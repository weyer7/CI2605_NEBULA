* NGSPICE file created from team_02.ext - technology: sky130A

* Black-box entry subcircuit for sky130_fd_sc_hd__and3_1 abstract view
.subckt sky130_fd_sc_hd__and3_1 A B C VGND VNB VPB VPWR X
.ends

* Black-box entry subcircuit for sky130_fd_sc_hd__tapvpwrvgnd_1 abstract view
.subckt sky130_fd_sc_hd__tapvpwrvgnd_1 VGND VPWR
.ends

* Black-box entry subcircuit for sky130_ef_sc_hd__decap_40_12 abstract view
.subckt sky130_ef_sc_hd__decap_40_12 VPWR VGND VPB VNB
.ends

* Black-box entry subcircuit for sky130_fd_sc_hd__or2_1 abstract view
.subckt sky130_fd_sc_hd__or2_1 A B VGND VNB VPB VPWR X
.ends

* Black-box entry subcircuit for sky130_fd_sc_hd__mux2_1 abstract view
.subckt sky130_fd_sc_hd__mux2_1 A0 A1 S VGND VNB VPB VPWR X
.ends

* Black-box entry subcircuit for sky130_fd_sc_hd__diode_2 abstract view
.subckt sky130_fd_sc_hd__diode_2 DIODE VGND VNB VPB VPWR
.ends

* Black-box entry subcircuit for sky130_fd_sc_hd__fill_2 abstract view
.subckt sky130_fd_sc_hd__fill_2 VGND VNB VPB VPWR
.ends

* Black-box entry subcircuit for sky130_fd_sc_hd__fill_1 abstract view
.subckt sky130_fd_sc_hd__fill_1 VGND VNB VPB VPWR
.ends

* Black-box entry subcircuit for sky130_fd_sc_hd__inv_2 abstract view
.subckt sky130_fd_sc_hd__inv_2 A VGND VNB VPB VPWR Y
.ends

* Black-box entry subcircuit for sky130_fd_sc_hd__dlygate4sd3_1 abstract view
.subckt sky130_fd_sc_hd__dlygate4sd3_1 A VGND VNB VPB VPWR X
.ends

* Black-box entry subcircuit for sky130_fd_sc_hd__fill_4 abstract view
.subckt sky130_fd_sc_hd__fill_4 VGND VNB VPB VPWR
.ends

* Black-box entry subcircuit for sky130_fd_sc_hd__nor2_1 abstract view
.subckt sky130_fd_sc_hd__nor2_1 A B VGND VNB VPB VPWR Y
.ends

* Black-box entry subcircuit for sky130_fd_sc_hd__a31o_1 abstract view
.subckt sky130_fd_sc_hd__a31o_1 A1 A2 A3 B1 VGND VNB VPB VPWR X
.ends

* Black-box entry subcircuit for sky130_fd_sc_hd__a22oi_1 abstract view
.subckt sky130_fd_sc_hd__a22oi_1 A1 A2 B1 B2 VGND VNB VPB VPWR Y
.ends

* Black-box entry subcircuit for sky130_fd_sc_hd__buf_2 abstract view
.subckt sky130_fd_sc_hd__buf_2 A VGND VNB VPB VPWR X
.ends

* Black-box entry subcircuit for sky130_fd_sc_hd__clkbuf_2 abstract view
.subckt sky130_fd_sc_hd__clkbuf_2 A VGND VNB VPB VPWR X
.ends

* Black-box entry subcircuit for sky130_fd_sc_hd__clkbuf_4 abstract view
.subckt sky130_fd_sc_hd__clkbuf_4 A VGND VNB VPB VPWR X
.ends

* Black-box entry subcircuit for sky130_fd_sc_hd__dfxtp_1 abstract view
.subckt sky130_fd_sc_hd__dfxtp_1 CLK D VGND VNB VPB VPWR Q
.ends

* Black-box entry subcircuit for sky130_fd_sc_hd__a22o_1 abstract view
.subckt sky130_fd_sc_hd__a22o_1 A1 A2 B1 B2 VGND VNB VPB VPWR X
.ends

* Black-box entry subcircuit for sky130_fd_sc_hd__nand2_1 abstract view
.subckt sky130_fd_sc_hd__nand2_1 A B VGND VNB VPB VPWR Y
.ends

* Black-box entry subcircuit for sky130_fd_sc_hd__xnor2_1 abstract view
.subckt sky130_fd_sc_hd__xnor2_1 A B VGND VNB VPB VPWR Y
.ends

* Black-box entry subcircuit for sky130_fd_sc_hd__and3b_1 abstract view
.subckt sky130_fd_sc_hd__and3b_1 A_N B C VGND VNB VPB VPWR X
.ends

* Black-box entry subcircuit for sky130_fd_sc_hd__nand2b_1 abstract view
.subckt sky130_fd_sc_hd__nand2b_1 A_N B VGND VNB VPB VPWR Y
.ends

* Black-box entry subcircuit for sky130_fd_sc_hd__nand3_1 abstract view
.subckt sky130_fd_sc_hd__nand3_1 A B C VGND VNB VPB VPWR Y
.ends

* Black-box entry subcircuit for sky130_fd_sc_hd__fill_8 abstract view
.subckt sky130_fd_sc_hd__fill_8 VGND VNB VPB VPWR
.ends

* Black-box entry subcircuit for sky130_fd_sc_hd__and2b_1 abstract view
.subckt sky130_fd_sc_hd__and2b_1 A_N B VGND VNB VPB VPWR X
.ends

* Black-box entry subcircuit for sky130_fd_sc_hd__dfrtp_1 abstract view
.subckt sky130_fd_sc_hd__dfrtp_1 CLK D RESET_B VGND VNB VPB VPWR Q
.ends

* Black-box entry subcircuit for sky130_fd_sc_hd__dfstp_1 abstract view
.subckt sky130_fd_sc_hd__dfstp_1 CLK D SET_B VGND VNB VPB VPWR Q
.ends

* Black-box entry subcircuit for sky130_fd_sc_hd__nand4_2 abstract view
.subckt sky130_fd_sc_hd__nand4_2 A B C D VGND VNB VPB VPWR Y
.ends

* Black-box entry subcircuit for sky130_fd_sc_hd__and4_1 abstract view
.subckt sky130_fd_sc_hd__and4_1 A B C D VGND VNB VPB VPWR X
.ends

* Black-box entry subcircuit for sky130_fd_sc_hd__or3_1 abstract view
.subckt sky130_fd_sc_hd__or3_1 A B C VGND VNB VPB VPWR X
.ends

* Black-box entry subcircuit for sky130_fd_sc_hd__o2bb2a_1 abstract view
.subckt sky130_fd_sc_hd__o2bb2a_1 A1_N A2_N B1 B2 VGND VNB VPB VPWR X
.ends

* Black-box entry subcircuit for sky130_fd_sc_hd__o31a_1 abstract view
.subckt sky130_fd_sc_hd__o31a_1 A1 A2 A3 B1 VGND VNB VPB VPWR X
.ends

* Black-box entry subcircuit for sky130_fd_sc_hd__nor4_1 abstract view
.subckt sky130_fd_sc_hd__nor4_1 A B C D VGND VNB VPB VPWR Y
.ends

* Black-box entry subcircuit for sky130_fd_sc_hd__a221o_1 abstract view
.subckt sky130_fd_sc_hd__a221o_1 A1 A2 B1 B2 C1 VGND VNB VPB VPWR X
.ends

* Black-box entry subcircuit for sky130_fd_sc_hd__o22a_1 abstract view
.subckt sky130_fd_sc_hd__o22a_1 A1 A2 B1 B2 VGND VNB VPB VPWR X
.ends

* Black-box entry subcircuit for sky130_fd_sc_hd__conb_1 abstract view
.subckt sky130_fd_sc_hd__conb_1 VGND VNB VPB VPWR HI LO
.ends

* Black-box entry subcircuit for sky130_fd_sc_hd__a21oi_1 abstract view
.subckt sky130_fd_sc_hd__a21oi_1 A1 A2 B1 VGND VNB VPB VPWR Y
.ends

* Black-box entry subcircuit for sky130_fd_sc_hd__a32o_1 abstract view
.subckt sky130_fd_sc_hd__a32o_1 A1 A2 A3 B1 B2 VGND VNB VPB VPWR X
.ends

* Black-box entry subcircuit for sky130_fd_sc_hd__o211ai_1 abstract view
.subckt sky130_fd_sc_hd__o211ai_1 A1 A2 B1 C1 VGND VNB VPB VPWR Y
.ends

* Black-box entry subcircuit for sky130_fd_sc_hd__and2_1 abstract view
.subckt sky130_fd_sc_hd__and2_1 A B VGND VNB VPB VPWR X
.ends

* Black-box entry subcircuit for sky130_fd_sc_hd__or2_2 abstract view
.subckt sky130_fd_sc_hd__or2_2 A B VGND VNB VPB VPWR X
.ends

* Black-box entry subcircuit for sky130_fd_sc_hd__dlymetal6s2s_1 abstract view
.subckt sky130_fd_sc_hd__dlymetal6s2s_1 A VGND VNB VPB VPWR X
.ends

* Black-box entry subcircuit for sky130_fd_sc_hd__buf_1 abstract view
.subckt sky130_fd_sc_hd__buf_1 A VGND VNB VPB VPWR X
.ends

* Black-box entry subcircuit for sky130_fd_sc_hd__decap_3 abstract view
.subckt sky130_fd_sc_hd__decap_3 VGND VNB VPB VPWR
.ends

* Black-box entry subcircuit for sky130_fd_sc_hd__o21a_1 abstract view
.subckt sky130_fd_sc_hd__o21a_1 A1 A2 B1 VGND VNB VPB VPWR X
.ends

* Black-box entry subcircuit for sky130_fd_sc_hd__buf_4 abstract view
.subckt sky130_fd_sc_hd__buf_4 A VGND VNB VPB VPWR X
.ends

* Black-box entry subcircuit for sky130_fd_sc_hd__a211o_1 abstract view
.subckt sky130_fd_sc_hd__a211o_1 A1 A2 B1 C1 VGND VNB VPB VPWR X
.ends

* Black-box entry subcircuit for sky130_fd_sc_hd__and2_2 abstract view
.subckt sky130_fd_sc_hd__and2_2 A B VGND VNB VPB VPWR X
.ends

* Black-box entry subcircuit for sky130_fd_sc_hd__o21bai_1 abstract view
.subckt sky130_fd_sc_hd__o21bai_1 A1 A2 B1_N VGND VNB VPB VPWR Y
.ends

* Black-box entry subcircuit for sky130_fd_sc_hd__o211a_1 abstract view
.subckt sky130_fd_sc_hd__o211a_1 A1 A2 B1 C1 VGND VNB VPB VPWR X
.ends

* Black-box entry subcircuit for sky130_fd_sc_hd__o21ai_1 abstract view
.subckt sky130_fd_sc_hd__o21ai_1 A1 A2 B1 VGND VNB VPB VPWR Y
.ends

* Black-box entry subcircuit for sky130_fd_sc_hd__a22oi_2 abstract view
.subckt sky130_fd_sc_hd__a22oi_2 A1 A2 B1 B2 VGND VNB VPB VPWR Y
.ends

* Black-box entry subcircuit for sky130_fd_sc_hd__a21o_1 abstract view
.subckt sky130_fd_sc_hd__a21o_1 A1 A2 B1 VGND VNB VPB VPWR X
.ends

* Black-box entry subcircuit for sky130_fd_sc_hd__or4bb_1 abstract view
.subckt sky130_fd_sc_hd__or4bb_1 A B C_N D_N VGND VNB VPB VPWR X
.ends

* Black-box entry subcircuit for sky130_fd_sc_hd__a41o_1 abstract view
.subckt sky130_fd_sc_hd__a41o_1 A1 A2 A3 A4 B1 VGND VNB VPB VPWR X
.ends

* Black-box entry subcircuit for sky130_fd_sc_hd__nand4_1 abstract view
.subckt sky130_fd_sc_hd__nand4_1 A B C D VGND VNB VPB VPWR Y
.ends

* Black-box entry subcircuit for sky130_fd_sc_hd__o22ai_2 abstract view
.subckt sky130_fd_sc_hd__o22ai_2 A1 A2 B1 B2 VGND VNB VPB VPWR Y
.ends

* Black-box entry subcircuit for sky130_fd_sc_hd__and4b_1 abstract view
.subckt sky130_fd_sc_hd__and4b_1 A_N B C D VGND VNB VPB VPWR X
.ends

* Black-box entry subcircuit for sky130_fd_sc_hd__a21bo_1 abstract view
.subckt sky130_fd_sc_hd__a21bo_1 A1 A2 B1_N VGND VNB VPB VPWR X
.ends

* Black-box entry subcircuit for sky130_fd_sc_hd__a32oi_2 abstract view
.subckt sky130_fd_sc_hd__a32oi_2 A1 A2 A3 B1 B2 VGND VNB VPB VPWR Y
.ends

* Black-box entry subcircuit for sky130_fd_sc_hd__clkbuf_8 abstract view
.subckt sky130_fd_sc_hd__clkbuf_8 A VGND VNB VPB VPWR X
.ends

* Black-box entry subcircuit for sky130_fd_sc_hd__inv_8 abstract view
.subckt sky130_fd_sc_hd__inv_8 A VGND VNB VPB VPWR Y
.ends

* Black-box entry subcircuit for sky130_fd_sc_hd__xor2_1 abstract view
.subckt sky130_fd_sc_hd__xor2_1 A B VGND VNB VPB VPWR X
.ends

* Black-box entry subcircuit for sky130_fd_sc_hd__or3b_1 abstract view
.subckt sky130_fd_sc_hd__or3b_1 A B C_N VGND VNB VPB VPWR X
.ends

* Black-box entry subcircuit for sky130_fd_sc_hd__o311a_1 abstract view
.subckt sky130_fd_sc_hd__o311a_1 A1 A2 A3 B1 C1 VGND VNB VPB VPWR X
.ends

* Black-box entry subcircuit for sky130_fd_sc_hd__inv_12 abstract view
.subckt sky130_fd_sc_hd__inv_12 A VGND VNB VPB VPWR Y
.ends

* Black-box entry subcircuit for sky130_fd_sc_hd__o21ba_1 abstract view
.subckt sky130_fd_sc_hd__o21ba_1 A1 A2 B1_N VGND VNB VPB VPWR X
.ends

* Black-box entry subcircuit for sky130_fd_sc_hd__clkbuf_1 abstract view
.subckt sky130_fd_sc_hd__clkbuf_1 A VGND VNB VPB VPWR X
.ends

* Black-box entry subcircuit for sky130_fd_sc_hd__dfrtp_4 abstract view
.subckt sky130_fd_sc_hd__dfrtp_4 CLK D RESET_B VGND VNB VPB VPWR Q
.ends

* Black-box entry subcircuit for sky130_fd_sc_hd__or3b_4 abstract view
.subckt sky130_fd_sc_hd__or3b_4 A B C_N VGND VNB VPB VPWR X
.ends

* Black-box entry subcircuit for sky130_fd_sc_hd__clkinv_2 abstract view
.subckt sky130_fd_sc_hd__clkinv_2 A VGND VNB VPB VPWR Y
.ends

* Black-box entry subcircuit for sky130_fd_sc_hd__inv_6 abstract view
.subckt sky130_fd_sc_hd__inv_6 A VGND VNB VPB VPWR Y
.ends

* Black-box entry subcircuit for sky130_fd_sc_hd__and4bb_1 abstract view
.subckt sky130_fd_sc_hd__and4bb_1 A_N B_N C D VGND VNB VPB VPWR X
.ends

* Black-box entry subcircuit for sky130_fd_sc_hd__dfxtp_2 abstract view
.subckt sky130_fd_sc_hd__dfxtp_2 CLK D VGND VNB VPB VPWR Q
.ends

* Black-box entry subcircuit for sky130_fd_sc_hd__or3b_2 abstract view
.subckt sky130_fd_sc_hd__or3b_2 A B C_N VGND VNB VPB VPWR X
.ends

* Black-box entry subcircuit for sky130_fd_sc_hd__clkbuf_16 abstract view
.subckt sky130_fd_sc_hd__clkbuf_16 A VGND VNB VPB VPWR X
.ends

* Black-box entry subcircuit for sky130_fd_sc_hd__clkinvlp_4 abstract view
.subckt sky130_fd_sc_hd__clkinvlp_4 A VGND VNB VPB VPWR Y
.ends

* Black-box entry subcircuit for sky130_fd_sc_hd__clkinv_4 abstract view
.subckt sky130_fd_sc_hd__clkinv_4 A VGND VNB VPB VPWR Y
.ends

* Black-box entry subcircuit for sky130_fd_sc_hd__or2_4 abstract view
.subckt sky130_fd_sc_hd__or2_4 A B VGND VNB VPB VPWR X
.ends

* Black-box entry subcircuit for sky130_fd_sc_hd__o31ai_2 abstract view
.subckt sky130_fd_sc_hd__o31ai_2 A1 A2 A3 B1 VGND VNB VPB VPWR Y
.ends

* Black-box entry subcircuit for sky130_fd_sc_hd__clkinv_8 abstract view
.subckt sky130_fd_sc_hd__clkinv_8 A VGND VNB VPB VPWR Y
.ends

* Black-box entry subcircuit for sky130_fd_sc_hd__o32a_1 abstract view
.subckt sky130_fd_sc_hd__o32a_1 A1 A2 A3 B1 B2 VGND VNB VPB VPWR X
.ends

* Black-box entry subcircuit for sky130_fd_sc_hd__a21boi_1 abstract view
.subckt sky130_fd_sc_hd__a21boi_1 A1 A2 B1_N VGND VNB VPB VPWR Y
.ends

* Black-box entry subcircuit for sky130_fd_sc_hd__o21ai_2 abstract view
.subckt sky130_fd_sc_hd__o21ai_2 A1 A2 B1 VGND VNB VPB VPWR Y
.ends

* Black-box entry subcircuit for sky130_fd_sc_hd__a22o_2 abstract view
.subckt sky130_fd_sc_hd__a22o_2 A1 A2 B1 B2 VGND VNB VPB VPWR X
.ends

* Black-box entry subcircuit for sky130_fd_sc_hd__or3_2 abstract view
.subckt sky130_fd_sc_hd__or3_2 A B C VGND VNB VPB VPWR X
.ends

* Black-box entry subcircuit for sky130_fd_sc_hd__o21bai_4 abstract view
.subckt sky130_fd_sc_hd__o21bai_4 A1 A2 B1_N VGND VNB VPB VPWR Y
.ends

* Black-box entry subcircuit for sky130_fd_sc_hd__xnor2_2 abstract view
.subckt sky130_fd_sc_hd__xnor2_2 A B VGND VNB VPB VPWR Y
.ends

* Black-box entry subcircuit for sky130_fd_sc_hd__a2111o_1 abstract view
.subckt sky130_fd_sc_hd__a2111o_1 A1 A2 B1 C1 D1 VGND VNB VPB VPWR X
.ends

* Black-box entry subcircuit for sky130_fd_sc_hd__or3_4 abstract view
.subckt sky130_fd_sc_hd__or3_4 A B C VGND VNB VPB VPWR X
.ends

* Black-box entry subcircuit for sky130_fd_sc_hd__or4b_1 abstract view
.subckt sky130_fd_sc_hd__or4b_1 A B C D_N VGND VNB VPB VPWR X
.ends

* Black-box entry subcircuit for sky130_fd_sc_hd__o21ai_4 abstract view
.subckt sky130_fd_sc_hd__o21ai_4 A1 A2 B1 VGND VNB VPB VPWR Y
.ends

* Black-box entry subcircuit for sky130_fd_sc_hd__a311o_1 abstract view
.subckt sky130_fd_sc_hd__a311o_1 A1 A2 A3 B1 C1 VGND VNB VPB VPWR X
.ends

* Black-box entry subcircuit for sky130_fd_sc_hd__nor3_1 abstract view
.subckt sky130_fd_sc_hd__nor3_1 A B C VGND VNB VPB VPWR Y
.ends

* Black-box entry subcircuit for sky130_fd_sc_hd__o221ai_4 abstract view
.subckt sky130_fd_sc_hd__o221ai_4 A1 A2 B1 B2 C1 VGND VNB VPB VPWR Y
.ends

* Black-box entry subcircuit for sky130_fd_sc_hd__a2bb2o_1 abstract view
.subckt sky130_fd_sc_hd__a2bb2o_1 A1_N A2_N B1 B2 VGND VNB VPB VPWR X
.ends

* Black-box entry subcircuit for sky130_fd_sc_hd__o221a_1 abstract view
.subckt sky130_fd_sc_hd__o221a_1 A1 A2 B1 B2 C1 VGND VNB VPB VPWR X
.ends

* Black-box entry subcircuit for sky130_fd_sc_hd__nor2_2 abstract view
.subckt sky130_fd_sc_hd__nor2_2 A B VGND VNB VPB VPWR Y
.ends

* Black-box entry subcircuit for sky130_fd_sc_hd__a21boi_2 abstract view
.subckt sky130_fd_sc_hd__a21boi_2 A1 A2 B1_N VGND VNB VPB VPWR Y
.ends

* Black-box entry subcircuit for sky130_fd_sc_hd__nor3_2 abstract view
.subckt sky130_fd_sc_hd__nor3_2 A B C VGND VNB VPB VPWR Y
.ends

* Black-box entry subcircuit for sky130_fd_sc_hd__xor2_2 abstract view
.subckt sky130_fd_sc_hd__xor2_2 A B VGND VNB VPB VPWR X
.ends

* Black-box entry subcircuit for sky130_fd_sc_hd__o22ai_1 abstract view
.subckt sky130_fd_sc_hd__o22ai_1 A1 A2 B1 B2 VGND VNB VPB VPWR Y
.ends

* Black-box entry subcircuit for sky130_fd_sc_hd__nand2_2 abstract view
.subckt sky130_fd_sc_hd__nand2_2 A B VGND VNB VPB VPWR Y
.ends

* Black-box entry subcircuit for sky130_fd_sc_hd__a211oi_1 abstract view
.subckt sky130_fd_sc_hd__a211oi_1 A1 A2 B1 C1 VGND VNB VPB VPWR Y
.ends

* Black-box entry subcircuit for sky130_fd_sc_hd__o2111ai_2 abstract view
.subckt sky130_fd_sc_hd__o2111ai_2 A1 A2 B1 C1 D1 VGND VNB VPB VPWR Y
.ends

* Black-box entry subcircuit for sky130_fd_sc_hd__nor2_4 abstract view
.subckt sky130_fd_sc_hd__nor2_4 A B VGND VNB VPB VPWR Y
.ends

* Black-box entry subcircuit for sky130_fd_sc_hd__o211ai_2 abstract view
.subckt sky130_fd_sc_hd__o211ai_2 A1 A2 B1 C1 VGND VNB VPB VPWR Y
.ends

* Black-box entry subcircuit for sky130_fd_sc_hd__a21oi_2 abstract view
.subckt sky130_fd_sc_hd__a21oi_2 A1 A2 B1 VGND VNB VPB VPWR Y
.ends

* Black-box entry subcircuit for sky130_fd_sc_hd__o31ai_1 abstract view
.subckt sky130_fd_sc_hd__o31ai_1 A1 A2 A3 B1 VGND VNB VPB VPWR Y
.ends

* Black-box entry subcircuit for sky130_fd_sc_hd__o2111a_1 abstract view
.subckt sky130_fd_sc_hd__o2111a_1 A1 A2 B1 C1 D1 VGND VNB VPB VPWR X
.ends

* Black-box entry subcircuit for sky130_fd_sc_hd__nand3_2 abstract view
.subckt sky130_fd_sc_hd__nand3_2 A B C VGND VNB VPB VPWR Y
.ends

* Black-box entry subcircuit for sky130_fd_sc_hd__and3b_4 abstract view
.subckt sky130_fd_sc_hd__and3b_4 A_N B C VGND VNB VPB VPWR X
.ends

.subckt team_02 clk en gpio_in[0] gpio_in[10] gpio_in[11] gpio_in[12] gpio_in[13]
+ gpio_in[14] gpio_in[15] gpio_in[16] gpio_in[17] gpio_in[18] gpio_in[19] gpio_in[1]
+ gpio_in[20] gpio_in[21] gpio_in[22] gpio_in[23] gpio_in[24] gpio_in[25] gpio_in[26]
+ gpio_in[27] gpio_in[28] gpio_in[29] gpio_in[2] gpio_in[30] gpio_in[31] gpio_in[32]
+ gpio_in[33] gpio_in[3] gpio_in[4] gpio_in[5] gpio_in[6] gpio_in[7] gpio_in[8] gpio_in[9]
+ gpio_oeb[0] gpio_oeb[10] gpio_oeb[11] gpio_oeb[12] gpio_oeb[13] gpio_oeb[14] gpio_oeb[15]
+ gpio_oeb[16] gpio_oeb[17] gpio_oeb[18] gpio_oeb[19] gpio_oeb[1] gpio_oeb[20] gpio_oeb[21]
+ gpio_oeb[22] gpio_oeb[23] gpio_oeb[24] gpio_oeb[25] gpio_oeb[26] gpio_oeb[27] gpio_oeb[28]
+ gpio_oeb[29] gpio_oeb[2] gpio_oeb[30] gpio_oeb[31] gpio_oeb[32] gpio_oeb[33] gpio_oeb[3]
+ gpio_oeb[4] gpio_oeb[5] gpio_oeb[6] gpio_oeb[7] gpio_oeb[8] gpio_oeb[9] gpio_out[0]
+ gpio_out[10] gpio_out[11] gpio_out[12] gpio_out[13] gpio_out[14] gpio_out[15] gpio_out[16]
+ gpio_out[17] gpio_out[18] gpio_out[19] gpio_out[1] gpio_out[20] gpio_out[21] gpio_out[22]
+ gpio_out[23] gpio_out[24] gpio_out[25] gpio_out[26] gpio_out[27] gpio_out[28] gpio_out[29]
+ gpio_out[2] gpio_out[30] gpio_out[31] gpio_out[32] gpio_out[33] gpio_out[3] gpio_out[4]
+ gpio_out[5] gpio_out[6] gpio_out[7] gpio_out[8] gpio_out[9] nrst vccd1 vssd1
X_3155_ net53 net83 net72 vssd1 vssd1 vccd1 vccd1 _0080_ sky130_fd_sc_hd__and3_1
XTAP_TAPCELL_ROW_65_721 vssd1 vccd1 sky130_fd_sc_hd__tapvpwrvgnd_1
XFILLER_27_428 vccd1 vssd1 vccd1 vssd1 sky130_ef_sc_hd__decap_40_12
X_3086_ _0758_ _1580_ vssd1 vssd1 vccd1 vccd1 _1582_ sky130_fd_sc_hd__or2_1
X_2106_ net315 net36 net16 vssd1 vssd1 vccd1 vccd1 _0262_ sky130_fd_sc_hd__mux2_1
XANTENNA__2455__A net190 vssd1 vssd1 vccd1 vccd1 sky130_fd_sc_hd__diode_2
X_2037_ net485 net48 net22 vssd1 vssd1 vccd1 vccd1 _0196_ sky130_fd_sc_hd__mux2_1
XANTENNA__3050__S net8 vssd1 vssd1 vccd1 vccd1 sky130_fd_sc_hd__diode_2
XTAP_TAPCELL_ROW_37_489 vssd1 vccd1 sky130_fd_sc_hd__tapvpwrvgnd_1
XFILLER_10_317 vssd1 vssd1 vccd1 vccd1 sky130_fd_sc_hd__fill_2
XFILLER_50_453 vssd1 vssd1 vccd1 vccd1 sky130_fd_sc_hd__fill_1
XFILLER_50_475 vssd1 vssd1 vccd1 vccd1 sky130_fd_sc_hd__fill_1
X_2939_ _1478_ vssd1 vssd1 vccd1 vccd1 _1479_ sky130_fd_sc_hd__inv_2
XTAP_TAPCELL_ROW_20_345 vssd1 vccd1 sky130_fd_sc_hd__tapvpwrvgnd_1
XANTENNA__1757__A2 net104 vssd1 vssd1 vccd1 vccd1 sky130_fd_sc_hd__diode_2
Xhold340 MATMULT_INST.matmult_inst.spi_inst.tx_reg_sys\[10\] vssd1 vssd1 vccd1 vccd1
+ net635 sky130_fd_sc_hd__dlygate4sd3_1
Xhold362 MATMULT_INST.matmult_inst.alu_inst.adder_inst.r3.fa3.a vssd1 vssd1 vccd1
+ vccd1 net657 sky130_fd_sc_hd__dlygate4sd3_1
Xhold351 MATMULT_INST.matmult_inst.spi_inst.tx_reg_sys\[9\] vssd1 vssd1 vccd1 vccd1
+ net646 sky130_fd_sc_hd__dlygate4sd3_1
Xhold373 MATMULT_INST.matmult_inst.alu_inst.adder_inst.r2.fa1.a vssd1 vssd1 vccd1
+ vccd1 net668 sky130_fd_sc_hd__dlygate4sd3_1
XTAP_TAPCELL_ROW_28_412 vssd1 vccd1 sky130_fd_sc_hd__tapvpwrvgnd_1
XFILLER_45_269 vssd1 vssd1 vccd1 vccd1 sky130_fd_sc_hd__fill_1
XFILLER_13_111 vssd1 vssd1 vccd1 vccd1 sky130_fd_sc_hd__fill_1
XANTENNA_fanout30_X net30 vssd1 vssd1 vccd1 vccd1 sky130_fd_sc_hd__diode_2
XTAP_TAPCELL_ROW_71_779 vssd1 vccd1 sky130_fd_sc_hd__tapvpwrvgnd_1
XFILLER_13_144 vssd1 vssd1 vccd1 vccd1 sky130_fd_sc_hd__fill_4
XFILLER_9_137 vssd1 vssd1 vccd1 vccd1 sky130_fd_sc_hd__fill_1
XTAP_TAPCELL_ROW_79_846 vssd1 vccd1 sky130_fd_sc_hd__tapvpwrvgnd_1
XFILLER_68_339 vssd1 vssd1 vccd1 vccd1 sky130_fd_sc_hd__fill_2
XANTENNA__2259__B MATMULT_INST.matmult_inst.alu_inst.adder_inst.r2.fa0.a vssd1 vssd1
+ vccd1 vccd1 sky130_fd_sc_hd__diode_2
XFILLER_67_81 vssd1 vssd1 vccd1 vccd1 sky130_fd_sc_hd__fill_1
XANTENNA__1684__A1 net218 vssd1 vssd1 vccd1 vccd1 sky130_fd_sc_hd__diode_2
XANTENNA__1684__B2 net223 vssd1 vssd1 vccd1 vccd1 sky130_fd_sc_hd__diode_2
XTAP_TAPCELL_ROW_62_702 vssd1 vccd1 sky130_fd_sc_hd__tapvpwrvgnd_1
XFILLER_44_291 vssd1 vssd1 vccd1 vccd1 sky130_fd_sc_hd__fill_1
XFILLER_32_475 vssd1 vssd1 vccd1 vccd1 sky130_fd_sc_hd__fill_1
XTAP_TAPCELL_ROW_34_459 vssd1 vccd1 sky130_fd_sc_hd__tapvpwrvgnd_1
XANTENNA__2281__Y _0906_ vssd1 vssd1 vccd1 vccd1 sky130_fd_sc_hd__diode_2
XANTENNA__1619__A net148 vssd1 vssd1 vccd1 vccd1 sky130_fd_sc_hd__diode_2
X_2724_ net114 _1272_ vssd1 vssd1 vccd1 vccd1 _1273_ sky130_fd_sc_hd__nor2_1
X_2655_ net94 _1239_ _1240_ _1241_ vssd1 vssd1 vccd1 vccd1 _0389_ sky130_fd_sc_hd__a31o_1
X_1606_ MATMULT_INST.matmult_inst.fsm_inst.count\[1\] _0536_ vssd1 vssd1 vccd1 vccd1
+ _0537_ sky130_fd_sc_hd__nor2_1
XANTENNA__2164__A2 _0811_ vssd1 vssd1 vccd1 vccd1 sky130_fd_sc_hd__diode_2
X_2586_ net190 net200 net188 net202 vssd1 vssd1 vccd1 vccd1 _1176_ sky130_fd_sc_hd__a22oi_1
Xfanout105 net106 vssd1 vssd1 vccd1 vccd1 net105 sky130_fd_sc_hd__buf_2
Xfanout127 net131 vssd1 vssd1 vccd1 vccd1 net127 sky130_fd_sc_hd__clkbuf_2
Xfanout138 net140 vssd1 vssd1 vccd1 vccd1 net138 sky130_fd_sc_hd__clkbuf_2
Xfanout116 net123 vssd1 vssd1 vccd1 vccd1 net116 sky130_fd_sc_hd__clkbuf_4
XANTENNA__3045__S net8 vssd1 vssd1 vccd1 vccd1 sky130_fd_sc_hd__diode_2
Xfanout149 net154 vssd1 vssd1 vccd1 vccd1 net149 sky130_fd_sc_hd__clkbuf_2
X_3207_ clknet_leaf_1_clk _0129_ vssd1 vssd1 vccd1 vccd1 MATMULT_INST.matmult_inst.mem_inst.matrixB2\[6\]
+ sky130_fd_sc_hd__dfxtp_1
X_3138_ net227 vssd1 vssd1 vccd1 vccd1 _0060_ sky130_fd_sc_hd__inv_2
X_3069_ MATMULT_INST.matmult_inst.alu_inst.out\[5\] net52 net7 net375 vssd1 vssd1
+ vccd1 vccd1 _0513_ sky130_fd_sc_hd__a22o_1
XANTENNA__2124__S net15 vssd1 vssd1 vccd1 vccd1 sky130_fd_sc_hd__diode_2
XANTENNA__1963__S net31 vssd1 vssd1 vccd1 vccd1 sky130_fd_sc_hd__diode_2
Xhold170 MATMULT_INST.matmult_inst.mem_inst.mem2\[1\] vssd1 vssd1 vccd1 vccd1 net465
+ sky130_fd_sc_hd__dlygate4sd3_1
Xhold192 MATMULT_INST.matmult_inst.mem_inst.mem1\[8\] vssd1 vssd1 vccd1 vccd1 net487
+ sky130_fd_sc_hd__dlygate4sd3_1
Xhold181 MATMULT_INST.matmult_inst.mem_inst.matrixB1\[6\] vssd1 vssd1 vccd1 vccd1
+ net476 sky130_fd_sc_hd__dlygate4sd3_1
XANTENNA__3182__C net74 vssd1 vssd1 vccd1 vccd1 sky130_fd_sc_hd__diode_2
XANTENNA_clkbuf_leaf_31_clk_A clknet_2_2__leaf_clk vssd1 vssd1 vccd1 vccd1 sky130_fd_sc_hd__diode_2
XFILLER_77_169 vssd1 vssd1 vccd1 vccd1 sky130_fd_sc_hd__fill_1
XTAP_TAPCELL_ROW_76_816 vssd1 vccd1 sky130_fd_sc_hd__tapvpwrvgnd_1
XFILLER_37_95 vssd1 vssd1 vccd1 vccd1 sky130_fd_sc_hd__fill_1
XANTENNA__2091__A1 _0814_ vssd1 vssd1 vccd1 vccd1 sky130_fd_sc_hd__diode_2
XANTENNA__2034__S net25 vssd1 vssd1 vccd1 vccd1 sky130_fd_sc_hd__diode_2
XFILLER_5_140 vssd1 vssd1 vccd1 vccd1 sky130_fd_sc_hd__fill_2
X_2440_ _1020_ _1033_ vssd1 vssd1 vccd1 vccd1 _1034_ sky130_fd_sc_hd__nand2_1
XFILLER_5_195 vssd1 vssd1 vccd1 vccd1 sky130_fd_sc_hd__fill_2
X_2371_ _0964_ _0967_ vssd1 vssd1 vccd1 vccd1 _0968_ sky130_fd_sc_hd__xnor2_1
XTAP_TAPCELL_ROW_39_507 vssd1 vccd1 sky130_fd_sc_hd__tapvpwrvgnd_1
XFILLER_49_361 vssd1 vssd1 vccd1 vccd1 sky130_fd_sc_hd__fill_2
XTAP_TAPCELL_ROW_47_573 vssd1 vccd1 sky130_fd_sc_hd__tapvpwrvgnd_1
XFILLER_32_250 vssd1 vssd1 vccd1 vccd1 sky130_fd_sc_hd__fill_2
XFILLER_32_261 vssd1 vssd1 vccd1 vccd1 sky130_fd_sc_hd__fill_1
XANTENNA_fanout125_A net131 vssd1 vssd1 vccd1 vccd1 sky130_fd_sc_hd__diode_2
XFILLER_9_490 vssd1 vssd1 vccd1 vccd1 sky130_fd_sc_hd__fill_1
X_2707_ _0775_ _1258_ _0753_ vssd1 vssd1 vccd1 vccd1 _1259_ sky130_fd_sc_hd__and3b_1
X_2638_ _1224_ _1225_ vssd1 vssd1 vccd1 vccd1 _1226_ sky130_fd_sc_hd__nand2b_1
X_2569_ _1153_ _1157_ _1158_ vssd1 vssd1 vccd1 vccd1 _1160_ sky130_fd_sc_hd__nand3_1
XFILLER_74_139 vssd1 vssd1 vccd1 vccd1 sky130_fd_sc_hd__fill_1
XFILLER_55_320 vssd1 vssd1 vccd1 vccd1 sky130_fd_sc_hd__fill_1
XTAP_TAPCELL_ROW_2_187 vssd1 vccd1 sky130_fd_sc_hd__tapvpwrvgnd_1
XFILLER_15_206 vccd1 vssd1 vccd1 vssd1 sky130_ef_sc_hd__decap_40_12
XANTENNA__2119__S net14 vssd1 vssd1 vccd1 vccd1 sky130_fd_sc_hd__diode_2
XFILLER_11_478 vccd1 vssd1 vccd1 vssd1 sky130_ef_sc_hd__decap_40_12
XFILLER_7_449 vssd1 vssd1 vccd1 vccd1 sky130_fd_sc_hd__fill_8
XANTENNA__3177__C net73 vssd1 vssd1 vccd1 vccd1 sky130_fd_sc_hd__diode_2
XFILLER_2_121 vccd1 vssd1 vccd1 vssd1 sky130_ef_sc_hd__decap_40_12
XFILLER_78_412 vssd1 vssd1 vccd1 vccd1 sky130_fd_sc_hd__fill_8
XANTENNA__1706__B _0557_ vssd1 vssd1 vccd1 vccd1 sky130_fd_sc_hd__diode_2
XFILLER_78_445 vccd1 vssd1 vccd1 vssd1 sky130_ef_sc_hd__decap_40_12
XFILLER_38_309 vssd1 vssd1 vccd1 vccd1 sky130_fd_sc_hd__fill_1
XFILLER_65_117 vccd1 vssd1 vccd1 vssd1 sky130_ef_sc_hd__decap_40_12
XFILLER_48_83 vssd1 vssd1 vccd1 vccd1 sky130_fd_sc_hd__fill_1
XFILLER_0_24 vssd1 vssd1 vccd1 vccd1 sky130_fd_sc_hd__fill_4
XANTENNA__2537__B net200 vssd1 vssd1 vccd1 vccd1 sky130_fd_sc_hd__diode_2
XANTENNA__2029__S net25 vssd1 vssd1 vccd1 vccd1 sky130_fd_sc_hd__diode_2
XFILLER_0_57 vccd1 vssd1 vccd1 vssd1 sky130_ef_sc_hd__decap_40_12
XFILLER_73_183 vssd1 vssd1 vccd1 vccd1 sky130_fd_sc_hd__fill_4
XFILLER_64_60 vssd1 vssd1 vccd1 vccd1 sky130_fd_sc_hd__fill_8
XFILLER_61_323 vssd1 vssd1 vccd1 vccd1 sky130_fd_sc_hd__fill_1
XFILLER_64_93 vssd1 vssd1 vccd1 vccd1 sky130_fd_sc_hd__fill_2
XTAP_TAPCELL_ROW_44_543 vssd1 vccd1 sky130_fd_sc_hd__tapvpwrvgnd_1
X_1940_ net71 net69 vssd1 vssd1 vccd1 vccd1 _0795_ sky130_fd_sc_hd__or2_1
XFILLER_9_55 vssd1 vssd1 vccd1 vccd1 sky130_fd_sc_hd__fill_1
X_1871_ net645 net298 vssd1 vssd1 vccd1 vccd1 _0004_ sky130_fd_sc_hd__and2b_1
X_3610_ clknet_leaf_21_clk _0503_ _0108_ vssd1 vssd1 vccd1 vccd1 MATMULT_INST.matmult_inst.spi_inst.tx_reg_sys\[13\]
+ sky130_fd_sc_hd__dfrtp_1
XFILLER_9_99 vssd1 vssd1 vccd1 vccd1 sky130_fd_sc_hd__fill_1
X_3541_ clknet_leaf_22_clk net296 _0049_ vssd1 vssd1 vccd1 vccd1 MATMULT_INST.matmult_inst.spi_inst.cs_sync_prev
+ sky130_fd_sc_hd__dfstp_1
XANTENNA__2699__S _1256_ vssd1 vssd1 vccd1 vccd1 sky130_fd_sc_hd__diode_2
X_3472_ clknet_leaf_27_clk _0392_ vssd1 vssd1 vccd1 vccd1 MATMULT_INST.matmult_inst.alu_inst.col1\[0\]
+ sky130_fd_sc_hd__dfxtp_1
XFILLER_50_3 vccd1 vssd1 vccd1 vssd1 sky130_ef_sc_hd__decap_40_12
X_2423_ net197 net195 net203 net205 vssd1 vssd1 vccd1 vccd1 _1018_ sky130_fd_sc_hd__nand4_2
XFILLER_69_445 vssd1 vssd1 vccd1 vccd1 sky130_fd_sc_hd__fill_2
X_2354_ _0939_ _0949_ _0950_ vssd1 vssd1 vccd1 vccd1 _0952_ sky130_fd_sc_hd__and3_1
X_2285_ _0907_ _0908_ vssd1 vssd1 vccd1 vccd1 _0909_ sky130_fd_sc_hd__nand2_1
XANTENNA__2827__B1 net173 vssd1 vssd1 vccd1 vccd1 sky130_fd_sc_hd__diode_2
XFILLER_37_353 vssd1 vssd1 vccd1 vccd1 sky130_fd_sc_hd__fill_1
XFILLER_37_386 vssd1 vssd1 vccd1 vccd1 sky130_fd_sc_hd__fill_4
XFILLER_52_334 vssd1 vssd1 vccd1 vccd1 sky130_fd_sc_hd__fill_8
XFILLER_52_389 vccd1 vssd1 vccd1 vssd1 sky130_ef_sc_hd__decap_40_12
XFILLER_20_231 vssd1 vssd1 vccd1 vccd1 sky130_fd_sc_hd__fill_2
XFILLER_60_29 vssd1 vssd1 vccd1 vccd1 sky130_fd_sc_hd__fill_1
XANTENNA_fanout128_X net128 vssd1 vssd1 vccd1 vccd1 sky130_fd_sc_hd__diode_2
XFILLER_79_209 vssd1 vssd1 vccd1 vccd1 sky130_fd_sc_hd__fill_4
XTAP_TAPCELL_ROW_7_235 vssd1 vccd1 sky130_fd_sc_hd__tapvpwrvgnd_1
XANTENNA_input2_X net2 vssd1 vssd1 vccd1 vccd1 sky130_fd_sc_hd__diode_2
XFILLER_47_128 vssd1 vssd1 vccd1 vccd1 sky130_fd_sc_hd__fill_1
XANTENNA__2294__A1 _0916_ vssd1 vssd1 vccd1 vccd1 sky130_fd_sc_hd__diode_2
XTAP_TAPCELL_ROW_58_668 vssd1 vccd1 sky130_fd_sc_hd__tapvpwrvgnd_1
XFILLER_18_97 vccd1 vssd1 vccd1 vssd1 sky130_ef_sc_hd__decap_40_12
XANTENNA__2046__A1 net39 vssd1 vssd1 vccd1 vccd1 sky130_fd_sc_hd__diode_2
XTAP_TAPCELL_ROW_41_524 vssd1 vccd1 sky130_fd_sc_hd__tapvpwrvgnd_1
XFILLER_11_253 vccd1 vssd1 vccd1 vssd1 sky130_ef_sc_hd__decap_40_12
XFILLER_7_279 vssd1 vssd1 vccd1 vccd1 sky130_fd_sc_hd__fill_1
XFILLER_3_485 vssd1 vssd1 vccd1 vccd1 sky130_fd_sc_hd__fill_8
XFILLER_66_437 vssd1 vssd1 vccd1 vccd1 sky130_fd_sc_hd__fill_2
X_2070_ net448 net34 net20 vssd1 vssd1 vccd1 vccd1 _0228_ sky130_fd_sc_hd__mux2_1
X_2972_ net160 net170 net158 net172 vssd1 vssd1 vccd1 vccd1 _1511_ sky130_fd_sc_hd__and4_1
XFILLER_34_389 vssd1 vssd1 vccd1 vccd1 sky130_fd_sc_hd__fill_8
X_1923_ MATMULT_INST.matmult_inst.spi_inst.tx_reg_sys\[2\] MATMULT_INST.matmult_inst.spi_inst.miso_shifter\[1\]
+ net136 vssd1 vssd1 vccd1 vccd1 _0015_ sky130_fd_sc_hd__mux2_1
X_1854_ MATMULT_INST.matmult_inst.spi_inst.mosi_shifter\[3\] MATMULT_INST.matmult_inst.spi_inst.mosi_data_spi\[4\]
+ _0744_ vssd1 vssd1 vccd1 vccd1 _0451_ sky130_fd_sc_hd__mux2_1
XTAP_TAPCELL_ROW_12_270 vssd1 vccd1 sky130_fd_sc_hd__tapvpwrvgnd_1
X_1785_ _0692_ _0699_ _0700_ vssd1 vssd1 vccd1 vccd1 _0701_ sky130_fd_sc_hd__or3_1
X_3524_ clknet_leaf_35_clk _0441_ vssd1 vssd1 vccd1 vccd1 MATMULT_INST.matmult_inst.alu_inst.adder_inst.r3.fa3.b
+ sky130_fd_sc_hd__dfxtp_1
Xfanout7 _1578_ vssd1 vssd1 vccd1 vccd1 net7 sky130_fd_sc_hd__clkbuf_2
XFILLER_6_290 vssd1 vssd1 vccd1 vccd1 sky130_fd_sc_hd__fill_2
X_3455_ clknet_leaf_3_clk _0376_ vssd1 vssd1 vccd1 vccd1 MATMULT_INST.matmult_inst.alu_inst.adder_inst.r0.fa1.a
+ sky130_fd_sc_hd__dfxtp_1
XFILLER_69_220 vssd1 vssd1 vccd1 vccd1 sky130_fd_sc_hd__fill_4
X_2406_ _0960_ _0985_ _0986_ _0993_ vssd1 vssd1 vccd1 vccd1 _1001_ sky130_fd_sc_hd__o2bb2a_1
XTAP_TAPCELL_ROW_4_205 vssd1 vccd1 sky130_fd_sc_hd__tapvpwrvgnd_1
X_3386_ clknet_leaf_6_clk _0308_ vssd1 vssd1 vccd1 vccd1 MATMULT_INST.matmult_inst.mem_inst.mem0\[5\]
+ sky130_fd_sc_hd__dfxtp_1
XANTENNA__3053__S net9 vssd1 vssd1 vccd1 vccd1 sky130_fd_sc_hd__diode_2
X_2337_ net114 _0936_ vssd1 vssd1 vccd1 vccd1 _0937_ sky130_fd_sc_hd__nor2_1
XFILLER_69_297 vssd1 vssd1 vccd1 vccd1 sky130_fd_sc_hd__fill_1
X_2268_ _0881_ _0886_ _0889_ _0887_ vssd1 vssd1 vccd1 vccd1 _0895_ sky130_fd_sc_hd__o31a_1
XFILLER_29_139 vssd1 vssd1 vccd1 vccd1 sky130_fd_sc_hd__fill_2
XFILLER_72_418 vssd1 vssd1 vccd1 vccd1 sky130_fd_sc_hd__fill_2
XANTENNA__2276__A1 _0901_ vssd1 vssd1 vccd1 vccd1 sky130_fd_sc_hd__diode_2
XFILLER_65_492 vssd1 vssd1 vccd1 vccd1 sky130_fd_sc_hd__fill_2
X_2199_ net203 net398 net65 vssd1 vssd1 vccd1 vccd1 _0331_ sky130_fd_sc_hd__mux2_1
XTAP_TAPCELL_ROW_55_638 vssd1 vccd1 sky130_fd_sc_hd__tapvpwrvgnd_1
XANTENNA__2028__A1 net38 vssd1 vssd1 vccd1 vccd1 sky130_fd_sc_hd__diode_2
XFILLER_25_389 vssd1 vssd1 vccd1 vccd1 sky130_fd_sc_hd__fill_2
XFILLER_52_175 vssd1 vssd1 vccd1 vccd1 sky130_fd_sc_hd__fill_2
XFILLER_40_337 vssd1 vssd1 vccd1 vccd1 sky130_fd_sc_hd__fill_2
XFILLER_52_197 vssd1 vssd1 vccd1 vccd1 sky130_fd_sc_hd__fill_2
XFILLER_4_205 vssd1 vssd1 vccd1 vccd1 sky130_fd_sc_hd__fill_2
XFILLER_20_21 vssd1 vssd1 vccd1 vccd1 sky130_fd_sc_hd__fill_2
XANTENNA__2132__S net12 vssd1 vssd1 vccd1 vccd1 sky130_fd_sc_hd__diode_2
XANTENNA__1971__S net31 vssd1 vssd1 vccd1 vccd1 sky130_fd_sc_hd__diode_2
XFILLER_0_433 vccd1 vssd1 vccd1 vssd1 sky130_ef_sc_hd__decap_40_12
XFILLER_0_477 vssd1 vssd1 vccd1 vccd1 sky130_fd_sc_hd__fill_8
XFILLER_29_52 vssd1 vssd1 vccd1 vccd1 sky130_fd_sc_hd__fill_1
Xhold41 MATMULT_INST.matmult_inst.mem_inst.matrixA3\[4\] vssd1 vssd1 vccd1 vccd1 net336
+ sky130_fd_sc_hd__dlygate4sd3_1
Xhold30 _0516_ vssd1 vssd1 vccd1 vccd1 net325 sky130_fd_sc_hd__dlygate4sd3_1
XFILLER_75_223 vssd1 vssd1 vccd1 vccd1 sky130_fd_sc_hd__fill_1
Xhold74 MATMULT_INST.matmult_inst.mem_inst.mem0\[8\] vssd1 vssd1 vccd1 vccd1 net369
+ sky130_fd_sc_hd__dlygate4sd3_1
Xhold52 MATMULT_INST.matmult_inst.fsm_inst.alu_result\[16\] vssd1 vssd1 vccd1 vccd1
+ net347 sky130_fd_sc_hd__dlygate4sd3_1
XANTENNA__1711__B1 net120 vssd1 vssd1 vccd1 vccd1 sky130_fd_sc_hd__diode_2
Xhold63 MATMULT_INST.matmult_inst.mem_inst.mem0\[9\] vssd1 vssd1 vccd1 vccd1 net358
+ sky130_fd_sc_hd__dlygate4sd3_1
Xhold85 MATMULT_INST.matmult_inst.mem_inst.matrixA3\[11\] vssd1 vssd1 vccd1 vccd1
+ net380 sky130_fd_sc_hd__dlygate4sd3_1
Xhold96 MATMULT_INST.matmult_inst.mem_inst.matrixA3\[10\] vssd1 vssd1 vccd1 vccd1
+ net391 sky130_fd_sc_hd__dlygate4sd3_1
XFILLER_75_289 vccd1 vssd1 vccd1 vssd1 sky130_ef_sc_hd__decap_40_12
XTAP_TAPCELL_ROW_18_329 vssd1 vccd1 sky130_fd_sc_hd__tapvpwrvgnd_1
XFILLER_28_161 vssd1 vssd1 vccd1 vccd1 sky130_fd_sc_hd__fill_1
XFILLER_45_51 vssd1 vssd1 vccd1 vccd1 sky130_fd_sc_hd__fill_4
XTAP_TAPCELL_ROW_26_395 vssd1 vccd1 sky130_fd_sc_hd__tapvpwrvgnd_1
XANTENNA__1778__B1 net120 vssd1 vssd1 vccd1 vccd1 sky130_fd_sc_hd__diode_2
XANTENNA__2042__S net22 vssd1 vssd1 vccd1 vccd1 sky130_fd_sc_hd__diode_2
XFILLER_3_260 vssd1 vssd1 vccd1 vccd1 sky130_fd_sc_hd__fill_8
X_3240_ clknet_leaf_4_clk _0162_ vssd1 vssd1 vccd1 vccd1 MATMULT_INST.matmult_inst.mem_inst.matrixB0\[3\]
+ sky130_fd_sc_hd__dfxtp_1
XFILLER_39_404 vssd1 vssd1 vccd1 vccd1 sky130_fd_sc_hd__fill_1
X_3171_ net53 net83 net72 vssd1 vssd1 vccd1 vccd1 _0096_ sky130_fd_sc_hd__and3_1
XFILLER_66_223 vssd1 vssd1 vccd1 vccd1 sky130_fd_sc_hd__fill_1
XFILLER_13_3 vccd1 vssd1 vccd1 vssd1 sky130_ef_sc_hd__decap_40_12
X_2122_ net522 net39 net15 vssd1 vssd1 vccd1 vccd1 _0277_ sky130_fd_sc_hd__mux2_1
X_2053_ net557 net32 net23 vssd1 vssd1 vccd1 vccd1 _0212_ sky130_fd_sc_hd__mux2_1
XFILLER_62_462 vssd1 vssd1 vccd1 vccd1 sky130_fd_sc_hd__fill_1
XFILLER_34_153 vccd1 vssd1 vccd1 vssd1 sky130_ef_sc_hd__decap_40_12
XFILLER_34_197 vssd1 vssd1 vccd1 vccd1 sky130_fd_sc_hd__fill_4
X_2955_ _1484_ _1494_ vssd1 vssd1 vccd1 vccd1 _1495_ sky130_fd_sc_hd__xnor2_1
X_2886_ net158 net178 net181 net157 vssd1 vssd1 vccd1 vccd1 _1428_ sky130_fd_sc_hd__a22o_1
X_1906_ MATMULT_INST.matmult_inst.fsm_inst.state\[4\] MATMULT_INST.matmult_inst.fsm_inst.rx_ready_edge_delay
+ _0737_ _0772_ vssd1 vssd1 vccd1 vccd1 _0783_ sky130_fd_sc_hd__nor4_1
XTAP_TAPCELL_ROW_60_685 vssd1 vccd1 sky130_fd_sc_hd__tapvpwrvgnd_1
X_1837_ MATMULT_INST.matmult_inst.spi_inst.rx_bit_count\[2\] MATMULT_INST.matmult_inst.spi_inst.rx_bit_count\[1\]
+ MATMULT_INST.matmult_inst.spi_inst.rx_bit_count\[0\] vssd1 vssd1 vccd1 vccd1 _0740_
+ sky130_fd_sc_hd__nand3_1
XANTENNA__3048__S net8 vssd1 vssd1 vccd1 vccd1 sky130_fd_sc_hd__diode_2
X_3507_ clknet_leaf_4_clk _0425_ vssd1 vssd1 vccd1 vccd1 MATMULT_INST.matmult_inst.addr\[1\]
+ sky130_fd_sc_hd__dfxtp_1
X_1768_ MATMULT_INST.matmult_inst.mem_inst.mem0\[4\] net108 _0683_ net222 _0684_ vssd1
+ vssd1 vccd1 vccd1 _0685_ sky130_fd_sc_hd__a221o_1
X_1699_ net632 net64 _0620_ _0622_ vssd1 vssd1 vccd1 vccd1 _0501_ sky130_fd_sc_hd__o22a_1
X_3438_ clknet_leaf_27_clk _0360_ vssd1 vssd1 vccd1 vccd1 MATMULT_INST.matmult_inst.alu_inst.b1_reg\[1\]
+ sky130_fd_sc_hd__dfxtp_1
X_3369_ clknet_leaf_7_clk _0291_ vssd1 vssd1 vccd1 vccd1 MATMULT_INST.matmult_inst.mem_inst.mem1\[6\]
+ sky130_fd_sc_hd__dfxtp_1
XTAP_TAPCELL_ROW_68_752 vssd1 vccd1 sky130_fd_sc_hd__tapvpwrvgnd_1
XANTENNA__2127__S net14 vssd1 vssd1 vccd1 vccd1 sky130_fd_sc_hd__diode_2
XFILLER_25_164 vssd1 vssd1 vccd1 vccd1 sky130_fd_sc_hd__fill_4
XFILLER_40_101 vssd1 vssd1 vccd1 vccd1 sky130_fd_sc_hd__fill_2
XFILLER_53_462 vssd1 vssd1 vccd1 vccd1 sky130_fd_sc_hd__fill_1
X_3596__293 vssd1 vssd1 vccd1 vccd1 net293 _3596__293/LO sky130_fd_sc_hd__conb_1
XFILLER_13_337 vssd1 vssd1 vccd1 vccd1 sky130_fd_sc_hd__fill_8
XFILLER_15_43 vssd1 vssd1 vccd1 vccd1 sky130_fd_sc_hd__fill_2
XFILLER_15_65 vccd1 vssd1 vccd1 vssd1 sky130_ef_sc_hd__decap_40_12
XFILLER_9_308 vccd1 vssd1 vccd1 vssd1 sky130_ef_sc_hd__decap_40_12
XFILLER_15_87 vssd1 vssd1 vccd1 vccd1 sky130_fd_sc_hd__fill_1
XTAP_TAPCELL_ROW_23_365 vssd1 vccd1 sky130_fd_sc_hd__tapvpwrvgnd_1
XANTENNA_fanout20_A net21 vssd1 vssd1 vccd1 vccd1 sky130_fd_sc_hd__diode_2
XFILLER_21_370 vssd1 vssd1 vccd1 vccd1 sky130_fd_sc_hd__fill_1
XANTENNA__3185__C net74 vssd1 vssd1 vccd1 vccd1 sky130_fd_sc_hd__diode_2
XFILLER_0_274 vssd1 vssd1 vccd1 vccd1 sky130_fd_sc_hd__fill_4
XFILLER_63_215 vssd1 vssd1 vccd1 vccd1 sky130_fd_sc_hd__fill_1
XFILLER_29_470 vccd1 vssd1 vccd1 vssd1 sky130_ef_sc_hd__decap_40_12
XFILLER_36_429 vssd1 vssd1 vccd1 vccd1 sky130_fd_sc_hd__fill_1
XTAP_TAPCELL_ROW_74_799 vssd1 vccd1 sky130_fd_sc_hd__tapvpwrvgnd_1
XFILLER_16_153 vccd1 vssd1 vccd1 vssd1 sky130_ef_sc_hd__decap_40_12
XANTENNA__2037__S net22 vssd1 vssd1 vccd1 vccd1 sky130_fd_sc_hd__diode_2
XFILLER_16_197 vccd1 vssd1 vccd1 vssd1 sky130_ef_sc_hd__decap_40_12
XFILLER_31_167 vssd1 vssd1 vccd1 vccd1 sky130_fd_sc_hd__fill_1
XANTENNA__2561__A net190 vssd1 vssd1 vccd1 vccd1 sky130_fd_sc_hd__diode_2
X_2740_ _1284_ _1286_ _1275_ vssd1 vssd1 vccd1 vccd1 _1287_ sky130_fd_sc_hd__a21oi_1
XFILLER_8_363 vssd1 vssd1 vccd1 vccd1 sky130_fd_sc_hd__fill_1
X_2671_ net610 _1246_ _1250_ net103 vssd1 vssd1 vccd1 vccd1 _0396_ sky130_fd_sc_hd__a22o_1
X_1622_ net153 net143 MATMULT_INST.matmult_inst.mem_inst.matrixB3\[17\] vssd1 vssd1
+ vccd1 vccd1 _0552_ sky130_fd_sc_hd__and3_1
X_3223_ clknet_leaf_3_clk _0145_ vssd1 vssd1 vccd1 vccd1 MATMULT_INST.matmult_inst.mem_inst.matrixB1\[4\]
+ sky130_fd_sc_hd__dfxtp_1
XANTENNA__1687__C1 _0545_ vssd1 vssd1 vccd1 vccd1 sky130_fd_sc_hd__diode_2
X_3154_ net53 net83 net72 vssd1 vssd1 vccd1 vccd1 _0079_ sky130_fd_sc_hd__and3_1
X_2105_ net421 net37 net17 vssd1 vssd1 vccd1 vccd1 _0261_ sky130_fd_sc_hd__mux2_1
XANTENNA__1640__A net150 vssd1 vssd1 vccd1 vccd1 sky130_fd_sc_hd__diode_2
XTAP_TAPCELL_ROW_65_722 vssd1 vccd1 sky130_fd_sc_hd__tapvpwrvgnd_1
X_3085_ net135 _1581_ _1579_ vssd1 vssd1 vccd1 vccd1 _0526_ sky130_fd_sc_hd__mux2_1
XANTENNA__2455__B net208 vssd1 vssd1 vccd1 vccd1 sky130_fd_sc_hd__diode_2
X_2036_ net536 net49 net22 vssd1 vssd1 vccd1 vccd1 _0195_ sky130_fd_sc_hd__mux2_1
XANTENNA_fanout155_A MATMULT_INST.matmult_inst.alu_inst.a1_reg\[7\] vssd1 vssd1 vccd1
+ vccd1 sky130_fd_sc_hd__diode_2
XFILLER_10_307 vssd1 vssd1 vccd1 vccd1 sky130_fd_sc_hd__fill_1
XANTENNA__1786__S net63 vssd1 vssd1 vccd1 vccd1 sky130_fd_sc_hd__diode_2
X_2938_ net160 net174 _1454_ net162 net171 vssd1 vssd1 vccd1 vccd1 _1478_ sky130_fd_sc_hd__a32o_1
XTAP_TAPCELL_ROW_20_346 vssd1 vccd1 sky130_fd_sc_hd__tapvpwrvgnd_1
X_2869_ _1389_ _1398_ _1409_ _1390_ vssd1 vssd1 vccd1 vccd1 _1411_ sky130_fd_sc_hd__o211ai_1
XANTENNA_fanout208_X net208 vssd1 vssd1 vccd1 vccd1 sky130_fd_sc_hd__diode_2
Xhold352 MATMULT_INST.matmult_inst.alu_inst.adder_inst.r2.fa3.a vssd1 vssd1 vccd1
+ vccd1 net647 sky130_fd_sc_hd__dlygate4sd3_1
Xhold341 MATMULT_INST.matmult_inst.alu_inst.adder_inst.r1.fa2.a vssd1 vssd1 vccd1
+ vccd1 net636 sky130_fd_sc_hd__dlygate4sd3_1
Xhold330 MATMULT_INST.matmult_inst.spi_inst.tx_reg_sys\[4\] vssd1 vssd1 vccd1 vccd1
+ net625 sky130_fd_sc_hd__dlygate4sd3_1
Xhold363 MATMULT_INST.matmult_inst.alu_inst.adder_inst.r0.fa1.b vssd1 vssd1 vccd1
+ vccd1 net658 sky130_fd_sc_hd__dlygate4sd3_1
Xhold374 MATMULT_INST.matmult_inst.fsm_inst.count\[3\] vssd1 vssd1 vccd1 vccd1 net669
+ sky130_fd_sc_hd__dlygate4sd3_1
XANTENNA_hold367_A MATMULT_INST.matmult_inst.spi_inst.current_state vssd1 vssd1 vccd1
+ vccd1 sky130_fd_sc_hd__diode_2
XFILLER_18_418 vssd1 vssd1 vccd1 vccd1 sky130_fd_sc_hd__fill_2
XTAP_TAPCELL_ROW_28_413 vssd1 vccd1 sky130_fd_sc_hd__tapvpwrvgnd_1
XFILLER_26_484 vssd1 vssd1 vccd1 vccd1 sky130_fd_sc_hd__fill_8
XFILLER_53_281 vssd1 vssd1 vccd1 vccd1 sky130_fd_sc_hd__fill_4
XANTENNA_fanout23_X net23 vssd1 vssd1 vccd1 vccd1 sky130_fd_sc_hd__diode_2
XFILLER_9_105 vssd1 vssd1 vccd1 vccd1 sky130_fd_sc_hd__fill_4
XFILLER_41_476 vssd1 vssd1 vccd1 vccd1 sky130_fd_sc_hd__fill_2
XANTENNA_clkbuf_leaf_5_clk_A clknet_2_1__leaf_clk vssd1 vssd1 vccd1 vccd1 sky130_fd_sc_hd__diode_2
XANTENNA__1725__A net152 vssd1 vssd1 vccd1 vccd1 sky130_fd_sc_hd__diode_2
XANTENNA__2320__S net67 vssd1 vssd1 vccd1 vccd1 sky130_fd_sc_hd__diode_2
XTAP_TAPCELL_ROW_79_847 vssd1 vccd1 sky130_fd_sc_hd__tapvpwrvgnd_1
XFILLER_36_226 vssd1 vssd1 vccd1 vccd1 sky130_fd_sc_hd__fill_4
XTAP_TAPCELL_ROW_62_703 vssd1 vccd1 sky130_fd_sc_hd__tapvpwrvgnd_1
XFILLER_51_207 vssd1 vssd1 vccd1 vccd1 sky130_fd_sc_hd__fill_2
XANTENNA__2633__A1 net200 vssd1 vssd1 vccd1 vccd1 sky130_fd_sc_hd__diode_2
XFILLER_32_421 vccd1 vssd1 vccd1 vssd1 sky130_ef_sc_hd__decap_40_12
X_2723_ net168 net183 net167 net184 vssd1 vssd1 vccd1 vccd1 _1272_ sky130_fd_sc_hd__and4_1
XANTENNA__1619__B net140 vssd1 vssd1 vccd1 vccd1 sky130_fd_sc_hd__diode_2
X_2654_ net670 net114 vssd1 vssd1 vccd1 vccd1 _1241_ sky130_fd_sc_hd__and2_1
X_2585_ net659 _1175_ net94 vssd1 vssd1 vccd1 vccd1 _0385_ sky130_fd_sc_hd__mux2_1
X_1605_ MATMULT_INST.matmult_inst.fsm_inst.count\[2\] MATMULT_INST.matmult_inst.fsm_inst.count\[3\]
+ vssd1 vssd1 vccd1 vccd1 _0536_ sky130_fd_sc_hd__or2_2
Xfanout128 net131 vssd1 vssd1 vccd1 vccd1 net128 sky130_fd_sc_hd__buf_2
Xfanout117 net123 vssd1 vssd1 vccd1 vccd1 net117 sky130_fd_sc_hd__dlymetal6s2s_1
Xfanout106 net107 vssd1 vssd1 vccd1 vccd1 net106 sky130_fd_sc_hd__clkbuf_2
Xfanout139 net140 vssd1 vssd1 vccd1 vccd1 net139 sky130_fd_sc_hd__buf_1
X_3206_ clknet_leaf_1_clk _0128_ vssd1 vssd1 vccd1 vccd1 MATMULT_INST.matmult_inst.mem_inst.matrixB2\[5\]
+ sky130_fd_sc_hd__dfxtp_1
XANTENNA__3061__S net9 vssd1 vssd1 vccd1 vccd1 sky130_fd_sc_hd__diode_2
X_3137_ net225 vssd1 vssd1 vccd1 vccd1 _0058_ sky130_fd_sc_hd__inv_2
XANTENNA__1675__A2 net108 vssd1 vssd1 vccd1 vccd1 sky130_fd_sc_hd__diode_2
X_3068_ net334 net52 net7 MATMULT_INST.matmult_inst.fsm_inst.alu_result\[4\] vssd1
+ vssd1 vccd1 vccd1 _0512_ sky130_fd_sc_hd__a22o_1
XFILLER_23_410 vccd1 vssd1 vccd1 vssd1 sky130_ef_sc_hd__decap_40_12
XFILLER_35_281 vssd1 vssd1 vccd1 vccd1 sky130_fd_sc_hd__fill_4
X_2019_ net318 net47 net24 vssd1 vssd1 vccd1 vccd1 _0179_ sky130_fd_sc_hd__mux2_1
XFILLER_23_465 vssd1 vssd1 vccd1 vccd1 sky130_fd_sc_hd__fill_2
XFILLER_50_262 vssd1 vssd1 vccd1 vccd1 sky130_fd_sc_hd__fill_8
XANTENNA__2351__D net210 vssd1 vssd1 vccd1 vccd1 sky130_fd_sc_hd__diode_2
Xhold160 MATMULT_INST.matmult_inst.mem_inst.matrixB3\[11\] vssd1 vssd1 vccd1 vccd1
+ net455 sky130_fd_sc_hd__dlygate4sd3_1
Xhold171 MATMULT_INST.matmult_inst.mem_inst.matrixB2\[4\] vssd1 vssd1 vccd1 vccd1
+ net466 sky130_fd_sc_hd__dlygate4sd3_1
XANTENNA__2140__S net13 vssd1 vssd1 vccd1 vccd1 sky130_fd_sc_hd__diode_2
Xhold182 MATMULT_INST.matmult_inst.fsm_inst.alu_result\[2\] vssd1 vssd1 vccd1 vccd1
+ net477 sky130_fd_sc_hd__dlygate4sd3_1
Xhold193 MATMULT_INST.matmult_inst.mem_inst.matrixA1\[0\] vssd1 vssd1 vccd1 vccd1
+ net488 sky130_fd_sc_hd__dlygate4sd3_1
XTAP_TAPCELL_ROW_76_817 vssd1 vccd1 sky130_fd_sc_hd__tapvpwrvgnd_1
XANTENNA__2312__B1 _0928_ vssd1 vssd1 vccd1 vccd1 sky130_fd_sc_hd__diode_2
XFILLER_26_270 vssd1 vssd1 vccd1 vccd1 sky130_fd_sc_hd__fill_4
XANTENNA__2050__S net23 vssd1 vssd1 vccd1 vccd1 sky130_fd_sc_hd__diode_2
XFILLER_5_174 vssd1 vssd1 vccd1 vccd1 sky130_fd_sc_hd__fill_4
X_2370_ _0965_ _0966_ vssd1 vssd1 vccd1 vccd1 _0967_ sky130_fd_sc_hd__nand2b_1
XFILLER_1_380 vssd1 vssd1 vccd1 vccd1 sky130_fd_sc_hd__fill_1
XFILLER_1_391 vssd1 vssd1 vccd1 vccd1 sky130_fd_sc_hd__fill_1
XTAP_TAPCELL_ROW_47_574 vssd1 vccd1 sky130_fd_sc_hd__tapvpwrvgnd_1
XFILLER_17_281 vssd1 vssd1 vccd1 vccd1 sky130_fd_sc_hd__fill_1
XTAP_TAPCELL_ROW_30_430 vssd1 vccd1 sky130_fd_sc_hd__tapvpwrvgnd_1
XFILLER_20_468 vssd1 vssd1 vccd1 vccd1 sky130_fd_sc_hd__fill_4
X_2706_ MATMULT_INST.matmult_inst.fsm_inst.tx_start_send _0549_ net103 _0544_ vssd1
+ vssd1 vccd1 vccd1 _1258_ sky130_fd_sc_hd__a31o_1
XPHY_EDGE_ROW_12_Right_12 vssd1 vssd1 vccd1 vccd1 sky130_fd_sc_hd__decap_3
X_2637_ _1180_ _1213_ _1211_ vssd1 vssd1 vccd1 vccd1 _1225_ sky130_fd_sc_hd__o21a_1
XANTENNA_fanout118_A net123 vssd1 vssd1 vccd1 vccd1 sky130_fd_sc_hd__diode_2
XANTENNA__3056__S net9 vssd1 vssd1 vccd1 vccd1 sky130_fd_sc_hd__diode_2
X_2568_ _1157_ _1158_ _1153_ vssd1 vssd1 vccd1 vccd1 _1159_ sky130_fd_sc_hd__a21oi_1
X_2499_ net188 net186 net208 net210 vssd1 vssd1 vccd1 vccd1 _1092_ sky130_fd_sc_hd__and4_1
XFILLER_67_181 vssd1 vssd1 vccd1 vccd1 sky130_fd_sc_hd__fill_2
XTAP_TAPCELL_ROW_2_188 vssd1 vccd1 sky130_fd_sc_hd__tapvpwrvgnd_1
XPHY_EDGE_ROW_21_Right_21 vssd1 vssd1 vccd1 vccd1 sky130_fd_sc_hd__decap_3
XANTENNA__2135__S net12 vssd1 vssd1 vccd1 vccd1 sky130_fd_sc_hd__diode_2
XFILLER_11_446 vssd1 vssd1 vccd1 vccd1 sky130_fd_sc_hd__fill_2
XFILLER_23_54 vssd1 vssd1 vccd1 vccd1 sky130_fd_sc_hd__fill_2
XFILLER_23_65 vssd1 vssd1 vccd1 vccd1 sky130_fd_sc_hd__fill_2
XANTENNA__3615__CLK net228 vssd1 vssd1 vccd1 vccd1 sky130_fd_sc_hd__diode_2
XPHY_EDGE_ROW_30_Right_30 vssd1 vssd1 vccd1 vccd1 sky130_fd_sc_hd__decap_3
XFILLER_2_133 vssd1 vssd1 vccd1 vccd1 sky130_fd_sc_hd__fill_2
XFILLER_78_457 vccd1 vssd1 vccd1 vssd1 sky130_ef_sc_hd__decap_40_12
XFILLER_65_129 vssd1 vssd1 vccd1 vccd1 sky130_fd_sc_hd__fill_1
XFILLER_0_69 vccd1 vssd1 vccd1 vssd1 sky130_ef_sc_hd__decap_40_12
XFILLER_61_335 vssd1 vssd1 vccd1 vccd1 sky130_fd_sc_hd__fill_1
XTAP_TAPCELL_ROW_44_544 vssd1 vccd1 sky130_fd_sc_hd__tapvpwrvgnd_1
XANTENNA__2045__S net22 vssd1 vssd1 vccd1 vccd1 sky130_fd_sc_hd__diode_2
X_1870_ net299 MATMULT_INST.matmult_inst.spi_inst.current_state vssd1 vssd1 vccd1
+ vccd1 _0005_ sky130_fd_sc_hd__nor2_1
X_3540_ _0048_ _0454_ _0047_ vssd1 vssd1 vccd1 vccd1 MATMULT_INST.matmult_inst.spi_inst.mosi_data_spi\[7\]
+ sky130_fd_sc_hd__dfrtp_1
X_3471_ clknet_leaf_17_clk net301 vssd1 vssd1 vccd1 vccd1 MATMULT_INST.matmult_inst.fsm_inst.rx_ready_edge_delay
+ sky130_fd_sc_hd__dfxtp_1
X_2422_ net197 net203 net204 net195 vssd1 vssd1 vccd1 vccd1 _1017_ sky130_fd_sc_hd__a22o_1
XFILLER_43_3 vssd1 vssd1 vccd1 vccd1 sky130_fd_sc_hd__fill_8
X_2353_ _0949_ _0950_ _0939_ vssd1 vssd1 vccd1 vccd1 _0951_ sky130_fd_sc_hd__a21oi_1
X_2284_ MATMULT_INST.matmult_inst.alu_inst.adder_inst.r3.fa0.b MATMULT_INST.matmult_inst.alu_inst.adder_inst.r3.fa0.a
+ vssd1 vssd1 vccd1 vccd1 _0908_ sky130_fd_sc_hd__nand2_1
XANTENNA__2287__Y _0911_ vssd1 vssd1 vccd1 vccd1 sky130_fd_sc_hd__diode_2
XFILLER_60_19 vssd1 vssd1 vccd1 vccd1 sky130_fd_sc_hd__fill_1
XFILLER_20_298 vssd1 vssd1 vccd1 vccd1 sky130_fd_sc_hd__fill_8
X_1999_ net48 net500 net26 vssd1 vssd1 vccd1 vccd1 _0160_ sky130_fd_sc_hd__mux2_1
XFILLER_69_39 vssd1 vssd1 vccd1 vccd1 sky130_fd_sc_hd__fill_1
XFILLER_75_449 vccd1 vssd1 vccd1 vssd1 sky130_ef_sc_hd__decap_40_12
XFILLER_18_54 vccd1 vssd1 vccd1 vssd1 sky130_ef_sc_hd__decap_40_12
XTAP_TAPCELL_ROW_58_669 vssd1 vccd1 sky130_fd_sc_hd__tapvpwrvgnd_1
XANTENNA__1969__S net30 vssd1 vssd1 vccd1 vccd1 sky130_fd_sc_hd__diode_2
XFILLER_55_173 vssd1 vssd1 vccd1 vccd1 sky130_fd_sc_hd__fill_1
XFILLER_70_176 vccd1 vssd1 vccd1 vssd1 sky130_ef_sc_hd__decap_40_12
XFILLER_34_64 vccd1 vssd1 vccd1 vssd1 sky130_ef_sc_hd__decap_40_12
XANTENNA__3188__C net74 vssd1 vssd1 vccd1 vccd1 sky130_fd_sc_hd__diode_2
XFILLER_11_210 vssd1 vssd1 vccd1 vccd1 sky130_fd_sc_hd__fill_2
XFILLER_11_265 vssd1 vssd1 vccd1 vccd1 sky130_fd_sc_hd__fill_4
XFILLER_11_287 vssd1 vssd1 vccd1 vccd1 sky130_fd_sc_hd__fill_1
XFILLER_7_236 vccd1 vssd1 vccd1 vssd1 sky130_ef_sc_hd__decap_40_12
XFILLER_50_96 vssd1 vssd1 vccd1 vccd1 sky130_fd_sc_hd__fill_4
XFILLER_19_310 vccd1 vssd1 vccd1 vssd1 sky130_ef_sc_hd__decap_40_12
XFILLER_19_343 vccd1 vssd1 vccd1 vssd1 sky130_ef_sc_hd__decap_40_12
XFILLER_19_365 vccd1 vssd1 vccd1 vssd1 sky130_ef_sc_hd__decap_40_12
X_2971_ net160 net170 net158 net172 vssd1 vssd1 vccd1 vccd1 _1510_ sky130_fd_sc_hd__a22oi_1
X_1922_ MATMULT_INST.matmult_inst.spi_inst.tx_reg_sys\[1\] MATMULT_INST.matmult_inst.spi_inst.miso_shifter\[0\]
+ net136 vssd1 vssd1 vccd1 vccd1 _0014_ sky130_fd_sc_hd__mux2_1
X_1853_ MATMULT_INST.matmult_inst.spi_inst.mosi_shifter\[4\] MATMULT_INST.matmult_inst.spi_inst.mosi_data_spi\[5\]
+ _0744_ vssd1 vssd1 vccd1 vccd1 _0452_ sky130_fd_sc_hd__mux2_1
XTAP_TAPCELL_ROW_12_271 vssd1 vccd1 sky130_fd_sc_hd__tapvpwrvgnd_1
XANTENNA__2745__B1 net97 vssd1 vssd1 vccd1 vccd1 sky130_fd_sc_hd__diode_2
X_1784_ net217 _0694_ _0698_ net219 vssd1 vssd1 vccd1 vccd1 _0700_ sky130_fd_sc_hd__a22o_1
X_3523_ clknet_leaf_35_clk _0440_ vssd1 vssd1 vccd1 vccd1 MATMULT_INST.matmult_inst.alu_inst.adder_inst.r3.fa2.b
+ sky130_fd_sc_hd__dfxtp_1
XFILLER_6_280 vssd1 vssd1 vccd1 vccd1 sky130_fd_sc_hd__fill_1
Xfanout8 _1577_ vssd1 vssd1 vccd1 vccd1 net8 sky130_fd_sc_hd__buf_4
X_3454_ clknet_leaf_27_clk _0375_ vssd1 vssd1 vccd1 vccd1 MATMULT_INST.matmult_inst.alu_inst.adder_inst.r0.fa0.a
+ sky130_fd_sc_hd__dfxtp_1
X_2405_ MATMULT_INST.matmult_inst.alu_inst.adder_inst.r1.fa1.a net96 _0999_ _1000_
+ vssd1 vssd1 vccd1 vccd1 _0380_ sky130_fd_sc_hd__o22a_1
XTAP_TAPCELL_ROW_4_206 vssd1 vccd1 sky130_fd_sc_hd__tapvpwrvgnd_1
X_3385_ clknet_leaf_4_clk _0307_ vssd1 vssd1 vccd1 vccd1 MATMULT_INST.matmult_inst.mem_inst.mem0\[4\]
+ sky130_fd_sc_hd__dfxtp_1
X_2336_ net213 net197 net196 net215 vssd1 vssd1 vccd1 vccd1 _0936_ sky130_fd_sc_hd__and4_1
X_2267_ _0892_ _0893_ vssd1 vssd1 vccd1 vccd1 _0894_ sky130_fd_sc_hd__nand2b_1
X_2198_ net205 net559 net65 vssd1 vssd1 vccd1 vccd1 _0330_ sky130_fd_sc_hd__mux2_1
XFILLER_37_184 vssd1 vssd1 vccd1 vccd1 sky130_fd_sc_hd__fill_2
XTAP_TAPCELL_ROW_55_639 vssd1 vccd1 sky130_fd_sc_hd__tapvpwrvgnd_1
XFILLER_25_335 vssd1 vssd1 vccd1 vccd1 sky130_fd_sc_hd__fill_1
XANTENNA_fanout140_X net140 vssd1 vssd1 vccd1 vccd1 sky130_fd_sc_hd__diode_2
XFILLER_0_445 vssd1 vssd1 vccd1 vccd1 sky130_fd_sc_hd__fill_2
XFILLER_75_202 vssd1 vssd1 vccd1 vccd1 sky130_fd_sc_hd__fill_4
Xhold20 MATMULT_INST.matmult_inst.mem_inst.mem3\[13\] vssd1 vssd1 vccd1 vccd1 net315
+ sky130_fd_sc_hd__dlygate4sd3_1
XFILLER_48_427 vssd1 vssd1 vccd1 vccd1 sky130_fd_sc_hd__fill_2
Xhold31 MATMULT_INST.matmult_inst.mem_inst.mem3\[0\] vssd1 vssd1 vccd1 vccd1 net326
+ sky130_fd_sc_hd__dlygate4sd3_1
Xhold64 MATMULT_INST.matmult_inst.alu_inst.col0\[2\] vssd1 vssd1 vccd1 vccd1 net359
+ sky130_fd_sc_hd__dlygate4sd3_1
Xhold42 MATMULT_INST.matmult_inst.fsm_inst.alu_result\[17\] vssd1 vssd1 vccd1 vccd1
+ net337 sky130_fd_sc_hd__dlygate4sd3_1
Xhold53 _0524_ vssd1 vssd1 vccd1 vccd1 net348 sky130_fd_sc_hd__dlygate4sd3_1
Xhold75 MATMULT_INST.matmult_inst.mem_inst.mem3\[2\] vssd1 vssd1 vccd1 vccd1 net370
+ sky130_fd_sc_hd__dlygate4sd3_1
Xhold97 MATMULT_INST.matmult_inst.mem_inst.mem1\[1\] vssd1 vssd1 vccd1 vccd1 net392
+ sky130_fd_sc_hd__dlygate4sd3_1
Xhold86 MATMULT_INST.matmult_inst.mem_inst.matrixB0\[9\] vssd1 vssd1 vccd1 vccd1 net381
+ sky130_fd_sc_hd__dlygate4sd3_1
XFILLER_56_482 vccd1 vssd1 vccd1 vssd1 sky130_ef_sc_hd__decap_40_12
XTAP_TAPCELL_ROW_26_396 vssd1 vccd1 sky130_fd_sc_hd__tapvpwrvgnd_1
XANTENNA__2323__S net67 vssd1 vssd1 vccd1 vccd1 sky130_fd_sc_hd__diode_2
X_3170_ net53 net83 net72 vssd1 vssd1 vccd1 vccd1 _0095_ sky130_fd_sc_hd__and3_1
XFILLER_39_438 vssd1 vssd1 vccd1 vccd1 sky130_fd_sc_hd__fill_2
XFILLER_39_449 vssd1 vssd1 vccd1 vccd1 sky130_fd_sc_hd__fill_1
X_2121_ net511 net40 net15 vssd1 vssd1 vccd1 vccd1 _0276_ sky130_fd_sc_hd__mux2_1
X_2052_ net591 net33 net23 vssd1 vssd1 vccd1 vccd1 _0211_ sky130_fd_sc_hd__mux2_1
XFILLER_47_493 vssd1 vssd1 vccd1 vccd1 sky130_fd_sc_hd__fill_1
XFILLER_34_165 vssd1 vssd1 vccd1 vccd1 sky130_fd_sc_hd__fill_2
X_2954_ _1485_ _1491_ vssd1 vssd1 vccd1 vccd1 _1494_ sky130_fd_sc_hd__xnor2_1
XANTENNA__1638__A net150 vssd1 vssd1 vccd1 vccd1 sky130_fd_sc_hd__diode_2
X_2885_ _1425_ _1426_ vssd1 vssd1 vccd1 vccd1 _1427_ sky130_fd_sc_hd__nand2_1
X_1905_ net101 _0771_ _0777_ _0782_ vssd1 vssd1 vccd1 vccd1 _0001_ sky130_fd_sc_hd__a31o_1
XTAP_TAPCELL_ROW_60_686 vssd1 vccd1 sky130_fd_sc_hd__tapvpwrvgnd_1
X_1836_ net59 net90 net80 vssd1 vssd1 vccd1 vccd1 _0065_ sky130_fd_sc_hd__and3_1
XPHY_EDGE_ROW_6_Right_6 vssd1 vssd1 vccd1 vccd1 sky130_fd_sc_hd__decap_3
X_1767_ MATMULT_INST.matmult_inst.mem_inst.matrixA0\[4\] net112 net104 MATMULT_INST.matmult_inst.mem_inst.matrixB0\[4\]
+ vssd1 vssd1 vccd1 vccd1 _0684_ sky130_fd_sc_hd__a22o_1
X_3506_ clknet_leaf_17_clk _0424_ vssd1 vssd1 vccd1 vccd1 MATMULT_INST.matmult_inst.addr\[0\]
+ sky130_fd_sc_hd__dfxtp_1
X_1698_ net373 net105 _0621_ _0545_ vssd1 vssd1 vccd1 vccd1 _0622_ sky130_fd_sc_hd__a211o_1
X_3437_ clknet_leaf_27_clk _0359_ vssd1 vssd1 vccd1 vccd1 MATMULT_INST.matmult_inst.alu_inst.b1_reg\[0\]
+ sky130_fd_sc_hd__dfxtp_1
XFILLER_66_18 vssd1 vssd1 vccd1 vccd1 sky130_fd_sc_hd__fill_2
X_3368_ clknet_leaf_1_clk _0290_ vssd1 vssd1 vccd1 vccd1 MATMULT_INST.matmult_inst.mem_inst.mem1\[5\]
+ sky130_fd_sc_hd__dfxtp_1
XFILLER_57_202 vssd1 vssd1 vccd1 vccd1 sky130_fd_sc_hd__fill_4
X_2319_ net176 net610 net67 vssd1 vssd1 vccd1 vccd1 _0363_ sky130_fd_sc_hd__mux2_1
XTAP_TAPCELL_ROW_68_753 vssd1 vccd1 sky130_fd_sc_hd__tapvpwrvgnd_1
X_3299_ clknet_leaf_14_clk _0221_ vssd1 vssd1 vccd1 vccd1 MATMULT_INST.matmult_inst.mem_inst.matrixA1\[8\]
+ sky130_fd_sc_hd__dfxtp_1
XFILLER_38_493 vssd1 vssd1 vccd1 vccd1 sky130_fd_sc_hd__fill_1
XFILLER_13_316 vssd1 vssd1 vccd1 vccd1 sky130_fd_sc_hd__fill_1
XFILLER_53_452 vssd1 vssd1 vccd1 vccd1 sky130_fd_sc_hd__fill_8
XFILLER_15_55 vssd1 vssd1 vccd1 vccd1 sky130_fd_sc_hd__fill_1
XFILLER_15_77 vssd1 vssd1 vccd1 vccd1 sky130_fd_sc_hd__fill_8
XTAP_TAPCELL_ROW_23_366 vssd1 vccd1 sky130_fd_sc_hd__tapvpwrvgnd_1
XANTENNA__2143__S net13 vssd1 vssd1 vccd1 vccd1 sky130_fd_sc_hd__diode_2
XFILLER_31_54 vssd1 vssd1 vccd1 vccd1 sky130_fd_sc_hd__fill_2
XANTENNA__1982__S net28 vssd1 vssd1 vccd1 vccd1 sky130_fd_sc_hd__diode_2
XFILLER_0_297 vssd1 vssd1 vccd1 vccd1 sky130_fd_sc_hd__fill_1
XANTENNA__2666__X _1248_ vssd1 vssd1 vccd1 vccd1 sky130_fd_sc_hd__diode_2
XFILLER_36_408 vccd1 vssd1 vccd1 vssd1 sky130_ef_sc_hd__decap_40_12
XFILLER_48_257 vssd1 vssd1 vccd1 vccd1 sky130_fd_sc_hd__fill_1
XFILLER_29_482 vccd1 vssd1 vccd1 vssd1 sky130_ef_sc_hd__decap_40_12
XANTENNA__2318__S net67 vssd1 vssd1 vccd1 vccd1 sky130_fd_sc_hd__diode_2
XFILLER_16_165 vccd1 vssd1 vccd1 vssd1 sky130_ef_sc_hd__decap_40_12
XFILLER_31_113 vssd1 vssd1 vccd1 vccd1 sky130_fd_sc_hd__fill_1
XFILLER_72_83 vssd1 vssd1 vccd1 vccd1 sky130_fd_sc_hd__fill_1
XPHY_EDGE_ROW_59_Right_59 vssd1 vssd1 vccd1 vccd1 sky130_fd_sc_hd__decap_3
XANTENNA__2053__S net23 vssd1 vssd1 vccd1 vccd1 sky130_fd_sc_hd__diode_2
XFILLER_75_6 vssd1 vssd1 vccd1 vccd1 sky130_fd_sc_hd__fill_8
XFILLER_12_393 vssd1 vssd1 vccd1 vccd1 sky130_fd_sc_hd__fill_4
X_2670_ _0691_ net101 vssd1 vssd1 vccd1 vccd1 _1250_ sky130_fd_sc_hd__and2_2
X_1621_ MATMULT_INST.matmult_inst.mem_inst.mem1\[17\] net129 net121 MATMULT_INST.matmult_inst.mem_inst.mem2\[17\]
+ _0550_ vssd1 vssd1 vccd1 vccd1 _0551_ sky130_fd_sc_hd__a221o_1
X_3222_ clknet_leaf_3_clk _0144_ vssd1 vssd1 vccd1 vccd1 MATMULT_INST.matmult_inst.mem_inst.matrixB1\[3\]
+ sky130_fd_sc_hd__dfxtp_1
XFILLER_79_393 vccd1 vssd1 vccd1 vssd1 sky130_ef_sc_hd__decap_40_12
XPHY_EDGE_ROW_68_Right_68 vssd1 vssd1 vccd1 vccd1 sky130_fd_sc_hd__decap_3
X_3153_ net53 net83 net72 vssd1 vssd1 vccd1 vccd1 _0078_ sky130_fd_sc_hd__and3_1
X_2104_ net323 net38 net17 vssd1 vssd1 vccd1 vccd1 _0260_ sky130_fd_sc_hd__mux2_1
XTAP_TAPCELL_ROW_65_723 vssd1 vccd1 sky130_fd_sc_hd__tapvpwrvgnd_1
X_3084_ net134 net133 net102 _0542_ vssd1 vssd1 vccd1 vccd1 _1581_ sky130_fd_sc_hd__a31o_1
X_2035_ net123 _0558_ net50 vssd1 vssd1 vccd1 vccd1 _0818_ sky130_fd_sc_hd__and3_1
XFILLER_22_124 vssd1 vssd1 vccd1 vccd1 sky130_fd_sc_hd__fill_1
XPHY_EDGE_ROW_77_Right_77 vssd1 vssd1 vccd1 vccd1 sky130_fd_sc_hd__decap_3
XANTENNA_fanout148_A net149 vssd1 vssd1 vccd1 vccd1 sky130_fd_sc_hd__diode_2
XANTENNA__3059__S net9 vssd1 vssd1 vccd1 vccd1 sky130_fd_sc_hd__diode_2
XFILLER_10_319 vssd1 vssd1 vccd1 vccd1 sky130_fd_sc_hd__fill_1
X_2937_ _1441_ _1450_ _1469_ vssd1 vssd1 vccd1 vccd1 _1477_ sky130_fd_sc_hd__o21bai_1
XFILLER_50_477 vssd1 vssd1 vccd1 vccd1 sky130_fd_sc_hd__fill_2
X_2868_ _1389_ _1398_ _1409_ _1390_ vssd1 vssd1 vccd1 vccd1 _1410_ sky130_fd_sc_hd__o211a_1
XANTENNA__1655__X _0583_ vssd1 vssd1 vccd1 vccd1 sky130_fd_sc_hd__diode_2
X_2799_ _1340_ _1341_ _1342_ _1325_ vssd1 vssd1 vccd1 vccd1 _1343_ sky130_fd_sc_hd__a22o_1
Xhold320 MATMULT_INST.matmult_inst.alu_inst.adder_inst.r2.fa3.b vssd1 vssd1 vccd1
+ vccd1 net615 sky130_fd_sc_hd__dlygate4sd3_1
X_1819_ MATMULT_INST.matmult_inst.fsm_inst.rx_data\[7\] net611 MATMULT_INST.matmult_inst.spi_inst.rx_done_sys
+ vssd1 vssd1 vccd1 vccd1 _0489_ sky130_fd_sc_hd__mux2_1
XPHY_EDGE_ROW_15_Left_95 vssd1 vssd1 vccd1 vccd1 sky130_fd_sc_hd__decap_3
XANTENNA_fanout103_X net103 vssd1 vssd1 vccd1 vccd1 sky130_fd_sc_hd__diode_2
Xhold353 MATMULT_INST.matmult_inst.alu_inst.adder_inst.r0.fa2.b vssd1 vssd1 vccd1
+ vccd1 net648 sky130_fd_sc_hd__dlygate4sd3_1
XANTENNA__2706__A3 net103 vssd1 vssd1 vccd1 vccd1 sky130_fd_sc_hd__diode_2
Xhold331 MATMULT_INST.matmult_inst.alu_inst.out\[16\] vssd1 vssd1 vccd1 vccd1 net626
+ sky130_fd_sc_hd__dlygate4sd3_1
Xhold342 MATMULT_INST.matmult_inst.spi_inst.tx_reg_sys\[5\] vssd1 vssd1 vccd1 vccd1
+ net637 sky130_fd_sc_hd__dlygate4sd3_1
Xhold375 MATMULT_INST.matmult_inst.alu_inst.adder_inst.r3.fa2.a vssd1 vssd1 vccd1
+ vccd1 net670 sky130_fd_sc_hd__dlygate4sd3_1
Xhold364 MATMULT_INST.matmult_inst.alu_inst.adder_inst.r2.fa2.a vssd1 vssd1 vccd1
+ vccd1 net659 sky130_fd_sc_hd__dlygate4sd3_1
XFILLER_18_408 vssd1 vssd1 vccd1 vccd1 sky130_fd_sc_hd__fill_1
XTAP_TAPCELL_ROW_28_414 vssd1 vccd1 sky130_fd_sc_hd__tapvpwrvgnd_1
XANTENNA__2138__S net12 vssd1 vssd1 vccd1 vccd1 sky130_fd_sc_hd__diode_2
XFILLER_26_452 vccd1 vssd1 vccd1 vssd1 sky130_ef_sc_hd__decap_40_12
XFILLER_60_219 vssd1 vssd1 vccd1 vccd1 sky130_fd_sc_hd__fill_4
XANTENNA__1977__S net31 vssd1 vssd1 vccd1 vccd1 sky130_fd_sc_hd__diode_2
XFILLER_13_113 vssd1 vssd1 vccd1 vccd1 sky130_fd_sc_hd__fill_8
XFILLER_26_98 vccd1 vssd1 vccd1 vssd1 sky130_ef_sc_hd__decap_40_12
XTAP_TAPCELL_ROW_36_480 vssd1 vccd1 sky130_fd_sc_hd__tapvpwrvgnd_1
XANTENNA_fanout16_X net16 vssd1 vssd1 vccd1 vccd1 sky130_fd_sc_hd__diode_2
XFILLER_5_312 vssd1 vssd1 vccd1 vccd1 sky130_fd_sc_hd__fill_1
XFILLER_5_367 vccd1 vssd1 vccd1 vssd1 sky130_ef_sc_hd__decap_40_12
XANTENNA__1725__B net143 vssd1 vssd1 vccd1 vccd1 sky130_fd_sc_hd__diode_2
XTAP_TAPCELL_ROW_79_848 vssd1 vccd1 sky130_fd_sc_hd__tapvpwrvgnd_1
XFILLER_67_94 vssd1 vssd1 vccd1 vccd1 sky130_fd_sc_hd__fill_4
XANTENNA__2048__S net23 vssd1 vssd1 vccd1 vccd1 sky130_fd_sc_hd__diode_2
XFILLER_32_433 vccd1 vssd1 vccd1 vssd1 sky130_ef_sc_hd__decap_40_12
XTAP_TAPCELL_ROW_70_770 vssd1 vccd1 sky130_fd_sc_hd__tapvpwrvgnd_1
XFILLER_32_477 vccd1 vssd1 vccd1 vssd1 sky130_ef_sc_hd__decap_40_12
X_2722_ net168 net183 net167 MATMULT_INST.matmult_inst.alu_inst.b1_reg\[0\] vssd1
+ vssd1 vccd1 vccd1 _1271_ sky130_fd_sc_hd__a22o_1
XFILLER_73_3 vccd1 vssd1 vccd1 vssd1 sky130_ef_sc_hd__decap_40_12
X_2653_ _1231_ _1235_ _1237_ vssd1 vssd1 vccd1 vccd1 _1240_ sky130_fd_sc_hd__nand3_1
X_1604_ net226 vssd1 vssd1 vccd1 vccd1 _0025_ sky130_fd_sc_hd__inv_2
X_2584_ _1171_ _1174_ vssd1 vssd1 vccd1 vccd1 _1175_ sky130_fd_sc_hd__xnor2_1
Xfanout129 net131 vssd1 vssd1 vccd1 vccd1 net129 sky130_fd_sc_hd__clkbuf_4
Xfanout107 _0561_ vssd1 vssd1 vccd1 vccd1 net107 sky130_fd_sc_hd__buf_2
Xfanout118 net123 vssd1 vssd1 vccd1 vccd1 net118 sky130_fd_sc_hd__clkbuf_4
XFILLER_67_341 vssd1 vssd1 vccd1 vccd1 sky130_fd_sc_hd__fill_2
X_3205_ clknet_leaf_3_clk _0127_ vssd1 vssd1 vccd1 vccd1 MATMULT_INST.matmult_inst.mem_inst.matrixB2\[4\]
+ sky130_fd_sc_hd__dfxtp_1
X_3136_ net225 vssd1 vssd1 vccd1 vccd1 _0056_ sky130_fd_sc_hd__inv_2
X_3067_ net361 net52 net7 MATMULT_INST.matmult_inst.fsm_inst.alu_result\[3\] vssd1
+ vssd1 vccd1 vccd1 _0511_ sky130_fd_sc_hd__a22o_1
X_2018_ net426 net48 net25 vssd1 vssd1 vccd1 vccd1 _0178_ sky130_fd_sc_hd__mux2_1
XFILLER_23_422 vssd1 vssd1 vccd1 vccd1 sky130_fd_sc_hd__fill_2
XANTENNA__1797__S net63 vssd1 vssd1 vccd1 vccd1 sky130_fd_sc_hd__diode_2
XTAP_TAPCELL_ROW_33_450 vssd1 vccd1 sky130_fd_sc_hd__tapvpwrvgnd_1
XFILLER_10_138 vssd1 vssd1 vccd1 vccd1 sky130_fd_sc_hd__fill_2
XANTENNA_fanout220_X net220 vssd1 vssd1 vccd1 vccd1 sky130_fd_sc_hd__diode_2
XFILLER_5_6 vccd1 vssd1 vccd1 vssd1 sky130_ef_sc_hd__decap_40_12
Xhold161 MATMULT_INST.matmult_inst.mem_inst.matrixA2\[2\] vssd1 vssd1 vccd1 vccd1
+ net456 sky130_fd_sc_hd__dlygate4sd3_1
Xhold150 MATMULT_INST.matmult_inst.mem_inst.matrixA1\[13\] vssd1 vssd1 vccd1 vccd1
+ net445 sky130_fd_sc_hd__dlygate4sd3_1
Xhold194 MATMULT_INST.matmult_inst.mem_inst.matrixB2\[15\] vssd1 vssd1 vccd1 vccd1
+ net489 sky130_fd_sc_hd__dlygate4sd3_1
XFILLER_2_359 vssd1 vssd1 vccd1 vccd1 sky130_fd_sc_hd__fill_4
Xhold172 MATMULT_INST.matmult_inst.mem_inst.matrixB3\[5\] vssd1 vssd1 vccd1 vccd1
+ net467 sky130_fd_sc_hd__dlygate4sd3_1
Xhold183 _0510_ vssd1 vssd1 vccd1 vccd1 net478 sky130_fd_sc_hd__dlygate4sd3_1
XTAP_TAPCELL_ROW_76_818 vssd1 vccd1 sky130_fd_sc_hd__tapvpwrvgnd_1
XFILLER_58_363 vssd1 vssd1 vccd1 vccd1 sky130_fd_sc_hd__fill_1
XFILLER_37_53 vssd1 vssd1 vccd1 vccd1 sky130_fd_sc_hd__fill_1
XFILLER_5_197 vssd1 vssd1 vccd1 vccd1 sky130_fd_sc_hd__fill_1
XFILLER_78_82 vssd1 vssd1 vccd1 vccd1 sky130_fd_sc_hd__fill_2
XFILLER_49_363 vssd1 vssd1 vccd1 vccd1 sky130_fd_sc_hd__fill_1
XFILLER_76_171 vssd1 vssd1 vccd1 vccd1 sky130_fd_sc_hd__fill_1
XFILLER_64_355 vssd1 vssd1 vccd1 vccd1 sky130_fd_sc_hd__fill_8
XFILLER_17_271 vssd1 vssd1 vccd1 vccd1 sky130_fd_sc_hd__fill_8
XTAP_TAPCELL_ROW_47_575 vssd1 vccd1 sky130_fd_sc_hd__tapvpwrvgnd_1
XFILLER_32_230 vccd1 vssd1 vccd1 vssd1 sky130_ef_sc_hd__decap_40_12
XANTENNA__1814__B1 net108 vssd1 vssd1 vccd1 vccd1 sky130_fd_sc_hd__diode_2
XTAP_TAPCELL_ROW_30_431 vssd1 vccd1 sky130_fd_sc_hd__tapvpwrvgnd_1
X_2705_ _0544_ _0732_ vssd1 vssd1 vccd1 vccd1 _1257_ sky130_fd_sc_hd__nor2_1
X_2636_ _1221_ _1223_ vssd1 vssd1 vccd1 vccd1 _1224_ sky130_fd_sc_hd__nand2_1
X_2567_ _1154_ _1155_ _1156_ vssd1 vssd1 vccd1 vccd1 _1158_ sky130_fd_sc_hd__o21ai_1
X_2498_ net188 net208 net210 net186 vssd1 vssd1 vccd1 vccd1 _1091_ sky130_fd_sc_hd__a22oi_2
XFILLER_55_300 vssd1 vssd1 vccd1 vccd1 sky130_fd_sc_hd__fill_4
XPHY_EDGE_ROW_27_Left_107 vssd1 vssd1 vccd1 vccd1 sky130_fd_sc_hd__decap_3
XANTENNA_clkbuf_leaf_4_clk_A clknet_2_0__leaf_clk vssd1 vssd1 vccd1 vccd1 sky130_fd_sc_hd__diode_2
XFILLER_55_333 vssd1 vssd1 vccd1 vccd1 sky130_fd_sc_hd__fill_2
XTAP_TAPCELL_ROW_2_189 vssd1 vccd1 sky130_fd_sc_hd__tapvpwrvgnd_1
X_3119_ net55 net84 net77 vssd1 vssd1 vccd1 vccd1 _0023_ sky130_fd_sc_hd__and3_1
XFILLER_23_241 vssd1 vssd1 vccd1 vccd1 sky130_fd_sc_hd__fill_2
XFILLER_7_407 vssd1 vssd1 vccd1 vccd1 sky130_fd_sc_hd__fill_2
XPHY_EDGE_ROW_36_Left_116 vssd1 vssd1 vccd1 vccd1 sky130_fd_sc_hd__decap_3
XANTENNA__2151__S net10 vssd1 vssd1 vccd1 vccd1 sky130_fd_sc_hd__diode_2
XFILLER_2_101 vssd1 vssd1 vccd1 vccd1 sky130_fd_sc_hd__fill_2
XANTENNA__1990__S net29 vssd1 vssd1 vccd1 vccd1 sky130_fd_sc_hd__diode_2
XFILLER_2_145 vssd1 vssd1 vccd1 vccd1 sky130_fd_sc_hd__fill_1
XFILLER_3_3 vccd1 vssd1 vccd1 vssd1 sky130_ef_sc_hd__decap_40_12
XFILLER_2_167 vssd1 vssd1 vccd1 vccd1 sky130_fd_sc_hd__fill_1
XFILLER_2_178 vssd1 vssd1 vccd1 vccd1 sky130_fd_sc_hd__fill_1
XFILLER_78_469 vssd1 vssd1 vccd1 vccd1 sky130_fd_sc_hd__fill_4
XPHY_EDGE_ROW_45_Left_125 vssd1 vssd1 vccd1 vccd1 sky130_fd_sc_hd__decap_3
XFILLER_48_96 vccd1 vssd1 vccd1 vssd1 sky130_ef_sc_hd__decap_40_12
XFILLER_58_182 vssd1 vssd1 vccd1 vccd1 sky130_fd_sc_hd__fill_4
XFILLER_0_48 vssd1 vssd1 vccd1 vccd1 sky130_fd_sc_hd__fill_8
XANTENNA__2674__X _1252_ vssd1 vssd1 vccd1 vccd1 sky130_fd_sc_hd__diode_2
XFILLER_73_174 vssd1 vssd1 vccd1 vccd1 sky130_fd_sc_hd__fill_4
XTAP_TAPCELL_ROW_44_545 vssd1 vccd1 sky130_fd_sc_hd__tapvpwrvgnd_1
XFILLER_9_57 vccd1 vssd1 vccd1 vssd1 sky130_ef_sc_hd__decap_40_12
XPHY_EDGE_ROW_54_Left_134 vssd1 vssd1 vccd1 vccd1 sky130_fd_sc_hd__decap_3
XANTENNA__2061__S net20 vssd1 vssd1 vccd1 vccd1 sky130_fd_sc_hd__diode_2
XFILLER_6_473 vssd1 vssd1 vccd1 vccd1 sky130_fd_sc_hd__fill_2
X_3470_ clknet_leaf_27_clk _0391_ vssd1 vssd1 vccd1 vccd1 MATMULT_INST.matmult_inst.alu_inst.adder_inst.fa.a
+ sky130_fd_sc_hd__dfxtp_1
X_2421_ net197 net203 vssd1 vssd1 vccd1 vccd1 _1016_ sky130_fd_sc_hd__nand2_1
XFILLER_69_403 vssd1 vssd1 vccd1 vccd1 sky130_fd_sc_hd__fill_2
X_2352_ net198 net209 net211 net195 vssd1 vssd1 vccd1 vccd1 _0950_ sky130_fd_sc_hd__a22o_1
XFILLER_36_3 vssd1 vssd1 vccd1 vccd1 sky130_fd_sc_hd__fill_2
XFILLER_69_447 vssd1 vssd1 vccd1 vccd1 sky130_fd_sc_hd__fill_1
XPHY_EDGE_ROW_63_Left_143 vssd1 vssd1 vccd1 vccd1 sky130_fd_sc_hd__decap_3
X_2283_ MATMULT_INST.matmult_inst.alu_inst.adder_inst.r3.fa0.b MATMULT_INST.matmult_inst.alu_inst.adder_inst.r3.fa0.a
+ vssd1 vssd1 vccd1 vccd1 _0907_ sky130_fd_sc_hd__or2_1
XPHY_EDGE_ROW_72_Left_152 vssd1 vssd1 vccd1 vccd1 sky130_fd_sc_hd__decap_3
XANTENNA__2463__C net210 vssd1 vssd1 vccd1 vccd1 sky130_fd_sc_hd__diode_2
XFILLER_20_233 vssd1 vssd1 vccd1 vccd1 sky130_fd_sc_hd__fill_1
XANTENNA_fanout228_A net1 vssd1 vssd1 vccd1 vccd1 sky130_fd_sc_hd__diode_2
XANTENNA_fanout130_A net131 vssd1 vssd1 vccd1 vccd1 sky130_fd_sc_hd__diode_2
X_1998_ _0797_ net581 net26 vssd1 vssd1 vccd1 vccd1 _0159_ sky130_fd_sc_hd__mux2_1
X_2619_ _1205_ _1206_ vssd1 vssd1 vccd1 vccd1 _1208_ sky130_fd_sc_hd__or2_1
X_3599_ clknet_leaf_17_clk _0492_ _0097_ vssd1 vssd1 vccd1 vccd1 MATMULT_INST.matmult_inst.spi_inst.tx_reg_sys\[2\]
+ sky130_fd_sc_hd__dfrtp_1
XFILLER_75_439 vssd1 vssd1 vccd1 vccd1 sky130_fd_sc_hd__fill_2
XFILLER_18_11 vssd1 vssd1 vccd1 vccd1 sky130_fd_sc_hd__fill_1
XFILLER_18_66 vssd1 vssd1 vccd1 vccd1 sky130_fd_sc_hd__fill_4
XFILLER_28_355 vssd1 vssd1 vccd1 vccd1 sky130_fd_sc_hd__fill_1
XANTENNA__2654__B net114 vssd1 vssd1 vccd1 vccd1 sky130_fd_sc_hd__diode_2
XANTENNA_fanout43_A _0803_ vssd1 vssd1 vccd1 vccd1 sky130_fd_sc_hd__diode_2
XANTENNA__2146__S net12 vssd1 vssd1 vccd1 vccd1 sky130_fd_sc_hd__diode_2
XFILLER_34_21 vssd1 vssd1 vccd1 vccd1 sky130_fd_sc_hd__fill_4
XFILLER_34_76 vssd1 vssd1 vccd1 vccd1 sky130_fd_sc_hd__fill_8
XANTENNA__1985__S net28 vssd1 vssd1 vccd1 vccd1 sky130_fd_sc_hd__diode_2
XFILLER_51_391 vssd1 vssd1 vccd1 vccd1 sky130_fd_sc_hd__fill_1
XANTENNA__2670__A _0691_ vssd1 vssd1 vccd1 vccd1 sky130_fd_sc_hd__diode_2
XFILLER_11_277 vssd1 vssd1 vccd1 vccd1 sky130_fd_sc_hd__fill_2
XFILLER_7_248 vssd1 vssd1 vccd1 vccd1 sky130_fd_sc_hd__fill_4
XFILLER_7_259 vccd1 vssd1 vccd1 vssd1 sky130_ef_sc_hd__decap_40_12
XFILLER_59_95 vssd1 vssd1 vccd1 vccd1 sky130_fd_sc_hd__fill_1
XFILLER_78_299 vssd1 vssd1 vccd1 vccd1 sky130_fd_sc_hd__fill_1
XPHY_EDGE_ROW_3_Left_83 vssd1 vssd1 vccd1 vccd1 sky130_fd_sc_hd__decap_3
XFILLER_19_322 vccd1 vssd1 vccd1 vssd1 sky130_ef_sc_hd__decap_40_12
XFILLER_75_72 vssd1 vssd1 vccd1 vccd1 sky130_fd_sc_hd__fill_1
XFILLER_74_450 vccd1 vssd1 vccd1 vssd1 sky130_ef_sc_hd__decap_40_12
XFILLER_19_355 vssd1 vssd1 vccd1 vccd1 sky130_fd_sc_hd__fill_1
XFILLER_19_377 vssd1 vssd1 vccd1 vccd1 sky130_fd_sc_hd__fill_4
XFILLER_34_314 vssd1 vssd1 vccd1 vccd1 sky130_fd_sc_hd__fill_1
XANTENNA__2056__S net20 vssd1 vssd1 vccd1 vccd1 sky130_fd_sc_hd__diode_2
XFILLER_61_111 vssd1 vssd1 vccd1 vccd1 sky130_fd_sc_hd__fill_1
X_2970_ net616 _1509_ net97 vssd1 vssd1 vccd1 vccd1 _0436_ sky130_fd_sc_hd__mux2_1
X_1921_ net136 MATMULT_INST.matmult_inst.spi_inst.tx_reg_sys\[0\] vssd1 vssd1 vccd1
+ vccd1 _0007_ sky130_fd_sc_hd__and2b_1
XFILLER_61_188 vssd1 vssd1 vccd1 vccd1 sky130_fd_sc_hd__fill_2
X_1852_ MATMULT_INST.matmult_inst.spi_inst.mosi_shifter\[5\] MATMULT_INST.matmult_inst.spi_inst.mosi_data_spi\[6\]
+ _0744_ vssd1 vssd1 vccd1 vccd1 _0453_ sky130_fd_sc_hd__mux2_1
XTAP_TAPCELL_ROW_12_272 vssd1 vccd1 sky130_fd_sc_hd__tapvpwrvgnd_1
X_1783_ MATMULT_INST.matmult_inst.mem_inst.matrixA0\[3\] net112 _0696_ net223 vssd1
+ vssd1 vccd1 vccd1 _0699_ sky130_fd_sc_hd__a22o_1
Xfanout9 _1577_ vssd1 vssd1 vccd1 vccd1 net9 sky130_fd_sc_hd__clkbuf_4
X_3522_ clknet_leaf_35_clk _0439_ vssd1 vssd1 vccd1 vccd1 MATMULT_INST.matmult_inst.alu_inst.adder_inst.r3.fa1.b
+ sky130_fd_sc_hd__dfxtp_1
XFILLER_6_292 vssd1 vssd1 vccd1 vccd1 sky130_fd_sc_hd__fill_1
X_3453_ clknet_leaf_26_clk net99 vssd1 vssd1 vccd1 vccd1 MATMULT_INST.matmult_inst.alu_inst.complete
+ sky130_fd_sc_hd__dfxtp_1
X_2404_ _0978_ _0996_ net114 vssd1 vssd1 vccd1 vccd1 _1000_ sky130_fd_sc_hd__a21o_1
X_3384_ clknet_leaf_4_clk _0306_ vssd1 vssd1 vccd1 vccd1 MATMULT_INST.matmult_inst.mem_inst.mem0\[3\]
+ sky130_fd_sc_hd__dfxtp_1
XTAP_TAPCELL_ROW_4_207 vssd1 vccd1 sky130_fd_sc_hd__tapvpwrvgnd_1
X_2335_ net213 net198 net196 net214 vssd1 vssd1 vccd1 vccd1 _0935_ sky130_fd_sc_hd__a22o_1
X_2266_ MATMULT_INST.matmult_inst.alu_inst.adder_inst.r2.fa1.b MATMULT_INST.matmult_inst.alu_inst.adder_inst.r2.fa1.a
+ vssd1 vssd1 vccd1 vccd1 _0893_ sky130_fd_sc_hd__nand2_1
XANTENNA__1720__A2 net63 vssd1 vssd1 vccd1 vccd1 sky130_fd_sc_hd__diode_2
X_2197_ net207 net444 net65 vssd1 vssd1 vccd1 vccd1 _0329_ sky130_fd_sc_hd__mux2_1
XFILLER_65_472 vccd1 vssd1 vccd1 vssd1 sky130_ef_sc_hd__decap_40_12
XANTENNA__2681__B1 _1254_ vssd1 vssd1 vccd1 vccd1 sky130_fd_sc_hd__diode_2
XFILLER_40_306 vssd1 vssd1 vccd1 vccd1 sky130_fd_sc_hd__fill_2
XFILLER_52_177 vssd1 vssd1 vccd1 vccd1 sky130_fd_sc_hd__fill_1
XFILLER_33_391 vssd1 vssd1 vccd1 vccd1 sky130_fd_sc_hd__fill_1
XFILLER_4_207 vssd1 vssd1 vccd1 vccd1 sky130_fd_sc_hd__fill_1
XFILLER_20_23 vssd1 vssd1 vccd1 vccd1 sky130_fd_sc_hd__fill_1
Xhold32 MATMULT_INST.matmult_inst.mem_inst.mem3\[4\] vssd1 vssd1 vccd1 vccd1 net327
+ sky130_fd_sc_hd__dlygate4sd3_1
Xhold10 MATMULT_INST.matmult_inst.fsm_inst.alu_result\[10\] vssd1 vssd1 vccd1 vccd1
+ net305 sky130_fd_sc_hd__dlygate4sd3_1
Xhold21 MATMULT_INST.matmult_inst.mem_inst.mem3\[7\] vssd1 vssd1 vccd1 vccd1 net316
+ sky130_fd_sc_hd__dlygate4sd3_1
Xhold54 MATMULT_INST.matmult_inst.mem_inst.mem3\[17\] vssd1 vssd1 vccd1 vccd1 net349
+ sky130_fd_sc_hd__dlygate4sd3_1
Xhold65 MATMULT_INST.matmult_inst.alu_inst.row1\[5\] vssd1 vssd1 vccd1 vccd1 net360
+ sky130_fd_sc_hd__dlygate4sd3_1
Xhold43 _0525_ vssd1 vssd1 vccd1 vccd1 net338 sky130_fd_sc_hd__dlygate4sd3_1
XANTENNA__1711__A2 net128 vssd1 vssd1 vccd1 vccd1 sky130_fd_sc_hd__diode_2
XFILLER_75_258 vssd1 vssd1 vccd1 vccd1 sky130_fd_sc_hd__fill_4
XFILLER_28_130 vssd1 vssd1 vccd1 vccd1 sky130_fd_sc_hd__fill_1
Xhold98 MATMULT_INST.matmult_inst.mem_inst.matrixA0\[4\] vssd1 vssd1 vccd1 vccd1 net393
+ sky130_fd_sc_hd__dlygate4sd3_1
Xhold76 MATMULT_INST.matmult_inst.mem_inst.matrixB2\[9\] vssd1 vssd1 vccd1 vccd1 net371
+ sky130_fd_sc_hd__dlygate4sd3_1
Xhold87 MATMULT_INST.matmult_inst.mem_inst.matrixA0\[1\] vssd1 vssd1 vccd1 vccd1 net382
+ sky130_fd_sc_hd__dlygate4sd3_1
XFILLER_45_31 vssd1 vssd1 vccd1 vccd1 sky130_fd_sc_hd__fill_4
XFILLER_56_472 vssd1 vssd1 vccd1 vccd1 sky130_fd_sc_hd__fill_4
XFILLER_71_442 vssd1 vssd1 vccd1 vccd1 sky130_fd_sc_hd__fill_2
XFILLER_16_325 vssd1 vssd1 vccd1 vccd1 sky130_fd_sc_hd__fill_2
XFILLER_43_111 vssd1 vssd1 vccd1 vccd1 sky130_fd_sc_hd__fill_1
XFILLER_16_369 vssd1 vssd1 vccd1 vccd1 sky130_fd_sc_hd__fill_2
XFILLER_31_306 vssd1 vssd1 vccd1 vccd1 sky130_fd_sc_hd__fill_2
XTAP_TAPCELL_ROW_26_397 vssd1 vccd1 sky130_fd_sc_hd__tapvpwrvgnd_1
XANTENNA__1778__A2 net128 vssd1 vssd1 vccd1 vccd1 sky130_fd_sc_hd__diode_2
XFILLER_6_36 vccd1 vssd1 vccd1 vssd1 sky130_ef_sc_hd__decap_40_12
XANTENNA__1950__A2 net71 vssd1 vssd1 vccd1 vccd1 sky130_fd_sc_hd__diode_2
XFILLER_3_273 vssd1 vssd1 vccd1 vccd1 sky130_fd_sc_hd__fill_4
X_2120_ net497 _0805_ net15 vssd1 vssd1 vccd1 vccd1 _0275_ sky130_fd_sc_hd__mux2_1
X_2051_ net526 net34 net23 vssd1 vssd1 vccd1 vccd1 _0210_ sky130_fd_sc_hd__mux2_1
XFILLER_74_291 vccd1 vssd1 vccd1 vssd1 sky130_ef_sc_hd__decap_40_12
XFILLER_62_431 vssd1 vssd1 vccd1 vccd1 sky130_fd_sc_hd__fill_2
XTAP_TAPCELL_ROW_17_320 vssd1 vccd1 sky130_fd_sc_hd__tapvpwrvgnd_1
XFILLER_34_111 vssd1 vssd1 vccd1 vccd1 sky130_fd_sc_hd__fill_1
X_2953_ _1491_ _1485_ vssd1 vssd1 vccd1 vccd1 _1493_ sky130_fd_sc_hd__nand2b_1
XFILLER_34_188 vssd1 vssd1 vccd1 vccd1 sky130_fd_sc_hd__fill_2
X_1904_ net221 _0780_ net71 _0778_ vssd1 vssd1 vccd1 vccd1 _0782_ sky130_fd_sc_hd__a22o_1
X_2884_ _1419_ _1423_ _1424_ vssd1 vssd1 vccd1 vccd1 _1426_ sky130_fd_sc_hd__nand3_1
X_1835_ MATMULT_INST.matmult_inst.fsm_inst.rx_ready_edge_delay _0738_ vssd1 vssd1
+ vccd1 vccd1 _0739_ sky130_fd_sc_hd__nand2_1
X_1766_ MATMULT_INST.matmult_inst.mem_inst.matrixA1\[4\] net125 net117 MATMULT_INST.matmult_inst.mem_inst.matrixA2\[4\]
+ _0682_ vssd1 vssd1 vccd1 vccd1 _0683_ sky130_fd_sc_hd__a221o_1
X_3505_ clknet_leaf_0_clk _0423_ vssd1 vssd1 vccd1 vccd1 MATMULT_INST.matmult_inst.alu_inst.row0\[7\]
+ sky130_fd_sc_hd__dfxtp_1
X_1697_ MATMULT_INST.matmult_inst.mem_inst.matrixA0\[11\] net113 net110 MATMULT_INST.matmult_inst.mem_inst.mem0\[11\]
+ vssd1 vssd1 vccd1 vccd1 _0621_ sky130_fd_sc_hd__a22o_1
X_3436_ clknet_leaf_27_clk _0358_ vssd1 vssd1 vccd1 vccd1 MATMULT_INST.matmult_inst.alu_inst.out\[17\]
+ sky130_fd_sc_hd__dfxtp_1
X_3367_ clknet_leaf_1_clk _0289_ vssd1 vssd1 vccd1 vccd1 MATMULT_INST.matmult_inst.mem_inst.mem1\[4\]
+ sky130_fd_sc_hd__dfxtp_1
X_2318_ net178 net486 net67 vssd1 vssd1 vccd1 vccd1 _0362_ sky130_fd_sc_hd__mux2_1
XTAP_TAPCELL_ROW_68_754 vssd1 vccd1 sky130_fd_sc_hd__tapvpwrvgnd_1
X_3298_ clknet_leaf_8_clk _0220_ vssd1 vssd1 vccd1 vccd1 MATMULT_INST.matmult_inst.mem_inst.matrixA1\[7\]
+ sky130_fd_sc_hd__dfxtp_1
X_2249_ _0876_ _0878_ vssd1 vssd1 vccd1 vccd1 _0879_ sky130_fd_sc_hd__xnor2_1
XFILLER_15_45 vssd1 vssd1 vccd1 vccd1 sky130_fd_sc_hd__fill_1
XFILLER_40_158 vssd1 vssd1 vccd1 vccd1 sky130_fd_sc_hd__fill_2
XFILLER_21_361 vssd1 vssd1 vccd1 vccd1 sky130_fd_sc_hd__fill_2
XTAP_TAPCELL_ROW_23_367 vssd1 vccd1 sky130_fd_sc_hd__tapvpwrvgnd_1
XANTENNA__1835__Y _0739_ vssd1 vssd1 vccd1 vccd1 sky130_fd_sc_hd__diode_2
XFILLER_0_221 vssd1 vssd1 vccd1 vccd1 sky130_fd_sc_hd__fill_2
XANTENNA__1696__A1 net217 vssd1 vssd1 vccd1 vccd1 sky130_fd_sc_hd__diode_2
XFILLER_56_85 vssd1 vssd1 vccd1 vccd1 sky130_fd_sc_hd__fill_1
XFILLER_16_177 vccd1 vssd1 vccd1 vssd1 sky130_ef_sc_hd__decap_40_12
XFILLER_72_95 vssd1 vssd1 vccd1 vccd1 sky130_fd_sc_hd__fill_2
XFILLER_72_73 vssd1 vssd1 vccd1 vccd1 sky130_fd_sc_hd__fill_2
XFILLER_12_361 vssd1 vssd1 vccd1 vccd1 sky130_fd_sc_hd__fill_2
X_1620_ net153 net143 MATMULT_INST.matmult_inst.mem_inst.mem3\[17\] vssd1 vssd1 vccd1
+ vccd1 _0550_ sky130_fd_sc_hd__and3_1
XFILLER_8_365 vccd1 vssd1 vccd1 vssd1 sky130_ef_sc_hd__decap_40_12
XFILLER_79_361 vssd1 vssd1 vccd1 vccd1 sky130_fd_sc_hd__fill_2
XANTENNA__3462__Q MATMULT_INST.matmult_inst.alu_inst.adder_inst.r2.fa0.a vssd1 vssd1
+ vccd1 vccd1 sky130_fd_sc_hd__diode_2
X_3221_ clknet_leaf_16_clk _0143_ vssd1 vssd1 vccd1 vccd1 MATMULT_INST.matmult_inst.mem_inst.matrixB1\[2\]
+ sky130_fd_sc_hd__dfxtp_1
X_3152_ net59 net89 net78 vssd1 vssd1 vccd1 vccd1 _0077_ sky130_fd_sc_hd__and3_1
X_2103_ net355 net39 net16 vssd1 vssd1 vccd1 vccd1 _0259_ sky130_fd_sc_hd__mux2_1
XTAP_TAPCELL_ROW_65_724 vssd1 vccd1 sky130_fd_sc_hd__tapvpwrvgnd_1
X_3083_ _0754_ _0833_ _0826_ net54 vssd1 vssd1 vccd1 vccd1 _1580_ sky130_fd_sc_hd__or4bb_1
X_2034_ net332 net32 net25 vssd1 vssd1 vccd1 vccd1 _0194_ sky130_fd_sc_hd__mux2_1
XFILLER_35_420 vssd1 vssd1 vccd1 vccd1 sky130_fd_sc_hd__fill_2
XTAP_TAPCELL_ROW_73_790 vssd1 vccd1 sky130_fd_sc_hd__tapvpwrvgnd_1
XFILLER_50_445 vssd1 vssd1 vccd1 vccd1 sky130_fd_sc_hd__fill_8
XFILLER_10_309 vssd1 vssd1 vccd1 vccd1 sky130_fd_sc_hd__fill_8
X_2936_ net650 _1476_ net97 vssd1 vssd1 vccd1 vccd1 _0435_ sky130_fd_sc_hd__mux2_1
X_2867_ _1407_ _1408_ vssd1 vssd1 vccd1 vccd1 _1409_ sky130_fd_sc_hd__xnor2_1
X_1818_ net621 _0730_ net63 vssd1 vssd1 vccd1 vccd1 _0490_ sky130_fd_sc_hd__mux2_1
XANTENNA__2167__A2 _0814_ vssd1 vssd1 vccd1 vccd1 sky130_fd_sc_hd__diode_2
Xhold310 MATMULT_INST.matmult_inst.mem_inst.matrixB0\[13\] vssd1 vssd1 vccd1 vccd1
+ net605 sky130_fd_sc_hd__dlygate4sd3_1
X_2798_ net169 net175 _1323_ _1324_ _1293_ vssd1 vssd1 vccd1 vccd1 _1342_ sky130_fd_sc_hd__a41o_1
Xhold343 MATMULT_INST.matmult_inst.spi_inst.tx_reg_sys\[14\] vssd1 vssd1 vccd1 vccd1
+ net638 sky130_fd_sc_hd__dlygate4sd3_1
Xhold321 MATMULT_INST.matmult_inst.alu_inst.adder_inst.r2.fa2.b vssd1 vssd1 vccd1
+ vccd1 net616 sky130_fd_sc_hd__dlygate4sd3_1
Xhold332 MATMULT_INST.matmult_inst.alu_inst.adder_inst.r1.fa0.a vssd1 vssd1 vccd1
+ vccd1 net627 sky130_fd_sc_hd__dlygate4sd3_1
X_1749_ MATMULT_INST.matmult_inst.mem_inst.matrixA0\[6\] net112 net104 MATMULT_INST.matmult_inst.mem_inst.matrixB0\[6\]
+ vssd1 vssd1 vccd1 vccd1 _0668_ sky130_fd_sc_hd__a22o_1
XFILLER_77_18 vssd1 vssd1 vccd1 vccd1 sky130_fd_sc_hd__fill_2
Xhold376 MATMULT_INST.matmult_inst.alu_inst.adder_inst.r3.fa2.b vssd1 vssd1 vccd1
+ vccd1 net671 sky130_fd_sc_hd__dlygate4sd3_1
Xhold354 MATMULT_INST.matmult_inst.alu_inst.adder_inst.r3.fa0.a vssd1 vssd1 vccd1
+ vccd1 net649 sky130_fd_sc_hd__dlygate4sd3_1
Xhold365 MATMULT_INST.matmult_inst.fsm_inst.state\[2\] vssd1 vssd1 vccd1 vccd1 net660
+ sky130_fd_sc_hd__dlygate4sd3_1
XFILLER_77_29 vssd1 vssd1 vccd1 vccd1 sky130_fd_sc_hd__fill_1
X_3419_ clknet_leaf_28_clk _0341_ vssd1 vssd1 vccd1 vccd1 MATMULT_INST.matmult_inst.alu_inst.out\[0\]
+ sky130_fd_sc_hd__dfxtp_1
XFILLER_45_239 vssd1 vssd1 vccd1 vccd1 sky130_fd_sc_hd__fill_1
XFILLER_26_464 vssd1 vssd1 vccd1 vccd1 sky130_fd_sc_hd__fill_4
XTAP_TAPCELL_ROW_36_481 vssd1 vccd1 sky130_fd_sc_hd__tapvpwrvgnd_1
XFILLER_41_445 vssd1 vssd1 vccd1 vccd1 sky130_fd_sc_hd__fill_2
XFILLER_9_129 vssd1 vssd1 vccd1 vccd1 sky130_fd_sc_hd__fill_8
XANTENNA__2154__S net10 vssd1 vssd1 vccd1 vccd1 sky130_fd_sc_hd__diode_2
XANTENNA__1993__S net28 vssd1 vssd1 vccd1 vccd1 sky130_fd_sc_hd__diode_2
XFILLER_5_379 vccd1 vssd1 vccd1 vssd1 sky130_ef_sc_hd__decap_40_12
XFILLER_3_15 vccd1 vssd1 vccd1 vssd1 sky130_ef_sc_hd__decap_40_12
XTAP_TAPCELL_ROW_79_849 vssd1 vccd1 sky130_fd_sc_hd__tapvpwrvgnd_1
XANTENNA__2329__S net67 vssd1 vssd1 vccd1 vccd1 sky130_fd_sc_hd__diode_2
XFILLER_51_209 vssd1 vssd1 vccd1 vccd1 sky130_fd_sc_hd__fill_1
XANTENNA__2094__A1 _0798_ vssd1 vssd1 vccd1 vccd1 sky130_fd_sc_hd__diode_2
XFILLER_32_445 vssd1 vssd1 vccd1 vccd1 sky130_fd_sc_hd__fill_4
XTAP_TAPCELL_ROW_70_771 vssd1 vccd1 sky130_fd_sc_hd__tapvpwrvgnd_1
XFILLER_32_489 vssd1 vssd1 vccd1 vccd1 sky130_fd_sc_hd__fill_4
XANTENNA__2064__S net21 vssd1 vssd1 vccd1 vccd1 sky130_fd_sc_hd__diode_2
XANTENNA__3457__Q MATMULT_INST.matmult_inst.alu_inst.adder_inst.r0.fa3.a vssd1 vssd1
+ vccd1 vccd1 sky130_fd_sc_hd__diode_2
X_2721_ net527 net115 _1270_ vssd1 vssd1 vccd1 vccd1 _0426_ sky130_fd_sc_hd__a21o_1
X_2652_ _1231_ _1235_ _1237_ _1238_ vssd1 vssd1 vccd1 vccd1 _1239_ sky130_fd_sc_hd__a22o_1
X_1603_ net3 vssd1 vssd1 vccd1 vccd1 _0535_ sky130_fd_sc_hd__inv_2
X_2583_ _1170_ _1173_ vssd1 vssd1 vccd1 vccd1 _1174_ sky130_fd_sc_hd__nand2_1
Xfanout119 net123 vssd1 vssd1 vccd1 vccd1 net119 sky130_fd_sc_hd__clkbuf_2
Xfanout108 net111 vssd1 vssd1 vccd1 vccd1 net108 sky130_fd_sc_hd__clkbuf_4
X_3204_ clknet_leaf_3_clk _0126_ vssd1 vssd1 vccd1 vccd1 MATMULT_INST.matmult_inst.mem_inst.matrixB2\[3\]
+ sky130_fd_sc_hd__dfxtp_1
X_3135_ net225 vssd1 vssd1 vccd1 vccd1 _0054_ sky130_fd_sc_hd__inv_2
X_3066_ MATMULT_INST.matmult_inst.alu_inst.out\[2\] net52 net7 net477 vssd1 vssd1
+ vccd1 vccd1 _0510_ sky130_fd_sc_hd__a22o_1
X_2017_ net304 net49 net24 vssd1 vssd1 vccd1 vccd1 _0177_ sky130_fd_sc_hd__mux2_1
XFILLER_35_261 vccd1 vssd1 vccd1 vssd1 sky130_ef_sc_hd__decap_40_12
XFILLER_23_445 vssd1 vssd1 vccd1 vccd1 sky130_fd_sc_hd__fill_2
XFILLER_23_467 vssd1 vssd1 vccd1 vccd1 sky130_fd_sc_hd__fill_1
XTAP_TAPCELL_ROW_33_451 vssd1 vccd1 sky130_fd_sc_hd__tapvpwrvgnd_1
X_2919_ _1453_ _1458_ vssd1 vssd1 vccd1 vccd1 _1460_ sky130_fd_sc_hd__nand2_1
XANTENNA__2702__S _1256_ vssd1 vssd1 vccd1 vccd1 sky130_fd_sc_hd__diode_2
Xhold162 MATMULT_INST.matmult_inst.mem_inst.matrixA1\[14\] vssd1 vssd1 vccd1 vccd1
+ net457 sky130_fd_sc_hd__dlygate4sd3_1
Xhold140 MATMULT_INST.matmult_inst.mem_inst.matrixB0\[16\] vssd1 vssd1 vccd1 vccd1
+ net435 sky130_fd_sc_hd__dlygate4sd3_1
Xhold151 MATMULT_INST.matmult_inst.mem_inst.matrixA1\[2\] vssd1 vssd1 vccd1 vccd1
+ net446 sky130_fd_sc_hd__dlygate4sd3_1
Xhold195 MATMULT_INST.matmult_inst.alu_inst.row0\[3\] vssd1 vssd1 vccd1 vccd1 net490
+ sky130_fd_sc_hd__dlygate4sd3_1
Xhold173 MATMULT_INST.matmult_inst.mem_inst.mem2\[5\] vssd1 vssd1 vccd1 vccd1 net468
+ sky130_fd_sc_hd__dlygate4sd3_1
Xhold184 MATMULT_INST.matmult_inst.fsm_inst.alu_result\[6\] vssd1 vssd1 vccd1 vccd1
+ net479 sky130_fd_sc_hd__dlygate4sd3_1
XANTENNA_fanout73_A net74 vssd1 vssd1 vccd1 vccd1 sky130_fd_sc_hd__diode_2
XTAP_TAPCELL_ROW_76_819 vssd1 vccd1 sky130_fd_sc_hd__tapvpwrvgnd_1
XFILLER_73_345 vssd1 vssd1 vccd1 vccd1 sky130_fd_sc_hd__fill_1
XANTENNA__1988__S net28 vssd1 vssd1 vccd1 vccd1 sky130_fd_sc_hd__diode_2
XFILLER_41_297 vssd1 vssd1 vccd1 vccd1 sky130_fd_sc_hd__fill_1
XFILLER_5_110 vssd1 vssd1 vccd1 vccd1 sky130_fd_sc_hd__fill_2
XFILLER_5_132 vssd1 vssd1 vccd1 vccd1 sky130_fd_sc_hd__fill_8
XFILLER_76_150 vssd1 vssd1 vccd1 vccd1 sky130_fd_sc_hd__fill_1
XANTENNA__2059__S net20 vssd1 vssd1 vccd1 vccd1 sky130_fd_sc_hd__diode_2
XFILLER_32_220 vssd1 vssd1 vccd1 vccd1 sky130_fd_sc_hd__fill_2
XFILLER_32_242 vssd1 vssd1 vccd1 vccd1 sky130_fd_sc_hd__fill_8
X_2704_ _1253_ net537 _1256_ vssd1 vssd1 vccd1 vccd1 _0423_ sky130_fd_sc_hd__mux2_1
X_2635_ _1210_ _1222_ vssd1 vssd1 vccd1 vccd1 _1223_ sky130_fd_sc_hd__or2_1
X_2566_ _1154_ _1155_ _1156_ vssd1 vssd1 vccd1 vccd1 _1157_ sky130_fd_sc_hd__or3_1
X_2497_ _1088_ _1089_ vssd1 vssd1 vccd1 vccd1 _1090_ sky130_fd_sc_hd__nand2_1
XANTENNA__2477__B net200 vssd1 vssd1 vccd1 vccd1 sky130_fd_sc_hd__diode_2
X_3118_ net61 net92 net80 vssd1 vssd1 vccd1 vccd1 _0024_ sky130_fd_sc_hd__and3_1
XFILLER_67_183 vssd1 vssd1 vccd1 vccd1 sky130_fd_sc_hd__fill_1
X_3049_ net309 net45 net8 vssd1 vssd1 vccd1 vccd1 _0468_ sky130_fd_sc_hd__mux2_1
XFILLER_55_389 vssd1 vssd1 vccd1 vccd1 sky130_fd_sc_hd__fill_2
XFILLER_23_34 vccd1 vssd1 vccd1 vssd1 sky130_ef_sc_hd__decap_40_12
XFILLER_23_67 vssd1 vssd1 vccd1 vccd1 sky130_fd_sc_hd__fill_1
XFILLER_73_131 vssd1 vssd1 vccd1 vccd1 sky130_fd_sc_hd__fill_8
XFILLER_58_194 vssd1 vssd1 vccd1 vccd1 sky130_fd_sc_hd__fill_2
XFILLER_61_337 vssd1 vssd1 vccd1 vccd1 sky130_fd_sc_hd__fill_1
XTAP_TAPCELL_ROW_44_546 vssd1 vccd1 sky130_fd_sc_hd__tapvpwrvgnd_1
XFILLER_14_242 vssd1 vssd1 vccd1 vccd1 sky130_fd_sc_hd__fill_2
XFILLER_9_69 vccd1 vssd1 vccd1 vssd1 sky130_ef_sc_hd__decap_40_12
Xfanout90 net92 vssd1 vssd1 vccd1 vccd1 net90 sky130_fd_sc_hd__dlymetal6s2s_1
X_2420_ _0982_ _0983_ _1014_ vssd1 vssd1 vccd1 vccd1 _1015_ sky130_fd_sc_hd__o21a_1
XFILLER_69_426 vssd1 vssd1 vccd1 vccd1 sky130_fd_sc_hd__fill_2
X_2351_ net198 net195 net209 net210 vssd1 vssd1 vccd1 vccd1 _0949_ sky130_fd_sc_hd__nand4_1
X_2282_ net474 _0906_ net99 vssd1 vssd1 vccd1 vccd1 _0352_ sky130_fd_sc_hd__mux2_1
XFILLER_29_3 vssd1 vssd1 vccd1 vccd1 sky130_fd_sc_hd__fill_4
XANTENNA__2288__A1 _0911_ vssd1 vssd1 vccd1 vccd1 sky130_fd_sc_hd__diode_2
XFILLER_20_223 vssd1 vssd1 vccd1 vccd1 sky130_fd_sc_hd__fill_8
XFILLER_20_245 vssd1 vssd1 vccd1 vccd1 sky130_fd_sc_hd__fill_4
X_1997_ net106 net50 vssd1 vssd1 vccd1 vccd1 _0816_ sky130_fd_sc_hd__nand2_1
XANTENNA__1944__X _0798_ vssd1 vssd1 vccd1 vccd1 sky130_fd_sc_hd__diode_2
X_2618_ _1205_ _1206_ vssd1 vssd1 vccd1 vccd1 _1207_ sky130_fd_sc_hd__nand2_1
X_3598_ clknet_leaf_17_clk _0491_ _0096_ vssd1 vssd1 vccd1 vccd1 MATMULT_INST.matmult_inst.spi_inst.tx_reg_sys\[1\]
+ sky130_fd_sc_hd__dfrtp_1
X_2549_ _1135_ _1136_ _1139_ _1080_ vssd1 vssd1 vccd1 vccd1 _1141_ sky130_fd_sc_hd__o22ai_2
XFILLER_68_470 vssd1 vssd1 vccd1 vccd1 sky130_fd_sc_hd__fill_4
XFILLER_18_78 vssd1 vssd1 vccd1 vccd1 sky130_fd_sc_hd__fill_1
XANTENNA_fanout36_A _0810_ vssd1 vssd1 vccd1 vccd1 sky130_fd_sc_hd__diode_2
XFILLER_34_33 vssd1 vssd1 vccd1 vccd1 sky130_fd_sc_hd__fill_1
XFILLER_11_223 vssd1 vssd1 vccd1 vccd1 sky130_fd_sc_hd__fill_1
XFILLER_51_381 vssd1 vssd1 vccd1 vccd1 sky130_fd_sc_hd__fill_4
XFILLER_11_234 vssd1 vssd1 vccd1 vccd1 sky130_fd_sc_hd__fill_2
XANTENNA__1714__B1 net121 vssd1 vssd1 vccd1 vccd1 sky130_fd_sc_hd__diode_2
XFILLER_66_407 vssd1 vssd1 vccd1 vccd1 sky130_fd_sc_hd__fill_2
XFILLER_59_481 vccd1 vssd1 vccd1 vssd1 sky130_ef_sc_hd__decap_40_12
XFILLER_19_334 vssd1 vssd1 vccd1 vccd1 sky130_fd_sc_hd__fill_2
XFILLER_74_462 vccd1 vssd1 vccd1 vssd1 sky130_ef_sc_hd__decap_40_12
XANTENNA__2690__A1 net93 vssd1 vssd1 vccd1 vccd1 sky130_fd_sc_hd__diode_2
XTAP_TAPCELL_ROW_57_660 vssd1 vccd1 sky130_fd_sc_hd__tapvpwrvgnd_1
XFILLER_46_197 vssd1 vssd1 vccd1 vccd1 sky130_fd_sc_hd__fill_1
XFILLER_61_167 vssd1 vssd1 vccd1 vccd1 sky130_fd_sc_hd__fill_1
X_1920_ MATMULT_INST.matmult_inst.spi_inst.current_state MATMULT_INST.matmult_inst.spi_inst.cs_sync_prev
+ _0793_ vssd1 vssd1 vccd1 vccd1 MATMULT_INST.matmult_inst.spi_inst.next_state sky130_fd_sc_hd__o21a_1
X_1851_ MATMULT_INST.matmult_inst.spi_inst.mosi_shifter\[6\] MATMULT_INST.matmult_inst.spi_inst.mosi_data_spi\[7\]
+ _0744_ vssd1 vssd1 vccd1 vccd1 _0454_ sky130_fd_sc_hd__mux2_1
XANTENNA__2072__S net21 vssd1 vssd1 vccd1 vccd1 sky130_fd_sc_hd__diode_2
XTAP_TAPCELL_ROW_12_273 vssd1 vccd1 sky130_fd_sc_hd__tapvpwrvgnd_1
X_3521_ clknet_leaf_31_clk _0438_ vssd1 vssd1 vccd1 vccd1 MATMULT_INST.matmult_inst.alu_inst.adder_inst.r3.fa0.b
+ sky130_fd_sc_hd__dfxtp_1
X_1782_ MATMULT_INST.matmult_inst.mem_inst.matrixB1\[3\] net128 net120 MATMULT_INST.matmult_inst.mem_inst.matrixB2\[3\]
+ _0697_ vssd1 vssd1 vccd1 vccd1 _0698_ sky130_fd_sc_hd__a221o_1
XANTENNA_clkbuf_leaf_3_clk_A clknet_2_0__leaf_clk vssd1 vssd1 vccd1 vccd1 sky130_fd_sc_hd__diode_2
X_3452_ clknet_leaf_34_clk _0374_ vssd1 vssd1 vccd1 vccd1 MATMULT_INST.matmult_inst.alu_inst.a1_reg\[7\]
+ sky130_fd_sc_hd__dfxtp_1
X_2403_ _0997_ _0978_ _0995_ vssd1 vssd1 vccd1 vccd1 _0999_ sky130_fd_sc_hd__mux2_1
X_3383_ clknet_leaf_4_clk _0305_ vssd1 vssd1 vccd1 vccd1 MATMULT_INST.matmult_inst.mem_inst.mem0\[2\]
+ sky130_fd_sc_hd__dfxtp_1
X_2334_ net655 net115 _0934_ vssd1 vssd1 vccd1 vccd1 _0375_ sky130_fd_sc_hd__a21o_1
XTAP_TAPCELL_ROW_4_208 vssd1 vccd1 sky130_fd_sc_hd__tapvpwrvgnd_1
X_2265_ MATMULT_INST.matmult_inst.alu_inst.adder_inst.r2.fa1.b MATMULT_INST.matmult_inst.alu_inst.adder_inst.r2.fa1.a
+ vssd1 vssd1 vccd1 vccd1 _0892_ sky130_fd_sc_hd__nor2_1
XANTENNA__1940__A net71 vssd1 vssd1 vccd1 vccd1 sky130_fd_sc_hd__diode_2
XFILLER_65_440 vssd1 vssd1 vccd1 vccd1 sky130_fd_sc_hd__fill_2
X_2196_ net208 net496 net66 vssd1 vssd1 vccd1 vccd1 _0328_ sky130_fd_sc_hd__mux2_1
XFILLER_65_484 vssd1 vssd1 vccd1 vccd1 sky130_fd_sc_hd__fill_8
XFILLER_1_92 vssd1 vssd1 vccd1 vccd1 sky130_fd_sc_hd__fill_1
XFILLER_25_304 vssd1 vssd1 vccd1 vccd1 sky130_fd_sc_hd__fill_4
XANTENNA__2681__A1 net82 vssd1 vssd1 vccd1 vccd1 sky130_fd_sc_hd__diode_2
XFILLER_40_329 vssd1 vssd1 vccd1 vccd1 sky130_fd_sc_hd__fill_4
XANTENNA__2984__A2 net173 vssd1 vssd1 vccd1 vccd1 sky130_fd_sc_hd__diode_2
XFILLER_0_447 vssd1 vssd1 vccd1 vccd1 sky130_fd_sc_hd__fill_1
XFILLER_0_469 vssd1 vssd1 vccd1 vccd1 sky130_fd_sc_hd__fill_2
Xhold22 MATMULT_INST.matmult_inst.mem_inst.mem3\[3\] vssd1 vssd1 vccd1 vccd1 net317
+ sky130_fd_sc_hd__dlygate4sd3_1
Xhold11 _0518_ vssd1 vssd1 vccd1 vccd1 net306 sky130_fd_sc_hd__dlygate4sd3_1
XFILLER_48_418 vssd1 vssd1 vccd1 vccd1 sky130_fd_sc_hd__fill_2
Xhold44 MATMULT_INST.matmult_inst.mem_inst.mem3\[15\] vssd1 vssd1 vccd1 vccd1 net339
+ sky130_fd_sc_hd__dlygate4sd3_1
XFILLER_29_55 vssd1 vssd1 vccd1 vccd1 sky130_fd_sc_hd__fill_1
Xhold55 MATMULT_INST.matmult_inst.mem_inst.matrixB3\[6\] vssd1 vssd1 vccd1 vccd1 net350
+ sky130_fd_sc_hd__dlygate4sd3_1
Xhold33 MATMULT_INST.matmult_inst.mem_inst.matrixB3\[7\] vssd1 vssd1 vccd1 vccd1 net328
+ sky130_fd_sc_hd__dlygate4sd3_1
XFILLER_75_248 vssd1 vssd1 vccd1 vccd1 sky130_fd_sc_hd__fill_2
Xhold77 MATMULT_INST.matmult_inst.mem_inst.matrixA0\[10\] vssd1 vssd1 vccd1 vccd1
+ net372 sky130_fd_sc_hd__dlygate4sd3_1
Xhold88 MATMULT_INST.matmult_inst.alu_inst.adder_inst.r0.fa3.b vssd1 vssd1 vccd1 vccd1
+ net383 sky130_fd_sc_hd__dlygate4sd3_1
Xhold66 MATMULT_INST.matmult_inst.alu_inst.out\[3\] vssd1 vssd1 vccd1 vccd1 net361
+ sky130_fd_sc_hd__dlygate4sd3_1
Xhold99 MATMULT_INST.matmult_inst.mem_inst.matrixA1\[6\] vssd1 vssd1 vccd1 vccd1 net394
+ sky130_fd_sc_hd__dlygate4sd3_1
XFILLER_16_304 vssd1 vssd1 vccd1 vccd1 sky130_fd_sc_hd__fill_4
XANTENNA__2157__S net10 vssd1 vssd1 vccd1 vccd1 sky130_fd_sc_hd__diode_2
XFILLER_71_421 vssd1 vssd1 vccd1 vccd1 sky130_fd_sc_hd__fill_4
XFILLER_45_65 vssd1 vssd1 vccd1 vccd1 sky130_fd_sc_hd__fill_4
XTAP_TAPCELL_ROW_54_630 vssd1 vccd1 sky130_fd_sc_hd__tapvpwrvgnd_1
XANTENNA__1996__S net29 vssd1 vssd1 vccd1 vccd1 sky130_fd_sc_hd__diode_2
XANTENNA__1849__X _0744_ vssd1 vssd1 vccd1 vccd1 sky130_fd_sc_hd__diode_2
XANTENNA_fanout39_X net39 vssd1 vssd1 vccd1 vccd1 sky130_fd_sc_hd__diode_2
XFILLER_43_145 vssd1 vssd1 vccd1 vccd1 sky130_fd_sc_hd__fill_1
XFILLER_24_381 vccd1 vssd1 vccd1 vssd1 sky130_ef_sc_hd__decap_40_12
XFILLER_6_48 vssd1 vssd1 vccd1 vccd1 sky130_fd_sc_hd__fill_2
XFILLER_6_26 vssd1 vssd1 vccd1 vccd1 sky130_fd_sc_hd__fill_2
X_2050_ net519 net35 net23 vssd1 vssd1 vccd1 vccd1 _0209_ sky130_fd_sc_hd__mux2_1
XANTENNA__2067__S net21 vssd1 vssd1 vccd1 vccd1 sky130_fd_sc_hd__diode_2
XFILLER_62_421 vssd1 vssd1 vccd1 vccd1 sky130_fd_sc_hd__fill_1
XANTENNA__2663__A1 net103 vssd1 vssd1 vccd1 vccd1 sky130_fd_sc_hd__diode_2
XFILLER_62_454 vssd1 vssd1 vccd1 vccd1 sky130_fd_sc_hd__fill_8
XFILLER_34_167 vssd1 vssd1 vccd1 vccd1 sky130_fd_sc_hd__fill_1
X_2952_ _1485_ _1491_ vssd1 vssd1 vccd1 vccd1 _1492_ sky130_fd_sc_hd__and2b_1
X_1903_ MATMULT_INST.matmult_inst.fsm_inst.rx_ready_edge_delay MATMULT_INST.matmult_inst.fsm_inst.rx_ready_edge
+ _0738_ _0772_ vssd1 vssd1 vccd1 vccd1 _0781_ sky130_fd_sc_hd__and4b_1
X_2883_ _1423_ _1424_ _1419_ vssd1 vssd1 vccd1 vccd1 _1425_ sky130_fd_sc_hd__a21o_1
XFILLER_30_362 vssd1 vssd1 vccd1 vccd1 sky130_fd_sc_hd__fill_2
X_1834_ MATMULT_INST.matmult_inst.fsm_inst.state\[4\] _0737_ vssd1 vssd1 vccd1 vccd1
+ _0738_ sky130_fd_sc_hd__nor2_1
X_1765_ net146 net138 MATMULT_INST.matmult_inst.mem_inst.matrixA3\[4\] vssd1 vssd1
+ vccd1 vccd1 _0682_ sky130_fd_sc_hd__and3_1
X_3504_ clknet_leaf_37_clk _0422_ vssd1 vssd1 vccd1 vccd1 MATMULT_INST.matmult_inst.alu_inst.row0\[6\]
+ sky130_fd_sc_hd__dfxtp_1
X_1696_ net217 _0614_ _0619_ vssd1 vssd1 vccd1 vccd1 _0620_ sky130_fd_sc_hd__a21o_1
X_3435_ clknet_leaf_27_clk _0357_ vssd1 vssd1 vccd1 vccd1 MATMULT_INST.matmult_inst.alu_inst.out\[16\]
+ sky130_fd_sc_hd__dfxtp_1
X_3366_ clknet_leaf_3_clk _0288_ vssd1 vssd1 vccd1 vccd1 MATMULT_INST.matmult_inst.mem_inst.mem1\[3\]
+ sky130_fd_sc_hd__dfxtp_1
X_2317_ net181 net606 net68 vssd1 vssd1 vccd1 vccd1 _0361_ sky130_fd_sc_hd__mux2_1
X_3297_ clknet_leaf_7_clk _0219_ vssd1 vssd1 vccd1 vccd1 MATMULT_INST.matmult_inst.mem_inst.matrixA1\[6\]
+ sky130_fd_sc_hd__dfxtp_1
XANTENNA__1670__A net150 vssd1 vssd1 vccd1 vccd1 sky130_fd_sc_hd__diode_2
X_2248_ _0869_ _0877_ vssd1 vssd1 vccd1 vccd1 _0878_ sky130_fd_sc_hd__or2_1
XFILLER_65_292 vccd1 vssd1 vccd1 vssd1 sky130_ef_sc_hd__decap_40_12
XFILLER_25_123 vssd1 vssd1 vccd1 vccd1 sky130_fd_sc_hd__fill_2
X_2179_ net667 _0832_ _0835_ vssd1 vssd1 vccd1 vccd1 _0321_ sky130_fd_sc_hd__a21bo_1
XANTENNA__1829__B net103 vssd1 vssd1 vccd1 vccd1 sky130_fd_sc_hd__diode_2
XTAP_TAPCELL_ROW_23_368 vssd1 vccd1 sky130_fd_sc_hd__tapvpwrvgnd_1
XFILLER_21_395 vssd1 vssd1 vccd1 vccd1 sky130_fd_sc_hd__fill_8
XANTENNA__2676__A _0661_ vssd1 vssd1 vccd1 vccd1 sky130_fd_sc_hd__diode_2
XFILLER_16_189 vssd1 vssd1 vccd1 vccd1 sky130_fd_sc_hd__fill_4
XANTENNA_clkbuf_2_0__f_clk_X clknet_2_0__leaf_clk vssd1 vssd1 vccd1 vccd1 sky130_fd_sc_hd__diode_2
XFILLER_31_137 vssd1 vssd1 vccd1 vccd1 sky130_fd_sc_hd__fill_2
XFILLER_8_377 vssd1 vssd1 vccd1 vccd1 sky130_fd_sc_hd__fill_2
X_3220_ clknet_leaf_15_clk _0142_ vssd1 vssd1 vccd1 vccd1 MATMULT_INST.matmult_inst.mem_inst.matrixB1\[1\]
+ sky130_fd_sc_hd__dfxtp_1
XFILLER_79_373 vssd1 vssd1 vccd1 vccd1 sky130_fd_sc_hd__fill_2
X_3151_ net56 net84 net77 vssd1 vssd1 vccd1 vccd1 _0076_ sky130_fd_sc_hd__and3_1
XFILLER_11_3 vccd1 vssd1 vccd1 vssd1 sky130_ef_sc_hd__decap_40_12
X_2102_ net331 net40 net17 vssd1 vssd1 vccd1 vccd1 _0258_ sky130_fd_sc_hd__mux2_1
X_3082_ _0833_ _0826_ _0753_ net54 vssd1 vssd1 vccd1 vccd1 _1579_ sky130_fd_sc_hd__and4b_1
X_2033_ net378 net33 net25 vssd1 vssd1 vccd1 vccd1 _0193_ sky130_fd_sc_hd__mux2_1
XTAP_TAPCELL_ROW_65_725 vssd1 vccd1 sky130_fd_sc_hd__tapvpwrvgnd_1
XFILLER_54_229 vssd1 vssd1 vccd1 vccd1 sky130_fd_sc_hd__fill_2
XFILLER_62_262 vssd1 vssd1 vccd1 vccd1 sky130_fd_sc_hd__fill_1
XFILLER_35_487 vssd1 vssd1 vccd1 vccd1 sky130_fd_sc_hd__fill_4
XTAP_TAPCELL_ROW_73_791 vssd1 vccd1 sky130_fd_sc_hd__tapvpwrvgnd_1
XANTENNA__3061__A1 _0813_ vssd1 vssd1 vccd1 vccd1 sky130_fd_sc_hd__diode_2
X_2935_ _1474_ _1475_ vssd1 vssd1 vccd1 vccd1 _1476_ sky130_fd_sc_hd__xnor2_1
X_2866_ net184 MATMULT_INST.matmult_inst.alu_inst.a1_reg\[7\] _1393_ _1394_ net157
+ vssd1 vssd1 vccd1 vccd1 _1408_ sky130_fd_sc_hd__a32oi_2
XTAP_TAPCELL_ROW_20_338 vssd1 vccd1 sky130_fd_sc_hd__tapvpwrvgnd_1
X_1817_ _0728_ _0729_ vssd1 vssd1 vccd1 vccd1 _0730_ sky130_fd_sc_hd__or2_2
X_2797_ net169 net173 net175 net166 vssd1 vssd1 vccd1 vccd1 _1341_ sky130_fd_sc_hd__a22o_1
XFILLER_7_91 vssd1 vssd1 vccd1 vccd1 sky130_fd_sc_hd__fill_4
Xhold300 MATMULT_INST.matmult_inst.alu_inst.row0\[6\] vssd1 vssd1 vccd1 vccd1 net595
+ sky130_fd_sc_hd__dlygate4sd3_1
Xhold311 MATMULT_INST.matmult_inst.alu_inst.col1\[2\] vssd1 vssd1 vccd1 vccd1 net606
+ sky130_fd_sc_hd__dlygate4sd3_1
Xhold344 _0504_ vssd1 vssd1 vccd1 vccd1 net639 sky130_fd_sc_hd__dlygate4sd3_1
Xhold322 MATMULT_INST.matmult_inst.alu_inst.out\[2\] vssd1 vssd1 vccd1 vccd1 net617
+ sky130_fd_sc_hd__dlygate4sd3_1
X_1748_ MATMULT_INST.matmult_inst.mem_inst.mem1\[6\] net124 net116 MATMULT_INST.matmult_inst.mem_inst.mem2\[6\]
+ _0666_ vssd1 vssd1 vccd1 vccd1 _0667_ sky130_fd_sc_hd__a221o_1
Xhold333 MATMULT_INST.matmult_inst.spi_inst.mosi_data_sync\[4\] vssd1 vssd1 vccd1
+ vccd1 net628 sky130_fd_sc_hd__dlygate4sd3_1
X_1679_ MATMULT_INST.matmult_inst.mem_inst.matrixB1\[12\] net130 net122 MATMULT_INST.matmult_inst.mem_inst.matrixB2\[12\]
+ _0603_ vssd1 vssd1 vccd1 vccd1 _0604_ sky130_fd_sc_hd__a221o_1
Xhold355 MATMULT_INST.matmult_inst.alu_inst.adder_inst.r2.fa1.b vssd1 vssd1 vccd1
+ vccd1 net650 sky130_fd_sc_hd__dlygate4sd3_1
Xhold366 MATMULT_INST.matmult_inst.alu_inst.adder_inst.r1.fa1.b vssd1 vssd1 vccd1
+ vccd1 net661 sky130_fd_sc_hd__dlygate4sd3_1
XANTENNA__1952__X _0802_ vssd1 vssd1 vccd1 vccd1 sky130_fd_sc_hd__diode_2
X_3418_ clknet_leaf_37_clk _0340_ vssd1 vssd1 vccd1 vccd1 MATMULT_INST.matmult_inst.alu_inst.a0_reg\[7\]
+ sky130_fd_sc_hd__dfxtp_1
X_3349_ clknet_leaf_1_clk _0271_ vssd1 vssd1 vccd1 vccd1 MATMULT_INST.matmult_inst.mem_inst.mem2\[4\]
+ sky130_fd_sc_hd__dfxtp_1
XFILLER_26_23 vssd1 vssd1 vccd1 vccd1 sky130_fd_sc_hd__fill_2
XFILLER_26_421 vccd1 vssd1 vccd1 vssd1 sky130_ef_sc_hd__decap_40_12
XFILLER_13_148 vssd1 vssd1 vccd1 vccd1 sky130_fd_sc_hd__fill_1
XTAP_TAPCELL_ROW_36_482 vssd1 vccd1 sky130_fd_sc_hd__tapvpwrvgnd_1
XFILLER_21_181 vccd1 vssd1 vccd1 vssd1 sky130_ef_sc_hd__decap_40_12
XFILLER_3_27 vssd1 vssd1 vccd1 vccd1 sky130_fd_sc_hd__fill_4
XFILLER_44_251 vssd1 vssd1 vccd1 vccd1 sky130_fd_sc_hd__fill_1
XFILLER_32_457 vccd1 vssd1 vccd1 vssd1 sky130_ef_sc_hd__decap_40_12
X_2720_ net168 MATMULT_INST.matmult_inst.alu_inst.b1_reg\[0\] net97 vssd1 vssd1 vccd1
+ vccd1 _1270_ sky130_fd_sc_hd__and3_1
X_2651_ net202 net187 _1204_ _1226_ _1222_ vssd1 vssd1 vccd1 vccd1 _1238_ sky130_fd_sc_hd__a221o_1
XANTENNA__2080__S net18 vssd1 vssd1 vccd1 vccd1 sky130_fd_sc_hd__diode_2
X_1602_ net619 vssd1 vssd1 vccd1 vccd1 _0534_ sky130_fd_sc_hd__inv_2
X_2582_ _1138_ _1169_ vssd1 vssd1 vccd1 vccd1 _1173_ sky130_fd_sc_hd__nand2_1
XFILLER_59_3 vccd1 vssd1 vccd1 vssd1 sky130_ef_sc_hd__decap_40_12
Xfanout109 net110 vssd1 vssd1 vccd1 vccd1 net109 sky130_fd_sc_hd__buf_2
X_3203_ clknet_leaf_16_clk _0125_ vssd1 vssd1 vccd1 vccd1 MATMULT_INST.matmult_inst.mem_inst.matrixB2\[2\]
+ sky130_fd_sc_hd__dfxtp_1
X_3134_ net57 net85 net75 vssd1 vssd1 vccd1 vccd1 _0052_ sky130_fd_sc_hd__and3_1
X_3065_ net419 net52 net7 MATMULT_INST.matmult_inst.fsm_inst.alu_result\[1\] vssd1
+ vssd1 vccd1 vccd1 _0509_ sky130_fd_sc_hd__a22o_1
X_2016_ _0548_ _0558_ net50 vssd1 vssd1 vccd1 vccd1 _0817_ sky130_fd_sc_hd__and3_1
XFILLER_35_273 vssd1 vssd1 vccd1 vccd1 sky130_fd_sc_hd__fill_1
XANTENNA_fanout153_A net154 vssd1 vssd1 vccd1 vccd1 sky130_fd_sc_hd__diode_2
XFILLER_23_424 vssd1 vssd1 vccd1 vccd1 sky130_fd_sc_hd__fill_1
XTAP_TAPCELL_ROW_33_452 vssd1 vccd1 sky130_fd_sc_hd__tapvpwrvgnd_1
X_2918_ _1453_ _1458_ vssd1 vssd1 vccd1 vccd1 _1459_ sky130_fd_sc_hd__and2_1
X_2849_ net184 MATMULT_INST.matmult_inst.alu_inst.a1_reg\[7\] vssd1 vssd1 vccd1 vccd1
+ _1392_ sky130_fd_sc_hd__nand2_1
Xhold130 MATMULT_INST.matmult_inst.mem_inst.mem0\[17\] vssd1 vssd1 vccd1 vccd1 net425
+ sky130_fd_sc_hd__dlygate4sd3_1
Xhold141 MATMULT_INST.matmult_inst.mem_inst.mem0\[16\] vssd1 vssd1 vccd1 vccd1 net436
+ sky130_fd_sc_hd__dlygate4sd3_1
Xhold152 MATMULT_INST.matmult_inst.mem_inst.mem1\[13\] vssd1 vssd1 vccd1 vccd1 net447
+ sky130_fd_sc_hd__dlygate4sd3_1
Xhold163 MATMULT_INST.matmult_inst.mem_inst.mem1\[4\] vssd1 vssd1 vccd1 vccd1 net458
+ sky130_fd_sc_hd__dlygate4sd3_1
Xhold174 MATMULT_INST.matmult_inst.mem_inst.matrixA1\[4\] vssd1 vssd1 vccd1 vccd1
+ net469 sky130_fd_sc_hd__dlygate4sd3_1
Xhold185 _0514_ vssd1 vssd1 vccd1 vccd1 net480 sky130_fd_sc_hd__dlygate4sd3_1
XFILLER_77_129 vssd1 vssd1 vccd1 vccd1 sky130_fd_sc_hd__fill_2
Xhold196 MATMULT_INST.matmult_inst.mem_inst.matrixB3\[3\] vssd1 vssd1 vccd1 vccd1
+ net491 sky130_fd_sc_hd__dlygate4sd3_1
XFILLER_58_398 vccd1 vssd1 vccd1 vssd1 sky130_ef_sc_hd__decap_40_12
XFILLER_26_251 vssd1 vssd1 vccd1 vccd1 sky130_fd_sc_hd__fill_1
XFILLER_41_221 vssd1 vssd1 vccd1 vccd1 sky130_fd_sc_hd__fill_2
XANTENNA_fanout21_X net21 vssd1 vssd1 vccd1 vccd1 sky130_fd_sc_hd__diode_2
XFILLER_53_65 vssd1 vssd1 vccd1 vccd1 sky130_fd_sc_hd__fill_4
Xclkbuf_leaf_21_clk clknet_2_3__leaf_clk vssd1 vssd1 vccd1 vccd1 clknet_leaf_21_clk
+ sky130_fd_sc_hd__clkbuf_8
XFILLER_64_313 vssd1 vssd1 vccd1 vccd1 sky130_fd_sc_hd__fill_1
XANTENNA__1814__A2 net112 vssd1 vssd1 vccd1 vccd1 sky130_fd_sc_hd__diode_2
XANTENNA__2075__S net18 vssd1 vssd1 vccd1 vccd1 sky130_fd_sc_hd__diode_2
XFILLER_20_405 vssd1 vssd1 vccd1 vccd1 sky130_fd_sc_hd__fill_4
XFILLER_32_276 vssd1 vssd1 vccd1 vccd1 sky130_fd_sc_hd__fill_4
Xclkbuf_leaf_12_clk clknet_2_1__leaf_clk vssd1 vssd1 vccd1 vccd1 clknet_leaf_12_clk
+ sky130_fd_sc_hd__clkbuf_8
X_2703_ _1252_ net595 _1256_ vssd1 vssd1 vccd1 vccd1 _0422_ sky130_fd_sc_hd__mux2_1
X_2634_ net199 net185 vssd1 vssd1 vccd1 vccd1 _1222_ sky130_fd_sc_hd__nand2_1
X_2565_ net185 net208 vssd1 vssd1 vccd1 vccd1 _1156_ sky130_fd_sc_hd__and2_1
X_2496_ _1082_ _1086_ _1087_ vssd1 vssd1 vccd1 vccd1 _1089_ sky130_fd_sc_hd__nand3_1
XANTENNA__1750__A1 net222 vssd1 vssd1 vccd1 vccd1 sky130_fd_sc_hd__diode_2
XANTENNA__1750__B2 net216 vssd1 vssd1 vccd1 vccd1 sky130_fd_sc_hd__diode_2
X_3117_ net62 net92 net80 vssd1 vssd1 vccd1 vccd1 _0026_ sky130_fd_sc_hd__and3_1
XFILLER_55_335 vssd1 vssd1 vccd1 vccd1 sky130_fd_sc_hd__fill_1
XFILLER_55_357 vccd1 vssd1 vccd1 vssd1 sky130_ef_sc_hd__decap_40_12
X_3048_ net491 net46 net8 vssd1 vssd1 vccd1 vccd1 _0467_ sky130_fd_sc_hd__mux2_1
XANTENNA__1805__A2 net112 vssd1 vssd1 vccd1 vccd1 sky130_fd_sc_hd__diode_2
XFILLER_11_405 vccd1 vssd1 vccd1 vssd1 sky130_ef_sc_hd__decap_40_12
XFILLER_23_46 vssd1 vssd1 vccd1 vccd1 sky130_fd_sc_hd__fill_8
XFILLER_11_449 vssd1 vssd1 vccd1 vccd1 sky130_fd_sc_hd__fill_1
XFILLER_48_43 vssd1 vssd1 vccd1 vccd1 sky130_fd_sc_hd__fill_4
XANTENNA__1999__S net26 vssd1 vssd1 vccd1 vccd1 sky130_fd_sc_hd__diode_2
XFILLER_73_165 vssd1 vssd1 vccd1 vccd1 sky130_fd_sc_hd__fill_2
XFILLER_73_187 vssd1 vssd1 vccd1 vccd1 sky130_fd_sc_hd__fill_2
XTAP_TAPCELL_ROW_1_180 vssd1 vccd1 sky130_fd_sc_hd__tapvpwrvgnd_1
XTAP_TAPCELL_ROW_44_547 vssd1 vccd1 sky130_fd_sc_hd__tapvpwrvgnd_1
XFILLER_14_265 vssd1 vssd1 vccd1 vccd1 sky130_fd_sc_hd__fill_2
XFILLER_14_276 vccd1 vssd1 vccd1 vssd1 sky130_ef_sc_hd__decap_40_12
Xfanout91 net92 vssd1 vssd1 vccd1 vccd1 net91 sky130_fd_sc_hd__clkbuf_2
Xfanout80 net81 vssd1 vssd1 vccd1 vccd1 net80 sky130_fd_sc_hd__buf_2
XFILLER_6_475 vssd1 vssd1 vccd1 vccd1 sky130_fd_sc_hd__fill_1
XANTENNA__1980__A1 _0798_ vssd1 vssd1 vccd1 vccd1 sky130_fd_sc_hd__diode_2
X_2350_ net198 net196 net209 net211 vssd1 vssd1 vccd1 vccd1 _0948_ sky130_fd_sc_hd__and4_1
XFILLER_69_449 vccd1 vssd1 vccd1 vssd1 sky130_ef_sc_hd__decap_40_12
X_2281_ _0904_ _0905_ vssd1 vssd1 vccd1 vccd1 _0906_ sky130_fd_sc_hd__xnor2_1
Xclkbuf_leaf_1_clk clknet_2_0__leaf_clk vssd1 vssd1 vccd1 vccd1 clknet_leaf_1_clk
+ sky130_fd_sc_hd__clkbuf_8
XFILLER_37_313 vssd1 vssd1 vccd1 vccd1 sky130_fd_sc_hd__fill_1
XFILLER_45_390 vssd1 vssd1 vccd1 vccd1 sky130_fd_sc_hd__fill_2
XANTENNA__1799__A1 net216 vssd1 vssd1 vccd1 vccd1 sky130_fd_sc_hd__diode_2
X_1996_ net416 net32 net29 vssd1 vssd1 vccd1 vccd1 _0158_ sky130_fd_sc_hd__mux2_1
XFILLER_20_257 vssd1 vssd1 vccd1 vccd1 sky130_fd_sc_hd__fill_1
XANTENNA__1971__A1 net35 vssd1 vssd1 vccd1 vccd1 sky130_fd_sc_hd__diode_2
XANTENNA_fanout116_A net123 vssd1 vssd1 vccd1 vccd1 sky130_fd_sc_hd__diode_2
X_2617_ _1185_ _1187_ _1184_ vssd1 vssd1 vccd1 vccd1 _1206_ sky130_fd_sc_hd__a21o_1
X_3597_ clknet_leaf_17_clk _0490_ _0095_ vssd1 vssd1 vccd1 vccd1 MATMULT_INST.matmult_inst.spi_inst.tx_reg_sys\[0\]
+ sky130_fd_sc_hd__dfrtp_1
X_2548_ _1080_ _1135_ _1136_ _1139_ vssd1 vssd1 vccd1 vccd1 _1140_ sky130_fd_sc_hd__nor4_1
XTAP_TAPCELL_ROW_7_228 vssd1 vccd1 sky130_fd_sc_hd__tapvpwrvgnd_1
X_2479_ _1070_ _1071_ vssd1 vssd1 vccd1 vccd1 _1072_ sky130_fd_sc_hd__xnor2_1
XFILLER_68_493 vssd1 vssd1 vccd1 vccd1 sky130_fd_sc_hd__fill_1
XFILLER_18_46 vssd1 vssd1 vccd1 vccd1 sky130_fd_sc_hd__fill_4
XTAP_TAPCELL_ROW_41_517 vssd1 vccd1 sky130_fd_sc_hd__tapvpwrvgnd_1
XFILLER_51_393 vssd1 vssd1 vccd1 vccd1 sky130_fd_sc_hd__fill_8
XFILLER_11_279 vssd1 vssd1 vccd1 vccd1 sky130_fd_sc_hd__fill_1
Xclkload0 clknet_2_0__leaf_clk vssd1 vssd1 vccd1 vccd1 clkload0/Y sky130_fd_sc_hd__inv_8
XFILLER_59_493 vssd1 vssd1 vccd1 vccd1 sky130_fd_sc_hd__fill_1
XFILLER_74_474 vssd1 vssd1 vccd1 vccd1 sky130_fd_sc_hd__fill_2
XANTENNA__2690__A2 _1248_ vssd1 vssd1 vccd1 vccd1 sky130_fd_sc_hd__diode_2
XFILLER_61_113 vssd1 vssd1 vccd1 vccd1 sky130_fd_sc_hd__fill_2
X_1850_ MATMULT_INST.matmult_inst.spi_inst.rx_done_spi _0744_ vssd1 vssd1 vccd1 vccd1
+ _0455_ sky130_fd_sc_hd__nand2b_1
X_1781_ net148 net140 MATMULT_INST.matmult_inst.mem_inst.matrixB3\[3\] vssd1 vssd1
+ vccd1 vccd1 _0697_ sky130_fd_sc_hd__and3_1
XTAP_TAPCELL_ROW_12_274 vssd1 vccd1 sky130_fd_sc_hd__tapvpwrvgnd_1
X_3520_ clknet_leaf_31_clk _0437_ vssd1 vssd1 vccd1 vccd1 MATMULT_INST.matmult_inst.alu_inst.adder_inst.r2.fa3.b
+ sky130_fd_sc_hd__dfxtp_1
XFILLER_6_261 vssd1 vssd1 vccd1 vccd1 sky130_fd_sc_hd__fill_2
X_3451_ clknet_leaf_34_clk _0373_ vssd1 vssd1 vccd1 vccd1 MATMULT_INST.matmult_inst.alu_inst.a1_reg\[6\]
+ sky130_fd_sc_hd__dfxtp_1
X_2402_ _0995_ _0997_ vssd1 vssd1 vccd1 vccd1 _0998_ sky130_fd_sc_hd__or2_1
XFILLER_41_3 vssd1 vssd1 vccd1 vccd1 sky130_fd_sc_hd__fill_2
X_3382_ clknet_leaf_5_clk _0304_ vssd1 vssd1 vccd1 vccd1 MATMULT_INST.matmult_inst.mem_inst.mem0\[1\]
+ sky130_fd_sc_hd__dfxtp_1
X_2333_ MATMULT_INST.matmult_inst.alu_inst.a0_reg\[0\] net215 net96 vssd1 vssd1 vccd1
+ vccd1 _0934_ sky130_fd_sc_hd__and3_1
XTAP_TAPCELL_ROW_4_209 vssd1 vccd1 sky130_fd_sc_hd__tapvpwrvgnd_1
XFILLER_57_408 vccd1 vssd1 vccd1 vssd1 sky130_ef_sc_hd__decap_40_12
X_2264_ net513 _0891_ net99 vssd1 vssd1 vccd1 vccd1 _0349_ sky130_fd_sc_hd__mux2_1
X_2195_ net211 net359 net66 vssd1 vssd1 vccd1 vccd1 _0327_ sky130_fd_sc_hd__mux2_1
XANTENNA__2681__A2 _1248_ vssd1 vssd1 vccd1 vccd1 sky130_fd_sc_hd__diode_2
XFILLER_37_198 vssd1 vssd1 vccd1 vccd1 sky130_fd_sc_hd__fill_8
XFILLER_52_102 vssd1 vssd1 vccd1 vccd1 sky130_fd_sc_hd__fill_1
XANTENNA__1668__A net150 vssd1 vssd1 vccd1 vccd1 sky130_fd_sc_hd__diode_2
X_1979_ net410 net49 net28 vssd1 vssd1 vccd1 vccd1 _0141_ sky130_fd_sc_hd__mux2_1
Xhold12 MATMULT_INST.matmult_inst.fsm_inst.alu_result\[15\] vssd1 vssd1 vccd1 vccd1
+ net307 sky130_fd_sc_hd__dlygate4sd3_1
Xhold23 MATMULT_INST.matmult_inst.mem_inst.matrixA3\[2\] vssd1 vssd1 vccd1 vccd1 net318
+ sky130_fd_sc_hd__dlygate4sd3_1
Xhold34 MATMULT_INST.matmult_inst.mem_inst.matrixA3\[14\] vssd1 vssd1 vccd1 vccd1
+ net329 sky130_fd_sc_hd__dlygate4sd3_1
Xhold45 MATMULT_INST.matmult_inst.mem_inst.matrixA3\[3\] vssd1 vssd1 vccd1 vccd1 net340
+ sky130_fd_sc_hd__dlygate4sd3_1
Xhold56 MATMULT_INST.matmult_inst.mem_inst.matrixA3\[7\] vssd1 vssd1 vccd1 vccd1 net351
+ sky130_fd_sc_hd__dlygate4sd3_1
Xhold89 MATMULT_INST.matmult_inst.mem_inst.matrixA3\[12\] vssd1 vssd1 vccd1 vccd1
+ net384 sky130_fd_sc_hd__dlygate4sd3_1
Xhold78 MATMULT_INST.matmult_inst.mem_inst.matrixB0\[11\] vssd1 vssd1 vccd1 vccd1
+ net373 sky130_fd_sc_hd__dlygate4sd3_1
XFILLER_68_290 vssd1 vssd1 vccd1 vccd1 sky130_fd_sc_hd__fill_4
Xhold67 _0511_ vssd1 vssd1 vccd1 vccd1 net362 sky130_fd_sc_hd__dlygate4sd3_1
XANTENNA__1850__B _0744_ vssd1 vssd1 vccd1 vccd1 sky130_fd_sc_hd__diode_2
XFILLER_16_327 vssd1 vssd1 vccd1 vccd1 sky130_fd_sc_hd__fill_1
XFILLER_43_113 vssd1 vssd1 vccd1 vccd1 sky130_fd_sc_hd__fill_1
XFILLER_45_55 vssd1 vssd1 vccd1 vccd1 sky130_fd_sc_hd__fill_1
XFILLER_71_444 vssd1 vssd1 vccd1 vccd1 sky130_fd_sc_hd__fill_1
XTAP_TAPCELL_ROW_54_631 vssd1 vccd1 sky130_fd_sc_hd__tapvpwrvgnd_1
XFILLER_24_393 vssd1 vssd1 vccd1 vccd1 sky130_fd_sc_hd__fill_8
XFILLER_61_76 vssd1 vssd1 vccd1 vccd1 sky130_fd_sc_hd__fill_2
XFILLER_62_433 vssd1 vssd1 vccd1 vccd1 sky130_fd_sc_hd__fill_1
XFILLER_62_466 vssd1 vssd1 vccd1 vccd1 sky130_fd_sc_hd__fill_1
XFILLER_34_135 vssd1 vssd1 vccd1 vccd1 sky130_fd_sc_hd__fill_4
XFILLER_15_371 vssd1 vssd1 vccd1 vccd1 sky130_fd_sc_hd__fill_2
X_2951_ _1489_ _1490_ vssd1 vssd1 vccd1 vccd1 _1491_ sky130_fd_sc_hd__xor2_1
XFILLER_34_179 vssd1 vssd1 vccd1 vccd1 sky130_fd_sc_hd__fill_4
XANTENNA__1623__B1 net121 vssd1 vssd1 vccd1 vccd1 sky130_fd_sc_hd__diode_2
X_1902_ _0776_ _0779_ _0754_ _0775_ vssd1 vssd1 vccd1 vccd1 _0780_ sky130_fd_sc_hd__a211o_1
XANTENNA__2083__S net19 vssd1 vssd1 vccd1 vccd1 sky130_fd_sc_hd__diode_2
X_2882_ _1420_ _1421_ _1422_ vssd1 vssd1 vccd1 vccd1 _1424_ sky130_fd_sc_hd__a21o_1
XANTENNA_clkbuf_0_clk_A clk vssd1 vssd1 vccd1 vccd1 sky130_fd_sc_hd__diode_2
XTAP_TAPCELL_ROW_60_678 vssd1 vccd1 sky130_fd_sc_hd__tapvpwrvgnd_1
X_1833_ net132 _1593_ _0540_ vssd1 vssd1 vccd1 vccd1 _0737_ sky130_fd_sc_hd__or3b_1
X_1764_ net637 _0681_ net63 vssd1 vssd1 vccd1 vccd1 _0495_ sky130_fd_sc_hd__mux2_1
X_3503_ clknet_leaf_37_clk _0421_ vssd1 vssd1 vccd1 vccd1 MATMULT_INST.matmult_inst.alu_inst.row0\[5\]
+ sky130_fd_sc_hd__dfxtp_1
X_1695_ net221 _0616_ _0618_ net223 vssd1 vssd1 vccd1 vccd1 _0619_ sky130_fd_sc_hd__a22o_1
X_3434_ clknet_leaf_26_clk _0356_ vssd1 vssd1 vccd1 vccd1 MATMULT_INST.matmult_inst.alu_inst.out\[15\]
+ sky130_fd_sc_hd__dfxtp_1
X_3365_ clknet_leaf_16_clk _0287_ vssd1 vssd1 vccd1 vccd1 MATMULT_INST.matmult_inst.mem_inst.mem1\[2\]
+ sky130_fd_sc_hd__dfxtp_1
X_2316_ net183 net515 net68 vssd1 vssd1 vccd1 vccd1 _0360_ sky130_fd_sc_hd__mux2_1
X_3296_ clknet_leaf_7_clk _0218_ vssd1 vssd1 vccd1 vccd1 MATMULT_INST.matmult_inst.mem_inst.matrixA1\[5\]
+ sky130_fd_sc_hd__dfxtp_1
X_2247_ _0857_ _0862_ _0865_ _0868_ _0863_ vssd1 vssd1 vccd1 vccd1 _0877_ sky130_fd_sc_hd__o311a_1
XFILLER_57_249 vssd1 vssd1 vccd1 vccd1 sky130_fd_sc_hd__fill_2
XANTENNA__2103__A1 net39 vssd1 vssd1 vccd1 vccd1 sky130_fd_sc_hd__diode_2
XFILLER_25_102 vssd1 vssd1 vccd1 vccd1 sky130_fd_sc_hd__fill_1
XFILLER_25_113 vssd1 vssd1 vccd1 vccd1 sky130_fd_sc_hd__fill_2
X_2178_ MATMULT_INST.matmult_inst.fsm_inst.count\[0\] _0832_ _0834_ vssd1 vssd1 vccd1
+ vccd1 _0835_ sky130_fd_sc_hd__or3b_1
XANTENNA__1862__B1 net2 vssd1 vssd1 vccd1 vccd1 sky130_fd_sc_hd__diode_2
XFILLER_40_149 vssd1 vssd1 vccd1 vccd1 sky130_fd_sc_hd__fill_1
XTAP_TAPCELL_ROW_23_369 vssd1 vccd1 sky130_fd_sc_hd__tapvpwrvgnd_1
XFILLER_31_57 vssd1 vssd1 vccd1 vccd1 sky130_fd_sc_hd__fill_1
XANTENNA_fanout96_A net98 vssd1 vssd1 vccd1 vccd1 sky130_fd_sc_hd__diode_2
XFILLER_0_223 vssd1 vssd1 vccd1 vccd1 sky130_fd_sc_hd__fill_1
XFILLER_0_278 vssd1 vssd1 vccd1 vccd1 sky130_fd_sc_hd__fill_2
XFILLER_48_205 vssd1 vssd1 vccd1 vccd1 sky130_fd_sc_hd__fill_1
XFILLER_0_289 vssd1 vssd1 vccd1 vccd1 sky130_fd_sc_hd__fill_1
XANTENNA_clkbuf_leaf_2_clk_A clknet_2_0__leaf_clk vssd1 vssd1 vccd1 vccd1 sky130_fd_sc_hd__diode_2
XFILLER_71_241 vssd1 vssd1 vccd1 vccd1 sky130_fd_sc_hd__fill_1
XPHY_EDGE_ROW_19_Right_19 vssd1 vssd1 vccd1 vccd1 sky130_fd_sc_hd__decap_3
XFILLER_72_53 vssd1 vssd1 vccd1 vccd1 sky130_fd_sc_hd__fill_8
XFILLER_44_477 vssd1 vssd1 vccd1 vccd1 sky130_fd_sc_hd__fill_2
XFILLER_72_97 vssd1 vssd1 vccd1 vccd1 sky130_fd_sc_hd__fill_1
XFILLER_12_363 vssd1 vssd1 vccd1 vccd1 sky130_fd_sc_hd__fill_1
XFILLER_8_323 vccd1 vssd1 vccd1 vssd1 sky130_ef_sc_hd__decap_40_12
XPHY_EDGE_ROW_28_Right_28 vssd1 vssd1 vccd1 vccd1 sky130_fd_sc_hd__decap_3
XFILLER_79_363 vssd1 vssd1 vccd1 vccd1 sky130_fd_sc_hd__fill_1
X_3150_ net55 net85 net76 vssd1 vssd1 vccd1 vccd1 _0075_ sky130_fd_sc_hd__and3_1
X_2101_ net322 net41 net17 vssd1 vssd1 vccd1 vccd1 _0257_ sky130_fd_sc_hd__mux2_1
X_3081_ MATMULT_INST.matmult_inst.alu_inst.out\[17\] net52 net6 net337 vssd1 vssd1
+ vccd1 vccd1 _0525_ sky130_fd_sc_hd__a22o_1
XANTENNA__2078__S net18 vssd1 vssd1 vccd1 vccd1 sky130_fd_sc_hd__diode_2
X_2032_ net353 net34 net25 vssd1 vssd1 vccd1 vccd1 _0192_ sky130_fd_sc_hd__mux2_1
XTAP_TAPCELL_ROW_65_726 vssd1 vccd1 sky130_fd_sc_hd__tapvpwrvgnd_1
XPHY_EDGE_ROW_37_Right_37 vssd1 vssd1 vccd1 vccd1 sky130_fd_sc_hd__decap_3
XFILLER_35_466 vssd1 vssd1 vccd1 vccd1 sky130_fd_sc_hd__fill_4
XTAP_TAPCELL_ROW_73_792 vssd1 vccd1 sky130_fd_sc_hd__tapvpwrvgnd_1
XFILLER_62_285 vssd1 vssd1 vccd1 vccd1 sky130_fd_sc_hd__fill_2
XFILLER_22_138 vssd1 vssd1 vccd1 vccd1 sky130_fd_sc_hd__fill_2
X_2934_ _1437_ _1439_ _1436_ vssd1 vssd1 vccd1 vccd1 _1475_ sky130_fd_sc_hd__o21a_1
X_2865_ net166 net171 _1339_ vssd1 vssd1 vccd1 vccd1 _1407_ sky130_fd_sc_hd__and3_1
XTAP_TAPCELL_ROW_20_339 vssd1 vccd1 sky130_fd_sc_hd__tapvpwrvgnd_1
XPHY_EDGE_ROW_46_Right_46 vssd1 vssd1 vccd1 vccd1 sky130_fd_sc_hd__decap_3
X_1816_ MATMULT_INST.matmult_inst.mem_inst.matrixB0\[0\] net104 _0724_ net219 _0727_
+ vssd1 vssd1 vccd1 vccd1 _0729_ sky130_fd_sc_hd__a221o_1
X_2796_ net169 net166 net173 net175 vssd1 vssd1 vccd1 vccd1 _1340_ sky130_fd_sc_hd__nand4_2
Xhold301 MATMULT_INST.matmult_inst.alu_inst.col1\[6\] vssd1 vssd1 vccd1 vccd1 net596
+ sky130_fd_sc_hd__dlygate4sd3_1
Xhold312 MATMULT_INST.matmult_inst.alu_inst.adder_inst.r1.fa3.b vssd1 vssd1 vccd1
+ vccd1 net607 sky130_fd_sc_hd__dlygate4sd3_1
Xhold323 MATMULT_INST.matmult_inst.alu_inst.b1_reg\[0\] vssd1 vssd1 vccd1 vccd1 net618
+ sky130_fd_sc_hd__dlygate4sd3_1
X_1747_ net146 net138 MATMULT_INST.matmult_inst.mem_inst.mem3\[6\] vssd1 vssd1 vccd1
+ vccd1 _0666_ sky130_fd_sc_hd__and3_1
Xhold334 _0486_ vssd1 vssd1 vccd1 vccd1 net629 sky130_fd_sc_hd__dlygate4sd3_1
Xhold345 MATMULT_INST.matmult_inst.spi_inst.tx_reg_sys\[17\] vssd1 vssd1 vccd1 vccd1
+ net640 sky130_fd_sc_hd__dlygate4sd3_1
X_1678_ net153 net144 MATMULT_INST.matmult_inst.mem_inst.matrixB3\[12\] vssd1 vssd1
+ vccd1 vccd1 _0603_ sky130_fd_sc_hd__and3_1
Xhold356 MATMULT_INST.matmult_inst.spi_inst.tx_reg_sys\[13\] vssd1 vssd1 vccd1 vccd1
+ net651 sky130_fd_sc_hd__dlygate4sd3_1
Xhold367 MATMULT_INST.matmult_inst.spi_inst.current_state vssd1 vssd1 vccd1 vccd1
+ net662 sky130_fd_sc_hd__dlygate4sd3_1
X_3417_ clknet_leaf_37_clk _0339_ vssd1 vssd1 vccd1 vccd1 MATMULT_INST.matmult_inst.alu_inst.a0_reg\[6\]
+ sky130_fd_sc_hd__dfxtp_1
X_3348_ clknet_leaf_3_clk _0270_ vssd1 vssd1 vccd1 vccd1 MATMULT_INST.matmult_inst.mem_inst.mem2\[3\]
+ sky130_fd_sc_hd__dfxtp_1
X_3279_ clknet_leaf_7_clk _0201_ vssd1 vssd1 vccd1 vccd1 MATMULT_INST.matmult_inst.mem_inst.matrixA2\[6\]
+ sky130_fd_sc_hd__dfxtp_1
XPHY_EDGE_ROW_55_Right_55 vssd1 vssd1 vccd1 vccd1 sky130_fd_sc_hd__decap_3
XTAP_TAPCELL_ROW_28_406 vssd1 vccd1 sky130_fd_sc_hd__tapvpwrvgnd_1
XFILLER_26_433 vccd1 vssd1 vccd1 vssd1 sky130_ef_sc_hd__decap_40_12
XFILLER_13_105 vssd1 vssd1 vccd1 vccd1 sky130_fd_sc_hd__fill_4
XFILLER_41_447 vssd1 vssd1 vccd1 vccd1 sky130_fd_sc_hd__fill_1
XFILLER_9_109 vssd1 vssd1 vccd1 vccd1 sky130_fd_sc_hd__fill_2
XPHY_EDGE_ROW_64_Right_64 vssd1 vssd1 vccd1 vccd1 sky130_fd_sc_hd__decap_3
XFILLER_42_45 vssd1 vssd1 vccd1 vccd1 sky130_fd_sc_hd__fill_1
XFILLER_21_193 vssd1 vssd1 vccd1 vccd1 sky130_fd_sc_hd__fill_2
XANTENNA__2012__B1 net27 vssd1 vssd1 vccd1 vccd1 sky130_fd_sc_hd__diode_2
XFILLER_5_348 vssd1 vssd1 vccd1 vccd1 sky130_fd_sc_hd__fill_4
XFILLER_3_39 vssd1 vssd1 vccd1 vccd1 sky130_fd_sc_hd__fill_8
XPHY_EDGE_ROW_73_Right_73 vssd1 vssd1 vccd1 vccd1 sky130_fd_sc_hd__decap_3
XANTENNA__2866__A2 MATMULT_INST.matmult_inst.alu_inst.a1_reg\[7\] vssd1 vssd1 vccd1
+ vccd1 sky130_fd_sc_hd__diode_2
XFILLER_32_469 vssd1 vssd1 vccd1 vccd1 sky130_fd_sc_hd__fill_4
X_2650_ net199 MATMULT_INST.matmult_inst.alu_inst.a0_reg\[7\] _1210_ _1236_ vssd1
+ vssd1 vccd1 vccd1 _1237_ sky130_fd_sc_hd__a31o_1
XFILLER_8_164 vccd1 vssd1 vccd1 vssd1 sky130_ef_sc_hd__decap_40_12
X_1601_ MATMULT_INST.matmult_inst.fsm_inst.count\[3\] vssd1 vssd1 vccd1 vccd1 _0533_
+ sky130_fd_sc_hd__inv_2
X_2581_ _1138_ _1169_ vssd1 vssd1 vccd1 vccd1 _1172_ sky130_fd_sc_hd__and2_1
XANTENNA__2306__A1 _0926_ vssd1 vssd1 vccd1 vccd1 sky130_fd_sc_hd__diode_2
X_3202_ clknet_leaf_5_clk _0124_ vssd1 vssd1 vccd1 vccd1 MATMULT_INST.matmult_inst.mem_inst.matrixB2\[1\]
+ sky130_fd_sc_hd__dfxtp_1
X_3133_ net227 vssd1 vssd1 vccd1 vccd1 _0051_ sky130_fd_sc_hd__inv_2
X_3064_ net600 net52 net7 MATMULT_INST.matmult_inst.fsm_inst.alu_result\[0\] vssd1
+ vssd1 vccd1 vccd1 _0508_ sky130_fd_sc_hd__a22o_1
X_2015_ net107 net32 net27 net387 vssd1 vssd1 vccd1 vccd1 _0176_ sky130_fd_sc_hd__a22o_1
XPHY_EDGE_ROW_19_Left_99 vssd1 vssd1 vccd1 vccd1 sky130_fd_sc_hd__decap_3
XFILLER_23_447 vssd1 vssd1 vccd1 vccd1 sky130_fd_sc_hd__fill_1
XFILLER_35_285 vssd1 vssd1 vccd1 vccd1 sky130_fd_sc_hd__fill_2
XTAP_TAPCELL_ROW_33_453 vssd1 vccd1 sky130_fd_sc_hd__tapvpwrvgnd_1
XANTENNA_fanout146_A net149 vssd1 vssd1 vccd1 vccd1 sky130_fd_sc_hd__diode_2
X_2917_ _1456_ _1457_ vssd1 vssd1 vccd1 vccd1 _1458_ sky130_fd_sc_hd__xor2_1
XFILLER_12_15 vccd1 vssd1 vccd1 vssd1 sky130_ef_sc_hd__decap_40_12
XFILLER_31_491 vssd1 vssd1 vccd1 vccd1 sky130_fd_sc_hd__fill_2
X_2848_ _1389_ _1390_ vssd1 vssd1 vccd1 vccd1 _1391_ sky130_fd_sc_hd__and2b_1
X_2779_ net182 net184 net161 net159 vssd1 vssd1 vccd1 vccd1 _1324_ sky130_fd_sc_hd__nand4_2
Xhold142 MATMULT_INST.matmult_inst.mem_inst.matrixB2\[8\] vssd1 vssd1 vccd1 vccd1
+ net437 sky130_fd_sc_hd__dlygate4sd3_1
Xhold153 MATMULT_INST.matmult_inst.mem_inst.matrixA1\[15\] vssd1 vssd1 vccd1 vccd1
+ net448 sky130_fd_sc_hd__dlygate4sd3_1
XFILLER_2_329 vssd1 vssd1 vccd1 vccd1 sky130_fd_sc_hd__fill_4
Xhold120 MATMULT_INST.matmult_inst.mem_inst.matrixA1\[1\] vssd1 vssd1 vccd1 vccd1
+ net415 sky130_fd_sc_hd__dlygate4sd3_1
Xhold131 MATMULT_INST.matmult_inst.mem_inst.matrixA3\[1\] vssd1 vssd1 vccd1 vccd1
+ net426 sky130_fd_sc_hd__dlygate4sd3_1
Xhold175 MATMULT_INST.matmult_inst.mem_inst.mem1\[15\] vssd1 vssd1 vccd1 vccd1 net470
+ sky130_fd_sc_hd__dlygate4sd3_1
Xhold164 MATMULT_INST.matmult_inst.mem_inst.matrixB1\[13\] vssd1 vssd1 vccd1 vccd1
+ net459 sky130_fd_sc_hd__dlygate4sd3_1
Xhold186 MATMULT_INST.matmult_inst.alu_inst.row1\[4\] vssd1 vssd1 vccd1 vccd1 net481
+ sky130_fd_sc_hd__dlygate4sd3_1
Xhold197 MATMULT_INST.matmult_inst.mem_inst.matrixB1\[14\] vssd1 vssd1 vccd1 vccd1
+ net492 sky130_fd_sc_hd__dlygate4sd3_1
XANTENNA_fanout59_A net62 vssd1 vssd1 vccd1 vccd1 sky130_fd_sc_hd__diode_2
XFILLER_53_11 vssd1 vssd1 vccd1 vccd1 sky130_fd_sc_hd__fill_2
XFILLER_14_447 vccd1 vssd1 vccd1 vssd1 sky130_ef_sc_hd__decap_40_12
XFILLER_26_274 vssd1 vssd1 vccd1 vccd1 sky130_fd_sc_hd__fill_2
XFILLER_53_33 vccd1 vssd1 vccd1 vssd1 sky130_ef_sc_hd__decap_40_12
XANTENNA_fanout14_X net14 vssd1 vssd1 vccd1 vccd1 sky130_fd_sc_hd__diode_2
XFILLER_78_41 vssd1 vssd1 vccd1 vccd1 sky130_fd_sc_hd__fill_1
XFILLER_78_85 vssd1 vssd1 vccd1 vccd1 sky130_fd_sc_hd__fill_2
XFILLER_49_300 vssd1 vssd1 vccd1 vccd1 sky130_fd_sc_hd__fill_1
XFILLER_76_141 vssd1 vssd1 vccd1 vccd1 sky130_fd_sc_hd__fill_1
XTAP_TAPCELL_ROW_75_810 vssd1 vccd1 sky130_fd_sc_hd__tapvpwrvgnd_1
XFILLER_72_380 vssd1 vssd1 vccd1 vccd1 sky130_fd_sc_hd__fill_4
XFILLER_20_417 vssd1 vssd1 vccd1 vccd1 sky130_fd_sc_hd__fill_2
XANTENNA__2091__S net19 vssd1 vssd1 vccd1 vccd1 sky130_fd_sc_hd__diode_2
X_2702_ _1251_ net609 _1256_ vssd1 vssd1 vccd1 vccd1 _0421_ sky130_fd_sc_hd__mux2_1
XTAP_TAPCELL_ROW_30_423 vssd1 vccd1 sky130_fd_sc_hd__tapvpwrvgnd_1
XFILLER_71_3 vssd1 vssd1 vccd1 vccd1 sky130_fd_sc_hd__fill_1
X_2633_ net200 net187 net185 net202 vssd1 vssd1 vccd1 vccd1 _1221_ sky130_fd_sc_hd__a22o_1
X_2564_ net188 net186 net204 net206 vssd1 vssd1 vccd1 vccd1 _1155_ sky130_fd_sc_hd__and4_1
X_2495_ _1086_ _1087_ _1082_ vssd1 vssd1 vccd1 vccd1 _1088_ sky130_fd_sc_hd__a21o_1
XFILLER_4_60 vssd1 vssd1 vccd1 vccd1 sky130_fd_sc_hd__fill_8
XFILLER_4_82 vssd1 vssd1 vccd1 vccd1 sky130_fd_sc_hd__fill_2
X_3116_ net61 net91 net79 vssd1 vssd1 vccd1 vccd1 _0028_ sky130_fd_sc_hd__and3_1
X_3047_ net427 _0799_ net8 vssd1 vssd1 vccd1 vccd1 _0466_ sky130_fd_sc_hd__mux2_1
XFILLER_55_369 vccd1 vssd1 vccd1 vssd1 sky130_ef_sc_hd__decap_40_12
XANTENNA__1958__X _0805_ vssd1 vssd1 vccd1 vccd1 sky130_fd_sc_hd__diode_2
XFILLER_11_417 vccd1 vssd1 vccd1 vssd1 sky130_ef_sc_hd__decap_40_12
XANTENNA_fanout149_X net149 vssd1 vssd1 vccd1 vccd1 sky130_fd_sc_hd__diode_2
XFILLER_48_55 vssd1 vssd1 vccd1 vccd1 sky130_fd_sc_hd__fill_8
XFILLER_58_141 vssd1 vssd1 vccd1 vccd1 sky130_fd_sc_hd__fill_8
XFILLER_58_174 vssd1 vssd1 vccd1 vccd1 sky130_fd_sc_hd__fill_4
XFILLER_0_29 vssd1 vssd1 vccd1 vccd1 sky130_fd_sc_hd__fill_2
XTAP_TAPCELL_ROW_1_181 vssd1 vccd1 sky130_fd_sc_hd__tapvpwrvgnd_1
XFILLER_54_391 vssd1 vssd1 vccd1 vccd1 sky130_fd_sc_hd__fill_4
XFILLER_14_244 vssd1 vssd1 vccd1 vccd1 sky130_fd_sc_hd__fill_1
XTAP_TAPCELL_ROW_44_548 vssd1 vccd1 sky130_fd_sc_hd__tapvpwrvgnd_1
XFILLER_14_288 vssd1 vssd1 vccd1 vccd1 sky130_fd_sc_hd__fill_8
XFILLER_9_49 vssd1 vssd1 vccd1 vccd1 sky130_fd_sc_hd__fill_4
Xfanout70 _0794_ vssd1 vssd1 vccd1 vccd1 net70 sky130_fd_sc_hd__buf_2
Xfanout81 _0739_ vssd1 vssd1 vccd1 vccd1 net81 sky130_fd_sc_hd__clkbuf_2
Xfanout92 _0735_ vssd1 vssd1 vccd1 vccd1 net92 sky130_fd_sc_hd__clkbuf_2
XFILLER_10_461 vccd1 vssd1 vccd1 vssd1 sky130_ef_sc_hd__decap_40_12
XFILLER_13_80 vccd1 vssd1 vccd1 vssd1 sky130_ef_sc_hd__decap_40_12
XFILLER_6_443 vssd1 vssd1 vccd1 vccd1 sky130_fd_sc_hd__fill_1
XFILLER_6_421 vssd1 vssd1 vccd1 vccd1 sky130_fd_sc_hd__fill_4
XPHY_EDGE_ROW_23_Left_103 vssd1 vssd1 vccd1 vccd1 sky130_fd_sc_hd__decap_3
XFILLER_69_428 vssd1 vssd1 vccd1 vccd1 sky130_fd_sc_hd__fill_1
X_2280_ _0897_ _0900_ _0898_ vssd1 vssd1 vccd1 vccd1 _0905_ sky130_fd_sc_hd__a21bo_1
XFILLER_1_181 vssd1 vssd1 vccd1 vccd1 sky130_fd_sc_hd__fill_2
XFILLER_49_141 vssd1 vssd1 vccd1 vccd1 sky130_fd_sc_hd__fill_8
XFILLER_77_461 vccd1 vssd1 vccd1 vssd1 sky130_ef_sc_hd__decap_40_12
XPHY_EDGE_ROW_32_Left_112 vssd1 vssd1 vccd1 vccd1 sky130_fd_sc_hd__decap_3
XFILLER_37_347 vssd1 vssd1 vccd1 vccd1 sky130_fd_sc_hd__fill_4
XFILLER_49_185 vssd1 vssd1 vccd1 vccd1 sky130_fd_sc_hd__fill_1
XANTENNA__2086__S net19 vssd1 vssd1 vccd1 vccd1 sky130_fd_sc_hd__diode_2
X_1995_ net473 net33 net29 vssd1 vssd1 vccd1 vccd1 _0157_ sky130_fd_sc_hd__mux2_1
XPHY_EDGE_ROW_41_Left_121 vssd1 vssd1 vccd1 vccd1 sky130_fd_sc_hd__decap_3
XFILLER_9_281 vssd1 vssd1 vccd1 vccd1 sky130_fd_sc_hd__fill_8
X_2616_ _1177_ _1202_ vssd1 vssd1 vccd1 vccd1 _1205_ sky130_fd_sc_hd__xnor2_1
X_3596_ net226 net293 _0094_ vssd1 vssd1 vccd1 vccd1 MATMULT_INST.matmult_inst.spi_inst.first_bit_sent
+ sky130_fd_sc_hd__dfrtp_1
X_2547_ _1079_ _1097_ vssd1 vssd1 vccd1 vccd1 _1139_ sky130_fd_sc_hd__nor2_1
XTAP_TAPCELL_ROW_7_229 vssd1 vccd1 sky130_fd_sc_hd__tapvpwrvgnd_1
X_2478_ net214 net185 _1056_ _1057_ net186 vssd1 vssd1 vccd1 vccd1 _1071_ sky130_fd_sc_hd__a32oi_2
XPHY_EDGE_ROW_50_Left_130 vssd1 vssd1 vccd1 vccd1 sky130_fd_sc_hd__decap_3
XFILLER_28_325 vccd1 vssd1 vccd1 vssd1 sky130_ef_sc_hd__decap_40_12
XANTENNA__2684__B1 _1254_ vssd1 vssd1 vccd1 vccd1 sky130_fd_sc_hd__diode_2
XFILLER_55_111 vssd1 vssd1 vccd1 vccd1 sky130_fd_sc_hd__fill_1
XTAP_TAPCELL_ROW_41_518 vssd1 vccd1 sky130_fd_sc_hd__tapvpwrvgnd_1
XFILLER_11_269 vssd1 vssd1 vccd1 vccd1 sky130_fd_sc_hd__fill_1
Xclkload1 clknet_2_2__leaf_clk vssd1 vssd1 vccd1 vccd1 clkload1/Y sky130_fd_sc_hd__inv_12
XFILLER_50_56 vssd1 vssd1 vccd1 vccd1 sky130_fd_sc_hd__fill_2
XFILLER_50_78 vssd1 vssd1 vccd1 vccd1 sky130_fd_sc_hd__fill_1
XFILLER_59_65 vssd1 vssd1 vccd1 vccd1 sky130_fd_sc_hd__fill_2
XANTENNA__1714__A2 net129 vssd1 vssd1 vccd1 vccd1 sky130_fd_sc_hd__diode_2
XFILLER_66_409 vssd1 vssd1 vccd1 vccd1 sky130_fd_sc_hd__fill_1
XANTENNA__2675__B1 _1252_ vssd1 vssd1 vccd1 vccd1 sky130_fd_sc_hd__diode_2
XFILLER_27_391 vssd1 vssd1 vccd1 vccd1 sky130_fd_sc_hd__fill_1
X_1780_ MATMULT_INST.matmult_inst.mem_inst.matrixA1\[3\] net128 net120 MATMULT_INST.matmult_inst.mem_inst.matrixA2\[3\]
+ _0695_ vssd1 vssd1 vccd1 vccd1 _0696_ sky130_fd_sc_hd__a221o_1
XTAP_TAPCELL_ROW_12_275 vssd1 vccd1 sky130_fd_sc_hd__tapvpwrvgnd_1
X_3450_ clknet_leaf_35_clk _0372_ vssd1 vssd1 vccd1 vccd1 MATMULT_INST.matmult_inst.alu_inst.a1_reg\[5\]
+ sky130_fd_sc_hd__dfxtp_1
X_2401_ _0979_ _0994_ _0978_ vssd1 vssd1 vccd1 vccd1 _0997_ sky130_fd_sc_hd__o21ba_1
X_3381_ clknet_leaf_5_clk _0303_ vssd1 vssd1 vccd1 vccd1 MATMULT_INST.matmult_inst.mem_inst.mem0\[0\]
+ sky130_fd_sc_hd__dfxtp_1
XFILLER_69_225 vssd1 vssd1 vccd1 vccd1 sky130_fd_sc_hd__fill_1
X_2332_ net114 vssd1 vssd1 vccd1 vccd1 _0531_ sky130_fd_sc_hd__inv_2
XFILLER_34_3 vssd1 vssd1 vccd1 vccd1 sky130_fd_sc_hd__fill_2
X_2263_ _0888_ _0890_ vssd1 vssd1 vccd1 vccd1 _0891_ sky130_fd_sc_hd__xnor2_1
XFILLER_65_442 vssd1 vssd1 vccd1 vccd1 sky130_fd_sc_hd__fill_1
X_2194_ net213 net509 net65 vssd1 vssd1 vccd1 vccd1 _0326_ sky130_fd_sc_hd__mux2_1
XFILLER_1_61 vssd1 vssd1 vccd1 vccd1 sky130_fd_sc_hd__fill_2
XFILLER_37_155 vssd1 vssd1 vccd1 vccd1 sky130_fd_sc_hd__fill_4
XFILLER_40_309 vssd1 vssd1 vccd1 vccd1 sky130_fd_sc_hd__fill_2
XFILLER_33_383 vssd1 vssd1 vccd1 vccd1 sky130_fd_sc_hd__fill_8
X_3717_ MATMULT_INST.matmult_inst.fsm_inst.transaction_ready vssd1 vssd1 vccd1 vccd1
+ net5 sky130_fd_sc_hd__clkbuf_1
X_1978_ net219 net128 net50 vssd1 vssd1 vccd1 vccd1 _0815_ sky130_fd_sc_hd__and3_1
XANTENNA__1944__A2 net71 vssd1 vssd1 vccd1 vccd1 sky130_fd_sc_hd__diode_2
X_3648_ clknet_leaf_27_clk net68 vssd1 vssd1 vccd1 vccd1 MATMULT_INST.matmult_inst.alu_inst.state\[0\]
+ sky130_fd_sc_hd__dfxtp_1
X_3579_ clknet_leaf_21_clk MATMULT_INST.matmult_inst.spi_inst.next_state _0077_ vssd1
+ vssd1 vccd1 vccd1 MATMULT_INST.matmult_inst.spi_inst.current_state sky130_fd_sc_hd__dfrtp_4
XFILLER_0_405 vccd1 vssd1 vccd1 vssd1 sky130_ef_sc_hd__decap_40_12
XFILLER_0_449 vccd1 vssd1 vccd1 vssd1 sky130_ef_sc_hd__decap_40_12
Xhold13 _0523_ vssd1 vssd1 vccd1 vccd1 net308 sky130_fd_sc_hd__dlygate4sd3_1
Xhold35 MATMULT_INST.matmult_inst.mem_inst.matrixB3\[17\] vssd1 vssd1 vccd1 vccd1
+ net330 sky130_fd_sc_hd__dlygate4sd3_1
XFILLER_75_217 vssd1 vssd1 vccd1 vccd1 sky130_fd_sc_hd__fill_4
Xhold24 MATMULT_INST.matmult_inst.mem_inst.mem3\[14\] vssd1 vssd1 vccd1 vccd1 net319
+ sky130_fd_sc_hd__dlygate4sd3_1
Xhold46 MATMULT_INST.matmult_inst.mem_inst.matrixA3\[9\] vssd1 vssd1 vccd1 vccd1 net341
+ sky130_fd_sc_hd__dlygate4sd3_1
Xhold68 MATMULT_INST.matmult_inst.mem_inst.matrixB3\[15\] vssd1 vssd1 vccd1 vccd1
+ net363 sky130_fd_sc_hd__dlygate4sd3_1
Xhold79 MATMULT_INST.matmult_inst.mem_inst.matrixA0\[8\] vssd1 vssd1 vccd1 vccd1 net374
+ sky130_fd_sc_hd__dlygate4sd3_1
Xhold57 MATMULT_INST.matmult_inst.mem_inst.matrixA3\[8\] vssd1 vssd1 vccd1 vccd1 net352
+ sky130_fd_sc_hd__dlygate4sd3_1
XFILLER_16_317 vssd1 vssd1 vccd1 vccd1 sky130_fd_sc_hd__fill_2
XANTENNA_fanout41_A _0805_ vssd1 vssd1 vccd1 vccd1 sky130_fd_sc_hd__diode_2
XTAP_TAPCELL_ROW_54_632 vssd1 vccd1 sky130_fd_sc_hd__tapvpwrvgnd_1
XFILLER_71_489 vssd1 vssd1 vccd1 vccd1 sky130_fd_sc_hd__fill_2
XFILLER_24_361 vssd1 vssd1 vccd1 vccd1 sky130_fd_sc_hd__fill_2
XTAP_TAPCELL_ROW_26_389 vssd1 vccd1 sky130_fd_sc_hd__tapvpwrvgnd_1
XFILLER_61_11 vssd1 vssd1 vccd1 vccd1 sky130_fd_sc_hd__fill_2
XPHY_EDGE_ROW_7_Left_87 vssd1 vssd1 vccd1 vccd1 sky130_fd_sc_hd__decap_3
XANTENNA__2696__Y _1256_ vssd1 vssd1 vccd1 vccd1 sky130_fd_sc_hd__diode_2
XFILLER_19_100 vssd1 vssd1 vccd1 vccd1 sky130_fd_sc_hd__fill_1
XFILLER_19_111 vssd1 vssd1 vccd1 vccd1 sky130_fd_sc_hd__fill_1
XFILLER_19_133 vccd1 vssd1 vccd1 vssd1 sky130_ef_sc_hd__decap_40_12
XFILLER_47_442 vssd1 vssd1 vccd1 vccd1 sky130_fd_sc_hd__fill_1
XFILLER_19_166 vssd1 vssd1 vccd1 vccd1 sky130_fd_sc_hd__fill_2
X_2950_ net155 net178 vssd1 vssd1 vccd1 vccd1 _1490_ sky130_fd_sc_hd__nand2_1
X_2881_ _1420_ _1421_ _1422_ vssd1 vssd1 vccd1 vccd1 _1423_ sky130_fd_sc_hd__nand3_1
XFILLER_30_331 vssd1 vssd1 vccd1 vccd1 sky130_fd_sc_hd__fill_4
X_1901_ net102 _0778_ _0543_ vssd1 vssd1 vccd1 vccd1 _0779_ sky130_fd_sc_hd__a21o_1
X_1832_ net135 MATMULT_INST.matmult_inst.fsm_inst.state\[3\] MATMULT_INST.matmult_inst.fsm_inst.state\[2\]
+ vssd1 vssd1 vccd1 vccd1 _0736_ sky130_fd_sc_hd__or3_1
XTAP_TAPCELL_ROW_60_679 vssd1 vccd1 sky130_fd_sc_hd__tapvpwrvgnd_1
X_1763_ _0675_ _0680_ vssd1 vssd1 vccd1 vccd1 _0681_ sky130_fd_sc_hd__or2_2
X_1694_ MATMULT_INST.matmult_inst.mem_inst.matrixA1\[11\] net130 net122 MATMULT_INST.matmult_inst.mem_inst.matrixA2\[11\]
+ _0617_ vssd1 vssd1 vccd1 vccd1 _0618_ sky130_fd_sc_hd__a221o_1
X_3502_ clknet_leaf_37_clk _0420_ vssd1 vssd1 vccd1 vccd1 MATMULT_INST.matmult_inst.alu_inst.row0\[4\]
+ sky130_fd_sc_hd__dfxtp_1
X_3433_ clknet_leaf_26_clk _0355_ vssd1 vssd1 vccd1 vccd1 MATMULT_INST.matmult_inst.alu_inst.out\[14\]
+ sky130_fd_sc_hd__dfxtp_1
X_3364_ clknet_leaf_5_clk _0286_ vssd1 vssd1 vccd1 vccd1 MATMULT_INST.matmult_inst.mem_inst.mem1\[1\]
+ sky130_fd_sc_hd__dfxtp_1
X_2315_ net618 net597 net68 vssd1 vssd1 vccd1 vccd1 _0359_ sky130_fd_sc_hd__mux2_1
X_3295_ clknet_leaf_4_clk _0217_ vssd1 vssd1 vccd1 vccd1 MATMULT_INST.matmult_inst.mem_inst.matrixA1\[4\]
+ sky130_fd_sc_hd__dfxtp_1
XFILLER_57_206 vssd1 vssd1 vccd1 vccd1 sky130_fd_sc_hd__fill_2
XTAP_TAPCELL_ROW_68_746 vssd1 vccd1 sky130_fd_sc_hd__tapvpwrvgnd_1
X_2246_ _0874_ _0875_ vssd1 vssd1 vccd1 vccd1 _0876_ sky130_fd_sc_hd__and2b_1
X_2177_ _0772_ _0833_ _0827_ vssd1 vssd1 vccd1 vccd1 _0834_ sky130_fd_sc_hd__mux2_1
XFILLER_53_423 vssd1 vssd1 vccd1 vccd1 sky130_fd_sc_hd__fill_1
XFILLER_25_125 vssd1 vssd1 vccd1 vccd1 sky130_fd_sc_hd__fill_1
XFILLER_25_136 vccd1 vssd1 vccd1 vssd1 sky130_ef_sc_hd__decap_40_12
XFILLER_15_15 vccd1 vssd1 vccd1 vssd1 sky130_ef_sc_hd__decap_40_12
XFILLER_25_169 vssd1 vssd1 vccd1 vccd1 sky130_fd_sc_hd__fill_4
XTAP_TAPCELL_ROW_51_602 vssd1 vccd1 sky130_fd_sc_hd__tapvpwrvgnd_1
XFILLER_40_139 vssd1 vssd1 vccd1 vccd1 sky130_fd_sc_hd__fill_1
XANTENNA_fanout131_X net131 vssd1 vssd1 vccd1 vccd1 sky130_fd_sc_hd__diode_2
XFILLER_16_114 vccd1 vssd1 vccd1 vssd1 sky130_ef_sc_hd__decap_40_12
XFILLER_31_139 vssd1 vssd1 vccd1 vccd1 sky130_fd_sc_hd__fill_1
XFILLER_72_87 vssd1 vssd1 vccd1 vccd1 sky130_fd_sc_hd__fill_8
XFILLER_12_353 vssd1 vssd1 vccd1 vccd1 sky130_fd_sc_hd__fill_8
XFILLER_12_397 vssd1 vssd1 vccd1 vccd1 sky130_fd_sc_hd__fill_2
XFILLER_8_335 vssd1 vssd1 vccd1 vccd1 sky130_fd_sc_hd__fill_4
XFILLER_79_386 vssd1 vssd1 vccd1 vccd1 sky130_fd_sc_hd__fill_4
X_3080_ MATMULT_INST.matmult_inst.alu_inst.out\[16\] net51 net6 net347 vssd1 vssd1
+ vccd1 vccd1 _0524_ sky130_fd_sc_hd__a22o_1
XANTENNA__3044__A net221 vssd1 vssd1 vccd1 vccd1 sky130_fd_sc_hd__diode_2
X_2100_ net316 net42 net16 vssd1 vssd1 vccd1 vccd1 _0256_ sky130_fd_sc_hd__mux2_1
X_2031_ net329 net35 net25 vssd1 vssd1 vccd1 vccd1 _0191_ sky130_fd_sc_hd__mux2_1
XTAP_TAPCELL_ROW_65_727 vssd1 vccd1 sky130_fd_sc_hd__tapvpwrvgnd_1
XFILLER_35_412 vssd1 vssd1 vccd1 vccd1 sky130_fd_sc_hd__fill_2
XFILLER_35_456 vssd1 vssd1 vccd1 vccd1 sky130_fd_sc_hd__fill_1
XANTENNA__2094__S net17 vssd1 vssd1 vccd1 vccd1 sky130_fd_sc_hd__diode_2
XTAP_TAPCELL_ROW_73_793 vssd1 vccd1 sky130_fd_sc_hd__tapvpwrvgnd_1
X_2933_ _1472_ _1473_ vssd1 vssd1 vccd1 vccd1 _1474_ sky130_fd_sc_hd__and2_1
XFILLER_50_426 vssd1 vssd1 vccd1 vccd1 sky130_fd_sc_hd__fill_4
X_2864_ _1382_ _1399_ _1381_ vssd1 vssd1 vccd1 vccd1 _1406_ sky130_fd_sc_hd__o21bai_1
X_2795_ net169 net173 vssd1 vssd1 vccd1 vccd1 _1339_ sky130_fd_sc_hd__nand2_1
XFILLER_30_183 vssd1 vssd1 vccd1 vccd1 sky130_fd_sc_hd__fill_2
X_1815_ net216 _0722_ _0726_ net222 vssd1 vssd1 vccd1 vccd1 _0728_ sky130_fd_sc_hd__a22o_1
Xhold302 MATMULT_INST.matmult_inst.alu_inst.col1\[0\] vssd1 vssd1 vccd1 vccd1 net597
+ sky130_fd_sc_hd__dlygate4sd3_1
X_1746_ MATMULT_INST.matmult_inst.mem_inst.matrixB1\[6\] net124 net116 MATMULT_INST.matmult_inst.mem_inst.matrixB2\[6\]
+ _0664_ vssd1 vssd1 vccd1 vccd1 _0665_ sky130_fd_sc_hd__a221o_1
Xhold313 MATMULT_INST.matmult_inst.mem_inst.matrixB0\[6\] vssd1 vssd1 vccd1 vccd1
+ net608 sky130_fd_sc_hd__dlygate4sd3_1
Xhold335 MATMULT_INST.matmult_inst.spi_inst.tx_reg_sys\[2\] vssd1 vssd1 vccd1 vccd1
+ net630 sky130_fd_sc_hd__dlygate4sd3_1
Xhold324 MATMULT_INST.matmult_inst.spi_inst.rx_done2 vssd1 vssd1 vccd1 vccd1 net619
+ sky130_fd_sc_hd__dlygate4sd3_1
X_1677_ net651 _0602_ net64 vssd1 vssd1 vccd1 vccd1 _0503_ sky130_fd_sc_hd__mux2_1
Xhold346 MATMULT_INST.matmult_inst.spi_inst.tx_reg_sys\[8\] vssd1 vssd1 vccd1 vccd1
+ net641 sky130_fd_sc_hd__dlygate4sd3_1
Xhold368 MATMULT_INST.matmult_inst.alu_inst.adder_inst.fa.b vssd1 vssd1 vccd1 vccd1
+ net663 sky130_fd_sc_hd__dlygate4sd3_1
XANTENNA__1780__B1 net120 vssd1 vssd1 vccd1 vccd1 sky130_fd_sc_hd__diode_2
Xhold357 MATMULT_INST.matmult_inst.spi_inst.tx_reg_sys\[3\] vssd1 vssd1 vccd1 vccd1
+ net652 sky130_fd_sc_hd__dlygate4sd3_1
X_3416_ clknet_leaf_37_clk _0338_ vssd1 vssd1 vccd1 vccd1 MATMULT_INST.matmult_inst.alu_inst.a0_reg\[5\]
+ sky130_fd_sc_hd__dfxtp_1
X_3347_ clknet_leaf_16_clk _0269_ vssd1 vssd1 vccd1 vccd1 MATMULT_INST.matmult_inst.mem_inst.mem2\[2\]
+ sky130_fd_sc_hd__dfxtp_1
X_3278_ clknet_leaf_7_clk _0200_ vssd1 vssd1 vccd1 vccd1 MATMULT_INST.matmult_inst.mem_inst.matrixA2\[5\]
+ sky130_fd_sc_hd__dfxtp_1
XANTENNA__2088__A1 _0811_ vssd1 vssd1 vccd1 vccd1 sky130_fd_sc_hd__diode_2
XTAP_TAPCELL_ROW_28_407 vssd1 vccd1 sky130_fd_sc_hd__tapvpwrvgnd_1
X_2229_ net361 _0861_ net100 vssd1 vssd1 vccd1 vccd1 _0344_ sky130_fd_sc_hd__mux2_1
XFILLER_26_25 vssd1 vssd1 vccd1 vccd1 sky130_fd_sc_hd__fill_1
XFILLER_26_445 vssd1 vssd1 vccd1 vccd1 sky130_fd_sc_hd__fill_4
XFILLER_42_79 vssd1 vssd1 vccd1 vccd1 sky130_fd_sc_hd__fill_1
XFILLER_5_316 vccd1 vssd1 vccd1 vssd1 sky130_ef_sc_hd__decap_40_12
XPHY_EDGE_ROW_79_Left_159 vssd1 vssd1 vccd1 vccd1 sky130_fd_sc_hd__decap_3
XFILLER_67_21 vssd1 vssd1 vccd1 vccd1 sky130_fd_sc_hd__fill_2
XANTENNA__2079__A1 _0802_ vssd1 vssd1 vccd1 vccd1 sky130_fd_sc_hd__diode_2
XFILLER_17_445 vssd1 vssd1 vccd1 vccd1 sky130_fd_sc_hd__fill_2
XFILLER_17_467 vccd1 vssd1 vccd1 vssd1 sky130_ef_sc_hd__decap_40_12
XFILLER_44_253 vssd1 vssd1 vccd1 vccd1 sky130_fd_sc_hd__fill_1
XTAP_TAPCELL_ROW_70_763 vssd1 vccd1 sky130_fd_sc_hd__tapvpwrvgnd_1
XFILLER_66_6 vccd1 vssd1 vccd1 vssd1 sky130_ef_sc_hd__decap_40_12
XFILLER_8_176 vssd1 vssd1 vccd1 vccd1 sky130_fd_sc_hd__fill_4
X_1600_ net666 vssd1 vssd1 vccd1 vccd1 _1594_ sky130_fd_sc_hd__inv_2
X_2580_ _1100_ _1140_ _1143_ _1141_ vssd1 vssd1 vccd1 vccd1 _1171_ sky130_fd_sc_hd__o31a_1
XANTENNA__2089__S net19 vssd1 vssd1 vccd1 vccd1 sky130_fd_sc_hd__diode_2
X_3201_ clknet_leaf_6_clk _0123_ vssd1 vssd1 vccd1 vccd1 MATMULT_INST.matmult_inst.mem_inst.matrixB2\[0\]
+ sky130_fd_sc_hd__dfxtp_1
X_3132_ net59 net89 net78 vssd1 vssd1 vccd1 vccd1 _0049_ sky130_fd_sc_hd__and3_1
X_3063_ net51 _1244_ vssd1 vssd1 vccd1 vccd1 _1578_ sky130_fd_sc_hd__nor2_1
X_2014_ net107 net33 net26 net435 vssd1 vssd1 vccd1 vccd1 _0175_ sky130_fd_sc_hd__a22o_1
XFILLER_35_242 vccd1 vssd1 vccd1 vssd1 sky130_ef_sc_hd__decap_40_12
XTAP_TAPCELL_ROW_33_454 vssd1 vccd1 sky130_fd_sc_hd__tapvpwrvgnd_1
X_2916_ net160 net174 vssd1 vssd1 vccd1 vccd1 _1457_ sky130_fd_sc_hd__nand2_1
XFILLER_12_27 vssd1 vssd1 vccd1 vccd1 sky130_fd_sc_hd__fill_1
X_2847_ _1383_ _1387_ _1388_ vssd1 vssd1 vccd1 vccd1 _1390_ sky130_fd_sc_hd__nand3_1
XANTENNA_fanout139_A net140 vssd1 vssd1 vccd1 vccd1 sky130_fd_sc_hd__diode_2
Xhold110 MATMULT_INST.matmult_inst.mem_inst.matrixA2\[13\] vssd1 vssd1 vccd1 vccd1
+ net405 sky130_fd_sc_hd__dlygate4sd3_1
X_2778_ net182 net161 net159 net184 vssd1 vssd1 vccd1 vccd1 _1323_ sky130_fd_sc_hd__a22o_1
XANTENNA_clkbuf_2_1__f_clk_A clknet_0_clk vssd1 vssd1 vccd1 vccd1 sky130_fd_sc_hd__diode_2
Xhold121 MATMULT_INST.matmult_inst.mem_inst.matrixB1\[17\] vssd1 vssd1 vccd1 vccd1
+ net416 sky130_fd_sc_hd__dlygate4sd3_1
X_1729_ MATMULT_INST.matmult_inst.mem_inst.matrixA0\[8\] net113 net105 MATMULT_INST.matmult_inst.mem_inst.matrixB0\[8\]
+ vssd1 vssd1 vccd1 vccd1 _0650_ sky130_fd_sc_hd__a22o_1
XANTENNA_clkbuf_leaf_1_clk_A clknet_2_0__leaf_clk vssd1 vssd1 vccd1 vccd1 sky130_fd_sc_hd__diode_2
Xhold143 MATMULT_INST.matmult_inst.mem_inst.matrixB2\[3\] vssd1 vssd1 vccd1 vccd1
+ net438 sky130_fd_sc_hd__dlygate4sd3_1
Xhold132 MATMULT_INST.matmult_inst.mem_inst.matrixB3\[2\] vssd1 vssd1 vccd1 vccd1
+ net427 sky130_fd_sc_hd__dlygate4sd3_1
Xhold176 MATMULT_INST.matmult_inst.mem_inst.matrixB1\[15\] vssd1 vssd1 vccd1 vccd1
+ net471 sky130_fd_sc_hd__dlygate4sd3_1
Xhold154 MATMULT_INST.matmult_inst.alu_inst.row0\[1\] vssd1 vssd1 vccd1 vccd1 net449
+ sky130_fd_sc_hd__dlygate4sd3_1
Xhold165 MATMULT_INST.matmult_inst.mem_inst.mem2\[0\] vssd1 vssd1 vccd1 vccd1 net460
+ sky130_fd_sc_hd__dlygate4sd3_1
Xhold187 MATMULT_INST.matmult_inst.mem_inst.matrixB0\[12\] vssd1 vssd1 vccd1 vccd1
+ net482 sky130_fd_sc_hd__dlygate4sd3_1
Xhold198 MATMULT_INST.matmult_inst.alu_inst.row1\[1\] vssd1 vssd1 vccd1 vccd1 net493
+ sky130_fd_sc_hd__dlygate4sd3_1
XFILLER_58_334 vssd1 vssd1 vccd1 vccd1 sky130_fd_sc_hd__fill_4
XFILLER_73_337 vssd1 vssd1 vccd1 vccd1 sky130_fd_sc_hd__fill_8
XFILLER_26_220 vccd1 vssd1 vccd1 vssd1 sky130_ef_sc_hd__decap_40_12
XFILLER_37_68 vssd1 vssd1 vccd1 vccd1 sky130_fd_sc_hd__fill_1
XFILLER_14_437 vssd1 vssd1 vccd1 vccd1 sky130_fd_sc_hd__fill_2
XFILLER_14_426 vssd1 vssd1 vccd1 vccd1 sky130_fd_sc_hd__fill_4
XFILLER_41_223 vssd1 vssd1 vccd1 vccd1 sky130_fd_sc_hd__fill_1
XFILLER_53_45 vssd1 vssd1 vccd1 vccd1 sky130_fd_sc_hd__fill_2
XFILLER_14_459 vssd1 vssd1 vccd1 vccd1 sky130_fd_sc_hd__fill_4
XFILLER_22_470 vssd1 vssd1 vccd1 vccd1 sky130_fd_sc_hd__fill_1
XFILLER_5_113 vccd1 vssd1 vccd1 vssd1 sky130_ef_sc_hd__decap_40_12
XFILLER_68_109 vssd1 vssd1 vccd1 vccd1 sky130_fd_sc_hd__fill_1
XFILLER_1_374 vssd1 vssd1 vccd1 vccd1 sky130_fd_sc_hd__fill_4
XFILLER_49_345 vccd1 vssd1 vccd1 vssd1 sky130_ef_sc_hd__decap_40_12
XTAP_TAPCELL_ROW_75_811 vssd1 vccd1 sky130_fd_sc_hd__tapvpwrvgnd_1
XTAP_TAPCELL_ROW_47_568 vssd1 vccd1 sky130_fd_sc_hd__tapvpwrvgnd_1
XANTENNA__2880__B net176 vssd1 vssd1 vccd1 vccd1 sky130_fd_sc_hd__diode_2
XFILLER_20_429 vssd1 vssd1 vccd1 vccd1 sky130_fd_sc_hd__fill_1
XFILLER_32_267 vssd1 vssd1 vccd1 vccd1 sky130_fd_sc_hd__fill_4
XANTENNA__1777__A net148 vssd1 vssd1 vccd1 vccd1 sky130_fd_sc_hd__diode_2
XFILLER_9_452 vccd1 vssd1 vccd1 vssd1 sky130_ef_sc_hd__decap_40_12
XFILLER_9_441 vssd1 vssd1 vccd1 vccd1 sky130_fd_sc_hd__fill_4
X_2701_ _1250_ net551 _1256_ vssd1 vssd1 vccd1 vccd1 _0420_ sky130_fd_sc_hd__mux2_1
XTAP_TAPCELL_ROW_30_424 vssd1 vccd1 sky130_fd_sc_hd__tapvpwrvgnd_1
XFILLER_64_3 vssd1 vssd1 vccd1 vccd1 sky130_fd_sc_hd__fill_8
X_2632_ net649 _1220_ net94 vssd1 vssd1 vccd1 vccd1 _0387_ sky130_fd_sc_hd__mux2_1
X_2563_ net188 net204 net206 net186 vssd1 vssd1 vccd1 vccd1 _1154_ sky130_fd_sc_hd__a22oi_1
X_2494_ _1083_ _1084_ _1085_ vssd1 vssd1 vccd1 vccd1 _1087_ sky130_fd_sc_hd__a21o_1
X_3115_ net61 net91 net78 vssd1 vssd1 vccd1 vccd1 _0030_ sky130_fd_sc_hd__and3_1
XFILLER_55_304 vssd1 vssd1 vccd1 vccd1 sky130_fd_sc_hd__fill_2
X_3046_ net592 net48 net8 vssd1 vssd1 vccd1 vccd1 _0465_ sky130_fd_sc_hd__mux2_1
XFILLER_70_307 vssd1 vssd1 vccd1 vccd1 sky130_fd_sc_hd__fill_1
XFILLER_11_429 vssd1 vssd1 vccd1 vccd1 sky130_fd_sc_hd__fill_4
XANTENNA__1974__X _0813_ vssd1 vssd1 vccd1 vccd1 sky130_fd_sc_hd__diode_2
XANTENNA__1726__B1 net121 vssd1 vssd1 vccd1 vccd1 sky130_fd_sc_hd__diode_2
XFILLER_2_138 vssd1 vssd1 vccd1 vccd1 sky130_fd_sc_hd__fill_2
XANTENNA_fanout71_A _0781_ vssd1 vssd1 vccd1 vccd1 sky130_fd_sc_hd__diode_2
XFILLER_58_153 vssd1 vssd1 vccd1 vccd1 sky130_fd_sc_hd__fill_4
XFILLER_64_11 vssd1 vssd1 vccd1 vccd1 sky130_fd_sc_hd__fill_1
XFILLER_58_197 vssd1 vssd1 vccd1 vccd1 sky130_fd_sc_hd__fill_8
XFILLER_73_167 vssd1 vssd1 vccd1 vccd1 sky130_fd_sc_hd__fill_1
XFILLER_73_178 vssd1 vssd1 vccd1 vccd1 sky130_fd_sc_hd__fill_2
XTAP_TAPCELL_ROW_1_182 vssd1 vccd1 sky130_fd_sc_hd__tapvpwrvgnd_1
XTAP_TAPCELL_ROW_44_549 vssd1 vccd1 sky130_fd_sc_hd__tapvpwrvgnd_1
Xfanout82 _0749_ vssd1 vssd1 vccd1 vccd1 net82 sky130_fd_sc_hd__clkbuf_4
Xfanout71 _0781_ vssd1 vssd1 vccd1 vccd1 net71 sky130_fd_sc_hd__clkbuf_4
Xfanout60 net62 vssd1 vssd1 vccd1 vccd1 net60 sky130_fd_sc_hd__buf_1
Xfanout93 _0538_ vssd1 vssd1 vccd1 vccd1 net93 sky130_fd_sc_hd__clkbuf_4
XFILLER_13_92 vssd1 vssd1 vccd1 vccd1 sky130_fd_sc_hd__fill_4
XFILLER_10_473 vssd1 vssd1 vccd1 vccd1 sky130_fd_sc_hd__fill_2
XFILLER_6_477 vccd1 vssd1 vccd1 vssd1 sky130_ef_sc_hd__decap_40_12
XFILLER_1_193 vssd1 vssd1 vccd1 vccd1 sky130_fd_sc_hd__fill_2
XFILLER_77_473 vccd1 vssd1 vccd1 vssd1 sky130_ef_sc_hd__decap_40_12
XANTENNA__2693__A1 net93 vssd1 vssd1 vccd1 vccd1 sky130_fd_sc_hd__diode_2
XFILLER_37_337 vssd1 vssd1 vccd1 vccd1 sky130_fd_sc_hd__fill_1
X_1994_ net471 net34 net29 vssd1 vssd1 vccd1 vccd1 _0156_ sky130_fd_sc_hd__mux2_1
Xclkload30 clknet_leaf_20_clk vssd1 vssd1 vccd1 vccd1 clkload30/X sky130_fd_sc_hd__clkbuf_4
X_2615_ _1177_ _1203_ vssd1 vssd1 vccd1 vccd1 _1204_ sky130_fd_sc_hd__nand2_1
X_3595_ net228 _0013_ _0093_ vssd1 vssd1 vccd1 vccd1 MATMULT_INST.matmult_inst.spi_inst.miso_shifter\[15\]
+ sky130_fd_sc_hd__dfrtp_1
XANTENNA__1708__B1 net121 vssd1 vssd1 vccd1 vccd1 sky130_fd_sc_hd__diode_2
X_2546_ _1123_ _1130_ _1131_ _1137_ vssd1 vssd1 vccd1 vccd1 _1138_ sky130_fd_sc_hd__a31o_1
X_2477_ net195 net200 _1016_ vssd1 vssd1 vccd1 vccd1 _1070_ sky130_fd_sc_hd__and3_1
XFILLER_28_337 vssd1 vssd1 vccd1 vccd1 sky130_fd_sc_hd__fill_2
XANTENNA__2684__A1 net82 vssd1 vssd1 vccd1 vccd1 sky130_fd_sc_hd__diode_2
XFILLER_55_167 vssd1 vssd1 vccd1 vccd1 sky130_fd_sc_hd__fill_1
X_3029_ _1563_ _1564_ vssd1 vssd1 vccd1 vccd1 _1566_ sky130_fd_sc_hd__or2_1
XFILLER_34_25 vssd1 vssd1 vccd1 vccd1 sky130_fd_sc_hd__fill_2
XTAP_TAPCELL_ROW_41_519 vssd1 vccd1 sky130_fd_sc_hd__tapvpwrvgnd_1
Xclkload2 clknet_2_3__leaf_clk vssd1 vssd1 vccd1 vccd1 clkload2/Y sky130_fd_sc_hd__inv_8
XFILLER_3_403 vccd1 vssd1 vccd1 vssd1 sky130_ef_sc_hd__decap_40_12
XFILLER_3_447 vssd1 vssd1 vccd1 vccd1 sky130_fd_sc_hd__fill_1
XANTENNA_fanout74_X net74 vssd1 vssd1 vccd1 vccd1 sky130_fd_sc_hd__diode_2
XANTENNA__2675__B2 net103 vssd1 vssd1 vccd1 vccd1 sky130_fd_sc_hd__diode_2
XFILLER_61_126 vccd1 vssd1 vccd1 vssd1 sky130_ef_sc_hd__decap_40_12
XANTENNA__2978__A2 net178 vssd1 vssd1 vccd1 vccd1 sky130_fd_sc_hd__diode_2
XFILLER_24_80 vssd1 vssd1 vccd1 vccd1 sky130_fd_sc_hd__fill_1
XTAP_TAPCELL_ROW_12_276 vssd1 vccd1 sky130_fd_sc_hd__tapvpwrvgnd_1
XFILLER_6_296 vccd1 vssd1 vccd1 vssd1 sky130_ef_sc_hd__decap_40_12
X_2400_ _0979_ _0994_ vssd1 vssd1 vccd1 vccd1 _0996_ sky130_fd_sc_hd__nor2_1
X_3380_ clknet_leaf_13_clk _0302_ vssd1 vssd1 vccd1 vccd1 MATMULT_INST.matmult_inst.mem_inst.mem1\[17\]
+ sky130_fd_sc_hd__dfxtp_1
XFILLER_69_204 vssd1 vssd1 vccd1 vccd1 sky130_fd_sc_hd__fill_2
X_2331_ MATMULT_INST.matmult_inst.alu_inst.state\[1\] MATMULT_INST.matmult_inst.alu_inst.state\[0\]
+ vssd1 vssd1 vccd1 vccd1 _0933_ sky130_fd_sc_hd__nand2b_1
X_2262_ _0881_ _0889_ vssd1 vssd1 vccd1 vccd1 _0890_ sky130_fd_sc_hd__nor2_1
XFILLER_27_3 vssd1 vssd1 vccd1 vccd1 sky130_fd_sc_hd__fill_8
XANTENNA__2097__S net16 vssd1 vssd1 vccd1 vccd1 sky130_fd_sc_hd__diode_2
X_2193_ net215 net440 net66 vssd1 vssd1 vccd1 vccd1 _0325_ sky130_fd_sc_hd__mux2_1
XANTENNA__2825__S net97 vssd1 vssd1 vccd1 vccd1 sky130_fd_sc_hd__diode_2
XFILLER_1_84 vssd1 vssd1 vccd1 vccd1 sky130_fd_sc_hd__fill_8
X_3716_ MATMULT_INST.matmult_inst.miso vssd1 vssd1 vccd1 vccd1 net4 sky130_fd_sc_hd__buf_1
X_1977_ net531 net32 net31 vssd1 vssd1 vccd1 vccd1 _0140_ sky130_fd_sc_hd__mux2_1
XANTENNA_fanout121_A net123 vssd1 vssd1 vccd1 vccd1 sky130_fd_sc_hd__diode_2
XANTENNA_fanout219_A net221 vssd1 vssd1 vccd1 vccd1 sky130_fd_sc_hd__diode_2
XANTENNA__2499__C net208 vssd1 vssd1 vccd1 vccd1 sky130_fd_sc_hd__diode_2
X_3647_ clknet_leaf_27_clk net97 vssd1 vssd1 vccd1 vccd1 MATMULT_INST.matmult_inst.alu_inst.state\[1\]
+ sky130_fd_sc_hd__dfxtp_1
X_3578_ clknet_leaf_22_clk net297 _0076_ vssd1 vssd1 vccd1 vccd1 MATMULT_INST.matmult_inst.spi_inst.rx_done2
+ sky130_fd_sc_hd__dfrtp_1
X_2529_ _1116_ _1120_ vssd1 vssd1 vccd1 vccd1 _1121_ sky130_fd_sc_hd__xnor2_1
XFILLER_0_417 vssd1 vssd1 vccd1 vccd1 sky130_fd_sc_hd__fill_2
Xhold14 MATMULT_INST.matmult_inst.mem_inst.matrixB3\[4\] vssd1 vssd1 vccd1 vccd1 net309
+ sky130_fd_sc_hd__dlygate4sd3_1
Xhold25 MATMULT_INST.matmult_inst.mem_inst.mem3\[16\] vssd1 vssd1 vccd1 vccd1 net320
+ sky130_fd_sc_hd__dlygate4sd3_1
Xhold36 MATMULT_INST.matmult_inst.mem_inst.mem3\[9\] vssd1 vssd1 vccd1 vccd1 net331
+ sky130_fd_sc_hd__dlygate4sd3_1
XTAP_TAPCELL_ROW_3_200 vssd1 vccd1 sky130_fd_sc_hd__tapvpwrvgnd_1
XFILLER_29_69 vssd1 vssd1 vccd1 vccd1 sky130_fd_sc_hd__fill_4
Xhold47 MATMULT_INST.matmult_inst.fsm_inst.alu_result\[13\] vssd1 vssd1 vccd1 vccd1
+ net342 sky130_fd_sc_hd__dlygate4sd3_1
Xhold58 MATMULT_INST.matmult_inst.mem_inst.matrixA3\[15\] vssd1 vssd1 vccd1 vccd1
+ net353 sky130_fd_sc_hd__dlygate4sd3_1
Xhold69 MATMULT_INST.matmult_inst.mem_inst.matrixA3\[6\] vssd1 vssd1 vccd1 vccd1 net364
+ sky130_fd_sc_hd__dlygate4sd3_1
XFILLER_56_421 vccd1 vssd1 vccd1 vssd1 sky130_ef_sc_hd__decap_40_12
XTAP_TAPCELL_ROW_54_633 vssd1 vccd1 sky130_fd_sc_hd__tapvpwrvgnd_1
XFILLER_61_34 vssd1 vssd1 vccd1 vccd1 sky130_fd_sc_hd__fill_4
XFILLER_6_29 vssd1 vssd1 vccd1 vccd1 sky130_fd_sc_hd__fill_4
XFILLER_6_18 vssd1 vssd1 vccd1 vccd1 sky130_fd_sc_hd__fill_8
XFILLER_10_71 vccd1 vssd1 vccd1 vssd1 sky130_ef_sc_hd__decap_40_12
XFILLER_3_277 vssd1 vssd1 vccd1 vccd1 sky130_fd_sc_hd__fill_2
XANTENNA__2345__B1 net96 vssd1 vssd1 vccd1 vccd1 sky130_fd_sc_hd__diode_2
XANTENNA__1699__A2 net64 vssd1 vssd1 vccd1 vccd1 sky130_fd_sc_hd__diode_2
XFILLER_19_145 vccd1 vssd1 vccd1 vssd1 sky130_ef_sc_hd__decap_40_12
XFILLER_74_251 vssd1 vssd1 vccd1 vccd1 sky130_fd_sc_hd__fill_1
XFILLER_62_402 vccd1 vssd1 vccd1 vssd1 sky130_ef_sc_hd__decap_40_12
XTAP_TAPCELL_ROW_17_313 vssd1 vccd1 sky130_fd_sc_hd__tapvpwrvgnd_1
XFILLER_15_351 vccd1 vssd1 vccd1 vssd1 sky130_ef_sc_hd__decap_40_12
XANTENNA__1623__A2 net129 vssd1 vssd1 vccd1 vccd1 sky130_fd_sc_hd__diode_2
X_2880_ net160 net176 vssd1 vssd1 vccd1 vccd1 _1422_ sky130_fd_sc_hd__nand2_1
X_1900_ _0537_ _0748_ vssd1 vssd1 vccd1 vccd1 _0778_ sky130_fd_sc_hd__nor2_1
XFILLER_30_354 vssd1 vssd1 vccd1 vccd1 sky130_fd_sc_hd__fill_8
X_1831_ MATMULT_INST.matmult_inst.fsm_inst.state\[0\] _0541_ net132 vssd1 vssd1 vccd1
+ vccd1 _0735_ sky130_fd_sc_hd__or3b_4
XFILLER_30_365 vssd1 vssd1 vccd1 vccd1 sky130_fd_sc_hd__fill_4
X_1762_ net216 _0677_ _0679_ net219 vssd1 vssd1 vccd1 vccd1 _0680_ sky130_fd_sc_hd__a22o_1
X_1693_ net152 net144 MATMULT_INST.matmult_inst.mem_inst.matrixA3\[11\] vssd1 vssd1
+ vccd1 vccd1 _0617_ sky130_fd_sc_hd__and3_1
X_3501_ clknet_leaf_0_clk _0419_ vssd1 vssd1 vccd1 vccd1 MATMULT_INST.matmult_inst.alu_inst.row0\[3\]
+ sky130_fd_sc_hd__dfxtp_1
X_3432_ clknet_leaf_26_clk _0354_ vssd1 vssd1 vccd1 vccd1 MATMULT_INST.matmult_inst.alu_inst.out\[13\]
+ sky130_fd_sc_hd__dfxtp_1
X_3363_ clknet_leaf_7_clk _0285_ vssd1 vssd1 vccd1 vccd1 MATMULT_INST.matmult_inst.mem_inst.mem1\[0\]
+ sky130_fd_sc_hd__dfxtp_1
X_2314_ net622 _0792_ _0931_ _0932_ vssd1 vssd1 vccd1 vccd1 _0358_ sky130_fd_sc_hd__a22o_1
X_3294_ clknet_leaf_4_clk _0216_ vssd1 vssd1 vccd1 vccd1 MATMULT_INST.matmult_inst.mem_inst.matrixA1\[3\]
+ sky130_fd_sc_hd__dfxtp_1
XTAP_TAPCELL_ROW_68_747 vssd1 vccd1 sky130_fd_sc_hd__tapvpwrvgnd_1
X_2245_ MATMULT_INST.matmult_inst.alu_inst.adder_inst.r1.fa2.b MATMULT_INST.matmult_inst.alu_inst.adder_inst.r1.fa2.a
+ vssd1 vssd1 vccd1 vccd1 _0875_ sky130_fd_sc_hd__nand2_1
XFILLER_38_421 vccd1 vssd1 vccd1 vssd1 sky130_ef_sc_hd__decap_40_12
X_2176_ _0544_ _0778_ _0829_ vssd1 vssd1 vccd1 vccd1 _0833_ sky130_fd_sc_hd__o21ai_1
XFILLER_25_115 vssd1 vssd1 vccd1 vccd1 sky130_fd_sc_hd__fill_1
XFILLER_15_27 vccd1 vssd1 vccd1 vssd1 sky130_ef_sc_hd__decap_40_12
XTAP_TAPCELL_ROW_51_603 vssd1 vccd1 sky130_fd_sc_hd__tapvpwrvgnd_1
XFILLER_31_15 vccd1 vssd1 vccd1 vssd1 sky130_ef_sc_hd__decap_40_12
XPHY_EDGE_ROW_1_Right_1 vssd1 vssd1 vccd1 vccd1 sky130_fd_sc_hd__decap_3
XFILLER_0_225 vccd1 vssd1 vccd1 vssd1 sky130_ef_sc_hd__decap_40_12
XFILLER_16_126 vccd1 vssd1 vccd1 vssd1 sky130_ef_sc_hd__decap_40_12
XANTENNA__3055__A1 net39 vssd1 vssd1 vccd1 vccd1 sky130_fd_sc_hd__diode_2
XFILLER_44_479 vssd1 vssd1 vccd1 vccd1 sky130_fd_sc_hd__fill_1
XFILLER_72_77 vssd1 vssd1 vccd1 vccd1 sky130_fd_sc_hd__fill_4
XFILLER_12_365 vssd1 vssd1 vccd1 vccd1 sky130_fd_sc_hd__fill_4
XTAP_TAPCELL_ROW_22_360 vssd1 vccd1 sky130_fd_sc_hd__tapvpwrvgnd_1
XFILLER_8_347 vccd1 vssd1 vccd1 vssd1 sky130_ef_sc_hd__decap_40_12
XANTENNA__2213__B MATMULT_INST.matmult_inst.alu_inst.adder_inst.r0.fa1.a vssd1 vssd1
+ vccd1 vccd1 sky130_fd_sc_hd__diode_2
XANTENNA__2318__A0 net178 vssd1 vssd1 vccd1 vccd1 sky130_fd_sc_hd__diode_2
XFILLER_79_365 vssd1 vssd1 vccd1 vccd1 sky130_fd_sc_hd__fill_8
X_2030_ net333 net36 net25 vssd1 vssd1 vccd1 vccd1 _0190_ sky130_fd_sc_hd__mux2_1
XTAP_TAPCELL_ROW_65_728 vssd1 vccd1 sky130_fd_sc_hd__tapvpwrvgnd_1
XFILLER_62_265 vccd1 vssd1 vccd1 vssd1 sky130_ef_sc_hd__decap_40_12
XTAP_TAPCELL_ROW_73_794 vssd1 vccd1 sky130_fd_sc_hd__tapvpwrvgnd_1
XFILLER_62_287 vssd1 vssd1 vccd1 vccd1 sky130_fd_sc_hd__fill_1
X_2932_ _1470_ _1471_ vssd1 vssd1 vccd1 vccd1 _1473_ sky130_fd_sc_hd__nand2_1
X_2863_ net607 _1405_ net97 vssd1 vssd1 vccd1 vccd1 _0433_ sky130_fd_sc_hd__mux2_1
X_2794_ _1317_ _1318_ _1337_ vssd1 vssd1 vccd1 vccd1 _1338_ sky130_fd_sc_hd__o21a_1
X_1814_ MATMULT_INST.matmult_inst.mem_inst.matrixA0\[0\] net112 net108 MATMULT_INST.matmult_inst.mem_inst.mem0\[0\]
+ vssd1 vssd1 vccd1 vccd1 _0727_ sky130_fd_sc_hd__a22o_1
X_1745_ net146 net138 MATMULT_INST.matmult_inst.mem_inst.matrixB3\[6\] vssd1 vssd1
+ vccd1 vccd1 _0664_ sky130_fd_sc_hd__and3_1
Xhold325 MATMULT_INST.matmult_inst.spi_inst.tx_reg_sys\[16\] vssd1 vssd1 vccd1 vccd1
+ net620 sky130_fd_sc_hd__dlygate4sd3_1
XFILLER_7_391 vssd1 vssd1 vccd1 vccd1 sky130_fd_sc_hd__fill_1
Xhold314 MATMULT_INST.matmult_inst.alu_inst.row0\[5\] vssd1 vssd1 vccd1 vccd1 net609
+ sky130_fd_sc_hd__dlygate4sd3_1
Xhold303 MATMULT_INST.matmult_inst.alu_inst.col0\[7\] vssd1 vssd1 vccd1 vccd1 net598
+ sky130_fd_sc_hd__dlygate4sd3_1
X_1676_ net220 _0595_ _0597_ net218 _0601_ vssd1 vssd1 vccd1 vccd1 _0602_ sky130_fd_sc_hd__a221o_1
Xhold347 _0498_ vssd1 vssd1 vccd1 vccd1 net642 sky130_fd_sc_hd__dlygate4sd3_1
Xhold358 MATMULT_INST.matmult_inst.alu_inst.adder_inst.r3.fa3.b vssd1 vssd1 vccd1
+ vccd1 net653 sky130_fd_sc_hd__dlygate4sd3_1
Xhold336 MATMULT_INST.matmult_inst.alu_inst.adder_inst.r3.fa1.b vssd1 vssd1 vccd1
+ vccd1 net631 sky130_fd_sc_hd__dlygate4sd3_1
Xhold369 MATMULT_INST.matmult_inst.alu_inst.adder_inst.fa.a vssd1 vssd1 vccd1 vccd1
+ net664 sky130_fd_sc_hd__dlygate4sd3_1
X_3415_ clknet_leaf_37_clk _0337_ vssd1 vssd1 vccd1 vccd1 MATMULT_INST.matmult_inst.alu_inst.a0_reg\[4\]
+ sky130_fd_sc_hd__dfxtp_1
X_3346_ clknet_leaf_5_clk _0268_ vssd1 vssd1 vccd1 vccd1 MATMULT_INST.matmult_inst.mem_inst.mem2\[1\]
+ sky130_fd_sc_hd__dfxtp_1
X_3277_ clknet_leaf_6_clk _0199_ vssd1 vssd1 vccd1 vccd1 MATMULT_INST.matmult_inst.mem_inst.matrixA2\[4\]
+ sky130_fd_sc_hd__dfxtp_1
XFILLER_26_15 vssd1 vssd1 vccd1 vccd1 sky130_fd_sc_hd__fill_8
XTAP_TAPCELL_ROW_28_408 vssd1 vccd1 sky130_fd_sc_hd__tapvpwrvgnd_1
X_2228_ _0859_ _0860_ vssd1 vssd1 vccd1 vccd1 _0861_ sky130_fd_sc_hd__xnor2_1
XFILLER_38_251 vssd1 vssd1 vccd1 vccd1 sky130_fd_sc_hd__fill_1
X_2159_ net109 _0806_ net11 net358 vssd1 vssd1 vccd1 vccd1 _0312_ sky130_fd_sc_hd__a22o_1
XFILLER_26_468 vssd1 vssd1 vccd1 vccd1 sky130_fd_sc_hd__fill_1
XTAP_TAPCELL_ROW_36_474 vssd1 vccd1 sky130_fd_sc_hd__tapvpwrvgnd_1
XFILLER_41_427 vssd1 vssd1 vccd1 vccd1 sky130_fd_sc_hd__fill_2
XFILLER_41_449 vssd1 vssd1 vccd1 vccd1 sky130_fd_sc_hd__fill_2
XFILLER_53_276 vssd1 vssd1 vccd1 vccd1 sky130_fd_sc_hd__fill_4
Xclkbuf_leaf_33_clk clknet_2_2__leaf_clk vssd1 vssd1 vccd1 vccd1 clknet_leaf_33_clk
+ sky130_fd_sc_hd__clkbuf_8
XANTENNA__1629__S net223 vssd1 vssd1 vccd1 vccd1 sky130_fd_sc_hd__diode_2
XANTENNA__2012__A2 net35 vssd1 vssd1 vccd1 vccd1 sky130_fd_sc_hd__diode_2
XFILLER_5_328 vssd1 vssd1 vccd1 vccd1 sky130_fd_sc_hd__fill_8
XPHY_EDGE_ROW_10_Left_90 vssd1 vssd1 vccd1 vccd1 sky130_fd_sc_hd__decap_3
XFILLER_67_77 vssd1 vssd1 vccd1 vccd1 sky130_fd_sc_hd__fill_4
XFILLER_29_251 vssd1 vssd1 vccd1 vccd1 sky130_fd_sc_hd__fill_1
XFILLER_17_435 vssd1 vssd1 vccd1 vccd1 sky130_fd_sc_hd__fill_2
XANTENNA__2195__S net66 vssd1 vssd1 vccd1 vccd1 sky130_fd_sc_hd__diode_2
XFILLER_17_479 vccd1 vssd1 vccd1 vssd1 sky130_ef_sc_hd__decap_40_12
XFILLER_44_243 vssd1 vssd1 vccd1 vccd1 sky130_fd_sc_hd__fill_4
XFILLER_16_70 vssd1 vssd1 vccd1 vccd1 sky130_fd_sc_hd__fill_1
XFILLER_44_276 vssd1 vssd1 vccd1 vccd1 sky130_fd_sc_hd__fill_2
XTAP_TAPCELL_ROW_70_764 vssd1 vccd1 sky130_fd_sc_hd__tapvpwrvgnd_1
XFILLER_32_449 vssd1 vssd1 vccd1 vccd1 sky130_fd_sc_hd__fill_2
Xclkbuf_leaf_24_clk clknet_2_3__leaf_clk vssd1 vssd1 vccd1 vccd1 clknet_leaf_24_clk
+ sky130_fd_sc_hd__clkbuf_8
XFILLER_8_111 vssd1 vssd1 vccd1 vccd1 sky130_fd_sc_hd__fill_2
XFILLER_12_173 vssd1 vssd1 vccd1 vccd1 sky130_fd_sc_hd__fill_1
XFILLER_8_133 vssd1 vssd1 vccd1 vccd1 sky130_fd_sc_hd__fill_4
XFILLER_40_493 vssd1 vssd1 vccd1 vccd1 sky130_fd_sc_hd__fill_1
XANTENNA__3039__B net114 vssd1 vssd1 vccd1 vccd1 sky130_fd_sc_hd__diode_2
XFILLER_32_91 vssd1 vssd1 vccd1 vccd1 sky130_fd_sc_hd__fill_2
XFILLER_4_361 vssd1 vssd1 vccd1 vccd1 sky130_fd_sc_hd__fill_2
XANTENNA__1762__A1 net216 vssd1 vssd1 vccd1 vccd1 sky130_fd_sc_hd__diode_2
XFILLER_4_372 vccd1 vssd1 vccd1 vssd1 sky130_ef_sc_hd__decap_40_12
XANTENNA__1762__B2 net219 vssd1 vssd1 vccd1 vccd1 sky130_fd_sc_hd__diode_2
X_3200_ clknet_leaf_23_clk _0122_ _0023_ vssd1 vssd1 vccd1 vccd1 MATMULT_INST.matmult_inst.spi_inst.rx_done_sys
+ sky130_fd_sc_hd__dfrtp_4
XFILLER_79_184 vccd1 vssd1 vccd1 vssd1 sky130_ef_sc_hd__decap_40_12
X_3131_ net225 vssd1 vssd1 vccd1 vccd1 _0048_ sky130_fd_sc_hd__inv_2
XTAP_TAPCELL_ROW_78_831 vssd1 vccd1 sky130_fd_sc_hd__tapvpwrvgnd_1
X_3062_ net330 net32 net9 vssd1 vssd1 vccd1 vccd1 _0481_ sky130_fd_sc_hd__mux2_1
X_2013_ net106 net34 net27 net412 vssd1 vssd1 vccd1 vccd1 _0174_ sky130_fd_sc_hd__a22o_1
XFILLER_35_254 vssd1 vssd1 vccd1 vccd1 sky130_fd_sc_hd__fill_4
XFILLER_35_287 vssd1 vssd1 vccd1 vccd1 sky130_fd_sc_hd__fill_1
XFILLER_23_449 vccd1 vssd1 vccd1 vssd1 sky130_ef_sc_hd__decap_40_12
XFILLER_50_257 vssd1 vssd1 vccd1 vccd1 sky130_fd_sc_hd__fill_1
Xclkbuf_leaf_15_clk clknet_2_1__leaf_clk vssd1 vssd1 vccd1 vccd1 clknet_leaf_15_clk
+ sky130_fd_sc_hd__clkbuf_8
X_2915_ net172 _1455_ _1454_ vssd1 vssd1 vccd1 vccd1 _1456_ sky130_fd_sc_hd__a21bo_1
XTAP_TAPCELL_ROW_33_455 vssd1 vccd1 sky130_fd_sc_hd__tapvpwrvgnd_1
X_2846_ _1387_ _1388_ _1383_ vssd1 vssd1 vccd1 vccd1 _1389_ sky130_fd_sc_hd__a21oi_1
XFILLER_31_493 vssd1 vssd1 vccd1 vccd1 sky130_fd_sc_hd__fill_1
Xhold100 MATMULT_INST.matmult_inst.mem_inst.mem2\[17\] vssd1 vssd1 vccd1 vccd1 net395
+ sky130_fd_sc_hd__dlygate4sd3_1
X_2777_ _1296_ _1320_ _1321_ vssd1 vssd1 vccd1 vccd1 _1322_ sky130_fd_sc_hd__a21oi_1
Xhold133 MATMULT_INST.matmult_inst.mem_inst.mem0\[14\] vssd1 vssd1 vccd1 vccd1 net428
+ sky130_fd_sc_hd__dlygate4sd3_1
Xhold122 MATMULT_INST.matmult_inst.mem_inst.matrixA0\[17\] vssd1 vssd1 vccd1 vccd1
+ net417 sky130_fd_sc_hd__dlygate4sd3_1
Xhold111 MATMULT_INST.matmult_inst.mem_inst.matrixA1\[16\] vssd1 vssd1 vccd1 vccd1
+ net406 sky130_fd_sc_hd__dlygate4sd3_1
X_1728_ net223 _0643_ _0648_ vssd1 vssd1 vccd1 vccd1 _0649_ sky130_fd_sc_hd__a21o_1
XANTENNA_fanout201_A net203 vssd1 vssd1 vccd1 vccd1 sky130_fd_sc_hd__diode_2
XANTENNA__1753__A1 _0671_ vssd1 vssd1 vccd1 vccd1 sky130_fd_sc_hd__diode_2
Xhold144 MATMULT_INST.matmult_inst.mem_inst.matrixA0\[7\] vssd1 vssd1 vccd1 vccd1
+ net439 sky130_fd_sc_hd__dlygate4sd3_1
X_1659_ net151 net142 MATMULT_INST.matmult_inst.mem_inst.matrixB3\[14\] vssd1 vssd1
+ vccd1 vccd1 _0586_ sky130_fd_sc_hd__and3_1
Xhold155 MATMULT_INST.matmult_inst.mem_inst.matrixA2\[10\] vssd1 vssd1 vccd1 vccd1
+ net450 sky130_fd_sc_hd__dlygate4sd3_1
Xhold177 MATMULT_INST.matmult_inst.alu_inst.row1\[7\] vssd1 vssd1 vccd1 vccd1 net472
+ sky130_fd_sc_hd__dlygate4sd3_1
Xhold166 MATMULT_INST.matmult_inst.mem_inst.matrixB1\[3\] vssd1 vssd1 vccd1 vccd1
+ net461 sky130_fd_sc_hd__dlygate4sd3_1
Xhold188 MATMULT_INST.matmult_inst.mem_inst.matrixB3\[14\] vssd1 vssd1 vccd1 vccd1
+ net483 sky130_fd_sc_hd__dlygate4sd3_1
Xhold199 MATMULT_INST.matmult_inst.mem_inst.matrixA0\[14\] vssd1 vssd1 vccd1 vccd1
+ net494 sky130_fd_sc_hd__dlygate4sd3_1
XANTENNA__2702__A0 _1251_ vssd1 vssd1 vccd1 vccd1 sky130_fd_sc_hd__diode_2
XFILLER_58_313 vssd1 vssd1 vccd1 vccd1 sky130_fd_sc_hd__fill_1
X_3329_ clknet_leaf_16_clk _0251_ vssd1 vssd1 vccd1 vccd1 MATMULT_INST.matmult_inst.mem_inst.mem3\[2\]
+ sky130_fd_sc_hd__dfxtp_1
XFILLER_37_36 vssd1 vssd1 vccd1 vccd1 sky130_fd_sc_hd__fill_1
XFILLER_26_232 vccd1 vssd1 vccd1 vssd1 sky130_ef_sc_hd__decap_40_12
XFILLER_26_276 vssd1 vssd1 vccd1 vccd1 sky130_fd_sc_hd__fill_1
XFILLER_41_213 vssd1 vssd1 vccd1 vccd1 sky130_fd_sc_hd__fill_2
XFILLER_53_13 vssd1 vssd1 vccd1 vccd1 sky130_fd_sc_hd__fill_1
XFILLER_22_460 vssd1 vssd1 vccd1 vccd1 sky130_fd_sc_hd__fill_2
XFILLER_41_279 vssd1 vssd1 vccd1 vccd1 sky130_fd_sc_hd__fill_1
XFILLER_5_147 vccd1 vssd1 vccd1 vssd1 sky130_ef_sc_hd__decap_40_12
XFILLER_1_353 vssd1 vssd1 vccd1 vccd1 sky130_fd_sc_hd__fill_4
XFILLER_49_357 vssd1 vssd1 vccd1 vccd1 sky130_fd_sc_hd__fill_4
XTAP_TAPCELL_ROW_75_812 vssd1 vccd1 sky130_fd_sc_hd__tapvpwrvgnd_1
XTAP_TAPCELL_ROW_47_569 vssd1 vccd1 sky130_fd_sc_hd__tapvpwrvgnd_1
XFILLER_20_419 vssd1 vssd1 vccd1 vccd1 sky130_fd_sc_hd__fill_1
XANTENNA__1777__B net140 vssd1 vssd1 vccd1 vccd1 sky130_fd_sc_hd__diode_2
X_2700_ _1249_ net490 _1256_ vssd1 vssd1 vccd1 vccd1 _0419_ sky130_fd_sc_hd__mux2_1
XTAP_TAPCELL_ROW_30_425 vssd1 vccd1 sky130_fd_sc_hd__tapvpwrvgnd_1
XFILLER_9_464 vccd1 vssd1 vccd1 vssd1 sky130_ef_sc_hd__decap_40_12
X_2631_ _1198_ _1219_ vssd1 vssd1 vccd1 vccd1 _1220_ sky130_fd_sc_hd__xnor2_1
X_2562_ _1116_ _1119_ _1117_ vssd1 vssd1 vccd1 vccd1 _1153_ sky130_fd_sc_hd__a21bo_1
XFILLER_57_3 vssd1 vssd1 vccd1 vccd1 sky130_fd_sc_hd__fill_2
X_2493_ _1083_ _1084_ _1085_ vssd1 vssd1 vccd1 vccd1 _1086_ sky130_fd_sc_hd__nand3_1
Xclkbuf_leaf_4_clk clknet_2_0__leaf_clk vssd1 vssd1 vccd1 vccd1 clknet_leaf_4_clk
+ sky130_fd_sc_hd__clkbuf_8
X_3114_ net56 net86 net75 vssd1 vssd1 vccd1 vccd1 _0033_ sky130_fd_sc_hd__and3_1
X_3045_ net314 _0797_ net8 vssd1 vssd1 vccd1 vccd1 _0464_ sky130_fd_sc_hd__mux2_1
XFILLER_63_371 vssd1 vssd1 vccd1 vccd1 sky130_fd_sc_hd__fill_1
XANTENNA_fanout151_A net154 vssd1 vssd1 vccd1 vccd1 sky130_fd_sc_hd__diode_2
XFILLER_23_279 vssd1 vssd1 vccd1 vccd1 sky130_fd_sc_hd__fill_1
X_2829_ _1350_ _1370_ _1371_ vssd1 vssd1 vccd1 vccd1 _1372_ sky130_fd_sc_hd__and3_1
XFILLER_46_316 vssd1 vssd1 vccd1 vccd1 sky130_fd_sc_hd__fill_8
XFILLER_48_79 vssd1 vssd1 vccd1 vccd1 sky130_fd_sc_hd__fill_4
XTAP_TAPCELL_ROW_1_183 vssd1 vccd1 sky130_fd_sc_hd__tapvpwrvgnd_1
Xfanout61 net62 vssd1 vssd1 vccd1 vccd1 net61 sky130_fd_sc_hd__clkbuf_2
Xfanout72 net73 vssd1 vssd1 vccd1 vccd1 net72 sky130_fd_sc_hd__clkbuf_2
Xfanout50 _0795_ vssd1 vssd1 vccd1 vccd1 net50 sky130_fd_sc_hd__clkbuf_2
Xfanout83 net86 vssd1 vssd1 vccd1 vccd1 net83 sky130_fd_sc_hd__clkbuf_2
XANTENNA__1965__A1 net38 vssd1 vssd1 vccd1 vccd1 sky130_fd_sc_hd__diode_2
Xfanout94 net95 vssd1 vssd1 vccd1 vccd1 net94 sky130_fd_sc_hd__buf_2
XFILLER_13_71 vssd1 vssd1 vccd1 vccd1 sky130_fd_sc_hd__fill_2
XFILLER_6_489 vssd1 vssd1 vccd1 vccd1 sky130_fd_sc_hd__fill_2
XTAP_TAPCELL_ROW_9_250 vssd1 vccd1 sky130_fd_sc_hd__tapvpwrvgnd_1
XFILLER_29_7 vssd1 vssd1 vccd1 vccd1 sky130_fd_sc_hd__fill_2
XANTENNA__2142__A1 net38 vssd1 vssd1 vccd1 vccd1 sky130_fd_sc_hd__diode_2
XFILLER_49_165 vssd1 vssd1 vccd1 vccd1 sky130_fd_sc_hd__fill_2
XFILLER_77_485 vssd1 vssd1 vccd1 vccd1 sky130_fd_sc_hd__fill_2
XANTENNA__2693__A2 _1251_ vssd1 vssd1 vccd1 vccd1 sky130_fd_sc_hd__diode_2
XANTENNA_clkbuf_leaf_0_clk_A clknet_2_0__leaf_clk vssd1 vssd1 vccd1 vccd1 sky130_fd_sc_hd__diode_2
XFILLER_60_330 vccd1 vssd1 vccd1 vssd1 sky130_ef_sc_hd__decap_40_12
X_1993_ net492 net35 net28 vssd1 vssd1 vccd1 vccd1 _0155_ sky130_fd_sc_hd__mux2_1
XFILLER_9_261 vssd1 vssd1 vccd1 vccd1 sky130_fd_sc_hd__fill_4
XTAP_TAPCELL_ROW_15_296 vssd1 vccd1 sky130_fd_sc_hd__tapvpwrvgnd_1
Xclkload20 clknet_leaf_15_clk vssd1 vssd1 vccd1 vccd1 clkload20/Y sky130_fd_sc_hd__clkinv_2
Xclkload31 clknet_leaf_21_clk vssd1 vssd1 vccd1 vccd1 clkload31/Y sky130_fd_sc_hd__inv_6
X_2614_ _1202_ vssd1 vssd1 vccd1 vccd1 _1203_ sky130_fd_sc_hd__inv_2
X_3594_ net228 _0012_ _0092_ vssd1 vssd1 vccd1 vccd1 MATMULT_INST.matmult_inst.spi_inst.miso_shifter\[14\]
+ sky130_fd_sc_hd__dfrtp_1
X_2545_ _1122_ _1132_ vssd1 vssd1 vccd1 vccd1 _1137_ sky130_fd_sc_hd__nor2_1
XANTENNA__2381__A1 _0977_ vssd1 vssd1 vccd1 vccd1 sky130_fd_sc_hd__diode_2
X_2476_ MATMULT_INST.matmult_inst.alu_inst.adder_inst.r1.fa3.a _1069_ net96 vssd1
+ vssd1 vccd1 vccd1 _0382_ sky130_fd_sc_hd__mux2_1
XFILLER_68_474 vssd1 vssd1 vccd1 vccd1 sky130_fd_sc_hd__fill_2
XANTENNA_fanout199_A net200 vssd1 vssd1 vccd1 vccd1 sky130_fd_sc_hd__diode_2
XFILLER_28_305 vssd1 vssd1 vccd1 vccd1 sky130_fd_sc_hd__fill_2
XANTENNA__2684__A2 _1251_ vssd1 vssd1 vccd1 vccd1 sky130_fd_sc_hd__diode_2
XFILLER_55_113 vssd1 vssd1 vccd1 vccd1 sky130_fd_sc_hd__fill_1
X_3028_ _1563_ _1564_ vssd1 vssd1 vccd1 vccd1 _1565_ sky130_fd_sc_hd__and2_1
XFILLER_70_149 vssd1 vssd1 vccd1 vccd1 sky130_fd_sc_hd__fill_1
XANTENNA_fanout154_X net154 vssd1 vssd1 vccd1 vccd1 sky130_fd_sc_hd__diode_2
XFILLER_51_385 vssd1 vssd1 vccd1 vccd1 sky130_fd_sc_hd__fill_1
XFILLER_7_209 vssd1 vssd1 vccd1 vccd1 sky130_fd_sc_hd__fill_2
Xclkload3 clknet_leaf_0_clk vssd1 vssd1 vccd1 vccd1 clkload3/X sky130_fd_sc_hd__clkbuf_4
XFILLER_3_415 vccd1 vssd1 vccd1 vssd1 sky130_ef_sc_hd__decap_40_12
XFILLER_78_227 vssd1 vssd1 vccd1 vccd1 sky130_fd_sc_hd__fill_2
XFILLER_78_238 vssd1 vssd1 vccd1 vccd1 sky130_fd_sc_hd__fill_2
XTAP_TAPCELL_ROW_6_220 vssd1 vccd1 sky130_fd_sc_hd__tapvpwrvgnd_1
XFILLER_59_441 vssd1 vssd1 vccd1 vccd1 sky130_fd_sc_hd__fill_2
XANTENNA_fanout67_X net67 vssd1 vssd1 vccd1 vccd1 sky130_fd_sc_hd__diode_2
XTAP_TAPCELL_ROW_57_653 vssd1 vccd1 sky130_fd_sc_hd__tapvpwrvgnd_1
XFILLER_74_477 vccd1 vssd1 vccd1 vssd1 sky130_ef_sc_hd__decap_40_12
XFILLER_61_138 vssd1 vssd1 vccd1 vccd1 sky130_fd_sc_hd__fill_1
XANTENNA_clkbuf_2_3__f_clk_X clknet_2_3__leaf_clk vssd1 vssd1 vccd1 vccd1 sky130_fd_sc_hd__diode_2
XTAP_TAPCELL_ROW_12_277 vssd1 vccd1 sky130_fd_sc_hd__tapvpwrvgnd_1
XFILLER_10_260 vccd1 vssd1 vccd1 vssd1 sky130_ef_sc_hd__decap_40_12
XFILLER_6_253 vssd1 vssd1 vccd1 vccd1 sky130_fd_sc_hd__fill_8
XFILLER_6_286 vssd1 vssd1 vccd1 vccd1 sky130_fd_sc_hd__fill_4
X_2330_ net155 net472 net67 vssd1 vssd1 vccd1 vccd1 _0374_ sky130_fd_sc_hd__mux2_1
X_2261_ _0869_ _0874_ _0877_ _0882_ _0875_ vssd1 vssd1 vccd1 vccd1 _0889_ sky130_fd_sc_hd__o311a_1
XFILLER_1_41 vssd1 vssd1 vccd1 vccd1 sky130_fd_sc_hd__fill_2
X_2192_ MATMULT_INST.matmult_inst.alu_inst.state\[1\] MATMULT_INST.matmult_inst.alu_inst.state\[0\]
+ _0751_ _0756_ vssd1 vssd1 vccd1 vccd1 _0532_ sky130_fd_sc_hd__and4bb_1
XFILLER_37_113 vssd1 vssd1 vccd1 vccd1 sky130_fd_sc_hd__fill_1
XFILLER_1_74 vssd1 vssd1 vccd1 vccd1 sky130_fd_sc_hd__fill_2
XFILLER_18_371 vccd1 vssd1 vccd1 vssd1 sky130_ef_sc_hd__decap_40_12
XFILLER_25_308 vssd1 vssd1 vccd1 vccd1 sky130_fd_sc_hd__fill_2
X_1976_ MATMULT_INST.matmult_inst.fsm_inst.alu_result\[17\] net70 vssd1 vssd1 vccd1
+ vccd1 _0814_ sky130_fd_sc_hd__and2_2
XANTENNA__2499__D net210 vssd1 vssd1 vccd1 vccd1 sky130_fd_sc_hd__diode_2
X_3646_ clknet_leaf_26_clk _0530_ vssd1 vssd1 vccd1 vccd1 MATMULT_INST.matmult_inst.fsm_inst.state\[0\]
+ sky130_fd_sc_hd__dfxtp_2
X_3577_ clknet_leaf_23_clk net612 _0075_ vssd1 vssd1 vccd1 vccd1 MATMULT_INST.matmult_inst.fsm_inst.rx_data\[7\]
+ sky130_fd_sc_hd__dfrtp_1
X_2528_ _1117_ _1119_ vssd1 vssd1 vccd1 vccd1 _1120_ sky130_fd_sc_hd__nand2_1
XFILLER_29_26 vssd1 vssd1 vccd1 vccd1 sky130_fd_sc_hd__fill_2
Xhold37 MATMULT_INST.matmult_inst.mem_inst.matrixA3\[17\] vssd1 vssd1 vccd1 vccd1
+ net332 sky130_fd_sc_hd__dlygate4sd3_1
X_2459_ _1046_ _1050_ _1051_ vssd1 vssd1 vccd1 vccd1 _1053_ sky130_fd_sc_hd__nand3_1
XTAP_TAPCELL_ROW_3_201 vssd1 vccd1 sky130_fd_sc_hd__tapvpwrvgnd_1
Xhold26 MATMULT_INST.matmult_inst.mem_inst.matrixA3\[5\] vssd1 vssd1 vccd1 vccd1 net321
+ sky130_fd_sc_hd__dlygate4sd3_1
Xhold15 MATMULT_INST.matmult_inst.fsm_inst.alu_result\[12\] vssd1 vssd1 vccd1 vccd1
+ net310 sky130_fd_sc_hd__dlygate4sd3_1
Xhold59 MATMULT_INST.matmult_inst.alu_inst.row1\[2\] vssd1 vssd1 vccd1 vccd1 net354
+ sky130_fd_sc_hd__dlygate4sd3_1
Xhold48 _0521_ vssd1 vssd1 vccd1 vccd1 net343 sky130_fd_sc_hd__dlygate4sd3_1
XFILLER_71_425 vssd1 vssd1 vccd1 vccd1 sky130_fd_sc_hd__fill_2
XFILLER_28_179 vssd1 vssd1 vccd1 vccd1 sky130_fd_sc_hd__fill_1
XFILLER_45_69 vssd1 vssd1 vccd1 vccd1 sky130_fd_sc_hd__fill_2
XTAP_TAPCELL_ROW_54_634 vssd1 vccd1 sky130_fd_sc_hd__tapvpwrvgnd_1
XFILLER_71_469 vccd1 vssd1 vccd1 vssd1 sky130_ef_sc_hd__decap_40_12
XFILLER_24_363 vssd1 vssd1 vccd1 vccd1 sky130_fd_sc_hd__fill_1
XFILLER_61_24 vssd1 vssd1 vccd1 vccd1 sky130_fd_sc_hd__fill_2
XFILLER_3_223 vssd1 vssd1 vccd1 vccd1 sky130_fd_sc_hd__fill_1
XFILLER_3_234 vssd1 vssd1 vccd1 vccd1 sky130_fd_sc_hd__fill_4
XFILLER_10_83 vssd1 vssd1 vccd1 vccd1 sky130_fd_sc_hd__fill_1
XFILLER_19_113 vssd1 vssd1 vccd1 vccd1 sky130_fd_sc_hd__fill_4
XFILLER_19_157 vssd1 vssd1 vccd1 vccd1 sky130_fd_sc_hd__fill_1
XFILLER_19_179 vssd1 vssd1 vccd1 vccd1 sky130_fd_sc_hd__fill_4
XTAP_TAPCELL_ROW_17_314 vssd1 vccd1 sky130_fd_sc_hd__tapvpwrvgnd_1
XFILLER_15_363 vssd1 vssd1 vccd1 vccd1 sky130_fd_sc_hd__fill_8
X_1830_ _0548_ _0733_ MATMULT_INST.matmult_inst.fsm_inst.tx_start_send vssd1 vssd1
+ vccd1 vccd1 _0734_ sky130_fd_sc_hd__or3b_2
XFILLER_30_388 vccd1 vssd1 vccd1 vssd1 sky130_ef_sc_hd__decap_40_12
X_3500_ clknet_leaf_0_clk _0418_ vssd1 vssd1 vccd1 vccd1 MATMULT_INST.matmult_inst.alu_inst.row0\[2\]
+ sky130_fd_sc_hd__dfxtp_1
X_1761_ MATMULT_INST.matmult_inst.mem_inst.matrixB1\[5\] net124 net116 MATMULT_INST.matmult_inst.mem_inst.matrixB2\[5\]
+ _0678_ vssd1 vssd1 vccd1 vccd1 _0679_ sky130_fd_sc_hd__a221o_1
X_1692_ MATMULT_INST.matmult_inst.mem_inst.matrixB1\[11\] net130 net122 MATMULT_INST.matmult_inst.mem_inst.matrixB2\[11\]
+ _0615_ vssd1 vssd1 vccd1 vccd1 _0616_ sky130_fd_sc_hd__a221o_1
X_3431_ clknet_leaf_26_clk _0353_ vssd1 vssd1 vccd1 vccd1 MATMULT_INST.matmult_inst.alu_inst.out\[12\]
+ sky130_fd_sc_hd__dfxtp_1
X_3362_ clknet_leaf_12_clk _0284_ vssd1 vssd1 vccd1 vccd1 MATMULT_INST.matmult_inst.mem_inst.mem2\[17\]
+ sky130_fd_sc_hd__dfxtp_1
X_2313_ MATMULT_INST.matmult_inst.alu_inst.adder_inst.fa.b MATMULT_INST.matmult_inst.alu_inst.adder_inst.fa.a
+ net99 vssd1 vssd1 vccd1 vccd1 _0932_ sky130_fd_sc_hd__o21a_1
X_3293_ clknet_leaf_15_clk _0215_ vssd1 vssd1 vccd1 vccd1 MATMULT_INST.matmult_inst.mem_inst.matrixA1\[2\]
+ sky130_fd_sc_hd__dfxtp_1
X_2244_ MATMULT_INST.matmult_inst.alu_inst.adder_inst.r1.fa2.b MATMULT_INST.matmult_inst.alu_inst.adder_inst.r1.fa2.a
+ vssd1 vssd1 vccd1 vccd1 _0874_ sky130_fd_sc_hd__nor2_1
XTAP_TAPCELL_ROW_68_748 vssd1 vccd1 sky130_fd_sc_hd__tapvpwrvgnd_1
X_2175_ _0774_ _0831_ vssd1 vssd1 vccd1 vccd1 _0832_ sky130_fd_sc_hd__or2_2
XFILLER_38_433 vssd1 vssd1 vccd1 vccd1 sky130_fd_sc_hd__fill_2
XFILLER_53_403 vssd1 vssd1 vccd1 vccd1 sky130_fd_sc_hd__fill_1
XFILLER_15_39 vssd1 vssd1 vccd1 vccd1 sky130_fd_sc_hd__fill_4
XTAP_TAPCELL_ROW_51_604 vssd1 vccd1 sky130_fd_sc_hd__tapvpwrvgnd_1
XFILLER_33_171 vssd1 vssd1 vccd1 vccd1 sky130_fd_sc_hd__fill_4
XFILLER_61_491 vssd1 vssd1 vccd1 vccd1 sky130_fd_sc_hd__fill_2
X_1959_ net437 net41 net31 vssd1 vssd1 vccd1 vccd1 _0131_ sky130_fd_sc_hd__mux2_1
XFILLER_31_27 vssd1 vssd1 vccd1 vccd1 sky130_fd_sc_hd__fill_2
X_3629_ clknet_leaf_24_clk net376 vssd1 vssd1 vccd1 vccd1 MATMULT_INST.matmult_inst.fsm_inst.alu_result\[5\]
+ sky130_fd_sc_hd__dfxtp_1
XFILLER_0_237 vccd1 vssd1 vccd1 vssd1 sky130_ef_sc_hd__decap_40_12
XFILLER_29_433 vssd1 vssd1 vccd1 vccd1 sky130_fd_sc_hd__fill_2
XFILLER_16_105 vssd1 vssd1 vccd1 vccd1 sky130_fd_sc_hd__fill_2
XFILLER_16_138 vssd1 vssd1 vccd1 vccd1 sky130_fd_sc_hd__fill_2
XFILLER_12_311 vssd1 vssd1 vccd1 vccd1 sky130_fd_sc_hd__fill_1
XFILLER_24_193 vssd1 vssd1 vccd1 vccd1 sky130_fd_sc_hd__fill_2
XTAP_TAPCELL_ROW_22_361 vssd1 vccd1 sky130_fd_sc_hd__tapvpwrvgnd_1
XANTENNA__2015__B1 net27 vssd1 vssd1 vccd1 vccd1 sky130_fd_sc_hd__diode_2
XFILLER_8_359 vssd1 vssd1 vccd1 vccd1 sky130_fd_sc_hd__fill_4
XFILLER_79_333 vssd1 vssd1 vccd1 vccd1 sky130_fd_sc_hd__fill_2
XFILLER_35_414 vssd1 vssd1 vccd1 vccd1 sky130_fd_sc_hd__fill_1
XFILLER_35_436 vssd1 vssd1 vccd1 vccd1 sky130_fd_sc_hd__fill_1
XFILLER_35_447 vssd1 vssd1 vccd1 vccd1 sky130_fd_sc_hd__fill_1
XTAP_TAPCELL_ROW_73_795 vssd1 vccd1 sky130_fd_sc_hd__tapvpwrvgnd_1
XFILLER_62_277 vssd1 vssd1 vccd1 vccd1 sky130_fd_sc_hd__fill_8
X_2931_ _1470_ _1471_ vssd1 vssd1 vccd1 vccd1 _1472_ sky130_fd_sc_hd__or2_1
XFILLER_15_171 vssd1 vssd1 vccd1 vccd1 sky130_fd_sc_hd__fill_1
XFILLER_22_108 vccd1 vssd1 vccd1 vssd1 sky130_ef_sc_hd__decap_40_12
Xclkbuf_0_clk clk vssd1 vssd1 vccd1 vccd1 clknet_0_clk sky130_fd_sc_hd__clkbuf_16
X_2862_ _1366_ _1404_ vssd1 vssd1 vccd1 vccd1 _1405_ sky130_fd_sc_hd__xnor2_1
XANTENNA__2006__B1 net27 vssd1 vssd1 vccd1 vccd1 sky130_fd_sc_hd__diode_2
X_2793_ _1317_ _1318_ _1294_ vssd1 vssd1 vccd1 vccd1 _1337_ sky130_fd_sc_hd__a21o_1
X_1813_ MATMULT_INST.matmult_inst.mem_inst.matrixA1\[0\] net124 net116 MATMULT_INST.matmult_inst.mem_inst.matrixA2\[0\]
+ _0725_ vssd1 vssd1 vccd1 vccd1 _0726_ sky130_fd_sc_hd__a221o_1
X_1744_ MATMULT_INST.matmult_inst.mem_inst.matrixA1\[6\] net124 net116 MATMULT_INST.matmult_inst.mem_inst.matrixA2\[6\]
+ _0662_ vssd1 vssd1 vccd1 vccd1 _0663_ sky130_fd_sc_hd__a221o_1
XFILLER_7_95 vssd1 vssd1 vccd1 vccd1 sky130_fd_sc_hd__fill_2
Xhold315 MATMULT_INST.matmult_inst.alu_inst.col1\[4\] vssd1 vssd1 vccd1 vccd1 net610
+ sky130_fd_sc_hd__dlygate4sd3_1
Xhold326 MATMULT_INST.matmult_inst.spi_inst.tx_reg_sys\[0\] vssd1 vssd1 vccd1 vccd1
+ net621 sky130_fd_sc_hd__dlygate4sd3_1
Xhold304 MATMULT_INST.matmult_inst.mem_inst.mem0\[7\] vssd1 vssd1 vccd1 vccd1 net599
+ sky130_fd_sc_hd__dlygate4sd3_1
Xhold337 MATMULT_INST.matmult_inst.spi_inst.tx_reg_sys\[11\] vssd1 vssd1 vccd1 vccd1
+ net632 sky130_fd_sc_hd__dlygate4sd3_1
X_1675_ MATMULT_INST.matmult_inst.mem_inst.mem0\[13\] net108 net104 MATMULT_INST.matmult_inst.mem_inst.matrixB0\[13\]
+ _0600_ vssd1 vssd1 vccd1 vccd1 _0601_ sky130_fd_sc_hd__a221o_1
Xhold348 MATMULT_INST.matmult_inst.alu_inst.adder_inst.r3.fa1.a vssd1 vssd1 vccd1
+ vccd1 net643 sky130_fd_sc_hd__dlygate4sd3_1
Xhold359 MATMULT_INST.matmult_inst.alu_inst.adder_inst.r1.fa2.b vssd1 vssd1 vccd1
+ vccd1 net654 sky130_fd_sc_hd__dlygate4sd3_1
X_3414_ clknet_leaf_0_clk _0336_ vssd1 vssd1 vccd1 vccd1 MATMULT_INST.matmult_inst.alu_inst.a0_reg\[3\]
+ sky130_fd_sc_hd__dfxtp_1
XANTENNA__1780__A2 net128 vssd1 vssd1 vccd1 vccd1 sky130_fd_sc_hd__diode_2
XPHY_EDGE_ROW_15_Right_15 vssd1 vssd1 vccd1 vccd1 sky130_fd_sc_hd__decap_3
X_3345_ clknet_leaf_7_clk _0267_ vssd1 vssd1 vccd1 vccd1 MATMULT_INST.matmult_inst.mem_inst.mem2\[0\]
+ sky130_fd_sc_hd__dfxtp_1
X_3276_ clknet_leaf_4_clk _0198_ vssd1 vssd1 vccd1 vccd1 MATMULT_INST.matmult_inst.mem_inst.matrixA2\[3\]
+ sky130_fd_sc_hd__dfxtp_1
X_2227_ _0851_ _0855_ _0852_ vssd1 vssd1 vccd1 vccd1 _0860_ sky130_fd_sc_hd__o21ai_1
XFILLER_26_403 vssd1 vssd1 vccd1 vccd1 sky130_fd_sc_hd__fill_4
XTAP_TAPCELL_ROW_28_409 vssd1 vccd1 sky130_fd_sc_hd__tapvpwrvgnd_1
X_2158_ net109 net41 net11 net369 vssd1 vssd1 vccd1 vccd1 _0311_ sky130_fd_sc_hd__a22o_1
XFILLER_26_414 vssd1 vssd1 vccd1 vccd1 sky130_fd_sc_hd__fill_4
X_2089_ net407 _0812_ net19 vssd1 vssd1 vccd1 vccd1 _0246_ sky130_fd_sc_hd__mux2_1
XPHY_EDGE_ROW_24_Right_24 vssd1 vssd1 vccd1 vccd1 sky130_fd_sc_hd__decap_3
XTAP_TAPCELL_ROW_36_475 vssd1 vccd1 sky130_fd_sc_hd__tapvpwrvgnd_1
XFILLER_42_37 vssd1 vssd1 vccd1 vccd1 sky130_fd_sc_hd__fill_8
XANTENNA__1645__S net64 vssd1 vssd1 vccd1 vccd1 sky130_fd_sc_hd__diode_2
XPHY_EDGE_ROW_33_Right_33 vssd1 vssd1 vccd1 vccd1 sky130_fd_sc_hd__decap_3
XANTENNA__2476__S net96 vssd1 vssd1 vccd1 vccd1 sky130_fd_sc_hd__diode_2
XANTENNA__3161__A net58 vssd1 vssd1 vccd1 vccd1 sky130_fd_sc_hd__diode_2
XFILLER_29_263 vccd1 vssd1 vccd1 vssd1 sky130_ef_sc_hd__decap_40_12
XPHY_EDGE_ROW_42_Right_42 vssd1 vssd1 vccd1 vccd1 sky130_fd_sc_hd__decap_3
XFILLER_17_447 vssd1 vssd1 vccd1 vccd1 sky130_fd_sc_hd__fill_1
XFILLER_32_417 vssd1 vssd1 vccd1 vccd1 sky130_fd_sc_hd__fill_2
XFILLER_25_491 vssd1 vssd1 vccd1 vccd1 sky130_fd_sc_hd__fill_2
XTAP_TAPCELL_ROW_70_765 vssd1 vccd1 sky130_fd_sc_hd__tapvpwrvgnd_1
XFILLER_12_141 vccd1 vssd1 vccd1 vssd1 sky130_ef_sc_hd__decap_40_12
XANTENNA__2224__B MATMULT_INST.matmult_inst.alu_inst.adder_inst.r0.fa3.a vssd1 vssd1
+ vccd1 vccd1 sky130_fd_sc_hd__diode_2
XPHY_EDGE_ROW_51_Right_51 vssd1 vssd1 vccd1 vccd1 sky130_fd_sc_hd__decap_3
XFILLER_4_384 vssd1 vssd1 vccd1 vccd1 sky130_fd_sc_hd__fill_4
XFILLER_79_141 vccd1 vssd1 vccd1 vssd1 sky130_ef_sc_hd__decap_40_12
XFILLER_79_163 vssd1 vssd1 vccd1 vccd1 sky130_fd_sc_hd__fill_4
X_3130_ net225 vssd1 vssd1 vccd1 vccd1 _0046_ sky130_fd_sc_hd__inv_2
XANTENNA__2711__A1 net148 vssd1 vssd1 vccd1 vccd1 sky130_fd_sc_hd__diode_2
XTAP_TAPCELL_ROW_78_832 vssd1 vccd1 sky130_fd_sc_hd__tapvpwrvgnd_1
X_3061_ net356 _0813_ net9 vssd1 vssd1 vccd1 vccd1 _0480_ sky130_fd_sc_hd__mux2_1
XPHY_EDGE_ROW_60_Right_60 vssd1 vssd1 vccd1 vccd1 sky130_fd_sc_hd__decap_3
XFILLER_75_391 vssd1 vssd1 vccd1 vccd1 sky130_fd_sc_hd__fill_1
X_2012_ net105 net35 net27 net563 vssd1 vssd1 vccd1 vccd1 _0173_ sky130_fd_sc_hd__a22o_1
X_2914_ net171 net165 net162 vssd1 vssd1 vccd1 vccd1 _1455_ sky130_fd_sc_hd__and3_1
XTAP_TAPCELL_ROW_33_456 vssd1 vccd1 sky130_fd_sc_hd__tapvpwrvgnd_1
X_2845_ _1384_ _1385_ _1386_ vssd1 vssd1 vccd1 vccd1 _1388_ sky130_fd_sc_hd__o21ai_1
XFILLER_12_29 vssd1 vssd1 vccd1 vccd1 sky130_fd_sc_hd__fill_2
Xhold101 MATMULT_INST.matmult_inst.mem_inst.mem0\[12\] vssd1 vssd1 vccd1 vccd1 net396
+ sky130_fd_sc_hd__dlygate4sd3_1
X_2776_ _1296_ _1319_ vssd1 vssd1 vccd1 vccd1 _1321_ sky130_fd_sc_hd__nor2_1
Xhold134 MATMULT_INST.matmult_inst.mem_inst.mem1\[16\] vssd1 vssd1 vccd1 vccd1 net429
+ sky130_fd_sc_hd__dlygate4sd3_1
Xhold112 MATMULT_INST.matmult_inst.mem_inst.matrixA0\[15\] vssd1 vssd1 vccd1 vccd1
+ net407 sky130_fd_sc_hd__dlygate4sd3_1
X_1727_ net220 _0645_ _0647_ net218 vssd1 vssd1 vccd1 vccd1 _0648_ sky130_fd_sc_hd__a22o_1
Xhold123 MATMULT_INST.matmult_inst.mem_inst.matrixA0\[9\] vssd1 vssd1 vccd1 vccd1
+ net418 sky130_fd_sc_hd__dlygate4sd3_1
X_1658_ MATMULT_INST.matmult_inst.mem_inst.matrixA1\[14\] net126 net118 MATMULT_INST.matmult_inst.mem_inst.matrixA2\[14\]
+ _0584_ vssd1 vssd1 vccd1 vccd1 _0585_ sky130_fd_sc_hd__a221o_1
Xhold145 MATMULT_INST.matmult_inst.alu_inst.col0\[0\] vssd1 vssd1 vccd1 vccd1 net440
+ sky130_fd_sc_hd__dlygate4sd3_1
Xhold167 MATMULT_INST.matmult_inst.mem_inst.matrixB1\[2\] vssd1 vssd1 vccd1 vccd1
+ net462 sky130_fd_sc_hd__dlygate4sd3_1
Xhold156 MATMULT_INST.matmult_inst.mem_inst.mem1\[10\] vssd1 vssd1 vccd1 vccd1 net451
+ sky130_fd_sc_hd__dlygate4sd3_1
Xhold178 MATMULT_INST.matmult_inst.mem_inst.matrixB1\[16\] vssd1 vssd1 vccd1 vccd1
+ net473 sky130_fd_sc_hd__dlygate4sd3_1
Xhold189 MATMULT_INST.matmult_inst.mem_inst.mem0\[11\] vssd1 vssd1 vccd1 vccd1 net484
+ sky130_fd_sc_hd__dlygate4sd3_1
X_3328_ clknet_leaf_15_clk _0250_ vssd1 vssd1 vccd1 vccd1 MATMULT_INST.matmult_inst.mem_inst.mem3\[1\]
+ sky130_fd_sc_hd__dfxtp_1
X_3259_ clknet_leaf_6_clk _0181_ vssd1 vssd1 vccd1 vccd1 MATMULT_INST.matmult_inst.mem_inst.matrixA3\[4\]
+ sky130_fd_sc_hd__dfxtp_1
XANTENNA__2309__B _0928_ vssd1 vssd1 vccd1 vccd1 sky130_fd_sc_hd__diode_2
XFILLER_26_244 vssd1 vssd1 vccd1 vccd1 sky130_fd_sc_hd__fill_1
XFILLER_26_288 vccd1 vssd1 vccd1 vssd1 sky130_ef_sc_hd__decap_40_12
XFILLER_14_439 vssd1 vssd1 vccd1 vccd1 sky130_fd_sc_hd__fill_1
XFILLER_53_47 vssd1 vssd1 vccd1 vccd1 sky130_fd_sc_hd__fill_1
XFILLER_53_69 vssd1 vssd1 vccd1 vccd1 sky130_fd_sc_hd__fill_2
XFILLER_5_159 vssd1 vssd1 vccd1 vccd1 sky130_fd_sc_hd__fill_2
XFILLER_78_11 vssd1 vssd1 vccd1 vccd1 sky130_fd_sc_hd__fill_1
XANTENNA_fanout97_X net97 vssd1 vssd1 vccd1 vccd1 sky130_fd_sc_hd__diode_2
XFILLER_1_387 vssd1 vssd1 vccd1 vccd1 sky130_fd_sc_hd__fill_4
XTAP_TAPCELL_ROW_75_813 vssd1 vccd1 sky130_fd_sc_hd__tapvpwrvgnd_1
XFILLER_57_391 vssd1 vssd1 vccd1 vccd1 sky130_fd_sc_hd__fill_1
XFILLER_13_461 vssd1 vssd1 vccd1 vccd1 sky130_fd_sc_hd__fill_2
XFILLER_20_409 vssd1 vssd1 vccd1 vccd1 sky130_fd_sc_hd__fill_1
XTAP_TAPCELL_ROW_30_426 vssd1 vccd1 sky130_fd_sc_hd__tapvpwrvgnd_1
XFILLER_9_476 vccd1 vssd1 vccd1 vssd1 sky130_ef_sc_hd__decap_40_12
X_2630_ _1217_ _1218_ vssd1 vssd1 vccd1 vccd1 _1219_ sky130_fd_sc_hd__and2b_1
X_2561_ net190 net201 vssd1 vssd1 vccd1 vccd1 _1152_ sky130_fd_sc_hd__nand2_1
X_2492_ net190 net206 vssd1 vssd1 vccd1 vccd1 _1085_ sky130_fd_sc_hd__nand2_1
XFILLER_4_85 vccd1 vssd1 vccd1 vssd1 sky130_ef_sc_hd__decap_40_12
XFILLER_67_111 vssd1 vssd1 vccd1 vccd1 sky130_fd_sc_hd__fill_1
XFILLER_67_155 vssd1 vssd1 vccd1 vccd1 sky130_fd_sc_hd__fill_1
XFILLER_55_306 vssd1 vssd1 vccd1 vccd1 sky130_fd_sc_hd__fill_1
X_3113_ net56 net89 net75 vssd1 vssd1 vccd1 vccd1 _0035_ sky130_fd_sc_hd__and3_1
XFILLER_67_177 vssd1 vssd1 vccd1 vccd1 sky130_fd_sc_hd__fill_4
X_3044_ net221 _0548_ net50 vssd1 vssd1 vccd1 vccd1 _1577_ sky130_fd_sc_hd__and3_1
XFILLER_70_309 vssd1 vssd1 vccd1 vccd1 sky130_fd_sc_hd__fill_1
XANTENNA_fanout144_A net145 vssd1 vssd1 vccd1 vccd1 sky130_fd_sc_hd__diode_2
X_2828_ net169 net166 net171 net173 vssd1 vssd1 vccd1 vccd1 _1371_ sky130_fd_sc_hd__nand4_1
X_2759_ _1299_ _1304_ vssd1 vssd1 vccd1 vccd1 _1305_ sky130_fd_sc_hd__nor2_1
XANTENNA__1726__A2 net129 vssd1 vssd1 vccd1 vccd1 sky130_fd_sc_hd__diode_2
XANTENNA_fanout57_A _0734_ vssd1 vssd1 vccd1 vccd1 sky130_fd_sc_hd__diode_2
XFILLER_73_169 vssd1 vssd1 vccd1 vccd1 sky130_fd_sc_hd__fill_1
XTAP_TAPCELL_ROW_1_184 vssd1 vccd1 sky130_fd_sc_hd__tapvpwrvgnd_1
XFILLER_54_361 vssd1 vssd1 vccd1 vccd1 sky130_fd_sc_hd__fill_2
Xfanout40 _0806_ vssd1 vssd1 vccd1 vccd1 net40 sky130_fd_sc_hd__clkbuf_2
Xfanout51 net52 vssd1 vssd1 vccd1 vccd1 net51 sky130_fd_sc_hd__buf_2
Xfanout73 net74 vssd1 vssd1 vccd1 vccd1 net73 sky130_fd_sc_hd__clkbuf_2
XANTENNA_fanout12_X net12 vssd1 vssd1 vccd1 vccd1 sky130_fd_sc_hd__diode_2
Xfanout62 _0734_ vssd1 vssd1 vccd1 vccd1 net62 sky130_fd_sc_hd__buf_2
XFILLER_13_50 vssd1 vssd1 vccd1 vccd1 sky130_fd_sc_hd__fill_4
Xfanout95 net96 vssd1 vssd1 vccd1 vccd1 net95 sky130_fd_sc_hd__clkbuf_2
Xfanout84 net85 vssd1 vssd1 vccd1 vccd1 net84 sky130_fd_sc_hd__clkbuf_2
XFILLER_10_475 vssd1 vssd1 vccd1 vccd1 sky130_fd_sc_hd__fill_1
XFILLER_6_435 vssd1 vssd1 vccd1 vccd1 sky130_fd_sc_hd__fill_2
XTAP_TAPCELL_ROW_9_251 vssd1 vccd1 sky130_fd_sc_hd__tapvpwrvgnd_1
XFILLER_1_173 vssd1 vssd1 vccd1 vccd1 sky130_fd_sc_hd__fill_8
XFILLER_49_111 vssd1 vssd1 vccd1 vccd1 sky130_fd_sc_hd__fill_1
XFILLER_49_122 vccd1 vssd1 vccd1 vssd1 sky130_ef_sc_hd__decap_40_12
XFILLER_45_350 vssd1 vssd1 vccd1 vccd1 sky130_fd_sc_hd__fill_4
XTAP_TAPCELL_ROW_43_540 vssd1 vccd1 sky130_fd_sc_hd__tapvpwrvgnd_1
X_1992_ net459 net36 net28 vssd1 vssd1 vccd1 vccd1 _0154_ sky130_fd_sc_hd__mux2_1
XTAP_TAPCELL_ROW_15_297 vssd1 vccd1 sky130_fd_sc_hd__tapvpwrvgnd_1
Xclkload10 clknet_leaf_37_clk vssd1 vssd1 vccd1 vccd1 clkload10/Y sky130_fd_sc_hd__inv_8
XANTENNA__1956__A2 _0781_ vssd1 vssd1 vccd1 vccd1 sky130_fd_sc_hd__diode_2
X_3593_ net226 _0011_ _0091_ vssd1 vssd1 vccd1 vccd1 MATMULT_INST.matmult_inst.spi_inst.miso_shifter\[13\]
+ sky130_fd_sc_hd__dfrtp_1
X_2613_ _1118_ _1180_ _1182_ _1179_ vssd1 vssd1 vccd1 vccd1 _1202_ sky130_fd_sc_hd__a22oi_2
XANTENNA__2412__B net190 vssd1 vssd1 vccd1 vccd1 sky130_fd_sc_hd__diode_2
Xclkload21 clknet_leaf_16_clk vssd1 vssd1 vccd1 vccd1 clkload21/Y sky130_fd_sc_hd__clkinvlp_4
Xclkload32 clknet_leaf_22_clk vssd1 vssd1 vccd1 vccd1 clkload32/Y sky130_fd_sc_hd__inv_8
XANTENNA__1708__A2 net129 vssd1 vssd1 vccd1 vccd1 sky130_fd_sc_hd__diode_2
X_2544_ _1122_ _1134_ vssd1 vssd1 vccd1 vccd1 _1136_ sky130_fd_sc_hd__and2_1
XFILLER_5_490 vssd1 vssd1 vccd1 vccd1 sky130_fd_sc_hd__fill_1
X_2475_ _1067_ _1068_ vssd1 vssd1 vccd1 vccd1 _1069_ sky130_fd_sc_hd__xnor2_1
XANTENNA__2669__B1 _1249_ vssd1 vssd1 vccd1 vccd1 sky130_fd_sc_hd__diode_2
X_3027_ _1539_ _1547_ _1540_ vssd1 vssd1 vccd1 vccd1 _1564_ sky130_fd_sc_hd__o21a_1
XANTENNA__1644__B2 net220 vssd1 vssd1 vccd1 vccd1 sky130_fd_sc_hd__diode_2
XANTENNA__1644__A1 net216 vssd1 vssd1 vccd1 vccd1 sky130_fd_sc_hd__diode_2
XFILLER_70_139 vssd1 vssd1 vccd1 vccd1 sky130_fd_sc_hd__fill_1
XFILLER_34_27 vssd1 vssd1 vccd1 vccd1 sky130_fd_sc_hd__fill_1
XFILLER_11_206 vssd1 vssd1 vccd1 vccd1 sky130_fd_sc_hd__fill_4
Xclkload4 clknet_leaf_1_clk vssd1 vssd1 vccd1 vccd1 clkload4/Y sky130_fd_sc_hd__clkinv_4
XFILLER_3_427 vccd1 vssd1 vccd1 vssd1 sky130_ef_sc_hd__decap_40_12
XFILLER_3_449 vccd1 vssd1 vccd1 vssd1 sky130_ef_sc_hd__decap_40_12
XTAP_TAPCELL_ROW_6_221 vssd1 vccd1 sky130_fd_sc_hd__tapvpwrvgnd_1
XTAP_TAPCELL_ROW_57_654 vssd1 vccd1 sky130_fd_sc_hd__tapvpwrvgnd_1
XFILLER_74_489 vssd1 vssd1 vccd1 vccd1 sky130_fd_sc_hd__fill_2
XTAP_TAPCELL_ROW_40_510 vssd1 vccd1 sky130_fd_sc_hd__tapvpwrvgnd_1
XTAP_TAPCELL_ROW_12_278 vssd1 vccd1 sky130_fd_sc_hd__tapvpwrvgnd_1
XFILLER_10_250 vssd1 vssd1 vccd1 vccd1 sky130_fd_sc_hd__fill_2
XFILLER_10_272 vssd1 vssd1 vccd1 vccd1 sky130_fd_sc_hd__fill_1
XFILLER_6_276 vssd1 vssd1 vccd1 vccd1 sky130_fd_sc_hd__fill_4
XFILLER_40_70 vccd1 vssd1 vccd1 vssd1 sky130_ef_sc_hd__decap_40_12
XFILLER_69_217 vssd1 vssd1 vccd1 vccd1 sky130_fd_sc_hd__fill_1
XFILLER_69_206 vssd1 vssd1 vccd1 vccd1 sky130_fd_sc_hd__fill_1
X_2260_ _0886_ _0887_ vssd1 vssd1 vccd1 vccd1 _0888_ sky130_fd_sc_hd__nand2b_1
XFILLER_65_401 vssd1 vssd1 vccd1 vccd1 sky130_fd_sc_hd__fill_2
X_2191_ net669 _0840_ _0844_ vssd1 vssd1 vccd1 vccd1 _0324_ sky130_fd_sc_hd__o21a_1
XFILLER_18_383 vccd1 vssd1 vccd1 vssd1 sky130_ef_sc_hd__decap_40_12
X_1975_ net534 net33 net31 vssd1 vssd1 vccd1 vccd1 _0139_ sky130_fd_sc_hd__mux2_1
XANTENNA__2051__A1 net34 vssd1 vssd1 vccd1 vccd1 sky130_fd_sc_hd__diode_2
XFILLER_20_29 vssd1 vssd1 vccd1 vccd1 sky130_fd_sc_hd__fill_1
X_3645_ clknet_leaf_26_clk _0529_ vssd1 vssd1 vccd1 vccd1 MATMULT_INST.matmult_inst.fsm_inst.state\[1\]
+ sky130_fd_sc_hd__dfxtp_1
X_3576_ clknet_leaf_23_clk net578 _0074_ vssd1 vssd1 vccd1 vccd1 MATMULT_INST.matmult_inst.fsm_inst.rx_data\[6\]
+ sky130_fd_sc_hd__dfrtp_1
X_2527_ net188 net187 net206 net208 vssd1 vssd1 vccd1 vccd1 _1119_ sky130_fd_sc_hd__nand4_1
XFILLER_0_419 vssd1 vssd1 vccd1 vccd1 sky130_fd_sc_hd__fill_1
X_2458_ _1050_ _1051_ _1046_ vssd1 vssd1 vccd1 vccd1 _1052_ sky130_fd_sc_hd__a21oi_1
XANTENNA__2796__C net173 vssd1 vssd1 vccd1 vccd1 sky130_fd_sc_hd__diode_2
Xhold27 MATMULT_INST.matmult_inst.mem_inst.mem3\[8\] vssd1 vssd1 vccd1 vccd1 net322
+ sky130_fd_sc_hd__dlygate4sd3_1
Xhold16 _0520_ vssd1 vssd1 vccd1 vccd1 net311 sky130_fd_sc_hd__dlygate4sd3_1
Xhold38 MATMULT_INST.matmult_inst.mem_inst.matrixA3\[13\] vssd1 vssd1 vccd1 vccd1
+ net333 sky130_fd_sc_hd__dlygate4sd3_1
Xhold49 MATMULT_INST.matmult_inst.mem_inst.matrixB3\[10\] vssd1 vssd1 vccd1 vccd1
+ net344 sky130_fd_sc_hd__dlygate4sd3_1
X_2389_ _0958_ _0984_ vssd1 vssd1 vccd1 vccd1 _0985_ sky130_fd_sc_hd__xnor2_1
XFILLER_68_294 vssd1 vssd1 vccd1 vccd1 sky130_fd_sc_hd__fill_1
XFILLER_71_415 vssd1 vssd1 vccd1 vccd1 sky130_fd_sc_hd__fill_1
XFILLER_16_309 vssd1 vssd1 vccd1 vccd1 sky130_fd_sc_hd__fill_8
XFILLER_45_15 vssd1 vssd1 vccd1 vccd1 sky130_fd_sc_hd__fill_4
XFILLER_36_180 vssd1 vssd1 vccd1 vccd1 sky130_fd_sc_hd__fill_1
XTAP_TAPCELL_ROW_54_635 vssd1 vccd1 sky130_fd_sc_hd__tapvpwrvgnd_1
XFILLER_3_268 vssd1 vssd1 vccd1 vccd1 sky130_fd_sc_hd__fill_2
XFILLER_3_279 vssd1 vssd1 vccd1 vccd1 sky130_fd_sc_hd__fill_1
XFILLER_47_401 vssd1 vssd1 vccd1 vccd1 sky130_fd_sc_hd__fill_1
XFILLER_74_220 vssd1 vssd1 vccd1 vccd1 sky130_fd_sc_hd__fill_4
XFILLER_74_253 vccd1 vssd1 vccd1 vssd1 sky130_ef_sc_hd__decap_40_12
XTAP_TAPCELL_ROW_17_315 vssd1 vccd1 sky130_fd_sc_hd__tapvpwrvgnd_1
XFILLER_34_139 vssd1 vssd1 vccd1 vccd1 sky130_fd_sc_hd__fill_1
XTAP_TAPCELL_ROW_25_381 vssd1 vccd1 sky130_fd_sc_hd__tapvpwrvgnd_1
X_1760_ net146 net138 MATMULT_INST.matmult_inst.mem_inst.matrixB3\[5\] vssd1 vssd1
+ vccd1 vccd1 _0678_ sky130_fd_sc_hd__and3_1
X_1691_ net152 net144 MATMULT_INST.matmult_inst.mem_inst.matrixB3\[11\] vssd1 vssd1
+ vccd1 vccd1 _0615_ sky130_fd_sc_hd__and3_1
XANTENNA__1792__B1 net120 vssd1 vssd1 vccd1 vccd1 sky130_fd_sc_hd__diode_2
X_3430_ clknet_leaf_26_clk _0352_ vssd1 vssd1 vccd1 vccd1 MATMULT_INST.matmult_inst.alu_inst.out\[11\]
+ sky130_fd_sc_hd__dfxtp_1
X_3361_ clknet_leaf_11_clk _0283_ vssd1 vssd1 vccd1 vccd1 MATMULT_INST.matmult_inst.mem_inst.mem2\[16\]
+ sky130_fd_sc_hd__dfxtp_1
XFILLER_32_3 vccd1 vssd1 vccd1 vssd1 sky130_ef_sc_hd__decap_40_12
X_2312_ MATMULT_INST.matmult_inst.alu_inst.adder_inst.fa.b MATMULT_INST.matmult_inst.alu_inst.adder_inst.fa.a
+ _0928_ vssd1 vssd1 vccd1 vccd1 _0931_ sky130_fd_sc_hd__a21o_1
X_3292_ clknet_leaf_5_clk _0214_ vssd1 vssd1 vccd1 vccd1 MATMULT_INST.matmult_inst.mem_inst.matrixA1\[1\]
+ sky130_fd_sc_hd__dfxtp_1
X_2243_ net590 _0873_ net100 vssd1 vssd1 vccd1 vccd1 _0346_ sky130_fd_sc_hd__mux2_1
XTAP_TAPCELL_ROW_68_749 vssd1 vccd1 sky130_fd_sc_hd__tapvpwrvgnd_1
X_2174_ _0543_ _0825_ _0830_ _0536_ _0828_ vssd1 vssd1 vccd1 vccd1 _0831_ sky130_fd_sc_hd__a221o_1
XFILLER_65_242 vccd1 vssd1 vccd1 vssd1 sky130_ef_sc_hd__decap_40_12
XFILLER_18_180 vssd1 vssd1 vccd1 vccd1 sky130_fd_sc_hd__fill_4
XTAP_TAPCELL_ROW_51_605 vssd1 vccd1 sky130_fd_sc_hd__tapvpwrvgnd_1
X_1958_ MATMULT_INST.matmult_inst.fsm_inst.alu_result\[8\] net69 vssd1 vssd1 vccd1
+ vccd1 _0805_ sky130_fd_sc_hd__and2_1
XANTENNA_fanout224_A net228 vssd1 vssd1 vccd1 vccd1 sky130_fd_sc_hd__diode_2
X_1889_ net135 _0539_ vssd1 vssd1 vccd1 vccd1 _0767_ sky130_fd_sc_hd__or2_4
X_3628_ clknet_leaf_24_clk net335 vssd1 vssd1 vccd1 vccd1 MATMULT_INST.matmult_inst.fsm_inst.alu_result\[4\]
+ sky130_fd_sc_hd__dfxtp_1
X_3559_ clknet_leaf_8_clk _0471_ vssd1 vssd1 vccd1 vccd1 MATMULT_INST.matmult_inst.mem_inst.matrixB3\[7\]
+ sky130_fd_sc_hd__dfxtp_1
XFILLER_0_249 vssd1 vssd1 vccd1 vccd1 sky130_fd_sc_hd__fill_2
XFILLER_24_150 vssd1 vssd1 vccd1 vccd1 sky130_fd_sc_hd__fill_8
XANTENNA__2015__A1 net107 vssd1 vssd1 vccd1 vccd1 sky130_fd_sc_hd__diode_2
XTAP_TAPCELL_ROW_22_362 vssd1 vccd1 sky130_fd_sc_hd__tapvpwrvgnd_1
XFILLER_21_83 vccd1 vssd1 vccd1 vssd1 sky130_ef_sc_hd__decap_40_12
XANTENNA__2002__S net26 vssd1 vssd1 vccd1 vccd1 sky130_fd_sc_hd__diode_2
XANTENNA_clkload2_A clknet_2_3__leaf_clk vssd1 vssd1 vccd1 vccd1 sky130_fd_sc_hd__diode_2
XTAP_TAPCELL_ROW_73_796 vssd1 vccd1 sky130_fd_sc_hd__tapvpwrvgnd_1
X_2930_ _1417_ _1433_ _1416_ vssd1 vssd1 vccd1 vccd1 _1471_ sky130_fd_sc_hd__o21ba_1
XFILLER_15_161 vssd1 vssd1 vccd1 vccd1 sky130_fd_sc_hd__fill_4
XFILLER_43_470 vssd1 vssd1 vccd1 vccd1 sky130_fd_sc_hd__fill_4
XFILLER_15_183 vssd1 vssd1 vccd1 vccd1 sky130_fd_sc_hd__fill_4
X_2861_ _1402_ _1403_ vssd1 vssd1 vccd1 vccd1 _1404_ sky130_fd_sc_hd__nand2b_1
X_2792_ _1331_ _1335_ vssd1 vssd1 vccd1 vccd1 _1336_ sky130_fd_sc_hd__and2_1
XFILLER_7_30 vccd1 vssd1 vccd1 vssd1 sky130_ef_sc_hd__decap_40_12
X_1812_ net147 net139 MATMULT_INST.matmult_inst.mem_inst.matrixA3\[0\] vssd1 vssd1
+ vccd1 vccd1 _0725_ sky130_fd_sc_hd__and3_1
X_1743_ net146 net138 MATMULT_INST.matmult_inst.mem_inst.matrixA3\[6\] vssd1 vssd1
+ vccd1 vccd1 _0662_ sky130_fd_sc_hd__and3_1
X_1674_ net222 _0557_ _0599_ net112 MATMULT_INST.matmult_inst.mem_inst.matrixA0\[13\]
+ vssd1 vssd1 vccd1 vccd1 _0600_ sky130_fd_sc_hd__a32o_1
XFILLER_7_382 vssd1 vssd1 vccd1 vccd1 sky130_fd_sc_hd__fill_2
Xhold305 MATMULT_INST.matmult_inst.alu_inst.out\[0\] vssd1 vssd1 vccd1 vccd1 net600
+ sky130_fd_sc_hd__dlygate4sd3_1
Xhold316 MATMULT_INST.matmult_inst.spi_inst.mosi_data_sync\[7\] vssd1 vssd1 vccd1
+ vccd1 net611 sky130_fd_sc_hd__dlygate4sd3_1
Xhold349 MATMULT_INST.matmult_inst.spi_inst.tx_reg_sys\[15\] vssd1 vssd1 vccd1 vccd1
+ net644 sky130_fd_sc_hd__dlygate4sd3_1
X_3413_ clknet_leaf_0_clk _0335_ vssd1 vssd1 vccd1 vccd1 MATMULT_INST.matmult_inst.alu_inst.a0_reg\[2\]
+ sky130_fd_sc_hd__dfxtp_1
Xhold327 MATMULT_INST.matmult_inst.alu_inst.out\[17\] vssd1 vssd1 vccd1 vccd1 net622
+ sky130_fd_sc_hd__dlygate4sd3_1
Xhold338 MATMULT_INST.matmult_inst.spi_inst.tx_reg_sys\[1\] vssd1 vssd1 vccd1 vccd1
+ net633 sky130_fd_sc_hd__dlygate4sd3_1
X_3344_ clknet_leaf_12_clk _0266_ vssd1 vssd1 vccd1 vccd1 MATMULT_INST.matmult_inst.mem_inst.mem3\[17\]
+ sky130_fd_sc_hd__dfxtp_1
X_3275_ clknet_leaf_15_clk _0197_ vssd1 vssd1 vccd1 vccd1 MATMULT_INST.matmult_inst.mem_inst.matrixA2\[2\]
+ sky130_fd_sc_hd__dfxtp_1
X_2226_ _0857_ _0858_ vssd1 vssd1 vccd1 vccd1 _0859_ sky130_fd_sc_hd__nand2b_1
XFILLER_38_220 vssd1 vssd1 vccd1 vccd1 sky130_fd_sc_hd__fill_2
XFILLER_38_253 vssd1 vssd1 vccd1 vccd1 sky130_fd_sc_hd__fill_1
X_2157_ net42 net599 net10 vssd1 vssd1 vccd1 vccd1 _0310_ sky130_fd_sc_hd__mux2_1
X_2088_ net494 _0811_ net19 vssd1 vssd1 vccd1 vccd1 _0245_ sky130_fd_sc_hd__mux2_1
XFILLER_13_109 vssd1 vssd1 vccd1 vccd1 sky130_fd_sc_hd__fill_2
XTAP_TAPCELL_ROW_36_476 vssd1 vccd1 sky130_fd_sc_hd__tapvpwrvgnd_1
XFILLER_41_429 vssd1 vssd1 vccd1 vccd1 sky130_fd_sc_hd__fill_1
XFILLER_42_27 vssd1 vssd1 vccd1 vccd1 sky130_fd_sc_hd__fill_1
XFILLER_21_164 vssd1 vssd1 vccd1 vccd1 sky130_fd_sc_hd__fill_4
XFILLER_5_308 vssd1 vssd1 vccd1 vccd1 sky130_fd_sc_hd__fill_4
XPHY_EDGE_ROW_39_Left_119 vssd1 vssd1 vccd1 vccd1 sky130_fd_sc_hd__decap_3
XANTENNA__1756__B1 net108 vssd1 vssd1 vccd1 vccd1 sky130_fd_sc_hd__diode_2
XANTENNA_fanout87_A _0735_ vssd1 vssd1 vccd1 vccd1 sky130_fd_sc_hd__diode_2
XFILLER_76_348 vssd1 vssd1 vccd1 vccd1 sky130_fd_sc_hd__fill_1
XFILLER_76_337 vssd1 vssd1 vccd1 vccd1 sky130_fd_sc_hd__fill_2
XPHY_EDGE_ROW_48_Left_128 vssd1 vssd1 vccd1 vccd1 sky130_fd_sc_hd__decap_3
XANTENNA__3161__B net87 vssd1 vssd1 vccd1 vccd1 sky130_fd_sc_hd__diode_2
XFILLER_17_437 vssd1 vssd1 vccd1 vccd1 sky130_fd_sc_hd__fill_1
XFILLER_29_275 vssd1 vssd1 vccd1 vccd1 sky130_fd_sc_hd__fill_2
XFILLER_44_278 vssd1 vssd1 vccd1 vccd1 sky130_fd_sc_hd__fill_1
XFILLER_44_289 vssd1 vssd1 vccd1 vccd1 sky130_fd_sc_hd__fill_2
XTAP_TAPCELL_ROW_70_766 vssd1 vccd1 sky130_fd_sc_hd__tapvpwrvgnd_1
XFILLER_12_153 vccd1 vssd1 vccd1 vssd1 sky130_ef_sc_hd__decap_40_12
XFILLER_40_440 vssd1 vssd1 vccd1 vccd1 sky130_fd_sc_hd__fill_4
XFILLER_8_113 vssd1 vssd1 vccd1 vccd1 sky130_fd_sc_hd__fill_1
XFILLER_12_197 vssd1 vssd1 vccd1 vccd1 sky130_fd_sc_hd__fill_4
XPHY_EDGE_ROW_57_Left_137 vssd1 vssd1 vccd1 vccd1 sky130_fd_sc_hd__decap_3
XFILLER_4_363 vssd1 vssd1 vccd1 vccd1 sky130_fd_sc_hd__fill_1
XFILLER_79_153 vssd1 vssd1 vccd1 vccd1 sky130_fd_sc_hd__fill_2
XFILLER_79_197 vssd1 vssd1 vccd1 vccd1 sky130_fd_sc_hd__fill_8
XTAP_TAPCELL_ROW_78_833 vssd1 vccd1 sky130_fd_sc_hd__tapvpwrvgnd_1
X_3060_ net363 net34 net9 vssd1 vssd1 vccd1 vccd1 _0479_ sky130_fd_sc_hd__mux2_1
XFILLER_67_337 vssd1 vssd1 vccd1 vccd1 sky130_fd_sc_hd__fill_4
XPHY_EDGE_ROW_66_Left_146 vssd1 vssd1 vccd1 vccd1 sky130_fd_sc_hd__decap_3
X_2011_ net107 net36 net26 net605 vssd1 vssd1 vccd1 vccd1 _0172_ sky130_fd_sc_hd__a22o_1
XFILLER_23_429 vccd1 vssd1 vccd1 vssd1 sky130_ef_sc_hd__decap_40_12
XPHY_EDGE_ROW_75_Left_155 vssd1 vssd1 vccd1 vccd1 sky130_fd_sc_hd__decap_3
X_2913_ net171 net165 net162 net172 vssd1 vssd1 vccd1 vccd1 _1454_ sky130_fd_sc_hd__a22o_1
X_2844_ _1384_ _1385_ _1386_ vssd1 vssd1 vccd1 vccd1 _1387_ sky130_fd_sc_hd__or3_1
X_2775_ _1294_ _1319_ vssd1 vssd1 vccd1 vccd1 _1320_ sky130_fd_sc_hd__xnor2_1
X_1726_ MATMULT_INST.matmult_inst.mem_inst.mem1\[8\] net129 net121 MATMULT_INST.matmult_inst.mem_inst.mem2\[8\]
+ _0646_ vssd1 vssd1 vccd1 vccd1 _0647_ sky130_fd_sc_hd__a221o_1
Xhold102 MATMULT_INST.matmult_inst.mem_inst.matrixA1\[10\] vssd1 vssd1 vccd1 vccd1
+ net397 sky130_fd_sc_hd__dlygate4sd3_1
XFILLER_7_190 vssd1 vssd1 vccd1 vccd1 sky130_fd_sc_hd__fill_4
Xhold124 MATMULT_INST.matmult_inst.alu_inst.out\[1\] vssd1 vssd1 vccd1 vccd1 net419
+ sky130_fd_sc_hd__dlygate4sd3_1
Xhold113 MATMULT_INST.matmult_inst.mem_inst.matrixB2\[1\] vssd1 vssd1 vccd1 vccd1
+ net408 sky130_fd_sc_hd__dlygate4sd3_1
Xhold135 MATMULT_INST.matmult_inst.mem_inst.matrixA1\[9\] vssd1 vssd1 vccd1 vccd1
+ net430 sky130_fd_sc_hd__dlygate4sd3_1
X_1657_ net151 net142 MATMULT_INST.matmult_inst.mem_inst.matrixA3\[14\] vssd1 vssd1
+ vccd1 vccd1 _0584_ sky130_fd_sc_hd__and3_1
Xhold157 MATMULT_INST.matmult_inst.mem_inst.mem1\[17\] vssd1 vssd1 vccd1 vccd1 net452
+ sky130_fd_sc_hd__dlygate4sd3_1
Xhold146 MATMULT_INST.matmult_inst.mem_inst.matrixB1\[10\] vssd1 vssd1 vccd1 vccd1
+ net441 sky130_fd_sc_hd__dlygate4sd3_1
Xhold168 MATMULT_INST.matmult_inst.alu_inst.out\[9\] vssd1 vssd1 vccd1 vccd1 net463
+ sky130_fd_sc_hd__dlygate4sd3_1
Xhold179 MATMULT_INST.matmult_inst.alu_inst.out\[11\] vssd1 vssd1 vccd1 vccd1 net474
+ sky130_fd_sc_hd__dlygate4sd3_1
XANTENNA__2163__B1 net10 vssd1 vssd1 vccd1 vccd1 sky130_fd_sc_hd__diode_2
X_3327_ clknet_leaf_7_clk _0249_ vssd1 vssd1 vccd1 vccd1 MATMULT_INST.matmult_inst.mem_inst.mem3\[0\]
+ sky130_fd_sc_hd__dfxtp_1
X_3258_ clknet_leaf_5_clk _0180_ vssd1 vssd1 vccd1 vccd1 MATMULT_INST.matmult_inst.mem_inst.matrixA3\[3\]
+ sky130_fd_sc_hd__dfxtp_1
X_2209_ MATMULT_INST.matmult_inst.alu_inst.adder_inst.r0.fa0.b MATMULT_INST.matmult_inst.alu_inst.adder_inst.r0.fa0.a
+ vssd1 vssd1 vccd1 vccd1 _0845_ sky130_fd_sc_hd__nand2_1
X_3189_ net56 net85 net75 vssd1 vssd1 vccd1 vccd1 _0114_ sky130_fd_sc_hd__and3_1
XTAP_TAPCELL_ROW_49_590 vssd1 vccd1 sky130_fd_sc_hd__tapvpwrvgnd_1
XANTENNA__3156__B net86 vssd1 vssd1 vccd1 vccd1 sky130_fd_sc_hd__diode_2
XANTENNA__2154__A0 _0801_ vssd1 vssd1 vccd1 vccd1 sky130_fd_sc_hd__diode_2
XFILLER_49_337 vssd1 vssd1 vccd1 vccd1 sky130_fd_sc_hd__fill_1
XFILLER_17_223 vssd1 vssd1 vccd1 vccd1 sky130_fd_sc_hd__fill_1
XFILLER_17_267 vssd1 vssd1 vccd1 vccd1 sky130_fd_sc_hd__fill_2
Xclkbuf_2_0__f_clk clknet_0_clk vssd1 vssd1 vccd1 vccd1 clknet_2_0__leaf_clk sky130_fd_sc_hd__clkbuf_16
XFILLER_72_384 vssd1 vssd1 vccd1 vccd1 sky130_fd_sc_hd__fill_1
XFILLER_17_289 vccd1 vssd1 vccd1 vssd1 sky130_ef_sc_hd__decap_40_12
XFILLER_32_259 vssd1 vssd1 vccd1 vccd1 sky130_fd_sc_hd__fill_2
XFILLER_13_484 vssd1 vssd1 vccd1 vccd1 sky130_fd_sc_hd__fill_4
XTAP_TAPCELL_ROW_30_427 vssd1 vccd1 sky130_fd_sc_hd__tapvpwrvgnd_1
XFILLER_9_488 vssd1 vssd1 vccd1 vccd1 sky130_fd_sc_hd__fill_2
X_2560_ _1112_ _1121_ _1114_ vssd1 vssd1 vccd1 vccd1 _1151_ sky130_fd_sc_hd__a21o_1
X_2491_ net201 net204 net193 net191 vssd1 vssd1 vccd1 vccd1 _1084_ sky130_fd_sc_hd__nand4_1
XFILLER_57_5 vssd1 vssd1 vccd1 vccd1 sky130_fd_sc_hd__fill_1
XFILLER_4_97 vccd1 vssd1 vccd1 vssd1 sky130_ef_sc_hd__decap_40_12
XFILLER_67_167 vssd1 vssd1 vccd1 vccd1 sky130_fd_sc_hd__fill_1
X_3112_ net56 net85 net75 vssd1 vssd1 vccd1 vccd1 _0037_ sky130_fd_sc_hd__and3_1
X_3043_ net663 net115 vssd1 vssd1 vccd1 vccd1 _0442_ sky130_fd_sc_hd__and2_1
XFILLER_55_329 vssd1 vssd1 vccd1 vccd1 sky130_fd_sc_hd__fill_4
XTAP_TAPCELL_ROW_46_560 vssd1 vccd1 sky130_fd_sc_hd__tapvpwrvgnd_1
XFILLER_23_259 vccd1 vssd1 vccd1 vssd1 sky130_ef_sc_hd__decap_40_12
XFILLER_31_281 vssd1 vssd1 vccd1 vccd1 sky130_fd_sc_hd__fill_4
X_2827_ net169 net171 net173 net166 vssd1 vssd1 vccd1 vccd1 _1370_ sky130_fd_sc_hd__a22o_1
X_2758_ _1300_ _1303_ vssd1 vssd1 vccd1 vccd1 _1304_ sky130_fd_sc_hd__xnor2_1
X_1709_ net217 _0626_ _0631_ net220 _0629_ vssd1 vssd1 vccd1 vccd1 _0632_ sky130_fd_sc_hd__a221o_1
XFILLER_2_108 vssd1 vssd1 vccd1 vccd1 sky130_fd_sc_hd__fill_1
X_2689_ net93 _1247_ _1255_ net493 vssd1 vssd1 vccd1 vccd1 _0409_ sky130_fd_sc_hd__a22o_1
XANTENNA__2687__A1 net93 vssd1 vssd1 vccd1 vccd1 sky130_fd_sc_hd__diode_2
XANTENNA__2100__S net16 vssd1 vssd1 vccd1 vccd1 sky130_fd_sc_hd__diode_2
XFILLER_46_329 vssd1 vssd1 vccd1 vccd1 sky130_fd_sc_hd__fill_1
XANTENNA__1647__C1 _0545_ vssd1 vssd1 vccd1 vccd1 sky130_fd_sc_hd__diode_2
XFILLER_14_226 vccd1 vssd1 vccd1 vssd1 sky130_ef_sc_hd__decap_40_12
XFILLER_54_395 vssd1 vssd1 vccd1 vccd1 sky130_fd_sc_hd__fill_1
Xfanout30 _0796_ vssd1 vssd1 vccd1 vccd1 net30 sky130_fd_sc_hd__buf_4
Xfanout41 _0805_ vssd1 vssd1 vccd1 vccd1 net41 sky130_fd_sc_hd__buf_2
Xfanout52 _0789_ vssd1 vssd1 vccd1 vccd1 net52 sky130_fd_sc_hd__buf_2
Xfanout74 _0739_ vssd1 vssd1 vccd1 vccd1 net74 sky130_fd_sc_hd__buf_2
Xfanout63 MATMULT_INST.matmult_inst.fsm_inst.load vssd1 vssd1 vccd1 vccd1 net63 sky130_fd_sc_hd__clkbuf_4
XFILLER_10_421 vssd1 vssd1 vccd1 vccd1 sky130_fd_sc_hd__fill_4
XFILLER_22_281 vssd1 vssd1 vccd1 vccd1 sky130_fd_sc_hd__fill_1
Xfanout96 net98 vssd1 vssd1 vccd1 vccd1 net96 sky130_fd_sc_hd__buf_2
Xfanout85 net86 vssd1 vssd1 vccd1 vccd1 net85 sky130_fd_sc_hd__clkbuf_2
XANTENNA__3167__A net58 vssd1 vssd1 vccd1 vccd1 sky130_fd_sc_hd__diode_2
XFILLER_13_73 vssd1 vssd1 vccd1 vccd1 sky130_fd_sc_hd__fill_1
XFILLER_6_469 vssd1 vssd1 vccd1 vccd1 sky130_fd_sc_hd__fill_4
XTAP_TAPCELL_ROW_9_252 vssd1 vccd1 sky130_fd_sc_hd__tapvpwrvgnd_1
XANTENNA__2678__A1 net82 vssd1 vssd1 vccd1 vccd1 sky130_fd_sc_hd__diode_2
XFILLER_29_9 vssd1 vssd1 vccd1 vccd1 sky130_fd_sc_hd__fill_1
XFILLER_49_134 vssd1 vssd1 vccd1 vccd1 sky130_fd_sc_hd__fill_4
XFILLER_77_487 vssd1 vssd1 vccd1 vccd1 sky130_fd_sc_hd__fill_1
XFILLER_49_167 vssd1 vssd1 vccd1 vccd1 sky130_fd_sc_hd__fill_1
XFILLER_72_170 vssd1 vssd1 vccd1 vccd1 sky130_fd_sc_hd__fill_1
XTAP_TAPCELL_ROW_43_541 vssd1 vccd1 sky130_fd_sc_hd__tapvpwrvgnd_1
X_1991_ net434 net37 net29 vssd1 vssd1 vccd1 vccd1 _0153_ sky130_fd_sc_hd__mux2_1
XTAP_TAPCELL_ROW_15_298 vssd1 vccd1 sky130_fd_sc_hd__tapvpwrvgnd_1
X_3592_ net226 _0010_ _0090_ vssd1 vssd1 vccd1 vccd1 MATMULT_INST.matmult_inst.spi_inst.miso_shifter\[12\]
+ sky130_fd_sc_hd__dfrtp_1
XFILLER_62_3 vssd1 vssd1 vccd1 vccd1 sky130_fd_sc_hd__fill_1
XFILLER_9_296 vccd1 vssd1 vccd1 vssd1 sky130_ef_sc_hd__decap_40_12
X_2612_ _1178_ _1190_ vssd1 vssd1 vccd1 vccd1 _1201_ sky130_fd_sc_hd__nand2_1
Xclkload22 clknet_leaf_17_clk vssd1 vssd1 vccd1 vccd1 clkload22/Y sky130_fd_sc_hd__inv_8
Xclkload33 clknet_leaf_23_clk vssd1 vssd1 vccd1 vccd1 clkload33/Y sky130_fd_sc_hd__inv_6
Xclkload11 clknet_leaf_5_clk vssd1 vssd1 vccd1 vccd1 clkload11/Y sky130_fd_sc_hd__clkinv_4
X_2543_ _1122_ _1134_ vssd1 vssd1 vccd1 vccd1 _1135_ sky130_fd_sc_hd__nor2_1
X_2474_ _0995_ _0997_ _1028_ _1029_ vssd1 vssd1 vccd1 vccd1 _1068_ sky130_fd_sc_hd__o31ai_2
XFILLER_68_421 vssd1 vssd1 vccd1 vccd1 sky130_fd_sc_hd__fill_4
XANTENNA__2669__B2 net103 vssd1 vssd1 vccd1 vccd1 sky130_fd_sc_hd__diode_2
XFILLER_28_307 vssd1 vssd1 vccd1 vccd1 sky130_fd_sc_hd__fill_1
X_3026_ _1535_ _1562_ vssd1 vssd1 vccd1 vccd1 _1563_ sky130_fd_sc_hd__xnor2_1
XANTENNA__2841__B2 net176 vssd1 vssd1 vccd1 vccd1 sky130_fd_sc_hd__diode_2
XFILLER_51_332 vssd1 vssd1 vccd1 vccd1 sky130_fd_sc_hd__fill_4
Xclkload5 clknet_leaf_2_clk vssd1 vssd1 vccd1 vccd1 clkload5/Y sky130_fd_sc_hd__clkinv_8
XANTENNA__1934__S net137 vssd1 vssd1 vccd1 vccd1 sky130_fd_sc_hd__diode_2
XFILLER_3_439 vssd1 vssd1 vccd1 vccd1 sky130_fd_sc_hd__fill_8
XFILLER_59_36 vssd1 vssd1 vccd1 vccd1 sky130_fd_sc_hd__fill_1
XFILLER_78_229 vssd1 vssd1 vccd1 vccd1 sky130_fd_sc_hd__fill_1
XTAP_TAPCELL_ROW_6_222 vssd1 vccd1 sky130_fd_sc_hd__tapvpwrvgnd_1
Xfanout220 net221 vssd1 vssd1 vccd1 vccd1 net220 sky130_fd_sc_hd__clkbuf_4
XTAP_TAPCELL_ROW_57_655 vssd1 vccd1 sky130_fd_sc_hd__tapvpwrvgnd_1
XANTENNA__1635__A2 net64 vssd1 vssd1 vccd1 vccd1 sky130_fd_sc_hd__diode_2
XTAP_TAPCELL_ROW_40_511 vssd1 vccd1 sky130_fd_sc_hd__tapvpwrvgnd_1
XFILLER_42_365 vssd1 vssd1 vccd1 vccd1 sky130_fd_sc_hd__fill_1
XFILLER_24_83 vssd1 vssd1 vccd1 vccd1 sky130_fd_sc_hd__fill_1
XFILLER_10_284 vssd1 vssd1 vccd1 vccd1 sky130_fd_sc_hd__fill_4
XFILLER_6_244 vssd1 vssd1 vccd1 vccd1 sky130_fd_sc_hd__fill_8
XANTENNA__2005__S net26 vssd1 vssd1 vccd1 vccd1 sky130_fd_sc_hd__diode_2
XFILLER_40_82 vssd1 vssd1 vccd1 vccd1 sky130_fd_sc_hd__fill_2
X_2190_ _1594_ _0533_ _0839_ _0843_ _0832_ vssd1 vssd1 vccd1 vccd1 _0844_ sky130_fd_sc_hd__o32a_1
XFILLER_1_21 vccd1 vssd1 vccd1 vssd1 sky130_ef_sc_hd__decap_40_12
XFILLER_65_446 vssd1 vssd1 vccd1 vccd1 sky130_fd_sc_hd__fill_2
XFILLER_1_54 vssd1 vssd1 vccd1 vccd1 sky130_fd_sc_hd__fill_2
XFILLER_1_43 vssd1 vssd1 vccd1 vccd1 sky130_fd_sc_hd__fill_1
XFILLER_37_126 vssd1 vssd1 vccd1 vccd1 sky130_fd_sc_hd__fill_2
XFILLER_1_76 vssd1 vssd1 vccd1 vccd1 sky130_fd_sc_hd__fill_1
XFILLER_18_395 vssd1 vssd1 vccd1 vccd1 sky130_fd_sc_hd__fill_4
X_1974_ MATMULT_INST.matmult_inst.fsm_inst.alu_result\[16\] net69 vssd1 vssd1 vccd1
+ vccd1 _0813_ sky130_fd_sc_hd__and2_2
X_3644_ clknet_leaf_33_clk _0528_ vssd1 vssd1 vccd1 vccd1 MATMULT_INST.matmult_inst.fsm_inst.state\[2\]
+ sky130_fd_sc_hd__dfxtp_1
X_3575_ clknet_leaf_24_clk net400 _0073_ vssd1 vssd1 vccd1 vccd1 MATMULT_INST.matmult_inst.fsm_inst.rx_data\[5\]
+ sky130_fd_sc_hd__dfrtp_1
X_2526_ net187 net206 vssd1 vssd1 vccd1 vccd1 _1118_ sky130_fd_sc_hd__and2_1
X_2457_ _1047_ _1048_ _1049_ vssd1 vssd1 vccd1 vccd1 _1051_ sky130_fd_sc_hd__o21ai_1
Xhold28 MATMULT_INST.matmult_inst.mem_inst.mem3\[11\] vssd1 vssd1 vccd1 vccd1 net323
+ sky130_fd_sc_hd__dlygate4sd3_1
XFILLER_29_28 vssd1 vssd1 vccd1 vccd1 sky130_fd_sc_hd__fill_1
Xhold17 MATMULT_INST.matmult_inst.fsm_inst.alu_result\[14\] vssd1 vssd1 vccd1 vccd1
+ net312 sky130_fd_sc_hd__dlygate4sd3_1
X_2388_ _0982_ _0983_ vssd1 vssd1 vccd1 vccd1 _0984_ sky130_fd_sc_hd__xnor2_1
Xhold39 MATMULT_INST.matmult_inst.alu_inst.out\[4\] vssd1 vssd1 vccd1 vccd1 net334
+ sky130_fd_sc_hd__dlygate4sd3_1
XFILLER_71_438 vssd1 vssd1 vccd1 vccd1 sky130_fd_sc_hd__fill_4
X_3009_ _1513_ _1546_ vssd1 vssd1 vccd1 vccd1 _1547_ sky130_fd_sc_hd__xnor2_1
XFILLER_51_151 vssd1 vssd1 vccd1 vccd1 sky130_fd_sc_hd__fill_4
XFILLER_10_85 vssd1 vssd1 vccd1 vccd1 sky130_fd_sc_hd__fill_4
XFILLER_59_262 vssd1 vssd1 vccd1 vccd1 sky130_fd_sc_hd__fill_1
XFILLER_19_61 vccd1 vssd1 vccd1 vssd1 sky130_ef_sc_hd__decap_40_12
XFILLER_74_265 vssd1 vssd1 vccd1 vccd1 sky130_fd_sc_hd__fill_1
XANTENNA__3058__A1 _0810_ vssd1 vssd1 vccd1 vccd1 sky130_fd_sc_hd__diode_2
XFILLER_62_427 vssd1 vssd1 vccd1 vccd1 sky130_fd_sc_hd__fill_4
XTAP_TAPCELL_ROW_17_316 vssd1 vccd1 sky130_fd_sc_hd__tapvpwrvgnd_1
XANTENNA__2805__A1 net176 vssd1 vssd1 vccd1 vccd1 sky130_fd_sc_hd__diode_2
XANTENNA__2805__B2 net178 vssd1 vssd1 vccd1 vccd1 sky130_fd_sc_hd__diode_2
XFILLER_27_181 vccd1 vssd1 vccd1 vssd1 sky130_ef_sc_hd__decap_40_12
XFILLER_70_460 vccd1 vssd1 vccd1 vssd1 sky130_ef_sc_hd__decap_40_12
XFILLER_35_82 vssd1 vssd1 vccd1 vccd1 sky130_fd_sc_hd__fill_4
XTAP_TAPCELL_ROW_25_382 vssd1 vccd1 sky130_fd_sc_hd__tapvpwrvgnd_1
XFILLER_30_335 vssd1 vssd1 vccd1 vccd1 sky130_fd_sc_hd__fill_1
XFILLER_42_195 vssd1 vssd1 vccd1 vccd1 sky130_fd_sc_hd__fill_1
X_1690_ MATMULT_INST.matmult_inst.mem_inst.mem1\[11\] net130 net122 MATMULT_INST.matmult_inst.mem_inst.mem2\[11\]
+ _0613_ vssd1 vssd1 vccd1 vccd1 _0614_ sky130_fd_sc_hd__a221o_1
X_3360_ clknet_leaf_9_clk _0282_ vssd1 vssd1 vccd1 vccd1 MATMULT_INST.matmult_inst.mem_inst.mem2\[15\]
+ sky130_fd_sc_hd__dfxtp_1
X_2311_ net626 _0792_ _0929_ _0930_ vssd1 vssd1 vccd1 vccd1 _0357_ sky130_fd_sc_hd__a22o_1
X_3291_ clknet_leaf_7_clk _0213_ vssd1 vssd1 vccd1 vccd1 MATMULT_INST.matmult_inst.mem_inst.matrixA1\[0\]
+ sky130_fd_sc_hd__dfxtp_1
XFILLER_25_3 vccd1 vssd1 vccd1 vssd1 sky130_ef_sc_hd__decap_40_12
X_2242_ _0871_ _0872_ vssd1 vssd1 vccd1 vccd1 _0873_ sky130_fd_sc_hd__xnor2_1
XANTENNA__1603__A net3 vssd1 vssd1 vccd1 vccd1 sky130_fd_sc_hd__diode_2
X_2173_ _0829_ vssd1 vssd1 vccd1 vccd1 _0830_ sky130_fd_sc_hd__inv_2
XFILLER_65_254 vssd1 vssd1 vccd1 vccd1 sky130_fd_sc_hd__fill_2
XTAP_TAPCELL_ROW_51_606 vssd1 vccd1 sky130_fd_sc_hd__tapvpwrvgnd_1
XFILLER_61_493 vssd1 vssd1 vccd1 vccd1 sky130_fd_sc_hd__fill_1
XFILLER_31_29 vssd1 vssd1 vccd1 vccd1 sky130_fd_sc_hd__fill_1
X_1957_ net510 net42 net30 vssd1 vssd1 vccd1 vccd1 _0130_ sky130_fd_sc_hd__mux2_1
X_1888_ net135 _0539_ vssd1 vssd1 vccd1 vccd1 _0766_ sky130_fd_sc_hd__nor2_1
XANTENNA_fanout217_A net218 vssd1 vssd1 vccd1 vccd1 sky130_fd_sc_hd__diode_2
XANTENNA__1783__B2 net223 vssd1 vssd1 vccd1 vccd1 sky130_fd_sc_hd__diode_2
X_3627_ clknet_leaf_24_clk net362 vssd1 vssd1 vccd1 vccd1 MATMULT_INST.matmult_inst.fsm_inst.alu_result\[3\]
+ sky130_fd_sc_hd__dfxtp_1
X_3558_ clknet_leaf_1_clk _0470_ vssd1 vssd1 vccd1 vccd1 MATMULT_INST.matmult_inst.mem_inst.matrixB3\[6\]
+ sky130_fd_sc_hd__dfxtp_1
X_2509_ _1100_ _1101_ vssd1 vssd1 vccd1 vccd1 _1102_ sky130_fd_sc_hd__or2_1
XANTENNA__2732__B1 net97 vssd1 vssd1 vccd1 vccd1 sky130_fd_sc_hd__diode_2
X_3489_ clknet_leaf_27_clk _0408_ vssd1 vssd1 vccd1 vccd1 MATMULT_INST.matmult_inst.alu_inst.row1\[0\]
+ sky130_fd_sc_hd__dfxtp_1
Xclkbuf_leaf_36_clk clknet_2_0__leaf_clk vssd1 vssd1 vccd1 vccd1 clknet_leaf_36_clk
+ sky130_fd_sc_hd__clkbuf_8
XFILLER_71_279 vssd1 vssd1 vccd1 vccd1 sky130_fd_sc_hd__fill_1
XANTENNA_fanout32_A _0814_ vssd1 vssd1 vccd1 vccd1 sky130_fd_sc_hd__diode_2
XFILLER_24_195 vssd1 vssd1 vccd1 vccd1 sky130_fd_sc_hd__fill_1
XFILLER_52_482 vccd1 vssd1 vccd1 vssd1 sky130_ef_sc_hd__decap_40_12
XFILLER_8_317 vssd1 vssd1 vccd1 vccd1 sky130_fd_sc_hd__fill_1
XFILLER_8_306 vssd1 vssd1 vccd1 vccd1 sky130_fd_sc_hd__fill_2
XANTENNA__3159__B net87 vssd1 vssd1 vccd1 vccd1 sky130_fd_sc_hd__diode_2
XFILLER_8_339 vssd1 vssd1 vccd1 vccd1 sky130_fd_sc_hd__fill_1
XTAP_TAPCELL_ROW_22_363 vssd1 vccd1 sky130_fd_sc_hd__tapvpwrvgnd_1
XFILLER_21_95 vssd1 vssd1 vccd1 vccd1 sky130_fd_sc_hd__fill_1
XFILLER_79_335 vssd1 vssd1 vccd1 vccd1 sky130_fd_sc_hd__fill_1
XFILLER_79_379 vssd1 vssd1 vccd1 vccd1 sky130_fd_sc_hd__fill_4
XANTENNA__2238__B MATMULT_INST.matmult_inst.alu_inst.adder_inst.r1.fa1.a vssd1 vssd1
+ vccd1 vccd1 sky130_fd_sc_hd__diode_2
Xclkbuf_leaf_27_clk clknet_2_2__leaf_clk vssd1 vssd1 vccd1 vccd1 clknet_leaf_27_clk
+ sky130_fd_sc_hd__clkbuf_8
X_2860_ _1400_ _1401_ _1369_ vssd1 vssd1 vccd1 vccd1 _1403_ sky130_fd_sc_hd__a21o_1
X_1811_ MATMULT_INST.matmult_inst.mem_inst.matrixB1\[0\] net124 net116 MATMULT_INST.matmult_inst.mem_inst.matrixB2\[0\]
+ _0723_ vssd1 vssd1 vccd1 vccd1 _0724_ sky130_fd_sc_hd__a221o_1
X_2791_ _1314_ _1329_ _1333_ vssd1 vssd1 vccd1 vccd1 _1335_ sky130_fd_sc_hd__o21bai_1
XFILLER_11_390 vssd1 vssd1 vccd1 vccd1 sky130_fd_sc_hd__fill_2
XFILLER_7_42 vssd1 vssd1 vccd1 vccd1 sky130_fd_sc_hd__fill_4
X_1742_ net623 _0661_ net63 vssd1 vssd1 vccd1 vccd1 _0497_ sky130_fd_sc_hd__mux2_1
X_1673_ MATMULT_INST.matmult_inst.mem_inst.matrixA1\[13\] net126 net118 MATMULT_INST.matmult_inst.mem_inst.matrixA2\[13\]
+ _0598_ vssd1 vssd1 vccd1 vccd1 _0599_ sky130_fd_sc_hd__a221o_1
XFILLER_7_97 vssd1 vssd1 vccd1 vccd1 sky130_fd_sc_hd__fill_1
Xhold306 _0508_ vssd1 vssd1 vccd1 vccd1 net601 sky130_fd_sc_hd__dlygate4sd3_1
Xhold317 _0489_ vssd1 vssd1 vccd1 vccd1 net612 sky130_fd_sc_hd__dlygate4sd3_1
Xhold339 MATMULT_INST.matmult_inst.alu_inst.adder_inst.r2.fa0.b vssd1 vssd1 vccd1
+ vccd1 net634 sky130_fd_sc_hd__dlygate4sd3_1
X_3412_ clknet_leaf_2_clk _0334_ vssd1 vssd1 vccd1 vccd1 MATMULT_INST.matmult_inst.alu_inst.a0_reg\[1\]
+ sky130_fd_sc_hd__dfxtp_1
Xhold328 MATMULT_INST.matmult_inst.spi_inst.tx_reg_sys\[7\] vssd1 vssd1 vccd1 vccd1
+ net623 sky130_fd_sc_hd__dlygate4sd3_1
XANTENNA__2714__A0 net148 vssd1 vssd1 vccd1 vccd1 sky130_fd_sc_hd__diode_2
X_3343_ clknet_leaf_11_clk _0265_ vssd1 vssd1 vccd1 vccd1 MATMULT_INST.matmult_inst.mem_inst.mem3\[16\]
+ sky130_fd_sc_hd__dfxtp_1
X_3274_ clknet_leaf_5_clk _0196_ vssd1 vssd1 vccd1 vccd1 MATMULT_INST.matmult_inst.mem_inst.matrixA2\[1\]
+ sky130_fd_sc_hd__dfxtp_1
X_2225_ MATMULT_INST.matmult_inst.alu_inst.adder_inst.r0.fa3.b MATMULT_INST.matmult_inst.alu_inst.adder_inst.r0.fa3.a
+ vssd1 vssd1 vccd1 vccd1 _0858_ sky130_fd_sc_hd__nand2_1
XTAP_TAPCELL_ROW_64_720 vssd1 vccd1 sky130_fd_sc_hd__tapvpwrvgnd_1
X_2156_ net43 net575 net10 vssd1 vssd1 vccd1 vccd1 _0309_ sky130_fd_sc_hd__mux2_1
XANTENNA__2863__S net97 vssd1 vssd1 vccd1 vccd1 sky130_fd_sc_hd__diode_2
XPHY_EDGE_ROW_5_Right_5 vssd1 vssd1 vccd1 vccd1 sky130_fd_sc_hd__decap_3
Xclkbuf_leaf_18_clk clknet_2_3__leaf_clk vssd1 vssd1 vccd1 vccd1 clknet_leaf_18_clk
+ sky130_fd_sc_hd__clkbuf_8
X_2087_ net414 net36 net18 vssd1 vssd1 vccd1 vccd1 _0244_ sky130_fd_sc_hd__mux2_1
XTAP_TAPCELL_ROW_36_477 vssd1 vccd1 sky130_fd_sc_hd__tapvpwrvgnd_1
X_2989_ _1482_ _1500_ vssd1 vssd1 vccd1 vccd1 _1528_ sky130_fd_sc_hd__nand2b_1
XANTENNA__2103__S net16 vssd1 vssd1 vccd1 vccd1 sky130_fd_sc_hd__diode_2
XANTENNA__3161__C _0739_ vssd1 vssd1 vccd1 vccd1 sky130_fd_sc_hd__diode_2
XFILLER_17_405 vccd1 vssd1 vccd1 vssd1 sky130_ef_sc_hd__decap_40_12
XTAP_TAPCELL_ROW_27_400 vssd1 vccd1 sky130_fd_sc_hd__tapvpwrvgnd_1
XANTENNA_fanout35_X net35 vssd1 vssd1 vccd1 vccd1 sky130_fd_sc_hd__diode_2
XFILLER_32_419 vssd1 vssd1 vccd1 vccd1 sky130_fd_sc_hd__fill_1
XFILLER_25_471 vssd1 vssd1 vccd1 vccd1 sky130_fd_sc_hd__fill_2
XFILLER_25_493 vssd1 vssd1 vccd1 vccd1 sky130_fd_sc_hd__fill_1
XTAP_TAPCELL_ROW_70_767 vssd1 vccd1 sky130_fd_sc_hd__tapvpwrvgnd_1
XFILLER_12_165 vssd1 vssd1 vccd1 vccd1 sky130_fd_sc_hd__fill_8
XFILLER_32_61 vssd1 vssd1 vccd1 vccd1 sky130_fd_sc_hd__fill_1
XFILLER_32_83 vssd1 vssd1 vccd1 vccd1 sky130_fd_sc_hd__fill_1
XFILLER_79_121 vssd1 vssd1 vccd1 vccd1 sky130_fd_sc_hd__fill_1
XFILLER_79_110 vssd1 vssd1 vccd1 vccd1 sky130_fd_sc_hd__fill_2
XANTENNA__1852__S _0744_ vssd1 vssd1 vccd1 vccd1 sky130_fd_sc_hd__diode_2
XFILLER_67_316 vccd1 vssd1 vccd1 vssd1 sky130_ef_sc_hd__decap_40_12
XFILLER_67_305 vssd1 vssd1 vccd1 vccd1 sky130_fd_sc_hd__fill_2
XTAP_TAPCELL_ROW_78_834 vssd1 vccd1 sky130_fd_sc_hd__tapvpwrvgnd_1
X_2010_ net105 net37 net27 net482 vssd1 vssd1 vccd1 vccd1 _0171_ sky130_fd_sc_hd__a22o_1
XANTENNA__1683__B1 net121 vssd1 vssd1 vccd1 vccd1 sky130_fd_sc_hd__diode_2
XFILLER_35_235 vssd1 vssd1 vccd1 vccd1 sky130_fd_sc_hd__fill_4
XFILLER_35_279 vssd1 vssd1 vccd1 vccd1 sky130_fd_sc_hd__fill_1
XFILLER_16_493 vssd1 vssd1 vccd1 vccd1 sky130_fd_sc_hd__fill_1
X_2912_ _1421_ _1422_ _1420_ vssd1 vssd1 vccd1 vccd1 _1453_ sky130_fd_sc_hd__a21boi_1
X_2843_ net161 net178 vssd1 vssd1 vccd1 vccd1 _1386_ sky130_fd_sc_hd__and2_1
X_2774_ _1317_ _1318_ vssd1 vssd1 vccd1 vccd1 _1319_ sky130_fd_sc_hd__xnor2_1
X_1725_ net152 net143 MATMULT_INST.matmult_inst.mem_inst.mem3\[8\] vssd1 vssd1 vccd1
+ vccd1 _0646_ sky130_fd_sc_hd__and3_1
Xhold114 MATMULT_INST.matmult_inst.mem_inst.matrixA1\[8\] vssd1 vssd1 vccd1 vccd1
+ net409 sky130_fd_sc_hd__dlygate4sd3_1
Xhold103 MATMULT_INST.matmult_inst.alu_inst.col0\[6\] vssd1 vssd1 vccd1 vccd1 net398
+ sky130_fd_sc_hd__dlygate4sd3_1
Xhold125 _0509_ vssd1 vssd1 vccd1 vccd1 net420 sky130_fd_sc_hd__dlygate4sd3_1
Xhold147 MATMULT_INST.matmult_inst.mem_inst.mem2\[14\] vssd1 vssd1 vccd1 vccd1 net442
+ sky130_fd_sc_hd__dlygate4sd3_1
X_1656_ net644 net64 _0575_ _0583_ vssd1 vssd1 vccd1 vccd1 _0505_ sky130_fd_sc_hd__o22a_1
Xclkbuf_leaf_7_clk clknet_2_1__leaf_clk vssd1 vssd1 vccd1 vccd1 clknet_leaf_7_clk
+ sky130_fd_sc_hd__clkbuf_8
Xhold136 MATMULT_INST.matmult_inst.mem_inst.matrixA1\[7\] vssd1 vssd1 vccd1 vccd1
+ net431 sky130_fd_sc_hd__dlygate4sd3_1
Xhold158 MATMULT_INST.matmult_inst.mem_inst.mem3\[1\] vssd1 vssd1 vccd1 vccd1 net453
+ sky130_fd_sc_hd__dlygate4sd3_1
Xhold169 MATMULT_INST.matmult_inst.mem_inst.matrixA0\[2\] vssd1 vssd1 vccd1 vccd1
+ net464 sky130_fd_sc_hd__dlygate4sd3_1
X_3326_ clknet_leaf_20_clk _0248_ vssd1 vssd1 vccd1 vccd1 MATMULT_INST.matmult_inst.mem_inst.matrixA0\[17\]
+ sky130_fd_sc_hd__dfxtp_1
XANTENNA__2163__A1 net108 vssd1 vssd1 vccd1 vccd1 sky130_fd_sc_hd__diode_2
XFILLER_58_338 vssd1 vssd1 vccd1 vccd1 sky130_fd_sc_hd__fill_1
X_3257_ clknet_leaf_15_clk _0179_ vssd1 vssd1 vccd1 vccd1 MATMULT_INST.matmult_inst.mem_inst.matrixA3\[2\]
+ sky130_fd_sc_hd__dfxtp_1
X_3188_ net62 net88 net74 vssd1 vssd1 vccd1 vccd1 _0113_ sky130_fd_sc_hd__and3_1
X_2208_ net185 net537 net65 vssd1 vssd1 vccd1 vccd1 _0340_ sky130_fd_sc_hd__mux2_1
X_2139_ net487 _0805_ net13 vssd1 vssd1 vccd1 vccd1 _0293_ sky130_fd_sc_hd__mux2_1
XANTENNA__1674__B1 net112 vssd1 vssd1 vccd1 vccd1 sky130_fd_sc_hd__diode_2
XTAP_TAPCELL_ROW_49_591 vssd1 vccd1 sky130_fd_sc_hd__tapvpwrvgnd_1
XFILLER_14_408 vccd1 vssd1 vccd1 vssd1 sky130_ef_sc_hd__decap_40_12
XFILLER_41_205 vssd1 vssd1 vccd1 vccd1 sky130_fd_sc_hd__fill_1
XPHY_EDGE_ROW_14_Left_94 vssd1 vssd1 vccd1 vccd1 sky130_fd_sc_hd__decap_3
XANTENNA__1937__S net137 vssd1 vssd1 vccd1 vccd1 sky130_fd_sc_hd__diode_2
XANTENNA__3156__C net73 vssd1 vssd1 vccd1 vccd1 sky130_fd_sc_hd__diode_2
XANTENNA__2768__S net98 vssd1 vssd1 vccd1 vccd1 sky130_fd_sc_hd__diode_2
XFILLER_1_378 vssd1 vssd1 vccd1 vccd1 sky130_fd_sc_hd__fill_2
XFILLER_49_316 vccd1 vssd1 vccd1 vssd1 sky130_ef_sc_hd__decap_40_12
XFILLER_76_146 vssd1 vssd1 vccd1 vccd1 sky130_fd_sc_hd__fill_4
XFILLER_72_363 vssd1 vssd1 vccd1 vccd1 sky130_fd_sc_hd__fill_1
XFILLER_17_279 vssd1 vssd1 vccd1 vccd1 sky130_fd_sc_hd__fill_1
XTAP_TAPCELL_ROW_30_428 vssd1 vccd1 sky130_fd_sc_hd__tapvpwrvgnd_1
XANTENNA__2251__B MATMULT_INST.matmult_inst.alu_inst.adder_inst.r1.fa3.a vssd1 vssd1
+ vccd1 vccd1 sky130_fd_sc_hd__diode_2
X_2490_ net201 net193 net191 net204 vssd1 vssd1 vccd1 vccd1 _1083_ sky130_fd_sc_hd__a22o_1
XANTENNA__2145__A1 net35 vssd1 vssd1 vccd1 vccd1 sky130_fd_sc_hd__diode_2
XFILLER_67_113 vssd1 vssd1 vccd1 vccd1 sky130_fd_sc_hd__fill_2
X_3111_ net59 net89 net75 vssd1 vssd1 vccd1 vccd1 _0039_ sky130_fd_sc_hd__and3_1
X_3042_ _1573_ _1576_ net653 net94 vssd1 vssd1 vccd1 vccd1 _0441_ sky130_fd_sc_hd__o2bb2a_1
XFILLER_63_330 vssd1 vssd1 vccd1 vccd1 sky130_fd_sc_hd__fill_4
XFILLER_23_205 vssd1 vssd1 vccd1 vccd1 sky130_fd_sc_hd__fill_8
XTAP_TAPCELL_ROW_46_561 vssd1 vccd1 sky130_fd_sc_hd__tapvpwrvgnd_1
X_2826_ _1348_ _1360_ _1347_ vssd1 vssd1 vccd1 vccd1 _1369_ sky130_fd_sc_hd__a21boi_1
X_2757_ _1301_ _1302_ vssd1 vssd1 vccd1 vccd1 _1303_ sky130_fd_sc_hd__nand2b_1
X_1708_ MATMULT_INST.matmult_inst.mem_inst.matrixB1\[10\] net129 net121 MATMULT_INST.matmult_inst.mem_inst.matrixB2\[10\]
+ _0630_ vssd1 vssd1 vccd1 vccd1 _0631_ sky130_fd_sc_hd__a221o_1
X_2688_ net93 _1243_ _1255_ net569 vssd1 vssd1 vccd1 vccd1 _0408_ sky130_fd_sc_hd__a22o_1
X_1639_ MATMULT_INST.matmult_inst.mem_inst.matrixB1\[16\] net127 net119 MATMULT_INST.matmult_inst.mem_inst.matrixB2\[16\]
+ _0567_ vssd1 vssd1 vccd1 vccd1 _0568_ sky130_fd_sc_hd__a221o_1
XFILLER_48_27 vssd1 vssd1 vccd1 vccd1 sky130_fd_sc_hd__fill_1
X_3309_ clknet_leaf_5_clk _0231_ vssd1 vssd1 vccd1 vccd1 MATMULT_INST.matmult_inst.mem_inst.matrixA0\[0\]
+ sky130_fd_sc_hd__dfxtp_1
XFILLER_58_157 vssd1 vssd1 vccd1 vccd1 sky130_fd_sc_hd__fill_1
XFILLER_64_48 vccd1 vssd1 vccd1 vssd1 sky130_ef_sc_hd__decap_40_12
XFILLER_54_363 vssd1 vssd1 vccd1 vccd1 sky130_fd_sc_hd__fill_1
XFILLER_14_238 vssd1 vssd1 vccd1 vccd1 sky130_fd_sc_hd__fill_4
XFILLER_14_216 vssd1 vssd1 vccd1 vccd1 sky130_fd_sc_hd__fill_1
Xfanout31 _0796_ vssd1 vssd1 vccd1 vccd1 net31 sky130_fd_sc_hd__clkbuf_4
Xfanout20 net21 vssd1 vssd1 vccd1 vccd1 net20 sky130_fd_sc_hd__buf_4
Xfanout64 MATMULT_INST.matmult_inst.fsm_inst.load vssd1 vssd1 vccd1 vccd1 net64 sky130_fd_sc_hd__buf_2
Xfanout53 net54 vssd1 vssd1 vccd1 vccd1 net53 sky130_fd_sc_hd__clkbuf_2
Xfanout42 _0804_ vssd1 vssd1 vccd1 vccd1 net42 sky130_fd_sc_hd__clkbuf_2
XFILLER_22_293 vssd1 vssd1 vccd1 vccd1 sky130_fd_sc_hd__fill_4
Xfanout97 net98 vssd1 vssd1 vccd1 vccd1 net97 sky130_fd_sc_hd__clkbuf_4
Xfanout86 _0735_ vssd1 vssd1 vccd1 vccd1 net86 sky130_fd_sc_hd__clkbuf_2
Xfanout75 net81 vssd1 vssd1 vccd1 vccd1 net75 sky130_fd_sc_hd__clkbuf_2
XANTENNA__3167__B net87 vssd1 vssd1 vccd1 vccd1 sky130_fd_sc_hd__diode_2
XFILLER_10_477 vccd1 vssd1 vccd1 vssd1 sky130_ef_sc_hd__decap_40_12
XFILLER_13_96 vssd1 vssd1 vccd1 vccd1 sky130_fd_sc_hd__fill_2
XFILLER_6_437 vssd1 vssd1 vccd1 vccd1 sky130_fd_sc_hd__fill_1
XANTENNA__2127__A1 net34 vssd1 vssd1 vccd1 vccd1 sky130_fd_sc_hd__diode_2
XFILLER_49_113 vssd1 vssd1 vccd1 vccd1 sky130_fd_sc_hd__fill_2
X_1990_ net366 net38 net29 vssd1 vssd1 vccd1 vccd1 _0152_ sky130_fd_sc_hd__mux2_1
XFILLER_54_81 vssd1 vssd1 vccd1 vccd1 sky130_fd_sc_hd__fill_2
XTAP_TAPCELL_ROW_15_299 vssd1 vccd1 sky130_fd_sc_hd__tapvpwrvgnd_1
X_3591_ net226 _0009_ _0089_ vssd1 vssd1 vccd1 vccd1 MATMULT_INST.matmult_inst.spi_inst.miso_shifter\[11\]
+ sky130_fd_sc_hd__dfrtp_1
X_2611_ net647 _1200_ net95 vssd1 vssd1 vccd1 vccd1 _0386_ sky130_fd_sc_hd__mux2_1
Xclkload23 clknet_leaf_28_clk vssd1 vssd1 vccd1 vccd1 clkload23/Y sky130_fd_sc_hd__clkinv_4
Xclkload12 clknet_leaf_6_clk vssd1 vssd1 vccd1 vccd1 clkload12/Y sky130_fd_sc_hd__clkinvlp_4
Xclkload34 clknet_leaf_25_clk vssd1 vssd1 vccd1 vccd1 clkload34/X sky130_fd_sc_hd__clkbuf_8
X_2542_ _1132_ _1133_ vssd1 vssd1 vccd1 vccd1 _1134_ sky130_fd_sc_hd__or2_1
XANTENNA__2412__D net210 vssd1 vssd1 vccd1 vccd1 sky130_fd_sc_hd__diode_2
XFILLER_55_3 vssd1 vssd1 vccd1 vccd1 sky130_fd_sc_hd__fill_8
X_2473_ _1065_ _1066_ vssd1 vssd1 vccd1 vccd1 _1067_ sky130_fd_sc_hd__nand2b_1
XANTENNA__2201__S net67 vssd1 vssd1 vccd1 vccd1 sky130_fd_sc_hd__diode_2
XFILLER_68_433 vccd1 vssd1 vccd1 vssd1 sky130_ef_sc_hd__decap_40_12
XFILLER_68_477 vccd1 vssd1 vccd1 vssd1 sky130_ef_sc_hd__decap_40_12
X_3025_ _1560_ _1561_ vssd1 vssd1 vccd1 vccd1 _1562_ sky130_fd_sc_hd__or2_1
XFILLER_51_311 vssd1 vssd1 vccd1 vccd1 sky130_fd_sc_hd__fill_1
XFILLER_34_29 vssd1 vssd1 vccd1 vccd1 sky130_fd_sc_hd__fill_4
XFILLER_51_377 vssd1 vssd1 vccd1 vccd1 sky130_fd_sc_hd__fill_2
Xclkload6 clknet_leaf_3_clk vssd1 vssd1 vccd1 vccd1 clkload6/X sky130_fd_sc_hd__clkbuf_8
XANTENNA__1801__B1 net120 vssd1 vssd1 vccd1 vccd1 sky130_fd_sc_hd__diode_2
X_2809_ net182 net159 net180 net160 vssd1 vssd1 vccd1 vccd1 _1353_ sky130_fd_sc_hd__a22o_1
XFILLER_59_15 vssd1 vssd1 vccd1 vccd1 sky130_fd_sc_hd__fill_2
XTAP_TAPCELL_ROW_6_223 vssd1 vccd1 sky130_fd_sc_hd__tapvpwrvgnd_1
Xfanout210 MATMULT_INST.matmult_inst.alu_inst.b0_reg\[2\] vssd1 vssd1 vccd1 vccd1
+ net210 sky130_fd_sc_hd__clkbuf_4
Xfanout221 MATMULT_INST.matmult_inst.fsm_inst.sel\[1\] vssd1 vssd1 vccd1 vccd1 net221
+ sky130_fd_sc_hd__buf_2
XFILLER_59_422 vssd1 vssd1 vccd1 vccd1 sky130_fd_sc_hd__fill_2
XFILLER_75_14 vssd1 vssd1 vccd1 vccd1 sky130_fd_sc_hd__fill_2
XFILLER_74_414 vssd1 vssd1 vccd1 vccd1 sky130_fd_sc_hd__fill_1
XANTENNA_fanout62_A _0734_ vssd1 vssd1 vccd1 vccd1 sky130_fd_sc_hd__diode_2
XTAP_TAPCELL_ROW_57_656 vssd1 vccd1 sky130_fd_sc_hd__tapvpwrvgnd_1
XANTENNA__3178__A net58 vssd1 vssd1 vccd1 vccd1 sky130_fd_sc_hd__diode_2
XTAP_TAPCELL_ROW_40_512 vssd1 vccd1 sky130_fd_sc_hd__tapvpwrvgnd_1
XFILLER_2_473 vssd1 vssd1 vccd1 vccd1 sky130_fd_sc_hd__fill_2
XANTENNA__2021__S net24 vssd1 vssd1 vccd1 vccd1 sky130_fd_sc_hd__diode_2
XFILLER_65_436 vssd1 vssd1 vccd1 vccd1 sky130_fd_sc_hd__fill_4
XFILLER_1_33 vssd1 vssd1 vccd1 vccd1 sky130_fd_sc_hd__fill_8
XFILLER_1_66 vssd1 vssd1 vccd1 vccd1 sky130_fd_sc_hd__fill_8
XFILLER_33_344 vccd1 vssd1 vccd1 vssd1 sky130_ef_sc_hd__decap_40_12
XFILLER_60_174 vssd1 vssd1 vccd1 vccd1 sky130_fd_sc_hd__fill_1
X_1973_ net489 net34 net31 vssd1 vssd1 vccd1 vccd1 _0138_ sky130_fd_sc_hd__mux2_1
XANTENNA__2423__C net203 vssd1 vssd1 vccd1 vccd1 sky130_fd_sc_hd__diode_2
X_3643_ clknet_leaf_33_clk _0527_ vssd1 vssd1 vccd1 vccd1 MATMULT_INST.matmult_inst.fsm_inst.state\[3\]
+ sky130_fd_sc_hd__dfxtp_1
X_3574_ clknet_leaf_23_clk net629 _0072_ vssd1 vssd1 vccd1 vccd1 MATMULT_INST.matmult_inst.fsm_inst.rx_data\[4\]
+ sky130_fd_sc_hd__dfrtp_1
X_2525_ net188 net206 net208 net186 vssd1 vssd1 vccd1 vccd1 _1117_ sky130_fd_sc_hd__a22o_1
X_2456_ _1047_ _1048_ _1049_ vssd1 vssd1 vccd1 vccd1 _1050_ sky130_fd_sc_hd__or3_1
Xhold18 _0522_ vssd1 vssd1 vccd1 vccd1 net313 sky130_fd_sc_hd__dlygate4sd3_1
Xhold29 MATMULT_INST.matmult_inst.fsm_inst.alu_result\[8\] vssd1 vssd1 vccd1 vccd1
+ net324 sky130_fd_sc_hd__dlygate4sd3_1
X_2387_ _0964_ _0965_ _0966_ vssd1 vssd1 vccd1 vccd1 _0983_ sky130_fd_sc_hd__o21ai_2
X_3008_ _1544_ _1545_ vssd1 vssd1 vccd1 vccd1 _1546_ sky130_fd_sc_hd__or2_1
XFILLER_24_322 vssd1 vssd1 vccd1 vccd1 sky130_fd_sc_hd__fill_1
XANTENNA_fanout152_X net152 vssd1 vssd1 vccd1 vccd1 sky130_fd_sc_hd__diode_2
XFILLER_61_38 vssd1 vssd1 vccd1 vccd1 sky130_fd_sc_hd__fill_2
XANTENNA__2333__C net96 vssd1 vssd1 vccd1 vccd1 sky130_fd_sc_hd__diode_2
XANTENNA__2106__S net16 vssd1 vssd1 vccd1 vccd1 sky130_fd_sc_hd__diode_2
XANTENNA__1945__S net30 vssd1 vssd1 vccd1 vccd1 sky130_fd_sc_hd__diode_2
XFILLER_3_248 vccd1 vssd1 vccd1 vssd1 sky130_ef_sc_hd__decap_40_12
XFILLER_19_73 vccd1 vssd1 vccd1 vssd1 sky130_ef_sc_hd__decap_40_12
XFILLER_74_244 vssd1 vssd1 vccd1 vccd1 sky130_fd_sc_hd__fill_1
XFILLER_47_469 vssd1 vssd1 vccd1 vccd1 sky130_fd_sc_hd__fill_4
XFILLER_62_417 vssd1 vssd1 vccd1 vccd1 sky130_fd_sc_hd__fill_2
XFILLER_15_300 vssd1 vssd1 vccd1 vccd1 sky130_fd_sc_hd__fill_2
XTAP_TAPCELL_ROW_17_317 vssd1 vccd1 sky130_fd_sc_hd__tapvpwrvgnd_1
XFILLER_27_193 vssd1 vssd1 vccd1 vccd1 sky130_fd_sc_hd__fill_4
XFILLER_70_472 vssd1 vssd1 vccd1 vccd1 sky130_fd_sc_hd__fill_4
XFILLER_35_94 vssd1 vssd1 vccd1 vccd1 sky130_fd_sc_hd__fill_1
XANTENNA__2524__B net210 vssd1 vssd1 vccd1 vccd1 sky130_fd_sc_hd__diode_2
XTAP_TAPCELL_ROW_25_383 vssd1 vccd1 sky130_fd_sc_hd__tapvpwrvgnd_1
XFILLER_30_369 vssd1 vssd1 vccd1 vccd1 sky130_fd_sc_hd__fill_1
XPHY_EDGE_ROW_2_Left_82 vssd1 vssd1 vccd1 vccd1 sky130_fd_sc_hd__decap_3
XFILLER_51_93 vssd1 vssd1 vccd1 vccd1 sky130_fd_sc_hd__fill_1
XANTENNA__1792__A2 net128 vssd1 vssd1 vccd1 vccd1 sky130_fd_sc_hd__diode_2
XANTENNA__1855__S _0744_ vssd1 vssd1 vccd1 vccd1 sky130_fd_sc_hd__diode_2
X_3290_ clknet_leaf_12_clk _0212_ vssd1 vssd1 vccd1 vccd1 MATMULT_INST.matmult_inst.mem_inst.matrixA2\[17\]
+ sky130_fd_sc_hd__dfxtp_1
X_2310_ _0927_ _0928_ net99 vssd1 vssd1 vccd1 vccd1 _0930_ sky130_fd_sc_hd__o21a_1
X_2241_ _0862_ _0866_ _0863_ vssd1 vssd1 vccd1 vccd1 _0872_ sky130_fd_sc_hd__o21ai_1
XANTENNA__1701__C1 _0545_ vssd1 vssd1 vccd1 vccd1 sky130_fd_sc_hd__diode_2
XFILLER_18_3 vssd1 vssd1 vccd1 vccd1 sky130_fd_sc_hd__fill_8
X_2172_ _1594_ MATMULT_INST.matmult_inst.fsm_inst.count\[3\] _0771_ net101 vssd1 vssd1
+ vccd1 vccd1 _0829_ sky130_fd_sc_hd__o31ai_2
XFILLER_65_233 vssd1 vssd1 vccd1 vccd1 sky130_fd_sc_hd__fill_1
XFILLER_25_108 vssd1 vssd1 vccd1 vccd1 sky130_fd_sc_hd__fill_4
XTAP_TAPCELL_ROW_51_607 vssd1 vccd1 sky130_fd_sc_hd__tapvpwrvgnd_1
XANTENNA__2009__B1 net27 vssd1 vssd1 vccd1 vccd1 sky130_fd_sc_hd__diode_2
X_1956_ MATMULT_INST.matmult_inst.fsm_inst.rx_data\[7\] _0781_ net70 MATMULT_INST.matmult_inst.fsm_inst.alu_result\[7\]
+ vssd1 vssd1 vccd1 vccd1 _0804_ sky130_fd_sc_hd__a22o_2
X_1887_ net132 _1593_ _0764_ vssd1 vssd1 vccd1 vccd1 _0765_ sky130_fd_sc_hd__or3_1
XANTENNA__1783__A2 net112 vssd1 vssd1 vccd1 vccd1 sky130_fd_sc_hd__diode_2
XANTENNA_fanout112_A _0559_ vssd1 vssd1 vccd1 vccd1 sky130_fd_sc_hd__diode_2
X_3626_ clknet_leaf_24_clk net478 vssd1 vssd1 vccd1 vccd1 MATMULT_INST.matmult_inst.fsm_inst.alu_result\[2\]
+ sky130_fd_sc_hd__dfxtp_1
X_3557_ clknet_leaf_0_clk _0469_ vssd1 vssd1 vccd1 vccd1 MATMULT_INST.matmult_inst.mem_inst.matrixB3\[5\]
+ sky130_fd_sc_hd__dfxtp_1
X_2508_ _1098_ _1099_ vssd1 vssd1 vccd1 vccd1 _1101_ sky130_fd_sc_hd__nor2_1
X_3488_ clknet_leaf_17_clk net300 vssd1 vssd1 vccd1 vccd1 MATMULT_INST.matmult_inst.fsm_inst.tx_start_send
+ sky130_fd_sc_hd__dfxtp_1
X_2439_ _0981_ _1021_ vssd1 vssd1 vccd1 vccd1 _1033_ sky130_fd_sc_hd__nand2_1
XTAP_TAPCELL_ROW_67_740 vssd1 vccd1 sky130_fd_sc_hd__tapvpwrvgnd_1
XFILLER_56_277 vccd1 vssd1 vccd1 vssd1 sky130_ef_sc_hd__decap_40_12
XFILLER_52_450 vssd1 vssd1 vccd1 vccd1 sky130_fd_sc_hd__fill_4
XANTENNA_fanout25_A _0817_ vssd1 vssd1 vccd1 vccd1 sky130_fd_sc_hd__diode_2
XFILLER_24_163 vssd1 vssd1 vccd1 vccd1 sky130_fd_sc_hd__fill_4
XFILLER_12_369 vssd1 vssd1 vccd1 vccd1 sky130_fd_sc_hd__fill_1
XFILLER_12_347 vssd1 vssd1 vccd1 vccd1 sky130_fd_sc_hd__fill_2
XANTENNA__3159__C net73 vssd1 vssd1 vccd1 vccd1 sky130_fd_sc_hd__diode_2
XFILLER_79_314 vssd1 vssd1 vccd1 vccd1 sky130_fd_sc_hd__fill_2
XANTENNA__1704__A net150 vssd1 vssd1 vccd1 vccd1 sky130_fd_sc_hd__diode_2
XFILLER_35_439 vssd1 vssd1 vccd1 vccd1 sky130_fd_sc_hd__fill_8
XFILLER_62_81 vssd1 vssd1 vccd1 vccd1 sky130_fd_sc_hd__fill_1
X_1810_ net147 net139 MATMULT_INST.matmult_inst.mem_inst.matrixB3\[0\] vssd1 vssd1
+ vccd1 vccd1 _0723_ sky130_fd_sc_hd__and3_1
X_2790_ net661 _1334_ net98 vssd1 vssd1 vccd1 vccd1 _0431_ sky130_fd_sc_hd__mux2_1
XANTENNA__2411__B1 net210 vssd1 vssd1 vccd1 vccd1 sky130_fd_sc_hd__diode_2
X_1741_ _0654_ _0659_ _0660_ vssd1 vssd1 vccd1 vccd1 _0661_ sky130_fd_sc_hd__or3_2
Xhold307 MATMULT_INST.matmult_inst.mem_inst.matrixB0\[4\] vssd1 vssd1 vccd1 vccd1
+ net602 sky130_fd_sc_hd__dlygate4sd3_1
X_1672_ net150 net141 MATMULT_INST.matmult_inst.mem_inst.matrixA3\[13\] vssd1 vssd1
+ vccd1 vccd1 _0598_ sky130_fd_sc_hd__and3_1
X_3411_ clknet_leaf_34_clk _0333_ vssd1 vssd1 vccd1 vccd1 MATMULT_INST.matmult_inst.alu_inst.a0_reg\[0\]
+ sky130_fd_sc_hd__dfxtp_1
Xhold318 MATMULT_INST.matmult_inst.mem_inst.matrixB0\[2\] vssd1 vssd1 vccd1 vccd1
+ net613 sky130_fd_sc_hd__dlygate4sd3_1
Xhold329 MATMULT_INST.matmult_inst.spi_inst.tx_reg_sys\[6\] vssd1 vssd1 vccd1 vccd1
+ net624 sky130_fd_sc_hd__dlygate4sd3_1
X_3342_ clknet_leaf_9_clk _0264_ vssd1 vssd1 vccd1 vccd1 MATMULT_INST.matmult_inst.mem_inst.mem3\[15\]
+ sky130_fd_sc_hd__dfxtp_1
X_3273_ clknet_leaf_7_clk _0195_ vssd1 vssd1 vccd1 vccd1 MATMULT_INST.matmult_inst.mem_inst.matrixA2\[0\]
+ sky130_fd_sc_hd__dfxtp_1
X_2224_ MATMULT_INST.matmult_inst.alu_inst.adder_inst.r0.fa3.b MATMULT_INST.matmult_inst.alu_inst.adder_inst.r0.fa3.a
+ vssd1 vssd1 vccd1 vccd1 _0857_ sky130_fd_sc_hd__nor2_1
X_2155_ _0802_ net604 net10 vssd1 vssd1 vccd1 vccd1 _0308_ sky130_fd_sc_hd__mux2_1
X_2086_ net386 _0809_ net19 vssd1 vssd1 vccd1 vccd1 _0243_ sky130_fd_sc_hd__mux2_1
XTAP_TAPCELL_ROW_36_478 vssd1 vccd1 sky130_fd_sc_hd__tapvpwrvgnd_1
XFILLER_21_144 vssd1 vssd1 vccd1 vccd1 sky130_fd_sc_hd__fill_1
X_2988_ _1512_ _1526_ vssd1 vssd1 vccd1 vccd1 _1527_ sky130_fd_sc_hd__xnor2_1
X_1939_ MATMULT_INST.matmult_inst.fsm_inst.state\[1\] _1593_ _0751_ vssd1 vssd1 vccd1
+ vccd1 _0794_ sky130_fd_sc_hd__and3_1
XANTENNA__1756__A2 net112 vssd1 vssd1 vccd1 vccd1 sky130_fd_sc_hd__diode_2
X_3609_ clknet_leaf_20_clk _0502_ _0107_ vssd1 vssd1 vccd1 vccd1 MATMULT_INST.matmult_inst.spi_inst.tx_reg_sys\[12\]
+ sky130_fd_sc_hd__dfrtp_1
XFILLER_17_417 vssd1 vssd1 vccd1 vccd1 sky130_fd_sc_hd__fill_4
XFILLER_17_428 vssd1 vssd1 vccd1 vccd1 sky130_fd_sc_hd__fill_4
XTAP_TAPCELL_ROW_27_401 vssd1 vccd1 sky130_fd_sc_hd__tapvpwrvgnd_1
XFILLER_44_247 vssd1 vssd1 vccd1 vccd1 sky130_fd_sc_hd__fill_2
XPHY_EDGE_ROW_11_Right_11 vssd1 vssd1 vccd1 vccd1 sky130_fd_sc_hd__decap_3
XFILLER_16_85 vssd1 vssd1 vccd1 vccd1 sky130_fd_sc_hd__fill_4
XFILLER_25_483 vssd1 vssd1 vccd1 vccd1 sky130_fd_sc_hd__fill_8
XTAP_TAPCELL_ROW_70_768 vssd1 vccd1 sky130_fd_sc_hd__tapvpwrvgnd_1
XANTENNA_fanout28_X net28 vssd1 vssd1 vccd1 vccd1 sky130_fd_sc_hd__diode_2
XFILLER_40_464 vssd1 vssd1 vccd1 vccd1 sky130_fd_sc_hd__fill_4
XANTENNA__3186__A net58 vssd1 vssd1 vccd1 vccd1 sky130_fd_sc_hd__diode_2
XFILLER_12_188 vssd1 vssd1 vccd1 vccd1 sky130_fd_sc_hd__fill_8
XFILLER_8_137 vssd1 vssd1 vccd1 vccd1 sky130_fd_sc_hd__fill_2
XFILLER_4_365 vssd1 vssd1 vccd1 vccd1 sky130_fd_sc_hd__fill_4
XPHY_EDGE_ROW_20_Right_20 vssd1 vssd1 vccd1 vccd1 sky130_fd_sc_hd__decap_3
XTAP_TAPCELL_ROW_78_835 vssd1 vccd1 sky130_fd_sc_hd__tapvpwrvgnd_1
XFILLER_67_328 vssd1 vssd1 vccd1 vccd1 sky130_fd_sc_hd__fill_8
XFILLER_35_258 vssd1 vssd1 vccd1 vccd1 sky130_fd_sc_hd__fill_1
X_2911_ _1441_ _1450_ vssd1 vssd1 vccd1 vccd1 _1452_ sky130_fd_sc_hd__xor2_1
XFILLER_31_442 vssd1 vssd1 vccd1 vccd1 sky130_fd_sc_hd__fill_4
XFILLER_43_291 vssd1 vssd1 vccd1 vccd1 sky130_fd_sc_hd__fill_1
X_2842_ net175 net177 net164 net162 vssd1 vssd1 vccd1 vccd1 _1385_ sky130_fd_sc_hd__and4_1
X_2773_ _1300_ _1301_ _1302_ vssd1 vssd1 vccd1 vccd1 _1318_ sky130_fd_sc_hd__o21ai_2
X_1724_ MATMULT_INST.matmult_inst.mem_inst.matrixB1\[8\] net129 net121 MATMULT_INST.matmult_inst.mem_inst.matrixB2\[8\]
+ _0644_ vssd1 vssd1 vccd1 vccd1 _0645_ sky130_fd_sc_hd__a221o_1
XANTENNA__2204__S net66 vssd1 vssd1 vccd1 vccd1 sky130_fd_sc_hd__diode_2
Xhold126 MATMULT_INST.matmult_inst.mem_inst.mem3\[12\] vssd1 vssd1 vccd1 vccd1 net421
+ sky130_fd_sc_hd__dlygate4sd3_1
Xhold104 MATMULT_INST.matmult_inst.spi_inst.mosi_data_sync\[5\] vssd1 vssd1 vccd1
+ vccd1 net399 sky130_fd_sc_hd__dlygate4sd3_1
Xhold115 MATMULT_INST.matmult_inst.mem_inst.matrixB1\[0\] vssd1 vssd1 vccd1 vccd1
+ net410 sky130_fd_sc_hd__dlygate4sd3_1
Xhold148 MATMULT_INST.matmult_inst.mem_inst.mem2\[16\] vssd1 vssd1 vccd1 vccd1 net443
+ sky130_fd_sc_hd__dlygate4sd3_1
Xhold137 MATMULT_INST.matmult_inst.mem_inst.matrixA1\[17\] vssd1 vssd1 vccd1 vccd1
+ net432 sky130_fd_sc_hd__dlygate4sd3_1
X_1655_ net220 _0577_ _0582_ net216 _0580_ vssd1 vssd1 vccd1 vccd1 _0583_ sky130_fd_sc_hd__a221o_1
Xhold159 MATMULT_INST.matmult_inst.mem_inst.mem2\[2\] vssd1 vssd1 vccd1 vccd1 net454
+ sky130_fd_sc_hd__dlygate4sd3_1
XANTENNA__2699__A0 _1248_ vssd1 vssd1 vccd1 vccd1 sky130_fd_sc_hd__diode_2
X_3325_ clknet_leaf_11_clk _0247_ vssd1 vssd1 vccd1 vccd1 MATMULT_INST.matmult_inst.mem_inst.matrixA0\[16\]
+ sky130_fd_sc_hd__dfxtp_1
X_3256_ clknet_leaf_12_clk _0178_ vssd1 vssd1 vccd1 vccd1 MATMULT_INST.matmult_inst.mem_inst.matrixA3\[1\]
+ sky130_fd_sc_hd__dfxtp_1
X_2207_ net186 net595 net65 vssd1 vssd1 vccd1 vccd1 _0339_ sky130_fd_sc_hd__mux2_1
X_3187_ net62 net88 net74 vssd1 vssd1 vccd1 vccd1 _0112_ sky130_fd_sc_hd__and3_1
XFILLER_66_372 vssd1 vssd1 vccd1 vccd1 sky130_fd_sc_hd__fill_2
XTAP_TAPCELL_ROW_49_592 vssd1 vccd1 sky130_fd_sc_hd__tapvpwrvgnd_1
X_2138_ net502 net42 net12 vssd1 vssd1 vccd1 vccd1 _0292_ sky130_fd_sc_hd__mux2_1
XANTENNA__1674__A1 net222 vssd1 vssd1 vccd1 vccd1 sky130_fd_sc_hd__diode_2
X_2069_ net457 net35 net20 vssd1 vssd1 vccd1 vccd1 _0227_ sky130_fd_sc_hd__mux2_1
XFILLER_41_217 vssd1 vssd1 vccd1 vccd1 sky130_fd_sc_hd__fill_2
XFILLER_22_475 vssd1 vssd1 vccd1 vccd1 sky130_fd_sc_hd__fill_1
XANTENNA__2114__S net15 vssd1 vssd1 vccd1 vccd1 sky130_fd_sc_hd__diode_2
XANTENNA__1953__S net30 vssd1 vssd1 vccd1 vccd1 sky130_fd_sc_hd__diode_2
XANTENNA__1806__X _0720_ vssd1 vssd1 vccd1 vccd1 sky130_fd_sc_hd__diode_2
XANTENNA_fanout92_A _0735_ vssd1 vssd1 vccd1 vccd1 sky130_fd_sc_hd__diode_2
XFILLER_1_357 vssd1 vssd1 vccd1 vccd1 sky130_fd_sc_hd__fill_1
XFILLER_49_328 vssd1 vssd1 vccd1 vccd1 sky130_fd_sc_hd__fill_8
XFILLER_76_158 vssd1 vssd1 vccd1 vccd1 sky130_fd_sc_hd__fill_1
XFILLER_27_73 vssd1 vssd1 vccd1 vccd1 sky130_fd_sc_hd__fill_2
XFILLER_9_424 vccd1 vssd1 vccd1 vssd1 sky130_ef_sc_hd__decap_40_12
XFILLER_43_72 vssd1 vssd1 vccd1 vccd1 sky130_fd_sc_hd__fill_1
XTAP_TAPCELL_ROW_30_429 vssd1 vccd1 sky130_fd_sc_hd__tapvpwrvgnd_1
XANTENNA__2024__S net24 vssd1 vssd1 vccd1 vccd1 sky130_fd_sc_hd__diode_2
XFILLER_4_184 vssd1 vssd1 vccd1 vccd1 sky130_fd_sc_hd__fill_4
XFILLER_4_195 vssd1 vssd1 vccd1 vccd1 sky130_fd_sc_hd__fill_1
X_3110_ net60 net90 net81 vssd1 vssd1 vccd1 vccd1 _0041_ sky130_fd_sc_hd__and3_1
X_3041_ net94 _1558_ _1571_ vssd1 vssd1 vccd1 vccd1 _1576_ sky130_fd_sc_hd__and3_1
XANTENNA__1656__B2 _0583_ vssd1 vssd1 vccd1 vccd1 sky130_fd_sc_hd__diode_2
XTAP_TAPCELL_ROW_46_562 vssd1 vccd1 sky130_fd_sc_hd__tapvpwrvgnd_1
X_2825_ net654 _1368_ net97 vssd1 vssd1 vccd1 vccd1 _0432_ sky130_fd_sc_hd__mux2_1
XFILLER_31_272 vssd1 vssd1 vccd1 vccd1 sky130_fd_sc_hd__fill_8
XFILLER_31_294 vccd1 vssd1 vccd1 vssd1 sky130_ef_sc_hd__decap_40_12
X_2756_ net182 net163 net181 net165 vssd1 vssd1 vccd1 vccd1 _1302_ sky130_fd_sc_hd__a22o_1
X_1707_ net152 net143 MATMULT_INST.matmult_inst.mem_inst.matrixB3\[10\] vssd1 vssd1
+ vccd1 vccd1 _0630_ sky130_fd_sc_hd__and3_1
X_2687_ net93 _0767_ _1245_ vssd1 vssd1 vccd1 vccd1 _1255_ sky130_fd_sc_hd__o21bai_4
X_1638_ net150 net142 MATMULT_INST.matmult_inst.mem_inst.matrixB3\[16\] vssd1 vssd1
+ vccd1 vccd1 _0567_ sky130_fd_sc_hd__and3_1
XFILLER_48_39 vssd1 vssd1 vccd1 vccd1 sky130_fd_sc_hd__fill_2
X_3308_ clknet_leaf_13_clk _0230_ vssd1 vssd1 vccd1 vccd1 MATMULT_INST.matmult_inst.mem_inst.matrixA1\[17\]
+ sky130_fd_sc_hd__dfxtp_1
XFILLER_58_125 vccd1 vssd1 vccd1 vssd1 sky130_ef_sc_hd__decap_40_12
X_3239_ clknet_leaf_4_clk _0161_ vssd1 vssd1 vccd1 vccd1 MATMULT_INST.matmult_inst.mem_inst.matrixB0\[2\]
+ sky130_fd_sc_hd__dfxtp_1
XFILLER_73_139 vssd1 vssd1 vccd1 vccd1 sky130_fd_sc_hd__fill_2
XFILLER_66_180 vssd1 vssd1 vccd1 vccd1 sky130_fd_sc_hd__fill_2
XANTENNA__2109__S net16 vssd1 vssd1 vccd1 vccd1 sky130_fd_sc_hd__diode_2
Xfanout21 _0819_ vssd1 vssd1 vccd1 vccd1 net21 sky130_fd_sc_hd__clkbuf_4
Xfanout10 _0824_ vssd1 vssd1 vccd1 vccd1 net10 sky130_fd_sc_hd__clkbuf_4
Xfanout32 _0814_ vssd1 vssd1 vccd1 vccd1 net32 sky130_fd_sc_hd__clkbuf_2
Xfanout65 net66 vssd1 vssd1 vccd1 vccd1 net65 sky130_fd_sc_hd__clkbuf_4
Xfanout43 _0803_ vssd1 vssd1 vccd1 vccd1 net43 sky130_fd_sc_hd__clkbuf_2
Xfanout54 _0734_ vssd1 vssd1 vccd1 vccd1 net54 sky130_fd_sc_hd__clkbuf_2
Xfanout98 _0531_ vssd1 vssd1 vccd1 vccd1 net98 sky130_fd_sc_hd__buf_2
Xfanout76 net81 vssd1 vssd1 vccd1 vccd1 net76 sky130_fd_sc_hd__clkbuf_2
Xfanout87 _0735_ vssd1 vssd1 vccd1 vccd1 net87 sky130_fd_sc_hd__buf_2
XFILLER_6_405 vssd1 vssd1 vccd1 vccd1 sky130_fd_sc_hd__fill_4
XANTENNA__3167__C net74 vssd1 vssd1 vccd1 vccd1 sky130_fd_sc_hd__diode_2
XFILLER_10_489 vssd1 vssd1 vccd1 vccd1 sky130_fd_sc_hd__fill_2
XFILLER_6_449 vssd1 vssd1 vccd1 vccd1 sky130_fd_sc_hd__fill_1
XFILLER_1_165 vssd1 vssd1 vccd1 vccd1 sky130_fd_sc_hd__fill_2
XFILLER_77_445 vssd1 vssd1 vccd1 vccd1 sky130_fd_sc_hd__fill_2
XFILLER_37_309 vssd1 vssd1 vccd1 vccd1 sky130_fd_sc_hd__fill_4
XFILLER_38_72 vssd1 vssd1 vccd1 vccd1 sky130_fd_sc_hd__fill_1
XANTENNA__2019__S net24 vssd1 vssd1 vccd1 vccd1 sky130_fd_sc_hd__diode_2
XFILLER_57_191 vssd1 vssd1 vccd1 vccd1 sky130_fd_sc_hd__fill_1
XFILLER_45_386 vssd1 vssd1 vccd1 vccd1 sky130_fd_sc_hd__fill_4
XANTENNA__1858__S _0744_ vssd1 vssd1 vccd1 vccd1 sky130_fd_sc_hd__diode_2
XFILLER_13_272 vssd1 vssd1 vccd1 vccd1 sky130_fd_sc_hd__fill_1
XFILLER_9_276 vssd1 vssd1 vccd1 vccd1 sky130_fd_sc_hd__fill_4
X_3590_ net226 _0008_ _0088_ vssd1 vssd1 vccd1 vccd1 MATMULT_INST.matmult_inst.spi_inst.miso_shifter\[10\]
+ sky130_fd_sc_hd__dfrtp_1
X_2610_ _1195_ _1198_ _1199_ vssd1 vssd1 vccd1 vccd1 _1200_ sky130_fd_sc_hd__o21a_1
Xclkload24 clknet_leaf_29_clk vssd1 vssd1 vccd1 vccd1 clkload24/Y sky130_fd_sc_hd__inv_12
Xclkload35 clknet_leaf_26_clk vssd1 vssd1 vccd1 vccd1 clkload35/X sky130_fd_sc_hd__clkbuf_4
Xclkload13 clknet_leaf_7_clk vssd1 vssd1 vccd1 vccd1 clkload13/X sky130_fd_sc_hd__clkbuf_8
X_2541_ _1123_ _1130_ _1131_ vssd1 vssd1 vccd1 vccd1 _1133_ sky130_fd_sc_hd__and3_1
X_2472_ _1063_ _1064_ _1032_ vssd1 vssd1 vccd1 vccd1 _1066_ sky130_fd_sc_hd__a21o_1
XFILLER_68_401 vccd1 vssd1 vccd1 vssd1 sky130_ef_sc_hd__decap_40_12
XFILLER_68_445 vssd1 vssd1 vccd1 vccd1 sky130_fd_sc_hd__fill_2
XFILLER_68_489 vssd1 vssd1 vccd1 vccd1 sky130_fd_sc_hd__fill_4
X_3024_ _1557_ _1558_ _1559_ vssd1 vssd1 vccd1 vccd1 _1561_ sky130_fd_sc_hd__a21oi_1
XFILLER_55_139 vssd1 vssd1 vccd1 vccd1 sky130_fd_sc_hd__fill_1
XFILLER_36_331 vccd1 vssd1 vccd1 vssd1 sky130_ef_sc_hd__decap_40_12
XANTENNA_fanout142_A net145 vssd1 vssd1 vccd1 vccd1 sky130_fd_sc_hd__diode_2
Xclkload7 clknet_leaf_4_clk vssd1 vssd1 vccd1 vccd1 clkload7/Y sky130_fd_sc_hd__clkinv_4
X_2808_ net184 net157 vssd1 vssd1 vccd1 vccd1 _1352_ sky130_fd_sc_hd__nand2_1
X_2739_ net168 net167 net179 net180 vssd1 vssd1 vccd1 vccd1 _1286_ sky130_fd_sc_hd__nand4_1
XFILLER_1_9 vccd1 vssd1 vccd1 vssd1 sky130_ef_sc_hd__decap_40_12
XTAP_TAPCELL_ROW_6_224 vssd1 vccd1 sky130_fd_sc_hd__tapvpwrvgnd_1
Xfanout200 MATMULT_INST.matmult_inst.alu_inst.b0_reg\[7\] vssd1 vssd1 vccd1 vccd1
+ net200 sky130_fd_sc_hd__buf_2
Xfanout211 MATMULT_INST.matmult_inst.alu_inst.b0_reg\[2\] vssd1 vssd1 vccd1 vccd1
+ net211 sky130_fd_sc_hd__clkbuf_2
Xfanout222 net223 vssd1 vssd1 vccd1 vccd1 net222 sky130_fd_sc_hd__clkbuf_4
XFILLER_75_37 vssd1 vssd1 vccd1 vccd1 sky130_fd_sc_hd__fill_1
XFILLER_75_26 vssd1 vssd1 vccd1 vccd1 sky130_fd_sc_hd__fill_1
XTAP_TAPCELL_ROW_57_657 vssd1 vccd1 sky130_fd_sc_hd__tapvpwrvgnd_1
XFILLER_61_109 vssd1 vssd1 vccd1 vccd1 sky130_fd_sc_hd__fill_2
XANTENNA__3178__B net87 vssd1 vssd1 vccd1 vccd1 sky130_fd_sc_hd__diode_2
XTAP_TAPCELL_ROW_40_513 vssd1 vccd1 sky130_fd_sc_hd__tapvpwrvgnd_1
XANTENNA_fanout10_X net10 vssd1 vssd1 vccd1 vccd1 sky130_fd_sc_hd__diode_2
XFILLER_6_213 vccd1 vssd1 vccd1 vssd1 sky130_ef_sc_hd__decap_40_12
XANTENNA__1707__A net152 vssd1 vssd1 vccd1 vccd1 sky130_fd_sc_hd__diode_2
XFILLER_49_93 vccd1 vssd1 vccd1 vssd1 sky130_ef_sc_hd__decap_40_12
XFILLER_33_334 vssd1 vssd1 vccd1 vccd1 sky130_fd_sc_hd__fill_2
XFILLER_33_356 vssd1 vssd1 vccd1 vccd1 sky130_fd_sc_hd__fill_4
X_1972_ MATMULT_INST.matmult_inst.fsm_inst.alu_result\[15\] net69 vssd1 vssd1 vccd1
+ vccd1 _0812_ sky130_fd_sc_hd__and2_1
XFILLER_60_197 vssd1 vssd1 vccd1 vccd1 sky130_fd_sc_hd__fill_1
XANTENNA__1795__B1 net104 vssd1 vssd1 vccd1 vccd1 sky130_fd_sc_hd__diode_2
X_3642_ clknet_leaf_33_clk _0526_ vssd1 vssd1 vccd1 vccd1 MATMULT_INST.matmult_inst.fsm_inst.state\[4\]
+ sky130_fd_sc_hd__dfxtp_1
X_3573_ clknet_leaf_24_clk net553 _0071_ vssd1 vssd1 vccd1 vccd1 MATMULT_INST.matmult_inst.fsm_inst.rx_data\[3\]
+ sky130_fd_sc_hd__dfrtp_1
XPHY_EDGE_ROW_49_Right_49 vssd1 vssd1 vccd1 vccd1 sky130_fd_sc_hd__decap_3
X_2524_ net185 net210 vssd1 vssd1 vccd1 vccd1 _1116_ sky130_fd_sc_hd__nand2_1
X_2455_ net190 net208 vssd1 vssd1 vccd1 vccd1 _1049_ sky130_fd_sc_hd__and2_1
X_2386_ _0980_ _0981_ vssd1 vssd1 vccd1 vccd1 _0982_ sky130_fd_sc_hd__nand2_1
Xhold19 MATMULT_INST.matmult_inst.mem_inst.matrixB3\[0\] vssd1 vssd1 vccd1 vccd1 net314
+ sky130_fd_sc_hd__dlygate4sd3_1
XFILLER_56_404 vccd1 vssd1 vccd1 vssd1 sky130_ef_sc_hd__decap_40_12
XFILLER_28_139 vssd1 vssd1 vccd1 vccd1 sky130_fd_sc_hd__fill_1
XFILLER_71_407 vssd1 vssd1 vccd1 vccd1 sky130_fd_sc_hd__fill_8
XPHY_EDGE_ROW_58_Right_58 vssd1 vssd1 vccd1 vccd1 sky130_fd_sc_hd__decap_3
X_3007_ net170 net158 net172 net156 vssd1 vssd1 vccd1 vccd1 _1545_ sky130_fd_sc_hd__and4_1
XTAP_TAPCELL_ROW_54_627 vssd1 vccd1 sky130_fd_sc_hd__tapvpwrvgnd_1
XANTENNA__2027__A1 net39 vssd1 vssd1 vccd1 vccd1 sky130_fd_sc_hd__diode_2
XANTENNA_fanout145_X net145 vssd1 vssd1 vccd1 vccd1 sky130_fd_sc_hd__diode_2
XFILLER_51_175 vssd1 vssd1 vccd1 vccd1 sky130_fd_sc_hd__fill_1
XPHY_EDGE_ROW_67_Right_67 vssd1 vssd1 vccd1 vccd1 sky130_fd_sc_hd__decap_3
XFILLER_3_205 vssd1 vssd1 vccd1 vccd1 sky130_fd_sc_hd__fill_4
XANTENNA__2122__S net15 vssd1 vssd1 vccd1 vccd1 sky130_fd_sc_hd__diode_2
XFILLER_3_238 vssd1 vssd1 vccd1 vccd1 sky130_fd_sc_hd__fill_1
XANTENNA__1961__S net30 vssd1 vssd1 vccd1 vccd1 sky130_fd_sc_hd__diode_2
XFILLER_10_98 vccd1 vssd1 vccd1 vssd1 sky130_ef_sc_hd__decap_40_12
XPHY_EDGE_ROW_76_Right_76 vssd1 vssd1 vccd1 vccd1 sky130_fd_sc_hd__decap_3
XFILLER_19_117 vssd1 vssd1 vccd1 vccd1 sky130_fd_sc_hd__fill_2
XFILLER_19_85 vssd1 vssd1 vccd1 vccd1 sky130_fd_sc_hd__fill_8
XANTENNA_fanout58_X net58 vssd1 vssd1 vccd1 vccd1 sky130_fd_sc_hd__diode_2
XTAP_TAPCELL_ROW_17_318 vssd1 vccd1 sky130_fd_sc_hd__tapvpwrvgnd_1
XFILLER_15_345 vssd1 vssd1 vccd1 vccd1 sky130_fd_sc_hd__fill_4
XTAP_TAPCELL_ROW_25_384 vssd1 vccd1 sky130_fd_sc_hd__tapvpwrvgnd_1
XANTENNA__2032__S net25 vssd1 vssd1 vccd1 vccd1 sky130_fd_sc_hd__diode_2
X_2240_ _0868_ _0870_ vssd1 vssd1 vccd1 vccd1 _0871_ sky130_fd_sc_hd__nand2_1
XFILLER_65_223 vssd1 vssd1 vccd1 vccd1 sky130_fd_sc_hd__fill_1
X_2171_ _0738_ _0827_ _0826_ vssd1 vssd1 vccd1 vccd1 _0828_ sky130_fd_sc_hd__o21ai_1
XFILLER_76_91 vssd1 vssd1 vccd1 vccd1 sky130_fd_sc_hd__fill_1
XFILLER_65_256 vssd1 vssd1 vccd1 vccd1 sky130_fd_sc_hd__fill_1
XFILLER_38_459 vssd1 vssd1 vccd1 vccd1 sky130_fd_sc_hd__fill_2
XFILLER_18_172 vssd1 vssd1 vccd1 vccd1 sky130_fd_sc_hd__fill_2
XFILLER_33_153 vssd1 vssd1 vccd1 vccd1 sky130_fd_sc_hd__fill_2
XTAP_TAPCELL_ROW_51_608 vssd1 vccd1 sky130_fd_sc_hd__tapvpwrvgnd_1
XFILLER_21_337 vccd1 vssd1 vccd1 vssd1 sky130_ef_sc_hd__decap_40_12
XFILLER_33_175 vssd1 vssd1 vccd1 vccd1 sky130_fd_sc_hd__fill_2
X_1955_ net401 net43 net30 vssd1 vssd1 vccd1 vccd1 _0129_ sky130_fd_sc_hd__mux2_1
X_1886_ net135 MATMULT_INST.matmult_inst.fsm_inst.state\[2\] net134 vssd1 vssd1 vccd1
+ vccd1 _0764_ sky130_fd_sc_hd__or3b_1
X_3625_ clknet_leaf_24_clk net420 vssd1 vssd1 vccd1 vccd1 MATMULT_INST.matmult_inst.fsm_inst.alu_result\[1\]
+ sky130_fd_sc_hd__dfxtp_1
XANTENNA_fanout105_A net106 vssd1 vssd1 vccd1 vccd1 sky130_fd_sc_hd__diode_2
X_3556_ clknet_leaf_2_clk _0468_ vssd1 vssd1 vccd1 vccd1 MATMULT_INST.matmult_inst.mem_inst.matrixB3\[4\]
+ sky130_fd_sc_hd__dfxtp_1
X_2507_ _1098_ _1099_ vssd1 vssd1 vccd1 vccd1 _1100_ sky130_fd_sc_hd__and2_1
X_3487_ clknet_leaf_0_clk _0407_ vssd1 vssd1 vccd1 vccd1 MATMULT_INST.matmult_inst.alu_inst.col0\[7\]
+ sky130_fd_sc_hd__dfxtp_1
X_2438_ _1013_ _1025_ _1024_ vssd1 vssd1 vccd1 vccd1 _1032_ sky130_fd_sc_hd__o21bai_1
X_2369_ net212 net192 net211 net194 vssd1 vssd1 vccd1 vccd1 _0966_ sky130_fd_sc_hd__a22o_1
XTAP_TAPCELL_ROW_67_741 vssd1 vccd1 sky130_fd_sc_hd__tapvpwrvgnd_1
XFILLER_56_289 vccd1 vssd1 vccd1 vssd1 sky130_ef_sc_hd__decap_40_12
XFILLER_72_27 vssd1 vssd1 vccd1 vccd1 sky130_fd_sc_hd__fill_1
XANTENNA__2117__S net14 vssd1 vssd1 vccd1 vccd1 sky130_fd_sc_hd__diode_2
XANTENNA_fanout18_A _0820_ vssd1 vssd1 vccd1 vccd1 sky130_fd_sc_hd__diode_2
XANTENNA__3175__C net73 vssd1 vssd1 vccd1 vccd1 sky130_fd_sc_hd__diode_2
XFILLER_79_337 vccd1 vssd1 vccd1 vssd1 sky130_ef_sc_hd__decap_40_12
XANTENNA__1704__B net143 vssd1 vssd1 vccd1 vccd1 sky130_fd_sc_hd__diode_2
XFILLER_47_201 vssd1 vssd1 vccd1 vccd1 sky130_fd_sc_hd__fill_2
XFILLER_47_223 vssd1 vssd1 vccd1 vccd1 sky130_fd_sc_hd__fill_1
XANTENNA__1998__A0 _0797_ vssd1 vssd1 vccd1 vccd1 sky130_fd_sc_hd__diode_2
XANTENNA__2027__S net24 vssd1 vssd1 vccd1 vccd1 sky130_fd_sc_hd__diode_2
XFILLER_7_55 vssd1 vssd1 vccd1 vccd1 sky130_fd_sc_hd__fill_1
XANTENNA__2411__B2 net190 vssd1 vssd1 vccd1 vccd1 sky130_fd_sc_hd__diode_2
X_1740_ MATMULT_INST.matmult_inst.mem_inst.matrixA0\[7\] net112 _0658_ net222 vssd1
+ vssd1 vccd1 vccd1 _0660_ sky130_fd_sc_hd__a22o_1
X_1671_ MATMULT_INST.matmult_inst.mem_inst.mem1\[13\] net126 net118 MATMULT_INST.matmult_inst.mem_inst.mem2\[13\]
+ _0596_ vssd1 vssd1 vccd1 vccd1 _0597_ sky130_fd_sc_hd__a221o_1
XFILLER_7_374 vssd1 vssd1 vccd1 vccd1 sky130_fd_sc_hd__fill_8
Xhold308 MATMULT_INST.matmult_inst.alu_inst.col1\[5\] vssd1 vssd1 vccd1 vccd1 net603
+ sky130_fd_sc_hd__dlygate4sd3_1
X_3410_ clknet_leaf_37_clk _0332_ vssd1 vssd1 vccd1 vccd1 MATMULT_INST.matmult_inst.alu_inst.b0_reg\[7\]
+ sky130_fd_sc_hd__dfxtp_1
Xhold319 MATMULT_INST.matmult_inst.alu_inst.col1\[7\] vssd1 vssd1 vccd1 vccd1 net614
+ sky130_fd_sc_hd__dlygate4sd3_1
X_3341_ clknet_leaf_10_clk _0263_ vssd1 vssd1 vccd1 vccd1 MATMULT_INST.matmult_inst.mem_inst.mem3\[14\]
+ sky130_fd_sc_hd__dfxtp_1
XANTENNA__2697__S _1256_ vssd1 vssd1 vccd1 vccd1 sky130_fd_sc_hd__diode_2
X_3272_ clknet_leaf_13_clk _0194_ vssd1 vssd1 vccd1 vccd1 MATMULT_INST.matmult_inst.mem_inst.matrixA3\[17\]
+ sky130_fd_sc_hd__dfxtp_1
XFILLER_30_3 vccd1 vssd1 vccd1 vssd1 sky130_ef_sc_hd__decap_40_12
X_2223_ net617 _0856_ net100 vssd1 vssd1 vccd1 vccd1 _0343_ sky130_fd_sc_hd__mux2_1
XANTENNA__1614__B MATMULT_INST.matmult_inst.spi_inst.current_state vssd1 vssd1 vccd1
+ vccd1 sky130_fd_sc_hd__diode_2
X_2154_ _0801_ net587 net10 vssd1 vssd1 vccd1 vccd1 _0307_ sky130_fd_sc_hd__mux2_1
XFILLER_26_418 vssd1 vssd1 vccd1 vccd1 sky130_fd_sc_hd__fill_2
XFILLER_38_289 vssd1 vssd1 vccd1 vccd1 sky130_fd_sc_hd__fill_2
X_2085_ net422 _0808_ net19 vssd1 vssd1 vccd1 vccd1 _0242_ sky130_fd_sc_hd__mux2_1
XANTENNA__1630__A net217 vssd1 vssd1 vccd1 vccd1 sky130_fd_sc_hd__diode_2
XTAP_TAPCELL_ROW_36_479 vssd1 vccd1 sky130_fd_sc_hd__tapvpwrvgnd_1
X_2987_ _1496_ _1524_ vssd1 vssd1 vccd1 vccd1 _1526_ sky130_fd_sc_hd__xor2_1
XANTENNA__1629__X _0559_ vssd1 vssd1 vccd1 vccd1 sky130_fd_sc_hd__diode_2
X_1938_ MATMULT_INST.matmult_inst.spi_inst.tx_reg_sys\[17\] MATMULT_INST.matmult_inst.spi_inst.miso_bit
+ net137 vssd1 vssd1 vccd1 vccd1 MATMULT_INST.matmult_inst.miso sky130_fd_sc_hd__mux2_1
XANTENNA_fanout222_A net223 vssd1 vssd1 vccd1 vccd1 sky130_fd_sc_hd__diode_2
X_1869_ MATMULT_INST.matmult_inst.fsm_inst.load_delay _0543_ _0749_ vssd1 vssd1 vccd1
+ vccd1 MATMULT_INST.matmult_inst.fsm_inst.transaction_ready sky130_fd_sc_hd__and3_1
X_3608_ clknet_leaf_21_clk _0501_ _0106_ vssd1 vssd1 vccd1 vccd1 MATMULT_INST.matmult_inst.spi_inst.tx_reg_sys\[11\]
+ sky130_fd_sc_hd__dfrtp_1
XANTENNA__2166__B1 net10 vssd1 vssd1 vccd1 vccd1 sky130_fd_sc_hd__diode_2
XANTENNA_fanout108_X net108 vssd1 vssd1 vccd1 vccd1 sky130_fd_sc_hd__diode_2
X_3539_ _0046_ _0453_ _0045_ vssd1 vssd1 vccd1 vccd1 MATMULT_INST.matmult_inst.spi_inst.mosi_data_spi\[6\]
+ sky130_fd_sc_hd__dfrtp_1
XTAP_TAPCELL_ROW_27_402 vssd1 vccd1 sky130_fd_sc_hd__tapvpwrvgnd_1
XTAP_TAPCELL_ROW_70_769 vssd1 vccd1 sky130_fd_sc_hd__tapvpwrvgnd_1
XFILLER_16_97 vssd1 vssd1 vccd1 vccd1 sky130_fd_sc_hd__fill_1
XFILLER_40_421 vssd1 vssd1 vccd1 vccd1 sky130_fd_sc_hd__fill_2
XFILLER_52_281 vssd1 vssd1 vccd1 vccd1 sky130_fd_sc_hd__fill_1
XFILLER_4_300 vssd1 vssd1 vccd1 vccd1 sky130_fd_sc_hd__fill_2
XPHY_EDGE_ROW_26_Left_106 vssd1 vssd1 vccd1 vccd1 sky130_fd_sc_hd__decap_3
XFILLER_4_388 vssd1 vssd1 vccd1 vccd1 sky130_fd_sc_hd__fill_1
XANTENNA__1904__B1 net71 vssd1 vssd1 vccd1 vccd1 sky130_fd_sc_hd__diode_2
XANTENNA__1715__A net152 vssd1 vssd1 vccd1 vccd1 sky130_fd_sc_hd__diode_2
XFILLER_79_134 vssd1 vssd1 vccd1 vccd1 sky130_fd_sc_hd__fill_4
XFILLER_67_307 vssd1 vssd1 vccd1 vccd1 sky130_fd_sc_hd__fill_1
XFILLER_79_167 vssd1 vssd1 vccd1 vccd1 sky130_fd_sc_hd__fill_1
XTAP_TAPCELL_ROW_78_836 vssd1 vccd1 sky130_fd_sc_hd__tapvpwrvgnd_1
XFILLER_75_351 vssd1 vssd1 vccd1 vccd1 sky130_fd_sc_hd__fill_4
XANTENNA__1683__A2 net129 vssd1 vssd1 vccd1 vccd1 sky130_fd_sc_hd__diode_2
XANTENNA_clkload0_A clknet_2_0__leaf_clk vssd1 vssd1 vccd1 vccd1 sky130_fd_sc_hd__diode_2
XPHY_EDGE_ROW_35_Left_115 vssd1 vssd1 vccd1 vccd1 sky130_fd_sc_hd__decap_3
XFILLER_16_451 vssd1 vssd1 vccd1 vccd1 sky130_fd_sc_hd__fill_2
X_2910_ _1441_ _1450_ vssd1 vssd1 vccd1 vccd1 _1451_ sky130_fd_sc_hd__nand2_1
XFILLER_16_473 vssd1 vssd1 vccd1 vccd1 sky130_fd_sc_hd__fill_2
XFILLER_50_207 vssd1 vssd1 vccd1 vccd1 sky130_fd_sc_hd__fill_4
XTAP_TAPCELL_ROW_33_449 vssd1 vccd1 sky130_fd_sc_hd__tapvpwrvgnd_1
X_2841_ net175 net164 net162 net176 vssd1 vssd1 vccd1 vccd1 _1384_ sky130_fd_sc_hd__a22oi_1
XFILLER_78_3 vssd1 vssd1 vccd1 vccd1 sky130_fd_sc_hd__fill_8
X_2772_ _1315_ _1316_ vssd1 vssd1 vccd1 vccd1 _1317_ sky130_fd_sc_hd__nand2_1
X_1723_ net152 net144 MATMULT_INST.matmult_inst.mem_inst.matrixB3\[8\] vssd1 vssd1
+ vccd1 vccd1 _0644_ sky130_fd_sc_hd__and3_1
XANTENNA__3527__D net63 vssd1 vssd1 vccd1 vccd1 sky130_fd_sc_hd__diode_2
XFILLER_7_171 vssd1 vssd1 vccd1 vccd1 sky130_fd_sc_hd__fill_1
Xhold116 MATMULT_INST.matmult_inst.mem_inst.mem1\[6\] vssd1 vssd1 vccd1 vccd1 net411
+ sky130_fd_sc_hd__dlygate4sd3_1
XPHY_EDGE_ROW_44_Left_124 vssd1 vssd1 vccd1 vccd1 sky130_fd_sc_hd__decap_3
Xhold105 _0487_ vssd1 vssd1 vccd1 vccd1 net400 sky130_fd_sc_hd__dlygate4sd3_1
X_1654_ MATMULT_INST.matmult_inst.mem_inst.mem1\[15\] net126 net118 MATMULT_INST.matmult_inst.mem_inst.mem2\[15\]
+ _0581_ vssd1 vssd1 vccd1 vccd1 _0582_ sky130_fd_sc_hd__a221o_1
Xhold138 MATMULT_INST.matmult_inst.mem_inst.matrixB3\[8\] vssd1 vssd1 vccd1 vccd1
+ net433 sky130_fd_sc_hd__dlygate4sd3_1
Xhold127 MATMULT_INST.matmult_inst.mem_inst.matrixA0\[11\] vssd1 vssd1 vccd1 vccd1
+ net422 sky130_fd_sc_hd__dlygate4sd3_1
Xhold149 MATMULT_INST.matmult_inst.alu_inst.col0\[4\] vssd1 vssd1 vccd1 vccd1 net444
+ sky130_fd_sc_hd__dlygate4sd3_1
X_3324_ clknet_leaf_20_clk _0246_ vssd1 vssd1 vccd1 vccd1 MATMULT_INST.matmult_inst.mem_inst.matrixA0\[15\]
+ sky130_fd_sc_hd__dfxtp_1
X_3255_ clknet_leaf_7_clk _0177_ vssd1 vssd1 vccd1 vccd1 MATMULT_INST.matmult_inst.mem_inst.matrixA3\[0\]
+ sky130_fd_sc_hd__dfxtp_1
X_2206_ net189 net609 net65 vssd1 vssd1 vccd1 vccd1 _0338_ sky130_fd_sc_hd__mux2_1
X_3186_ net58 net88 net74 vssd1 vssd1 vccd1 vccd1 _0111_ sky130_fd_sc_hd__and3_1
XPHY_EDGE_ROW_53_Left_133 vssd1 vssd1 vccd1 vccd1 sky130_fd_sc_hd__decap_3
XANTENNA__1674__A2 _0557_ vssd1 vssd1 vccd1 vccd1 sky130_fd_sc_hd__diode_2
XANTENNA_fanout172_A net173 vssd1 vssd1 vccd1 vccd1 sky130_fd_sc_hd__diode_2
XANTENNA__3051__S net8 vssd1 vssd1 vccd1 vccd1 sky130_fd_sc_hd__diode_2
X_2137_ net411 net43 net12 vssd1 vssd1 vccd1 vccd1 _0291_ sky130_fd_sc_hd__mux2_1
X_2068_ net445 net36 net20 vssd1 vssd1 vccd1 vccd1 _0226_ sky130_fd_sc_hd__mux2_1
XPHY_EDGE_ROW_62_Left_142 vssd1 vssd1 vccd1 vccd1 sky130_fd_sc_hd__decap_3
XANTENNA__2341__D net210 vssd1 vssd1 vccd1 vccd1 sky130_fd_sc_hd__diode_2
XFILLER_1_314 vssd1 vssd1 vccd1 vccd1 sky130_fd_sc_hd__fill_2
XANTENNA_fanout85_A net86 vssd1 vssd1 vccd1 vccd1 sky130_fd_sc_hd__diode_2
XPHY_EDGE_ROW_71_Left_151 vssd1 vssd1 vccd1 vccd1 sky130_fd_sc_hd__decap_3
XTAP_TAPCELL_ROW_75_806 vssd1 vccd1 sky130_fd_sc_hd__tapvpwrvgnd_1
XFILLER_17_259 vssd1 vssd1 vccd1 vccd1 sky130_fd_sc_hd__fill_8
XFILLER_25_281 vssd1 vssd1 vccd1 vccd1 sky130_fd_sc_hd__fill_4
XFILLER_40_251 vssd1 vssd1 vccd1 vccd1 sky130_fd_sc_hd__fill_1
XFILLER_4_174 vssd1 vssd1 vccd1 vccd1 sky130_fd_sc_hd__fill_2
XANTENNA__2040__S net22 vssd1 vssd1 vccd1 vccd1 sky130_fd_sc_hd__diode_2
XFILLER_67_115 vssd1 vssd1 vccd1 vccd1 sky130_fd_sc_hd__fill_1
XFILLER_4_78 vssd1 vssd1 vccd1 vccd1 sky130_fd_sc_hd__fill_4
XFILLER_0_391 vssd1 vssd1 vccd1 vccd1 sky130_fd_sc_hd__fill_1
X_3040_ net94 _1573_ _1574_ _1575_ vssd1 vssd1 vccd1 vccd1 _0440_ sky130_fd_sc_hd__a31o_1
XFILLER_48_362 vssd1 vssd1 vccd1 vccd1 sky130_fd_sc_hd__fill_2
XANTENNA__1656__A2 net64 vssd1 vssd1 vccd1 vccd1 sky130_fd_sc_hd__diode_2
XTAP_TAPCELL_ROW_46_563 vssd1 vccd1 sky130_fd_sc_hd__tapvpwrvgnd_1
X_2824_ _1336_ _1364_ _1367_ vssd1 vssd1 vccd1 vccd1 _1368_ sky130_fd_sc_hd__o21a_1
XANTENNA__2442__C net200 vssd1 vssd1 vccd1 vccd1 sky130_fd_sc_hd__diode_2
X_2755_ net182 net165 net163 net180 vssd1 vssd1 vccd1 vccd1 _1301_ sky130_fd_sc_hd__and4_1
X_2686_ net82 _1253_ _1254_ net598 vssd1 vssd1 vccd1 vccd1 _0407_ sky130_fd_sc_hd__a22o_1
X_1706_ net222 _0557_ _0628_ vssd1 vssd1 vccd1 vccd1 _0629_ sky130_fd_sc_hd__and3_1
X_1637_ MATMULT_INST.matmult_inst.mem_inst.mem1\[16\] net127 net119 MATMULT_INST.matmult_inst.mem_inst.mem2\[16\]
+ _0565_ vssd1 vssd1 vccd1 vccd1 _0566_ sky130_fd_sc_hd__a221o_1
XANTENNA__3046__S net8 vssd1 vssd1 vccd1 vccd1 sky130_fd_sc_hd__diode_2
X_3307_ clknet_leaf_11_clk _0229_ vssd1 vssd1 vccd1 vccd1 MATMULT_INST.matmult_inst.mem_inst.matrixA1\[16\]
+ sky130_fd_sc_hd__dfxtp_1
XFILLER_58_137 vssd1 vssd1 vccd1 vccd1 sky130_fd_sc_hd__fill_2
X_3238_ clknet_leaf_5_clk _0160_ vssd1 vssd1 vccd1 vccd1 MATMULT_INST.matmult_inst.mem_inst.matrixB0\[1\]
+ sky130_fd_sc_hd__dfxtp_1
X_3169_ net61 net91 net78 vssd1 vssd1 vccd1 vccd1 _0094_ sky130_fd_sc_hd__and3_1
XTAP_TAPCELL_ROW_1_177 vssd1 vccd1 sky130_fd_sc_hd__tapvpwrvgnd_1
XFILLER_54_365 vssd1 vssd1 vccd1 vccd1 sky130_fd_sc_hd__fill_2
Xfanout11 _0824_ vssd1 vssd1 vccd1 vccd1 net11 sky130_fd_sc_hd__buf_2
Xfanout22 _0818_ vssd1 vssd1 vccd1 vccd1 net22 sky130_fd_sc_hd__buf_4
Xfanout33 _0813_ vssd1 vssd1 vccd1 vccd1 net33 sky130_fd_sc_hd__clkbuf_2
XFILLER_22_251 vssd1 vssd1 vccd1 vccd1 sky130_fd_sc_hd__fill_1
Xfanout44 _0802_ vssd1 vssd1 vccd1 vccd1 net44 sky130_fd_sc_hd__clkbuf_2
Xfanout55 net56 vssd1 vssd1 vccd1 vccd1 net55 sky130_fd_sc_hd__clkbuf_2
Xfanout88 _0735_ vssd1 vssd1 vccd1 vccd1 net88 sky130_fd_sc_hd__buf_1
XANTENNA__2125__S net14 vssd1 vssd1 vccd1 vccd1 sky130_fd_sc_hd__diode_2
Xfanout66 _0532_ vssd1 vssd1 vccd1 vccd1 net66 sky130_fd_sc_hd__buf_2
Xfanout99 net100 vssd1 vssd1 vccd1 vccd1 net99 sky130_fd_sc_hd__clkbuf_4
Xfanout77 net81 vssd1 vssd1 vccd1 vccd1 net77 sky130_fd_sc_hd__buf_1
XFILLER_13_54 vssd1 vssd1 vccd1 vccd1 sky130_fd_sc_hd__fill_2
XFILLER_6_417 vssd1 vssd1 vccd1 vccd1 sky130_fd_sc_hd__fill_2
XANTENNA__1817__X _0730_ vssd1 vssd1 vccd1 vccd1 sky130_fd_sc_hd__diode_2
XFILLER_8_3 vssd1 vssd1 vccd1 vccd1 sky130_fd_sc_hd__fill_4
XFILLER_1_111 vssd1 vssd1 vccd1 vccd1 sky130_fd_sc_hd__fill_1
XFILLER_77_413 vccd1 vssd1 vccd1 vssd1 sky130_ef_sc_hd__decap_40_12
XFILLER_1_144 vccd1 vssd1 vccd1 vssd1 sky130_ef_sc_hd__decap_40_12
XFILLER_49_115 vssd1 vssd1 vccd1 vccd1 sky130_fd_sc_hd__fill_1
XFILLER_38_95 vssd1 vssd1 vccd1 vccd1 sky130_fd_sc_hd__fill_8
XFILLER_45_310 vssd1 vssd1 vccd1 vccd1 sky130_fd_sc_hd__fill_8
XFILLER_57_181 vssd1 vssd1 vccd1 vccd1 sky130_fd_sc_hd__fill_8
XFILLER_54_83 vssd1 vssd1 vccd1 vccd1 sky130_fd_sc_hd__fill_1
XFILLER_9_222 vssd1 vssd1 vccd1 vccd1 sky130_fd_sc_hd__fill_2
XFILLER_70_60 vssd1 vssd1 vccd1 vccd1 sky130_fd_sc_hd__fill_1
XFILLER_9_255 vssd1 vssd1 vccd1 vccd1 sky130_fd_sc_hd__fill_1
Xclkload25 clknet_leaf_31_clk vssd1 vssd1 vccd1 vccd1 clkload25/Y sky130_fd_sc_hd__inv_12
Xclkload14 clknet_leaf_8_clk vssd1 vssd1 vccd1 vccd1 clkload14/X sky130_fd_sc_hd__clkbuf_8
X_2540_ _1130_ _1131_ _1123_ vssd1 vssd1 vccd1 vccd1 _1132_ sky130_fd_sc_hd__a21oi_1
X_2471_ _1032_ _1063_ _1064_ vssd1 vssd1 vccd1 vccd1 _1065_ sky130_fd_sc_hd__and3_1
XFILLER_79_80 vssd1 vssd1 vccd1 vccd1 sky130_fd_sc_hd__fill_2
XFILLER_79_91 vssd1 vssd1 vccd1 vccd1 sky130_fd_sc_hd__fill_1
XFILLER_55_107 vssd1 vssd1 vccd1 vccd1 sky130_fd_sc_hd__fill_4
XANTENNA__1622__B net143 vssd1 vssd1 vccd1 vccd1 sky130_fd_sc_hd__diode_2
X_3023_ _1557_ _1558_ _1559_ vssd1 vssd1 vccd1 vccd1 _1560_ sky130_fd_sc_hd__and3_1
XFILLER_36_343 vccd1 vssd1 vccd1 vssd1 sky130_ef_sc_hd__decap_40_12
XTAP_TAPCELL_ROW_14_290 vssd1 vccd1 sky130_fd_sc_hd__tapvpwrvgnd_1
Xclkload8 clknet_leaf_35_clk vssd1 vssd1 vccd1 vccd1 clkload8/Y sky130_fd_sc_hd__clkinv_8
XANTENNA__1801__A2 net128 vssd1 vssd1 vccd1 vccd1 sky130_fd_sc_hd__diode_2
X_2807_ _1349_ _1350_ vssd1 vssd1 vccd1 vccd1 _1351_ sky130_fd_sc_hd__or2_1
X_2738_ net168 net166 net179 net180 vssd1 vssd1 vccd1 vccd1 _1285_ sky130_fd_sc_hd__and4_1
X_2669_ net486 _1246_ _1249_ net103 vssd1 vssd1 vccd1 vccd1 _0395_ sky130_fd_sc_hd__a22o_1
XTAP_TAPCELL_ROW_6_225 vssd1 vccd1 sky130_fd_sc_hd__tapvpwrvgnd_1
Xfanout201 net203 vssd1 vssd1 vccd1 vccd1 net201 sky130_fd_sc_hd__buf_2
Xfanout212 MATMULT_INST.matmult_inst.alu_inst.b0_reg\[1\] vssd1 vssd1 vccd1 vccd1
+ net212 sky130_fd_sc_hd__buf_2
Xfanout223 MATMULT_INST.matmult_inst.fsm_inst.sel\[0\] vssd1 vssd1 vccd1 vccd1 net223
+ sky130_fd_sc_hd__clkbuf_4
XFILLER_75_16 vssd1 vssd1 vccd1 vccd1 sky130_fd_sc_hd__fill_1
XTAP_TAPCELL_ROW_57_658 vssd1 vccd1 sky130_fd_sc_hd__tapvpwrvgnd_1
XANTENNA__1959__S net31 vssd1 vssd1 vccd1 vccd1 sky130_fd_sc_hd__diode_2
XANTENNA_fanout48_A _0798_ vssd1 vssd1 vccd1 vccd1 sky130_fd_sc_hd__diode_2
XFILLER_54_195 vssd1 vssd1 vccd1 vccd1 sky130_fd_sc_hd__fill_1
XANTENNA__3178__C net74 vssd1 vssd1 vccd1 vccd1 sky130_fd_sc_hd__diode_2
XTAP_TAPCELL_ROW_40_514 vssd1 vccd1 sky130_fd_sc_hd__tapvpwrvgnd_1
XFILLER_6_225 vccd1 vssd1 vccd1 vssd1 sky130_ef_sc_hd__decap_40_12
XANTENNA__1707__B net143 vssd1 vssd1 vccd1 vccd1 sky130_fd_sc_hd__diode_2
XFILLER_40_85 vccd1 vssd1 vccd1 vssd1 sky130_ef_sc_hd__decap_40_12
XFILLER_2_475 vssd1 vssd1 vccd1 vccd1 sky130_fd_sc_hd__fill_1
XANTENNA__1723__A net152 vssd1 vssd1 vccd1 vccd1 sky130_fd_sc_hd__diode_2
XFILLER_77_276 vssd1 vssd1 vccd1 vccd1 sky130_fd_sc_hd__fill_4
XFILLER_1_57 vssd1 vssd1 vccd1 vccd1 sky130_fd_sc_hd__fill_4
XFILLER_33_302 vssd1 vssd1 vccd1 vccd1 sky130_fd_sc_hd__fill_1
XFILLER_73_493 vssd1 vssd1 vccd1 vccd1 sky130_fd_sc_hd__fill_1
XFILLER_33_324 vssd1 vssd1 vccd1 vccd1 sky130_fd_sc_hd__fill_4
XFILLER_45_184 vssd1 vssd1 vccd1 vccd1 sky130_fd_sc_hd__fill_1
XFILLER_60_165 vssd1 vssd1 vccd1 vccd1 sky130_fd_sc_hd__fill_1
X_1971_ net543 net35 net31 vssd1 vssd1 vccd1 vccd1 _0137_ sky130_fd_sc_hd__mux2_1
X_3641_ clknet_leaf_25_clk net338 vssd1 vssd1 vccd1 vccd1 MATMULT_INST.matmult_inst.fsm_inst.alu_result\[17\]
+ sky130_fd_sc_hd__dfxtp_1
X_3572_ clknet_leaf_22_clk net574 _0070_ vssd1 vssd1 vccd1 vccd1 MATMULT_INST.matmult_inst.fsm_inst.rx_data\[2\]
+ sky130_fd_sc_hd__dfrtp_1
XFILLER_60_3 vccd1 vssd1 vccd1 vssd1 sky130_ef_sc_hd__decap_40_12
X_2523_ _1113_ _1114_ vssd1 vssd1 vccd1 vccd1 _1115_ sky130_fd_sc_hd__nor2_1
XANTENNA__2720__C net97 vssd1 vssd1 vccd1 vccd1 sky130_fd_sc_hd__diode_2
X_2454_ net204 net206 net193 net191 vssd1 vssd1 vccd1 vccd1 _1048_ sky130_fd_sc_hd__and4_1
X_2385_ net208 net194 net191 net210 vssd1 vssd1 vccd1 vccd1 _0981_ sky130_fd_sc_hd__nand4_2
Xinput1 gpio_in[0] vssd1 vssd1 vccd1 vccd1 net1 sky130_fd_sc_hd__dlymetal6s2s_1
XFILLER_56_416 vssd1 vssd1 vccd1 vccd1 sky130_fd_sc_hd__fill_4
XFILLER_45_19 vssd1 vssd1 vccd1 vccd1 sky130_fd_sc_hd__fill_1
X_3006_ _1543_ vssd1 vssd1 vccd1 vccd1 _1544_ sky130_fd_sc_hd__inv_2
XTAP_TAPCELL_ROW_54_628 vssd1 vccd1 sky130_fd_sc_hd__tapvpwrvgnd_1
XFILLER_64_493 vssd1 vssd1 vccd1 vccd1 sky130_fd_sc_hd__fill_1
XFILLER_36_195 vssd1 vssd1 vccd1 vccd1 sky130_fd_sc_hd__fill_1
XFILLER_24_357 vssd1 vssd1 vccd1 vccd1 sky130_fd_sc_hd__fill_4
XFILLER_59_221 vssd1 vssd1 vccd1 vccd1 sky130_fd_sc_hd__fill_1
XANTENNA__1830__X _0734_ vssd1 vssd1 vccd1 vccd1 sky130_fd_sc_hd__diode_2
XFILLER_74_279 vccd1 vssd1 vccd1 vssd1 sky130_ef_sc_hd__decap_40_12
XFILLER_62_419 vssd1 vssd1 vccd1 vccd1 sky130_fd_sc_hd__fill_1
XFILLER_27_151 vssd1 vssd1 vccd1 vccd1 sky130_fd_sc_hd__fill_8
XFILLER_15_313 vccd1 vssd1 vccd1 vssd1 sky130_ef_sc_hd__decap_40_12
XTAP_TAPCELL_ROW_17_319 vssd1 vccd1 sky130_fd_sc_hd__tapvpwrvgnd_1
XFILLER_70_441 vccd1 vssd1 vccd1 vssd1 sky130_ef_sc_hd__decap_40_12
XTAP_TAPCELL_ROW_25_385 vssd1 vccd1 sky130_fd_sc_hd__tapvpwrvgnd_1
XANTENNA__2380__Y _0977_ vssd1 vssd1 vccd1 vccd1 sky130_fd_sc_hd__diode_2
XFILLER_2_261 vssd1 vssd1 vccd1 vccd1 sky130_fd_sc_hd__fill_2
X_2170_ net134 _0785_ _0768_ vssd1 vssd1 vccd1 vccd1 _0827_ sky130_fd_sc_hd__o21ai_2
XFILLER_18_184 vssd1 vssd1 vccd1 vccd1 sky130_fd_sc_hd__fill_2
XFILLER_18_195 vssd1 vssd1 vccd1 vccd1 sky130_fd_sc_hd__fill_1
XFILLER_61_463 vssd1 vssd1 vccd1 vccd1 sky130_fd_sc_hd__fill_1
XFILLER_33_121 vccd1 vssd1 vccd1 vssd1 sky130_ef_sc_hd__decap_40_12
XTAP_TAPCELL_ROW_51_609 vssd1 vccd1 sky130_fd_sc_hd__tapvpwrvgnd_1
XANTENNA__2009__A2 net38 vssd1 vssd1 vccd1 vccd1 sky130_fd_sc_hd__diode_2
XFILLER_21_349 vccd1 vssd1 vccd1 vssd1 sky130_ef_sc_hd__decap_40_12
X_1954_ MATMULT_INST.matmult_inst.fsm_inst.rx_data\[6\] net71 net70 MATMULT_INST.matmult_inst.fsm_inst.alu_result\[6\]
+ vssd1 vssd1 vccd1 vccd1 _0803_ sky130_fd_sc_hd__a22o_2
XANTENNA__1768__B2 net222 vssd1 vssd1 vccd1 vccd1 sky130_fd_sc_hd__diode_2
X_1885_ _0757_ _0762_ vssd1 vssd1 vccd1 vccd1 _0763_ sky130_fd_sc_hd__nand2_1
X_3624_ clknet_leaf_24_clk net601 vssd1 vssd1 vccd1 vccd1 MATMULT_INST.matmult_inst.fsm_inst.alu_result\[0\]
+ sky130_fd_sc_hd__dfxtp_1
XANTENNA__1628__A net219 vssd1 vssd1 vccd1 vccd1 sky130_fd_sc_hd__diode_2
X_3555_ clknet_leaf_3_clk _0467_ vssd1 vssd1 vccd1 vccd1 MATMULT_INST.matmult_inst.mem_inst.matrixB3\[3\]
+ sky130_fd_sc_hd__dfxtp_1
X_2506_ _1045_ _1062_ _1044_ vssd1 vssd1 vccd1 vccd1 _1099_ sky130_fd_sc_hd__o21bai_1
XFILLER_0_209 vccd1 vssd1 vccd1 vssd1 sky130_ef_sc_hd__decap_40_12
X_3486_ clknet_leaf_0_clk _0406_ vssd1 vssd1 vccd1 vccd1 MATMULT_INST.matmult_inst.alu_inst.col0\[6\]
+ sky130_fd_sc_hd__dfxtp_1
X_2437_ net636 _1031_ net98 vssd1 vssd1 vccd1 vccd1 _0381_ sky130_fd_sc_hd__mux2_1
XANTENNA__3054__S net8 vssd1 vssd1 vccd1 vccd1 sky130_fd_sc_hd__diode_2
X_2368_ net212 net194 net192 net211 vssd1 vssd1 vccd1 vccd1 _0965_ sky130_fd_sc_hd__and4_1
XFILLER_29_405 vssd1 vssd1 vccd1 vccd1 sky130_fd_sc_hd__fill_2
XFILLER_29_416 vssd1 vssd1 vccd1 vccd1 sky130_fd_sc_hd__fill_1
XFILLER_56_29 vssd1 vssd1 vccd1 vccd1 sky130_fd_sc_hd__fill_2
XTAP_TAPCELL_ROW_67_742 vssd1 vccd1 sky130_fd_sc_hd__tapvpwrvgnd_1
X_2299_ _0919_ _0920_ vssd1 vssd1 vccd1 vccd1 _0921_ sky130_fd_sc_hd__xnor2_2
XFILLER_37_471 vssd1 vssd1 vccd1 vccd1 sky130_fd_sc_hd__fill_2
XFILLER_37_493 vssd1 vssd1 vccd1 vccd1 sky130_fd_sc_hd__fill_1
XFILLER_12_327 vccd1 vssd1 vccd1 vssd1 sky130_ef_sc_hd__decap_40_12
XFILLER_12_305 vssd1 vssd1 vccd1 vccd1 sky130_fd_sc_hd__fill_2
XFILLER_52_474 vssd1 vssd1 vccd1 vccd1 sky130_fd_sc_hd__fill_2
XFILLER_12_349 vssd1 vssd1 vccd1 vccd1 sky130_fd_sc_hd__fill_1
XFILLER_8_309 vssd1 vssd1 vccd1 vccd1 sky130_fd_sc_hd__fill_8
XTAP_TAPCELL_ROW_22_355 vssd1 vccd1 sky130_fd_sc_hd__tapvpwrvgnd_1
XANTENNA__2133__S net13 vssd1 vssd1 vccd1 vccd1 sky130_fd_sc_hd__diode_2
XFILLER_79_305 vssd1 vssd1 vccd1 vccd1 sky130_fd_sc_hd__fill_2
XFILLER_79_349 vccd1 vssd1 vccd1 vssd1 sky130_ef_sc_hd__decap_40_12
XFILLER_79_316 vssd1 vssd1 vccd1 vccd1 sky130_fd_sc_hd__fill_1
XFILLER_62_205 vssd1 vssd1 vccd1 vccd1 sky130_fd_sc_hd__fill_1
XFILLER_35_408 vssd1 vssd1 vccd1 vccd1 sky130_fd_sc_hd__fill_4
XFILLER_28_493 vssd1 vssd1 vccd1 vccd1 sky130_fd_sc_hd__fill_1
XFILLER_46_62 vssd1 vssd1 vccd1 vccd1 sky130_fd_sc_hd__fill_2
XFILLER_62_249 vssd1 vssd1 vccd1 vccd1 sky130_fd_sc_hd__fill_1
XTAP_TAPCELL_ROW_73_789 vssd1 vccd1 sky130_fd_sc_hd__tapvpwrvgnd_1
XFILLER_15_165 vssd1 vssd1 vccd1 vccd1 sky130_fd_sc_hd__fill_2
XFILLER_15_187 vssd1 vssd1 vccd1 vccd1 sky130_fd_sc_hd__fill_1
XFILLER_30_179 vssd1 vssd1 vccd1 vccd1 sky130_fd_sc_hd__fill_4
XFILLER_11_393 vccd1 vssd1 vccd1 vssd1 sky130_ef_sc_hd__decap_40_12
XFILLER_11_382 vssd1 vssd1 vccd1 vccd1 sky130_fd_sc_hd__fill_8
XFILLER_7_331 vssd1 vssd1 vccd1 vccd1 sky130_fd_sc_hd__fill_4
XFILLER_7_320 vssd1 vssd1 vccd1 vccd1 sky130_fd_sc_hd__fill_1
XANTENNA__2043__S net23 vssd1 vssd1 vccd1 vccd1 sky130_fd_sc_hd__diode_2
X_1670_ net150 net141 MATMULT_INST.matmult_inst.mem_inst.mem3\[13\] vssd1 vssd1 vccd1
+ vccd1 _0596_ sky130_fd_sc_hd__and3_1
Xhold309 MATMULT_INST.matmult_inst.mem_inst.mem0\[5\] vssd1 vssd1 vccd1 vccd1 net604
+ sky130_fd_sc_hd__dlygate4sd3_1
X_3340_ clknet_leaf_9_clk _0262_ vssd1 vssd1 vccd1 vccd1 MATMULT_INST.matmult_inst.mem_inst.mem3\[13\]
+ sky130_fd_sc_hd__dfxtp_1
X_3271_ clknet_leaf_11_clk _0193_ vssd1 vssd1 vccd1 vccd1 MATMULT_INST.matmult_inst.mem_inst.matrixA3\[16\]
+ sky130_fd_sc_hd__dfxtp_1
XFILLER_23_3 vssd1 vssd1 vccd1 vccd1 sky130_fd_sc_hd__fill_4
X_2222_ _0853_ _0855_ vssd1 vssd1 vccd1 vccd1 _0856_ sky130_fd_sc_hd__xnor2_1
X_2153_ net46 net550 net10 vssd1 vssd1 vccd1 vccd1 _0306_ sky130_fd_sc_hd__mux2_1
XTAP_TAPCELL_ROW_64_712 vssd1 vccd1 sky130_fd_sc_hd__tapvpwrvgnd_1
X_2084_ net372 _0807_ net19 vssd1 vssd1 vccd1 vccd1 _0241_ sky130_fd_sc_hd__mux2_1
XFILLER_19_493 vssd1 vssd1 vccd1 vccd1 sky130_fd_sc_hd__fill_1
XANTENNA__1989__A1 net39 vssd1 vssd1 vccd1 vccd1 sky130_fd_sc_hd__diode_2
XFILLER_61_293 vssd1 vssd1 vccd1 vccd1 sky130_fd_sc_hd__fill_1
XFILLER_21_113 vccd1 vssd1 vccd1 vssd1 sky130_ef_sc_hd__decap_40_12
X_2986_ _1496_ _1524_ vssd1 vssd1 vccd1 vccd1 _1525_ sky130_fd_sc_hd__nand2_1
X_1937_ MATMULT_INST.matmult_inst.spi_inst.tx_reg_sys\[16\] MATMULT_INST.matmult_inst.spi_inst.miso_shifter\[15\]
+ net137 vssd1 vssd1 vccd1 vccd1 _0006_ sky130_fd_sc_hd__mux2_1
XANTENNA__3049__S net8 vssd1 vssd1 vccd1 vccd1 sky130_fd_sc_hd__diode_2
X_1868_ MATMULT_INST.matmult_inst.fsm_inst.count\[1\] _0748_ vssd1 vssd1 vccd1 vccd1
+ _0749_ sky130_fd_sc_hd__and2_1
X_3607_ clknet_leaf_21_clk _0500_ _0105_ vssd1 vssd1 vccd1 vccd1 MATMULT_INST.matmult_inst.spi_inst.tx_reg_sys\[10\]
+ sky130_fd_sc_hd__dfrtp_1
XANTENNA__2166__A1 net111 vssd1 vssd1 vccd1 vccd1 sky130_fd_sc_hd__diode_2
X_3538_ _0044_ _0452_ _0043_ vssd1 vssd1 vccd1 vccd1 MATMULT_INST.matmult_inst.spi_inst.mosi_data_spi\[5\]
+ sky130_fd_sc_hd__dfrtp_1
X_1799_ net216 MATMULT_INST.matmult_inst.mem_inst.mem3\[1\] _0712_ vssd1 vssd1 vccd1
+ vccd1 _0713_ sky130_fd_sc_hd__a21o_1
XFILLER_67_39 vssd1 vssd1 vccd1 vccd1 sky130_fd_sc_hd__fill_1
XFILLER_67_17 vssd1 vssd1 vccd1 vccd1 sky130_fd_sc_hd__fill_4
X_3469_ clknet_leaf_36_clk _0390_ vssd1 vssd1 vccd1 vccd1 MATMULT_INST.matmult_inst.alu_inst.adder_inst.r3.fa3.a
+ sky130_fd_sc_hd__dfxtp_1
XFILLER_29_235 vssd1 vssd1 vccd1 vccd1 sky130_fd_sc_hd__fill_1
XTAP_TAPCELL_ROW_27_403 vssd1 vccd1 sky130_fd_sc_hd__tapvpwrvgnd_1
XANTENNA__2128__S net14 vssd1 vssd1 vccd1 vccd1 sky130_fd_sc_hd__diode_2
XFILLER_25_441 vssd1 vssd1 vccd1 vccd1 sky130_fd_sc_hd__fill_4
XFILLER_16_76 vssd1 vssd1 vccd1 vccd1 sky130_fd_sc_hd__fill_1
XANTENNA__1967__S net31 vssd1 vssd1 vccd1 vccd1 sky130_fd_sc_hd__diode_2
XFILLER_12_135 vssd1 vssd1 vccd1 vccd1 sky130_fd_sc_hd__fill_4
XFILLER_40_444 vssd1 vssd1 vccd1 vccd1 sky130_fd_sc_hd__fill_2
XFILLER_8_139 vssd1 vssd1 vccd1 vccd1 sky130_fd_sc_hd__fill_1
XFILLER_32_53 vssd1 vssd1 vccd1 vccd1 sky130_fd_sc_hd__fill_8
XANTENNA__3186__C net74 vssd1 vssd1 vccd1 vccd1 sky130_fd_sc_hd__diode_2
XFILLER_4_312 vssd1 vssd1 vccd1 vccd1 sky130_fd_sc_hd__fill_4
XFILLER_79_113 vssd1 vssd1 vccd1 vccd1 sky130_fd_sc_hd__fill_8
XANTENNA_clkbuf_leaf_19_clk_A clknet_2_3__leaf_clk vssd1 vssd1 vccd1 vccd1 sky130_fd_sc_hd__diode_2
XANTENNA__1904__A1 net221 vssd1 vssd1 vccd1 vccd1 sky130_fd_sc_hd__diode_2
XANTENNA__1715__B net143 vssd1 vssd1 vccd1 vccd1 sky130_fd_sc_hd__diode_2
XTAP_TAPCELL_ROW_78_837 vssd1 vccd1 sky130_fd_sc_hd__tapvpwrvgnd_1
XANTENNA__2038__S net22 vssd1 vssd1 vccd1 vccd1 sky130_fd_sc_hd__diode_2
XFILLER_73_93 vssd1 vssd1 vccd1 vccd1 sky130_fd_sc_hd__fill_1
X_2840_ _1352_ _1354_ _1353_ vssd1 vssd1 vccd1 vccd1 _1383_ sky130_fd_sc_hd__a21bo_1
X_2771_ net179 net164 net163 net180 vssd1 vssd1 vccd1 vccd1 _1316_ sky130_fd_sc_hd__a22o_1
X_1722_ MATMULT_INST.matmult_inst.mem_inst.matrixA1\[8\] net130 net122 MATMULT_INST.matmult_inst.mem_inst.matrixA2\[8\]
+ _0642_ vssd1 vssd1 vccd1 vccd1 _0643_ sky130_fd_sc_hd__a221o_1
Xhold117 MATMULT_INST.matmult_inst.mem_inst.matrixB0\[15\] vssd1 vssd1 vccd1 vccd1
+ net412 sky130_fd_sc_hd__dlygate4sd3_1
X_1653_ net151 net141 MATMULT_INST.matmult_inst.mem_inst.mem3\[15\] vssd1 vssd1 vccd1
+ vccd1 _0581_ sky130_fd_sc_hd__and3_1
Xhold106 MATMULT_INST.matmult_inst.mem_inst.matrixB2\[6\] vssd1 vssd1 vccd1 vccd1
+ net401 sky130_fd_sc_hd__dlygate4sd3_1
Xhold139 MATMULT_INST.matmult_inst.mem_inst.matrixB1\[12\] vssd1 vssd1 vccd1 vccd1
+ net434 sky130_fd_sc_hd__dlygate4sd3_1
Xhold128 MATMULT_INST.matmult_inst.mem_inst.matrixB1\[8\] vssd1 vssd1 vccd1 vccd1
+ net423 sky130_fd_sc_hd__dlygate4sd3_1
XPHY_EDGE_ROW_9_Right_9 vssd1 vssd1 vccd1 vccd1 sky130_fd_sc_hd__decap_3
X_3323_ clknet_leaf_20_clk _0245_ vssd1 vssd1 vccd1 vccd1 MATMULT_INST.matmult_inst.mem_inst.matrixA0\[14\]
+ sky130_fd_sc_hd__dfxtp_1
X_3254_ clknet_leaf_12_clk _0176_ vssd1 vssd1 vccd1 vccd1 MATMULT_INST.matmult_inst.mem_inst.matrixB0\[17\]
+ sky130_fd_sc_hd__dfxtp_1
X_2205_ net190 net551 net65 vssd1 vssd1 vccd1 vccd1 _0337_ sky130_fd_sc_hd__mux2_1
X_3185_ net62 net88 net74 vssd1 vssd1 vccd1 vccd1 _0110_ sky130_fd_sc_hd__and3_1
X_2136_ net520 net44 net12 vssd1 vssd1 vccd1 vccd1 _0290_ sky130_fd_sc_hd__mux2_1
X_2067_ net539 net37 net21 vssd1 vssd1 vccd1 vccd1 _0225_ sky130_fd_sc_hd__mux2_1
XFILLER_41_208 vssd1 vssd1 vccd1 vccd1 sky130_fd_sc_hd__fill_1
X_2969_ _1506_ _1508_ vssd1 vssd1 vccd1 vccd1 _1509_ sky130_fd_sc_hd__xnor2_1
XANTENNA_fanout218_X net218 vssd1 vssd1 vccd1 vccd1 sky130_fd_sc_hd__diode_2
XANTENNA_fanout120_X net120 vssd1 vssd1 vccd1 vccd1 sky130_fd_sc_hd__diode_2
XANTENNA__2139__A1 _0805_ vssd1 vssd1 vccd1 vccd1 sky130_fd_sc_hd__diode_2
XTAP_TAPCELL_ROW_75_807 vssd1 vccd1 sky130_fd_sc_hd__tapvpwrvgnd_1
XFILLER_57_341 vssd1 vssd1 vccd1 vccd1 sky130_fd_sc_hd__fill_1
XFILLER_72_311 vssd1 vssd1 vccd1 vccd1 sky130_fd_sc_hd__fill_1
XFILLER_17_227 vssd1 vssd1 vccd1 vccd1 sky130_fd_sc_hd__fill_1
XFILLER_57_385 vssd1 vssd1 vccd1 vccd1 sky130_fd_sc_hd__fill_4
XFILLER_27_86 vssd1 vssd1 vccd1 vccd1 sky130_fd_sc_hd__fill_1
XFILLER_32_208 vccd1 vssd1 vccd1 vssd1 sky130_ef_sc_hd__decap_40_12
XANTENNA__2321__S net67 vssd1 vssd1 vccd1 vccd1 sky130_fd_sc_hd__diode_2
XFILLER_4_197 vssd1 vssd1 vccd1 vccd1 sky130_fd_sc_hd__fill_8
XFILLER_4_68 vssd1 vssd1 vccd1 vccd1 sky130_fd_sc_hd__fill_2
XFILLER_67_105 vssd1 vssd1 vccd1 vccd1 sky130_fd_sc_hd__fill_4
XFILLER_67_127 vssd1 vssd1 vccd1 vccd1 sky130_fd_sc_hd__fill_4
XTAP_TAPCELL_ROW_46_564 vssd1 vccd1 sky130_fd_sc_hd__tapvpwrvgnd_1
XFILLER_31_230 vssd1 vssd1 vccd1 vccd1 sky130_fd_sc_hd__fill_4
X_2823_ _1336_ _1365_ _1366_ vssd1 vssd1 vccd1 vccd1 _1367_ sky130_fd_sc_hd__a21bo_1
XFILLER_31_285 vssd1 vssd1 vccd1 vccd1 sky130_fd_sc_hd__fill_2
XANTENNA__2442__D net203 vssd1 vssd1 vccd1 vccd1 sky130_fd_sc_hd__diode_2
X_2754_ net184 net161 vssd1 vssd1 vccd1 vccd1 _1300_ sky130_fd_sc_hd__and2_1
X_1705_ MATMULT_INST.matmult_inst.mem_inst.matrixA1\[10\] net127 net119 MATMULT_INST.matmult_inst.mem_inst.matrixA2\[10\]
+ _0627_ vssd1 vssd1 vccd1 vccd1 _0628_ sky130_fd_sc_hd__a221o_1
XANTENNA__1636__A net150 vssd1 vssd1 vccd1 vccd1 sky130_fd_sc_hd__diode_2
X_2685_ net82 _1252_ _1254_ net398 vssd1 vssd1 vccd1 vccd1 _0406_ sky130_fd_sc_hd__a22o_1
X_1636_ net150 net142 MATMULT_INST.matmult_inst.mem_inst.mem3\[16\] vssd1 vssd1 vccd1
+ vccd1 _0565_ sky130_fd_sc_hd__and3_1
X_3306_ clknet_leaf_9_clk _0228_ vssd1 vssd1 vccd1 vccd1 MATMULT_INST.matmult_inst.mem_inst.matrixA1\[15\]
+ sky130_fd_sc_hd__dfxtp_1
XPHY_EDGE_ROW_18_Left_98 vssd1 vssd1 vccd1 vccd1 sky130_fd_sc_hd__decap_3
XFILLER_48_19 vssd1 vssd1 vccd1 vccd1 sky130_fd_sc_hd__fill_8
XANTENNA__3062__S net9 vssd1 vssd1 vccd1 vccd1 sky130_fd_sc_hd__diode_2
X_3237_ clknet_leaf_8_clk _0159_ vssd1 vssd1 vccd1 vccd1 MATMULT_INST.matmult_inst.mem_inst.matrixB0\[0\]
+ sky130_fd_sc_hd__dfxtp_1
XFILLER_58_149 vssd1 vssd1 vccd1 vccd1 sky130_fd_sc_hd__fill_2
X_3168_ net58 net88 net74 vssd1 vssd1 vccd1 vccd1 _0093_ sky130_fd_sc_hd__and3_1
X_2119_ net499 net42 net14 vssd1 vssd1 vccd1 vccd1 _0274_ sky130_fd_sc_hd__mux2_1
XFILLER_14_208 vssd1 vssd1 vccd1 vccd1 sky130_fd_sc_hd__fill_8
XTAP_TAPCELL_ROW_1_178 vssd1 vccd1 sky130_fd_sc_hd__tapvpwrvgnd_1
X_3099_ _1593_ _0751_ _0784_ _1257_ _1580_ vssd1 vssd1 vccd1 vccd1 _0530_ sky130_fd_sc_hd__a2111o_1
Xfanout12 _0823_ vssd1 vssd1 vccd1 vccd1 net12 sky130_fd_sc_hd__buf_4
Xfanout23 _0818_ vssd1 vssd1 vccd1 vccd1 net23 sky130_fd_sc_hd__clkbuf_4
Xfanout34 _0812_ vssd1 vssd1 vccd1 vccd1 net34 sky130_fd_sc_hd__buf_2
Xfanout45 _0801_ vssd1 vssd1 vccd1 vccd1 net45 sky130_fd_sc_hd__clkbuf_2
Xfanout56 net57 vssd1 vssd1 vccd1 vccd1 net56 sky130_fd_sc_hd__clkbuf_2
Xfanout78 net80 vssd1 vssd1 vccd1 vccd1 net78 sky130_fd_sc_hd__clkbuf_2
XFILLER_10_403 vssd1 vssd1 vccd1 vccd1 sky130_fd_sc_hd__fill_2
Xfanout67 _0532_ vssd1 vssd1 vccd1 vccd1 net67 sky130_fd_sc_hd__clkbuf_4
Xfanout89 net92 vssd1 vssd1 vccd1 vccd1 net89 sky130_fd_sc_hd__clkbuf_2
XANTENNA__2141__S net13 vssd1 vssd1 vccd1 vccd1 sky130_fd_sc_hd__diode_2
XTAP_TAPCELL_ROW_9_245 vssd1 vccd1 sky130_fd_sc_hd__tapvpwrvgnd_1
XFILLER_1_167 vssd1 vssd1 vccd1 vccd1 sky130_fd_sc_hd__fill_1
XFILLER_1_156 vssd1 vssd1 vccd1 vccd1 sky130_fd_sc_hd__fill_1
XFILLER_49_105 vssd1 vssd1 vccd1 vccd1 sky130_fd_sc_hd__fill_4
XANTENNA__1980__S net29 vssd1 vssd1 vccd1 vccd1 sky130_fd_sc_hd__diode_2
XFILLER_77_447 vssd1 vssd1 vccd1 vccd1 sky130_fd_sc_hd__fill_1
XFILLER_77_425 vccd1 vssd1 vccd1 vssd1 sky130_ef_sc_hd__decap_40_12
XFILLER_49_138 vssd1 vssd1 vccd1 vccd1 sky130_fd_sc_hd__fill_1
XFILLER_38_41 vssd1 vssd1 vccd1 vccd1 sky130_fd_sc_hd__fill_1
XANTENNA__2527__D net208 vssd1 vssd1 vccd1 vccd1 sky130_fd_sc_hd__diode_2
XANTENNA__2664__X _1247_ vssd1 vssd1 vccd1 vccd1 sky130_fd_sc_hd__diode_2
XFILLER_72_141 vccd1 vssd1 vccd1 vssd1 sky130_ef_sc_hd__decap_40_12
XTAP_TAPCELL_ROW_43_534 vssd1 vccd1 sky130_fd_sc_hd__tapvpwrvgnd_1
XFILLER_54_62 vssd1 vssd1 vccd1 vccd1 sky130_fd_sc_hd__fill_4
XFILLER_13_263 vssd1 vssd1 vccd1 vccd1 sky130_fd_sc_hd__fill_2
Xclkload15 clknet_leaf_10_clk vssd1 vssd1 vccd1 vccd1 clkload15/Y sky130_fd_sc_hd__clkinvlp_4
XFILLER_70_83 vssd1 vssd1 vccd1 vccd1 sky130_fd_sc_hd__fill_1
Xclkload26 clknet_leaf_32_clk vssd1 vssd1 vccd1 vccd1 clkload26/Y sky130_fd_sc_hd__inv_12
XANTENNA__2051__S net23 vssd1 vssd1 vccd1 vccd1 sky130_fd_sc_hd__diode_2
X_2470_ _1044_ _1045_ _1062_ vssd1 vssd1 vccd1 vccd1 _1064_ sky130_fd_sc_hd__o21ai_1
XFILLER_68_458 vccd1 vssd1 vccd1 vssd1 sky130_ef_sc_hd__decap_40_12
X_3022_ _1513_ _1545_ _1543_ vssd1 vssd1 vccd1 vccd1 _1559_ sky130_fd_sc_hd__o21a_1
XFILLER_48_171 vssd1 vssd1 vccd1 vccd1 sky130_fd_sc_hd__fill_4
XFILLER_36_355 vssd1 vssd1 vccd1 vccd1 sky130_fd_sc_hd__fill_1
XANTENNA__2293__Y _0916_ vssd1 vssd1 vccd1 vccd1 sky130_fd_sc_hd__diode_2
XTAP_TAPCELL_ROW_14_291 vssd1 vccd1 sky130_fd_sc_hd__tapvpwrvgnd_1
Xclkload9 clknet_leaf_36_clk vssd1 vssd1 vccd1 vccd1 clkload9/Y sky130_fd_sc_hd__clkinv_8
X_2806_ net177 net179 net164 net163 vssd1 vssd1 vccd1 vccd1 _1350_ sky130_fd_sc_hd__and4_1
XANTENNA_fanout128_A net131 vssd1 vssd1 vccd1 vccd1 sky130_fd_sc_hd__diode_2
XANTENNA__3057__S net9 vssd1 vssd1 vccd1 vccd1 sky130_fd_sc_hd__diode_2
X_2737_ net168 net179 net180 net167 vssd1 vssd1 vccd1 vccd1 _1284_ sky130_fd_sc_hd__a22o_1
X_2668_ _0701_ net101 vssd1 vssd1 vccd1 vccd1 _1249_ sky130_fd_sc_hd__and2_2
X_1619_ net148 net140 vssd1 vssd1 vccd1 vccd1 _0549_ sky130_fd_sc_hd__nand2_1
Xfanout202 net203 vssd1 vssd1 vccd1 vccd1 net202 sky130_fd_sc_hd__buf_1
X_2599_ _1163_ _1188_ vssd1 vssd1 vccd1 vccd1 _1189_ sky130_fd_sc_hd__or2_1
Xfanout213 MATMULT_INST.matmult_inst.alu_inst.b0_reg\[1\] vssd1 vssd1 vccd1 vccd1
+ net213 sky130_fd_sc_hd__buf_1
XTAP_TAPCELL_ROW_6_226 vssd1 vccd1 sky130_fd_sc_hd__tapvpwrvgnd_1
Xfanout224 net228 vssd1 vssd1 vccd1 vccd1 net224 sky130_fd_sc_hd__buf_2
XANTENNA_input2_A gpio_in[1] vssd1 vssd1 vccd1 vccd1 sky130_fd_sc_hd__diode_2
XFILLER_59_469 vccd1 vssd1 vccd1 vssd1 sky130_ef_sc_hd__decap_40_12
XFILLER_39_182 vssd1 vssd1 vccd1 vccd1 sky130_fd_sc_hd__fill_1
XTAP_TAPCELL_ROW_57_659 vssd1 vccd1 sky130_fd_sc_hd__tapvpwrvgnd_1
XANTENNA__2136__S net12 vssd1 vssd1 vccd1 vccd1 sky130_fd_sc_hd__diode_2
XFILLER_42_347 vssd1 vssd1 vccd1 vccd1 sky130_fd_sc_hd__fill_1
XTAP_TAPCELL_ROW_40_515 vssd1 vccd1 sky130_fd_sc_hd__tapvpwrvgnd_1
XANTENNA__1975__S net31 vssd1 vssd1 vccd1 vccd1 sky130_fd_sc_hd__diode_2
XFILLER_24_87 vssd1 vssd1 vccd1 vccd1 sky130_fd_sc_hd__fill_8
XFILLER_10_299 vssd1 vssd1 vccd1 vccd1 sky130_fd_sc_hd__fill_8
XFILLER_40_97 vssd1 vssd1 vccd1 vccd1 sky130_fd_sc_hd__fill_4
XFILLER_2_421 vccd1 vssd1 vccd1 vssd1 sky130_ef_sc_hd__decap_40_12
XFILLER_73_461 vccd1 vssd1 vccd1 vssd1 sky130_ef_sc_hd__decap_40_12
XFILLER_65_61 vssd1 vssd1 vccd1 vccd1 sky130_fd_sc_hd__fill_2
XFILLER_45_141 vssd1 vssd1 vccd1 vccd1 sky130_fd_sc_hd__fill_2
XANTENNA__2046__S net22 vssd1 vssd1 vccd1 vccd1 sky130_fd_sc_hd__diode_2
X_1970_ MATMULT_INST.matmult_inst.fsm_inst.alu_result\[14\] net69 vssd1 vssd1 vccd1
+ vccd1 _0811_ sky130_fd_sc_hd__and2_1
XANTENNA__2441__B1 net203 vssd1 vssd1 vccd1 vccd1 sky130_fd_sc_hd__diode_2
XANTENNA__1795__A2 net108 vssd1 vssd1 vccd1 vccd1 sky130_fd_sc_hd__diode_2
X_3640_ clknet_leaf_24_clk net348 vssd1 vssd1 vccd1 vccd1 MATMULT_INST.matmult_inst.fsm_inst.alu_result\[16\]
+ sky130_fd_sc_hd__dfxtp_1
X_3571_ clknet_leaf_25_clk net580 _0069_ vssd1 vssd1 vccd1 vccd1 MATMULT_INST.matmult_inst.fsm_inst.rx_data\[1\]
+ sky130_fd_sc_hd__dfrtp_1
X_2522_ _1105_ _1110_ _1111_ vssd1 vssd1 vccd1 vccd1 _1114_ sky130_fd_sc_hd__and3_1
XFILLER_53_3 vssd1 vssd1 vccd1 vccd1 sky130_fd_sc_hd__fill_8
X_2453_ net204 net193 net191 net206 vssd1 vssd1 vccd1 vccd1 _1047_ sky130_fd_sc_hd__a22oi_1
X_2384_ net209 net194 net192 net211 vssd1 vssd1 vccd1 vccd1 _0980_ sky130_fd_sc_hd__a22o_1
Xinput2 gpio_in[1] vssd1 vssd1 vccd1 vccd1 net2 sky130_fd_sc_hd__buf_2
X_3005_ net170 net158 net172 net156 vssd1 vssd1 vccd1 vccd1 _1543_ sky130_fd_sc_hd__a22o_1
XFILLER_64_450 vccd1 vssd1 vccd1 vssd1 sky130_ef_sc_hd__decap_40_12
XANTENNA__2680__B1 _1254_ vssd1 vssd1 vccd1 vccd1 sky130_fd_sc_hd__diode_2
XTAP_TAPCELL_ROW_54_629 vssd1 vccd1 sky130_fd_sc_hd__tapvpwrvgnd_1
XFILLER_51_122 vssd1 vssd1 vccd1 vccd1 sky130_fd_sc_hd__fill_1
XFILLER_51_155 vssd1 vssd1 vccd1 vccd1 sky130_fd_sc_hd__fill_2
XTAP_TAPCELL_ROW_62_695 vssd1 vccd1 sky130_fd_sc_hd__tapvpwrvgnd_1
XANTENNA_fanout200_X net200 vssd1 vssd1 vccd1 vccd1 sky130_fd_sc_hd__diode_2
XFILLER_10_89 vssd1 vssd1 vccd1 vccd1 sky130_fd_sc_hd__fill_2
XANTENNA__1710__A2 net64 vssd1 vssd1 vccd1 vccd1 sky130_fd_sc_hd__diode_2
XANTENNA_fanout60_A net62 vssd1 vssd1 vccd1 vccd1 sky130_fd_sc_hd__diode_2
XFILLER_15_325 vssd1 vssd1 vccd1 vccd1 sky130_fd_sc_hd__fill_2
XANTENNA__2671__B1 _1250_ vssd1 vssd1 vccd1 vccd1 sky130_fd_sc_hd__diode_2
XFILLER_70_453 vssd1 vssd1 vccd1 vccd1 sky130_fd_sc_hd__fill_2
XFILLER_42_188 vssd1 vssd1 vccd1 vccd1 sky130_fd_sc_hd__fill_2
XFILLER_23_391 vssd1 vssd1 vccd1 vccd1 sky130_fd_sc_hd__fill_1
XTAP_TAPCELL_ROW_25_386 vssd1 vccd1 sky130_fd_sc_hd__tapvpwrvgnd_1
XFILLER_42_199 vssd1 vssd1 vccd1 vccd1 sky130_fd_sc_hd__fill_1
XFILLER_2_251 vssd1 vssd1 vccd1 vccd1 sky130_fd_sc_hd__fill_1
XFILLER_65_203 vccd1 vssd1 vccd1 vssd1 sky130_ef_sc_hd__decap_40_12
XFILLER_76_71 vssd1 vssd1 vccd1 vccd1 sky130_fd_sc_hd__fill_1
XFILLER_65_225 vssd1 vssd1 vccd1 vccd1 sky130_fd_sc_hd__fill_8
XFILLER_46_461 vssd1 vssd1 vccd1 vccd1 sky130_fd_sc_hd__fill_2
XFILLER_53_409 vssd1 vssd1 vccd1 vccd1 sky130_fd_sc_hd__fill_1
XFILLER_46_472 vssd1 vssd1 vccd1 vccd1 sky130_fd_sc_hd__fill_4
XFILLER_33_133 vccd1 vssd1 vccd1 vssd1 sky130_ef_sc_hd__decap_40_12
XFILLER_21_317 vssd1 vssd1 vccd1 vccd1 sky130_fd_sc_hd__fill_1
XFILLER_33_155 vssd1 vssd1 vccd1 vccd1 sky130_fd_sc_hd__fill_1
XFILLER_33_177 vssd1 vssd1 vccd1 vccd1 sky130_fd_sc_hd__fill_1
X_1953_ net504 net44 net30 vssd1 vssd1 vccd1 vccd1 _0128_ sky130_fd_sc_hd__mux2_1
X_1884_ _0761_ _0539_ vssd1 vssd1 vccd1 vccd1 _0762_ sky130_fd_sc_hd__and2b_1
XANTENNA__1768__A2 net108 vssd1 vssd1 vccd1 vccd1 sky130_fd_sc_hd__diode_2
XANTENNA__1628__B net217 vssd1 vssd1 vccd1 vccd1 sky130_fd_sc_hd__diode_2
X_3623_ clknet_leaf_23_clk MATMULT_INST.matmult_inst.spi_inst.mosi_data_spi\[7\] _0121_
+ vssd1 vssd1 vccd1 vccd1 MATMULT_INST.matmult_inst.spi_inst.mosi_data_sync\[7\] sky130_fd_sc_hd__dfrtp_1
X_3554_ clknet_leaf_16_clk _0466_ vssd1 vssd1 vccd1 vccd1 MATMULT_INST.matmult_inst.mem_inst.matrixB3\[2\]
+ sky130_fd_sc_hd__dfxtp_1
X_2505_ _1081_ _1097_ vssd1 vssd1 vccd1 vccd1 _1098_ sky130_fd_sc_hd__xnor2_1
X_3485_ clknet_leaf_0_clk _0405_ vssd1 vssd1 vccd1 vccd1 MATMULT_INST.matmult_inst.alu_inst.col0\[5\]
+ sky130_fd_sc_hd__dfxtp_1
X_2436_ _0998_ _1030_ vssd1 vssd1 vccd1 vccd1 _1031_ sky130_fd_sc_hd__xnor2_2
X_2367_ net214 MATMULT_INST.matmult_inst.alu_inst.a0_reg\[4\] vssd1 vssd1 vccd1 vccd1
+ _0964_ sky130_fd_sc_hd__and2_1
XTAP_TAPCELL_ROW_67_743 vssd1 vccd1 sky130_fd_sc_hd__tapvpwrvgnd_1
X_2298_ _0912_ _0915_ _0913_ vssd1 vssd1 vccd1 vccd1 _0920_ sky130_fd_sc_hd__o21ai_2
XFILLER_56_214 vssd1 vssd1 vccd1 vccd1 sky130_fd_sc_hd__fill_2
XFILLER_71_206 vssd1 vssd1 vccd1 vccd1 sky130_fd_sc_hd__fill_1
XFILLER_37_483 vssd1 vssd1 vccd1 vccd1 sky130_fd_sc_hd__fill_2
XANTENNA_fanout150_X net150 vssd1 vssd1 vccd1 vccd1 sky130_fd_sc_hd__diode_2
XFILLER_12_339 vssd1 vssd1 vccd1 vccd1 sky130_fd_sc_hd__fill_8
XFILLER_20_350 vccd1 vssd1 vccd1 vssd1 sky130_ef_sc_hd__decap_40_12
XTAP_TAPCELL_ROW_22_356 vssd1 vccd1 sky130_fd_sc_hd__tapvpwrvgnd_1
XFILLER_21_66 vssd1 vssd1 vccd1 vccd1 sky130_fd_sc_hd__fill_1
XFILLER_47_203 vssd1 vssd1 vccd1 vccd1 sky130_fd_sc_hd__fill_1
XANTENNA__1695__A1 net221 vssd1 vssd1 vccd1 vccd1 sky130_fd_sc_hd__diode_2
XANTENNA__1695__B2 net223 vssd1 vssd1 vccd1 vccd1 sky130_fd_sc_hd__diode_2
XANTENNA_fanout63_X net63 vssd1 vssd1 vccd1 vccd1 sky130_fd_sc_hd__diode_2
XPHY_EDGE_ROW_6_Left_86 vssd1 vssd1 vccd1 vccd1 sky130_fd_sc_hd__decap_3
XANTENNA__2385__A net208 vssd1 vssd1 vccd1 vccd1 sky130_fd_sc_hd__diode_2
XFILLER_47_247 vssd1 vssd1 vccd1 vccd1 sky130_fd_sc_hd__fill_1
XFILLER_47_258 vssd1 vssd1 vccd1 vccd1 sky130_fd_sc_hd__fill_1
XANTENNA__2672__X _1251_ vssd1 vssd1 vccd1 vccd1 sky130_fd_sc_hd__diode_2
XFILLER_62_73 vssd1 vssd1 vccd1 vccd1 sky130_fd_sc_hd__fill_8
XFILLER_62_40 vssd1 vssd1 vccd1 vccd1 sky130_fd_sc_hd__fill_1
XFILLER_7_79 vccd1 vssd1 vccd1 vssd1 sky130_ef_sc_hd__decap_40_12
XFILLER_7_387 vssd1 vssd1 vccd1 vccd1 sky130_fd_sc_hd__fill_4
X_3270_ clknet_leaf_9_clk _0192_ vssd1 vssd1 vccd1 vccd1 MATMULT_INST.matmult_inst.mem_inst.matrixA3\[15\]
+ sky130_fd_sc_hd__dfxtp_1
X_2221_ _0847_ _0854_ vssd1 vssd1 vccd1 vccd1 _0855_ sky130_fd_sc_hd__or2_1
XANTENNA__3452__Q MATMULT_INST.matmult_inst.alu_inst.a1_reg\[7\] vssd1 vssd1 vccd1
+ vccd1 sky130_fd_sc_hd__diode_2
XFILLER_16_3 vssd1 vssd1 vccd1 vccd1 sky130_fd_sc_hd__fill_8
X_2152_ net47 net554 net10 vssd1 vssd1 vccd1 vccd1 _0305_ sky130_fd_sc_hd__mux2_1
X_2083_ net418 _0806_ net19 vssd1 vssd1 vccd1 vccd1 _0240_ sky130_fd_sc_hd__mux2_1
XTAP_TAPCELL_ROW_64_713 vssd1 vccd1 sky130_fd_sc_hd__tapvpwrvgnd_1
XFILLER_34_475 vssd1 vssd1 vccd1 vccd1 sky130_fd_sc_hd__fill_1
XFILLER_34_486 vssd1 vssd1 vccd1 vccd1 sky130_fd_sc_hd__fill_8
XFILLER_21_125 vssd1 vssd1 vccd1 vccd1 sky130_fd_sc_hd__fill_4
XFILLER_21_136 vssd1 vssd1 vccd1 vccd1 sky130_fd_sc_hd__fill_8
X_2985_ _1522_ _1523_ vssd1 vssd1 vccd1 vccd1 _1524_ sky130_fd_sc_hd__xnor2_1
XFILLER_21_169 vccd1 vssd1 vccd1 vssd1 sky130_ef_sc_hd__decap_40_12
X_1936_ MATMULT_INST.matmult_inst.spi_inst.tx_reg_sys\[15\] MATMULT_INST.matmult_inst.spi_inst.miso_shifter\[14\]
+ net137 vssd1 vssd1 vccd1 vccd1 _0013_ sky130_fd_sc_hd__mux2_1
X_1867_ MATMULT_INST.matmult_inst.fsm_inst.count\[0\] _0536_ vssd1 vssd1 vccd1 vccd1
+ _0748_ sky130_fd_sc_hd__nor2_1
XANTENNA_fanout110_A net111 vssd1 vssd1 vccd1 vccd1 sky130_fd_sc_hd__diode_2
X_3606_ clknet_leaf_25_clk _0499_ _0104_ vssd1 vssd1 vccd1 vccd1 MATMULT_INST.matmult_inst.spi_inst.tx_reg_sys\[9\]
+ sky130_fd_sc_hd__dfrtp_1
X_1798_ net220 MATMULT_INST.matmult_inst.mem_inst.matrixB3\[1\] MATMULT_INST.matmult_inst.mem_inst.matrixA3\[1\]
+ net222 vssd1 vssd1 vccd1 vccd1 _0712_ sky130_fd_sc_hd__a22o_1
X_3537_ _0042_ _0451_ _0041_ vssd1 vssd1 vccd1 vccd1 MATMULT_INST.matmult_inst.spi_inst.mosi_data_spi\[4\]
+ sky130_fd_sc_hd__dfrtp_1
X_3468_ clknet_leaf_36_clk _0389_ vssd1 vssd1 vccd1 vccd1 MATMULT_INST.matmult_inst.alu_inst.adder_inst.r3.fa2.a
+ sky130_fd_sc_hd__dfxtp_1
X_2419_ _0982_ _0983_ _0958_ vssd1 vssd1 vccd1 vccd1 _1014_ sky130_fd_sc_hd__a21o_1
X_3399_ clknet_leaf_3_clk _0321_ vssd1 vssd1 vccd1 vccd1 MATMULT_INST.matmult_inst.fsm_inst.count\[0\]
+ sky130_fd_sc_hd__dfxtp_1
XANTENNA__1677__A1 _0602_ vssd1 vssd1 vccd1 vccd1 sky130_fd_sc_hd__diode_2
XFILLER_16_11 vssd1 vssd1 vccd1 vccd1 sky130_fd_sc_hd__fill_1
XTAP_TAPCELL_ROW_27_404 vssd1 vccd1 sky130_fd_sc_hd__tapvpwrvgnd_1
XANTENNA_fanout23_A _0818_ vssd1 vssd1 vccd1 vccd1 sky130_fd_sc_hd__diode_2
XFILLER_12_114 vssd1 vssd1 vccd1 vccd1 sky130_fd_sc_hd__fill_1
XTAP_TAPCELL_ROW_35_470 vssd1 vccd1 sky130_fd_sc_hd__tapvpwrvgnd_1
XFILLER_40_412 vssd1 vssd1 vccd1 vccd1 sky130_fd_sc_hd__fill_8
XFILLER_40_423 vssd1 vssd1 vccd1 vccd1 sky130_fd_sc_hd__fill_1
XANTENNA__2144__S net12 vssd1 vssd1 vccd1 vccd1 sky130_fd_sc_hd__diode_2
XFILLER_32_87 vssd1 vssd1 vccd1 vccd1 sky130_fd_sc_hd__fill_4
XANTENNA__1983__S net28 vssd1 vssd1 vccd1 vccd1 sky130_fd_sc_hd__diode_2
XTAP_TAPCELL_ROW_78_838 vssd1 vccd1 sky130_fd_sc_hd__tapvpwrvgnd_1
XANTENNA__2319__S net67 vssd1 vssd1 vccd1 vccd1 sky130_fd_sc_hd__diode_2
XFILLER_16_431 vssd1 vssd1 vccd1 vccd1 sky130_fd_sc_hd__fill_4
XFILLER_35_239 vssd1 vssd1 vccd1 vccd1 sky130_fd_sc_hd__fill_1
XFILLER_16_475 vssd1 vssd1 vccd1 vccd1 sky130_fd_sc_hd__fill_1
XFILLER_31_423 vssd1 vssd1 vccd1 vccd1 sky130_fd_sc_hd__fill_1
XFILLER_31_467 vccd1 vssd1 vccd1 vssd1 sky130_ef_sc_hd__decap_40_12
X_2770_ net178 net164 net162 net180 vssd1 vssd1 vccd1 vccd1 _1315_ sky130_fd_sc_hd__nand4_2
X_1721_ net152 net143 MATMULT_INST.matmult_inst.mem_inst.matrixA3\[8\] vssd1 vssd1
+ vccd1 vccd1 _0642_ sky130_fd_sc_hd__and3_1
Xhold107 MATMULT_INST.matmult_inst.mem_inst.matrixA0\[16\] vssd1 vssd1 vccd1 vccd1
+ net402 sky130_fd_sc_hd__dlygate4sd3_1
X_1652_ net223 _0557_ _0579_ vssd1 vssd1 vccd1 vccd1 _0580_ sky130_fd_sc_hd__and3_1
XFILLER_7_162 vssd1 vssd1 vccd1 vccd1 sky130_fd_sc_hd__fill_4
Xhold129 MATMULT_INST.matmult_inst.mem_inst.matrixA0\[0\] vssd1 vssd1 vccd1 vccd1
+ net424 sky130_fd_sc_hd__dlygate4sd3_1
Xhold118 MATMULT_INST.matmult_inst.mem_inst.matrixB3\[9\] vssd1 vssd1 vccd1 vccd1
+ net413 sky130_fd_sc_hd__dlygate4sd3_1
X_3322_ clknet_leaf_8_clk _0244_ vssd1 vssd1 vccd1 vccd1 MATMULT_INST.matmult_inst.mem_inst.matrixA0\[13\]
+ sky130_fd_sc_hd__dfxtp_1
X_3253_ clknet_leaf_12_clk _0175_ vssd1 vssd1 vccd1 vccd1 MATMULT_INST.matmult_inst.mem_inst.matrixB0\[16\]
+ sky130_fd_sc_hd__dfxtp_1
X_3184_ net58 net88 net74 vssd1 vssd1 vccd1 vccd1 _0109_ sky130_fd_sc_hd__and3_1
X_2204_ net192 net490 net66 vssd1 vssd1 vccd1 vccd1 _0336_ sky130_fd_sc_hd__mux2_1
X_2135_ net458 net45 net12 vssd1 vssd1 vccd1 vccd1 _0289_ sky130_fd_sc_hd__mux2_1
X_2066_ net389 net38 net21 vssd1 vssd1 vccd1 vccd1 _0224_ sky130_fd_sc_hd__mux2_1
XFILLER_34_250 vssd1 vssd1 vccd1 vccd1 sky130_fd_sc_hd__fill_2
XFILLER_22_434 vccd1 vssd1 vccd1 vssd1 sky130_ef_sc_hd__decap_40_12
XFILLER_34_283 vssd1 vssd1 vccd1 vccd1 sky130_fd_sc_hd__fill_1
XTAP_TAPCELL_ROW_32_440 vssd1 vccd1 sky130_fd_sc_hd__tapvpwrvgnd_1
X_2968_ _1504_ _1507_ vssd1 vssd1 vccd1 vccd1 _1508_ sky130_fd_sc_hd__nor2_1
X_1919_ MATMULT_INST.matmult_inst.spi_inst.current_state MATMULT_INST.matmult_inst.spi_inst.cs_sync_prev
+ MATMULT_INST.matmult_inst.spi_inst.cs_sync vssd1 vssd1 vccd1 vccd1 _0793_ sky130_fd_sc_hd__a21bo_1
XANTENNA__2899__S net97 vssd1 vssd1 vccd1 vccd1 sky130_fd_sc_hd__diode_2
X_2899_ net634 _1440_ net97 vssd1 vssd1 vccd1 vccd1 _0434_ sky130_fd_sc_hd__mux2_1
XFILLER_78_39 vssd1 vssd1 vccd1 vccd1 sky130_fd_sc_hd__fill_2
XTAP_TAPCELL_ROW_75_808 vssd1 vccd1 sky130_fd_sc_hd__tapvpwrvgnd_1
XANTENNA__2139__S net13 vssd1 vssd1 vccd1 vccd1 sky130_fd_sc_hd__diode_2
XFILLER_17_206 vssd1 vssd1 vccd1 vccd1 sky130_fd_sc_hd__fill_1
XFILLER_27_54 vssd1 vssd1 vccd1 vccd1 sky130_fd_sc_hd__fill_2
XANTENNA_fanout26_X net26 vssd1 vssd1 vccd1 vccd1 sky130_fd_sc_hd__diode_2
XFILLER_4_154 vccd1 vssd1 vccd1 vssd1 sky130_ef_sc_hd__decap_40_12
XFILLER_0_393 vccd1 vssd1 vccd1 vssd1 sky130_ef_sc_hd__decap_40_12
XANTENNA__2049__S net23 vssd1 vssd1 vccd1 vccd1 sky130_fd_sc_hd__diode_2
XFILLER_63_334 vssd1 vssd1 vccd1 vccd1 sky130_fd_sc_hd__fill_2
XANTENNA__2066__A1 net38 vssd1 vssd1 vccd1 vccd1 sky130_fd_sc_hd__diode_2
XTAP_TAPCELL_ROW_46_565 vssd1 vccd1 sky130_fd_sc_hd__tapvpwrvgnd_1
XFILLER_31_253 vssd1 vssd1 vccd1 vccd1 sky130_fd_sc_hd__fill_1
X_2822_ _1331_ _1335_ _1364_ _1365_ vssd1 vssd1 vccd1 vccd1 _1366_ sky130_fd_sc_hd__a31o_1
X_2753_ _1285_ _1296_ _1297_ vssd1 vssd1 vccd1 vccd1 _1299_ sky130_fd_sc_hd__and3_1
X_1704_ net150 net143 MATMULT_INST.matmult_inst.mem_inst.matrixA3\[10\] vssd1 vssd1
+ vccd1 vccd1 _0627_ sky130_fd_sc_hd__and3_1
XFILLER_8_493 vssd1 vssd1 vccd1 vccd1 sky130_fd_sc_hd__fill_1
X_2684_ net82 _1251_ _1254_ net559 vssd1 vssd1 vccd1 vccd1 _0405_ sky130_fd_sc_hd__a22o_1
X_1635_ net640 net64 _0562_ _0564_ vssd1 vssd1 vccd1 vccd1 _0507_ sky130_fd_sc_hd__o22a_1
X_3305_ clknet_leaf_10_clk _0227_ vssd1 vssd1 vccd1 vccd1 MATMULT_INST.matmult_inst.mem_inst.matrixA1\[14\]
+ sky130_fd_sc_hd__dfxtp_1
XANTENNA__1652__A net223 vssd1 vssd1 vccd1 vccd1 sky130_fd_sc_hd__diode_2
XFILLER_58_139 vssd1 vssd1 vccd1 vccd1 sky130_fd_sc_hd__fill_1
X_3236_ clknet_leaf_13_clk _0158_ vssd1 vssd1 vccd1 vccd1 MATMULT_INST.matmult_inst.mem_inst.matrixB1\[17\]
+ sky130_fd_sc_hd__dfxtp_1
X_3167_ net58 net87 net74 vssd1 vssd1 vccd1 vccd1 _0092_ sky130_fd_sc_hd__and3_1
XFILLER_39_375 vssd1 vssd1 vccd1 vccd1 sky130_fd_sc_hd__fill_1
X_3098_ _1582_ _1591_ _0753_ vssd1 vssd1 vccd1 vccd1 _0529_ sky130_fd_sc_hd__o21a_1
X_2118_ net521 net43 net14 vssd1 vssd1 vccd1 vccd1 _0273_ sky130_fd_sc_hd__mux2_1
XTAP_TAPCELL_ROW_1_179 vssd1 vccd1 sky130_fd_sc_hd__tapvpwrvgnd_1
XFILLER_54_367 vssd1 vssd1 vccd1 vccd1 sky130_fd_sc_hd__fill_1
X_2049_ net405 net36 net23 vssd1 vssd1 vccd1 vccd1 _0208_ sky130_fd_sc_hd__mux2_1
Xfanout13 _0823_ vssd1 vssd1 vccd1 vccd1 net13 sky130_fd_sc_hd__clkbuf_4
Xfanout35 _0811_ vssd1 vssd1 vccd1 vccd1 net35 sky130_fd_sc_hd__buf_2
Xfanout46 _0800_ vssd1 vssd1 vccd1 vccd1 net46 sky130_fd_sc_hd__clkbuf_2
Xfanout24 _0817_ vssd1 vssd1 vccd1 vccd1 net24 sky130_fd_sc_hd__buf_4
XANTENNA__1804__A1 net222 vssd1 vssd1 vccd1 vccd1 sky130_fd_sc_hd__diode_2
XANTENNA__1804__B2 net216 vssd1 vssd1 vccd1 vccd1 sky130_fd_sc_hd__diode_2
XANTENNA_clkbuf_leaf_18_clk_A clknet_2_3__leaf_clk vssd1 vssd1 vccd1 vccd1 sky130_fd_sc_hd__diode_2
Xfanout79 net80 vssd1 vssd1 vccd1 vccd1 net79 sky130_fd_sc_hd__buf_1
XFILLER_10_415 vssd1 vssd1 vccd1 vccd1 sky130_fd_sc_hd__fill_4
XFILLER_22_264 vssd1 vssd1 vccd1 vccd1 sky130_fd_sc_hd__fill_2
Xfanout68 _0532_ vssd1 vssd1 vccd1 vccd1 net68 sky130_fd_sc_hd__buf_2
Xfanout57 _0734_ vssd1 vssd1 vccd1 vccd1 net57 sky130_fd_sc_hd__dlymetal6s2s_1
XFILLER_22_297 vssd1 vssd1 vccd1 vccd1 sky130_fd_sc_hd__fill_2
XFILLER_6_419 vssd1 vssd1 vccd1 vccd1 sky130_fd_sc_hd__fill_1
XTAP_TAPCELL_ROW_9_246 vssd1 vccd1 sky130_fd_sc_hd__tapvpwrvgnd_1
XFILLER_1_113 vccd1 vssd1 vccd1 vssd1 sky130_ef_sc_hd__decap_40_12
XFILLER_77_437 vssd1 vssd1 vccd1 vccd1 sky130_fd_sc_hd__fill_8
XFILLER_72_153 vssd1 vssd1 vccd1 vccd1 sky130_fd_sc_hd__fill_4
XTAP_TAPCELL_ROW_43_535 vssd1 vccd1 sky130_fd_sc_hd__tapvpwrvgnd_1
XFILLER_54_85 vccd1 vssd1 vccd1 vssd1 sky130_ef_sc_hd__decap_40_12
Xclkload16 clknet_leaf_11_clk vssd1 vssd1 vccd1 vccd1 clkload16/Y sky130_fd_sc_hd__inv_6
XANTENNA__1737__A net150 vssd1 vssd1 vccd1 vccd1 sky130_fd_sc_hd__diode_2
Xclkload27 clknet_leaf_33_clk vssd1 vssd1 vccd1 vccd1 clkload27/X sky130_fd_sc_hd__clkbuf_8
XANTENNA__2220__B2 MATMULT_INST.matmult_inst.alu_inst.adder_inst.r0.fa1.a vssd1 vssd1
+ vccd1 vccd1 sky130_fd_sc_hd__diode_2
XFILLER_5_441 vssd1 vssd1 vccd1 vccd1 sky130_fd_sc_hd__fill_2
X_3021_ net170 net172 net156 net155 vssd1 vssd1 vccd1 vccd1 _1558_ sky130_fd_sc_hd__nand4_1
XFILLER_36_323 vssd1 vssd1 vccd1 vccd1 sky130_fd_sc_hd__fill_2
X_2805_ net176 net164 net163 net178 vssd1 vssd1 vccd1 vccd1 _1349_ sky130_fd_sc_hd__a22oi_1
XTAP_TAPCELL_ROW_14_292 vssd1 vccd1 sky130_fd_sc_hd__tapvpwrvgnd_1
X_2736_ _1281_ _1282_ vssd1 vssd1 vccd1 vccd1 _1283_ sky130_fd_sc_hd__nor2_1
X_2667_ net606 _1246_ _1248_ _0732_ vssd1 vssd1 vccd1 vccd1 _0394_ sky130_fd_sc_hd__a22o_1
X_1618_ net148 net140 vssd1 vssd1 vccd1 vccd1 _0548_ sky130_fd_sc_hd__and2_2
X_2598_ _1186_ _1187_ vssd1 vssd1 vccd1 vccd1 _1188_ sky130_fd_sc_hd__xnor2_1
Xfanout203 MATMULT_INST.matmult_inst.alu_inst.b0_reg\[6\] vssd1 vssd1 vccd1 vccd1
+ net203 sky130_fd_sc_hd__buf_2
Xfanout214 net215 vssd1 vssd1 vccd1 vccd1 net214 sky130_fd_sc_hd__buf_2
Xfanout225 net227 vssd1 vssd1 vccd1 vccd1 net225 sky130_fd_sc_hd__buf_4
XTAP_TAPCELL_ROW_6_227 vssd1 vccd1 sky130_fd_sc_hd__tapvpwrvgnd_1
X_3219_ clknet_leaf_6_clk _0141_ vssd1 vssd1 vccd1 vccd1 MATMULT_INST.matmult_inst.mem_inst.matrixB1\[0\]
+ sky130_fd_sc_hd__dfxtp_1
XFILLER_67_492 vssd1 vssd1 vccd1 vccd1 sky130_fd_sc_hd__fill_2
XFILLER_54_164 vssd1 vssd1 vccd1 vccd1 sky130_fd_sc_hd__fill_4
XTAP_TAPCELL_ROW_40_516 vssd1 vccd1 sky130_fd_sc_hd__tapvpwrvgnd_1
XANTENNA__1789__B1 net120 vssd1 vssd1 vccd1 vccd1 sky130_fd_sc_hd__diode_2
XANTENNA__2152__S net10 vssd1 vssd1 vccd1 vccd1 sky130_fd_sc_hd__diode_2
XANTENNA__1991__S net29 vssd1 vssd1 vccd1 vccd1 sky130_fd_sc_hd__diode_2
XFILLER_2_433 vccd1 vssd1 vccd1 vssd1 sky130_ef_sc_hd__decap_40_12
XANTENNA_fanout93_X net93 vssd1 vssd1 vccd1 vccd1 sky130_fd_sc_hd__diode_2
XFILLER_49_30 vssd1 vssd1 vccd1 vccd1 sky130_fd_sc_hd__fill_2
XFILLER_2_477 vccd1 vssd1 vccd1 vssd1 sky130_ef_sc_hd__decap_40_12
Xhold290 MATMULT_INST.matmult_inst.mem_inst.mem0\[1\] vssd1 vssd1 vccd1 vccd1 net585
+ sky130_fd_sc_hd__dlygate4sd3_1
XFILLER_45_120 vssd1 vssd1 vccd1 vccd1 sky130_fd_sc_hd__fill_1
XFILLER_73_473 vccd1 vssd1 vccd1 vssd1 sky130_ef_sc_hd__decap_40_12
XFILLER_33_337 vssd1 vssd1 vccd1 vccd1 sky130_fd_sc_hd__fill_2
XFILLER_60_123 vssd1 vssd1 vccd1 vccd1 sky130_fd_sc_hd__fill_1
XTAP_TAPCELL_ROW_11_262 vssd1 vccd1 sky130_fd_sc_hd__tapvpwrvgnd_1
X_3570_ clknet_leaf_25_clk net524 _0068_ vssd1 vssd1 vccd1 vccd1 MATMULT_INST.matmult_inst.fsm_inst.rx_data\[0\]
+ sky130_fd_sc_hd__dfrtp_1
XANTENNA__2062__S net20 vssd1 vssd1 vccd1 vccd1 sky130_fd_sc_hd__diode_2
X_2521_ _1112_ vssd1 vssd1 vccd1 vccd1 _1113_ sky130_fd_sc_hd__inv_2
XANTENNA__3455__Q MATMULT_INST.matmult_inst.alu_inst.adder_inst.r0.fa1.a vssd1 vssd1
+ vccd1 vccd1 sky130_fd_sc_hd__diode_2
X_2452_ _1005_ _1007_ _1006_ vssd1 vssd1 vccd1 vccd1 _1046_ sky130_fd_sc_hd__a21bo_1
XFILLER_46_3 vssd1 vssd1 vccd1 vccd1 sky130_fd_sc_hd__fill_4
XPHY_EDGE_ROW_18_Right_18 vssd1 vssd1 vccd1 vccd1 sky130_fd_sc_hd__decap_3
X_2383_ _0962_ _0969_ vssd1 vssd1 vccd1 vccd1 _0979_ sky130_fd_sc_hd__or2_1
Xinput3 gpio_in[2] vssd1 vssd1 vccd1 vccd1 net3 sky130_fd_sc_hd__dlymetal6s2s_1
X_3004_ net172 net156 vssd1 vssd1 vccd1 vccd1 _1542_ sky130_fd_sc_hd__nand2_1
XFILLER_64_462 vccd1 vssd1 vccd1 vssd1 sky130_ef_sc_hd__decap_40_12
XANTENNA__2680__A1 net82 vssd1 vssd1 vccd1 vccd1 sky130_fd_sc_hd__diode_2
XPHY_EDGE_ROW_27_Right_27 vssd1 vssd1 vccd1 vccd1 sky130_fd_sc_hd__decap_3
XFILLER_51_167 vssd1 vssd1 vccd1 vccd1 sky130_fd_sc_hd__fill_1
XTAP_TAPCELL_ROW_62_696 vssd1 vccd1 sky130_fd_sc_hd__tapvpwrvgnd_1
XANTENNA_fanout140_A net145 vssd1 vssd1 vccd1 vccd1 sky130_fd_sc_hd__diode_2
XANTENNA__2196__A0 net208 vssd1 vssd1 vccd1 vccd1 sky130_fd_sc_hd__diode_2
X_2719_ net140 _1269_ _1259_ vssd1 vssd1 vccd1 vccd1 _0425_ sky130_fd_sc_hd__mux2_1
XANTENNA__1664__X _0591_ vssd1 vssd1 vccd1 vccd1 sky130_fd_sc_hd__diode_2
XFILLER_10_35 vccd1 vssd1 vccd1 vssd1 sky130_ef_sc_hd__decap_40_12
XFILLER_3_219 vssd1 vssd1 vccd1 vccd1 sky130_fd_sc_hd__fill_4
XANTENNA__2700__S _1256_ vssd1 vssd1 vccd1 vccd1 sky130_fd_sc_hd__diode_2
XPHY_EDGE_ROW_36_Right_36 vssd1 vssd1 vccd1 vccd1 sky130_fd_sc_hd__decap_3
XFILLER_19_109 vssd1 vssd1 vccd1 vccd1 sky130_fd_sc_hd__fill_2
XFILLER_74_226 vssd1 vssd1 vccd1 vccd1 sky130_fd_sc_hd__fill_2
XANTENNA__2147__S net12 vssd1 vssd1 vccd1 vccd1 sky130_fd_sc_hd__diode_2
XPHY_EDGE_ROW_45_Right_45 vssd1 vssd1 vccd1 vccd1 sky130_fd_sc_hd__decap_3
XANTENNA__2671__B2 net103 vssd1 vssd1 vccd1 vccd1 sky130_fd_sc_hd__diode_2
XFILLER_35_65 vssd1 vssd1 vccd1 vccd1 sky130_fd_sc_hd__fill_1
XANTENNA__1986__S net28 vssd1 vssd1 vccd1 vccd1 sky130_fd_sc_hd__diode_2
XTAP_TAPCELL_ROW_25_387 vssd1 vccd1 sky130_fd_sc_hd__tapvpwrvgnd_1
XPHY_EDGE_ROW_54_Right_54 vssd1 vssd1 vccd1 vccd1 sky130_fd_sc_hd__decap_3
XANTENNA__1698__C1 _0545_ vssd1 vssd1 vccd1 vccd1 sky130_fd_sc_hd__diode_2
XFILLER_38_407 vssd1 vssd1 vccd1 vccd1 sky130_fd_sc_hd__fill_2
XFILLER_38_418 vssd1 vssd1 vccd1 vccd1 sky130_fd_sc_hd__fill_2
XFILLER_76_83 vssd1 vssd1 vccd1 vccd1 sky130_fd_sc_hd__fill_1
XFILLER_65_215 vssd1 vssd1 vccd1 vccd1 sky130_fd_sc_hd__fill_8
XPHY_EDGE_ROW_63_Right_63 vssd1 vssd1 vccd1 vccd1 sky130_fd_sc_hd__decap_3
XANTENNA__2565__B net208 vssd1 vssd1 vccd1 vccd1 sky130_fd_sc_hd__diode_2
XANTENNA__2662__A1 net103 vssd1 vssd1 vccd1 vccd1 sky130_fd_sc_hd__diode_2
XANTENNA__2057__S net21 vssd1 vssd1 vccd1 vccd1 sky130_fd_sc_hd__diode_2
XTAP_TAPCELL_ROW_16_310 vssd1 vccd1 sky130_fd_sc_hd__tapvpwrvgnd_1
XFILLER_33_145 vssd1 vssd1 vccd1 vccd1 sky130_fd_sc_hd__fill_8
XFILLER_61_487 vssd1 vssd1 vccd1 vccd1 sky130_fd_sc_hd__fill_4
XFILLER_33_167 vssd1 vssd1 vccd1 vccd1 sky130_fd_sc_hd__fill_1
X_1952_ MATMULT_INST.matmult_inst.fsm_inst.rx_data\[5\] net71 net70 MATMULT_INST.matmult_inst.fsm_inst.alu_result\[5\]
+ vssd1 vssd1 vccd1 vccd1 _0802_ sky130_fd_sc_hd__a22o_2
X_1883_ net135 net134 MATMULT_INST.matmult_inst.fsm_inst.state\[2\] vssd1 vssd1 vccd1
+ vccd1 _0761_ sky130_fd_sc_hd__or3b_1
X_3622_ clknet_leaf_23_clk MATMULT_INST.matmult_inst.spi_inst.mosi_data_spi\[6\] _0120_
+ vssd1 vssd1 vccd1 vccd1 MATMULT_INST.matmult_inst.spi_inst.mosi_data_sync\[6\] sky130_fd_sc_hd__dfrtp_1
XPHY_EDGE_ROW_72_Right_72 vssd1 vssd1 vccd1 vccd1 sky130_fd_sc_hd__decap_3
X_3553_ clknet_leaf_12_clk _0465_ vssd1 vssd1 vccd1 vccd1 MATMULT_INST.matmult_inst.mem_inst.matrixB3\[1\]
+ sky130_fd_sc_hd__dfxtp_1
X_2504_ _1090_ _1096_ vssd1 vssd1 vccd1 vccd1 _1097_ sky130_fd_sc_hd__xnor2_2
XANTENNA__2299__Y _0921_ vssd1 vssd1 vccd1 vccd1 sky130_fd_sc_hd__diode_2
X_3484_ clknet_leaf_0_clk _0404_ vssd1 vssd1 vccd1 vccd1 MATMULT_INST.matmult_inst.alu_inst.col0\[4\]
+ sky130_fd_sc_hd__dfxtp_1
X_2435_ _1028_ _1029_ vssd1 vssd1 vccd1 vccd1 _1030_ sky130_fd_sc_hd__and2b_1
X_2366_ _0948_ _0960_ _0961_ vssd1 vssd1 vccd1 vccd1 _0963_ sky130_fd_sc_hd__and3_1
XFILLER_29_407 vssd1 vssd1 vccd1 vccd1 sky130_fd_sc_hd__fill_1
X_2297_ _0917_ _0918_ vssd1 vssd1 vccd1 vccd1 _0919_ sky130_fd_sc_hd__nand2_1
XTAP_TAPCELL_ROW_67_744 vssd1 vccd1 sky130_fd_sc_hd__tapvpwrvgnd_1
XFILLER_37_473 vssd1 vssd1 vccd1 vccd1 sky130_fd_sc_hd__fill_1
XFILLER_64_281 vccd1 vssd1 vccd1 vssd1 sky130_ef_sc_hd__decap_40_12
XFILLER_52_421 vssd1 vssd1 vccd1 vccd1 sky130_fd_sc_hd__fill_8
XANTENNA__1861__C1 net2 vssd1 vssd1 vccd1 vccd1 sky130_fd_sc_hd__diode_2
XFILLER_12_307 vssd1 vssd1 vccd1 vccd1 sky130_fd_sc_hd__fill_1
XTAP_TAPCELL_ROW_50_600 vssd1 vccd1 sky130_fd_sc_hd__tapvpwrvgnd_1
XANTENNA__2405__A1 MATMULT_INST.matmult_inst.alu_inst.adder_inst.r1.fa1.a vssd1 vssd1
+ vccd1 vccd1 sky130_fd_sc_hd__diode_2
XANTENNA_fanout143_X net143 vssd1 vssd1 vccd1 vccd1 sky130_fd_sc_hd__diode_2
XTAP_TAPCELL_ROW_22_357 vssd1 vccd1 sky130_fd_sc_hd__tapvpwrvgnd_1
XFILLER_20_362 vssd1 vssd1 vccd1 vccd1 sky130_fd_sc_hd__fill_2
XFILLER_79_329 vssd1 vssd1 vccd1 vccd1 sky130_fd_sc_hd__fill_4
XFILLER_79_307 vssd1 vssd1 vccd1 vccd1 sky130_fd_sc_hd__fill_1
XFILLER_28_462 vccd1 vssd1 vccd1 vssd1 sky130_ef_sc_hd__decap_40_12
XFILLER_43_443 vssd1 vssd1 vccd1 vccd1 sky130_fd_sc_hd__fill_1
XFILLER_70_262 vssd1 vssd1 vccd1 vccd1 sky130_fd_sc_hd__fill_1
XFILLER_15_167 vssd1 vssd1 vccd1 vccd1 sky130_fd_sc_hd__fill_1
XFILLER_62_85 vssd1 vssd1 vccd1 vccd1 sky130_fd_sc_hd__fill_1
XANTENNA__3647__D net97 vssd1 vssd1 vccd1 vccd1 sky130_fd_sc_hd__diode_2
X_2220_ MATMULT_INST.matmult_inst.alu_inst.adder_inst.r0.fa0.b MATMULT_INST.matmult_inst.alu_inst.adder_inst.r0.fa0.a
+ MATMULT_INST.matmult_inst.alu_inst.adder_inst.r0.fa1.b MATMULT_INST.matmult_inst.alu_inst.adder_inst.r0.fa1.a
+ vssd1 vssd1 vccd1 vccd1 _0854_ sky130_fd_sc_hd__a22oi_1
XFILLER_78_362 vssd1 vssd1 vccd1 vccd1 sky130_fd_sc_hd__fill_2
X_2151_ net48 net585 net10 vssd1 vssd1 vccd1 vccd1 _0304_ sky130_fd_sc_hd__mux2_1
X_2082_ net374 net41 net19 vssd1 vssd1 vccd1 vccd1 _0239_ sky130_fd_sc_hd__mux2_1
XTAP_TAPCELL_ROW_64_714 vssd1 vccd1 sky130_fd_sc_hd__tapvpwrvgnd_1
XFILLER_34_421 vssd1 vssd1 vccd1 vccd1 sky130_fd_sc_hd__fill_1
XFILLER_34_432 vccd1 vssd1 vccd1 vssd1 sky130_ef_sc_hd__decap_40_12
XTAP_TAPCELL_ROW_72_780 vssd1 vccd1 sky130_fd_sc_hd__tapvpwrvgnd_1
X_2984_ net160 net173 _1493_ _1492_ vssd1 vssd1 vccd1 vccd1 _1523_ sky130_fd_sc_hd__a31o_1
X_1935_ MATMULT_INST.matmult_inst.spi_inst.tx_reg_sys\[14\] MATMULT_INST.matmult_inst.spi_inst.miso_shifter\[13\]
+ net137 vssd1 vssd1 vccd1 vccd1 _0012_ sky130_fd_sc_hd__mux2_1
XANTENNA__3060__A1 net34 vssd1 vssd1 vccd1 vccd1 sky130_fd_sc_hd__diode_2
X_1866_ net297 _0534_ MATMULT_INST.matmult_inst.spi_inst.rx_done_sys vssd1 vssd1 vccd1
+ vccd1 _0122_ sky130_fd_sc_hd__a21o_1
X_3605_ clknet_leaf_18_clk net642 _0103_ vssd1 vssd1 vccd1 vccd1 MATMULT_INST.matmult_inst.spi_inst.tx_reg_sys\[8\]
+ sky130_fd_sc_hd__dfrtp_1
X_1797_ net630 _0711_ net63 vssd1 vssd1 vccd1 vccd1 _0492_ sky130_fd_sc_hd__mux2_1
X_3536_ _0040_ _0450_ _0039_ vssd1 vssd1 vccd1 vccd1 MATMULT_INST.matmult_inst.spi_inst.mosi_data_spi\[3\]
+ sky130_fd_sc_hd__dfrtp_1
X_3467_ clknet_leaf_36_clk _0388_ vssd1 vssd1 vccd1 vccd1 MATMULT_INST.matmult_inst.alu_inst.adder_inst.r3.fa1.a
+ sky130_fd_sc_hd__dfxtp_1
XANTENNA__1942__X _0797_ vssd1 vssd1 vccd1 vccd1 sky130_fd_sc_hd__diode_2
X_3398_ clknet_leaf_19_clk _0320_ vssd1 vssd1 vccd1 vccd1 MATMULT_INST.matmult_inst.mem_inst.mem0\[17\]
+ sky130_fd_sc_hd__dfxtp_1
X_2418_ _1004_ _1012_ vssd1 vssd1 vccd1 vccd1 _1013_ sky130_fd_sc_hd__xnor2_1
X_2349_ _0945_ _0946_ vssd1 vssd1 vccd1 vccd1 _0947_ sky130_fd_sc_hd__nor2_1
XTAP_TAPCELL_ROW_27_405 vssd1 vccd1 sky130_fd_sc_hd__tapvpwrvgnd_1
XFILLER_37_281 vssd1 vssd1 vccd1 vccd1 sky130_fd_sc_hd__fill_8
XPHY_EDGE_ROW_0_Right_0 vssd1 vssd1 vccd1 vccd1 sky130_fd_sc_hd__decap_3
XFILLER_25_465 vssd1 vssd1 vccd1 vccd1 sky130_fd_sc_hd__fill_1
XTAP_TAPCELL_ROW_35_471 vssd1 vccd1 sky130_fd_sc_hd__tapvpwrvgnd_1
XFILLER_32_33 vssd1 vssd1 vccd1 vccd1 sky130_fd_sc_hd__fill_1
XANTENNA__3051__A1 _0803_ vssd1 vssd1 vccd1 vccd1 sky130_fd_sc_hd__diode_2
XTAP_TAPCELL_ROW_78_839 vssd1 vccd1 sky130_fd_sc_hd__tapvpwrvgnd_1
XFILLER_75_387 vssd1 vssd1 vccd1 vccd1 sky130_fd_sc_hd__fill_4
XFILLER_75_365 vccd1 vssd1 vccd1 vssd1 sky130_ef_sc_hd__decap_40_12
XANTENNA__2843__B net178 vssd1 vssd1 vccd1 vccd1 sky130_fd_sc_hd__diode_2
XFILLER_43_262 vssd1 vssd1 vccd1 vccd1 sky130_fd_sc_hd__fill_2
XFILLER_31_446 vssd1 vssd1 vccd1 vccd1 sky130_fd_sc_hd__fill_2
XFILLER_31_479 vccd1 vssd1 vccd1 vssd1 sky130_ef_sc_hd__decap_40_12
X_1720_ net646 net63 _0639_ _0641_ vssd1 vssd1 vccd1 vccd1 _0499_ sky130_fd_sc_hd__o22a_1
Xhold108 MATMULT_INST.matmult_inst.mem_inst.matrixB3\[12\] vssd1 vssd1 vccd1 vccd1
+ net403 sky130_fd_sc_hd__dlygate4sd3_1
X_1651_ MATMULT_INST.matmult_inst.mem_inst.matrixA1\[15\] net126 net118 MATMULT_INST.matmult_inst.mem_inst.matrixA2\[15\]
+ _0578_ vssd1 vssd1 vccd1 vccd1 _0579_ sky130_fd_sc_hd__a221o_1
XANTENNA__2070__S net20 vssd1 vssd1 vccd1 vccd1 sky130_fd_sc_hd__diode_2
Xhold119 MATMULT_INST.matmult_inst.mem_inst.matrixA0\[13\] vssd1 vssd1 vccd1 vccd1
+ net414 sky130_fd_sc_hd__dlygate4sd3_1
X_3321_ clknet_leaf_19_clk _0243_ vssd1 vssd1 vccd1 vccd1 MATMULT_INST.matmult_inst.mem_inst.matrixA0\[12\]
+ sky130_fd_sc_hd__dfxtp_1
X_3252_ clknet_leaf_20_clk _0174_ vssd1 vssd1 vccd1 vccd1 MATMULT_INST.matmult_inst.mem_inst.matrixB0\[15\]
+ sky130_fd_sc_hd__dfxtp_1
XFILLER_3_391 vssd1 vssd1 vccd1 vccd1 sky130_fd_sc_hd__fill_1
X_3183_ net59 net91 net78 vssd1 vssd1 vccd1 vccd1 _0108_ sky130_fd_sc_hd__and3_1
X_2203_ net194 net546 net66 vssd1 vssd1 vccd1 vccd1 _0335_ sky130_fd_sc_hd__mux2_1
X_2134_ net549 net46 net13 vssd1 vssd1 vccd1 vccd1 _0288_ sky130_fd_sc_hd__mux2_1
XFILLER_66_376 vssd1 vssd1 vccd1 vccd1 sky130_fd_sc_hd__fill_1
X_2065_ net397 net39 net20 vssd1 vssd1 vccd1 vccd1 _0223_ sky130_fd_sc_hd__mux2_1
XTAP_TAPCELL_ROW_49_585 vssd1 vccd1 sky130_fd_sc_hd__tapvpwrvgnd_1
XPHY_EDGE_ROW_22_Left_102 vssd1 vssd1 vccd1 vccd1 sky130_fd_sc_hd__decap_3
XFILLER_22_424 vssd1 vssd1 vccd1 vccd1 sky130_fd_sc_hd__fill_4
XFILLER_22_446 vssd1 vssd1 vccd1 vccd1 sky130_fd_sc_hd__fill_1
XTAP_TAPCELL_ROW_32_441 vssd1 vccd1 sky130_fd_sc_hd__tapvpwrvgnd_1
X_2967_ _1451_ _1477_ _1502_ vssd1 vssd1 vccd1 vccd1 _1507_ sky130_fd_sc_hd__and3_1
X_2898_ _1438_ _1439_ vssd1 vssd1 vccd1 vccd1 _1440_ sky130_fd_sc_hd__xnor2_1
X_1918_ _0792_ vssd1 vssd1 vccd1 vccd1 _0003_ sky130_fd_sc_hd__inv_2
XANTENNA_fanout220_A net221 vssd1 vssd1 vccd1 vccd1 sky130_fd_sc_hd__diode_2
X_1849_ MATMULT_INST.matmult_inst.spi_inst.rx_bit_count\[3\] MATMULT_INST.matmult_inst.cs
+ _0740_ vssd1 vssd1 vccd1 vccd1 _0744_ sky130_fd_sc_hd__or3_4
XPHY_EDGE_ROW_31_Left_111 vssd1 vssd1 vccd1 vccd1 sky130_fd_sc_hd__decap_3
XANTENNA_fanout106_X net106 vssd1 vssd1 vccd1 vccd1 sky130_fd_sc_hd__diode_2
X_3519_ clknet_leaf_31_clk _0436_ vssd1 vssd1 vccd1 vccd1 MATMULT_INST.matmult_inst.alu_inst.adder_inst.r2.fa2.b
+ sky130_fd_sc_hd__dfxtp_1
XTAP_TAPCELL_ROW_75_809 vssd1 vccd1 sky130_fd_sc_hd__tapvpwrvgnd_1
XFILLER_27_11 vssd1 vssd1 vccd1 vccd1 sky130_fd_sc_hd__fill_2
XPHY_EDGE_ROW_40_Left_120 vssd1 vssd1 vccd1 vccd1 sky130_fd_sc_hd__decap_3
XANTENNA__2155__S net10 vssd1 vssd1 vccd1 vccd1 sky130_fd_sc_hd__diode_2
XFILLER_13_446 vssd1 vssd1 vccd1 vccd1 sky130_fd_sc_hd__fill_2
XFILLER_13_435 vssd1 vssd1 vccd1 vccd1 sky130_fd_sc_hd__fill_2
XANTENNA__1994__S net29 vssd1 vssd1 vccd1 vccd1 sky130_fd_sc_hd__diode_2
XANTENNA_fanout19_X net19 vssd1 vssd1 vccd1 vccd1 sky130_fd_sc_hd__diode_2
Xclkbuf_leaf_20_clk clknet_2_3__leaf_clk vssd1 vssd1 vccd1 vccd1 clknet_leaf_20_clk
+ sky130_fd_sc_hd__clkbuf_8
XFILLER_21_490 vssd1 vssd1 vccd1 vccd1 sky130_fd_sc_hd__fill_4
XFILLER_4_133 vssd1 vssd1 vccd1 vccd1 sky130_fd_sc_hd__fill_1
XFILLER_4_111 vssd1 vssd1 vccd1 vccd1 sky130_fd_sc_hd__fill_1
XFILLER_4_166 vssd1 vssd1 vccd1 vccd1 sky130_fd_sc_hd__fill_8
XFILLER_4_48 vccd1 vssd1 vccd1 vssd1 sky130_ef_sc_hd__decap_40_12
XFILLER_4_26 vssd1 vssd1 vccd1 vccd1 sky130_fd_sc_hd__fill_2
XFILLER_0_361 vssd1 vssd1 vccd1 vccd1 sky130_fd_sc_hd__fill_2
XFILLER_48_365 vssd1 vssd1 vccd1 vccd1 sky130_fd_sc_hd__fill_1
XFILLER_75_195 vssd1 vssd1 vccd1 vccd1 sky130_fd_sc_hd__fill_1
XFILLER_16_251 vssd1 vssd1 vccd1 vccd1 sky130_fd_sc_hd__fill_1
XTAP_TAPCELL_ROW_46_566 vssd1 vccd1 sky130_fd_sc_hd__tapvpwrvgnd_1
XANTENNA__2065__S net20 vssd1 vssd1 vccd1 vccd1 sky130_fd_sc_hd__diode_2
XFILLER_16_273 vssd1 vssd1 vccd1 vccd1 sky130_fd_sc_hd__fill_2
X_2821_ _1361_ _1362_ _1363_ vssd1 vssd1 vccd1 vccd1 _1365_ sky130_fd_sc_hd__o21a_1
Xclkbuf_leaf_11_clk clknet_2_1__leaf_clk vssd1 vssd1 vccd1 vccd1 clknet_leaf_11_clk
+ sky130_fd_sc_hd__clkbuf_8
X_2752_ _1296_ _1297_ _1285_ vssd1 vssd1 vccd1 vccd1 _1298_ sky130_fd_sc_hd__a21oi_1
X_1703_ MATMULT_INST.matmult_inst.mem_inst.mem1\[10\] net129 net121 MATMULT_INST.matmult_inst.mem_inst.mem2\[10\]
+ _0625_ vssd1 vssd1 vccd1 vccd1 _0626_ sky130_fd_sc_hd__a221o_1
X_2683_ net82 _1250_ _1254_ net444 vssd1 vssd1 vccd1 vccd1 _0404_ sky130_fd_sc_hd__a22o_1
X_1634_ net220 _0553_ _0555_ net223 _0563_ vssd1 vssd1 vccd1 vccd1 _0564_ sky130_fd_sc_hd__a221o_1
X_3304_ clknet_leaf_9_clk _0226_ vssd1 vssd1 vccd1 vccd1 MATMULT_INST.matmult_inst.mem_inst.matrixA1\[13\]
+ sky130_fd_sc_hd__dfxtp_1
X_3235_ clknet_leaf_11_clk _0157_ vssd1 vssd1 vccd1 vccd1 MATMULT_INST.matmult_inst.mem_inst.matrixB1\[16\]
+ sky130_fd_sc_hd__dfxtp_1
XANTENNA__1652__B _0557_ vssd1 vssd1 vccd1 vccd1 sky130_fd_sc_hd__diode_2
X_3166_ net61 net91 net78 vssd1 vssd1 vccd1 vccd1 _0091_ sky130_fd_sc_hd__and3_1
XFILLER_39_354 vssd1 vssd1 vccd1 vccd1 sky130_fd_sc_hd__fill_1
X_3097_ _0783_ _1590_ _1257_ _0763_ vssd1 vssd1 vccd1 vccd1 _1591_ sky130_fd_sc_hd__or4b_1
X_2117_ net468 net44 net14 vssd1 vssd1 vccd1 vccd1 _0272_ sky130_fd_sc_hd__mux2_1
XFILLER_54_313 vssd1 vssd1 vccd1 vccd1 sky130_fd_sc_hd__fill_2
XFILLER_54_324 vccd1 vssd1 vccd1 vssd1 sky130_ef_sc_hd__decap_40_12
X_2048_ net506 net37 net23 vssd1 vssd1 vccd1 vccd1 _0207_ sky130_fd_sc_hd__mux2_1
Xfanout25 _0817_ vssd1 vssd1 vccd1 vccd1 net25 sky130_fd_sc_hd__clkbuf_4
Xfanout36 _0810_ vssd1 vssd1 vccd1 vccd1 net36 sky130_fd_sc_hd__buf_2
XFILLER_62_390 vccd1 vssd1 vccd1 vssd1 sky130_ef_sc_hd__decap_40_12
XFILLER_22_243 vssd1 vssd1 vccd1 vccd1 sky130_fd_sc_hd__fill_8
Xfanout47 _0799_ vssd1 vssd1 vccd1 vccd1 net47 sky130_fd_sc_hd__clkbuf_2
Xfanout14 _0822_ vssd1 vssd1 vccd1 vccd1 net14 sky130_fd_sc_hd__buf_4
XFILLER_10_405 vssd1 vssd1 vccd1 vccd1 sky130_fd_sc_hd__fill_1
Xfanout69 net70 vssd1 vssd1 vccd1 vccd1 net69 sky130_fd_sc_hd__clkbuf_2
Xfanout58 net62 vssd1 vssd1 vccd1 vccd1 net58 sky130_fd_sc_hd__clkbuf_2
XFILLER_13_57 vssd1 vssd1 vccd1 vccd1 sky130_fd_sc_hd__fill_8
XANTENNA__2703__S _1256_ vssd1 vssd1 vccd1 vccd1 sky130_fd_sc_hd__diode_2
XANTENNA_fanout223_X net223 vssd1 vssd1 vccd1 vccd1 sky130_fd_sc_hd__diode_2
XFILLER_6_409 vssd1 vssd1 vccd1 vccd1 sky130_fd_sc_hd__fill_1
XTAP_TAPCELL_ROW_9_247 vssd1 vccd1 sky130_fd_sc_hd__tapvpwrvgnd_1
XFILLER_1_125 vssd1 vssd1 vccd1 vccd1 sky130_fd_sc_hd__fill_1
XANTENNA_fanout83_A net86 vssd1 vssd1 vccd1 vccd1 sky130_fd_sc_hd__diode_2
XANTENNA__1740__B2 net222 vssd1 vssd1 vccd1 vccd1 sky130_fd_sc_hd__diode_2
XFILLER_77_449 vccd1 vssd1 vccd1 vssd1 sky130_ef_sc_hd__decap_40_12
XANTENNA__1989__S net29 vssd1 vssd1 vccd1 vccd1 sky130_fd_sc_hd__diode_2
XANTENNA__2674__A _0671_ vssd1 vssd1 vccd1 vccd1 sky130_fd_sc_hd__diode_2
XFILLER_45_335 vssd1 vssd1 vccd1 vccd1 sky130_fd_sc_hd__fill_1
XFILLER_54_31 vccd1 vssd1 vccd1 vssd1 sky130_ef_sc_hd__decap_40_12
XTAP_TAPCELL_ROW_43_536 vssd1 vccd1 sky130_fd_sc_hd__tapvpwrvgnd_1
XFILLER_54_97 vssd1 vssd1 vccd1 vccd1 sky130_fd_sc_hd__fill_4
XFILLER_9_225 vssd1 vssd1 vccd1 vccd1 sky130_fd_sc_hd__fill_2
XFILLER_70_85 vssd1 vssd1 vccd1 vccd1 sky130_fd_sc_hd__fill_1
Xclkload17 clknet_leaf_12_clk vssd1 vssd1 vccd1 vccd1 clkload17/Y sky130_fd_sc_hd__clkinv_4
Xclkload28 clknet_leaf_18_clk vssd1 vssd1 vccd1 vccd1 clkload28/X sky130_fd_sc_hd__clkbuf_4
XFILLER_5_464 vccd1 vssd1 vccd1 vssd1 sky130_ef_sc_hd__decap_40_12
XFILLER_5_453 vssd1 vssd1 vccd1 vccd1 sky130_fd_sc_hd__fill_1
X_3020_ net170 net156 net155 net172 vssd1 vssd1 vccd1 vccd1 _1557_ sky130_fd_sc_hd__a22o_1
Xclkbuf_leaf_0_clk clknet_2_0__leaf_clk vssd1 vssd1 vccd1 vccd1 clknet_leaf_0_clk
+ sky130_fd_sc_hd__clkbuf_8
XFILLER_44_390 vssd1 vssd1 vccd1 vccd1 sky130_fd_sc_hd__fill_1
XANTENNA__1798__A1 net220 vssd1 vssd1 vccd1 vccd1 sky130_fd_sc_hd__diode_2
XANTENNA__1798__B2 net222 vssd1 vssd1 vccd1 vccd1 sky130_fd_sc_hd__diode_2
X_2804_ _1345_ _1346_ _1338_ vssd1 vssd1 vccd1 vccd1 _1348_ sky130_fd_sc_hd__a21o_1
XTAP_TAPCELL_ROW_14_293 vssd1 vccd1 sky130_fd_sc_hd__tapvpwrvgnd_1
X_2735_ net182 net184 net164 net163 vssd1 vssd1 vccd1 vccd1 _1282_ sky130_fd_sc_hd__and4_1
X_2666_ _0711_ net101 vssd1 vssd1 vccd1 vccd1 _1248_ sky130_fd_sc_hd__and2_2
X_1617_ net147 net139 vssd1 vssd1 vccd1 vccd1 _0547_ sky130_fd_sc_hd__and2b_1
Xfanout204 MATMULT_INST.matmult_inst.alu_inst.b0_reg\[5\] vssd1 vssd1 vccd1 vccd1
+ net204 sky130_fd_sc_hd__buf_2
X_2597_ net190 net201 _1160_ _1159_ vssd1 vssd1 vccd1 vccd1 _1187_ sky130_fd_sc_hd__a31o_1
Xfanout226 net227 vssd1 vssd1 vccd1 vccd1 net226 sky130_fd_sc_hd__clkbuf_4
Xfanout215 MATMULT_INST.matmult_inst.alu_inst.b0_reg\[0\] vssd1 vssd1 vccd1 vccd1
+ net215 sky130_fd_sc_hd__buf_1
XANTENNA__1950__X _0801_ vssd1 vssd1 vccd1 vccd1 sky130_fd_sc_hd__diode_2
X_3218_ clknet_leaf_13_clk _0140_ vssd1 vssd1 vccd1 vccd1 MATMULT_INST.matmult_inst.mem_inst.matrixB2\[17\]
+ sky130_fd_sc_hd__dfxtp_1
XFILLER_39_151 vssd1 vssd1 vccd1 vccd1 sky130_fd_sc_hd__fill_1
X_3149_ net57 net84 net76 vssd1 vssd1 vccd1 vccd1 _0074_ sky130_fd_sc_hd__and3_1
XANTENNA_fanout173_X net173 vssd1 vssd1 vccd1 vccd1 sky130_fd_sc_hd__diode_2
XFILLER_27_379 vssd1 vssd1 vccd1 vccd1 sky130_fd_sc_hd__fill_8
XFILLER_40_33 vssd1 vssd1 vccd1 vccd1 sky130_fd_sc_hd__fill_2
XFILLER_2_445 vccd1 vssd1 vccd1 vssd1 sky130_ef_sc_hd__decap_40_12
Xhold280 MATMULT_INST.matmult_inst.mem_inst.mem0\[6\] vssd1 vssd1 vccd1 vccd1 net575
+ sky130_fd_sc_hd__dlygate4sd3_1
XFILLER_2_489 vssd1 vssd1 vccd1 vccd1 sky130_fd_sc_hd__fill_2
XANTENNA_fanout86_X net86 vssd1 vssd1 vccd1 vccd1 sky130_fd_sc_hd__diode_2
Xhold291 MATMULT_INST.matmult_inst.mem_inst.matrixA2\[3\] vssd1 vssd1 vccd1 vccd1
+ net586 sky130_fd_sc_hd__dlygate4sd3_1
XFILLER_18_313 vssd1 vssd1 vccd1 vccd1 sky130_fd_sc_hd__fill_2
XFILLER_58_471 vssd1 vssd1 vccd1 vccd1 sky130_fd_sc_hd__fill_2
XTAP_TAPCELL_ROW_56_650 vssd1 vccd1 sky130_fd_sc_hd__tapvpwrvgnd_1
XFILLER_73_485 vssd1 vssd1 vccd1 vccd1 sky130_fd_sc_hd__fill_8
XANTENNA__2441__A2 net200 vssd1 vssd1 vccd1 vccd1 sky130_fd_sc_hd__diode_2
XFILLER_41_393 vssd1 vssd1 vccd1 vccd1 sky130_fd_sc_hd__fill_2
XTAP_TAPCELL_ROW_11_263 vssd1 vccd1 sky130_fd_sc_hd__tapvpwrvgnd_1
X_2520_ _1110_ _1111_ _1105_ vssd1 vssd1 vccd1 vccd1 _1112_ sky130_fd_sc_hd__a21o_1
X_2451_ _1034_ _1042_ _1043_ vssd1 vssd1 vccd1 vccd1 _1045_ sky130_fd_sc_hd__and3_1
X_2382_ _0955_ _0974_ _0975_ vssd1 vssd1 vccd1 vccd1 _0978_ sky130_fd_sc_hd__a21bo_1
XFILLER_39_3 vccd1 vssd1 vccd1 vssd1 sky130_ef_sc_hd__decap_40_12
XANTENNA_clkbuf_leaf_17_clk_A clknet_2_1__leaf_clk vssd1 vssd1 vccd1 vccd1 sky130_fd_sc_hd__diode_2
X_3003_ _1539_ _1540_ vssd1 vssd1 vccd1 vccd1 _1541_ sky130_fd_sc_hd__nand2b_1
XFILLER_49_493 vssd1 vssd1 vccd1 vccd1 sky130_fd_sc_hd__fill_1
XTAP_TAPCELL_ROW_19_330 vssd1 vccd1 sky130_fd_sc_hd__tapvpwrvgnd_1
XFILLER_64_474 vssd1 vssd1 vccd1 vccd1 sky130_fd_sc_hd__fill_2
XANTENNA__2680__A2 _1247_ vssd1 vssd1 vccd1 vccd1 sky130_fd_sc_hd__diode_2
Xclkbuf_2_1__f_clk clknet_0_clk vssd1 vssd1 vccd1 vccd1 clknet_2_1__leaf_clk sky130_fd_sc_hd__clkbuf_16
XFILLER_51_157 vssd1 vssd1 vccd1 vccd1 sky130_fd_sc_hd__fill_1
XTAP_TAPCELL_ROW_62_697 vssd1 vccd1 sky130_fd_sc_hd__tapvpwrvgnd_1
XFILLER_3_209 vssd1 vssd1 vccd1 vccd1 sky130_fd_sc_hd__fill_1
X_2718_ _0731_ _0770_ _0771_ _1268_ vssd1 vssd1 vccd1 vccd1 _1269_ sky130_fd_sc_hd__a31o_1
XFILLER_10_47 vccd1 vssd1 vccd1 vssd1 sky130_ef_sc_hd__decap_40_12
X_2649_ _1204_ _1226_ vssd1 vssd1 vccd1 vccd1 _1236_ sky130_fd_sc_hd__nand2_1
XFILLER_59_246 vssd1 vssd1 vccd1 vccd1 sky130_fd_sc_hd__fill_1
XFILLER_74_249 vssd1 vssd1 vccd1 vccd1 sky130_fd_sc_hd__fill_2
XANTENNA__2120__A1 _0805_ vssd1 vssd1 vccd1 vccd1 sky130_fd_sc_hd__diode_2
XFILLER_35_33 vssd1 vssd1 vccd1 vccd1 sky130_fd_sc_hd__fill_4
XANTENNA_fanout46_A _0800_ vssd1 vssd1 vccd1 vccd1 sky130_fd_sc_hd__diode_2
XTAP_TAPCELL_ROW_53_620 vssd1 vccd1 sky130_fd_sc_hd__tapvpwrvgnd_1
XFILLER_70_477 vccd1 vssd1 vccd1 vssd1 sky130_ef_sc_hd__decap_40_12
XFILLER_30_319 vccd1 vssd1 vccd1 vssd1 sky130_ef_sc_hd__decap_40_12
XTAP_TAPCELL_ROW_25_388 vssd1 vccd1 sky130_fd_sc_hd__tapvpwrvgnd_1
XANTENNA__2016__X _0817_ vssd1 vssd1 vccd1 vccd1 sky130_fd_sc_hd__diode_2
XFILLER_51_32 vssd1 vssd1 vccd1 vccd1 sky130_fd_sc_hd__fill_4
XFILLER_51_54 vssd1 vssd1 vccd1 vccd1 sky130_fd_sc_hd__fill_2
XFILLER_2_253 vssd1 vssd1 vccd1 vccd1 sky130_fd_sc_hd__fill_8
XPHY_EDGE_ROW_69_Left_149 vssd1 vssd1 vccd1 vccd1 sky130_fd_sc_hd__decap_3
XFILLER_46_485 vssd1 vssd1 vccd1 vccd1 sky130_fd_sc_hd__fill_1
XTAP_TAPCELL_ROW_16_311 vssd1 vccd1 sky130_fd_sc_hd__tapvpwrvgnd_1
XFILLER_14_360 vssd1 vssd1 vccd1 vccd1 sky130_fd_sc_hd__fill_4
X_1951_ net466 net45 net30 vssd1 vssd1 vccd1 vccd1 _0127_ sky130_fd_sc_hd__mux2_1
X_1882_ _0755_ _0759_ vssd1 vssd1 vccd1 vccd1 _0760_ sky130_fd_sc_hd__nand2_1
XPHY_EDGE_ROW_78_Left_158 vssd1 vssd1 vccd1 vccd1 sky130_fd_sc_hd__decap_3
X_3621_ clknet_leaf_23_clk MATMULT_INST.matmult_inst.spi_inst.mosi_data_spi\[5\] _0119_
+ vssd1 vssd1 vccd1 vccd1 MATMULT_INST.matmult_inst.spi_inst.mosi_data_sync\[5\] sky130_fd_sc_hd__dfrtp_1
XANTENNA__2717__A3 _0557_ vssd1 vssd1 vccd1 vccd1 sky130_fd_sc_hd__diode_2
X_3552_ clknet_leaf_8_clk _0464_ vssd1 vssd1 vccd1 vccd1 MATMULT_INST.matmult_inst.mem_inst.matrixB3\[0\]
+ sky130_fd_sc_hd__dfxtp_1
X_2503_ _1094_ _1095_ vssd1 vssd1 vccd1 vccd1 _1096_ sky130_fd_sc_hd__nor2_1
X_3483_ clknet_leaf_0_clk _0403_ vssd1 vssd1 vccd1 vccd1 MATMULT_INST.matmult_inst.alu_inst.col0\[3\]
+ sky130_fd_sc_hd__dfxtp_1
X_2434_ _1001_ _1026_ _1027_ vssd1 vssd1 vccd1 vccd1 _1029_ sky130_fd_sc_hd__nand3_1
X_2365_ _0960_ _0961_ _0948_ vssd1 vssd1 vccd1 vccd1 _0962_ sky130_fd_sc_hd__a21oi_1
XANTENNA__1941__A net219 vssd1 vssd1 vccd1 vccd1 sky130_fd_sc_hd__diode_2
X_2296_ MATMULT_INST.matmult_inst.alu_inst.adder_inst.r3.fa2.b MATMULT_INST.matmult_inst.alu_inst.adder_inst.r3.fa2.a
+ vssd1 vssd1 vccd1 vccd1 _0918_ sky130_fd_sc_hd__nand2_1
XTAP_TAPCELL_ROW_67_745 vssd1 vccd1 sky130_fd_sc_hd__tapvpwrvgnd_1
XFILLER_37_441 vssd1 vssd1 vccd1 vccd1 sky130_fd_sc_hd__fill_4
XANTENNA__2405__A2 net96 vssd1 vssd1 vccd1 vccd1 sky130_fd_sc_hd__diode_2
XTAP_TAPCELL_ROW_50_601 vssd1 vccd1 sky130_fd_sc_hd__tapvpwrvgnd_1
XTAP_TAPCELL_ROW_22_358 vssd1 vccd1 sky130_fd_sc_hd__tapvpwrvgnd_1
XFILLER_47_227 vssd1 vssd1 vccd1 vccd1 sky130_fd_sc_hd__fill_1
XFILLER_28_474 vssd1 vssd1 vccd1 vccd1 sky130_fd_sc_hd__fill_2
XFILLER_15_102 vssd1 vssd1 vccd1 vccd1 sky130_fd_sc_hd__fill_1
XFILLER_15_113 vccd1 vssd1 vccd1 vssd1 sky130_ef_sc_hd__decap_40_12
XTAP_TAPCELL_ROW_38_491 vssd1 vccd1 sky130_fd_sc_hd__tapvpwrvgnd_1
XFILLER_30_116 vssd1 vssd1 vccd1 vccd1 sky130_fd_sc_hd__fill_1
XFILLER_11_90 vssd1 vssd1 vccd1 vccd1 sky130_fd_sc_hd__fill_1
XFILLER_38_216 vssd1 vssd1 vccd1 vccd1 sky130_fd_sc_hd__fill_4
XFILLER_38_227 vssd1 vssd1 vccd1 vccd1 sky130_fd_sc_hd__fill_1
X_2150_ net49 net562 net10 vssd1 vssd1 vccd1 vccd1 _0303_ sky130_fd_sc_hd__mux2_1
X_2081_ net439 net42 net18 vssd1 vssd1 vccd1 vccd1 _0238_ sky130_fd_sc_hd__mux2_1
XANTENNA__2068__S net20 vssd1 vssd1 vccd1 vccd1 sky130_fd_sc_hd__diode_2
XTAP_TAPCELL_ROW_64_715 vssd1 vccd1 sky130_fd_sc_hd__tapvpwrvgnd_1
XFILLER_34_444 vssd1 vssd1 vccd1 vccd1 sky130_fd_sc_hd__fill_4
XFILLER_34_455 vccd1 vssd1 vccd1 vssd1 sky130_ef_sc_hd__decap_40_12
XTAP_TAPCELL_ROW_72_781 vssd1 vccd1 sky130_fd_sc_hd__tapvpwrvgnd_1
X_2983_ _1520_ _1521_ vssd1 vssd1 vccd1 vccd1 _1522_ sky130_fd_sc_hd__and2b_1
X_1934_ MATMULT_INST.matmult_inst.spi_inst.tx_reg_sys\[13\] MATMULT_INST.matmult_inst.spi_inst.miso_shifter\[12\]
+ net137 vssd1 vssd1 vccd1 vccd1 _0011_ sky130_fd_sc_hd__mux2_1
X_1865_ _0742_ _0747_ net2 vssd1 vssd1 vccd1 vccd1 _0443_ sky130_fd_sc_hd__and3b_1
X_1796_ _0708_ _0710_ vssd1 vssd1 vccd1 vccd1 _0711_ sky130_fd_sc_hd__or2_1
X_3604_ clknet_leaf_18_clk _0497_ _0102_ vssd1 vssd1 vccd1 vccd1 MATMULT_INST.matmult_inst.spi_inst.tx_reg_sys\[7\]
+ sky130_fd_sc_hd__dfrtp_1
X_3535_ _0038_ _0449_ _0037_ vssd1 vssd1 vccd1 vccd1 MATMULT_INST.matmult_inst.spi_inst.mosi_data_spi\[2\]
+ sky130_fd_sc_hd__dfrtp_1
X_3466_ clknet_leaf_36_clk _0387_ vssd1 vssd1 vccd1 vccd1 MATMULT_INST.matmult_inst.alu_inst.adder_inst.r3.fa0.a
+ sky130_fd_sc_hd__dfxtp_1
X_2417_ _1010_ _1011_ vssd1 vssd1 vccd1 vccd1 _1012_ sky130_fd_sc_hd__nand2_1
X_3397_ clknet_leaf_11_clk _0319_ vssd1 vssd1 vccd1 vccd1 MATMULT_INST.matmult_inst.mem_inst.mem0\[16\]
+ sky130_fd_sc_hd__dfxtp_1
X_2348_ net212 net214 net194 net192 vssd1 vssd1 vccd1 vccd1 _0946_ sky130_fd_sc_hd__and4_1
XFILLER_29_205 vssd1 vssd1 vccd1 vccd1 sky130_fd_sc_hd__fill_4
X_2279_ _0902_ _0903_ vssd1 vssd1 vccd1 vccd1 _0904_ sky130_fd_sc_hd__nand2_1
XFILLER_29_249 vssd1 vssd1 vccd1 vccd1 sky130_fd_sc_hd__fill_2
XFILLER_16_68 vssd1 vssd1 vccd1 vccd1 sky130_fd_sc_hd__fill_2
XTAP_TAPCELL_ROW_35_472 vssd1 vccd1 sky130_fd_sc_hd__tapvpwrvgnd_1
XANTENNA__2011__B1 net26 vssd1 vssd1 vccd1 vccd1 sky130_fd_sc_hd__diode_2
XFILLER_4_337 vccd1 vssd1 vccd1 vssd1 sky130_ef_sc_hd__decap_40_12
XFILLER_79_138 vssd1 vssd1 vccd1 vccd1 sky130_fd_sc_hd__fill_2
XFILLER_75_355 vssd1 vssd1 vccd1 vccd1 sky130_fd_sc_hd__fill_1
XFILLER_75_377 vssd1 vssd1 vccd1 vccd1 sky130_fd_sc_hd__fill_2
XFILLER_73_85 vssd1 vssd1 vccd1 vccd1 sky130_fd_sc_hd__fill_8
XFILLER_16_477 vccd1 vssd1 vccd1 vssd1 sky130_ef_sc_hd__decap_40_12
X_1650_ net151 net141 MATMULT_INST.matmult_inst.mem_inst.matrixA3\[15\] vssd1 vssd1
+ vccd1 vccd1 _0578_ sky130_fd_sc_hd__and3_1
Xhold109 MATMULT_INST.matmult_inst.mem_inst.mem0\[15\] vssd1 vssd1 vccd1 vccd1 net404
+ sky130_fd_sc_hd__dlygate4sd3_1
X_3320_ clknet_leaf_20_clk _0242_ vssd1 vssd1 vccd1 vccd1 MATMULT_INST.matmult_inst.mem_inst.matrixA0\[11\]
+ sky130_fd_sc_hd__dfxtp_1
X_3251_ clknet_leaf_20_clk _0173_ vssd1 vssd1 vccd1 vccd1 MATMULT_INST.matmult_inst.mem_inst.matrixB0\[14\]
+ sky130_fd_sc_hd__dfxtp_1
XANTENNA__2587__A net190 vssd1 vssd1 vccd1 vccd1 sky130_fd_sc_hd__diode_2
X_3182_ net58 net87 net74 vssd1 vssd1 vccd1 vccd1 _0107_ sky130_fd_sc_hd__and3_1
XFILLER_21_3 vssd1 vssd1 vccd1 vccd1 sky130_fd_sc_hd__fill_8
X_2202_ net196 net449 net65 vssd1 vssd1 vccd1 vccd1 _0334_ sky130_fd_sc_hd__mux2_1
X_2133_ net556 net47 net13 vssd1 vssd1 vccd1 vccd1 _0287_ sky130_fd_sc_hd__mux2_1
XFILLER_66_399 vssd1 vssd1 vccd1 vccd1 sky130_fd_sc_hd__fill_1
XTAP_TAPCELL_ROW_49_586 vssd1 vccd1 sky130_fd_sc_hd__tapvpwrvgnd_1
X_2064_ net430 net40 net21 vssd1 vssd1 vccd1 vccd1 _0222_ sky130_fd_sc_hd__mux2_1
X_2966_ _1473_ _1505_ vssd1 vssd1 vccd1 vccd1 _1506_ sky130_fd_sc_hd__nand2_1
XTAP_TAPCELL_ROW_32_442 vssd1 vccd1 sky130_fd_sc_hd__tapvpwrvgnd_1
X_2897_ _1366_ _1402_ _1403_ vssd1 vssd1 vccd1 vccd1 _1439_ sky130_fd_sc_hd__o21ai_4
X_1917_ MATMULT_INST.matmult_inst.alu_inst.state\[0\] MATMULT_INST.matmult_inst.alu_inst.state\[1\]
+ vssd1 vssd1 vccd1 vccd1 _0792_ sky130_fd_sc_hd__nand2b_1
X_1848_ MATMULT_INST.matmult_inst.spi_inst.rx_bit_count\[1\] _0742_ vssd1 vssd1 vccd1
+ vccd1 _0743_ sky130_fd_sc_hd__and2_1
X_1779_ net149 net140 MATMULT_INST.matmult_inst.mem_inst.matrixA3\[3\] vssd1 vssd1
+ vccd1 vccd1 _0695_ sky130_fd_sc_hd__and3_1
X_3518_ clknet_leaf_31_clk _0435_ vssd1 vssd1 vccd1 vccd1 MATMULT_INST.matmult_inst.alu_inst.adder_inst.r2.fa1.b
+ sky130_fd_sc_hd__dfxtp_1
X_3449_ clknet_leaf_32_clk _0371_ vssd1 vssd1 vccd1 vccd1 MATMULT_INST.matmult_inst.alu_inst.a1_reg\[4\]
+ sky130_fd_sc_hd__dfxtp_1
XFILLER_69_193 vssd1 vssd1 vccd1 vccd1 sky130_fd_sc_hd__fill_2
XANTENNA__2944__B net173 vssd1 vssd1 vccd1 vccd1 sky130_fd_sc_hd__diode_2
XFILLER_25_285 vssd1 vssd1 vccd1 vccd1 sky130_fd_sc_hd__fill_1
XFILLER_43_11 vssd1 vssd1 vccd1 vccd1 sky130_fd_sc_hd__fill_2
XFILLER_9_407 vssd1 vssd1 vccd1 vccd1 sky130_fd_sc_hd__fill_1
XFILLER_40_255 vssd1 vssd1 vccd1 vccd1 sky130_fd_sc_hd__fill_1
XANTENNA__2678__Y _1254_ vssd1 vssd1 vccd1 vccd1 sky130_fd_sc_hd__diode_2
XFILLER_68_85 vssd1 vssd1 vccd1 vccd1 sky130_fd_sc_hd__fill_4
XFILLER_75_152 vssd1 vssd1 vccd1 vccd1 sky130_fd_sc_hd__fill_4
XTAP_TAPCELL_ROW_46_567 vssd1 vccd1 sky130_fd_sc_hd__tapvpwrvgnd_1
XFILLER_31_211 vssd1 vssd1 vccd1 vccd1 sky130_fd_sc_hd__fill_4
X_2820_ _1361_ _1362_ _1363_ vssd1 vssd1 vccd1 vccd1 _1364_ sky130_fd_sc_hd__or3_1
X_2751_ _1294_ _1295_ _1282_ vssd1 vssd1 vccd1 vccd1 _1297_ sky130_fd_sc_hd__a21o_1
X_2682_ net82 _1249_ _1254_ net496 vssd1 vssd1 vccd1 vccd1 _0403_ sky130_fd_sc_hd__a22o_1
XANTENNA__2081__S net18 vssd1 vssd1 vccd1 vccd1 sky130_fd_sc_hd__diode_2
X_1702_ net152 net143 MATMULT_INST.matmult_inst.mem_inst.mem3\[10\] vssd1 vssd1 vccd1
+ vccd1 _0625_ sky130_fd_sc_hd__and3_1
X_1633_ net216 _0551_ net104 MATMULT_INST.matmult_inst.mem_inst.matrixB0\[17\] _0545_
+ vssd1 vssd1 vccd1 vccd1 _0563_ sky130_fd_sc_hd__a221o_1
X_3303_ clknet_leaf_13_clk _0225_ vssd1 vssd1 vccd1 vccd1 MATMULT_INST.matmult_inst.mem_inst.matrixA1\[12\]
+ sky130_fd_sc_hd__dfxtp_1
X_3234_ clknet_leaf_10_clk _0156_ vssd1 vssd1 vccd1 vccd1 MATMULT_INST.matmult_inst.mem_inst.matrixB1\[15\]
+ sky130_fd_sc_hd__dfxtp_1
X_3165_ net61 net91 net79 vssd1 vssd1 vccd1 vccd1 _0090_ sky130_fd_sc_hd__and3_1
X_3096_ _0539_ _0542_ _0757_ _1589_ vssd1 vssd1 vccd1 vccd1 _1590_ sky130_fd_sc_hd__a31o_1
X_2116_ net379 net45 net14 vssd1 vssd1 vccd1 vccd1 _0271_ sky130_fd_sc_hd__mux2_1
XFILLER_54_336 vssd1 vssd1 vccd1 vccd1 sky130_fd_sc_hd__fill_4
X_2047_ net545 net38 net23 vssd1 vssd1 vccd1 vccd1 _0206_ sky130_fd_sc_hd__mux2_1
Xfanout37 _0809_ vssd1 vssd1 vccd1 vccd1 net37 sky130_fd_sc_hd__buf_2
XANTENNA__2462__B1 net210 vssd1 vssd1 vccd1 vccd1 sky130_fd_sc_hd__diode_2
XANTENNA__1948__X _0800_ vssd1 vssd1 vccd1 vccd1 sky130_fd_sc_hd__diode_2
Xfanout26 net27 vssd1 vssd1 vccd1 vccd1 net26 sky130_fd_sc_hd__clkbuf_4
Xfanout15 _0822_ vssd1 vssd1 vccd1 vccd1 net15 sky130_fd_sc_hd__clkbuf_4
XFILLER_22_266 vssd1 vssd1 vccd1 vccd1 sky130_fd_sc_hd__fill_1
Xfanout48 _0798_ vssd1 vssd1 vccd1 vccd1 net48 sky130_fd_sc_hd__clkbuf_2
Xfanout59 net62 vssd1 vssd1 vccd1 vccd1 net59 sky130_fd_sc_hd__clkbuf_2
X_2949_ net174 _1487_ _1486_ vssd1 vssd1 vccd1 vccd1 _1489_ sky130_fd_sc_hd__a21bo_1
XANTENNA_fanout216_X net216 vssd1 vssd1 vccd1 vccd1 sky130_fd_sc_hd__diode_2
XTAP_TAPCELL_ROW_9_248 vssd1 vccd1 sky130_fd_sc_hd__tapvpwrvgnd_1
XFILLER_8_7 vssd1 vssd1 vccd1 vccd1 sky130_fd_sc_hd__fill_2
XANTENNA__1740__A2 net112 vssd1 vssd1 vccd1 vccd1 sky130_fd_sc_hd__diode_2
XFILLER_54_21 vssd1 vssd1 vccd1 vccd1 sky130_fd_sc_hd__fill_1
XTAP_TAPCELL_ROW_0_170 vssd1 vccd1 sky130_fd_sc_hd__tapvpwrvgnd_1
XFILLER_54_43 vssd1 vssd1 vccd1 vccd1 sky130_fd_sc_hd__fill_2
XANTENNA_fanout31_X net31 vssd1 vssd1 vccd1 vccd1 sky130_fd_sc_hd__diode_2
XTAP_TAPCELL_ROW_43_537 vssd1 vccd1 sky130_fd_sc_hd__tapvpwrvgnd_1
XFILLER_53_391 vssd1 vssd1 vccd1 vccd1 sky130_fd_sc_hd__fill_1
XFILLER_13_244 vssd1 vssd1 vccd1 vccd1 sky130_fd_sc_hd__fill_2
XFILLER_13_288 vccd1 vssd1 vccd1 vssd1 sky130_ef_sc_hd__decap_40_12
XANTENNA__2205__A0 net190 vssd1 vssd1 vccd1 vccd1 sky130_fd_sc_hd__diode_2
Xclkload18 clknet_leaf_13_clk vssd1 vssd1 vccd1 vccd1 clkload18/Y sky130_fd_sc_hd__clkinv_2
Xclkload29 clknet_leaf_19_clk vssd1 vssd1 vccd1 vccd1 clkload29/Y sky130_fd_sc_hd__clkinvlp_4
XFILLER_5_421 vssd1 vssd1 vccd1 vccd1 sky130_fd_sc_hd__fill_1
XANTENNA__2849__B MATMULT_INST.matmult_inst.alu_inst.a1_reg\[7\] vssd1 vssd1 vccd1
+ vccd1 sky130_fd_sc_hd__diode_2
XFILLER_5_476 vccd1 vssd1 vccd1 vssd1 sky130_ef_sc_hd__decap_40_12
XANTENNA__1731__A2 net64 vssd1 vssd1 vccd1 vccd1 sky130_fd_sc_hd__diode_2
XFILLER_0_181 vccd1 vssd1 vccd1 vssd1 sky130_ef_sc_hd__decap_40_12
XFILLER_48_141 vccd1 vssd1 vccd1 vssd1 sky130_ef_sc_hd__decap_40_12
XFILLER_36_325 vssd1 vssd1 vccd1 vccd1 sky130_fd_sc_hd__fill_1
XTAP_TAPCELL_ROW_59_670 vssd1 vccd1 sky130_fd_sc_hd__tapvpwrvgnd_1
XANTENNA__2076__S net18 vssd1 vssd1 vccd1 vccd1 sky130_fd_sc_hd__diode_2
XFILLER_63_188 vssd1 vssd1 vccd1 vccd1 sky130_fd_sc_hd__fill_1
X_2803_ _1338_ _1345_ _1346_ vssd1 vssd1 vccd1 vccd1 _1347_ sky130_fd_sc_hd__nand3_1
XTAP_TAPCELL_ROW_14_294 vssd1 vccd1 sky130_fd_sc_hd__tapvpwrvgnd_1
X_2734_ net183 net164 net163 net184 vssd1 vssd1 vccd1 vccd1 _1281_ sky130_fd_sc_hd__a22oi_1
X_2665_ net515 _1246_ _1247_ net103 vssd1 vssd1 vccd1 vccd1 _0393_ sky130_fd_sc_hd__a22o_1
X_2596_ _1184_ _1185_ vssd1 vssd1 vccd1 vccd1 _1186_ sky130_fd_sc_hd__nand2b_1
X_1616_ net138 net146 vssd1 vssd1 vccd1 vccd1 _0546_ sky130_fd_sc_hd__and2b_1
XFILLER_5_70 vccd1 vssd1 vccd1 vssd1 sky130_ef_sc_hd__decap_40_12
Xfanout205 MATMULT_INST.matmult_inst.alu_inst.b0_reg\[5\] vssd1 vssd1 vccd1 vccd1
+ net205 sky130_fd_sc_hd__clkbuf_2
Xfanout227 net228 vssd1 vssd1 vccd1 vccd1 net227 sky130_fd_sc_hd__clkbuf_4
Xfanout216 net218 vssd1 vssd1 vccd1 vccd1 net216 sky130_fd_sc_hd__clkbuf_4
X_3217_ clknet_leaf_10_clk _0139_ vssd1 vssd1 vccd1 vccd1 MATMULT_INST.matmult_inst.mem_inst.matrixB2\[16\]
+ sky130_fd_sc_hd__dfxtp_1
XFILLER_74_409 vssd1 vssd1 vccd1 vccd1 sky130_fd_sc_hd__fill_2
XANTENNA__2683__B1 _1254_ vssd1 vssd1 vccd1 vccd1 sky130_fd_sc_hd__diode_2
X_3148_ net57 net84 net76 vssd1 vssd1 vccd1 vccd1 _0073_ sky130_fd_sc_hd__and3_1
XANTENNA__1891__D1 net86 vssd1 vssd1 vccd1 vccd1 sky130_fd_sc_hd__diode_2
X_3079_ MATMULT_INST.matmult_inst.alu_inst.out\[15\] net51 net6 net307 vssd1 vssd1
+ vccd1 vccd1 _0523_ sky130_fd_sc_hd__a22o_1
XFILLER_35_380 vssd1 vssd1 vccd1 vccd1 sky130_fd_sc_hd__fill_4
XFILLER_50_350 vssd1 vssd1 vccd1 vccd1 sky130_fd_sc_hd__fill_2
XANTENNA__1789__A2 net128 vssd1 vssd1 vccd1 vccd1 sky130_fd_sc_hd__diode_2
XANTENNA__1838__B net2 vssd1 vssd1 vccd1 vccd1 sky130_fd_sc_hd__diode_2
XFILLER_10_214 vccd1 vssd1 vccd1 vssd1 sky130_ef_sc_hd__decap_40_12
XFILLER_24_68 vccd1 vssd1 vccd1 vssd1 sky130_ef_sc_hd__decap_40_12
XFILLER_40_12 vssd1 vssd1 vccd1 vccd1 sky130_fd_sc_hd__fill_1
Xhold270 MATMULT_INST.matmult_inst.mem_inst.mem2\[15\] vssd1 vssd1 vccd1 vccd1 net565
+ sky130_fd_sc_hd__dlygate4sd3_1
XFILLER_2_457 vccd1 vssd1 vccd1 vssd1 sky130_ef_sc_hd__decap_40_12
Xhold281 MATMULT_INST.matmult_inst.alu_inst.row1\[3\] vssd1 vssd1 vccd1 vccd1 net576
+ sky130_fd_sc_hd__dlygate4sd3_1
Xhold292 MATMULT_INST.matmult_inst.mem_inst.mem0\[4\] vssd1 vssd1 vccd1 vccd1 net587
+ sky130_fd_sc_hd__dlygate4sd3_1
XFILLER_49_54 vssd1 vssd1 vccd1 vccd1 sky130_fd_sc_hd__fill_2
XFILLER_49_65 vssd1 vssd1 vccd1 vccd1 sky130_fd_sc_hd__fill_1
XFILLER_73_420 vssd1 vssd1 vccd1 vccd1 sky130_fd_sc_hd__fill_2
XFILLER_65_31 vssd1 vssd1 vccd1 vccd1 sky130_fd_sc_hd__fill_1
XFILLER_65_53 vssd1 vssd1 vccd1 vccd1 sky130_fd_sc_hd__fill_2
XTAP_TAPCELL_ROW_56_651 vssd1 vccd1 sky130_fd_sc_hd__tapvpwrvgnd_1
XFILLER_60_103 vssd1 vssd1 vccd1 vccd1 sky130_fd_sc_hd__fill_2
XFILLER_26_391 vssd1 vssd1 vccd1 vccd1 sky130_fd_sc_hd__fill_1
XFILLER_33_339 vssd1 vssd1 vccd1 vccd1 sky130_fd_sc_hd__fill_1
XTAP_TAPCELL_ROW_11_264 vssd1 vccd1 sky130_fd_sc_hd__tapvpwrvgnd_1
X_2450_ _1042_ _1043_ _1034_ vssd1 vssd1 vccd1 vccd1 _1044_ sky130_fd_sc_hd__a21oi_1
XANTENNA__1952__A2 net71 vssd1 vssd1 vccd1 vccd1 sky130_fd_sc_hd__diode_2
XFILLER_5_284 vccd1 vssd1 vccd1 vssd1 sky130_ef_sc_hd__decap_40_12
X_2381_ net627 _0977_ net97 vssd1 vssd1 vccd1 vccd1 _0379_ sky130_fd_sc_hd__mux2_1
X_3002_ _1521_ _1538_ _1537_ vssd1 vssd1 vccd1 vccd1 _1540_ sky130_fd_sc_hd__a21o_1
XTAP_TAPCELL_ROW_19_331 vssd1 vccd1 sky130_fd_sc_hd__tapvpwrvgnd_1
XANTENNA__2665__B1 _1247_ vssd1 vssd1 vccd1 vccd1 sky130_fd_sc_hd__diode_2
XFILLER_17_391 vssd1 vssd1 vccd1 vccd1 sky130_fd_sc_hd__fill_1
XTAP_TAPCELL_ROW_62_698 vssd1 vccd1 sky130_fd_sc_hd__tapvpwrvgnd_1
XANTENNA_fanout126_A net131 vssd1 vssd1 vccd1 vccd1 sky130_fd_sc_hd__diode_2
X_2717_ _0543_ _0549_ _0557_ _0760_ _1267_ vssd1 vssd1 vccd1 vccd1 _1268_ sky130_fd_sc_hd__a311o_1
XFILLER_10_59 vccd1 vssd1 vccd1 vssd1 sky130_ef_sc_hd__decap_40_12
X_2648_ _1194_ _1197_ _1218_ _1230_ _1217_ vssd1 vssd1 vccd1 vccd1 _1235_ sky130_fd_sc_hd__a311o_1
X_2579_ _1138_ _1169_ vssd1 vssd1 vccd1 vccd1 _1170_ sky130_fd_sc_hd__or2_1
XFILLER_19_46 vssd1 vssd1 vccd1 vccd1 sky130_fd_sc_hd__fill_1
XFILLER_55_431 vssd1 vssd1 vccd1 vccd1 sky130_fd_sc_hd__fill_8
XFILLER_27_166 vssd1 vssd1 vccd1 vccd1 sky130_fd_sc_hd__fill_2
XTAP_TAPCELL_ROW_53_621 vssd1 vccd1 sky130_fd_sc_hd__tapvpwrvgnd_1
XFILLER_70_489 vssd1 vssd1 vccd1 vccd1 sky130_fd_sc_hd__fill_2
XFILLER_51_66 vssd1 vssd1 vccd1 vccd1 sky130_fd_sc_hd__fill_1
XFILLER_61_401 vssd1 vssd1 vccd1 vccd1 sky130_fd_sc_hd__fill_2
XFILLER_73_272 vssd1 vssd1 vccd1 vccd1 sky130_fd_sc_hd__fill_8
XTAP_TAPCELL_ROW_16_312 vssd1 vccd1 sky130_fd_sc_hd__tapvpwrvgnd_1
XFILLER_33_103 vssd1 vssd1 vccd1 vccd1 sky130_fd_sc_hd__fill_4
X_1950_ MATMULT_INST.matmult_inst.fsm_inst.rx_data\[4\] net71 net70 MATMULT_INST.matmult_inst.fsm_inst.alu_result\[4\]
+ vssd1 vssd1 vccd1 vccd1 _0801_ sky130_fd_sc_hd__a22o_2
XFILLER_14_394 vssd1 vssd1 vccd1 vccd1 sky130_fd_sc_hd__fill_4
X_1881_ net132 net133 _0758_ vssd1 vssd1 vccd1 vccd1 _0759_ sky130_fd_sc_hd__o21ai_1
X_3620_ clknet_leaf_22_clk MATMULT_INST.matmult_inst.spi_inst.mosi_data_spi\[4\] _0118_
+ vssd1 vssd1 vccd1 vccd1 MATMULT_INST.matmult_inst.spi_inst.mosi_data_sync\[4\] sky130_fd_sc_hd__dfrtp_1
X_3551_ clknet_leaf_22_clk MATMULT_INST.matmult_inst.spi_inst.rx_done_spi _0067_ vssd1
+ vssd1 vccd1 vccd1 MATMULT_INST.matmult_inst.spi_inst.rx_done1 sky130_fd_sc_hd__dfrtp_1
X_2502_ _1091_ _1092_ _1093_ vssd1 vssd1 vccd1 vccd1 _1095_ sky130_fd_sc_hd__nor3_1
X_3482_ clknet_leaf_2_clk _0402_ vssd1 vssd1 vccd1 vccd1 MATMULT_INST.matmult_inst.alu_inst.col0\[2\]
+ sky130_fd_sc_hd__dfxtp_1
XFILLER_51_3 vssd1 vssd1 vccd1 vccd1 sky130_fd_sc_hd__fill_2
X_2433_ _1026_ _1027_ _1001_ vssd1 vssd1 vccd1 vccd1 _1028_ sky130_fd_sc_hd__a21oi_1
X_2364_ _0958_ _0959_ _0946_ vssd1 vssd1 vccd1 vccd1 _0961_ sky130_fd_sc_hd__a21o_1
XANTENNA__1941__B net120 vssd1 vssd1 vccd1 vccd1 sky130_fd_sc_hd__diode_2
X_2295_ MATMULT_INST.matmult_inst.alu_inst.adder_inst.r3.fa2.b MATMULT_INST.matmult_inst.alu_inst.adder_inst.r3.fa2.a
+ vssd1 vssd1 vccd1 vccd1 _0917_ sky130_fd_sc_hd__or2_1
XFILLER_56_239 vssd1 vssd1 vccd1 vccd1 sky130_fd_sc_hd__fill_2
XFILLER_52_401 vccd1 vssd1 vccd1 vssd1 sky130_ef_sc_hd__decap_40_12
XFILLER_12_309 vssd1 vssd1 vccd1 vccd1 sky130_fd_sc_hd__fill_2
XFILLER_52_467 vssd1 vssd1 vccd1 vccd1 sky130_fd_sc_hd__fill_1
XANTENNA__1956__X _0804_ vssd1 vssd1 vccd1 vccd1 sky130_fd_sc_hd__diode_2
XTAP_TAPCELL_ROW_22_359 vssd1 vccd1 sky130_fd_sc_hd__tapvpwrvgnd_1
XANTENNA_fanout129_X net129 vssd1 vssd1 vccd1 vccd1 sky130_fd_sc_hd__diode_2
XANTENNA_input3_X net3 vssd1 vssd1 vccd1 vccd1 sky130_fd_sc_hd__diode_2
XANTENNA__2385__D net210 vssd1 vssd1 vccd1 vccd1 sky130_fd_sc_hd__diode_2
XFILLER_15_125 vccd1 vssd1 vccd1 vssd1 sky130_ef_sc_hd__decap_40_12
XFILLER_15_169 vssd1 vssd1 vccd1 vccd1 sky130_fd_sc_hd__fill_2
XANTENNA_clkbuf_2_0__f_clk_A clknet_0_clk vssd1 vssd1 vccd1 vccd1 sky130_fd_sc_hd__diode_2
XTAP_TAPCELL_ROW_38_492 vssd1 vccd1 sky130_fd_sc_hd__tapvpwrvgnd_1
XANTENNA_clkbuf_leaf_16_clk_A clknet_2_1__leaf_clk vssd1 vssd1 vccd1 vccd1 sky130_fd_sc_hd__diode_2
XANTENNA_fanout8_X net8 vssd1 vssd1 vccd1 vccd1 sky130_fd_sc_hd__diode_2
XFILLER_7_357 vssd1 vssd1 vccd1 vccd1 sky130_fd_sc_hd__fill_2
XFILLER_7_335 vssd1 vssd1 vccd1 vccd1 sky130_fd_sc_hd__fill_1
XANTENNA__3018__B net114 vssd1 vssd1 vccd1 vccd1 sky130_fd_sc_hd__diode_2
XFILLER_23_7 vssd1 vssd1 vccd1 vccd1 sky130_fd_sc_hd__fill_2
X_2080_ net560 net43 net18 vssd1 vssd1 vccd1 vccd1 _0237_ sky130_fd_sc_hd__mux2_1
XTAP_TAPCELL_ROW_64_716 vssd1 vccd1 sky130_fd_sc_hd__tapvpwrvgnd_1
XFILLER_34_401 vssd1 vssd1 vccd1 vccd1 sky130_fd_sc_hd__fill_1
XFILLER_46_261 vssd1 vssd1 vccd1 vccd1 sky130_fd_sc_hd__fill_2
XANTENNA__2084__S net19 vssd1 vssd1 vccd1 vccd1 sky130_fd_sc_hd__diode_2
XFILLER_34_467 vssd1 vssd1 vccd1 vccd1 sky130_fd_sc_hd__fill_8
XFILLER_61_253 vssd1 vssd1 vccd1 vccd1 sky130_fd_sc_hd__fill_2
XTAP_TAPCELL_ROW_72_782 vssd1 vccd1 sky130_fd_sc_hd__tapvpwrvgnd_1
X_2982_ _1481_ _1519_ vssd1 vssd1 vccd1 vccd1 _1521_ sky130_fd_sc_hd__or2_1
X_1933_ MATMULT_INST.matmult_inst.spi_inst.tx_reg_sys\[12\] MATMULT_INST.matmult_inst.spi_inst.miso_shifter\[11\]
+ net137 vssd1 vssd1 vccd1 vccd1 _0010_ sky130_fd_sc_hd__mux2_1
X_1864_ MATMULT_INST.matmult_inst.spi_inst.rx_bit_count\[0\] MATMULT_INST.matmult_inst.spi_inst.rx_bit_count\[3\]
+ vssd1 vssd1 vccd1 vccd1 _0747_ sky130_fd_sc_hd__nand2b_1
X_3603_ clknet_leaf_18_clk _0496_ _0101_ vssd1 vssd1 vccd1 vccd1 MATMULT_INST.matmult_inst.spi_inst.tx_reg_sys\[6\]
+ sky130_fd_sc_hd__dfrtp_1
X_1795_ MATMULT_INST.matmult_inst.mem_inst.mem0\[2\] net108 net104 MATMULT_INST.matmult_inst.mem_inst.matrixB0\[2\]
+ _0709_ vssd1 vssd1 vccd1 vccd1 _0710_ sky130_fd_sc_hd__a221o_1
X_3534_ _0036_ _0448_ _0035_ vssd1 vssd1 vccd1 vccd1 MATMULT_INST.matmult_inst.spi_inst.mosi_data_spi\[1\]
+ sky130_fd_sc_hd__dfrtp_1
X_3465_ clknet_leaf_35_clk _0386_ vssd1 vssd1 vccd1 vccd1 MATMULT_INST.matmult_inst.alu_inst.adder_inst.r2.fa3.a
+ sky130_fd_sc_hd__dfxtp_1
X_2416_ _1008_ _1009_ _0989_ vssd1 vssd1 vccd1 vccd1 _1011_ sky130_fd_sc_hd__a21o_1
X_3396_ clknet_leaf_20_clk _0318_ vssd1 vssd1 vccd1 vccd1 MATMULT_INST.matmult_inst.mem_inst.mem0\[15\]
+ sky130_fd_sc_hd__dfxtp_1
X_2347_ net213 net194 net192 net214 vssd1 vssd1 vccd1 vccd1 _0945_ sky130_fd_sc_hd__a22oi_1
X_2278_ MATMULT_INST.matmult_inst.alu_inst.adder_inst.r2.fa3.b MATMULT_INST.matmult_inst.alu_inst.adder_inst.r2.fa3.a
+ vssd1 vssd1 vccd1 vccd1 _0903_ sky130_fd_sc_hd__nand2_1
XFILLER_25_445 vssd1 vssd1 vccd1 vccd1 sky130_fd_sc_hd__fill_2
XFILLER_12_106 vssd1 vssd1 vccd1 vccd1 sky130_fd_sc_hd__fill_8
XTAP_TAPCELL_ROW_35_473 vssd1 vccd1 sky130_fd_sc_hd__tapvpwrvgnd_1
XFILLER_12_139 vssd1 vssd1 vccd1 vccd1 sky130_fd_sc_hd__fill_1
XFILLER_4_316 vssd1 vssd1 vccd1 vccd1 sky130_fd_sc_hd__fill_2
XFILLER_20_194 vssd1 vssd1 vccd1 vccd1 sky130_fd_sc_hd__fill_2
XANTENNA__2011__A1 net107 vssd1 vssd1 vccd1 vccd1 sky130_fd_sc_hd__diode_2
XFILLER_4_349 vccd1 vssd1 vccd1 vssd1 sky130_ef_sc_hd__decap_40_12
XFILLER_79_106 vssd1 vssd1 vccd1 vccd1 sky130_fd_sc_hd__fill_4
XFILLER_75_301 vssd1 vssd1 vccd1 vccd1 sky130_fd_sc_hd__fill_4
XFILLER_75_345 vssd1 vssd1 vccd1 vccd1 sky130_fd_sc_hd__fill_2
XANTENNA__2078__A1 _0801_ vssd1 vssd1 vccd1 vccd1 sky130_fd_sc_hd__diode_2
XFILLER_73_31 vccd1 vssd1 vccd1 vssd1 sky130_ef_sc_hd__decap_40_12
XFILLER_16_401 vccd1 vssd1 vccd1 vssd1 sky130_ef_sc_hd__decap_40_12
XFILLER_28_294 vssd1 vssd1 vccd1 vccd1 sky130_fd_sc_hd__fill_2
XFILLER_16_489 vssd1 vssd1 vccd1 vccd1 sky130_fd_sc_hd__fill_4
XFILLER_7_121 vssd1 vssd1 vccd1 vccd1 sky130_fd_sc_hd__fill_4
XFILLER_11_194 vccd1 vssd1 vccd1 vssd1 sky130_ef_sc_hd__decap_40_12
X_3250_ clknet_leaf_12_clk _0172_ vssd1 vssd1 vccd1 vccd1 MATMULT_INST.matmult_inst.mem_inst.matrixB0\[13\]
+ sky130_fd_sc_hd__dfxtp_1
X_3181_ net61 net91 net79 vssd1 vssd1 vccd1 vccd1 _0106_ sky130_fd_sc_hd__and3_1
X_2201_ net558 net532 net67 vssd1 vssd1 vccd1 vccd1 _0333_ sky130_fd_sc_hd__mux2_1
XANTENNA__2079__S net18 vssd1 vssd1 vccd1 vccd1 sky130_fd_sc_hd__diode_2
XTAP_TAPCELL_ROW_77_830 vssd1 vccd1 sky130_fd_sc_hd__tapvpwrvgnd_1
XFILLER_14_3 vccd1 vssd1 vccd1 vssd1 sky130_ef_sc_hd__decap_40_12
X_2132_ net392 net48 net12 vssd1 vssd1 vccd1 vccd1 _0286_ sky130_fd_sc_hd__mux2_1
XANTENNA__2069__A1 net35 vssd1 vssd1 vccd1 vccd1 sky130_fd_sc_hd__diode_2
XFILLER_26_209 vssd1 vssd1 vccd1 vccd1 sky130_fd_sc_hd__fill_8
X_2063_ net409 net41 net21 vssd1 vssd1 vccd1 vccd1 _0221_ sky130_fd_sc_hd__mux2_1
XTAP_TAPCELL_ROW_49_587 vssd1 vccd1 sky130_fd_sc_hd__tapvpwrvgnd_1
XANTENNA__1816__B2 net219 vssd1 vssd1 vccd1 vccd1 sky130_fd_sc_hd__diode_2
X_2965_ _1437_ _1439_ _1470_ _1471_ _1436_ vssd1 vssd1 vccd1 vccd1 _1505_ sky130_fd_sc_hd__o221ai_4
XTAP_TAPCELL_ROW_32_443 vssd1 vccd1 sky130_fd_sc_hd__tapvpwrvgnd_1
X_2896_ _1435_ _1437_ vssd1 vssd1 vccd1 vccd1 _1438_ sky130_fd_sc_hd__nor2_1
X_1916_ net132 _1593_ _0542_ _0791_ vssd1 vssd1 vccd1 vccd1 _0002_ sky130_fd_sc_hd__a31o_1
X_1847_ MATMULT_INST.matmult_inst.spi_inst.rx_bit_count\[3\] MATMULT_INST.matmult_inst.spi_inst.rx_bit_count\[0\]
+ vssd1 vssd1 vccd1 vccd1 _0742_ sky130_fd_sc_hd__and2b_1
X_3517_ clknet_leaf_29_clk _0434_ vssd1 vssd1 vccd1 vccd1 MATMULT_INST.matmult_inst.alu_inst.adder_inst.r2.fa0.b
+ sky130_fd_sc_hd__dfxtp_1
X_1778_ MATMULT_INST.matmult_inst.mem_inst.mem1\[3\] net128 net120 MATMULT_INST.matmult_inst.mem_inst.mem2\[3\]
+ _0693_ vssd1 vssd1 vccd1 vccd1 _0694_ sky130_fd_sc_hd__a221o_1
X_3448_ clknet_leaf_33_clk _0370_ vssd1 vssd1 vccd1 vccd1 MATMULT_INST.matmult_inst.alu_inst.a1_reg\[3\]
+ sky130_fd_sc_hd__dfxtp_1
X_3379_ clknet_leaf_11_clk _0301_ vssd1 vssd1 vccd1 vccd1 MATMULT_INST.matmult_inst.mem_inst.mem1\[16\]
+ sky130_fd_sc_hd__dfxtp_1
XFILLER_57_389 vssd1 vssd1 vccd1 vccd1 sky130_fd_sc_hd__fill_2
XANTENNA__1807__A1 _0720_ vssd1 vssd1 vccd1 vccd1 sky130_fd_sc_hd__diode_2
XFILLER_13_437 vssd1 vssd1 vccd1 vccd1 sky130_fd_sc_hd__fill_1
XFILLER_43_34 vccd1 vssd1 vccd1 vssd1 sky130_ef_sc_hd__decap_40_12
XFILLER_21_470 vssd1 vssd1 vccd1 vccd1 sky130_fd_sc_hd__fill_4
XFILLER_67_109 vssd1 vssd1 vccd1 vccd1 sky130_fd_sc_hd__fill_2
XFILLER_0_363 vssd1 vssd1 vccd1 vccd1 sky130_fd_sc_hd__fill_1
XTAP_TAPCELL_ROW_74_800 vssd1 vccd1 sky130_fd_sc_hd__tapvpwrvgnd_1
XFILLER_63_337 vssd1 vssd1 vccd1 vccd1 sky130_fd_sc_hd__fill_1
XFILLER_16_253 vccd1 vssd1 vccd1 vssd1 sky130_ef_sc_hd__decap_40_12
XFILLER_31_223 vssd1 vssd1 vccd1 vccd1 sky130_fd_sc_hd__fill_1
XFILLER_31_234 vssd1 vssd1 vccd1 vccd1 sky130_fd_sc_hd__fill_1
XFILLER_31_245 vssd1 vssd1 vccd1 vccd1 sky130_fd_sc_hd__fill_8
X_2750_ _1282_ _1294_ _1295_ vssd1 vssd1 vccd1 vccd1 _1296_ sky130_fd_sc_hd__nand3_1
X_1701_ MATMULT_INST.matmult_inst.mem_inst.matrixA0\[10\] net113 _0623_ _0545_ vssd1
+ vssd1 vccd1 vccd1 _0624_ sky130_fd_sc_hd__a211o_1
X_2681_ net82 _1248_ _1254_ net359 vssd1 vssd1 vccd1 vccd1 _0402_ sky130_fd_sc_hd__a22o_1
X_1632_ MATMULT_INST.matmult_inst.mem_inst.matrixA0\[17\] net113 net110 MATMULT_INST.matmult_inst.mem_inst.mem0\[17\]
+ vssd1 vssd1 vccd1 vccd1 _0562_ sky130_fd_sc_hd__a22o_1
XANTENNA__1734__B1 net107 vssd1 vssd1 vccd1 vccd1 sky130_fd_sc_hd__diode_2
X_3302_ clknet_leaf_14_clk _0224_ vssd1 vssd1 vccd1 vccd1 MATMULT_INST.matmult_inst.mem_inst.matrixA1\[11\]
+ sky130_fd_sc_hd__dfxtp_1
X_3233_ clknet_leaf_10_clk _0155_ vssd1 vssd1 vccd1 vccd1 MATMULT_INST.matmult_inst.mem_inst.matrixB1\[14\]
+ sky130_fd_sc_hd__dfxtp_1
XFILLER_39_312 vssd1 vssd1 vccd1 vccd1 sky130_fd_sc_hd__fill_1
XFILLER_39_334 vssd1 vssd1 vccd1 vccd1 sky130_fd_sc_hd__fill_2
X_3164_ net61 net91 net79 vssd1 vssd1 vccd1 vccd1 _0089_ sky130_fd_sc_hd__and3_1
XFILLER_39_367 vssd1 vssd1 vccd1 vccd1 sky130_fd_sc_hd__fill_8
XFILLER_66_186 vssd1 vssd1 vccd1 vccd1 sky130_fd_sc_hd__fill_1
X_3095_ net134 net133 _0756_ net135 vssd1 vssd1 vccd1 vccd1 _1589_ sky130_fd_sc_hd__and4b_1
X_2115_ net588 net46 net15 vssd1 vssd1 vccd1 vccd1 _0270_ sky130_fd_sc_hd__mux2_1
XFILLER_54_315 vssd1 vssd1 vccd1 vccd1 sky130_fd_sc_hd__fill_1
X_2046_ net450 net39 net22 vssd1 vssd1 vccd1 vccd1 _0205_ sky130_fd_sc_hd__mux2_1
Xfanout38 _0808_ vssd1 vssd1 vccd1 vccd1 net38 sky130_fd_sc_hd__buf_2
Xfanout27 _0816_ vssd1 vssd1 vccd1 vccd1 net27 sky130_fd_sc_hd__clkbuf_4
Xfanout16 _0821_ vssd1 vssd1 vccd1 vccd1 net16 sky130_fd_sc_hd__buf_4
XFILLER_13_15 vccd1 vssd1 vccd1 vssd1 sky130_ef_sc_hd__decap_40_12
Xfanout49 _0797_ vssd1 vssd1 vccd1 vccd1 net49 sky130_fd_sc_hd__clkbuf_2
X_2948_ net174 _1487_ vssd1 vssd1 vccd1 vccd1 _1488_ sky130_fd_sc_hd__and2_1
X_2879_ net173 net175 net165 net162 vssd1 vssd1 vccd1 vccd1 _1421_ sky130_fd_sc_hd__nand4_1
XANTENNA_fanout111_X net111 vssd1 vssd1 vccd1 vccd1 sky130_fd_sc_hd__diode_2
XTAP_TAPCELL_ROW_9_249 vssd1 vccd1 sky130_fd_sc_hd__tapvpwrvgnd_1
XFILLER_49_109 vssd1 vssd1 vccd1 vccd1 sky130_fd_sc_hd__fill_2
XTAP_TAPCELL_ROW_0_160 vssd1 vccd1 sky130_fd_sc_hd__tapvpwrvgnd_1
XTAP_TAPCELL_ROW_0_171 vssd1 vccd1 sky130_fd_sc_hd__tapvpwrvgnd_1
XFILLER_13_223 vssd1 vssd1 vccd1 vccd1 sky130_fd_sc_hd__fill_1
XTAP_TAPCELL_ROW_43_538 vssd1 vccd1 sky130_fd_sc_hd__tapvpwrvgnd_1
XANTENNA_fanout24_X net24 vssd1 vssd1 vccd1 vccd1 sky130_fd_sc_hd__diode_2
XFILLER_13_278 vssd1 vssd1 vccd1 vccd1 sky130_fd_sc_hd__fill_2
XANTENNA__2035__X _0818_ vssd1 vssd1 vccd1 vccd1 sky130_fd_sc_hd__diode_2
Xclkload19 clknet_leaf_14_clk vssd1 vssd1 vccd1 vccd1 clkload19/Y sky130_fd_sc_hd__inv_6
XFILLER_5_411 vssd1 vssd1 vccd1 vccd1 sky130_fd_sc_hd__fill_8
XFILLER_5_488 vssd1 vssd1 vccd1 vccd1 sky130_fd_sc_hd__fill_2
XANTENNA__1716__B1 net121 vssd1 vssd1 vccd1 vccd1 sky130_fd_sc_hd__diode_2
XFILLER_68_418 vssd1 vssd1 vccd1 vccd1 sky130_fd_sc_hd__fill_2
XFILLER_0_193 vssd1 vssd1 vccd1 vccd1 sky130_fd_sc_hd__fill_2
XFILLER_48_153 vccd1 vssd1 vccd1 vssd1 sky130_ef_sc_hd__decap_40_12
XANTENNA__2692__A1 net93 vssd1 vssd1 vccd1 vccd1 sky130_fd_sc_hd__diode_2
XFILLER_36_304 vssd1 vssd1 vccd1 vccd1 sky130_fd_sc_hd__fill_4
XFILLER_36_315 vssd1 vssd1 vccd1 vccd1 sky130_fd_sc_hd__fill_8
XFILLER_48_175 vssd1 vssd1 vccd1 vccd1 sky130_fd_sc_hd__fill_2
XTAP_TAPCELL_ROW_59_671 vssd1 vccd1 sky130_fd_sc_hd__tapvpwrvgnd_1
Xteam_02_290 vssd1 vssd1 vccd1 vccd1 team_02_290/HI gpio_out[31] sky130_fd_sc_hd__conb_1
X_2802_ _1343_ _1344_ _1315_ vssd1 vssd1 vccd1 vccd1 _1346_ sky130_fd_sc_hd__a21o_1
XTAP_TAPCELL_ROW_14_295 vssd1 vccd1 sky130_fd_sc_hd__tapvpwrvgnd_1
X_2733_ _1279_ _1280_ net648 net115 vssd1 vssd1 vccd1 vccd1 _0428_ sky130_fd_sc_hd__a2bb2o_1
X_2664_ _0720_ net101 vssd1 vssd1 vccd1 vccd1 _1247_ sky130_fd_sc_hd__and2_2
X_2595_ _1149_ _1183_ vssd1 vssd1 vccd1 vccd1 _1185_ sky130_fd_sc_hd__or2_1
X_1615_ _0545_ vssd1 vssd1 vccd1 vccd1 MATMULT_INST.matmult_inst.fsm_inst.load sky130_fd_sc_hd__inv_2
XFILLER_5_82 vccd1 vssd1 vccd1 vssd1 sky130_ef_sc_hd__decap_40_12
Xfanout228 net1 vssd1 vssd1 vccd1 vccd1 net228 sky130_fd_sc_hd__clkbuf_2
XTAP_TAPCELL_ROW_6_219 vssd1 vccd1 sky130_fd_sc_hd__tapvpwrvgnd_1
Xfanout206 net207 vssd1 vssd1 vccd1 vccd1 net206 sky130_fd_sc_hd__buf_2
Xfanout217 net218 vssd1 vssd1 vccd1 vccd1 net217 sky130_fd_sc_hd__clkbuf_4
XFILLER_59_418 vssd1 vssd1 vccd1 vccd1 sky130_fd_sc_hd__fill_4
XFILLER_59_429 vccd1 vssd1 vccd1 vssd1 sky130_ef_sc_hd__decap_40_12
X_3216_ clknet_leaf_9_clk _0138_ vssd1 vssd1 vccd1 vccd1 MATMULT_INST.matmult_inst.mem_inst.matrixB2\[15\]
+ sky130_fd_sc_hd__dfxtp_1
XFILLER_67_484 vssd1 vssd1 vccd1 vccd1 sky130_fd_sc_hd__fill_8
XFILLER_67_462 vssd1 vssd1 vccd1 vccd1 sky130_fd_sc_hd__fill_2
XFILLER_27_315 vccd1 vssd1 vccd1 vssd1 sky130_ef_sc_hd__decap_40_12
XANTENNA__2683__A1 net82 vssd1 vssd1 vccd1 vccd1 sky130_fd_sc_hd__diode_2
X_3147_ net55 net85 net76 vssd1 vssd1 vccd1 vccd1 _0072_ sky130_fd_sc_hd__and3_1
XFILLER_54_101 vssd1 vssd1 vccd1 vccd1 sky130_fd_sc_hd__fill_1
XFILLER_27_337 vssd1 vssd1 vccd1 vccd1 sky130_fd_sc_hd__fill_2
XFILLER_54_145 vssd1 vssd1 vccd1 vccd1 sky130_fd_sc_hd__fill_1
X_3078_ MATMULT_INST.matmult_inst.alu_inst.out\[14\] net51 net6 net312 vssd1 vssd1
+ vccd1 vccd1 _0522_ sky130_fd_sc_hd__a22o_1
X_2029_ net384 net37 net25 vssd1 vssd1 vccd1 vccd1 _0189_ sky130_fd_sc_hd__mux2_1
XTAP_TAPCELL_ROW_40_508 vssd1 vccd1 sky130_fd_sc_hd__tapvpwrvgnd_1
XFILLER_10_226 vssd1 vssd1 vccd1 vccd1 sky130_fd_sc_hd__fill_2
XANTENNA__2199__A0 net203 vssd1 vssd1 vccd1 vccd1 sky130_fd_sc_hd__diode_2
XFILLER_40_24 vssd1 vssd1 vccd1 vccd1 sky130_fd_sc_hd__fill_4
Xhold260 MATMULT_INST.matmult_inst.alu_inst.out\[6\] vssd1 vssd1 vccd1 vccd1 net555
+ sky130_fd_sc_hd__dlygate4sd3_1
Xhold271 MATMULT_INST.matmult_inst.mem_inst.matrixA2\[4\] vssd1 vssd1 vccd1 vccd1
+ net566 sky130_fd_sc_hd__dlygate4sd3_1
XFILLER_2_469 vssd1 vssd1 vccd1 vccd1 sky130_fd_sc_hd__fill_4
Xhold293 MATMULT_INST.matmult_inst.mem_inst.mem2\[3\] vssd1 vssd1 vccd1 vccd1 net588
+ sky130_fd_sc_hd__dlygate4sd3_1
Xhold282 MATMULT_INST.matmult_inst.spi_inst.mosi_data_sync\[6\] vssd1 vssd1 vccd1
+ vccd1 net577 sky130_fd_sc_hd__dlygate4sd3_1
XFILLER_58_473 vssd1 vssd1 vccd1 vccd1 sky130_fd_sc_hd__fill_1
XANTENNA__1869__X MATMULT_INST.matmult_inst.fsm_inst.transaction_ready vssd1 vssd1
+ vccd1 vccd1 sky130_fd_sc_hd__diode_2
XTAP_TAPCELL_ROW_56_652 vssd1 vccd1 sky130_fd_sc_hd__tapvpwrvgnd_1
XFILLER_14_91 vssd1 vssd1 vccd1 vccd1 sky130_fd_sc_hd__fill_1
XTAP_TAPCELL_ROW_11_265 vssd1 vccd1 sky130_fd_sc_hd__tapvpwrvgnd_1
XFILLER_5_263 vssd1 vssd1 vccd1 vccd1 sky130_fd_sc_hd__fill_2
XFILLER_5_296 vccd1 vssd1 vccd1 vssd1 sky130_ef_sc_hd__decap_40_12
X_2380_ _0955_ _0976_ vssd1 vssd1 vccd1 vccd1 _0977_ sky130_fd_sc_hd__xnor2_2
XFILLER_64_410 vssd1 vssd1 vccd1 vccd1 sky130_fd_sc_hd__fill_1
X_3001_ _1521_ _1537_ _1538_ vssd1 vssd1 vccd1 vccd1 _1539_ sky130_fd_sc_hd__and3_1
XANTENNA__2087__S net18 vssd1 vssd1 vccd1 vccd1 sky130_fd_sc_hd__diode_2
XFILLER_64_421 vssd1 vssd1 vccd1 vccd1 sky130_fd_sc_hd__fill_2
XANTENNA__2665__B2 net103 vssd1 vssd1 vccd1 vccd1 sky130_fd_sc_hd__diode_2
XTAP_TAPCELL_ROW_19_332 vssd1 vccd1 sky130_fd_sc_hd__tapvpwrvgnd_1
XTAP_TAPCELL_ROW_62_699 vssd1 vccd1 sky130_fd_sc_hd__tapvpwrvgnd_1
X_2716_ net134 _0776_ _1266_ _0748_ net102 vssd1 vssd1 vccd1 vccd1 _1267_ sky130_fd_sc_hd__o221a_1
XANTENNA_fanout119_A net123 vssd1 vssd1 vccd1 vccd1 sky130_fd_sc_hd__diode_2
X_2647_ net643 _1234_ net94 vssd1 vssd1 vccd1 vccd1 _0388_ sky130_fd_sc_hd__mux2_1
X_2578_ _1150_ _1168_ vssd1 vssd1 vccd1 vccd1 _1169_ sky130_fd_sc_hd__xnor2_1
XTAP_TAPCELL_ROW_53_622 vssd1 vccd1 sky130_fd_sc_hd__tapvpwrvgnd_1
XPHY_EDGE_ROW_14_Right_14 vssd1 vssd1 vccd1 vccd1 sky130_fd_sc_hd__decap_3
XFILLER_2_200 vssd1 vssd1 vccd1 vccd1 sky130_fd_sc_hd__fill_1
XFILLER_2_288 vssd1 vssd1 vccd1 vccd1 sky130_fd_sc_hd__fill_8
XPHY_EDGE_ROW_23_Right_23 vssd1 vssd1 vccd1 vccd1 sky130_fd_sc_hd__decap_3
XFILLER_18_156 vccd1 vssd1 vccd1 vssd1 sky130_ef_sc_hd__decap_40_12
XFILLER_61_435 vssd1 vssd1 vccd1 vccd1 sky130_fd_sc_hd__fill_2
XFILLER_61_413 vssd1 vssd1 vccd1 vccd1 sky130_fd_sc_hd__fill_2
XPHY_EDGE_ROW_32_Right_32 vssd1 vssd1 vccd1 vccd1 sky130_fd_sc_hd__decap_3
X_1880_ MATMULT_INST.matmult_inst.fsm_inst.state\[4\] MATMULT_INST.matmult_inst.fsm_inst.state\[3\]
+ _0539_ _0757_ vssd1 vssd1 vccd1 vccd1 _0758_ sky130_fd_sc_hd__and4b_1
X_3550_ _0066_ _0463_ _0065_ vssd1 vssd1 vccd1 vccd1 MATMULT_INST.matmult_inst.spi_inst.mosi_shifter\[6\]
+ sky130_fd_sc_hd__dfrtp_1
X_2501_ _1091_ _1092_ _1093_ vssd1 vssd1 vccd1 vccd1 _1094_ sky130_fd_sc_hd__o21a_1
X_3481_ clknet_leaf_2_clk _0401_ vssd1 vssd1 vccd1 vccd1 MATMULT_INST.matmult_inst.alu_inst.col0\[1\]
+ sky130_fd_sc_hd__dfxtp_1
X_2432_ _1024_ _1025_ _1013_ vssd1 vssd1 vccd1 vccd1 _1027_ sky130_fd_sc_hd__o21ai_1
XPHY_EDGE_ROW_41_Right_41 vssd1 vssd1 vccd1 vccd1 sky130_fd_sc_hd__decap_3
XFILLER_44_3 vssd1 vssd1 vccd1 vccd1 sky130_fd_sc_hd__fill_2
X_2363_ _0946_ _0958_ _0959_ vssd1 vssd1 vccd1 vccd1 _0960_ sky130_fd_sc_hd__nand3_1
X_2294_ net583 _0916_ net99 vssd1 vssd1 vccd1 vccd1 _0354_ sky130_fd_sc_hd__mux2_1
XFILLER_56_229 vssd1 vssd1 vccd1 vccd1 sky130_fd_sc_hd__fill_1
XFILLER_37_421 vssd1 vssd1 vccd1 vccd1 sky130_fd_sc_hd__fill_4
XFILLER_49_270 vssd1 vssd1 vccd1 vccd1 sky130_fd_sc_hd__fill_2
XPHY_EDGE_ROW_50_Right_50 vssd1 vssd1 vccd1 vccd1 sky130_fd_sc_hd__decap_3
XFILLER_52_413 vssd1 vssd1 vccd1 vccd1 sky130_fd_sc_hd__fill_4
XFILLER_32_181 vssd1 vssd1 vccd1 vccd1 sky130_fd_sc_hd__fill_1
XFILLER_20_365 vccd1 vssd1 vccd1 vssd1 sky130_ef_sc_hd__decap_40_12
XANTENNA__2947__C net176 vssd1 vssd1 vccd1 vccd1 sky130_fd_sc_hd__diode_2
XFILLER_46_34 vssd1 vssd1 vccd1 vccd1 sky130_fd_sc_hd__fill_1
XFILLER_70_210 vssd1 vssd1 vccd1 vccd1 sky130_fd_sc_hd__fill_4
XFILLER_15_137 vccd1 vssd1 vccd1 vssd1 sky130_ef_sc_hd__decap_40_12
XTAP_TAPCELL_ROW_38_493 vssd1 vccd1 sky130_fd_sc_hd__tapvpwrvgnd_1
XFILLER_43_446 vssd1 vssd1 vccd1 vccd1 sky130_fd_sc_hd__fill_2
XFILLER_11_365 vccd1 vssd1 vccd1 vssd1 sky130_ef_sc_hd__decap_40_12
XFILLER_78_376 vssd1 vssd1 vccd1 vccd1 sky130_fd_sc_hd__fill_1
XFILLER_78_365 vssd1 vssd1 vccd1 vccd1 sky130_fd_sc_hd__fill_2
XTAP_TAPCELL_ROW_64_717 vssd1 vccd1 sky130_fd_sc_hd__tapvpwrvgnd_1
XTAP_TAPCELL_ROW_72_783 vssd1 vccd1 sky130_fd_sc_hd__tapvpwrvgnd_1
X_2981_ _1481_ _1519_ vssd1 vssd1 vccd1 vccd1 _1520_ sky130_fd_sc_hd__and2_1
XANTENNA__3045__A1 _0797_ vssd1 vssd1 vccd1 vccd1 sky130_fd_sc_hd__diode_2
X_1932_ MATMULT_INST.matmult_inst.spi_inst.tx_reg_sys\[11\] MATMULT_INST.matmult_inst.spi_inst.miso_shifter\[10\]
+ net137 vssd1 vssd1 vccd1 vccd1 _0009_ sky130_fd_sc_hd__mux2_1
XFILLER_21_129 vssd1 vssd1 vccd1 vccd1 sky130_fd_sc_hd__fill_1
X_1863_ _0743_ _0746_ vssd1 vssd1 vccd1 vccd1 _0444_ sky130_fd_sc_hd__nor2_1
X_3602_ clknet_leaf_25_clk _0495_ _0100_ vssd1 vssd1 vccd1 vccd1 MATMULT_INST.matmult_inst.spi_inst.tx_reg_sys\[5\]
+ sky130_fd_sc_hd__dfrtp_1
X_1794_ MATMULT_INST.matmult_inst.mem_inst.matrixA0\[2\] net112 _0707_ MATMULT_INST.matmult_inst.fsm_inst.sel\[0\]
+ vssd1 vssd1 vccd1 vccd1 _0709_ sky130_fd_sc_hd__a22o_1
X_3533_ _0034_ _0447_ _0033_ vssd1 vssd1 vccd1 vccd1 MATMULT_INST.matmult_inst.spi_inst.mosi_data_spi\[0\]
+ sky130_fd_sc_hd__dfrtp_1
X_3464_ clknet_leaf_36_clk _0385_ vssd1 vssd1 vccd1 vccd1 MATMULT_INST.matmult_inst.alu_inst.adder_inst.r2.fa2.a
+ sky130_fd_sc_hd__dfxtp_1
XFILLER_69_310 vssd1 vssd1 vccd1 vccd1 sky130_fd_sc_hd__fill_8
X_2415_ _0989_ _1008_ _1009_ vssd1 vssd1 vccd1 vccd1 _1010_ sky130_fd_sc_hd__nand3_1
X_3395_ clknet_leaf_20_clk _0317_ vssd1 vssd1 vccd1 vccd1 MATMULT_INST.matmult_inst.mem_inst.mem0\[14\]
+ sky130_fd_sc_hd__dfxtp_1
X_2346_ _0943_ _0944_ MATMULT_INST.matmult_inst.alu_inst.adder_inst.r0.fa2.a net114
+ vssd1 vssd1 vccd1 vccd1 _0377_ sky130_fd_sc_hd__a2bb2o_1
X_2277_ MATMULT_INST.matmult_inst.alu_inst.adder_inst.r2.fa3.b MATMULT_INST.matmult_inst.alu_inst.adder_inst.r2.fa3.a
+ vssd1 vssd1 vccd1 vccd1 _0902_ sky130_fd_sc_hd__or2_1
XFILLER_25_457 vssd1 vssd1 vccd1 vccd1 sky130_fd_sc_hd__fill_2
Xclkbuf_leaf_32_clk clknet_2_2__leaf_clk vssd1 vssd1 vccd1 vccd1 clknet_leaf_32_clk
+ sky130_fd_sc_hd__clkbuf_8
XFILLER_52_287 vccd1 vssd1 vccd1 vssd1 sky130_ef_sc_hd__decap_40_12
XFILLER_20_173 vssd1 vssd1 vccd1 vccd1 sky130_fd_sc_hd__fill_1
XFILLER_57_33 vssd1 vssd1 vccd1 vccd1 sky130_fd_sc_hd__fill_4
XFILLER_75_324 vssd1 vssd1 vccd1 vccd1 sky130_fd_sc_hd__fill_1
XFILLER_57_55 vssd1 vssd1 vccd1 vccd1 sky130_fd_sc_hd__fill_1
XFILLER_16_413 vssd1 vssd1 vccd1 vccd1 sky130_fd_sc_hd__fill_4
XFILLER_28_251 vssd1 vssd1 vccd1 vccd1 sky130_fd_sc_hd__fill_1
XFILLER_16_435 vssd1 vssd1 vccd1 vccd1 sky130_fd_sc_hd__fill_2
XFILLER_16_457 vccd1 vssd1 vccd1 vssd1 sky130_ef_sc_hd__decap_40_12
XFILLER_43_254 vssd1 vssd1 vccd1 vccd1 sky130_fd_sc_hd__fill_8
XFILLER_31_449 vssd1 vssd1 vccd1 vccd1 sky130_fd_sc_hd__fill_1
Xclkbuf_leaf_23_clk clknet_2_3__leaf_clk vssd1 vssd1 vccd1 vccd1 clknet_leaf_23_clk
+ sky130_fd_sc_hd__clkbuf_8
XFILLER_11_173 vssd1 vssd1 vccd1 vccd1 sky130_fd_sc_hd__fill_2
XFILLER_7_111 vssd1 vssd1 vccd1 vccd1 sky130_fd_sc_hd__fill_1
XFILLER_7_166 vssd1 vssd1 vccd1 vccd1 sky130_fd_sc_hd__fill_2
X_2200_ net200 net598 net65 vssd1 vssd1 vccd1 vccd1 _0332_ sky130_fd_sc_hd__mux2_1
X_3180_ net59 net89 net78 vssd1 vssd1 vccd1 vccd1 _0105_ sky130_fd_sc_hd__and3_1
XFILLER_66_335 vssd1 vssd1 vccd1 vccd1 sky130_fd_sc_hd__fill_4
X_2131_ net528 net49 net12 vssd1 vssd1 vccd1 vccd1 _0285_ sky130_fd_sc_hd__mux2_1
X_2062_ net431 _0804_ net20 vssd1 vssd1 vccd1 vccd1 _0220_ sky130_fd_sc_hd__mux2_1
XANTENNA__2095__S net17 vssd1 vssd1 vccd1 vccd1 sky130_fd_sc_hd__diode_2
XTAP_TAPCELL_ROW_49_588 vssd1 vccd1 sky130_fd_sc_hd__tapvpwrvgnd_1
XANTENNA__1816__A2 net104 vssd1 vssd1 vccd1 vccd1 sky130_fd_sc_hd__diode_2
X_2964_ _1503_ vssd1 vssd1 vccd1 vccd1 _1504_ sky130_fd_sc_hd__inv_2
Xclkbuf_leaf_14_clk clknet_2_1__leaf_clk vssd1 vssd1 vccd1 vccd1 clknet_leaf_14_clk
+ sky130_fd_sc_hd__clkbuf_8
XTAP_TAPCELL_ROW_32_444 vssd1 vccd1 sky130_fd_sc_hd__tapvpwrvgnd_1
X_1915_ _0752_ _0775_ _0779_ _0790_ net217 vssd1 vssd1 vccd1 vccd1 _0791_ sky130_fd_sc_hd__o32a_1
X_2895_ _1406_ _1434_ vssd1 vssd1 vccd1 vccd1 _1437_ sky130_fd_sc_hd__nor2_1
XFILLER_30_493 vssd1 vssd1 vccd1 vccd1 sky130_fd_sc_hd__fill_1
X_1846_ MATMULT_INST.matmult_inst.spi_inst.rx_done_sys net298 vssd1 vssd1 vccd1 vccd1
+ _0456_ sky130_fd_sc_hd__or2_1
X_1777_ net148 net140 MATMULT_INST.matmult_inst.mem_inst.mem3\[3\] vssd1 vssd1 vccd1
+ vccd1 _0693_ sky130_fd_sc_hd__and3_1
X_3516_ clknet_2_2__leaf_clk _0433_ vssd1 vssd1 vccd1 vccd1 MATMULT_INST.matmult_inst.alu_inst.adder_inst.r1.fa3.b
+ sky130_fd_sc_hd__dfxtp_1
XPHY_EDGE_ROW_4_Right_4 vssd1 vssd1 vccd1 vccd1 sky130_fd_sc_hd__decap_3
X_3447_ clknet_leaf_33_clk _0369_ vssd1 vssd1 vccd1 vccd1 MATMULT_INST.matmult_inst.alu_inst.a1_reg\[2\]
+ sky130_fd_sc_hd__dfxtp_1
X_3378_ clknet_leaf_9_clk _0300_ vssd1 vssd1 vccd1 vccd1 MATMULT_INST.matmult_inst.mem_inst.mem1\[15\]
+ sky130_fd_sc_hd__dfxtp_1
XANTENNA__2701__A0 _1250_ vssd1 vssd1 vccd1 vccd1 sky130_fd_sc_hd__diode_2
XANTENNA_clkbuf_leaf_15_clk_A clknet_2_1__leaf_clk vssd1 vssd1 vccd1 vccd1 sky130_fd_sc_hd__diode_2
XFILLER_69_195 vssd1 vssd1 vccd1 vccd1 sky130_fd_sc_hd__fill_1
X_2329_ net156 net508 net67 vssd1 vssd1 vccd1 vccd1 _0373_ sky130_fd_sc_hd__mux2_1
XFILLER_27_36 vssd1 vssd1 vccd1 vccd1 sky130_fd_sc_hd__fill_1
XFILLER_25_265 vccd1 vssd1 vccd1 vssd1 sky130_ef_sc_hd__decap_40_12
XFILLER_43_13 vssd1 vssd1 vccd1 vccd1 sky130_fd_sc_hd__fill_1
XFILLER_13_449 vccd1 vssd1 vccd1 vssd1 sky130_ef_sc_hd__decap_40_12
XFILLER_13_427 vssd1 vssd1 vccd1 vccd1 sky130_fd_sc_hd__fill_8
XFILLER_43_46 vssd1 vssd1 vccd1 vccd1 sky130_fd_sc_hd__fill_1
XANTENNA__2305__Y _0926_ vssd1 vssd1 vccd1 vccd1 sky130_fd_sc_hd__diode_2
XFILLER_4_114 vssd1 vssd1 vccd1 vccd1 sky130_fd_sc_hd__fill_2
XFILLER_4_125 vssd1 vssd1 vccd1 vccd1 sky130_fd_sc_hd__fill_8
XFILLER_4_29 vssd1 vssd1 vccd1 vccd1 sky130_fd_sc_hd__fill_4
XFILLER_4_18 vssd1 vssd1 vccd1 vccd1 sky130_fd_sc_hd__fill_8
XFILLER_68_76 vssd1 vssd1 vccd1 vccd1 sky130_fd_sc_hd__fill_8
XTAP_TAPCELL_ROW_74_801 vssd1 vccd1 sky130_fd_sc_hd__tapvpwrvgnd_1
XFILLER_16_265 vssd1 vssd1 vccd1 vccd1 sky130_fd_sc_hd__fill_8
XFILLER_71_371 vssd1 vssd1 vccd1 vccd1 sky130_fd_sc_hd__fill_1
XFILLER_31_257 vssd1 vssd1 vccd1 vccd1 sky130_fd_sc_hd__fill_8
XFILLER_76_6 vssd1 vssd1 vccd1 vccd1 sky130_fd_sc_hd__fill_2
X_1700_ MATMULT_INST.matmult_inst.mem_inst.mem0\[10\] net109 net105 MATMULT_INST.matmult_inst.mem_inst.matrixB0\[10\]
+ vssd1 vssd1 vccd1 vccd1 _0623_ sky130_fd_sc_hd__a22o_1
X_2680_ net82 _1247_ _1254_ net509 vssd1 vssd1 vccd1 vccd1 _0401_ sky130_fd_sc_hd__a22o_1
XANTENNA__2879__A net173 vssd1 vssd1 vccd1 vccd1 sky130_fd_sc_hd__diode_2
X_1631_ net219 _0556_ vssd1 vssd1 vccd1 vccd1 _0561_ sky130_fd_sc_hd__and2_1
X_3301_ clknet_leaf_12_clk _0223_ vssd1 vssd1 vccd1 vccd1 MATMULT_INST.matmult_inst.mem_inst.matrixA1\[10\]
+ sky130_fd_sc_hd__dfxtp_1
X_3232_ clknet_leaf_9_clk _0154_ vssd1 vssd1 vccd1 vccd1 MATMULT_INST.matmult_inst.mem_inst.matrixB1\[13\]
+ sky130_fd_sc_hd__dfxtp_1
Xclkbuf_leaf_3_clk clknet_2_0__leaf_clk vssd1 vssd1 vccd1 vccd1 clknet_leaf_3_clk
+ sky130_fd_sc_hd__clkbuf_8
XFILLER_79_482 vssd1 vssd1 vccd1 vccd1 sky130_fd_sc_hd__fill_1
X_3163_ net61 net91 net78 vssd1 vssd1 vccd1 vccd1 _0088_ sky130_fd_sc_hd__and3_1
XANTENNA_clkbuf_2_2__f_clk_X clknet_2_2__leaf_clk vssd1 vssd1 vccd1 vccd1 sky130_fd_sc_hd__diode_2
X_2114_ net454 net47 net15 vssd1 vssd1 vccd1 vccd1 _0269_ sky130_fd_sc_hd__mux2_1
X_3094_ net660 _1582_ _1588_ _1579_ vssd1 vssd1 vccd1 vccd1 _0528_ sky130_fd_sc_hd__a22o_1
XFILLER_54_305 vssd1 vssd1 vccd1 vccd1 sky130_fd_sc_hd__fill_2
XFILLER_54_349 vccd1 vssd1 vccd1 vssd1 sky130_ef_sc_hd__decap_40_12
X_2045_ net544 net40 net22 vssd1 vssd1 vccd1 vccd1 _0204_ sky130_fd_sc_hd__mux2_1
Xfanout17 _0821_ vssd1 vssd1 vccd1 vccd1 net17 sky130_fd_sc_hd__clkbuf_4
Xfanout28 _0815_ vssd1 vssd1 vccd1 vccd1 net28 sky130_fd_sc_hd__buf_4
Xfanout39 _0807_ vssd1 vssd1 vccd1 vccd1 net39 sky130_fd_sc_hd__buf_2
XANTENNA_fanout149_A net154 vssd1 vssd1 vccd1 vccd1 sky130_fd_sc_hd__diode_2
XFILLER_13_27 vccd1 vssd1 vccd1 vssd1 sky130_ef_sc_hd__decap_40_12
XFILLER_10_419 vssd1 vssd1 vccd1 vccd1 sky130_fd_sc_hd__fill_1
X_2947_ net158 net156 net176 vssd1 vssd1 vccd1 vccd1 _1487_ sky130_fd_sc_hd__and3_1
XANTENNA__1973__A1 net34 vssd1 vssd1 vccd1 vccd1 sky130_fd_sc_hd__diode_2
X_2878_ MATMULT_INST.matmult_inst.alu_inst.b1_reg\[6\] net165 net162 net174 vssd1
+ vssd1 vccd1 vccd1 _1420_ sky130_fd_sc_hd__a22o_1
XANTENNA__1693__A net152 vssd1 vssd1 vccd1 vccd1 sky130_fd_sc_hd__diode_2
X_1829_ _0543_ net103 vssd1 vssd1 vccd1 vccd1 _0733_ sky130_fd_sc_hd__nand2_1
XANTENNA_fanout104_X net104 vssd1 vssd1 vccd1 vccd1 sky130_fd_sc_hd__diode_2
XFILLER_8_9 vssd1 vssd1 vccd1 vccd1 sky130_fd_sc_hd__fill_1
XANTENNA__2922__B1 net178 vssd1 vssd1 vccd1 vccd1 sky130_fd_sc_hd__diode_2
XPHY_EDGE_ROW_13_Left_93 vssd1 vssd1 vccd1 vccd1 sky130_fd_sc_hd__decap_3
XFILLER_57_121 vssd1 vssd1 vccd1 vccd1 sky130_fd_sc_hd__fill_8
XPHY_EDGE_ROW_79_Right_79 vssd1 vssd1 vccd1 vccd1 sky130_fd_sc_hd__decap_3
XFILLER_72_179 vssd1 vssd1 vccd1 vccd1 sky130_fd_sc_hd__fill_1
XFILLER_72_157 vssd1 vssd1 vccd1 vccd1 sky130_fd_sc_hd__fill_2
XTAP_TAPCELL_ROW_0_161 vssd1 vccd1 sky130_fd_sc_hd__tapvpwrvgnd_1
XTAP_TAPCELL_ROW_0_172 vssd1 vccd1 sky130_fd_sc_hd__tapvpwrvgnd_1
XFILLER_54_45 vssd1 vssd1 vccd1 vccd1 sky130_fd_sc_hd__fill_1
XTAP_TAPCELL_ROW_43_539 vssd1 vccd1 sky130_fd_sc_hd__tapvpwrvgnd_1
XFILLER_13_246 vssd1 vssd1 vccd1 vccd1 sky130_fd_sc_hd__fill_1
XANTENNA_fanout17_X net17 vssd1 vssd1 vccd1 vccd1 sky130_fd_sc_hd__diode_2
XANTENNA__1807__S net63 vssd1 vssd1 vccd1 vccd1 sky130_fd_sc_hd__diode_2
XFILLER_48_121 vssd1 vssd1 vccd1 vccd1 sky130_fd_sc_hd__fill_2
XANTENNA__2141__A1 net39 vssd1 vssd1 vccd1 vccd1 sky130_fd_sc_hd__diode_2
Xteam_02_280 vssd1 vssd1 vccd1 vccd1 team_02_280/HI gpio_out[21] sky130_fd_sc_hd__conb_1
XFILLER_76_474 vssd1 vssd1 vccd1 vccd1 sky130_fd_sc_hd__fill_2
XANTENNA__2692__A2 _1250_ vssd1 vssd1 vccd1 vccd1 sky130_fd_sc_hd__diode_2
XFILLER_48_165 vssd1 vssd1 vccd1 vccd1 sky130_fd_sc_hd__fill_2
XTAP_TAPCELL_ROW_59_672 vssd1 vccd1 sky130_fd_sc_hd__tapvpwrvgnd_1
Xteam_02_291 vssd1 vssd1 vccd1 vccd1 team_02_291/HI gpio_out[32] sky130_fd_sc_hd__conb_1
XFILLER_29_390 vssd1 vssd1 vccd1 vccd1 sky130_fd_sc_hd__fill_2
X_2801_ _1315_ _1343_ _1344_ vssd1 vssd1 vccd1 vccd1 _1345_ sky130_fd_sc_hd__nand3_1
X_2732_ _1272_ _1278_ net97 vssd1 vssd1 vccd1 vccd1 _1280_ sky130_fd_sc_hd__o21ai_1
XFILLER_8_250 vssd1 vssd1 vccd1 vccd1 sky130_fd_sc_hd__fill_2
X_2663_ net103 _1243_ _1246_ net597 vssd1 vssd1 vccd1 vccd1 _0392_ sky130_fd_sc_hd__a22o_1
X_2594_ _1149_ _1183_ vssd1 vssd1 vccd1 vccd1 _1184_ sky130_fd_sc_hd__and2_1
X_1614_ _0544_ MATMULT_INST.matmult_inst.spi_inst.current_state _0538_ vssd1 vssd1
+ vccd1 vccd1 _0545_ sky130_fd_sc_hd__or3b_4
XFILLER_5_61 vssd1 vssd1 vccd1 vccd1 sky130_fd_sc_hd__fill_1
XFILLER_5_94 vssd1 vssd1 vccd1 vccd1 sky130_fd_sc_hd__fill_1
Xfanout207 MATMULT_INST.matmult_inst.alu_inst.b0_reg\[4\] vssd1 vssd1 vccd1 vccd1
+ net207 sky130_fd_sc_hd__clkbuf_2
Xfanout218 MATMULT_INST.matmult_inst.fsm_inst.sel\[2\] vssd1 vssd1 vccd1 vccd1 net218
+ sky130_fd_sc_hd__clkbuf_4
X_3215_ clknet_leaf_10_clk _0137_ vssd1 vssd1 vccd1 vccd1 MATMULT_INST.matmult_inst.mem_inst.matrixB2\[14\]
+ sky130_fd_sc_hd__dfxtp_1
XFILLER_67_441 vssd1 vssd1 vccd1 vccd1 sky130_fd_sc_hd__fill_2
XANTENNA__2683__A2 _1250_ vssd1 vssd1 vccd1 vccd1 sky130_fd_sc_hd__diode_2
X_3146_ net57 net84 net76 vssd1 vssd1 vccd1 vccd1 _0071_ sky130_fd_sc_hd__and3_1
X_3077_ MATMULT_INST.matmult_inst.alu_inst.out\[13\] net51 net6 net342 vssd1 vssd1
+ vccd1 vccd1 _0521_ sky130_fd_sc_hd__a22o_1
X_2028_ net380 net38 net25 vssd1 vssd1 vccd1 vccd1 _0188_ sky130_fd_sc_hd__mux2_1
XFILLER_24_15 vssd1 vssd1 vccd1 vccd1 sky130_fd_sc_hd__fill_2
XANTENNA__1643__B1 net104 vssd1 vssd1 vccd1 vccd1 sky130_fd_sc_hd__diode_2
XFILLER_50_352 vssd1 vssd1 vccd1 vccd1 sky130_fd_sc_hd__fill_1
XTAP_TAPCELL_ROW_40_509 vssd1 vccd1 sky130_fd_sc_hd__tapvpwrvgnd_1
XANTENNA_fanout221_X net221 vssd1 vssd1 vccd1 vccd1 sky130_fd_sc_hd__diode_2
Xhold250 MATMULT_INST.matmult_inst.mem_inst.matrixA2\[11\] vssd1 vssd1 vccd1 vccd1
+ net545 sky130_fd_sc_hd__dlygate4sd3_1
XFILLER_6_6 vccd1 vssd1 vccd1 vssd1 sky130_ef_sc_hd__decap_40_12
Xhold261 MATMULT_INST.matmult_inst.mem_inst.mem1\[2\] vssd1 vssd1 vccd1 vccd1 net556
+ sky130_fd_sc_hd__dlygate4sd3_1
Xhold272 MATMULT_INST.matmult_inst.alu_inst.out\[7\] vssd1 vssd1 vccd1 vccd1 net567
+ sky130_fd_sc_hd__dlygate4sd3_1
Xhold294 MATMULT_INST.matmult_inst.alu_inst.out\[10\] vssd1 vssd1 vccd1 vccd1 net589
+ sky130_fd_sc_hd__dlygate4sd3_1
Xhold283 _0488_ vssd1 vssd1 vccd1 vccd1 net578 sky130_fd_sc_hd__dlygate4sd3_1
XANTENNA__1870__B MATMULT_INST.matmult_inst.spi_inst.current_state vssd1 vssd1 vccd1
+ vccd1 sky130_fd_sc_hd__diode_2
XANTENNA_fanout81_A _0739_ vssd1 vssd1 vccd1 vccd1 sky130_fd_sc_hd__diode_2
XANTENNA__2123__A1 net38 vssd1 vssd1 vccd1 vccd1 sky130_fd_sc_hd__diode_2
XFILLER_58_441 vssd1 vssd1 vccd1 vccd1 sky130_fd_sc_hd__fill_4
XFILLER_73_422 vssd1 vssd1 vccd1 vccd1 sky130_fd_sc_hd__fill_1
XFILLER_65_55 vssd1 vssd1 vccd1 vccd1 sky130_fd_sc_hd__fill_1
XFILLER_26_360 vssd1 vssd1 vccd1 vccd1 sky130_fd_sc_hd__fill_2
XFILLER_26_382 vssd1 vssd1 vccd1 vccd1 sky130_fd_sc_hd__fill_2
XFILLER_60_105 vssd1 vssd1 vccd1 vccd1 sky130_fd_sc_hd__fill_1
XANTENNA__2193__S net66 vssd1 vssd1 vccd1 vccd1 sky130_fd_sc_hd__diode_2
XTAP_TAPCELL_ROW_11_266 vssd1 vccd1 sky130_fd_sc_hd__tapvpwrvgnd_1
XFILLER_46_7 vssd1 vssd1 vccd1 vccd1 sky130_fd_sc_hd__fill_2
XFILLER_64_400 vssd1 vssd1 vccd1 vccd1 sky130_fd_sc_hd__fill_8
X_3000_ _1520_ _1523_ vssd1 vssd1 vccd1 vccd1 _1538_ sky130_fd_sc_hd__or2_1
XFILLER_64_477 vccd1 vssd1 vccd1 vssd1 sky130_ef_sc_hd__decap_40_12
XTAP_TAPCELL_ROW_19_333 vssd1 vccd1 sky130_fd_sc_hd__tapvpwrvgnd_1
XFILLER_36_168 vssd1 vssd1 vccd1 vccd1 sky130_fd_sc_hd__fill_1
XANTENNA__1625__B1 net121 vssd1 vssd1 vccd1 vccd1 sky130_fd_sc_hd__diode_2
XFILLER_17_393 vccd1 vssd1 vccd1 vssd1 sky130_ef_sc_hd__decap_40_12
X_2715_ MATMULT_INST.matmult_inst.fsm_inst.count\[1\] _0536_ net140 vssd1 vssd1 vccd1
+ vccd1 _1266_ sky130_fd_sc_hd__o21a_1
X_2646_ _1232_ _1233_ vssd1 vssd1 vccd1 vccd1 _1234_ sky130_fd_sc_hd__xnor2_1
X_2577_ _1166_ _1167_ vssd1 vssd1 vccd1 vccd1 _1168_ sky130_fd_sc_hd__and2_1
XFILLER_59_216 vssd1 vssd1 vccd1 vccd1 sky130_fd_sc_hd__fill_2
XFILLER_74_208 vccd1 vssd1 vccd1 vssd1 sky130_ef_sc_hd__decap_40_12
X_3129_ net226 vssd1 vssd1 vccd1 vccd1 _0044_ sky130_fd_sc_hd__inv_2
XFILLER_70_414 vssd1 vssd1 vccd1 vccd1 sky130_fd_sc_hd__fill_1
XTAP_TAPCELL_ROW_53_623 vssd1 vccd1 sky130_fd_sc_hd__tapvpwrvgnd_1
XFILLER_23_341 vssd1 vssd1 vccd1 vccd1 sky130_fd_sc_hd__fill_1
XFILLER_23_363 vssd1 vssd1 vccd1 vccd1 sky130_fd_sc_hd__fill_4
XANTENNA__1919__A1 MATMULT_INST.matmult_inst.spi_inst.current_state vssd1 vssd1 vccd1
+ vccd1 sky130_fd_sc_hd__diode_2
XPHY_EDGE_ROW_29_Left_109 vssd1 vssd1 vccd1 vccd1 sky130_fd_sc_hd__decap_3
XFILLER_18_113 vssd1 vssd1 vccd1 vccd1 sky130_fd_sc_hd__fill_2
XFILLER_18_168 vssd1 vssd1 vccd1 vccd1 sky130_fd_sc_hd__fill_4
XFILLER_61_403 vssd1 vssd1 vccd1 vccd1 sky130_fd_sc_hd__fill_1
XPHY_EDGE_ROW_38_Left_118 vssd1 vssd1 vccd1 vccd1 sky130_fd_sc_hd__decap_3
XTAP_TAPCELL_ROW_24_380 vssd1 vccd1 sky130_fd_sc_hd__tapvpwrvgnd_1
X_2500_ net212 net185 vssd1 vssd1 vccd1 vccd1 _1093_ sky130_fd_sc_hd__nand2_1
X_3480_ clknet_leaf_34_clk _0400_ vssd1 vssd1 vccd1 vccd1 MATMULT_INST.matmult_inst.alu_inst.col0\[0\]
+ sky130_fd_sc_hd__dfxtp_1
X_2431_ _1013_ _1024_ _1025_ vssd1 vssd1 vccd1 vccd1 _1026_ sky130_fd_sc_hd__or3_1
XPHY_EDGE_ROW_47_Left_127 vssd1 vssd1 vccd1 vccd1 sky130_fd_sc_hd__decap_3
XANTENNA__1791__A net149 vssd1 vssd1 vccd1 vccd1 sky130_fd_sc_hd__diode_2
XANTENNA__2886__A2 net178 vssd1 vssd1 vccd1 vccd1 sky130_fd_sc_hd__diode_2
X_2362_ net198 net207 net209 net196 vssd1 vssd1 vccd1 vccd1 _0959_ sky130_fd_sc_hd__a22o_1
XFILLER_37_3 vssd1 vssd1 vccd1 vccd1 sky130_fd_sc_hd__fill_2
X_2293_ _0914_ _0915_ vssd1 vssd1 vccd1 vccd1 _0916_ sky130_fd_sc_hd__xnor2_2
XANTENNA__2098__S net16 vssd1 vssd1 vccd1 vccd1 sky130_fd_sc_hd__diode_2
XFILLER_2_62 vssd1 vssd1 vccd1 vccd1 sky130_fd_sc_hd__fill_1
XPHY_EDGE_ROW_56_Left_136 vssd1 vssd1 vccd1 vccd1 sky130_fd_sc_hd__decap_3
XFILLER_24_116 vssd1 vssd1 vccd1 vccd1 sky130_fd_sc_hd__fill_2
XFILLER_20_377 vssd1 vssd1 vccd1 vccd1 sky130_fd_sc_hd__fill_1
XPHY_EDGE_ROW_65_Left_145 vssd1 vssd1 vccd1 vccd1 sky130_fd_sc_hd__decap_3
X_2629_ _1189_ _1201_ _1216_ vssd1 vssd1 vccd1 vccd1 _1218_ sky130_fd_sc_hd__a21o_1
XPHY_EDGE_ROW_74_Left_154 vssd1 vssd1 vccd1 vccd1 sky130_fd_sc_hd__decap_3
XANTENNA__2308__Y _0928_ vssd1 vssd1 vccd1 vccd1 sky130_fd_sc_hd__diode_2
XFILLER_28_477 vccd1 vssd1 vccd1 vssd1 sky130_ef_sc_hd__decap_40_12
XANTENNA_fanout44_A _0802_ vssd1 vssd1 vccd1 vccd1 sky130_fd_sc_hd__diode_2
XFILLER_15_149 vccd1 vssd1 vccd1 vssd1 sky130_ef_sc_hd__decap_40_12
XTAP_TAPCELL_ROW_38_494 vssd1 vccd1 sky130_fd_sc_hd__tapvpwrvgnd_1
XFILLER_70_299 vssd1 vssd1 vccd1 vccd1 sky130_fd_sc_hd__fill_1
XFILLER_51_491 vssd1 vssd1 vccd1 vccd1 sky130_fd_sc_hd__fill_2
XFILLER_7_18 vssd1 vssd1 vccd1 vccd1 sky130_fd_sc_hd__fill_2
XANTENNA__2014__B1 net26 vssd1 vssd1 vccd1 vccd1 sky130_fd_sc_hd__diode_2
XFILLER_7_337 vccd1 vssd1 vccd1 vssd1 sky130_ef_sc_hd__decap_40_12
XTAP_TAPCELL_ROW_21_350 vssd1 vccd1 sky130_fd_sc_hd__tapvpwrvgnd_1
XFILLER_11_71 vssd1 vssd1 vccd1 vccd1 sky130_fd_sc_hd__fill_4
XFILLER_19_466 vssd1 vssd1 vccd1 vccd1 sky130_fd_sc_hd__fill_4
XTAP_TAPCELL_ROW_64_718 vssd1 vccd1 sky130_fd_sc_hd__tapvpwrvgnd_1
XFILLER_19_477 vccd1 vssd1 vccd1 vssd1 sky130_ef_sc_hd__decap_40_12
XPHY_EDGE_ROW_1_Left_81 vssd1 vssd1 vccd1 vccd1 sky130_fd_sc_hd__decap_3
X_2980_ _1516_ _1517_ vssd1 vssd1 vccd1 vccd1 _1519_ sky130_fd_sc_hd__xnor2_1
XFILLER_21_108 vssd1 vssd1 vccd1 vccd1 sky130_fd_sc_hd__fill_4
XFILLER_61_255 vssd1 vssd1 vccd1 vccd1 sky130_fd_sc_hd__fill_1
XTAP_TAPCELL_ROW_72_784 vssd1 vccd1 sky130_fd_sc_hd__tapvpwrvgnd_1
X_1931_ MATMULT_INST.matmult_inst.spi_inst.tx_reg_sys\[10\] MATMULT_INST.matmult_inst.spi_inst.miso_shifter\[9\]
+ net136 vssd1 vssd1 vccd1 vccd1 _0008_ sky130_fd_sc_hd__mux2_1
XFILLER_42_491 vssd1 vssd1 vccd1 vccd1 sky130_fd_sc_hd__fill_2
X_1862_ MATMULT_INST.matmult_inst.spi_inst.rx_bit_count\[1\] _0742_ net2 vssd1 vssd1
+ vccd1 vccd1 _0746_ sky130_fd_sc_hd__o21ai_1
XFILLER_14_193 vssd1 vssd1 vccd1 vccd1 sky130_fd_sc_hd__fill_2
XANTENNA__2381__S net97 vssd1 vssd1 vccd1 vccd1 sky130_fd_sc_hd__diode_2
X_3601_ clknet_leaf_25_clk _0494_ _0099_ vssd1 vssd1 vccd1 vccd1 MATMULT_INST.matmult_inst.spi_inst.tx_reg_sys\[4\]
+ sky130_fd_sc_hd__dfrtp_1
X_1793_ net217 _0703_ _0705_ net221 vssd1 vssd1 vccd1 vccd1 _0708_ sky130_fd_sc_hd__a22o_1
X_3532_ clknet_leaf_21_clk MATMULT_INST.matmult_inst.cs _0032_ vssd1 vssd1 vccd1 vccd1
+ MATMULT_INST.matmult_inst.spi_inst.cs_sync sky130_fd_sc_hd__dfstp_1
X_3463_ clknet_leaf_36_clk _0384_ vssd1 vssd1 vccd1 vccd1 MATMULT_INST.matmult_inst.alu_inst.adder_inst.r2.fa1.a
+ sky130_fd_sc_hd__dfxtp_1
X_2414_ _1006_ _1007_ _1005_ vssd1 vssd1 vccd1 vccd1 _1009_ sky130_fd_sc_hd__a21o_1
X_3394_ clknet_leaf_11_clk _0316_ vssd1 vssd1 vccd1 vccd1 MATMULT_INST.matmult_inst.mem_inst.mem0\[13\]
+ sky130_fd_sc_hd__dfxtp_1
X_2345_ _0936_ _0942_ net96 vssd1 vssd1 vccd1 vccd1 _0944_ sky130_fd_sc_hd__o21ai_1
XFILLER_69_399 vssd1 vssd1 vccd1 vccd1 sky130_fd_sc_hd__fill_4
X_2276_ net589 _0901_ net100 vssd1 vssd1 vccd1 vccd1 _0351_ sky130_fd_sc_hd__mux2_1
XFILLER_37_241 vssd1 vssd1 vccd1 vccd1 sky130_fd_sc_hd__fill_1
XFILLER_25_447 vssd1 vssd1 vccd1 vccd1 sky130_fd_sc_hd__fill_1
XFILLER_20_141 vccd1 vssd1 vccd1 vssd1 sky130_ef_sc_hd__decap_40_12
XFILLER_32_15 vccd1 vssd1 vccd1 vssd1 sky130_ef_sc_hd__decap_40_12
XFILLER_4_318 vssd1 vssd1 vccd1 vccd1 sky130_fd_sc_hd__fill_1
XFILLER_75_358 vssd1 vssd1 vccd1 vccd1 sky130_fd_sc_hd__fill_1
XFILLER_28_296 vssd1 vssd1 vccd1 vccd1 sky130_fd_sc_hd__fill_1
XFILLER_16_469 vssd1 vssd1 vccd1 vccd1 sky130_fd_sc_hd__fill_4
XFILLER_43_244 vssd1 vssd1 vccd1 vccd1 sky130_fd_sc_hd__fill_4
XFILLER_7_145 vssd1 vssd1 vccd1 vccd1 sky130_fd_sc_hd__fill_2
XFILLER_78_174 vssd1 vssd1 vccd1 vccd1 sky130_fd_sc_hd__fill_1
X_2130_ net217 net128 _0795_ vssd1 vssd1 vccd1 vccd1 _0823_ sky130_fd_sc_hd__and3_1
X_2061_ net394 net43 net20 vssd1 vssd1 vccd1 vccd1 _0219_ sky130_fd_sc_hd__mux2_1
XTAP_TAPCELL_ROW_49_589 vssd1 vccd1 sky130_fd_sc_hd__tapvpwrvgnd_1
XFILLER_22_406 vssd1 vssd1 vccd1 vccd1 sky130_fd_sc_hd__fill_2
X_2963_ _1451_ _1477_ _1502_ vssd1 vssd1 vccd1 vccd1 _1503_ sky130_fd_sc_hd__a21o_1
XFILLER_22_428 vssd1 vssd1 vccd1 vccd1 sky130_fd_sc_hd__fill_2
XFILLER_34_288 vssd1 vssd1 vccd1 vccd1 sky130_fd_sc_hd__fill_1
XTAP_TAPCELL_ROW_32_445 vssd1 vccd1 sky130_fd_sc_hd__tapvpwrvgnd_1
X_1914_ _0544_ _0776_ net51 vssd1 vssd1 vccd1 vccd1 _0790_ sky130_fd_sc_hd__o21bai_1
X_2894_ _1406_ _1434_ vssd1 vssd1 vccd1 vccd1 _1436_ sky130_fd_sc_hd__nand2_1
X_1845_ MATMULT_INST.matmult_inst.spi_inst.mosi_shifter\[0\] _0535_ _0741_ vssd1 vssd1
+ vccd1 vccd1 _0457_ sky130_fd_sc_hd__mux2_1
X_1776_ MATMULT_INST.matmult_inst.mem_inst.mem0\[3\] net108 net104 MATMULT_INST.matmult_inst.mem_inst.matrixB0\[3\]
+ vssd1 vssd1 vccd1 vccd1 _0692_ sky130_fd_sc_hd__a22o_1
X_3515_ clknet_leaf_29_clk _0432_ vssd1 vssd1 vccd1 vccd1 MATMULT_INST.matmult_inst.alu_inst.adder_inst.r1.fa2.b
+ sky130_fd_sc_hd__dfxtp_1
X_3446_ clknet_leaf_27_clk _0368_ vssd1 vssd1 vccd1 vccd1 MATMULT_INST.matmult_inst.alu_inst.a1_reg\[1\]
+ sky130_fd_sc_hd__dfxtp_1
X_3377_ clknet_leaf_10_clk _0299_ vssd1 vssd1 vccd1 vccd1 MATMULT_INST.matmult_inst.mem_inst.mem1\[14\]
+ sky130_fd_sc_hd__dfxtp_1
XFILLER_69_185 vssd1 vssd1 vccd1 vccd1 sky130_fd_sc_hd__fill_8
X_2328_ net158 net360 net67 vssd1 vssd1 vccd1 vccd1 _0372_ sky130_fd_sc_hd__mux2_1
X_2259_ MATMULT_INST.matmult_inst.alu_inst.adder_inst.r2.fa0.b MATMULT_INST.matmult_inst.alu_inst.adder_inst.r2.fa0.a
+ vssd1 vssd1 vccd1 vccd1 _0887_ sky130_fd_sc_hd__nand2_1
XFILLER_25_233 vssd1 vssd1 vccd1 vccd1 sky130_fd_sc_hd__fill_2
XFILLER_25_277 vssd1 vssd1 vccd1 vccd1 sky130_fd_sc_hd__fill_2
XFILLER_43_25 vssd1 vssd1 vccd1 vccd1 sky130_fd_sc_hd__fill_1
XFILLER_21_461 vssd1 vssd1 vccd1 vccd1 sky130_fd_sc_hd__fill_2
XFILLER_68_44 vssd1 vssd1 vccd1 vccd1 sky130_fd_sc_hd__fill_1
XANTENNA__2940__B2 net173 vssd1 vssd1 vccd1 vccd1 sky130_fd_sc_hd__diode_2
XFILLER_0_321 vccd1 vssd1 vccd1 vssd1 sky130_ef_sc_hd__decap_40_12
XFILLER_75_111 vssd1 vssd1 vccd1 vccd1 sky130_fd_sc_hd__fill_1
XFILLER_0_365 vccd1 vssd1 vccd1 vssd1 sky130_ef_sc_hd__decap_40_12
XFILLER_48_325 vssd1 vssd1 vccd1 vccd1 sky130_fd_sc_hd__fill_4
XANTENNA__2196__S net66 vssd1 vssd1 vccd1 vccd1 sky130_fd_sc_hd__diode_2
XFILLER_48_358 vssd1 vssd1 vccd1 vccd1 sky130_fd_sc_hd__fill_4
XFILLER_75_188 vssd1 vssd1 vccd1 vccd1 sky130_fd_sc_hd__fill_1
XFILLER_75_177 vssd1 vssd1 vccd1 vccd1 sky130_fd_sc_hd__fill_2
XTAP_TAPCELL_ROW_74_802 vssd1 vccd1 sky130_fd_sc_hd__tapvpwrvgnd_1
XFILLER_63_317 vssd1 vssd1 vccd1 vccd1 sky130_fd_sc_hd__fill_2
XFILLER_17_92 vssd1 vssd1 vccd1 vccd1 sky130_fd_sc_hd__fill_2
XTAP_TAPCELL_ROW_46_559 vssd1 vccd1 sky130_fd_sc_hd__tapvpwrvgnd_1
XFILLER_8_421 vccd1 vssd1 vccd1 vssd1 sky130_ef_sc_hd__decap_40_12
X_1630_ net217 _0556_ vssd1 vssd1 vccd1 vccd1 _0560_ sky130_fd_sc_hd__and2_1
X_3300_ clknet_leaf_16_clk _0222_ vssd1 vssd1 vccd1 vccd1 MATMULT_INST.matmult_inst.mem_inst.matrixA1\[9\]
+ sky130_fd_sc_hd__dfxtp_1
XANTENNA__1734__A2 net108 vssd1 vssd1 vccd1 vccd1 sky130_fd_sc_hd__diode_2
XFILLER_79_461 vssd1 vssd1 vccd1 vccd1 sky130_fd_sc_hd__fill_4
X_3231_ clknet_leaf_13_clk _0153_ vssd1 vssd1 vccd1 vccd1 MATMULT_INST.matmult_inst.mem_inst.matrixB1\[12\]
+ sky130_fd_sc_hd__dfxtp_1
X_3162_ net59 net89 net78 vssd1 vssd1 vccd1 vccd1 _0087_ sky130_fd_sc_hd__and3_1
X_2113_ net465 net48 net14 vssd1 vssd1 vccd1 vccd1 _0268_ sky130_fd_sc_hd__mux2_1
X_3093_ _1585_ _1587_ vssd1 vssd1 vccd1 vccd1 _1588_ sky130_fd_sc_hd__or2_1
X_2044_ net529 net41 net22 vssd1 vssd1 vccd1 vccd1 _0203_ sky130_fd_sc_hd__mux2_1
Xfanout29 _0815_ vssd1 vssd1 vccd1 vccd1 net29 sky130_fd_sc_hd__clkbuf_4
Xfanout18 _0820_ vssd1 vssd1 vccd1 vccd1 net18 sky130_fd_sc_hd__clkbuf_4
XFILLER_13_39 vssd1 vssd1 vccd1 vccd1 sky130_fd_sc_hd__fill_4
X_2946_ net158 net174 net176 net156 vssd1 vssd1 vccd1 vccd1 _1486_ sky130_fd_sc_hd__a22o_1
X_2877_ _1385_ _1386_ _1384_ vssd1 vssd1 vccd1 vccd1 _1419_ sky130_fd_sc_hd__o21bai_1
XFILLER_30_280 vssd1 vssd1 vccd1 vccd1 sky130_fd_sc_hd__fill_2
X_1828_ _0536_ _0731_ vssd1 vssd1 vccd1 vccd1 _0732_ sky130_fd_sc_hd__nor2_2
X_1759_ MATMULT_INST.matmult_inst.mem_inst.mem1\[5\] net124 net116 MATMULT_INST.matmult_inst.mem_inst.mem2\[5\]
+ _0676_ vssd1 vssd1 vccd1 vccd1 _0677_ sky130_fd_sc_hd__a221o_1
X_3429_ clknet_leaf_26_clk _0351_ vssd1 vssd1 vccd1 vccd1 MATMULT_INST.matmult_inst.alu_inst.out\[10\]
+ sky130_fd_sc_hd__dfxtp_1
XANTENNA__2686__B1 _1254_ vssd1 vssd1 vccd1 vccd1 sky130_fd_sc_hd__diode_2
XTAP_TAPCELL_ROW_0_162 vssd1 vccd1 sky130_fd_sc_hd__tapvpwrvgnd_1
XFILLER_54_24 vssd1 vssd1 vccd1 vccd1 sky130_fd_sc_hd__fill_4
XFILLER_60_309 vssd1 vssd1 vccd1 vccd1 sky130_fd_sc_hd__fill_1
XTAP_TAPCELL_ROW_0_173 vssd1 vccd1 sky130_fd_sc_hd__tapvpwrvgnd_1
XFILLER_54_68 vssd1 vssd1 vccd1 vccd1 sky130_fd_sc_hd__fill_8
XFILLER_13_236 vssd1 vssd1 vccd1 vccd1 sky130_fd_sc_hd__fill_8
XFILLER_9_207 vssd1 vssd1 vccd1 vccd1 sky130_fd_sc_hd__fill_8
XFILLER_70_23 vssd1 vssd1 vccd1 vccd1 sky130_fd_sc_hd__fill_4
XFILLER_70_56 vssd1 vssd1 vccd1 vccd1 sky130_fd_sc_hd__fill_4
XANTENNA__1716__A2 net129 vssd1 vssd1 vccd1 vccd1 sky130_fd_sc_hd__diode_2
XFILLER_79_65 vssd1 vssd1 vccd1 vccd1 sky130_fd_sc_hd__fill_1
XTAP_TAPCELL_ROW_8_240 vssd1 vccd1 sky130_fd_sc_hd__tapvpwrvgnd_1
XFILLER_0_195 vssd1 vssd1 vccd1 vccd1 sky130_fd_sc_hd__fill_1
XANTENNA__2677__B1 _1253_ vssd1 vssd1 vccd1 vccd1 sky130_fd_sc_hd__diode_2
Xteam_02_270 vssd1 vssd1 vccd1 vccd1 team_02_270/HI gpio_out[11] sky130_fd_sc_hd__conb_1
XTAP_TAPCELL_ROW_59_673 vssd1 vccd1 sky130_fd_sc_hd__tapvpwrvgnd_1
Xteam_02_281 vssd1 vssd1 vccd1 vccd1 team_02_281/HI gpio_out[22] sky130_fd_sc_hd__conb_1
Xteam_02_292 vssd1 vssd1 vccd1 vccd1 team_02_292/HI gpio_out[33] sky130_fd_sc_hd__conb_1
XFILLER_28_91 vssd1 vssd1 vccd1 vccd1 sky130_fd_sc_hd__fill_1
XFILLER_51_309 vssd1 vssd1 vccd1 vccd1 sky130_fd_sc_hd__fill_2
X_2800_ _1325_ _1340_ _1341_ _1342_ vssd1 vssd1 vccd1 vccd1 _1344_ sky130_fd_sc_hd__nand4_1
XANTENNA_clkbuf_leaf_14_clk_A clknet_2_1__leaf_clk vssd1 vssd1 vccd1 vccd1 sky130_fd_sc_hd__diode_2
X_2731_ _1272_ _1278_ vssd1 vssd1 vccd1 vccd1 _1279_ sky130_fd_sc_hd__and2_1
XFILLER_8_262 vssd1 vssd1 vccd1 vccd1 sky130_fd_sc_hd__fill_4
X_2662_ net103 _0767_ _1245_ vssd1 vssd1 vccd1 vccd1 _1246_ sky130_fd_sc_hd__o21bai_4
X_2593_ _1181_ _1182_ vssd1 vssd1 vccd1 vccd1 _1183_ sky130_fd_sc_hd__xnor2_1
XANTENNA_clkbuf_leaf_29_clk_A clknet_2_2__leaf_clk vssd1 vssd1 vccd1 vccd1 sky130_fd_sc_hd__diode_2
X_1613_ _0539_ _0541_ vssd1 vssd1 vccd1 vccd1 _0544_ sky130_fd_sc_hd__or2_2
Xfanout208 MATMULT_INST.matmult_inst.alu_inst.b0_reg\[3\] vssd1 vssd1 vccd1 vccd1
+ net208 sky130_fd_sc_hd__buf_2
Xfanout219 net221 vssd1 vssd1 vccd1 vccd1 net219 sky130_fd_sc_hd__clkbuf_4
X_3214_ clknet_leaf_9_clk _0136_ vssd1 vssd1 vccd1 vccd1 MATMULT_INST.matmult_inst.mem_inst.matrixB2\[13\]
+ sky130_fd_sc_hd__dfxtp_1
XFILLER_39_100 vssd1 vssd1 vccd1 vccd1 sky130_fd_sc_hd__fill_4
X_3145_ net55 net84 net76 vssd1 vssd1 vccd1 vccd1 _0070_ sky130_fd_sc_hd__and3_1
X_3076_ MATMULT_INST.matmult_inst.alu_inst.out\[12\] net51 net6 net310 vssd1 vssd1
+ vccd1 vccd1 _0520_ sky130_fd_sc_hd__a22o_1
X_2027_ net391 net39 net24 vssd1 vssd1 vccd1 vccd1 _0187_ sky130_fd_sc_hd__mux2_1
XFILLER_10_228 vssd1 vssd1 vccd1 vccd1 sky130_fd_sc_hd__fill_1
X_2929_ _1452_ _1469_ vssd1 vssd1 vccd1 vccd1 _1470_ sky130_fd_sc_hd__xnor2_2
XANTENNA__1946__A2 net71 vssd1 vssd1 vccd1 vccd1 sky130_fd_sc_hd__diode_2
Xhold262 MATMULT_INST.matmult_inst.mem_inst.matrixA2\[17\] vssd1 vssd1 vccd1 vccd1
+ net557 sky130_fd_sc_hd__dlygate4sd3_1
Xhold240 MATMULT_INST.matmult_inst.mem_inst.matrixB2\[13\] vssd1 vssd1 vccd1 vccd1
+ net535 sky130_fd_sc_hd__dlygate4sd3_1
Xhold251 MATMULT_INST.matmult_inst.alu_inst.row0\[2\] vssd1 vssd1 vccd1 vccd1 net546
+ sky130_fd_sc_hd__dlygate4sd3_1
Xhold295 MATMULT_INST.matmult_inst.alu_inst.out\[5\] vssd1 vssd1 vccd1 vccd1 net590
+ sky130_fd_sc_hd__dlygate4sd3_1
Xhold273 _0515_ vssd1 vssd1 vccd1 vccd1 net568 sky130_fd_sc_hd__dlygate4sd3_1
Xhold284 MATMULT_INST.matmult_inst.spi_inst.mosi_data_sync\[1\] vssd1 vssd1 vccd1
+ vccd1 net579 sky130_fd_sc_hd__dlygate4sd3_1
XFILLER_49_57 vssd1 vssd1 vccd1 vccd1 sky130_fd_sc_hd__fill_8
XANTENNA_fanout74_A _0739_ vssd1 vssd1 vccd1 vccd1 sky130_fd_sc_hd__diode_2
XFILLER_18_328 vssd1 vssd1 vccd1 vccd1 sky130_fd_sc_hd__fill_2
XFILLER_58_486 vssd1 vssd1 vccd1 vccd1 sky130_fd_sc_hd__fill_8
XANTENNA__1634__B2 net223 vssd1 vssd1 vccd1 vccd1 sky130_fd_sc_hd__diode_2
XANTENNA__1634__A1 net220 vssd1 vssd1 vccd1 vccd1 sky130_fd_sc_hd__diode_2
XFILLER_41_375 vssd1 vssd1 vccd1 vccd1 sky130_fd_sc_hd__fill_1
XFILLER_14_71 vccd1 vssd1 vccd1 vssd1 sky130_ef_sc_hd__decap_40_12
XANTENNA__1818__S net63 vssd1 vssd1 vccd1 vccd1 sky130_fd_sc_hd__diode_2
XTAP_TAPCELL_ROW_11_267 vssd1 vccd1 sky130_fd_sc_hd__tapvpwrvgnd_1
XFILLER_5_265 vssd1 vssd1 vccd1 vccd1 sky130_fd_sc_hd__fill_1
XFILLER_49_431 vccd1 vssd1 vccd1 vssd1 sky130_ef_sc_hd__decap_40_12
XFILLER_64_423 vssd1 vssd1 vccd1 vccd1 sky130_fd_sc_hd__fill_1
XTAP_TAPCELL_ROW_19_334 vssd1 vccd1 sky130_fd_sc_hd__tapvpwrvgnd_1
XFILLER_64_489 vssd1 vssd1 vccd1 vccd1 sky130_fd_sc_hd__fill_4
XFILLER_17_350 vssd1 vssd1 vccd1 vccd1 sky130_fd_sc_hd__fill_2
XFILLER_51_139 vssd1 vssd1 vccd1 vccd1 sky130_fd_sc_hd__fill_4
XANTENNA__2050__A1 net35 vssd1 vssd1 vccd1 vccd1 sky130_fd_sc_hd__diode_2
X_2714_ net148 _1265_ _1259_ vssd1 vssd1 vccd1 vccd1 _0424_ sky130_fd_sc_hd__mux2_1
X_2645_ _1194_ _1197_ _1218_ _1217_ vssd1 vssd1 vccd1 vccd1 _1233_ sky130_fd_sc_hd__a31o_1
XFILLER_10_29 vssd1 vssd1 vccd1 vccd1 sky130_fd_sc_hd__fill_2
X_2576_ _1164_ _1165_ vssd1 vssd1 vccd1 vccd1 _1167_ sky130_fd_sc_hd__or2_1
XFILLER_19_27 vssd1 vssd1 vccd1 vccd1 sky130_fd_sc_hd__fill_8
XFILLER_27_125 vccd1 vssd1 vccd1 vssd1 sky130_ef_sc_hd__decap_40_12
X_3128_ net225 vssd1 vssd1 vccd1 vccd1 _0042_ sky130_fd_sc_hd__inv_2
X_3059_ net483 net35 net9 vssd1 vssd1 vccd1 vccd1 _0478_ sky130_fd_sc_hd__mux2_1
XFILLER_27_169 vccd1 vssd1 vccd1 vssd1 sky130_ef_sc_hd__decap_40_12
XFILLER_35_37 vssd1 vssd1 vccd1 vccd1 sky130_fd_sc_hd__fill_1
XTAP_TAPCELL_ROW_53_624 vssd1 vccd1 sky130_fd_sc_hd__tapvpwrvgnd_1
XFILLER_42_139 vssd1 vssd1 vccd1 vccd1 sky130_fd_sc_hd__fill_1
XFILLER_50_150 vssd1 vssd1 vccd1 vccd1 sky130_fd_sc_hd__fill_2
XFILLER_51_36 vssd1 vssd1 vccd1 vccd1 sky130_fd_sc_hd__fill_2
XTAP_TAPCELL_ROW_61_690 vssd1 vccd1 sky130_fd_sc_hd__tapvpwrvgnd_1
XANTENNA__1865__C net2 vssd1 vssd1 vccd1 vccd1 sky130_fd_sc_hd__diode_2
XFILLER_46_423 vssd1 vssd1 vccd1 vccd1 sky130_fd_sc_hd__fill_4
XTAP_TAPCELL_ROW_16_304 vssd1 vccd1 sky130_fd_sc_hd__tapvpwrvgnd_1
XFILLER_14_320 vssd1 vssd1 vccd1 vccd1 sky130_fd_sc_hd__fill_1
XFILLER_26_180 vccd1 vssd1 vccd1 vssd1 sky130_ef_sc_hd__decap_40_12
XANTENNA__2217__B MATMULT_INST.matmult_inst.alu_inst.adder_inst.r0.fa2.a vssd1 vssd1
+ vccd1 vccd1 sky130_fd_sc_hd__diode_2
XFILLER_41_183 vssd1 vssd1 vccd1 vccd1 sky130_fd_sc_hd__fill_2
XANTENNA__2032__A1 net34 vssd1 vssd1 vccd1 vccd1 sky130_fd_sc_hd__diode_2
XANTENNA__3516__CLK clknet_2_2__leaf_clk vssd1 vssd1 vccd1 vccd1 sky130_fd_sc_hd__diode_2
X_2430_ _1015_ _1022_ _1023_ vssd1 vssd1 vccd1 vccd1 _1025_ sky130_fd_sc_hd__and3_1
XFILLER_44_5 vssd1 vssd1 vccd1 vccd1 sky130_fd_sc_hd__fill_1
XANTENNA__1791__B net145 vssd1 vssd1 vccd1 vccd1 sky130_fd_sc_hd__diode_2
X_2361_ net197 net195 net207 net209 vssd1 vssd1 vccd1 vccd1 _0958_ sky130_fd_sc_hd__nand4_2
X_2292_ _0907_ _0910_ _0908_ vssd1 vssd1 vccd1 vccd1 _0915_ sky130_fd_sc_hd__a21boi_2
XTAP_TAPCELL_ROW_67_738 vssd1 vccd1 sky130_fd_sc_hd__tapvpwrvgnd_1
XFILLER_49_272 vssd1 vssd1 vccd1 vccd1 sky130_fd_sc_hd__fill_1
XFILLER_37_445 vssd1 vssd1 vccd1 vccd1 sky130_fd_sc_hd__fill_2
XFILLER_64_253 vssd1 vssd1 vccd1 vccd1 sky130_fd_sc_hd__fill_2
XFILLER_24_139 vssd1 vssd1 vccd1 vccd1 sky130_fd_sc_hd__fill_1
XFILLER_60_470 vssd1 vssd1 vccd1 vccd1 sky130_fd_sc_hd__fill_4
XFILLER_32_194 vssd1 vssd1 vccd1 vccd1 sky130_fd_sc_hd__fill_2
XFILLER_21_28 vssd1 vssd1 vccd1 vccd1 sky130_fd_sc_hd__fill_1
XANTENNA_fanout124_A net131 vssd1 vssd1 vccd1 vccd1 sky130_fd_sc_hd__diode_2
XANTENNA__1782__B1 net120 vssd1 vssd1 vccd1 vccd1 sky130_fd_sc_hd__diode_2
X_2628_ _1189_ _1201_ _1216_ vssd1 vssd1 vccd1 vccd1 _1217_ sky130_fd_sc_hd__and3_1
X_2559_ _1147_ _1149_ vssd1 vssd1 vccd1 vccd1 _1150_ sky130_fd_sc_hd__or2_1
XFILLER_28_489 vssd1 vssd1 vccd1 vccd1 sky130_fd_sc_hd__fill_4
XTAP_TAPCELL_ROW_38_495 vssd1 vccd1 sky130_fd_sc_hd__tapvpwrvgnd_1
XFILLER_11_301 vccd1 vssd1 vccd1 vssd1 sky130_ef_sc_hd__decap_40_12
XFILLER_23_183 vssd1 vssd1 vccd1 vccd1 sky130_fd_sc_hd__fill_4
XFILLER_51_481 vssd1 vssd1 vccd1 vccd1 sky130_fd_sc_hd__fill_1
XFILLER_11_334 vssd1 vssd1 vccd1 vccd1 sky130_fd_sc_hd__fill_2
XANTENNA__2014__A1 net107 vssd1 vssd1 vccd1 vccd1 sky130_fd_sc_hd__diode_2
XTAP_TAPCELL_ROW_21_351 vssd1 vccd1 sky130_fd_sc_hd__tapvpwrvgnd_1
XFILLER_7_349 vssd1 vssd1 vccd1 vccd1 sky130_fd_sc_hd__fill_8
XFILLER_19_401 vssd1 vssd1 vccd1 vccd1 sky130_fd_sc_hd__fill_2
XTAP_TAPCELL_ROW_64_719 vssd1 vccd1 sky130_fd_sc_hd__tapvpwrvgnd_1
XFILLER_19_489 vssd1 vssd1 vccd1 vccd1 sky130_fd_sc_hd__fill_4
XTAP_TAPCELL_ROW_72_785 vssd1 vccd1 sky130_fd_sc_hd__tapvpwrvgnd_1
X_1930_ MATMULT_INST.matmult_inst.spi_inst.tx_reg_sys\[9\] MATMULT_INST.matmult_inst.spi_inst.miso_shifter\[8\]
+ net136 vssd1 vssd1 vccd1 vccd1 _0022_ sky130_fd_sc_hd__mux2_1
XFILLER_61_289 vssd1 vssd1 vccd1 vccd1 sky130_fd_sc_hd__fill_4
X_1861_ MATMULT_INST.matmult_inst.spi_inst.rx_bit_count\[3\] _0740_ _0745_ net2 vssd1
+ vssd1 vccd1 vccd1 _0445_ sky130_fd_sc_hd__o211a_1
X_3600_ clknet_leaf_17_clk _0493_ _0098_ vssd1 vssd1 vccd1 vccd1 MATMULT_INST.matmult_inst.spi_inst.tx_reg_sys\[3\]
+ sky130_fd_sc_hd__dfrtp_1
X_3531_ _0031_ _0446_ _0030_ vssd1 vssd1 vccd1 vccd1 MATMULT_INST.matmult_inst.spi_inst.rx_bit_count\[3\]
+ sky130_fd_sc_hd__dfrtp_1
X_1792_ MATMULT_INST.matmult_inst.mem_inst.matrixA1\[2\] net128 net120 MATMULT_INST.matmult_inst.mem_inst.matrixA2\[2\]
+ _0706_ vssd1 vssd1 vccd1 vccd1 _0707_ sky130_fd_sc_hd__a221o_1
X_3462_ clknet_leaf_34_clk _0383_ vssd1 vssd1 vccd1 vccd1 MATMULT_INST.matmult_inst.alu_inst.adder_inst.r2.fa0.a
+ sky130_fd_sc_hd__dfxtp_1
X_3393_ clknet_leaf_20_clk _0315_ vssd1 vssd1 vccd1 vccd1 MATMULT_INST.matmult_inst.mem_inst.mem0\[12\]
+ sky130_fd_sc_hd__dfxtp_1
X_2413_ _1005_ _1006_ _1007_ vssd1 vssd1 vccd1 vccd1 _1008_ sky130_fd_sc_hd__nand3_1
XFILLER_69_334 vssd1 vssd1 vccd1 vccd1 sky130_fd_sc_hd__fill_2
X_2344_ _0936_ _0942_ vssd1 vssd1 vccd1 vccd1 _0943_ sky130_fd_sc_hd__and2_1
XFILLER_29_209 vssd1 vssd1 vccd1 vccd1 sky130_fd_sc_hd__fill_1
X_2275_ _0899_ _0900_ vssd1 vssd1 vccd1 vccd1 _0901_ sky130_fd_sc_hd__xnor2_1
XFILLER_37_220 vssd1 vssd1 vccd1 vccd1 sky130_fd_sc_hd__fill_4
XFILLER_37_297 vccd1 vssd1 vccd1 vssd1 sky130_ef_sc_hd__decap_40_12
XFILLER_25_459 vssd1 vssd1 vccd1 vccd1 sky130_fd_sc_hd__fill_1
XFILLER_20_131 vssd1 vssd1 vccd1 vccd1 sky130_fd_sc_hd__fill_8
XFILLER_32_27 vssd1 vssd1 vccd1 vccd1 sky130_fd_sc_hd__fill_1
XFILLER_20_153 vccd1 vssd1 vccd1 vssd1 sky130_ef_sc_hd__decap_40_12
XFILLER_20_197 vssd1 vssd1 vccd1 vccd1 sky130_fd_sc_hd__fill_8
XANTENNA_input1_X net1 vssd1 vssd1 vccd1 vccd1 sky130_fd_sc_hd__diode_2
XFILLER_75_337 vssd1 vssd1 vccd1 vccd1 sky130_fd_sc_hd__fill_8
XFILLER_16_437 vssd1 vssd1 vccd1 vccd1 sky130_fd_sc_hd__fill_1
XFILLER_73_67 vssd1 vssd1 vccd1 vccd1 sky130_fd_sc_hd__fill_2
XFILLER_31_407 vccd1 vssd1 vccd1 vssd1 sky130_ef_sc_hd__decap_40_12
XFILLER_7_113 vssd1 vssd1 vccd1 vccd1 sky130_fd_sc_hd__fill_2
XFILLER_11_175 vssd1 vssd1 vccd1 vccd1 sky130_fd_sc_hd__fill_1
XFILLER_3_341 vssd1 vssd1 vccd1 vccd1 sky130_fd_sc_hd__fill_2
XFILLER_3_385 vssd1 vssd1 vccd1 vccd1 sky130_fd_sc_hd__fill_4
XFILLER_78_197 vssd1 vssd1 vccd1 vccd1 sky130_fd_sc_hd__fill_2
X_2060_ net498 net44 net20 vssd1 vssd1 vccd1 vccd1 _0218_ sky130_fd_sc_hd__mux2_1
XFILLER_74_381 vssd1 vssd1 vccd1 vccd1 sky130_fd_sc_hd__fill_2
XFILLER_34_201 vssd1 vssd1 vccd1 vccd1 sky130_fd_sc_hd__fill_1
XFILLER_34_234 vssd1 vssd1 vccd1 vccd1 sky130_fd_sc_hd__fill_1
X_2962_ _1482_ _1501_ vssd1 vssd1 vccd1 vccd1 _1502_ sky130_fd_sc_hd__xor2_1
XFILLER_15_492 vssd1 vssd1 vccd1 vccd1 sky130_fd_sc_hd__fill_2
XTAP_TAPCELL_ROW_32_446 vssd1 vccd1 sky130_fd_sc_hd__tapvpwrvgnd_1
X_1913_ MATMULT_INST.matmult_inst.alu_inst.complete _0752_ vssd1 vssd1 vccd1 vccd1
+ _0789_ sky130_fd_sc_hd__and2_1
X_2893_ _1406_ _1434_ vssd1 vssd1 vccd1 vccd1 _1435_ sky130_fd_sc_hd__and2_1
X_1844_ MATMULT_INST.matmult_inst.spi_inst.mosi_shifter\[1\] MATMULT_INST.matmult_inst.spi_inst.mosi_shifter\[0\]
+ _0741_ vssd1 vssd1 vccd1 vccd1 _0458_ sky130_fd_sc_hd__mux2_1
XFILLER_8_62 vssd1 vssd1 vccd1 vccd1 sky130_fd_sc_hd__fill_4
X_1775_ net625 _0691_ net63 vssd1 vssd1 vccd1 vccd1 _0494_ sky130_fd_sc_hd__mux2_1
X_3514_ clknet_leaf_29_clk _0431_ vssd1 vssd1 vccd1 vccd1 MATMULT_INST.matmult_inst.alu_inst.adder_inst.r1.fa1.b
+ sky130_fd_sc_hd__dfxtp_1
X_3445_ clknet_leaf_27_clk _0367_ vssd1 vssd1 vccd1 vccd1 MATMULT_INST.matmult_inst.alu_inst.a1_reg\[0\]
+ sky130_fd_sc_hd__dfxtp_1
X_3376_ clknet_leaf_9_clk _0298_ vssd1 vssd1 vccd1 vccd1 MATMULT_INST.matmult_inst.mem_inst.mem1\[13\]
+ sky130_fd_sc_hd__dfxtp_1
X_2327_ net160 net481 net68 vssd1 vssd1 vccd1 vccd1 _0371_ sky130_fd_sc_hd__mux2_1
X_2258_ MATMULT_INST.matmult_inst.alu_inst.adder_inst.r2.fa0.b MATMULT_INST.matmult_inst.alu_inst.adder_inst.r2.fa0.a
+ vssd1 vssd1 vccd1 vccd1 _0886_ sky130_fd_sc_hd__nor2_1
XFILLER_57_337 vssd1 vssd1 vccd1 vccd1 sky130_fd_sc_hd__fill_4
XFILLER_72_307 vssd1 vssd1 vccd1 vccd1 sky130_fd_sc_hd__fill_1
XFILLER_25_223 vssd1 vssd1 vccd1 vccd1 sky130_fd_sc_hd__fill_1
X_2189_ _0772_ _0827_ _0836_ vssd1 vssd1 vccd1 vccd1 _0843_ sky130_fd_sc_hd__o21a_1
XFILLER_0_377 vccd1 vssd1 vccd1 vssd1 sky130_ef_sc_hd__decap_40_12
XFILLER_75_167 vssd1 vssd1 vccd1 vccd1 sky130_fd_sc_hd__fill_1
XTAP_TAPCELL_ROW_74_803 vssd1 vccd1 sky130_fd_sc_hd__tapvpwrvgnd_1
XFILLER_31_215 vssd1 vssd1 vccd1 vccd1 sky130_fd_sc_hd__fill_2
XFILLER_12_473 vssd1 vssd1 vccd1 vccd1 sky130_fd_sc_hd__fill_2
XANTENNA__2225__B MATMULT_INST.matmult_inst.alu_inst.adder_inst.r0.fa3.a vssd1 vssd1
+ vccd1 vccd1 sky130_fd_sc_hd__diode_2
XFILLER_76_8 vssd1 vssd1 vccd1 vccd1 sky130_fd_sc_hd__fill_1
XFILLER_8_433 vccd1 vssd1 vccd1 vssd1 sky130_ef_sc_hd__decap_40_12
XFILLER_8_477 vccd1 vssd1 vccd1 vssd1 sky130_ef_sc_hd__decap_40_12
X_3230_ clknet_leaf_19_clk _0152_ vssd1 vssd1 vccd1 vccd1 MATMULT_INST.matmult_inst.mem_inst.matrixB1\[11\]
+ sky130_fd_sc_hd__dfxtp_1
XANTENNA__2695__A1 net93 vssd1 vssd1 vccd1 vccd1 sky130_fd_sc_hd__diode_2
X_3161_ net58 net87 _0739_ vssd1 vssd1 vccd1 vccd1 _0086_ sky130_fd_sc_hd__and3_1
XFILLER_12_3 vccd1 vssd1 vccd1 vssd1 sky130_ef_sc_hd__decap_40_12
XFILLER_39_337 vssd1 vssd1 vccd1 vccd1 sky130_fd_sc_hd__fill_2
X_2112_ net460 net49 net14 vssd1 vssd1 vccd1 vccd1 _0267_ sky130_fd_sc_hd__mux2_1
X_3092_ _0543_ _0732_ net102 _0540_ _0762_ vssd1 vssd1 vccd1 vccd1 _1587_ sky130_fd_sc_hd__a221o_1
XFILLER_54_307 vssd1 vssd1 vccd1 vccd1 sky130_fd_sc_hd__fill_1
X_2043_ net507 _0804_ net23 vssd1 vssd1 vccd1 vccd1 _0202_ sky130_fd_sc_hd__mux2_1
Xfanout19 _0820_ vssd1 vssd1 vccd1 vccd1 net19 sky130_fd_sc_hd__clkbuf_4
X_2945_ _1464_ _1467_ _1463_ vssd1 vssd1 vccd1 vccd1 _1485_ sky130_fd_sc_hd__o21ai_1
X_2876_ _1416_ _1417_ vssd1 vssd1 vccd1 vccd1 _1418_ sky130_fd_sc_hd__nor2_1
X_1827_ MATMULT_INST.matmult_inst.fsm_inst.count\[1\] MATMULT_INST.matmult_inst.fsm_inst.count\[0\]
+ vssd1 vssd1 vccd1 vccd1 _0731_ sky130_fd_sc_hd__nand2_1
X_1758_ net146 net138 MATMULT_INST.matmult_inst.mem_inst.mem3\[5\] vssd1 vssd1 vccd1
+ vccd1 _0676_ sky130_fd_sc_hd__and3_1
X_1689_ net152 net144 MATMULT_INST.matmult_inst.mem_inst.mem3\[11\] vssd1 vssd1 vccd1
+ vccd1 _0613_ sky130_fd_sc_hd__and3_1
XANTENNA__2922__A2 net176 vssd1 vssd1 vccd1 vccd1 sky130_fd_sc_hd__diode_2
X_3428_ clknet_leaf_25_clk _0350_ vssd1 vssd1 vccd1 vccd1 MATMULT_INST.matmult_inst.alu_inst.out\[9\]
+ sky130_fd_sc_hd__dfxtp_1
X_3359_ clknet_leaf_10_clk _0281_ vssd1 vssd1 vccd1 vccd1 MATMULT_INST.matmult_inst.mem_inst.mem2\[14\]
+ sky130_fd_sc_hd__dfxtp_1
XANTENNA__2686__A1 net82 vssd1 vssd1 vccd1 vccd1 sky130_fd_sc_hd__diode_2
XFILLER_38_15 vssd1 vssd1 vccd1 vccd1 sky130_fd_sc_hd__fill_4
XFILLER_45_318 vssd1 vssd1 vccd1 vccd1 sky130_fd_sc_hd__fill_1
XFILLER_72_137 vssd1 vssd1 vccd1 vccd1 sky130_fd_sc_hd__fill_2
XFILLER_57_189 vssd1 vssd1 vccd1 vccd1 sky130_fd_sc_hd__fill_2
XTAP_TAPCELL_ROW_0_163 vssd1 vccd1 sky130_fd_sc_hd__tapvpwrvgnd_1
XFILLER_13_204 vssd1 vssd1 vccd1 vccd1 sky130_fd_sc_hd__fill_4
XTAP_TAPCELL_ROW_0_174 vssd1 vccd1 sky130_fd_sc_hd__tapvpwrvgnd_1
XFILLER_53_362 vssd1 vssd1 vccd1 vccd1 sky130_fd_sc_hd__fill_1
XFILLER_53_395 vssd1 vssd1 vccd1 vccd1 sky130_fd_sc_hd__fill_8
XFILLER_21_281 vccd1 vssd1 vccd1 vssd1 sky130_ef_sc_hd__decap_40_12
XFILLER_70_79 vssd1 vssd1 vccd1 vccd1 sky130_fd_sc_hd__fill_4
XFILLER_5_447 vssd1 vssd1 vccd1 vccd1 sky130_fd_sc_hd__fill_1
XTAP_TAPCELL_ROW_8_241 vssd1 vccd1 sky130_fd_sc_hd__tapvpwrvgnd_1
XFILLER_0_141 vccd1 vssd1 vccd1 vssd1 sky130_ef_sc_hd__decap_40_12
XFILLER_76_421 vccd1 vssd1 vccd1 vssd1 sky130_ef_sc_hd__decap_40_12
XANTENNA__2677__B2 net103 vssd1 vssd1 vccd1 vccd1 sky130_fd_sc_hd__diode_2
XFILLER_48_123 vssd1 vssd1 vccd1 vccd1 sky130_fd_sc_hd__fill_1
XANTENNA__2000__S net26 vssd1 vssd1 vccd1 vccd1 sky130_fd_sc_hd__diode_2
Xteam_02_260 vssd1 vssd1 vccd1 vccd1 team_02_260/HI gpio_oeb[33] sky130_fd_sc_hd__conb_1
XFILLER_76_454 vccd1 vssd1 vccd1 vssd1 sky130_ef_sc_hd__decap_40_12
Xteam_02_271 vssd1 vssd1 vccd1 vccd1 team_02_271/HI gpio_out[12] sky130_fd_sc_hd__conb_1
XTAP_TAPCELL_ROW_59_674 vssd1 vccd1 sky130_fd_sc_hd__tapvpwrvgnd_1
Xteam_02_282 vssd1 vssd1 vccd1 vccd1 team_02_282/HI gpio_out[23] sky130_fd_sc_hd__conb_1
XTAP_TAPCELL_ROW_42_530 vssd1 vccd1 sky130_fd_sc_hd__tapvpwrvgnd_1
XTAP_TAPCELL_ROW_14_287 vssd1 vccd1 sky130_fd_sc_hd__tapvpwrvgnd_1
X_2730_ _1276_ _1277_ vssd1 vssd1 vccd1 vccd1 _1278_ sky130_fd_sc_hd__nor2_1
X_2661_ net102 _1244_ vssd1 vssd1 vccd1 vccd1 _1245_ sky130_fd_sc_hd__nor2_1
XFILLER_8_274 vccd1 vssd1 vccd1 vssd1 sky130_ef_sc_hd__decap_40_12
X_1612_ _0539_ _0541_ vssd1 vssd1 vccd1 vccd1 _0543_ sky130_fd_sc_hd__nor2_2
X_2592_ _1155_ _1156_ _1154_ vssd1 vssd1 vccd1 vccd1 _1182_ sky130_fd_sc_hd__o21ba_1
Xfanout209 MATMULT_INST.matmult_inst.alu_inst.b0_reg\[3\] vssd1 vssd1 vccd1 vccd1
+ net209 sky130_fd_sc_hd__clkbuf_2
X_3213_ clknet_leaf_13_clk _0135_ vssd1 vssd1 vccd1 vccd1 MATMULT_INST.matmult_inst.mem_inst.matrixB2\[12\]
+ sky130_fd_sc_hd__dfxtp_1
XFILLER_79_281 vssd1 vssd1 vccd1 vccd1 sky130_fd_sc_hd__fill_8
XFILLER_39_134 vssd1 vssd1 vccd1 vccd1 sky130_fd_sc_hd__fill_1
X_3144_ net56 net85 net75 vssd1 vssd1 vccd1 vccd1 _0069_ sky130_fd_sc_hd__and3_1
X_3075_ MATMULT_INST.matmult_inst.alu_inst.out\[11\] net51 net6 net302 vssd1 vssd1
+ vccd1 vccd1 _0519_ sky130_fd_sc_hd__a22o_1
XFILLER_54_137 vssd1 vssd1 vccd1 vccd1 sky130_fd_sc_hd__fill_1
X_2026_ net341 net40 net24 vssd1 vssd1 vccd1 vccd1 _0186_ sky130_fd_sc_hd__mux2_1
XFILLER_35_351 vssd1 vssd1 vccd1 vccd1 sky130_fd_sc_hd__fill_1
XANTENNA__1643__A2 net111 vssd1 vssd1 vccd1 vccd1 sky130_fd_sc_hd__diode_2
XFILLER_24_17 vssd1 vssd1 vccd1 vccd1 sky130_fd_sc_hd__fill_1
XFILLER_35_384 vssd1 vssd1 vccd1 vccd1 sky130_fd_sc_hd__fill_2
XFILLER_50_321 vssd1 vssd1 vccd1 vccd1 sky130_fd_sc_hd__fill_4
X_2928_ _1462_ _1468_ vssd1 vssd1 vccd1 vccd1 _1469_ sky130_fd_sc_hd__xnor2_2
X_2859_ _1369_ _1400_ _1401_ vssd1 vssd1 vccd1 vccd1 _1402_ sky130_fd_sc_hd__and3_1
Xhold230 MATMULT_INST.matmult_inst.mem_inst.matrixB2\[12\] vssd1 vssd1 vccd1 vccd1
+ net525 sky130_fd_sc_hd__dlygate4sd3_1
Xhold241 MATMULT_INST.matmult_inst.mem_inst.matrixA2\[0\] vssd1 vssd1 vccd1 vccd1
+ net536 sky130_fd_sc_hd__dlygate4sd3_1
Xhold252 MATMULT_INST.matmult_inst.mem_inst.matrixB2\[2\] vssd1 vssd1 vccd1 vccd1
+ net547 sky130_fd_sc_hd__dlygate4sd3_1
Xhold296 MATMULT_INST.matmult_inst.mem_inst.matrixA2\[16\] vssd1 vssd1 vccd1 vccd1
+ net591 sky130_fd_sc_hd__dlygate4sd3_1
Xhold263 MATMULT_INST.matmult_inst.alu_inst.a0_reg\[0\] vssd1 vssd1 vccd1 vccd1 net558
+ sky130_fd_sc_hd__dlygate4sd3_1
Xhold274 MATMULT_INST.matmult_inst.alu_inst.row1\[0\] vssd1 vssd1 vccd1 vccd1 net569
+ sky130_fd_sc_hd__dlygate4sd3_1
Xhold285 _0483_ vssd1 vssd1 vccd1 vccd1 net580 sky130_fd_sc_hd__dlygate4sd3_1
XTAP_TAPCELL_ROW_5_211 vssd1 vccd1 sky130_fd_sc_hd__tapvpwrvgnd_1
XFILLER_58_410 vssd1 vssd1 vccd1 vccd1 sky130_fd_sc_hd__fill_4
XFILLER_65_57 vssd1 vssd1 vccd1 vccd1 sky130_fd_sc_hd__fill_4
XTAP_TAPCELL_ROW_56_644 vssd1 vccd1 sky130_fd_sc_hd__tapvpwrvgnd_1
XANTENNA_fanout22_X net22 vssd1 vssd1 vccd1 vccd1 sky130_fd_sc_hd__diode_2
XANTENNA_clkbuf_2_3__f_clk_A clknet_0_clk vssd1 vssd1 vccd1 vccd1 sky130_fd_sc_hd__diode_2
XFILLER_14_83 vssd1 vssd1 vccd1 vccd1 sky130_fd_sc_hd__fill_1
XTAP_TAPCELL_ROW_11_268 vssd1 vccd1 sky130_fd_sc_hd__tapvpwrvgnd_1
XFILLER_5_211 vccd1 vssd1 vccd1 vssd1 sky130_ef_sc_hd__decap_40_12
XFILLER_5_233 vssd1 vssd1 vccd1 vccd1 sky130_fd_sc_hd__fill_4
XFILLER_46_9 vssd1 vssd1 vccd1 vccd1 sky130_fd_sc_hd__fill_1
XFILLER_1_461 vccd1 vssd1 vccd1 vssd1 sky130_ef_sc_hd__decap_40_12
XFILLER_49_443 vssd1 vssd1 vccd1 vccd1 sky130_fd_sc_hd__fill_4
XTAP_TAPCELL_ROW_19_335 vssd1 vccd1 sky130_fd_sc_hd__tapvpwrvgnd_1
XANTENNA__1625__A2 net129 vssd1 vssd1 vccd1 vccd1 sky130_fd_sc_hd__diode_2
XANTENNA__3595__CLK net228 vssd1 vssd1 vccd1 vccd1 sky130_fd_sc_hd__diode_2
X_2713_ _1260_ _1262_ _1263_ _1264_ vssd1 vssd1 vccd1 vccd1 _1265_ sky130_fd_sc_hd__or4b_1
X_2644_ _1230_ _1231_ vssd1 vssd1 vccd1 vccd1 _1232_ sky130_fd_sc_hd__nand2b_1
X_2575_ _1164_ _1165_ vssd1 vssd1 vccd1 vccd1 _1166_ sky130_fd_sc_hd__nand2_1
XFILLER_59_218 vssd1 vssd1 vccd1 vccd1 sky130_fd_sc_hd__fill_1
X_3127_ net225 vssd1 vssd1 vccd1 vccd1 _0040_ sky130_fd_sc_hd__inv_2
XFILLER_27_159 vssd1 vssd1 vccd1 vccd1 sky130_fd_sc_hd__fill_2
XFILLER_70_405 vssd1 vssd1 vccd1 vccd1 sky130_fd_sc_hd__fill_2
X_3058_ net357 _0810_ net8 vssd1 vssd1 vccd1 vccd1 _0477_ sky130_fd_sc_hd__mux2_1
X_2009_ net105 net38 net27 net373 vssd1 vssd1 vccd1 vccd1 _0170_ sky130_fd_sc_hd__a22o_1
XTAP_TAPCELL_ROW_53_625 vssd1 vccd1 sky130_fd_sc_hd__tapvpwrvgnd_1
XFILLER_23_398 vccd1 vssd1 vccd1 vssd1 sky130_ef_sc_hd__decap_40_12
XTAP_TAPCELL_ROW_61_691 vssd1 vccd1 sky130_fd_sc_hd__tapvpwrvgnd_1
XANTENNA_clkbuf_leaf_13_clk_A clknet_2_1__leaf_clk vssd1 vssd1 vccd1 vccd1 sky130_fd_sc_hd__diode_2
XFILLER_18_115 vssd1 vssd1 vccd1 vccd1 sky130_fd_sc_hd__fill_1
XFILLER_18_137 vssd1 vssd1 vccd1 vccd1 sky130_fd_sc_hd__fill_2
XTAP_TAPCELL_ROW_16_305 vssd1 vccd1 sky130_fd_sc_hd__tapvpwrvgnd_1
XFILLER_33_107 vssd1 vssd1 vccd1 vccd1 sky130_fd_sc_hd__fill_2
XANTENNA_clkbuf_leaf_28_clk_A clknet_2_2__leaf_clk vssd1 vssd1 vccd1 vccd1 sky130_fd_sc_hd__diode_2
XFILLER_14_365 vccd1 vssd1 vccd1 vssd1 sky130_ef_sc_hd__decap_40_12
XFILLER_26_192 vssd1 vssd1 vccd1 vccd1 sky130_fd_sc_hd__fill_4
XFILLER_41_162 vssd1 vssd1 vccd1 vccd1 sky130_fd_sc_hd__fill_4
XANTENNA__2073__X _0820_ vssd1 vssd1 vccd1 vccd1 sky130_fd_sc_hd__diode_2
XFILLER_41_70 vssd1 vssd1 vccd1 vccd1 sky130_fd_sc_hd__fill_2
XANTENNA__2887__C net178 vssd1 vssd1 vccd1 vccd1 sky130_fd_sc_hd__diode_2
X_2360_ net195 net207 vssd1 vssd1 vccd1 vccd1 _0957_ sky130_fd_sc_hd__and2_1
X_2291_ _0912_ _0913_ vssd1 vssd1 vccd1 vccd1 _0914_ sky130_fd_sc_hd__and2b_1
XPHY_EDGE_ROW_10_Right_10 vssd1 vssd1 vccd1 vccd1 sky130_fd_sc_hd__decap_3
XTAP_TAPCELL_ROW_67_739 vssd1 vccd1 sky130_fd_sc_hd__tapvpwrvgnd_1
XFILLER_64_221 vssd1 vssd1 vccd1 vccd1 sky130_fd_sc_hd__fill_2
XFILLER_2_97 vssd1 vssd1 vccd1 vccd1 sky130_fd_sc_hd__fill_4
XANTENNA__2408__B net208 vssd1 vssd1 vccd1 vccd1 sky130_fd_sc_hd__diode_2
XFILLER_24_118 vssd1 vssd1 vccd1 vccd1 sky130_fd_sc_hd__fill_1
XFILLER_60_482 vccd1 vssd1 vccd1 vssd1 sky130_ef_sc_hd__decap_40_12
XFILLER_9_391 vssd1 vssd1 vccd1 vccd1 sky130_fd_sc_hd__fill_1
XANTENNA_fanout117_A net123 vssd1 vssd1 vccd1 vccd1 sky130_fd_sc_hd__diode_2
X_2627_ _1209_ _1215_ vssd1 vssd1 vccd1 vccd1 _1216_ sky130_fd_sc_hd__xnor2_1
X_2558_ net199 net191 _1148_ vssd1 vssd1 vccd1 vccd1 _1149_ sky130_fd_sc_hd__and3_1
X_2489_ _1048_ _1049_ _1047_ vssd1 vssd1 vccd1 vccd1 _1082_ sky130_fd_sc_hd__o21bai_1
XFILLER_46_26 vssd1 vssd1 vccd1 vccd1 sky130_fd_sc_hd__fill_2
XFILLER_55_221 vssd1 vssd1 vccd1 vccd1 sky130_fd_sc_hd__fill_2
XTAP_TAPCELL_ROW_38_496 vssd1 vccd1 sky130_fd_sc_hd__tapvpwrvgnd_1
XFILLER_43_449 vssd1 vssd1 vccd1 vccd1 sky130_fd_sc_hd__fill_1
XFILLER_62_36 vssd1 vssd1 vccd1 vccd1 sky130_fd_sc_hd__fill_4
Xclkbuf_leaf_35_clk clknet_2_0__leaf_clk vssd1 vssd1 vccd1 vccd1 clknet_leaf_35_clk
+ sky130_fd_sc_hd__clkbuf_8
XFILLER_70_279 vssd1 vssd1 vccd1 vccd1 sky130_fd_sc_hd__fill_1
XFILLER_11_313 vssd1 vssd1 vccd1 vccd1 sky130_fd_sc_hd__fill_8
XFILLER_23_151 vccd1 vssd1 vccd1 vssd1 sky130_ef_sc_hd__decap_40_12
XFILLER_51_493 vssd1 vssd1 vccd1 vccd1 sky130_fd_sc_hd__fill_1
XTAP_TAPCELL_ROW_21_352 vssd1 vccd1 sky130_fd_sc_hd__tapvpwrvgnd_1
XANTENNA__1773__A1 net219 vssd1 vssd1 vccd1 vccd1 sky130_fd_sc_hd__diode_2
XANTENNA__1773__B2 net216 vssd1 vssd1 vccd1 vccd1 sky130_fd_sc_hd__diode_2
XFILLER_11_84 vssd1 vssd1 vccd1 vccd1 sky130_fd_sc_hd__fill_4
XFILLER_34_405 vssd1 vssd1 vccd1 vccd1 sky130_fd_sc_hd__fill_4
Xclkbuf_leaf_26_clk clknet_2_3__leaf_clk vssd1 vssd1 vccd1 vccd1 clknet_leaf_26_clk
+ sky130_fd_sc_hd__clkbuf_8
XTAP_TAPCELL_ROW_72_786 vssd1 vccd1 sky130_fd_sc_hd__tapvpwrvgnd_1
XFILLER_61_279 vssd1 vssd1 vccd1 vccd1 sky130_fd_sc_hd__fill_1
X_1860_ MATMULT_INST.matmult_inst.spi_inst.rx_bit_count\[2\] _0743_ vssd1 vssd1 vccd1
+ vccd1 _0745_ sky130_fd_sc_hd__or2_1
XFILLER_14_195 vssd1 vssd1 vccd1 vccd1 sky130_fd_sc_hd__fill_1
XFILLER_42_493 vssd1 vssd1 vccd1 vccd1 sky130_fd_sc_hd__fill_1
X_1791_ net149 net145 MATMULT_INST.matmult_inst.mem_inst.matrixA3\[2\] vssd1 vssd1
+ vccd1 vccd1 _0706_ sky130_fd_sc_hd__and3_1
X_3530_ _0029_ _0445_ _0028_ vssd1 vssd1 vccd1 vccd1 MATMULT_INST.matmult_inst.spi_inst.rx_bit_count\[2\]
+ sky130_fd_sc_hd__dfrtp_1
XFILLER_6_361 vssd1 vssd1 vccd1 vccd1 sky130_fd_sc_hd__fill_2
XANTENNA__1764__A1 _0681_ vssd1 vssd1 vccd1 vccd1 sky130_fd_sc_hd__diode_2
X_3461_ clknet_leaf_34_clk _0382_ vssd1 vssd1 vccd1 vccd1 MATMULT_INST.matmult_inst.alu_inst.adder_inst.r1.fa3.a
+ sky130_fd_sc_hd__dfxtp_1
X_3392_ clknet_leaf_20_clk _0314_ vssd1 vssd1 vccd1 vccd1 MATMULT_INST.matmult_inst.mem_inst.mem0\[11\]
+ sky130_fd_sc_hd__dfxtp_1
X_2412_ net212 net190 net189 net210 vssd1 vssd1 vccd1 vccd1 _1007_ sky130_fd_sc_hd__nand4_1
X_2343_ _0940_ _0941_ vssd1 vssd1 vccd1 vccd1 _0942_ sky130_fd_sc_hd__nor2_1
X_2274_ _0892_ _0895_ _0893_ vssd1 vssd1 vccd1 vccd1 _0900_ sky130_fd_sc_hd__o21ai_1
XFILLER_52_235 vssd1 vssd1 vccd1 vccd1 sky130_fd_sc_hd__fill_1
Xclkbuf_leaf_17_clk clknet_2_1__leaf_clk vssd1 vssd1 vccd1 vccd1 clknet_leaf_17_clk
+ sky130_fd_sc_hd__clkbuf_8
XTAP_TAPCELL_ROW_35_466 vssd1 vccd1 sky130_fd_sc_hd__tapvpwrvgnd_1
XFILLER_33_493 vssd1 vssd1 vccd1 vccd1 sky130_fd_sc_hd__fill_1
XFILLER_20_165 vssd1 vssd1 vccd1 vccd1 sky130_fd_sc_hd__fill_8
X_1989_ net441 net39 net29 vssd1 vssd1 vccd1 vccd1 _0151_ sky130_fd_sc_hd__mux2_1
XANTENNA__2704__A0 _1253_ vssd1 vssd1 vccd1 vccd1 sky130_fd_sc_hd__diode_2
XANTENNA__1932__S net137 vssd1 vssd1 vccd1 vccd1 sky130_fd_sc_hd__diode_2
XFILLER_75_316 vssd1 vssd1 vccd1 vccd1 sky130_fd_sc_hd__fill_8
XFILLER_73_57 vssd1 vssd1 vccd1 vccd1 sky130_fd_sc_hd__fill_2
XFILLER_24_471 vssd1 vssd1 vccd1 vccd1 sky130_fd_sc_hd__fill_4
XFILLER_31_419 vssd1 vssd1 vccd1 vccd1 sky130_fd_sc_hd__fill_4
XFILLER_24_493 vssd1 vssd1 vccd1 vccd1 sky130_fd_sc_hd__fill_1
XANTENNA__1994__A1 net34 vssd1 vssd1 vccd1 vccd1 sky130_fd_sc_hd__diode_2
XFILLER_7_147 vssd1 vssd1 vccd1 vccd1 sky130_fd_sc_hd__fill_1
XFILLER_7_125 vssd1 vssd1 vccd1 vccd1 sky130_fd_sc_hd__fill_2
XFILLER_7_169 vssd1 vssd1 vccd1 vccd1 sky130_fd_sc_hd__fill_2
XANTENNA__2003__S net26 vssd1 vssd1 vccd1 vccd1 sky130_fd_sc_hd__diode_2
XTAP_TAPCELL_ROW_77_823 vssd1 vccd1 sky130_fd_sc_hd__tapvpwrvgnd_1
XFILLER_66_305 vssd1 vssd1 vccd1 vccd1 sky130_fd_sc_hd__fill_2
XFILLER_19_221 vssd1 vssd1 vccd1 vccd1 sky130_fd_sc_hd__fill_2
XFILLER_22_408 vssd1 vssd1 vccd1 vccd1 sky130_fd_sc_hd__fill_1
X_2961_ _1499_ _1500_ vssd1 vssd1 vccd1 vccd1 _1501_ sky130_fd_sc_hd__nand2_1
XFILLER_22_419 vssd1 vssd1 vccd1 vccd1 sky130_fd_sc_hd__fill_1
XFILLER_34_279 vssd1 vssd1 vccd1 vccd1 sky130_fd_sc_hd__fill_4
XFILLER_63_90 vssd1 vssd1 vccd1 vccd1 sky130_fd_sc_hd__fill_2
XTAP_TAPCELL_ROW_32_447 vssd1 vccd1 sky130_fd_sc_hd__tapvpwrvgnd_1
X_1912_ net665 _0780_ net71 _0777_ _0788_ vssd1 vssd1 vccd1 vccd1 _0000_ sky130_fd_sc_hd__a221o_1
X_2892_ _1418_ _1433_ vssd1 vssd1 vccd1 vccd1 _1434_ sky130_fd_sc_hd__xnor2_1
X_1843_ MATMULT_INST.matmult_inst.spi_inst.mosi_shifter\[2\] MATMULT_INST.matmult_inst.spi_inst.mosi_shifter\[1\]
+ _0741_ vssd1 vssd1 vccd1 vccd1 _0459_ sky130_fd_sc_hd__mux2_1
X_1774_ _0685_ _0690_ vssd1 vssd1 vccd1 vccd1 _0691_ sky130_fd_sc_hd__or2_1
XANTENNA__2421__B net203 vssd1 vssd1 vccd1 vccd1 sky130_fd_sc_hd__diode_2
X_3513_ clknet_leaf_28_clk _0430_ vssd1 vssd1 vccd1 vccd1 MATMULT_INST.matmult_inst.alu_inst.adder_inst.r1.fa0.b
+ sky130_fd_sc_hd__dfxtp_1
X_3444_ clknet_leaf_35_clk _0366_ vssd1 vssd1 vccd1 vccd1 MATMULT_INST.matmult_inst.alu_inst.b1_reg\[7\]
+ sky130_fd_sc_hd__dfxtp_1
Xclkbuf_leaf_6_clk clknet_2_1__leaf_clk vssd1 vssd1 vccd1 vccd1 clknet_leaf_6_clk
+ sky130_fd_sc_hd__clkbuf_8
XFILLER_69_143 vssd1 vssd1 vccd1 vccd1 sky130_fd_sc_hd__fill_1
X_3375_ clknet_leaf_14_clk _0297_ vssd1 vssd1 vccd1 vccd1 MATMULT_INST.matmult_inst.mem_inst.mem1\[12\]
+ sky130_fd_sc_hd__dfxtp_1
X_2326_ net162 net576 net68 vssd1 vssd1 vccd1 vccd1 _0370_ sky130_fd_sc_hd__mux2_1
X_2257_ net567 _0885_ net100 vssd1 vssd1 vccd1 vccd1 _0348_ sky130_fd_sc_hd__mux2_1
XANTENNA__2149__A net111 vssd1 vssd1 vccd1 vccd1 sky130_fd_sc_hd__diode_2
XFILLER_57_349 vssd1 vssd1 vccd1 vccd1 sky130_fd_sc_hd__fill_2
X_2188_ _1594_ _0839_ _0842_ vssd1 vssd1 vccd1 vccd1 _0323_ sky130_fd_sc_hd__a21boi_1
XTAP_TAPCELL_ROW_48_580 vssd1 vccd1 sky130_fd_sc_hd__tapvpwrvgnd_1
XFILLER_25_279 vssd1 vssd1 vccd1 vccd1 sky130_fd_sc_hd__fill_1
XANTENNA__1728__A1 net223 vssd1 vssd1 vccd1 vccd1 sky130_fd_sc_hd__diode_2
XANTENNA_fanout97_A net98 vssd1 vssd1 vccd1 vccd1 sky130_fd_sc_hd__diode_2
XFILLER_0_345 vccd1 vssd1 vccd1 vssd1 sky130_ef_sc_hd__decap_40_12
XFILLER_0_389 vssd1 vssd1 vccd1 vccd1 sky130_fd_sc_hd__fill_2
XFILLER_75_179 vssd1 vssd1 vccd1 vccd1 sky130_fd_sc_hd__fill_1
XFILLER_75_146 vssd1 vssd1 vccd1 vccd1 sky130_fd_sc_hd__fill_4
XTAP_TAPCELL_ROW_74_804 vssd1 vccd1 sky130_fd_sc_hd__tapvpwrvgnd_1
XTAP_TAPCELL_ROW_3_194 vssd1 vccd1 sky130_fd_sc_hd__tapvpwrvgnd_1
XFILLER_8_445 vccd1 vssd1 vccd1 vssd1 sky130_ef_sc_hd__decap_40_12
XFILLER_8_489 vssd1 vssd1 vccd1 vccd1 sky130_fd_sc_hd__fill_4
XANTENNA__1719__A1 net220 vssd1 vssd1 vccd1 vccd1 sky130_fd_sc_hd__diode_2
XANTENNA__1719__B2 net218 vssd1 vssd1 vccd1 vccd1 sky130_fd_sc_hd__diode_2
XFILLER_3_161 vssd1 vssd1 vccd1 vccd1 sky130_fd_sc_hd__fill_4
X_3160_ net58 net87 net72 vssd1 vssd1 vccd1 vccd1 _0085_ sky130_fd_sc_hd__and3_1
Xhold1 MATMULT_INST.matmult_inst.spi_inst.cs_sync vssd1 vssd1 vccd1 vccd1 net296 sky130_fd_sc_hd__dlygate4sd3_1
XANTENNA__2695__A2 _1253_ vssd1 vssd1 vccd1 vccd1 sky130_fd_sc_hd__diode_2
X_3091_ _1582_ _1585_ _1586_ _1579_ net134 vssd1 vssd1 vccd1 vccd1 _0527_ sky130_fd_sc_hd__o32a_1
X_2111_ net217 net120 _0795_ vssd1 vssd1 vccd1 vccd1 _0822_ sky130_fd_sc_hd__and3_1
X_2042_ net533 net43 net22 vssd1 vssd1 vccd1 vccd1 _0201_ sky130_fd_sc_hd__mux2_1
XFILLER_74_190 vssd1 vssd1 vccd1 vccd1 sky130_fd_sc_hd__fill_4
XFILLER_47_393 vssd1 vssd1 vccd1 vccd1 sky130_fd_sc_hd__fill_2
XFILLER_62_363 vssd1 vssd1 vccd1 vccd1 sky130_fd_sc_hd__fill_1
XPHY_EDGE_ROW_8_Right_8 vssd1 vssd1 vccd1 vccd1 sky130_fd_sc_hd__decap_3
XFILLER_22_205 vssd1 vssd1 vccd1 vccd1 sky130_fd_sc_hd__fill_1
X_2944_ net160 net173 vssd1 vssd1 vccd1 vccd1 _1484_ sky130_fd_sc_hd__nand2_1
X_2875_ _1375_ _1413_ _1414_ _1415_ vssd1 vssd1 vccd1 vccd1 _1417_ sky130_fd_sc_hd__and4_1
XFILLER_30_282 vssd1 vssd1 vccd1 vccd1 sky130_fd_sc_hd__fill_1
X_1826_ MATMULT_INST.matmult_inst.fsm_inst.rx_data\[0\] net523 MATMULT_INST.matmult_inst.spi_inst.rx_done_sys
+ vssd1 vssd1 vccd1 vccd1 _0482_ sky130_fd_sc_hd__mux2_1
X_1757_ MATMULT_INST.matmult_inst.mem_inst.matrixB0\[5\] net104 _0673_ net222 _0674_
+ vssd1 vssd1 vccd1 vccd1 _0675_ sky130_fd_sc_hd__a221o_1
X_1688_ net656 net64 _0610_ _0612_ vssd1 vssd1 vccd1 vccd1 _0502_ sky130_fd_sc_hd__o22a_1
X_3427_ clknet_leaf_27_clk _0349_ vssd1 vssd1 vccd1 vccd1 MATMULT_INST.matmult_inst.alu_inst.out\[8\]
+ sky130_fd_sc_hd__dfxtp_1
XPHY_EDGE_ROW_39_Right_39 vssd1 vssd1 vccd1 vccd1 sky130_fd_sc_hd__decap_3
X_3358_ clknet_leaf_9_clk _0280_ vssd1 vssd1 vccd1 vccd1 MATMULT_INST.matmult_inst.mem_inst.mem2\[13\]
+ sky130_fd_sc_hd__dfxtp_1
XANTENNA__2686__A2 _1253_ vssd1 vssd1 vccd1 vccd1 sky130_fd_sc_hd__diode_2
X_2309_ _0927_ _0928_ vssd1 vssd1 vccd1 vccd1 _0929_ sky130_fd_sc_hd__nand2_1
X_3289_ clknet_leaf_11_clk _0211_ vssd1 vssd1 vccd1 vccd1 MATMULT_INST.matmult_inst.mem_inst.matrixA2\[16\]
+ sky130_fd_sc_hd__dfxtp_1
XANTENNA__1646__B1 net106 vssd1 vssd1 vccd1 vccd1 sky130_fd_sc_hd__diode_2
XFILLER_53_341 vssd1 vssd1 vccd1 vccd1 sky130_fd_sc_hd__fill_2
XFILLER_54_15 vssd1 vssd1 vccd1 vccd1 sky130_fd_sc_hd__fill_4
XTAP_TAPCELL_ROW_0_164 vssd1 vccd1 sky130_fd_sc_hd__tapvpwrvgnd_1
XTAP_TAPCELL_ROW_0_175 vssd1 vccd1 sky130_fd_sc_hd__tapvpwrvgnd_1
XFILLER_13_227 vssd1 vssd1 vccd1 vccd1 sky130_fd_sc_hd__fill_4
XPHY_EDGE_ROW_48_Right_48 vssd1 vssd1 vccd1 vccd1 sky130_fd_sc_hd__decap_3
XFILLER_21_293 vssd1 vssd1 vccd1 vccd1 sky130_fd_sc_hd__fill_8
XFILLER_79_12 vccd1 vssd1 vccd1 vssd1 sky130_ef_sc_hd__decap_40_12
XPHY_EDGE_ROW_57_Right_57 vssd1 vssd1 vccd1 vccd1 sky130_fd_sc_hd__decap_3
XANTENNA__2126__A1 net35 vssd1 vssd1 vccd1 vccd1 sky130_fd_sc_hd__diode_2
XTAP_TAPCELL_ROW_8_242 vssd1 vccd1 sky130_fd_sc_hd__tapvpwrvgnd_1
XFILLER_76_400 vccd1 vssd1 vccd1 vssd1 sky130_ef_sc_hd__decap_40_12
XFILLER_0_153 vccd1 vssd1 vccd1 vssd1 sky130_ef_sc_hd__decap_40_12
XFILLER_76_433 vssd1 vssd1 vccd1 vccd1 sky130_fd_sc_hd__fill_1
XFILLER_0_197 vccd1 vssd1 vccd1 vssd1 sky130_ef_sc_hd__decap_40_12
XFILLER_76_477 vccd1 vssd1 vccd1 vssd1 sky130_ef_sc_hd__decap_40_12
XFILLER_76_466 vssd1 vssd1 vccd1 vccd1 sky130_fd_sc_hd__fill_8
Xteam_02_261 vssd1 vssd1 vccd1 vccd1 team_02_261/HI gpio_out[0] sky130_fd_sc_hd__conb_1
Xteam_02_250 vssd1 vssd1 vccd1 vccd1 team_02_250/HI gpio_oeb[23] sky130_fd_sc_hd__conb_1
Xteam_02_294 vssd1 vssd1 vccd1 vccd1 gpio_oeb[3] team_02_294/LO sky130_fd_sc_hd__conb_1
Xteam_02_283 vssd1 vssd1 vccd1 vccd1 team_02_283/HI gpio_out[24] sky130_fd_sc_hd__conb_1
XFILLER_63_127 vssd1 vssd1 vccd1 vccd1 sky130_fd_sc_hd__fill_2
Xteam_02_272 vssd1 vssd1 vccd1 vccd1 team_02_272/HI gpio_out[13] sky130_fd_sc_hd__conb_1
XFILLER_48_179 vssd1 vssd1 vccd1 vccd1 sky130_fd_sc_hd__fill_1
XTAP_TAPCELL_ROW_59_675 vssd1 vccd1 sky130_fd_sc_hd__tapvpwrvgnd_1
XANTENNA__2517__A net190 vssd1 vssd1 vccd1 vccd1 sky130_fd_sc_hd__diode_2
XPHY_EDGE_ROW_66_Right_66 vssd1 vssd1 vccd1 vccd1 sky130_fd_sc_hd__decap_3
XTAP_TAPCELL_ROW_42_531 vssd1 vccd1 sky130_fd_sc_hd__tapvpwrvgnd_1
XTAP_TAPCELL_ROW_14_288 vssd1 vccd1 sky130_fd_sc_hd__tapvpwrvgnd_1
XFILLER_74_6 vssd1 vssd1 vccd1 vccd1 sky130_fd_sc_hd__fill_4
XFILLER_8_253 vssd1 vssd1 vccd1 vccd1 sky130_fd_sc_hd__fill_4
X_2660_ net134 net133 _0785_ vssd1 vssd1 vccd1 vccd1 _1244_ sky130_fd_sc_hd__nor3_2
XFILLER_67_5 vccd1 vssd1 vccd1 vssd1 sky130_ef_sc_hd__decap_40_12
XFILLER_8_286 vccd1 vssd1 vccd1 vssd1 sky130_ef_sc_hd__decap_40_12
X_1611_ _0541_ vssd1 vssd1 vccd1 vccd1 _0542_ sky130_fd_sc_hd__inv_2
XPHY_EDGE_ROW_75_Right_75 vssd1 vssd1 vccd1 vccd1 sky130_fd_sc_hd__decap_3
X_2591_ _1118_ _1180_ _1179_ vssd1 vssd1 vccd1 vccd1 _1181_ sky130_fd_sc_hd__a21bo_1
XFILLER_5_53 vssd1 vssd1 vccd1 vccd1 sky130_fd_sc_hd__fill_2
X_3212_ clknet_leaf_13_clk _0134_ vssd1 vssd1 vccd1 vccd1 MATMULT_INST.matmult_inst.mem_inst.matrixB2\[11\]
+ sky130_fd_sc_hd__dfxtp_1
XFILLER_79_293 vccd1 vssd1 vccd1 vssd1 sky130_ef_sc_hd__decap_40_12
X_3143_ net56 net85 net75 vssd1 vssd1 vccd1 vccd1 _0068_ sky130_fd_sc_hd__and3_1
X_3074_ MATMULT_INST.matmult_inst.alu_inst.out\[10\] net51 net6 net305 vssd1 vssd1
+ vccd1 vccd1 _0518_ sky130_fd_sc_hd__a22o_1
X_2025_ net352 net41 net24 vssd1 vssd1 vccd1 vccd1 _0185_ sky130_fd_sc_hd__mux2_1
XFILLER_24_29 vssd1 vssd1 vccd1 vccd1 sky130_fd_sc_hd__fill_1
XFILLER_50_311 vssd1 vssd1 vccd1 vccd1 sky130_fd_sc_hd__fill_1
XANTENNA_fanout147_A net149 vssd1 vssd1 vccd1 vccd1 sky130_fd_sc_hd__diode_2
X_2927_ _1466_ _1467_ vssd1 vssd1 vccd1 vccd1 _1468_ sky130_fd_sc_hd__xor2_2
XPHY_EDGE_ROW_17_Left_97 vssd1 vssd1 vccd1 vccd1 sky130_fd_sc_hd__decap_3
X_2858_ _1381_ _1382_ _1399_ vssd1 vssd1 vccd1 vccd1 _1401_ sky130_fd_sc_hd__o21ai_1
X_2789_ _1332_ _1333_ vssd1 vssd1 vccd1 vccd1 _1334_ sky130_fd_sc_hd__xnor2_1
Xhold220 MATMULT_INST.matmult_inst.alu_inst.col1\[1\] vssd1 vssd1 vccd1 vccd1 net515
+ sky130_fd_sc_hd__dlygate4sd3_1
X_1809_ MATMULT_INST.matmult_inst.mem_inst.mem1\[0\] net124 net116 MATMULT_INST.matmult_inst.mem_inst.mem2\[0\]
+ _0721_ vssd1 vssd1 vccd1 vccd1 _0722_ sky130_fd_sc_hd__a221o_1
Xhold231 MATMULT_INST.matmult_inst.mem_inst.matrixA2\[15\] vssd1 vssd1 vccd1 vccd1
+ net526 sky130_fd_sc_hd__dlygate4sd3_1
Xhold242 MATMULT_INST.matmult_inst.alu_inst.row0\[7\] vssd1 vssd1 vccd1 vccd1 net537
+ sky130_fd_sc_hd__dlygate4sd3_1
Xhold253 MATMULT_INST.matmult_inst.mem_inst.matrixB1\[7\] vssd1 vssd1 vccd1 vccd1
+ net548 sky130_fd_sc_hd__dlygate4sd3_1
Xhold264 MATMULT_INST.matmult_inst.alu_inst.col0\[5\] vssd1 vssd1 vccd1 vccd1 net559
+ sky130_fd_sc_hd__dlygate4sd3_1
Xhold275 MATMULT_INST.matmult_inst.mem_inst.matrixB0\[5\] vssd1 vssd1 vccd1 vccd1
+ net570 sky130_fd_sc_hd__dlygate4sd3_1
Xhold286 MATMULT_INST.matmult_inst.mem_inst.matrixB0\[0\] vssd1 vssd1 vccd1 vccd1
+ net581 sky130_fd_sc_hd__dlygate4sd3_1
XANTENNA__2108__A1 net34 vssd1 vssd1 vccd1 vccd1 sky130_fd_sc_hd__diode_2
XANTENNA__2101__S net17 vssd1 vssd1 vccd1 vccd1 sky130_fd_sc_hd__diode_2
Xhold297 MATMULT_INST.matmult_inst.mem_inst.matrixB3\[1\] vssd1 vssd1 vccd1 vccd1
+ net592 sky130_fd_sc_hd__dlygate4sd3_1
XTAP_TAPCELL_ROW_5_212 vssd1 vccd1 sky130_fd_sc_hd__tapvpwrvgnd_1
XFILLER_65_14 vssd1 vssd1 vccd1 vccd1 sky130_fd_sc_hd__fill_2
XFILLER_73_447 vssd1 vssd1 vccd1 vccd1 sky130_fd_sc_hd__fill_1
XANTENNA__2337__A net114 vssd1 vssd1 vccd1 vccd1 sky130_fd_sc_hd__diode_2
XTAP_TAPCELL_ROW_56_645 vssd1 vccd1 sky130_fd_sc_hd__tapvpwrvgnd_1
XFILLER_26_374 vssd1 vssd1 vccd1 vccd1 sky130_fd_sc_hd__fill_8
XANTENNA_fanout15_X net15 vssd1 vssd1 vccd1 vccd1 sky130_fd_sc_hd__diode_2
XANTENNA__3168__A net58 vssd1 vssd1 vccd1 vccd1 sky130_fd_sc_hd__diode_2
XTAP_TAPCELL_ROW_11_269 vssd1 vccd1 sky130_fd_sc_hd__tapvpwrvgnd_1
XFILLER_5_223 vssd1 vssd1 vccd1 vccd1 sky130_fd_sc_hd__fill_1
XFILLER_30_83 vssd1 vssd1 vccd1 vccd1 sky130_fd_sc_hd__fill_1
XFILLER_1_473 vccd1 vssd1 vccd1 vssd1 sky130_ef_sc_hd__decap_40_12
XTAP_TAPCELL_ROW_19_336 vssd1 vccd1 sky130_fd_sc_hd__tapvpwrvgnd_1
XFILLER_36_138 vssd1 vssd1 vccd1 vccd1 sky130_fd_sc_hd__fill_2
XFILLER_17_352 vssd1 vssd1 vccd1 vccd1 sky130_fd_sc_hd__fill_1
XFILLER_17_363 vssd1 vssd1 vccd1 vccd1 sky130_fd_sc_hd__fill_4
XFILLER_32_300 vssd1 vssd1 vccd1 vccd1 sky130_fd_sc_hd__fill_1
XANTENNA__2586__A1 net190 vssd1 vssd1 vccd1 vccd1 sky130_fd_sc_hd__diode_2
X_2712_ net148 _0544_ _0755_ _0765_ vssd1 vssd1 vccd1 vccd1 _1264_ sky130_fd_sc_hd__o211a_1
X_2643_ _1208_ _1229_ _1228_ vssd1 vssd1 vccd1 vccd1 _1231_ sky130_fd_sc_hd__a21o_1
XANTENNA__2338__A1 MATMULT_INST.matmult_inst.alu_inst.adder_inst.r0.fa1.a vssd1 vssd1
+ vccd1 vccd1 sky130_fd_sc_hd__diode_2
X_2574_ _1127_ _1129_ _1126_ vssd1 vssd1 vccd1 vccd1 _1165_ sky130_fd_sc_hd__a21bo_1
X_3126_ net225 vssd1 vssd1 vccd1 vccd1 _0038_ sky130_fd_sc_hd__inv_2
XFILLER_55_447 vssd1 vssd1 vccd1 vccd1 sky130_fd_sc_hd__fill_1
X_3057_ net403 net37 net9 vssd1 vssd1 vccd1 vccd1 _0476_ sky130_fd_sc_hd__mux2_1
XFILLER_55_469 vssd1 vssd1 vccd1 vccd1 sky130_fd_sc_hd__fill_2
X_2008_ net105 net39 net27 net540 vssd1 vssd1 vccd1 vccd1 _0169_ sky130_fd_sc_hd__a22o_1
XFILLER_35_171 vssd1 vssd1 vccd1 vccd1 sky130_fd_sc_hd__fill_4
XTAP_TAPCELL_ROW_53_626 vssd1 vccd1 sky130_fd_sc_hd__tapvpwrvgnd_1
XFILLER_35_193 vssd1 vssd1 vccd1 vccd1 sky130_fd_sc_hd__fill_2
XTAP_TAPCELL_ROW_61_692 vssd1 vccd1 sky130_fd_sc_hd__tapvpwrvgnd_1
XANTENNA__1935__S net137 vssd1 vssd1 vccd1 vccd1 sky130_fd_sc_hd__diode_2
XFILLER_4_6 vccd1 vssd1 vccd1 vssd1 sky130_ef_sc_hd__decap_40_12
XFILLER_58_230 vssd1 vssd1 vccd1 vccd1 sky130_fd_sc_hd__fill_1
XTAP_TAPCELL_ROW_16_306 vssd1 vccd1 sky130_fd_sc_hd__tapvpwrvgnd_1
XTAP_TAPCELL_ROW_24_372 vssd1 vccd1 sky130_fd_sc_hd__tapvpwrvgnd_1
XFILLER_41_185 vssd1 vssd1 vccd1 vccd1 sky130_fd_sc_hd__fill_1
X_2290_ MATMULT_INST.matmult_inst.alu_inst.adder_inst.r3.fa1.b MATMULT_INST.matmult_inst.alu_inst.adder_inst.r3.fa1.a
+ vssd1 vssd1 vccd1 vccd1 _0913_ sky130_fd_sc_hd__nand2_1
XFILLER_1_281 vssd1 vssd1 vccd1 vccd1 sky130_fd_sc_hd__fill_8
XFILLER_37_447 vssd1 vssd1 vccd1 vccd1 sky130_fd_sc_hd__fill_1
XFILLER_64_277 vssd1 vssd1 vccd1 vccd1 sky130_fd_sc_hd__fill_2
XFILLER_64_255 vssd1 vssd1 vccd1 vccd1 sky130_fd_sc_hd__fill_1
XFILLER_52_417 vssd1 vssd1 vccd1 vccd1 sky130_fd_sc_hd__fill_2
XFILLER_17_182 vccd1 vssd1 vccd1 vssd1 sky130_ef_sc_hd__decap_40_12
XFILLER_45_491 vssd1 vssd1 vccd1 vccd1 sky130_fd_sc_hd__fill_2
XFILLER_32_141 vssd1 vssd1 vccd1 vccd1 sky130_fd_sc_hd__fill_4
XANTENNA__2008__B1 net27 vssd1 vssd1 vccd1 vccd1 sky130_fd_sc_hd__diode_2
XPHY_EDGE_ROW_25_Left_105 vssd1 vssd1 vccd1 vccd1 sky130_fd_sc_hd__decap_3
X_2626_ _1180_ _1214_ vssd1 vssd1 vccd1 vccd1 _1215_ sky130_fd_sc_hd__xnor2_1
XANTENNA__1782__A2 net128 vssd1 vssd1 vccd1 vccd1 sky130_fd_sc_hd__diode_2
X_2557_ net201 net193 _1107_ _1109_ vssd1 vssd1 vccd1 vccd1 _1148_ sky130_fd_sc_hd__a22o_1
XPHY_EDGE_ROW_34_Left_114 vssd1 vssd1 vccd1 vccd1 sky130_fd_sc_hd__decap_3
X_2488_ _1079_ _1080_ vssd1 vssd1 vccd1 vccd1 _1081_ sky130_fd_sc_hd__or2_1
XFILLER_28_425 vccd1 vssd1 vccd1 vssd1 sky130_ef_sc_hd__decap_40_12
XFILLER_55_233 vssd1 vssd1 vccd1 vccd1 sky130_fd_sc_hd__fill_2
X_3109_ net60 net92 net80 vssd1 vssd1 vccd1 vccd1 _0043_ sky130_fd_sc_hd__and3_1
XFILLER_15_108 vssd1 vssd1 vccd1 vccd1 sky130_fd_sc_hd__fill_4
XFILLER_55_266 vccd1 vssd1 vccd1 vssd1 sky130_ef_sc_hd__decap_40_12
XFILLER_70_214 vssd1 vssd1 vccd1 vccd1 sky130_fd_sc_hd__fill_2
XTAP_TAPCELL_ROW_38_497 vssd1 vccd1 sky130_fd_sc_hd__tapvpwrvgnd_1
XFILLER_23_130 vssd1 vssd1 vccd1 vccd1 sky130_fd_sc_hd__fill_1
XPHY_EDGE_ROW_43_Left_123 vssd1 vssd1 vccd1 vccd1 sky130_fd_sc_hd__decap_3
XFILLER_23_163 vssd1 vssd1 vccd1 vccd1 sky130_fd_sc_hd__fill_4
XTAP_TAPCELL_ROW_21_353 vssd1 vccd1 sky130_fd_sc_hd__tapvpwrvgnd_1
XPHY_EDGE_ROW_52_Left_132 vssd1 vssd1 vccd1 vccd1 sky130_fd_sc_hd__decap_3
XANTENNA_fanout82_X net82 vssd1 vssd1 vccd1 vccd1 sky130_fd_sc_hd__diode_2
XFILLER_19_403 vssd1 vssd1 vccd1 vccd1 sky130_fd_sc_hd__fill_1
XFILLER_19_425 vssd1 vssd1 vccd1 vccd1 sky130_fd_sc_hd__fill_4
XFILLER_19_447 vssd1 vssd1 vccd1 vccd1 sky130_fd_sc_hd__fill_1
XTAP_TAPCELL_ROW_29_420 vssd1 vccd1 sky130_fd_sc_hd__tapvpwrvgnd_1
XFILLER_46_233 vssd1 vssd1 vccd1 vccd1 sky130_fd_sc_hd__fill_1
XPHY_EDGE_ROW_61_Left_141 vssd1 vssd1 vccd1 vccd1 sky130_fd_sc_hd__decap_3
XFILLER_27_480 vccd1 vssd1 vccd1 vssd1 sky130_ef_sc_hd__decap_40_12
XTAP_TAPCELL_ROW_72_787 vssd1 vccd1 sky130_fd_sc_hd__tapvpwrvgnd_1
XFILLER_14_152 vssd1 vssd1 vccd1 vccd1 sky130_fd_sc_hd__fill_4
XFILLER_14_141 vssd1 vssd1 vccd1 vccd1 sky130_fd_sc_hd__fill_2
XFILLER_14_185 vssd1 vssd1 vccd1 vccd1 sky130_fd_sc_hd__fill_8
X_1790_ MATMULT_INST.matmult_inst.mem_inst.matrixB3\[2\] _0548_ _0704_ vssd1 vssd1
+ vccd1 vccd1 _0705_ sky130_fd_sc_hd__a21o_1
XPHY_EDGE_ROW_70_Left_150 vssd1 vssd1 vccd1 vccd1 sky130_fd_sc_hd__decap_3
XFILLER_6_340 vssd1 vssd1 vccd1 vccd1 sky130_fd_sc_hd__fill_1
X_3460_ clknet_leaf_29_clk _0381_ vssd1 vssd1 vccd1 vccd1 MATMULT_INST.matmult_inst.alu_inst.adder_inst.r1.fa2.a
+ sky130_fd_sc_hd__dfxtp_1
X_3391_ clknet_leaf_18_clk _0313_ vssd1 vssd1 vccd1 vccd1 MATMULT_INST.matmult_inst.mem_inst.mem0\[10\]
+ sky130_fd_sc_hd__dfxtp_1
X_2411_ net212 net189 net210 net190 vssd1 vssd1 vccd1 vccd1 _1006_ sky130_fd_sc_hd__a22o_1
X_2342_ net198 net211 _0938_ _0939_ vssd1 vssd1 vccd1 vccd1 _0941_ sky130_fd_sc_hd__o2bb2a_1
XFILLER_35_3 vssd1 vssd1 vccd1 vccd1 sky130_fd_sc_hd__fill_4
XFILLER_69_347 vssd1 vssd1 vccd1 vccd1 sky130_fd_sc_hd__fill_1
X_2273_ _0897_ _0898_ vssd1 vssd1 vccd1 vccd1 _0899_ sky130_fd_sc_hd__nand2_1
XTAP_TAPCELL_ROW_63_710 vssd1 vccd1 sky130_fd_sc_hd__tapvpwrvgnd_1
XTAP_TAPCELL_ROW_35_467 vssd1 vccd1 sky130_fd_sc_hd__tapvpwrvgnd_1
XFILLER_52_269 vccd1 vssd1 vccd1 vssd1 sky130_ef_sc_hd__decap_40_12
XFILLER_32_29 vssd1 vssd1 vccd1 vccd1 sky130_fd_sc_hd__fill_4
XANTENNA_fanout227_A net228 vssd1 vssd1 vccd1 vccd1 sky130_fd_sc_hd__diode_2
XANTENNA_clkbuf_leaf_12_clk_A clknet_2_1__leaf_clk vssd1 vssd1 vccd1 vccd1 sky130_fd_sc_hd__diode_2
X_1988_ net475 net40 net28 vssd1 vssd1 vccd1 vccd1 _0150_ sky130_fd_sc_hd__mux2_1
X_3589_ net225 _0022_ _0087_ vssd1 vssd1 vccd1 vccd1 MATMULT_INST.matmult_inst.spi_inst.miso_shifter\[9\]
+ sky130_fd_sc_hd__dfrtp_1
X_2609_ _1170_ _1171_ _1194_ _1196_ _1172_ vssd1 vssd1 vccd1 vccd1 _1199_ sky130_fd_sc_hd__a221o_1
XANTENNA_clkbuf_leaf_27_clk_A clknet_2_2__leaf_clk vssd1 vssd1 vccd1 vccd1 sky130_fd_sc_hd__diode_2
XFILLER_57_37 vssd1 vssd1 vccd1 vccd1 sky130_fd_sc_hd__fill_2
Xclkbuf_2_2__f_clk clknet_0_clk vssd1 vssd1 vccd1 vccd1 clknet_2_2__leaf_clk sky130_fd_sc_hd__clkbuf_16
XFILLER_16_417 vssd1 vssd1 vccd1 vccd1 sky130_fd_sc_hd__fill_1
XANTENNA_fanout42_A _0804_ vssd1 vssd1 vccd1 vccd1 sky130_fd_sc_hd__diode_2
XFILLER_11_111 vssd1 vssd1 vccd1 vccd1 sky130_fd_sc_hd__fill_1
XFILLER_7_137 vssd1 vssd1 vccd1 vccd1 sky130_fd_sc_hd__fill_8
XFILLER_7_115 vssd1 vssd1 vccd1 vccd1 sky130_fd_sc_hd__fill_1
XFILLER_22_40 vssd1 vssd1 vccd1 vccd1 sky130_fd_sc_hd__fill_4
XPHY_EDGE_ROW_5_Left_85 vssd1 vssd1 vccd1 vccd1 sky130_fd_sc_hd__decap_3
XFILLER_3_332 vssd1 vssd1 vccd1 vccd1 sky130_fd_sc_hd__fill_4
XTAP_TAPCELL_ROW_77_824 vssd1 vccd1 sky130_fd_sc_hd__tapvpwrvgnd_1
XFILLER_78_199 vssd1 vssd1 vccd1 vccd1 sky130_fd_sc_hd__fill_1
XFILLER_66_339 vssd1 vssd1 vccd1 vccd1 sky130_fd_sc_hd__fill_1
Xfanout190 MATMULT_INST.matmult_inst.alu_inst.a0_reg\[4\] vssd1 vssd1 vccd1 vccd1
+ net190 sky130_fd_sc_hd__buf_2
XANTENNA__2239__B MATMULT_INST.matmult_inst.alu_inst.adder_inst.r1.fa1.a vssd1 vssd1
+ vccd1 vccd1 sky130_fd_sc_hd__diode_2
XFILLER_74_383 vssd1 vssd1 vccd1 vccd1 sky130_fd_sc_hd__fill_1
XFILLER_19_299 vssd1 vssd1 vccd1 vccd1 sky130_fd_sc_hd__fill_8
X_2960_ _1445_ _1498_ _1497_ vssd1 vssd1 vccd1 vccd1 _1500_ sky130_fd_sc_hd__a21o_1
XFILLER_15_461 vssd1 vssd1 vccd1 vccd1 sky130_fd_sc_hd__fill_4
X_2891_ _1427_ _1432_ vssd1 vssd1 vccd1 vccd1 _1433_ sky130_fd_sc_hd__xnor2_1
X_1911_ _0783_ _0786_ _0787_ vssd1 vssd1 vccd1 vccd1 _0788_ sky130_fd_sc_hd__or3_1
XTAP_TAPCELL_ROW_32_448 vssd1 vccd1 sky130_fd_sc_hd__tapvpwrvgnd_1
X_1842_ MATMULT_INST.matmult_inst.spi_inst.mosi_shifter\[3\] MATMULT_INST.matmult_inst.spi_inst.mosi_shifter\[2\]
+ _0741_ vssd1 vssd1 vccd1 vccd1 _0460_ sky130_fd_sc_hd__mux2_1
XFILLER_8_42 vssd1 vssd1 vccd1 vccd1 sky130_fd_sc_hd__fill_4
XFILLER_8_75 vssd1 vssd1 vccd1 vccd1 sky130_fd_sc_hd__fill_4
X_1773_ net219 _0687_ _0689_ net216 vssd1 vssd1 vccd1 vccd1 _0690_ sky130_fd_sc_hd__a22o_1
X_3512_ clknet_leaf_28_clk _0429_ vssd1 vssd1 vccd1 vccd1 MATMULT_INST.matmult_inst.alu_inst.adder_inst.r0.fa3.b
+ sky130_fd_sc_hd__dfxtp_1
X_3443_ clknet_leaf_34_clk _0365_ vssd1 vssd1 vccd1 vccd1 MATMULT_INST.matmult_inst.alu_inst.b1_reg\[6\]
+ sky130_fd_sc_hd__dfxtp_1
XANTENNA__2698__A0 _1247_ vssd1 vssd1 vccd1 vccd1 sky130_fd_sc_hd__diode_2
X_3374_ clknet_leaf_19_clk _0296_ vssd1 vssd1 vccd1 vccd1 MATMULT_INST.matmult_inst.mem_inst.mem1\[11\]
+ sky130_fd_sc_hd__dfxtp_1
X_2325_ net165 net354 net68 vssd1 vssd1 vccd1 vccd1 _0369_ sky130_fd_sc_hd__mux2_1
X_2256_ _0883_ _0884_ vssd1 vssd1 vccd1 vccd1 _0885_ sky130_fd_sc_hd__xnor2_1
XFILLER_72_309 vssd1 vssd1 vccd1 vccd1 sky130_fd_sc_hd__fill_2
XFILLER_65_361 vssd1 vssd1 vccd1 vccd1 sky130_fd_sc_hd__fill_4
X_2187_ _1594_ _0839_ _0841_ _0832_ vssd1 vssd1 vccd1 vccd1 _0842_ sky130_fd_sc_hd__o22a_1
XANTENNA__2436__Y _1031_ vssd1 vssd1 vccd1 vccd1 sky130_fd_sc_hd__diode_2
XFILLER_25_225 vssd1 vssd1 vccd1 vccd1 sky130_fd_sc_hd__fill_8
XTAP_TAPCELL_ROW_48_581 vssd1 vccd1 sky130_fd_sc_hd__tapvpwrvgnd_1
XFILLER_21_442 vssd1 vssd1 vccd1 vccd1 sky130_fd_sc_hd__fill_1
XANTENNA__2104__S net17 vssd1 vssd1 vccd1 vccd1 sky130_fd_sc_hd__diode_2
XANTENNA__1943__S net30 vssd1 vssd1 vccd1 vccd1 sky130_fd_sc_hd__diode_2
XFILLER_68_58 vssd1 vssd1 vccd1 vccd1 sky130_fd_sc_hd__fill_1
XFILLER_0_357 vssd1 vssd1 vccd1 vccd1 sky130_fd_sc_hd__fill_4
XTAP_TAPCELL_ROW_74_805 vssd1 vccd1 sky130_fd_sc_hd__tapvpwrvgnd_1
XTAP_TAPCELL_ROW_3_195 vssd1 vccd1 sky130_fd_sc_hd__tapvpwrvgnd_1
XANTENNA__1664__A1 net223 vssd1 vssd1 vccd1 vccd1 sky130_fd_sc_hd__diode_2
XFILLER_16_247 vssd1 vssd1 vccd1 vccd1 sky130_fd_sc_hd__fill_4
XFILLER_31_217 vssd1 vssd1 vccd1 vccd1 sky130_fd_sc_hd__fill_1
XFILLER_12_431 vssd1 vssd1 vccd1 vccd1 sky130_fd_sc_hd__fill_1
XFILLER_8_402 vccd1 vssd1 vccd1 vssd1 sky130_ef_sc_hd__decap_40_12
XFILLER_12_475 vssd1 vssd1 vccd1 vccd1 sky130_fd_sc_hd__fill_1
XFILLER_8_457 vssd1 vssd1 vccd1 vccd1 sky130_fd_sc_hd__fill_1
XANTENNA__1853__S _0744_ vssd1 vssd1 vccd1 vccd1 sky130_fd_sc_hd__diode_2
XFILLER_79_475 vssd1 vssd1 vccd1 vccd1 sky130_fd_sc_hd__fill_1
X_2110_ net349 net32 net17 vssd1 vssd1 vccd1 vccd1 _0266_ sky130_fd_sc_hd__mux2_1
X_3090_ _0539_ _0761_ _0764_ _0757_ vssd1 vssd1 vccd1 vccd1 _1586_ sky130_fd_sc_hd__o22ai_1
Xhold2 MATMULT_INST.matmult_inst.spi_inst.rx_done1 vssd1 vssd1 vccd1 vccd1 net297
+ sky130_fd_sc_hd__dlygate4sd3_1
X_2041_ net571 net44 net22 vssd1 vssd1 vccd1 vccd1 _0200_ sky130_fd_sc_hd__mux2_1
XFILLER_54_309 vssd1 vssd1 vccd1 vccd1 sky130_fd_sc_hd__fill_4
XANTENNA__1655__B2 net216 vssd1 vssd1 vccd1 vccd1 sky130_fd_sc_hd__diode_2
XANTENNA__1655__A1 net220 vssd1 vssd1 vccd1 vccd1 sky130_fd_sc_hd__diode_2
XTAP_TAPCELL_ROW_45_551 vssd1 vccd1 sky130_fd_sc_hd__tapvpwrvgnd_1
X_2943_ _1460_ _1468_ _1461_ vssd1 vssd1 vccd1 vccd1 _1483_ sky130_fd_sc_hd__a21oi_1
X_2874_ _1413_ _1414_ _1415_ _1375_ vssd1 vssd1 vccd1 vccd1 _1416_ sky130_fd_sc_hd__a22oi_1
XFILLER_30_272 vssd1 vssd1 vccd1 vccd1 sky130_fd_sc_hd__fill_1
X_1825_ MATMULT_INST.matmult_inst.fsm_inst.rx_data\[1\] net579 MATMULT_INST.matmult_inst.spi_inst.rx_done_sys
+ vssd1 vssd1 vccd1 vccd1 _0483_ sky130_fd_sc_hd__mux2_1
X_1756_ MATMULT_INST.matmult_inst.mem_inst.matrixA0\[5\] net112 net108 MATMULT_INST.matmult_inst.mem_inst.mem0\[5\]
+ vssd1 vssd1 vccd1 vccd1 _0674_ sky130_fd_sc_hd__a22o_1
XFILLER_7_490 vssd1 vssd1 vccd1 vccd1 sky130_fd_sc_hd__fill_1
X_1687_ net396 net110 _0611_ _0545_ vssd1 vssd1 vccd1 vccd1 _0612_ sky130_fd_sc_hd__a211o_1
X_3426_ clknet_leaf_28_clk _0348_ vssd1 vssd1 vccd1 vccd1 MATMULT_INST.matmult_inst.alu_inst.out\[7\]
+ sky130_fd_sc_hd__dfxtp_1
X_3357_ clknet_leaf_15_clk _0279_ vssd1 vssd1 vccd1 vccd1 MATMULT_INST.matmult_inst.mem_inst.mem2\[12\]
+ sky130_fd_sc_hd__dfxtp_1
X_2308_ _0922_ _0925_ _0923_ vssd1 vssd1 vccd1 vccd1 _0928_ sky130_fd_sc_hd__o21ai_2
X_3288_ clknet_leaf_9_clk _0210_ vssd1 vssd1 vccd1 vccd1 MATMULT_INST.matmult_inst.mem_inst.matrixA2\[15\]
+ sky130_fd_sc_hd__dfxtp_1
XFILLER_57_169 vccd1 vssd1 vccd1 vssd1 sky130_ef_sc_hd__decap_40_12
X_2239_ MATMULT_INST.matmult_inst.alu_inst.adder_inst.r1.fa1.b MATMULT_INST.matmult_inst.alu_inst.adder_inst.r1.fa1.a
+ vssd1 vssd1 vccd1 vccd1 _0870_ sky130_fd_sc_hd__or2_1
XFILLER_72_139 vssd1 vssd1 vccd1 vccd1 sky130_fd_sc_hd__fill_1
XTAP_TAPCELL_ROW_0_165 vssd1 vccd1 sky130_fd_sc_hd__tapvpwrvgnd_1
XTAP_TAPCELL_ROW_0_176 vssd1 vccd1 sky130_fd_sc_hd__tapvpwrvgnd_1
XANTENNA__1938__S net137 vssd1 vssd1 vccd1 vccd1 sky130_fd_sc_hd__diode_2
XFILLER_5_427 vssd1 vssd1 vccd1 vccd1 sky130_fd_sc_hd__fill_8
XANTENNA__3157__C net73 vssd1 vssd1 vccd1 vccd1 sky130_fd_sc_hd__diode_2
XFILLER_79_24 vssd1 vssd1 vccd1 vccd1 sky130_fd_sc_hd__fill_4
XFILLER_5_449 vssd1 vssd1 vccd1 vccd1 sky130_fd_sc_hd__fill_4
XFILLER_79_68 vccd1 vssd1 vccd1 vssd1 sky130_ef_sc_hd__decap_40_12
XFILLER_79_57 vssd1 vssd1 vccd1 vccd1 sky130_fd_sc_hd__fill_8
XTAP_TAPCELL_ROW_8_243 vssd1 vccd1 sky130_fd_sc_hd__tapvpwrvgnd_1
XFILLER_76_412 vssd1 vssd1 vccd1 vccd1 sky130_fd_sc_hd__fill_8
XFILLER_0_165 vssd1 vssd1 vccd1 vccd1 sky130_fd_sc_hd__fill_2
Xteam_02_240 vssd1 vssd1 vccd1 vccd1 team_02_240/HI gpio_oeb[13] sky130_fd_sc_hd__conb_1
Xteam_02_262 vssd1 vssd1 vccd1 vccd1 team_02_262/HI gpio_out[1] sky130_fd_sc_hd__conb_1
Xteam_02_251 vssd1 vssd1 vccd1 vccd1 team_02_251/HI gpio_oeb[24] sky130_fd_sc_hd__conb_1
Xteam_02_273 vssd1 vssd1 vccd1 vccd1 team_02_273/HI gpio_out[14] sky130_fd_sc_hd__conb_1
XFILLER_76_489 vssd1 vssd1 vccd1 vccd1 sky130_fd_sc_hd__fill_2
Xteam_02_295 vssd1 vssd1 vccd1 vccd1 gpio_oeb[4] team_02_295/LO sky130_fd_sc_hd__conb_1
Xteam_02_284 vssd1 vssd1 vccd1 vccd1 team_02_284/HI gpio_out[25] sky130_fd_sc_hd__conb_1
XFILLER_28_83 vssd1 vssd1 vccd1 vccd1 sky130_fd_sc_hd__fill_1
XFILLER_29_350 vccd1 vssd1 vccd1 vssd1 sky130_ef_sc_hd__decap_40_12
XANTENNA__1702__A net152 vssd1 vssd1 vccd1 vccd1 sky130_fd_sc_hd__diode_2
XTAP_TAPCELL_ROW_59_676 vssd1 vccd1 sky130_fd_sc_hd__tapvpwrvgnd_1
XTAP_TAPCELL_ROW_42_532 vssd1 vccd1 sky130_fd_sc_hd__tapvpwrvgnd_1
XTAP_TAPCELL_ROW_14_289 vssd1 vccd1 sky130_fd_sc_hd__tapvpwrvgnd_1
XANTENNA__2062__A1 _0804_ vssd1 vssd1 vccd1 vccd1 sky130_fd_sc_hd__diode_2
X_1610_ net135 _0540_ vssd1 vssd1 vccd1 vccd1 _0541_ sky130_fd_sc_hd__nand2_2
XFILLER_8_298 vssd1 vssd1 vccd1 vccd1 sky130_fd_sc_hd__fill_8
X_2590_ net204 net185 vssd1 vssd1 vccd1 vccd1 _1180_ sky130_fd_sc_hd__and2_1
X_3211_ clknet_leaf_15_clk _0133_ vssd1 vssd1 vccd1 vccd1 MATMULT_INST.matmult_inst.mem_inst.matrixB2\[10\]
+ sky130_fd_sc_hd__dfxtp_1
XFILLER_79_261 vssd1 vssd1 vccd1 vccd1 sky130_fd_sc_hd__fill_1
X_3142_ net55 net84 net77 vssd1 vssd1 vccd1 vccd1 _0067_ sky130_fd_sc_hd__and3_1
X_3073_ MATMULT_INST.matmult_inst.alu_inst.out\[9\] net51 net6 net345 vssd1 vssd1
+ vccd1 vccd1 _0517_ sky130_fd_sc_hd__a22o_1
XFILLER_54_106 vssd1 vssd1 vccd1 vccd1 sky130_fd_sc_hd__fill_1
XFILLER_35_320 vssd1 vssd1 vccd1 vccd1 sky130_fd_sc_hd__fill_4
X_2024_ net351 net42 net24 vssd1 vssd1 vccd1 vccd1 _0184_ sky130_fd_sc_hd__mux2_1
X_2926_ MATMULT_INST.matmult_inst.alu_inst.a1_reg\[7\] net181 vssd1 vssd1 vccd1 vccd1
+ _1467_ sky130_fd_sc_hd__and2_1
X_2857_ _1381_ _1382_ _1399_ vssd1 vssd1 vccd1 vccd1 _1400_ sky130_fd_sc_hd__or3_1
XFILLER_40_29 vssd1 vssd1 vccd1 vccd1 sky130_fd_sc_hd__fill_4
X_1808_ net147 net139 MATMULT_INST.matmult_inst.mem_inst.mem3\[0\] vssd1 vssd1 vccd1
+ vccd1 _0721_ sky130_fd_sc_hd__and3_1
X_2788_ _1291_ _1310_ _1311_ vssd1 vssd1 vccd1 vccd1 _1333_ sky130_fd_sc_hd__a21bo_1
Xhold210 MATMULT_INST.matmult_inst.mem_inst.matrixB1\[4\] vssd1 vssd1 vccd1 vccd1
+ net505 sky130_fd_sc_hd__dlygate4sd3_1
XFILLER_2_408 vccd1 vssd1 vccd1 vssd1 sky130_ef_sc_hd__decap_40_12
Xhold232 MATMULT_INST.matmult_inst.alu_inst.adder_inst.r0.fa0.b vssd1 vssd1 vccd1
+ vccd1 net527 sky130_fd_sc_hd__dlygate4sd3_1
Xhold243 MATMULT_INST.matmult_inst.mem_inst.matrixA1\[3\] vssd1 vssd1 vccd1 vccd1
+ net538 sky130_fd_sc_hd__dlygate4sd3_1
X_1739_ net220 _0653_ _0656_ net216 vssd1 vssd1 vccd1 vccd1 _0659_ sky130_fd_sc_hd__a22o_1
Xhold221 MATMULT_INST.matmult_inst.mem_inst.mem0\[10\] vssd1 vssd1 vccd1 vccd1 net516
+ sky130_fd_sc_hd__dlygate4sd3_1
Xhold254 MATMULT_INST.matmult_inst.mem_inst.mem1\[3\] vssd1 vssd1 vccd1 vccd1 net549
+ sky130_fd_sc_hd__dlygate4sd3_1
Xhold265 MATMULT_INST.matmult_inst.mem_inst.matrixA0\[6\] vssd1 vssd1 vccd1 vccd1
+ net560 sky130_fd_sc_hd__dlygate4sd3_1
Xhold287 MATMULT_INST.matmult_inst.alu_inst.out\[12\] vssd1 vssd1 vccd1 vccd1 net582
+ sky130_fd_sc_hd__dlygate4sd3_1
Xhold276 MATMULT_INST.matmult_inst.mem_inst.matrixA2\[5\] vssd1 vssd1 vccd1 vccd1
+ net571 sky130_fd_sc_hd__dlygate4sd3_1
X_3409_ clknet_leaf_0_clk _0331_ vssd1 vssd1 vccd1 vccd1 MATMULT_INST.matmult_inst.alu_inst.b0_reg\[6\]
+ sky130_fd_sc_hd__dfxtp_1
Xhold298 MATMULT_INST.matmult_inst.mem_inst.matrixB0\[7\] vssd1 vssd1 vccd1 vccd1
+ net593 sky130_fd_sc_hd__dlygate4sd3_1
XTAP_TAPCELL_ROW_5_213 vssd1 vccd1 sky130_fd_sc_hd__tapvpwrvgnd_1
XFILLER_58_445 vssd1 vssd1 vccd1 vccd1 sky130_fd_sc_hd__fill_2
XFILLER_58_467 vssd1 vssd1 vccd1 vccd1 sky130_fd_sc_hd__fill_4
XFILLER_73_404 vccd1 vssd1 vccd1 vssd1 sky130_ef_sc_hd__decap_40_12
XTAP_TAPCELL_ROW_56_646 vssd1 vccd1 sky130_fd_sc_hd__tapvpwrvgnd_1
XFILLER_53_194 vssd1 vssd1 vccd1 vccd1 sky130_fd_sc_hd__fill_1
XFILLER_14_41 vssd1 vssd1 vccd1 vccd1 sky130_fd_sc_hd__fill_8
XFILLER_14_96 vssd1 vssd1 vccd1 vccd1 sky130_fd_sc_hd__fill_2
XFILLER_14_85 vssd1 vssd1 vccd1 vccd1 sky130_fd_sc_hd__fill_4
XANTENNA__3184__A net58 vssd1 vssd1 vccd1 vccd1 sky130_fd_sc_hd__diode_2
XFILLER_30_73 vssd1 vssd1 vccd1 vccd1 sky130_fd_sc_hd__fill_8
XFILLER_1_485 vssd1 vssd1 vccd1 vccd1 sky130_fd_sc_hd__fill_2
XFILLER_76_231 vssd1 vssd1 vccd1 vccd1 sky130_fd_sc_hd__fill_4
XFILLER_76_253 vssd1 vssd1 vccd1 vccd1 sky130_fd_sc_hd__fill_2
XFILLER_64_426 vccd1 vssd1 vccd1 vssd1 sky130_ef_sc_hd__decap_40_12
XTAP_TAPCELL_ROW_19_337 vssd1 vccd1 sky130_fd_sc_hd__tapvpwrvgnd_1
XFILLER_17_342 vssd1 vssd1 vccd1 vccd1 sky130_fd_sc_hd__fill_8
XFILLER_32_323 vccd1 vssd1 vccd1 vssd1 sky130_ef_sc_hd__decap_40_12
XANTENNA__2586__A2 net200 vssd1 vssd1 vccd1 vccd1 sky130_fd_sc_hd__diode_2
X_2711_ net148 _0777_ net102 net133 vssd1 vssd1 vccd1 vccd1 _1263_ sky130_fd_sc_hd__o211a_1
X_2642_ _1208_ _1228_ _1229_ vssd1 vssd1 vccd1 vccd1 _1230_ sky130_fd_sc_hd__and3_1
X_2573_ _1151_ _1162_ vssd1 vssd1 vccd1 vccd1 _1164_ sky130_fd_sc_hd__xnor2_1
XANTENNA__2338__A2 net114 vssd1 vssd1 vccd1 vccd1 sky130_fd_sc_hd__diode_2
XFILLER_55_404 vssd1 vssd1 vccd1 vccd1 sky130_fd_sc_hd__fill_4
X_3125_ net225 vssd1 vssd1 vccd1 vccd1 _0036_ sky130_fd_sc_hd__inv_2
X_3056_ net455 net38 net9 vssd1 vssd1 vccd1 vccd1 _0475_ sky130_fd_sc_hd__mux2_1
XFILLER_70_407 vssd1 vssd1 vccd1 vccd1 sky130_fd_sc_hd__fill_1
X_2007_ net106 net40 net27 net381 vssd1 vssd1 vccd1 vccd1 _0168_ sky130_fd_sc_hd__a22o_1
XFILLER_23_367 vssd1 vssd1 vccd1 vccd1 sky130_fd_sc_hd__fill_2
XTAP_TAPCELL_ROW_61_693 vssd1 vccd1 sky130_fd_sc_hd__tapvpwrvgnd_1
X_2909_ _1446_ _1449_ vssd1 vssd1 vccd1 vccd1 _1450_ sky130_fd_sc_hd__xnor2_1
XFILLER_2_216 vssd1 vssd1 vccd1 vccd1 sky130_fd_sc_hd__fill_2
XANTENNA__2112__S net14 vssd1 vssd1 vccd1 vccd1 sky130_fd_sc_hd__diode_2
XANTENNA__1951__S net30 vssd1 vssd1 vccd1 vccd1 sky130_fd_sc_hd__diode_2
XFILLER_76_25 vssd1 vssd1 vccd1 vccd1 sky130_fd_sc_hd__fill_2
XANTENNA_fanout72_A net73 vssd1 vssd1 vccd1 vccd1 sky130_fd_sc_hd__diode_2
XTAP_TAPCELL_ROW_69_760 vssd1 vccd1 sky130_fd_sc_hd__tapvpwrvgnd_1
XFILLER_18_139 vssd1 vssd1 vccd1 vccd1 sky130_fd_sc_hd__fill_1
XFILLER_33_109 vssd1 vssd1 vccd1 vccd1 sky130_fd_sc_hd__fill_1
XTAP_TAPCELL_ROW_16_307 vssd1 vccd1 sky130_fd_sc_hd__tapvpwrvgnd_1
XANTENNA__3179__A net58 vssd1 vssd1 vccd1 vccd1 sky130_fd_sc_hd__diode_2
XTAP_TAPCELL_ROW_24_373 vssd1 vccd1 sky130_fd_sc_hd__tapvpwrvgnd_1
XANTENNA__1776__B1 net104 vssd1 vssd1 vccd1 vccd1 sky130_fd_sc_hd__diode_2
XANTENNA__2022__S net24 vssd1 vssd1 vccd1 vccd1 sky130_fd_sc_hd__diode_2
XFILLER_37_459 vccd1 vssd1 vccd1 vssd1 sky130_ef_sc_hd__decap_40_12
XFILLER_17_194 vccd1 vssd1 vccd1 vssd1 sky130_ef_sc_hd__decap_40_12
XFILLER_20_326 vccd1 vssd1 vccd1 vssd1 sky130_ef_sc_hd__decap_40_12
XFILLER_32_197 vssd1 vssd1 vccd1 vccd1 sky130_fd_sc_hd__fill_2
XANTENNA__1767__B1 net104 vssd1 vssd1 vccd1 vccd1 sky130_fd_sc_hd__diode_2
X_2625_ _1212_ _1213_ vssd1 vssd1 vccd1 vccd1 _1214_ sky130_fd_sc_hd__or2_1
X_2556_ _1146_ vssd1 vssd1 vccd1 vccd1 _1147_ sky130_fd_sc_hd__inv_2
X_2487_ _1040_ _1076_ _1077_ _1078_ vssd1 vssd1 vccd1 vccd1 _1080_ sky130_fd_sc_hd__and4_1
XTAP_TAPCELL_ROW_66_730 vssd1 vccd1 sky130_fd_sc_hd__tapvpwrvgnd_1
XFILLER_28_437 vccd1 vssd1 vccd1 vssd1 sky130_ef_sc_hd__decap_40_12
XFILLER_55_223 vssd1 vssd1 vccd1 vccd1 sky130_fd_sc_hd__fill_1
X_3108_ net60 net90 net80 vssd1 vssd1 vccd1 vccd1 _0045_ sky130_fd_sc_hd__and3_1
X_3039_ net671 net114 vssd1 vssd1 vccd1 vccd1 _1575_ sky130_fd_sc_hd__and2_1
XTAP_TAPCELL_ROW_38_498 vssd1 vccd1 sky130_fd_sc_hd__tapvpwrvgnd_1
XANTENNA__2107__S net16 vssd1 vssd1 vccd1 vccd1 sky130_fd_sc_hd__diode_2
XFILLER_11_337 vssd1 vssd1 vccd1 vccd1 sky130_fd_sc_hd__fill_2
XFILLER_11_326 vssd1 vssd1 vccd1 vccd1 sky130_fd_sc_hd__fill_8
XFILLER_7_308 vssd1 vssd1 vccd1 vccd1 sky130_fd_sc_hd__fill_4
XTAP_TAPCELL_ROW_21_354 vssd1 vccd1 sky130_fd_sc_hd__tapvpwrvgnd_1
XFILLER_11_75 vssd1 vssd1 vccd1 vccd1 sky130_fd_sc_hd__fill_2
XFILLER_11_97 vccd1 vssd1 vccd1 vssd1 sky130_ef_sc_hd__decap_40_12
XTAP_TAPCELL_ROW_29_421 vssd1 vccd1 sky130_fd_sc_hd__tapvpwrvgnd_1
XFILLER_34_418 vssd1 vssd1 vccd1 vccd1 sky130_fd_sc_hd__fill_2
XFILLER_27_492 vssd1 vssd1 vccd1 vccd1 sky130_fd_sc_hd__fill_2
XTAP_TAPCELL_ROW_72_788 vssd1 vccd1 sky130_fd_sc_hd__tapvpwrvgnd_1
XANTENNA__2017__S net24 vssd1 vssd1 vccd1 vccd1 sky130_fd_sc_hd__diode_2
XANTENNA__1856__S _0744_ vssd1 vssd1 vccd1 vccd1 sky130_fd_sc_hd__diode_2
XANTENNA__1749__B1 net104 vssd1 vssd1 vccd1 vccd1 sky130_fd_sc_hd__diode_2
XFILLER_6_330 vssd1 vssd1 vccd1 vccd1 sky130_fd_sc_hd__fill_8
XFILLER_6_363 vssd1 vssd1 vccd1 vccd1 sky130_fd_sc_hd__fill_1
X_2410_ net214 net186 vssd1 vssd1 vccd1 vccd1 _1005_ sky130_fd_sc_hd__nand2_1
X_3390_ clknet_leaf_18_clk _0312_ vssd1 vssd1 vccd1 vccd1 MATMULT_INST.matmult_inst.mem_inst.mem0\[9\]
+ sky130_fd_sc_hd__dfxtp_1
X_2341_ _0938_ _0939_ net198 net210 vssd1 vssd1 vccd1 vccd1 _0940_ sky130_fd_sc_hd__and4bb_1
X_2272_ MATMULT_INST.matmult_inst.alu_inst.adder_inst.r2.fa2.b MATMULT_INST.matmult_inst.alu_inst.adder_inst.r2.fa2.a
+ vssd1 vssd1 vccd1 vccd1 _0898_ sky130_fd_sc_hd__nand2_1
XFILLER_77_90 vssd1 vssd1 vccd1 vccd1 sky130_fd_sc_hd__fill_1
XFILLER_28_3 vccd1 vssd1 vccd1 vssd1 sky130_ef_sc_hd__decap_40_12
XTAP_TAPCELL_ROW_63_711 vssd1 vccd1 sky130_fd_sc_hd__tapvpwrvgnd_1
XFILLER_37_289 vssd1 vssd1 vccd1 vccd1 sky130_fd_sc_hd__fill_1
XTAP_TAPCELL_ROW_35_468 vssd1 vccd1 sky130_fd_sc_hd__tapvpwrvgnd_1
X_1987_ net423 net41 net29 vssd1 vssd1 vccd1 vccd1 _0149_ sky130_fd_sc_hd__mux2_1
XANTENNA_fanout122_A net123 vssd1 vssd1 vccd1 vccd1 sky130_fd_sc_hd__diode_2
XFILLER_9_190 vssd1 vssd1 vccd1 vccd1 sky130_fd_sc_hd__fill_1
X_3588_ net224 _0021_ _0086_ vssd1 vssd1 vccd1 vccd1 MATMULT_INST.matmult_inst.spi_inst.miso_shifter\[8\]
+ sky130_fd_sc_hd__dfrtp_1
X_2608_ _1194_ _1197_ vssd1 vssd1 vccd1 vccd1 _1198_ sky130_fd_sc_hd__nand2_1
X_2539_ _1126_ _1127_ _1129_ vssd1 vssd1 vccd1 vccd1 _1131_ sky130_fd_sc_hd__nand3_1
XANTENNA__1912__B1 net71 vssd1 vssd1 vccd1 vccd1 sky130_fd_sc_hd__diode_2
XFILLER_28_223 vssd1 vssd1 vccd1 vccd1 sky130_fd_sc_hd__fill_2
XFILLER_28_256 vssd1 vssd1 vccd1 vccd1 sky130_fd_sc_hd__fill_4
XFILLER_73_15 vssd1 vssd1 vccd1 vccd1 sky130_fd_sc_hd__fill_2
XFILLER_43_237 vssd1 vssd1 vccd1 vccd1 sky130_fd_sc_hd__fill_1
XANTENNA_fanout35_A _0811_ vssd1 vssd1 vccd1 vccd1 sky130_fd_sc_hd__diode_2
XFILLER_24_440 vssd1 vssd1 vccd1 vccd1 sky130_fd_sc_hd__fill_4
XFILLER_7_105 vssd1 vssd1 vccd1 vccd1 sky130_fd_sc_hd__fill_4
XFILLER_11_167 vssd1 vssd1 vccd1 vccd1 sky130_fd_sc_hd__fill_1
XANTENNA__3176__B net87 vssd1 vssd1 vccd1 vccd1 sky130_fd_sc_hd__diode_2
XFILLER_22_96 vccd1 vssd1 vccd1 vssd1 sky130_ef_sc_hd__decap_40_12
XFILLER_66_307 vssd1 vssd1 vccd1 vccd1 sky130_fd_sc_hd__fill_1
XTAP_TAPCELL_ROW_77_825 vssd1 vccd1 sky130_fd_sc_hd__tapvpwrvgnd_1
Xfanout191 MATMULT_INST.matmult_inst.alu_inst.a0_reg\[3\] vssd1 vssd1 vccd1 vccd1
+ net191 sky130_fd_sc_hd__buf_2
XFILLER_19_223 vssd1 vssd1 vccd1 vccd1 sky130_fd_sc_hd__fill_1
Xfanout180 net181 vssd1 vssd1 vccd1 vccd1 net180 sky130_fd_sc_hd__buf_2
XFILLER_74_373 vssd1 vssd1 vccd1 vccd1 sky130_fd_sc_hd__fill_8
XFILLER_15_440 vssd1 vssd1 vccd1 vccd1 sky130_fd_sc_hd__fill_8
XFILLER_63_92 vssd1 vssd1 vccd1 vccd1 sky130_fd_sc_hd__fill_1
X_2890_ _1430_ _1431_ vssd1 vssd1 vccd1 vccd1 _1432_ sky130_fd_sc_hd__xnor2_1
XANTENNA__2970__S net97 vssd1 vssd1 vccd1 vccd1 sky130_fd_sc_hd__diode_2
X_1910_ _0767_ _0776_ vssd1 vssd1 vccd1 vccd1 _0787_ sky130_fd_sc_hd__nor2_1
X_1841_ MATMULT_INST.matmult_inst.spi_inst.mosi_shifter\[4\] MATMULT_INST.matmult_inst.spi_inst.mosi_shifter\[3\]
+ _0741_ vssd1 vssd1 vccd1 vccd1 _0461_ sky130_fd_sc_hd__mux2_1
XFILLER_42_292 vssd1 vssd1 vccd1 vccd1 sky130_fd_sc_hd__fill_2
X_1772_ MATMULT_INST.matmult_inst.mem_inst.mem1\[4\] net125 net117 MATMULT_INST.matmult_inst.mem_inst.mem2\[4\]
+ _0688_ vssd1 vssd1 vccd1 vccd1 _0689_ sky130_fd_sc_hd__a221o_1
X_3511_ clknet_leaf_27_clk _0428_ vssd1 vssd1 vccd1 vccd1 MATMULT_INST.matmult_inst.alu_inst.adder_inst.r0.fa2.b
+ sky130_fd_sc_hd__dfxtp_1
XFILLER_6_193 vssd1 vssd1 vccd1 vccd1 sky130_fd_sc_hd__fill_2
X_3442_ clknet_leaf_32_clk _0364_ vssd1 vssd1 vccd1 vccd1 MATMULT_INST.matmult_inst.alu_inst.b1_reg\[5\]
+ sky130_fd_sc_hd__dfxtp_1
X_3373_ clknet_leaf_15_clk _0295_ vssd1 vssd1 vccd1 vccd1 MATMULT_INST.matmult_inst.mem_inst.mem1\[10\]
+ sky130_fd_sc_hd__dfxtp_1
X_2324_ net167 net493 net68 vssd1 vssd1 vccd1 vccd1 _0368_ sky130_fd_sc_hd__mux2_1
XANTENNA__1615__A _0545_ vssd1 vssd1 vccd1 vccd1 sky130_fd_sc_hd__diode_2
X_2255_ _0874_ _0878_ _0875_ vssd1 vssd1 vccd1 vccd1 _0884_ sky130_fd_sc_hd__o21ai_1
X_2186_ _0827_ _0829_ vssd1 vssd1 vccd1 vccd1 _0841_ sky130_fd_sc_hd__nand2_1
XTAP_TAPCELL_ROW_48_582 vssd1 vccd1 sky130_fd_sc_hd__tapvpwrvgnd_1
XANTENNA__2120__S net15 vssd1 vssd1 vccd1 vccd1 sky130_fd_sc_hd__diode_2
XFILLER_0_314 vssd1 vssd1 vccd1 vccd1 sky130_fd_sc_hd__fill_4
XANTENNA__2689__A1 net93 vssd1 vssd1 vccd1 vccd1 sky130_fd_sc_hd__diode_2
XFILLER_75_115 vssd1 vssd1 vccd1 vccd1 sky130_fd_sc_hd__fill_2
XFILLER_48_329 vssd1 vssd1 vccd1 vccd1 sky130_fd_sc_hd__fill_1
XTAP_TAPCELL_ROW_3_196 vssd1 vccd1 sky130_fd_sc_hd__tapvpwrvgnd_1
XFILLER_17_74 vssd1 vssd1 vccd1 vccd1 sky130_fd_sc_hd__fill_1
XANTENNA_fanout38_X net38 vssd1 vssd1 vccd1 vccd1 sky130_fd_sc_hd__diode_2
XFILLER_12_421 vssd1 vssd1 vccd1 vccd1 sky130_fd_sc_hd__fill_8
XANTENNA__2790__S net98 vssd1 vssd1 vccd1 vccd1 sky130_fd_sc_hd__diode_2
XANTENNA__3187__A net62 vssd1 vssd1 vccd1 vccd1 sky130_fd_sc_hd__diode_2
XFILLER_8_414 vssd1 vssd1 vccd1 vccd1 sky130_fd_sc_hd__fill_4
XFILLER_33_73 vccd1 vssd1 vccd1 vssd1 sky130_ef_sc_hd__decap_40_12
XFILLER_79_421 vccd1 vssd1 vccd1 vssd1 sky130_ef_sc_hd__decap_40_12
XFILLER_3_185 vssd1 vssd1 vccd1 vccd1 sky130_fd_sc_hd__fill_1
XANTENNA__2030__S net25 vssd1 vssd1 vccd1 vccd1 sky130_fd_sc_hd__diode_2
XFILLER_79_454 vssd1 vssd1 vccd1 vccd1 sky130_fd_sc_hd__fill_4
XFILLER_66_126 vssd1 vssd1 vccd1 vccd1 sky130_fd_sc_hd__fill_1
Xhold3 MATMULT_INST.matmult_inst.fsm_inst.rx_valid vssd1 vssd1 vccd1 vccd1 net298
+ sky130_fd_sc_hd__dlygate4sd3_1
X_2040_ net566 net45 net22 vssd1 vssd1 vccd1 vccd1 _0199_ sky130_fd_sc_hd__mux2_1
XANTENNA_clkbuf_leaf_11_clk_A clknet_2_1__leaf_clk vssd1 vssd1 vccd1 vccd1 sky130_fd_sc_hd__diode_2
XFILLER_62_332 vssd1 vssd1 vccd1 vccd1 sky130_fd_sc_hd__fill_2
XTAP_TAPCELL_ROW_45_552 vssd1 vccd1 sky130_fd_sc_hd__tapvpwrvgnd_1
X_2942_ _1479_ _1481_ vssd1 vssd1 vccd1 vccd1 _1482_ sky130_fd_sc_hd__or2_1
XANTENNA_clkbuf_leaf_26_clk_A clknet_2_3__leaf_clk vssd1 vssd1 vccd1 vccd1 sky130_fd_sc_hd__diode_2
XFILLER_15_281 vssd1 vssd1 vccd1 vccd1 sky130_fd_sc_hd__fill_1
X_2873_ _1340_ _1376_ vssd1 vssd1 vccd1 vccd1 _1415_ sky130_fd_sc_hd__nand2b_1
XFILLER_30_251 vssd1 vssd1 vccd1 vccd1 sky130_fd_sc_hd__fill_1
X_1824_ MATMULT_INST.matmult_inst.fsm_inst.rx_data\[2\] net573 MATMULT_INST.matmult_inst.spi_inst.rx_done_sys
+ vssd1 vssd1 vccd1 vccd1 _0484_ sky130_fd_sc_hd__mux2_1
X_1755_ MATMULT_INST.matmult_inst.mem_inst.matrixA1\[5\] net124 net116 MATMULT_INST.matmult_inst.mem_inst.matrixA2\[5\]
+ _0672_ vssd1 vssd1 vccd1 vccd1 _0673_ sky130_fd_sc_hd__a221o_1
X_1686_ MATMULT_INST.matmult_inst.mem_inst.matrixA0\[12\] net113 net105 MATMULT_INST.matmult_inst.mem_inst.matrixB0\[12\]
+ vssd1 vssd1 vccd1 vccd1 _0611_ sky130_fd_sc_hd__a22o_1
X_3425_ clknet_leaf_28_clk _0347_ vssd1 vssd1 vccd1 vccd1 MATMULT_INST.matmult_inst.alu_inst.out\[6\]
+ sky130_fd_sc_hd__dfxtp_1
X_3356_ clknet_leaf_19_clk _0278_ vssd1 vssd1 vccd1 vccd1 MATMULT_INST.matmult_inst.mem_inst.mem2\[11\]
+ sky130_fd_sc_hd__dfxtp_1
X_3287_ clknet_leaf_10_clk _0209_ vssd1 vssd1 vccd1 vccd1 MATMULT_INST.matmult_inst.mem_inst.matrixA2\[14\]
+ sky130_fd_sc_hd__dfxtp_1
X_2307_ MATMULT_INST.matmult_inst.alu_inst.adder_inst.fa.b MATMULT_INST.matmult_inst.alu_inst.adder_inst.fa.a
+ vssd1 vssd1 vccd1 vccd1 _0927_ sky130_fd_sc_hd__xor2_1
X_2238_ MATMULT_INST.matmult_inst.alu_inst.adder_inst.r1.fa1.b MATMULT_INST.matmult_inst.alu_inst.adder_inst.r1.fa1.a
+ vssd1 vssd1 vccd1 vccd1 _0869_ sky130_fd_sc_hd__nor2_1
XFILLER_38_395 vccd1 vssd1 vccd1 vssd1 sky130_ef_sc_hd__decap_40_12
X_2169_ MATMULT_INST.matmult_inst.fsm_inst.tx_start_send _0733_ vssd1 vssd1 vccd1
+ vccd1 _0826_ sky130_fd_sc_hd__or2_1
XTAP_TAPCELL_ROW_0_166 vssd1 vccd1 sky130_fd_sc_hd__tapvpwrvgnd_1
XFILLER_53_343 vssd1 vssd1 vccd1 vccd1 sky130_fd_sc_hd__fill_1
XFILLER_70_27 vssd1 vssd1 vccd1 vccd1 sky130_fd_sc_hd__fill_1
XANTENNA__2115__S net15 vssd1 vssd1 vccd1 vccd1 sky130_fd_sc_hd__diode_2
XANTENNA__2359__B1 MATMULT_INST.matmult_inst.alu_inst.adder_inst.r0.fa3.a vssd1 vssd1
+ vccd1 vccd1 sky130_fd_sc_hd__diode_2
XTAP_TAPCELL_ROW_8_244 vssd1 vccd1 sky130_fd_sc_hd__tapvpwrvgnd_1
XFILLER_0_111 vssd1 vssd1 vccd1 vccd1 sky130_fd_sc_hd__fill_1
XFILLER_48_126 vccd1 vssd1 vccd1 vssd1 sky130_ef_sc_hd__decap_40_12
Xteam_02_252 vssd1 vssd1 vccd1 vccd1 team_02_252/HI gpio_oeb[25] sky130_fd_sc_hd__conb_1
Xteam_02_241 vssd1 vssd1 vccd1 vccd1 team_02_241/HI gpio_oeb[14] sky130_fd_sc_hd__conb_1
Xteam_02_230 vssd1 vssd1 vccd1 vccd1 team_02_230/HI gpio_oeb[1] sky130_fd_sc_hd__conb_1
Xteam_02_274 vssd1 vssd1 vccd1 vccd1 team_02_274/HI gpio_out[15] sky130_fd_sc_hd__conb_1
Xteam_02_263 vssd1 vssd1 vccd1 vccd1 team_02_263/HI gpio_out[2] sky130_fd_sc_hd__conb_1
Xteam_02_285 vssd1 vssd1 vccd1 vccd1 team_02_285/HI gpio_out[26] sky130_fd_sc_hd__conb_1
XFILLER_29_362 vssd1 vssd1 vccd1 vccd1 sky130_fd_sc_hd__fill_2
XFILLER_29_373 vssd1 vssd1 vccd1 vccd1 sky130_fd_sc_hd__fill_2
XTAP_TAPCELL_ROW_59_677 vssd1 vccd1 sky130_fd_sc_hd__tapvpwrvgnd_1
XANTENNA__1702__B net143 vssd1 vssd1 vccd1 vccd1 sky130_fd_sc_hd__diode_2
XFILLER_71_140 vccd1 vssd1 vccd1 vssd1 sky130_ef_sc_hd__decap_40_12
XTAP_TAPCELL_ROW_42_533 vssd1 vccd1 sky130_fd_sc_hd__tapvpwrvgnd_1
XFILLER_12_251 vssd1 vssd1 vccd1 vccd1 sky130_fd_sc_hd__fill_1
XFILLER_12_284 vssd1 vssd1 vccd1 vccd1 sky130_fd_sc_hd__fill_8
XANTENNA__2025__S net24 vssd1 vssd1 vccd1 vccd1 sky130_fd_sc_hd__diode_2
XFILLER_8_266 vssd1 vssd1 vccd1 vccd1 sky130_fd_sc_hd__fill_1
XFILLER_5_22 vssd1 vssd1 vccd1 vccd1 sky130_fd_sc_hd__fill_2
XFILLER_5_55 vssd1 vssd1 vccd1 vccd1 sky130_fd_sc_hd__fill_1
XFILLER_79_251 vssd1 vssd1 vccd1 vccd1 sky130_fd_sc_hd__fill_1
X_3210_ clknet_leaf_16_clk _0132_ vssd1 vssd1 vccd1 vccd1 MATMULT_INST.matmult_inst.mem_inst.matrixB2\[9\]
+ sky130_fd_sc_hd__dfxtp_1
X_3141_ net227 vssd1 vssd1 vccd1 vccd1 _0066_ sky130_fd_sc_hd__inv_2
XFILLER_39_104 vssd1 vssd1 vccd1 vccd1 sky130_fd_sc_hd__fill_2
XFILLER_10_3 vccd1 vssd1 vccd1 vssd1 sky130_ef_sc_hd__decap_40_12
X_3072_ MATMULT_INST.matmult_inst.alu_inst.out\[8\] _0789_ net6 net324 vssd1 vssd1
+ vccd1 vccd1 _0516_ sky130_fd_sc_hd__a22o_1
X_2023_ net364 net43 net24 vssd1 vssd1 vccd1 vccd1 _0183_ sky130_fd_sc_hd__mux2_1
XFILLER_47_192 vssd1 vssd1 vccd1 vccd1 sky130_fd_sc_hd__fill_1
XFILLER_62_195 vssd1 vssd1 vccd1 vccd1 sky130_fd_sc_hd__fill_1
XANTENNA__2724__A net114 vssd1 vssd1 vccd1 vccd1 sky130_fd_sc_hd__diode_2
XFILLER_50_346 vssd1 vssd1 vccd1 vccd1 sky130_fd_sc_hd__fill_4
X_2925_ _1463_ _1465_ vssd1 vssd1 vccd1 vccd1 _1466_ sky130_fd_sc_hd__nand2_1
XFILLER_50_379 vssd1 vssd1 vccd1 vccd1 sky130_fd_sc_hd__fill_1
X_2856_ _1391_ _1398_ vssd1 vssd1 vccd1 vccd1 _1399_ sky130_fd_sc_hd__xnor2_1
X_1807_ net633 _0720_ net63 vssd1 vssd1 vccd1 vccd1 _0491_ sky130_fd_sc_hd__mux2_1
Xhold211 MATMULT_INST.matmult_inst.mem_inst.matrixA2\[12\] vssd1 vssd1 vccd1 vccd1
+ net506 sky130_fd_sc_hd__dlygate4sd3_1
X_2787_ _1330_ _1331_ vssd1 vssd1 vccd1 vccd1 _1332_ sky130_fd_sc_hd__nand2_1
XANTENNA__1627__X _0557_ vssd1 vssd1 vccd1 vccd1 sky130_fd_sc_hd__diode_2
Xhold200 MATMULT_INST.matmult_inst.mem_inst.mem1\[9\] vssd1 vssd1 vccd1 vccd1 net495
+ sky130_fd_sc_hd__dlygate4sd3_1
Xhold244 MATMULT_INST.matmult_inst.mem_inst.matrixA1\[12\] vssd1 vssd1 vccd1 vccd1
+ net539 sky130_fd_sc_hd__dlygate4sd3_1
XANTENNA_fanout202_A net203 vssd1 vssd1 vccd1 vccd1 sky130_fd_sc_hd__diode_2
Xhold233 MATMULT_INST.matmult_inst.mem_inst.mem1\[0\] vssd1 vssd1 vccd1 vccd1 net528
+ sky130_fd_sc_hd__dlygate4sd3_1
Xhold222 MATMULT_INST.matmult_inst.mem_inst.matrixB1\[1\] vssd1 vssd1 vccd1 vccd1
+ net517 sky130_fd_sc_hd__dlygate4sd3_1
X_1738_ MATMULT_INST.matmult_inst.mem_inst.matrixA1\[7\] net126 net118 MATMULT_INST.matmult_inst.mem_inst.matrixA2\[7\]
+ _0657_ vssd1 vssd1 vccd1 vccd1 _0658_ sky130_fd_sc_hd__a221o_1
Xhold266 MATMULT_INST.matmult_inst.mem_inst.mem2\[12\] vssd1 vssd1 vccd1 vccd1 net561
+ sky130_fd_sc_hd__dlygate4sd3_1
X_1669_ MATMULT_INST.matmult_inst.mem_inst.matrixB1\[13\] net127 net119 MATMULT_INST.matmult_inst.mem_inst.matrixB2\[13\]
+ _0594_ vssd1 vssd1 vccd1 vccd1 _0595_ sky130_fd_sc_hd__a221o_1
Xhold277 MATMULT_INST.matmult_inst.alu_inst.out\[15\] vssd1 vssd1 vccd1 vccd1 net572
+ sky130_fd_sc_hd__dlygate4sd3_1
Xhold255 MATMULT_INST.matmult_inst.mem_inst.mem0\[3\] vssd1 vssd1 vccd1 vccd1 net550
+ sky130_fd_sc_hd__dlygate4sd3_1
Xhold299 MATMULT_INST.matmult_inst.mem_inst.matrixB2\[11\] vssd1 vssd1 vccd1 vccd1
+ net594 sky130_fd_sc_hd__dlygate4sd3_1
X_3408_ clknet_leaf_0_clk _0330_ vssd1 vssd1 vccd1 vccd1 MATMULT_INST.matmult_inst.alu_inst.b0_reg\[5\]
+ sky130_fd_sc_hd__dfxtp_1
Xhold288 MATMULT_INST.matmult_inst.alu_inst.out\[13\] vssd1 vssd1 vccd1 vccd1 net583
+ sky130_fd_sc_hd__dlygate4sd3_1
XTAP_TAPCELL_ROW_5_214 vssd1 vccd1 sky130_fd_sc_hd__tapvpwrvgnd_1
X_3339_ clknet_leaf_15_clk _0261_ vssd1 vssd1 vccd1 vccd1 MATMULT_INST.matmult_inst.mem_inst.mem3\[12\]
+ sky130_fd_sc_hd__dfxtp_1
XFILLER_73_416 vssd1 vssd1 vccd1 vccd1 sky130_fd_sc_hd__fill_4
XFILLER_65_49 vssd1 vssd1 vccd1 vccd1 sky130_fd_sc_hd__fill_4
XFILLER_65_27 vssd1 vssd1 vccd1 vccd1 sky130_fd_sc_hd__fill_4
XFILLER_73_449 vccd1 vssd1 vccd1 vssd1 sky130_ef_sc_hd__decap_40_12
XTAP_TAPCELL_ROW_56_647 vssd1 vccd1 sky130_fd_sc_hd__tapvpwrvgnd_1
XANTENNA__1949__S net30 vssd1 vssd1 vccd1 vccd1 sky130_fd_sc_hd__diode_2
XFILLER_53_173 vssd1 vssd1 vccd1 vccd1 sky130_fd_sc_hd__fill_1
XANTENNA__3168__C net74 vssd1 vssd1 vccd1 vccd1 sky130_fd_sc_hd__diode_2
XANTENNA__1713__A net152 vssd1 vssd1 vccd1 vccd1 sky130_fd_sc_hd__diode_2
XFILLER_49_457 vssd1 vssd1 vccd1 vccd1 sky130_fd_sc_hd__fill_2
XFILLER_76_276 vssd1 vssd1 vccd1 vccd1 sky130_fd_sc_hd__fill_1
XFILLER_64_438 vccd1 vssd1 vccd1 vssd1 sky130_ef_sc_hd__decap_40_12
XFILLER_55_93 vssd1 vssd1 vccd1 vccd1 sky130_fd_sc_hd__fill_2
XFILLER_32_335 vssd1 vssd1 vccd1 vccd1 sky130_fd_sc_hd__fill_2
XFILLER_32_357 vssd1 vssd1 vccd1 vccd1 sky130_fd_sc_hd__fill_2
X_2710_ _0776_ _1261_ net133 _0767_ vssd1 vssd1 vccd1 vccd1 _1262_ sky130_fd_sc_hd__a211oi_1
XTAP_TAPCELL_ROW_10_260 vssd1 vccd1 sky130_fd_sc_hd__tapvpwrvgnd_1
X_2641_ _1205_ _1206_ _1215_ vssd1 vssd1 vccd1 vccd1 _1229_ sky130_fd_sc_hd__a21o_1
X_2572_ _1151_ _1162_ vssd1 vssd1 vccd1 vccd1 _1163_ sky130_fd_sc_hd__and2b_1
XFILLER_58_3 vssd1 vssd1 vccd1 vccd1 sky130_fd_sc_hd__fill_4
X_3124_ net224 vssd1 vssd1 vccd1 vccd1 _0034_ sky130_fd_sc_hd__inv_2
X_3055_ net344 net39 net9 vssd1 vssd1 vccd1 vccd1 _0474_ sky130_fd_sc_hd__mux2_1
X_2006_ net105 net41 net27 net518 vssd1 vssd1 vccd1 vccd1 _0167_ sky130_fd_sc_hd__a22o_1
XANTENNA_fanout152_A net154 vssd1 vssd1 vccd1 vccd1 sky130_fd_sc_hd__diode_2
XTAP_TAPCELL_ROW_61_694 vssd1 vccd1 sky130_fd_sc_hd__tapvpwrvgnd_1
X_2908_ _1448_ vssd1 vssd1 vccd1 vccd1 _1449_ sky130_fd_sc_hd__inv_2
X_2839_ _1377_ _1378_ _1380_ vssd1 vssd1 vccd1 vccd1 _1382_ sky130_fd_sc_hd__and3_1
XTAP_TAPCELL_ROW_69_761 vssd1 vccd1 sky130_fd_sc_hd__tapvpwrvgnd_1
XANTENNA_fanout65_A net66 vssd1 vssd1 vccd1 vccd1 sky130_fd_sc_hd__diode_2
XFILLER_46_427 vssd1 vssd1 vccd1 vccd1 sky130_fd_sc_hd__fill_2
XTAP_TAPCELL_ROW_16_308 vssd1 vccd1 sky130_fd_sc_hd__tapvpwrvgnd_1
XANTENNA__3179__B net87 vssd1 vssd1 vccd1 vccd1 sky130_fd_sc_hd__diode_2
XFILLER_14_379 vssd1 vssd1 vccd1 vccd1 sky130_fd_sc_hd__fill_8
XFILLER_25_96 vssd1 vssd1 vccd1 vccd1 sky130_fd_sc_hd__fill_2
XANTENNA_fanout20_X net20 vssd1 vssd1 vccd1 vccd1 sky130_fd_sc_hd__diode_2
XTAP_TAPCELL_ROW_24_374 vssd1 vccd1 sky130_fd_sc_hd__tapvpwrvgnd_1
XANTENNA__2258__B MATMULT_INST.matmult_inst.alu_inst.adder_inst.r2.fa0.a vssd1 vssd1
+ vccd1 vccd1 sky130_fd_sc_hd__diode_2
XFILLER_64_213 vssd1 vssd1 vccd1 vccd1 sky130_fd_sc_hd__fill_8
XFILLER_37_449 vssd1 vssd1 vccd1 vccd1 sky130_fd_sc_hd__fill_1
Xclkbuf_leaf_29_clk clknet_2_2__leaf_clk vssd1 vssd1 vccd1 vccd1 clknet_leaf_29_clk
+ sky130_fd_sc_hd__clkbuf_8
XFILLER_17_173 vssd1 vssd1 vccd1 vccd1 sky130_fd_sc_hd__fill_2
XFILLER_52_419 vssd1 vssd1 vccd1 vccd1 sky130_fd_sc_hd__fill_1
XFILLER_32_110 vssd1 vssd1 vccd1 vccd1 sky130_fd_sc_hd__fill_1
XFILLER_45_493 vssd1 vssd1 vccd1 vccd1 sky130_fd_sc_hd__fill_1
XFILLER_60_430 vssd1 vssd1 vccd1 vccd1 sky130_fd_sc_hd__fill_4
XANTENNA__2008__A2 net39 vssd1 vssd1 vccd1 vccd1 sky130_fd_sc_hd__diode_2
XFILLER_60_474 vssd1 vssd1 vccd1 vccd1 sky130_fd_sc_hd__fill_2
XFILLER_20_338 vccd1 vssd1 vccd1 vssd1 sky130_ef_sc_hd__decap_40_12
XFILLER_13_390 vssd1 vssd1 vccd1 vccd1 sky130_fd_sc_hd__fill_2
X_2624_ net199 net188 net201 net187 vssd1 vssd1 vccd1 vccd1 _1213_ sky130_fd_sc_hd__and4_1
XANTENNA__1618__A net148 vssd1 vssd1 vccd1 vccd1 sky130_fd_sc_hd__diode_2
X_2555_ net199 net191 _1107_ _1109_ vssd1 vssd1 vccd1 vccd1 _1146_ sky130_fd_sc_hd__a22o_1
X_2486_ _1076_ _1077_ _1078_ _1040_ vssd1 vssd1 vccd1 vccd1 _1079_ sky130_fd_sc_hd__a22oi_1
XFILLER_28_449 vssd1 vssd1 vccd1 vccd1 sky130_fd_sc_hd__fill_2
X_3107_ net55 net90 net76 vssd1 vssd1 vccd1 vccd1 _0047_ sky130_fd_sc_hd__and3_1
XTAP_TAPCELL_ROW_66_731 vssd1 vccd1 sky130_fd_sc_hd__tapvpwrvgnd_1
XFILLER_70_216 vssd1 vssd1 vccd1 vccd1 sky130_fd_sc_hd__fill_1
X_3038_ _1570_ _1571_ _1572_ _1566_ vssd1 vssd1 vccd1 vccd1 _1574_ sky130_fd_sc_hd__a22o_1
XFILLER_36_493 vssd1 vssd1 vccd1 vccd1 sky130_fd_sc_hd__fill_1
XTAP_TAPCELL_ROW_38_499 vssd1 vccd1 sky130_fd_sc_hd__tapvpwrvgnd_1
XFILLER_23_187 vssd1 vssd1 vccd1 vccd1 sky130_fd_sc_hd__fill_2
XANTENNA__2123__S net15 vssd1 vssd1 vccd1 vccd1 sky130_fd_sc_hd__diode_2
XFILLER_11_65 vssd1 vssd1 vccd1 vccd1 sky130_fd_sc_hd__fill_1
XFILLER_11_54 vssd1 vssd1 vccd1 vccd1 sky130_fd_sc_hd__fill_2
XFILLER_19_449 vssd1 vssd1 vccd1 vccd1 sky130_fd_sc_hd__fill_4
XTAP_TAPCELL_ROW_29_422 vssd1 vccd1 sky130_fd_sc_hd__tapvpwrvgnd_1
XFILLER_61_249 vssd1 vssd1 vccd1 vccd1 sky130_fd_sc_hd__fill_4
XFILLER_52_61 vssd1 vssd1 vccd1 vccd1 sky130_fd_sc_hd__fill_2
XANTENNA__2946__B1 net176 vssd1 vssd1 vccd1 vccd1 sky130_fd_sc_hd__diode_2
XANTENNA__2033__S net25 vssd1 vssd1 vccd1 vccd1 sky130_fd_sc_hd__diode_2
X_2340_ net213 net196 net214 net194 vssd1 vssd1 vccd1 vccd1 _0939_ sky130_fd_sc_hd__and4_1
X_2271_ MATMULT_INST.matmult_inst.alu_inst.adder_inst.r2.fa2.b MATMULT_INST.matmult_inst.alu_inst.adder_inst.r2.fa2.a
+ vssd1 vssd1 vccd1 vccd1 _0897_ sky130_fd_sc_hd__or2_1
XANTENNA__2275__Y _0901_ vssd1 vssd1 vccd1 vccd1 sky130_fd_sc_hd__diode_2
XFILLER_25_419 vssd1 vssd1 vccd1 vccd1 sky130_fd_sc_hd__fill_2
XFILLER_37_279 vssd1 vssd1 vccd1 vccd1 sky130_fd_sc_hd__fill_1
XANTENNA__1620__B net143 vssd1 vssd1 vccd1 vccd1 sky130_fd_sc_hd__diode_2
XFILLER_18_493 vssd1 vssd1 vccd1 vccd1 sky130_fd_sc_hd__fill_1
XTAP_TAPCELL_ROW_35_469 vssd1 vccd1 sky130_fd_sc_hd__tapvpwrvgnd_1
XFILLER_60_271 vssd1 vssd1 vccd1 vccd1 sky130_fd_sc_hd__fill_1
X_1986_ net548 net42 net28 vssd1 vssd1 vccd1 vccd1 _0148_ sky130_fd_sc_hd__mux2_1
Xclkbuf_leaf_9_clk clknet_2_1__leaf_clk vssd1 vssd1 vccd1 vccd1 clknet_leaf_9_clk
+ sky130_fd_sc_hd__clkbuf_8
X_2607_ _1170_ _1171_ _1172_ _1195_ vssd1 vssd1 vccd1 vccd1 _1197_ sky130_fd_sc_hd__a211o_1
X_3587_ net224 _0020_ _0085_ vssd1 vssd1 vccd1 vccd1 MATMULT_INST.matmult_inst.spi_inst.miso_shifter\[7\]
+ sky130_fd_sc_hd__dfrtp_1
X_2538_ _1126_ _1127_ _1129_ vssd1 vssd1 vccd1 vccd1 _1130_ sky130_fd_sc_hd__a21o_1
X_2469_ _1044_ _1045_ _1062_ vssd1 vssd1 vccd1 vccd1 _1063_ sky130_fd_sc_hd__or3_1
XFILLER_28_268 vssd1 vssd1 vccd1 vccd1 sky130_fd_sc_hd__fill_2
XANTENNA__2118__S net14 vssd1 vssd1 vccd1 vccd1 sky130_fd_sc_hd__diode_2
XFILLER_11_113 vssd1 vssd1 vccd1 vccd1 sky130_fd_sc_hd__fill_4
XFILLER_24_485 vssd1 vssd1 vccd1 vccd1 sky130_fd_sc_hd__fill_8
XANTENNA__1957__S net30 vssd1 vssd1 vccd1 vccd1 sky130_fd_sc_hd__diode_2
XFILLER_11_135 vccd1 vssd1 vccd1 vssd1 sky130_ef_sc_hd__decap_40_12
XFILLER_3_345 vssd1 vssd1 vccd1 vccd1 sky130_fd_sc_hd__fill_1
XFILLER_3_389 vssd1 vssd1 vccd1 vccd1 sky130_fd_sc_hd__fill_2
XFILLER_78_157 vssd1 vssd1 vccd1 vccd1 sky130_fd_sc_hd__fill_1
XTAP_TAPCELL_ROW_77_826 vssd1 vccd1 sky130_fd_sc_hd__tapvpwrvgnd_1
Xfanout170 MATMULT_INST.matmult_inst.alu_inst.b1_reg\[7\] vssd1 vssd1 vccd1 vccd1
+ net170 sky130_fd_sc_hd__buf_2
Xfanout192 MATMULT_INST.matmult_inst.alu_inst.a0_reg\[3\] vssd1 vssd1 vccd1 vccd1
+ net192 sky130_fd_sc_hd__clkbuf_2
Xfanout181 MATMULT_INST.matmult_inst.alu_inst.b1_reg\[2\] vssd1 vssd1 vccd1 vccd1
+ net181 sky130_fd_sc_hd__clkbuf_2
XANTENNA__1667__B1 _0591_ vssd1 vssd1 vccd1 vccd1 sky130_fd_sc_hd__diode_2
XANTENNA__1721__A net152 vssd1 vssd1 vccd1 vccd1 sky130_fd_sc_hd__diode_2
XFILLER_74_363 vssd1 vssd1 vccd1 vccd1 sky130_fd_sc_hd__fill_1
XANTENNA__2028__S net25 vssd1 vssd1 vccd1 vccd1 sky130_fd_sc_hd__diode_2
XFILLER_30_400 vssd1 vssd1 vccd1 vccd1 sky130_fd_sc_hd__fill_4
X_1840_ MATMULT_INST.matmult_inst.spi_inst.mosi_shifter\[5\] MATMULT_INST.matmult_inst.spi_inst.mosi_shifter\[4\]
+ _0741_ vssd1 vssd1 vccd1 vccd1 _0462_ sky130_fd_sc_hd__mux2_1
XFILLER_8_66 vssd1 vssd1 vccd1 vccd1 sky130_fd_sc_hd__fill_1
XFILLER_30_477 vccd1 vssd1 vccd1 vssd1 sky130_ef_sc_hd__decap_40_12
XFILLER_8_99 vccd1 vssd1 vccd1 vssd1 sky130_ef_sc_hd__decap_40_12
X_3510_ clknet_leaf_27_clk _0427_ vssd1 vssd1 vccd1 vccd1 MATMULT_INST.matmult_inst.alu_inst.adder_inst.r0.fa1.b
+ sky130_fd_sc_hd__dfxtp_1
X_1771_ net146 net138 MATMULT_INST.matmult_inst.mem_inst.mem3\[4\] vssd1 vssd1 vccd1
+ vccd1 _0688_ sky130_fd_sc_hd__and3_1
XFILLER_10_190 vssd1 vssd1 vccd1 vccd1 sky130_fd_sc_hd__fill_4
XANTENNA__2147__A1 _0813_ vssd1 vssd1 vccd1 vccd1 sky130_fd_sc_hd__diode_2
X_3441_ clknet_leaf_32_clk _0363_ vssd1 vssd1 vccd1 vccd1 MATMULT_INST.matmult_inst.alu_inst.b1_reg\[4\]
+ sky130_fd_sc_hd__dfxtp_1
XANTENNA__2698__S _1256_ vssd1 vssd1 vccd1 vccd1 sky130_fd_sc_hd__diode_2
XFILLER_40_3 vssd1 vssd1 vccd1 vccd1 sky130_fd_sc_hd__fill_4
X_3372_ clknet_leaf_18_clk _0294_ vssd1 vssd1 vccd1 vccd1 MATMULT_INST.matmult_inst.mem_inst.mem1\[9\]
+ sky130_fd_sc_hd__dfxtp_1
XFILLER_69_113 vssd1 vssd1 vccd1 vccd1 sky130_fd_sc_hd__fill_1
X_2323_ net168 net569 net67 vssd1 vssd1 vccd1 vccd1 _0367_ sky130_fd_sc_hd__mux2_1
X_2254_ _0880_ _0882_ vssd1 vssd1 vccd1 vccd1 _0883_ sky130_fd_sc_hd__nand2_1
X_2185_ _1594_ _0839_ vssd1 vssd1 vccd1 vccd1 _0840_ sky130_fd_sc_hd__nor2_1
XANTENNA__1631__A net219 vssd1 vssd1 vccd1 vccd1 sky130_fd_sc_hd__diode_2
XTAP_TAPCELL_ROW_48_583 vssd1 vccd1 sky130_fd_sc_hd__tapvpwrvgnd_1
XFILLER_40_208 vssd1 vssd1 vccd1 vccd1 sky130_fd_sc_hd__fill_1
XFILLER_21_422 vssd1 vssd1 vccd1 vccd1 sky130_fd_sc_hd__fill_4
X_1969_ net535 _0810_ net30 vssd1 vssd1 vccd1 vccd1 _0136_ sky130_fd_sc_hd__mux2_1
XFILLER_4_109 vssd1 vssd1 vccd1 vccd1 sky130_fd_sc_hd__fill_2
X_3639_ clknet_leaf_26_clk net308 vssd1 vssd1 vccd1 vccd1 MATMULT_INST.matmult_inst.fsm_inst.alu_result\[15\]
+ sky130_fd_sc_hd__dfxtp_1
XFILLER_0_304 vssd1 vssd1 vccd1 vccd1 sky130_fd_sc_hd__fill_4
XFILLER_0_337 vssd1 vssd1 vccd1 vccd1 sky130_fd_sc_hd__fill_2
XANTENNA__2689__A2 _1247_ vssd1 vssd1 vccd1 vccd1 sky130_fd_sc_hd__diode_2
XFILLER_56_352 vssd1 vssd1 vccd1 vccd1 sky130_fd_sc_hd__fill_2
XTAP_TAPCELL_ROW_3_197 vssd1 vccd1 sky130_fd_sc_hd__tapvpwrvgnd_1
XFILLER_17_64 vssd1 vssd1 vccd1 vccd1 sky130_fd_sc_hd__fill_1
XFILLER_24_271 vssd1 vssd1 vccd1 vccd1 sky130_fd_sc_hd__fill_1
XFILLER_12_477 vccd1 vssd1 vccd1 vssd1 sky130_ef_sc_hd__decap_40_12
XFILLER_33_85 vssd1 vssd1 vccd1 vccd1 sky130_fd_sc_hd__fill_1
XFILLER_3_131 vccd1 vssd1 vccd1 vssd1 sky130_ef_sc_hd__decap_40_12
XFILLER_3_153 vssd1 vssd1 vccd1 vccd1 sky130_fd_sc_hd__fill_2
XFILLER_79_433 vccd1 vssd1 vccd1 vssd1 sky130_ef_sc_hd__decap_40_12
XFILLER_79_477 vssd1 vssd1 vccd1 vccd1 sky130_fd_sc_hd__fill_2
Xhold4 MATMULT_INST.matmult_inst.fsm_inst.tx_ready_delay vssd1 vssd1 vccd1 vccd1 net299
+ sky130_fd_sc_hd__dlygate4sd3_1
XFILLER_47_352 vssd1 vssd1 vccd1 vccd1 sky130_fd_sc_hd__fill_2
XTAP_TAPCELL_ROW_45_553 vssd1 vccd1 sky130_fd_sc_hd__tapvpwrvgnd_1
X_2941_ net170 net162 _1480_ vssd1 vssd1 vccd1 vccd1 _1481_ sky130_fd_sc_hd__and3_1
X_2872_ _1411_ _1412_ _1372_ vssd1 vssd1 vccd1 vccd1 _1414_ sky130_fd_sc_hd__a21bo_1
X_1823_ MATMULT_INST.matmult_inst.fsm_inst.rx_data\[3\] net552 MATMULT_INST.matmult_inst.spi_inst.rx_done_sys
+ vssd1 vssd1 vccd1 vccd1 _0485_ sky130_fd_sc_hd__mux2_1
X_1754_ net147 net139 MATMULT_INST.matmult_inst.mem_inst.matrixA3\[5\] vssd1 vssd1
+ vccd1 vccd1 _0672_ sky130_fd_sc_hd__and3_1
X_1685_ net221 _0604_ _0609_ vssd1 vssd1 vccd1 vccd1 _0610_ sky130_fd_sc_hd__a21o_1
X_3424_ clknet_leaf_28_clk _0346_ vssd1 vssd1 vccd1 vccd1 MATMULT_INST.matmult_inst.alu_inst.out\[5\]
+ sky130_fd_sc_hd__dfxtp_1
XANTENNA__1626__A net148 vssd1 vssd1 vccd1 vccd1 sky130_fd_sc_hd__diode_2
X_3355_ clknet_leaf_15_clk _0277_ vssd1 vssd1 vccd1 vccd1 MATMULT_INST.matmult_inst.mem_inst.mem2\[10\]
+ sky130_fd_sc_hd__dfxtp_1
X_3286_ clknet_leaf_9_clk _0208_ vssd1 vssd1 vccd1 vccd1 MATMULT_INST.matmult_inst.mem_inst.matrixA2\[13\]
+ sky130_fd_sc_hd__dfxtp_1
XFILLER_38_19 vssd1 vssd1 vccd1 vccd1 sky130_fd_sc_hd__fill_1
X_2306_ net572 _0926_ net99 vssd1 vssd1 vccd1 vccd1 _0356_ sky130_fd_sc_hd__mux2_1
X_2237_ MATMULT_INST.matmult_inst.alu_inst.adder_inst.r1.fa1.b MATMULT_INST.matmult_inst.alu_inst.adder_inst.r1.fa1.a
+ vssd1 vssd1 vccd1 vccd1 _0868_ sky130_fd_sc_hd__nand2_1
XFILLER_38_363 vssd1 vssd1 vccd1 vccd1 sky130_fd_sc_hd__fill_1
XANTENNA__3052__S net8 vssd1 vssd1 vccd1 vccd1 sky130_fd_sc_hd__diode_2
X_2168_ MATMULT_INST.matmult_inst.spi_inst.current_state net93 net82 _1592_ vssd1
+ vssd1 vccd1 vccd1 _0825_ sky130_fd_sc_hd__a22o_1
XTAP_TAPCELL_ROW_0_167 vssd1 vccd1 sky130_fd_sc_hd__tapvpwrvgnd_1
X_2099_ net367 net43 net16 vssd1 vssd1 vccd1 vccd1 _0255_ sky130_fd_sc_hd__mux2_1
XFILLER_13_208 vssd1 vssd1 vccd1 vccd1 sky130_fd_sc_hd__fill_2
XFILLER_70_39 vccd1 vssd1 vccd1 vssd1 sky130_ef_sc_hd__decap_40_12
XFILLER_21_263 vssd1 vssd1 vccd1 vccd1 sky130_fd_sc_hd__fill_1
XPHY_EDGE_ROW_17_Right_17 vssd1 vssd1 vccd1 vccd1 sky130_fd_sc_hd__decap_3
XANTENNA__2359__B2 net114 vssd1 vssd1 vccd1 vccd1 sky130_fd_sc_hd__diode_2
XFILLER_79_37 vccd1 vssd1 vccd1 vssd1 sky130_ef_sc_hd__decap_40_12
XANTENNA__2131__S net12 vssd1 vssd1 vccd1 vccd1 sky130_fd_sc_hd__diode_2
XANTENNA_fanout95_A net96 vssd1 vssd1 vccd1 vccd1 sky130_fd_sc_hd__diode_2
XFILLER_0_167 vssd1 vssd1 vccd1 vccd1 sky130_fd_sc_hd__fill_1
XPHY_EDGE_ROW_26_Right_26 vssd1 vssd1 vccd1 vccd1 sky130_fd_sc_hd__decap_3
Xteam_02_231 vssd1 vssd1 vccd1 vccd1 team_02_231/HI gpio_oeb[2] sky130_fd_sc_hd__conb_1
Xteam_02_253 vssd1 vssd1 vccd1 vccd1 team_02_253/HI gpio_oeb[26] sky130_fd_sc_hd__conb_1
Xteam_02_242 vssd1 vssd1 vccd1 vccd1 team_02_242/HI gpio_oeb[15] sky130_fd_sc_hd__conb_1
XFILLER_48_138 vssd1 vssd1 vccd1 vccd1 sky130_fd_sc_hd__fill_2
Xteam_02_275 vssd1 vssd1 vccd1 vccd1 team_02_275/HI gpio_out[16] sky130_fd_sc_hd__conb_1
Xteam_02_264 vssd1 vssd1 vccd1 vccd1 team_02_264/HI gpio_out[5] sky130_fd_sc_hd__conb_1
Xteam_02_286 vssd1 vssd1 vccd1 vccd1 team_02_286/HI gpio_out[27] sky130_fd_sc_hd__conb_1
XFILLER_29_341 vssd1 vssd1 vccd1 vccd1 sky130_fd_sc_hd__fill_1
XFILLER_28_85 vssd1 vssd1 vccd1 vccd1 sky130_fd_sc_hd__fill_4
XFILLER_44_355 vssd1 vssd1 vccd1 vccd1 sky130_fd_sc_hd__fill_2
XFILLER_71_152 vssd1 vssd1 vccd1 vccd1 sky130_fd_sc_hd__fill_8
XFILLER_44_388 vssd1 vssd1 vccd1 vccd1 sky130_fd_sc_hd__fill_2
XPHY_EDGE_ROW_35_Right_35 vssd1 vssd1 vccd1 vccd1 sky130_fd_sc_hd__decap_3
XFILLER_60_72 vssd1 vssd1 vccd1 vccd1 sky130_fd_sc_hd__fill_1
XFILLER_5_45 vssd1 vssd1 vccd1 vccd1 sky130_fd_sc_hd__fill_8
XANTENNA__2041__S net22 vssd1 vssd1 vccd1 vccd1 sky130_fd_sc_hd__diode_2
XFILLER_4_473 vssd1 vssd1 vccd1 vccd1 sky130_fd_sc_hd__fill_2
XPHY_EDGE_ROW_44_Right_44 vssd1 vssd1 vccd1 vccd1 sky130_fd_sc_hd__decap_3
X_3140_ net227 vssd1 vssd1 vccd1 vccd1 _0064_ sky130_fd_sc_hd__inv_2
XFILLER_67_458 vssd1 vssd1 vccd1 vccd1 sky130_fd_sc_hd__fill_4
XANTENNA__1730__C1 _0545_ vssd1 vssd1 vccd1 vccd1 sky130_fd_sc_hd__diode_2
X_3071_ net567 net52 net7 MATMULT_INST.matmult_inst.fsm_inst.alu_result\[7\] vssd1
+ vssd1 vccd1 vccd1 _0515_ sky130_fd_sc_hd__a22o_1
X_2022_ net321 net44 net24 vssd1 vssd1 vccd1 vccd1 _0182_ sky130_fd_sc_hd__mux2_1
XFILLER_47_171 vssd1 vssd1 vccd1 vccd1 sky130_fd_sc_hd__fill_1
XFILLER_35_388 vssd1 vssd1 vccd1 vccd1 sky130_fd_sc_hd__fill_4
XFILLER_50_325 vssd1 vssd1 vccd1 vccd1 sky130_fd_sc_hd__fill_2
XPHY_EDGE_ROW_53_Right_53 vssd1 vssd1 vccd1 vccd1 sky130_fd_sc_hd__decap_3
X_2924_ _1464_ vssd1 vssd1 vccd1 vccd1 _1465_ sky130_fd_sc_hd__inv_2
X_2855_ _1392_ _1395_ vssd1 vssd1 vccd1 vccd1 _1398_ sky130_fd_sc_hd__xor2_1
XTAP_TAPCELL_ROW_13_280 vssd1 vccd1 sky130_fd_sc_hd__tapvpwrvgnd_1
X_1806_ MATMULT_INST.matmult_inst.mem_inst.mem0\[1\] net108 net104 MATMULT_INST.matmult_inst.mem_inst.matrixB0\[1\]
+ _0719_ vssd1 vssd1 vccd1 vccd1 _0720_ sky130_fd_sc_hd__a221o_1
X_2786_ _1314_ _1329_ vssd1 vssd1 vccd1 vccd1 _1331_ sky130_fd_sc_hd__nand2_1
Xhold201 MATMULT_INST.matmult_inst.alu_inst.col0\[3\] vssd1 vssd1 vccd1 vccd1 net496
+ sky130_fd_sc_hd__dlygate4sd3_1
Xhold223 MATMULT_INST.matmult_inst.mem_inst.matrixB0\[8\] vssd1 vssd1 vccd1 vccd1
+ net518 sky130_fd_sc_hd__dlygate4sd3_1
Xhold234 MATMULT_INST.matmult_inst.mem_inst.matrixA2\[8\] vssd1 vssd1 vccd1 vccd1
+ net529 sky130_fd_sc_hd__dlygate4sd3_1
XANTENNA__3047__S net8 vssd1 vssd1 vccd1 vccd1 sky130_fd_sc_hd__diode_2
X_1737_ net150 net141 MATMULT_INST.matmult_inst.mem_inst.matrixA3\[7\] vssd1 vssd1
+ vccd1 vccd1 _0657_ sky130_fd_sc_hd__and3_1
Xhold212 MATMULT_INST.matmult_inst.mem_inst.matrixA2\[7\] vssd1 vssd1 vccd1 vccd1
+ net507 sky130_fd_sc_hd__dlygate4sd3_1
X_1668_ net150 net141 MATMULT_INST.matmult_inst.mem_inst.matrixB3\[13\] vssd1 vssd1
+ vccd1 vccd1 _0594_ sky130_fd_sc_hd__and3_1
Xhold245 MATMULT_INST.matmult_inst.mem_inst.matrixB0\[10\] vssd1 vssd1 vccd1 vccd1
+ net540 sky130_fd_sc_hd__dlygate4sd3_1
XPHY_EDGE_ROW_62_Right_62 vssd1 vssd1 vccd1 vccd1 sky130_fd_sc_hd__decap_3
Xhold256 MATMULT_INST.matmult_inst.alu_inst.row0\[4\] vssd1 vssd1 vccd1 vccd1 net551
+ sky130_fd_sc_hd__dlygate4sd3_1
Xhold267 MATMULT_INST.matmult_inst.mem_inst.mem0\[0\] vssd1 vssd1 vccd1 vccd1 net562
+ sky130_fd_sc_hd__dlygate4sd3_1
Xhold278 MATMULT_INST.matmult_inst.spi_inst.mosi_data_sync\[2\] vssd1 vssd1 vccd1
+ vccd1 net573 sky130_fd_sc_hd__dlygate4sd3_1
X_3407_ clknet_leaf_0_clk _0329_ vssd1 vssd1 vccd1 vccd1 MATMULT_INST.matmult_inst.alu_inst.b0_reg\[4\]
+ sky130_fd_sc_hd__dfxtp_1
Xhold289 MATMULT_INST.matmult_inst.mem_inst.matrixB0\[3\] vssd1 vssd1 vccd1 vccd1
+ net584 sky130_fd_sc_hd__dlygate4sd3_1
X_1599_ net2 vssd1 vssd1 vccd1 vccd1 MATMULT_INST.matmult_inst.cs sky130_fd_sc_hd__inv_2
X_3338_ clknet_leaf_14_clk _0260_ vssd1 vssd1 vccd1 vccd1 MATMULT_INST.matmult_inst.mem_inst.mem3\[11\]
+ sky130_fd_sc_hd__dfxtp_1
XTAP_TAPCELL_ROW_5_215 vssd1 vccd1 sky130_fd_sc_hd__tapvpwrvgnd_1
XFILLER_58_414 vssd1 vssd1 vccd1 vccd1 sky130_fd_sc_hd__fill_2
X_3269_ clknet_leaf_10_clk _0191_ vssd1 vssd1 vccd1 vccd1 MATMULT_INST.matmult_inst.mem_inst.matrixA3\[14\]
+ sky130_fd_sc_hd__dfxtp_1
XFILLER_26_300 vssd1 vssd1 vccd1 vccd1 sky130_fd_sc_hd__fill_8
XFILLER_26_344 vccd1 vssd1 vccd1 vssd1 sky130_ef_sc_hd__decap_40_12
XTAP_TAPCELL_ROW_56_648 vssd1 vccd1 sky130_fd_sc_hd__tapvpwrvgnd_1
XPHY_EDGE_ROW_71_Right_71 vssd1 vssd1 vccd1 vccd1 sky130_fd_sc_hd__decap_3
XFILLER_53_185 vssd1 vssd1 vccd1 vccd1 sky130_fd_sc_hd__fill_1
XANTENNA__2126__S net14 vssd1 vssd1 vccd1 vccd1 sky130_fd_sc_hd__diode_2
XANTENNA__1965__S net31 vssd1 vssd1 vccd1 vccd1 sky130_fd_sc_hd__diode_2
XFILLER_14_98 vssd1 vssd1 vccd1 vccd1 sky130_fd_sc_hd__fill_1
XANTENNA_clkbuf_leaf_10_clk_A clknet_2_1__leaf_clk vssd1 vssd1 vccd1 vccd1 sky130_fd_sc_hd__diode_2
XFILLER_5_237 vssd1 vssd1 vccd1 vccd1 sky130_fd_sc_hd__fill_1
XFILLER_5_259 vssd1 vssd1 vccd1 vccd1 sky130_fd_sc_hd__fill_4
XANTENNA__3184__C net74 vssd1 vssd1 vccd1 vccd1 sky130_fd_sc_hd__diode_2
XANTENNA_fanout98_X net98 vssd1 vssd1 vccd1 vccd1 sky130_fd_sc_hd__diode_2
XANTENNA_clkbuf_leaf_25_clk_A clknet_2_3__leaf_clk vssd1 vssd1 vccd1 vccd1 sky130_fd_sc_hd__diode_2
XFILLER_1_487 vssd1 vssd1 vccd1 vccd1 sky130_fd_sc_hd__fill_1
XFILLER_49_447 vssd1 vssd1 vccd1 vccd1 sky130_fd_sc_hd__fill_1
XANTENNA__1713__B net143 vssd1 vssd1 vccd1 vccd1 sky130_fd_sc_hd__diode_2
XFILLER_29_160 vssd1 vssd1 vccd1 vccd1 sky130_fd_sc_hd__fill_1
XFILLER_17_333 vssd1 vssd1 vccd1 vccd1 sky130_fd_sc_hd__fill_2
XFILLER_57_491 vssd1 vssd1 vccd1 vccd1 sky130_fd_sc_hd__fill_2
XANTENNA__2036__S net22 vssd1 vssd1 vccd1 vccd1 sky130_fd_sc_hd__diode_2
XFILLER_72_6 vssd1 vssd1 vccd1 vccd1 sky130_fd_sc_hd__fill_8
X_2640_ _1204_ _1227_ vssd1 vssd1 vccd1 vccd1 _1228_ sky130_fd_sc_hd__xnor2_1
XANTENNA__1794__A2 net112 vssd1 vssd1 vccd1 vccd1 sky130_fd_sc_hd__diode_2
XTAP_TAPCELL_ROW_10_261 vssd1 vccd1 sky130_fd_sc_hd__tapvpwrvgnd_1
X_2571_ _1152_ _1161_ vssd1 vssd1 vccd1 vccd1 _1162_ sky130_fd_sc_hd__xnor2_1
X_3123_ net61 net91 net79 vssd1 vssd1 vccd1 vccd1 _0032_ sky130_fd_sc_hd__and3_1
XFILLER_27_119 vssd1 vssd1 vccd1 vccd1 sky130_fd_sc_hd__fill_4
X_3054_ net413 net40 net8 vssd1 vssd1 vccd1 vccd1 _0473_ sky130_fd_sc_hd__mux2_1
XFILLER_55_439 vssd1 vssd1 vccd1 vccd1 sky130_fd_sc_hd__fill_1
X_2005_ net42 net593 net26 vssd1 vssd1 vccd1 vccd1 _0166_ sky130_fd_sc_hd__mux2_1
XFILLER_63_461 vssd1 vssd1 vccd1 vccd1 sky130_fd_sc_hd__fill_4
XFILLER_23_358 vssd1 vssd1 vccd1 vccd1 sky130_fd_sc_hd__fill_1
X_2907_ net166 net171 _1447_ vssd1 vssd1 vccd1 vccd1 _1448_ sky130_fd_sc_hd__and3_1
X_2838_ _1377_ _1378_ _1380_ vssd1 vssd1 vccd1 vccd1 _1381_ sky130_fd_sc_hd__a21oi_1
X_2769_ _1298_ _1305_ vssd1 vssd1 vccd1 vccd1 _1314_ sky130_fd_sc_hd__or2_1
XFILLER_2_218 vssd1 vssd1 vccd1 vccd1 sky130_fd_sc_hd__fill_1
XFILLER_76_27 vssd1 vssd1 vccd1 vccd1 sky130_fd_sc_hd__fill_1
XANTENNA__2498__B1 net210 vssd1 vssd1 vccd1 vccd1 sky130_fd_sc_hd__diode_2
XTAP_TAPCELL_ROW_69_762 vssd1 vccd1 sky130_fd_sc_hd__tapvpwrvgnd_1
XFILLER_46_417 vssd1 vssd1 vccd1 vccd1 sky130_fd_sc_hd__fill_2
XANTENNA_fanout58_A net62 vssd1 vssd1 vccd1 vccd1 sky130_fd_sc_hd__diode_2
XTAP_TAPCELL_ROW_16_309 vssd1 vccd1 sky130_fd_sc_hd__tapvpwrvgnd_1
XFILLER_26_141 vssd1 vssd1 vccd1 vccd1 sky130_fd_sc_hd__fill_8
XANTENNA__3179__C net73 vssd1 vssd1 vccd1 vccd1 sky130_fd_sc_hd__diode_2
XTAP_TAPCELL_ROW_24_375 vssd1 vccd1 sky130_fd_sc_hd__tapvpwrvgnd_1
XANTENNA_fanout13_X net13 vssd1 vssd1 vccd1 vccd1 sky130_fd_sc_hd__diode_2
XANTENNA__1776__A2 net108 vssd1 vssd1 vccd1 vccd1 sky130_fd_sc_hd__diode_2
XFILLER_64_225 vssd1 vssd1 vccd1 vccd1 sky130_fd_sc_hd__fill_2
XFILLER_17_152 vssd1 vssd1 vccd1 vccd1 sky130_fd_sc_hd__fill_1
XFILLER_72_291 vssd1 vssd1 vccd1 vccd1 sky130_fd_sc_hd__fill_1
XFILLER_20_306 vssd1 vssd1 vccd1 vccd1 sky130_fd_sc_hd__fill_2
XFILLER_32_199 vssd1 vssd1 vccd1 vccd1 sky130_fd_sc_hd__fill_1
XANTENNA__1767__A2 net112 vssd1 vssd1 vccd1 vccd1 sky130_fd_sc_hd__diode_2
X_2623_ _1211_ vssd1 vssd1 vccd1 vccd1 _1212_ sky130_fd_sc_hd__inv_2
XANTENNA__1618__B net140 vssd1 vssd1 vccd1 vccd1 sky130_fd_sc_hd__diode_2
X_2554_ net668 _1145_ net95 vssd1 vssd1 vccd1 vccd1 _0384_ sky130_fd_sc_hd__mux2_1
X_2485_ _1018_ _1041_ vssd1 vssd1 vccd1 vccd1 _1078_ sky130_fd_sc_hd__nand2b_1
X_3106_ net55 net90 net77 vssd1 vssd1 vccd1 vccd1 _0050_ sky130_fd_sc_hd__and3_1
XTAP_TAPCELL_ROW_66_732 vssd1 vccd1 sky130_fd_sc_hd__tapvpwrvgnd_1
XFILLER_55_247 vssd1 vssd1 vccd1 vccd1 sky130_fd_sc_hd__fill_2
XANTENNA__3060__S net9 vssd1 vssd1 vccd1 vccd1 sky130_fd_sc_hd__diode_2
X_3037_ _1566_ _1570_ _1571_ _1572_ vssd1 vssd1 vccd1 vccd1 _1573_ sky130_fd_sc_hd__nand4_1
XFILLER_23_111 vssd1 vssd1 vccd1 vccd1 sky130_fd_sc_hd__fill_1
XFILLER_11_339 vssd1 vssd1 vccd1 vccd1 sky130_fd_sc_hd__fill_1
XANTENNA_fanout148_X net148 vssd1 vssd1 vccd1 vccd1 sky130_fd_sc_hd__diode_2
XANTENNA__2404__B1 net114 vssd1 vssd1 vccd1 vccd1 sky130_fd_sc_hd__diode_2
XFILLER_11_88 vssd1 vssd1 vccd1 vccd1 sky130_fd_sc_hd__fill_2
XFILLER_2_6 vccd1 vssd1 vccd1 vssd1 sky130_ef_sc_hd__decap_40_12
XPHY_EDGE_ROW_21_Left_101 vssd1 vssd1 vccd1 vccd1 sky130_fd_sc_hd__decap_3
XFILLER_19_439 vssd1 vssd1 vccd1 vccd1 sky130_fd_sc_hd__fill_8
XANTENNA__1831__X _0735_ vssd1 vssd1 vccd1 vccd1 sky130_fd_sc_hd__diode_2
XFILLER_34_409 vssd1 vssd1 vccd1 vccd1 sky130_fd_sc_hd__fill_1
XFILLER_42_453 vssd1 vssd1 vccd1 vccd1 sky130_fd_sc_hd__fill_4
XPHY_EDGE_ROW_30_Left_110 vssd1 vssd1 vccd1 vccd1 sky130_fd_sc_hd__decap_3
XANTENNA__1749__A2 net112 vssd1 vssd1 vccd1 vccd1 sky130_fd_sc_hd__diode_2
XFILLER_6_365 vccd1 vssd1 vccd1 vssd1 sky130_ef_sc_hd__decap_40_12
XFILLER_42_7 vssd1 vssd1 vccd1 vccd1 sky130_fd_sc_hd__fill_4
X_2270_ net463 _0896_ net99 vssd1 vssd1 vccd1 vccd1 _0350_ sky130_fd_sc_hd__mux2_1
XANTENNA__1741__X _0661_ vssd1 vssd1 vccd1 vccd1 sky130_fd_sc_hd__diode_2
XANTENNA__1685__A1 net221 vssd1 vssd1 vccd1 vccd1 sky130_fd_sc_hd__diode_2
XFILLER_37_225 vssd1 vssd1 vccd1 vccd1 sky130_fd_sc_hd__fill_2
XFILLER_33_431 vccd1 vssd1 vccd1 vssd1 sky130_ef_sc_hd__decap_40_12
XFILLER_60_250 vssd1 vssd1 vccd1 vccd1 sky130_fd_sc_hd__fill_2
X_1985_ net476 net43 net28 vssd1 vssd1 vccd1 vccd1 _0147_ sky130_fd_sc_hd__mux2_1
X_2606_ _1166_ _1193_ _1192_ vssd1 vssd1 vccd1 vccd1 _1196_ sky130_fd_sc_hd__a21o_1
XANTENNA_fanout108_A net111 vssd1 vssd1 vccd1 vccd1 sky130_fd_sc_hd__diode_2
X_3586_ net224 _0019_ _0084_ vssd1 vssd1 vccd1 vccd1 MATMULT_INST.matmult_inst.spi_inst.miso_shifter\[6\]
+ sky130_fd_sc_hd__dfrtp_1
XANTENNA__3055__S net9 vssd1 vssd1 vccd1 vccd1 sky130_fd_sc_hd__diode_2
X_2537_ net195 net200 _1128_ vssd1 vssd1 vccd1 vccd1 _1129_ sky130_fd_sc_hd__and3_1
X_2468_ _1054_ _1061_ vssd1 vssd1 vccd1 vccd1 _1062_ sky130_fd_sc_hd__xnor2_1
X_2399_ _0979_ _0994_ vssd1 vssd1 vccd1 vccd1 _0995_ sky130_fd_sc_hd__and2_1
XANTENNA__1676__B2 net218 vssd1 vssd1 vccd1 vccd1 sky130_fd_sc_hd__diode_2
XANTENNA__1676__A1 net220 vssd1 vssd1 vccd1 vccd1 sky130_fd_sc_hd__diode_2
XFILLER_28_225 vssd1 vssd1 vccd1 vccd1 sky130_fd_sc_hd__fill_1
XFILLER_73_17 vssd1 vssd1 vccd1 vccd1 sky130_fd_sc_hd__fill_1
XFILLER_36_280 vccd1 vssd1 vccd1 vssd1 sky130_ef_sc_hd__decap_40_12
XFILLER_24_475 vssd1 vssd1 vccd1 vccd1 sky130_fd_sc_hd__fill_1
XFILLER_11_147 vccd1 vssd1 vccd1 vssd1 sky130_ef_sc_hd__decap_40_12
XFILLER_11_169 vssd1 vssd1 vccd1 vccd1 sky130_fd_sc_hd__fill_4
XANTENNA__2134__S net13 vssd1 vssd1 vccd1 vccd1 sky130_fd_sc_hd__diode_2
XANTENNA__1973__S net31 vssd1 vssd1 vccd1 vccd1 sky130_fd_sc_hd__diode_2
XFILLER_78_103 vssd1 vssd1 vccd1 vccd1 sky130_fd_sc_hd__fill_2
XTAP_TAPCELL_ROW_77_827 vssd1 vccd1 sky130_fd_sc_hd__tapvpwrvgnd_1
Xfanout171 MATMULT_INST.matmult_inst.alu_inst.b1_reg\[7\] vssd1 vssd1 vccd1 vccd1
+ net171 sky130_fd_sc_hd__clkbuf_2
Xfanout160 MATMULT_INST.matmult_inst.alu_inst.a1_reg\[4\] vssd1 vssd1 vccd1 vccd1
+ net160 sky130_fd_sc_hd__buf_2
Xfanout182 MATMULT_INST.matmult_inst.alu_inst.b1_reg\[1\] vssd1 vssd1 vccd1 vccd1
+ net182 sky130_fd_sc_hd__buf_2
Xfanout193 MATMULT_INST.matmult_inst.alu_inst.a0_reg\[2\] vssd1 vssd1 vccd1 vccd1
+ net193 sky130_fd_sc_hd__buf_2
XFILLER_19_225 vssd1 vssd1 vccd1 vccd1 sky130_fd_sc_hd__fill_2
XFILLER_47_73 vssd1 vssd1 vccd1 vccd1 sky130_fd_sc_hd__fill_2
XANTENNA__1721__B net143 vssd1 vssd1 vccd1 vccd1 sky130_fd_sc_hd__diode_2
XFILLER_42_294 vssd1 vssd1 vccd1 vccd1 sky130_fd_sc_hd__fill_1
XANTENNA__2044__S net22 vssd1 vssd1 vccd1 vccd1 sky130_fd_sc_hd__diode_2
XFILLER_30_489 vssd1 vssd1 vccd1 vccd1 sky130_fd_sc_hd__fill_4
X_1770_ MATMULT_INST.matmult_inst.mem_inst.matrixB1\[4\] net125 net117 MATMULT_INST.matmult_inst.mem_inst.matrixB2\[4\]
+ _0686_ vssd1 vssd1 vccd1 vccd1 _0687_ sky130_fd_sc_hd__a221o_1
XFILLER_6_195 vssd1 vssd1 vccd1 vccd1 sky130_fd_sc_hd__fill_1
X_3440_ clknet_leaf_33_clk _0362_ vssd1 vssd1 vccd1 vccd1 MATMULT_INST.matmult_inst.alu_inst.b1_reg\[3\]
+ sky130_fd_sc_hd__dfxtp_1
X_3371_ clknet_leaf_19_clk _0293_ vssd1 vssd1 vccd1 vccd1 MATMULT_INST.matmult_inst.mem_inst.mem1\[8\]
+ sky130_fd_sc_hd__dfxtp_1
X_2322_ net170 net614 net67 vssd1 vssd1 vccd1 vccd1 _0366_ sky130_fd_sc_hd__mux2_1
XFILLER_33_3 vccd1 vssd1 vccd1 vssd1 sky130_ef_sc_hd__decap_40_12
X_2253_ MATMULT_INST.matmult_inst.alu_inst.adder_inst.r1.fa3.b MATMULT_INST.matmult_inst.alu_inst.adder_inst.r1.fa3.a
+ vssd1 vssd1 vccd1 vccd1 _0882_ sky130_fd_sc_hd__nand2_1
X_2184_ _0731_ _0832_ vssd1 vssd1 vccd1 vccd1 _0839_ sky130_fd_sc_hd__or2_1
XTAP_TAPCELL_ROW_48_584 vssd1 vccd1 sky130_fd_sc_hd__tapvpwrvgnd_1
XFILLER_33_250 vssd1 vssd1 vccd1 vccd1 sky130_fd_sc_hd__fill_1
XFILLER_33_294 vssd1 vssd1 vccd1 vccd1 sky130_fd_sc_hd__fill_1
X_1968_ MATMULT_INST.matmult_inst.fsm_inst.alu_result\[13\] net69 vssd1 vssd1 vccd1
+ vccd1 _0810_ sky130_fd_sc_hd__and2_1
X_1899_ _0537_ _0748_ vssd1 vssd1 vccd1 vccd1 _0777_ sky130_fd_sc_hd__or2_1
X_3638_ clknet_leaf_26_clk net313 vssd1 vssd1 vccd1 vccd1 MATMULT_INST.matmult_inst.fsm_inst.alu_result\[14\]
+ sky130_fd_sc_hd__dfxtp_1
X_3569_ clknet_leaf_13_clk _0481_ vssd1 vssd1 vccd1 vccd1 MATMULT_INST.matmult_inst.mem_inst.matrixB3\[17\]
+ sky130_fd_sc_hd__dfxtp_1
XANTENNA__2129__S net15 vssd1 vssd1 vccd1 vccd1 sky130_fd_sc_hd__diode_2
XANTENNA__2310__A2 _0928_ vssd1 vssd1 vccd1 vccd1 sky130_fd_sc_hd__diode_2
XFILLER_71_323 vssd1 vssd1 vccd1 vccd1 sky130_fd_sc_hd__fill_1
XTAP_TAPCELL_ROW_3_198 vssd1 vccd1 sky130_fd_sc_hd__tapvpwrvgnd_1
XFILLER_17_43 vssd1 vssd1 vccd1 vccd1 sky130_fd_sc_hd__fill_2
XPHY_EDGE_ROW_9_Left_89 vssd1 vssd1 vccd1 vccd1 sky130_fd_sc_hd__decap_3
XANTENNA__3187__C net74 vssd1 vssd1 vccd1 vccd1 sky130_fd_sc_hd__diode_2
XFILLER_12_489 vssd1 vssd1 vccd1 vccd1 sky130_fd_sc_hd__fill_2
XFILLER_3_165 vssd1 vssd1 vccd1 vccd1 sky130_fd_sc_hd__fill_2
XFILLER_79_445 vssd1 vssd1 vccd1 vccd1 sky130_fd_sc_hd__fill_2
XFILLER_79_489 vssd1 vssd1 vccd1 vccd1 sky130_fd_sc_hd__fill_2
XFILLER_66_106 vccd1 vssd1 vccd1 vssd1 sky130_ef_sc_hd__decap_40_12
XANTENNA__1732__A net150 vssd1 vssd1 vccd1 vccd1 sky130_fd_sc_hd__diode_2
XFILLER_58_61 vssd1 vssd1 vccd1 vccd1 sky130_fd_sc_hd__fill_2
Xhold5 _0005_ vssd1 vssd1 vccd1 vccd1 net300 sky130_fd_sc_hd__dlygate4sd3_1
XANTENNA__2039__S net22 vssd1 vssd1 vccd1 vccd1 sky130_fd_sc_hd__diode_2
XFILLER_74_60 vssd1 vssd1 vccd1 vccd1 sky130_fd_sc_hd__fill_8
XFILLER_47_386 vssd1 vssd1 vccd1 vccd1 sky130_fd_sc_hd__fill_1
XFILLER_74_194 vssd1 vssd1 vccd1 vccd1 sky130_fd_sc_hd__fill_2
XTAP_TAPCELL_ROW_45_554 vssd1 vccd1 sky130_fd_sc_hd__tapvpwrvgnd_1
XANTENNA__2065__A1 net39 vssd1 vssd1 vccd1 vccd1 sky130_fd_sc_hd__diode_2
X_2940_ net160 net174 _1454_ net165 net173 vssd1 vssd1 vccd1 vccd1 _1480_ sky130_fd_sc_hd__a32o_1
X_2871_ _1372_ _1410_ _1412_ vssd1 vssd1 vccd1 vccd1 _1413_ sky130_fd_sc_hd__or3b_1
XFILLER_30_253 vssd1 vssd1 vccd1 vccd1 sky130_fd_sc_hd__fill_4
X_1822_ MATMULT_INST.matmult_inst.fsm_inst.rx_data\[4\] net628 MATMULT_INST.matmult_inst.spi_inst.rx_done_sys
+ vssd1 vssd1 vccd1 vccd1 _0486_ sky130_fd_sc_hd__mux2_1
X_1753_ net624 _0671_ net63 vssd1 vssd1 vccd1 vccd1 _0496_ sky130_fd_sc_hd__mux2_1
X_1684_ net218 _0606_ _0608_ net223 vssd1 vssd1 vccd1 vccd1 _0609_ sky130_fd_sc_hd__a22o_1
X_3423_ clknet_leaf_28_clk _0345_ vssd1 vssd1 vccd1 vccd1 MATMULT_INST.matmult_inst.alu_inst.out\[4\]
+ sky130_fd_sc_hd__dfxtp_1
XANTENNA__1626__B net140 vssd1 vssd1 vccd1 vccd1 sky130_fd_sc_hd__diode_2
X_3354_ clknet_leaf_18_clk _0276_ vssd1 vssd1 vccd1 vccd1 MATMULT_INST.matmult_inst.mem_inst.mem2\[9\]
+ sky130_fd_sc_hd__dfxtp_1
X_3285_ clknet_leaf_13_clk _0207_ vssd1 vssd1 vccd1 vccd1 MATMULT_INST.matmult_inst.mem_inst.matrixA2\[12\]
+ sky130_fd_sc_hd__dfxtp_1
X_2305_ _0924_ _0925_ vssd1 vssd1 vccd1 vccd1 _0926_ sky130_fd_sc_hd__xnor2_1
X_2236_ net334 _0867_ net100 vssd1 vssd1 vccd1 vccd1 _0345_ sky130_fd_sc_hd__mux2_1
XFILLER_38_320 vssd1 vssd1 vccd1 vccd1 sky130_fd_sc_hd__fill_2
X_2167_ net110 _0814_ net11 net425 vssd1 vssd1 vccd1 vccd1 _0320_ sky130_fd_sc_hd__a22o_1
XFILLER_54_19 vssd1 vssd1 vccd1 vccd1 sky130_fd_sc_hd__fill_2
XTAP_TAPCELL_ROW_0_168 vssd1 vccd1 sky130_fd_sc_hd__tapvpwrvgnd_1
X_2098_ net368 net44 net16 vssd1 vssd1 vccd1 vccd1 _0254_ sky130_fd_sc_hd__mux2_1
XFILLER_53_334 vssd1 vssd1 vccd1 vccd1 sky130_fd_sc_hd__fill_2
XFILLER_53_367 vssd1 vssd1 vccd1 vccd1 sky130_fd_sc_hd__fill_8
XANTENNA__1803__B2 net219 vssd1 vssd1 vccd1 vccd1 sky130_fd_sc_hd__diode_2
XANTENNA_fanout228_X net228 vssd1 vssd1 vccd1 vccd1 sky130_fd_sc_hd__diode_2
XFILLER_5_419 vssd1 vssd1 vccd1 vccd1 sky130_fd_sc_hd__fill_2
XFILLER_79_49 vssd1 vssd1 vccd1 vccd1 sky130_fd_sc_hd__fill_1
XANTENNA_fanout88_A _0735_ vssd1 vssd1 vccd1 vccd1 sky130_fd_sc_hd__diode_2
XFILLER_0_113 vccd1 vssd1 vccd1 vssd1 sky130_ef_sc_hd__decap_40_12
XFILLER_48_117 vssd1 vssd1 vccd1 vccd1 sky130_fd_sc_hd__fill_4
Xteam_02_243 vssd1 vssd1 vccd1 vccd1 team_02_243/HI gpio_oeb[16] sky130_fd_sc_hd__conb_1
Xteam_02_232 vssd1 vssd1 vccd1 vccd1 team_02_232/HI gpio_oeb[5] sky130_fd_sc_hd__conb_1
Xteam_02_265 vssd1 vssd1 vccd1 vccd1 team_02_265/HI gpio_out[6] sky130_fd_sc_hd__conb_1
Xteam_02_276 vssd1 vssd1 vccd1 vccd1 team_02_276/HI gpio_out[17] sky130_fd_sc_hd__conb_1
Xteam_02_254 vssd1 vssd1 vccd1 vccd1 team_02_254/HI gpio_oeb[27] sky130_fd_sc_hd__conb_1
Xteam_02_287 vssd1 vssd1 vccd1 vccd1 team_02_287/HI gpio_out[28] sky130_fd_sc_hd__conb_1
XANTENNA__2047__A1 net38 vssd1 vssd1 vccd1 vccd1 sky130_fd_sc_hd__diode_2
XFILLER_44_41 vssd1 vssd1 vccd1 vccd1 sky130_fd_sc_hd__fill_2
XFILLER_44_52 vssd1 vssd1 vccd1 vccd1 sky130_fd_sc_hd__fill_4
XFILLER_12_253 vccd1 vssd1 vccd1 vssd1 sky130_ef_sc_hd__decap_40_12
XANTENNA__2670__X _1250_ vssd1 vssd1 vccd1 vccd1 sky130_fd_sc_hd__diode_2
XANTENNA__2322__S net67 vssd1 vssd1 vccd1 vccd1 sky130_fd_sc_hd__diode_2
XFILLER_60_95 vssd1 vssd1 vccd1 vccd1 sky130_fd_sc_hd__fill_8
XFILLER_5_35 vssd1 vssd1 vccd1 vccd1 sky130_fd_sc_hd__fill_1
XFILLER_5_24 vssd1 vssd1 vccd1 vccd1 sky130_fd_sc_hd__fill_1
XFILLER_5_57 vssd1 vssd1 vccd1 vccd1 sky130_fd_sc_hd__fill_4
XFILLER_67_437 vssd1 vssd1 vccd1 vccd1 sky130_fd_sc_hd__fill_1
X_3070_ MATMULT_INST.matmult_inst.alu_inst.out\[6\] net52 net7 net479 vssd1 vssd1
+ vccd1 vccd1 _0514_ sky130_fd_sc_hd__a22o_1
X_2021_ net336 net45 net24 vssd1 vssd1 vccd1 vccd1 _0181_ sky130_fd_sc_hd__mux2_1
XFILLER_62_175 vssd1 vssd1 vccd1 vccd1 sky130_fd_sc_hd__fill_2
XPHY_EDGE_ROW_59_Left_139 vssd1 vssd1 vccd1 vccd1 sky130_fd_sc_hd__decap_3
X_2923_ net158 net157 net176 net178 vssd1 vssd1 vccd1 vccd1 _1464_ sky130_fd_sc_hd__and4_1
X_2854_ _1392_ _1395_ vssd1 vssd1 vccd1 vccd1 _1397_ sky130_fd_sc_hd__or2_1
XTAP_TAPCELL_ROW_13_281 vssd1 vccd1 sky130_fd_sc_hd__tapvpwrvgnd_1
X_2785_ _1314_ _1329_ vssd1 vssd1 vccd1 vccd1 _1330_ sky130_fd_sc_hd__or2_1
X_1805_ MATMULT_INST.matmult_inst.mem_inst.matrixA0\[1\] net112 _0717_ _0718_ vssd1
+ vssd1 vccd1 vccd1 _0719_ sky130_fd_sc_hd__a211o_1
Xhold202 MATMULT_INST.matmult_inst.mem_inst.mem2\[8\] vssd1 vssd1 vccd1 vccd1 net497
+ sky130_fd_sc_hd__dlygate4sd3_1
X_1736_ MATMULT_INST.matmult_inst.mem_inst.mem1\[7\] net126 net118 MATMULT_INST.matmult_inst.mem_inst.mem2\[7\]
+ _0655_ vssd1 vssd1 vccd1 vccd1 _0656_ sky130_fd_sc_hd__a221o_1
Xhold235 MATMULT_INST.matmult_inst.mem_inst.mem2\[11\] vssd1 vssd1 vccd1 vccd1 net530
+ sky130_fd_sc_hd__dlygate4sd3_1
Xhold224 MATMULT_INST.matmult_inst.mem_inst.matrixA2\[14\] vssd1 vssd1 vccd1 vccd1
+ net519 sky130_fd_sc_hd__dlygate4sd3_1
XPHY_EDGE_ROW_68_Left_148 vssd1 vssd1 vccd1 vccd1 sky130_fd_sc_hd__decap_3
Xhold213 MATMULT_INST.matmult_inst.alu_inst.row1\[6\] vssd1 vssd1 vccd1 vccd1 net508
+ sky130_fd_sc_hd__dlygate4sd3_1
X_1667_ net638 net64 _0591_ _0593_ vssd1 vssd1 vccd1 vccd1 _0504_ sky130_fd_sc_hd__o22a_1
Xhold268 MATMULT_INST.matmult_inst.mem_inst.matrixB0\[14\] vssd1 vssd1 vccd1 vccd1
+ net563 sky130_fd_sc_hd__dlygate4sd3_1
Xhold257 MATMULT_INST.matmult_inst.spi_inst.mosi_data_sync\[3\] vssd1 vssd1 vccd1
+ vccd1 net552 sky130_fd_sc_hd__dlygate4sd3_1
Xhold246 MATMULT_INST.matmult_inst.mem_inst.matrixB2\[0\] vssd1 vssd1 vccd1 vccd1
+ net541 sky130_fd_sc_hd__dlygate4sd3_1
X_3406_ clknet_leaf_0_clk _0328_ vssd1 vssd1 vccd1 vccd1 MATMULT_INST.matmult_inst.alu_inst.b0_reg\[3\]
+ sky130_fd_sc_hd__dfxtp_1
X_1598_ MATMULT_INST.matmult_inst.fsm_inst.state\[0\] vssd1 vssd1 vccd1 vccd1 _1593_
+ sky130_fd_sc_hd__inv_2
Xhold279 _0484_ vssd1 vssd1 vccd1 vccd1 net574 sky130_fd_sc_hd__dlygate4sd3_1
XTAP_TAPCELL_ROW_5_216 vssd1 vccd1 sky130_fd_sc_hd__tapvpwrvgnd_1
X_3337_ clknet_leaf_15_clk _0259_ vssd1 vssd1 vccd1 vccd1 MATMULT_INST.matmult_inst.mem_inst.mem3\[10\]
+ sky130_fd_sc_hd__dfxtp_1
X_3268_ clknet_leaf_9_clk _0190_ vssd1 vssd1 vccd1 vccd1 MATMULT_INST.matmult_inst.mem_inst.matrixA3\[13\]
+ sky130_fd_sc_hd__dfxtp_1
XANTENNA_fanout178_X net178 vssd1 vssd1 vccd1 vccd1 sky130_fd_sc_hd__diode_2
X_2219_ _0851_ _0852_ vssd1 vssd1 vccd1 vccd1 _0853_ sky130_fd_sc_hd__and2b_1
X_3199_ clknet_leaf_26_clk _0002_ vssd1 vssd1 vccd1 vccd1 MATMULT_INST.matmult_inst.fsm_inst.sel\[2\]
+ sky130_fd_sc_hd__dfxtp_1
XPHY_EDGE_ROW_77_Left_157 vssd1 vssd1 vccd1 vccd1 sky130_fd_sc_hd__decap_3
XFILLER_26_356 vssd1 vssd1 vccd1 vccd1 sky130_fd_sc_hd__fill_4
XTAP_TAPCELL_ROW_56_649 vssd1 vccd1 sky130_fd_sc_hd__tapvpwrvgnd_1
XANTENNA__1788__B1 net120 vssd1 vssd1 vccd1 vccd1 sky130_fd_sc_hd__diode_2
XANTENNA__2142__S net13 vssd1 vssd1 vccd1 vccd1 sky130_fd_sc_hd__diode_2
XANTENNA__1981__S net28 vssd1 vssd1 vccd1 vccd1 sky130_fd_sc_hd__diode_2
XFILLER_76_212 vssd1 vssd1 vccd1 vccd1 sky130_fd_sc_hd__fill_2
XFILLER_49_459 vssd1 vssd1 vccd1 vccd1 sky130_fd_sc_hd__fill_1
XFILLER_17_301 vssd1 vssd1 vccd1 vccd1 sky130_fd_sc_hd__fill_2
XFILLER_72_473 vssd1 vssd1 vccd1 vccd1 sky130_fd_sc_hd__fill_2
XFILLER_17_367 vssd1 vssd1 vccd1 vccd1 sky130_fd_sc_hd__fill_2
XFILLER_55_95 vssd1 vssd1 vccd1 vccd1 sky130_fd_sc_hd__fill_1
XANTENNA__2052__S net23 vssd1 vssd1 vccd1 vccd1 sky130_fd_sc_hd__diode_2
XFILLER_65_6 vssd1 vssd1 vccd1 vccd1 sky130_fd_sc_hd__fill_8
X_2570_ _1159_ _1160_ vssd1 vssd1 vccd1 vccd1 _1161_ sky130_fd_sc_hd__and2b_1
X_3122_ net226 vssd1 vssd1 vccd1 vccd1 _0031_ sky130_fd_sc_hd__inv_2
XANTENNA__1703__B1 net121 vssd1 vssd1 vccd1 vccd1 sky130_fd_sc_hd__diode_2
X_3053_ net433 net41 net9 vssd1 vssd1 vccd1 vccd1 _0472_ sky130_fd_sc_hd__mux2_1
XFILLER_63_440 vssd1 vssd1 vccd1 vccd1 sky130_fd_sc_hd__fill_1
X_2004_ _0803_ net608 net26 vssd1 vssd1 vccd1 vccd1 _0165_ sky130_fd_sc_hd__mux2_1
XFILLER_48_492 vssd1 vssd1 vccd1 vccd1 sky130_fd_sc_hd__fill_2
XTAP_TAPCELL_ROW_53_619 vssd1 vccd1 sky130_fd_sc_hd__tapvpwrvgnd_1
XFILLER_35_197 vssd1 vssd1 vccd1 vccd1 sky130_fd_sc_hd__fill_4
X_2906_ _1339_ _1408_ vssd1 vssd1 vccd1 vccd1 _1447_ sky130_fd_sc_hd__nand2_1
XANTENNA_fanout138_A net140 vssd1 vssd1 vccd1 vccd1 sky130_fd_sc_hd__diode_2
XANTENNA__3058__S net8 vssd1 vssd1 vccd1 vccd1 sky130_fd_sc_hd__diode_2
X_2837_ _1343_ _1379_ vssd1 vssd1 vccd1 vccd1 _1380_ sky130_fd_sc_hd__nand2_1
X_2768_ net388 _1313_ net98 vssd1 vssd1 vccd1 vccd1 _0430_ sky130_fd_sc_hd__mux2_1
XFILLER_2_208 vssd1 vssd1 vccd1 vccd1 sky130_fd_sc_hd__fill_8
X_2699_ _1248_ net546 _1256_ vssd1 vssd1 vccd1 vccd1 _0418_ sky130_fd_sc_hd__mux2_1
X_1719_ net220 _0634_ _0636_ net218 _0640_ vssd1 vssd1 vccd1 vccd1 _0641_ sky130_fd_sc_hd__a221o_1
XFILLER_73_215 vssd1 vssd1 vccd1 vccd1 sky130_fd_sc_hd__fill_2
XANTENNA__2926__A MATMULT_INST.matmult_inst.alu_inst.a1_reg\[7\] vssd1 vssd1 vccd1
+ vccd1 sky130_fd_sc_hd__diode_2
XFILLER_18_109 vssd1 vssd1 vccd1 vccd1 sky130_fd_sc_hd__fill_4
XFILLER_39_470 vssd1 vssd1 vccd1 vccd1 sky130_fd_sc_hd__fill_2
XFILLER_26_120 vssd1 vssd1 vccd1 vccd1 sky130_fd_sc_hd__fill_4
XFILLER_39_492 vssd1 vssd1 vccd1 vccd1 sky130_fd_sc_hd__fill_2
XANTENNA__2137__S net12 vssd1 vssd1 vccd1 vccd1 sky130_fd_sc_hd__diode_2
XFILLER_25_54 vssd1 vssd1 vccd1 vccd1 sky130_fd_sc_hd__fill_2
XFILLER_26_197 vssd1 vssd1 vccd1 vccd1 sky130_fd_sc_hd__fill_2
XFILLER_25_65 vssd1 vssd1 vccd1 vccd1 sky130_fd_sc_hd__fill_2
XTAP_TAPCELL_ROW_24_376 vssd1 vccd1 sky130_fd_sc_hd__tapvpwrvgnd_1
XFILLER_22_381 vssd1 vssd1 vccd1 vccd1 sky130_fd_sc_hd__fill_1
XFILLER_1_241 vssd1 vssd1 vccd1 vccd1 sky130_fd_sc_hd__fill_4
XFILLER_2_69 vssd1 vssd1 vccd1 vccd1 sky130_fd_sc_hd__fill_1
XFILLER_64_248 vssd1 vssd1 vccd1 vccd1 sky130_fd_sc_hd__fill_4
XFILLER_72_281 vssd1 vssd1 vccd1 vccd1 sky130_fd_sc_hd__fill_1
XANTENNA__2047__S net23 vssd1 vssd1 vccd1 vccd1 sky130_fd_sc_hd__diode_2
XFILLER_32_145 vssd1 vssd1 vccd1 vccd1 sky130_fd_sc_hd__fill_1
XFILLER_63_3 vssd1 vssd1 vccd1 vccd1 sky130_fd_sc_hd__fill_4
X_2622_ net199 net188 net201 net187 vssd1 vssd1 vccd1 vccd1 _1211_ sky130_fd_sc_hd__a22o_1
X_2553_ _1142_ _1144_ vssd1 vssd1 vccd1 vccd1 _1145_ sky130_fd_sc_hd__xnor2_1
X_2484_ _1074_ _1075_ _1037_ vssd1 vssd1 vccd1 vccd1 _1077_ sky130_fd_sc_hd__a21bo_1
X_3105_ net59 net89 net75 vssd1 vssd1 vccd1 vccd1 _0053_ sky130_fd_sc_hd__and3_1
XTAP_TAPCELL_ROW_66_733 vssd1 vccd1 sky130_fd_sc_hd__tapvpwrvgnd_1
X_3036_ _1529_ _1550_ _1553_ _1565_ _1551_ vssd1 vssd1 vccd1 vccd1 _1572_ sky130_fd_sc_hd__a311o_1
XFILLER_63_281 vssd1 vssd1 vccd1 vccd1 sky130_fd_sc_hd__fill_4
XFILLER_23_167 vssd1 vssd1 vccd1 vccd1 sky130_fd_sc_hd__fill_1
XANTENNA_clkbuf_leaf_24_clk_A clknet_2_3__leaf_clk vssd1 vssd1 vccd1 vccd1 sky130_fd_sc_hd__diode_2
XANTENNA_fanout210_X net210 vssd1 vssd1 vccd1 vccd1 sky130_fd_sc_hd__diode_2
XANTENNA__2168__B1 net82 vssd1 vssd1 vccd1 vccd1 sky130_fd_sc_hd__diode_2
XFILLER_27_440 vssd1 vssd1 vccd1 vccd1 sky130_fd_sc_hd__fill_8
XFILLER_42_421 vssd1 vssd1 vccd1 vccd1 sky130_fd_sc_hd__fill_8
XTAP_TAPCELL_ROW_37_490 vssd1 vccd1 sky130_fd_sc_hd__tapvpwrvgnd_1
XFILLER_14_156 vssd1 vssd1 vccd1 vccd1 sky130_fd_sc_hd__fill_2
XFILLER_42_465 vssd1 vssd1 vccd1 vccd1 sky130_fd_sc_hd__fill_1
XFILLER_42_487 vssd1 vssd1 vccd1 vccd1 sky130_fd_sc_hd__fill_4
XFILLER_52_63 vssd1 vssd1 vccd1 vccd1 sky130_fd_sc_hd__fill_1
XFILLER_10_362 vssd1 vssd1 vccd1 vccd1 sky130_fd_sc_hd__fill_2
XFILLER_6_377 vccd1 vssd1 vccd1 vssd1 sky130_ef_sc_hd__decap_40_12
XANTENNA__2330__S net67 vssd1 vssd1 vccd1 vccd1 sky130_fd_sc_hd__diode_2
XANTENNA__1735__A net150 vssd1 vssd1 vccd1 vccd1 sky130_fd_sc_hd__diode_2
XFILLER_35_7 vssd1 vssd1 vccd1 vccd1 sky130_fd_sc_hd__fill_2
XFILLER_77_93 vssd1 vssd1 vccd1 vccd1 sky130_fd_sc_hd__fill_2
XFILLER_45_281 vssd1 vssd1 vccd1 vccd1 sky130_fd_sc_hd__fill_2
XFILLER_33_443 vssd1 vssd1 vccd1 vccd1 sky130_fd_sc_hd__fill_4
XFILLER_45_292 vssd1 vssd1 vccd1 vccd1 sky130_fd_sc_hd__fill_2
XFILLER_33_465 vccd1 vssd1 vccd1 vssd1 sky130_ef_sc_hd__decap_40_12
XFILLER_20_126 vssd1 vssd1 vccd1 vccd1 sky130_fd_sc_hd__fill_2
X_1984_ net501 net44 net28 vssd1 vssd1 vccd1 vccd1 _0146_ sky130_fd_sc_hd__mux2_1
X_2605_ _1166_ _1193_ _1192_ vssd1 vssd1 vccd1 vccd1 _1195_ sky130_fd_sc_hd__a21oi_1
X_3585_ net224 _0018_ _0083_ vssd1 vssd1 vccd1 vccd1 MATMULT_INST.matmult_inst.spi_inst.miso_shifter\[5\]
+ sky130_fd_sc_hd__dfrtp_1
X_2536_ _1016_ _1071_ vssd1 vssd1 vccd1 vccd1 _1128_ sky130_fd_sc_hd__nand2_1
X_2467_ _1055_ _1058_ vssd1 vssd1 vccd1 vccd1 _1061_ sky130_fd_sc_hd__xor2_1
XFILLER_68_373 vssd1 vssd1 vccd1 vccd1 sky130_fd_sc_hd__fill_8
X_2398_ _0987_ _0993_ vssd1 vssd1 vccd1 vccd1 _0994_ sky130_fd_sc_hd__xnor2_1
X_3019_ net95 _1554_ _1555_ _1556_ vssd1 vssd1 vccd1 vccd1 _0438_ sky130_fd_sc_hd__a31o_1
XFILLER_36_270 vssd1 vssd1 vccd1 vccd1 sky130_fd_sc_hd__fill_4
XFILLER_36_292 vccd1 vssd1 vccd1 vssd1 sky130_ef_sc_hd__decap_40_12
XTAP_TAPCELL_ROW_34_460 vssd1 vccd1 sky130_fd_sc_hd__tapvpwrvgnd_1
XFILLER_11_159 vssd1 vssd1 vccd1 vccd1 sky130_fd_sc_hd__fill_8
XFILLER_22_44 vssd1 vssd1 vccd1 vccd1 sky130_fd_sc_hd__fill_2
XFILLER_3_314 vssd1 vssd1 vccd1 vccd1 sky130_fd_sc_hd__fill_2
XANTENNA__2150__S net10 vssd1 vssd1 vccd1 vccd1 sky130_fd_sc_hd__diode_2
XTAP_TAPCELL_ROW_77_828 vssd1 vccd1 sky130_fd_sc_hd__tapvpwrvgnd_1
Xfanout150 net154 vssd1 vssd1 vccd1 vccd1 net150 sky130_fd_sc_hd__buf_2
Xfanout161 MATMULT_INST.matmult_inst.alu_inst.a1_reg\[4\] vssd1 vssd1 vccd1 vccd1
+ net161 sky130_fd_sc_hd__dlymetal6s2s_1
Xfanout172 net173 vssd1 vssd1 vccd1 vccd1 net172 sky130_fd_sc_hd__buf_2
Xfanout183 MATMULT_INST.matmult_inst.alu_inst.b1_reg\[1\] vssd1 vssd1 vccd1 vccd1
+ net183 sky130_fd_sc_hd__dlymetal6s2s_1
XANTENNA_fanout73_X net73 vssd1 vssd1 vccd1 vccd1 sky130_fd_sc_hd__diode_2
XANTENNA__1667__A2 net64 vssd1 vssd1 vccd1 vccd1 sky130_fd_sc_hd__diode_2
XFILLER_74_332 vccd1 vssd1 vccd1 vssd1 sky130_ef_sc_hd__decap_40_12
Xfanout194 MATMULT_INST.matmult_inst.alu_inst.a0_reg\[2\] vssd1 vssd1 vccd1 vccd1
+ net194 sky130_fd_sc_hd__clkbuf_2
XFILLER_15_410 vssd1 vssd1 vccd1 vccd1 sky130_fd_sc_hd__fill_1
XFILLER_34_218 vssd1 vssd1 vccd1 vccd1 sky130_fd_sc_hd__fill_2
XFILLER_15_465 vssd1 vssd1 vccd1 vccd1 sky130_fd_sc_hd__fill_2
XFILLER_42_251 vssd1 vssd1 vccd1 vccd1 sky130_fd_sc_hd__fill_1
XFILLER_8_46 vssd1 vssd1 vccd1 vccd1 sky130_fd_sc_hd__fill_2
XFILLER_8_79 vssd1 vssd1 vccd1 vccd1 sky130_fd_sc_hd__fill_1
XFILLER_6_141 vccd1 vssd1 vccd1 vssd1 sky130_ef_sc_hd__decap_40_12
XANTENNA__2060__S net20 vssd1 vssd1 vccd1 vccd1 sky130_fd_sc_hd__diode_2
X_3370_ clknet_leaf_8_clk _0292_ vssd1 vssd1 vccd1 vccd1 MATMULT_INST.matmult_inst.mem_inst.mem1\[7\]
+ sky130_fd_sc_hd__dfxtp_1
X_2321_ net172 net596 net67 vssd1 vssd1 vccd1 vccd1 _0365_ sky130_fd_sc_hd__mux2_1
X_2252_ _0880_ vssd1 vssd1 vccd1 vccd1 _0881_ sky130_fd_sc_hd__inv_2
XANTENNA__1752__X _0671_ vssd1 vssd1 vccd1 vccd1 sky130_fd_sc_hd__diode_2
XFILLER_26_3 vccd1 vssd1 vccd1 vssd1 sky130_ef_sc_hd__decap_40_12
X_2183_ _0838_ MATMULT_INST.matmult_inst.fsm_inst.count\[1\] _0832_ vssd1 vssd1 vccd1
+ vccd1 _0322_ sky130_fd_sc_hd__mux2_1
XFILLER_21_435 vssd1 vssd1 vccd1 vccd1 sky130_fd_sc_hd__fill_1
X_1967_ net525 net37 net31 vssd1 vssd1 vccd1 vccd1 _0135_ sky130_fd_sc_hd__mux2_1
XANTENNA_fanout120_A net123 vssd1 vssd1 vccd1 vccd1 sky130_fd_sc_hd__diode_2
X_1898_ _0536_ _0771_ vssd1 vssd1 vccd1 vccd1 _0776_ sky130_fd_sc_hd__or2_2
X_3637_ clknet_leaf_25_clk net343 vssd1 vssd1 vccd1 vccd1 MATMULT_INST.matmult_inst.fsm_inst.alu_result\[13\]
+ sky130_fd_sc_hd__dfxtp_1
X_3568_ clknet_leaf_10_clk _0480_ vssd1 vssd1 vccd1 vccd1 MATMULT_INST.matmult_inst.mem_inst.matrixB3\[16\]
+ sky130_fd_sc_hd__dfxtp_1
X_2519_ _1106_ _1108_ _1109_ vssd1 vssd1 vccd1 vccd1 _1111_ sky130_fd_sc_hd__or3_1
XFILLER_0_339 vssd1 vssd1 vccd1 vccd1 sky130_fd_sc_hd__fill_1
X_3499_ clknet_leaf_2_clk _0417_ vssd1 vssd1 vccd1 vccd1 MATMULT_INST.matmult_inst.alu_inst.row0\[1\]
+ sky130_fd_sc_hd__dfxtp_1
XFILLER_56_354 vssd1 vssd1 vccd1 vccd1 sky130_fd_sc_hd__fill_1
XTAP_TAPCELL_ROW_3_199 vssd1 vccd1 sky130_fd_sc_hd__tapvpwrvgnd_1
XFILLER_71_335 vssd1 vssd1 vccd1 vccd1 sky130_fd_sc_hd__fill_1
XANTENNA_fanout33_A _0813_ vssd1 vssd1 vccd1 vccd1 sky130_fd_sc_hd__diode_2
XANTENNA__2145__S net12 vssd1 vssd1 vccd1 vccd1 sky130_fd_sc_hd__diode_2
XANTENNA__1984__S net28 vssd1 vssd1 vccd1 vccd1 sky130_fd_sc_hd__diode_2
XFILLER_3_122 vssd1 vssd1 vccd1 vccd1 sky130_fd_sc_hd__fill_4
XFILLER_3_155 vssd1 vssd1 vccd1 vccd1 sky130_fd_sc_hd__fill_1
XFILLER_3_177 vssd1 vssd1 vccd1 vccd1 sky130_fd_sc_hd__fill_2
XANTENNA__2668__X _1249_ vssd1 vssd1 vccd1 vccd1 sky130_fd_sc_hd__diode_2
XFILLER_79_468 vssd1 vssd1 vccd1 vccd1 sky130_fd_sc_hd__fill_4
XFILLER_66_118 vssd1 vssd1 vccd1 vccd1 sky130_fd_sc_hd__fill_8
Xhold6 MATMULT_INST.matmult_inst.fsm_inst.rx_ready_edge vssd1 vssd1 vccd1 vccd1 net301
+ sky130_fd_sc_hd__dlygate4sd3_1
XFILLER_58_95 vssd1 vssd1 vccd1 vccd1 sky130_fd_sc_hd__fill_4
XTAP_TAPCELL_ROW_45_555 vssd1 vccd1 sky130_fd_sc_hd__tapvpwrvgnd_1
X_2870_ _1390_ _1396_ _1397_ _1409_ _1389_ vssd1 vssd1 vccd1 vccd1 _1412_ sky130_fd_sc_hd__a311o_1
XANTENNA__2055__S net20 vssd1 vssd1 vccd1 vccd1 sky130_fd_sc_hd__diode_2
X_1821_ MATMULT_INST.matmult_inst.fsm_inst.rx_data\[5\] net399 MATMULT_INST.matmult_inst.spi_inst.rx_done_sys
+ vssd1 vssd1 vccd1 vccd1 _0487_ sky130_fd_sc_hd__mux2_1
XFILLER_30_287 vccd1 vssd1 vccd1 vssd1 sky130_ef_sc_hd__decap_40_12
Xclkbuf_leaf_10_clk clknet_2_1__leaf_clk vssd1 vssd1 vccd1 vccd1 clknet_leaf_10_clk
+ sky130_fd_sc_hd__clkbuf_8
XFILLER_11_490 vssd1 vssd1 vccd1 vccd1 sky130_fd_sc_hd__fill_1
X_1752_ _0669_ _0670_ vssd1 vssd1 vccd1 vccd1 _0671_ sky130_fd_sc_hd__or2_2
X_1683_ MATMULT_INST.matmult_inst.mem_inst.matrixA1\[12\] net129 net121 MATMULT_INST.matmult_inst.mem_inst.matrixA2\[12\]
+ _0607_ vssd1 vssd1 vccd1 vccd1 _0608_ sky130_fd_sc_hd__a221o_1
X_3422_ clknet_leaf_24_clk _0344_ vssd1 vssd1 vccd1 vccd1 MATMULT_INST.matmult_inst.alu_inst.out\[3\]
+ sky130_fd_sc_hd__dfxtp_1
XANTENNA__2525__B1 net208 vssd1 vssd1 vccd1 vccd1 sky130_fd_sc_hd__diode_2
X_3353_ clknet_leaf_19_clk _0275_ vssd1 vssd1 vccd1 vccd1 MATMULT_INST.matmult_inst.mem_inst.mem2\[8\]
+ sky130_fd_sc_hd__dfxtp_1
X_3284_ clknet_leaf_14_clk _0206_ vssd1 vssd1 vccd1 vccd1 MATMULT_INST.matmult_inst.mem_inst.matrixA2\[11\]
+ sky130_fd_sc_hd__dfxtp_1
X_2304_ _0917_ _0920_ _0918_ vssd1 vssd1 vccd1 vccd1 _0925_ sky130_fd_sc_hd__a21boi_2
X_2235_ _0864_ _0866_ vssd1 vssd1 vccd1 vccd1 _0867_ sky130_fd_sc_hd__xnor2_1
X_2166_ net111 net33 net10 net436 vssd1 vssd1 vccd1 vccd1 _0319_ sky130_fd_sc_hd__a22o_1
XFILLER_38_332 vssd1 vssd1 vccd1 vccd1 sky130_fd_sc_hd__fill_2
XFILLER_38_365 vccd1 vssd1 vccd1 vssd1 sky130_ef_sc_hd__decap_40_12
XTAP_TAPCELL_ROW_0_169 vssd1 vccd1 sky130_fd_sc_hd__tapvpwrvgnd_1
X_2097_ net327 net45 net16 vssd1 vssd1 vccd1 vccd1 _0253_ sky130_fd_sc_hd__mux2_1
XPHY_EDGE_ROW_3_Right_3 vssd1 vssd1 vccd1 vccd1 sky130_fd_sc_hd__decap_3
X_2999_ _1535_ _1536_ vssd1 vssd1 vccd1 vccd1 _1537_ sky130_fd_sc_hd__nor2_1
XANTENNA_fanout123_X net123 vssd1 vssd1 vccd1 vccd1 sky130_fd_sc_hd__diode_2
XTAP_TAPCELL_ROW_8_236 vssd1 vccd1 sky130_fd_sc_hd__tapvpwrvgnd_1
XFILLER_0_125 vccd1 vssd1 vccd1 vssd1 sky130_ef_sc_hd__decap_40_12
XFILLER_0_169 vccd1 vssd1 vccd1 vssd1 sky130_ef_sc_hd__decap_40_12
Xteam_02_233 vssd1 vssd1 vccd1 vccd1 team_02_233/HI gpio_oeb[6] sky130_fd_sc_hd__conb_1
Xteam_02_244 vssd1 vssd1 vccd1 vccd1 team_02_244/HI gpio_oeb[17] sky130_fd_sc_hd__conb_1
Xteam_02_266 vssd1 vssd1 vccd1 vccd1 team_02_266/HI gpio_out[7] sky130_fd_sc_hd__conb_1
Xteam_02_255 vssd1 vssd1 vccd1 vccd1 team_02_255/HI gpio_oeb[28] sky130_fd_sc_hd__conb_1
Xteam_02_277 vssd1 vssd1 vccd1 vccd1 team_02_277/HI gpio_out[18] sky130_fd_sc_hd__conb_1
XFILLER_28_54 vssd1 vssd1 vccd1 vccd1 sky130_fd_sc_hd__fill_2
Xteam_02_288 vssd1 vssd1 vccd1 vccd1 team_02_288/HI gpio_out[29] sky130_fd_sc_hd__conb_1
XANTENNA__1979__S net28 vssd1 vssd1 vccd1 vccd1 sky130_fd_sc_hd__diode_2
XFILLER_71_121 vssd1 vssd1 vccd1 vccd1 sky130_fd_sc_hd__fill_1
XANTENNA__2664__A _0720_ vssd1 vssd1 vccd1 vccd1 sky130_fd_sc_hd__diode_2
XTAP_TAPCELL_ROW_42_525 vssd1 vccd1 sky130_fd_sc_hd__tapvpwrvgnd_1
XFILLER_12_265 vssd1 vssd1 vccd1 vccd1 sky130_fd_sc_hd__fill_4
XFILLER_4_475 vssd1 vssd1 vccd1 vccd1 sky130_fd_sc_hd__fill_1
XFILLER_79_221 vssd1 vssd1 vccd1 vccd1 sky130_fd_sc_hd__fill_2
X_2020_ net340 net46 net24 vssd1 vssd1 vccd1 vccd1 _0180_ sky130_fd_sc_hd__mux2_1
XFILLER_35_324 vssd1 vssd1 vccd1 vccd1 sky130_fd_sc_hd__fill_1
XFILLER_50_305 vssd1 vssd1 vccd1 vccd1 sky130_fd_sc_hd__fill_2
X_2922_ net158 net176 net178 net157 vssd1 vssd1 vccd1 vccd1 _1463_ sky130_fd_sc_hd__a22o_1
XFILLER_50_338 vssd1 vssd1 vccd1 vccd1 sky130_fd_sc_hd__fill_1
X_2853_ _1392_ _1395_ vssd1 vssd1 vccd1 vccd1 _1396_ sky130_fd_sc_hd__nand2_1
XTAP_TAPCELL_ROW_13_282 vssd1 vccd1 sky130_fd_sc_hd__tapvpwrvgnd_1
X_2784_ _1322_ _1328_ vssd1 vssd1 vccd1 vccd1 _1329_ sky130_fd_sc_hd__xnor2_1
X_1804_ net222 _0714_ _0716_ net216 vssd1 vssd1 vccd1 vccd1 _0718_ sky130_fd_sc_hd__a22o_1
X_1735_ net150 net141 MATMULT_INST.matmult_inst.mem_inst.mem3\[7\] vssd1 vssd1 vccd1
+ vccd1 _0655_ sky130_fd_sc_hd__and3_1
Xhold214 MATMULT_INST.matmult_inst.alu_inst.col0\[1\] vssd1 vssd1 vccd1 vccd1 net509
+ sky130_fd_sc_hd__dlygate4sd3_1
Xhold225 MATMULT_INST.matmult_inst.mem_inst.mem1\[5\] vssd1 vssd1 vccd1 vccd1 net520
+ sky130_fd_sc_hd__dlygate4sd3_1
Xhold203 MATMULT_INST.matmult_inst.mem_inst.matrixA1\[5\] vssd1 vssd1 vccd1 vccd1
+ net498 sky130_fd_sc_hd__dlygate4sd3_1
Xhold236 MATMULT_INST.matmult_inst.mem_inst.matrixB2\[17\] vssd1 vssd1 vccd1 vccd1
+ net531 sky130_fd_sc_hd__dlygate4sd3_1
X_1666_ MATMULT_INST.matmult_inst.mem_inst.matrixB0\[14\] net105 _0592_ _0545_ vssd1
+ vssd1 vccd1 vccd1 _0593_ sky130_fd_sc_hd__a211o_1
Xhold247 MATMULT_INST.matmult_inst.mem_inst.mem2\[13\] vssd1 vssd1 vccd1 vccd1 net542
+ sky130_fd_sc_hd__dlygate4sd3_1
Xhold269 MATMULT_INST.matmult_inst.mem_inst.matrixB2\[10\] vssd1 vssd1 vccd1 vccd1
+ net564 sky130_fd_sc_hd__dlygate4sd3_1
Xhold258 _0485_ vssd1 vssd1 vccd1 vccd1 net553 sky130_fd_sc_hd__dlygate4sd3_1
X_3405_ clknet_leaf_0_clk _0327_ vssd1 vssd1 vccd1 vccd1 MATMULT_INST.matmult_inst.alu_inst.b0_reg\[2\]
+ sky130_fd_sc_hd__dfxtp_1
X_1597_ net662 vssd1 vssd1 vccd1 vccd1 MATMULT_INST.matmult_inst.fsm_inst.tx_ready
+ sky130_fd_sc_hd__inv_2
XTAP_TAPCELL_ROW_5_217 vssd1 vccd1 sky130_fd_sc_hd__tapvpwrvgnd_1
X_3336_ clknet_leaf_19_clk _0258_ vssd1 vssd1 vccd1 vccd1 MATMULT_INST.matmult_inst.mem_inst.mem3\[9\]
+ sky130_fd_sc_hd__dfxtp_1
X_3267_ clknet_leaf_13_clk _0189_ vssd1 vssd1 vccd1 vccd1 MATMULT_INST.matmult_inst.mem_inst.matrixA3\[12\]
+ sky130_fd_sc_hd__dfxtp_1
XFILLER_66_482 vccd1 vssd1 vccd1 vssd1 sky130_ef_sc_hd__decap_40_12
X_2218_ MATMULT_INST.matmult_inst.alu_inst.adder_inst.r0.fa2.b MATMULT_INST.matmult_inst.alu_inst.adder_inst.r0.fa2.a
+ vssd1 vssd1 vccd1 vccd1 _0852_ sky130_fd_sc_hd__nand2_1
X_3198_ clknet_leaf_3_clk _0001_ vssd1 vssd1 vccd1 vccd1 MATMULT_INST.matmult_inst.fsm_inst.sel\[1\]
+ sky130_fd_sc_hd__dfxtp_1
X_2149_ net111 net50 vssd1 vssd1 vccd1 vccd1 _0824_ sky130_fd_sc_hd__nand2_1
XFILLER_53_121 vssd1 vssd1 vccd1 vccd1 sky130_fd_sc_hd__fill_1
XFILLER_14_89 vssd1 vssd1 vccd1 vccd1 sky130_fd_sc_hd__fill_2
XPHY_EDGE_ROW_12_Left_92 vssd1 vssd1 vccd1 vccd1 sky130_fd_sc_hd__decap_3
XFILLER_1_401 vccd1 vssd1 vccd1 vssd1 sky130_ef_sc_hd__decap_40_12
XANTENNA__2659__A _0730_ vssd1 vssd1 vccd1 vccd1 sky130_fd_sc_hd__diode_2
XFILLER_1_445 vssd1 vssd1 vccd1 vccd1 sky130_fd_sc_hd__fill_2
XFILLER_49_449 vssd1 vssd1 vccd1 vccd1 sky130_fd_sc_hd__fill_8
XFILLER_76_235 vssd1 vssd1 vccd1 vccd1 sky130_fd_sc_hd__fill_1
XFILLER_64_408 vssd1 vssd1 vccd1 vccd1 sky130_fd_sc_hd__fill_2
XFILLER_64_419 vssd1 vssd1 vccd1 vccd1 sky130_fd_sc_hd__fill_1
XFILLER_17_335 vssd1 vssd1 vccd1 vccd1 sky130_fd_sc_hd__fill_1
XFILLER_57_493 vssd1 vssd1 vccd1 vccd1 sky130_fd_sc_hd__fill_1
XANTENNA__2976__B1 net176 vssd1 vssd1 vccd1 vccd1 sky130_fd_sc_hd__diode_2
XFILLER_71_95 vssd1 vssd1 vccd1 vccd1 sky130_fd_sc_hd__fill_2
XFILLER_4_250 vssd1 vssd1 vccd1 vccd1 sky130_fd_sc_hd__fill_2
X_3121_ net226 vssd1 vssd1 vccd1 vccd1 _0029_ sky130_fd_sc_hd__inv_2
XFILLER_67_202 vssd1 vssd1 vccd1 vccd1 sky130_fd_sc_hd__fill_1
XANTENNA__3461__Q MATMULT_INST.matmult_inst.alu_inst.adder_inst.r1.fa3.a vssd1 vssd1
+ vccd1 vccd1 sky130_fd_sc_hd__diode_2
XFILLER_67_279 vssd1 vssd1 vccd1 vccd1 sky130_fd_sc_hd__fill_1
XFILLER_48_471 vssd1 vssd1 vccd1 vccd1 sky130_fd_sc_hd__fill_4
X_3052_ net328 net42 net8 vssd1 vssd1 vccd1 vccd1 _0471_ sky130_fd_sc_hd__mux2_1
X_2003_ net44 net570 net26 vssd1 vssd1 vccd1 vccd1 _0164_ sky130_fd_sc_hd__mux2_1
X_2905_ _1444_ _1445_ vssd1 vssd1 vccd1 vccd1 _1446_ sky130_fd_sc_hd__nand2_1
X_2836_ _1315_ _1344_ vssd1 vssd1 vccd1 vccd1 _1379_ sky130_fd_sc_hd__nand2_1
XANTENNA__2719__A0 net140 vssd1 vssd1 vccd1 vccd1 sky130_fd_sc_hd__diode_2
X_2767_ _1291_ _1312_ vssd1 vssd1 vccd1 vccd1 _1313_ sky130_fd_sc_hd__xnor2_1
X_2698_ _1247_ net449 _1256_ vssd1 vssd1 vccd1 vccd1 _0417_ sky130_fd_sc_hd__mux2_1
X_1718_ MATMULT_INST.matmult_inst.mem_inst.matrixB0\[9\] net106 _0638_ net223 _0545_
+ vssd1 vssd1 vccd1 vccd1 _0640_ sky130_fd_sc_hd__a221o_1
X_1649_ MATMULT_INST.matmult_inst.mem_inst.matrixB1\[15\] net126 net118 MATMULT_INST.matmult_inst.mem_inst.matrixB2\[15\]
+ _0576_ vssd1 vssd1 vccd1 vccd1 _0577_ sky130_fd_sc_hd__a221o_1
XFILLER_76_29 vssd1 vssd1 vccd1 vccd1 sky130_fd_sc_hd__fill_1
XANTENNA__2498__A2 net208 vssd1 vssd1 vccd1 vccd1 sky130_fd_sc_hd__diode_2
X_3319_ clknet_leaf_21_clk _0241_ vssd1 vssd1 vccd1 vccd1 MATMULT_INST.matmult_inst.mem_inst.matrixA0\[10\]
+ sky130_fd_sc_hd__dfxtp_1
XANTENNA_fanout190_X net190 vssd1 vssd1 vccd1 vccd1 sky130_fd_sc_hd__diode_2
XFILLER_46_419 vssd1 vssd1 vccd1 vccd1 sky130_fd_sc_hd__fill_1
XFILLER_26_110 vssd1 vssd1 vccd1 vccd1 sky130_fd_sc_hd__fill_4
XFILLER_14_338 vssd1 vssd1 vccd1 vccd1 sky130_fd_sc_hd__fill_4
XFILLER_14_316 vssd1 vssd1 vccd1 vccd1 sky130_fd_sc_hd__fill_4
XFILLER_14_305 vssd1 vssd1 vccd1 vccd1 sky130_fd_sc_hd__fill_2
XFILLER_54_485 vssd1 vssd1 vccd1 vccd1 sky130_fd_sc_hd__fill_1
XFILLER_25_88 vssd1 vssd1 vccd1 vccd1 sky130_fd_sc_hd__fill_8
XFILLER_41_146 vssd1 vssd1 vccd1 vccd1 sky130_fd_sc_hd__fill_1
XANTENNA__2422__A2 net203 vssd1 vssd1 vccd1 vccd1 sky130_fd_sc_hd__diode_2
XTAP_TAPCELL_ROW_24_377 vssd1 vccd1 sky130_fd_sc_hd__tapvpwrvgnd_1
XANTENNA__2153__S net10 vssd1 vssd1 vccd1 vccd1 sky130_fd_sc_hd__diode_2
XANTENNA__1992__S net28 vssd1 vssd1 vccd1 vccd1 sky130_fd_sc_hd__diode_2
XFILLER_2_26 vssd1 vssd1 vccd1 vccd1 sky130_fd_sc_hd__fill_2
XFILLER_2_37 vssd1 vssd1 vccd1 vccd1 sky130_fd_sc_hd__fill_2
XANTENNA__2676__X _1253_ vssd1 vssd1 vccd1 vccd1 sky130_fd_sc_hd__diode_2
XFILLER_64_227 vssd1 vssd1 vccd1 vccd1 sky130_fd_sc_hd__fill_1
XANTENNA__2328__S net67 vssd1 vssd1 vccd1 vccd1 sky130_fd_sc_hd__diode_2
XFILLER_17_132 vssd1 vssd1 vccd1 vccd1 sky130_fd_sc_hd__fill_4
XTAP_TAPCELL_ROW_15_300 vssd1 vccd1 sky130_fd_sc_hd__tapvpwrvgnd_1
XFILLER_32_113 vssd1 vssd1 vccd1 vccd1 sky130_fd_sc_hd__fill_2
XFILLER_32_179 vssd1 vssd1 vccd1 vccd1 sky130_fd_sc_hd__fill_2
XANTENNA__1621__B1 net121 vssd1 vssd1 vccd1 vccd1 sky130_fd_sc_hd__diode_2
XANTENNA__2063__S net21 vssd1 vssd1 vccd1 vccd1 sky130_fd_sc_hd__diode_2
XFILLER_13_393 vssd1 vssd1 vccd1 vccd1 sky130_fd_sc_hd__fill_4
XFILLER_9_320 vssd1 vssd1 vccd1 vccd1 sky130_fd_sc_hd__fill_8
XFILLER_9_353 vccd1 vssd1 vccd1 vssd1 sky130_ef_sc_hd__decap_40_12
X_2621_ net202 net187 vssd1 vssd1 vccd1 vccd1 _1210_ sky130_fd_sc_hd__nand2_1
XANTENNA__3456__Q MATMULT_INST.matmult_inst.alu_inst.adder_inst.r0.fa2.a vssd1 vssd1
+ vccd1 vccd1 sky130_fd_sc_hd__diode_2
X_2552_ _1100_ _1143_ vssd1 vssd1 vccd1 vccd1 _1144_ sky130_fd_sc_hd__or2_1
XFILLER_56_3 vssd1 vssd1 vccd1 vccd1 sky130_fd_sc_hd__fill_1
X_2483_ _1037_ _1073_ _1075_ vssd1 vssd1 vccd1 vccd1 _1076_ sky130_fd_sc_hd__or3b_1
X_3104_ net59 net89 net81 vssd1 vssd1 vccd1 vccd1 _0055_ sky130_fd_sc_hd__and3_1
XTAP_TAPCELL_ROW_66_734 vssd1 vccd1 sky130_fd_sc_hd__tapvpwrvgnd_1
X_3035_ _1535_ _1560_ _1542_ net170 net155 vssd1 vssd1 vccd1 vccd1 _1571_ sky130_fd_sc_hd__o2111ai_2
XFILLER_23_113 vssd1 vssd1 vccd1 vccd1 sky130_fd_sc_hd__fill_4
XFILLER_36_474 vssd1 vssd1 vccd1 vccd1 sky130_fd_sc_hd__fill_2
XANTENNA_fanout150_A net154 vssd1 vssd1 vccd1 vccd1 sky130_fd_sc_hd__diode_2
XTAP_TAPCELL_ROW_21_347 vssd1 vccd1 sky130_fd_sc_hd__tapvpwrvgnd_1
X_2819_ _1296_ _1320_ _1321_ _1328_ vssd1 vssd1 vccd1 vccd1 _1363_ sky130_fd_sc_hd__o2bb2a_1
XANTENNA__2168__A1 MATMULT_INST.matmult_inst.spi_inst.current_state vssd1 vssd1 vccd1
+ vccd1 sky130_fd_sc_hd__diode_2
XFILLER_11_57 vssd1 vssd1 vccd1 vccd1 sky130_fd_sc_hd__fill_8
XANTENNA_fanout203_X net203 vssd1 vssd1 vccd1 vccd1 sky130_fd_sc_hd__diode_2
XANTENNA__2701__S _1256_ vssd1 vssd1 vccd1 vccd1 sky130_fd_sc_hd__diode_2
XANTENNA__1915__B2 net217 vssd1 vssd1 vccd1 vccd1 sky130_fd_sc_hd__diode_2
XANTENNA__2148__S net13 vssd1 vssd1 vccd1 vccd1 sky130_fd_sc_hd__diode_2
XANTENNA__1987__S net29 vssd1 vssd1 vccd1 vccd1 sky130_fd_sc_hd__diode_2
XANTENNA__2672__A _0681_ vssd1 vssd1 vccd1 vccd1 sky130_fd_sc_hd__diode_2
XFILLER_10_330 vccd1 vssd1 vccd1 vssd1 sky130_ef_sc_hd__decap_40_12
XFILLER_6_389 vssd1 vssd1 vccd1 vccd1 sky130_fd_sc_hd__fill_2
XFILLER_77_330 vssd1 vssd1 vccd1 vccd1 sky130_fd_sc_hd__fill_1
XANTENNA__2058__S net21 vssd1 vssd1 vccd1 vccd1 sky130_fd_sc_hd__diode_2
XTAP_TAPCELL_ROW_63_704 vssd1 vccd1 sky130_fd_sc_hd__tapvpwrvgnd_1
XFILLER_18_485 vssd1 vssd1 vccd1 vccd1 sky130_fd_sc_hd__fill_8
XFILLER_33_411 vssd1 vssd1 vccd1 vccd1 sky130_fd_sc_hd__fill_1
XFILLER_33_477 vccd1 vssd1 vccd1 vssd1 sky130_ef_sc_hd__decap_40_12
XFILLER_20_116 vssd1 vssd1 vccd1 vccd1 sky130_fd_sc_hd__fill_2
X_1983_ net505 net45 net28 vssd1 vssd1 vccd1 vccd1 _0145_ sky130_fd_sc_hd__mux2_1
XFILLER_9_161 vssd1 vssd1 vccd1 vccd1 sky130_fd_sc_hd__fill_4
X_2604_ _1166_ _1192_ _1193_ vssd1 vssd1 vccd1 vccd1 _1194_ sky130_fd_sc_hd__nand3_1
X_3584_ net224 _0017_ _0082_ vssd1 vssd1 vccd1 vccd1 MATMULT_INST.matmult_inst.spi_inst.miso_shifter\[4\]
+ sky130_fd_sc_hd__dfrtp_1
X_2535_ _1088_ _1124_ _1125_ vssd1 vssd1 vccd1 vccd1 _1127_ sky130_fd_sc_hd__nand3_1
X_2466_ _1055_ _1058_ vssd1 vssd1 vccd1 vccd1 _1060_ sky130_fd_sc_hd__or2_1
X_2397_ _0957_ _0992_ vssd1 vssd1 vccd1 vccd1 _0993_ sky130_fd_sc_hd__xnor2_1
XFILLER_28_205 vssd1 vssd1 vccd1 vccd1 sky130_fd_sc_hd__fill_2
X_3018_ MATMULT_INST.matmult_inst.alu_inst.adder_inst.r3.fa0.b net114 vssd1 vssd1
+ vccd1 vccd1 _1556_ sky130_fd_sc_hd__and2_1
XANTENNA__2492__A net190 vssd1 vssd1 vccd1 vccd1 sky130_fd_sc_hd__diode_2
XFILLER_24_444 vssd1 vssd1 vccd1 vccd1 sky130_fd_sc_hd__fill_1
XANTENNA__2923__C net176 vssd1 vssd1 vccd1 vccd1 sky130_fd_sc_hd__diode_2
XFILLER_24_455 vssd1 vssd1 vccd1 vccd1 sky130_fd_sc_hd__fill_8
XFILLER_24_477 vssd1 vssd1 vccd1 vccd1 sky130_fd_sc_hd__fill_2
XTAP_TAPCELL_ROW_34_461 vssd1 vccd1 sky130_fd_sc_hd__tapvpwrvgnd_1
XFILLER_51_241 vssd1 vssd1 vccd1 vccd1 sky130_fd_sc_hd__fill_1
XFILLER_7_109 vssd1 vssd1 vccd1 vccd1 sky130_fd_sc_hd__fill_2
XFILLER_22_34 vssd1 vssd1 vccd1 vccd1 sky130_fd_sc_hd__fill_4
XANTENNA__2010__B1 net27 vssd1 vssd1 vccd1 vccd1 sky130_fd_sc_hd__diode_2
XFILLER_3_337 vssd1 vssd1 vccd1 vccd1 sky130_fd_sc_hd__fill_4
Xfanout140 net145 vssd1 vssd1 vccd1 vccd1 net140 sky130_fd_sc_hd__clkbuf_4
XTAP_TAPCELL_ROW_77_829 vssd1 vccd1 sky130_fd_sc_hd__tapvpwrvgnd_1
Xfanout151 net154 vssd1 vssd1 vccd1 vccd1 net151 sky130_fd_sc_hd__buf_1
Xfanout173 MATMULT_INST.matmult_inst.alu_inst.b1_reg\[6\] vssd1 vssd1 vccd1 vccd1
+ net173 sky130_fd_sc_hd__clkbuf_4
Xfanout162 MATMULT_INST.matmult_inst.alu_inst.a1_reg\[3\] vssd1 vssd1 vccd1 vccd1
+ net162 sky130_fd_sc_hd__buf_2
XFILLER_19_227 vssd1 vssd1 vccd1 vccd1 sky130_fd_sc_hd__fill_1
Xfanout184 MATMULT_INST.matmult_inst.alu_inst.b1_reg\[0\] vssd1 vssd1 vccd1 vccd1
+ net184 sky130_fd_sc_hd__buf_2
XANTENNA_fanout66_X net66 vssd1 vssd1 vccd1 vccd1 sky130_fd_sc_hd__diode_2
Xfanout195 MATMULT_INST.matmult_inst.alu_inst.a0_reg\[1\] vssd1 vssd1 vccd1 vccd1
+ net195 sky130_fd_sc_hd__buf_2
XFILLER_74_344 vssd1 vssd1 vccd1 vccd1 sky130_fd_sc_hd__fill_4
XFILLER_47_75 vssd1 vssd1 vccd1 vccd1 sky130_fd_sc_hd__fill_1
XFILLER_47_86 vssd1 vssd1 vccd1 vccd1 sky130_fd_sc_hd__fill_1
XFILLER_63_74 vssd1 vssd1 vccd1 vccd1 sky130_fd_sc_hd__fill_2
XFILLER_6_153 vccd1 vssd1 vccd1 vssd1 sky130_ef_sc_hd__decap_40_12
XANTENNA__2001__A0 _0800_ vssd1 vssd1 vccd1 vccd1 sky130_fd_sc_hd__diode_2
XFILLER_6_197 vssd1 vssd1 vccd1 vccd1 sky130_fd_sc_hd__fill_2
X_2320_ net174 net603 net67 vssd1 vssd1 vccd1 vccd1 _0364_ sky130_fd_sc_hd__mux2_1
XPHY_EDGE_ROW_0_Left_80 vssd1 vssd1 vccd1 vccd1 sky130_fd_sc_hd__decap_3
X_2251_ MATMULT_INST.matmult_inst.alu_inst.adder_inst.r1.fa3.b MATMULT_INST.matmult_inst.alu_inst.adder_inst.r1.fa3.a
+ vssd1 vssd1 vccd1 vccd1 _0880_ sky130_fd_sc_hd__or2_1
XANTENNA_clkbuf_leaf_23_clk_A clknet_2_3__leaf_clk vssd1 vssd1 vccd1 vccd1 sky130_fd_sc_hd__diode_2
XFILLER_19_3 vssd1 vssd1 vccd1 vccd1 sky130_fd_sc_hd__fill_8
X_2182_ _0543_ _0771_ _0777_ _0837_ vssd1 vssd1 vccd1 vccd1 _0838_ sky130_fd_sc_hd__a31o_1
XFILLER_21_403 vssd1 vssd1 vccd1 vccd1 sky130_fd_sc_hd__fill_2
XFILLER_33_274 vssd1 vssd1 vccd1 vccd1 sky130_fd_sc_hd__fill_2
X_1966_ MATMULT_INST.matmult_inst.fsm_inst.alu_result\[12\] net69 vssd1 vssd1 vccd1
+ vccd1 _0809_ sky130_fd_sc_hd__and2_1
X_1897_ _0737_ _0770_ _0774_ vssd1 vssd1 vccd1 vccd1 _0775_ sky130_fd_sc_hd__a21o_1
X_3636_ clknet_leaf_26_clk net311 vssd1 vssd1 vccd1 vccd1 MATMULT_INST.matmult_inst.fsm_inst.alu_result\[12\]
+ sky130_fd_sc_hd__dfxtp_1
XANTENNA_fanout113_A _0559_ vssd1 vssd1 vccd1 vccd1 sky130_fd_sc_hd__diode_2
X_3567_ clknet_leaf_9_clk _0479_ vssd1 vssd1 vccd1 vccd1 MATMULT_INST.matmult_inst.mem_inst.matrixB3\[15\]
+ sky130_fd_sc_hd__dfxtp_1
X_2518_ _1106_ _1108_ _1109_ vssd1 vssd1 vccd1 vccd1 _1110_ sky130_fd_sc_hd__o21ai_1
X_3498_ clknet_leaf_34_clk _0416_ vssd1 vssd1 vccd1 vccd1 MATMULT_INST.matmult_inst.alu_inst.row0\[0\]
+ sky130_fd_sc_hd__dfxtp_1
X_2449_ _1040_ _1041_ _1018_ vssd1 vssd1 vccd1 vccd1 _1043_ sky130_fd_sc_hd__a21o_1
XANTENNA__1806__B1 net104 vssd1 vssd1 vccd1 vccd1 sky130_fd_sc_hd__diode_2
XFILLER_12_414 vssd1 vssd1 vccd1 vccd1 sky130_fd_sc_hd__fill_1
XANTENNA_fanout26_A net27 vssd1 vssd1 vccd1 vccd1 sky130_fd_sc_hd__diode_2
XFILLER_12_447 vccd1 vssd1 vccd1 vssd1 sky130_ef_sc_hd__decap_40_12
XFILLER_8_418 vssd1 vssd1 vccd1 vccd1 sky130_fd_sc_hd__fill_2
XFILLER_3_167 vssd1 vssd1 vccd1 vccd1 sky130_fd_sc_hd__fill_1
XFILLER_79_447 vssd1 vssd1 vccd1 vccd1 sky130_fd_sc_hd__fill_1
XFILLER_58_63 vssd1 vssd1 vccd1 vccd1 sky130_fd_sc_hd__fill_1
Xhold7 MATMULT_INST.matmult_inst.fsm_inst.alu_result\[11\] vssd1 vssd1 vccd1 vccd1
+ net302 sky130_fd_sc_hd__dlygate4sd3_1
XTAP_TAPCELL_ROW_45_556 vssd1 vccd1 sky130_fd_sc_hd__tapvpwrvgnd_1
XFILLER_15_296 vssd1 vssd1 vccd1 vccd1 sky130_fd_sc_hd__fill_4
X_1820_ MATMULT_INST.matmult_inst.fsm_inst.rx_data\[6\] net577 MATMULT_INST.matmult_inst.spi_inst.rx_done_sys
+ vssd1 vssd1 vccd1 vccd1 _0488_ sky130_fd_sc_hd__mux2_1
XANTENNA__2071__S net21 vssd1 vssd1 vccd1 vccd1 sky130_fd_sc_hd__diode_2
XFILLER_7_440 vssd1 vssd1 vccd1 vccd1 sky130_fd_sc_hd__fill_8
XFILLER_30_299 vssd1 vssd1 vccd1 vccd1 sky130_fd_sc_hd__fill_4
X_1751_ MATMULT_INST.matmult_inst.mem_inst.mem0\[6\] net108 _0665_ net219 _0668_ vssd1
+ vssd1 vccd1 vccd1 _0670_ sky130_fd_sc_hd__a221o_1
X_1682_ net153 net144 MATMULT_INST.matmult_inst.mem_inst.matrixA3\[12\] vssd1 vssd1
+ vccd1 vccd1 _0607_ sky130_fd_sc_hd__and3_1
X_3421_ clknet_leaf_28_clk _0343_ vssd1 vssd1 vccd1 vccd1 MATMULT_INST.matmult_inst.alu_inst.out\[2\]
+ sky130_fd_sc_hd__dfxtp_1
XANTENNA__1763__X _0681_ vssd1 vssd1 vccd1 vccd1 sky130_fd_sc_hd__diode_2
X_3352_ clknet_leaf_8_clk _0274_ vssd1 vssd1 vccd1 vccd1 MATMULT_INST.matmult_inst.mem_inst.mem2\[7\]
+ sky130_fd_sc_hd__dfxtp_1
X_2303_ _0922_ _0923_ vssd1 vssd1 vccd1 vccd1 _0924_ sky130_fd_sc_hd__and2b_1
X_3283_ clknet_leaf_12_clk _0205_ vssd1 vssd1 vccd1 vccd1 MATMULT_INST.matmult_inst.mem_inst.matrixA2\[10\]
+ sky130_fd_sc_hd__dfxtp_1
XFILLER_57_108 vssd1 vssd1 vccd1 vccd1 sky130_fd_sc_hd__fill_4
X_2234_ _0857_ _0865_ vssd1 vssd1 vccd1 vccd1 _0866_ sky130_fd_sc_hd__or2_1
X_2165_ net109 _0812_ net11 net404 vssd1 vssd1 vccd1 vccd1 _0318_ sky130_fd_sc_hd__a22o_1
XFILLER_38_377 vccd1 vssd1 vccd1 vssd1 sky130_ef_sc_hd__decap_40_12
XFILLER_53_314 vccd1 vssd1 vccd1 vssd1 sky130_ef_sc_hd__decap_40_12
X_2096_ net317 net46 net17 vssd1 vssd1 vccd1 vccd1 _0252_ sky130_fd_sc_hd__mux2_1
XFILLER_0_81 vssd1 vssd1 vccd1 vccd1 sky130_fd_sc_hd__fill_2
XANTENNA__2770__A net178 vssd1 vssd1 vccd1 vccd1 sky130_fd_sc_hd__diode_2
XFILLER_21_233 vssd1 vssd1 vccd1 vccd1 sky130_fd_sc_hd__fill_2
X_2998_ _1511_ _1514_ _1518_ vssd1 vssd1 vccd1 vccd1 _1536_ sky130_fd_sc_hd__nor3_1
X_1949_ net438 net46 net30 vssd1 vssd1 vccd1 vccd1 _0126_ sky130_fd_sc_hd__mux2_1
X_3619_ clknet_leaf_24_clk MATMULT_INST.matmult_inst.spi_inst.mosi_data_spi\[3\] _0117_
+ vssd1 vssd1 vccd1 vccd1 MATMULT_INST.matmult_inst.spi_inst.mosi_data_sync\[3\] sky130_fd_sc_hd__dfrtp_1
XTAP_TAPCELL_ROW_8_237 vssd1 vccd1 sky130_fd_sc_hd__tapvpwrvgnd_1
XFILLER_0_137 vssd1 vssd1 vccd1 vccd1 sky130_fd_sc_hd__fill_2
XFILLER_48_108 vssd1 vssd1 vccd1 vccd1 sky130_fd_sc_hd__fill_1
Xteam_02_234 vssd1 vssd1 vccd1 vccd1 team_02_234/HI gpio_oeb[7] sky130_fd_sc_hd__conb_1
Xteam_02_256 vssd1 vssd1 vccd1 vccd1 team_02_256/HI gpio_oeb[29] sky130_fd_sc_hd__conb_1
Xteam_02_245 vssd1 vssd1 vccd1 vccd1 team_02_245/HI gpio_oeb[18] sky130_fd_sc_hd__conb_1
Xteam_02_267 vssd1 vssd1 vccd1 vccd1 team_02_267/HI gpio_out[8] sky130_fd_sc_hd__conb_1
Xteam_02_278 vssd1 vssd1 vccd1 vccd1 team_02_278/HI gpio_out[19] sky130_fd_sc_hd__conb_1
XFILLER_29_333 vssd1 vssd1 vccd1 vccd1 sky130_fd_sc_hd__fill_2
Xteam_02_289 vssd1 vssd1 vccd1 vccd1 team_02_289/HI gpio_out[30] sky130_fd_sc_hd__conb_1
XANTENNA__2156__S net10 vssd1 vssd1 vccd1 vccd1 sky130_fd_sc_hd__diode_2
XFILLER_44_43 vssd1 vssd1 vccd1 vccd1 sky130_fd_sc_hd__fill_1
XTAP_TAPCELL_ROW_42_526 vssd1 vccd1 sky130_fd_sc_hd__tapvpwrvgnd_1
XANTENNA__1995__S net29 vssd1 vssd1 vccd1 vccd1 sky130_fd_sc_hd__diode_2
XANTENNA_fanout29_X net29 vssd1 vssd1 vccd1 vccd1 sky130_fd_sc_hd__diode_2
XFILLER_12_233 vssd1 vssd1 vccd1 vccd1 sky130_fd_sc_hd__fill_2
XFILLER_60_64 vssd1 vssd1 vccd1 vccd1 sky130_fd_sc_hd__fill_8
XFILLER_4_421 vccd1 vssd1 vccd1 vssd1 sky130_ef_sc_hd__decap_40_12
XFILLER_79_233 vccd1 vssd1 vccd1 vssd1 sky130_ef_sc_hd__decap_40_12
XFILLER_69_73 vssd1 vssd1 vccd1 vccd1 sky130_fd_sc_hd__fill_1
XFILLER_79_266 vccd1 vssd1 vccd1 vssd1 sky130_ef_sc_hd__decap_40_12
XFILLER_79_255 vssd1 vssd1 vccd1 vccd1 sky130_fd_sc_hd__fill_4
XPHY_EDGE_ROW_13_Right_13 vssd1 vssd1 vccd1 vccd1 sky130_fd_sc_hd__decap_3
XFILLER_75_461 vccd1 vssd1 vccd1 vssd1 sky130_ef_sc_hd__decap_40_12
XANTENNA__2066__S net21 vssd1 vssd1 vccd1 vccd1 sky130_fd_sc_hd__diode_2
XFILLER_62_177 vssd1 vssd1 vccd1 vccd1 sky130_fd_sc_hd__fill_1
X_2921_ _1459_ _1461_ vssd1 vssd1 vccd1 vccd1 _1462_ sky130_fd_sc_hd__nor2_1
XANTENNA__3459__Q MATMULT_INST.matmult_inst.alu_inst.adder_inst.r1.fa1.a vssd1 vssd1
+ vccd1 vccd1 sky130_fd_sc_hd__diode_2
X_2852_ net157 _1394_ _1393_ vssd1 vssd1 vccd1 vccd1 _1395_ sky130_fd_sc_hd__a21bo_1
X_2783_ _1293_ _1327_ vssd1 vssd1 vccd1 vccd1 _1328_ sky130_fd_sc_hd__xnor2_1
XTAP_TAPCELL_ROW_13_283 vssd1 vccd1 sky130_fd_sc_hd__tapvpwrvgnd_1
XPHY_EDGE_ROW_22_Right_22 vssd1 vssd1 vccd1 vccd1 sky130_fd_sc_hd__decap_3
X_1803_ _0548_ _0713_ _0715_ net219 vssd1 vssd1 vccd1 vccd1 _0717_ sky130_fd_sc_hd__a22o_1
X_1734_ MATMULT_INST.matmult_inst.mem_inst.mem0\[7\] net108 net107 MATMULT_INST.matmult_inst.mem_inst.matrixB0\[7\]
+ vssd1 vssd1 vccd1 vccd1 _0654_ sky130_fd_sc_hd__a22o_1
Xhold226 MATMULT_INST.matmult_inst.mem_inst.mem2\[6\] vssd1 vssd1 vccd1 vccd1 net521
+ sky130_fd_sc_hd__dlygate4sd3_1
Xhold215 MATMULT_INST.matmult_inst.mem_inst.matrixB2\[7\] vssd1 vssd1 vccd1 vccd1
+ net510 sky130_fd_sc_hd__dlygate4sd3_1
Xhold204 MATMULT_INST.matmult_inst.mem_inst.mem2\[7\] vssd1 vssd1 vccd1 vccd1 net499
+ sky130_fd_sc_hd__dlygate4sd3_1
Xhold248 MATMULT_INST.matmult_inst.mem_inst.matrixB2\[14\] vssd1 vssd1 vccd1 vccd1
+ net543 sky130_fd_sc_hd__dlygate4sd3_1
X_1665_ MATMULT_INST.matmult_inst.mem_inst.matrixA0\[14\] net113 net109 MATMULT_INST.matmult_inst.mem_inst.mem0\[14\]
+ vssd1 vssd1 vccd1 vccd1 _0592_ sky130_fd_sc_hd__a22o_1
Xhold237 MATMULT_INST.matmult_inst.alu_inst.row0\[0\] vssd1 vssd1 vccd1 vccd1 net532
+ sky130_fd_sc_hd__dlygate4sd3_1
X_3404_ clknet_leaf_2_clk _0326_ vssd1 vssd1 vccd1 vccd1 MATMULT_INST.matmult_inst.alu_inst.b0_reg\[1\]
+ sky130_fd_sc_hd__dfxtp_1
Xhold259 MATMULT_INST.matmult_inst.mem_inst.mem0\[2\] vssd1 vssd1 vccd1 vccd1 net554
+ sky130_fd_sc_hd__dlygate4sd3_1
X_1596_ MATMULT_INST.matmult_inst.fsm_inst.load_delay vssd1 vssd1 vccd1 vccd1 _1592_
+ sky130_fd_sc_hd__inv_2
X_3335_ clknet_leaf_14_clk _0257_ vssd1 vssd1 vccd1 vccd1 MATMULT_INST.matmult_inst.mem_inst.mem3\[8\]
+ sky130_fd_sc_hd__dfxtp_1
XTAP_TAPCELL_ROW_5_218 vssd1 vccd1 sky130_fd_sc_hd__tapvpwrvgnd_1
X_3266_ clknet_leaf_14_clk _0188_ vssd1 vssd1 vccd1 vccd1 MATMULT_INST.matmult_inst.mem_inst.matrixA3\[11\]
+ sky130_fd_sc_hd__dfxtp_1
XPHY_EDGE_ROW_31_Right_31 vssd1 vssd1 vccd1 vccd1 sky130_fd_sc_hd__decap_3
X_2217_ MATMULT_INST.matmult_inst.alu_inst.adder_inst.r0.fa2.b MATMULT_INST.matmult_inst.alu_inst.adder_inst.r0.fa2.a
+ vssd1 vssd1 vccd1 vccd1 _0851_ sky130_fd_sc_hd__nor2_1
XFILLER_38_130 vssd1 vssd1 vccd1 vccd1 sky130_fd_sc_hd__fill_1
X_3197_ clknet_leaf_26_clk _0000_ vssd1 vssd1 vccd1 vccd1 MATMULT_INST.matmult_inst.fsm_inst.sel\[0\]
+ sky130_fd_sc_hd__dfxtp_1
X_2148_ net452 net32 net13 vssd1 vssd1 vccd1 vccd1 _0302_ sky130_fd_sc_hd__mux2_1
XANTENNA__2682__B1 _1254_ vssd1 vssd1 vccd1 vccd1 sky130_fd_sc_hd__diode_2
X_2079_ net385 _0802_ net18 vssd1 vssd1 vccd1 vccd1 _0236_ sky130_fd_sc_hd__mux2_1
XANTENNA__1788__A2 net128 vssd1 vssd1 vccd1 vccd1 sky130_fd_sc_hd__diode_2
XANTENNA__2704__S _1256_ vssd1 vssd1 vccd1 vccd1 sky130_fd_sc_hd__diode_2
XPHY_EDGE_ROW_40_Right_40 vssd1 vssd1 vccd1 vccd1 sky130_fd_sc_hd__decap_3
XFILLER_30_45 vssd1 vssd1 vccd1 vccd1 sky130_fd_sc_hd__fill_1
XFILLER_1_413 vccd1 vssd1 vccd1 vssd1 sky130_ef_sc_hd__decap_40_12
XFILLER_76_214 vssd1 vssd1 vccd1 vccd1 sky130_fd_sc_hd__fill_1
XFILLER_39_43 vccd1 vssd1 vccd1 vssd1 sky130_ef_sc_hd__decap_40_12
XFILLER_39_65 vssd1 vssd1 vccd1 vccd1 sky130_fd_sc_hd__fill_2
XANTENNA__2673__B1 _1251_ vssd1 vssd1 vccd1 vccd1 sky130_fd_sc_hd__diode_2
XFILLER_72_453 vccd1 vssd1 vccd1 vssd1 sky130_ef_sc_hd__decap_40_12
XTAP_TAPCELL_ROW_55_640 vssd1 vccd1 sky130_fd_sc_hd__tapvpwrvgnd_1
XFILLER_72_475 vssd1 vssd1 vccd1 vccd1 sky130_fd_sc_hd__fill_1
XFILLER_32_306 vssd1 vssd1 vccd1 vccd1 sky130_fd_sc_hd__fill_2
XFILLER_25_391 vssd1 vssd1 vccd1 vccd1 sky130_fd_sc_hd__fill_1
XTAP_TAPCELL_ROW_10_253 vssd1 vccd1 sky130_fd_sc_hd__tapvpwrvgnd_1
XFILLER_58_7 vssd1 vssd1 vccd1 vccd1 sky130_fd_sc_hd__fill_2
XFILLER_4_284 vccd1 vssd1 vccd1 vssd1 sky130_ef_sc_hd__decap_40_12
X_3120_ net226 vssd1 vssd1 vccd1 vccd1 _0027_ sky130_fd_sc_hd__inv_2
XANTENNA__1703__A2 net129 vssd1 vssd1 vccd1 vccd1 sky130_fd_sc_hd__diode_2
X_3051_ net350 _0803_ net8 vssd1 vssd1 vccd1 vccd1 _0470_ sky130_fd_sc_hd__mux2_1
XFILLER_48_450 vssd1 vssd1 vccd1 vccd1 sky130_fd_sc_hd__fill_1
XFILLER_35_111 vssd1 vssd1 vccd1 vccd1 sky130_fd_sc_hd__fill_1
X_2002_ net45 net602 net26 vssd1 vssd1 vccd1 vccd1 _0163_ sky130_fd_sc_hd__mux2_1
XFILLER_35_155 vssd1 vssd1 vccd1 vccd1 sky130_fd_sc_hd__fill_4
XFILLER_63_486 vssd1 vssd1 vccd1 vccd1 sky130_fd_sc_hd__fill_8
X_2904_ _1425_ _1442_ _1443_ vssd1 vssd1 vccd1 vccd1 _1445_ sky130_fd_sc_hd__nand3_1
XANTENNA_clkbuf_0_clk_X clknet_0_clk vssd1 vssd1 vccd1 vccd1 sky130_fd_sc_hd__diode_2
XTAP_TAPCELL_ROW_61_687 vssd1 vccd1 sky130_fd_sc_hd__tapvpwrvgnd_1
X_2835_ _1375_ _1376_ _1340_ vssd1 vssd1 vccd1 vccd1 _1378_ sky130_fd_sc_hd__a21o_1
X_2766_ _1310_ _1311_ vssd1 vssd1 vccd1 vccd1 _1312_ sky130_fd_sc_hd__nand2_1
X_2697_ _1243_ net532 _1256_ vssd1 vssd1 vccd1 vccd1 _0416_ sky130_fd_sc_hd__mux2_1
X_1717_ MATMULT_INST.matmult_inst.mem_inst.matrixA0\[9\] net113 net109 MATMULT_INST.matmult_inst.mem_inst.mem0\[9\]
+ vssd1 vssd1 vccd1 vccd1 _0639_ sky130_fd_sc_hd__a22o_1
X_1648_ net151 net141 MATMULT_INST.matmult_inst.mem_inst.matrixB3\[15\] vssd1 vssd1
+ vccd1 vccd1 _0576_ sky130_fd_sc_hd__and3_1
XANTENNA__1942__A2 net71 vssd1 vssd1 vccd1 vccd1 sky130_fd_sc_hd__diode_2
X_3318_ clknet_leaf_18_clk _0240_ vssd1 vssd1 vccd1 vccd1 MATMULT_INST.matmult_inst.mem_inst.matrixA0\[9\]
+ sky130_fd_sc_hd__dfxtp_1
XFILLER_73_217 vssd1 vssd1 vccd1 vccd1 sky130_fd_sc_hd__fill_1
X_3249_ clknet_leaf_19_clk _0171_ vssd1 vssd1 vccd1 vccd1 MATMULT_INST.matmult_inst.mem_inst.matrixB0\[12\]
+ sky130_fd_sc_hd__dfxtp_1
XFILLER_58_269 vssd1 vssd1 vccd1 vccd1 sky130_fd_sc_hd__fill_1
XTAP_TAPCELL_ROW_52_610 vssd1 vccd1 sky130_fd_sc_hd__tapvpwrvgnd_1
XFILLER_25_67 vssd1 vssd1 vccd1 vccd1 sky130_fd_sc_hd__fill_1
XTAP_TAPCELL_ROW_24_378 vssd1 vccd1 sky130_fd_sc_hd__tapvpwrvgnd_1
XFILLER_22_394 vccd1 vssd1 vccd1 vssd1 sky130_ef_sc_hd__decap_40_12
XANTENNA_fanout96_X net96 vssd1 vssd1 vccd1 vccd1 sky130_fd_sc_hd__diode_2
XFILLER_49_203 vssd1 vssd1 vccd1 vccd1 sky130_fd_sc_hd__fill_1
XFILLER_66_63 vssd1 vssd1 vccd1 vccd1 sky130_fd_sc_hd__fill_4
XFILLER_37_409 vccd1 vssd1 vccd1 vssd1 sky130_ef_sc_hd__decap_40_12
XFILLER_66_85 vssd1 vssd1 vccd1 vccd1 sky130_fd_sc_hd__fill_1
XFILLER_17_111 vssd1 vssd1 vccd1 vccd1 sky130_fd_sc_hd__fill_1
XFILLER_57_291 vssd1 vssd1 vccd1 vccd1 sky130_fd_sc_hd__fill_2
XTAP_TAPCELL_ROW_15_301 vssd1 vccd1 sky130_fd_sc_hd__tapvpwrvgnd_1
XFILLER_45_475 vssd1 vssd1 vccd1 vccd1 sky130_fd_sc_hd__fill_2
XFILLER_60_434 vssd1 vssd1 vccd1 vccd1 sky130_fd_sc_hd__fill_1
XFILLER_70_6 vssd1 vssd1 vccd1 vccd1 sky130_fd_sc_hd__fill_1
XFILLER_9_365 vssd1 vssd1 vccd1 vccd1 sky130_fd_sc_hd__fill_1
X_2620_ _1207_ _1208_ vssd1 vssd1 vccd1 vccd1 _1209_ sky130_fd_sc_hd__nand2_1
X_2551_ _1065_ _1068_ _1098_ _1099_ _1066_ vssd1 vssd1 vccd1 vccd1 _1143_ sky130_fd_sc_hd__o221a_1
X_2482_ _1053_ _1059_ _1060_ _1072_ _1052_ vssd1 vssd1 vccd1 vccd1 _1075_ sky130_fd_sc_hd__a311o_1
XFILLER_49_3 vssd1 vssd1 vccd1 vccd1 sky130_fd_sc_hd__fill_8
X_3103_ net59 net89 net78 vssd1 vssd1 vccd1 vccd1 _0057_ sky130_fd_sc_hd__and3_1
XTAP_TAPCELL_ROW_66_735 vssd1 vccd1 sky130_fd_sc_hd__tapvpwrvgnd_1
X_3034_ net170 net155 _1542_ _1560_ _1535_ vssd1 vssd1 vccd1 vccd1 _1570_ sky130_fd_sc_hd__a311o_1
XFILLER_55_239 vssd1 vssd1 vccd1 vccd1 sky130_fd_sc_hd__fill_8
XFILLER_23_169 vssd1 vssd1 vccd1 vccd1 sky130_fd_sc_hd__fill_2
XANTENNA_fanout143_A net145 vssd1 vssd1 vccd1 vccd1 sky130_fd_sc_hd__diode_2
XTAP_TAPCELL_ROW_21_348 vssd1 vccd1 sky130_fd_sc_hd__tapvpwrvgnd_1
XANTENNA__1946__X _0799_ vssd1 vssd1 vccd1 vccd1 sky130_fd_sc_hd__diode_2
X_2818_ _1347_ _1348_ _1360_ vssd1 vssd1 vccd1 vccd1 _1362_ sky130_fd_sc_hd__a21oi_1
X_2749_ net168 net177 net179 net166 vssd1 vssd1 vccd1 vccd1 _1295_ sky130_fd_sc_hd__a22o_1
XANTENNA__2168__A2 net93 vssd1 vssd1 vccd1 vccd1 sky130_fd_sc_hd__diode_2
XTAP_TAPCELL_ROW_29_415 vssd1 vccd1 sky130_fd_sc_hd__tapvpwrvgnd_1
XFILLER_14_125 vssd1 vssd1 vccd1 vccd1 sky130_fd_sc_hd__fill_2
XFILLER_10_342 vccd1 vssd1 vccd1 vssd1 sky130_ef_sc_hd__decap_40_12
XFILLER_22_180 vccd1 vssd1 vccd1 vssd1 sky130_ef_sc_hd__decap_40_12
XFILLER_10_375 vccd1 vssd1 vccd1 vssd1 sky130_ef_sc_hd__decap_40_12
XFILLER_6_313 vssd1 vssd1 vccd1 vccd1 sky130_fd_sc_hd__fill_1
XFILLER_6_357 vssd1 vssd1 vccd1 vccd1 sky130_fd_sc_hd__fill_4
XFILLER_77_95 vssd1 vssd1 vccd1 vccd1 sky130_fd_sc_hd__fill_1
XTAP_TAPCELL_ROW_63_705 vssd1 vccd1 sky130_fd_sc_hd__tapvpwrvgnd_1
XFILLER_45_272 vssd1 vssd1 vccd1 vccd1 sky130_fd_sc_hd__fill_8
XANTENNA__2074__S net18 vssd1 vssd1 vccd1 vccd1 sky130_fd_sc_hd__diode_2
XFILLER_60_242 vssd1 vssd1 vccd1 vccd1 sky130_fd_sc_hd__fill_8
XFILLER_20_139 vssd1 vssd1 vccd1 vccd1 sky130_fd_sc_hd__fill_1
XFILLER_33_489 vssd1 vssd1 vccd1 vccd1 sky130_fd_sc_hd__fill_4
X_1982_ net461 net46 net28 vssd1 vssd1 vccd1 vccd1 _0144_ sky130_fd_sc_hd__mux2_1
XFILLER_13_180 vccd1 vssd1 vccd1 vssd1 sky130_ef_sc_hd__decap_40_12
XFILLER_9_184 vssd1 vssd1 vccd1 vccd1 sky130_fd_sc_hd__fill_4
X_2603_ _1164_ _1165_ _1150_ vssd1 vssd1 vccd1 vccd1 _1193_ sky130_fd_sc_hd__o21bai_1
X_3583_ net224 _0016_ _0081_ vssd1 vssd1 vccd1 vccd1 MATMULT_INST.matmult_inst.spi_inst.miso_shifter\[3\]
+ sky130_fd_sc_hd__dfrtp_1
X_2534_ _1088_ _1125_ _1124_ vssd1 vssd1 vccd1 vccd1 _1126_ sky130_fd_sc_hd__a21o_1
X_2465_ _1055_ _1058_ vssd1 vssd1 vccd1 vccd1 _1059_ sky130_fd_sc_hd__nand2_1
XFILLER_68_331 vssd1 vssd1 vccd1 vccd1 sky130_fd_sc_hd__fill_8
X_2396_ net197 _0991_ _0990_ vssd1 vssd1 vccd1 vccd1 _0992_ sky130_fd_sc_hd__a21bo_1
X_3017_ _1550_ _1552_ _1553_ _1529_ vssd1 vssd1 vccd1 vccd1 _1555_ sky130_fd_sc_hd__a22o_1
XFILLER_24_401 vssd1 vssd1 vccd1 vccd1 sky130_fd_sc_hd__fill_2
XANTENNA__2923__D net178 vssd1 vssd1 vccd1 vccd1 sky130_fd_sc_hd__diode_2
XTAP_TAPCELL_ROW_34_462 vssd1 vccd1 sky130_fd_sc_hd__tapvpwrvgnd_1
XANTENNA__1676__X _0602_ vssd1 vssd1 vccd1 vccd1 sky130_fd_sc_hd__diode_2
XFILLER_22_46 vssd1 vssd1 vccd1 vccd1 sky130_fd_sc_hd__fill_1
XFILLER_3_349 vssd1 vssd1 vccd1 vccd1 sky130_fd_sc_hd__fill_2
Xfanout130 net131 vssd1 vssd1 vccd1 vccd1 net130 sky130_fd_sc_hd__clkbuf_2
Xfanout152 net154 vssd1 vssd1 vccd1 vccd1 net152 sky130_fd_sc_hd__clkbuf_2
Xfanout174 MATMULT_INST.matmult_inst.alu_inst.b1_reg\[5\] vssd1 vssd1 vccd1 vccd1
+ net174 sky130_fd_sc_hd__buf_2
Xfanout163 MATMULT_INST.matmult_inst.alu_inst.a1_reg\[3\] vssd1 vssd1 vccd1 vccd1
+ net163 sky130_fd_sc_hd__dlymetal6s2s_1
Xfanout141 net145 vssd1 vssd1 vccd1 vccd1 net141 sky130_fd_sc_hd__buf_2
Xfanout185 MATMULT_INST.matmult_inst.alu_inst.a0_reg\[7\] vssd1 vssd1 vccd1 vccd1
+ net185 sky130_fd_sc_hd__buf_2
Xfanout196 MATMULT_INST.matmult_inst.alu_inst.a0_reg\[1\] vssd1 vssd1 vccd1 vccd1
+ net196 sky130_fd_sc_hd__dlymetal6s2s_1
XFILLER_19_239 vssd1 vssd1 vccd1 vccd1 sky130_fd_sc_hd__fill_1
XANTENNA__1998__S net26 vssd1 vssd1 vccd1 vccd1 sky130_fd_sc_hd__diode_2
XANTENNA__2077__A1 _0800_ vssd1 vssd1 vccd1 vccd1 sky130_fd_sc_hd__diode_2
XPHY_EDGE_ROW_69_Right_69 vssd1 vssd1 vccd1 vccd1 sky130_fd_sc_hd__decap_3
XFILLER_63_53 vssd1 vssd1 vccd1 vccd1 sky130_fd_sc_hd__fill_2
XFILLER_15_467 vssd1 vssd1 vccd1 vccd1 sky130_fd_sc_hd__fill_1
XFILLER_8_48 vssd1 vssd1 vccd1 vccd1 sky130_fd_sc_hd__fill_1
XFILLER_10_150 vccd1 vssd1 vccd1 vssd1 sky130_ef_sc_hd__decap_40_12
XFILLER_10_194 vssd1 vssd1 vccd1 vccd1 sky130_fd_sc_hd__fill_2
XFILLER_6_165 vccd1 vssd1 vccd1 vssd1 sky130_ef_sc_hd__decap_40_12
XPHY_EDGE_ROW_78_Right_78 vssd1 vssd1 vccd1 vccd1 sky130_fd_sc_hd__decap_3
XFILLER_69_106 vssd1 vssd1 vccd1 vccd1 sky130_fd_sc_hd__fill_4
XFILLER_69_139 vssd1 vssd1 vccd1 vccd1 sky130_fd_sc_hd__fill_4
X_2250_ net555 _0879_ net100 vssd1 vssd1 vccd1 vccd1 _0347_ sky130_fd_sc_hd__mux2_1
XANTENNA__2069__S net20 vssd1 vssd1 vccd1 vccd1 sky130_fd_sc_hd__diode_2
X_2181_ _0731_ _0771_ _0836_ vssd1 vssd1 vccd1 vccd1 _0837_ sky130_fd_sc_hd__and3_1
XTAP_TAPCELL_ROW_48_576 vssd1 vccd1 sky130_fd_sc_hd__tapvpwrvgnd_1
XANTENNA__1815__A1 net216 vssd1 vssd1 vccd1 vccd1 sky130_fd_sc_hd__diode_2
XANTENNA__1815__B2 net222 vssd1 vssd1 vccd1 vccd1 sky130_fd_sc_hd__diode_2
XFILLER_21_426 vssd1 vssd1 vccd1 vccd1 sky130_fd_sc_hd__fill_2
X_1965_ net594 net38 net31 vssd1 vssd1 vccd1 vccd1 _0134_ sky130_fd_sc_hd__mux2_1
XTAP_TAPCELL_ROW_31_432 vssd1 vccd1 sky130_fd_sc_hd__tapvpwrvgnd_1
X_1896_ MATMULT_INST.matmult_inst.fsm_inst.rx_ready_edge _0773_ net72 vssd1 vssd1
+ vccd1 vccd1 _0774_ sky130_fd_sc_hd__o21ai_1
X_3635_ clknet_leaf_25_clk net303 vssd1 vssd1 vccd1 vccd1 MATMULT_INST.matmult_inst.fsm_inst.alu_result\[11\]
+ sky130_fd_sc_hd__dfxtp_1
X_3566_ clknet_leaf_10_clk _0478_ vssd1 vssd1 vccd1 vccd1 MATMULT_INST.matmult_inst.mem_inst.matrixB3\[14\]
+ sky130_fd_sc_hd__dfxtp_1
XANTENNA_fanout106_A net107 vssd1 vssd1 vccd1 vccd1 sky130_fd_sc_hd__diode_2
X_2517_ net190 net204 vssd1 vssd1 vccd1 vccd1 _1109_ sky130_fd_sc_hd__and2_1
X_3497_ clknet_leaf_24_clk _0004_ vssd1 vssd1 vccd1 vccd1 MATMULT_INST.matmult_inst.fsm_inst.rx_ready_edge
+ sky130_fd_sc_hd__dfxtp_1
X_2448_ _1018_ _1040_ _1041_ vssd1 vssd1 vccd1 vccd1 _1042_ sky130_fd_sc_hd__nand3_1
XANTENNA__1672__A net150 vssd1 vssd1 vccd1 vccd1 sky130_fd_sc_hd__diode_2
X_2379_ _0974_ _0975_ vssd1 vssd1 vccd1 vccd1 _0976_ sky130_fd_sc_hd__nand2_1
XFILLER_68_183 vccd1 vssd1 vccd1 vssd1 sky130_ef_sc_hd__decap_40_12
XFILLER_17_35 vssd1 vssd1 vccd1 vccd1 sky130_fd_sc_hd__fill_8
XFILLER_24_242 vssd1 vssd1 vccd1 vccd1 sky130_fd_sc_hd__fill_2
XANTENNA__2950__B net178 vssd1 vssd1 vccd1 vccd1 sky130_fd_sc_hd__diode_2
XANTENNA_fanout19_A _0820_ vssd1 vssd1 vccd1 vccd1 sky130_fd_sc_hd__diode_2
XFILLER_3_113 vssd1 vssd1 vccd1 vccd1 sky130_fd_sc_hd__fill_1
XFILLER_3_179 vssd1 vssd1 vccd1 vccd1 sky130_fd_sc_hd__fill_1
XANTENNA__2828__D net173 vssd1 vssd1 vccd1 vccd1 sky130_fd_sc_hd__diode_2
Xhold8 _0519_ vssd1 vssd1 vccd1 vccd1 net303 sky130_fd_sc_hd__dlygate4sd3_1
XFILLER_74_197 vssd1 vssd1 vccd1 vccd1 sky130_fd_sc_hd__fill_1
XFILLER_74_186 vssd1 vssd1 vccd1 vccd1 sky130_fd_sc_hd__fill_2
XTAP_TAPCELL_ROW_2_190 vssd1 vccd1 sky130_fd_sc_hd__tapvpwrvgnd_1
XFILLER_15_220 vssd1 vssd1 vccd1 vccd1 sky130_fd_sc_hd__fill_4
XTAP_TAPCELL_ROW_45_557 vssd1 vccd1 sky130_fd_sc_hd__tapvpwrvgnd_1
X_1750_ net222 _0663_ _0667_ net216 vssd1 vssd1 vccd1 vccd1 _0669_ sky130_fd_sc_hd__a22o_1
X_1681_ MATMULT_INST.matmult_inst.mem_inst.mem1\[12\] net130 net122 MATMULT_INST.matmult_inst.mem_inst.mem2\[12\]
+ _0605_ vssd1 vssd1 vccd1 vccd1 _0606_ sky130_fd_sc_hd__a221o_1
X_3420_ clknet_leaf_28_clk _0342_ vssd1 vssd1 vccd1 vccd1 MATMULT_INST.matmult_inst.alu_inst.out\[1\]
+ sky130_fd_sc_hd__dfxtp_1
X_3351_ clknet_leaf_7_clk _0273_ vssd1 vssd1 vccd1 vccd1 MATMULT_INST.matmult_inst.mem_inst.mem2\[6\]
+ sky130_fd_sc_hd__dfxtp_1
X_2302_ MATMULT_INST.matmult_inst.alu_inst.adder_inst.r3.fa3.b MATMULT_INST.matmult_inst.alu_inst.adder_inst.r3.fa3.a
+ vssd1 vssd1 vccd1 vccd1 _0923_ sky130_fd_sc_hd__nand2_1
XFILLER_31_3 vccd1 vssd1 vccd1 vssd1 sky130_ef_sc_hd__decap_40_12
X_3282_ clknet_leaf_16_clk _0204_ vssd1 vssd1 vccd1 vccd1 MATMULT_INST.matmult_inst.mem_inst.matrixA2\[9\]
+ sky130_fd_sc_hd__dfxtp_1
XFILLER_78_481 vssd1 vssd1 vccd1 vccd1 sky130_fd_sc_hd__fill_1
X_2233_ _0847_ _0851_ _0854_ _0858_ _0852_ vssd1 vssd1 vccd1 vccd1 _0865_ sky130_fd_sc_hd__o311a_1
XFILLER_38_312 vssd1 vssd1 vccd1 vccd1 sky130_fd_sc_hd__fill_8
X_2164_ net109 _0811_ net11 net428 vssd1 vssd1 vccd1 vccd1 _0317_ sky130_fd_sc_hd__a22o_1
XFILLER_38_334 vssd1 vssd1 vccd1 vccd1 sky130_fd_sc_hd__fill_1
X_2095_ net370 net47 net17 vssd1 vssd1 vccd1 vccd1 _0251_ sky130_fd_sc_hd__mux2_1
XFILLER_53_326 vssd1 vssd1 vccd1 vccd1 sky130_fd_sc_hd__fill_8
XFILLER_53_337 vssd1 vssd1 vccd1 vccd1 sky130_fd_sc_hd__fill_4
XFILLER_21_223 vssd1 vssd1 vccd1 vccd1 sky130_fd_sc_hd__fill_1
X_2997_ _1514_ _1518_ _1511_ vssd1 vssd1 vccd1 vccd1 _1535_ sky130_fd_sc_hd__o21a_1
X_1948_ MATMULT_INST.matmult_inst.fsm_inst.rx_data\[3\] net71 net70 MATMULT_INST.matmult_inst.fsm_inst.alu_result\[3\]
+ vssd1 vssd1 vccd1 vccd1 _0800_ sky130_fd_sc_hd__a22o_1
X_1879_ MATMULT_INST.matmult_inst.fsm_inst.state\[1\] MATMULT_INST.matmult_inst.fsm_inst.state\[0\]
+ vssd1 vssd1 vccd1 vccd1 _0757_ sky130_fd_sc_hd__or2_2
XANTENNA__1954__X _0803_ vssd1 vssd1 vccd1 vccd1 sky130_fd_sc_hd__diode_2
X_3618_ clknet_leaf_22_clk MATMULT_INST.matmult_inst.spi_inst.mosi_data_spi\[2\] _0116_
+ vssd1 vssd1 vccd1 vccd1 MATMULT_INST.matmult_inst.spi_inst.mosi_data_sync\[2\] sky130_fd_sc_hd__dfrtp_1
X_3549_ _0064_ _0462_ _0063_ vssd1 vssd1 vccd1 vccd1 MATMULT_INST.matmult_inst.spi_inst.mosi_shifter\[5\]
+ sky130_fd_sc_hd__dfrtp_1
XANTENNA__1724__B1 net121 vssd1 vssd1 vccd1 vccd1 sky130_fd_sc_hd__diode_2
XTAP_TAPCELL_ROW_8_238 vssd1 vccd1 sky130_fd_sc_hd__tapvpwrvgnd_1
Xteam_02_235 vssd1 vssd1 vccd1 vccd1 team_02_235/HI gpio_oeb[8] sky130_fd_sc_hd__conb_1
Xteam_02_257 vssd1 vssd1 vccd1 vccd1 team_02_257/HI gpio_oeb[30] sky130_fd_sc_hd__conb_1
Xteam_02_268 vssd1 vssd1 vccd1 vccd1 team_02_268/HI gpio_out[9] sky130_fd_sc_hd__conb_1
Xteam_02_246 vssd1 vssd1 vccd1 vccd1 team_02_246/HI gpio_oeb[19] sky130_fd_sc_hd__conb_1
XFILLER_28_56 vssd1 vssd1 vccd1 vccd1 sky130_fd_sc_hd__fill_1
Xteam_02_279 vssd1 vssd1 vccd1 vccd1 team_02_279/HI gpio_out[20] sky130_fd_sc_hd__conb_1
XANTENNA__2437__S net98 vssd1 vssd1 vccd1 vccd1 sky130_fd_sc_hd__diode_2
XFILLER_28_89 vssd1 vssd1 vccd1 vccd1 sky130_fd_sc_hd__fill_2
XFILLER_44_22 vssd1 vssd1 vccd1 vccd1 sky130_fd_sc_hd__fill_1
XFILLER_12_201 vssd1 vssd1 vccd1 vccd1 sky130_fd_sc_hd__fill_1
XTAP_TAPCELL_ROW_42_527 vssd1 vccd1 sky130_fd_sc_hd__tapvpwrvgnd_1
XFILLER_44_66 vssd1 vssd1 vccd1 vccd1 sky130_fd_sc_hd__fill_2
XFILLER_8_205 vssd1 vssd1 vccd1 vccd1 sky130_fd_sc_hd__fill_1
XANTENNA_clkbuf_leaf_22_clk_A clknet_2_3__leaf_clk vssd1 vssd1 vccd1 vccd1 sky130_fd_sc_hd__diode_2
XTAP_TAPCELL_ROW_50_593 vssd1 vccd1 sky130_fd_sc_hd__tapvpwrvgnd_1
XFILLER_4_400 vccd1 vssd1 vccd1 vssd1 sky130_ef_sc_hd__decap_40_12
XFILLER_4_433 vccd1 vssd1 vccd1 vssd1 sky130_ef_sc_hd__decap_40_12
XFILLER_4_477 vccd1 vssd1 vccd1 vssd1 sky130_ef_sc_hd__decap_40_12
XANTENNA_clkbuf_leaf_37_clk_A clknet_2_0__leaf_clk vssd1 vssd1 vccd1 vccd1 sky130_fd_sc_hd__diode_2
XFILLER_79_223 vssd1 vssd1 vccd1 vccd1 sky130_fd_sc_hd__fill_1
XFILLER_79_245 vssd1 vssd1 vccd1 vccd1 sky130_fd_sc_hd__fill_4
XFILLER_79_289 vssd1 vssd1 vccd1 vccd1 sky130_fd_sc_hd__fill_1
XFILLER_79_278 vssd1 vssd1 vccd1 vccd1 sky130_fd_sc_hd__fill_2
XFILLER_67_429 vssd1 vssd1 vccd1 vccd1 sky130_fd_sc_hd__fill_8
XFILLER_75_473 vccd1 vssd1 vccd1 vssd1 sky130_ef_sc_hd__decap_40_12
Xclkbuf_2_3__f_clk clknet_0_clk vssd1 vssd1 vccd1 vccd1 clknet_2_3__leaf_clk sky130_fd_sc_hd__clkbuf_16
XANTENNA_clkload1_A clknet_2_2__leaf_clk vssd1 vssd1 vccd1 vccd1 sky130_fd_sc_hd__diode_2
XANTENNA__2691__A1 net93 vssd1 vssd1 vccd1 vccd1 sky130_fd_sc_hd__diode_2
XFILLER_35_337 vccd1 vssd1 vccd1 vssd1 sky130_ef_sc_hd__decap_40_12
X_2920_ _1453_ _1458_ vssd1 vssd1 vccd1 vccd1 _1461_ sky130_fd_sc_hd__nor2_1
XFILLER_50_307 vssd1 vssd1 vccd1 vccd1 sky130_fd_sc_hd__fill_1
XANTENNA__2082__S net19 vssd1 vssd1 vccd1 vccd1 sky130_fd_sc_hd__diode_2
X_2851_ net182 net159 net181 vssd1 vssd1 vccd1 vccd1 _1394_ sky130_fd_sc_hd__and3_1
XPHY_EDGE_ROW_28_Left_108 vssd1 vssd1 vccd1 vccd1 sky130_fd_sc_hd__decap_3
X_2782_ net169 _1326_ _1325_ vssd1 vssd1 vccd1 vccd1 _1327_ sky130_fd_sc_hd__a21bo_1
XTAP_TAPCELL_ROW_13_284 vssd1 vccd1 sky130_fd_sc_hd__tapvpwrvgnd_1
X_1802_ MATMULT_INST.matmult_inst.mem_inst.mem1\[1\] net125 net117 MATMULT_INST.matmult_inst.mem_inst.mem2\[1\]
+ vssd1 vssd1 vccd1 vccd1 _0716_ sky130_fd_sc_hd__a22o_1
XANTENNA__1774__X _0691_ vssd1 vssd1 vccd1 vccd1 sky130_fd_sc_hd__diode_2
X_1733_ MATMULT_INST.matmult_inst.mem_inst.matrixB1\[7\] net124 net116 MATMULT_INST.matmult_inst.mem_inst.matrixB2\[7\]
+ _0652_ vssd1 vssd1 vccd1 vccd1 _0653_ sky130_fd_sc_hd__a221o_1
Xhold216 MATMULT_INST.matmult_inst.mem_inst.mem2\[9\] vssd1 vssd1 vccd1 vccd1 net511
+ sky130_fd_sc_hd__dlygate4sd3_1
XFILLER_7_271 vssd1 vssd1 vccd1 vccd1 sky130_fd_sc_hd__fill_8
Xhold205 MATMULT_INST.matmult_inst.mem_inst.matrixB0\[1\] vssd1 vssd1 vccd1 vccd1
+ net500 sky130_fd_sc_hd__dlygate4sd3_1
X_1664_ net223 _0585_ _0590_ vssd1 vssd1 vccd1 vccd1 _0591_ sky130_fd_sc_hd__a21o_1
X_3403_ clknet_leaf_3_clk _0325_ vssd1 vssd1 vccd1 vccd1 MATMULT_INST.matmult_inst.alu_inst.b0_reg\[0\]
+ sky130_fd_sc_hd__dfxtp_1
Xhold238 MATMULT_INST.matmult_inst.mem_inst.matrixA2\[6\] vssd1 vssd1 vccd1 vccd1
+ net533 sky130_fd_sc_hd__dlygate4sd3_1
Xhold249 MATMULT_INST.matmult_inst.mem_inst.matrixA2\[9\] vssd1 vssd1 vccd1 vccd1
+ net544 sky130_fd_sc_hd__dlygate4sd3_1
Xhold227 MATMULT_INST.matmult_inst.mem_inst.mem2\[10\] vssd1 vssd1 vccd1 vccd1 net522
+ sky130_fd_sc_hd__dlygate4sd3_1
XPHY_EDGE_ROW_37_Left_117 vssd1 vssd1 vccd1 vccd1 sky130_fd_sc_hd__decap_3
XANTENNA__2111__A net217 vssd1 vssd1 vccd1 vccd1 sky130_fd_sc_hd__diode_2
X_3334_ clknet_leaf_8_clk _0256_ vssd1 vssd1 vccd1 vccd1 MATMULT_INST.matmult_inst.mem_inst.mem3\[7\]
+ sky130_fd_sc_hd__dfxtp_1
X_3265_ clknet_leaf_12_clk _0187_ vssd1 vssd1 vccd1 vccd1 MATMULT_INST.matmult_inst.mem_inst.matrixA3\[10\]
+ sky130_fd_sc_hd__dfxtp_1
X_2216_ net419 _0850_ net100 vssd1 vssd1 vccd1 vccd1 _0342_ sky130_fd_sc_hd__mux2_1
X_3196_ net55 net90 net77 vssd1 vssd1 vccd1 vccd1 _0121_ sky130_fd_sc_hd__and3_1
X_2147_ net429 _0813_ net12 vssd1 vssd1 vccd1 vccd1 _0301_ sky130_fd_sc_hd__mux2_1
XANTENNA__2682__A1 net82 vssd1 vssd1 vccd1 vccd1 sky130_fd_sc_hd__diode_2
X_2078_ net393 _0801_ net18 vssd1 vssd1 vccd1 vccd1 _0235_ sky130_fd_sc_hd__mux2_1
XPHY_EDGE_ROW_46_Left_126 vssd1 vssd1 vccd1 vccd1 sky130_fd_sc_hd__decap_3
XANTENNA__3117__A net62 vssd1 vssd1 vccd1 vccd1 sky130_fd_sc_hd__diode_2
XFILLER_1_425 vccd1 vssd1 vccd1 vssd1 sky130_ef_sc_hd__decap_40_12
XPHY_EDGE_ROW_55_Left_135 vssd1 vssd1 vccd1 vccd1 sky130_fd_sc_hd__decap_3
XFILLER_1_447 vssd1 vssd1 vccd1 vccd1 sky130_fd_sc_hd__fill_1
XANTENNA_fanout86_A _0735_ vssd1 vssd1 vccd1 vccd1 sky130_fd_sc_hd__diode_2
XFILLER_39_55 vssd1 vssd1 vccd1 vccd1 sky130_fd_sc_hd__fill_1
XFILLER_72_421 vccd1 vssd1 vccd1 vssd1 sky130_ef_sc_hd__decap_40_12
XFILLER_72_410 vssd1 vssd1 vccd1 vccd1 sky130_fd_sc_hd__fill_8
XANTENNA__2673__B2 net103 vssd1 vssd1 vccd1 vccd1 sky130_fd_sc_hd__diode_2
XFILLER_72_465 vssd1 vssd1 vccd1 vccd1 sky130_fd_sc_hd__fill_8
XFILLER_55_54 vssd1 vssd1 vccd1 vccd1 sky130_fd_sc_hd__fill_2
XTAP_TAPCELL_ROW_55_641 vssd1 vccd1 sky130_fd_sc_hd__tapvpwrvgnd_1
XPHY_EDGE_ROW_64_Left_144 vssd1 vssd1 vccd1 vccd1 sky130_fd_sc_hd__decap_3
XTAP_TAPCELL_ROW_27_398 vssd1 vccd1 sky130_fd_sc_hd__tapvpwrvgnd_1
XANTENNA__1633__C1 _0545_ vssd1 vssd1 vccd1 vccd1 sky130_fd_sc_hd__diode_2
XTAP_TAPCELL_ROW_10_254 vssd1 vccd1 sky130_fd_sc_hd__tapvpwrvgnd_1
XPHY_EDGE_ROW_73_Left_153 vssd1 vssd1 vccd1 vccd1 sky130_fd_sc_hd__decap_3
XFILLER_4_296 vssd1 vssd1 vccd1 vccd1 sky130_fd_sc_hd__fill_4
X_3050_ net467 net44 net8 vssd1 vssd1 vccd1 vccd1 _0469_ sky130_fd_sc_hd__mux2_1
X_2001_ _0800_ net584 net26 vssd1 vssd1 vccd1 vccd1 _0162_ sky130_fd_sc_hd__mux2_1
XANTENNA__2077__S net18 vssd1 vssd1 vccd1 vccd1 sky130_fd_sc_hd__diode_2
XFILLER_48_484 vssd1 vssd1 vccd1 vccd1 sky130_fd_sc_hd__fill_8
XFILLER_63_465 vssd1 vssd1 vccd1 vccd1 sky130_fd_sc_hd__fill_1
XTAP_TAPCELL_ROW_18_321 vssd1 vccd1 sky130_fd_sc_hd__tapvpwrvgnd_1
X_2903_ _1425_ _1443_ _1442_ vssd1 vssd1 vccd1 vccd1 _1444_ sky130_fd_sc_hd__a21o_1
X_2834_ _1340_ _1375_ _1376_ vssd1 vssd1 vccd1 vccd1 _1377_ sky130_fd_sc_hd__nand3_1
XTAP_TAPCELL_ROW_61_688 vssd1 vccd1 sky130_fd_sc_hd__tapvpwrvgnd_1
X_2765_ _1306_ _1307_ _1309_ vssd1 vssd1 vccd1 vccd1 _1311_ sky130_fd_sc_hd__nand3_1
X_2696_ _0787_ _1244_ vssd1 vssd1 vccd1 vccd1 _1256_ sky130_fd_sc_hd__nor2_4
X_1716_ MATMULT_INST.matmult_inst.mem_inst.matrixA1\[9\] net129 net121 MATMULT_INST.matmult_inst.mem_inst.matrixA2\[9\]
+ _0637_ vssd1 vssd1 vccd1 vccd1 _0638_ sky130_fd_sc_hd__a221o_1
X_1647_ MATMULT_INST.matmult_inst.mem_inst.matrixA0\[15\] net113 _0574_ _0545_ vssd1
+ vssd1 vccd1 vccd1 _0575_ sky130_fd_sc_hd__a211o_1
X_3317_ clknet_leaf_18_clk _0239_ vssd1 vssd1 vccd1 vccd1 MATMULT_INST.matmult_inst.mem_inst.matrixA0\[8\]
+ sky130_fd_sc_hd__dfxtp_1
XTAP_TAPCELL_ROW_69_755 vssd1 vccd1 sky130_fd_sc_hd__tapvpwrvgnd_1
X_3248_ clknet_leaf_21_clk _0170_ vssd1 vssd1 vccd1 vccd1 MATMULT_INST.matmult_inst.mem_inst.matrixB0\[11\]
+ sky130_fd_sc_hd__dfxtp_1
XFILLER_39_440 vssd1 vssd1 vccd1 vccd1 sky130_fd_sc_hd__fill_1
XANTENNA_fanout176_X net176 vssd1 vssd1 vccd1 vccd1 sky130_fd_sc_hd__diode_2
X_3179_ net58 net87 net73 vssd1 vssd1 vccd1 vccd1 _0104_ sky130_fd_sc_hd__and3_1
XFILLER_54_432 vccd1 vssd1 vccd1 vssd1 sky130_ef_sc_hd__decap_40_12
XFILLER_14_307 vssd1 vssd1 vccd1 vccd1 sky130_fd_sc_hd__fill_1
XTAP_TAPCELL_ROW_52_611 vssd1 vccd1 sky130_fd_sc_hd__tapvpwrvgnd_1
XANTENNA__2407__B2 net208 vssd1 vssd1 vccd1 vccd1 sky130_fd_sc_hd__diode_2
XTAP_TAPCELL_ROW_24_379 vssd1 vccd1 sky130_fd_sc_hd__tapvpwrvgnd_1
XFILLER_41_78 vssd1 vssd1 vccd1 vccd1 sky130_fd_sc_hd__fill_2
XFILLER_45_432 vssd1 vssd1 vccd1 vccd1 sky130_fd_sc_hd__fill_2
XFILLER_45_454 vssd1 vssd1 vccd1 vccd1 sky130_fd_sc_hd__fill_1
XFILLER_72_262 vssd1 vssd1 vccd1 vccd1 sky130_fd_sc_hd__fill_1
XFILLER_72_251 vssd1 vssd1 vccd1 vccd1 sky130_fd_sc_hd__fill_1
XTAP_TAPCELL_ROW_15_302 vssd1 vccd1 sky130_fd_sc_hd__tapvpwrvgnd_1
XFILLER_32_115 vssd1 vssd1 vccd1 vccd1 sky130_fd_sc_hd__fill_1
XFILLER_32_126 vccd1 vssd1 vccd1 vssd1 sky130_ef_sc_hd__decap_40_12
XANTENNA__1621__A2 net129 vssd1 vssd1 vccd1 vccd1 sky130_fd_sc_hd__diode_2
XFILLER_13_373 vssd1 vssd1 vccd1 vccd1 sky130_fd_sc_hd__fill_1
XFILLER_9_399 vssd1 vssd1 vccd1 vccd1 sky130_fd_sc_hd__fill_8
X_2550_ _1140_ _1141_ vssd1 vssd1 vccd1 vccd1 _1142_ sky130_fd_sc_hd__nand2b_1
X_2481_ _1052_ _1061_ _1072_ _1053_ vssd1 vssd1 vccd1 vccd1 _1074_ sky130_fd_sc_hd__o211ai_1
XANTENNA__1688__A2 net64 vssd1 vssd1 vccd1 vccd1 sky130_fd_sc_hd__diode_2
X_3102_ net60 net90 net80 vssd1 vssd1 vccd1 vccd1 _0059_ sky130_fd_sc_hd__and3_1
XFILLER_55_207 vccd1 vssd1 vccd1 vssd1 sky130_ef_sc_hd__decap_40_12
XTAP_TAPCELL_ROW_66_736 vssd1 vccd1 sky130_fd_sc_hd__tapvpwrvgnd_1
X_3033_ net631 _1569_ net95 vssd1 vssd1 vccd1 vccd1 _0439_ sky130_fd_sc_hd__mux2_1
XFILLER_36_421 vssd1 vssd1 vccd1 vccd1 sky130_fd_sc_hd__fill_8
XANTENNA_fanout136_A net137 vssd1 vssd1 vccd1 vccd1 sky130_fd_sc_hd__diode_2
XTAP_TAPCELL_ROW_21_349 vssd1 vccd1 sky130_fd_sc_hd__tapvpwrvgnd_1
X_2817_ _1347_ _1348_ _1360_ vssd1 vssd1 vccd1 vccd1 _1361_ sky130_fd_sc_hd__and3_1
XFILLER_11_15 vccd1 vssd1 vccd1 vssd1 sky130_ef_sc_hd__decap_40_12
X_2748_ net169 net166 net177 net179 vssd1 vssd1 vccd1 vccd1 _1294_ sky130_fd_sc_hd__nand4_2
X_2679_ net82 _1243_ _1254_ net440 vssd1 vssd1 vccd1 vccd1 _0400_ sky130_fd_sc_hd__a22o_1
XTAP_TAPCELL_ROW_29_416 vssd1 vccd1 sky130_fd_sc_hd__tapvpwrvgnd_1
XANTENNA__3114__B net86 vssd1 vssd1 vccd1 vccd1 sky130_fd_sc_hd__diode_2
XFILLER_36_34 vssd1 vssd1 vccd1 vccd1 sky130_fd_sc_hd__fill_1
XFILLER_39_281 vccd1 vssd1 vccd1 vssd1 sky130_ef_sc_hd__decap_40_12
XFILLER_36_67 vssd1 vssd1 vccd1 vccd1 sky130_fd_sc_hd__fill_1
XANTENNA_fanout49_A _0797_ vssd1 vssd1 vccd1 vccd1 sky130_fd_sc_hd__diode_2
XFILLER_54_262 vssd1 vssd1 vccd1 vccd1 sky130_fd_sc_hd__fill_1
XFILLER_14_137 vssd1 vssd1 vccd1 vccd1 sky130_fd_sc_hd__fill_2
XFILLER_22_192 vssd1 vssd1 vccd1 vccd1 sky130_fd_sc_hd__fill_4
XFILLER_10_365 vssd1 vssd1 vccd1 vccd1 sky130_fd_sc_hd__fill_4
XFILLER_10_354 vssd1 vssd1 vccd1 vccd1 sky130_fd_sc_hd__fill_8
XFILLER_10_387 vccd1 vssd1 vccd1 vssd1 sky130_ef_sc_hd__decap_40_12
XFILLER_18_421 vccd1 vssd1 vccd1 vssd1 sky130_ef_sc_hd__decap_40_12
XFILLER_18_443 vccd1 vssd1 vccd1 vssd1 sky130_ef_sc_hd__decap_40_12
XTAP_TAPCELL_ROW_63_706 vssd1 vccd1 sky130_fd_sc_hd__tapvpwrvgnd_1
XTAP_TAPCELL_ROW_71_772 vssd1 vccd1 sky130_fd_sc_hd__tapvpwrvgnd_1
XFILLER_20_118 vssd1 vssd1 vccd1 vccd1 sky130_fd_sc_hd__fill_1
X_1981_ net462 _0799_ net28 vssd1 vssd1 vccd1 vccd1 _0143_ sky130_fd_sc_hd__mux2_1
XFILLER_13_192 vccd1 vssd1 vccd1 vssd1 sky130_ef_sc_hd__decap_40_12
XFILLER_9_174 vssd1 vssd1 vccd1 vccd1 sky130_fd_sc_hd__fill_2
XANTENNA__2090__S net18 vssd1 vssd1 vccd1 vccd1 sky130_fd_sc_hd__diode_2
X_2602_ _1178_ _1191_ vssd1 vssd1 vccd1 vccd1 _1192_ sky130_fd_sc_hd__xnor2_1
X_3582_ net224 _0015_ _0080_ vssd1 vssd1 vccd1 vccd1 MATMULT_INST.matmult_inst.spi_inst.miso_shifter\[2\]
+ sky130_fd_sc_hd__dfrtp_1
XFILLER_61_3 vssd1 vssd1 vccd1 vccd1 sky130_fd_sc_hd__fill_8
X_2533_ _1082_ _1086_ _1087_ _1094_ _1095_ vssd1 vssd1 vccd1 vccd1 _1125_ sky130_fd_sc_hd__a311o_1
XFILLER_5_391 vssd1 vssd1 vccd1 vccd1 sky130_fd_sc_hd__fill_1
X_2464_ net186 _1057_ _1056_ vssd1 vssd1 vccd1 vccd1 _1058_ sky130_fd_sc_hd__a21bo_1
X_2395_ net205 _0988_ _0989_ vssd1 vssd1 vccd1 vccd1 _0991_ sky130_fd_sc_hd__and3_1
XTAP_TAPCELL_ROW_79_850 vssd1 vccd1 sky130_fd_sc_hd__tapvpwrvgnd_1
XFILLER_3_93 vssd1 vssd1 vccd1 vccd1 sky130_fd_sc_hd__fill_1
X_3016_ _1529_ _1550_ _1552_ _1553_ vssd1 vssd1 vccd1 vccd1 _1554_ sky130_fd_sc_hd__nand4_1
XFILLER_36_251 vssd1 vssd1 vccd1 vccd1 sky130_fd_sc_hd__fill_1
XTAP_TAPCELL_ROW_34_463 vssd1 vccd1 sky130_fd_sc_hd__tapvpwrvgnd_1
XFILLER_51_265 vccd1 vssd1 vccd1 vssd1 sky130_ef_sc_hd__decap_40_12
Xclkbuf_leaf_31_clk clknet_2_2__leaf_clk vssd1 vssd1 vccd1 vccd1 clknet_leaf_31_clk
+ sky130_fd_sc_hd__clkbuf_8
XANTENNA_clkbuf_2_1__f_clk_X clknet_2_1__leaf_clk vssd1 vssd1 vccd1 vccd1 sky130_fd_sc_hd__diode_2
Xfanout131 _0546_ vssd1 vssd1 vccd1 vccd1 net131 sky130_fd_sc_hd__clkbuf_4
Xfanout120 net123 vssd1 vssd1 vccd1 vccd1 net120 sky130_fd_sc_hd__buf_2
Xfanout142 net145 vssd1 vssd1 vccd1 vccd1 net142 sky130_fd_sc_hd__buf_1
Xfanout153 net154 vssd1 vssd1 vccd1 vccd1 net153 sky130_fd_sc_hd__buf_1
Xfanout164 net165 vssd1 vssd1 vccd1 vccd1 net164 sky130_fd_sc_hd__buf_2
Xfanout186 net187 vssd1 vssd1 vccd1 vccd1 net186 sky130_fd_sc_hd__buf_2
Xfanout175 MATMULT_INST.matmult_inst.alu_inst.b1_reg\[5\] vssd1 vssd1 vccd1 vccd1
+ net175 sky130_fd_sc_hd__clkbuf_2
Xfanout197 MATMULT_INST.matmult_inst.alu_inst.a0_reg\[0\] vssd1 vssd1 vccd1 vccd1
+ net197 sky130_fd_sc_hd__buf_2
XFILLER_59_387 vssd1 vssd1 vccd1 vccd1 sky130_fd_sc_hd__fill_1
XFILLER_27_262 vssd1 vssd1 vccd1 vccd1 sky130_fd_sc_hd__fill_2
XFILLER_42_232 vssd1 vssd1 vccd1 vccd1 sky130_fd_sc_hd__fill_2
XFILLER_23_490 vssd1 vssd1 vccd1 vccd1 sky130_fd_sc_hd__fill_4
Xclkbuf_leaf_22_clk clknet_2_3__leaf_clk vssd1 vssd1 vccd1 vccd1 clknet_leaf_22_clk
+ sky130_fd_sc_hd__clkbuf_8
XFILLER_10_162 vccd1 vssd1 vccd1 vssd1 sky130_ef_sc_hd__decap_40_12
XFILLER_6_177 vccd1 vssd1 vccd1 vssd1 sky130_ef_sc_hd__decap_40_12
XFILLER_6_199 vssd1 vssd1 vccd1 vccd1 sky130_fd_sc_hd__fill_1
X_2180_ _0767_ _0827_ vssd1 vssd1 vccd1 vccd1 _0836_ sky130_fd_sc_hd__nand2_1
XTAP_TAPCELL_ROW_76_820 vssd1 vccd1 sky130_fd_sc_hd__tapvpwrvgnd_1
XFILLER_65_313 vssd1 vssd1 vccd1 vccd1 sky130_fd_sc_hd__fill_2
XFILLER_65_335 vssd1 vssd1 vccd1 vccd1 sky130_fd_sc_hd__fill_1
XFILLER_18_251 vssd1 vssd1 vccd1 vccd1 sky130_fd_sc_hd__fill_1
XTAP_TAPCELL_ROW_48_577 vssd1 vccd1 sky130_fd_sc_hd__tapvpwrvgnd_1
XANTENNA__2085__S net19 vssd1 vssd1 vccd1 vccd1 sky130_fd_sc_hd__diode_2
XFILLER_18_284 vccd1 vssd1 vccd1 vssd1 sky130_ef_sc_hd__decap_40_12
XFILLER_33_210 vssd1 vssd1 vccd1 vccd1 sky130_fd_sc_hd__fill_2
XFILLER_33_276 vssd1 vssd1 vccd1 vccd1 sky130_fd_sc_hd__fill_1
Xclkbuf_leaf_13_clk clknet_2_1__leaf_clk vssd1 vssd1 vccd1 vccd1 clknet_leaf_13_clk
+ sky130_fd_sc_hd__clkbuf_8
XTAP_TAPCELL_ROW_31_433 vssd1 vccd1 sky130_fd_sc_hd__tapvpwrvgnd_1
X_1964_ MATMULT_INST.matmult_inst.fsm_inst.alu_result\[11\] net69 vssd1 vssd1 vccd1
+ vccd1 _0808_ sky130_fd_sc_hd__and2_1
X_1895_ _0738_ _0772_ vssd1 vssd1 vccd1 vccd1 _0773_ sky130_fd_sc_hd__nand2_1
X_3634_ clknet_leaf_25_clk net306 vssd1 vssd1 vccd1 vccd1 MATMULT_INST.matmult_inst.fsm_inst.alu_result\[10\]
+ sky130_fd_sc_hd__dfxtp_1
X_3565_ clknet_leaf_9_clk _0477_ vssd1 vssd1 vccd1 vccd1 MATMULT_INST.matmult_inst.mem_inst.matrixB3\[13\]
+ sky130_fd_sc_hd__dfxtp_1
X_2516_ net199 net201 net193 net191 vssd1 vssd1 vccd1 vccd1 _1108_ sky130_fd_sc_hd__and4_1
X_3496_ clknet_leaf_34_clk _0415_ vssd1 vssd1 vccd1 vccd1 MATMULT_INST.matmult_inst.alu_inst.row1\[7\]
+ sky130_fd_sc_hd__dfxtp_1
X_2447_ _1037_ _1038_ _1039_ _1011_ vssd1 vssd1 vccd1 vccd1 _1041_ sky130_fd_sc_hd__o211ai_2
XANTENNA__1751__B2 net219 vssd1 vssd1 vccd1 vccd1 sky130_fd_sc_hd__diode_2
XANTENNA__2700__A0 _1249_ vssd1 vssd1 vccd1 vccd1 sky130_fd_sc_hd__diode_2
X_2378_ _0970_ _0971_ _0973_ vssd1 vssd1 vccd1 vccd1 _0975_ sky130_fd_sc_hd__nand3_1
XTAP_TAPCELL_ROW_39_500 vssd1 vccd1 sky130_fd_sc_hd__tapvpwrvgnd_1
XFILLER_68_195 vssd1 vssd1 vccd1 vccd1 sky130_fd_sc_hd__fill_1
XFILLER_24_221 vssd1 vssd1 vccd1 vccd1 sky130_fd_sc_hd__fill_1
XANTENNA__1806__A2 net108 vssd1 vssd1 vccd1 vccd1 sky130_fd_sc_hd__diode_2
XFILLER_33_24 vccd1 vssd1 vccd1 vssd1 sky130_ef_sc_hd__decap_40_12
XFILLER_33_57 vccd1 vssd1 vccd1 vssd1 sky130_ef_sc_hd__decap_40_12
XANTENNA__1990__A1 net38 vssd1 vssd1 vccd1 vccd1 sky130_fd_sc_hd__diode_2
XFILLER_79_405 vccd1 vssd1 vccd1 vssd1 sky130_ef_sc_hd__decap_40_12
XFILLER_3_169 vssd1 vssd1 vccd1 vccd1 sky130_fd_sc_hd__fill_8
XFILLER_79_449 vssd1 vssd1 vccd1 vccd1 sky130_fd_sc_hd__fill_2
XANTENNA__1742__A1 _0661_ vssd1 vssd1 vccd1 vccd1 sky130_fd_sc_hd__diode_2
XANTENNA_fanout71_X net71 vssd1 vssd1 vccd1 vccd1 sky130_fd_sc_hd__diode_2
Xhold9 MATMULT_INST.matmult_inst.mem_inst.matrixA3\[0\] vssd1 vssd1 vccd1 vccd1 net304
+ sky130_fd_sc_hd__dlygate4sd3_1
XFILLER_47_335 vssd1 vssd1 vccd1 vccd1 sky130_fd_sc_hd__fill_1
XTAP_TAPCELL_ROW_2_191 vssd1 vccd1 sky130_fd_sc_hd__tapvpwrvgnd_1
XTAP_TAPCELL_ROW_45_558 vssd1 vccd1 sky130_fd_sc_hd__tapvpwrvgnd_1
XFILLER_30_224 vssd1 vssd1 vccd1 vccd1 sky130_fd_sc_hd__fill_4
XFILLER_30_257 vssd1 vssd1 vccd1 vccd1 sky130_fd_sc_hd__fill_2
XFILLER_30_268 vssd1 vssd1 vccd1 vccd1 sky130_fd_sc_hd__fill_4
X_1680_ net153 net143 MATMULT_INST.matmult_inst.mem_inst.mem3\[12\] vssd1 vssd1 vccd1
+ vccd1 _0605_ sky130_fd_sc_hd__and3_1
XANTENNA__1981__A1 _0799_ vssd1 vssd1 vccd1 vccd1 sky130_fd_sc_hd__diode_2
X_3350_ clknet_leaf_1_clk _0272_ vssd1 vssd1 vccd1 vccd1 MATMULT_INST.matmult_inst.mem_inst.mem2\[5\]
+ sky130_fd_sc_hd__dfxtp_1
X_2301_ MATMULT_INST.matmult_inst.alu_inst.adder_inst.r3.fa3.b MATMULT_INST.matmult_inst.alu_inst.adder_inst.r3.fa3.a
+ vssd1 vssd1 vccd1 vccd1 _0922_ sky130_fd_sc_hd__nor2_1
X_3281_ clknet_leaf_14_clk _0203_ vssd1 vssd1 vccd1 vccd1 MATMULT_INST.matmult_inst.mem_inst.matrixA2\[8\]
+ sky130_fd_sc_hd__dfxtp_1
XFILLER_24_3 vccd1 vssd1 vccd1 vssd1 sky130_ef_sc_hd__decap_40_12
Xclkbuf_leaf_2_clk clknet_2_0__leaf_clk vssd1 vssd1 vccd1 vccd1 clknet_leaf_2_clk
+ sky130_fd_sc_hd__clkbuf_8
X_2232_ _0862_ _0863_ vssd1 vssd1 vccd1 vccd1 _0864_ sky130_fd_sc_hd__and2b_1
X_2163_ net108 net36 net10 net365 vssd1 vssd1 vccd1 vccd1 _0316_ sky130_fd_sc_hd__a22o_1
XFILLER_38_324 vssd1 vssd1 vccd1 vccd1 sky130_fd_sc_hd__fill_8
XFILLER_53_305 vssd1 vssd1 vccd1 vccd1 sky130_fd_sc_hd__fill_4
X_2094_ net453 _0798_ net17 vssd1 vssd1 vccd1 vccd1 _0250_ sky130_fd_sc_hd__mux2_1
XFILLER_0_83 vssd1 vssd1 vccd1 vccd1 sky130_fd_sc_hd__fill_1
XFILLER_9_81 vssd1 vssd1 vccd1 vccd1 sky130_fd_sc_hd__fill_4
X_2996_ net615 _1534_ net95 vssd1 vssd1 vccd1 vccd1 _0437_ sky130_fd_sc_hd__mux2_1
X_1947_ net547 net47 net30 vssd1 vssd1 vccd1 vccd1 _0125_ sky130_fd_sc_hd__mux2_1
X_1878_ net132 MATMULT_INST.matmult_inst.fsm_inst.state\[0\] vssd1 vssd1 vccd1 vccd1
+ _0756_ sky130_fd_sc_hd__nor2_1
XANTENNA_fanout216_A net218 vssd1 vssd1 vccd1 vccd1 sky130_fd_sc_hd__diode_2
X_3617_ clknet_leaf_25_clk MATMULT_INST.matmult_inst.spi_inst.mosi_data_spi\[1\] _0115_
+ vssd1 vssd1 vccd1 vccd1 MATMULT_INST.matmult_inst.spi_inst.mosi_data_sync\[1\] sky130_fd_sc_hd__dfrtp_1
X_3548_ _0062_ _0461_ _0061_ vssd1 vssd1 vccd1 vccd1 MATMULT_INST.matmult_inst.spi_inst.mosi_shifter\[4\]
+ sky130_fd_sc_hd__dfrtp_1
XTAP_TAPCELL_ROW_8_239 vssd1 vccd1 sky130_fd_sc_hd__tapvpwrvgnd_1
XFILLER_0_139 vssd1 vssd1 vccd1 vccd1 sky130_fd_sc_hd__fill_1
X_3479_ clknet_leaf_34_clk _0399_ vssd1 vssd1 vccd1 vccd1 MATMULT_INST.matmult_inst.alu_inst.col1\[7\]
+ sky130_fd_sc_hd__dfxtp_1
XANTENNA__1970__X _0811_ vssd1 vssd1 vccd1 vccd1 sky130_fd_sc_hd__diode_2
XFILLER_69_493 vssd1 vssd1 vccd1 vccd1 sky130_fd_sc_hd__fill_1
Xteam_02_236 vssd1 vssd1 vccd1 vccd1 team_02_236/HI gpio_oeb[9] sky130_fd_sc_hd__conb_1
Xteam_02_247 vssd1 vssd1 vccd1 vccd1 team_02_247/HI gpio_oeb[20] sky130_fd_sc_hd__conb_1
Xteam_02_269 vssd1 vssd1 vccd1 vccd1 team_02_269/HI gpio_out[10] sky130_fd_sc_hd__conb_1
Xteam_02_258 vssd1 vssd1 vccd1 vccd1 team_02_258/HI gpio_oeb[31] sky130_fd_sc_hd__conb_1
XFILLER_29_335 vssd1 vssd1 vccd1 vccd1 sky130_fd_sc_hd__fill_1
XFILLER_37_390 vssd1 vssd1 vccd1 vccd1 sky130_fd_sc_hd__fill_2
XTAP_TAPCELL_ROW_42_528 vssd1 vccd1 sky130_fd_sc_hd__tapvpwrvgnd_1
XTAP_TAPCELL_ROW_50_594 vssd1 vccd1 sky130_fd_sc_hd__tapvpwrvgnd_1
XANTENNA__1963__A1 net39 vssd1 vssd1 vccd1 vccd1 sky130_fd_sc_hd__diode_2
XFILLER_4_412 vssd1 vssd1 vccd1 vccd1 sky130_fd_sc_hd__fill_8
XFILLER_69_31 vssd1 vssd1 vccd1 vccd1 sky130_fd_sc_hd__fill_8
XFILLER_4_445 vccd1 vssd1 vccd1 vssd1 sky130_ef_sc_hd__decap_40_12
XFILLER_69_53 vssd1 vssd1 vccd1 vccd1 sky130_fd_sc_hd__fill_2
XFILLER_4_489 vssd1 vssd1 vccd1 vccd1 sky130_fd_sc_hd__fill_2
XFILLER_47_154 vssd1 vssd1 vccd1 vccd1 sky130_fd_sc_hd__fill_2
XTAP_TAPCELL_ROW_58_661 vssd1 vccd1 sky130_fd_sc_hd__tapvpwrvgnd_1
XFILLER_75_485 vssd1 vssd1 vccd1 vccd1 sky130_fd_sc_hd__fill_4
XANTENNA__2691__A2 _1249_ vssd1 vssd1 vccd1 vccd1 sky130_fd_sc_hd__diode_2
XFILLER_35_316 vssd1 vssd1 vccd1 vccd1 sky130_fd_sc_hd__fill_1
XFILLER_35_349 vssd1 vssd1 vccd1 vccd1 sky130_fd_sc_hd__fill_2
X_2850_ net182 net157 net181 net159 vssd1 vssd1 vccd1 vccd1 _1393_ sky130_fd_sc_hd__a22o_1
XFILLER_43_393 vssd1 vssd1 vccd1 vccd1 sky130_fd_sc_hd__fill_2
X_1801_ MATMULT_INST.matmult_inst.mem_inst.matrixB1\[1\] net128 net120 MATMULT_INST.matmult_inst.mem_inst.matrixB2\[1\]
+ vssd1 vssd1 vccd1 vccd1 _0715_ sky130_fd_sc_hd__a22o_1
X_2781_ net175 _1323_ _1324_ vssd1 vssd1 vccd1 vccd1 _1326_ sky130_fd_sc_hd__and3_1
XTAP_TAPCELL_ROW_13_285 vssd1 vccd1 sky130_fd_sc_hd__tapvpwrvgnd_1
X_1732_ net150 net141 MATMULT_INST.matmult_inst.mem_inst.matrixB3\[7\] vssd1 vssd1
+ vccd1 vccd1 _0652_ sky130_fd_sc_hd__and3_1
Xhold217 MATMULT_INST.matmult_inst.mem_inst.mem1\[14\] vssd1 vssd1 vccd1 vccd1 net512
+ sky130_fd_sc_hd__dlygate4sd3_1
X_1663_ net220 _0587_ _0589_ net218 vssd1 vssd1 vccd1 vccd1 _0590_ sky130_fd_sc_hd__a22o_1
Xhold206 MATMULT_INST.matmult_inst.mem_inst.matrixB1\[5\] vssd1 vssd1 vccd1 vccd1
+ net501 sky130_fd_sc_hd__dlygate4sd3_1
Xhold239 MATMULT_INST.matmult_inst.mem_inst.matrixB2\[16\] vssd1 vssd1 vccd1 vccd1
+ net534 sky130_fd_sc_hd__dlygate4sd3_1
X_3402_ clknet_leaf_34_clk _0324_ vssd1 vssd1 vccd1 vccd1 MATMULT_INST.matmult_inst.fsm_inst.count\[3\]
+ sky130_fd_sc_hd__dfxtp_1
Xhold228 MATMULT_INST.matmult_inst.spi_inst.mosi_data_sync\[0\] vssd1 vssd1 vccd1
+ vccd1 net523 sky130_fd_sc_hd__dlygate4sd3_1
X_3333_ clknet_leaf_7_clk _0255_ vssd1 vssd1 vccd1 vccd1 MATMULT_INST.matmult_inst.mem_inst.mem3\[6\]
+ sky130_fd_sc_hd__dfxtp_1
XANTENNA__2111__B net120 vssd1 vssd1 vccd1 vccd1 sky130_fd_sc_hd__diode_2
XPHY_EDGE_ROW_7_Right_7 vssd1 vssd1 vccd1 vccd1 sky130_fd_sc_hd__decap_3
X_3264_ clknet_leaf_16_clk _0186_ vssd1 vssd1 vccd1 vccd1 MATMULT_INST.matmult_inst.mem_inst.matrixA3\[9\]
+ sky130_fd_sc_hd__dfxtp_1
XFILLER_58_419 vssd1 vssd1 vccd1 vccd1 sky130_fd_sc_hd__fill_1
X_2215_ _0845_ _0849_ vssd1 vssd1 vccd1 vccd1 _0850_ sky130_fd_sc_hd__xnor2_1
XFILLER_38_154 vssd1 vssd1 vccd1 vccd1 sky130_fd_sc_hd__fill_4
X_3195_ net57 net84 net76 vssd1 vssd1 vccd1 vccd1 _0120_ sky130_fd_sc_hd__and3_1
X_2146_ net470 net34 net12 vssd1 vssd1 vccd1 vccd1 _0300_ sky130_fd_sc_hd__mux2_1
XANTENNA__2682__A2 _1249_ vssd1 vssd1 vccd1 vccd1 sky130_fd_sc_hd__diode_2
X_2077_ net377 _0800_ net18 vssd1 vssd1 vccd1 vccd1 _0234_ sky130_fd_sc_hd__mux2_1
XANTENNA__1642__B1 net112 vssd1 vssd1 vccd1 vccd1 sky130_fd_sc_hd__diode_2
XFILLER_14_15 vccd1 vssd1 vccd1 vssd1 sky130_ef_sc_hd__decap_40_12
XFILLER_14_59 vccd1 vssd1 vccd1 vssd1 sky130_ef_sc_hd__decap_40_12
XFILLER_61_190 vssd1 vssd1 vccd1 vccd1 sky130_fd_sc_hd__fill_1
X_2979_ _1515_ _1517_ vssd1 vssd1 vccd1 vccd1 _1518_ sky130_fd_sc_hd__and2_1
XANTENNA_fanout121_X net121 vssd1 vssd1 vccd1 vccd1 sky130_fd_sc_hd__diode_2
XANTENNA_fanout219_X net219 vssd1 vssd1 vccd1 vccd1 sky130_fd_sc_hd__diode_2
XFILLER_1_437 vssd1 vssd1 vccd1 vccd1 sky130_fd_sc_hd__fill_8
XFILLER_29_121 vssd1 vssd1 vccd1 vccd1 sky130_fd_sc_hd__fill_1
XFILLER_55_11 vssd1 vssd1 vccd1 vccd1 sky130_fd_sc_hd__fill_2
XANTENNA__2122__A1 net39 vssd1 vssd1 vccd1 vccd1 sky130_fd_sc_hd__diode_2
XFILLER_29_165 vssd1 vssd1 vccd1 vccd1 sky130_fd_sc_hd__fill_2
XFILLER_44_135 vssd1 vssd1 vccd1 vccd1 sky130_fd_sc_hd__fill_1
XTAP_TAPCELL_ROW_55_642 vssd1 vccd1 sky130_fd_sc_hd__tapvpwrvgnd_1
XFILLER_72_477 vccd1 vssd1 vccd1 vssd1 sky130_ef_sc_hd__decap_40_12
XANTENNA_fanout34_X net34 vssd1 vssd1 vccd1 vccd1 sky130_fd_sc_hd__diode_2
XFILLER_25_393 vssd1 vssd1 vccd1 vccd1 sky130_fd_sc_hd__fill_8
XTAP_TAPCELL_ROW_27_399 vssd1 vccd1 sky130_fd_sc_hd__tapvpwrvgnd_1
XANTENNA__1633__B1 net104 vssd1 vssd1 vccd1 vccd1 sky130_fd_sc_hd__diode_2
XFILLER_40_363 vssd1 vssd1 vccd1 vccd1 sky130_fd_sc_hd__fill_1
XTAP_TAPCELL_ROW_10_255 vssd1 vccd1 sky130_fd_sc_hd__tapvpwrvgnd_1
XFILLER_58_9 vssd1 vssd1 vccd1 vccd1 sky130_fd_sc_hd__fill_1
XFILLER_67_227 vssd1 vssd1 vccd1 vccd1 sky130_fd_sc_hd__fill_1
X_2000_ net47 net613 net26 vssd1 vssd1 vccd1 vccd1 _0161_ sky130_fd_sc_hd__mux2_1
XFILLER_35_113 vssd1 vssd1 vccd1 vccd1 sky130_fd_sc_hd__fill_1
XTAP_TAPCELL_ROW_18_322 vssd1 vccd1 sky130_fd_sc_hd__tapvpwrvgnd_1
X_2902_ _1432_ _1426_ vssd1 vssd1 vccd1 vccd1 _1443_ sky130_fd_sc_hd__nand2b_1
XFILLER_16_393 vssd1 vssd1 vccd1 vccd1 sky130_fd_sc_hd__fill_2
XANTENNA__2093__S net16 vssd1 vssd1 vccd1 vccd1 sky130_fd_sc_hd__diode_2
XFILLER_50_116 vssd1 vssd1 vccd1 vccd1 sky130_fd_sc_hd__fill_1
X_2833_ _1372_ _1373_ _1374_ _1358_ vssd1 vssd1 vccd1 vccd1 _1376_ sky130_fd_sc_hd__o211ai_2
XTAP_TAPCELL_ROW_61_689 vssd1 vccd1 sky130_fd_sc_hd__tapvpwrvgnd_1
X_2764_ _1306_ _1307_ _1309_ vssd1 vssd1 vccd1 vccd1 _1310_ sky130_fd_sc_hd__a21o_1
X_1715_ net152 net143 MATMULT_INST.matmult_inst.mem_inst.matrixA3\[9\] vssd1 vssd1
+ vccd1 vccd1 _0637_ sky130_fd_sc_hd__and3_1
X_2695_ net93 _1253_ _1255_ net472 vssd1 vssd1 vccd1 vccd1 _0415_ sky130_fd_sc_hd__a22o_1
X_1646_ MATMULT_INST.matmult_inst.mem_inst.mem0\[15\] net109 net106 MATMULT_INST.matmult_inst.mem_inst.matrixB0\[15\]
+ vssd1 vssd1 vccd1 vccd1 _0574_ sky130_fd_sc_hd__a22o_1
XFILLER_6_82 vssd1 vssd1 vccd1 vccd1 sky130_fd_sc_hd__fill_2
X_3316_ clknet_leaf_8_clk _0238_ vssd1 vssd1 vccd1 vccd1 MATMULT_INST.matmult_inst.mem_inst.matrixA0\[7\]
+ sky130_fd_sc_hd__dfxtp_1
XANTENNA__1680__B net143 vssd1 vssd1 vccd1 vccd1 sky130_fd_sc_hd__diode_2
XANTENNA__2104__A1 net38 vssd1 vssd1 vccd1 vccd1 sky130_fd_sc_hd__diode_2
XTAP_TAPCELL_ROW_69_756 vssd1 vccd1 sky130_fd_sc_hd__tapvpwrvgnd_1
XANTENNA_clkbuf_leaf_21_clk_A clknet_2_3__leaf_clk vssd1 vssd1 vccd1 vccd1 sky130_fd_sc_hd__diode_2
X_3247_ clknet_leaf_18_clk _0169_ vssd1 vssd1 vccd1 vccd1 MATMULT_INST.matmult_inst.mem_inst.matrixB0\[10\]
+ sky130_fd_sc_hd__dfxtp_1
X_3178_ net58 net87 net74 vssd1 vssd1 vccd1 vccd1 _0103_ sky130_fd_sc_hd__and3_1
XPHY_EDGE_ROW_16_Left_96 vssd1 vssd1 vccd1 vccd1 sky130_fd_sc_hd__decap_3
X_2129_ net395 net32 net15 vssd1 vssd1 vccd1 vccd1 _0284_ sky130_fd_sc_hd__mux2_1
XFILLER_54_444 vssd1 vssd1 vccd1 vccd1 sky130_fd_sc_hd__fill_4
XFILLER_54_455 vssd1 vssd1 vccd1 vccd1 sky130_fd_sc_hd__fill_1
XFILLER_26_168 vccd1 vssd1 vccd1 vssd1 sky130_ef_sc_hd__decap_40_12
XANTENNA_clkbuf_leaf_36_clk_A clknet_2_0__leaf_clk vssd1 vssd1 vccd1 vccd1 sky130_fd_sc_hd__diode_2
XTAP_TAPCELL_ROW_52_612 vssd1 vccd1 sky130_fd_sc_hd__tapvpwrvgnd_1
XFILLER_22_341 vssd1 vssd1 vccd1 vccd1 sky130_fd_sc_hd__fill_2
XFILLER_22_352 vssd1 vssd1 vccd1 vccd1 sky130_fd_sc_hd__fill_2
XFILLER_41_149 vssd1 vssd1 vccd1 vccd1 sky130_fd_sc_hd__fill_1
XFILLER_1_289 vssd1 vssd1 vccd1 vccd1 sky130_fd_sc_hd__fill_1
XFILLER_2_18 vssd1 vssd1 vccd1 vccd1 sky130_fd_sc_hd__fill_8
XFILLER_2_29 vssd1 vssd1 vccd1 vccd1 sky130_fd_sc_hd__fill_8
XFILLER_17_113 vssd1 vssd1 vccd1 vccd1 sky130_fd_sc_hd__fill_4
XTAP_TAPCELL_ROW_15_303 vssd1 vccd1 sky130_fd_sc_hd__tapvpwrvgnd_1
XFILLER_32_138 vssd1 vssd1 vccd1 vccd1 sky130_fd_sc_hd__fill_2
XFILLER_60_458 vccd1 vssd1 vccd1 vssd1 sky130_ef_sc_hd__decap_40_12
XFILLER_9_334 vssd1 vssd1 vccd1 vccd1 sky130_fd_sc_hd__fill_2
XFILLER_40_193 vssd1 vssd1 vccd1 vccd1 sky130_fd_sc_hd__fill_2
XFILLER_63_7 vssd1 vssd1 vccd1 vccd1 sky130_fd_sc_hd__fill_1
X_2480_ _1052_ _1061_ _1072_ _1053_ vssd1 vssd1 vccd1 vccd1 _1073_ sky130_fd_sc_hd__o211a_1
XANTENNA__1781__A net148 vssd1 vssd1 vccd1 vccd1 sky130_fd_sc_hd__diode_2
X_3101_ net60 net92 net80 vssd1 vssd1 vccd1 vccd1 _0061_ sky130_fd_sc_hd__and3_1
XANTENNA__2088__S net19 vssd1 vssd1 vccd1 vccd1 sky130_fd_sc_hd__diode_2
XTAP_TAPCELL_ROW_66_737 vssd1 vccd1 sky130_fd_sc_hd__tapvpwrvgnd_1
X_3032_ _1567_ _1568_ vssd1 vssd1 vccd1 vccd1 _1569_ sky130_fd_sc_hd__xnor2_1
XFILLER_36_477 vccd1 vssd1 vccd1 vssd1 sky130_ef_sc_hd__decap_40_12
XFILLER_63_285 vssd1 vssd1 vccd1 vccd1 sky130_fd_sc_hd__fill_2
XFILLER_51_469 vccd1 vssd1 vccd1 vssd1 sky130_ef_sc_hd__decap_40_12
X_2816_ _1351_ _1359_ vssd1 vssd1 vccd1 vccd1 _1360_ sky130_fd_sc_hd__xnor2_1
XFILLER_31_171 vccd1 vssd1 vccd1 vssd1 sky130_ef_sc_hd__decap_40_12
XANTENNA_fanout129_A net131 vssd1 vssd1 vccd1 vccd1 sky130_fd_sc_hd__diode_2
X_2747_ net166 net177 vssd1 vssd1 vccd1 vccd1 _1293_ sky130_fd_sc_hd__and2_1
XFILLER_11_27 vssd1 vssd1 vccd1 vccd1 sky130_fd_sc_hd__fill_8
X_2678_ net82 _0767_ _1245_ vssd1 vssd1 vccd1 vccd1 _1254_ sky130_fd_sc_hd__o21bai_4
X_1629_ _0558_ _0556_ net223 vssd1 vssd1 vccd1 vccd1 _0559_ sky130_fd_sc_hd__mux2_1
XANTENNA__1691__A net152 vssd1 vssd1 vccd1 vccd1 sky130_fd_sc_hd__diode_2
XANTENNA_input3_A gpio_in[2] vssd1 vssd1 vccd1 vccd1 sky130_fd_sc_hd__diode_2
XTAP_TAPCELL_ROW_29_417 vssd1 vccd1 sky130_fd_sc_hd__tapvpwrvgnd_1
XFILLER_39_293 vssd1 vssd1 vccd1 vccd1 sky130_fd_sc_hd__fill_2
XTAP_TAPCELL_ROW_37_483 vssd1 vccd1 sky130_fd_sc_hd__tapvpwrvgnd_1
XFILLER_52_23 vssd1 vssd1 vccd1 vccd1 sky130_fd_sc_hd__fill_4
XANTENNA__2013__B1 net27 vssd1 vssd1 vccd1 vccd1 sky130_fd_sc_hd__diode_2
XFILLER_10_399 vssd1 vssd1 vccd1 vccd1 sky130_fd_sc_hd__fill_4
XFILLER_37_208 vccd1 vssd1 vccd1 vssd1 sky130_ef_sc_hd__decap_40_12
XFILLER_18_433 vssd1 vssd1 vccd1 vccd1 sky130_fd_sc_hd__fill_4
XTAP_TAPCELL_ROW_63_707 vssd1 vccd1 sky130_fd_sc_hd__tapvpwrvgnd_1
XFILLER_18_455 vccd1 vssd1 vccd1 vssd1 sky130_ef_sc_hd__decap_40_12
XFILLER_33_447 vssd1 vssd1 vccd1 vccd1 sky130_fd_sc_hd__fill_1
X_1980_ net517 _0798_ net29 vssd1 vssd1 vccd1 vccd1 _0142_ sky130_fd_sc_hd__mux2_1
XTAP_TAPCELL_ROW_71_773 vssd1 vccd1 sky130_fd_sc_hd__tapvpwrvgnd_1
XFILLER_60_288 vssd1 vssd1 vccd1 vccd1 sky130_fd_sc_hd__fill_2
X_2601_ _1189_ _1190_ vssd1 vssd1 vccd1 vccd1 _1191_ sky130_fd_sc_hd__nand2_1
XANTENNA__2004__A0 _0803_ vssd1 vssd1 vccd1 vccd1 sky130_fd_sc_hd__diode_2
X_3581_ net224 _0014_ _0079_ vssd1 vssd1 vccd1 vccd1 MATMULT_INST.matmult_inst.spi_inst.miso_shifter\[1\]
+ sky130_fd_sc_hd__dfrtp_1
X_2532_ _1091_ _1093_ _1092_ vssd1 vssd1 vccd1 vccd1 _1124_ sky130_fd_sc_hd__o21ba_1
XFILLER_54_3 vccd1 vssd1 vccd1 vssd1 sky130_ef_sc_hd__decap_40_12
X_2463_ net212 net189 net210 vssd1 vssd1 vccd1 vccd1 _1057_ sky130_fd_sc_hd__and3_1
X_2394_ net197 net205 _0988_ _0989_ vssd1 vssd1 vccd1 vccd1 _0990_ sky130_fd_sc_hd__a22o_1
XTAP_TAPCELL_ROW_79_851 vssd1 vccd1 sky130_fd_sc_hd__tapvpwrvgnd_1
XTAP_TAPCELL_ROW_79_840 vssd1 vccd1 sky130_fd_sc_hd__tapvpwrvgnd_1
X_3015_ _1473_ _1503_ _1505_ _1507_ _1530_ vssd1 vssd1 vccd1 vccd1 _1553_ sky130_fd_sc_hd__a311o_1
XFILLER_24_403 vssd1 vssd1 vccd1 vccd1 sky130_fd_sc_hd__fill_1
XFILLER_36_274 vssd1 vssd1 vccd1 vccd1 sky130_fd_sc_hd__fill_2
XTAP_TAPCELL_ROW_34_464 vssd1 vccd1 sky130_fd_sc_hd__tapvpwrvgnd_1
XFILLER_51_277 vssd1 vssd1 vccd1 vccd1 sky130_fd_sc_hd__fill_2
XFILLER_22_15 vccd1 vssd1 vccd1 vssd1 sky130_ef_sc_hd__decap_40_12
XFILLER_3_318 vssd1 vssd1 vccd1 vccd1 sky130_fd_sc_hd__fill_8
Xfanout110 net111 vssd1 vssd1 vccd1 vccd1 net110 sky130_fd_sc_hd__clkbuf_2
Xfanout121 net123 vssd1 vssd1 vccd1 vccd1 net121 sky130_fd_sc_hd__clkbuf_4
Xfanout165 MATMULT_INST.matmult_inst.alu_inst.a1_reg\[2\] vssd1 vssd1 vccd1 vccd1
+ net165 sky130_fd_sc_hd__clkbuf_2
Xfanout132 MATMULT_INST.matmult_inst.fsm_inst.state\[1\] vssd1 vssd1 vccd1 vccd1 net132
+ sky130_fd_sc_hd__clkbuf_2
Xfanout154 MATMULT_INST.matmult_inst.addr\[0\] vssd1 vssd1 vccd1 vccd1 net154 sky130_fd_sc_hd__clkbuf_2
Xfanout143 net145 vssd1 vssd1 vccd1 vccd1 net143 sky130_fd_sc_hd__buf_2
XFILLER_74_303 vssd1 vssd1 vccd1 vccd1 sky130_fd_sc_hd__fill_4
Xfanout187 MATMULT_INST.matmult_inst.alu_inst.a0_reg\[6\] vssd1 vssd1 vccd1 vccd1
+ net187 sky130_fd_sc_hd__buf_2
Xfanout176 MATMULT_INST.matmult_inst.alu_inst.b1_reg\[4\] vssd1 vssd1 vccd1 vccd1
+ net176 sky130_fd_sc_hd__buf_2
Xfanout198 MATMULT_INST.matmult_inst.alu_inst.a0_reg\[0\] vssd1 vssd1 vccd1 vccd1
+ net198 sky130_fd_sc_hd__dlymetal6s2s_1
XFILLER_59_366 vssd1 vssd1 vccd1 vccd1 sky130_fd_sc_hd__fill_1
XANTENNA_fanout61_A net62 vssd1 vssd1 vccd1 vccd1 sky130_fd_sc_hd__diode_2
XFILLER_63_33 vccd1 vssd1 vccd1 vssd1 sky130_ef_sc_hd__decap_40_12
XFILLER_63_55 vssd1 vssd1 vccd1 vccd1 sky130_fd_sc_hd__fill_1
XFILLER_10_141 vssd1 vssd1 vccd1 vccd1 sky130_fd_sc_hd__fill_4
XFILLER_6_134 vssd1 vssd1 vccd1 vccd1 sky130_fd_sc_hd__fill_4
XFILLER_6_189 vssd1 vssd1 vccd1 vccd1 sky130_fd_sc_hd__fill_4
XTAP_TAPCELL_ROW_76_821 vssd1 vccd1 sky130_fd_sc_hd__tapvpwrvgnd_1
XTAP_TAPCELL_ROW_48_578 vssd1 vccd1 sky130_fd_sc_hd__tapvpwrvgnd_1
XFILLER_73_391 vssd1 vssd1 vccd1 vccd1 sky130_fd_sc_hd__fill_1
XFILLER_18_296 vssd1 vssd1 vccd1 vccd1 sky130_fd_sc_hd__fill_1
XFILLER_33_222 vssd1 vssd1 vccd1 vccd1 sky130_fd_sc_hd__fill_2
XFILLER_33_266 vssd1 vssd1 vccd1 vccd1 sky130_fd_sc_hd__fill_8
X_1963_ net564 net39 net31 vssd1 vssd1 vccd1 vccd1 _0133_ sky130_fd_sc_hd__mux2_1
XTAP_TAPCELL_ROW_31_434 vssd1 vccd1 sky130_fd_sc_hd__tapvpwrvgnd_1
X_1894_ MATMULT_INST.matmult_inst.fsm_inst.count\[2\] _0533_ _0771_ vssd1 vssd1 vccd1
+ vccd1 _0772_ sky130_fd_sc_hd__or3_2
X_3633_ clknet_leaf_25_clk net346 vssd1 vssd1 vccd1 vccd1 MATMULT_INST.matmult_inst.fsm_inst.alu_result\[9\]
+ sky130_fd_sc_hd__dfxtp_1
X_3564_ clknet_leaf_13_clk _0476_ vssd1 vssd1 vccd1 vccd1 MATMULT_INST.matmult_inst.mem_inst.matrixB3\[12\]
+ sky130_fd_sc_hd__dfxtp_1
X_2515_ net199 net193 net191 net201 vssd1 vssd1 vccd1 vccd1 _1107_ sky130_fd_sc_hd__a22o_1
X_3495_ clknet_leaf_34_clk _0414_ vssd1 vssd1 vccd1 vccd1 MATMULT_INST.matmult_inst.alu_inst.row1\[6\]
+ sky130_fd_sc_hd__dfxtp_1
X_2446_ _1011_ _1039_ _1038_ _1037_ vssd1 vssd1 vccd1 vccd1 _1040_ sky130_fd_sc_hd__a211o_1
XANTENNA__1751__A2 net108 vssd1 vssd1 vccd1 vccd1 sky130_fd_sc_hd__diode_2
XANTENNA__2130__A net217 vssd1 vssd1 vccd1 vccd1 sky130_fd_sc_hd__diode_2
X_2377_ _0970_ _0971_ _0973_ vssd1 vssd1 vccd1 vccd1 _0974_ sky130_fd_sc_hd__a21o_1
XTAP_TAPCELL_ROW_39_501 vssd1 vccd1 sky130_fd_sc_hd__tapvpwrvgnd_1
XFILLER_17_15 vccd1 vssd1 vccd1 vssd1 sky130_ef_sc_hd__decap_40_12
XFILLER_56_369 vccd1 vssd1 vccd1 vssd1 sky130_ef_sc_hd__decap_40_12
XFILLER_24_233 vssd1 vssd1 vccd1 vccd1 sky130_fd_sc_hd__fill_1
XANTENNA__1968__X _0810_ vssd1 vssd1 vccd1 vccd1 sky130_fd_sc_hd__diode_2
XFILLER_33_36 vccd1 vssd1 vccd1 vssd1 sky130_ef_sc_hd__decap_40_12
XFILLER_33_69 vssd1 vssd1 vccd1 vccd1 sky130_fd_sc_hd__fill_2
XFILLER_20_472 vssd1 vssd1 vccd1 vccd1 sky130_fd_sc_hd__fill_2
XFILLER_79_417 vssd1 vssd1 vccd1 vccd1 sky130_fd_sc_hd__fill_2
XFILLER_58_99 vssd1 vssd1 vccd1 vccd1 sky130_fd_sc_hd__fill_2
XANTENNA_fanout64_X net64 vssd1 vssd1 vccd1 vccd1 sky130_fd_sc_hd__diode_2
XFILLER_74_166 vccd1 vssd1 vccd1 vssd1 sky130_ef_sc_hd__decap_40_12
XANTENNA__3579__Q MATMULT_INST.matmult_inst.spi_inst.current_state vssd1 vssd1 vccd1
+ vccd1 sky130_fd_sc_hd__diode_2
XFILLER_62_328 vssd1 vssd1 vccd1 vccd1 sky130_fd_sc_hd__fill_4
XTAP_TAPCELL_ROW_2_192 vssd1 vccd1 sky130_fd_sc_hd__tapvpwrvgnd_1
XFILLER_55_391 vssd1 vssd1 vccd1 vccd1 sky130_fd_sc_hd__fill_1
XFILLER_15_266 vccd1 vssd1 vccd1 vssd1 sky130_ef_sc_hd__decap_40_12
XPHY_EDGE_ROW_4_Left_84 vssd1 vssd1 vccd1 vccd1 sky130_fd_sc_hd__decap_3
XFILLER_7_476 vccd1 vssd1 vccd1 vssd1 sky130_ef_sc_hd__decap_40_12
XANTENNA__1718__C1 _0545_ vssd1 vssd1 vccd1 vccd1 sky130_fd_sc_hd__diode_2
X_2300_ net390 _0921_ net99 vssd1 vssd1 vccd1 vccd1 _0355_ sky130_fd_sc_hd__mux2_1
X_3280_ clknet_leaf_8_clk _0202_ vssd1 vssd1 vccd1 vccd1 MATMULT_INST.matmult_inst.mem_inst.matrixA2\[7\]
+ sky130_fd_sc_hd__dfxtp_1
X_2231_ MATMULT_INST.matmult_inst.alu_inst.adder_inst.r1.fa0.b MATMULT_INST.matmult_inst.alu_inst.adder_inst.r1.fa0.a
+ vssd1 vssd1 vccd1 vccd1 _0863_ sky130_fd_sc_hd__nand2_1
X_2162_ net110 _0809_ net11 net396 vssd1 vssd1 vccd1 vccd1 _0315_ sky130_fd_sc_hd__a22o_1
XFILLER_65_111 vssd1 vssd1 vccd1 vccd1 sky130_fd_sc_hd__fill_1
XFILLER_17_3 vccd1 vssd1 vccd1 vssd1 sky130_ef_sc_hd__decap_40_12
XANTENNA__2096__S net17 vssd1 vssd1 vccd1 vccd1 sky130_fd_sc_hd__diode_2
X_2093_ net326 net49 net16 vssd1 vssd1 vccd1 vccd1 _0249_ sky130_fd_sc_hd__mux2_1
XFILLER_65_166 vssd1 vssd1 vccd1 vccd1 sky130_fd_sc_hd__fill_2
X_2995_ _1532_ _1533_ vssd1 vssd1 vccd1 vccd1 _1534_ sky130_fd_sc_hd__xnor2_1
X_1946_ MATMULT_INST.matmult_inst.fsm_inst.rx_data\[2\] net71 net70 MATMULT_INST.matmult_inst.fsm_inst.alu_result\[2\]
+ vssd1 vssd1 vccd1 vccd1 _0799_ sky130_fd_sc_hd__a22o_1
X_1877_ net132 _1593_ _0541_ vssd1 vssd1 vccd1 vccd1 _0755_ sky130_fd_sc_hd__or3_1
X_3616_ clknet_leaf_25_clk MATMULT_INST.matmult_inst.spi_inst.mosi_data_spi\[0\] _0114_
+ vssd1 vssd1 vccd1 vccd1 MATMULT_INST.matmult_inst.spi_inst.mosi_data_sync\[0\] sky130_fd_sc_hd__dfrtp_1
X_3547_ _0060_ _0460_ _0059_ vssd1 vssd1 vccd1 vccd1 MATMULT_INST.matmult_inst.spi_inst.mosi_shifter\[3\]
+ sky130_fd_sc_hd__dfrtp_1
XANTENNA__1724__A2 net129 vssd1 vssd1 vccd1 vccd1 sky130_fd_sc_hd__diode_2
X_3478_ clknet_leaf_34_clk _0398_ vssd1 vssd1 vccd1 vccd1 MATMULT_INST.matmult_inst.alu_inst.col1\[6\]
+ sky130_fd_sc_hd__dfxtp_1
XFILLER_69_461 vccd1 vssd1 vccd1 vssd1 sky130_ef_sc_hd__decap_40_12
X_2429_ _1022_ _1023_ _1015_ vssd1 vssd1 vccd1 vccd1 _1024_ sky130_fd_sc_hd__a21oi_1
Xteam_02_237 vssd1 vssd1 vccd1 vccd1 team_02_237/HI gpio_oeb[10] sky130_fd_sc_hd__conb_1
Xteam_02_259 vssd1 vssd1 vccd1 vccd1 team_02_259/HI gpio_oeb[32] sky130_fd_sc_hd__conb_1
Xteam_02_248 vssd1 vssd1 vccd1 vccd1 team_02_248/HI gpio_oeb[21] sky130_fd_sc_hd__conb_1
XANTENNA__2685__B1 _1254_ vssd1 vssd1 vccd1 vccd1 sky130_fd_sc_hd__diode_2
XFILLER_44_317 vssd1 vssd1 vccd1 vccd1 sky130_fd_sc_hd__fill_4
XFILLER_56_177 vssd1 vssd1 vccd1 vccd1 sky130_fd_sc_hd__fill_2
XTAP_TAPCELL_ROW_42_529 vssd1 vccd1 sky130_fd_sc_hd__tapvpwrvgnd_1
XANTENNA_fanout24_A _0817_ vssd1 vssd1 vccd1 vccd1 sky130_fd_sc_hd__diode_2
XANTENNA__2035__A net123 vssd1 vssd1 vccd1 vccd1 sky130_fd_sc_hd__diode_2
XFILLER_20_280 vssd1 vssd1 vccd1 vccd1 sky130_fd_sc_hd__fill_4
XTAP_TAPCELL_ROW_50_595 vssd1 vccd1 sky130_fd_sc_hd__tapvpwrvgnd_1
XFILLER_5_18 vssd1 vssd1 vccd1 vccd1 sky130_fd_sc_hd__fill_4
XFILLER_4_457 vccd1 vssd1 vccd1 vssd1 sky130_ef_sc_hd__decap_40_12
XFILLER_69_65 vssd1 vssd1 vccd1 vccd1 sky130_fd_sc_hd__fill_8
XFILLER_47_111 vssd1 vssd1 vccd1 vccd1 sky130_fd_sc_hd__fill_1
XTAP_TAPCELL_ROW_58_662 vssd1 vccd1 sky130_fd_sc_hd__tapvpwrvgnd_1
XFILLER_50_309 vssd1 vssd1 vccd1 vccd1 sky130_fd_sc_hd__fill_2
XFILLER_34_90 vssd1 vssd1 vccd1 vccd1 sky130_fd_sc_hd__fill_1
X_1800_ MATMULT_INST.matmult_inst.mem_inst.matrixA1\[1\] net125 net117 MATMULT_INST.matmult_inst.mem_inst.matrixA2\[1\]
+ vssd1 vssd1 vccd1 vccd1 _0714_ sky130_fd_sc_hd__a22o_1
X_2780_ net169 net175 _1323_ _1324_ vssd1 vssd1 vccd1 vccd1 _1325_ sky130_fd_sc_hd__a22o_1
X_1731_ net641 net64 _0649_ _0651_ vssd1 vssd1 vccd1 vccd1 _0498_ sky130_fd_sc_hd__o22a_1
XTAP_TAPCELL_ROW_13_286 vssd1 vccd1 sky130_fd_sc_hd__tapvpwrvgnd_1
X_1662_ MATMULT_INST.matmult_inst.mem_inst.mem1\[14\] net126 net118 MATMULT_INST.matmult_inst.mem_inst.mem2\[14\]
+ _0588_ vssd1 vssd1 vccd1 vccd1 _0589_ sky130_fd_sc_hd__a221o_1
XANTENNA__1954__A2 net71 vssd1 vssd1 vccd1 vccd1 sky130_fd_sc_hd__diode_2
Xhold207 MATMULT_INST.matmult_inst.mem_inst.mem1\[7\] vssd1 vssd1 vccd1 vccd1 net502
+ sky130_fd_sc_hd__dlygate4sd3_1
X_3401_ clknet_leaf_34_clk _0323_ vssd1 vssd1 vccd1 vccd1 MATMULT_INST.matmult_inst.fsm_inst.count\[2\]
+ sky130_fd_sc_hd__dfxtp_1
Xhold218 MATMULT_INST.matmult_inst.alu_inst.out\[8\] vssd1 vssd1 vccd1 vccd1 net513
+ sky130_fd_sc_hd__dlygate4sd3_1
Xhold229 _0482_ vssd1 vssd1 vccd1 vccd1 net524 sky130_fd_sc_hd__dlygate4sd3_1
X_3332_ clknet_leaf_1_clk _0254_ vssd1 vssd1 vccd1 vccd1 MATMULT_INST.matmult_inst.mem_inst.mem3\[5\]
+ sky130_fd_sc_hd__dfxtp_1
X_3263_ clknet_leaf_15_clk _0185_ vssd1 vssd1 vccd1 vccd1 MATMULT_INST.matmult_inst.mem_inst.matrixA3\[8\]
+ sky130_fd_sc_hd__dfxtp_1
XFILLER_78_280 vssd1 vssd1 vccd1 vccd1 sky130_fd_sc_hd__fill_2
XANTENNA__2667__B1 _1248_ vssd1 vssd1 vccd1 vccd1 sky130_fd_sc_hd__diode_2
X_2214_ _0847_ _0848_ vssd1 vssd1 vccd1 vccd1 _0849_ sky130_fd_sc_hd__nor2_1
X_3194_ net55 net84 net76 vssd1 vssd1 vccd1 vccd1 _0119_ sky130_fd_sc_hd__and3_1
X_2145_ net512 net35 net12 vssd1 vssd1 vccd1 vccd1 _0299_ sky130_fd_sc_hd__mux2_1
XFILLER_66_464 vssd1 vssd1 vccd1 vccd1 sky130_fd_sc_hd__fill_2
XFILLER_38_122 vssd1 vssd1 vccd1 vccd1 sky130_fd_sc_hd__fill_8
XFILLER_66_475 vssd1 vssd1 vccd1 vccd1 sky130_fd_sc_hd__fill_1
XFILLER_26_317 vssd1 vssd1 vccd1 vccd1 sky130_fd_sc_hd__fill_2
XFILLER_26_328 vssd1 vssd1 vccd1 vccd1 sky130_fd_sc_hd__fill_1
XFILLER_19_391 vssd1 vssd1 vccd1 vccd1 sky130_fd_sc_hd__fill_1
X_2076_ net464 net47 net18 vssd1 vssd1 vccd1 vccd1 _0233_ sky130_fd_sc_hd__mux2_1
XFILLER_34_361 vssd1 vssd1 vccd1 vccd1 sky130_fd_sc_hd__fill_2
XANTENNA__1642__A1 net222 vssd1 vssd1 vccd1 vccd1 sky130_fd_sc_hd__diode_2
XFILLER_14_27 vssd1 vssd1 vccd1 vccd1 sky130_fd_sc_hd__fill_1
XFILLER_14_49 vssd1 vssd1 vccd1 vccd1 sky130_fd_sc_hd__fill_1
X_2978_ net155 net178 _1486_ _1488_ vssd1 vssd1 vccd1 vccd1 _1517_ sky130_fd_sc_hd__a31o_1
X_1929_ MATMULT_INST.matmult_inst.spi_inst.tx_reg_sys\[8\] MATMULT_INST.matmult_inst.spi_inst.miso_shifter\[7\]
+ net136 vssd1 vssd1 vccd1 vccd1 _0021_ sky130_fd_sc_hd__mux2_1
XFILLER_30_15 vccd1 vssd1 vccd1 vssd1 sky130_ef_sc_hd__decap_40_12
XANTENNA_fanout114_X net114 vssd1 vssd1 vccd1 vccd1 sky130_fd_sc_hd__diode_2
XFILLER_1_449 vccd1 vssd1 vccd1 vssd1 sky130_ef_sc_hd__decap_40_12
XFILLER_39_57 vssd1 vssd1 vccd1 vccd1 sky130_fd_sc_hd__fill_8
XTAP_TAPCELL_ROW_4_210 vssd1 vccd1 sky130_fd_sc_hd__tapvpwrvgnd_1
XFILLER_57_420 vssd1 vssd1 vccd1 vccd1 sky130_fd_sc_hd__fill_4
XFILLER_69_291 vssd1 vssd1 vccd1 vccd1 sky130_fd_sc_hd__fill_4
XFILLER_29_177 vssd1 vssd1 vccd1 vccd1 sky130_fd_sc_hd__fill_2
XTAP_TAPCELL_ROW_55_643 vssd1 vccd1 sky130_fd_sc_hd__tapvpwrvgnd_1
XFILLER_72_489 vssd1 vssd1 vccd1 vccd1 sky130_fd_sc_hd__fill_2
XANTENNA__1633__A1 net216 vssd1 vssd1 vccd1 vccd1 sky130_fd_sc_hd__diode_2
XANTENNA_fanout27_X net27 vssd1 vssd1 vccd1 vccd1 sky130_fd_sc_hd__diode_2
XFILLER_40_375 vssd1 vssd1 vccd1 vccd1 sky130_fd_sc_hd__fill_2
XTAP_TAPCELL_ROW_10_256 vssd1 vccd1 sky130_fd_sc_hd__tapvpwrvgnd_1
XANTENNA__2212__B MATMULT_INST.matmult_inst.alu_inst.adder_inst.r0.fa1.a vssd1 vssd1
+ vccd1 vccd1 sky130_fd_sc_hd__diode_2
XFILLER_0_471 vssd1 vssd1 vccd1 vccd1 sky130_fd_sc_hd__fill_1
XFILLER_63_401 vccd1 vssd1 vccd1 vssd1 sky130_ef_sc_hd__decap_40_12
Xhold90 MATMULT_INST.matmult_inst.mem_inst.matrixA0\[5\] vssd1 vssd1 vccd1 vccd1 net385
+ sky130_fd_sc_hd__dlygate4sd3_1
XFILLER_48_475 vssd1 vssd1 vccd1 vccd1 sky130_fd_sc_hd__fill_1
XTAP_TAPCELL_ROW_18_323 vssd1 vccd1 sky130_fd_sc_hd__tapvpwrvgnd_1
XANTENNA__1779__A net149 vssd1 vssd1 vccd1 vccd1 sky130_fd_sc_hd__diode_2
X_2901_ _1429_ _1431_ _1428_ vssd1 vssd1 vccd1 vccd1 _1442_ sky130_fd_sc_hd__a21bo_1
XFILLER_31_320 vccd1 vssd1 vccd1 vssd1 sky130_ef_sc_hd__decap_40_12
XFILLER_31_353 vssd1 vssd1 vccd1 vccd1 sky130_fd_sc_hd__fill_4
X_2832_ _1358_ _1374_ _1373_ _1372_ vssd1 vssd1 vccd1 vccd1 _1375_ sky130_fd_sc_hd__a211o_1
X_2763_ _1287_ _1308_ vssd1 vssd1 vccd1 vccd1 _1309_ sky130_fd_sc_hd__nor2_1
X_1714_ MATMULT_INST.matmult_inst.mem_inst.mem1\[9\] net129 net121 MATMULT_INST.matmult_inst.mem_inst.mem2\[9\]
+ _0635_ vssd1 vssd1 vccd1 vccd1 _0636_ sky130_fd_sc_hd__a221o_1
X_2694_ net93 _1252_ _1255_ net508 vssd1 vssd1 vccd1 vccd1 _0414_ sky130_fd_sc_hd__a22o_1
X_1645_ net620 _0573_ net64 vssd1 vssd1 vccd1 vccd1 _0506_ sky130_fd_sc_hd__mux2_1
X_3315_ clknet_leaf_6_clk _0237_ vssd1 vssd1 vccd1 vccd1 MATMULT_INST.matmult_inst.mem_inst.matrixA0\[6\]
+ sky130_fd_sc_hd__dfxtp_1
XFILLER_58_239 vssd1 vssd1 vccd1 vccd1 sky130_fd_sc_hd__fill_1
X_3246_ clknet_leaf_18_clk _0168_ vssd1 vssd1 vccd1 vccd1 MATMULT_INST.matmult_inst.mem_inst.matrixB0\[9\]
+ sky130_fd_sc_hd__dfxtp_1
XTAP_TAPCELL_ROW_69_757 vssd1 vccd1 sky130_fd_sc_hd__tapvpwrvgnd_1
X_3177_ net58 net87 net73 vssd1 vssd1 vccd1 vccd1 _0102_ sky130_fd_sc_hd__and3_1
X_2128_ net443 net33 net14 vssd1 vssd1 vccd1 vccd1 _0283_ sky130_fd_sc_hd__mux2_1
XANTENNA__1689__A net152 vssd1 vssd1 vccd1 vccd1 sky130_fd_sc_hd__diode_2
XFILLER_25_15 vssd1 vssd1 vccd1 vccd1 sky130_fd_sc_hd__fill_2
X_2059_ net469 net45 net20 vssd1 vssd1 vccd1 vccd1 _0217_ sky130_fd_sc_hd__mux2_1
XTAP_TAPCELL_ROW_52_613 vssd1 vccd1 sky130_fd_sc_hd__tapvpwrvgnd_1
XANTENNA__1976__X _0814_ vssd1 vssd1 vccd1 vccd1 sky130_fd_sc_hd__diode_2
XFILLER_1_202 vccd1 vssd1 vccd1 vssd1 sky130_ef_sc_hd__decap_40_12
XFILLER_1_279 vssd1 vssd1 vccd1 vccd1 sky130_fd_sc_hd__fill_1
XFILLER_17_136 vssd1 vssd1 vccd1 vccd1 sky130_fd_sc_hd__fill_2
XFILLER_45_434 vssd1 vssd1 vccd1 vccd1 sky130_fd_sc_hd__fill_1
XANTENNA__1599__A net2 vssd1 vssd1 vccd1 vccd1 sky130_fd_sc_hd__diode_2
XFILLER_17_169 vssd1 vssd1 vccd1 vccd1 sky130_fd_sc_hd__fill_4
XFILLER_32_106 vssd1 vssd1 vccd1 vccd1 sky130_fd_sc_hd__fill_4
XFILLER_13_331 vssd1 vssd1 vccd1 vccd1 sky130_fd_sc_hd__fill_4
XFILLER_13_386 vssd1 vssd1 vccd1 vccd1 sky130_fd_sc_hd__fill_4
XFILLER_13_397 vssd1 vssd1 vccd1 vccd1 sky130_fd_sc_hd__fill_2
XTAP_TAPCELL_ROW_23_370 vssd1 vccd1 sky130_fd_sc_hd__tapvpwrvgnd_1
XANTENNA__2031__A1 net35 vssd1 vssd1 vccd1 vccd1 sky130_fd_sc_hd__diode_2
XANTENNA__1781__B net140 vssd1 vssd1 vccd1 vccd1 sky130_fd_sc_hd__diode_2
X_3100_ net60 net89 net80 vssd1 vssd1 vccd1 vccd1 _0063_ sky130_fd_sc_hd__and3_1
X_3031_ _1529_ _1550_ _1553_ _1551_ vssd1 vssd1 vccd1 vccd1 _1568_ sky130_fd_sc_hd__a31o_1
XFILLER_48_294 vssd1 vssd1 vccd1 vccd1 sky130_fd_sc_hd__fill_1
XFILLER_23_117 vssd1 vssd1 vccd1 vccd1 sky130_fd_sc_hd__fill_2
XFILLER_36_489 vssd1 vssd1 vccd1 vccd1 sky130_fd_sc_hd__fill_4
XFILLER_51_426 vssd1 vssd1 vccd1 vccd1 sky130_fd_sc_hd__fill_2
XFILLER_23_139 vccd1 vssd1 vccd1 vssd1 sky130_ef_sc_hd__decap_40_12
X_2815_ _1357_ _1358_ vssd1 vssd1 vccd1 vccd1 _1359_ sky130_fd_sc_hd__nand2_1
XFILLER_31_183 vssd1 vssd1 vccd1 vccd1 sky130_fd_sc_hd__fill_4
X_2746_ _1291_ _1292_ net383 net115 vssd1 vssd1 vccd1 vccd1 _0429_ sky130_fd_sc_hd__a2bb2o_1
X_2677_ net614 _1246_ _1253_ net103 vssd1 vssd1 vccd1 vccd1 _0399_ sky130_fd_sc_hd__a22o_1
X_1628_ net219 net217 vssd1 vssd1 vccd1 vccd1 _0558_ sky130_fd_sc_hd__nor2_1
X_3229_ clknet_leaf_15_clk _0151_ vssd1 vssd1 vccd1 vccd1 MATMULT_INST.matmult_inst.mem_inst.matrixB1\[10\]
+ sky130_fd_sc_hd__dfxtp_1
XTAP_TAPCELL_ROW_29_418 vssd1 vccd1 sky130_fd_sc_hd__tapvpwrvgnd_1
XFILLER_27_412 vssd1 vssd1 vccd1 vccd1 sky130_fd_sc_hd__fill_2
XFILLER_27_456 vccd1 vssd1 vccd1 vssd1 sky130_ef_sc_hd__decap_40_12
XFILLER_14_117 vssd1 vssd1 vccd1 vccd1 sky130_fd_sc_hd__fill_8
XTAP_TAPCELL_ROW_37_484 vssd1 vccd1 sky130_fd_sc_hd__tapvpwrvgnd_1
XFILLER_14_139 vssd1 vssd1 vccd1 vccd1 sky130_fd_sc_hd__fill_1
XFILLER_50_492 vssd1 vssd1 vccd1 vccd1 sky130_fd_sc_hd__fill_2
XTAP_TAPCELL_ROW_20_340 vssd1 vccd1 sky130_fd_sc_hd__tapvpwrvgnd_1
XANTENNA__2013__A1 net106 vssd1 vssd1 vccd1 vccd1 sky130_fd_sc_hd__diode_2
XFILLER_6_338 vssd1 vssd1 vccd1 vccd1 sky130_fd_sc_hd__fill_2
XTAP_TAPCELL_ROW_63_708 vssd1 vccd1 sky130_fd_sc_hd__tapvpwrvgnd_1
XFILLER_60_223 vssd1 vssd1 vccd1 vccd1 sky130_fd_sc_hd__fill_2
XTAP_TAPCELL_ROW_71_774 vssd1 vccd1 sky130_fd_sc_hd__tapvpwrvgnd_1
XFILLER_9_121 vssd1 vssd1 vccd1 vccd1 sky130_fd_sc_hd__fill_2
XFILLER_9_165 vssd1 vssd1 vccd1 vccd1 sky130_fd_sc_hd__fill_2
XANTENNA_clkbuf_leaf_20_clk_A clknet_2_3__leaf_clk vssd1 vssd1 vccd1 vccd1 sky130_fd_sc_hd__diode_2
X_2600_ _1163_ _1188_ vssd1 vssd1 vccd1 vccd1 _1190_ sky130_fd_sc_hd__nand2_1
X_3580_ net224 _0007_ _0078_ vssd1 vssd1 vccd1 vccd1 MATMULT_INST.matmult_inst.spi_inst.miso_shifter\[0\]
+ sky130_fd_sc_hd__dfrtp_1
X_2531_ _1037_ _1075_ _1073_ vssd1 vssd1 vccd1 vccd1 _1123_ sky130_fd_sc_hd__a21o_1
XANTENNA_clkbuf_leaf_35_clk_A clknet_2_0__leaf_clk vssd1 vssd1 vccd1 vccd1 sky130_fd_sc_hd__diode_2
XFILLER_5_393 vssd1 vssd1 vccd1 vccd1 sky130_fd_sc_hd__fill_4
X_2462_ net212 net186 net210 net189 vssd1 vssd1 vccd1 vccd1 _1056_ sky130_fd_sc_hd__a22o_1
XANTENNA__2099__S net16 vssd1 vssd1 vccd1 vccd1 sky130_fd_sc_hd__diode_2
XFILLER_47_3 vccd1 vssd1 vccd1 vssd1 sky130_ef_sc_hd__decap_40_12
X_2393_ net212 net214 MATMULT_INST.matmult_inst.alu_inst.a0_reg\[4\] net189 vssd1
+ vssd1 vccd1 vccd1 _0989_ sky130_fd_sc_hd__nand4_2
XTAP_TAPCELL_ROW_79_852 vssd1 vccd1 sky130_fd_sc_hd__tapvpwrvgnd_1
XTAP_TAPCELL_ROW_79_841 vssd1 vccd1 sky130_fd_sc_hd__tapvpwrvgnd_1
X_3014_ _1551_ vssd1 vssd1 vccd1 vccd1 _1552_ sky130_fd_sc_hd__inv_2
XANTENNA__1818__A1 _0730_ vssd1 vssd1 vccd1 vccd1 sky130_fd_sc_hd__diode_2
XFILLER_36_253 vccd1 vssd1 vccd1 vssd1 sky130_ef_sc_hd__decap_40_12
XFILLER_51_223 vssd1 vssd1 vccd1 vccd1 sky130_fd_sc_hd__fill_1
XFILLER_11_109 vssd1 vssd1 vccd1 vccd1 sky130_fd_sc_hd__fill_2
XTAP_TAPCELL_ROW_34_465 vssd1 vccd1 sky130_fd_sc_hd__tapvpwrvgnd_1
XANTENNA_fanout141_A net145 vssd1 vssd1 vccd1 vccd1 sky130_fd_sc_hd__diode_2
XFILLER_22_27 vssd1 vssd1 vccd1 vccd1 sky130_fd_sc_hd__fill_1
X_2729_ net168 net180 _1274_ _1275_ vssd1 vssd1 vccd1 vccd1 _1277_ sky130_fd_sc_hd__o2bb2a_1
Xfanout122 net123 vssd1 vssd1 vccd1 vccd1 net122 sky130_fd_sc_hd__clkbuf_2
Xfanout100 _0003_ vssd1 vssd1 vccd1 vccd1 net100 sky130_fd_sc_hd__clkbuf_4
Xfanout111 _0560_ vssd1 vssd1 vccd1 vccd1 net111 sky130_fd_sc_hd__buf_2
Xfanout144 net145 vssd1 vssd1 vccd1 vccd1 net144 sky130_fd_sc_hd__clkbuf_2
Xfanout155 MATMULT_INST.matmult_inst.alu_inst.a1_reg\[7\] vssd1 vssd1 vccd1 vccd1
+ net155 sky130_fd_sc_hd__buf_2
Xfanout133 MATMULT_INST.matmult_inst.fsm_inst.state\[2\] vssd1 vssd1 vccd1 vccd1 net133
+ sky130_fd_sc_hd__buf_2
XFILLER_59_334 vssd1 vssd1 vccd1 vccd1 sky130_fd_sc_hd__fill_2
XFILLER_59_345 vssd1 vssd1 vccd1 vccd1 sky130_fd_sc_hd__fill_1
Xfanout188 MATMULT_INST.matmult_inst.alu_inst.a0_reg\[5\] vssd1 vssd1 vccd1 vccd1
+ net188 sky130_fd_sc_hd__buf_2
Xfanout199 net200 vssd1 vssd1 vccd1 vccd1 net199 sky130_fd_sc_hd__buf_2
Xfanout177 MATMULT_INST.matmult_inst.alu_inst.b1_reg\[4\] vssd1 vssd1 vccd1 vccd1
+ net177 sky130_fd_sc_hd__dlymetal6s2s_1
Xfanout166 MATMULT_INST.matmult_inst.alu_inst.a1_reg\[1\] vssd1 vssd1 vccd1 vccd1
+ net166 sky130_fd_sc_hd__buf_2
XFILLER_74_348 vssd1 vssd1 vccd1 vccd1 sky130_fd_sc_hd__fill_2
XPHY_EDGE_ROW_29_Right_29 vssd1 vssd1 vccd1 vccd1 sky130_fd_sc_hd__decap_3
XFILLER_27_231 vssd1 vssd1 vccd1 vccd1 sky130_fd_sc_hd__fill_1
XANTENNA_fanout54_A _0734_ vssd1 vssd1 vccd1 vccd1 sky130_fd_sc_hd__diode_2
XFILLER_27_286 vccd1 vssd1 vccd1 vssd1 sky130_ef_sc_hd__decap_40_12
XFILLER_63_45 vssd1 vssd1 vccd1 vccd1 sky130_fd_sc_hd__fill_8
XFILLER_42_223 vssd1 vssd1 vccd1 vccd1 sky130_fd_sc_hd__fill_1
XFILLER_42_234 vssd1 vssd1 vccd1 vccd1 sky130_fd_sc_hd__fill_1
XFILLER_63_78 vssd1 vssd1 vccd1 vccd1 sky130_fd_sc_hd__fill_4
XFILLER_8_29 vssd1 vssd1 vccd1 vccd1 sky130_fd_sc_hd__fill_2
XPHY_EDGE_ROW_38_Right_38 vssd1 vssd1 vccd1 vccd1 sky130_fd_sc_hd__decap_3
XFILLER_2_363 vssd1 vssd1 vccd1 vccd1 sky130_fd_sc_hd__fill_1
XFILLER_65_304 vssd1 vssd1 vccd1 vccd1 sky130_fd_sc_hd__fill_2
XPHY_EDGE_ROW_47_Right_47 vssd1 vssd1 vccd1 vccd1 sky130_fd_sc_hd__decap_3
XTAP_TAPCELL_ROW_76_822 vssd1 vccd1 sky130_fd_sc_hd__tapvpwrvgnd_1
XFILLER_33_212 vssd1 vssd1 vccd1 vccd1 sky130_fd_sc_hd__fill_1
XTAP_TAPCELL_ROW_48_579 vssd1 vccd1 sky130_fd_sc_hd__tapvpwrvgnd_1
XANTENNA__1787__A net148 vssd1 vssd1 vccd1 vccd1 sky130_fd_sc_hd__diode_2
X_1962_ MATMULT_INST.matmult_inst.fsm_inst.alu_result\[10\] net69 vssd1 vssd1 vccd1
+ vccd1 _0807_ sky130_fd_sc_hd__and2_1
XPHY_EDGE_ROW_56_Right_56 vssd1 vssd1 vccd1 vccd1 sky130_fd_sc_hd__decap_3
XTAP_TAPCELL_ROW_31_435 vssd1 vccd1 sky130_fd_sc_hd__tapvpwrvgnd_1
X_1893_ MATMULT_INST.matmult_inst.fsm_inst.count\[1\] MATMULT_INST.matmult_inst.fsm_inst.count\[0\]
+ vssd1 vssd1 vccd1 vccd1 _0771_ sky130_fd_sc_hd__or2_2
X_3632_ clknet_leaf_24_clk net325 vssd1 vssd1 vccd1 vccd1 MATMULT_INST.matmult_inst.fsm_inst.alu_result\[8\]
+ sky130_fd_sc_hd__dfxtp_1
X_3563_ clknet_leaf_13_clk _0475_ vssd1 vssd1 vccd1 vccd1 MATMULT_INST.matmult_inst.mem_inst.matrixB3\[11\]
+ sky130_fd_sc_hd__dfxtp_1
X_2514_ net199 net193 net191 net201 vssd1 vssd1 vccd1 vccd1 _1106_ sky130_fd_sc_hd__a22oi_1
X_3494_ clknet_leaf_34_clk _0413_ vssd1 vssd1 vccd1 vccd1 MATMULT_INST.matmult_inst.alu_inst.row1\[5\]
+ sky130_fd_sc_hd__dfxtp_1
XPHY_EDGE_ROW_65_Right_65 vssd1 vssd1 vccd1 vccd1 sky130_fd_sc_hd__decap_3
X_2445_ _0989_ _1008_ _1009_ _1004_ vssd1 vssd1 vccd1 vccd1 _1039_ sky130_fd_sc_hd__a31o_1
XANTENNA__2130__B net128 vssd1 vssd1 vccd1 vccd1 sky130_fd_sc_hd__diode_2
X_2376_ _0951_ _0972_ vssd1 vssd1 vccd1 vccd1 _0973_ sky130_fd_sc_hd__nor2_1
XTAP_TAPCELL_ROW_39_502 vssd1 vccd1 sky130_fd_sc_hd__tapvpwrvgnd_1
XFILLER_56_348 vssd1 vssd1 vccd1 vccd1 sky130_fd_sc_hd__fill_4
XPHY_EDGE_ROW_74_Right_74 vssd1 vssd1 vccd1 vccd1 sky130_fd_sc_hd__decap_3
XFILLER_12_418 vssd1 vssd1 vccd1 vccd1 sky130_fd_sc_hd__fill_2
XFILLER_33_15 vssd1 vssd1 vccd1 vccd1 sky130_fd_sc_hd__fill_1
XFILLER_12_429 vssd1 vssd1 vccd1 vccd1 sky130_fd_sc_hd__fill_2
XFILLER_33_48 vssd1 vssd1 vccd1 vccd1 sky130_fd_sc_hd__fill_8
XFILLER_3_149 vssd1 vssd1 vccd1 vccd1 sky130_fd_sc_hd__fill_4
XFILLER_58_45 vssd1 vssd1 vccd1 vccd1 sky130_fd_sc_hd__fill_8
XANTENNA__2975__B net176 vssd1 vssd1 vccd1 vccd1 sky130_fd_sc_hd__diode_2
XFILLER_47_348 vssd1 vssd1 vccd1 vccd1 sky130_fd_sc_hd__fill_4
XFILLER_47_359 vssd1 vssd1 vccd1 vccd1 sky130_fd_sc_hd__fill_4
XFILLER_74_178 vssd1 vssd1 vccd1 vccd1 sky130_fd_sc_hd__fill_8
XFILLER_74_44 vssd1 vssd1 vccd1 vccd1 sky130_fd_sc_hd__fill_4
XTAP_TAPCELL_ROW_2_193 vssd1 vccd1 sky130_fd_sc_hd__tapvpwrvgnd_1
XFILLER_55_381 vssd1 vssd1 vccd1 vccd1 sky130_fd_sc_hd__fill_8
XFILLER_15_278 vssd1 vssd1 vccd1 vccd1 sky130_fd_sc_hd__fill_2
XFILLER_30_215 vssd1 vssd1 vccd1 vccd1 sky130_fd_sc_hd__fill_2
XFILLER_30_259 vssd1 vssd1 vccd1 vccd1 sky130_fd_sc_hd__fill_1
XFILLER_23_70 vssd1 vssd1 vccd1 vccd1 sky130_fd_sc_hd__fill_2
XFILLER_7_488 vssd1 vssd1 vccd1 vccd1 sky130_fd_sc_hd__fill_2
X_2230_ MATMULT_INST.matmult_inst.alu_inst.adder_inst.r1.fa0.b MATMULT_INST.matmult_inst.alu_inst.adder_inst.r1.fa0.a
+ vssd1 vssd1 vccd1 vccd1 _0862_ sky130_fd_sc_hd__nor2_1
XFILLER_78_473 vssd1 vssd1 vccd1 vccd1 sky130_fd_sc_hd__fill_2
X_2161_ net110 _0808_ net11 net484 vssd1 vssd1 vccd1 vccd1 _0314_ sky130_fd_sc_hd__a22o_1
XANTENNA__2694__A1 net93 vssd1 vssd1 vccd1 vccd1 sky130_fd_sc_hd__diode_2
XANTENNA_clkbuf_2_2__f_clk_A clknet_0_clk vssd1 vssd1 vccd1 vccd1 sky130_fd_sc_hd__diode_2
XFILLER_38_359 vssd1 vssd1 vccd1 vccd1 sky130_fd_sc_hd__fill_4
X_2092_ net217 _0548_ net50 vssd1 vssd1 vccd1 vccd1 _0821_ sky130_fd_sc_hd__and3_1
XFILLER_0_85 vccd1 vssd1 vccd1 vssd1 sky130_ef_sc_hd__decap_40_12
XFILLER_61_395 vssd1 vssd1 vccd1 vccd1 sky130_fd_sc_hd__fill_2
X_2994_ _1473_ _1503_ _1505_ _1507_ vssd1 vssd1 vccd1 vccd1 _1533_ sky130_fd_sc_hd__a31o_1
XFILLER_21_259 vssd1 vssd1 vccd1 vccd1 sky130_fd_sc_hd__fill_4
X_1945_ net408 net48 net30 vssd1 vssd1 vccd1 vccd1 _0124_ sky130_fd_sc_hd__mux2_1
X_1876_ _0753_ vssd1 vssd1 vccd1 vccd1 _0754_ sky130_fd_sc_hd__inv_2
X_3615_ net228 _0006_ _0113_ vssd1 vssd1 vccd1 vccd1 MATMULT_INST.matmult_inst.spi_inst.miso_bit
+ sky130_fd_sc_hd__dfrtp_1
X_3546_ _0058_ _0459_ _0057_ vssd1 vssd1 vccd1 vccd1 MATMULT_INST.matmult_inst.spi_inst.mosi_shifter\[2\]
+ sky130_fd_sc_hd__dfrtp_1
XANTENNA_fanout104_A net107 vssd1 vssd1 vccd1 vccd1 sky130_fd_sc_hd__diode_2
X_3477_ clknet_leaf_34_clk _0397_ vssd1 vssd1 vccd1 vccd1 MATMULT_INST.matmult_inst.alu_inst.col1\[5\]
+ sky130_fd_sc_hd__dfxtp_1
XANTENNA__2795__B net173 vssd1 vssd1 vccd1 vccd1 sky130_fd_sc_hd__diode_2
X_2428_ _1020_ _1021_ _0981_ vssd1 vssd1 vccd1 vccd1 _1023_ sky130_fd_sc_hd__a21o_1
XFILLER_69_473 vccd1 vssd1 vccd1 vssd1 sky130_ef_sc_hd__decap_40_12
Xteam_02_249 vssd1 vssd1 vccd1 vccd1 team_02_249/HI gpio_oeb[22] sky130_fd_sc_hd__conb_1
Xteam_02_238 vssd1 vssd1 vccd1 vccd1 team_02_238/HI gpio_oeb[11] sky130_fd_sc_hd__conb_1
XANTENNA__2685__A1 net82 vssd1 vssd1 vccd1 vccd1 sky130_fd_sc_hd__diode_2
XFILLER_28_15 vccd1 vssd1 vccd1 vssd1 sky130_ef_sc_hd__decap_40_12
XFILLER_29_337 vssd1 vssd1 vccd1 vccd1 sky130_fd_sc_hd__fill_4
X_2359_ _0955_ _0956_ MATMULT_INST.matmult_inst.alu_inst.adder_inst.r0.fa3.a net114
+ vssd1 vssd1 vccd1 vccd1 _0378_ sky130_fd_sc_hd__a2bb2o_1
XANTENNA__2437__A1 _1031_ vssd1 vssd1 vccd1 vccd1 sky130_fd_sc_hd__diode_2
XFILLER_44_329 vssd1 vssd1 vccd1 vccd1 sky130_fd_sc_hd__fill_2
XFILLER_44_58 vssd1 vssd1 vccd1 vccd1 sky130_fd_sc_hd__fill_8
XTAP_TAPCELL_ROW_50_596 vssd1 vccd1 sky130_fd_sc_hd__tapvpwrvgnd_1
XFILLER_69_55 vssd1 vssd1 vccd1 vccd1 sky130_fd_sc_hd__fill_1
XFILLER_4_469 vssd1 vssd1 vccd1 vccd1 sky130_fd_sc_hd__fill_4
XTAP_TAPCELL_ROW_7_230 vssd1 vccd1 sky130_fd_sc_hd__tapvpwrvgnd_1
XFILLER_79_259 vssd1 vssd1 vccd1 vccd1 sky130_fd_sc_hd__fill_2
XFILLER_18_70 vssd1 vssd1 vccd1 vccd1 sky130_fd_sc_hd__fill_1
XFILLER_47_156 vssd1 vssd1 vccd1 vccd1 sky130_fd_sc_hd__fill_1
XFILLER_47_167 vssd1 vssd1 vccd1 vccd1 sky130_fd_sc_hd__fill_1
XTAP_TAPCELL_ROW_58_663 vssd1 vccd1 sky130_fd_sc_hd__tapvpwrvgnd_1
XFILLER_62_137 vssd1 vssd1 vccd1 vccd1 sky130_fd_sc_hd__fill_2
X_1730_ MATMULT_INST.matmult_inst.mem_inst.mem0\[8\] net109 _0650_ _0545_ vssd1 vssd1
+ vccd1 vccd1 _0651_ sky130_fd_sc_hd__a211o_1
XFILLER_11_281 vssd1 vssd1 vccd1 vccd1 sky130_fd_sc_hd__fill_4
X_1661_ net151 net141 MATMULT_INST.matmult_inst.mem_inst.mem3\[14\] vssd1 vssd1 vccd1
+ vccd1 _0588_ sky130_fd_sc_hd__and3_1
Xhold208 MATMULT_INST.matmult_inst.mem_inst.mem1\[12\] vssd1 vssd1 vccd1 vccd1 net503
+ sky130_fd_sc_hd__dlygate4sd3_1
XFILLER_7_252 vssd1 vssd1 vccd1 vccd1 sky130_fd_sc_hd__fill_2
Xhold219 MATMULT_INST.matmult_inst.mem_inst.mem1\[11\] vssd1 vssd1 vccd1 vccd1 net514
+ sky130_fd_sc_hd__dlygate4sd3_1
X_3400_ clknet_leaf_3_clk _0322_ vssd1 vssd1 vccd1 vccd1 MATMULT_INST.matmult_inst.fsm_inst.count\[1\]
+ sky130_fd_sc_hd__dfxtp_1
X_3331_ clknet_leaf_1_clk _0253_ vssd1 vssd1 vccd1 vccd1 MATMULT_INST.matmult_inst.mem_inst.mem3\[4\]
+ sky130_fd_sc_hd__dfxtp_1
X_3262_ clknet_leaf_8_clk _0184_ vssd1 vssd1 vccd1 vccd1 MATMULT_INST.matmult_inst.mem_inst.matrixA3\[7\]
+ sky130_fd_sc_hd__dfxtp_1
XFILLER_66_421 vccd1 vssd1 vccd1 vssd1 sky130_ef_sc_hd__decap_40_12
X_2213_ MATMULT_INST.matmult_inst.alu_inst.adder_inst.r0.fa1.b MATMULT_INST.matmult_inst.alu_inst.adder_inst.r0.fa1.a
+ vssd1 vssd1 vccd1 vccd1 _0848_ sky130_fd_sc_hd__and2_1
X_3193_ net60 net90 net77 vssd1 vssd1 vccd1 vccd1 _0118_ sky130_fd_sc_hd__and3_1
X_2144_ net447 net36 net12 vssd1 vssd1 vccd1 vccd1 _0298_ sky130_fd_sc_hd__mux2_1
XFILLER_38_145 vssd1 vssd1 vccd1 vccd1 sky130_fd_sc_hd__fill_1
X_2075_ net382 net48 net18 vssd1 vssd1 vccd1 vccd1 _0232_ sky130_fd_sc_hd__mux2_1
XANTENNA__1642__A2 _0557_ vssd1 vssd1 vccd1 vccd1 sky130_fd_sc_hd__diode_2
X_2977_ _1514_ _1515_ vssd1 vssd1 vccd1 vccd1 _1516_ sky130_fd_sc_hd__nand2b_1
X_1928_ MATMULT_INST.matmult_inst.spi_inst.tx_reg_sys\[7\] MATMULT_INST.matmult_inst.spi_inst.miso_shifter\[6\]
+ net136 vssd1 vssd1 vccd1 vccd1 _0020_ sky130_fd_sc_hd__mux2_1
X_1859_ MATMULT_INST.matmult_inst.cs _0741_ vssd1 vssd1 vccd1 vccd1 _0446_ sky130_fd_sc_hd__nor2_1
XFILLER_30_27 vssd1 vssd1 vccd1 vccd1 sky130_fd_sc_hd__fill_1
XANTENNA_fanout107_X net107 vssd1 vssd1 vccd1 vccd1 sky130_fd_sc_hd__diode_2
X_3529_ _0027_ _0444_ _0026_ vssd1 vssd1 vccd1 vccd1 MATMULT_INST.matmult_inst.spi_inst.rx_bit_count\[1\]
+ sky130_fd_sc_hd__dfrtp_1
XPHY_EDGE_ROW_24_Left_104 vssd1 vssd1 vccd1 vccd1 sky130_fd_sc_hd__decap_3
XFILLER_29_156 vssd1 vssd1 vccd1 vccd1 sky130_fd_sc_hd__fill_4
XFILLER_29_167 vssd1 vssd1 vccd1 vccd1 sky130_fd_sc_hd__fill_1
XFILLER_57_465 vssd1 vssd1 vccd1 vccd1 sky130_fd_sc_hd__fill_1
XFILLER_25_373 vccd1 vssd1 vccd1 vssd1 sky130_ef_sc_hd__decap_40_12
XPHY_EDGE_ROW_33_Left_113 vssd1 vssd1 vccd1 vccd1 sky130_fd_sc_hd__decap_3
XTAP_TAPCELL_ROW_10_257 vssd1 vccd1 sky130_fd_sc_hd__tapvpwrvgnd_1
XANTENNA__2346__B1 MATMULT_INST.matmult_inst.alu_inst.adder_inst.r0.fa2.a vssd1 vssd1
+ vccd1 vccd1 sky130_fd_sc_hd__diode_2
XPHY_EDGE_ROW_42_Left_122 vssd1 vssd1 vccd1 vccd1 sky130_fd_sc_hd__decap_3
XFILLER_0_461 vssd1 vssd1 vccd1 vccd1 sky130_fd_sc_hd__fill_8
XFILLER_75_262 vssd1 vssd1 vccd1 vccd1 sky130_fd_sc_hd__fill_2
XFILLER_75_240 vssd1 vssd1 vccd1 vccd1 sky130_fd_sc_hd__fill_8
Xhold91 MATMULT_INST.matmult_inst.mem_inst.matrixA0\[12\] vssd1 vssd1 vccd1 vccd1
+ net386 sky130_fd_sc_hd__dlygate4sd3_1
XFILLER_63_413 vccd1 vssd1 vccd1 vssd1 sky130_ef_sc_hd__decap_40_12
Xhold80 MATMULT_INST.matmult_inst.fsm_inst.alu_result\[5\] vssd1 vssd1 vccd1 vccd1
+ net375 sky130_fd_sc_hd__dlygate4sd3_1
XFILLER_63_446 vssd1 vssd1 vccd1 vccd1 sky130_fd_sc_hd__fill_2
XTAP_TAPCELL_ROW_18_324 vssd1 vccd1 sky130_fd_sc_hd__tapvpwrvgnd_1
XFILLER_16_351 vssd1 vssd1 vccd1 vccd1 sky130_fd_sc_hd__fill_2
XFILLER_35_159 vssd1 vssd1 vccd1 vccd1 sky130_fd_sc_hd__fill_1
XANTENNA__1779__B net140 vssd1 vssd1 vccd1 vccd1 sky130_fd_sc_hd__diode_2
X_2900_ _1372_ _1412_ _1410_ vssd1 vssd1 vccd1 vccd1 _1441_ sky130_fd_sc_hd__a21oi_2
XFILLER_16_395 vssd1 vssd1 vccd1 vccd1 sky130_fd_sc_hd__fill_1
XTAP_TAPCELL_ROW_26_390 vssd1 vccd1 sky130_fd_sc_hd__tapvpwrvgnd_1
XFILLER_31_332 vssd1 vssd1 vccd1 vccd1 sky130_fd_sc_hd__fill_4
XPHY_EDGE_ROW_51_Left_131 vssd1 vssd1 vccd1 vccd1 sky130_fd_sc_hd__decap_3
X_2831_ _1324_ _1355_ _1356_ _1351_ vssd1 vssd1 vccd1 vccd1 _1374_ sky130_fd_sc_hd__a31o_1
X_2762_ _1283_ _1288_ vssd1 vssd1 vccd1 vccd1 _1308_ sky130_fd_sc_hd__nor2_1
X_1713_ net152 net143 MATMULT_INST.matmult_inst.mem_inst.mem3\[9\] vssd1 vssd1 vccd1
+ vccd1 _0635_ sky130_fd_sc_hd__and3_1
X_2693_ net93 _1251_ _1255_ net360 vssd1 vssd1 vccd1 vccd1 _0413_ sky130_fd_sc_hd__a22o_1
X_1644_ net216 _0566_ _0568_ net220 _0572_ vssd1 vssd1 vccd1 vccd1 _0573_ sky130_fd_sc_hd__a221o_1
XPHY_EDGE_ROW_60_Left_140 vssd1 vssd1 vccd1 vccd1 sky130_fd_sc_hd__decap_3
X_3314_ clknet_leaf_6_clk _0236_ vssd1 vssd1 vccd1 vccd1 MATMULT_INST.matmult_inst.mem_inst.matrixA0\[5\]
+ sky130_fd_sc_hd__dfxtp_1
X_3245_ clknet_leaf_18_clk _0167_ vssd1 vssd1 vccd1 vccd1 MATMULT_INST.matmult_inst.mem_inst.matrixB0\[8\]
+ sky130_fd_sc_hd__dfxtp_1
XTAP_TAPCELL_ROW_69_758 vssd1 vccd1 sky130_fd_sc_hd__tapvpwrvgnd_1
XFILLER_39_421 vssd1 vssd1 vccd1 vccd1 sky130_fd_sc_hd__fill_8
X_3176_ net53 net87 net72 vssd1 vssd1 vccd1 vccd1 _0101_ sky130_fd_sc_hd__and3_1
X_2127_ net565 net34 net14 vssd1 vssd1 vccd1 vccd1 _0282_ sky130_fd_sc_hd__mux2_1
XFILLER_66_284 vssd1 vssd1 vccd1 vccd1 sky130_fd_sc_hd__fill_4
X_2058_ net538 net46 net21 vssd1 vssd1 vccd1 vccd1 _0216_ sky130_fd_sc_hd__mux2_1
XTAP_TAPCELL_ROW_52_614 vssd1 vccd1 sky130_fd_sc_hd__tapvpwrvgnd_1
XFILLER_22_343 vssd1 vssd1 vccd1 vccd1 sky130_fd_sc_hd__fill_1
XFILLER_34_192 vssd1 vssd1 vccd1 vccd1 sky130_fd_sc_hd__fill_4
XANTENNA__3594__CLK net228 vssd1 vssd1 vccd1 vccd1 sky130_fd_sc_hd__diode_2
XFILLER_22_354 vssd1 vssd1 vccd1 vccd1 sky130_fd_sc_hd__fill_1
XTAP_TAPCELL_ROW_60_680 vssd1 vccd1 sky130_fd_sc_hd__tapvpwrvgnd_1
XFILLER_9_6 vssd1 vssd1 vccd1 vccd1 sky130_fd_sc_hd__fill_4
XFILLER_1_214 vssd1 vssd1 vccd1 vccd1 sky130_fd_sc_hd__fill_1
XFILLER_1_269 vssd1 vssd1 vccd1 vccd1 sky130_fd_sc_hd__fill_2
XFILLER_57_251 vssd1 vssd1 vccd1 vccd1 sky130_fd_sc_hd__fill_1
XFILLER_57_262 vssd1 vssd1 vccd1 vccd1 sky130_fd_sc_hd__fill_2
XANTENNA__3160__A net58 vssd1 vssd1 vccd1 vccd1 sky130_fd_sc_hd__diode_2
XANTENNA__3056__A1 net38 vssd1 vssd1 vccd1 vccd1 sky130_fd_sc_hd__diode_2
XFILLER_17_148 vssd1 vssd1 vccd1 vccd1 sky130_fd_sc_hd__fill_4
XFILLER_13_365 vssd1 vssd1 vccd1 vccd1 sky130_fd_sc_hd__fill_8
XFILLER_9_347 vssd1 vssd1 vccd1 vccd1 sky130_fd_sc_hd__fill_2
XTAP_TAPCELL_ROW_23_371 vssd1 vccd1 sky130_fd_sc_hd__tapvpwrvgnd_1
XFILLER_40_195 vssd1 vssd1 vccd1 vccd1 sky130_fd_sc_hd__fill_1
XANTENNA__2319__A0 net176 vssd1 vssd1 vccd1 vccd1 sky130_fd_sc_hd__diode_2
XFILLER_31_81 vssd1 vssd1 vccd1 vccd1 sky130_fd_sc_hd__fill_1
X_3030_ _1565_ _1566_ vssd1 vssd1 vccd1 vccd1 _1567_ sky130_fd_sc_hd__nand2b_1
XFILLER_48_251 vssd1 vssd1 vccd1 vccd1 sky130_fd_sc_hd__fill_1
XFILLER_63_243 vssd1 vssd1 vccd1 vccd1 sky130_fd_sc_hd__fill_2
XANTENNA__3047__A1 _0799_ vssd1 vssd1 vccd1 vccd1 sky130_fd_sc_hd__diode_2
XFILLER_63_287 vssd1 vssd1 vccd1 vccd1 sky130_fd_sc_hd__fill_1
XANTENNA_clkbuf_leaf_9_clk_A clknet_2_1__leaf_clk vssd1 vssd1 vccd1 vccd1 sky130_fd_sc_hd__diode_2
X_2814_ _1355_ _1356_ _1324_ vssd1 vssd1 vccd1 vccd1 _1358_ sky130_fd_sc_hd__a21o_1
X_2745_ _1276_ _1279_ _1290_ net97 vssd1 vssd1 vccd1 vccd1 _1292_ sky130_fd_sc_hd__o31ai_1
X_2676_ _0661_ net101 vssd1 vssd1 vccd1 vccd1 _1253_ sky130_fd_sc_hd__and2_2
X_1627_ net146 net138 vssd1 vssd1 vccd1 vccd1 _0557_ sky130_fd_sc_hd__or2_2
X_3228_ clknet_leaf_17_clk _0150_ vssd1 vssd1 vccd1 vccd1 MATMULT_INST.matmult_inst.mem_inst.matrixB1\[9\]
+ sky130_fd_sc_hd__dfxtp_1
XTAP_TAPCELL_ROW_29_419 vssd1 vccd1 sky130_fd_sc_hd__tapvpwrvgnd_1
X_3159_ net53 net87 net73 vssd1 vssd1 vccd1 vccd1 _0084_ sky130_fd_sc_hd__and3_1
XFILLER_27_468 vccd1 vssd1 vccd1 vssd1 sky130_ef_sc_hd__decap_40_12
XFILLER_54_243 vssd1 vssd1 vccd1 vccd1 sky130_fd_sc_hd__fill_1
Xclkbuf_leaf_34_clk clknet_2_0__leaf_clk vssd1 vssd1 vccd1 vccd1 clknet_leaf_34_clk
+ sky130_fd_sc_hd__clkbuf_8
XTAP_TAPCELL_ROW_37_485 vssd1 vccd1 sky130_fd_sc_hd__tapvpwrvgnd_1
XFILLER_22_151 vccd1 vssd1 vccd1 vssd1 sky130_ef_sc_hd__decap_40_12
XTAP_TAPCELL_ROW_20_341 vssd1 vccd1 sky130_fd_sc_hd__tapvpwrvgnd_1
XANTENNA__2013__A2 net34 vssd1 vssd1 vccd1 vccd1 sky130_fd_sc_hd__diode_2
XANTENNA_fanout87_X net87 vssd1 vssd1 vccd1 vccd1 sky130_fd_sc_hd__diode_2
XTAP_TAPCELL_ROW_63_709 vssd1 vccd1 sky130_fd_sc_hd__tapvpwrvgnd_1
XFILLER_45_243 vssd1 vssd1 vccd1 vccd1 sky130_fd_sc_hd__fill_1
XANTENNA__2218__B MATMULT_INST.matmult_inst.alu_inst.adder_inst.r0.fa2.a vssd1 vssd1
+ vccd1 vccd1 sky130_fd_sc_hd__diode_2
XFILLER_45_265 vssd1 vssd1 vccd1 vccd1 sky130_fd_sc_hd__fill_4
XFILLER_45_298 vccd1 vssd1 vccd1 vssd1 sky130_ef_sc_hd__decap_40_12
Xclkbuf_leaf_25_clk clknet_2_3__leaf_clk vssd1 vssd1 vccd1 vccd1 clknet_leaf_25_clk
+ sky130_fd_sc_hd__clkbuf_8
XTAP_TAPCELL_ROW_71_775 vssd1 vccd1 sky130_fd_sc_hd__tapvpwrvgnd_1
XFILLER_9_111 vssd1 vssd1 vccd1 vccd1 sky130_fd_sc_hd__fill_1
XFILLER_9_188 vssd1 vssd1 vccd1 vccd1 sky130_fd_sc_hd__fill_2
X_2530_ _1115_ _1121_ vssd1 vssd1 vccd1 vccd1 _1122_ sky130_fd_sc_hd__xor2_1
X_2461_ net214 net185 vssd1 vssd1 vccd1 vccd1 _1055_ sky130_fd_sc_hd__nand2_1
X_2392_ net212 MATMULT_INST.matmult_inst.alu_inst.a0_reg\[4\] net189 net214 vssd1
+ vssd1 vccd1 vccd1 _0988_ sky130_fd_sc_hd__a22o_1
XTAP_TAPCELL_ROW_79_842 vssd1 vccd1 sky130_fd_sc_hd__tapvpwrvgnd_1
XTAP_TAPCELL_ROW_79_853 vssd1 vccd1 sky130_fd_sc_hd__tapvpwrvgnd_1
XFILLER_3_85 vssd1 vssd1 vccd1 vccd1 sky130_fd_sc_hd__fill_8
X_3013_ _1525_ _1548_ _1549_ vssd1 vssd1 vccd1 vccd1 _1551_ sky130_fd_sc_hd__and3_1
XFILLER_36_265 vssd1 vssd1 vccd1 vccd1 sky130_fd_sc_hd__fill_2
XFILLER_36_276 vssd1 vssd1 vccd1 vccd1 sky130_fd_sc_hd__fill_1
Xclkbuf_leaf_16_clk clknet_2_1__leaf_clk vssd1 vssd1 vccd1 vccd1 clknet_leaf_16_clk
+ sky130_fd_sc_hd__clkbuf_8
XFILLER_51_279 vssd1 vssd1 vccd1 vccd1 sky130_fd_sc_hd__fill_1
XFILLER_32_493 vssd1 vssd1 vccd1 vccd1 sky130_fd_sc_hd__fill_1
X_2728_ _1274_ _1275_ net168 net180 vssd1 vssd1 vccd1 vccd1 _1276_ sky130_fd_sc_hd__and4bb_1
X_2659_ _0730_ net101 vssd1 vssd1 vccd1 vccd1 _1243_ sky130_fd_sc_hd__and2_1
XANTENNA__2703__A0 _1252_ vssd1 vssd1 vccd1 vccd1 sky130_fd_sc_hd__diode_2
Xfanout101 _0766_ vssd1 vssd1 vccd1 vccd1 net101 sky130_fd_sc_hd__clkbuf_2
Xfanout112 _0559_ vssd1 vssd1 vccd1 vccd1 net112 sky130_fd_sc_hd__clkbuf_4
Xfanout156 MATMULT_INST.matmult_inst.alu_inst.a1_reg\[6\] vssd1 vssd1 vccd1 vccd1
+ net156 sky130_fd_sc_hd__buf_2
Xfanout134 MATMULT_INST.matmult_inst.fsm_inst.state\[3\] vssd1 vssd1 vccd1 vccd1 net134
+ sky130_fd_sc_hd__buf_2
Xfanout145 MATMULT_INST.matmult_inst.addr\[1\] vssd1 vssd1 vccd1 vccd1 net145 sky130_fd_sc_hd__buf_2
Xfanout123 _0547_ vssd1 vssd1 vccd1 vccd1 net123 sky130_fd_sc_hd__clkbuf_4
Xfanout189 MATMULT_INST.matmult_inst.alu_inst.a0_reg\[5\] vssd1 vssd1 vccd1 vccd1
+ net189 sky130_fd_sc_hd__clkbuf_2
Xfanout167 MATMULT_INST.matmult_inst.alu_inst.a1_reg\[1\] vssd1 vssd1 vccd1 vccd1
+ net167 sky130_fd_sc_hd__clkbuf_2
Xfanout178 MATMULT_INST.matmult_inst.alu_inst.b1_reg\[3\] vssd1 vssd1 vccd1 vccd1
+ net178 sky130_fd_sc_hd__buf_2
XFILLER_63_24 vssd1 vssd1 vccd1 vccd1 sky130_fd_sc_hd__fill_1
XANTENNA_fanout47_A _0799_ vssd1 vssd1 vccd1 vccd1 sky130_fd_sc_hd__diode_2
XFILLER_63_57 vssd1 vssd1 vccd1 vccd1 sky130_fd_sc_hd__fill_1
XFILLER_15_449 vccd1 vssd1 vccd1 vssd1 sky130_ef_sc_hd__decap_40_12
XFILLER_27_298 vssd1 vssd1 vccd1 vccd1 sky130_fd_sc_hd__fill_1
XFILLER_10_110 vssd1 vssd1 vccd1 vccd1 sky130_fd_sc_hd__fill_4
XFILLER_23_471 vssd1 vssd1 vccd1 vccd1 sky130_fd_sc_hd__fill_2
XANTENNA__1993__A1 net35 vssd1 vssd1 vccd1 vccd1 sky130_fd_sc_hd__diode_2
XANTENNA__2054__A net131 vssd1 vssd1 vccd1 vccd1 sky130_fd_sc_hd__diode_2
XFILLER_6_114 vccd1 vssd1 vccd1 vssd1 sky130_ef_sc_hd__decap_40_12
XFILLER_65_349 vccd1 vssd1 vccd1 vssd1 sky130_ef_sc_hd__decap_40_12
XFILLER_73_371 vccd1 vssd1 vccd1 vssd1 sky130_ef_sc_hd__decap_40_12
XFILLER_33_202 vssd1 vssd1 vccd1 vccd1 sky130_fd_sc_hd__fill_8
XANTENNA__1787__B net145 vssd1 vssd1 vccd1 vccd1 sky130_fd_sc_hd__diode_2
X_1961_ net371 net40 net30 vssd1 vssd1 vccd1 vccd1 _0132_ sky130_fd_sc_hd__mux2_1
XTAP_TAPCELL_ROW_31_436 vssd1 vccd1 sky130_fd_sc_hd__tapvpwrvgnd_1
X_1892_ _0760_ _0765_ _0769_ vssd1 vssd1 vccd1 vccd1 _0770_ sky130_fd_sc_hd__and3b_1
X_3631_ clknet_leaf_28_clk net568 vssd1 vssd1 vccd1 vccd1 MATMULT_INST.matmult_inst.fsm_inst.alu_result\[7\]
+ sky130_fd_sc_hd__dfxtp_1
X_3562_ clknet_leaf_15_clk _0474_ vssd1 vssd1 vccd1 vccd1 MATMULT_INST.matmult_inst.mem_inst.matrixB3\[10\]
+ sky130_fd_sc_hd__dfxtp_1
X_2513_ _1084_ _1085_ _1083_ vssd1 vssd1 vccd1 vccd1 _1105_ sky130_fd_sc_hd__a21bo_1
X_3493_ clknet_leaf_33_clk _0412_ vssd1 vssd1 vccd1 vccd1 MATMULT_INST.matmult_inst.alu_inst.row1\[4\]
+ sky130_fd_sc_hd__dfxtp_1
X_2444_ _1035_ _1036_ _1003_ vssd1 vssd1 vccd1 vccd1 _1038_ sky130_fd_sc_hd__a21oi_1
Xclkbuf_leaf_5_clk clknet_2_1__leaf_clk vssd1 vssd1 vccd1 vccd1 clknet_leaf_5_clk
+ sky130_fd_sc_hd__clkbuf_8
X_2375_ _0947_ _0952_ vssd1 vssd1 vccd1 vccd1 _0972_ sky130_fd_sc_hd__nor2_1
XANTENNA__1742__S net63 vssd1 vssd1 vccd1 vccd1 sky130_fd_sc_hd__diode_2
XFILLER_68_165 vssd1 vssd1 vccd1 vccd1 sky130_fd_sc_hd__fill_1
XTAP_TAPCELL_ROW_39_503 vssd1 vccd1 sky130_fd_sc_hd__tapvpwrvgnd_1
XFILLER_24_213 vssd1 vssd1 vccd1 vccd1 sky130_fd_sc_hd__fill_8
XANTENNA__1978__A net219 vssd1 vssd1 vccd1 vccd1 sky130_fd_sc_hd__diode_2
XANTENNA_fanout137_X net137 vssd1 vssd1 vccd1 vccd1 sky130_fd_sc_hd__diode_2
XFILLER_20_441 vccd1 vssd1 vccd1 vssd1 sky130_ef_sc_hd__decap_40_12
XANTENNA__1727__B2 net218 vssd1 vssd1 vccd1 vccd1 sky130_fd_sc_hd__diode_2
XANTENNA__1727__A1 net220 vssd1 vssd1 vccd1 vccd1 sky130_fd_sc_hd__diode_2
XFILLER_79_419 vssd1 vssd1 vccd1 vccd1 sky130_fd_sc_hd__fill_1
XFILLER_70_363 vssd1 vssd1 vccd1 vccd1 sky130_fd_sc_hd__fill_1
XANTENNA_clkbuf_leaf_34_clk_A clknet_2_0__leaf_clk vssd1 vssd1 vccd1 vccd1 sky130_fd_sc_hd__diode_2
XFILLER_7_434 vssd1 vssd1 vccd1 vccd1 sky130_fd_sc_hd__fill_2
XANTENNA__1718__B2 net223 vssd1 vssd1 vccd1 vccd1 sky130_fd_sc_hd__diode_2
XANTENNA__2694__A2 _1252_ vssd1 vssd1 vccd1 vccd1 sky130_fd_sc_hd__diode_2
X_2160_ net109 _0807_ net11 net516 vssd1 vssd1 vccd1 vccd1 _0313_ sky130_fd_sc_hd__a22o_1
X_2091_ net417 _0814_ net19 vssd1 vssd1 vccd1 vccd1 _0248_ sky130_fd_sc_hd__mux2_1
XFILLER_0_42 vssd1 vssd1 vccd1 vccd1 sky130_fd_sc_hd__fill_2
XFILLER_0_97 vccd1 vssd1 vccd1 vssd1 sky130_ef_sc_hd__decap_40_12
XTAP_TAPCELL_ROW_44_550 vssd1 vccd1 sky130_fd_sc_hd__tapvpwrvgnd_1
X_2993_ _1529_ _1531_ vssd1 vssd1 vccd1 vccd1 _1532_ sky130_fd_sc_hd__nand2_1
X_1944_ MATMULT_INST.matmult_inst.fsm_inst.rx_data\[1\] net71 net70 MATMULT_INST.matmult_inst.fsm_inst.alu_result\[1\]
+ vssd1 vssd1 vccd1 vccd1 _0798_ sky130_fd_sc_hd__a22o_2
X_3614_ clknet_leaf_20_clk _0507_ _0112_ vssd1 vssd1 vccd1 vccd1 MATMULT_INST.matmult_inst.spi_inst.tx_reg_sys\[17\]
+ sky130_fd_sc_hd__dfrtp_1
X_1875_ MATMULT_INST.matmult_inst.alu_inst.complete _0752_ vssd1 vssd1 vccd1 vccd1
+ _0753_ sky130_fd_sc_hd__nand2b_1
XANTENNA__1709__B2 net220 vssd1 vssd1 vccd1 vccd1 sky130_fd_sc_hd__diode_2
XANTENNA__1709__A1 net217 vssd1 vssd1 vccd1 vccd1 sky130_fd_sc_hd__diode_2
X_3545_ _0056_ _0458_ _0055_ vssd1 vssd1 vccd1 vccd1 MATMULT_INST.matmult_inst.spi_inst.mosi_shifter\[1\]
+ sky130_fd_sc_hd__dfrtp_1
XFILLER_0_109 vssd1 vssd1 vccd1 vccd1 sky130_fd_sc_hd__fill_2
X_3476_ clknet_leaf_33_clk _0396_ vssd1 vssd1 vccd1 vccd1 MATMULT_INST.matmult_inst.alu_inst.col1\[4\]
+ sky130_fd_sc_hd__dfxtp_1
X_2427_ _0981_ _1020_ _1021_ vssd1 vssd1 vccd1 vccd1 _1022_ sky130_fd_sc_hd__nand3_1
XFILLER_69_441 vssd1 vssd1 vccd1 vccd1 sky130_fd_sc_hd__fill_4
Xteam_02_239 vssd1 vssd1 vccd1 vccd1 team_02_239/HI gpio_oeb[12] sky130_fd_sc_hd__conb_1
XFILLER_69_485 vssd1 vssd1 vccd1 vccd1 sky130_fd_sc_hd__fill_8
XANTENNA__2685__A2 _1252_ vssd1 vssd1 vccd1 vccd1 sky130_fd_sc_hd__diode_2
XFILLER_28_27 vssd1 vssd1 vccd1 vccd1 sky130_fd_sc_hd__fill_1
X_2358_ _0940_ _0943_ _0954_ net96 vssd1 vssd1 vccd1 vccd1 _0956_ sky130_fd_sc_hd__o31ai_1
X_2289_ MATMULT_INST.matmult_inst.alu_inst.adder_inst.r3.fa1.b MATMULT_INST.matmult_inst.alu_inst.adder_inst.r3.fa1.a
+ vssd1 vssd1 vccd1 vccd1 _0912_ sky130_fd_sc_hd__nor2_1
XFILLER_56_179 vssd1 vssd1 vccd1 vccd1 sky130_fd_sc_hd__fill_1
XFILLER_44_37 vssd1 vssd1 vccd1 vccd1 sky130_fd_sc_hd__fill_4
XTAP_TAPCELL_ROW_50_597 vssd1 vccd1 sky130_fd_sc_hd__tapvpwrvgnd_1
XANTENNA__2332__A net114 vssd1 vssd1 vccd1 vccd1 sky130_fd_sc_hd__diode_2
XFILLER_79_205 vssd1 vssd1 vccd1 vccd1 sky130_fd_sc_hd__fill_1
XFILLER_69_45 vssd1 vssd1 vccd1 vccd1 sky130_fd_sc_hd__fill_8
XFILLER_79_249 vssd1 vssd1 vccd1 vccd1 sky130_fd_sc_hd__fill_2
XTAP_TAPCELL_ROW_7_231 vssd1 vccd1 sky130_fd_sc_hd__tapvpwrvgnd_1
XTAP_TAPCELL_ROW_58_664 vssd1 vccd1 sky130_fd_sc_hd__tapvpwrvgnd_1
XFILLER_43_352 vssd1 vssd1 vccd1 vccd1 sky130_fd_sc_hd__fill_2
XTAP_TAPCELL_ROW_41_520 vssd1 vccd1 sky130_fd_sc_hd__tapvpwrvgnd_1
XFILLER_7_220 vssd1 vssd1 vccd1 vccd1 sky130_fd_sc_hd__fill_1
X_1660_ MATMULT_INST.matmult_inst.mem_inst.matrixB1\[14\] net126 net118 MATMULT_INST.matmult_inst.mem_inst.matrixB2\[14\]
+ _0586_ vssd1 vssd1 vccd1 vccd1 _0587_ sky130_fd_sc_hd__a221o_1
Xhold209 MATMULT_INST.matmult_inst.mem_inst.matrixB2\[5\] vssd1 vssd1 vccd1 vccd1
+ net504 sky130_fd_sc_hd__dlygate4sd3_1
X_3330_ clknet_leaf_3_clk _0252_ vssd1 vssd1 vccd1 vccd1 MATMULT_INST.matmult_inst.mem_inst.mem3\[3\]
+ sky130_fd_sc_hd__dfxtp_1
X_3261_ clknet_leaf_7_clk _0183_ vssd1 vssd1 vccd1 vccd1 MATMULT_INST.matmult_inst.mem_inst.matrixA3\[6\]
+ sky130_fd_sc_hd__dfxtp_1
XFILLER_22_3 vccd1 vssd1 vccd1 vssd1 sky130_ef_sc_hd__decap_40_12
X_2212_ MATMULT_INST.matmult_inst.alu_inst.adder_inst.r0.fa1.b MATMULT_INST.matmult_inst.alu_inst.adder_inst.r0.fa1.a
+ vssd1 vssd1 vccd1 vccd1 _0847_ sky130_fd_sc_hd__nor2_1
X_3192_ net57 net85 net76 vssd1 vssd1 vccd1 vccd1 _0117_ sky130_fd_sc_hd__and3_1
X_2143_ net503 net37 net13 vssd1 vssd1 vccd1 vccd1 _0297_ sky130_fd_sc_hd__mux2_1
XFILLER_66_433 vssd1 vssd1 vccd1 vccd1 sky130_fd_sc_hd__fill_4
XFILLER_26_319 vssd1 vssd1 vccd1 vccd1 sky130_fd_sc_hd__fill_1
X_2074_ net424 net49 net18 vssd1 vssd1 vccd1 vccd1 _0231_ sky130_fd_sc_hd__mux2_1
XFILLER_34_341 vccd1 vssd1 vccd1 vssd1 sky130_ef_sc_hd__decap_40_12
XFILLER_34_363 vssd1 vssd1 vccd1 vccd1 sky130_fd_sc_hd__fill_1
XFILLER_14_29 vccd1 vssd1 vccd1 vssd1 sky130_ef_sc_hd__decap_40_12
X_2976_ net156 net174 net176 net155 vssd1 vssd1 vccd1 vccd1 _1515_ sky130_fd_sc_hd__a22o_1
X_1927_ MATMULT_INST.matmult_inst.spi_inst.tx_reg_sys\[6\] MATMULT_INST.matmult_inst.spi_inst.miso_shifter\[5\]
+ net136 vssd1 vssd1 vccd1 vccd1 _0019_ sky130_fd_sc_hd__mux2_1
X_1858_ _0535_ MATMULT_INST.matmult_inst.spi_inst.mosi_data_spi\[0\] _0744_ vssd1
+ vssd1 vccd1 vccd1 _0447_ sky130_fd_sc_hd__mux2_1
X_1789_ MATMULT_INST.matmult_inst.mem_inst.matrixB1\[2\] net128 net120 MATMULT_INST.matmult_inst.mem_inst.matrixB2\[2\]
+ vssd1 vssd1 vccd1 vccd1 _0704_ sky130_fd_sc_hd__a22o_1
X_3528_ _0025_ _0443_ _0024_ vssd1 vssd1 vccd1 vccd1 MATMULT_INST.matmult_inst.spi_inst.rx_bit_count\[0\]
+ sky130_fd_sc_hd__dfrtp_1
XFILLER_39_15 vccd1 vssd1 vccd1 vssd1 sky130_ef_sc_hd__decap_40_12
XANTENNA__2107__A1 net35 vssd1 vssd1 vccd1 vccd1 sky130_fd_sc_hd__diode_2
X_3459_ clknet_leaf_34_clk _0380_ vssd1 vssd1 vccd1 vccd1 MATMULT_INST.matmult_inst.alu_inst.adder_inst.r1.fa1.a
+ sky130_fd_sc_hd__dfxtp_1
XFILLER_76_208 vssd1 vssd1 vccd1 vccd1 sky130_fd_sc_hd__fill_4
XFILLER_29_179 vssd1 vssd1 vccd1 vccd1 sky130_fd_sc_hd__fill_1
XFILLER_25_385 vssd1 vssd1 vccd1 vccd1 sky130_fd_sc_hd__fill_4
XFILLER_40_333 vssd1 vssd1 vccd1 vccd1 sky130_fd_sc_hd__fill_2
XFILLER_40_377 vssd1 vssd1 vccd1 vccd1 sky130_fd_sc_hd__fill_1
XTAP_TAPCELL_ROW_10_258 vssd1 vccd1 sky130_fd_sc_hd__tapvpwrvgnd_1
XANTENNA__2346__B2 net114 vssd1 vssd1 vccd1 vccd1 sky130_fd_sc_hd__diode_2
XFILLER_20_83 vssd1 vssd1 vccd1 vccd1 sky130_fd_sc_hd__fill_1
XANTENNA__2001__S net26 vssd1 vssd1 vccd1 vccd1 sky130_fd_sc_hd__diode_2
XANTENNA__2936__S net97 vssd1 vssd1 vccd1 vccd1 sky130_fd_sc_hd__diode_2
Xhold92 MATMULT_INST.matmult_inst.mem_inst.matrixB0\[17\] vssd1 vssd1 vccd1 vccd1
+ net387 sky130_fd_sc_hd__dlygate4sd3_1
Xhold70 MATMULT_INST.matmult_inst.mem_inst.mem0\[13\] vssd1 vssd1 vccd1 vccd1 net365
+ sky130_fd_sc_hd__dlygate4sd3_1
XFILLER_29_92 vssd1 vssd1 vccd1 vccd1 sky130_fd_sc_hd__fill_4
Xhold81 _0513_ vssd1 vssd1 vccd1 vccd1 net376 sky130_fd_sc_hd__dlygate4sd3_1
XFILLER_63_436 vssd1 vssd1 vccd1 vccd1 sky130_fd_sc_hd__fill_4
XFILLER_63_425 vssd1 vssd1 vccd1 vccd1 sky130_fd_sc_hd__fill_8
XTAP_TAPCELL_ROW_18_325 vssd1 vccd1 sky130_fd_sc_hd__tapvpwrvgnd_1
X_2830_ _1370_ _1371_ _1350_ vssd1 vssd1 vccd1 vccd1 _1373_ sky130_fd_sc_hd__a21oi_1
XTAP_TAPCELL_ROW_26_391 vssd1 vccd1 sky130_fd_sc_hd__tapvpwrvgnd_1
X_2761_ _1298_ _1299_ _1304_ vssd1 vssd1 vccd1 vccd1 _1307_ sky130_fd_sc_hd__o21bai_1
X_2692_ net93 _1250_ _1255_ net481 vssd1 vssd1 vccd1 vccd1 _0412_ sky130_fd_sc_hd__a22o_1
X_1712_ MATMULT_INST.matmult_inst.mem_inst.matrixB3\[9\] _0548_ _0633_ vssd1 vssd1
+ vccd1 vccd1 _0634_ sky130_fd_sc_hd__a21o_1
X_1643_ MATMULT_INST.matmult_inst.mem_inst.mem0\[16\] net111 net104 MATMULT_INST.matmult_inst.mem_inst.matrixB0\[16\]
+ _0571_ vssd1 vssd1 vccd1 vccd1 _0572_ sky130_fd_sc_hd__a221o_1
XFILLER_6_85 vccd1 vssd1 vccd1 vssd1 sky130_ef_sc_hd__decap_40_12
XFILLER_6_74 vssd1 vssd1 vccd1 vccd1 sky130_fd_sc_hd__fill_8
X_3313_ clknet_leaf_6_clk _0235_ vssd1 vssd1 vccd1 vccd1 MATMULT_INST.matmult_inst.mem_inst.matrixA0\[4\]
+ sky130_fd_sc_hd__dfxtp_1
X_3244_ clknet_leaf_8_clk _0166_ vssd1 vssd1 vccd1 vccd1 MATMULT_INST.matmult_inst.mem_inst.matrixB0\[7\]
+ sky130_fd_sc_hd__dfxtp_1
XTAP_TAPCELL_ROW_69_759 vssd1 vccd1 sky130_fd_sc_hd__tapvpwrvgnd_1
XFILLER_39_466 vssd1 vssd1 vccd1 vccd1 sky130_fd_sc_hd__fill_4
X_3175_ net54 net83 net73 vssd1 vssd1 vccd1 vccd1 _0100_ sky130_fd_sc_hd__and3_1
X_2126_ net442 net35 net14 vssd1 vssd1 vccd1 vccd1 _0281_ sky130_fd_sc_hd__mux2_1
XFILLER_26_127 vccd1 vssd1 vccd1 vssd1 sky130_ef_sc_hd__decap_40_12
XFILLER_39_488 vssd1 vssd1 vccd1 vccd1 sky130_fd_sc_hd__fill_4
XFILLER_25_17 vssd1 vssd1 vccd1 vccd1 sky130_fd_sc_hd__fill_1
XFILLER_26_149 vssd1 vssd1 vccd1 vccd1 sky130_fd_sc_hd__fill_1
X_2057_ net446 net47 net21 vssd1 vssd1 vccd1 vccd1 _0215_ sky130_fd_sc_hd__mux2_1
XTAP_TAPCELL_ROW_52_615 vssd1 vccd1 sky130_fd_sc_hd__tapvpwrvgnd_1
X_2959_ _1445_ _1497_ _1498_ vssd1 vssd1 vccd1 vccd1 _1499_ sky130_fd_sc_hd__nand3_1
XTAP_TAPCELL_ROW_60_681 vssd1 vccd1 sky130_fd_sc_hd__tapvpwrvgnd_1
XANTENNA_fanout217_X net217 vssd1 vssd1 vccd1 vccd1 sky130_fd_sc_hd__diode_2
XANTENNA__1925__S net137 vssd1 vssd1 vccd1 vccd1 sky130_fd_sc_hd__diode_2
XANTENNA__3160__B net87 vssd1 vssd1 vccd1 vccd1 sky130_fd_sc_hd__diode_2
XFILLER_13_300 vccd1 vssd1 vccd1 vssd1 sky130_ef_sc_hd__decap_40_12
XFILLER_13_322 vssd1 vssd1 vccd1 vccd1 sky130_fd_sc_hd__fill_1
XFILLER_25_193 vssd1 vssd1 vccd1 vccd1 sky130_fd_sc_hd__fill_2
XFILLER_53_491 vssd1 vssd1 vccd1 vccd1 sky130_fd_sc_hd__fill_2
XFILLER_13_399 vssd1 vssd1 vccd1 vccd1 sky130_fd_sc_hd__fill_1
XFILLER_0_281 vssd1 vssd1 vccd1 vccd1 sky130_fd_sc_hd__fill_8
XTAP_TAPCELL_ROW_66_729 vssd1 vccd1 sky130_fd_sc_hd__tapvpwrvgnd_1
XFILLER_56_90 vssd1 vssd1 vccd1 vccd1 sky130_fd_sc_hd__fill_1
XFILLER_23_119 vssd1 vssd1 vccd1 vccd1 sky130_fd_sc_hd__fill_1
XFILLER_16_193 vssd1 vssd1 vccd1 vccd1 sky130_fd_sc_hd__fill_2
X_2813_ _1324_ _1355_ _1356_ vssd1 vssd1 vccd1 vccd1 _1357_ sky130_fd_sc_hd__nand3_1
XANTENNA__2007__B1 net27 vssd1 vssd1 vccd1 vccd1 sky130_fd_sc_hd__diode_2
X_2744_ _1276_ _1279_ _1290_ vssd1 vssd1 vccd1 vccd1 _1291_ sky130_fd_sc_hd__o21a_1
X_2675_ net596 _1246_ _1252_ net103 vssd1 vssd1 vccd1 vccd1 _0398_ sky130_fd_sc_hd__a22o_1
X_1626_ net148 net140 vssd1 vssd1 vccd1 vccd1 _0556_ sky130_fd_sc_hd__nor2_1
X_3227_ clknet_leaf_19_clk _0149_ vssd1 vssd1 vccd1 vccd1 MATMULT_INST.matmult_inst.mem_inst.matrixB1\[8\]
+ sky130_fd_sc_hd__dfxtp_1
XFILLER_36_27 vssd1 vssd1 vccd1 vccd1 sky130_fd_sc_hd__fill_1
XFILLER_39_274 vssd1 vssd1 vccd1 vccd1 sky130_fd_sc_hd__fill_1
X_3158_ net53 net87 net73 vssd1 vssd1 vccd1 vccd1 _0083_ sky130_fd_sc_hd__and3_1
X_2109_ net320 net33 net16 vssd1 vssd1 vccd1 vccd1 _0265_ sky130_fd_sc_hd__mux2_1
X_3089_ net134 _1584_ vssd1 vssd1 vccd1 vccd1 _1585_ sky130_fd_sc_hd__and2_1
XFILLER_35_491 vssd1 vssd1 vccd1 vccd1 sky130_fd_sc_hd__fill_2
XTAP_TAPCELL_ROW_37_486 vssd1 vccd1 sky130_fd_sc_hd__tapvpwrvgnd_1
XFILLER_22_163 vssd1 vssd1 vccd1 vccd1 sky130_fd_sc_hd__fill_4
XFILLER_10_369 vssd1 vssd1 vccd1 vccd1 sky130_fd_sc_hd__fill_1
XFILLER_6_318 vccd1 vssd1 vccd1 vssd1 sky130_ef_sc_hd__decap_40_12
XTAP_TAPCELL_ROW_20_342 vssd1 vccd1 sky130_fd_sc_hd__tapvpwrvgnd_1
Xhold370 MATMULT_INST.matmult_inst.fsm_inst.sel\[0\] vssd1 vssd1 vccd1 vccd1 net665
+ sky130_fd_sc_hd__dlygate4sd3_1
XFILLER_18_414 vssd1 vssd1 vccd1 vccd1 sky130_fd_sc_hd__fill_4
XFILLER_45_288 vssd1 vssd1 vccd1 vccd1 sky130_fd_sc_hd__fill_2
XFILLER_60_236 vssd1 vssd1 vccd1 vccd1 sky130_fd_sc_hd__fill_2
XTAP_TAPCELL_ROW_71_776 vssd1 vccd1 sky130_fd_sc_hd__tapvpwrvgnd_1
XFILLER_13_174 vssd1 vssd1 vccd1 vccd1 sky130_fd_sc_hd__fill_1
XFILLER_9_167 vssd1 vssd1 vccd1 vccd1 sky130_fd_sc_hd__fill_1
X_2460_ _1052_ _1053_ vssd1 vssd1 vccd1 vccd1 _1054_ sky130_fd_sc_hd__and2b_1
XFILLER_3_31 vssd1 vssd1 vccd1 vccd1 sky130_fd_sc_hd__fill_2
X_2391_ _0960_ _0985_ _0986_ vssd1 vssd1 vccd1 vccd1 _0987_ sky130_fd_sc_hd__a21oi_1
XANTENNA__2712__A1 net148 vssd1 vssd1 vccd1 vccd1 sky130_fd_sc_hd__diode_2
XTAP_TAPCELL_ROW_79_843 vssd1 vccd1 sky130_fd_sc_hd__tapvpwrvgnd_1
XFILLER_3_64 vssd1 vssd1 vccd1 vccd1 sky130_fd_sc_hd__fill_2
XTAP_TAPCELL_ROW_79_854 vssd1 vccd1 sky130_fd_sc_hd__tapvpwrvgnd_1
XFILLER_3_97 vssd1 vssd1 vccd1 vccd1 sky130_fd_sc_hd__fill_4
X_3012_ _1525_ _1549_ _1548_ vssd1 vssd1 vccd1 vccd1 _1550_ sky130_fd_sc_hd__a21o_1
XANTENNA__2476__A0 MATMULT_INST.matmult_inst.alu_inst.adder_inst.r1.fa3.a vssd1 vssd1
+ vccd1 vccd1 sky130_fd_sc_hd__diode_2
XFILLER_24_417 vssd1 vssd1 vccd1 vccd1 sky130_fd_sc_hd__fill_2
XFILLER_51_203 vssd1 vssd1 vccd1 vccd1 sky130_fd_sc_hd__fill_4
XFILLER_17_491 vssd1 vssd1 vccd1 vccd1 sky130_fd_sc_hd__fill_2
XFILLER_22_29 vssd1 vssd1 vccd1 vccd1 sky130_fd_sc_hd__fill_1
XANTENNA_fanout127_A net131 vssd1 vssd1 vccd1 vccd1 sky130_fd_sc_hd__diode_2
X_2727_ net183 net167 net184 net164 vssd1 vssd1 vccd1 vccd1 _1275_ sky130_fd_sc_hd__and4_1
X_2658_ net664 net115 vssd1 vssd1 vccd1 vccd1 _0391_ sky130_fd_sc_hd__and2_1
X_2589_ net187 net204 net206 net185 vssd1 vssd1 vccd1 vccd1 _1179_ sky130_fd_sc_hd__a22o_1
Xfanout102 _0766_ vssd1 vssd1 vccd1 vccd1 net102 sky130_fd_sc_hd__clkbuf_2
X_1609_ MATMULT_INST.matmult_inst.fsm_inst.state\[3\] net133 vssd1 vssd1 vccd1 vccd1
+ _0540_ sky130_fd_sc_hd__nor2_1
Xfanout113 _0559_ vssd1 vssd1 vccd1 vccd1 net113 sky130_fd_sc_hd__buf_2
Xfanout135 MATMULT_INST.matmult_inst.fsm_inst.state\[4\] vssd1 vssd1 vccd1 vccd1 net135
+ sky130_fd_sc_hd__clkbuf_2
Xfanout124 net131 vssd1 vssd1 vccd1 vccd1 net124 sky130_fd_sc_hd__clkbuf_4
Xfanout146 net149 vssd1 vssd1 vccd1 vccd1 net146 sky130_fd_sc_hd__clkbuf_2
XANTENNA_input1_A gpio_in[0] vssd1 vssd1 vccd1 vccd1 sky130_fd_sc_hd__diode_2
Xfanout157 MATMULT_INST.matmult_inst.alu_inst.a1_reg\[6\] vssd1 vssd1 vccd1 vccd1
+ net157 sky130_fd_sc_hd__clkbuf_2
Xfanout179 MATMULT_INST.matmult_inst.alu_inst.b1_reg\[3\] vssd1 vssd1 vccd1 vccd1
+ net179 sky130_fd_sc_hd__clkbuf_2
Xfanout168 net169 vssd1 vssd1 vccd1 vccd1 net168 sky130_fd_sc_hd__clkbuf_2
XFILLER_47_15 vssd1 vssd1 vccd1 vccd1 sky130_fd_sc_hd__fill_2
XFILLER_15_428 vccd1 vssd1 vccd1 vssd1 sky130_ef_sc_hd__decap_40_12
XFILLER_23_461 vssd1 vssd1 vccd1 vccd1 sky130_fd_sc_hd__fill_4
XFILLER_10_122 vccd1 vssd1 vccd1 vssd1 sky130_ef_sc_hd__decap_40_12
XFILLER_6_126 vssd1 vssd1 vccd1 vccd1 sky130_fd_sc_hd__fill_2
XFILLER_2_376 vssd1 vssd1 vccd1 vccd1 sky130_fd_sc_hd__fill_1
XANTENNA_clkbuf_leaf_8_clk_A clknet_2_1__leaf_clk vssd1 vssd1 vccd1 vccd1 sky130_fd_sc_hd__diode_2
XFILLER_65_339 vssd1 vssd1 vccd1 vccd1 sky130_fd_sc_hd__fill_4
XFILLER_65_306 vssd1 vssd1 vccd1 vccd1 sky130_fd_sc_hd__fill_1
XFILLER_73_383 vssd1 vssd1 vccd1 vccd1 sky130_fd_sc_hd__fill_8
X_1960_ MATMULT_INST.matmult_inst.fsm_inst.alu_result\[9\] net69 vssd1 vssd1 vccd1
+ vccd1 _0806_ sky130_fd_sc_hd__and2_1
XTAP_TAPCELL_ROW_31_437 vssd1 vccd1 sky130_fd_sc_hd__tapvpwrvgnd_1
X_1891_ MATMULT_INST.matmult_inst.fsm_inst.state\[0\] _0736_ _0763_ _0768_ net86 vssd1
+ vssd1 vccd1 vccd1 _0769_ sky130_fd_sc_hd__o2111a_1
X_3630_ clknet_leaf_23_clk net480 vssd1 vssd1 vccd1 vccd1 MATMULT_INST.matmult_inst.fsm_inst.alu_result\[6\]
+ sky130_fd_sc_hd__dfxtp_1
X_3561_ clknet_leaf_18_clk _0473_ vssd1 vssd1 vccd1 vccd1 MATMULT_INST.matmult_inst.mem_inst.matrixB3\[9\]
+ sky130_fd_sc_hd__dfxtp_1
X_2512_ MATMULT_INST.matmult_inst.alu_inst.adder_inst.r2.fa0.a _1104_ net94 vssd1
+ vssd1 vccd1 vccd1 _0383_ sky130_fd_sc_hd__mux2_1
XFILLER_52_3 vssd1 vssd1 vccd1 vccd1 sky130_fd_sc_hd__fill_4
X_3492_ clknet_leaf_33_clk _0411_ vssd1 vssd1 vccd1 vccd1 MATMULT_INST.matmult_inst.alu_inst.row1\[3\]
+ sky130_fd_sc_hd__dfxtp_1
X_2443_ _1003_ _1035_ _1036_ vssd1 vssd1 vccd1 vccd1 _1037_ sky130_fd_sc_hd__and3_1
XFILLER_68_100 vssd1 vssd1 vccd1 vccd1 sky130_fd_sc_hd__fill_1
X_2374_ _0962_ _0963_ _0968_ vssd1 vssd1 vccd1 vccd1 _0971_ sky130_fd_sc_hd__o21bai_1
XTAP_TAPCELL_ROW_39_504 vssd1 vccd1 sky130_fd_sc_hd__tapvpwrvgnd_1
XTAP_TAPCELL_ROW_47_570 vssd1 vccd1 sky130_fd_sc_hd__tapvpwrvgnd_1
XANTENNA__1978__B net128 vssd1 vssd1 vccd1 vccd1 sky130_fd_sc_hd__diode_2
XFILLER_12_409 vssd1 vssd1 vccd1 vccd1 sky130_fd_sc_hd__fill_1
XFILLER_24_269 vssd1 vssd1 vccd1 vccd1 sky130_fd_sc_hd__fill_2
XFILLER_32_280 vssd1 vssd1 vccd1 vccd1 sky130_fd_sc_hd__fill_2
XFILLER_20_453 vssd1 vssd1 vccd1 vccd1 sky130_fd_sc_hd__fill_2
XANTENNA__1933__S net137 vssd1 vssd1 vccd1 vccd1 sky130_fd_sc_hd__diode_2
XANTENNA__1663__A1 net220 vssd1 vssd1 vccd1 vccd1 sky130_fd_sc_hd__diode_2
XFILLER_15_225 vccd1 vssd1 vccd1 vssd1 sky130_ef_sc_hd__decap_40_12
XANTENNA__1663__B2 net218 vssd1 vssd1 vccd1 vccd1 sky130_fd_sc_hd__diode_2
XFILLER_11_442 vssd1 vssd1 vccd1 vccd1 sky130_fd_sc_hd__fill_4
XFILLER_30_239 vccd1 vssd1 vccd1 vssd1 sky130_ef_sc_hd__decap_40_12
XANTENNA_fanout9_X net9 vssd1 vssd1 vccd1 vccd1 sky130_fd_sc_hd__diode_2
XFILLER_7_457 vssd1 vssd1 vccd1 vccd1 sky130_fd_sc_hd__fill_1
XANTENNA__2004__S net26 vssd1 vssd1 vccd1 vccd1 sky130_fd_sc_hd__diode_2
XANTENNA__1718__A2 net106 vssd1 vssd1 vccd1 vccd1 sky130_fd_sc_hd__diode_2
XFILLER_2_151 vssd1 vssd1 vccd1 vccd1 sky130_fd_sc_hd__fill_2
XANTENNA__2679__B1 _1254_ vssd1 vssd1 vccd1 vccd1 sky130_fd_sc_hd__diode_2
XFILLER_2_195 vssd1 vssd1 vccd1 vccd1 sky130_fd_sc_hd__fill_1
XFILLER_78_475 vssd1 vssd1 vccd1 vccd1 sky130_fd_sc_hd__fill_1
X_2090_ net402 net33 net18 vssd1 vssd1 vccd1 vccd1 _0247_ sky130_fd_sc_hd__mux2_1
XFILLER_73_180 vssd1 vssd1 vccd1 vccd1 sky130_fd_sc_hd__fill_1
X_2992_ _1530_ vssd1 vssd1 vccd1 vccd1 _1531_ sky130_fd_sc_hd__inv_2
XFILLER_61_397 vssd1 vssd1 vccd1 vccd1 sky130_fd_sc_hd__fill_1
X_1943_ net541 net49 net30 vssd1 vssd1 vccd1 vccd1 _0123_ sky130_fd_sc_hd__mux2_1
XFILLER_9_85 vssd1 vssd1 vccd1 vccd1 sky130_fd_sc_hd__fill_2
X_3613_ clknet_leaf_20_clk _0506_ _0111_ vssd1 vssd1 vccd1 vccd1 MATMULT_INST.matmult_inst.spi_inst.tx_reg_sys\[16\]
+ sky130_fd_sc_hd__dfrtp_1
X_1874_ net132 MATMULT_INST.matmult_inst.fsm_inst.state\[0\] _0751_ vssd1 vssd1 vccd1
+ vccd1 _0752_ sky130_fd_sc_hd__and3b_1
X_3544_ _0054_ _0457_ _0053_ vssd1 vssd1 vccd1 vccd1 MATMULT_INST.matmult_inst.spi_inst.mosi_shifter\[0\]
+ sky130_fd_sc_hd__dfrtp_1
X_3475_ clknet_leaf_33_clk _0395_ vssd1 vssd1 vccd1 vccd1 MATMULT_INST.matmult_inst.alu_inst.col1\[3\]
+ sky130_fd_sc_hd__dfxtp_1
XANTENNA__1753__S net63 vssd1 vssd1 vccd1 vccd1 sky130_fd_sc_hd__diode_2
X_2426_ _0990_ _1017_ _1018_ _1019_ vssd1 vssd1 vccd1 vccd1 _1021_ sky130_fd_sc_hd__nand4_1
Xteam_02_229 vssd1 vssd1 vccd1 vccd1 team_02_229/HI gpio_oeb[0] sky130_fd_sc_hd__conb_1
X_2357_ _0940_ _0943_ _0954_ vssd1 vssd1 vccd1 vccd1 _0955_ sky130_fd_sc_hd__o21a_1
X_2288_ net582 _0911_ net99 vssd1 vssd1 vccd1 vccd1 _0353_ sky130_fd_sc_hd__mux2_1
XFILLER_52_342 vssd1 vssd1 vccd1 vccd1 sky130_fd_sc_hd__fill_2
XANTENNA__2070__A1 net34 vssd1 vssd1 vccd1 vccd1 sky130_fd_sc_hd__diode_2
XANTENNA__1948__A2 net71 vssd1 vssd1 vccd1 vccd1 sky130_fd_sc_hd__diode_2
XFILLER_60_15 vssd1 vssd1 vccd1 vccd1 sky130_fd_sc_hd__fill_4
XTAP_TAPCELL_ROW_50_598 vssd1 vccd1 sky130_fd_sc_hd__tapvpwrvgnd_1
XTAP_TAPCELL_ROW_7_232 vssd1 vccd1 sky130_fd_sc_hd__tapvpwrvgnd_1
XPHY_EDGE_ROW_8_Left_88 vssd1 vssd1 vccd1 vccd1 sky130_fd_sc_hd__decap_3
XFILLER_75_412 vccd1 vssd1 vccd1 vssd1 sky130_ef_sc_hd__decap_40_12
XFILLER_47_125 vssd1 vssd1 vccd1 vccd1 sky130_fd_sc_hd__fill_1
XANTENNA_fanout62_X net62 vssd1 vssd1 vccd1 vccd1 sky130_fd_sc_hd__diode_2
XFILLER_75_489 vssd1 vssd1 vccd1 vccd1 sky130_fd_sc_hd__fill_2
XTAP_TAPCELL_ROW_58_665 vssd1 vccd1 sky130_fd_sc_hd__tapvpwrvgnd_1
XFILLER_62_139 vssd1 vssd1 vccd1 vccd1 sky130_fd_sc_hd__fill_1
XFILLER_62_117 vccd1 vssd1 vccd1 vssd1 sky130_ef_sc_hd__decap_40_12
XFILLER_18_83 vssd1 vssd1 vccd1 vccd1 sky130_fd_sc_hd__fill_1
XFILLER_34_60 vssd1 vssd1 vccd1 vccd1 sky130_fd_sc_hd__fill_2
XTAP_TAPCELL_ROW_41_521 vssd1 vccd1 sky130_fd_sc_hd__tapvpwrvgnd_1
XFILLER_7_287 vssd1 vssd1 vccd1 vccd1 sky130_fd_sc_hd__fill_1
XFILLER_3_493 vssd1 vssd1 vccd1 vccd1 sky130_fd_sc_hd__fill_1
X_3260_ clknet_leaf_7_clk _0182_ vssd1 vssd1 vccd1 vccd1 MATMULT_INST.matmult_inst.mem_inst.matrixA3\[5\]
+ sky130_fd_sc_hd__dfxtp_1
X_2211_ net600 _0792_ _0845_ _0846_ vssd1 vssd1 vccd1 vccd1 _0341_ sky130_fd_sc_hd__a22o_1
X_3191_ net55 net84 net77 vssd1 vssd1 vccd1 vccd1 _0116_ sky130_fd_sc_hd__and3_1
X_2142_ net514 net38 net13 vssd1 vssd1 vccd1 vccd1 _0296_ sky130_fd_sc_hd__mux2_1
XFILLER_15_3 vccd1 vssd1 vccd1 vssd1 sky130_ef_sc_hd__decap_40_12
XFILLER_26_309 vssd1 vssd1 vccd1 vccd1 sky130_fd_sc_hd__fill_8
X_2073_ _0556_ _0558_ net50 vssd1 vssd1 vccd1 vccd1 _0820_ sky130_fd_sc_hd__and3_1
XFILLER_46_180 vssd1 vssd1 vccd1 vccd1 sky130_fd_sc_hd__fill_1
XFILLER_34_353 vssd1 vssd1 vccd1 vccd1 sky130_fd_sc_hd__fill_8
XFILLER_34_397 vssd1 vssd1 vccd1 vccd1 sky130_fd_sc_hd__fill_2
X_2975_ net156 net176 _1513_ vssd1 vssd1 vccd1 vccd1 _1514_ sky130_fd_sc_hd__and3_1
X_1926_ MATMULT_INST.matmult_inst.spi_inst.tx_reg_sys\[5\] MATMULT_INST.matmult_inst.spi_inst.miso_shifter\[4\]
+ net136 vssd1 vssd1 vccd1 vccd1 _0018_ sky130_fd_sc_hd__mux2_1
X_1857_ MATMULT_INST.matmult_inst.spi_inst.mosi_shifter\[0\] MATMULT_INST.matmult_inst.spi_inst.mosi_data_spi\[1\]
+ _0744_ vssd1 vssd1 vccd1 vccd1 _0448_ sky130_fd_sc_hd__mux2_1
X_3527_ clknet_leaf_4_clk net63 vssd1 vssd1 vccd1 vccd1 MATMULT_INST.matmult_inst.fsm_inst.load_delay
+ sky130_fd_sc_hd__dfxtp_1
X_1788_ MATMULT_INST.matmult_inst.mem_inst.mem1\[2\] net128 net120 MATMULT_INST.matmult_inst.mem_inst.mem2\[2\]
+ _0702_ vssd1 vssd1 vccd1 vccd1 _0703_ sky130_fd_sc_hd__a221o_1
XANTENNA_clkbuf_leaf_33_clk_A clknet_2_2__leaf_clk vssd1 vssd1 vccd1 vccd1 sky130_fd_sc_hd__diode_2
X_3458_ clknet_leaf_28_clk _0379_ vssd1 vssd1 vccd1 vccd1 MATMULT_INST.matmult_inst.alu_inst.adder_inst.r1.fa0.a
+ sky130_fd_sc_hd__dfxtp_1
XFILLER_39_27 vssd1 vssd1 vccd1 vccd1 sky130_fd_sc_hd__fill_2
X_3389_ clknet_leaf_18_clk _0311_ vssd1 vssd1 vccd1 vccd1 MATMULT_INST.matmult_inst.mem_inst.mem0\[8\]
+ sky130_fd_sc_hd__dfxtp_1
XTAP_TAPCELL_ROW_4_202 vssd1 vccd1 sky130_fd_sc_hd__tapvpwrvgnd_1
X_2409_ _1002_ _1003_ vssd1 vssd1 vccd1 vccd1 _1004_ sky130_fd_sc_hd__or2_1
XFILLER_29_169 vssd1 vssd1 vccd1 vccd1 sky130_fd_sc_hd__fill_8
XFILLER_37_180 vssd1 vssd1 vccd1 vccd1 sky130_fd_sc_hd__fill_4
XFILLER_52_150 vssd1 vssd1 vccd1 vccd1 sky130_fd_sc_hd__fill_2
XANTENNA_fanout22_A _0818_ vssd1 vssd1 vccd1 vccd1 sky130_fd_sc_hd__diode_2
XFILLER_40_367 vssd1 vssd1 vccd1 vccd1 sky130_fd_sc_hd__fill_8
XANTENNA__2043__A1 _0804_ vssd1 vssd1 vccd1 vccd1 sky130_fd_sc_hd__diode_2
XANTENNA__3158__B net87 vssd1 vssd1 vccd1 vccd1 sky130_fd_sc_hd__diode_2
XTAP_TAPCELL_ROW_10_259 vssd1 vccd1 sky130_fd_sc_hd__tapvpwrvgnd_1
XFILLER_4_224 vssd1 vssd1 vccd1 vccd1 sky130_fd_sc_hd__fill_4
XFILLER_4_268 vssd1 vssd1 vccd1 vccd1 sky130_fd_sc_hd__fill_2
XFILLER_20_95 vssd1 vssd1 vccd1 vccd1 sky130_fd_sc_hd__fill_1
XFILLER_48_423 vssd1 vssd1 vccd1 vccd1 sky130_fd_sc_hd__fill_4
XFILLER_48_434 vssd1 vssd1 vccd1 vccd1 sky130_fd_sc_hd__fill_1
Xhold71 MATMULT_INST.matmult_inst.mem_inst.matrixB1\[11\] vssd1 vssd1 vccd1 vccd1
+ net366 sky130_fd_sc_hd__dlygate4sd3_1
Xhold60 MATMULT_INST.matmult_inst.mem_inst.mem3\[10\] vssd1 vssd1 vccd1 vccd1 net355
+ sky130_fd_sc_hd__dlygate4sd3_1
Xhold82 MATMULT_INST.matmult_inst.mem_inst.matrixA0\[3\] vssd1 vssd1 vccd1 vccd1 net377
+ sky130_fd_sc_hd__dlygate4sd3_1
Xhold93 MATMULT_INST.matmult_inst.alu_inst.adder_inst.r1.fa0.b vssd1 vssd1 vccd1 vccd1
+ net388 sky130_fd_sc_hd__dlygate4sd3_1
XFILLER_16_331 vccd1 vssd1 vccd1 vssd1 sky130_ef_sc_hd__decap_40_12
XTAP_TAPCELL_ROW_18_326 vssd1 vccd1 sky130_fd_sc_hd__tapvpwrvgnd_1
XANTENNA__2237__B MATMULT_INST.matmult_inst.alu_inst.adder_inst.r1.fa1.a vssd1 vssd1
+ vccd1 vccd1 sky130_fd_sc_hd__diode_2
XFILLER_16_353 vssd1 vssd1 vccd1 vccd1 sky130_fd_sc_hd__fill_1
XANTENNA__2282__A1 _0906_ vssd1 vssd1 vccd1 vccd1 sky130_fd_sc_hd__diode_2
XFILLER_71_481 vssd1 vssd1 vccd1 vccd1 sky130_fd_sc_hd__fill_8
XTAP_TAPCELL_ROW_26_392 vssd1 vccd1 sky130_fd_sc_hd__tapvpwrvgnd_1
X_2760_ _1298_ _1299_ _1304_ vssd1 vssd1 vccd1 vccd1 _1306_ sky130_fd_sc_hd__or3b_1
X_2691_ net93 _1249_ _1255_ net576 vssd1 vssd1 vccd1 vccd1 _0411_ sky130_fd_sc_hd__a22o_1
X_1711_ MATMULT_INST.matmult_inst.mem_inst.matrixB1\[9\] net128 net120 MATMULT_INST.matmult_inst.mem_inst.matrixB2\[9\]
+ vssd1 vssd1 vccd1 vccd1 _0633_ sky130_fd_sc_hd__a22o_1
X_1642_ net222 _0557_ _0570_ net112 MATMULT_INST.matmult_inst.mem_inst.matrixA0\[16\]
+ vssd1 vssd1 vccd1 vccd1 _0571_ sky130_fd_sc_hd__a32o_1
XFILLER_6_97 vssd1 vssd1 vccd1 vccd1 sky130_fd_sc_hd__fill_2
X_3312_ clknet_leaf_4_clk _0234_ vssd1 vssd1 vccd1 vccd1 MATMULT_INST.matmult_inst.mem_inst.matrixA0\[3\]
+ sky130_fd_sc_hd__dfxtp_1
X_3243_ clknet_leaf_6_clk _0165_ vssd1 vssd1 vccd1 vccd1 MATMULT_INST.matmult_inst.mem_inst.matrixB0\[6\]
+ sky130_fd_sc_hd__dfxtp_1
X_3174_ net54 net83 net73 vssd1 vssd1 vccd1 vccd1 _0099_ sky130_fd_sc_hd__and3_1
X_2125_ net542 net36 net14 vssd1 vssd1 vccd1 vccd1 _0280_ sky130_fd_sc_hd__mux2_1
XFILLER_26_139 vssd1 vssd1 vccd1 vccd1 sky130_fd_sc_hd__fill_1
X_2056_ net415 net48 net20 vssd1 vssd1 vccd1 vccd1 _0214_ sky130_fd_sc_hd__mux2_1
XFILLER_54_448 vssd1 vssd1 vccd1 vccd1 sky130_fd_sc_hd__fill_2
XTAP_TAPCELL_ROW_52_616 vssd1 vccd1 sky130_fd_sc_hd__tapvpwrvgnd_1
XFILLER_34_183 vssd1 vssd1 vccd1 vccd1 sky130_fd_sc_hd__fill_2
X_2958_ _1444_ _1449_ vssd1 vssd1 vccd1 vccd1 _1498_ sky130_fd_sc_hd__nand2_1
XTAP_TAPCELL_ROW_60_682 vssd1 vccd1 sky130_fd_sc_hd__tapvpwrvgnd_1
X_1909_ _0736_ _0757_ _0785_ vssd1 vssd1 vccd1 vccd1 _0786_ sky130_fd_sc_hd__o21ai_1
X_2889_ net182 net155 vssd1 vssd1 vccd1 vccd1 _1431_ sky130_fd_sc_hd__nand2_1
XANTENNA_fanout112_X net112 vssd1 vssd1 vccd1 vccd1 sky130_fd_sc_hd__diode_2
XANTENNA__2102__S net17 vssd1 vssd1 vccd1 vccd1 sky130_fd_sc_hd__diode_2
XFILLER_17_117 vssd1 vssd1 vccd1 vccd1 sky130_fd_sc_hd__fill_2
XFILLER_13_312 vssd1 vssd1 vccd1 vccd1 sky130_fd_sc_hd__fill_4
XANTENNA_fanout25_X net25 vssd1 vssd1 vccd1 vccd1 sky130_fd_sc_hd__diode_2
XFILLER_13_345 vssd1 vssd1 vccd1 vccd1 sky130_fd_sc_hd__fill_2
XFILLER_9_349 vssd1 vssd1 vccd1 vccd1 sky130_fd_sc_hd__fill_1
Xoutput4 net4 vssd1 vssd1 vccd1 vccd1 gpio_out[3] sky130_fd_sc_hd__buf_2
XANTENNA__1851__S _0744_ vssd1 vssd1 vccd1 vccd1 sky130_fd_sc_hd__diode_2
XFILLER_0_293 vssd1 vssd1 vccd1 vccd1 sky130_fd_sc_hd__fill_4
XFILLER_48_275 vssd1 vssd1 vccd1 vccd1 sky130_fd_sc_hd__fill_2
XFILLER_63_245 vssd1 vssd1 vccd1 vccd1 sky130_fd_sc_hd__fill_1
XFILLER_63_234 vssd1 vssd1 vccd1 vccd1 sky130_fd_sc_hd__fill_1
XFILLER_63_278 vssd1 vssd1 vccd1 vccd1 sky130_fd_sc_hd__fill_2
XFILLER_51_418 vssd1 vssd1 vccd1 vccd1 sky130_fd_sc_hd__fill_8
X_2812_ _1353_ _1354_ _1352_ vssd1 vssd1 vccd1 vccd1 _1356_ sky130_fd_sc_hd__a21o_1
XANTENNA__2007__A1 net106 vssd1 vssd1 vccd1 vccd1 sky130_fd_sc_hd__diode_2
X_2743_ _1283_ _1289_ vssd1 vssd1 vccd1 vccd1 _1290_ sky130_fd_sc_hd__xnor2_1
X_2674_ _0671_ net101 vssd1 vssd1 vccd1 vccd1 _1252_ sky130_fd_sc_hd__and2_2
X_1625_ MATMULT_INST.matmult_inst.mem_inst.matrixA1\[17\] net129 net121 MATMULT_INST.matmult_inst.mem_inst.matrixA2\[17\]
+ _0554_ vssd1 vssd1 vccd1 vccd1 _0555_ sky130_fd_sc_hd__a221o_1
XANTENNA__1614__X _0545_ vssd1 vssd1 vccd1 vccd1 sky130_fd_sc_hd__diode_2
X_3226_ clknet_leaf_8_clk _0148_ vssd1 vssd1 vccd1 vccd1 MATMULT_INST.matmult_inst.mem_inst.matrixB1\[7\]
+ sky130_fd_sc_hd__dfxtp_1
X_3157_ net53 net83 net73 vssd1 vssd1 vccd1 vccd1 _0082_ sky130_fd_sc_hd__and3_1
XFILLER_54_201 vssd1 vssd1 vccd1 vccd1 sky130_fd_sc_hd__fill_1
X_2108_ net339 net34 net16 vssd1 vssd1 vccd1 vccd1 _0264_ sky130_fd_sc_hd__mux2_1
X_3088_ net133 _0767_ _1583_ vssd1 vssd1 vccd1 vccd1 _1584_ sky130_fd_sc_hd__o21ai_1
XANTENNA__1997__A net106 vssd1 vssd1 vccd1 vccd1 sky130_fd_sc_hd__diode_2
XFILLER_54_267 vssd1 vssd1 vccd1 vccd1 sky130_fd_sc_hd__fill_2
XFILLER_35_470 vssd1 vssd1 vccd1 vccd1 sky130_fd_sc_hd__fill_1
XTAP_TAPCELL_ROW_37_487 vssd1 vccd1 sky130_fd_sc_hd__tapvpwrvgnd_1
X_2039_ net586 net46 net22 vssd1 vssd1 vccd1 vccd1 _0198_ sky130_fd_sc_hd__mux2_1
XANTENNA__2797__A2 net173 vssd1 vssd1 vccd1 vccd1 sky130_fd_sc_hd__diode_2
XFILLER_22_120 vssd1 vssd1 vccd1 vccd1 sky130_fd_sc_hd__fill_4
XFILLER_52_27 vssd1 vssd1 vccd1 vccd1 sky130_fd_sc_hd__fill_1
XFILLER_22_197 vssd1 vssd1 vccd1 vccd1 sky130_fd_sc_hd__fill_8
XANTENNA__1936__S net137 vssd1 vssd1 vccd1 vccd1 sky130_fd_sc_hd__diode_2
XTAP_TAPCELL_ROW_20_343 vssd1 vccd1 sky130_fd_sc_hd__tapvpwrvgnd_1
XANTENNA__3717__A MATMULT_INST.matmult_inst.fsm_inst.transaction_ready vssd1 vssd1
+ vccd1 vccd1 sky130_fd_sc_hd__diode_2
Xhold371 MATMULT_INST.matmult_inst.fsm_inst.count\[2\] vssd1 vssd1 vccd1 vccd1 net666
+ sky130_fd_sc_hd__dlygate4sd3_1
Xhold360 MATMULT_INST.matmult_inst.alu_inst.adder_inst.r0.fa0.a vssd1 vssd1 vccd1
+ vccd1 net655 sky130_fd_sc_hd__dlygate4sd3_1
XFILLER_18_404 vssd1 vssd1 vccd1 vccd1 sky130_fd_sc_hd__fill_4
XTAP_TAPCELL_ROW_28_410 vssd1 vccd1 sky130_fd_sc_hd__tapvpwrvgnd_1
XFILLER_26_492 vssd1 vssd1 vccd1 vccd1 sky130_fd_sc_hd__fill_2
XTAP_TAPCELL_ROW_71_777 vssd1 vccd1 sky130_fd_sc_hd__tapvpwrvgnd_1
XFILLER_41_451 vssd1 vssd1 vccd1 vccd1 sky130_fd_sc_hd__fill_1
XFILLER_13_164 vssd1 vssd1 vccd1 vccd1 sky130_fd_sc_hd__fill_1
XFILLER_9_113 vssd1 vssd1 vccd1 vccd1 sky130_fd_sc_hd__fill_8
XFILLER_5_352 vssd1 vssd1 vccd1 vccd1 sky130_fd_sc_hd__fill_2
X_2390_ _0960_ _0984_ vssd1 vssd1 vccd1 vccd1 _0986_ sky130_fd_sc_hd__nor2_1
XTAP_TAPCELL_ROW_79_855 vssd1 vccd1 sky130_fd_sc_hd__tapvpwrvgnd_1
XTAP_TAPCELL_ROW_79_844 vssd1 vccd1 sky130_fd_sc_hd__tapvpwrvgnd_1
X_3011_ _1496_ _1524_ _1512_ vssd1 vssd1 vccd1 vccd1 _1549_ sky130_fd_sc_hd__o21bai_1
XTAP_TAPCELL_ROW_62_700 vssd1 vccd1 sky130_fd_sc_hd__tapvpwrvgnd_1
XFILLER_36_267 vssd1 vssd1 vccd1 vccd1 sky130_fd_sc_hd__fill_1
XTAP_TAPCELL_ROW_34_457 vssd1 vccd1 sky130_fd_sc_hd__tapvpwrvgnd_1
XFILLER_32_473 vssd1 vssd1 vccd1 vccd1 sky130_fd_sc_hd__fill_2
X_2726_ net183 net167 MATMULT_INST.matmult_inst.alu_inst.b1_reg\[0\] net164 vssd1
+ vssd1 vccd1 vccd1 _1274_ sky130_fd_sc_hd__a22oi_1
X_2657_ _1240_ _1242_ net657 net94 vssd1 vssd1 vccd1 vccd1 _0390_ sky130_fd_sc_hd__o2bb2a_1
X_1608_ net132 MATMULT_INST.matmult_inst.fsm_inst.state\[0\] vssd1 vssd1 vccd1 vccd1
+ _0539_ sky130_fd_sc_hd__nand2_2
X_2588_ _1176_ _1177_ vssd1 vssd1 vccd1 vccd1 _1178_ sky130_fd_sc_hd__or2_1
Xfanout103 _0732_ vssd1 vssd1 vccd1 vccd1 net103 sky130_fd_sc_hd__clkbuf_4
Xfanout136 net137 vssd1 vssd1 vccd1 vccd1 net136 sky130_fd_sc_hd__clkbuf_4
Xfanout114 _0933_ vssd1 vssd1 vccd1 vccd1 net114 sky130_fd_sc_hd__clkbuf_4
Xfanout125 net131 vssd1 vssd1 vccd1 vccd1 net125 sky130_fd_sc_hd__dlymetal6s2s_1
Xfanout147 net149 vssd1 vssd1 vccd1 vccd1 net147 sky130_fd_sc_hd__buf_1
XFILLER_59_337 vssd1 vssd1 vccd1 vccd1 sky130_fd_sc_hd__fill_8
Xfanout158 MATMULT_INST.matmult_inst.alu_inst.a1_reg\[5\] vssd1 vssd1 vccd1 vccd1
+ net158 sky130_fd_sc_hd__buf_2
Xfanout169 MATMULT_INST.matmult_inst.alu_inst.a1_reg\[0\] vssd1 vssd1 vccd1 vccd1
+ net169 sky130_fd_sc_hd__clkbuf_4
XFILLER_74_307 vssd1 vssd1 vccd1 vccd1 sky130_fd_sc_hd__fill_1
XFILLER_67_370 vssd1 vssd1 vccd1 vccd1 sky130_fd_sc_hd__fill_2
X_3209_ clknet_leaf_14_clk _0131_ vssd1 vssd1 vccd1 vccd1 MATMULT_INST.matmult_inst.mem_inst.matrixB2\[8\]
+ sky130_fd_sc_hd__dfxtp_1
XFILLER_23_473 vssd1 vssd1 vccd1 vccd1 sky130_fd_sc_hd__fill_1
XFILLER_10_134 vssd1 vssd1 vccd1 vccd1 sky130_fd_sc_hd__fill_4
XFILLER_6_138 vssd1 vssd1 vccd1 vccd1 sky130_fd_sc_hd__fill_2
XFILLER_2_333 vssd1 vssd1 vccd1 vccd1 sky130_fd_sc_hd__fill_1
XANTENNA__2155__A0 _0802_ vssd1 vssd1 vccd1 vccd1 sky130_fd_sc_hd__diode_2
XANTENNA__3182__A net58 vssd1 vssd1 vccd1 vccd1 sky130_fd_sc_hd__diode_2
Xhold190 MATMULT_INST.matmult_inst.mem_inst.matrixA2\[1\] vssd1 vssd1 vccd1 vccd1
+ net485 sky130_fd_sc_hd__dlygate4sd3_1
XTAP_TAPCELL_ROW_76_814 vssd1 vccd1 sky130_fd_sc_hd__tapvpwrvgnd_1
XFILLER_18_201 vssd1 vssd1 vccd1 vccd1 sky130_fd_sc_hd__fill_1
XFILLER_58_392 vssd1 vssd1 vccd1 vccd1 sky130_fd_sc_hd__fill_1
XANTENNA__1666__C1 _0545_ vssd1 vssd1 vccd1 vccd1 sky130_fd_sc_hd__diode_2
XPHY_EDGE_ROW_16_Right_16 vssd1 vssd1 vccd1 vccd1 sky130_fd_sc_hd__decap_3
XFILLER_33_237 vssd1 vssd1 vccd1 vccd1 sky130_fd_sc_hd__fill_4
X_1890_ net134 net133 _0539_ _0767_ vssd1 vssd1 vccd1 vccd1 _0768_ sky130_fd_sc_hd__o31a_1
XTAP_TAPCELL_ROW_31_438 vssd1 vccd1 sky130_fd_sc_hd__tapvpwrvgnd_1
XFILLER_41_281 vccd1 vssd1 vccd1 vssd1 sky130_ef_sc_hd__decap_40_12
X_3560_ clknet_leaf_14_clk _0472_ vssd1 vssd1 vccd1 vccd1 MATMULT_INST.matmult_inst.mem_inst.matrixB3\[8\]
+ sky130_fd_sc_hd__dfxtp_1
XPHY_EDGE_ROW_25_Right_25 vssd1 vssd1 vccd1 vccd1 sky130_fd_sc_hd__decap_3
X_2511_ _1102_ _1103_ vssd1 vssd1 vccd1 vccd1 _1104_ sky130_fd_sc_hd__xnor2_1
X_3491_ clknet_leaf_33_clk _0410_ vssd1 vssd1 vccd1 vccd1 MATMULT_INST.matmult_inst.alu_inst.row1\[2\]
+ sky130_fd_sc_hd__dfxtp_1
X_2442_ net197 net195 net200 net203 vssd1 vssd1 vccd1 vccd1 _1036_ sky130_fd_sc_hd__nand4_1
XFILLER_45_3 vccd1 vssd1 vccd1 vssd1 sky130_ef_sc_hd__decap_40_12
X_2373_ _0962_ _0963_ _0968_ vssd1 vssd1 vccd1 vccd1 _0970_ sky130_fd_sc_hd__or3b_1
XTAP_TAPCELL_ROW_39_505 vssd1 vccd1 sky130_fd_sc_hd__tapvpwrvgnd_1
XPHY_EDGE_ROW_34_Right_34 vssd1 vssd1 vccd1 vccd1 sky130_fd_sc_hd__decap_3
XTAP_TAPCELL_ROW_47_571 vssd1 vccd1 sky130_fd_sc_hd__tapvpwrvgnd_1
XFILLER_20_421 vssd1 vssd1 vccd1 vccd1 sky130_fd_sc_hd__fill_8
XPHY_EDGE_ROW_43_Right_43 vssd1 vssd1 vccd1 vccd1 sky130_fd_sc_hd__decap_3
X_2709_ net148 _0778_ vssd1 vssd1 vccd1 vccd1 _1261_ sky130_fd_sc_hd__nand2_1
XANTENNA__2688__A1 net93 vssd1 vssd1 vccd1 vccd1 sky130_fd_sc_hd__diode_2
XFILLER_58_26 vssd1 vssd1 vccd1 vccd1 sky130_fd_sc_hd__fill_2
XANTENNA__2110__S net17 vssd1 vssd1 vccd1 vccd1 sky130_fd_sc_hd__diode_2
XPHY_EDGE_ROW_52_Right_52 vssd1 vssd1 vccd1 vccd1 sky130_fd_sc_hd__decap_3
XFILLER_59_178 vssd1 vssd1 vccd1 vccd1 sky130_fd_sc_hd__fill_1
XFILLER_74_137 vssd1 vssd1 vccd1 vccd1 sky130_fd_sc_hd__fill_2
XTAP_TAPCELL_ROW_2_185 vssd1 vccd1 sky130_fd_sc_hd__tapvpwrvgnd_1
XFILLER_15_237 vccd1 vssd1 vccd1 vssd1 sky130_ef_sc_hd__decap_40_12
XFILLER_30_207 vssd1 vssd1 vccd1 vccd1 sky130_fd_sc_hd__fill_8
XPHY_EDGE_ROW_61_Right_61 vssd1 vssd1 vccd1 vccd1 sky130_fd_sc_hd__decap_3
XFILLER_23_95 vssd1 vssd1 vccd1 vccd1 sky130_fd_sc_hd__fill_4
XANTENNA__3177__A net58 vssd1 vssd1 vccd1 vccd1 sky130_fd_sc_hd__diode_2
XFILLER_78_421 vccd1 vssd1 vccd1 vssd1 sky130_ef_sc_hd__decap_40_12
XPHY_EDGE_ROW_70_Right_70 vssd1 vssd1 vccd1 vccd1 sky130_fd_sc_hd__decap_3
XFILLER_2_141 vssd1 vssd1 vccd1 vccd1 sky130_fd_sc_hd__fill_4
XANTENNA__2679__A1 net82 vssd1 vssd1 vccd1 vccd1 sky130_fd_sc_hd__diode_2
XANTENNA__2020__S net24 vssd1 vssd1 vccd1 vccd1 sky130_fd_sc_hd__diode_2
XFILLER_38_307 vssd1 vssd1 vccd1 vccd1 sky130_fd_sc_hd__fill_1
XFILLER_0_44 vssd1 vssd1 vccd1 vccd1 sky130_fd_sc_hd__fill_1
XFILLER_46_340 vssd1 vssd1 vccd1 vccd1 sky130_fd_sc_hd__fill_8
XFILLER_61_354 vssd1 vssd1 vccd1 vccd1 sky130_fd_sc_hd__fill_1
X_2991_ _1499_ _1528_ _1527_ vssd1 vssd1 vccd1 vccd1 _1530_ sky130_fd_sc_hd__a21oi_1
XFILLER_9_53 vssd1 vssd1 vccd1 vccd1 sky130_fd_sc_hd__fill_2
X_1942_ MATMULT_INST.matmult_inst.fsm_inst.rx_data\[0\] net71 net70 MATMULT_INST.matmult_inst.fsm_inst.alu_result\[0\]
+ vssd1 vssd1 vccd1 vccd1 _0797_ sky130_fd_sc_hd__a22o_2
X_1873_ _0541_ _0750_ vssd1 vssd1 vccd1 vccd1 _0751_ sky130_fd_sc_hd__nand2_1
X_3612_ clknet_leaf_20_clk _0505_ _0110_ vssd1 vssd1 vccd1 vccd1 MATMULT_INST.matmult_inst.spi_inst.tx_reg_sys\[15\]
+ sky130_fd_sc_hd__dfrtp_1
X_3543_ clknet_leaf_24_clk _0456_ _0052_ vssd1 vssd1 vccd1 vccd1 MATMULT_INST.matmult_inst.fsm_inst.rx_valid
+ sky130_fd_sc_hd__dfrtp_1
X_3474_ clknet_leaf_33_clk _0394_ vssd1 vssd1 vccd1 vccd1 MATMULT_INST.matmult_inst.alu_inst.col1\[2\]
+ sky130_fd_sc_hd__dfxtp_1
X_2425_ _1017_ _1018_ _1019_ _0990_ vssd1 vssd1 vccd1 vccd1 _1020_ sky130_fd_sc_hd__a22o_1
XFILLER_28_29 vssd1 vssd1 vccd1 vccd1 sky130_fd_sc_hd__fill_1
X_2356_ _0947_ _0953_ vssd1 vssd1 vccd1 vccd1 _0954_ sky130_fd_sc_hd__xnor2_1
X_2287_ _0909_ _0910_ vssd1 vssd1 vccd1 vccd1 _0911_ sky130_fd_sc_hd__xnor2_1
XFILLER_29_329 vssd1 vssd1 vccd1 vccd1 sky130_fd_sc_hd__fill_4
XFILLER_37_351 vssd1 vssd1 vccd1 vccd1 sky130_fd_sc_hd__fill_2
XFILLER_12_229 vssd1 vssd1 vccd1 vccd1 sky130_fd_sc_hd__fill_4
XFILLER_20_251 vssd1 vssd1 vccd1 vccd1 sky130_fd_sc_hd__fill_1
XANTENNA__2105__S net17 vssd1 vssd1 vccd1 vccd1 sky130_fd_sc_hd__diode_2
XFILLER_20_284 vssd1 vssd1 vccd1 vccd1 sky130_fd_sc_hd__fill_1
XANTENNA_clkbuf_leaf_7_clk_A clknet_2_1__leaf_clk vssd1 vssd1 vccd1 vccd1 sky130_fd_sc_hd__diode_2
XTAP_TAPCELL_ROW_50_599 vssd1 vccd1 sky130_fd_sc_hd__tapvpwrvgnd_1
XANTENNA__2358__B1 net96 vssd1 vssd1 vccd1 vccd1 sky130_fd_sc_hd__diode_2
XTAP_TAPCELL_ROW_7_233 vssd1 vccd1 sky130_fd_sc_hd__tapvpwrvgnd_1
XFILLER_75_435 vssd1 vssd1 vccd1 vccd1 sky130_fd_sc_hd__fill_4
XFILLER_75_424 vssd1 vssd1 vccd1 vccd1 sky130_fd_sc_hd__fill_8
XFILLER_47_148 vssd1 vssd1 vccd1 vccd1 sky130_fd_sc_hd__fill_2
XTAP_TAPCELL_ROW_58_666 vssd1 vccd1 sky130_fd_sc_hd__tapvpwrvgnd_1
XFILLER_62_129 vssd1 vssd1 vccd1 vccd1 sky130_fd_sc_hd__fill_8
XFILLER_43_332 vssd1 vssd1 vccd1 vccd1 sky130_fd_sc_hd__fill_4
XFILLER_43_354 vssd1 vssd1 vccd1 vccd1 sky130_fd_sc_hd__fill_1
XTAP_TAPCELL_ROW_41_522 vssd1 vccd1 sky130_fd_sc_hd__tapvpwrvgnd_1
XFILLER_34_94 vssd1 vssd1 vccd1 vccd1 sky130_fd_sc_hd__fill_8
XTAP_TAPCELL_ROW_13_279 vssd1 vccd1 sky130_fd_sc_hd__tapvpwrvgnd_1
XFILLER_11_273 vssd1 vssd1 vccd1 vccd1 sky130_fd_sc_hd__fill_4
XFILLER_7_211 vssd1 vssd1 vccd1 vccd1 sky130_fd_sc_hd__fill_1
XANTENNA__1854__S _0744_ vssd1 vssd1 vccd1 vccd1 sky130_fd_sc_hd__diode_2
XFILLER_50_93 vssd1 vssd1 vccd1 vccd1 sky130_fd_sc_hd__fill_1
XFILLER_3_461 vccd1 vssd1 vccd1 vssd1 sky130_ef_sc_hd__decap_40_12
X_2210_ MATMULT_INST.matmult_inst.alu_inst.adder_inst.r0.fa0.b MATMULT_INST.matmult_inst.alu_inst.adder_inst.r0.fa0.a
+ net100 vssd1 vssd1 vccd1 vccd1 _0846_ sky130_fd_sc_hd__o21a_1
XFILLER_78_240 vssd1 vssd1 vccd1 vccd1 sky130_fd_sc_hd__fill_1
X_3190_ net56 net85 net75 vssd1 vssd1 vccd1 vccd1 _0115_ sky130_fd_sc_hd__and3_1
XFILLER_59_91 vssd1 vssd1 vccd1 vccd1 sky130_fd_sc_hd__fill_4
X_2141_ net451 net39 net13 vssd1 vssd1 vccd1 vccd1 _0295_ sky130_fd_sc_hd__mux2_1
X_2072_ net432 net32 net21 vssd1 vssd1 vccd1 vccd1 _0230_ sky130_fd_sc_hd__mux2_1
XFILLER_34_365 vccd1 vssd1 vccd1 vssd1 sky130_ef_sc_hd__decap_40_12
X_2974_ net174 net155 vssd1 vssd1 vccd1 vccd1 _1513_ sky130_fd_sc_hd__and2_1
X_1925_ MATMULT_INST.matmult_inst.spi_inst.tx_reg_sys\[4\] MATMULT_INST.matmult_inst.spi_inst.miso_shifter\[3\]
+ net137 vssd1 vssd1 vccd1 vccd1 _0017_ sky130_fd_sc_hd__mux2_1
X_1856_ MATMULT_INST.matmult_inst.spi_inst.mosi_shifter\[1\] MATMULT_INST.matmult_inst.spi_inst.mosi_data_spi\[2\]
+ _0744_ vssd1 vssd1 vccd1 vccd1 _0449_ sky130_fd_sc_hd__mux2_1
XANTENNA__1764__S net63 vssd1 vssd1 vccd1 vccd1 sky130_fd_sc_hd__diode_2
X_1787_ net148 net145 MATMULT_INST.matmult_inst.mem_inst.mem3\[2\] vssd1 vssd1 vccd1
+ vccd1 _0702_ sky130_fd_sc_hd__and3_1
X_3526_ clknet_leaf_16_clk MATMULT_INST.matmult_inst.fsm_inst.tx_ready vssd1 vssd1
+ vccd1 vccd1 MATMULT_INST.matmult_inst.fsm_inst.tx_ready_delay sky130_fd_sc_hd__dfxtp_1
X_3457_ clknet_leaf_3_clk _0378_ vssd1 vssd1 vccd1 vccd1 MATMULT_INST.matmult_inst.alu_inst.adder_inst.r0.fa3.a
+ sky130_fd_sc_hd__dfxtp_1
XANTENNA__2512__A0 MATMULT_INST.matmult_inst.alu_inst.adder_inst.r2.fa0.a vssd1 vssd1
+ vccd1 vccd1 sky130_fd_sc_hd__diode_2
XTAP_TAPCELL_ROW_4_203 vssd1 vccd1 sky130_fd_sc_hd__tapvpwrvgnd_1
X_2408_ net206 net208 net193 net192 vssd1 vssd1 vccd1 vccd1 _1003_ sky130_fd_sc_hd__and4_1
X_3388_ clknet_leaf_8_clk _0310_ vssd1 vssd1 vccd1 vccd1 MATMULT_INST.matmult_inst.mem_inst.mem0\[7\]
+ sky130_fd_sc_hd__dfxtp_1
XFILLER_69_295 vssd1 vssd1 vccd1 vccd1 sky130_fd_sc_hd__fill_2
X_2339_ net213 net196 net215 net194 vssd1 vssd1 vccd1 vccd1 _0938_ sky130_fd_sc_hd__a22oi_1
XFILLER_57_435 vssd1 vssd1 vccd1 vccd1 sky130_fd_sc_hd__fill_4
XPHY_EDGE_ROW_2_Right_2 vssd1 vssd1 vccd1 vccd1 sky130_fd_sc_hd__decap_3
XFILLER_29_148 vssd1 vssd1 vccd1 vccd1 sky130_fd_sc_hd__fill_2
XTAP_TAPCELL_ROW_55_636 vssd1 vccd1 sky130_fd_sc_hd__tapvpwrvgnd_1
XFILLER_40_302 vssd1 vssd1 vccd1 vccd1 sky130_fd_sc_hd__fill_2
XFILLER_71_37 vssd1 vssd1 vccd1 vccd1 sky130_fd_sc_hd__fill_1
XFILLER_52_195 vssd1 vssd1 vccd1 vccd1 sky130_fd_sc_hd__fill_1
XANTENNA__3158__C net73 vssd1 vssd1 vccd1 vccd1 sky130_fd_sc_hd__diode_2
XFILLER_75_221 vssd1 vssd1 vccd1 vccd1 sky130_fd_sc_hd__fill_2
XFILLER_0_475 vssd1 vssd1 vccd1 vccd1 sky130_fd_sc_hd__fill_1
XFILLER_29_61 vssd1 vssd1 vccd1 vccd1 sky130_fd_sc_hd__fill_4
Xhold50 MATMULT_INST.matmult_inst.fsm_inst.alu_result\[9\] vssd1 vssd1 vccd1 vccd1
+ net345 sky130_fd_sc_hd__dlygate4sd3_1
Xhold61 MATMULT_INST.matmult_inst.mem_inst.matrixB3\[16\] vssd1 vssd1 vccd1 vccd1
+ net356 sky130_fd_sc_hd__dlygate4sd3_1
Xhold83 MATMULT_INST.matmult_inst.mem_inst.matrixA3\[16\] vssd1 vssd1 vccd1 vccd1
+ net378 sky130_fd_sc_hd__dlygate4sd3_1
Xhold72 MATMULT_INST.matmult_inst.mem_inst.mem3\[6\] vssd1 vssd1 vccd1 vccd1 net367
+ sky130_fd_sc_hd__dlygate4sd3_1
XFILLER_48_446 vssd1 vssd1 vccd1 vccd1 sky130_fd_sc_hd__fill_4
XANTENNA__3059__A1 net35 vssd1 vssd1 vccd1 vccd1 sky130_fd_sc_hd__diode_2
Xhold94 MATMULT_INST.matmult_inst.mem_inst.matrixA1\[11\] vssd1 vssd1 vccd1 vccd1
+ net389 sky130_fd_sc_hd__dlygate4sd3_1
XFILLER_63_449 vccd1 vssd1 vccd1 vssd1 sky130_ef_sc_hd__decap_40_12
XFILLER_16_321 vssd1 vssd1 vccd1 vccd1 sky130_fd_sc_hd__fill_4
XTAP_TAPCELL_ROW_18_327 vssd1 vccd1 sky130_fd_sc_hd__tapvpwrvgnd_1
XFILLER_16_343 vssd1 vssd1 vccd1 vccd1 sky130_fd_sc_hd__fill_8
XFILLER_16_365 vssd1 vssd1 vccd1 vccd1 sky130_fd_sc_hd__fill_4
XFILLER_45_71 vssd1 vssd1 vccd1 vccd1 sky130_fd_sc_hd__fill_1
XTAP_TAPCELL_ROW_26_393 vssd1 vccd1 sky130_fd_sc_hd__tapvpwrvgnd_1
XFILLER_31_357 vssd1 vssd1 vccd1 vccd1 sky130_fd_sc_hd__fill_2
XANTENNA__2253__B MATMULT_INST.matmult_inst.alu_inst.adder_inst.r1.fa3.a vssd1 vssd1
+ vccd1 vccd1 sky130_fd_sc_hd__diode_2
XFILLER_77_6 vccd1 vssd1 vccd1 vssd1 sky130_ef_sc_hd__decap_40_12
X_1710_ net635 net64 _0624_ _0632_ vssd1 vssd1 vccd1 vccd1 _0500_ sky130_fd_sc_hd__o22a_1
XPHY_EDGE_ROW_20_Left_100 vssd1 vssd1 vccd1 vccd1 sky130_fd_sc_hd__decap_3
X_2690_ net93 _1248_ _1255_ net354 vssd1 vssd1 vccd1 vccd1 _0410_ sky130_fd_sc_hd__a22o_1
X_1641_ MATMULT_INST.matmult_inst.mem_inst.matrixA1\[16\] net127 net119 MATMULT_INST.matmult_inst.mem_inst.matrixA2\[16\]
+ _0569_ vssd1 vssd1 vccd1 vccd1 _0570_ sky130_fd_sc_hd__a221o_1
XANTENNA__1793__A1 net217 vssd1 vssd1 vccd1 vccd1 sky130_fd_sc_hd__diode_2
XANTENNA__1793__B2 net221 vssd1 vssd1 vccd1 vccd1 sky130_fd_sc_hd__diode_2
X_3311_ clknet_leaf_16_clk _0233_ vssd1 vssd1 vccd1 vccd1 MATMULT_INST.matmult_inst.mem_inst.matrixA0\[2\]
+ sky130_fd_sc_hd__dfxtp_1
XFILLER_3_291 vssd1 vssd1 vccd1 vccd1 sky130_fd_sc_hd__fill_8
XFILLER_39_402 vssd1 vssd1 vccd1 vccd1 sky130_fd_sc_hd__fill_2
X_3242_ clknet_leaf_6_clk _0164_ vssd1 vssd1 vccd1 vccd1 MATMULT_INST.matmult_inst.mem_inst.matrixB0\[5\]
+ sky130_fd_sc_hd__dfxtp_1
XANTENNA__2709__A net148 vssd1 vssd1 vccd1 vccd1 sky130_fd_sc_hd__diode_2
X_3173_ net54 net83 net72 vssd1 vssd1 vccd1 vccd1 _0098_ sky130_fd_sc_hd__and3_1
X_2124_ net561 net37 net15 vssd1 vssd1 vccd1 vccd1 _0279_ sky130_fd_sc_hd__mux2_1
XFILLER_54_416 vssd1 vssd1 vccd1 vccd1 sky130_fd_sc_hd__fill_4
X_2055_ net488 net49 net20 vssd1 vssd1 vccd1 vccd1 _0213_ sky130_fd_sc_hd__mux2_1
XTAP_TAPCELL_ROW_52_617 vssd1 vccd1 sky130_fd_sc_hd__tapvpwrvgnd_1
XFILLER_62_493 vssd1 vssd1 vccd1 vccd1 sky130_fd_sc_hd__fill_1
X_2957_ _1483_ _1495_ vssd1 vssd1 vccd1 vccd1 _1497_ sky130_fd_sc_hd__xor2_1
XTAP_TAPCELL_ROW_60_683 vssd1 vccd1 sky130_fd_sc_hd__tapvpwrvgnd_1
X_2888_ _1428_ _1429_ vssd1 vssd1 vccd1 vccd1 _1430_ sky130_fd_sc_hd__nand2_1
X_1908_ MATMULT_INST.matmult_inst.fsm_inst.state\[4\] MATMULT_INST.matmult_inst.fsm_inst.state\[0\]
+ net132 vssd1 vssd1 vccd1 vccd1 _0785_ sky130_fd_sc_hd__or3b_2
X_1839_ MATMULT_INST.matmult_inst.spi_inst.mosi_shifter\[6\] MATMULT_INST.matmult_inst.spi_inst.mosi_shifter\[5\]
+ _0741_ vssd1 vssd1 vccd1 vccd1 _0463_ sky130_fd_sc_hd__mux2_1
XANTENNA__1784__B2 net219 vssd1 vssd1 vccd1 vccd1 sky130_fd_sc_hd__diode_2
XANTENNA__1784__A1 net217 vssd1 vssd1 vccd1 vccd1 sky130_fd_sc_hd__diode_2
X_3509_ clknet_leaf_27_clk _0426_ vssd1 vssd1 vccd1 vccd1 MATMULT_INST.matmult_inst.alu_inst.adder_inst.r0.fa0.b
+ sky130_fd_sc_hd__dfxtp_1
XTAP_TAPCELL_ROW_68_750 vssd1 vccd1 sky130_fd_sc_hd__tapvpwrvgnd_1
XFILLER_72_213 vssd1 vssd1 vccd1 vccd1 sky130_fd_sc_hd__fill_4
XFILLER_17_107 vssd1 vssd1 vccd1 vccd1 sky130_fd_sc_hd__fill_4
XFILLER_57_287 vssd1 vssd1 vccd1 vccd1 sky130_fd_sc_hd__fill_4
Xclkbuf_leaf_37_clk clknet_2_0__leaf_clk vssd1 vssd1 vccd1 vccd1 clknet_leaf_37_clk
+ sky130_fd_sc_hd__clkbuf_8
XFILLER_72_279 vssd1 vssd1 vccd1 vccd1 sky130_fd_sc_hd__fill_2
XFILLER_72_268 vssd1 vssd1 vccd1 vccd1 sky130_fd_sc_hd__fill_1
XPHY_EDGE_ROW_11_Left_91 vssd1 vssd1 vccd1 vccd1 sky130_fd_sc_hd__decap_3
XFILLER_53_460 vssd1 vssd1 vccd1 vccd1 sky130_fd_sc_hd__fill_2
XFILLER_25_173 vssd1 vssd1 vccd1 vccd1 sky130_fd_sc_hd__fill_1
XFILLER_53_493 vssd1 vssd1 vccd1 vccd1 sky130_fd_sc_hd__fill_1
XFILLER_13_335 vssd1 vssd1 vccd1 vccd1 sky130_fd_sc_hd__fill_1
XFILLER_40_143 vssd1 vssd1 vccd1 vccd1 sky130_fd_sc_hd__fill_1
XFILLER_15_85 vssd1 vssd1 vccd1 vccd1 sky130_fd_sc_hd__fill_2
XFILLER_40_154 vssd1 vssd1 vccd1 vccd1 sky130_fd_sc_hd__fill_4
XANTENNA_fanout18_X net18 vssd1 vssd1 vccd1 vccd1 sky130_fd_sc_hd__diode_2
XANTENNA__1775__A1 _0691_ vssd1 vssd1 vccd1 vccd1 sky130_fd_sc_hd__diode_2
XANTENNA__3185__A net62 vssd1 vssd1 vccd1 vccd1 sky130_fd_sc_hd__diode_2
Xoutput5 net5 vssd1 vssd1 vccd1 vccd1 gpio_out[4] sky130_fd_sc_hd__buf_2
Xclkbuf_leaf_28_clk clknet_2_2__leaf_clk vssd1 vssd1 vccd1 vccd1 clknet_leaf_28_clk
+ sky130_fd_sc_hd__clkbuf_8
XTAP_TAPCELL_ROW_74_797 vssd1 vccd1 sky130_fd_sc_hd__tapvpwrvgnd_1
XFILLER_44_460 vssd1 vssd1 vccd1 vccd1 sky130_fd_sc_hd__fill_1
XFILLER_44_493 vssd1 vssd1 vccd1 vccd1 sky130_fd_sc_hd__fill_1
XFILLER_16_195 vssd1 vssd1 vccd1 vccd1 sky130_fd_sc_hd__fill_1
X_2811_ _1352_ _1353_ _1354_ vssd1 vssd1 vccd1 vccd1 _1355_ sky130_fd_sc_hd__nand3_1
XANTENNA_clkbuf_leaf_32_clk_A clknet_2_2__leaf_clk vssd1 vssd1 vccd1 vccd1 sky130_fd_sc_hd__diode_2
X_2742_ _1287_ _1288_ vssd1 vssd1 vccd1 vccd1 _1289_ sky130_fd_sc_hd__or2_1
XFILLER_31_187 vssd1 vssd1 vccd1 vccd1 sky130_fd_sc_hd__fill_2
X_2673_ net603 _1246_ _1251_ net103 vssd1 vssd1 vccd1 vccd1 _0397_ sky130_fd_sc_hd__a22o_1
XANTENNA__2203__S net66 vssd1 vssd1 vccd1 vccd1 sky130_fd_sc_hd__diode_2
X_1624_ net153 net144 MATMULT_INST.matmult_inst.mem_inst.matrixA3\[17\] vssd1 vssd1
+ vccd1 vccd1 _0554_ sky130_fd_sc_hd__and3_1
XANTENNA__2715__B1 net140 vssd1 vssd1 vccd1 vccd1 sky130_fd_sc_hd__diode_2
X_3225_ clknet_leaf_1_clk _0147_ vssd1 vssd1 vccd1 vccd1 MATMULT_INST.matmult_inst.mem_inst.matrixB1\[6\]
+ sky130_fd_sc_hd__dfxtp_1
XFILLER_79_390 vssd1 vssd1 vccd1 vccd1 sky130_fd_sc_hd__fill_2
XFILLER_39_232 vssd1 vssd1 vccd1 vccd1 sky130_fd_sc_hd__fill_1
X_3156_ net54 net86 net73 vssd1 vssd1 vccd1 vccd1 _0081_ sky130_fd_sc_hd__and3_1
X_2107_ net319 net35 net16 vssd1 vssd1 vccd1 vccd1 _0263_ sky130_fd_sc_hd__mux2_1
Xclkbuf_leaf_19_clk clknet_2_3__leaf_clk vssd1 vssd1 vccd1 vccd1 clknet_leaf_19_clk
+ sky130_fd_sc_hd__clkbuf_8
X_3087_ _0757_ net135 net133 vssd1 vssd1 vccd1 vccd1 _1583_ sky130_fd_sc_hd__or3b_1
X_2038_ net456 net47 net22 vssd1 vssd1 vccd1 vccd1 _0197_ sky130_fd_sc_hd__mux2_1
XFILLER_35_493 vssd1 vssd1 vccd1 vccd1 sky130_fd_sc_hd__fill_1
XTAP_TAPCELL_ROW_37_488 vssd1 vccd1 sky130_fd_sc_hd__tapvpwrvgnd_1
XFILLER_50_430 vssd1 vssd1 vccd1 vccd1 sky130_fd_sc_hd__fill_1
XANTENNA_fanout222_X net222 vssd1 vssd1 vccd1 vccd1 sky130_fd_sc_hd__diode_2
XFILLER_6_309 vssd1 vssd1 vccd1 vccd1 sky130_fd_sc_hd__fill_4
XTAP_TAPCELL_ROW_20_344 vssd1 vccd1 sky130_fd_sc_hd__tapvpwrvgnd_1
XANTENNA__1757__B2 net222 vssd1 vssd1 vccd1 vccd1 sky130_fd_sc_hd__diode_2
XANTENNA__2113__S net14 vssd1 vssd1 vccd1 vccd1 sky130_fd_sc_hd__diode_2
Xhold361 MATMULT_INST.matmult_inst.spi_inst.tx_reg_sys\[12\] vssd1 vssd1 vccd1 vccd1
+ net656 sky130_fd_sc_hd__dlygate4sd3_1
XFILLER_7_6 vccd1 vssd1 vccd1 vssd1 sky130_ef_sc_hd__decap_40_12
Xhold350 MATMULT_INST.matmult_inst.fsm_inst.rx_valid_delay vssd1 vssd1 vccd1 vccd1
+ net645 sky130_fd_sc_hd__dlygate4sd3_1
Xhold372 MATMULT_INST.matmult_inst.fsm_inst.count\[0\] vssd1 vssd1 vccd1 vccd1 net667
+ sky130_fd_sc_hd__dlygate4sd3_1
XTAP_TAPCELL_ROW_28_411 vssd1 vccd1 sky130_fd_sc_hd__tapvpwrvgnd_1
XFILLER_13_132 vccd1 vssd1 vccd1 vssd1 sky130_ef_sc_hd__decap_40_12
XFILLER_13_121 vssd1 vssd1 vccd1 vccd1 sky130_fd_sc_hd__fill_1
XTAP_TAPCELL_ROW_71_778 vssd1 vccd1 sky130_fd_sc_hd__tapvpwrvgnd_1
XANTENNA__2023__S net24 vssd1 vssd1 vccd1 vccd1 sky130_fd_sc_hd__diode_2
XFILLER_5_397 vssd1 vssd1 vccd1 vccd1 sky130_fd_sc_hd__fill_1
XANTENNA__1920__A1 MATMULT_INST.matmult_inst.spi_inst.current_state vssd1 vssd1 vccd1
+ vccd1 sky130_fd_sc_hd__diode_2
XFILLER_3_33 vssd1 vssd1 vccd1 vccd1 sky130_fd_sc_hd__fill_1
XTAP_TAPCELL_ROW_79_856 vssd1 vccd1 sky130_fd_sc_hd__tapvpwrvgnd_1
XTAP_TAPCELL_ROW_79_845 vssd1 vccd1 sky130_fd_sc_hd__tapvpwrvgnd_1
X_3010_ _1541_ _1547_ vssd1 vssd1 vccd1 vccd1 _1548_ sky130_fd_sc_hd__xnor2_1
XTAP_TAPCELL_ROW_62_701 vssd1 vccd1 sky130_fd_sc_hd__tapvpwrvgnd_1
XFILLER_24_419 vssd1 vssd1 vccd1 vccd1 sky130_fd_sc_hd__fill_1
XFILLER_17_493 vssd1 vssd1 vccd1 vccd1 sky130_fd_sc_hd__fill_1
XTAP_TAPCELL_ROW_34_458 vssd1 vccd1 sky130_fd_sc_hd__tapvpwrvgnd_1
XANTENNA__1739__B2 net216 vssd1 vssd1 vccd1 vccd1 sky130_fd_sc_hd__diode_2
XANTENNA__1739__A1 net220 vssd1 vssd1 vccd1 vccd1 sky130_fd_sc_hd__diode_2
X_2725_ net658 net115 _1271_ _1273_ vssd1 vssd1 vccd1 vccd1 _0427_ sky130_fd_sc_hd__a22o_1
X_2656_ net94 _1223_ _1238_ vssd1 vssd1 vccd1 vccd1 _1242_ sky130_fd_sc_hd__and3_1
Xclkbuf_leaf_8_clk clknet_2_1__leaf_clk vssd1 vssd1 vccd1 vccd1 clknet_leaf_8_clk
+ sky130_fd_sc_hd__clkbuf_8
X_1607_ MATMULT_INST.matmult_inst.fsm_inst.count\[0\] _0537_ vssd1 vssd1 vccd1 vccd1
+ _0538_ sky130_fd_sc_hd__and2_1
X_2587_ net190 net199 net188 net202 vssd1 vssd1 vccd1 vccd1 _1177_ sky130_fd_sc_hd__and4_1
Xfanout104 net107 vssd1 vssd1 vccd1 vccd1 net104 sky130_fd_sc_hd__clkbuf_4
Xfanout137 MATMULT_INST.matmult_inst.spi_inst.first_bit_sent vssd1 vssd1 vccd1 vccd1
+ net137 sky130_fd_sc_hd__clkbuf_4
Xfanout115 _0933_ vssd1 vssd1 vccd1 vccd1 net115 sky130_fd_sc_hd__dlymetal6s2s_1
Xfanout126 net131 vssd1 vssd1 vccd1 vccd1 net126 sky130_fd_sc_hd__clkbuf_4
XFILLER_59_305 vssd1 vssd1 vccd1 vccd1 sky130_fd_sc_hd__fill_1
Xfanout159 MATMULT_INST.matmult_inst.alu_inst.a1_reg\[5\] vssd1 vssd1 vccd1 vccd1
+ net159 sky130_fd_sc_hd__clkbuf_2
Xfanout148 net149 vssd1 vssd1 vccd1 vccd1 net148 sky130_fd_sc_hd__buf_2
X_3208_ clknet_leaf_8_clk _0130_ vssd1 vssd1 vccd1 vccd1 MATMULT_INST.matmult_inst.mem_inst.matrixB2\[7\]
+ sky130_fd_sc_hd__dfxtp_1
X_3139_ net227 vssd1 vssd1 vccd1 vccd1 _0062_ sky130_fd_sc_hd__inv_2
XANTENNA__1675__B1 net104 vssd1 vssd1 vccd1 vccd1 sky130_fd_sc_hd__diode_2
XFILLER_15_408 vssd1 vssd1 vccd1 vccd1 sky130_fd_sc_hd__fill_2
XANTENNA__2108__S net16 vssd1 vssd1 vccd1 vccd1 sky130_fd_sc_hd__diode_2
XFILLER_23_441 vssd1 vssd1 vccd1 vccd1 sky130_fd_sc_hd__fill_4
XANTENNA__1947__S net30 vssd1 vssd1 vccd1 vccd1 sky130_fd_sc_hd__diode_2
Xhold180 MATMULT_INST.matmult_inst.mem_inst.matrixB1\[9\] vssd1 vssd1 vccd1 vccd1
+ net475 sky130_fd_sc_hd__dlygate4sd3_1
XANTENNA__3182__B net87 vssd1 vssd1 vccd1 vccd1 sky130_fd_sc_hd__diode_2
Xhold191 MATMULT_INST.matmult_inst.alu_inst.col1\[3\] vssd1 vssd1 vccd1 vccd1 net486
+ sky130_fd_sc_hd__dlygate4sd3_1
XTAP_TAPCELL_ROW_76_815 vssd1 vccd1 sky130_fd_sc_hd__tapvpwrvgnd_1
XFILLER_18_224 vssd1 vssd1 vccd1 vccd1 sky130_fd_sc_hd__fill_1
XFILLER_14_430 vssd1 vssd1 vccd1 vccd1 sky130_fd_sc_hd__fill_2
XANTENNA__2018__S net25 vssd1 vssd1 vccd1 vccd1 sky130_fd_sc_hd__diode_2
XANTENNA__1969__A1 _0810_ vssd1 vssd1 vccd1 vccd1 sky130_fd_sc_hd__diode_2
XTAP_TAPCELL_ROW_31_439 vssd1 vccd1 sky130_fd_sc_hd__tapvpwrvgnd_1
XFILLER_41_293 vssd1 vssd1 vccd1 vccd1 sky130_fd_sc_hd__fill_4
XANTENNA__1857__S _0744_ vssd1 vssd1 vccd1 vccd1 sky130_fd_sc_hd__diode_2
X_2510_ _1065_ _1068_ _1066_ vssd1 vssd1 vccd1 vccd1 _1103_ sky130_fd_sc_hd__o21a_1
X_3490_ clknet_leaf_33_clk _0409_ vssd1 vssd1 vccd1 vccd1 MATMULT_INST.matmult_inst.alu_inst.row1\[1\]
+ sky130_fd_sc_hd__dfxtp_1
XFILLER_5_161 vssd1 vssd1 vccd1 vccd1 sky130_fd_sc_hd__fill_1
X_2441_ net197 net200 net203 net195 vssd1 vssd1 vccd1 vccd1 _1035_ sky130_fd_sc_hd__a22o_1
XANTENNA__2146__A1 net34 vssd1 vssd1 vccd1 vccd1 sky130_fd_sc_hd__diode_2
XFILLER_5_183 vccd1 vssd1 vccd1 vssd1 sky130_ef_sc_hd__decap_40_12
X_2372_ _0963_ _0968_ vssd1 vssd1 vccd1 vccd1 _0969_ sky130_fd_sc_hd__nor2_1
XFILLER_38_3 vccd1 vssd1 vccd1 vssd1 sky130_ef_sc_hd__decap_40_12
XTAP_TAPCELL_ROW_39_506 vssd1 vccd1 sky130_fd_sc_hd__tapvpwrvgnd_1
XFILLER_64_363 vssd1 vssd1 vccd1 vccd1 sky130_fd_sc_hd__fill_1
XTAP_TAPCELL_ROW_47_572 vssd1 vccd1 sky130_fd_sc_hd__tapvpwrvgnd_1
XFILLER_32_271 vssd1 vssd1 vccd1 vccd1 sky130_fd_sc_hd__fill_1
XPHY_EDGE_ROW_49_Left_129 vssd1 vssd1 vccd1 vccd1 sky130_fd_sc_hd__decap_3
X_2708_ MATMULT_INST.matmult_inst.fsm_inst.count\[0\] _0770_ _0772_ vssd1 vssd1 vccd1
+ vccd1 _1260_ sky130_fd_sc_hd__and3b_1
X_2639_ _1224_ _1225_ vssd1 vssd1 vccd1 vccd1 _1227_ sky130_fd_sc_hd__xnor2_1
XPHY_EDGE_ROW_58_Left_138 vssd1 vssd1 vccd1 vccd1 sky130_fd_sc_hd__decap_3
XFILLER_74_48 vssd1 vssd1 vccd1 vccd1 sky130_fd_sc_hd__fill_2
XTAP_TAPCELL_ROW_2_186 vssd1 vccd1 sky130_fd_sc_hd__tapvpwrvgnd_1
XANTENNA_fanout45_A _0801_ vssd1 vssd1 vccd1 vccd1 sky130_fd_sc_hd__diode_2
XFILLER_15_249 vccd1 vssd1 vccd1 vssd1 sky130_ef_sc_hd__decap_40_12
XPHY_EDGE_ROW_67_Left_147 vssd1 vssd1 vccd1 vccd1 sky130_fd_sc_hd__decap_3
XANTENNA__1677__S net64 vssd1 vssd1 vccd1 vccd1 sky130_fd_sc_hd__diode_2
XFILLER_11_433 vssd1 vssd1 vccd1 vccd1 sky130_fd_sc_hd__fill_2
XFILLER_23_271 vssd1 vssd1 vccd1 vccd1 sky130_fd_sc_hd__fill_8
XFILLER_11_466 vccd1 vssd1 vccd1 vssd1 sky130_ef_sc_hd__decap_40_12
XFILLER_7_426 vssd1 vssd1 vccd1 vccd1 sky130_fd_sc_hd__fill_8
XANTENNA__3177__B net87 vssd1 vssd1 vccd1 vccd1 sky130_fd_sc_hd__diode_2
XANTENNA__1706__A net222 vssd1 vssd1 vccd1 vccd1 sky130_fd_sc_hd__diode_2
XFILLER_78_400 vccd1 vssd1 vccd1 vssd1 sky130_ef_sc_hd__decap_40_12
XPHY_EDGE_ROW_76_Left_156 vssd1 vssd1 vccd1 vccd1 sky130_fd_sc_hd__decap_3
XFILLER_2_153 vssd1 vssd1 vccd1 vccd1 sky130_fd_sc_hd__fill_1
XFILLER_78_433 vccd1 vssd1 vccd1 vssd1 sky130_ef_sc_hd__decap_40_12
XFILLER_78_477 vssd1 vssd1 vccd1 vccd1 sky130_fd_sc_hd__fill_4
XFILLER_48_93 vssd1 vssd1 vccd1 vccd1 sky130_fd_sc_hd__fill_1
XFILLER_0_34 vssd1 vssd1 vccd1 vccd1 sky130_fd_sc_hd__fill_8
XFILLER_0_12 vccd1 vssd1 vccd1 vssd1 sky130_ef_sc_hd__decap_40_12
XANTENNA__2300__A1 _0921_ vssd1 vssd1 vccd1 vccd1 sky130_fd_sc_hd__diode_2
XFILLER_61_311 vccd1 vssd1 vccd1 vssd1 sky130_ef_sc_hd__decap_40_12
XFILLER_61_333 vssd1 vssd1 vccd1 vccd1 sky130_fd_sc_hd__fill_2
XFILLER_46_396 vssd1 vssd1 vccd1 vccd1 sky130_fd_sc_hd__fill_1
XFILLER_9_10 vssd1 vssd1 vccd1 vccd1 sky130_fd_sc_hd__fill_1
X_2990_ _1499_ _1527_ _1528_ vssd1 vssd1 vccd1 vccd1 _1529_ sky130_fd_sc_hd__nand3_2
XTAP_TAPCELL_ROW_44_542 vssd1 vccd1 sky130_fd_sc_hd__tapvpwrvgnd_1
X_1941_ net219 net120 net50 vssd1 vssd1 vccd1 vccd1 _0796_ sky130_fd_sc_hd__and3_1
X_1872_ net135 _0540_ vssd1 vssd1 vccd1 vccd1 _0750_ sky130_fd_sc_hd__or2_1
X_3611_ clknet_leaf_20_clk net639 _0109_ vssd1 vssd1 vccd1 vccd1 MATMULT_INST.matmult_inst.spi_inst.tx_reg_sys\[14\]
+ sky130_fd_sc_hd__dfrtp_1
X_3542_ _0051_ _0455_ _0050_ vssd1 vssd1 vccd1 vccd1 MATMULT_INST.matmult_inst.spi_inst.rx_done_spi
+ sky130_fd_sc_hd__dfrtp_1
X_3473_ clknet_leaf_33_clk _0393_ vssd1 vssd1 vccd1 vccd1 MATMULT_INST.matmult_inst.alu_inst.col1\[1\]
+ sky130_fd_sc_hd__dfxtp_1
X_2424_ net197 net205 _0988_ _0989_ _0957_ vssd1 vssd1 vccd1 vccd1 _1019_ sky130_fd_sc_hd__a41o_1
X_2355_ _0951_ _0952_ vssd1 vssd1 vccd1 vccd1 _0953_ sky130_fd_sc_hd__or2_1
XANTENNA__1903__X _0781_ vssd1 vssd1 vccd1 vccd1 sky130_fd_sc_hd__diode_2
X_2286_ _0902_ _0905_ _0903_ vssd1 vssd1 vccd1 vccd1 _0910_ sky130_fd_sc_hd__a21bo_1
XFILLER_37_330 vssd1 vssd1 vccd1 vccd1 sky130_fd_sc_hd__fill_4
XFILLER_64_160 vssd1 vssd1 vccd1 vccd1 sky130_fd_sc_hd__fill_1
XFILLER_64_182 vssd1 vssd1 vccd1 vccd1 sky130_fd_sc_hd__fill_1
XFILLER_52_377 vccd1 vssd1 vccd1 vssd1 sky130_ef_sc_hd__decap_40_12
XFILLER_69_15 vssd1 vssd1 vccd1 vccd1 sky130_fd_sc_hd__fill_1
XANTENNA__2121__S net15 vssd1 vssd1 vccd1 vccd1 sky130_fd_sc_hd__diode_2
XTAP_TAPCELL_ROW_7_234 vssd1 vccd1 sky130_fd_sc_hd__tapvpwrvgnd_1
XTAP_TAPCELL_ROW_58_667 vssd1 vccd1 sky130_fd_sc_hd__tapvpwrvgnd_1
XFILLER_18_85 vccd1 vssd1 vccd1 vssd1 sky130_ef_sc_hd__decap_40_12
XFILLER_55_171 vssd1 vssd1 vccd1 vccd1 sky130_fd_sc_hd__fill_2
XTAP_TAPCELL_ROW_41_523 vssd1 vccd1 sky130_fd_sc_hd__tapvpwrvgnd_1
XFILLER_43_388 vssd1 vssd1 vccd1 vccd1 sky130_fd_sc_hd__fill_4
XANTENNA__3188__A net62 vssd1 vssd1 vccd1 vccd1 sky130_fd_sc_hd__diode_2
XANTENNA__2597__A1 net190 vssd1 vssd1 vccd1 vccd1 sky130_fd_sc_hd__diode_2
XANTENNA__2092__A net217 vssd1 vssd1 vccd1 vccd1 sky130_fd_sc_hd__diode_2
XFILLER_7_201 vssd1 vssd1 vccd1 vccd1 sky130_fd_sc_hd__fill_8
XFILLER_11_285 vssd1 vssd1 vccd1 vccd1 sky130_fd_sc_hd__fill_2
XANTENNA__2031__S net25 vssd1 vssd1 vccd1 vccd1 sky130_fd_sc_hd__diode_2
XFILLER_3_473 vccd1 vssd1 vccd1 vssd1 sky130_ef_sc_hd__decap_40_12
X_2140_ net495 net40 net13 vssd1 vssd1 vccd1 vccd1 _0294_ sky130_fd_sc_hd__mux2_1
X_2071_ net406 net33 net21 vssd1 vssd1 vccd1 vccd1 _0229_ sky130_fd_sc_hd__mux2_1
XFILLER_46_193 vssd1 vssd1 vccd1 vccd1 sky130_fd_sc_hd__fill_1
XFILLER_34_377 vccd1 vssd1 vccd1 vssd1 sky130_ef_sc_hd__decap_40_12
X_2973_ _1510_ _1511_ vssd1 vssd1 vccd1 vccd1 _1512_ sky130_fd_sc_hd__nor2_1
X_1924_ MATMULT_INST.matmult_inst.spi_inst.tx_reg_sys\[3\] MATMULT_INST.matmult_inst.spi_inst.miso_shifter\[2\]
+ net136 vssd1 vssd1 vccd1 vccd1 _0016_ sky130_fd_sc_hd__mux2_1
X_1855_ MATMULT_INST.matmult_inst.spi_inst.mosi_shifter\[2\] MATMULT_INST.matmult_inst.spi_inst.mosi_data_spi\[3\]
+ _0744_ vssd1 vssd1 vccd1 vccd1 _0450_ sky130_fd_sc_hd__mux2_1
X_1786_ net652 _0701_ net63 vssd1 vssd1 vccd1 vccd1 _0493_ sky130_fd_sc_hd__mux2_1
X_3525_ clknet_leaf_27_clk _0442_ vssd1 vssd1 vccd1 vccd1 MATMULT_INST.matmult_inst.alu_inst.adder_inst.fa.b
+ sky130_fd_sc_hd__dfxtp_1
Xfanout6 _1578_ vssd1 vssd1 vccd1 vccd1 net6 sky130_fd_sc_hd__buf_2
X_3456_ clknet_leaf_3_clk _0377_ vssd1 vssd1 vccd1 vccd1 MATMULT_INST.matmult_inst.alu_inst.adder_inst.r0.fa2.a
+ sky130_fd_sc_hd__dfxtp_1
XFILLER_69_252 vssd1 vssd1 vccd1 vccd1 sky130_fd_sc_hd__fill_1
X_2407_ net207 net193 net192 net208 vssd1 vssd1 vccd1 vccd1 _1002_ sky130_fd_sc_hd__a22oi_1
XTAP_TAPCELL_ROW_4_204 vssd1 vccd1 sky130_fd_sc_hd__tapvpwrvgnd_1
X_3387_ clknet_leaf_6_clk _0309_ vssd1 vssd1 vccd1 vccd1 MATMULT_INST.matmult_inst.mem_inst.mem0\[6\]
+ sky130_fd_sc_hd__dfxtp_1
XFILLER_29_105 vssd1 vssd1 vccd1 vccd1 sky130_fd_sc_hd__fill_1
X_2338_ MATMULT_INST.matmult_inst.alu_inst.adder_inst.r0.fa1.a net114 _0935_ _0937_
+ vssd1 vssd1 vccd1 vccd1 _0376_ sky130_fd_sc_hd__a22o_1
X_2269_ _0894_ _0895_ vssd1 vssd1 vccd1 vccd1 _0896_ sky130_fd_sc_hd__xor2_1
XFILLER_44_119 vssd1 vssd1 vccd1 vccd1 sky130_fd_sc_hd__fill_2
XTAP_TAPCELL_ROW_55_637 vssd1 vccd1 sky130_fd_sc_hd__tapvpwrvgnd_1
XFILLER_52_163 vssd1 vssd1 vccd1 vccd1 sky130_fd_sc_hd__fill_2
XANTENNA__2116__S net14 vssd1 vssd1 vccd1 vccd1 sky130_fd_sc_hd__diode_2
XANTENNA__1955__S net30 vssd1 vssd1 vccd1 vccd1 sky130_fd_sc_hd__diode_2
XANTENNA__2200__A0 net200 vssd1 vssd1 vccd1 vccd1 sky130_fd_sc_hd__diode_2
XFILLER_20_75 vssd1 vssd1 vccd1 vccd1 sky130_fd_sc_hd__fill_8
XANTENNA__3174__C net73 vssd1 vssd1 vccd1 vccd1 sky130_fd_sc_hd__diode_2
XFILLER_0_421 vccd1 vssd1 vccd1 vssd1 sky130_ef_sc_hd__decap_40_12
Xhold40 _0512_ vssd1 vssd1 vccd1 vccd1 net335 sky130_fd_sc_hd__dlygate4sd3_1
XFILLER_48_414 vssd1 vssd1 vccd1 vccd1 sky130_fd_sc_hd__fill_4
XFILLER_75_233 vssd1 vssd1 vccd1 vccd1 sky130_fd_sc_hd__fill_1
Xhold62 MATMULT_INST.matmult_inst.mem_inst.matrixB3\[13\] vssd1 vssd1 vccd1 vccd1
+ net357 sky130_fd_sc_hd__dlygate4sd3_1
Xhold73 MATMULT_INST.matmult_inst.mem_inst.mem3\[5\] vssd1 vssd1 vccd1 vccd1 net368
+ sky130_fd_sc_hd__dlygate4sd3_1
Xhold51 _0517_ vssd1 vssd1 vccd1 vccd1 net346 sky130_fd_sc_hd__dlygate4sd3_1
Xhold95 MATMULT_INST.matmult_inst.alu_inst.out\[14\] vssd1 vssd1 vccd1 vccd1 net390
+ sky130_fd_sc_hd__dlygate4sd3_1
Xhold84 MATMULT_INST.matmult_inst.mem_inst.mem2\[4\] vssd1 vssd1 vccd1 vccd1 net379
+ sky130_fd_sc_hd__dlygate4sd3_1
XTAP_TAPCELL_ROW_18_328 vssd1 vccd1 sky130_fd_sc_hd__tapvpwrvgnd_1
XTAP_TAPCELL_ROW_26_394 vssd1 vccd1 sky130_fd_sc_hd__tapvpwrvgnd_1
XANTENNA__2026__S net24 vssd1 vssd1 vccd1 vccd1 sky130_fd_sc_hd__diode_2
X_1640_ net150 net142 MATMULT_INST.matmult_inst.mem_inst.matrixA3\[16\] vssd1 vssd1
+ vccd1 vccd1 _0569_ sky130_fd_sc_hd__and3_1
XFILLER_6_33 vssd1 vssd1 vccd1 vccd1 sky130_fd_sc_hd__fill_1
X_3310_ clknet_leaf_5_clk _0232_ vssd1 vssd1 vccd1 vccd1 MATMULT_INST.matmult_inst.mem_inst.matrixA0\[1\]
+ sky130_fd_sc_hd__dfxtp_1
XFILLER_3_281 vssd1 vssd1 vccd1 vccd1 sky130_fd_sc_hd__fill_1
X_3241_ clknet_leaf_6_clk _0163_ vssd1 vssd1 vccd1 vccd1 MATMULT_INST.matmult_inst.mem_inst.matrixB0\[4\]
+ sky130_fd_sc_hd__dfxtp_1
XFILLER_20_3 vssd1 vssd1 vccd1 vccd1 sky130_fd_sc_hd__fill_2
X_3172_ net53 net83 net72 vssd1 vssd1 vccd1 vccd1 _0097_ sky130_fd_sc_hd__and3_1
X_2123_ net530 net38 net15 vssd1 vssd1 vccd1 vccd1 _0278_ sky130_fd_sc_hd__mux2_1
XANTENNA_clkbuf_leaf_6_clk_A clknet_2_1__leaf_clk vssd1 vssd1 vccd1 vccd1 sky130_fd_sc_hd__diode_2
XFILLER_66_288 vssd1 vssd1 vccd1 vccd1 sky130_fd_sc_hd__fill_1
X_2054_ net131 _0558_ net50 vssd1 vssd1 vccd1 vccd1 _0819_ sky130_fd_sc_hd__and3_1
XFILLER_34_141 vccd1 vssd1 vccd1 vssd1 sky130_ef_sc_hd__decap_40_12
XFILLER_34_185 vssd1 vssd1 vccd1 vccd1 sky130_fd_sc_hd__fill_1
XTAP_TAPCELL_ROW_52_618 vssd1 vccd1 sky130_fd_sc_hd__tapvpwrvgnd_1
X_2956_ _1483_ _1495_ vssd1 vssd1 vccd1 vccd1 _1496_ sky130_fd_sc_hd__nand2_1
X_2887_ net159 net157 net178 net181 vssd1 vssd1 vccd1 vccd1 _1429_ sky130_fd_sc_hd__nand4_1
X_1907_ MATMULT_INST.matmult_inst.fsm_inst.state\[1\] _0736_ vssd1 vssd1 vccd1 vccd1
+ _0784_ sky130_fd_sc_hd__nor2_1
XANTENNA__1775__S net63 vssd1 vssd1 vccd1 vccd1 sky130_fd_sc_hd__diode_2
XTAP_TAPCELL_ROW_60_684 vssd1 vccd1 sky130_fd_sc_hd__tapvpwrvgnd_1
X_1838_ MATMULT_INST.matmult_inst.spi_inst.rx_bit_count\[3\] net2 _0740_ vssd1 vssd1
+ vccd1 vccd1 _0741_ sky130_fd_sc_hd__and3b_4
X_1769_ net146 net138 MATMULT_INST.matmult_inst.mem_inst.matrixB3\[4\] vssd1 vssd1
+ vccd1 vccd1 _0686_ sky130_fd_sc_hd__and3_1
X_3508_ clknet_leaf_24_clk net298 vssd1 vssd1 vccd1 vccd1 MATMULT_INST.matmult_inst.fsm_inst.rx_valid_delay
+ sky130_fd_sc_hd__dfxtp_1
X_3439_ clknet_leaf_33_clk _0361_ vssd1 vssd1 vccd1 vccd1 MATMULT_INST.matmult_inst.alu_inst.b1_reg\[2\]
+ sky130_fd_sc_hd__dfxtp_1
XFILLER_66_38 vssd1 vssd1 vccd1 vccd1 sky130_fd_sc_hd__fill_1
XTAP_TAPCELL_ROW_68_751 vssd1 vccd1 sky130_fd_sc_hd__tapvpwrvgnd_1
XFILLER_17_119 vssd1 vssd1 vccd1 vccd1 sky130_fd_sc_hd__fill_1
XFILLER_25_185 vssd1 vssd1 vccd1 vccd1 sky130_fd_sc_hd__fill_8
XFILLER_40_122 vssd1 vssd1 vccd1 vccd1 sky130_fd_sc_hd__fill_1
XTAP_TAPCELL_ROW_23_364 vssd1 vccd1 sky130_fd_sc_hd__tapvpwrvgnd_1
XFILLER_21_391 vssd1 vssd1 vccd1 vccd1 sky130_fd_sc_hd__fill_1
XFILLER_40_199 vssd1 vssd1 vccd1 vccd1 sky130_fd_sc_hd__fill_1
XFILLER_0_251 vssd1 vssd1 vccd1 vccd1 sky130_fd_sc_hd__fill_1
XFILLER_0_262 vccd1 vssd1 vccd1 vssd1 sky130_ef_sc_hd__decap_40_12
XFILLER_48_277 vssd1 vssd1 vccd1 vccd1 sky130_fd_sc_hd__fill_1
XFILLER_16_141 vccd1 vssd1 vccd1 vssd1 sky130_ef_sc_hd__decap_40_12
XTAP_TAPCELL_ROW_74_798 vssd1 vccd1 sky130_fd_sc_hd__tapvpwrvgnd_1
XFILLER_31_111 vssd1 vssd1 vccd1 vccd1 sky130_fd_sc_hd__fill_1
XFILLER_72_81 vssd1 vssd1 vccd1 vccd1 sky130_fd_sc_hd__fill_2
X_2810_ net182 net161 net159 net180 vssd1 vssd1 vccd1 vccd1 _1354_ sky130_fd_sc_hd__nand4_1
X_2741_ _1275_ _1284_ _1286_ vssd1 vssd1 vccd1 vccd1 _1288_ sky130_fd_sc_hd__and3_1
X_2672_ _0681_ net101 vssd1 vssd1 vccd1 vccd1 _1251_ sky130_fd_sc_hd__and2_2
X_1623_ MATMULT_INST.matmult_inst.mem_inst.matrixB1\[17\] net129 net121 MATMULT_INST.matmult_inst.mem_inst.matrixB2\[17\]
+ _0552_ vssd1 vssd1 vccd1 vccd1 _0553_ sky130_fd_sc_hd__a221o_1
X_3224_ clknet_leaf_1_clk _0146_ vssd1 vssd1 vccd1 vccd1 MATMULT_INST.matmult_inst.mem_inst.matrixB1\[5\]
+ sky130_fd_sc_hd__dfxtp_1
.ends
