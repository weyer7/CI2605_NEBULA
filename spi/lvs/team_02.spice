* NGSPICE file created from team_02.ext - technology: sky130A

* Black-box entry subcircuit for sky130_fd_sc_hd__fill_1 abstract view
.subckt sky130_fd_sc_hd__fill_1 VGND VNB VPB VPWR
.ends

* Black-box entry subcircuit for sky130_fd_sc_hd__diode_2 abstract view
.subckt sky130_fd_sc_hd__diode_2 DIODE VGND VNB VPB VPWR
.ends

* Black-box entry subcircuit for sky130_fd_sc_hd__dfrtp_1 abstract view
.subckt sky130_fd_sc_hd__dfrtp_1 CLK D RESET_B VGND VNB VPB VPWR Q
.ends

* Black-box entry subcircuit for sky130_fd_sc_hd__nor2_1 abstract view
.subckt sky130_fd_sc_hd__nor2_1 A B VGND VNB VPB VPWR Y
.ends

* Black-box entry subcircuit for sky130_fd_sc_hd__tapvpwrvgnd_1 abstract view
.subckt sky130_fd_sc_hd__tapvpwrvgnd_1 VGND VPWR
.ends

* Black-box entry subcircuit for sky130_fd_sc_hd__mux2_1 abstract view
.subckt sky130_fd_sc_hd__mux2_1 A0 A1 S VGND VNB VPB VPWR X
.ends

* Black-box entry subcircuit for sky130_fd_sc_hd__fill_4 abstract view
.subckt sky130_fd_sc_hd__fill_4 VGND VNB VPB VPWR
.ends

* Black-box entry subcircuit for sky130_fd_sc_hd__fill_8 abstract view
.subckt sky130_fd_sc_hd__fill_8 VGND VNB VPB VPWR
.ends

* Black-box entry subcircuit for sky130_fd_sc_hd__dlygate4sd3_1 abstract view
.subckt sky130_fd_sc_hd__dlygate4sd3_1 A VGND VNB VPB VPWR X
.ends

* Black-box entry subcircuit for sky130_ef_sc_hd__decap_40_12 abstract view
.subckt sky130_ef_sc_hd__decap_40_12 VPWR VGND VPB VNB
.ends

* Black-box entry subcircuit for sky130_fd_sc_hd__nand2_1 abstract view
.subckt sky130_fd_sc_hd__nand2_1 A B VGND VNB VPB VPWR Y
.ends

* Black-box entry subcircuit for sky130_fd_sc_hd__nor2_2 abstract view
.subckt sky130_fd_sc_hd__nor2_2 A B VGND VNB VPB VPWR Y
.ends

* Black-box entry subcircuit for sky130_fd_sc_hd__clkbuf_4 abstract view
.subckt sky130_fd_sc_hd__clkbuf_4 A VGND VNB VPB VPWR X
.ends

* Black-box entry subcircuit for sky130_fd_sc_hd__clkbuf_2 abstract view
.subckt sky130_fd_sc_hd__clkbuf_2 A VGND VNB VPB VPWR X
.ends

* Black-box entry subcircuit for sky130_fd_sc_hd__inv_2 abstract view
.subckt sky130_fd_sc_hd__inv_2 A VGND VNB VPB VPWR Y
.ends

* Black-box entry subcircuit for sky130_fd_sc_hd__a22o_1 abstract view
.subckt sky130_fd_sc_hd__a22o_1 A1 A2 B1 B2 VGND VNB VPB VPWR X
.ends

* Black-box entry subcircuit for sky130_fd_sc_hd__and2_1 abstract view
.subckt sky130_fd_sc_hd__and2_1 A B VGND VNB VPB VPWR X
.ends

* Black-box entry subcircuit for sky130_fd_sc_hd__o21ai_2 abstract view
.subckt sky130_fd_sc_hd__o21ai_2 A1 A2 B1 VGND VNB VPB VPWR Y
.ends

* Black-box entry subcircuit for sky130_fd_sc_hd__fill_2 abstract view
.subckt sky130_fd_sc_hd__fill_2 VGND VNB VPB VPWR
.ends

* Black-box entry subcircuit for sky130_fd_sc_hd__and2b_1 abstract view
.subckt sky130_fd_sc_hd__and2b_1 A_N B VGND VNB VPB VPWR X
.ends

* Black-box entry subcircuit for sky130_fd_sc_hd__xnor2_1 abstract view
.subckt sky130_fd_sc_hd__xnor2_1 A B VGND VNB VPB VPWR Y
.ends

* Black-box entry subcircuit for sky130_fd_sc_hd__or3_1 abstract view
.subckt sky130_fd_sc_hd__or3_1 A B C VGND VNB VPB VPWR X
.ends

* Black-box entry subcircuit for sky130_fd_sc_hd__and4_1 abstract view
.subckt sky130_fd_sc_hd__and4_1 A B C D VGND VNB VPB VPWR X
.ends

* Black-box entry subcircuit for sky130_fd_sc_hd__and3_1 abstract view
.subckt sky130_fd_sc_hd__and3_1 A B C VGND VNB VPB VPWR X
.ends

* Black-box entry subcircuit for sky130_fd_sc_hd__nand2b_1 abstract view
.subckt sky130_fd_sc_hd__nand2b_1 A_N B VGND VNB VPB VPWR Y
.ends

* Black-box entry subcircuit for sky130_fd_sc_hd__o21bai_1 abstract view
.subckt sky130_fd_sc_hd__o21bai_1 A1 A2 B1_N VGND VNB VPB VPWR Y
.ends

* Black-box entry subcircuit for sky130_fd_sc_hd__o211a_1 abstract view
.subckt sky130_fd_sc_hd__o211a_1 A1 A2 B1 C1 VGND VNB VPB VPWR X
.ends

* Black-box entry subcircuit for sky130_fd_sc_hd__buf_2 abstract view
.subckt sky130_fd_sc_hd__buf_2 A VGND VNB VPB VPWR X
.ends

* Black-box entry subcircuit for sky130_fd_sc_hd__o211ai_2 abstract view
.subckt sky130_fd_sc_hd__o211ai_2 A1 A2 B1 C1 VGND VNB VPB VPWR Y
.ends

* Black-box entry subcircuit for sky130_fd_sc_hd__a21oi_1 abstract view
.subckt sky130_fd_sc_hd__a21oi_1 A1 A2 B1 VGND VNB VPB VPWR Y
.ends

* Black-box entry subcircuit for sky130_fd_sc_hd__a21bo_1 abstract view
.subckt sky130_fd_sc_hd__a21bo_1 A1 A2 B1_N VGND VNB VPB VPWR X
.ends

* Black-box entry subcircuit for sky130_fd_sc_hd__o21ai_1 abstract view
.subckt sky130_fd_sc_hd__o21ai_1 A1 A2 B1 VGND VNB VPB VPWR Y
.ends

* Black-box entry subcircuit for sky130_fd_sc_hd__a21o_1 abstract view
.subckt sky130_fd_sc_hd__a21o_1 A1 A2 B1 VGND VNB VPB VPWR X
.ends

* Black-box entry subcircuit for sky130_fd_sc_hd__decap_3 abstract view
.subckt sky130_fd_sc_hd__decap_3 VGND VNB VPB VPWR
.ends

* Black-box entry subcircuit for sky130_fd_sc_hd__o311a_1 abstract view
.subckt sky130_fd_sc_hd__o311a_1 A1 A2 A3 B1 C1 VGND VNB VPB VPWR X
.ends

* Black-box entry subcircuit for sky130_fd_sc_hd__a221o_1 abstract view
.subckt sky130_fd_sc_hd__a221o_1 A1 A2 B1 B2 C1 VGND VNB VPB VPWR X
.ends

* Black-box entry subcircuit for sky130_fd_sc_hd__buf_4 abstract view
.subckt sky130_fd_sc_hd__buf_4 A VGND VNB VPB VPWR X
.ends

* Black-box entry subcircuit for sky130_fd_sc_hd__dfstp_1 abstract view
.subckt sky130_fd_sc_hd__dfstp_1 CLK D SET_B VGND VNB VPB VPWR Q
.ends

* Black-box entry subcircuit for sky130_fd_sc_hd__o21a_1 abstract view
.subckt sky130_fd_sc_hd__o21a_1 A1 A2 B1 VGND VNB VPB VPWR X
.ends

* Black-box entry subcircuit for sky130_fd_sc_hd__dfrtp_4 abstract view
.subckt sky130_fd_sc_hd__dfrtp_4 CLK D RESET_B VGND VNB VPB VPWR Q
.ends

* Black-box entry subcircuit for sky130_fd_sc_hd__xor2_1 abstract view
.subckt sky130_fd_sc_hd__xor2_1 A B VGND VNB VPB VPWR X
.ends

* Black-box entry subcircuit for sky130_fd_sc_hd__a31o_1 abstract view
.subckt sky130_fd_sc_hd__a31o_1 A1 A2 A3 B1 VGND VNB VPB VPWR X
.ends

* Black-box entry subcircuit for sky130_fd_sc_hd__or2_4 abstract view
.subckt sky130_fd_sc_hd__or2_4 A B VGND VNB VPB VPWR X
.ends

* Black-box entry subcircuit for sky130_fd_sc_hd__or3b_1 abstract view
.subckt sky130_fd_sc_hd__or3b_1 A B C_N VGND VNB VPB VPWR X
.ends

* Black-box entry subcircuit for sky130_fd_sc_hd__a211o_1 abstract view
.subckt sky130_fd_sc_hd__a211o_1 A1 A2 B1 C1 VGND VNB VPB VPWR X
.ends

* Black-box entry subcircuit for sky130_fd_sc_hd__or2_1 abstract view
.subckt sky130_fd_sc_hd__or2_1 A B VGND VNB VPB VPWR X
.ends

* Black-box entry subcircuit for sky130_fd_sc_hd__dfxtp_1 abstract view
.subckt sky130_fd_sc_hd__dfxtp_1 CLK D VGND VNB VPB VPWR Q
.ends

* Black-box entry subcircuit for sky130_fd_sc_hd__nand4_2 abstract view
.subckt sky130_fd_sc_hd__nand4_2 A B C D VGND VNB VPB VPWR Y
.ends

* Black-box entry subcircuit for sky130_fd_sc_hd__a22oi_1 abstract view
.subckt sky130_fd_sc_hd__a22oi_1 A1 A2 B1 B2 VGND VNB VPB VPWR Y
.ends

* Black-box entry subcircuit for sky130_fd_sc_hd__o22a_1 abstract view
.subckt sky130_fd_sc_hd__o22a_1 A1 A2 B1 B2 VGND VNB VPB VPWR X
.ends

* Black-box entry subcircuit for sky130_fd_sc_hd__a311o_1 abstract view
.subckt sky130_fd_sc_hd__a311o_1 A1 A2 A3 B1 C1 VGND VNB VPB VPWR X
.ends

* Black-box entry subcircuit for sky130_fd_sc_hd__a2bb2o_1 abstract view
.subckt sky130_fd_sc_hd__a2bb2o_1 A1_N A2_N B1 B2 VGND VNB VPB VPWR X
.ends

* Black-box entry subcircuit for sky130_fd_sc_hd__clkbuf_8 abstract view
.subckt sky130_fd_sc_hd__clkbuf_8 A VGND VNB VPB VPWR X
.ends

* Black-box entry subcircuit for sky130_fd_sc_hd__nand3_1 abstract view
.subckt sky130_fd_sc_hd__nand3_1 A B C VGND VNB VPB VPWR Y
.ends

* Black-box entry subcircuit for sky130_fd_sc_hd__clkinvlp_4 abstract view
.subckt sky130_fd_sc_hd__clkinvlp_4 A VGND VNB VPB VPWR Y
.ends

* Black-box entry subcircuit for sky130_fd_sc_hd__o31a_1 abstract view
.subckt sky130_fd_sc_hd__o31a_1 A1 A2 A3 B1 VGND VNB VPB VPWR X
.ends

* Black-box entry subcircuit for sky130_fd_sc_hd__nor3b_1 abstract view
.subckt sky130_fd_sc_hd__nor3b_1 A B C_N VGND VNB VPB VPWR Y
.ends

* Black-box entry subcircuit for sky130_fd_sc_hd__o21ba_1 abstract view
.subckt sky130_fd_sc_hd__o21ba_1 A1 A2 B1_N VGND VNB VPB VPWR X
.ends

* Black-box entry subcircuit for sky130_fd_sc_hd__o2bb2a_1 abstract view
.subckt sky130_fd_sc_hd__o2bb2a_1 A1_N A2_N B1 B2 VGND VNB VPB VPWR X
.ends

* Black-box entry subcircuit for sky130_fd_sc_hd__a211oi_1 abstract view
.subckt sky130_fd_sc_hd__a211oi_1 A1 A2 B1 C1 VGND VNB VPB VPWR Y
.ends

* Black-box entry subcircuit for sky130_fd_sc_hd__nor2_4 abstract view
.subckt sky130_fd_sc_hd__nor2_4 A B VGND VNB VPB VPWR Y
.ends

* Black-box entry subcircuit for sky130_fd_sc_hd__inv_6 abstract view
.subckt sky130_fd_sc_hd__inv_6 A VGND VNB VPB VPWR Y
.ends

* Black-box entry subcircuit for sky130_fd_sc_hd__conb_1 abstract view
.subckt sky130_fd_sc_hd__conb_1 VGND VNB VPB VPWR HI LO
.ends

* Black-box entry subcircuit for sky130_fd_sc_hd__dlymetal6s2s_1 abstract view
.subckt sky130_fd_sc_hd__dlymetal6s2s_1 A VGND VNB VPB VPWR X
.ends

* Black-box entry subcircuit for sky130_fd_sc_hd__o221a_1 abstract view
.subckt sky130_fd_sc_hd__o221a_1 A1 A2 B1 B2 C1 VGND VNB VPB VPWR X
.ends

* Black-box entry subcircuit for sky130_fd_sc_hd__nand4_1 abstract view
.subckt sky130_fd_sc_hd__nand4_1 A B C D VGND VNB VPB VPWR Y
.ends

* Black-box entry subcircuit for sky130_fd_sc_hd__a21boi_1 abstract view
.subckt sky130_fd_sc_hd__a21boi_1 A1 A2 B1_N VGND VNB VPB VPWR Y
.ends

* Black-box entry subcircuit for sky130_fd_sc_hd__clkinv_2 abstract view
.subckt sky130_fd_sc_hd__clkinv_2 A VGND VNB VPB VPWR Y
.ends

* Black-box entry subcircuit for sky130_fd_sc_hd__clkinv_4 abstract view
.subckt sky130_fd_sc_hd__clkinv_4 A VGND VNB VPB VPWR Y
.ends

* Black-box entry subcircuit for sky130_fd_sc_hd__clkbuf_16 abstract view
.subckt sky130_fd_sc_hd__clkbuf_16 A VGND VNB VPB VPWR X
.ends

* Black-box entry subcircuit for sky130_fd_sc_hd__and3b_1 abstract view
.subckt sky130_fd_sc_hd__and3b_1 A_N B C VGND VNB VPB VPWR X
.ends

* Black-box entry subcircuit for sky130_fd_sc_hd__a22oi_2 abstract view
.subckt sky130_fd_sc_hd__a22oi_2 A1 A2 B1 B2 VGND VNB VPB VPWR Y
.ends

* Black-box entry subcircuit for sky130_fd_sc_hd__inv_8 abstract view
.subckt sky130_fd_sc_hd__inv_8 A VGND VNB VPB VPWR Y
.ends

* Black-box entry subcircuit for sky130_fd_sc_hd__bufinv_16 abstract view
.subckt sky130_fd_sc_hd__bufinv_16 A VGND VNB VPB VPWR Y
.ends

* Black-box entry subcircuit for sky130_fd_sc_hd__inv_12 abstract view
.subckt sky130_fd_sc_hd__inv_12 A VGND VNB VPB VPWR Y
.ends

* Black-box entry subcircuit for sky130_fd_sc_hd__or2_2 abstract view
.subckt sky130_fd_sc_hd__or2_2 A B VGND VNB VPB VPWR X
.ends

* Black-box entry subcircuit for sky130_fd_sc_hd__o211ai_1 abstract view
.subckt sky130_fd_sc_hd__o211ai_1 A1 A2 B1 C1 VGND VNB VPB VPWR Y
.ends

* Black-box entry subcircuit for sky130_fd_sc_hd__or4b_1 abstract view
.subckt sky130_fd_sc_hd__or4b_1 A B C D_N VGND VNB VPB VPWR X
.ends

* Black-box entry subcircuit for sky130_fd_sc_hd__and2_2 abstract view
.subckt sky130_fd_sc_hd__and2_2 A B VGND VNB VPB VPWR X
.ends

* Black-box entry subcircuit for sky130_fd_sc_hd__or3_4 abstract view
.subckt sky130_fd_sc_hd__or3_4 A B C VGND VNB VPB VPWR X
.ends

* Black-box entry subcircuit for sky130_fd_sc_hd__xnor2_2 abstract view
.subckt sky130_fd_sc_hd__xnor2_2 A B VGND VNB VPB VPWR Y
.ends

* Black-box entry subcircuit for sky130_fd_sc_hd__a32o_1 abstract view
.subckt sky130_fd_sc_hd__a32o_1 A1 A2 A3 B1 B2 VGND VNB VPB VPWR X
.ends

* Black-box entry subcircuit for sky130_fd_sc_hd__clkinv_8 abstract view
.subckt sky130_fd_sc_hd__clkinv_8 A VGND VNB VPB VPWR Y
.ends

* Black-box entry subcircuit for sky130_fd_sc_hd__buf_1 abstract view
.subckt sky130_fd_sc_hd__buf_1 A VGND VNB VPB VPWR X
.ends

* Black-box entry subcircuit for sky130_fd_sc_hd__xor2_2 abstract view
.subckt sky130_fd_sc_hd__xor2_2 A B VGND VNB VPB VPWR X
.ends

* Black-box entry subcircuit for sky130_fd_sc_hd__and4b_1 abstract view
.subckt sky130_fd_sc_hd__and4b_1 A_N B C D VGND VNB VPB VPWR X
.ends

* Black-box entry subcircuit for sky130_fd_sc_hd__a32oi_2 abstract view
.subckt sky130_fd_sc_hd__a32oi_2 A1 A2 A3 B1 B2 VGND VNB VPB VPWR Y
.ends

* Black-box entry subcircuit for sky130_fd_sc_hd__o21bai_4 abstract view
.subckt sky130_fd_sc_hd__o21bai_4 A1 A2 B1_N VGND VNB VPB VPWR Y
.ends

* Black-box entry subcircuit for sky130_fd_sc_hd__nor3_2 abstract view
.subckt sky130_fd_sc_hd__nor3_2 A B C VGND VNB VPB VPWR Y
.ends

* Black-box entry subcircuit for sky130_fd_sc_hd__a211oi_2 abstract view
.subckt sky130_fd_sc_hd__a211oi_2 A1 A2 B1 C1 VGND VNB VPB VPWR Y
.ends

* Black-box entry subcircuit for sky130_fd_sc_hd__nand3b_1 abstract view
.subckt sky130_fd_sc_hd__nand3b_1 A_N B C VGND VNB VPB VPWR Y
.ends

* Black-box entry subcircuit for sky130_fd_sc_hd__and3b_2 abstract view
.subckt sky130_fd_sc_hd__and3b_2 A_N B C VGND VNB VPB VPWR X
.ends

* Black-box entry subcircuit for sky130_fd_sc_hd__clkbuf_1 abstract view
.subckt sky130_fd_sc_hd__clkbuf_1 A VGND VNB VPB VPWR X
.ends

* Black-box entry subcircuit for sky130_fd_sc_hd__a41o_1 abstract view
.subckt sky130_fd_sc_hd__a41o_1 A1 A2 A3 A4 B1 VGND VNB VPB VPWR X
.ends

* Black-box entry subcircuit for sky130_fd_sc_hd__a31oi_1 abstract view
.subckt sky130_fd_sc_hd__a31oi_1 A1 A2 A3 B1 VGND VNB VPB VPWR Y
.ends

* Black-box entry subcircuit for sky130_fd_sc_hd__a2111o_1 abstract view
.subckt sky130_fd_sc_hd__a2111o_1 A1 A2 B1 C1 D1 VGND VNB VPB VPWR X
.ends

* Black-box entry subcircuit for sky130_fd_sc_hd__and4bb_1 abstract view
.subckt sky130_fd_sc_hd__and4bb_1 A_N B_N C D VGND VNB VPB VPWR X
.ends

* Black-box entry subcircuit for sky130_fd_sc_hd__o32a_1 abstract view
.subckt sky130_fd_sc_hd__o32a_1 A1 A2 A3 B1 B2 VGND VNB VPB VPWR X
.ends

* Black-box entry subcircuit for sky130_fd_sc_hd__or4_1 abstract view
.subckt sky130_fd_sc_hd__or4_1 A B C D VGND VNB VPB VPWR X
.ends

* Black-box entry subcircuit for sky130_fd_sc_hd__dfrtp_2 abstract view
.subckt sky130_fd_sc_hd__dfrtp_2 CLK D RESET_B VGND VNB VPB VPWR Q
.ends

* Black-box entry subcircuit for sky130_fd_sc_hd__a211oi_4 abstract view
.subckt sky130_fd_sc_hd__a211oi_4 A1 A2 B1 C1 VGND VNB VPB VPWR Y
.ends

* Black-box entry subcircuit for sky130_fd_sc_hd__or3_2 abstract view
.subckt sky130_fd_sc_hd__or3_2 A B C VGND VNB VPB VPWR X
.ends

* Black-box entry subcircuit for sky130_fd_sc_hd__nor3_1 abstract view
.subckt sky130_fd_sc_hd__nor3_1 A B C VGND VNB VPB VPWR Y
.ends

* Black-box entry subcircuit for sky130_fd_sc_hd__or3b_2 abstract view
.subckt sky130_fd_sc_hd__or3b_2 A B C_N VGND VNB VPB VPWR X
.ends

* Black-box entry subcircuit for sky130_fd_sc_hd__a32oi_1 abstract view
.subckt sky130_fd_sc_hd__a32oi_1 A1 A2 A3 B1 B2 VGND VNB VPB VPWR Y
.ends

* Black-box entry subcircuit for sky130_fd_sc_hd__nand3_2 abstract view
.subckt sky130_fd_sc_hd__nand3_2 A B C VGND VNB VPB VPWR Y
.ends

.subckt team_02 clk en gpio_in[0] gpio_in[10] gpio_in[11] gpio_in[12] gpio_in[13]
+ gpio_in[14] gpio_in[15] gpio_in[16] gpio_in[17] gpio_in[18] gpio_in[19] gpio_in[1]
+ gpio_in[20] gpio_in[21] gpio_in[22] gpio_in[23] gpio_in[24] gpio_in[25] gpio_in[26]
+ gpio_in[27] gpio_in[28] gpio_in[29] gpio_in[2] gpio_in[30] gpio_in[31] gpio_in[32]
+ gpio_in[33] gpio_in[3] gpio_in[4] gpio_in[5] gpio_in[6] gpio_in[7] gpio_in[8] gpio_in[9]
+ gpio_oeb[0] gpio_oeb[10] gpio_oeb[11] gpio_oeb[12] gpio_oeb[13] gpio_oeb[14] gpio_oeb[15]
+ gpio_oeb[16] gpio_oeb[17] gpio_oeb[18] gpio_oeb[19] gpio_oeb[1] gpio_oeb[20] gpio_oeb[21]
+ gpio_oeb[22] gpio_oeb[23] gpio_oeb[24] gpio_oeb[25] gpio_oeb[26] gpio_oeb[27] gpio_oeb[28]
+ gpio_oeb[29] gpio_oeb[2] gpio_oeb[30] gpio_oeb[31] gpio_oeb[32] gpio_oeb[33] gpio_oeb[3]
+ gpio_oeb[4] gpio_oeb[5] gpio_oeb[6] gpio_oeb[7] gpio_oeb[8] gpio_oeb[9] gpio_out[0]
+ gpio_out[10] gpio_out[11] gpio_out[12] gpio_out[13] gpio_out[14] gpio_out[15] gpio_out[16]
+ gpio_out[17] gpio_out[18] gpio_out[19] gpio_out[1] gpio_out[20] gpio_out[21] gpio_out[22]
+ gpio_out[23] gpio_out[24] gpio_out[25] gpio_out[26] gpio_out[27] gpio_out[28] gpio_out[29]
+ gpio_out[2] gpio_out[30] gpio_out[31] gpio_out[32] gpio_out[33] gpio_out[3] gpio_out[4]
+ gpio_out[5] gpio_out[6] gpio_out[7] gpio_out[8] gpio_out[9] nrst vccd1 vssd1
XFILLER_79_391 vssd1 vssd1 vccd1 vccd1 sky130_fd_sc_hd__fill_1
XANTENNA__2439__B net172 vssd1 vssd1 vccd1 vccd1 sky130_fd_sc_hd__diode_2
X_3155_ clknet_leaf_23_clk _0113_ net115 vssd1 vssd1 vccd1 vccd1 MATMULT_INST.matmult_inst.mem_inst.mem3\[16\]
+ sky130_fd_sc_hd__dfrtp_1
X_2106_ _0636_ _0657_ vssd1 vssd1 vccd1 vccd1 _0658_ sky130_fd_sc_hd__nor2_1
X_3086_ clknet_leaf_8_clk _0044_ net110 vssd1 vssd1 vccd1 vccd1 MATMULT_INST.matmult_inst.mem_inst.matrixB0\[1\]
+ sky130_fd_sc_hd__dfrtp_1
XTAP_TAPCELL_ROW_65_721 vssd1 vccd1 sky130_fd_sc_hd__tapvpwrvgnd_1
X_2037_ net209 net396 net56 vssd1 vssd1 vccd1 vccd1 _0278_ sky130_fd_sc_hd__mux2_1
XFILLER_54_247 vssd1 vssd1 vccd1 vccd1 sky130_fd_sc_hd__fill_1
XFILLER_22_100 vssd1 vssd1 vccd1 vccd1 sky130_fd_sc_hd__fill_4
XTAP_TAPCELL_ROW_37_489 vssd1 vccd1 sky130_fd_sc_hd__tapvpwrvgnd_1
XANTENNA_fanout162_A net164 vssd1 vssd1 vccd1 vccd1 sky130_fd_sc_hd__diode_2
XFILLER_22_122 vssd1 vssd1 vccd1 vccd1 sky130_fd_sc_hd__fill_8
X_2939_ MATMULT_INST.matmult_inst.fsm_inst.rx_data\[0\] net326 MATMULT_INST.matmult_inst.spi_inst.rx_done_sys
+ vssd1 vssd1 vccd1 vccd1 _0426_ sky130_fd_sc_hd__mux2_1
XTAP_TAPCELL_ROW_20_345 vssd1 vccd1 sky130_fd_sc_hd__tapvpwrvgnd_1
XANTENNA__2954__A1 _1032_ vssd1 vssd1 vccd1 vccd1 sky130_fd_sc_hd__diode_2
XANTENNA__3436__D net58 vssd1 vssd1 vccd1 vccd1 sky130_fd_sc_hd__diode_2
Xhold340 MATMULT_INST.matmult_inst.mem_inst.matrixA1\[12\] vssd1 vssd1 vccd1 vccd1
+ net653 sky130_fd_sc_hd__dlygate4sd3_1
Xhold351 MATMULT_INST.matmult_inst.alu_inst.adder_inst.fa.b vssd1 vssd1 vccd1 vccd1
+ net664 sky130_fd_sc_hd__dlygate4sd3_1
XTAP_TAPCELL_ROW_28_412 vssd1 vccd1 sky130_fd_sc_hd__tapvpwrvgnd_1
XANTENNA__1693__B2 MATMULT_INST.matmult_inst.fsm_inst.alu_result\[7\] vssd1 vssd1
+ vccd1 vccd1 sky130_fd_sc_hd__diode_2
XFILLER_45_269 vssd1 vssd1 vccd1 vccd1 sky130_fd_sc_hd__fill_1
XANTENNA_fanout30_X net30 vssd1 vssd1 vccd1 vccd1 sky130_fd_sc_hd__diode_2
XTAP_TAPCELL_ROW_71_779 vssd1 vccd1 sky130_fd_sc_hd__tapvpwrvgnd_1
XFILLER_9_137 vccd1 vssd1 vccd1 vssd1 sky130_ef_sc_hd__decap_40_12
XFILLER_42_62 vssd1 vssd1 vccd1 vccd1 sky130_fd_sc_hd__fill_4
XANTENNA__2250__D net235 vssd1 vssd1 vccd1 vccd1 sky130_fd_sc_hd__diode_2
XTAP_TAPCELL_ROW_79_846 vssd1 vccd1 sky130_fd_sc_hd__tapvpwrvgnd_1
XTAP_TAPCELL_ROW_62_702 vssd1 vccd1 sky130_fd_sc_hd__tapvpwrvgnd_1
XTAP_TAPCELL_ROW_34_459 vssd1 vccd1 sky130_fd_sc_hd__tapvpwrvgnd_1
X_2724_ _1192_ _1195_ vssd1 vssd1 vccd1 vccd1 _1196_ sky130_fd_sc_hd__nand2_1
X_2655_ net659 _1128_ net72 vssd1 vssd1 vccd1 vccd1 _0375_ sky130_fd_sc_hd__mux2_1
X_1606_ _1497_ _1509_ vssd1 vssd1 vccd1 vccd1 _1524_ sky130_fd_sc_hd__nor2_2
X_2586_ _1065_ net172 _1055_ vssd1 vssd1 vccd1 vccd1 _0369_ sky130_fd_sc_hd__mux2_1
Xfanout138 net141 vssd1 vssd1 vccd1 vccd1 net138 sky130_fd_sc_hd__clkbuf_4
Xfanout116 net123 vssd1 vssd1 vccd1 vccd1 net116 sky130_fd_sc_hd__clkbuf_2
Xfanout127 net132 vssd1 vssd1 vccd1 vccd1 net127 sky130_fd_sc_hd__clkbuf_2
Xfanout105 net114 vssd1 vssd1 vccd1 vccd1 net105 sky130_fd_sc_hd__clkbuf_2
Xfanout149 net150 vssd1 vssd1 vccd1 vccd1 net149 sky130_fd_sc_hd__clkbuf_4
X_3207_ clknet_leaf_24_clk _0165_ net116 vssd1 vssd1 vccd1 vccd1 MATMULT_INST.matmult_inst.mem_inst.matrixA3\[14\]
+ sky130_fd_sc_hd__dfrtp_1
X_3138_ clknet_leaf_20_clk _0096_ net126 vssd1 vssd1 vccd1 vccd1 MATMULT_INST.matmult_inst.mem_inst.matrixA2\[17\]
+ sky130_fd_sc_hd__dfrtp_1
X_3069_ net245 vssd1 vssd1 vccd1 vccd1 _0027_ sky130_fd_sc_hd__inv_2
XANTENNA_fanout165_X net165 vssd1 vssd1 vccd1 vccd1 sky130_fd_sc_hd__diode_2
XFILLER_12_43 vssd1 vssd1 vccd1 vccd1 sky130_fd_sc_hd__fill_8
XANTENNA__2070__D net238 vssd1 vssd1 vccd1 vccd1 sky130_fd_sc_hd__diode_2
XFILLER_2_357 vssd1 vssd1 vccd1 vccd1 sky130_fd_sc_hd__fill_4
Xhold170 MATMULT_INST.matmult_inst.mem_inst.matrixB2\[12\] vssd1 vssd1 vccd1 vccd1
+ net483 sky130_fd_sc_hd__dlygate4sd3_1
Xhold192 MATMULT_INST.matmult_inst.mem_inst.matrixA1\[17\] vssd1 vssd1 vccd1 vccd1
+ net505 sky130_fd_sc_hd__dlygate4sd3_1
Xhold181 MATMULT_INST.matmult_inst.mem_inst.mem2\[11\] vssd1 vssd1 vccd1 vccd1 net494
+ sky130_fd_sc_hd__dlygate4sd3_1
XANTENNA_fanout78_X net78 vssd1 vssd1 vccd1 vccd1 sky130_fd_sc_hd__diode_2
XTAP_TAPCELL_ROW_76_816 vssd1 vccd1 sky130_fd_sc_hd__tapvpwrvgnd_1
XANTENNA__1711__B net60 vssd1 vssd1 vccd1 vccd1 sky130_fd_sc_hd__diode_2
XANTENNA__2823__A net184 vssd1 vssd1 vccd1 vccd1 sky130_fd_sc_hd__diode_2
XANTENNA__1873__S net12 vssd1 vssd1 vccd1 vccd1 sky130_fd_sc_hd__diode_2
X_2440_ MATMULT_INST.matmult_inst.mem_inst.mem2\[1\] net91 net82 MATMULT_INST.matmult_inst.mem_inst.mem1\[1\]
+ vssd1 vssd1 vccd1 vccd1 _0956_ sky130_fd_sc_hd__a22o_1
X_2371_ MATMULT_INST.matmult_inst.alu_inst.adder_inst.r3.fa2.a net67 vssd1 vssd1 vccd1
+ vccd1 _0914_ sky130_fd_sc_hd__and2_1
XTAP_TAPCELL_ROW_39_507 vssd1 vccd1 sky130_fd_sc_hd__tapvpwrvgnd_1
XFILLER_24_217 vccd1 vssd1 vccd1 vssd1 sky130_ef_sc_hd__decap_40_12
XTAP_TAPCELL_ROW_47_573 vssd1 vccd1 sky130_fd_sc_hd__tapvpwrvgnd_1
XANTENNA__2909__A1 net201 vssd1 vssd1 vccd1 vccd1 sky130_fd_sc_hd__diode_2
XANTENNA_fanout125_A net132 vssd1 vssd1 vccd1 vccd1 sky130_fd_sc_hd__diode_2
X_2707_ _1109_ _1140_ vssd1 vssd1 vccd1 vccd1 _1179_ sky130_fd_sc_hd__nand2_1
XANTENNA__1783__S net31 vssd1 vssd1 vccd1 vccd1 sky130_fd_sc_hd__diode_2
X_2638_ _1096_ _1097_ _1098_ vssd1 vssd1 vccd1 vccd1 _1112_ sky130_fd_sc_hd__o21ai_2
X_2569_ _1000_ net507 _1053_ vssd1 vssd1 vccd1 vccd1 _0364_ sky130_fd_sc_hd__mux2_1
XFILLER_58_39 vssd1 vssd1 vccd1 vccd1 sky130_fd_sc_hd__fill_2
XFILLER_59_147 vssd1 vssd1 vccd1 vccd1 sky130_fd_sc_hd__fill_4
XFILLER_59_169 vssd1 vssd1 vccd1 vccd1 sky130_fd_sc_hd__fill_4
XFILLER_74_27 vssd1 vssd1 vccd1 vccd1 sky130_fd_sc_hd__fill_1
XANTENNA__2845__B1 net204 vssd1 vssd1 vccd1 vccd1 sky130_fd_sc_hd__diode_2
XFILLER_15_217 vssd1 vssd1 vccd1 vccd1 sky130_fd_sc_hd__fill_4
XTAP_TAPCELL_ROW_2_187 vssd1 vccd1 sky130_fd_sc_hd__tapvpwrvgnd_1
XFILLER_11_445 vssd1 vssd1 vccd1 vccd1 sky130_fd_sc_hd__fill_2
XFILLER_7_405 vccd1 vssd1 vccd1 vssd1 sky130_ef_sc_hd__decap_40_12
XFILLER_7_449 vccd1 vssd1 vccd1 vssd1 sky130_ef_sc_hd__decap_40_12
XFILLER_2_121 vccd1 vssd1 vccd1 vssd1 sky130_ef_sc_hd__decap_40_12
XFILLER_2_165 vccd1 vssd1 vccd1 vssd1 sky130_ef_sc_hd__decap_40_12
XFILLER_78_489 vssd1 vssd1 vccd1 vccd1 sky130_fd_sc_hd__fill_4
XFILLER_0_57 vccd1 vssd1 vccd1 vssd1 sky130_ef_sc_hd__decap_40_12
XFILLER_0_79 vssd1 vssd1 vccd1 vccd1 sky130_fd_sc_hd__fill_1
XANTENNA__1868__S net12 vssd1 vssd1 vccd1 vccd1 sky130_fd_sc_hd__diode_2
XTAP_TAPCELL_ROW_44_543 vssd1 vccd1 sky130_fd_sc_hd__tapvpwrvgnd_1
X_1940_ _0527_ _0528_ vssd1 vssd1 vccd1 vccd1 _0529_ sky130_fd_sc_hd__and2b_1
X_1871_ net587 net45 net12 vssd1 vssd1 vccd1 vccd1 _0202_ sky130_fd_sc_hd__mux2_1
XFILLER_9_55 vssd1 vssd1 vccd1 vccd1 sky130_fd_sc_hd__fill_1
XFILLER_6_493 vssd1 vssd1 vccd1 vccd1 sky130_fd_sc_hd__fill_1
X_3472_ clknet_leaf_17_clk _0416_ net130 vssd1 vssd1 vccd1 vccd1 MATMULT_INST.matmult_inst.mem_inst.matrixB3\[8\]
+ sky130_fd_sc_hd__dfrtp_1
XFILLER_50_3 vssd1 vssd1 vccd1 vccd1 sky130_fd_sc_hd__fill_8
X_2423_ _0940_ MATMULT_INST.matmult_inst.fsm_inst.state\[4\] _0930_ vssd1 vssd1 vccd1
+ vccd1 _0331_ sky130_fd_sc_hd__mux2_1
X_2354_ _0879_ _0897_ vssd1 vssd1 vccd1 vccd1 _0899_ sky130_fd_sc_hd__xnor2_1
X_2285_ _0829_ _0830_ _0831_ vssd1 vssd1 vccd1 vccd1 _0832_ sky130_fd_sc_hd__or3_1
XFILLER_64_150 vssd1 vssd1 vccd1 vccd1 sky130_fd_sc_hd__fill_1
XFILLER_64_161 vssd1 vssd1 vccd1 vccd1 sky130_fd_sc_hd__fill_1
XFILLER_12_209 vccd1 vssd1 vccd1 vssd1 sky130_ef_sc_hd__decap_40_12
XANTENNA_fanout242_A net2 vssd1 vssd1 vccd1 vccd1 sky130_fd_sc_hd__diode_2
XANTENNA__2055__A1 net240 vssd1 vssd1 vccd1 vccd1 sky130_fd_sc_hd__diode_2
XANTENNA__3004__B1 net77 vssd1 vssd1 vccd1 vccd1 sky130_fd_sc_hd__diode_2
XANTENNA__3493__CLK net246 vssd1 vssd1 vccd1 vccd1 sky130_fd_sc_hd__diode_2
XFILLER_4_419 vssd1 vssd1 vccd1 vccd1 sky130_fd_sc_hd__fill_1
XTAP_TAPCELL_ROW_7_235 vssd1 vccd1 sky130_fd_sc_hd__tapvpwrvgnd_1
XANTENNA_input2_X net2 vssd1 vssd1 vccd1 vccd1 sky130_fd_sc_hd__diode_2
XFILLER_18_20 vssd1 vssd1 vccd1 vccd1 sky130_fd_sc_hd__fill_1
XTAP_TAPCELL_ROW_58_668 vssd1 vccd1 sky130_fd_sc_hd__tapvpwrvgnd_1
XFILLER_70_131 vssd1 vssd1 vccd1 vccd1 sky130_fd_sc_hd__fill_2
XANTENNA__1688__S net25 vssd1 vssd1 vccd1 vccd1 sky130_fd_sc_hd__diode_2
XANTENNA__2373__A net228 vssd1 vssd1 vccd1 vccd1 sky130_fd_sc_hd__diode_2
XFILLER_34_41 vssd1 vssd1 vccd1 vccd1 sky130_fd_sc_hd__fill_4
XTAP_TAPCELL_ROW_41_524 vssd1 vccd1 sky130_fd_sc_hd__tapvpwrvgnd_1
XFILLER_70_197 vssd1 vssd1 vccd1 vccd1 sky130_fd_sc_hd__fill_1
XFILLER_34_96 vssd1 vssd1 vccd1 vccd1 sky130_fd_sc_hd__fill_1
XFILLER_7_279 vssd1 vssd1 vccd1 vccd1 sky130_fd_sc_hd__fill_1
XANTENNA__1717__A _0480_ vssd1 vssd1 vccd1 vccd1 sky130_fd_sc_hd__diode_2
XFILLER_3_441 vssd1 vssd1 vccd1 vccd1 sky130_fd_sc_hd__fill_4
XFILLER_3_485 vssd1 vssd1 vccd1 vccd1 sky130_fd_sc_hd__fill_8
XFILLER_15_6 vccd1 vssd1 vccd1 vssd1 sky130_ef_sc_hd__decap_40_12
X_2070_ net226 net223 net235 net238 vssd1 vssd1 vccd1 vccd1 _0624_ sky130_fd_sc_hd__and4_1
X_2972_ net177 net168 MATMULT_INST.matmult_inst.mem_inst.matrixA3\[9\] vssd1 vssd1
+ vccd1 vccd1 _1398_ sky130_fd_sc_hd__and3_1
X_1923_ net224 net557 net53 vssd1 vssd1 vccd1 vccd1 _0251_ sky130_fd_sc_hd__mux2_1
XANTENNA__2588__A2 net68 vssd1 vssd1 vccd1 vccd1 sky130_fd_sc_hd__diode_2
XTAP_TAPCELL_ROW_12_270 vssd1 vccd1 sky130_fd_sc_hd__tapvpwrvgnd_1
X_1854_ net467 net43 net28 vssd1 vssd1 vccd1 vccd1 _0186_ sky130_fd_sc_hd__mux2_1
X_1785_ net436 net34 net31 vssd1 vssd1 vccd1 vccd1 _0120_ sky130_fd_sc_hd__mux2_1
X_3524_ clknet_leaf_19_clk _0449_ net125 vssd1 vssd1 vccd1 vccd1 MATMULT_INST.matmult_inst.spi_inst.tx_reg_sys\[15\]
+ sky130_fd_sc_hd__dfrtp_1
X_3455_ clknet_leaf_10_clk _0400_ net137 vssd1 vssd1 vccd1 vccd1 MATMULT_INST.matmult_inst.fsm_inst.rx_valid
+ sky130_fd_sc_hd__dfrtp_1
X_2406_ _1499_ net66 vssd1 vssd1 vccd1 vccd1 _0928_ sky130_fd_sc_hd__nand2_1
XTAP_TAPCELL_ROW_4_205 vssd1 vccd1 sky130_fd_sc_hd__tapvpwrvgnd_1
X_3386_ clknet_leaf_0_clk _0340_ net94 vssd1 vssd1 vccd1 vccd1 MATMULT_INST.matmult_inst.alu_inst.col0\[0\]
+ sky130_fd_sc_hd__dfrtp_1
XANTENNA__3053__S net57 vssd1 vssd1 vccd1 vccd1 sky130_fd_sc_hd__diode_2
X_2337_ _0881_ _0854_ vssd1 vssd1 vccd1 vccd1 _0882_ sky130_fd_sc_hd__nand2b_1
XANTENNA__2458__A net181 vssd1 vssd1 vccd1 vccd1 sky130_fd_sc_hd__diode_2
XANTENNA__2512__A2 _0954_ vssd1 vssd1 vccd1 vccd1 sky130_fd_sc_hd__diode_2
X_2268_ _0759_ _0775_ _0758_ vssd1 vssd1 vccd1 vccd1 _0816_ sky130_fd_sc_hd__o21bai_1
X_2199_ net339 _0748_ net70 vssd1 vssd1 vccd1 vccd1 _0299_ sky130_fd_sc_hd__mux2_1
XTAP_TAPCELL_ROW_55_638 vssd1 vccd1 sky130_fd_sc_hd__tapvpwrvgnd_1
XFILLER_52_186 vssd1 vssd1 vccd1 vccd1 sky130_fd_sc_hd__fill_8
XFILLER_4_249 vssd1 vssd1 vccd1 vccd1 sky130_fd_sc_hd__fill_2
XFILLER_20_98 vssd1 vssd1 vccd1 vccd1 sky130_fd_sc_hd__fill_4
XFILLER_0_433 vssd1 vssd1 vccd1 vccd1 sky130_fd_sc_hd__fill_4
XFILLER_0_477 vssd1 vssd1 vccd1 vccd1 sky130_fd_sc_hd__fill_8
XFILLER_29_41 vssd1 vssd1 vccd1 vccd1 sky130_fd_sc_hd__fill_8
Xhold30 MATMULT_INST.matmult_inst.mem_inst.matrixA3\[1\] vssd1 vssd1 vccd1 vccd1 net343
+ sky130_fd_sc_hd__dlygate4sd3_1
Xhold41 MATMULT_INST.matmult_inst.spi_inst.tx_reg_sys\[0\] vssd1 vssd1 vccd1 vccd1
+ net354 sky130_fd_sc_hd__dlygate4sd3_1
XANTENNA__2087__B net218 vssd1 vssd1 vccd1 vccd1 sky130_fd_sc_hd__diode_2
Xhold63 MATMULT_INST.matmult_inst.mem_inst.matrixB3\[12\] vssd1 vssd1 vccd1 vccd1
+ net376 sky130_fd_sc_hd__dlygate4sd3_1
Xhold52 MATMULT_INST.matmult_inst.mem_inst.mem3\[14\] vssd1 vssd1 vccd1 vccd1 net365
+ sky130_fd_sc_hd__dlygate4sd3_1
XANTENNA_fanout60_X net60 vssd1 vssd1 vccd1 vccd1 sky130_fd_sc_hd__diode_2
Xhold74 MATMULT_INST.matmult_inst.alu_inst.out\[1\] vssd1 vssd1 vccd1 vccd1 net387
+ sky130_fd_sc_hd__dlygate4sd3_1
Xhold96 MATMULT_INST.matmult_inst.spi_inst.tx_reg_sys\[6\] vssd1 vssd1 vccd1 vccd1
+ net409 sky130_fd_sc_hd__dlygate4sd3_1
Xhold85 MATMULT_INST.matmult_inst.mem_inst.matrixA2\[2\] vssd1 vssd1 vccd1 vccd1 net398
+ sky130_fd_sc_hd__dlygate4sd3_1
XTAP_TAPCELL_ROW_18_329 vssd1 vccd1 sky130_fd_sc_hd__tapvpwrvgnd_1
XFILLER_16_367 vssd1 vssd1 vccd1 vccd1 sky130_fd_sc_hd__fill_1
XTAP_TAPCELL_ROW_26_395 vssd1 vccd1 sky130_fd_sc_hd__tapvpwrvgnd_1
XANTENNA__2990__A2 net87 vssd1 vssd1 vccd1 vccd1 sky130_fd_sc_hd__diode_2
X_1570_ MATMULT_INST.matmult_inst.spi_inst.rx_bit_count\[3\] _1487_ _1492_ net3 vssd1
+ vssd1 vccd1 vccd1 _0389_ sky130_fd_sc_hd__o211a_1
XANTENNA__2042__S net55 vssd1 vssd1 vccd1 vccd1 sky130_fd_sc_hd__diode_2
XANTENNA__1881__S net11 vssd1 vssd1 vccd1 vccd1 sky130_fd_sc_hd__diode_2
XFILLER_3_293 vccd1 vssd1 vccd1 vssd1 sky130_ef_sc_hd__decap_40_12
X_3240_ clknet_leaf_18_clk _0198_ net130 vssd1 vssd1 vccd1 vccd1 MATMULT_INST.matmult_inst.mem_inst.matrixB2\[11\]
+ sky130_fd_sc_hd__dfrtp_1
X_3171_ clknet_leaf_26_clk _0129_ net98 vssd1 vssd1 vccd1 vccd1 MATMULT_INST.matmult_inst.mem_inst.matrixB1\[14\]
+ sky130_fd_sc_hd__dfrtp_1
XFILLER_13_3 vccd1 vssd1 vccd1 vssd1 sky130_ef_sc_hd__decap_40_12
X_2122_ _0670_ _0671_ vssd1 vssd1 vccd1 vccd1 _0674_ sky130_fd_sc_hd__nand2_1
X_2053_ net226 MATMULT_INST.matmult_inst.alu_inst.b0_reg\[0\] net70 vssd1 vssd1 vccd1
+ vccd1 _0610_ sky130_fd_sc_hd__and3_1
XFILLER_22_348 vssd1 vssd1 vccd1 vccd1 sky130_fd_sc_hd__fill_1
X_2955_ net156 MATMULT_INST.matmult_inst.mem_inst.mem0\[8\] MATMULT_INST.matmult_inst.mem_inst.matrixB0\[8\]
+ net161 vssd1 vssd1 vccd1 vccd1 _1382_ sky130_fd_sc_hd__a22o_1
X_1906_ net653 net48 net26 vssd1 vssd1 vccd1 vccd1 _0235_ sky130_fd_sc_hd__mux2_1
X_2886_ _1349_ _1351_ vssd1 vssd1 vccd1 vccd1 _1353_ sky130_fd_sc_hd__nand2_1
XTAP_TAPCELL_ROW_60_685 vssd1 vccd1 sky130_fd_sc_hd__tapvpwrvgnd_1
X_1837_ net445 net39 net29 vssd1 vssd1 vccd1 vccd1 _0169_ sky130_fd_sc_hd__mux2_1
X_3507_ net242 _0012_ net125 vssd1 vssd1 vccd1 vccd1 MATMULT_INST.matmult_inst.spi_inst.miso_shifter\[15\]
+ sky130_fd_sc_hd__dfrtp_1
X_1768_ net627 net52 net18 vssd1 vssd1 vccd1 vccd1 _0105_ sky130_fd_sc_hd__mux2_1
XANTENNA__1791__S net30 vssd1 vssd1 vccd1 vccd1 sky130_fd_sc_hd__diode_2
X_1699_ MATMULT_INST.matmult_inst.fsm_inst.alu_result\[10\] net60 vssd1 vssd1 vccd1
+ vccd1 _0495_ sky130_fd_sc_hd__and2_1
X_3438_ clknet_leaf_9_clk _0001_ net113 vssd1 vssd1 vccd1 vccd1 MATMULT_INST.matmult_inst.fsm_inst.sel\[1\]
+ sky130_fd_sc_hd__dfrtp_1
X_3369_ clknet_leaf_25_clk net643 net101 vssd1 vssd1 vccd1 vccd1 MATMULT_INST.matmult_inst.fsm_inst.alu_result\[15\]
+ sky130_fd_sc_hd__dfrtp_1
XANTENNA__2497__A1 net163 vssd1 vssd1 vccd1 vccd1 sky130_fd_sc_hd__diode_2
XANTENNA__2497__B2 net158 vssd1 vssd1 vccd1 vccd1 sky130_fd_sc_hd__diode_2
XTAP_TAPCELL_ROW_68_752 vssd1 vccd1 sky130_fd_sc_hd__tapvpwrvgnd_1
XFILLER_40_101 vssd1 vssd1 vccd1 vccd1 sky130_fd_sc_hd__fill_2
XFILLER_13_337 vccd1 vssd1 vccd1 vssd1 sky130_ef_sc_hd__decap_40_12
XTAP_TAPCELL_ROW_23_365 vssd1 vccd1 sky130_fd_sc_hd__tapvpwrvgnd_1
XANTENNA_fanout20_A _0508_ vssd1 vssd1 vccd1 vccd1 sky130_fd_sc_hd__diode_2
XFILLER_31_53 vssd1 vssd1 vccd1 vccd1 sky130_fd_sc_hd__fill_2
Xoutput7 net7 vssd1 vssd1 vccd1 vccd1 gpio_out[4] sky130_fd_sc_hd__buf_2
XANTENNA__2488__B2 net66 vssd1 vssd1 vccd1 vccd1 sky130_fd_sc_hd__diode_2
XFILLER_56_72 vssd1 vssd1 vccd1 vccd1 sky130_fd_sc_hd__fill_1
XTAP_TAPCELL_ROW_74_799 vssd1 vccd1 sky130_fd_sc_hd__tapvpwrvgnd_1
XFILLER_16_197 vccd1 vssd1 vccd1 vssd1 sky130_ef_sc_hd__decap_40_12
XFILLER_72_82 vssd1 vssd1 vccd1 vccd1 sky130_fd_sc_hd__fill_2
XFILLER_31_167 vssd1 vssd1 vccd1 vccd1 sky130_fd_sc_hd__fill_1
XANTENNA__1876__S net11 vssd1 vssd1 vccd1 vccd1 sky130_fd_sc_hd__diode_2
X_2740_ _1189_ _1198_ _1210_ _1190_ vssd1 vssd1 vccd1 vccd1 _1211_ sky130_fd_sc_hd__o211ai_2
X_2671_ _1141_ _1142_ _1133_ vssd1 vssd1 vccd1 vccd1 _1144_ sky130_fd_sc_hd__a21oi_1
XFILLER_8_363 vssd1 vssd1 vccd1 vccd1 sky130_fd_sc_hd__fill_1
X_1622_ _1526_ _1536_ _0455_ vssd1 vssd1 vccd1 vccd1 _0456_ sky130_fd_sc_hd__a21bo_1
X_1553_ MATMULT_INST.matmult_inst.spi_inst.mosi_shifter\[2\] MATMULT_INST.matmult_inst.spi_inst.mosi_shifter\[1\]
+ _1488_ vssd1 vssd1 vccd1 vccd1 _0403_ sky130_fd_sc_hd__mux2_1
X_3223_ clknet_leaf_27_clk _0181_ net97 vssd1 vssd1 vccd1 vccd1 MATMULT_INST.matmult_inst.mem_inst.mem1\[12\]
+ sky130_fd_sc_hd__dfrtp_1
XANTENNA__2479__A1 net157 vssd1 vssd1 vccd1 vccd1 sky130_fd_sc_hd__diode_2
XANTENNA__2479__B2 net162 vssd1 vssd1 vccd1 vccd1 sky130_fd_sc_hd__diode_2
X_3154_ clknet_leaf_20_clk _0112_ net124 vssd1 vssd1 vccd1 vccd1 MATMULT_INST.matmult_inst.mem_inst.mem3\[15\]
+ sky130_fd_sc_hd__dfrtp_1
X_2105_ _0655_ _0656_ vssd1 vssd1 vccd1 vccd1 _0657_ sky130_fd_sc_hd__xnor2_1
XTAP_TAPCELL_ROW_65_722 vssd1 vccd1 sky130_fd_sc_hd__tapvpwrvgnd_1
X_3085_ clknet_leaf_11_clk _0043_ net146 vssd1 vssd1 vccd1 vccd1 MATMULT_INST.matmult_inst.mem_inst.matrixB0\[0\]
+ sky130_fd_sc_hd__dfrtp_1
X_2036_ net211 net559 net55 vssd1 vssd1 vccd1 vccd1 _0277_ sky130_fd_sc_hd__mux2_1
XANTENNA_fanout155_A net156 vssd1 vssd1 vccd1 vccd1 sky130_fd_sc_hd__diode_2
XANTENNA__1786__S net31 vssd1 vssd1 vccd1 vccd1 sky130_fd_sc_hd__diode_2
XFILLER_10_307 vssd1 vssd1 vccd1 vccd1 sky130_fd_sc_hd__fill_1
X_2938_ net430 net43 net8 vssd1 vssd1 vccd1 vccd1 _0425_ sky130_fd_sc_hd__mux2_1
XTAP_TAPCELL_ROW_20_346 vssd1 vccd1 sky130_fd_sc_hd__tapvpwrvgnd_1
X_2869_ net380 _1336_ net70 vssd1 vssd1 vccd1 vccd1 _0381_ sky130_fd_sc_hd__mux2_1
XANTENNA__2167__B1 net238 vssd1 vssd1 vccd1 vccd1 sky130_fd_sc_hd__diode_2
Xhold341 MATMULT_INST.matmult_inst.mem_inst.matrixB2\[8\] vssd1 vssd1 vccd1 vccd1
+ net654 sky130_fd_sc_hd__dlygate4sd3_1
Xhold330 _0324_ vssd1 vssd1 vccd1 vccd1 net643 sky130_fd_sc_hd__dlygate4sd3_1
Xhold352 MATMULT_INST.matmult_inst.alu_inst.adder_inst.r0.fa1.b vssd1 vssd1 vccd1
+ vccd1 net665 sky130_fd_sc_hd__dlygate4sd3_1
XTAP_TAPCELL_ROW_28_413 vssd1 vccd1 sky130_fd_sc_hd__tapvpwrvgnd_1
XANTENNA__1693__A2 _0467_ vssd1 vssd1 vccd1 vccd1 sky130_fd_sc_hd__diode_2
XFILLER_26_64 vssd1 vssd1 vccd1 vccd1 sky130_fd_sc_hd__fill_1
XFILLER_13_167 vssd1 vssd1 vccd1 vccd1 sky130_fd_sc_hd__fill_1
XFILLER_9_105 vssd1 vssd1 vccd1 vccd1 sky130_fd_sc_hd__fill_4
XANTENNA__1696__S net24 vssd1 vssd1 vccd1 vccd1 sky130_fd_sc_hd__diode_2
XANTENNA_fanout23_X net23 vssd1 vssd1 vccd1 vccd1 sky130_fd_sc_hd__diode_2
XFILLER_9_149 vccd1 vssd1 vccd1 vssd1 sky130_ef_sc_hd__decap_40_12
XANTENNA__1709__B net60 vssd1 vssd1 vccd1 vccd1 sky130_fd_sc_hd__diode_2
XANTENNA_clkbuf_leaf_5_clk_A clknet_2_1__leaf_clk vssd1 vssd1 vccd1 vccd1 sky130_fd_sc_hd__diode_2
XFILLER_5_333 vssd1 vssd1 vccd1 vccd1 sky130_fd_sc_hd__fill_2
XTAP_TAPCELL_ROW_79_847 vssd1 vccd1 sky130_fd_sc_hd__tapvpwrvgnd_1
XFILLER_3_57 vccd1 vssd1 vccd1 vssd1 sky130_ef_sc_hd__decap_40_12
XTAP_TAPCELL_ROW_62_703 vssd1 vccd1 sky130_fd_sc_hd__tapvpwrvgnd_1
X_2723_ net186 _1194_ _1193_ vssd1 vssd1 vccd1 vccd1 _1195_ sky130_fd_sc_hd__a21bo_1
XFILLER_8_193 vssd1 vssd1 vccd1 vccd1 sky130_fd_sc_hd__fill_2
X_2654_ _1126_ _1127_ vssd1 vssd1 vccd1 vccd1 _1128_ sky130_fd_sc_hd__xnor2_1
X_2585_ _1061_ _1063_ _1064_ vssd1 vssd1 vccd1 vccd1 _1065_ sky130_fd_sc_hd__or3_1
X_1605_ _1497_ net76 vssd1 vssd1 vccd1 vccd1 _1523_ sky130_fd_sc_hd__nand2_1
Xfanout106 net107 vssd1 vssd1 vccd1 vccd1 net106 sky130_fd_sc_hd__clkbuf_4
Xfanout117 net123 vssd1 vssd1 vccd1 vccd1 net117 sky130_fd_sc_hd__clkbuf_4
Xfanout128 net132 vssd1 vssd1 vccd1 vccd1 net128 sky130_fd_sc_hd__clkbuf_4
Xfanout139 net141 vssd1 vssd1 vccd1 vccd1 net139 sky130_fd_sc_hd__clkbuf_4
X_3206_ clknet_leaf_22_clk _0164_ net117 vssd1 vssd1 vccd1 vccd1 MATMULT_INST.matmult_inst.mem_inst.matrixA3\[13\]
+ sky130_fd_sc_hd__dfrtp_1
X_3137_ clknet_leaf_22_clk _0095_ net115 vssd1 vssd1 vccd1 vccd1 MATMULT_INST.matmult_inst.mem_inst.matrixA2\[16\]
+ sky130_fd_sc_hd__dfrtp_1
XANTENNA__2466__A net182 vssd1 vssd1 vccd1 vccd1 sky130_fd_sc_hd__diode_2
X_3068_ net245 vssd1 vssd1 vccd1 vccd1 _0026_ sky130_fd_sc_hd__inv_2
X_2019_ _0588_ _0591_ _0589_ vssd1 vssd1 vccd1 vccd1 _0596_ sky130_fd_sc_hd__o21ai_1
XANTENNA_fanout158_X net158 vssd1 vssd1 vccd1 vccd1 sky130_fd_sc_hd__diode_2
XFILLER_50_251 vssd1 vssd1 vccd1 vccd1 sky130_fd_sc_hd__fill_1
XFILLER_10_137 vssd1 vssd1 vccd1 vccd1 sky130_fd_sc_hd__fill_2
XFILLER_12_88 vssd1 vssd1 vccd1 vccd1 sky130_fd_sc_hd__fill_1
Xhold171 MATMULT_INST.matmult_inst.mem_inst.mem3\[12\] vssd1 vssd1 vccd1 vccd1 net484
+ sky130_fd_sc_hd__dlygate4sd3_1
Xhold160 MATMULT_INST.matmult_inst.alu_inst.col1\[5\] vssd1 vssd1 vccd1 vccd1 net473
+ sky130_fd_sc_hd__dlygate4sd3_1
Xhold193 MATMULT_INST.matmult_inst.mem_inst.mem1\[16\] vssd1 vssd1 vccd1 vccd1 net506
+ sky130_fd_sc_hd__dlygate4sd3_1
Xhold182 MATMULT_INST.matmult_inst.mem_inst.matrixB0\[13\] vssd1 vssd1 vccd1 vccd1
+ net495 sky130_fd_sc_hd__dlygate4sd3_1
XTAP_TAPCELL_ROW_76_817 vssd1 vccd1 sky130_fd_sc_hd__tapvpwrvgnd_1
XFILLER_58_384 vssd1 vssd1 vccd1 vccd1 sky130_fd_sc_hd__fill_1
XFILLER_73_332 vssd1 vssd1 vccd1 vccd1 sky130_fd_sc_hd__fill_4
XFILLER_37_96 vssd1 vssd1 vccd1 vccd1 sky130_fd_sc_hd__fill_4
XANTENNA__2823__B net206 vssd1 vssd1 vccd1 vccd1 sky130_fd_sc_hd__diode_2
XANTENNA__3040__A1 net161 vssd1 vssd1 vccd1 vccd1 sky130_fd_sc_hd__diode_2
XANTENNA__3040__B2 net156 vssd1 vssd1 vccd1 vccd1 sky130_fd_sc_hd__diode_2
XANTENNA__2050__S net55 vssd1 vssd1 vccd1 vccd1 sky130_fd_sc_hd__diode_2
XFILLER_68_104 vssd1 vssd1 vccd1 vccd1 sky130_fd_sc_hd__fill_1
X_2370_ net431 _0913_ net69 vssd1 vssd1 vccd1 vccd1 _0305_ sky130_fd_sc_hd__mux2_1
XFILLER_78_81 vssd1 vssd1 vccd1 vccd1 sky130_fd_sc_hd__fill_2
XFILLER_1_391 vssd1 vssd1 vccd1 vccd1 sky130_fd_sc_hd__fill_1
XTAP_TAPCELL_ROW_47_574 vssd1 vccd1 sky130_fd_sc_hd__tapvpwrvgnd_1
XFILLER_24_229 vssd1 vssd1 vccd1 vccd1 sky130_fd_sc_hd__fill_8
XFILLER_32_251 vssd1 vssd1 vccd1 vccd1 sky130_fd_sc_hd__fill_1
XTAP_TAPCELL_ROW_30_430 vssd1 vccd1 sky130_fd_sc_hd__tapvpwrvgnd_1
X_2706_ _1175_ _1176_ _1136_ vssd1 vssd1 vccd1 vccd1 _1178_ sky130_fd_sc_hd__a21o_1
X_2637_ _1109_ _1110_ vssd1 vssd1 vccd1 vccd1 _1111_ sky130_fd_sc_hd__nand2_1
XPHY_EDGE_ROW_12_Right_12 vssd1 vssd1 vccd1 vccd1 sky130_fd_sc_hd__decap_3
X_2568_ _0988_ net617 _1053_ vssd1 vssd1 vccd1 vccd1 _0363_ sky130_fd_sc_hd__mux2_1
X_2499_ net75 _1010_ vssd1 vssd1 vccd1 vccd1 _1011_ sky130_fd_sc_hd__and2_1
XFILLER_59_115 vssd1 vssd1 vccd1 vccd1 sky130_fd_sc_hd__fill_1
XANTENNA__2908__B net67 vssd1 vssd1 vccd1 vccd1 sky130_fd_sc_hd__diode_2
XANTENNA__2845__B2 net184 vssd1 vssd1 vccd1 vccd1 sky130_fd_sc_hd__diode_2
XFILLER_67_181 vssd1 vssd1 vccd1 vccd1 sky130_fd_sc_hd__fill_2
XTAP_TAPCELL_ROW_2_188 vssd1 vccd1 sky130_fd_sc_hd__tapvpwrvgnd_1
XPHY_EDGE_ROW_21_Right_21 vssd1 vssd1 vccd1 vccd1 sky130_fd_sc_hd__decap_3
XFILLER_23_54 vssd1 vssd1 vccd1 vccd1 sky130_fd_sc_hd__fill_2
XFILLER_7_417 vccd1 vssd1 vccd1 vssd1 sky130_ef_sc_hd__decap_40_12
XFILLER_23_76 vssd1 vssd1 vccd1 vccd1 sky130_fd_sc_hd__fill_2
XANTENNA__2081__D net235 vssd1 vssd1 vccd1 vccd1 sky130_fd_sc_hd__diode_2
XPHY_EDGE_ROW_30_Right_30 vssd1 vssd1 vccd1 vccd1 sky130_fd_sc_hd__decap_3
XFILLER_2_133 vssd1 vssd1 vccd1 vccd1 sky130_fd_sc_hd__fill_4
XANTENNA__2533__A0 _1022_ vssd1 vssd1 vccd1 vccd1 sky130_fd_sc_hd__diode_2
XANTENNA_fanout90_X net90 vssd1 vssd1 vccd1 vccd1 sky130_fd_sc_hd__diode_2
XFILLER_2_177 vccd1 vssd1 vccd1 vssd1 sky130_ef_sc_hd__decap_40_12
XFILLER_0_69 vssd1 vssd1 vccd1 vccd1 sky130_fd_sc_hd__fill_8
XTAP_TAPCELL_ROW_44_544 vssd1 vccd1 sky130_fd_sc_hd__tapvpwrvgnd_1
XFILLER_14_251 vssd1 vssd1 vccd1 vccd1 sky130_fd_sc_hd__fill_1
X_1870_ net489 net46 net12 vssd1 vssd1 vccd1 vccd1 _0201_ sky130_fd_sc_hd__mux2_1
XANTENNA__1884__S net10 vssd1 vssd1 vccd1 vccd1 sky130_fd_sc_hd__diode_2
XANTENNA__2772__B1 net71 vssd1 vssd1 vccd1 vccd1 sky130_fd_sc_hd__diode_2
X_3471_ clknet_leaf_14_clk _0415_ net144 vssd1 vssd1 vccd1 vccd1 MATMULT_INST.matmult_inst.mem_inst.matrixB3\[7\]
+ sky130_fd_sc_hd__dfrtp_1
X_2422_ _1507_ _1522_ _1498_ vssd1 vssd1 vccd1 vccd1 _0940_ sky130_fd_sc_hd__o21ai_1
XFILLER_43_3 vssd1 vssd1 vccd1 vccd1 sky130_fd_sc_hd__fill_8
X_2353_ _0847_ _0850_ _0873_ _0875_ _0896_ vssd1 vssd1 vccd1 vccd1 _0898_ sky130_fd_sc_hd__o311a_1
XANTENNA__2524__B1 _1033_ vssd1 vssd1 vccd1 vccd1 sky130_fd_sc_hd__diode_2
X_2284_ net213 net235 vssd1 vssd1 vccd1 vccd1 _0831_ sky130_fd_sc_hd__and2_1
XFILLER_52_324 vssd1 vssd1 vccd1 vccd1 sky130_fd_sc_hd__fill_1
XFILLER_64_195 vssd1 vssd1 vccd1 vccd1 sky130_fd_sc_hd__fill_1
XFILLER_20_221 vssd1 vssd1 vccd1 vccd1 sky130_fd_sc_hd__fill_4
XANTENNA__1794__S net30 vssd1 vssd1 vccd1 vccd1 sky130_fd_sc_hd__diode_2
XANTENNA_clkbuf_leaf_30_clk_A clknet_2_0__leaf_clk vssd1 vssd1 vccd1 vccd1 sky130_fd_sc_hd__diode_2
X_1999_ MATMULT_INST.matmult_inst.alu_inst.adder_inst.r2.fa3.b MATMULT_INST.matmult_inst.alu_inst.adder_inst.r2.fa3.a
+ vssd1 vssd1 vccd1 vccd1 _0579_ sky130_fd_sc_hd__nand2_1
XANTENNA__2515__B1 net84 vssd1 vssd1 vccd1 vccd1 sky130_fd_sc_hd__diode_2
XANTENNA__2818__A1 net184 vssd1 vssd1 vccd1 vccd1 sky130_fd_sc_hd__diode_2
XTAP_TAPCELL_ROW_58_669 vssd1 vccd1 sky130_fd_sc_hd__tapvpwrvgnd_1
XFILLER_11_221 vssd1 vssd1 vccd1 vccd1 sky130_fd_sc_hd__fill_2
XFILLER_34_75 vssd1 vssd1 vccd1 vccd1 sky130_fd_sc_hd__fill_8
XFILLER_7_225 vccd1 vssd1 vccd1 vssd1 sky130_ef_sc_hd__decap_40_12
XANTENNA__2820__C net204 vssd1 vssd1 vccd1 vccd1 sky130_fd_sc_hd__diode_2
XANTENNA__2506__B1 net84 vssd1 vssd1 vccd1 vccd1 sky130_fd_sc_hd__diode_2
XFILLER_46_151 vssd1 vssd1 vccd1 vccd1 sky130_fd_sc_hd__fill_1
XFILLER_75_93 vssd1 vssd1 vccd1 vccd1 sky130_fd_sc_hd__fill_4
XANTENNA__1879__S net11 vssd1 vssd1 vccd1 vccd1 sky130_fd_sc_hd__diode_2
X_2971_ MATMULT_INST.matmult_inst.mem_inst.mem2\[9\] net86 net78 MATMULT_INST.matmult_inst.mem_inst.mem1\[9\]
+ _1396_ vssd1 vssd1 vccd1 vccd1 _1397_ sky130_fd_sc_hd__a221o_1
X_1922_ net226 net535 net54 vssd1 vssd1 vccd1 vccd1 _0250_ sky130_fd_sc_hd__mux2_1
X_1853_ net506 net44 net28 vssd1 vssd1 vccd1 vccd1 _0185_ sky130_fd_sc_hd__mux2_1
XTAP_TAPCELL_ROW_12_271 vssd1 vccd1 sky130_fd_sc_hd__tapvpwrvgnd_1
X_1784_ net542 _0489_ net30 vssd1 vssd1 vccd1 vccd1 _0119_ sky130_fd_sc_hd__mux2_1
X_3523_ clknet_leaf_24_clk _0448_ net118 vssd1 vssd1 vccd1 vccd1 MATMULT_INST.matmult_inst.spi_inst.tx_reg_sys\[14\]
+ sky130_fd_sc_hd__dfrtp_1
Xfanout8 _1381_ vssd1 vssd1 vccd1 vccd1 net8 sky130_fd_sc_hd__buf_4
X_3454_ _0034_ _0399_ net150 vssd1 vssd1 vccd1 vccd1 MATMULT_INST.matmult_inst.spi_inst.rx_done_spi
+ sky130_fd_sc_hd__dfrtp_1
X_2405_ _1501_ _0459_ vssd1 vssd1 vccd1 vccd1 _0927_ sky130_fd_sc_hd__nor2_1
XTAP_TAPCELL_ROW_4_206 vssd1 vccd1 sky130_fd_sc_hd__tapvpwrvgnd_1
X_3385_ clknet_leaf_2_clk _0339_ net104 vssd1 vssd1 vccd1 vccd1 MATMULT_INST.matmult_inst.alu_inst.col1\[7\]
+ sky130_fd_sc_hd__dfrtp_1
X_2336_ _0856_ _0859_ _0858_ vssd1 vssd1 vccd1 vccd1 _0881_ sky130_fd_sc_hd__a21oi_1
XANTENNA__2458__B net172 vssd1 vssd1 vccd1 vccd1 sky130_fd_sc_hd__diode_2
X_2267_ _0801_ _0811_ _0814_ vssd1 vssd1 vccd1 vccd1 _0815_ sky130_fd_sc_hd__a21bo_1
XANTENNA_fanout185_A net186 vssd1 vssd1 vccd1 vccd1 sky130_fd_sc_hd__diode_2
XANTENNA__2276__A2 net222 vssd1 vssd1 vccd1 vccd1 sky130_fd_sc_hd__diode_2
X_2198_ _0745_ _0747_ vssd1 vssd1 vccd1 vccd1 _0748_ sky130_fd_sc_hd__xnor2_1
XANTENNA__1789__S net31 vssd1 vssd1 vccd1 vccd1 sky130_fd_sc_hd__diode_2
XTAP_TAPCELL_ROW_55_639 vssd1 vccd1 sky130_fd_sc_hd__tapvpwrvgnd_1
XFILLER_65_493 vssd1 vssd1 vccd1 vccd1 sky130_fd_sc_hd__fill_1
XFILLER_52_154 vssd1 vssd1 vccd1 vccd1 sky130_fd_sc_hd__fill_2
XANTENNA__2984__B1 net78 vssd1 vssd1 vccd1 vccd1 sky130_fd_sc_hd__diode_2
XANTENNA_fanout238_X net238 vssd1 vssd1 vccd1 vccd1 sky130_fd_sc_hd__diode_2
XFILLER_20_33 vssd1 vssd1 vccd1 vccd1 sky130_fd_sc_hd__fill_2
Xhold20 MATMULT_INST.matmult_inst.spi_inst.mosi_data_sync\[7\] vssd1 vssd1 vccd1 vccd1
+ net333 sky130_fd_sc_hd__dlygate4sd3_1
Xhold31 MATMULT_INST.matmult_inst.mem_inst.matrixA3\[0\] vssd1 vssd1 vccd1 vccd1 net344
+ sky130_fd_sc_hd__dlygate4sd3_1
Xhold64 MATMULT_INST.matmult_inst.alu_inst.row1\[3\] vssd1 vssd1 vccd1 vccd1 net377
+ sky130_fd_sc_hd__dlygate4sd3_1
Xhold42 MATMULT_INST.matmult_inst.mem_inst.matrixA3\[5\] vssd1 vssd1 vccd1 vccd1 net355
+ sky130_fd_sc_hd__dlygate4sd3_1
Xhold53 MATMULT_INST.matmult_inst.mem_inst.matrixB3\[2\] vssd1 vssd1 vccd1 vccd1 net366
+ sky130_fd_sc_hd__dlygate4sd3_1
XFILLER_75_279 vssd1 vssd1 vccd1 vccd1 sky130_fd_sc_hd__fill_1
Xhold86 MATMULT_INST.matmult_inst.spi_inst.tx_reg_sys\[10\] vssd1 vssd1 vccd1 vccd1
+ net399 sky130_fd_sc_hd__dlygate4sd3_1
Xhold97 MATMULT_INST.matmult_inst.mem_inst.matrixB0\[5\] vssd1 vssd1 vccd1 vccd1 net410
+ sky130_fd_sc_hd__dlygate4sd3_1
Xhold75 _0310_ vssd1 vssd1 vccd1 vccd1 net388 sky130_fd_sc_hd__dlygate4sd3_1
XFILLER_56_493 vssd1 vssd1 vccd1 vccd1 sky130_fd_sc_hd__fill_1
XTAP_TAPCELL_ROW_26_396 vssd1 vccd1 sky130_fd_sc_hd__tapvpwrvgnd_1
XFILLER_61_40 vccd1 vssd1 vccd1 vssd1 sky130_ef_sc_hd__decap_40_12
XFILLER_3_261 vccd1 vssd1 vccd1 vssd1 sky130_ef_sc_hd__decap_40_12
X_3170_ clknet_leaf_22_clk _0128_ net117 vssd1 vssd1 vccd1 vccd1 MATMULT_INST.matmult_inst.mem_inst.matrixB1\[13\]
+ sky130_fd_sc_hd__dfrtp_1
X_2121_ _0671_ _0672_ vssd1 vssd1 vccd1 vccd1 _0673_ sky130_fd_sc_hd__nand2_1
XFILLER_66_235 vssd1 vssd1 vccd1 vccd1 sky130_fd_sc_hd__fill_1
XFILLER_54_419 vssd1 vssd1 vccd1 vccd1 sky130_fd_sc_hd__fill_1
X_2052_ net108 _0453_ vssd1 vssd1 vccd1 vccd1 _0609_ sky130_fd_sc_hd__nand2_1
XFILLER_74_290 vssd1 vssd1 vccd1 vccd1 sky130_fd_sc_hd__fill_4
XFILLER_19_184 vccd1 vssd1 vccd1 vssd1 sky130_ef_sc_hd__decap_40_12
X_2954_ net433 _1032_ net58 vssd1 vssd1 vccd1 vccd1 _0441_ sky130_fd_sc_hd__mux2_1
X_1905_ net481 net49 net26 vssd1 vssd1 vccd1 vccd1 _0234_ sky130_fd_sc_hd__mux2_1
X_2885_ _1351_ vssd1 vssd1 vccd1 vccd1 _1352_ sky130_fd_sc_hd__inv_2
XTAP_TAPCELL_ROW_60_686 vssd1 vccd1 sky130_fd_sc_hd__tapvpwrvgnd_1
XPHY_EDGE_ROW_6_Right_6 vssd1 vssd1 vccd1 vccd1 sky130_fd_sc_hd__decap_3
X_1836_ net157 _0482_ net82 vssd1 vssd1 vccd1 vccd1 _0516_ sky130_fd_sc_hd__and3_1
X_1767_ net341 net32 net19 vssd1 vssd1 vccd1 vccd1 _0104_ sky130_fd_sc_hd__mux2_1
X_3506_ net242 _0011_ net125 vssd1 vssd1 vccd1 vccd1 MATMULT_INST.matmult_inst.spi_inst.miso_shifter\[14\]
+ sky130_fd_sc_hd__dfrtp_1
X_1698_ net596 _0494_ net24 vssd1 vssd1 vccd1 vccd1 _0052_ sky130_fd_sc_hd__mux2_1
XANTENNA__3064__S net57 vssd1 vssd1 vccd1 vccd1 sky130_fd_sc_hd__diode_2
XANTENNA__2469__A net182 vssd1 vssd1 vccd1 vccd1 sky130_fd_sc_hd__diode_2
X_3437_ clknet_leaf_10_clk _0000_ net138 vssd1 vssd1 vccd1 vccd1 MATMULT_INST.matmult_inst.fsm_inst.sel\[0\]
+ sky130_fd_sc_hd__dfstp_1
X_3368_ clknet_leaf_25_clk net353 net100 vssd1 vssd1 vccd1 vccd1 MATMULT_INST.matmult_inst.fsm_inst.alu_result\[14\]
+ sky130_fd_sc_hd__dfrtp_1
X_2319_ _0827_ _0834_ _0836_ vssd1 vssd1 vccd1 vccd1 _0865_ sky130_fd_sc_hd__o21a_1
XANTENNA__3361__Q MATMULT_INST.matmult_inst.fsm_inst.alu_result\[7\] vssd1 vssd1 vccd1
+ vccd1 sky130_fd_sc_hd__diode_2
XTAP_TAPCELL_ROW_68_753 vssd1 vccd1 sky130_fd_sc_hd__tapvpwrvgnd_1
X_3299_ clknet_leaf_0_clk net362 net95 vssd1 vssd1 vccd1 vccd1 MATMULT_INST.matmult_inst.alu_inst.a0_reg\[7\]
+ sky130_fd_sc_hd__dfrtp_1
XFILLER_57_279 vssd1 vssd1 vccd1 vccd1 sky130_fd_sc_hd__fill_1
XFILLER_25_110 vssd1 vssd1 vccd1 vccd1 sky130_fd_sc_hd__fill_2
XFILLER_13_305 vccd1 vssd1 vccd1 vssd1 sky130_ef_sc_hd__decap_40_12
XFILLER_25_154 vssd1 vssd1 vccd1 vccd1 sky130_fd_sc_hd__fill_1
XFILLER_13_349 vccd1 vssd1 vccd1 vssd1 sky130_ef_sc_hd__decap_40_12
XFILLER_21_382 vssd1 vssd1 vccd1 vccd1 sky130_fd_sc_hd__fill_1
XTAP_TAPCELL_ROW_23_366 vssd1 vccd1 sky130_fd_sc_hd__tapvpwrvgnd_1
XANTENNA_fanout13_A _0517_ vssd1 vssd1 vccd1 vccd1 sky130_fd_sc_hd__diode_2
XFILLER_31_43 vssd1 vssd1 vccd1 vccd1 sky130_fd_sc_hd__fill_2
XFILLER_31_65 vssd1 vssd1 vccd1 vccd1 sky130_fd_sc_hd__fill_2
XFILLER_0_253 vssd1 vssd1 vccd1 vccd1 sky130_fd_sc_hd__fill_2
XANTENNA__2488__A2 _0954_ vssd1 vssd1 vccd1 vccd1 sky130_fd_sc_hd__diode_2
XFILLER_56_62 vssd1 vssd1 vccd1 vccd1 sky130_fd_sc_hd__fill_1
XFILLER_63_205 vssd1 vssd1 vccd1 vccd1 sky130_fd_sc_hd__fill_4
XANTENNA__3003__A net176 vssd1 vssd1 vccd1 vccd1 sky130_fd_sc_hd__diode_2
XFILLER_72_61 vssd1 vssd1 vccd1 vccd1 sky130_fd_sc_hd__fill_4
XFILLER_31_157 vssd1 vssd1 vccd1 vccd1 sky130_fd_sc_hd__fill_1
XPHY_EDGE_ROW_59_Right_59 vssd1 vssd1 vccd1 vccd1 sky130_fd_sc_hd__decap_3
XFILLER_75_6 vccd1 vssd1 vccd1 vssd1 sky130_ef_sc_hd__decap_40_12
X_2670_ _1133_ _1141_ _1142_ vssd1 vssd1 vccd1 vccd1 _1143_ sky130_fd_sc_hd__and3_1
XANTENNA__3288__RESET_B net96 vssd1 vssd1 vccd1 vccd1 sky130_fd_sc_hd__diode_2
X_1621_ _1484_ _0454_ vssd1 vssd1 vccd1 vccd1 _0455_ sky130_fd_sc_hd__nand2_1
XANTENNA__1892__S net10 vssd1 vssd1 vccd1 vccd1 sky130_fd_sc_hd__diode_2
X_1552_ MATMULT_INST.matmult_inst.spi_inst.mosi_shifter\[3\] MATMULT_INST.matmult_inst.spi_inst.mosi_shifter\[2\]
+ _1488_ vssd1 vssd1 vccd1 vccd1 _0404_ sky130_fd_sc_hd__mux2_1
X_3222_ clknet_leaf_19_clk _0180_ net128 vssd1 vssd1 vccd1 vccd1 MATMULT_INST.matmult_inst.mem_inst.mem1\[11\]
+ sky130_fd_sc_hd__dfrtp_1
XPHY_EDGE_ROW_68_Right_68 vssd1 vssd1 vccd1 vccd1 sky130_fd_sc_hd__decap_3
X_3153_ clknet_leaf_26_clk _0111_ net97 vssd1 vssd1 vccd1 vccd1 MATMULT_INST.matmult_inst.mem_inst.mem3\[14\]
+ sky130_fd_sc_hd__dfrtp_1
X_2104_ _0640_ _0641_ _0642_ vssd1 vssd1 vccd1 vccd1 _0656_ sky130_fd_sc_hd__o21ai_1
XANTENNA__1687__B1 net61 vssd1 vssd1 vccd1 vccd1 sky130_fd_sc_hd__diode_2
X_3084_ clknet_leaf_12_clk _0042_ net149 vssd1 vssd1 vccd1 vccd1 MATMULT_INST.matmult_inst.spi_inst.rx_done_sys
+ sky130_fd_sc_hd__dfrtp_4
XTAP_TAPCELL_ROW_65_723 vssd1 vccd1 sky130_fd_sc_hd__tapvpwrvgnd_1
X_2035_ MATMULT_INST.matmult_inst.alu_inst.b1_reg\[0\] net395 net55 vssd1 vssd1 vccd1
+ vccd1 _0276_ sky130_fd_sc_hd__mux2_1
XPHY_EDGE_ROW_77_Right_77 vssd1 vssd1 vccd1 vccd1 sky130_fd_sc_hd__decap_3
X_2937_ net510 net44 net8 vssd1 vssd1 vccd1 vccd1 _0424_ sky130_fd_sc_hd__mux2_1
X_2868_ _1334_ _1335_ vssd1 vssd1 vccd1 vccd1 _1336_ sky130_fd_sc_hd__xor2_1
XANTENNA__2167__A1 net239 vssd1 vssd1 vccd1 vccd1 sky130_fd_sc_hd__diode_2
Xhold320 MATMULT_INST.matmult_inst.mem_inst.matrixA2\[9\] vssd1 vssd1 vccd1 vccd1
+ net633 sky130_fd_sc_hd__dlygate4sd3_1
X_1819_ net343 net38 net14 vssd1 vssd1 vccd1 vccd1 _0152_ sky130_fd_sc_hd__mux2_1
X_2799_ _1134_ _1209_ vssd1 vssd1 vccd1 vccd1 _1269_ sky130_fd_sc_hd__nand2_1
XPHY_EDGE_ROW_15_Left_95 vssd1 vssd1 vccd1 vccd1 sky130_fd_sc_hd__decap_3
Xhold342 MATMULT_INST.matmult_inst.mem_inst.matrixA2\[17\] vssd1 vssd1 vccd1 vccd1
+ net655 sky130_fd_sc_hd__dlygate4sd3_1
Xhold331 MATMULT_INST.matmult_inst.mem_inst.mem0\[17\] vssd1 vssd1 vccd1 vccd1 net644
+ sky130_fd_sc_hd__dlygate4sd3_1
Xhold353 MATMULT_INST.matmult_inst.alu_inst.adder_inst.r1.fa1.a vssd1 vssd1 vccd1
+ vccd1 net666 sky130_fd_sc_hd__dlygate4sd3_1
XFILLER_18_419 vssd1 vssd1 vccd1 vccd1 sky130_fd_sc_hd__fill_1
XTAP_TAPCELL_ROW_28_414 vssd1 vccd1 sky130_fd_sc_hd__tapvpwrvgnd_1
XFILLER_26_21 vssd1 vssd1 vccd1 vccd1 sky130_fd_sc_hd__fill_1
XTAP_TAPCELL_ROW_36_480 vssd1 vccd1 sky130_fd_sc_hd__tapvpwrvgnd_1
XANTENNA_fanout16_X net16 vssd1 vssd1 vccd1 vccd1 sky130_fd_sc_hd__diode_2
XFILLER_5_389 vssd1 vssd1 vccd1 vccd1 sky130_fd_sc_hd__fill_2
XTAP_TAPCELL_ROW_79_848 vssd1 vccd1 sky130_fd_sc_hd__tapvpwrvgnd_1
XFILLER_3_69 vccd1 vssd1 vccd1 vssd1 sky130_ef_sc_hd__decap_40_12
XFILLER_36_249 vssd1 vssd1 vccd1 vccd1 sky130_fd_sc_hd__fill_1
XANTENNA__2048__S net54 vssd1 vssd1 vccd1 vccd1 sky130_fd_sc_hd__diode_2
XANTENNA__1887__S net10 vssd1 vssd1 vccd1 vccd1 sky130_fd_sc_hd__diode_2
XTAP_TAPCELL_ROW_70_770 vssd1 vccd1 sky130_fd_sc_hd__tapvpwrvgnd_1
X_2722_ net210 net188 net208 vssd1 vssd1 vccd1 vccd1 _1194_ sky130_fd_sc_hd__and3_1
XFILLER_73_3 vccd1 vssd1 vccd1 vssd1 sky130_ef_sc_hd__decap_40_12
X_2653_ _1087_ _1104_ _1105_ vssd1 vssd1 vccd1 vccd1 _1127_ sky130_fd_sc_hd__o21ai_1
X_2584_ _1499_ _0480_ _0509_ _1511_ vssd1 vssd1 vccd1 vccd1 _1064_ sky130_fd_sc_hd__a31o_1
X_1604_ MATMULT_INST.matmult_inst.fsm_inst.state\[4\] _1495_ vssd1 vssd1 vccd1 vccd1
+ _1522_ sky130_fd_sc_hd__or2_4
Xfanout107 net114 vssd1 vssd1 vccd1 vccd1 net107 sky130_fd_sc_hd__clkbuf_2
Xfanout118 net123 vssd1 vssd1 vccd1 vccd1 net118 sky130_fd_sc_hd__buf_2
Xfanout129 net132 vssd1 vssd1 vccd1 vccd1 net129 sky130_fd_sc_hd__buf_2
X_3205_ clknet_leaf_23_clk _0163_ net97 vssd1 vssd1 vccd1 vccd1 MATMULT_INST.matmult_inst.mem_inst.matrixA3\[12\]
+ sky130_fd_sc_hd__dfrtp_1
XFILLER_67_341 vssd1 vssd1 vccd1 vccd1 sky130_fd_sc_hd__fill_1
X_3136_ clknet_leaf_20_clk _0094_ net126 vssd1 vssd1 vccd1 vccd1 MATMULT_INST.matmult_inst.mem_inst.matrixA2\[15\]
+ sky130_fd_sc_hd__dfrtp_1
XANTENNA__2466__B net173 vssd1 vssd1 vccd1 vccd1 sky130_fd_sc_hd__diode_2
X_3067_ net245 vssd1 vssd1 vccd1 vccd1 _0025_ sky130_fd_sc_hd__inv_2
X_2018_ _0593_ _0594_ vssd1 vssd1 vccd1 vccd1 _0595_ sky130_fd_sc_hd__nand2_1
XANTENNA__1797__S net30 vssd1 vssd1 vccd1 vccd1 sky130_fd_sc_hd__diode_2
XTAP_TAPCELL_ROW_33_450 vssd1 vccd1 sky130_fd_sc_hd__tapvpwrvgnd_1
XFILLER_6_109 vccd1 vssd1 vccd1 vssd1 sky130_ef_sc_hd__decap_40_12
Xhold150 MATMULT_INST.matmult_inst.mem_inst.mem2\[15\] vssd1 vssd1 vccd1 vccd1 net463
+ sky130_fd_sc_hd__dlygate4sd3_1
Xhold161 MATMULT_INST.matmult_inst.alu_inst.row0\[6\] vssd1 vssd1 vccd1 vccd1 net474
+ sky130_fd_sc_hd__dlygate4sd3_1
Xhold194 MATMULT_INST.matmult_inst.alu_inst.row0\[4\] vssd1 vssd1 vccd1 vccd1 net507
+ sky130_fd_sc_hd__dlygate4sd3_1
Xhold183 MATMULT_INST.matmult_inst.mem_inst.matrixA3\[11\] vssd1 vssd1 vccd1 vccd1
+ net496 sky130_fd_sc_hd__dlygate4sd3_1
XANTENNA__2560__A1 _1000_ vssd1 vssd1 vccd1 vccd1 sky130_fd_sc_hd__diode_2
Xhold172 MATMULT_INST.matmult_inst.mem_inst.matrixB1\[6\] vssd1 vssd1 vccd1 vccd1
+ net485 sky130_fd_sc_hd__dlygate4sd3_1
XTAP_TAPCELL_ROW_76_818 vssd1 vccd1 sky130_fd_sc_hd__tapvpwrvgnd_1
XFILLER_73_388 vssd1 vssd1 vccd1 vccd1 sky130_fd_sc_hd__fill_2
XFILLER_14_433 vssd1 vssd1 vccd1 vccd1 sky130_fd_sc_hd__fill_1
XFILLER_14_466 vssd1 vssd1 vccd1 vccd1 sky130_fd_sc_hd__fill_1
XTAP_TAPCELL_ROW_47_575 vssd1 vccd1 sky130_fd_sc_hd__tapvpwrvgnd_1
XFILLER_20_414 vssd1 vssd1 vccd1 vccd1 sky130_fd_sc_hd__fill_1
XTAP_TAPCELL_ROW_30_431 vssd1 vccd1 sky130_fd_sc_hd__tapvpwrvgnd_1
X_2705_ _1135_ _1174_ _1176_ vssd1 vssd1 vccd1 vccd1 _1177_ sky130_fd_sc_hd__or3b_1
X_2636_ net207 net193 net191 net209 vssd1 vssd1 vccd1 vccd1 _1110_ sky130_fd_sc_hd__a22o_1
X_2567_ _0977_ net518 _1053_ vssd1 vssd1 vccd1 vccd1 _0362_ sky130_fd_sc_hd__mux2_1
X_2498_ net166 _1008_ _1009_ _1004_ vssd1 vssd1 vccd1 vccd1 _1010_ sky130_fd_sc_hd__a211o_1
XFILLER_74_18 vssd1 vssd1 vccd1 vccd1 sky130_fd_sc_hd__fill_4
XPHY_EDGE_ROW_27_Left_107 vssd1 vssd1 vccd1 vccd1 sky130_fd_sc_hd__decap_3
XANTENNA__2845__A2 net203 vssd1 vssd1 vccd1 vccd1 sky130_fd_sc_hd__diode_2
XFILLER_67_193 vssd1 vssd1 vccd1 vccd1 sky130_fd_sc_hd__fill_1
XTAP_TAPCELL_ROW_2_189 vssd1 vccd1 sky130_fd_sc_hd__tapvpwrvgnd_1
X_3119_ clknet_leaf_24_clk _0077_ net116 vssd1 vssd1 vccd1 vccd1 MATMULT_INST.matmult_inst.mem_inst.matrixA0\[16\]
+ sky130_fd_sc_hd__dfrtp_1
XFILLER_11_447 vssd1 vssd1 vccd1 vccd1 sky130_fd_sc_hd__fill_1
XFILLER_7_429 vccd1 vssd1 vccd1 vssd1 sky130_ef_sc_hd__decap_40_12
XPHY_EDGE_ROW_36_Left_116 vssd1 vssd1 vccd1 vccd1 sky130_fd_sc_hd__decap_3
XFILLER_3_3 vccd1 vssd1 vccd1 vssd1 sky130_ef_sc_hd__decap_40_12
XFILLER_2_189 vssd1 vssd1 vccd1 vccd1 sky130_fd_sc_hd__fill_4
XANTENNA_fanout83_X net83 vssd1 vssd1 vccd1 vccd1 sky130_fd_sc_hd__diode_2
XPHY_EDGE_ROW_45_Left_125 vssd1 vssd1 vccd1 vccd1 sky130_fd_sc_hd__decap_3
XFILLER_65_108 vssd1 vssd1 vccd1 vccd1 sky130_fd_sc_hd__fill_4
XFILLER_0_15 vccd1 vssd1 vccd1 vssd1 sky130_ef_sc_hd__decap_40_12
XFILLER_58_193 vssd1 vssd1 vccd1 vccd1 sky130_fd_sc_hd__fill_2
XFILLER_0_48 vssd1 vssd1 vccd1 vccd1 sky130_fd_sc_hd__fill_8
XFILLER_0_37 vssd1 vssd1 vccd1 vccd1 sky130_fd_sc_hd__fill_1
XTAP_TAPCELL_ROW_44_545 vssd1 vccd1 sky130_fd_sc_hd__tapvpwrvgnd_1
XANTENNA__3011__A net178 vssd1 vssd1 vccd1 vccd1 sky130_fd_sc_hd__diode_2
XFILLER_9_57 vccd1 vssd1 vccd1 vssd1 sky130_ef_sc_hd__decap_40_12
XPHY_EDGE_ROW_54_Left_134 vssd1 vssd1 vccd1 vccd1 sky130_fd_sc_hd__decap_3
XFILLER_6_473 vssd1 vssd1 vccd1 vccd1 sky130_fd_sc_hd__fill_2
X_3470_ clknet_leaf_13_clk _0414_ net146 vssd1 vssd1 vccd1 vccd1 MATMULT_INST.matmult_inst.mem_inst.matrixB3\[6\]
+ sky130_fd_sc_hd__dfrtp_1
X_2421_ MATMULT_INST.matmult_inst.fsm_inst.state\[3\] _1517_ _0938_ _0939_ vssd1 vssd1
+ vccd1 vccd1 _0330_ sky130_fd_sc_hd__a22o_1
X_2352_ _0895_ _0896_ vssd1 vssd1 vccd1 vccd1 _0897_ sky130_fd_sc_hd__and2b_1
XFILLER_36_3 vssd1 vssd1 vccd1 vccd1 sky130_fd_sc_hd__fill_4
XANTENNA__2524__B2 net66 vssd1 vssd1 vccd1 vccd1 sky130_fd_sc_hd__diode_2
X_2283_ net216 net214 net231 net233 vssd1 vssd1 vccd1 vccd1 _0830_ sky130_fd_sc_hd__and4_1
XPHY_EDGE_ROW_63_Left_143 vssd1 vssd1 vccd1 vccd1 sky130_fd_sc_hd__decap_3
XPHY_EDGE_ROW_72_Left_152 vssd1 vssd1 vccd1 vccd1 sky130_fd_sc_hd__decap_3
XANTENNA_fanout130_A net132 vssd1 vssd1 vccd1 vccd1 sky130_fd_sc_hd__diode_2
X_1998_ MATMULT_INST.matmult_inst.alu_inst.adder_inst.r2.fa3.b MATMULT_INST.matmult_inst.alu_inst.adder_inst.r2.fa3.a
+ vssd1 vssd1 vccd1 vccd1 _0578_ sky130_fd_sc_hd__or2_1
X_2619_ _1092_ _1093_ _1080_ vssd1 vssd1 vccd1 vccd1 _1094_ sky130_fd_sc_hd__a21oi_1
XANTENNA__2919__B MATMULT_INST.matmult_inst.spi_inst.rx_done_sys vssd1 vssd1 vccd1
+ vccd1 sky130_fd_sc_hd__diode_2
XFILLER_75_417 vssd1 vssd1 vccd1 vccd1 sky130_fd_sc_hd__fill_2
XFILLER_47_108 vssd1 vssd1 vccd1 vccd1 sky130_fd_sc_hd__fill_4
XFILLER_18_44 vssd1 vssd1 vccd1 vccd1 sky130_fd_sc_hd__fill_8
XFILLER_70_155 vssd1 vssd1 vccd1 vccd1 sky130_fd_sc_hd__fill_2
XANTENNA__2451__B1 _0966_ vssd1 vssd1 vccd1 vccd1 sky130_fd_sc_hd__diode_2
XFILLER_11_277 vssd1 vssd1 vccd1 vccd1 sky130_fd_sc_hd__fill_2
XFILLER_7_237 vccd1 vssd1 vccd1 vssd1 sky130_ef_sc_hd__decap_40_12
XFILLER_50_42 vssd1 vssd1 vccd1 vccd1 sky130_fd_sc_hd__fill_2
XFILLER_59_84 vssd1 vssd1 vccd1 vccd1 sky130_fd_sc_hd__fill_4
XPHY_EDGE_ROW_3_Left_83 vssd1 vssd1 vccd1 vccd1 sky130_fd_sc_hd__decap_3
XFILLER_46_141 vssd1 vssd1 vccd1 vccd1 sky130_fd_sc_hd__fill_1
XFILLER_74_461 vccd1 vssd1 vccd1 vssd1 sky130_ef_sc_hd__decap_40_12
X_2970_ net177 net168 MATMULT_INST.matmult_inst.mem_inst.mem3\[9\] vssd1 vssd1 vccd1
+ vccd1 _1396_ sky130_fd_sc_hd__and3_1
XFILLER_61_166 vssd1 vssd1 vccd1 vccd1 sky130_fd_sc_hd__fill_2
X_1921_ net228 net601 net53 vssd1 vssd1 vccd1 vccd1 _0249_ sky130_fd_sc_hd__mux2_1
XANTENNA__1895__S net26 vssd1 vssd1 vccd1 vccd1 sky130_fd_sc_hd__diode_2
X_1852_ net533 net45 net28 vssd1 vssd1 vccd1 vccd1 _0184_ sky130_fd_sc_hd__mux2_1
XTAP_TAPCELL_ROW_12_272 vssd1 vccd1 sky130_fd_sc_hd__tapvpwrvgnd_1
X_1783_ net600 net36 net31 vssd1 vssd1 vccd1 vccd1 _0118_ sky130_fd_sc_hd__mux2_1
X_3522_ clknet_leaf_22_clk _0447_ net118 vssd1 vssd1 vccd1 vccd1 MATMULT_INST.matmult_inst.spi_inst.tx_reg_sys\[13\]
+ sky130_fd_sc_hd__dfrtp_1
Xfanout9 _1381_ vssd1 vssd1 vccd1 vccd1 net9 sky130_fd_sc_hd__clkbuf_4
X_3453_ clknet_leaf_10_clk net315 net141 vssd1 vssd1 vccd1 vccd1 MATMULT_INST.matmult_inst.spi_inst.cs_sync_prev
+ sky130_fd_sc_hd__dfstp_1
X_2404_ net183 net175 MATMULT_INST.matmult_inst.fsm_inst.tx_start_send vssd1 vssd1
+ vccd1 vccd1 _0926_ sky130_fd_sc_hd__and3_1
X_3384_ clknet_leaf_2_clk _0338_ net105 vssd1 vssd1 vccd1 vccd1 MATMULT_INST.matmult_inst.alu_inst.col1\[6\]
+ sky130_fd_sc_hd__dfrtp_1
XTAP_TAPCELL_ROW_4_207 vssd1 vccd1 sky130_fd_sc_hd__tapvpwrvgnd_1
X_2335_ _0855_ _0868_ _0869_ vssd1 vssd1 vccd1 vccd1 _0880_ sky130_fd_sc_hd__o21ai_1
X_2266_ _0801_ _0812_ _0811_ vssd1 vssd1 vccd1 vccd1 _0814_ sky130_fd_sc_hd__a21o_1
X_2197_ _0702_ _0746_ vssd1 vssd1 vccd1 vccd1 _0747_ sky130_fd_sc_hd__or2_1
XANTENNA_fanout178_A net180 vssd1 vssd1 vccd1 vccd1 sky130_fd_sc_hd__diode_2
XANTENNA__2474__B _0987_ vssd1 vssd1 vccd1 vccd1 sky130_fd_sc_hd__diode_2
Xhold21 _0433_ vssd1 vssd1 vccd1 vccd1 net334 sky130_fd_sc_hd__dlygate4sd3_1
Xhold10 _0429_ vssd1 vssd1 vccd1 vccd1 net323 sky130_fd_sc_hd__dlygate4sd3_1
Xhold32 MATMULT_INST.matmult_inst.mem_inst.matrixB3\[3\] vssd1 vssd1 vccd1 vccd1 net345
+ sky130_fd_sc_hd__dlygate4sd3_1
Xhold54 MATMULT_INST.matmult_inst.mem_inst.matrixA3\[17\] vssd1 vssd1 vccd1 vccd1
+ net367 sky130_fd_sc_hd__dlygate4sd3_1
Xhold43 MATMULT_INST.matmult_inst.alu_inst.adder_inst.r2.fa2.a vssd1 vssd1 vccd1 vccd1
+ net356 sky130_fd_sc_hd__dlygate4sd3_1
Xhold65 MATMULT_INST.matmult_inst.spi_inst.tx_reg_sys\[8\] vssd1 vssd1 vccd1 vccd1
+ net378 sky130_fd_sc_hd__dlygate4sd3_1
Xhold98 MATMULT_INST.matmult_inst.alu_inst.adder_inst.r3.fa0.a vssd1 vssd1 vccd1 vccd1
+ net411 sky130_fd_sc_hd__dlygate4sd3_1
Xhold76 MATMULT_INST.matmult_inst.mem_inst.matrixA2\[4\] vssd1 vssd1 vccd1 vccd1 net389
+ sky130_fd_sc_hd__dlygate4sd3_1
Xhold87 MATMULT_INST.matmult_inst.spi_inst.tx_reg_sys\[1\] vssd1 vssd1 vccd1 vccd1
+ net400 sky130_fd_sc_hd__dlygate4sd3_1
XFILLER_43_111 vssd1 vssd1 vccd1 vccd1 sky130_fd_sc_hd__fill_1
XFILLER_45_42 vssd1 vssd1 vccd1 vccd1 sky130_fd_sc_hd__fill_2
XTAP_TAPCELL_ROW_26_397 vssd1 vccd1 sky130_fd_sc_hd__tapvpwrvgnd_1
XANTENNA__2975__A1 net165 vssd1 vssd1 vccd1 vccd1 sky130_fd_sc_hd__diode_2
XFILLER_61_52 vssd1 vssd1 vccd1 vccd1 sky130_fd_sc_hd__fill_4
XFILLER_61_85 vssd1 vssd1 vccd1 vccd1 sky130_fd_sc_hd__fill_1
XFILLER_3_273 vssd1 vssd1 vccd1 vccd1 sky130_fd_sc_hd__fill_4
X_2120_ _0668_ _0669_ _0652_ vssd1 vssd1 vccd1 vccd1 _0672_ sky130_fd_sc_hd__a21o_1
X_2051_ net5 net1 _0453_ vssd1 vssd1 vccd1 vccd1 _0608_ sky130_fd_sc_hd__and3_1
XTAP_TAPCELL_ROW_17_320 vssd1 vccd1 sky130_fd_sc_hd__tapvpwrvgnd_1
XFILLER_19_196 vccd1 vssd1 vccd1 vssd1 sky130_ef_sc_hd__decap_40_12
XFILLER_62_475 vssd1 vssd1 vccd1 vccd1 sky130_fd_sc_hd__fill_1
X_2953_ net409 _1021_ net58 vssd1 vssd1 vccd1 vccd1 _0440_ sky130_fd_sc_hd__mux2_1
X_1904_ net520 net50 net26 vssd1 vssd1 vccd1 vccd1 _0233_ sky130_fd_sc_hd__mux2_1
X_2884_ _1327_ _1348_ _1347_ vssd1 vssd1 vccd1 vccd1 _1351_ sky130_fd_sc_hd__a21o_1
X_1835_ net367 net43 net14 vssd1 vssd1 vccd1 vccd1 _0168_ sky130_fd_sc_hd__mux2_1
XFILLER_30_394 vssd1 vssd1 vccd1 vccd1 sky130_fd_sc_hd__fill_1
X_1766_ net347 net33 net19 vssd1 vssd1 vccd1 vccd1 _0103_ sky130_fd_sc_hd__mux2_1
X_3505_ net242 _0010_ net118 vssd1 vssd1 vccd1 vccd1 MATMULT_INST.matmult_inst.spi_inst.miso_shifter\[13\]
+ sky130_fd_sc_hd__dfrtp_1
X_1697_ MATMULT_INST.matmult_inst.fsm_inst.alu_result\[9\] net60 vssd1 vssd1 vccd1
+ vccd1 _0494_ sky130_fd_sc_hd__and2_1
X_3436_ clknet_leaf_10_clk net58 net137 vssd1 vssd1 vccd1 vccd1 MATMULT_INST.matmult_inst.fsm_inst.load_delay
+ sky130_fd_sc_hd__dfrtp_1
XANTENNA__2469__B net173 vssd1 vssd1 vccd1 vccd1 sky130_fd_sc_hd__diode_2
X_3367_ clknet_leaf_26_clk net418 net101 vssd1 vssd1 vccd1 vccd1 MATMULT_INST.matmult_inst.fsm_inst.alu_result\[13\]
+ sky130_fd_sc_hd__dfrtp_1
X_2318_ _0862_ _0863_ vssd1 vssd1 vccd1 vccd1 _0864_ sky130_fd_sc_hd__nand2b_1
XTAP_TAPCELL_ROW_68_754 vssd1 vccd1 sky130_fd_sc_hd__tapvpwrvgnd_1
X_3298_ clknet_leaf_28_clk _0256_ net95 vssd1 vssd1 vccd1 vccd1 MATMULT_INST.matmult_inst.alu_inst.a0_reg\[6\]
+ sky130_fd_sc_hd__dfrtp_1
X_2249_ net216 net233 net235 net214 vssd1 vssd1 vccd1 vccd1 _0797_ sky130_fd_sc_hd__a22o_1
XFILLER_13_317 vccd1 vssd1 vccd1 vssd1 sky130_ef_sc_hd__decap_40_12
XFILLER_40_103 vssd1 vssd1 vccd1 vccd1 sky130_fd_sc_hd__fill_1
XTAP_TAPCELL_ROW_23_367 vssd1 vccd1 sky130_fd_sc_hd__tapvpwrvgnd_1
XFILLER_31_55 vssd1 vssd1 vccd1 vccd1 sky130_fd_sc_hd__fill_1
XFILLER_56_41 vssd1 vssd1 vccd1 vccd1 sky130_fd_sc_hd__fill_2
XFILLER_16_122 vssd1 vssd1 vccd1 vccd1 sky130_fd_sc_hd__fill_1
XFILLER_16_155 vccd1 vssd1 vccd1 vssd1 sky130_ef_sc_hd__decap_40_12
XANTENNA__3003__B net167 vssd1 vssd1 vccd1 vccd1 sky130_fd_sc_hd__diode_2
XFILLER_72_51 vssd1 vssd1 vccd1 vccd1 sky130_fd_sc_hd__fill_1
XFILLER_31_125 vssd1 vssd1 vccd1 vccd1 sky130_fd_sc_hd__fill_1
XFILLER_12_361 vssd1 vssd1 vccd1 vccd1 sky130_fd_sc_hd__fill_2
XFILLER_8_321 vccd1 vssd1 vccd1 vssd1 sky130_ef_sc_hd__decap_40_12
XFILLER_8_365 vccd1 vssd1 vccd1 vssd1 sky130_ef_sc_hd__decap_40_12
X_1620_ _1498_ _1520_ _1504_ vssd1 vssd1 vccd1 vccd1 _0454_ sky130_fd_sc_hd__a21oi_1
X_1551_ MATMULT_INST.matmult_inst.spi_inst.mosi_shifter\[4\] MATMULT_INST.matmult_inst.spi_inst.mosi_shifter\[3\]
+ _1488_ vssd1 vssd1 vccd1 vccd1 _0405_ sky130_fd_sc_hd__mux2_1
XFILLER_79_361 vssd1 vssd1 vccd1 vccd1 sky130_fd_sc_hd__fill_2
X_3221_ clknet_leaf_24_clk _0179_ net119 vssd1 vssd1 vccd1 vccd1 MATMULT_INST.matmult_inst.mem_inst.mem1\[10\]
+ sky130_fd_sc_hd__dfrtp_1
X_3152_ clknet_leaf_22_clk _0110_ net117 vssd1 vssd1 vccd1 vccd1 MATMULT_INST.matmult_inst.mem_inst.mem3\[13\]
+ sky130_fd_sc_hd__dfrtp_1
XFILLER_39_203 vssd1 vssd1 vccd1 vccd1 sky130_fd_sc_hd__fill_2
XFILLER_39_214 vssd1 vssd1 vccd1 vccd1 sky130_fd_sc_hd__fill_2
XFILLER_39_225 vssd1 vssd1 vccd1 vccd1 sky130_fd_sc_hd__fill_1
X_2103_ _0653_ _0654_ vssd1 vssd1 vccd1 vccd1 _0655_ sky130_fd_sc_hd__nand2_1
X_3083_ net246 vssd1 vssd1 vccd1 vccd1 _0041_ sky130_fd_sc_hd__inv_2
XTAP_TAPCELL_ROW_65_724 vssd1 vccd1 sky130_fd_sc_hd__tapvpwrvgnd_1
X_2034_ net637 _0476_ _0606_ _0607_ vssd1 vssd1 vccd1 vccd1 _0275_ sky130_fd_sc_hd__a22o_1
XTAP_TAPCELL_ROW_73_790 vssd1 vccd1 sky130_fd_sc_hd__tapvpwrvgnd_1
XFILLER_22_147 vccd1 vssd1 vccd1 vssd1 sky130_ef_sc_hd__decap_40_12
X_2936_ net414 net45 net8 vssd1 vssd1 vccd1 vccd1 _0423_ sky130_fd_sc_hd__mux2_1
XANTENNA__3061__B1 net79 vssd1 vssd1 vccd1 vccd1 sky130_fd_sc_hd__diode_2
XFILLER_10_309 vccd1 vssd1 vccd1 vssd1 sky130_ef_sc_hd__decap_40_12
X_2867_ _1279_ _1305_ _1307_ _1304_ vssd1 vssd1 vccd1 vccd1 _1335_ sky130_fd_sc_hd__a31o_1
X_1818_ net344 net39 net15 vssd1 vssd1 vccd1 vccd1 _0151_ sky130_fd_sc_hd__mux2_1
Xhold310 MATMULT_INST.matmult_inst.mem_inst.mem0\[8\] vssd1 vssd1 vccd1 vccd1 net623
+ sky130_fd_sc_hd__dlygate4sd3_1
X_2798_ _1266_ _1267_ vssd1 vssd1 vccd1 vccd1 _1268_ sky130_fd_sc_hd__nand2b_1
X_1749_ net652 _0495_ net20 vssd1 vssd1 vccd1 vccd1 _0089_ sky130_fd_sc_hd__mux2_1
Xhold321 MATMULT_INST.matmult_inst.mem_inst.matrixB1\[9\] vssd1 vssd1 vccd1 vccd1
+ net634 sky130_fd_sc_hd__dlygate4sd3_1
Xhold343 MATMULT_INST.matmult_inst.fsm_inst.alu_result\[5\] vssd1 vssd1 vccd1 vccd1
+ net656 sky130_fd_sc_hd__dlygate4sd3_1
Xhold332 MATMULT_INST.matmult_inst.alu_inst.out\[0\] vssd1 vssd1 vccd1 vccd1 net645
+ sky130_fd_sc_hd__dlygate4sd3_1
Xhold354 MATMULT_INST.matmult_inst.spi_inst.current_state vssd1 vssd1 vccd1 vccd1
+ net667 sky130_fd_sc_hd__dlygate4sd3_1
XFILLER_77_18 vccd1 vssd1 vccd1 vssd1 sky130_ef_sc_hd__decap_40_12
X_3419_ clknet_leaf_7_clk _0371_ vssd1 vssd1 vccd1 vccd1 MATMULT_INST.matmult_inst.alu_inst.adder_inst.r0.fa1.b
+ sky130_fd_sc_hd__dfxtp_1
XANTENNA__2875__B1 net201 vssd1 vssd1 vccd1 vccd1 sky130_fd_sc_hd__diode_2
XFILLER_45_239 vssd1 vssd1 vccd1 vccd1 sky130_fd_sc_hd__fill_1
XTAP_TAPCELL_ROW_36_481 vssd1 vccd1 sky130_fd_sc_hd__tapvpwrvgnd_1
XFILLER_13_169 vccd1 vssd1 vccd1 vssd1 sky130_ef_sc_hd__decap_40_12
XANTENNA__2158__A2 net222 vssd1 vssd1 vccd1 vccd1 sky130_fd_sc_hd__diode_2
XFILLER_5_335 vssd1 vssd1 vccd1 vccd1 sky130_fd_sc_hd__fill_1
XFILLER_3_15 vccd1 vssd1 vccd1 vssd1 sky130_ef_sc_hd__decap_40_12
XTAP_TAPCELL_ROW_79_849 vssd1 vccd1 sky130_fd_sc_hd__tapvpwrvgnd_1
XFILLER_36_228 vssd1 vssd1 vccd1 vccd1 sky130_fd_sc_hd__fill_2
XTAP_TAPCELL_ROW_70_771 vssd1 vccd1 sky130_fd_sc_hd__tapvpwrvgnd_1
X_2721_ net210 net186 net208 net188 vssd1 vssd1 vccd1 vccd1 _1193_ sky130_fd_sc_hd__a22o_1
XFILLER_8_195 vssd1 vssd1 vccd1 vccd1 sky130_fd_sc_hd__fill_1
X_2652_ _1124_ _1125_ vssd1 vssd1 vccd1 vccd1 _1126_ sky130_fd_sc_hd__or2_1
XFILLER_66_3 vssd1 vssd1 vccd1 vccd1 sky130_fd_sc_hd__fill_8
X_2583_ MATMULT_INST.matmult_inst.fsm_inst.state\[3\] _0463_ _1062_ net76 vssd1 vssd1
+ vccd1 vccd1 _1063_ sky130_fd_sc_hd__o211a_1
X_1603_ MATMULT_INST.matmult_inst.fsm_inst.state\[4\] _1495_ vssd1 vssd1 vccd1 vccd1
+ _1521_ sky130_fd_sc_hd__nor2_1
Xfanout119 net122 vssd1 vssd1 vccd1 vccd1 net119 sky130_fd_sc_hd__clkbuf_4
Xfanout108 net111 vssd1 vssd1 vccd1 vccd1 net108 sky130_fd_sc_hd__clkbuf_4
X_3204_ clknet_leaf_20_clk _0162_ net127 vssd1 vssd1 vccd1 vccd1 MATMULT_INST.matmult_inst.mem_inst.matrixA3\[11\]
+ sky130_fd_sc_hd__dfrtp_1
X_3135_ clknet_leaf_24_clk _0093_ net119 vssd1 vssd1 vccd1 vccd1 MATMULT_INST.matmult_inst.mem_inst.matrixA2\[14\]
+ sky130_fd_sc_hd__dfrtp_1
X_3066_ net245 vssd1 vssd1 vccd1 vccd1 _0024_ sky130_fd_sc_hd__inv_2
X_2017_ MATMULT_INST.matmult_inst.alu_inst.adder_inst.r3.fa2.b MATMULT_INST.matmult_inst.alu_inst.adder_inst.r3.fa2.a
+ vssd1 vssd1 vccd1 vccd1 _0594_ sky130_fd_sc_hd__nand2_1
XANTENNA_fanout160_A net161 vssd1 vssd1 vccd1 vccd1 sky130_fd_sc_hd__diode_2
XANTENNA__3034__B1 net79 vssd1 vssd1 vccd1 vccd1 sky130_fd_sc_hd__diode_2
XTAP_TAPCELL_ROW_33_451 vssd1 vccd1 sky130_fd_sc_hd__tapvpwrvgnd_1
XANTENNA__3496__CLK net242 vssd1 vssd1 vccd1 vccd1 sky130_fd_sc_hd__diode_2
X_2919_ net316 MATMULT_INST.matmult_inst.spi_inst.rx_done_sys vssd1 vssd1 vccd1 vccd1
+ _0400_ sky130_fd_sc_hd__or2_1
XFILLER_10_139 vssd1 vssd1 vccd1 vccd1 sky130_fd_sc_hd__fill_1
XANTENNA_fanout213_X net213 vssd1 vssd1 vccd1 vccd1 sky130_fd_sc_hd__diode_2
XFILLER_2_305 vssd1 vssd1 vccd1 vccd1 sky130_fd_sc_hd__fill_2
Xhold151 MATMULT_INST.matmult_inst.mem_inst.matrixB0\[15\] vssd1 vssd1 vccd1 vccd1
+ net464 sky130_fd_sc_hd__dlygate4sd3_1
Xhold140 MATMULT_INST.matmult_inst.alu_inst.col0\[6\] vssd1 vssd1 vccd1 vccd1 net453
+ sky130_fd_sc_hd__dlygate4sd3_1
Xhold162 MATMULT_INST.matmult_inst.mem_inst.matrixB0\[1\] vssd1 vssd1 vccd1 vccd1
+ net475 sky130_fd_sc_hd__dlygate4sd3_1
Xhold184 MATMULT_INST.matmult_inst.mem_inst.matrixA2\[16\] vssd1 vssd1 vccd1 vccd1
+ net497 sky130_fd_sc_hd__dlygate4sd3_1
Xhold173 MATMULT_INST.matmult_inst.mem_inst.mem1\[11\] vssd1 vssd1 vccd1 vccd1 net486
+ sky130_fd_sc_hd__dlygate4sd3_1
Xhold195 MATMULT_INST.matmult_inst.mem_inst.mem1\[3\] vssd1 vssd1 vccd1 vccd1 net508
+ sky130_fd_sc_hd__dlygate4sd3_1
XTAP_TAPCELL_ROW_76_819 vssd1 vccd1 sky130_fd_sc_hd__tapvpwrvgnd_1
XFILLER_37_43 vssd1 vssd1 vccd1 vccd1 sky130_fd_sc_hd__fill_2
XANTENNA__2673__A net204 vssd1 vssd1 vccd1 vccd1 sky130_fd_sc_hd__diode_2
XFILLER_14_456 vssd1 vssd1 vccd1 vccd1 sky130_fd_sc_hd__fill_1
XANTENNA__3025__B1 net78 vssd1 vssd1 vccd1 vccd1 sky130_fd_sc_hd__diode_2
XANTENNA__1736__B net167 vssd1 vssd1 vccd1 vccd1 sky130_fd_sc_hd__diode_2
XFILLER_5_165 vssd1 vssd1 vccd1 vccd1 sky130_fd_sc_hd__fill_2
XFILLER_78_83 vssd1 vssd1 vccd1 vccd1 sky130_fd_sc_hd__fill_1
XFILLER_68_139 vssd1 vssd1 vccd1 vccd1 sky130_fd_sc_hd__fill_1
XFILLER_1_393 vccd1 vssd1 vccd1 vssd1 sky130_ef_sc_hd__decap_40_12
XFILLER_76_150 vssd1 vssd1 vccd1 vccd1 sky130_fd_sc_hd__fill_4
XFILLER_76_194 vssd1 vssd1 vccd1 vccd1 sky130_fd_sc_hd__fill_2
XANTENNA__1898__S net27 vssd1 vssd1 vccd1 vccd1 sky130_fd_sc_hd__diode_2
XANTENNA__2067__A1 net239 vssd1 vssd1 vccd1 vccd1 sky130_fd_sc_hd__diode_2
XANTENNA__2067__B2 net241 vssd1 vssd1 vccd1 vccd1 sky130_fd_sc_hd__diode_2
XANTENNA__3016__B1 net77 vssd1 vssd1 vccd1 vccd1 sky130_fd_sc_hd__diode_2
X_2704_ _1170_ _1172_ _1173_ _1154_ vssd1 vssd1 vccd1 vccd1 _1176_ sky130_fd_sc_hd__o211ai_2
XFILLER_9_493 vssd1 vssd1 vccd1 vccd1 sky130_fd_sc_hd__fill_1
X_2635_ net207 net193 net190 net209 vssd1 vssd1 vccd1 vccd1 _1109_ sky130_fd_sc_hd__nand4_2
X_2566_ _0966_ net557 _1053_ vssd1 vssd1 vccd1 vccd1 _0361_ sky130_fd_sc_hd__mux2_1
XANTENNA__2758__A net187 vssd1 vssd1 vccd1 vccd1 sky130_fd_sc_hd__diode_2
X_2497_ net163 _1002_ _1006_ net158 vssd1 vssd1 vccd1 vccd1 _1009_ sky130_fd_sc_hd__a22o_1
X_3118_ clknet_leaf_19_clk _0076_ net127 vssd1 vssd1 vccd1 vccd1 MATMULT_INST.matmult_inst.mem_inst.matrixA0\[15\]
+ sky130_fd_sc_hd__dfrtp_1
XFILLER_67_183 vssd1 vssd1 vccd1 vccd1 sky130_fd_sc_hd__fill_1
XANTENNA_fanout163_X net163 vssd1 vssd1 vccd1 vccd1 sky130_fd_sc_hd__diode_2
X_3049_ MATMULT_INST.matmult_inst.mem_inst.matrixB2\[16\] net85 net77 MATMULT_INST.matmult_inst.mem_inst.matrixB1\[16\]
+ _1467_ vssd1 vssd1 vccd1 vccd1 _1468_ sky130_fd_sc_hd__a221o_1
XANTENNA__2493__A net182 vssd1 vssd1 vccd1 vccd1 sky130_fd_sc_hd__diode_2
XFILLER_23_23 vssd1 vssd1 vccd1 vccd1 sky130_fd_sc_hd__fill_1
XFILLER_23_89 vssd1 vssd1 vccd1 vccd1 sky130_fd_sc_hd__fill_4
XFILLER_0_27 vssd1 vssd1 vccd1 vccd1 sky130_fd_sc_hd__fill_1
XTAP_TAPCELL_ROW_44_546 vssd1 vccd1 sky130_fd_sc_hd__tapvpwrvgnd_1
XFILLER_64_85 vssd1 vssd1 vccd1 vccd1 sky130_fd_sc_hd__fill_4
XANTENNA__3011__B net169 vssd1 vssd1 vccd1 vccd1 sky130_fd_sc_hd__diode_2
XFILLER_14_253 vccd1 vssd1 vccd1 vssd1 sky130_ef_sc_hd__decap_40_12
XFILLER_9_69 vccd1 vssd1 vccd1 vssd1 sky130_ef_sc_hd__decap_40_12
Xfanout90 net91 vssd1 vssd1 vccd1 vccd1 net90 sky130_fd_sc_hd__clkbuf_4
X_2420_ _1497_ _1507_ net76 _0933_ vssd1 vssd1 vccd1 vccd1 _0939_ sky130_fd_sc_hd__a31o_1
X_2351_ _0880_ _0894_ vssd1 vssd1 vccd1 vccd1 _0896_ sky130_fd_sc_hd__or2_1
XANTENNA__2524__A2 _0954_ vssd1 vssd1 vccd1 vccd1 sky130_fd_sc_hd__diode_2
X_2282_ net216 net231 net233 net214 vssd1 vssd1 vccd1 vccd1 _0829_ sky130_fd_sc_hd__a22oi_1
XFILLER_29_3 vssd1 vssd1 vccd1 vccd1 sky130_fd_sc_hd__fill_2
XFILLER_64_197 vssd1 vssd1 vccd1 vccd1 sky130_fd_sc_hd__fill_8
XANTENNA__2460__B2 net166 vssd1 vssd1 vccd1 vccd1 sky130_fd_sc_hd__diode_2
XANTENNA__2460__A1 net162 vssd1 vssd1 vccd1 vccd1 sky130_fd_sc_hd__diode_2
X_1997_ net336 _0577_ net73 vssd1 vssd1 vccd1 vccd1 _0268_ sky130_fd_sc_hd__mux2_1
XANTENNA_fanout123_A net151 vssd1 vssd1 vccd1 vccd1 sky130_fd_sc_hd__diode_2
X_2618_ _1090_ _1091_ _1078_ vssd1 vssd1 vccd1 vccd1 _1093_ sky130_fd_sc_hd__a21o_1
X_2549_ _1039_ _1041_ _1047_ MATMULT_INST.matmult_inst.fsm_inst.count\[2\] vssd1 vssd1
+ vccd1 vccd1 _1048_ sky130_fd_sc_hd__o22a_1
XANTENNA__2515__A2 net90 vssd1 vssd1 vccd1 vccd1 sky130_fd_sc_hd__diode_2
XANTENNA__2427__S net166 vssd1 vssd1 vccd1 vccd1 sky130_fd_sc_hd__diode_2
XFILLER_43_348 vssd1 vssd1 vccd1 vccd1 sky130_fd_sc_hd__fill_1
XFILLER_55_197 vssd1 vssd1 vccd1 vccd1 sky130_fd_sc_hd__fill_2
XFILLER_70_178 vssd1 vssd1 vccd1 vccd1 sky130_fd_sc_hd__fill_1
XFILLER_34_33 vssd1 vssd1 vccd1 vccd1 sky130_fd_sc_hd__fill_1
XANTENNA__2451__B2 net66 vssd1 vssd1 vccd1 vccd1 sky130_fd_sc_hd__diode_2
XFILLER_11_223 vssd1 vssd1 vccd1 vccd1 sky130_fd_sc_hd__fill_1
XFILLER_7_205 vccd1 vssd1 vccd1 vssd1 sky130_ef_sc_hd__decap_40_12
XFILLER_7_249 vccd1 vssd1 vccd1 vssd1 sky130_ef_sc_hd__decap_40_12
XFILLER_50_54 vssd1 vssd1 vccd1 vccd1 sky130_fd_sc_hd__fill_4
XANTENNA__2506__A2 net90 vssd1 vssd1 vccd1 vccd1 sky130_fd_sc_hd__diode_2
XFILLER_74_473 vssd1 vssd1 vccd1 vccd1 sky130_fd_sc_hd__fill_2
XTAP_TAPCELL_ROW_57_660 vssd1 vccd1 sky130_fd_sc_hd__tapvpwrvgnd_1
XANTENNA__3022__A net176 vssd1 vssd1 vccd1 vccd1 sky130_fd_sc_hd__diode_2
X_1920_ net230 net453 net53 vssd1 vssd1 vccd1 vccd1 _0248_ sky130_fd_sc_hd__mux2_1
XANTENNA__2442__A1 net157 vssd1 vssd1 vccd1 vccd1 sky130_fd_sc_hd__diode_2
XANTENNA__2442__B2 net162 vssd1 vssd1 vccd1 vccd1 sky130_fd_sc_hd__diode_2
X_1851_ net639 net46 net28 vssd1 vssd1 vccd1 vccd1 _0183_ sky130_fd_sc_hd__mux2_1
XTAP_TAPCELL_ROW_12_273 vssd1 vccd1 sky130_fd_sc_hd__tapvpwrvgnd_1
X_3521_ clknet_leaf_24_clk _0446_ net117 vssd1 vssd1 vccd1 vccd1 MATMULT_INST.matmult_inst.spi_inst.tx_reg_sys\[12\]
+ sky130_fd_sc_hd__dfrtp_1
X_1782_ net511 net37 net31 vssd1 vssd1 vccd1 vccd1 _0117_ sky130_fd_sc_hd__mux2_1
XANTENNA_clkbuf_leaf_3_clk_A clknet_2_1__leaf_clk vssd1 vssd1 vccd1 vccd1 sky130_fd_sc_hd__diode_2
X_3452_ _0033_ _0398_ net147 vssd1 vssd1 vccd1 vccd1 MATMULT_INST.matmult_inst.spi_inst.mosi_data_spi\[7\]
+ sky130_fd_sc_hd__dfrtp_1
X_2403_ _0924_ vssd1 vssd1 vccd1 vccd1 _0925_ sky130_fd_sc_hd__inv_2
X_3383_ clknet_leaf_2_clk _0337_ net104 vssd1 vssd1 vccd1 vccd1 MATMULT_INST.matmult_inst.alu_inst.col1\[5\]
+ sky130_fd_sc_hd__dfrtp_1
XFILLER_69_234 vssd1 vssd1 vccd1 vccd1 sky130_fd_sc_hd__fill_2
XFILLER_69_223 vssd1 vssd1 vccd1 vccd1 sky130_fd_sc_hd__fill_1
XANTENNA__2101__A net235 vssd1 vssd1 vccd1 vccd1 sky130_fd_sc_hd__diode_2
X_2334_ _0851_ _0874_ _0875_ vssd1 vssd1 vccd1 vccd1 _0879_ sky130_fd_sc_hd__a21bo_1
XTAP_TAPCELL_ROW_4_208 vssd1 vccd1 sky130_fd_sc_hd__tapvpwrvgnd_1
X_2265_ _0801_ _0812_ vssd1 vssd1 vccd1 vccd1 _0813_ sky130_fd_sc_hd__or2_1
X_2196_ _0671_ _0672_ _0703_ vssd1 vssd1 vccd1 vccd1 _0746_ sky130_fd_sc_hd__and3_1
XFILLER_1_81 vccd1 vssd1 vccd1 vssd1 sky130_ef_sc_hd__decap_40_12
XANTENNA__2433__B2 net158 vssd1 vssd1 vccd1 vccd1 sky130_fd_sc_hd__diode_2
XANTENNA__2433__A1 net163 vssd1 vssd1 vccd1 vccd1 sky130_fd_sc_hd__diode_2
XANTENNA__1674__X _0480_ vssd1 vssd1 vccd1 vccd1 sky130_fd_sc_hd__diode_2
XFILLER_20_35 vssd1 vssd1 vccd1 vccd1 sky130_fd_sc_hd__fill_1
XFILLER_0_414 vssd1 vssd1 vccd1 vccd1 sky130_fd_sc_hd__fill_2
Xhold11 MATMULT_INST.matmult_inst.spi_inst.mosi_data_sync\[5\] vssd1 vssd1 vccd1 vccd1
+ net324 sky130_fd_sc_hd__dlygate4sd3_1
XFILLER_0_469 vssd1 vssd1 vccd1 vccd1 sky130_fd_sc_hd__fill_2
XFILLER_29_33 vssd1 vssd1 vccd1 vccd1 sky130_fd_sc_hd__fill_2
Xhold22 MATMULT_INST.matmult_inst.mem_inst.matrixB3\[6\] vssd1 vssd1 vccd1 vccd1 net335
+ sky130_fd_sc_hd__dlygate4sd3_1
Xhold44 MATMULT_INST.matmult_inst.alu_inst.row1\[2\] vssd1 vssd1 vccd1 vccd1 net357
+ sky130_fd_sc_hd__dlygate4sd3_1
Xhold55 MATMULT_INST.matmult_inst.mem_inst.mem3\[4\] vssd1 vssd1 vccd1 vccd1 net368
+ sky130_fd_sc_hd__dlygate4sd3_1
Xhold33 MATMULT_INST.matmult_inst.mem_inst.matrixA3\[3\] vssd1 vssd1 vccd1 vccd1 net346
+ sky130_fd_sc_hd__dlygate4sd3_1
Xhold99 MATMULT_INST.matmult_inst.mem_inst.mem3\[17\] vssd1 vssd1 vccd1 vccd1 net412
+ sky130_fd_sc_hd__dlygate4sd3_1
Xhold66 MATMULT_INST.matmult_inst.alu_inst.adder_inst.r1.fa2.b vssd1 vssd1 vccd1 vccd1
+ net379 sky130_fd_sc_hd__dlygate4sd3_1
Xhold88 MATMULT_INST.matmult_inst.mem_inst.mem2\[6\] vssd1 vssd1 vccd1 vccd1 net401
+ sky130_fd_sc_hd__dlygate4sd3_1
Xhold77 MATMULT_INST.matmult_inst.mem_inst.matrixA3\[7\] vssd1 vssd1 vccd1 vccd1 net390
+ sky130_fd_sc_hd__dlygate4sd3_1
XFILLER_43_101 vssd1 vssd1 vccd1 vccd1 sky130_fd_sc_hd__fill_8
XTAP_TAPCELL_ROW_54_630 vssd1 vccd1 sky130_fd_sc_hd__tapvpwrvgnd_1
XFILLER_43_167 vssd1 vssd1 vccd1 vccd1 sky130_fd_sc_hd__fill_1
XFILLER_6_15 vccd1 vssd1 vccd1 vssd1 sky130_ef_sc_hd__decap_40_12
XFILLER_20_7 vssd1 vssd1 vccd1 vccd1 sky130_fd_sc_hd__fill_2
XFILLER_66_204 vssd1 vssd1 vccd1 vccd1 sky130_fd_sc_hd__fill_1
X_2050_ net184 net462 net55 vssd1 vssd1 vccd1 vccd1 _0291_ sky130_fd_sc_hd__mux2_1
XFILLER_19_153 vssd1 vssd1 vccd1 vccd1 sky130_fd_sc_hd__fill_4
XANTENNA_max_cap40_X net40 vssd1 vssd1 vccd1 vccd1 sky130_fd_sc_hd__diode_2
XFILLER_22_307 vssd1 vssd1 vccd1 vccd1 sky130_fd_sc_hd__fill_1
X_2952_ net340 _1010_ net58 vssd1 vssd1 vccd1 vccd1 _0439_ sky130_fd_sc_hd__mux2_1
XANTENNA__2591__A net68 vssd1 vssd1 vccd1 vccd1 sky130_fd_sc_hd__diode_2
X_1903_ net457 net51 net27 vssd1 vssd1 vccd1 vccd1 _0232_ sky130_fd_sc_hd__mux2_1
X_2883_ _1279_ _1305_ _1307_ _1332_ _1304_ vssd1 vssd1 vccd1 vccd1 _1350_ sky130_fd_sc_hd__a311o_1
X_1834_ net402 net44 net14 vssd1 vssd1 vccd1 vccd1 _0167_ sky130_fd_sc_hd__mux2_1
XANTENNA__1926__A0 net218 vssd1 vssd1 vccd1 vccd1 sky130_fd_sc_hd__diode_2
X_1765_ net374 net34 net19 vssd1 vssd1 vccd1 vccd1 _0102_ sky130_fd_sc_hd__mux2_1
XANTENNA__2530__S _1035_ vssd1 vssd1 vccd1 vccd1 sky130_fd_sc_hd__diode_2
X_3504_ net242 _0009_ net118 vssd1 vssd1 vccd1 vccd1 MATMULT_INST.matmult_inst.spi_inst.miso_shifter\[12\]
+ sky130_fd_sc_hd__dfrtp_1
X_3435_ clknet_leaf_10_clk MATMULT_INST.matmult_inst.fsm_inst.tx_ready net137 vssd1
+ vssd1 vccd1 vccd1 MATMULT_INST.matmult_inst.fsm_inst.tx_ready_delay sky130_fd_sc_hd__dfrtp_1
X_1696_ net603 net52 net24 vssd1 vssd1 vccd1 vccd1 _0051_ sky130_fd_sc_hd__mux2_1
X_3366_ clknet_leaf_26_clk net424 net100 vssd1 vssd1 vccd1 vccd1 MATMULT_INST.matmult_inst.fsm_inst.alu_result\[12\]
+ sky130_fd_sc_hd__dfrtp_1
X_2317_ _0824_ _0861_ vssd1 vssd1 vccd1 vccd1 _0863_ sky130_fd_sc_hd__or2_1
X_3297_ clknet_leaf_28_clk _0255_ net96 vssd1 vssd1 vccd1 vccd1 MATMULT_INST.matmult_inst.alu_inst.a0_reg\[5\]
+ sky130_fd_sc_hd__dfrtp_1
X_2248_ net213 net238 vssd1 vssd1 vccd1 vccd1 _0796_ sky130_fd_sc_hd__nand2_1
XFILLER_72_218 vssd1 vssd1 vccd1 vccd1 sky130_fd_sc_hd__fill_8
X_2179_ _0727_ _0728_ vssd1 vssd1 vccd1 vccd1 _0729_ sky130_fd_sc_hd__or2_1
XFILLER_65_270 vssd1 vssd1 vccd1 vccd1 sky130_fd_sc_hd__fill_1
XFILLER_13_329 vssd1 vssd1 vccd1 vccd1 sky130_fd_sc_hd__fill_4
XTAP_TAPCELL_ROW_23_368 vssd1 vccd1 sky130_fd_sc_hd__tapvpwrvgnd_1
XFILLER_31_45 vssd1 vssd1 vccd1 vccd1 sky130_fd_sc_hd__fill_1
XFILLER_0_244 vssd1 vssd1 vccd1 vccd1 sky130_fd_sc_hd__fill_4
XFILLER_44_421 vssd1 vssd1 vccd1 vccd1 sky130_fd_sc_hd__fill_1
XFILLER_63_229 vssd1 vssd1 vccd1 vccd1 sky130_fd_sc_hd__fill_1
XFILLER_16_134 vssd1 vssd1 vccd1 vccd1 sky130_fd_sc_hd__fill_4
XFILLER_16_167 vssd1 vssd1 vccd1 vccd1 sky130_fd_sc_hd__fill_4
XANTENNA_clkbuf_2_0__f_clk_X clknet_2_0__leaf_clk vssd1 vssd1 vccd1 vccd1 sky130_fd_sc_hd__diode_2
XFILLER_72_85 vssd1 vssd1 vccd1 vccd1 sky130_fd_sc_hd__fill_2
XFILLER_8_333 vccd1 vssd1 vccd1 vssd1 sky130_ef_sc_hd__decap_40_12
XFILLER_68_7 vssd1 vssd1 vccd1 vccd1 sky130_fd_sc_hd__fill_2
XFILLER_8_377 vccd1 vssd1 vccd1 vssd1 sky130_ef_sc_hd__decap_40_12
X_1550_ MATMULT_INST.matmult_inst.spi_inst.mosi_shifter\[5\] MATMULT_INST.matmult_inst.spi_inst.mosi_shifter\[4\]
+ _1488_ vssd1 vssd1 vccd1 vccd1 _0406_ sky130_fd_sc_hd__mux2_1
X_3220_ clknet_leaf_25_clk _0178_ net102 vssd1 vssd1 vccd1 vccd1 MATMULT_INST.matmult_inst.mem_inst.mem1\[9\]
+ sky130_fd_sc_hd__dfrtp_1
XFILLER_79_373 vssd1 vssd1 vccd1 vccd1 sky130_fd_sc_hd__fill_1
X_3151_ clknet_leaf_27_clk _0109_ net97 vssd1 vssd1 vccd1 vccd1 MATMULT_INST.matmult_inst.mem_inst.mem3\[12\]
+ sky130_fd_sc_hd__dfrtp_1
XFILLER_11_3 vccd1 vssd1 vccd1 vssd1 sky130_ef_sc_hd__decap_40_12
X_2102_ net235 net221 net220 net237 vssd1 vssd1 vccd1 vccd1 _0654_ sky130_fd_sc_hd__a22o_1
XANTENNA__3297__RESET_B net96 vssd1 vssd1 vccd1 vccd1 sky130_fd_sc_hd__diode_2
XANTENNA__1687__A2 net59 vssd1 vssd1 vccd1 vccd1 sky130_fd_sc_hd__diode_2
X_3082_ net244 vssd1 vssd1 vccd1 vccd1 _0040_ sky130_fd_sc_hd__inv_2
XFILLER_35_432 vssd1 vssd1 vccd1 vccd1 sky130_fd_sc_hd__fill_1
X_2033_ MATMULT_INST.matmult_inst.alu_inst.adder_inst.fa.b MATMULT_INST.matmult_inst.alu_inst.adder_inst.fa.a
+ net73 vssd1 vssd1 vccd1 vccd1 _0607_ sky130_fd_sc_hd__o21a_1
XTAP_TAPCELL_ROW_65_725 vssd1 vccd1 sky130_fd_sc_hd__tapvpwrvgnd_1
XFILLER_22_104 vssd1 vssd1 vccd1 vccd1 sky130_fd_sc_hd__fill_2
XTAP_TAPCELL_ROW_73_791 vssd1 vccd1 sky130_fd_sc_hd__tapvpwrvgnd_1
XFILLER_22_159 vssd1 vssd1 vccd1 vccd1 sky130_fd_sc_hd__fill_4
X_2935_ net480 net46 net8 vssd1 vssd1 vccd1 vccd1 _0422_ sky130_fd_sc_hd__mux2_1
XTAP_TAPCELL_ROW_20_338 vssd1 vccd1 sky130_fd_sc_hd__tapvpwrvgnd_1
X_2866_ _1332_ _1333_ vssd1 vssd1 vccd1 vccd1 _1334_ sky130_fd_sc_hd__nand2b_1
X_1817_ _0504_ _0509_ vssd1 vssd1 vccd1 vccd1 _0515_ sky130_fd_sc_hd__nor2_1
X_2797_ _1226_ _1265_ _1264_ vssd1 vssd1 vccd1 vccd1 _1267_ sky130_fd_sc_hd__a21bo_1
Xhold311 MATMULT_INST.matmult_inst.alu_inst.col0\[5\] vssd1 vssd1 vccd1 vccd1 net624
+ sky130_fd_sc_hd__dlygate4sd3_1
Xhold300 MATMULT_INST.matmult_inst.spi_inst.tx_reg_sys\[14\] vssd1 vssd1 vccd1 vccd1
+ net613 sky130_fd_sc_hd__dlygate4sd3_1
Xhold344 MATMULT_INST.matmult_inst.mem_inst.matrixA2\[15\] vssd1 vssd1 vccd1 vccd1
+ net657 sky130_fd_sc_hd__dlygate4sd3_1
Xhold322 MATMULT_INST.matmult_inst.mem_inst.matrixA2\[14\] vssd1 vssd1 vccd1 vccd1
+ net635 sky130_fd_sc_hd__dlygate4sd3_1
XANTENNA__2572__A0 _1033_ vssd1 vssd1 vccd1 vccd1 sky130_fd_sc_hd__diode_2
X_1748_ net633 net51 net21 vssd1 vssd1 vccd1 vccd1 _0088_ sky130_fd_sc_hd__mux2_1
Xhold333 _0309_ vssd1 vssd1 vccd1 vccd1 net646 sky130_fd_sc_hd__dlygate4sd3_1
Xhold355 MATMULT_INST.matmult_inst.fsm_inst.tx_start_send vssd1 vssd1 vccd1 vccd1
+ net668 sky130_fd_sc_hd__dlygate4sd3_1
X_1679_ MATMULT_INST.matmult_inst.fsm_inst.rx_data\[0\] net59 net61 MATMULT_INST.matmult_inst.fsm_inst.alu_result\[0\]
+ vssd1 vssd1 vccd1 vccd1 _0485_ sky130_fd_sc_hd__a22o_1
X_3418_ clknet_leaf_7_clk _0370_ vssd1 vssd1 vccd1 vccd1 MATMULT_INST.matmult_inst.alu_inst.adder_inst.r0.fa0.b
+ sky130_fd_sc_hd__dfxtp_1
X_3349_ clknet_leaf_29_clk _0304_ vssd1 vssd1 vccd1 vccd1 MATMULT_INST.matmult_inst.alu_inst.adder_inst.r3.fa0.a
+ sky130_fd_sc_hd__dfxtp_1
XANTENNA__2875__A1 net198 vssd1 vssd1 vccd1 vccd1 sky130_fd_sc_hd__diode_2
XFILLER_26_45 vssd1 vssd1 vccd1 vccd1 sky130_fd_sc_hd__fill_4
XFILLER_26_56 vssd1 vssd1 vccd1 vccd1 sky130_fd_sc_hd__fill_8
XFILLER_13_137 vccd1 vssd1 vccd1 vssd1 sky130_ef_sc_hd__decap_40_12
XTAP_TAPCELL_ROW_36_482 vssd1 vccd1 sky130_fd_sc_hd__tapvpwrvgnd_1
XFILLER_42_11 vssd1 vssd1 vccd1 vccd1 sky130_fd_sc_hd__fill_1
XFILLER_21_181 vccd1 vssd1 vccd1 vssd1 sky130_ef_sc_hd__decap_40_12
XFILLER_3_27 vccd1 vssd1 vccd1 vssd1 sky130_ef_sc_hd__decap_40_12
XANTENNA__3390__RESET_B net96 vssd1 vssd1 vccd1 vccd1 sky130_fd_sc_hd__diode_2
XFILLER_76_398 vssd1 vssd1 vccd1 vccd1 sky130_fd_sc_hd__fill_2
XANTENNA__3043__A1 net155 vssd1 vssd1 vccd1 vccd1 sky130_fd_sc_hd__diode_2
XANTENNA__3043__B2 net160 vssd1 vssd1 vccd1 vccd1 sky130_fd_sc_hd__diode_2
X_2720_ net212 net184 vssd1 vssd1 vccd1 vccd1 _1192_ sky130_fd_sc_hd__nand2_1
XFILLER_8_141 vccd1 vssd1 vccd1 vssd1 sky130_ef_sc_hd__decap_40_12
X_2651_ _1108_ _1123_ vssd1 vssd1 vccd1 vccd1 _1125_ sky130_fd_sc_hd__and2_1
X_1602_ MATMULT_INST.matmult_inst.fsm_inst.state\[4\] _1496_ vssd1 vssd1 vccd1 vccd1
+ _1520_ sky130_fd_sc_hd__or2_1
X_2582_ MATMULT_INST.matmult_inst.fsm_inst.count\[0\] _1501_ _0457_ net172 vssd1 vssd1
+ vccd1 vccd1 _1062_ sky130_fd_sc_hd__a2bb2o_1
XFILLER_59_3 vssd1 vssd1 vccd1 vccd1 sky130_fd_sc_hd__fill_2
Xfanout109 net111 vssd1 vssd1 vccd1 vccd1 net109 sky130_fd_sc_hd__clkbuf_4
X_3203_ clknet_leaf_24_clk _0161_ net121 vssd1 vssd1 vccd1 vccd1 MATMULT_INST.matmult_inst.mem_inst.matrixA3\[10\]
+ sky130_fd_sc_hd__dfrtp_1
X_3134_ clknet_leaf_21_clk _0092_ net117 vssd1 vssd1 vccd1 vccd1 MATMULT_INST.matmult_inst.mem_inst.matrixA2\[13\]
+ sky130_fd_sc_hd__dfrtp_1
X_3065_ net245 vssd1 vssd1 vccd1 vccd1 _0023_ sky130_fd_sc_hd__inv_2
X_2016_ MATMULT_INST.matmult_inst.alu_inst.adder_inst.r3.fa2.b MATMULT_INST.matmult_inst.alu_inst.adder_inst.r3.fa2.a
+ vssd1 vssd1 vccd1 vccd1 _0593_ sky130_fd_sc_hd__or2_1
XTAP_TAPCELL_ROW_33_452 vssd1 vccd1 sky130_fd_sc_hd__tapvpwrvgnd_1
X_2918_ net664 net67 vssd1 vssd1 vccd1 vccd1 _0386_ sky130_fd_sc_hd__and2_1
Xclkbuf_leaf_30_clk clknet_2_0__leaf_clk vssd1 vssd1 vccd1 vccd1 clknet_leaf_30_clk
+ sky130_fd_sc_hd__clkbuf_8
XFILLER_12_58 vccd1 vssd1 vccd1 vssd1 sky130_ef_sc_hd__decap_40_12
X_2849_ net184 net206 _1288_ _1290_ vssd1 vssd1 vccd1 vccd1 _1317_ sky130_fd_sc_hd__a31o_1
XANTENNA_fanout206_X net206 vssd1 vssd1 vccd1 vccd1 sky130_fd_sc_hd__diode_2
Xhold130 MATMULT_INST.matmult_inst.mem_inst.matrixA2\[6\] vssd1 vssd1 vccd1 vccd1
+ net443 sky130_fd_sc_hd__dlygate4sd3_1
Xhold141 MATMULT_INST.matmult_inst.mem_inst.mem2\[1\] vssd1 vssd1 vccd1 vccd1 net454
+ sky130_fd_sc_hd__dlygate4sd3_1
Xhold152 MATMULT_INST.matmult_inst.alu_inst.adder_inst.r1.fa0.b vssd1 vssd1 vccd1
+ vccd1 net465 sky130_fd_sc_hd__dlygate4sd3_1
Xhold163 MATMULT_INST.matmult_inst.mem_inst.matrixB2\[10\] vssd1 vssd1 vccd1 vccd1
+ net476 sky130_fd_sc_hd__dlygate4sd3_1
Xhold185 MATMULT_INST.matmult_inst.mem_inst.mem0\[4\] vssd1 vssd1 vccd1 vccd1 net498
+ sky130_fd_sc_hd__dlygate4sd3_1
Xhold174 MATMULT_INST.matmult_inst.mem_inst.mem1\[2\] vssd1 vssd1 vccd1 vccd1 net487
+ sky130_fd_sc_hd__dlygate4sd3_1
Xhold196 MATMULT_INST.matmult_inst.mem_inst.matrixB3\[13\] vssd1 vssd1 vccd1 vccd1
+ net509 sky130_fd_sc_hd__dlygate4sd3_1
XFILLER_58_343 vssd1 vssd1 vccd1 vccd1 sky130_fd_sc_hd__fill_1
XFILLER_73_346 vssd1 vssd1 vccd1 vccd1 sky130_fd_sc_hd__fill_2
XANTENNA__2673__B net206 vssd1 vssd1 vccd1 vccd1 sky130_fd_sc_hd__diode_2
XANTENNA_fanout21_X net21 vssd1 vssd1 vccd1 vccd1 sky130_fd_sc_hd__diode_2
XFILLER_41_287 vssd1 vssd1 vccd1 vccd1 sky130_fd_sc_hd__fill_1
Xclkbuf_leaf_21_clk clknet_2_2__leaf_clk vssd1 vssd1 vccd1 vccd1 clknet_leaf_21_clk
+ sky130_fd_sc_hd__clkbuf_8
XFILLER_5_111 vssd1 vssd1 vccd1 vccd1 sky130_fd_sc_hd__fill_1
XFILLER_1_361 vccd1 vssd1 vccd1 vssd1 sky130_ef_sc_hd__decap_40_12
XANTENNA__2067__A2 net222 vssd1 vssd1 vccd1 vccd1 sky130_fd_sc_hd__diode_2
Xclkbuf_leaf_12_clk clknet_2_3__leaf_clk vssd1 vssd1 vccd1 vccd1 clknet_leaf_12_clk
+ sky130_fd_sc_hd__clkbuf_8
XFILLER_9_461 vccd1 vssd1 vccd1 vssd1 sky130_ef_sc_hd__decap_40_12
X_2703_ _1154_ _1173_ _1172_ _1170_ vssd1 vssd1 vccd1 vccd1 _1175_ sky130_fd_sc_hd__a211o_1
XANTENNA__2527__A0 _0952_ vssd1 vssd1 vccd1 vccd1 sky130_fd_sc_hd__diode_2
X_2634_ _1095_ _1100_ _1094_ vssd1 vssd1 vccd1 vccd1 _1108_ sky130_fd_sc_hd__o21bai_1
X_2565_ _0952_ net535 _1053_ vssd1 vssd1 vccd1 vccd1 _0360_ sky130_fd_sc_hd__mux2_1
XANTENNA__2758__B net186 vssd1 vssd1 vccd1 vccd1 sky130_fd_sc_hd__diode_2
X_2496_ MATMULT_INST.matmult_inst.mem_inst.matrixA2\[5\] net91 net84 MATMULT_INST.matmult_inst.mem_inst.matrixA1\[5\]
+ _1007_ vssd1 vssd1 vccd1 vccd1 _1008_ sky130_fd_sc_hd__a221o_1
XFILLER_4_81 vssd1 vssd1 vccd1 vccd1 sky130_fd_sc_hd__fill_2
X_3117_ clknet_leaf_24_clk _0075_ net116 vssd1 vssd1 vccd1 vccd1 MATMULT_INST.matmult_inst.mem_inst.matrixA0\[14\]
+ sky130_fd_sc_hd__dfrtp_1
X_3048_ net176 net167 MATMULT_INST.matmult_inst.mem_inst.matrixB3\[16\] vssd1 vssd1
+ vccd1 vccd1 _1467_ sky130_fd_sc_hd__and3_1
XANTENNA__2058__A2 net67 vssd1 vssd1 vccd1 vccd1 sky130_fd_sc_hd__diode_2
XANTENNA__2493__B net173 vssd1 vssd1 vccd1 vccd1 sky130_fd_sc_hd__diode_2
XFILLER_23_210 vccd1 vssd1 vccd1 vssd1 sky130_ef_sc_hd__decap_40_12
XANTENNA_fanout156_X net156 vssd1 vssd1 vccd1 vccd1 sky130_fd_sc_hd__diode_2
XFILLER_11_405 vccd1 vssd1 vccd1 vssd1 sky130_ef_sc_hd__decap_40_12
XANTENNA__3007__A1 net165 vssd1 vssd1 vccd1 vccd1 sky130_fd_sc_hd__diode_2
XANTENNA__3007__B2 net160 vssd1 vssd1 vccd1 vccd1 sky130_fd_sc_hd__diode_2
XFILLER_11_449 vccd1 vssd1 vccd1 vssd1 sky130_ef_sc_hd__decap_40_12
XFILLER_23_68 vssd1 vssd1 vccd1 vccd1 sky130_fd_sc_hd__fill_8
XFILLER_58_151 vssd1 vssd1 vccd1 vccd1 sky130_fd_sc_hd__fill_1
XFILLER_46_302 vssd1 vssd1 vccd1 vccd1 sky130_fd_sc_hd__fill_1
XFILLER_58_195 vssd1 vssd1 vccd1 vccd1 sky130_fd_sc_hd__fill_1
XFILLER_14_221 vccd1 vssd1 vccd1 vssd1 sky130_ef_sc_hd__decap_40_12
XTAP_TAPCELL_ROW_1_180 vssd1 vccd1 sky130_fd_sc_hd__tapvpwrvgnd_1
XTAP_TAPCELL_ROW_44_547 vssd1 vccd1 sky130_fd_sc_hd__tapvpwrvgnd_1
XFILLER_14_265 vccd1 vssd1 vccd1 vssd1 sky130_ef_sc_hd__decap_40_12
XFILLER_9_15 vccd1 vssd1 vccd1 vssd1 sky130_ef_sc_hd__decap_40_12
Xfanout80 _0512_ vssd1 vssd1 vccd1 vccd1 net80 sky130_fd_sc_hd__clkbuf_2
Xfanout91 _0506_ vssd1 vssd1 vccd1 vccd1 net91 sky130_fd_sc_hd__buf_2
XFILLER_10_493 vssd1 vssd1 vccd1 vccd1 sky130_fd_sc_hd__fill_1
XFILLER_6_475 vssd1 vssd1 vccd1 vccd1 sky130_fd_sc_hd__fill_1
X_2350_ _0880_ _0894_ vssd1 vssd1 vccd1 vccd1 _0895_ sky130_fd_sc_hd__and2_1
X_2281_ _0796_ _0798_ _0797_ vssd1 vssd1 vccd1 vccd1 _0828_ sky130_fd_sc_hd__a21bo_1
Xclkbuf_leaf_1_clk clknet_2_0__leaf_clk vssd1 vssd1 vccd1 vccd1 clknet_leaf_1_clk
+ sky130_fd_sc_hd__clkbuf_8
XFILLER_49_162 vssd1 vssd1 vccd1 vccd1 sky130_fd_sc_hd__fill_4
XFILLER_49_173 vssd1 vssd1 vccd1 vccd1 sky130_fd_sc_hd__fill_2
XANTENNA__1702__S net24 vssd1 vssd1 vccd1 vccd1 sky130_fd_sc_hd__diode_2
XFILLER_37_335 vssd1 vssd1 vccd1 vccd1 sky130_fd_sc_hd__fill_1
XANTENNA__2533__S _1035_ vssd1 vssd1 vccd1 vccd1 sky130_fd_sc_hd__diode_2
X_1996_ _0575_ _0576_ vssd1 vssd1 vccd1 vccd1 _0577_ sky130_fd_sc_hd__xnor2_1
XANTENNA__2212__A2 net222 vssd1 vssd1 vccd1 vccd1 sky130_fd_sc_hd__diode_2
XANTENNA__1673__A net178 vssd1 vssd1 vccd1 vccd1 sky130_fd_sc_hd__diode_2
X_2617_ _1078_ _1090_ _1091_ vssd1 vssd1 vccd1 vccd1 _1092_ sky130_fd_sc_hd__nand3_1
X_2548_ _0459_ _1039_ vssd1 vssd1 vccd1 vccd1 _1047_ sky130_fd_sc_hd__nor2_1
XTAP_TAPCELL_ROW_7_228 vssd1 vccd1 sky130_fd_sc_hd__tapvpwrvgnd_1
X_2479_ net157 MATMULT_INST.matmult_inst.mem_inst.mem0\[4\] MATMULT_INST.matmult_inst.mem_inst.matrixB0\[4\]
+ net162 vssd1 vssd1 vccd1 vccd1 _0992_ sky130_fd_sc_hd__a22o_1
XFILLER_68_493 vssd1 vssd1 vccd1 vccd1 sky130_fd_sc_hd__fill_1
XFILLER_70_146 vssd1 vssd1 vccd1 vccd1 sky130_fd_sc_hd__fill_1
XFILLER_34_45 vssd1 vssd1 vccd1 vccd1 sky130_fd_sc_hd__fill_1
XANTENNA__2451__A2 _0954_ vssd1 vssd1 vccd1 vccd1 sky130_fd_sc_hd__diode_2
XTAP_TAPCELL_ROW_41_517 vssd1 vccd1 sky130_fd_sc_hd__tapvpwrvgnd_1
XFILLER_11_279 vssd1 vssd1 vccd1 vccd1 sky130_fd_sc_hd__fill_1
XFILLER_7_217 vssd1 vssd1 vccd1 vccd1 sky130_fd_sc_hd__fill_4
Xclkload0 clknet_2_0__leaf_clk vssd1 vssd1 vccd1 vccd1 clkload0/Y sky130_fd_sc_hd__clkinvlp_4
XFILLER_50_11 vssd1 vssd1 vccd1 vccd1 sky130_fd_sc_hd__fill_2
XFILLER_3_445 vssd1 vssd1 vccd1 vccd1 sky130_fd_sc_hd__fill_2
XFILLER_66_419 vssd1 vssd1 vccd1 vccd1 sky130_fd_sc_hd__fill_1
XFILLER_75_30 vssd1 vssd1 vccd1 vccd1 sky130_fd_sc_hd__fill_4
XFILLER_46_110 vssd1 vssd1 vccd1 vccd1 sky130_fd_sc_hd__fill_4
XFILLER_59_493 vssd1 vssd1 vccd1 vccd1 sky130_fd_sc_hd__fill_1
XANTENNA__3022__B net167 vssd1 vssd1 vccd1 vccd1 sky130_fd_sc_hd__diode_2
XFILLER_34_338 vssd1 vssd1 vccd1 vccd1 sky130_fd_sc_hd__fill_1
XFILLER_61_113 vssd1 vssd1 vccd1 vccd1 sky130_fd_sc_hd__fill_8
XANTENNA__2978__B1 net78 vssd1 vssd1 vccd1 vccd1 sky130_fd_sc_hd__diode_2
XANTENNA__1758__A net157 vssd1 vssd1 vccd1 vccd1 sky130_fd_sc_hd__diode_2
X_1850_ net537 net47 net29 vssd1 vssd1 vccd1 vccd1 _0182_ sky130_fd_sc_hd__mux2_1
X_1781_ net576 net38 net31 vssd1 vssd1 vccd1 vccd1 _0116_ sky130_fd_sc_hd__mux2_1
XTAP_TAPCELL_ROW_12_274 vssd1 vccd1 sky130_fd_sc_hd__tapvpwrvgnd_1
X_3520_ clknet_leaf_19_clk _0445_ net128 vssd1 vssd1 vccd1 vccd1 MATMULT_INST.matmult_inst.spi_inst.tx_reg_sys\[11\]
+ sky130_fd_sc_hd__dfrtp_1
X_3451_ _0032_ _0397_ net148 vssd1 vssd1 vccd1 vccd1 MATMULT_INST.matmult_inst.spi_inst.mosi_data_spi\[6\]
+ sky130_fd_sc_hd__dfrtp_1
X_2402_ MATMULT_INST.matmult_inst.fsm_inst.count\[2\] _1483_ _1529_ _1522_ vssd1 vssd1
+ vccd1 vccd1 _0924_ sky130_fd_sc_hd__a31o_1
XFILLER_41_3 vccd1 vssd1 vccd1 vssd1 sky130_ef_sc_hd__decap_40_12
X_3382_ clknet_leaf_2_clk _0336_ net114 vssd1 vssd1 vccd1 vccd1 MATMULT_INST.matmult_inst.alu_inst.col1\[4\]
+ sky130_fd_sc_hd__dfrtp_1
X_2333_ net67 _0876_ _0877_ _0878_ vssd1 vssd1 vccd1 vccd1 _0303_ sky130_fd_sc_hd__o31a_1
XTAP_TAPCELL_ROW_4_209 vssd1 vccd1 sky130_fd_sc_hd__tapvpwrvgnd_1
XFILLER_69_279 vssd1 vssd1 vccd1 vccd1 sky130_fd_sc_hd__fill_1
X_2264_ _0809_ _0810_ _0802_ vssd1 vssd1 vccd1 vccd1 _0812_ sky130_fd_sc_hd__a21o_1
X_2195_ _0743_ _0744_ vssd1 vssd1 vccd1 vccd1 _0745_ sky130_fd_sc_hd__or2_1
XANTENNA__2528__S _1035_ vssd1 vssd1 vccd1 vccd1 sky130_fd_sc_hd__diode_2
XFILLER_1_93 vccd1 vssd1 vccd1 vssd1 sky130_ef_sc_hd__decap_40_12
XANTENNA__3501__CLK net242 vssd1 vssd1 vccd1 vccd1 sky130_fd_sc_hd__diode_2
X_1979_ MATMULT_INST.matmult_inst.alu_inst.adder_inst.r2.fa0.b MATMULT_INST.matmult_inst.alu_inst.adder_inst.r2.fa0.a
+ vssd1 vssd1 vccd1 vccd1 _0562_ sky130_fd_sc_hd__nor2_1
XFILLER_4_209 vccd1 vssd1 vccd1 vssd1 sky130_ef_sc_hd__decap_40_12
XFILLER_0_426 vssd1 vssd1 vccd1 vccd1 sky130_fd_sc_hd__fill_4
Xhold12 _0431_ vssd1 vssd1 vccd1 vccd1 net325 sky130_fd_sc_hd__dlygate4sd3_1
Xhold23 MATMULT_INST.matmult_inst.alu_inst.out\[10\] vssd1 vssd1 vccd1 vccd1 net336
+ sky130_fd_sc_hd__dlygate4sd3_1
Xhold34 MATMULT_INST.matmult_inst.mem_inst.mem3\[6\] vssd1 vssd1 vccd1 vccd1 net347
+ sky130_fd_sc_hd__dlygate4sd3_1
Xhold56 MATMULT_INST.matmult_inst.mem_inst.matrixB3\[10\] vssd1 vssd1 vccd1 vccd1
+ net369 sky130_fd_sc_hd__dlygate4sd3_1
Xhold45 MATMULT_INST.matmult_inst.alu_inst.adder_inst.r2.fa2.b vssd1 vssd1 vccd1 vccd1
+ net358 sky130_fd_sc_hd__dlygate4sd3_1
Xhold89 MATMULT_INST.matmult_inst.mem_inst.matrixA3\[16\] vssd1 vssd1 vccd1 vccd1
+ net402 sky130_fd_sc_hd__dlygate4sd3_1
Xhold67 MATMULT_INST.matmult_inst.alu_inst.adder_inst.r2.fa3.b vssd1 vssd1 vccd1 vccd1
+ net380 sky130_fd_sc_hd__dlygate4sd3_1
Xhold78 MATMULT_INST.matmult_inst.mem_inst.mem3\[3\] vssd1 vssd1 vccd1 vccd1 net391
+ sky130_fd_sc_hd__dlygate4sd3_1
XFILLER_28_143 vssd1 vssd1 vccd1 vccd1 sky130_fd_sc_hd__fill_2
XANTENNA__2672__A2 net192 vssd1 vssd1 vccd1 vccd1 sky130_fd_sc_hd__diode_2
XFILLER_16_327 vssd1 vssd1 vccd1 vccd1 sky130_fd_sc_hd__fill_1
XFILLER_43_113 vssd1 vssd1 vccd1 vccd1 sky130_fd_sc_hd__fill_4
XFILLER_45_55 vssd1 vssd1 vccd1 vccd1 sky130_fd_sc_hd__fill_1
XFILLER_45_77 vssd1 vssd1 vccd1 vccd1 sky130_fd_sc_hd__fill_4
XTAP_TAPCELL_ROW_54_631 vssd1 vccd1 sky130_fd_sc_hd__tapvpwrvgnd_1
XFILLER_6_27 vssd1 vssd1 vccd1 vccd1 sky130_fd_sc_hd__fill_1
XFILLER_39_408 vssd1 vssd1 vccd1 vccd1 sky130_fd_sc_hd__fill_1
XANTENNA__3033__A net178 vssd1 vssd1 vccd1 vccd1 sky130_fd_sc_hd__diode_2
X_2951_ net348 _0999_ net58 vssd1 vssd1 vccd1 vccd1 _0438_ sky130_fd_sc_hd__mux2_1
X_1902_ net565 net52 net26 vssd1 vssd1 vccd1 vccd1 _0231_ sky130_fd_sc_hd__mux2_1
XANTENNA_clkbuf_0_clk_A clk vssd1 vssd1 vccd1 vccd1 sky130_fd_sc_hd__diode_2
X_2882_ _1327_ _1347_ _1348_ vssd1 vssd1 vccd1 vccd1 _1349_ sky130_fd_sc_hd__nand3_1
XTAP_TAPCELL_ROW_60_678 vssd1 vccd1 sky130_fd_sc_hd__tapvpwrvgnd_1
X_1833_ net598 _0500_ net14 vssd1 vssd1 vccd1 vccd1 _0166_ sky130_fd_sc_hd__mux2_1
X_1764_ net368 net35 net18 vssd1 vssd1 vccd1 vccd1 _0101_ sky130_fd_sc_hd__mux2_1
X_3503_ net242 _0008_ net128 vssd1 vssd1 vccd1 vccd1 MATMULT_INST.matmult_inst.spi_inst.miso_shifter\[11\]
+ sky130_fd_sc_hd__dfrtp_1
X_3434_ clknet_leaf_1_clk _0386_ vssd1 vssd1 vccd1 vccd1 MATMULT_INST.matmult_inst.alu_inst.adder_inst.fa.b
+ sky130_fd_sc_hd__dfxtp_1
X_1695_ MATMULT_INST.matmult_inst.fsm_inst.alu_result\[8\] net60 vssd1 vssd1 vccd1
+ vccd1 _0493_ sky130_fd_sc_hd__and2_1
X_3365_ clknet_leaf_25_clk net574 net101 vssd1 vssd1 vccd1 vccd1 MATMULT_INST.matmult_inst.fsm_inst.alu_result\[11\]
+ sky130_fd_sc_hd__dfrtp_1
X_2316_ _0824_ _0861_ vssd1 vssd1 vccd1 vccd1 _0862_ sky130_fd_sc_hd__and2_1
X_3296_ clknet_leaf_26_clk _0254_ net99 vssd1 vssd1 vccd1 vccd1 MATMULT_INST.matmult_inst.alu_inst.a0_reg\[4\]
+ sky130_fd_sc_hd__dfrtp_1
X_2247_ _0793_ _0794_ vssd1 vssd1 vccd1 vccd1 _0795_ sky130_fd_sc_hd__nor2_1
X_2178_ _0725_ _0726_ _0689_ vssd1 vssd1 vccd1 vccd1 _0728_ sky130_fd_sc_hd__a21oi_1
XFILLER_65_260 vssd1 vssd1 vccd1 vccd1 sky130_fd_sc_hd__fill_8
XTAP_TAPCELL_ROW_23_369 vssd1 vccd1 sky130_fd_sc_hd__tapvpwrvgnd_1
XFILLER_31_57 vssd1 vssd1 vccd1 vccd1 sky130_fd_sc_hd__fill_8
XANTENNA_fanout96_A net152 vssd1 vssd1 vccd1 vccd1 sky130_fd_sc_hd__diode_2
XFILLER_0_278 vssd1 vssd1 vccd1 vccd1 sky130_fd_sc_hd__fill_2
XFILLER_56_54 vssd1 vssd1 vccd1 vccd1 sky130_fd_sc_hd__fill_1
XANTENNA__2645__A2 net203 vssd1 vssd1 vccd1 vccd1 sky130_fd_sc_hd__diode_2
XFILLER_16_102 vccd1 vssd1 vccd1 vssd1 sky130_ef_sc_hd__decap_40_12
XANTENNA_clkbuf_leaf_2_clk_A clknet_2_1__leaf_clk vssd1 vssd1 vccd1 vccd1 sky130_fd_sc_hd__diode_2
XFILLER_71_241 vssd1 vssd1 vccd1 vccd1 sky130_fd_sc_hd__fill_1
XPHY_EDGE_ROW_19_Right_19 vssd1 vssd1 vccd1 vccd1 sky130_fd_sc_hd__decap_3
XANTENNA__1800__S net17 vssd1 vssd1 vccd1 vccd1 sky130_fd_sc_hd__diode_2
XFILLER_12_363 vssd1 vssd1 vccd1 vccd1 sky130_fd_sc_hd__fill_1
XFILLER_8_301 vssd1 vssd1 vccd1 vccd1 sky130_fd_sc_hd__fill_4
XFILLER_8_345 vccd1 vssd1 vccd1 vssd1 sky130_ef_sc_hd__decap_40_12
XFILLER_8_389 vccd1 vssd1 vccd1 vssd1 sky130_ef_sc_hd__decap_40_12
XPHY_EDGE_ROW_28_Right_28 vssd1 vssd1 vccd1 vccd1 sky130_fd_sc_hd__decap_3
XFILLER_79_363 vssd1 vssd1 vccd1 vccd1 sky130_fd_sc_hd__fill_1
XANTENNA__2333__A1 net67 vssd1 vssd1 vccd1 vccd1 sky130_fd_sc_hd__diode_2
X_3150_ clknet_leaf_19_clk _0108_ net128 vssd1 vssd1 vccd1 vccd1 MATMULT_INST.matmult_inst.mem_inst.mem3\[11\]
+ sky130_fd_sc_hd__dfrtp_1
X_3081_ net244 vssd1 vssd1 vccd1 vccd1 _0039_ sky130_fd_sc_hd__inv_2
X_2101_ net235 net221 net220 net237 vssd1 vssd1 vccd1 vccd1 _0653_ sky130_fd_sc_hd__nand4_2
X_2032_ MATMULT_INST.matmult_inst.alu_inst.adder_inst.fa.b MATMULT_INST.matmult_inst.alu_inst.adder_inst.fa.a
+ _0604_ vssd1 vssd1 vccd1 vccd1 _0606_ sky130_fd_sc_hd__a21o_1
XPHY_EDGE_ROW_37_Right_37 vssd1 vssd1 vccd1 vccd1 sky130_fd_sc_hd__decap_3
XTAP_TAPCELL_ROW_65_726 vssd1 vccd1 sky130_fd_sc_hd__tapvpwrvgnd_1
XANTENNA__1710__S net24 vssd1 vssd1 vccd1 vccd1 sky130_fd_sc_hd__diode_2
XTAP_TAPCELL_ROW_73_792 vssd1 vccd1 sky130_fd_sc_hd__tapvpwrvgnd_1
X_2934_ net509 net47 net8 vssd1 vssd1 vccd1 vccd1 _0421_ sky130_fd_sc_hd__mux2_1
XANTENNA__3061__A2 net87 vssd1 vssd1 vccd1 vccd1 sky130_fd_sc_hd__diode_2
XTAP_TAPCELL_ROW_20_339 vssd1 vccd1 sky130_fd_sc_hd__tapvpwrvgnd_1
X_2865_ _1301_ _1331_ _1330_ vssd1 vssd1 vccd1 vccd1 _1333_ sky130_fd_sc_hd__a21o_1
X_1816_ net501 net43 net16 vssd1 vssd1 vccd1 vccd1 _0150_ sky130_fd_sc_hd__mux2_1
XPHY_EDGE_ROW_46_Right_46 vssd1 vssd1 vccd1 vccd1 sky130_fd_sc_hd__decap_3
X_2796_ _1225_ _1264_ _1265_ vssd1 vssd1 vccd1 vccd1 _1266_ sky130_fd_sc_hd__nor3b_1
XFILLER_7_81 vccd1 vssd1 vccd1 vssd1 sky130_ef_sc_hd__decap_40_12
Xhold301 MATMULT_INST.matmult_inst.mem_inst.mem0\[7\] vssd1 vssd1 vccd1 vccd1 net614
+ sky130_fd_sc_hd__dlygate4sd3_1
Xhold312 MATMULT_INST.matmult_inst.mem_inst.mem0\[16\] vssd1 vssd1 vccd1 vccd1 net625
+ sky130_fd_sc_hd__dlygate4sd3_1
Xhold323 MATMULT_INST.matmult_inst.mem_inst.mem1\[9\] vssd1 vssd1 vccd1 vccd1 net636
+ sky130_fd_sc_hd__dlygate4sd3_1
X_1747_ net488 net52 net20 vssd1 vssd1 vccd1 vccd1 _0087_ sky130_fd_sc_hd__mux2_1
Xhold334 MATMULT_INST.matmult_inst.alu_inst.adder_inst.r3.fa3.b vssd1 vssd1 vccd1
+ vccd1 net647 sky130_fd_sc_hd__dlygate4sd3_1
Xhold345 MATMULT_INST.matmult_inst.alu_inst.adder_inst.r2.fa0.a vssd1 vssd1 vccd1
+ vccd1 net658 sky130_fd_sc_hd__dlygate4sd3_1
Xhold356 MATMULT_INST.matmult_inst.alu_inst.adder_inst.r0.fa0.a vssd1 vssd1 vccd1
+ vccd1 net669 sky130_fd_sc_hd__dlygate4sd3_1
X_1678_ _0480_ _0483_ vssd1 vssd1 vccd1 vccd1 _0484_ sky130_fd_sc_hd__nor2_1
X_3417_ clknet_leaf_10_clk net316 net137 vssd1 vssd1 vccd1 vccd1 MATMULT_INST.matmult_inst.fsm_inst.rx_valid_delay
+ sky130_fd_sc_hd__dfrtp_1
X_3348_ clknet_leaf_29_clk _0303_ vssd1 vssd1 vccd1 vccd1 MATMULT_INST.matmult_inst.alu_inst.adder_inst.r2.fa3.a
+ sky130_fd_sc_hd__dfxtp_1
XANTENNA__2875__A2 net187 vssd1 vssd1 vccd1 vccd1 sky130_fd_sc_hd__diode_2
X_3279_ clknet_leaf_24_clk _0237_ net119 vssd1 vssd1 vccd1 vccd1 MATMULT_INST.matmult_inst.mem_inst.matrixA1\[14\]
+ sky130_fd_sc_hd__dfrtp_1
XANTENNA_fanout186_X net186 vssd1 vssd1 vccd1 vccd1 sky130_fd_sc_hd__diode_2
XPHY_EDGE_ROW_55_Right_55 vssd1 vssd1 vccd1 vccd1 sky130_fd_sc_hd__decap_3
XTAP_TAPCELL_ROW_28_406 vssd1 vccd1 sky130_fd_sc_hd__tapvpwrvgnd_1
XFILLER_38_282 vssd1 vssd1 vccd1 vccd1 sky130_fd_sc_hd__fill_1
XFILLER_26_477 vssd1 vssd1 vccd1 vccd1 sky130_fd_sc_hd__fill_1
XFILLER_13_149 vccd1 vssd1 vccd1 vssd1 sky130_ef_sc_hd__decap_40_12
XFILLER_41_447 vssd1 vssd1 vccd1 vccd1 sky130_fd_sc_hd__fill_1
XFILLER_9_109 vssd1 vssd1 vccd1 vccd1 sky130_fd_sc_hd__fill_2
XANTENNA__3052__A2 net64 vssd1 vssd1 vccd1 vccd1 sky130_fd_sc_hd__diode_2
XPHY_EDGE_ROW_64_Right_64 vssd1 vssd1 vccd1 vccd1 sky130_fd_sc_hd__decap_3
XFILLER_21_193 vccd1 vssd1 vccd1 vssd1 sky130_ef_sc_hd__decap_40_12
XFILLER_5_337 vccd1 vssd1 vccd1 vssd1 sky130_ef_sc_hd__decap_40_12
XANTENNA__2563__A1 _1033_ vssd1 vssd1 vccd1 vccd1 sky130_fd_sc_hd__diode_2
XFILLER_3_39 vccd1 vssd1 vccd1 vssd1 sky130_ef_sc_hd__decap_40_12
XPHY_EDGE_ROW_73_Right_73 vssd1 vssd1 vccd1 vccd1 sky130_fd_sc_hd__decap_3
XFILLER_12_193 vssd1 vssd1 vccd1 vccd1 sky130_fd_sc_hd__fill_2
XFILLER_8_153 vccd1 vssd1 vccd1 vssd1 sky130_ef_sc_hd__decap_40_12
X_2650_ _1108_ _1123_ vssd1 vssd1 vccd1 vccd1 _1124_ sky130_fd_sc_hd__nor2_1
XFILLER_8_197 vccd1 vssd1 vccd1 vssd1 sky130_ef_sc_hd__decap_40_12
X_1601_ MATMULT_INST.matmult_inst.fsm_inst.state\[1\] MATMULT_INST.matmult_inst.fsm_inst.state\[4\]
+ _1496_ vssd1 vssd1 vccd1 vccd1 _1519_ sky130_fd_sc_hd__nand3_1
X_2581_ _1503_ _0469_ _1056_ vssd1 vssd1 vccd1 vccd1 _1061_ sky130_fd_sc_hd__o21ba_1
X_3202_ clknet_leaf_25_clk _0160_ net101 vssd1 vssd1 vccd1 vccd1 MATMULT_INST.matmult_inst.mem_inst.matrixA3\[9\]
+ sky130_fd_sc_hd__dfrtp_1
X_3133_ clknet_leaf_23_clk _0091_ net97 vssd1 vssd1 vccd1 vccd1 MATMULT_INST.matmult_inst.mem_inst.matrixA2\[12\]
+ sky130_fd_sc_hd__dfrtp_1
X_3064_ net422 _1481_ net57 vssd1 vssd1 vccd1 vccd1 _0451_ sky130_fd_sc_hd__mux2_1
X_2015_ net417 _0592_ net73 vssd1 vssd1 vccd1 vccd1 _0271_ sky130_fd_sc_hd__mux2_1
XPHY_EDGE_ROW_19_Left_99 vssd1 vssd1 vccd1 vccd1 sky130_fd_sc_hd__decap_3
XFILLER_23_414 vssd1 vssd1 vccd1 vccd1 sky130_fd_sc_hd__fill_1
XFILLER_23_447 vssd1 vssd1 vccd1 vccd1 sky130_fd_sc_hd__fill_1
XANTENNA__2490__B1 net83 vssd1 vssd1 vccd1 vccd1 sky130_fd_sc_hd__diode_2
XANTENNA__3034__A2 net87 vssd1 vssd1 vccd1 vccd1 sky130_fd_sc_hd__diode_2
XTAP_TAPCELL_ROW_33_453 vssd1 vccd1 sky130_fd_sc_hd__tapvpwrvgnd_1
X_2917_ _1379_ _1380_ net647 net69 vssd1 vssd1 vccd1 vccd1 _0385_ sky130_fd_sc_hd__o2bb2a_1
XFILLER_12_15 vccd1 vssd1 vccd1 vssd1 sky130_ef_sc_hd__decap_40_12
XANTENNA__1676__A net59 vssd1 vssd1 vccd1 vccd1 sky130_fd_sc_hd__diode_2
XFILLER_12_37 vssd1 vssd1 vccd1 vccd1 sky130_fd_sc_hd__fill_2
X_2848_ _1257_ _1314_ _1313_ vssd1 vssd1 vccd1 vccd1 _1316_ sky130_fd_sc_hd__a21bo_1
X_2779_ _1245_ _1248_ vssd1 vssd1 vccd1 vccd1 _1249_ sky130_fd_sc_hd__xor2_1
XFILLER_2_307 vssd1 vssd1 vccd1 vccd1 sky130_fd_sc_hd__fill_1
Xhold142 MATMULT_INST.matmult_inst.mem_inst.mem2\[12\] vssd1 vssd1 vccd1 vccd1 net455
+ sky130_fd_sc_hd__dlygate4sd3_1
Xhold131 MATMULT_INST.matmult_inst.mem_inst.matrixA0\[5\] vssd1 vssd1 vccd1 vccd1
+ net444 sky130_fd_sc_hd__dlygate4sd3_1
Xhold120 MATMULT_INST.matmult_inst.spi_inst.tx_reg_sys\[7\] vssd1 vssd1 vccd1 vccd1
+ net433 sky130_fd_sc_hd__dlygate4sd3_1
Xhold153 MATMULT_INST.matmult_inst.mem_inst.matrixA2\[5\] vssd1 vssd1 vccd1 vccd1
+ net466 sky130_fd_sc_hd__dlygate4sd3_1
Xhold175 MATMULT_INST.matmult_inst.mem_inst.matrixA2\[8\] vssd1 vssd1 vccd1 vccd1
+ net488 sky130_fd_sc_hd__dlygate4sd3_1
Xhold186 MATMULT_INST.matmult_inst.mem_inst.mem2\[4\] vssd1 vssd1 vccd1 vccd1 net499
+ sky130_fd_sc_hd__dlygate4sd3_1
Xhold164 MATMULT_INST.matmult_inst.mem_inst.matrixA2\[7\] vssd1 vssd1 vccd1 vccd1
+ net477 sky130_fd_sc_hd__dlygate4sd3_1
Xhold197 MATMULT_INST.matmult_inst.mem_inst.matrixB3\[16\] vssd1 vssd1 vccd1 vccd1
+ net510 sky130_fd_sc_hd__dlygate4sd3_1
XFILLER_37_45 vssd1 vssd1 vccd1 vccd1 sky130_fd_sc_hd__fill_1
XANTENNA_fanout59_A _0467_ vssd1 vssd1 vccd1 vccd1 sky130_fd_sc_hd__diode_2
XANTENNA__2673__C net192 vssd1 vssd1 vccd1 vccd1 sky130_fd_sc_hd__diode_2
XFILLER_14_403 vssd1 vssd1 vccd1 vccd1 sky130_fd_sc_hd__fill_1
XFILLER_26_263 vssd1 vssd1 vccd1 vccd1 sky130_fd_sc_hd__fill_4
XFILLER_41_222 vssd1 vssd1 vccd1 vccd1 sky130_fd_sc_hd__fill_2
XFILLER_41_233 vssd1 vssd1 vccd1 vccd1 sky130_fd_sc_hd__fill_1
XANTENNA__2970__A net177 vssd1 vssd1 vccd1 vccd1 sky130_fd_sc_hd__diode_2
XANTENNA_fanout14_X net14 vssd1 vssd1 vccd1 vccd1 sky130_fd_sc_hd__diode_2
XFILLER_5_167 vssd1 vssd1 vccd1 vccd1 sky130_fd_sc_hd__fill_1
XFILLER_78_41 vccd1 vssd1 vccd1 vssd1 sky130_ef_sc_hd__decap_40_12
XFILLER_78_85 vccd1 vssd1 vccd1 vssd1 sky130_ef_sc_hd__decap_40_12
XFILLER_1_373 vccd1 vssd1 vccd1 vssd1 sky130_ef_sc_hd__decap_40_12
XTAP_TAPCELL_ROW_75_810 vssd1 vccd1 sky130_fd_sc_hd__tapvpwrvgnd_1
X_2702_ _1154_ _1173_ _1172_ _1170_ vssd1 vssd1 vccd1 vccd1 _1174_ sky130_fd_sc_hd__a211oi_1
XTAP_TAPCELL_ROW_30_423 vssd1 vccd1 sky130_fd_sc_hd__tapvpwrvgnd_1
XFILLER_9_473 vccd1 vssd1 vccd1 vssd1 sky130_ef_sc_hd__decap_40_12
X_2633_ net465 _1107_ net72 vssd1 vssd1 vccd1 vccd1 _0374_ sky130_fd_sc_hd__mux2_1
X_2564_ _1524_ _0465_ vssd1 vssd1 vccd1 vccd1 _1053_ sky130_fd_sc_hd__nor2_4
XANTENNA__2758__C net206 vssd1 vssd1 vccd1 vccd1 sky130_fd_sc_hd__diode_2
X_2495_ net182 net173 MATMULT_INST.matmult_inst.mem_inst.matrixA3\[5\] vssd1 vssd1
+ vccd1 vccd1 _1007_ sky130_fd_sc_hd__and3_1
XFILLER_59_119 vssd1 vssd1 vccd1 vccd1 sky130_fd_sc_hd__fill_2
X_3116_ clknet_leaf_22_clk _0074_ net118 vssd1 vssd1 vccd1 vccd1 MATMULT_INST.matmult_inst.mem_inst.matrixA0\[13\]
+ sky130_fd_sc_hd__dfrtp_1
XANTENNA__2774__B net71 vssd1 vssd1 vccd1 vccd1 sky130_fd_sc_hd__diode_2
X_3047_ MATMULT_INST.matmult_inst.mem_inst.mem2\[16\] net85 net77 MATMULT_INST.matmult_inst.mem_inst.mem1\[16\]
+ _1465_ vssd1 vssd1 vccd1 vccd1 _1466_ sky130_fd_sc_hd__a221o_1
XANTENNA__2463__B1 _0977_ vssd1 vssd1 vccd1 vccd1 sky130_fd_sc_hd__diode_2
XFILLER_23_222 vssd1 vssd1 vccd1 vccd1 sky130_fd_sc_hd__fill_2
XFILLER_23_233 vssd1 vssd1 vccd1 vccd1 sky130_fd_sc_hd__fill_1
XFILLER_11_417 vccd1 vssd1 vccd1 vssd1 sky130_ef_sc_hd__decap_40_12
XFILLER_23_14 vssd1 vssd1 vccd1 vccd1 sky130_fd_sc_hd__fill_4
XFILLER_2_137 vssd1 vssd1 vccd1 vccd1 sky130_fd_sc_hd__fill_2
XFILLER_0_29 vssd1 vssd1 vccd1 vccd1 sky130_fd_sc_hd__fill_8
XFILLER_58_185 vssd1 vssd1 vccd1 vccd1 sky130_fd_sc_hd__fill_2
XFILLER_64_43 vccd1 vssd1 vccd1 vssd1 sky130_ef_sc_hd__decap_40_12
XTAP_TAPCELL_ROW_1_181 vssd1 vccd1 sky130_fd_sc_hd__tapvpwrvgnd_1
XFILLER_14_233 vccd1 vssd1 vccd1 vssd1 sky130_ef_sc_hd__decap_40_12
XFILLER_9_27 vccd1 vssd1 vccd1 vssd1 sky130_ef_sc_hd__decap_40_12
XTAP_TAPCELL_ROW_44_548 vssd1 vccd1 sky130_fd_sc_hd__tapvpwrvgnd_1
XFILLER_14_277 vccd1 vssd1 vccd1 vssd1 sky130_ef_sc_hd__decap_40_12
Xfanout92 _0479_ vssd1 vssd1 vccd1 vccd1 net92 sky130_fd_sc_hd__clkbuf_4
Xfanout81 net84 vssd1 vssd1 vccd1 vccd1 net81 sky130_fd_sc_hd__clkbuf_4
Xfanout70 net71 vssd1 vssd1 vccd1 vccd1 net70 sky130_fd_sc_hd__clkbuf_4
XANTENNA__2757__B2 net186 vssd1 vssd1 vccd1 vccd1 sky130_fd_sc_hd__diode_2
XFILLER_6_421 vccd1 vssd1 vccd1 vssd1 sky130_ef_sc_hd__decap_40_12
XPHY_EDGE_ROW_23_Left_103 vssd1 vssd1 vccd1 vccd1 sky130_fd_sc_hd__decap_3
XANTENNA__2509__A1 net166 vssd1 vssd1 vccd1 vccd1 sky130_fd_sc_hd__diode_2
XANTENNA__2509__B2 net158 vssd1 vssd1 vccd1 vccd1 sky130_fd_sc_hd__diode_2
X_2280_ net218 net229 vssd1 vssd1 vccd1 vccd1 _0827_ sky130_fd_sc_hd__and2_1
XFILLER_1_181 vccd1 vssd1 vccd1 vssd1 sky130_ef_sc_hd__decap_40_12
XFILLER_77_461 vccd1 vssd1 vccd1 vssd1 sky130_ef_sc_hd__decap_40_12
XPHY_EDGE_ROW_32_Left_112 vssd1 vssd1 vccd1 vccd1 sky130_fd_sc_hd__decap_3
XANTENNA__2445__B1 net81 vssd1 vssd1 vccd1 vccd1 sky130_fd_sc_hd__diode_2
XANTENNA__2996__B2 net159 vssd1 vssd1 vccd1 vccd1 sky130_fd_sc_hd__diode_2
XANTENNA__2996__A1 net161 vssd1 vssd1 vccd1 vccd1 sky130_fd_sc_hd__diode_2
XFILLER_45_391 vssd1 vssd1 vccd1 vccd1 sky130_fd_sc_hd__fill_1
XFILLER_20_225 vssd1 vssd1 vccd1 vccd1 sky130_fd_sc_hd__fill_2
X_1995_ _0568_ _0571_ _0569_ vssd1 vssd1 vccd1 vccd1 _0576_ sky130_fd_sc_hd__o21ai_1
XPHY_EDGE_ROW_41_Left_121 vssd1 vssd1 vccd1 vccd1 sky130_fd_sc_hd__decap_3
XFILLER_9_281 vccd1 vssd1 vccd1 vssd1 sky130_ef_sc_hd__decap_40_12
X_2616_ net196 net204 net206 net195 vssd1 vssd1 vccd1 vccd1 _1091_ sky130_fd_sc_hd__a22o_1
XANTENNA__1673__B net169 vssd1 vssd1 vccd1 vccd1 sky130_fd_sc_hd__diode_2
X_2547_ MATMULT_INST.matmult_inst.fsm_inst.count\[1\] _1039_ _1046_ vssd1 vssd1 vccd1
+ vccd1 _0349_ sky130_fd_sc_hd__a21o_1
XTAP_TAPCELL_ROW_7_229 vssd1 vccd1 sky130_fd_sc_hd__tapvpwrvgnd_1
X_2478_ net166 _0990_ vssd1 vssd1 vccd1 vccd1 _0991_ sky130_fd_sc_hd__and2_1
XPHY_EDGE_ROW_50_Left_130 vssd1 vssd1 vccd1 vccd1 sky130_fd_sc_hd__decap_3
XTAP_TAPCELL_ROW_41_518 vssd1 vccd1 sky130_fd_sc_hd__tapvpwrvgnd_1
XFILLER_11_225 vccd1 vssd1 vccd1 vssd1 sky130_ef_sc_hd__decap_40_12
Xclkload1 clknet_2_1__leaf_clk vssd1 vssd1 vccd1 vccd1 clkload1/Y sky130_fd_sc_hd__inv_6
XFILLER_1_3 vccd1 vssd1 vccd1 vssd1 sky130_ef_sc_hd__decap_40_12
XANTENNA_fanout81_X net81 vssd1 vssd1 vccd1 vccd1 sky130_fd_sc_hd__diode_2
XANTENNA__1803__S net17 vssd1 vssd1 vccd1 vccd1 sky130_fd_sc_hd__diode_2
XFILLER_75_97 vssd1 vssd1 vccd1 vccd1 sky130_fd_sc_hd__fill_2
XFILLER_74_475 vssd1 vssd1 vccd1 vccd1 sky130_fd_sc_hd__fill_1
XFILLER_61_136 vccd1 vssd1 vccd1 vssd1 sky130_ef_sc_hd__decap_40_12
X_1780_ net560 net39 net31 vssd1 vssd1 vccd1 vccd1 _0115_ sky130_fd_sc_hd__mux2_1
XTAP_TAPCELL_ROW_12_275 vssd1 vccd1 sky130_fd_sc_hd__tapvpwrvgnd_1
XFILLER_6_251 vssd1 vssd1 vccd1 vccd1 sky130_fd_sc_hd__fill_1
X_3450_ _0031_ _0396_ net147 vssd1 vssd1 vccd1 vccd1 MATMULT_INST.matmult_inst.spi_inst.mosi_data_spi\[5\]
+ sky130_fd_sc_hd__dfrtp_1
X_3381_ clknet_leaf_5_clk _0335_ net106 vssd1 vssd1 vccd1 vccd1 MATMULT_INST.matmult_inst.alu_inst.col1\[3\]
+ sky130_fd_sc_hd__dfrtp_1
X_2401_ net637 net62 net41 MATMULT_INST.matmult_inst.fsm_inst.alu_result\[17\] vssd1
+ vssd1 vccd1 vccd1 _0326_ sky130_fd_sc_hd__a22o_1
X_2332_ MATMULT_INST.matmult_inst.alu_inst.adder_inst.r2.fa3.a net69 vssd1 vssd1 vccd1
+ vccd1 _0878_ sky130_fd_sc_hd__or2_1
XFILLER_69_236 vssd1 vssd1 vccd1 vccd1 sky130_fd_sc_hd__fill_1
X_2263_ _0802_ _0809_ _0810_ vssd1 vssd1 vccd1 vccd1 _0811_ sky130_fd_sc_hd__and3_1
X_2194_ _0706_ _0739_ _0740_ vssd1 vssd1 vccd1 vccd1 _0744_ sky130_fd_sc_hd__and3_1
XFILLER_37_100 vssd1 vssd1 vccd1 vccd1 sky130_fd_sc_hd__fill_1
XANTENNA__2969__B2 net92 vssd1 vssd1 vccd1 vccd1 sky130_fd_sc_hd__diode_2
X_1978_ net503 _0561_ net74 vssd1 vssd1 vccd1 vccd1 _0265_ sky130_fd_sc_hd__mux2_1
XANTENNA__2499__B _1010_ vssd1 vssd1 vccd1 vccd1 sky130_fd_sc_hd__diode_2
XFILLER_0_449 vccd1 vssd1 vccd1 vssd1 sky130_ef_sc_hd__decap_40_12
XFILLER_29_35 vssd1 vssd1 vccd1 vccd1 sky130_fd_sc_hd__fill_1
Xhold13 MATMULT_INST.matmult_inst.spi_inst.mosi_data_sync\[0\] vssd1 vssd1 vccd1 vccd1
+ net326 sky130_fd_sc_hd__dlygate4sd3_1
Xhold24 _0319_ vssd1 vssd1 vccd1 vccd1 net337 sky130_fd_sc_hd__dlygate4sd3_1
Xhold46 MATMULT_INST.matmult_inst.alu_inst.row1\[5\] vssd1 vssd1 vccd1 vccd1 net359
+ sky130_fd_sc_hd__dlygate4sd3_1
Xhold35 MATMULT_INST.matmult_inst.spi_inst.tx_reg_sys\[4\] vssd1 vssd1 vccd1 vccd1
+ net348 sky130_fd_sc_hd__dlygate4sd3_1
Xhold79 MATMULT_INST.matmult_inst.mem_inst.matrixA3\[6\] vssd1 vssd1 vccd1 vccd1 net392
+ sky130_fd_sc_hd__dlygate4sd3_1
Xhold68 MATMULT_INST.matmult_inst.mem_inst.matrixA3\[4\] vssd1 vssd1 vccd1 vccd1 net381
+ sky130_fd_sc_hd__dlygate4sd3_1
Xhold57 MATMULT_INST.matmult_inst.spi_inst.tx_reg_sys\[3\] vssd1 vssd1 vccd1 vccd1
+ net370 sky130_fd_sc_hd__dlygate4sd3_1
XTAP_TAPCELL_ROW_54_632 vssd1 vccd1 sky130_fd_sc_hd__tapvpwrvgnd_1
XFILLER_71_489 vssd1 vssd1 vccd1 vccd1 sky130_fd_sc_hd__fill_2
XTAP_TAPCELL_ROW_26_389 vssd1 vccd1 sky130_fd_sc_hd__tapvpwrvgnd_1
XPHY_EDGE_ROW_7_Left_87 vssd1 vssd1 vccd1 vccd1 sky130_fd_sc_hd__decap_3
XFILLER_3_221 vssd1 vssd1 vccd1 vccd1 sky130_fd_sc_hd__fill_2
XFILLER_10_81 vssd1 vssd1 vccd1 vccd1 sky130_fd_sc_hd__fill_2
XFILLER_74_250 vssd1 vssd1 vccd1 vccd1 sky130_fd_sc_hd__fill_2
XANTENNA__3033__B net169 vssd1 vssd1 vccd1 vccd1 sky130_fd_sc_hd__diode_2
XFILLER_74_261 vssd1 vssd1 vccd1 vccd1 sky130_fd_sc_hd__fill_2
X_2950_ net370 _0987_ net58 vssd1 vssd1 vccd1 vccd1 _0437_ sky130_fd_sc_hd__mux2_1
X_2881_ _1312_ _1328_ vssd1 vssd1 vccd1 vccd1 _1348_ sky130_fd_sc_hd__nand2_1
X_1901_ net628 net32 net27 vssd1 vssd1 vccd1 vccd1 _0230_ sky130_fd_sc_hd__mux2_1
X_1832_ net386 net46 net14 vssd1 vssd1 vccd1 vccd1 _0165_ sky130_fd_sc_hd__mux2_1
XTAP_TAPCELL_ROW_60_679 vssd1 vccd1 sky130_fd_sc_hd__tapvpwrvgnd_1
XANTENNA__1708__S net24 vssd1 vssd1 vccd1 vccd1 sky130_fd_sc_hd__diode_2
X_1763_ net391 net36 net19 vssd1 vssd1 vccd1 vccd1 _0100_ sky130_fd_sc_hd__mux2_1
X_3502_ net242 _0007_ net128 vssd1 vssd1 vccd1 vccd1 MATMULT_INST.matmult_inst.spi_inst.miso_shifter\[10\]
+ sky130_fd_sc_hd__dfrtp_1
X_1694_ net492 _0492_ net25 vssd1 vssd1 vccd1 vccd1 _0050_ sky130_fd_sc_hd__mux2_1
X_3433_ clknet_leaf_30_clk _0385_ vssd1 vssd1 vccd1 vccd1 MATMULT_INST.matmult_inst.alu_inst.adder_inst.r3.fa3.b
+ sky130_fd_sc_hd__dfxtp_1
X_3364_ clknet_leaf_25_clk net337 net102 vssd1 vssd1 vccd1 vccd1 MATMULT_INST.matmult_inst.fsm_inst.alu_result\[10\]
+ sky130_fd_sc_hd__dfrtp_1
X_2315_ _0856_ _0860_ vssd1 vssd1 vccd1 vccd1 _0861_ sky130_fd_sc_hd__xnor2_1
X_3295_ clknet_leaf_26_clk _0253_ net99 vssd1 vssd1 vccd1 vccd1 MATMULT_INST.matmult_inst.alu_inst.a0_reg\[3\]
+ sky130_fd_sc_hd__dfrtp_1
XTAP_TAPCELL_ROW_68_746 vssd1 vccd1 sky130_fd_sc_hd__tapvpwrvgnd_1
X_2246_ _0785_ _0790_ _0791_ vssd1 vssd1 vccd1 vccd1 _0794_ sky130_fd_sc_hd__and3_1
X_2177_ _0689_ _0725_ _0726_ vssd1 vssd1 vccd1 vccd1 _0727_ sky130_fd_sc_hd__and3_1
XANTENNA_fanout176_A net177 vssd1 vssd1 vccd1 vccd1 sky130_fd_sc_hd__diode_2
XFILLER_25_158 vssd1 vssd1 vccd1 vccd1 sky130_fd_sc_hd__fill_1
XTAP_TAPCELL_ROW_51_602 vssd1 vccd1 sky130_fd_sc_hd__tapvpwrvgnd_1
XANTENNA_fanout89_A net91 vssd1 vssd1 vccd1 vccd1 sky130_fd_sc_hd__diode_2
Xteam_02_310 vssd1 vssd1 vccd1 vccd1 gpio_oeb[30] team_02_310/LO sky130_fd_sc_hd__conb_1
XFILLER_56_33 vssd1 vssd1 vccd1 vccd1 sky130_fd_sc_hd__fill_8
XFILLER_16_114 vssd1 vssd1 vccd1 vccd1 sky130_fd_sc_hd__fill_8
XANTENNA__2692__B net71 vssd1 vssd1 vccd1 vccd1 sky130_fd_sc_hd__diode_2
XANTENNA__3055__B1 net79 vssd1 vssd1 vccd1 vccd1 sky130_fd_sc_hd__diode_2
XFILLER_72_65 vssd1 vssd1 vccd1 vccd1 sky130_fd_sc_hd__fill_2
XFILLER_31_117 vssd1 vssd1 vccd1 vccd1 sky130_fd_sc_hd__fill_8
XFILLER_31_128 vssd1 vssd1 vccd1 vccd1 sky130_fd_sc_hd__fill_2
XFILLER_8_357 vssd1 vssd1 vccd1 vccd1 sky130_fd_sc_hd__fill_4
XFILLER_21_80 vccd1 vssd1 vccd1 vssd1 sky130_ef_sc_hd__decap_40_12
XFILLER_79_353 vssd1 vssd1 vccd1 vccd1 sky130_fd_sc_hd__fill_8
X_3080_ net244 vssd1 vssd1 vccd1 vccd1 _0038_ sky130_fd_sc_hd__inv_2
XANTENNA__3044__A net176 vssd1 vssd1 vccd1 vccd1 sky130_fd_sc_hd__diode_2
X_2100_ _0631_ _0648_ _0649_ vssd1 vssd1 vccd1 vccd1 _0652_ sky130_fd_sc_hd__o21ai_1
X_2031_ net650 _0605_ net73 vssd1 vssd1 vccd1 vccd1 _0274_ sky130_fd_sc_hd__mux2_1
XTAP_TAPCELL_ROW_65_727 vssd1 vccd1 sky130_fd_sc_hd__tapvpwrvgnd_1
XTAP_TAPCELL_ROW_73_793 vssd1 vccd1 sky130_fd_sc_hd__tapvpwrvgnd_1
X_2933_ net376 net48 net8 vssd1 vssd1 vccd1 vccd1 _0420_ sky130_fd_sc_hd__mux2_1
XFILLER_22_139 vssd1 vssd1 vccd1 vccd1 sky130_fd_sc_hd__fill_1
X_2864_ _1301_ _1330_ _1331_ vssd1 vssd1 vccd1 vccd1 _1332_ sky130_fd_sc_hd__and3_1
X_2795_ _1218_ _1222_ _1223_ _1231_ _1232_ vssd1 vssd1 vccd1 vccd1 _1265_ sky130_fd_sc_hd__a311o_1
X_1815_ net519 net44 net16 vssd1 vssd1 vccd1 vccd1 _0149_ sky130_fd_sc_hd__mux2_1
Xhold302 MATMULT_INST.matmult_inst.mem_inst.mem0\[11\] vssd1 vssd1 vccd1 vccd1 net615
+ sky130_fd_sc_hd__dlygate4sd3_1
X_1746_ net477 net32 net21 vssd1 vssd1 vccd1 vccd1 _0086_ sky130_fd_sc_hd__mux2_1
Xhold335 MATMULT_INST.matmult_inst.mem_inst.matrixB1\[16\] vssd1 vssd1 vccd1 vccd1
+ net648 sky130_fd_sc_hd__dlygate4sd3_1
XFILLER_7_93 vccd1 vssd1 vccd1 vssd1 sky130_ef_sc_hd__decap_40_12
Xhold313 MATMULT_INST.matmult_inst.mem_inst.matrixB0\[14\] vssd1 vssd1 vccd1 vccd1
+ net626 sky130_fd_sc_hd__dlygate4sd3_1
Xhold324 MATMULT_INST.matmult_inst.alu_inst.out\[17\] vssd1 vssd1 vccd1 vccd1 net637
+ sky130_fd_sc_hd__dlygate4sd3_1
Xhold357 MATMULT_INST.matmult_inst.alu_inst.adder_inst.r0.fa3.a vssd1 vssd1 vccd1
+ vccd1 net670 sky130_fd_sc_hd__dlygate4sd3_1
Xhold346 MATMULT_INST.matmult_inst.alu_inst.adder_inst.r1.fa1.b vssd1 vssd1 vccd1
+ vccd1 net659 sky130_fd_sc_hd__dlygate4sd3_1
X_1677_ net162 _0482_ vssd1 vssd1 vccd1 vccd1 _0483_ sky130_fd_sc_hd__nand2_1
X_3416_ clknet_leaf_10_clk _0369_ net137 vssd1 vssd1 vccd1 vccd1 MATMULT_INST.matmult_inst.addr\[1\]
+ sky130_fd_sc_hd__dfrtp_1
XANTENNA__2777__B net192 vssd1 vssd1 vccd1 vccd1 sky130_fd_sc_hd__diode_2
X_3347_ clknet_leaf_30_clk _0302_ vssd1 vssd1 vccd1 vccd1 MATMULT_INST.matmult_inst.alu_inst.adder_inst.r2.fa2.a
+ sky130_fd_sc_hd__dfxtp_1
X_3278_ clknet_leaf_22_clk _0236_ net117 vssd1 vssd1 vccd1 vccd1 MATMULT_INST.matmult_inst.mem_inst.matrixA1\[13\]
+ sky130_fd_sc_hd__dfrtp_1
XANTENNA__1901__S net27 vssd1 vssd1 vccd1 vccd1 sky130_fd_sc_hd__diode_2
X_2229_ _0741_ _0776_ _0777_ vssd1 vssd1 vccd1 vccd1 _0778_ sky130_fd_sc_hd__and3_1
XTAP_TAPCELL_ROW_28_407 vssd1 vccd1 sky130_fd_sc_hd__tapvpwrvgnd_1
XANTENNA__3037__B1 net79 vssd1 vssd1 vccd1 vccd1 sky130_fd_sc_hd__diode_2
XFILLER_5_305 vccd1 vssd1 vccd1 vssd1 sky130_ef_sc_hd__decap_40_12
XFILLER_5_349 vccd1 vssd1 vccd1 vssd1 sky130_ef_sc_hd__decap_40_12
XPHY_EDGE_ROW_79_Left_159 vssd1 vssd1 vccd1 vccd1 sky130_fd_sc_hd__decap_3
XFILLER_67_32 vssd1 vssd1 vccd1 vccd1 sky130_fd_sc_hd__fill_8
XANTENNA__1811__S net16 vssd1 vssd1 vccd1 vccd1 sky130_fd_sc_hd__diode_2
XTAP_TAPCELL_ROW_70_763 vssd1 vccd1 sky130_fd_sc_hd__tapvpwrvgnd_1
XFILLER_8_121 vccd1 vssd1 vccd1 vssd1 sky130_ef_sc_hd__decap_40_12
XFILLER_8_165 vccd1 vssd1 vccd1 vssd1 sky130_ef_sc_hd__decap_40_12
X_1600_ _1496_ _1517_ vssd1 vssd1 vccd1 vccd1 _1518_ sky130_fd_sc_hd__nand2_1
X_2580_ _1060_ net183 _1055_ vssd1 vssd1 vccd1 vccd1 _0368_ sky130_fd_sc_hd__mux2_1
X_3201_ clknet_leaf_18_clk _0159_ net130 vssd1 vssd1 vccd1 vccd1 MATMULT_INST.matmult_inst.mem_inst.matrixA3\[8\]
+ sky130_fd_sc_hd__dfrtp_1
XFILLER_79_183 vssd1 vssd1 vccd1 vccd1 sky130_fd_sc_hd__fill_4
X_3132_ clknet_leaf_19_clk _0090_ net126 vssd1 vssd1 vccd1 vccd1 MATMULT_INST.matmult_inst.mem_inst.matrixA2\[11\]
+ sky130_fd_sc_hd__dfrtp_1
X_3063_ net165 _1479_ _1480_ _1475_ vssd1 vssd1 vccd1 vccd1 _1481_ sky130_fd_sc_hd__a211o_1
XANTENNA__1721__S net23 vssd1 vssd1 vccd1 vccd1 sky130_fd_sc_hd__diode_2
X_2014_ _0590_ _0591_ vssd1 vssd1 vccd1 vccd1 _0592_ sky130_fd_sc_hd__xnor2_1
XTAP_TAPCELL_ROW_33_454 vssd1 vccd1 sky130_fd_sc_hd__tapvpwrvgnd_1
XFILLER_10_109 vccd1 vssd1 vccd1 vssd1 sky130_ef_sc_hd__decap_40_12
X_2916_ net69 _1359_ _1376_ vssd1 vssd1 vccd1 vccd1 _1380_ sky130_fd_sc_hd__and3_1
XFILLER_12_27 vssd1 vssd1 vccd1 vccd1 sky130_fd_sc_hd__fill_1
X_2847_ _1257_ _1314_ vssd1 vssd1 vccd1 vccd1 _1315_ sky130_fd_sc_hd__and2_1
XANTENNA__1676__B net61 vssd1 vssd1 vccd1 vccd1 sky130_fd_sc_hd__diode_2
Xhold110 MATMULT_INST.matmult_inst.fsm_inst.alu_result\[12\] vssd1 vssd1 vccd1 vccd1
+ net423 sky130_fd_sc_hd__dlygate4sd3_1
XANTENNA_clkbuf_2_1__f_clk_A clknet_0_clk vssd1 vssd1 vccd1 vccd1 sky130_fd_sc_hd__diode_2
X_2778_ net200 _1247_ _1246_ vssd1 vssd1 vccd1 vccd1 _1248_ sky130_fd_sc_hd__a21bo_1
X_1729_ net591 _0496_ net22 vssd1 vssd1 vccd1 vccd1 _0072_ sky130_fd_sc_hd__mux2_1
Xhold121 MATMULT_INST.matmult_inst.mem_inst.matrixA3\[10\] vssd1 vssd1 vccd1 vccd1
+ net434 sky130_fd_sc_hd__dlygate4sd3_1
XANTENNA_clkbuf_leaf_1_clk_A clknet_2_0__leaf_clk vssd1 vssd1 vccd1 vccd1 sky130_fd_sc_hd__diode_2
Xhold143 MATMULT_INST.matmult_inst.mem_inst.matrixA0\[7\] vssd1 vssd1 vccd1 vccd1
+ net456 sky130_fd_sc_hd__dlygate4sd3_1
Xhold132 MATMULT_INST.matmult_inst.mem_inst.mem1\[0\] vssd1 vssd1 vccd1 vccd1 net445
+ sky130_fd_sc_hd__dlygate4sd3_1
XANTENNA__2788__A net187 vssd1 vssd1 vccd1 vccd1 sky130_fd_sc_hd__diode_2
Xhold154 MATMULT_INST.matmult_inst.mem_inst.mem1\[17\] vssd1 vssd1 vccd1 vccd1 net467
+ sky130_fd_sc_hd__dlygate4sd3_1
Xhold176 MATMULT_INST.matmult_inst.mem_inst.matrixB2\[14\] vssd1 vssd1 vccd1 vccd1
+ net489 sky130_fd_sc_hd__dlygate4sd3_1
Xhold165 MATMULT_INST.matmult_inst.mem_inst.mem0\[1\] vssd1 vssd1 vccd1 vccd1 net478
+ sky130_fd_sc_hd__dlygate4sd3_1
Xhold187 MATMULT_INST.matmult_inst.alu_inst.col1\[4\] vssd1 vssd1 vccd1 vccd1 net500
+ sky130_fd_sc_hd__dlygate4sd3_1
Xhold198 MATMULT_INST.matmult_inst.mem_inst.matrixB1\[2\] vssd1 vssd1 vccd1 vccd1
+ net511 sky130_fd_sc_hd__dlygate4sd3_1
XFILLER_18_209 vccd1 vssd1 vccd1 vssd1 sky130_ef_sc_hd__decap_40_12
XFILLER_53_34 vssd1 vssd1 vccd1 vccd1 sky130_fd_sc_hd__fill_1
XANTENNA__2970__B net168 vssd1 vssd1 vccd1 vccd1 sky130_fd_sc_hd__diode_2
XFILLER_5_113 vccd1 vssd1 vccd1 vssd1 sky130_ef_sc_hd__decap_40_12
XANTENNA__1806__S net17 vssd1 vssd1 vccd1 vccd1 sky130_fd_sc_hd__diode_2
XFILLER_78_53 vccd1 vssd1 vccd1 vssd1 sky130_ef_sc_hd__decap_40_12
XFILLER_78_97 vssd1 vssd1 vccd1 vccd1 sky130_fd_sc_hd__fill_4
XFILLER_1_385 vssd1 vssd1 vccd1 vccd1 sky130_fd_sc_hd__fill_4
XTAP_TAPCELL_ROW_75_811 vssd1 vccd1 sky130_fd_sc_hd__tapvpwrvgnd_1
XFILLER_76_197 vccd1 vssd1 vccd1 vssd1 sky130_ef_sc_hd__decap_40_12
XFILLER_17_264 vssd1 vssd1 vccd1 vccd1 sky130_fd_sc_hd__fill_2
XTAP_TAPCELL_ROW_47_568 vssd1 vccd1 sky130_fd_sc_hd__tapvpwrvgnd_1
XANTENNA__2472__A1 net163 vssd1 vssd1 vccd1 vccd1 sky130_fd_sc_hd__diode_2
XANTENNA__2472__B2 net93 vssd1 vssd1 vccd1 vccd1 sky130_fd_sc_hd__diode_2
X_2701_ _1118_ _1151_ _1152_ _1147_ vssd1 vssd1 vccd1 vccd1 _1173_ sky130_fd_sc_hd__a31o_1
XFILLER_13_481 vssd1 vssd1 vccd1 vccd1 sky130_fd_sc_hd__fill_1
XFILLER_9_441 vssd1 vssd1 vccd1 vccd1 sky130_fd_sc_hd__fill_4
XTAP_TAPCELL_ROW_30_424 vssd1 vccd1 sky130_fd_sc_hd__tapvpwrvgnd_1
XFILLER_9_485 vssd1 vssd1 vccd1 vccd1 sky130_fd_sc_hd__fill_8
X_2632_ _1087_ _1106_ vssd1 vssd1 vccd1 vccd1 _1107_ sky130_fd_sc_hd__xnor2_1
XFILLER_64_3 vssd1 vssd1 vccd1 vccd1 sky130_fd_sc_hd__fill_8
X_2563_ net462 _1033_ net40 vssd1 vssd1 vccd1 vccd1 _0359_ sky130_fd_sc_hd__mux2_1
X_2494_ MATMULT_INST.matmult_inst.mem_inst.mem2\[5\] net90 net83 MATMULT_INST.matmult_inst.mem_inst.mem1\[5\]
+ _1005_ vssd1 vssd1 vccd1 vccd1 _1006_ sky130_fd_sc_hd__a221o_1
XFILLER_4_83 vssd1 vssd1 vccd1 vccd1 sky130_fd_sc_hd__fill_1
X_3115_ clknet_leaf_24_clk _0073_ net116 vssd1 vssd1 vccd1 vccd1 MATMULT_INST.matmult_inst.mem_inst.matrixA0\[12\]
+ sky130_fd_sc_hd__dfrtp_1
X_3046_ net176 net167 MATMULT_INST.matmult_inst.mem_inst.mem3\[16\] vssd1 vssd1 vccd1
+ vccd1 _1465_ sky130_fd_sc_hd__and3_1
XFILLER_55_337 vssd1 vssd1 vccd1 vccd1 sky130_fd_sc_hd__fill_1
XFILLER_70_307 vssd1 vssd1 vccd1 vccd1 sky130_fd_sc_hd__fill_1
XANTENNA__2463__B2 net66 vssd1 vssd1 vccd1 vccd1 sky130_fd_sc_hd__diode_2
XFILLER_11_429 vccd1 vssd1 vccd1 vssd1 sky130_ef_sc_hd__decap_40_12
XFILLER_23_37 vccd1 vssd1 vccd1 vssd1 sky130_ef_sc_hd__decap_40_12
XFILLER_64_11 vssd1 vssd1 vccd1 vccd1 sky130_fd_sc_hd__fill_1
XFILLER_73_167 vssd1 vssd1 vccd1 vccd1 sky130_fd_sc_hd__fill_1
XFILLER_61_318 vssd1 vssd1 vccd1 vccd1 sky130_fd_sc_hd__fill_1
XFILLER_64_55 vssd1 vssd1 vccd1 vccd1 sky130_fd_sc_hd__fill_2
XANTENNA__2454__B2 net162 vssd1 vssd1 vccd1 vccd1 sky130_fd_sc_hd__diode_2
XANTENNA__2454__A1 net157 vssd1 vssd1 vccd1 vccd1 sky130_fd_sc_hd__diode_2
XTAP_TAPCELL_ROW_1_182 vssd1 vccd1 sky130_fd_sc_hd__tapvpwrvgnd_1
XANTENNA__2981__A net177 vssd1 vssd1 vccd1 vccd1 sky130_fd_sc_hd__diode_2
XFILLER_14_245 vssd1 vssd1 vccd1 vccd1 sky130_fd_sc_hd__fill_4
XTAP_TAPCELL_ROW_44_549 vssd1 vccd1 sky130_fd_sc_hd__tapvpwrvgnd_1
XFILLER_14_289 vssd1 vssd1 vccd1 vccd1 sky130_fd_sc_hd__fill_4
XFILLER_9_39 vccd1 vssd1 vccd1 vssd1 sky130_ef_sc_hd__decap_40_12
XANTENNA__2757__A2 net206 vssd1 vssd1 vccd1 vccd1 sky130_fd_sc_hd__diode_2
Xfanout60 _0481_ vssd1 vssd1 vccd1 vccd1 net60 sky130_fd_sc_hd__buf_2
Xfanout82 net84 vssd1 vssd1 vccd1 vccd1 net82 sky130_fd_sc_hd__dlymetal6s2s_1
Xfanout71 _0608_ vssd1 vssd1 vccd1 vccd1 net71 sky130_fd_sc_hd__clkbuf_4
Xfanout93 _0479_ vssd1 vssd1 vccd1 vccd1 net93 sky130_fd_sc_hd__clkbuf_4
XFILLER_10_473 vssd1 vssd1 vccd1 vccd1 sky130_fd_sc_hd__fill_2
XFILLER_6_433 vccd1 vssd1 vccd1 vssd1 sky130_ef_sc_hd__decap_40_12
XANTENNA__2509__A2 _0480_ vssd1 vssd1 vccd1 vccd1 sky130_fd_sc_hd__diode_2
XFILLER_6_477 vccd1 vssd1 vccd1 vssd1 sky130_ef_sc_hd__decap_40_12
XFILLER_1_193 vccd1 vssd1 vccd1 vssd1 sky130_ef_sc_hd__decap_40_12
XFILLER_49_131 vssd1 vssd1 vccd1 vccd1 sky130_fd_sc_hd__fill_1
XFILLER_77_473 vccd1 vssd1 vccd1 vssd1 sky130_ef_sc_hd__decap_40_12
XFILLER_49_175 vssd1 vssd1 vccd1 vccd1 sky130_fd_sc_hd__fill_1
XFILLER_45_370 vssd1 vssd1 vccd1 vccd1 sky130_fd_sc_hd__fill_1
X_1994_ _0573_ _0574_ vssd1 vssd1 vccd1 vccd1 _0575_ sky130_fd_sc_hd__nand2_1
XFILLER_9_293 vccd1 vssd1 vccd1 vssd1 sky130_ef_sc_hd__decap_40_12
X_2615_ net196 net195 net205 net206 vssd1 vssd1 vccd1 vccd1 _1090_ sky130_fd_sc_hd__nand4_2
X_2546_ _1503_ _0469_ _1045_ _1502_ _1040_ vssd1 vssd1 vccd1 vccd1 _1046_ sky130_fd_sc_hd__o221a_1
X_2477_ MATMULT_INST.matmult_inst.mem_inst.matrixA2\[4\] net89 net81 MATMULT_INST.matmult_inst.mem_inst.matrixA1\[4\]
+ _0989_ vssd1 vssd1 vccd1 vccd1 _0990_ sky130_fd_sc_hd__a221o_1
X_3029_ net160 _1444_ _1446_ net155 vssd1 vssd1 vccd1 vccd1 _1450_ sky130_fd_sc_hd__a22o_1
XANTENNA_fanout161_X net161 vssd1 vssd1 vccd1 vccd1 sky130_fd_sc_hd__diode_2
XTAP_TAPCELL_ROW_41_519 vssd1 vccd1 sky130_fd_sc_hd__tapvpwrvgnd_1
XFILLER_11_237 vccd1 vssd1 vccd1 vssd1 sky130_ef_sc_hd__decap_40_12
Xclkload2 clknet_leaf_1_clk vssd1 vssd1 vccd1 vccd1 clkload2/X sky130_fd_sc_hd__clkbuf_8
XFILLER_3_447 vssd1 vssd1 vccd1 vccd1 sky130_fd_sc_hd__fill_1
XFILLER_59_55 vssd1 vssd1 vccd1 vccd1 sky130_fd_sc_hd__fill_1
XFILLER_59_77 vssd1 vssd1 vccd1 vccd1 sky130_fd_sc_hd__fill_4
XFILLER_34_307 vssd1 vssd1 vccd1 vccd1 sky130_fd_sc_hd__fill_1
XFILLER_61_104 vssd1 vssd1 vccd1 vccd1 sky130_fd_sc_hd__fill_8
XANTENNA__2427__A1 net93 vssd1 vssd1 vccd1 vccd1 sky130_fd_sc_hd__diode_2
XFILLER_61_148 vssd1 vssd1 vccd1 vccd1 sky130_fd_sc_hd__fill_4
XTAP_TAPCELL_ROW_12_276 vssd1 vccd1 sky130_fd_sc_hd__tapvpwrvgnd_1
X_2400_ MATMULT_INST.matmult_inst.alu_inst.out\[16\] net62 net41 net579 vssd1 vssd1
+ vccd1 vccd1 _0325_ sky130_fd_sc_hd__a22o_1
X_3380_ clknet_leaf_5_clk _0334_ net106 vssd1 vssd1 vccd1 vccd1 MATMULT_INST.matmult_inst.alu_inst.col1\[2\]
+ sky130_fd_sc_hd__dfrtp_1
X_2331_ _0851_ _0874_ _0875_ vssd1 vssd1 vccd1 vccd1 _0877_ sky130_fd_sc_hd__and3_1
X_2262_ _0805_ _0806_ _0808_ vssd1 vssd1 vccd1 vccd1 _0810_ sky130_fd_sc_hd__a21o_1
XFILLER_27_3 vccd1 vssd1 vccd1 vssd1 sky130_ef_sc_hd__decap_40_12
X_2193_ _0742_ vssd1 vssd1 vccd1 vccd1 _0743_ sky130_fd_sc_hd__inv_2
XFILLER_1_51 vssd1 vssd1 vccd1 vccd1 sky130_fd_sc_hd__fill_4
XANTENNA__2969__A2 net64 vssd1 vssd1 vccd1 vccd1 sky130_fd_sc_hd__diode_2
XFILLER_52_126 vssd1 vssd1 vccd1 vccd1 sky130_fd_sc_hd__fill_1
XFILLER_52_159 vssd1 vssd1 vccd1 vccd1 sky130_fd_sc_hd__fill_4
X_1977_ _0559_ _0560_ vssd1 vssd1 vccd1 vccd1 _0561_ sky130_fd_sc_hd__xnor2_1
XANTENNA__2560__S net40 vssd1 vssd1 vccd1 vccd1 sky130_fd_sc_hd__diode_2
X_2529_ _0977_ net605 _1035_ vssd1 vssd1 vccd1 vccd1 _0342_ sky130_fd_sc_hd__mux2_1
XANTENNA__1904__S net26 vssd1 vssd1 vccd1 vccd1 sky130_fd_sc_hd__diode_2
Xhold14 _0426_ vssd1 vssd1 vccd1 vccd1 net327 sky130_fd_sc_hd__dlygate4sd3_1
Xhold25 MATMULT_INST.matmult_inst.mem_inst.mem3\[2\] vssd1 vssd1 vccd1 vccd1 net338
+ sky130_fd_sc_hd__dlygate4sd3_1
XTAP_TAPCELL_ROW_3_200 vssd1 vccd1 sky130_fd_sc_hd__tapvpwrvgnd_1
XFILLER_29_69 vssd1 vssd1 vccd1 vccd1 sky130_fd_sc_hd__fill_1
Xhold36 MATMULT_INST.matmult_inst.mem_inst.mem3\[0\] vssd1 vssd1 vccd1 vccd1 net349
+ sky130_fd_sc_hd__dlygate4sd3_1
Xhold47 MATMULT_INST.matmult_inst.spi_inst.tx_reg_sys\[2\] vssd1 vssd1 vccd1 vccd1
+ net360 sky130_fd_sc_hd__dlygate4sd3_1
Xhold58 MATMULT_INST.matmult_inst.fsm_inst.alu_result\[9\] vssd1 vssd1 vccd1 vccd1
+ net371 sky130_fd_sc_hd__dlygate4sd3_1
Xhold69 MATMULT_INST.matmult_inst.mem_inst.matrixB0\[0\] vssd1 vssd1 vccd1 vccd1 net382
+ sky130_fd_sc_hd__dlygate4sd3_1
XFILLER_16_307 vssd1 vssd1 vccd1 vccd1 sky130_fd_sc_hd__fill_1
XFILLER_45_24 vssd1 vssd1 vccd1 vccd1 sky130_fd_sc_hd__fill_2
XFILLER_45_57 vssd1 vssd1 vccd1 vccd1 sky130_fd_sc_hd__fill_2
XTAP_TAPCELL_ROW_54_633 vssd1 vccd1 sky130_fd_sc_hd__tapvpwrvgnd_1
XFILLER_6_29 vccd1 vssd1 vccd1 vssd1 sky130_ef_sc_hd__decap_40_12
XFILLER_3_277 vssd1 vssd1 vccd1 vccd1 sky130_fd_sc_hd__fill_2
XANTENNA__1814__S net16 vssd1 vssd1 vccd1 vccd1 sky130_fd_sc_hd__diode_2
XFILLER_19_80 vssd1 vssd1 vccd1 vccd1 sky130_fd_sc_hd__fill_1
XTAP_TAPCELL_ROW_17_313 vssd1 vccd1 sky130_fd_sc_hd__tapvpwrvgnd_1
X_2880_ _1341_ _1346_ vssd1 vssd1 vccd1 vccd1 _1347_ sky130_fd_sc_hd__xnor2_1
X_1900_ net435 _0491_ net27 vssd1 vssd1 vccd1 vccd1 _0229_ sky130_fd_sc_hd__mux2_1
X_1831_ net385 net47 net14 vssd1 vssd1 vccd1 vccd1 _0164_ sky130_fd_sc_hd__mux2_1
XFILLER_30_376 vssd1 vssd1 vccd1 vccd1 sky130_fd_sc_hd__fill_1
X_1762_ net338 net37 net19 vssd1 vssd1 vccd1 vccd1 _0099_ sky130_fd_sc_hd__mux2_1
X_3501_ net242 _0021_ net128 vssd1 vssd1 vccd1 vccd1 MATMULT_INST.matmult_inst.spi_inst.miso_shifter\[9\]
+ sky130_fd_sc_hd__dfrtp_1
X_1693_ MATMULT_INST.matmult_inst.fsm_inst.rx_data\[7\] _0467_ net61 MATMULT_INST.matmult_inst.fsm_inst.alu_result\[7\]
+ vssd1 vssd1 vccd1 vccd1 _0492_ sky130_fd_sc_hd__a22o_1
X_3432_ clknet_leaf_30_clk _0384_ vssd1 vssd1 vccd1 vccd1 MATMULT_INST.matmult_inst.alu_inst.adder_inst.r3.fa2.b
+ sky130_fd_sc_hd__dfxtp_1
X_3363_ clknet_leaf_1_clk net372 net103 vssd1 vssd1 vccd1 vccd1 MATMULT_INST.matmult_inst.fsm_inst.alu_result\[9\]
+ sky130_fd_sc_hd__dfrtp_1
XANTENNA__1724__S net23 vssd1 vssd1 vccd1 vccd1 sky130_fd_sc_hd__diode_2
X_2314_ _0858_ _0859_ vssd1 vssd1 vccd1 vccd1 _0860_ sky130_fd_sc_hd__nand2b_1
X_3294_ clknet_leaf_0_clk _0252_ net94 vssd1 vssd1 vccd1 vccd1 MATMULT_INST.matmult_inst.alu_inst.a0_reg\[2\]
+ sky130_fd_sc_hd__dfrtp_1
XTAP_TAPCELL_ROW_68_747 vssd1 vccd1 sky130_fd_sc_hd__tapvpwrvgnd_1
X_2245_ _0792_ vssd1 vssd1 vccd1 vccd1 _0793_ sky130_fd_sc_hd__inv_2
X_2176_ net225 net223 net227 net230 vssd1 vssd1 vccd1 vccd1 _0726_ sky130_fd_sc_hd__nand4_1
XANTENNA_fanout169_A net171 vssd1 vssd1 vccd1 vccd1 sky130_fd_sc_hd__diode_2
XTAP_TAPCELL_ROW_51_603 vssd1 vccd1 sky130_fd_sc_hd__tapvpwrvgnd_1
XANTENNA__1695__A MATMULT_INST.matmult_inst.fsm_inst.alu_result\[8\] vssd1 vssd1 vccd1
+ vccd1 sky130_fd_sc_hd__diode_2
XPHY_EDGE_ROW_1_Right_1 vssd1 vssd1 vccd1 vccd1 sky130_fd_sc_hd__decap_3
XFILLER_0_225 vccd1 vssd1 vccd1 vssd1 sky130_ef_sc_hd__decap_40_12
Xteam_02_311 vssd1 vssd1 vccd1 vccd1 gpio_oeb[31] team_02_311/LO sky130_fd_sc_hd__conb_1
XFILLER_0_258 vccd1 vssd1 vccd1 vssd1 sky130_ef_sc_hd__decap_40_12
Xteam_02_300 vssd1 vssd1 vccd1 vccd1 gpio_oeb[20] team_02_300/LO sky130_fd_sc_hd__conb_1
XFILLER_72_44 vssd1 vssd1 vccd1 vccd1 sky130_fd_sc_hd__fill_2
XFILLER_71_276 vssd1 vssd1 vccd1 vccd1 sky130_fd_sc_hd__fill_2
XFILLER_12_321 vccd1 vssd1 vccd1 vssd1 sky130_ef_sc_hd__decap_40_12
XFILLER_12_365 vccd1 vssd1 vccd1 vssd1 sky130_ef_sc_hd__decap_40_12
XTAP_TAPCELL_ROW_22_360 vssd1 vccd1 sky130_fd_sc_hd__tapvpwrvgnd_1
XANTENNA__1809__S net16 vssd1 vssd1 vccd1 vccd1 sky130_fd_sc_hd__diode_2
XANTENNA__2566__A0 _0966_ vssd1 vssd1 vccd1 vccd1 sky130_fd_sc_hd__diode_2
XFILLER_21_92 vccd1 vssd1 vccd1 vssd1 sky130_ef_sc_hd__decap_40_12
XFILLER_79_365 vssd1 vssd1 vccd1 vccd1 sky130_fd_sc_hd__fill_8
XANTENNA__3044__B net168 vssd1 vssd1 vccd1 vccd1 sky130_fd_sc_hd__diode_2
X_2030_ _0603_ _0604_ vssd1 vssd1 vccd1 vccd1 _0605_ sky130_fd_sc_hd__xnor2_1
XTAP_TAPCELL_ROW_65_728 vssd1 vccd1 sky130_fd_sc_hd__tapvpwrvgnd_1
XANTENNA__3060__A net178 vssd1 vssd1 vccd1 vccd1 sky130_fd_sc_hd__diode_2
XTAP_TAPCELL_ROW_73_794 vssd1 vccd1 sky130_fd_sc_hd__tapvpwrvgnd_1
X_2932_ net446 net49 net8 vssd1 vssd1 vccd1 vccd1 _0419_ sky130_fd_sc_hd__mux2_1
XFILLER_62_287 vssd1 vssd1 vccd1 vccd1 sky130_fd_sc_hd__fill_1
XFILLER_15_181 vccd1 vssd1 vccd1 vssd1 sky130_ef_sc_hd__decap_40_12
XANTENNA__1719__S net23 vssd1 vssd1 vccd1 vccd1 sky130_fd_sc_hd__diode_2
X_2863_ _1299_ _1300_ _1285_ vssd1 vssd1 vccd1 vccd1 _1331_ sky130_fd_sc_hd__o21bai_1
XANTENNA__2404__A net183 vssd1 vssd1 vccd1 vccd1 sky130_fd_sc_hd__diode_2
X_2794_ _1229_ _1230_ _1228_ vssd1 vssd1 vccd1 vccd1 _1264_ sky130_fd_sc_hd__a21bo_1
X_1814_ net463 net45 net16 vssd1 vssd1 vccd1 vccd1 _0148_ sky130_fd_sc_hd__mux2_1
X_1745_ net443 net33 net21 vssd1 vssd1 vccd1 vccd1 _0085_ sky130_fd_sc_hd__mux2_1
XFILLER_7_391 vssd1 vssd1 vccd1 vccd1 sky130_fd_sc_hd__fill_1
Xhold325 _0326_ vssd1 vssd1 vccd1 vccd1 net638 sky130_fd_sc_hd__dlygate4sd3_1
Xhold314 MATMULT_INST.matmult_inst.mem_inst.mem3\[8\] vssd1 vssd1 vccd1 vccd1 net627
+ sky130_fd_sc_hd__dlygate4sd3_1
Xhold303 MATMULT_INST.matmult_inst.mem_inst.mem1\[1\] vssd1 vssd1 vccd1 vccd1 net616
+ sky130_fd_sc_hd__dlygate4sd3_1
Xhold347 MATMULT_INST.matmult_inst.spi_inst.tx_reg_sys\[16\] vssd1 vssd1 vccd1 vccd1
+ net660 sky130_fd_sc_hd__dlygate4sd3_1
Xhold358 MATMULT_INST.matmult_inst.alu_inst.adder_inst.r0.fa2.a vssd1 vssd1 vccd1
+ vccd1 net671 sky130_fd_sc_hd__dlygate4sd3_1
Xhold336 MATMULT_INST.matmult_inst.alu_inst.adder_inst.r1.fa0.a vssd1 vssd1 vccd1
+ vccd1 net649 sky130_fd_sc_hd__dlygate4sd3_1
X_1676_ net59 net61 vssd1 vssd1 vccd1 vccd1 _0482_ sky130_fd_sc_hd__or2_1
X_3415_ clknet_leaf_10_clk _0368_ net138 vssd1 vssd1 vccd1 vccd1 MATMULT_INST.matmult_inst.addr\[0\]
+ sky130_fd_sc_hd__dfrtp_1
X_3346_ clknet_leaf_30_clk _0301_ vssd1 vssd1 vccd1 vccd1 MATMULT_INST.matmult_inst.alu_inst.adder_inst.r2.fa1.a
+ sky130_fd_sc_hd__dfxtp_1
X_3277_ clknet_leaf_23_clk _0235_ net97 vssd1 vssd1 vccd1 vccd1 MATMULT_INST.matmult_inst.mem_inst.matrixA1\[12\]
+ sky130_fd_sc_hd__dfrtp_1
X_2228_ _0758_ _0759_ _0775_ vssd1 vssd1 vccd1 vccd1 _0777_ sky130_fd_sc_hd__o21ai_1
XFILLER_26_15 vssd1 vssd1 vccd1 vccd1 sky130_fd_sc_hd__fill_4
XTAP_TAPCELL_ROW_28_408 vssd1 vccd1 sky130_fd_sc_hd__tapvpwrvgnd_1
X_2159_ net231 net233 net222 net219 vssd1 vssd1 vccd1 vccd1 _0709_ sky130_fd_sc_hd__and4_1
XFILLER_53_221 vssd1 vssd1 vccd1 vccd1 sky130_fd_sc_hd__fill_2
XANTENNA_fanout241_X net241 vssd1 vssd1 vccd1 vccd1 sky130_fd_sc_hd__diode_2
XTAP_TAPCELL_ROW_36_474 vssd1 vccd1 sky130_fd_sc_hd__tapvpwrvgnd_1
XFILLER_21_140 vssd1 vssd1 vccd1 vccd1 sky130_fd_sc_hd__fill_2
XFILLER_5_317 vccd1 vssd1 vccd1 vssd1 sky130_ef_sc_hd__decap_40_12
XPHY_EDGE_ROW_10_Left_90 vssd1 vssd1 vccd1 vccd1 sky130_fd_sc_hd__decap_3
XFILLER_67_11 vssd1 vssd1 vccd1 vccd1 sky130_fd_sc_hd__fill_2
XANTENNA__2079__A2 net68 vssd1 vssd1 vccd1 vccd1 sky130_fd_sc_hd__diode_2
XANTENNA__3028__A1 net92 vssd1 vssd1 vccd1 vccd1 sky130_fd_sc_hd__diode_2
XANTENNA__3028__B2 net165 vssd1 vssd1 vccd1 vccd1 sky130_fd_sc_hd__diode_2
XANTENNA__2923__S net9 vssd1 vssd1 vccd1 vccd1 sky130_fd_sc_hd__diode_2
XTAP_TAPCELL_ROW_70_764 vssd1 vccd1 sky130_fd_sc_hd__tapvpwrvgnd_1
XFILLER_16_81 vssd1 vssd1 vccd1 vccd1 sky130_fd_sc_hd__fill_2
Xclkbuf_leaf_24_clk clknet_2_2__leaf_clk vssd1 vssd1 vccd1 vccd1 clknet_leaf_24_clk
+ sky130_fd_sc_hd__clkbuf_8
XFILLER_12_195 vssd1 vssd1 vccd1 vccd1 sky130_fd_sc_hd__fill_1
XFILLER_8_133 vssd1 vssd1 vccd1 vccd1 sky130_fd_sc_hd__fill_4
XFILLER_8_177 vccd1 vssd1 vccd1 vssd1 sky130_ef_sc_hd__decap_40_12
XANTENNA__2511__X _1022_ vssd1 vssd1 vccd1 vccd1 sky130_fd_sc_hd__diode_2
XFILLER_4_361 vssd1 vssd1 vccd1 vccd1 sky130_fd_sc_hd__fill_2
X_3200_ clknet_leaf_13_clk _0158_ net145 vssd1 vssd1 vccd1 vccd1 MATMULT_INST.matmult_inst.mem_inst.matrixA3\[7\]
+ sky130_fd_sc_hd__dfrtp_1
X_3131_ clknet_leaf_24_clk _0089_ net121 vssd1 vssd1 vccd1 vccd1 MATMULT_INST.matmult_inst.mem_inst.matrixA2\[10\]
+ sky130_fd_sc_hd__dfrtp_1
XFILLER_67_302 vssd1 vssd1 vccd1 vccd1 sky130_fd_sc_hd__fill_1
XTAP_TAPCELL_ROW_78_831 vssd1 vccd1 sky130_fd_sc_hd__tapvpwrvgnd_1
XFILLER_67_335 vssd1 vssd1 vccd1 vccd1 sky130_fd_sc_hd__fill_1
X_3062_ net156 _1473_ _1477_ net161 vssd1 vssd1 vccd1 vccd1 _1480_ sky130_fd_sc_hd__a22o_1
X_2013_ _0583_ _0586_ _0584_ vssd1 vssd1 vccd1 vccd1 _0591_ sky130_fd_sc_hd__a21boi_1
XANTENNA__2490__A2 net90 vssd1 vssd1 vccd1 vccd1 sky130_fd_sc_hd__diode_2
Xclkbuf_leaf_15_clk clknet_2_3__leaf_clk vssd1 vssd1 vccd1 vccd1 clknet_leaf_15_clk
+ sky130_fd_sc_hd__clkbuf_8
XTAP_TAPCELL_ROW_33_455 vssd1 vccd1 sky130_fd_sc_hd__tapvpwrvgnd_1
X_2915_ net69 _1378_ _1379_ _1373_ vssd1 vssd1 vccd1 vccd1 _0384_ sky130_fd_sc_hd__a31o_1
XFILLER_50_279 vssd1 vssd1 vccd1 vccd1 sky130_fd_sc_hd__fill_1
X_2846_ net203 net184 vssd1 vssd1 vccd1 vccd1 _1314_ sky130_fd_sc_hd__and2_1
Xhold100 MATMULT_INST.matmult_inst.spi_inst.tx_reg_sys\[15\] vssd1 vssd1 vccd1 vccd1
+ net413 sky130_fd_sc_hd__dlygate4sd3_1
X_2777_ net199 net192 net190 vssd1 vssd1 vccd1 vccd1 _1247_ sky130_fd_sc_hd__and3_1
Xhold122 MATMULT_INST.matmult_inst.mem_inst.matrixA1\[6\] vssd1 vssd1 vccd1 vccd1
+ net435 sky130_fd_sc_hd__dlygate4sd3_1
XFILLER_2_309 vccd1 vssd1 vccd1 vssd1 sky130_ef_sc_hd__decap_40_12
Xhold133 MATMULT_INST.matmult_inst.mem_inst.matrixB3\[11\] vssd1 vssd1 vccd1 vccd1
+ net446 sky130_fd_sc_hd__dlygate4sd3_1
Xhold111 _0321_ vssd1 vssd1 vccd1 vccd1 net424 sky130_fd_sc_hd__dlygate4sd3_1
X_1728_ net622 net50 net22 vssd1 vssd1 vccd1 vccd1 _0071_ sky130_fd_sc_hd__mux2_1
Xhold144 MATMULT_INST.matmult_inst.mem_inst.matrixA1\[9\] vssd1 vssd1 vccd1 vccd1
+ net457 sky130_fd_sc_hd__dlygate4sd3_1
XANTENNA__2788__B net206 vssd1 vssd1 vccd1 vccd1 sky130_fd_sc_hd__diode_2
Xhold177 MATMULT_INST.matmult_inst.alu_inst.row0\[5\] vssd1 vssd1 vccd1 vccd1 net490
+ sky130_fd_sc_hd__dlygate4sd3_1
X_1659_ MATMULT_INST.matmult_inst.spi_inst.tx_reg_sys\[8\] MATMULT_INST.matmult_inst.spi_inst.miso_shifter\[7\]
+ net153 vssd1 vssd1 vccd1 vccd1 _0020_ sky130_fd_sc_hd__mux2_1
Xhold155 MATMULT_INST.matmult_inst.mem_inst.matrixA0\[3\] vssd1 vssd1 vccd1 vccd1
+ net468 sky130_fd_sc_hd__dlygate4sd3_1
Xhold166 MATMULT_INST.matmult_inst.mem_inst.mem0\[5\] vssd1 vssd1 vccd1 vccd1 net479
+ sky130_fd_sc_hd__dlygate4sd3_1
Xhold188 MATMULT_INST.matmult_inst.mem_inst.mem2\[17\] vssd1 vssd1 vccd1 vccd1 net501
+ sky130_fd_sc_hd__dlygate4sd3_1
Xhold199 MATMULT_INST.matmult_inst.mem_inst.mem0\[2\] vssd1 vssd1 vccd1 vccd1 net512
+ sky130_fd_sc_hd__dlygate4sd3_1
X_3329_ clknet_leaf_6_clk _0285_ net112 vssd1 vssd1 vccd1 vccd1 MATMULT_INST.matmult_inst.alu_inst.a1_reg\[1\]
+ sky130_fd_sc_hd__dfrtp_1
XFILLER_53_57 vssd1 vssd1 vccd1 vccd1 sky130_fd_sc_hd__fill_2
XFILLER_41_279 vssd1 vssd1 vccd1 vccd1 sky130_fd_sc_hd__fill_1
XFILLER_22_493 vssd1 vssd1 vccd1 vccd1 sky130_fd_sc_hd__fill_1
XFILLER_5_125 vccd1 vssd1 vccd1 vssd1 sky130_ef_sc_hd__decap_40_12
XFILLER_5_169 vccd1 vssd1 vccd1 vssd1 sky130_ef_sc_hd__decap_40_12
XFILLER_78_65 vccd1 vssd1 vccd1 vssd1 sky130_ef_sc_hd__decap_40_12
XANTENNA__1822__S net15 vssd1 vssd1 vccd1 vccd1 sky130_fd_sc_hd__diode_2
XFILLER_76_154 vssd1 vssd1 vccd1 vccd1 sky130_fd_sc_hd__fill_2
XTAP_TAPCELL_ROW_75_812 vssd1 vccd1 sky130_fd_sc_hd__tapvpwrvgnd_1
XTAP_TAPCELL_ROW_47_569 vssd1 vccd1 sky130_fd_sc_hd__tapvpwrvgnd_1
X_2700_ _1168_ _1169_ _1146_ vssd1 vssd1 vccd1 vccd1 _1172_ sky130_fd_sc_hd__a21oi_1
XTAP_TAPCELL_ROW_30_425 vssd1 vccd1 sky130_fd_sc_hd__tapvpwrvgnd_1
X_2631_ _1104_ _1105_ vssd1 vssd1 vccd1 vccd1 _1106_ sky130_fd_sc_hd__and2b_1
X_2562_ net425 _1022_ net40 vssd1 vssd1 vccd1 vccd1 _0358_ sky130_fd_sc_hd__mux2_1
X_2493_ net182 net173 MATMULT_INST.matmult_inst.mem_inst.mem3\[5\] vssd1 vssd1 vccd1
+ vccd1 _1005_ sky130_fd_sc_hd__and3_1
XANTENNA__1732__S net22 vssd1 vssd1 vccd1 vccd1 sky130_fd_sc_hd__diode_2
XFILLER_67_110 vssd1 vssd1 vccd1 vccd1 sky130_fd_sc_hd__fill_2
X_3114_ clknet_leaf_18_clk _0072_ net130 vssd1 vssd1 vccd1 vccd1 MATMULT_INST.matmult_inst.mem_inst.matrixA0\[11\]
+ sky130_fd_sc_hd__dfrtp_1
X_3045_ MATMULT_INST.matmult_inst.mem_inst.matrixA2\[16\] net85 net77 MATMULT_INST.matmult_inst.mem_inst.matrixA1\[16\]
+ _1463_ vssd1 vssd1 vccd1 vccd1 _1464_ sky130_fd_sc_hd__a221o_1
XANTENNA__2463__A2 _0954_ vssd1 vssd1 vccd1 vccd1 sky130_fd_sc_hd__diode_2
XANTENNA__3504__CLK net242 vssd1 vssd1 vccd1 vccd1 sky130_fd_sc_hd__diode_2
XANTENNA_fanout151_A net152 vssd1 vssd1 vccd1 vccd1 sky130_fd_sc_hd__diode_2
XANTENNA__2563__S net40 vssd1 vssd1 vccd1 vccd1 sky130_fd_sc_hd__diode_2
XFILLER_23_279 vssd1 vssd1 vccd1 vccd1 sky130_fd_sc_hd__fill_1
XFILLER_23_49 vssd1 vssd1 vccd1 vccd1 sky130_fd_sc_hd__fill_2
XANTENNA__1907__S net26 vssd1 vssd1 vccd1 vccd1 sky130_fd_sc_hd__diode_2
X_2829_ _1251_ _1296_ _1295_ vssd1 vssd1 vccd1 vccd1 _1298_ sky130_fd_sc_hd__a21oi_1
XANTENNA_fanout204_X net204 vssd1 vssd1 vccd1 vccd1 sky130_fd_sc_hd__diode_2
XANTENNA__2311__B net213 vssd1 vssd1 vccd1 vccd1 sky130_fd_sc_hd__diode_2
XFILLER_2_139 vssd1 vssd1 vccd1 vccd1 sky130_fd_sc_hd__fill_1
XFILLER_78_419 vssd1 vssd1 vccd1 vccd1 sky130_fd_sc_hd__fill_1
XFILLER_58_143 vssd1 vssd1 vccd1 vccd1 sky130_fd_sc_hd__fill_8
XANTENNA_fanout64_A _0944_ vssd1 vssd1 vccd1 vccd1 sky130_fd_sc_hd__diode_2
XFILLER_61_308 vssd1 vssd1 vccd1 vccd1 sky130_fd_sc_hd__fill_1
XTAP_TAPCELL_ROW_1_183 vssd1 vccd1 sky130_fd_sc_hd__tapvpwrvgnd_1
XANTENNA__2981__B net168 vssd1 vssd1 vccd1 vccd1 sky130_fd_sc_hd__diode_2
XFILLER_64_89 vssd1 vssd1 vccd1 vccd1 sky130_fd_sc_hd__fill_1
Xfanout50 _0495_ vssd1 vssd1 vccd1 vccd1 net50 sky130_fd_sc_hd__clkbuf_2
Xfanout83 net84 vssd1 vssd1 vccd1 vccd1 net83 sky130_fd_sc_hd__clkbuf_4
Xfanout72 _0608_ vssd1 vssd1 vccd1 vccd1 net72 sky130_fd_sc_hd__clkbuf_2
Xfanout61 _0481_ vssd1 vssd1 vccd1 vccd1 net61 sky130_fd_sc_hd__clkbuf_4
XFILLER_6_401 vccd1 vssd1 vccd1 vssd1 sky130_ef_sc_hd__decap_40_12
Xfanout94 net95 vssd1 vssd1 vccd1 vccd1 net94 sky130_fd_sc_hd__clkbuf_4
XFILLER_6_445 vccd1 vssd1 vccd1 vssd1 sky130_ef_sc_hd__decap_40_12
XFILLER_6_489 vssd1 vssd1 vccd1 vccd1 sky130_fd_sc_hd__fill_4
XTAP_TAPCELL_ROW_9_250 vssd1 vccd1 sky130_fd_sc_hd__tapvpwrvgnd_1
XANTENNA__2390__B2 MATMULT_INST.matmult_inst.fsm_inst.alu_result\[6\] vssd1 vssd1
+ vccd1 vccd1 sky130_fd_sc_hd__diode_2
XFILLER_1_161 vssd1 vssd1 vccd1 vccd1 sky130_fd_sc_hd__fill_4
XFILLER_49_121 vssd1 vssd1 vccd1 vccd1 sky130_fd_sc_hd__fill_1
XANTENNA__2142__A1 net239 vssd1 vssd1 vccd1 vccd1 sky130_fd_sc_hd__diode_2
XFILLER_77_485 vssd1 vssd1 vccd1 vccd1 sky130_fd_sc_hd__fill_4
XANTENNA__3527__CLK net242 vssd1 vssd1 vccd1 vccd1 sky130_fd_sc_hd__diode_2
XFILLER_64_113 vssd1 vssd1 vccd1 vccd1 sky130_fd_sc_hd__fill_2
XANTENNA__2594__D net192 vssd1 vssd1 vccd1 vccd1 sky130_fd_sc_hd__diode_2
XANTENNA__2445__A2 net89 vssd1 vssd1 vccd1 vccd1 sky130_fd_sc_hd__diode_2
XANTENNA_clkbuf_leaf_0_clk_A clknet_2_0__leaf_clk vssd1 vssd1 vccd1 vccd1 sky130_fd_sc_hd__diode_2
XFILLER_20_227 vssd1 vssd1 vccd1 vccd1 sky130_fd_sc_hd__fill_1
X_1993_ MATMULT_INST.matmult_inst.alu_inst.adder_inst.r2.fa2.b MATMULT_INST.matmult_inst.alu_inst.adder_inst.r2.fa2.a
+ vssd1 vssd1 vccd1 vccd1 _0574_ sky130_fd_sc_hd__nand2_1
XTAP_TAPCELL_ROW_15_296 vssd1 vccd1 sky130_fd_sc_hd__tapvpwrvgnd_1
XFILLER_9_261 vccd1 vssd1 vccd1 vssd1 sky130_ef_sc_hd__decap_40_12
XANTENNA__1727__S net22 vssd1 vssd1 vccd1 vccd1 sky130_fd_sc_hd__diode_2
Xclkload20 clknet_leaf_8_clk vssd1 vssd1 vccd1 vccd1 clkload20/Y sky130_fd_sc_hd__clkinv_2
X_2614_ net194 net205 vssd1 vssd1 vccd1 vccd1 _1089_ sky130_fd_sc_hd__and2_1
X_2545_ net76 _1534_ vssd1 vssd1 vccd1 vccd1 _1045_ sky130_fd_sc_hd__or2_1
X_2476_ net181 net172 MATMULT_INST.matmult_inst.mem_inst.matrixA3\[4\] vssd1 vssd1
+ vccd1 vccd1 _0989_ sky130_fd_sc_hd__and3_1
XFILLER_55_113 vssd1 vssd1 vccd1 vccd1 sky130_fd_sc_hd__fill_1
X_3028_ net92 _1442_ _1448_ net165 vssd1 vssd1 vccd1 vccd1 _1449_ sky130_fd_sc_hd__a22o_1
XFILLER_11_205 vccd1 vssd1 vccd1 vssd1 sky130_ef_sc_hd__decap_40_12
XFILLER_11_249 vccd1 vssd1 vccd1 vssd1 sky130_ef_sc_hd__decap_40_12
Xclkload3 clknet_leaf_26_clk vssd1 vssd1 vccd1 vccd1 clkload3/Y sky130_fd_sc_hd__clkinv_4
XFILLER_50_58 vssd1 vssd1 vccd1 vccd1 sky130_fd_sc_hd__fill_2
XFILLER_78_249 vssd1 vssd1 vccd1 vccd1 sky130_fd_sc_hd__fill_2
XTAP_TAPCELL_ROW_6_220 vssd1 vccd1 sky130_fd_sc_hd__tapvpwrvgnd_1
Xfanout240 MATMULT_INST.matmult_inst.alu_inst.b0_reg\[1\] vssd1 vssd1 vccd1 vccd1
+ net240 sky130_fd_sc_hd__clkbuf_2
XANTENNA_fanout67_X net67 vssd1 vssd1 vccd1 vccd1 sky130_fd_sc_hd__diode_2
XTAP_TAPCELL_ROW_57_653 vssd1 vccd1 sky130_fd_sc_hd__tapvpwrvgnd_1
XFILLER_75_99 vssd1 vssd1 vccd1 vccd1 sky130_fd_sc_hd__fill_1
XFILLER_74_477 vccd1 vssd1 vccd1 vssd1 sky130_ef_sc_hd__decap_40_12
XFILLER_42_363 vssd1 vssd1 vccd1 vccd1 sky130_fd_sc_hd__fill_1
XANTENNA_clkbuf_2_3__f_clk_X clknet_2_3__leaf_clk vssd1 vssd1 vccd1 vccd1 sky130_fd_sc_hd__diode_2
XANTENNA__2931__S net8 vssd1 vssd1 vccd1 vccd1 sky130_fd_sc_hd__diode_2
XTAP_TAPCELL_ROW_12_277 vssd1 vccd1 sky130_fd_sc_hd__tapvpwrvgnd_1
XFILLER_6_253 vccd1 vssd1 vccd1 vssd1 sky130_ef_sc_hd__decap_40_12
XFILLER_40_80 vssd1 vssd1 vccd1 vccd1 sky130_fd_sc_hd__fill_4
X_2330_ _0874_ _0875_ _0851_ vssd1 vssd1 vccd1 vccd1 _0876_ sky130_fd_sc_hd__a21oi_1
XFILLER_69_249 vssd1 vssd1 vccd1 vccd1 sky130_fd_sc_hd__fill_4
X_2261_ _0805_ _0806_ _0808_ vssd1 vssd1 vccd1 vccd1 _0809_ sky130_fd_sc_hd__nand3_1
X_2192_ _0739_ _0740_ _0706_ vssd1 vssd1 vccd1 vccd1 _0742_ sky130_fd_sc_hd__a21o_1
XFILLER_37_157 vssd1 vssd1 vccd1 vccd1 sky130_fd_sc_hd__fill_1
X_1976_ _0550_ _0554_ _0551_ vssd1 vssd1 vccd1 vccd1 _0560_ sky130_fd_sc_hd__o21ai_1
XANTENNA_fanout114_A net152 vssd1 vssd1 vccd1 vccd1 sky130_fd_sc_hd__diode_2
XFILLER_20_17 vssd1 vssd1 vccd1 vccd1 sky130_fd_sc_hd__fill_1
X_2528_ _0966_ net621 _1035_ vssd1 vssd1 vccd1 vccd1 _0341_ sky130_fd_sc_hd__mux2_1
Xhold15 MATMULT_INST.matmult_inst.spi_inst.mosi_data_sync\[2\] vssd1 vssd1 vccd1 vccd1
+ net328 sky130_fd_sc_hd__dlygate4sd3_1
XTAP_TAPCELL_ROW_3_201 vssd1 vccd1 sky130_fd_sc_hd__tapvpwrvgnd_1
Xhold26 MATMULT_INST.matmult_inst.alu_inst.adder_inst.r1.fa3.a vssd1 vssd1 vccd1 vccd1
+ net339 sky130_fd_sc_hd__dlygate4sd3_1
Xhold37 MATMULT_INST.matmult_inst.mem_inst.matrixB3\[0\] vssd1 vssd1 vccd1 vccd1 net350
+ sky130_fd_sc_hd__dlygate4sd3_1
X_2459_ MATMULT_INST.matmult_inst.mem_inst.matrixA2\[2\] net89 net82 MATMULT_INST.matmult_inst.mem_inst.matrixA1\[2\]
+ _0973_ vssd1 vssd1 vccd1 vccd1 _0974_ sky130_fd_sc_hd__a221o_1
Xhold48 MATMULT_INST.matmult_inst.alu_inst.row0\[7\] vssd1 vssd1 vccd1 vccd1 net361
+ sky130_fd_sc_hd__dlygate4sd3_1
Xhold59 _0318_ vssd1 vssd1 vccd1 vccd1 net372 sky130_fd_sc_hd__dlygate4sd3_1
XFILLER_28_157 vssd1 vssd1 vccd1 vccd1 sky130_fd_sc_hd__fill_8
XFILLER_71_447 vssd1 vssd1 vccd1 vccd1 sky130_fd_sc_hd__fill_1
XTAP_TAPCELL_ROW_54_634 vssd1 vccd1 sky130_fd_sc_hd__tapvpwrvgnd_1
XFILLER_61_57 vccd1 vssd1 vccd1 vssd1 sky130_ef_sc_hd__decap_40_12
XANTENNA__2042__A0 net198 vssd1 vssd1 vccd1 vccd1 sky130_fd_sc_hd__diode_2
XFILLER_3_223 vssd1 vssd1 vccd1 vccd1 sky130_fd_sc_hd__fill_1
XFILLER_10_83 vssd1 vssd1 vccd1 vccd1 sky130_fd_sc_hd__fill_1
XFILLER_19_102 vssd1 vssd1 vccd1 vccd1 sky130_fd_sc_hd__fill_1
XFILLER_19_113 vssd1 vssd1 vccd1 vccd1 sky130_fd_sc_hd__fill_1
XANTENNA__1830__S net14 vssd1 vssd1 vccd1 vccd1 sky130_fd_sc_hd__diode_2
XFILLER_19_124 vssd1 vssd1 vccd1 vccd1 sky130_fd_sc_hd__fill_1
XFILLER_19_135 vssd1 vssd1 vccd1 vccd1 sky130_fd_sc_hd__fill_4
XANTENNA__2926__S net9 vssd1 vssd1 vccd1 vccd1 sky130_fd_sc_hd__diode_2
XFILLER_74_263 vssd1 vssd1 vccd1 vccd1 sky130_fd_sc_hd__fill_1
XFILLER_19_157 vssd1 vssd1 vccd1 vccd1 sky130_fd_sc_hd__fill_2
XANTENNA__3322__RESET_B net114 vssd1 vssd1 vccd1 vccd1 sky130_fd_sc_hd__diode_2
XTAP_TAPCELL_ROW_17_314 vssd1 vccd1 sky130_fd_sc_hd__tapvpwrvgnd_1
XFILLER_27_190 vssd1 vssd1 vccd1 vccd1 sky130_fd_sc_hd__fill_2
X_1830_ net610 net48 net14 vssd1 vssd1 vccd1 vccd1 _0163_ sky130_fd_sc_hd__mux2_1
XFILLER_30_333 vssd1 vssd1 vccd1 vccd1 sky130_fd_sc_hd__fill_1
XFILLER_42_193 vssd1 vssd1 vccd1 vccd1 sky130_fd_sc_hd__fill_2
XANTENNA__3058__A net178 vssd1 vssd1 vccd1 vccd1 sky130_fd_sc_hd__diode_2
X_3500_ net243 _0020_ net129 vssd1 vssd1 vccd1 vccd1 MATMULT_INST.matmult_inst.spi_inst.miso_shifter\[8\]
+ sky130_fd_sc_hd__dfrtp_1
X_1761_ net351 net38 net19 vssd1 vssd1 vccd1 vccd1 _0098_ sky130_fd_sc_hd__mux2_1
X_1692_ net528 net33 net25 vssd1 vssd1 vccd1 vccd1 _0049_ sky130_fd_sc_hd__mux2_1
X_3431_ clknet_leaf_30_clk _0383_ vssd1 vssd1 vccd1 vccd1 MATMULT_INST.matmult_inst.alu_inst.adder_inst.r3.fa1.b
+ sky130_fd_sc_hd__dfxtp_1
X_3362_ clknet_leaf_1_clk net515 net103 vssd1 vssd1 vccd1 vccd1 MATMULT_INST.matmult_inst.fsm_inst.alu_result\[8\]
+ sky130_fd_sc_hd__dfrtp_1
X_2313_ net215 net231 net233 net213 vssd1 vssd1 vccd1 vccd1 _0859_ sky130_fd_sc_hd__a22o_1
X_3293_ clknet_leaf_0_clk _0251_ net94 vssd1 vssd1 vccd1 vccd1 MATMULT_INST.matmult_inst.alu_inst.a0_reg\[1\]
+ sky130_fd_sc_hd__dfrtp_1
X_2244_ _0790_ _0791_ _0785_ vssd1 vssd1 vccd1 vccd1 _0792_ sky130_fd_sc_hd__a21o_1
XTAP_TAPCELL_ROW_68_748 vssd1 vccd1 sky130_fd_sc_hd__tapvpwrvgnd_1
X_2175_ net225 net228 net230 net223 vssd1 vssd1 vccd1 vccd1 _0725_ sky130_fd_sc_hd__a22o_1
XANTENNA__1740__S net20 vssd1 vssd1 vccd1 vccd1 sky130_fd_sc_hd__diode_2
XTAP_TAPCELL_ROW_51_604 vssd1 vccd1 sky130_fd_sc_hd__tapvpwrvgnd_1
XFILLER_53_469 vssd1 vssd1 vccd1 vccd1 sky130_fd_sc_hd__fill_1
XANTENNA__2571__S _1053_ vssd1 vssd1 vccd1 vccd1 sky130_fd_sc_hd__diode_2
XANTENNA__1695__B net60 vssd1 vssd1 vccd1 vccd1 sky130_fd_sc_hd__diode_2
XFILLER_31_27 vccd1 vssd1 vccd1 vssd1 sky130_ef_sc_hd__decap_40_12
X_1959_ MATMULT_INST.matmult_inst.alu_inst.adder_inst.r1.fa1.b MATMULT_INST.matmult_inst.alu_inst.adder_inst.r1.fa1.a
+ vssd1 vssd1 vccd1 vccd1 _0545_ sky130_fd_sc_hd__nor2_1
XANTENNA__1915__S net54 vssd1 vssd1 vccd1 vccd1 sky130_fd_sc_hd__diode_2
XFILLER_0_237 vssd1 vssd1 vccd1 vccd1 sky130_fd_sc_hd__fill_4
Xteam_02_301 vssd1 vssd1 vccd1 vccd1 gpio_oeb[21] team_02_301/LO sky130_fd_sc_hd__conb_1
Xteam_02_312 vssd1 vssd1 vccd1 vccd1 gpio_oeb[32] team_02_312/LO sky130_fd_sc_hd__conb_1
XFILLER_56_24 vssd1 vssd1 vccd1 vccd1 sky130_fd_sc_hd__fill_1
XFILLER_71_200 vssd1 vssd1 vccd1 vccd1 sky130_fd_sc_hd__fill_2
XFILLER_56_68 vssd1 vssd1 vccd1 vccd1 sky130_fd_sc_hd__fill_4
XFILLER_16_138 vssd1 vssd1 vccd1 vccd1 sky130_fd_sc_hd__fill_2
XANTENNA__3055__A2 net87 vssd1 vssd1 vccd1 vccd1 sky130_fd_sc_hd__diode_2
XFILLER_72_67 vssd1 vssd1 vccd1 vccd1 sky130_fd_sc_hd__fill_1
XFILLER_12_333 vccd1 vssd1 vccd1 vssd1 sky130_ef_sc_hd__decap_40_12
XFILLER_12_377 vccd1 vssd1 vccd1 vssd1 sky130_ef_sc_hd__decap_40_12
XTAP_TAPCELL_ROW_22_361 vssd1 vccd1 sky130_fd_sc_hd__tapvpwrvgnd_1
XANTENNA__2213__C net222 vssd1 vssd1 vccd1 vccd1 sky130_fd_sc_hd__diode_2
XANTENNA__1825__S net15 vssd1 vssd1 vccd1 vccd1 sky130_fd_sc_hd__diode_2
XFILLER_79_399 vssd1 vssd1 vccd1 vccd1 sky130_fd_sc_hd__fill_8
XFILLER_79_377 vssd1 vssd1 vccd1 vccd1 sky130_fd_sc_hd__fill_8
XANTENNA__3060__B net169 vssd1 vssd1 vccd1 vccd1 sky130_fd_sc_hd__diode_2
XTAP_TAPCELL_ROW_73_795 vssd1 vccd1 sky130_fd_sc_hd__tapvpwrvgnd_1
X_2931_ net369 net50 net8 vssd1 vssd1 vccd1 vccd1 _0418_ sky130_fd_sc_hd__mux2_1
XFILLER_15_193 vccd1 vssd1 vccd1 vssd1 sky130_ef_sc_hd__decap_40_12
Xclkbuf_0_clk clk vssd1 vssd1 vccd1 vccd1 clknet_0_clk sky130_fd_sc_hd__clkbuf_16
X_2862_ _1312_ _1329_ vssd1 vssd1 vccd1 vccd1 _1330_ sky130_fd_sc_hd__xnor2_1
XANTENNA__2557__A1 _0966_ vssd1 vssd1 vccd1 vccd1 sky130_fd_sc_hd__diode_2
X_1813_ net521 _0499_ net16 vssd1 vssd1 vccd1 vccd1 _0147_ sky130_fd_sc_hd__mux2_1
X_2793_ _1171_ _1211_ vssd1 vssd1 vccd1 vccd1 _1263_ sky130_fd_sc_hd__nand2_1
XFILLER_7_51 vssd1 vssd1 vccd1 vccd1 sky130_fd_sc_hd__fill_4
X_1744_ net466 net34 net21 vssd1 vssd1 vccd1 vccd1 _0084_ sky130_fd_sc_hd__mux2_1
Xhold304 MATMULT_INST.matmult_inst.alu_inst.row0\[3\] vssd1 vssd1 vccd1 vccd1 net617
+ sky130_fd_sc_hd__dlygate4sd3_1
Xhold326 MATMULT_INST.matmult_inst.mem_inst.mem1\[14\] vssd1 vssd1 vccd1 vccd1 net639
+ sky130_fd_sc_hd__dlygate4sd3_1
Xhold315 MATMULT_INST.matmult_inst.mem_inst.matrixA1\[7\] vssd1 vssd1 vccd1 vccd1
+ net628 sky130_fd_sc_hd__dlygate4sd3_1
XANTENNA__1735__S net22 vssd1 vssd1 vccd1 vccd1 sky130_fd_sc_hd__diode_2
Xhold337 MATMULT_INST.matmult_inst.alu_inst.out\[16\] vssd1 vssd1 vccd1 vccd1 net650
+ sky130_fd_sc_hd__dlygate4sd3_1
X_3414_ clknet_leaf_29_clk _0367_ net95 vssd1 vssd1 vccd1 vccd1 MATMULT_INST.matmult_inst.alu_inst.row0\[7\]
+ sky130_fd_sc_hd__dfrtp_1
Xhold359 MATMULT_INST.matmult_inst.alu_inst.adder_inst.fa.a vssd1 vssd1 vccd1 vccd1
+ net672 sky130_fd_sc_hd__dlygate4sd3_1
Xhold348 MATMULT_INST.matmult_inst.alu_inst.out\[6\] vssd1 vssd1 vccd1 vccd1 net661
+ sky130_fd_sc_hd__dlygate4sd3_1
X_1675_ MATMULT_INST.matmult_inst.fsm_inst.state\[0\] MATMULT_INST.matmult_inst.fsm_inst.state\[1\]
+ _1537_ vssd1 vssd1 vccd1 vccd1 _0481_ sky130_fd_sc_hd__and3b_1
XPHY_EDGE_ROW_15_Right_15 vssd1 vssd1 vccd1 vccd1 sky130_fd_sc_hd__decap_3
X_3345_ clknet_leaf_0_clk _0300_ vssd1 vssd1 vccd1 vccd1 MATMULT_INST.matmult_inst.alu_inst.adder_inst.r2.fa0.a
+ sky130_fd_sc_hd__dfxtp_1
X_3276_ clknet_leaf_19_clk _0234_ net126 vssd1 vssd1 vccd1 vccd1 MATMULT_INST.matmult_inst.mem_inst.matrixA1\[11\]
+ sky130_fd_sc_hd__dfrtp_1
X_2227_ _0758_ _0759_ _0775_ vssd1 vssd1 vccd1 vccd1 _0776_ sky130_fd_sc_hd__or3_1
XANTENNA__2566__S _1053_ vssd1 vssd1 vccd1 vccd1 sky130_fd_sc_hd__diode_2
XANTENNA_fanout181_A net183 vssd1 vssd1 vccd1 vccd1 sky130_fd_sc_hd__diode_2
XTAP_TAPCELL_ROW_28_409 vssd1 vccd1 sky130_fd_sc_hd__tapvpwrvgnd_1
X_2158_ net231 net222 net219 net233 vssd1 vssd1 vccd1 vccd1 _0708_ sky130_fd_sc_hd__a22oi_2
XFILLER_26_27 vssd1 vssd1 vccd1 vccd1 sky130_fd_sc_hd__fill_1
X_2089_ net239 net220 net237 net221 vssd1 vssd1 vccd1 vccd1 _0642_ sky130_fd_sc_hd__a22o_1
XANTENNA__3037__A2 net87 vssd1 vssd1 vccd1 vccd1 sky130_fd_sc_hd__diode_2
XPHY_EDGE_ROW_24_Right_24 vssd1 vssd1 vccd1 vccd1 sky130_fd_sc_hd__decap_3
XFILLER_26_49 vssd1 vssd1 vccd1 vccd1 sky130_fd_sc_hd__fill_2
XFILLER_13_108 vssd1 vssd1 vccd1 vccd1 sky130_fd_sc_hd__fill_4
XTAP_TAPCELL_ROW_36_475 vssd1 vccd1 sky130_fd_sc_hd__tapvpwrvgnd_1
XFILLER_21_152 vccd1 vssd1 vccd1 vssd1 sky130_ef_sc_hd__decap_40_12
XFILLER_5_329 vssd1 vssd1 vccd1 vccd1 sky130_fd_sc_hd__fill_4
XPHY_EDGE_ROW_33_Right_33 vssd1 vssd1 vccd1 vccd1 sky130_fd_sc_hd__decap_3
XFILLER_67_67 vccd1 vssd1 vccd1 vssd1 sky130_ef_sc_hd__decap_40_12
XANTENNA__2484__B1 net81 vssd1 vssd1 vccd1 vccd1 sky130_fd_sc_hd__diode_2
XPHY_EDGE_ROW_42_Right_42 vssd1 vssd1 vccd1 vccd1 sky130_fd_sc_hd__decap_3
XFILLER_17_469 vssd1 vssd1 vccd1 vccd1 sky130_fd_sc_hd__fill_1
XANTENNA__2505__A net183 vssd1 vssd1 vccd1 vccd1 sky130_fd_sc_hd__diode_2
XTAP_TAPCELL_ROW_70_765 vssd1 vccd1 sky130_fd_sc_hd__tapvpwrvgnd_1
XFILLER_12_141 vccd1 vssd1 vccd1 vssd1 sky130_ef_sc_hd__decap_40_12
XPHY_EDGE_ROW_51_Right_51 vssd1 vssd1 vccd1 vccd1 sky130_fd_sc_hd__decap_3
XFILLER_8_189 vssd1 vssd1 vccd1 vccd1 sky130_fd_sc_hd__fill_4
XFILLER_79_141 vccd1 vssd1 vccd1 vssd1 sky130_ef_sc_hd__decap_40_12
X_3130_ clknet_leaf_25_clk _0088_ net120 vssd1 vssd1 vccd1 vccd1 MATMULT_INST.matmult_inst.mem_inst.matrixA2\[9\]
+ sky130_fd_sc_hd__dfrtp_1
XTAP_TAPCELL_ROW_78_832 vssd1 vccd1 sky130_fd_sc_hd__tapvpwrvgnd_1
X_3061_ MATMULT_INST.matmult_inst.mem_inst.matrixA2\[17\] net87 net79 MATMULT_INST.matmult_inst.mem_inst.matrixA1\[17\]
+ _1478_ vssd1 vssd1 vccd1 vccd1 _1479_ sky130_fd_sc_hd__a221o_1
XPHY_EDGE_ROW_60_Right_60 vssd1 vssd1 vccd1 vccd1 sky130_fd_sc_hd__decap_3
XANTENNA__2475__B1 _0988_ vssd1 vssd1 vccd1 vccd1 sky130_fd_sc_hd__diode_2
XFILLER_35_222 vssd1 vssd1 vccd1 vccd1 sky130_fd_sc_hd__fill_2
X_2012_ _0588_ _0589_ vssd1 vssd1 vccd1 vccd1 _0590_ sky130_fd_sc_hd__and2b_1
XANTENNA__3019__A2 net64 vssd1 vssd1 vccd1 vccd1 sky130_fd_sc_hd__diode_2
XFILLER_50_236 vssd1 vssd1 vccd1 vccd1 sky130_fd_sc_hd__fill_1
XTAP_TAPCELL_ROW_33_456 vssd1 vccd1 sky130_fd_sc_hd__tapvpwrvgnd_1
X_2914_ _1365_ _1369_ _1375_ vssd1 vssd1 vccd1 vccd1 _1379_ sky130_fd_sc_hd__a21o_1
X_2845_ net185 net203 net204 net184 vssd1 vssd1 vccd1 vccd1 _1313_ sky130_fd_sc_hd__a22o_1
XFILLER_12_29 vssd1 vssd1 vccd1 vccd1 sky130_fd_sc_hd__fill_8
Xhold101 MATMULT_INST.matmult_inst.mem_inst.matrixB3\[15\] vssd1 vssd1 vccd1 vccd1
+ net414 sky130_fd_sc_hd__dlygate4sd3_1
X_2776_ net199 net192 net190 net200 vssd1 vssd1 vccd1 vccd1 _1246_ sky130_fd_sc_hd__a22o_1
X_1727_ net525 net51 net22 vssd1 vssd1 vccd1 vccd1 _0070_ sky130_fd_sc_hd__mux2_1
Xhold112 MATMULT_INST.matmult_inst.alu_inst.row1\[6\] vssd1 vssd1 vccd1 vccd1 net425
+ sky130_fd_sc_hd__dlygate4sd3_1
Xhold123 MATMULT_INST.matmult_inst.mem_inst.matrixB1\[5\] vssd1 vssd1 vccd1 vccd1
+ net436 sky130_fd_sc_hd__dlygate4sd3_1
Xhold134 MATMULT_INST.matmult_inst.alu_inst.adder_inst.r0.fa0.b vssd1 vssd1 vccd1
+ vccd1 net447 sky130_fd_sc_hd__dlygate4sd3_1
Xhold167 MATMULT_INST.matmult_inst.mem_inst.matrixB3\[14\] vssd1 vssd1 vccd1 vccd1
+ net480 sky130_fd_sc_hd__dlygate4sd3_1
Xhold156 MATMULT_INST.matmult_inst.mem_inst.matrixA2\[1\] vssd1 vssd1 vccd1 vccd1
+ net469 sky130_fd_sc_hd__dlygate4sd3_1
XANTENNA__2950__A1 _0987_ vssd1 vssd1 vccd1 vccd1 sky130_fd_sc_hd__diode_2
X_1658_ MATMULT_INST.matmult_inst.spi_inst.tx_reg_sys\[7\] MATMULT_INST.matmult_inst.spi_inst.miso_shifter\[6\]
+ net154 vssd1 vssd1 vccd1 vccd1 _0019_ sky130_fd_sc_hd__mux2_1
Xhold145 MATMULT_INST.matmult_inst.alu_inst.out\[2\] vssd1 vssd1 vccd1 vccd1 net458
+ sky130_fd_sc_hd__dlygate4sd3_1
Xhold189 MATMULT_INST.matmult_inst.mem_inst.matrixB2\[5\] vssd1 vssd1 vccd1 vccd1
+ net502 sky130_fd_sc_hd__dlygate4sd3_1
Xhold178 MATMULT_INST.matmult_inst.alu_inst.col1\[6\] vssd1 vssd1 vccd1 vccd1 net491
+ sky130_fd_sc_hd__dlygate4sd3_1
X_3328_ clknet_leaf_6_clk _0284_ net106 vssd1 vssd1 vccd1 vccd1 MATMULT_INST.matmult_inst.alu_inst.a1_reg\[0\]
+ sky130_fd_sc_hd__dfrtp_1
X_1589_ MATMULT_INST.matmult_inst.fsm_inst.state\[2\] MATMULT_INST.matmult_inst.fsm_inst.state\[3\]
+ vssd1 vssd1 vccd1 vccd1 _1507_ sky130_fd_sc_hd__nand2_1
XFILLER_37_15 vccd1 vssd1 vccd1 vssd1 sky130_ef_sc_hd__decap_40_12
X_3259_ clknet_leaf_23_clk _0217_ net98 vssd1 vssd1 vccd1 vccd1 MATMULT_INST.matmult_inst.mem_inst.mem0\[12\]
+ sky130_fd_sc_hd__dfrtp_1
XANTENNA_fanout184_X net184 vssd1 vssd1 vccd1 vccd1 sky130_fd_sc_hd__diode_2
XFILLER_26_211 vssd1 vssd1 vccd1 vccd1 sky130_fd_sc_hd__fill_1
XFILLER_5_137 vccd1 vssd1 vccd1 vssd1 sky130_ef_sc_hd__decap_40_12
XANTENNA__2060__A net240 vssd1 vssd1 vccd1 vccd1 sky130_fd_sc_hd__diode_2
XFILLER_78_77 vssd1 vssd1 vccd1 vccd1 sky130_fd_sc_hd__fill_4
XTAP_TAPCELL_ROW_75_813 vssd1 vccd1 sky130_fd_sc_hd__tapvpwrvgnd_1
XFILLER_17_200 vccd1 vssd1 vccd1 vssd1 sky130_ef_sc_hd__decap_40_12
XANTENNA__2934__S net8 vssd1 vssd1 vccd1 vccd1 sky130_fd_sc_hd__diode_2
XFILLER_17_266 vssd1 vssd1 vccd1 vccd1 sky130_fd_sc_hd__fill_1
XTAP_TAPCELL_ROW_30_426 vssd1 vccd1 sky130_fd_sc_hd__tapvpwrvgnd_1
XFILLER_71_6 vssd1 vssd1 vccd1 vccd1 sky130_fd_sc_hd__fill_8
XANTENNA__2522__X _1032_ vssd1 vssd1 vccd1 vccd1 sky130_fd_sc_hd__diode_2
X_2630_ _1101_ _1102_ _1103_ vssd1 vssd1 vccd1 vccd1 _1105_ sky130_fd_sc_hd__a21o_1
X_2561_ net359 _1011_ net40 vssd1 vssd1 vccd1 vccd1 _0357_ sky130_fd_sc_hd__mux2_1
X_2492_ MATMULT_INST.matmult_inst.mem_inst.matrixA0\[5\] net65 _1003_ net93 vssd1
+ vssd1 vccd1 vccd1 _1004_ sky130_fd_sc_hd__a22o_1
XFILLER_4_41 vccd1 vssd1 vccd1 vssd1 sky130_ef_sc_hd__decap_40_12
XFILLER_4_85 vccd1 vssd1 vccd1 vssd1 sky130_ef_sc_hd__decap_40_12
XFILLER_67_133 vssd1 vssd1 vccd1 vccd1 sky130_fd_sc_hd__fill_2
X_3113_ clknet_leaf_24_clk _0071_ net121 vssd1 vssd1 vccd1 vccd1 MATMULT_INST.matmult_inst.mem_inst.matrixA0\[10\]
+ sky130_fd_sc_hd__dfrtp_1
XFILLER_67_166 vssd1 vssd1 vccd1 vccd1 sky130_fd_sc_hd__fill_2
X_3044_ net176 net168 MATMULT_INST.matmult_inst.mem_inst.matrixA3\[16\] vssd1 vssd1
+ vccd1 vccd1 _1463_ sky130_fd_sc_hd__and3_1
XANTENNA__2999__B2 net160 vssd1 vssd1 vccd1 vccd1 sky130_fd_sc_hd__diode_2
XANTENNA__2999__A1 net155 vssd1 vssd1 vccd1 vccd1 sky130_fd_sc_hd__diode_2
XFILLER_23_225 vssd1 vssd1 vccd1 vccd1 sky130_fd_sc_hd__fill_8
XFILLER_23_28 vssd1 vssd1 vccd1 vccd1 sky130_fd_sc_hd__fill_2
X_2828_ _1251_ _1295_ _1296_ vssd1 vssd1 vccd1 vccd1 _1297_ sky130_fd_sc_hd__and3_1
X_2759_ net210 MATMULT_INST.matmult_inst.alu_inst.a1_reg\[7\] vssd1 vssd1 vccd1 vccd1
+ _1230_ sky130_fd_sc_hd__nand2_1
XANTENNA_fanout57_A net58 vssd1 vssd1 vccd1 vccd1 sky130_fd_sc_hd__diode_2
XTAP_TAPCELL_ROW_1_184 vssd1 vccd1 sky130_fd_sc_hd__tapvpwrvgnd_1
Xfanout73 _0003_ vssd1 vssd1 vccd1 vccd1 net73 sky130_fd_sc_hd__clkbuf_4
Xfanout62 net63 vssd1 vssd1 vccd1 vccd1 net62 sky130_fd_sc_hd__buf_2
XANTENNA_fanout12_X net12 vssd1 vssd1 vccd1 vccd1 sky130_fd_sc_hd__diode_2
Xfanout51 _0494_ vssd1 vssd1 vccd1 vccd1 net51 sky130_fd_sc_hd__clkbuf_2
Xfanout95 net96 vssd1 vssd1 vccd1 vccd1 net95 sky130_fd_sc_hd__clkbuf_4
Xfanout84 _0512_ vssd1 vssd1 vccd1 vccd1 net84 sky130_fd_sc_hd__buf_2
XFILLER_10_475 vssd1 vssd1 vccd1 vccd1 sky130_fd_sc_hd__fill_1
XFILLER_6_413 vssd1 vssd1 vccd1 vccd1 sky130_fd_sc_hd__fill_4
XFILLER_6_457 vccd1 vssd1 vccd1 vssd1 sky130_ef_sc_hd__decap_40_12
XANTENNA__2221__C net235 vssd1 vssd1 vccd1 vccd1 sky130_fd_sc_hd__diode_2
XTAP_TAPCELL_ROW_9_251 vssd1 vccd1 sky130_fd_sc_hd__tapvpwrvgnd_1
XANTENNA__1833__S net14 vssd1 vssd1 vccd1 vccd1 sky130_fd_sc_hd__diode_2
XANTENNA__1778__A_N net171 vssd1 vssd1 vccd1 vccd1 sky130_fd_sc_hd__diode_2
XANTENNA__2929__S net8 vssd1 vssd1 vccd1 vccd1 sky130_fd_sc_hd__diode_2
XFILLER_49_111 vssd1 vssd1 vccd1 vccd1 sky130_fd_sc_hd__fill_1
XFILLER_77_442 vssd1 vssd1 vccd1 vccd1 sky130_fd_sc_hd__fill_4
XFILLER_49_166 vssd1 vssd1 vccd1 vccd1 sky130_fd_sc_hd__fill_2
XTAP_TAPCELL_ROW_43_540 vssd1 vccd1 sky130_fd_sc_hd__tapvpwrvgnd_1
X_1992_ MATMULT_INST.matmult_inst.alu_inst.adder_inst.r2.fa2.b MATMULT_INST.matmult_inst.alu_inst.adder_inst.r2.fa2.a
+ vssd1 vssd1 vccd1 vccd1 _0573_ sky130_fd_sc_hd__or2_1
XTAP_TAPCELL_ROW_15_297 vssd1 vccd1 sky130_fd_sc_hd__tapvpwrvgnd_1
Xclkload10 clknet_leaf_5_clk vssd1 vssd1 vccd1 vccd1 clkload10/Y sky130_fd_sc_hd__inv_8
XFILLER_9_273 vssd1 vssd1 vccd1 vccd1 sky130_fd_sc_hd__fill_4
X_2613_ net543 net68 _1087_ _1088_ vssd1 vssd1 vccd1 vccd1 _0373_ sky130_fd_sc_hd__a22o_1
Xclkload21 clknet_leaf_9_clk vssd1 vssd1 vccd1 vccd1 clkload21/Y sky130_fd_sc_hd__bufinv_16
X_2544_ MATMULT_INST.matmult_inst.fsm_inst.count\[0\] _1039_ _1044_ vssd1 vssd1 vccd1
+ vccd1 _0348_ sky130_fd_sc_hd__a21bo_1
X_2475_ net482 _0954_ _0988_ net66 vssd1 vssd1 vccd1 vccd1 _0335_ sky130_fd_sc_hd__a22o_1
XANTENNA__1743__S net21 vssd1 vssd1 vccd1 vccd1 sky130_fd_sc_hd__diode_2
X_3027_ MATMULT_INST.matmult_inst.mem_inst.matrixA2\[14\] net85 net77 MATMULT_INST.matmult_inst.mem_inst.matrixA1\[14\]
+ _1447_ vssd1 vssd1 vccd1 vccd1 _1448_ sky130_fd_sc_hd__a221o_1
XANTENNA__2427__X _0944_ vssd1 vssd1 vccd1 vccd1 sky130_fd_sc_hd__diode_2
XFILLER_34_27 vssd1 vssd1 vccd1 vccd1 sky130_fd_sc_hd__fill_1
XFILLER_11_217 vssd1 vssd1 vccd1 vccd1 sky130_fd_sc_hd__fill_4
XFILLER_51_386 vssd1 vssd1 vccd1 vccd1 sky130_fd_sc_hd__fill_1
Xclkload4 clknet_leaf_27_clk vssd1 vssd1 vccd1 vccd1 clkload4/Y sky130_fd_sc_hd__inv_12
XFILLER_3_405 vccd1 vssd1 vccd1 vssd1 sky130_ef_sc_hd__decap_40_12
XFILLER_3_449 vccd1 vssd1 vccd1 vssd1 sky130_ef_sc_hd__decap_40_12
XFILLER_59_57 vccd1 vssd1 vccd1 vssd1 sky130_ef_sc_hd__decap_40_12
XTAP_TAPCELL_ROW_6_221 vssd1 vccd1 sky130_fd_sc_hd__tapvpwrvgnd_1
Xfanout241 MATMULT_INST.matmult_inst.alu_inst.b0_reg\[0\] vssd1 vssd1 vccd1 vccd1
+ net241 sky130_fd_sc_hd__buf_2
Xfanout230 MATMULT_INST.matmult_inst.alu_inst.b0_reg\[6\] vssd1 vssd1 vccd1 vccd1
+ net230 sky130_fd_sc_hd__buf_2
XFILLER_19_339 vssd1 vssd1 vccd1 vccd1 sky130_fd_sc_hd__fill_1
XFILLER_46_114 vssd1 vssd1 vccd1 vccd1 sky130_fd_sc_hd__fill_2
XTAP_TAPCELL_ROW_57_654 vssd1 vccd1 sky130_fd_sc_hd__tapvpwrvgnd_1
XFILLER_74_489 vssd1 vssd1 vccd1 vccd1 sky130_fd_sc_hd__fill_2
XTAP_TAPCELL_ROW_40_510 vssd1 vccd1 sky130_fd_sc_hd__tapvpwrvgnd_1
XANTENNA__1828__S net14 vssd1 vssd1 vccd1 vccd1 sky130_fd_sc_hd__diode_2
XTAP_TAPCELL_ROW_12_278 vssd1 vccd1 sky130_fd_sc_hd__tapvpwrvgnd_1
XFILLER_6_221 vccd1 vssd1 vccd1 vssd1 sky130_ef_sc_hd__decap_40_12
XFILLER_6_265 vccd1 vssd1 vccd1 vssd1 sky130_ef_sc_hd__decap_40_12
XFILLER_69_228 vssd1 vssd1 vccd1 vccd1 sky130_fd_sc_hd__fill_1
X_2260_ net223 net227 _0807_ vssd1 vssd1 vccd1 vccd1 _0808_ sky130_fd_sc_hd__and3_1
X_2191_ _0724_ _0738_ _0737_ vssd1 vssd1 vccd1 vccd1 _0741_ sky130_fd_sc_hd__a21boi_1
XFILLER_37_169 vssd1 vssd1 vccd1 vccd1 sky130_fd_sc_hd__fill_1
XFILLER_52_139 vssd1 vssd1 vccd1 vccd1 sky130_fd_sc_hd__fill_1
X_1975_ _0556_ _0558_ vssd1 vssd1 vccd1 vccd1 _0559_ sky130_fd_sc_hd__nand2_1
XFILLER_20_29 vssd1 vssd1 vccd1 vccd1 sky130_fd_sc_hd__fill_4
XANTENNA_fanout107_A net114 vssd1 vssd1 vccd1 vccd1 sky130_fd_sc_hd__diode_2
XFILLER_0_419 vssd1 vssd1 vccd1 vccd1 sky130_fd_sc_hd__fill_1
XANTENNA__2569__S _1053_ vssd1 vssd1 vccd1 vccd1 sky130_fd_sc_hd__diode_2
X_2527_ _0952_ net527 _1035_ vssd1 vssd1 vccd1 vccd1 _0340_ sky130_fd_sc_hd__mux2_1
X_2458_ net181 net172 MATMULT_INST.matmult_inst.mem_inst.matrixA3\[2\] vssd1 vssd1
+ vccd1 vccd1 _0973_ sky130_fd_sc_hd__and3_1
Xhold16 _0428_ vssd1 vssd1 vccd1 vccd1 net329 sky130_fd_sc_hd__dlygate4sd3_1
XFILLER_29_49 vssd1 vssd1 vccd1 vccd1 sky130_fd_sc_hd__fill_1
Xhold38 MATMULT_INST.matmult_inst.mem_inst.mem3\[1\] vssd1 vssd1 vccd1 vccd1 net351
+ sky130_fd_sc_hd__dlygate4sd3_1
Xhold27 MATMULT_INST.matmult_inst.spi_inst.tx_reg_sys\[5\] vssd1 vssd1 vccd1 vccd1
+ net340 sky130_fd_sc_hd__dlygate4sd3_1
Xhold49 _0257_ vssd1 vssd1 vccd1 vccd1 net362 sky130_fd_sc_hd__dlygate4sd3_1
X_2389_ net564 net63 net42 net656 vssd1 vssd1 vccd1 vccd1 _0314_ sky130_fd_sc_hd__a22o_1
XFILLER_28_147 vssd1 vssd1 vccd1 vccd1 sky130_fd_sc_hd__fill_2
XFILLER_45_15 vssd1 vssd1 vccd1 vccd1 sky130_fd_sc_hd__fill_4
XFILLER_36_180 vssd1 vssd1 vccd1 vccd1 sky130_fd_sc_hd__fill_1
XFILLER_43_117 vssd1 vssd1 vccd1 vccd1 sky130_fd_sc_hd__fill_2
XFILLER_45_59 vssd1 vssd1 vccd1 vccd1 sky130_fd_sc_hd__fill_1
XTAP_TAPCELL_ROW_54_635 vssd1 vccd1 sky130_fd_sc_hd__tapvpwrvgnd_1
XANTENNA__2814__B1 net192 vssd1 vssd1 vccd1 vccd1 sky130_fd_sc_hd__diode_2
XFILLER_61_69 vccd1 vssd1 vccd1 vssd1 sky130_ef_sc_hd__decap_40_12
XFILLER_3_279 vssd1 vssd1 vccd1 vccd1 sky130_fd_sc_hd__fill_1
XFILLER_47_401 vssd1 vssd1 vccd1 vccd1 sky130_fd_sc_hd__fill_1
XTAP_TAPCELL_ROW_17_315 vssd1 vccd1 sky130_fd_sc_hd__tapvpwrvgnd_1
XANTENNA__2942__S MATMULT_INST.matmult_inst.spi_inst.rx_done_sys vssd1 vssd1 vccd1
+ vccd1 sky130_fd_sc_hd__diode_2
XFILLER_70_481 vssd1 vssd1 vccd1 vccd1 sky130_fd_sc_hd__fill_1
XTAP_TAPCELL_ROW_25_381 vssd1 vccd1 sky130_fd_sc_hd__tapvpwrvgnd_1
X_1760_ net349 net39 net19 vssd1 vssd1 vccd1 vccd1 _0097_ sky130_fd_sc_hd__mux2_1
XANTENNA__2584__A2 _0480_ vssd1 vssd1 vccd1 vccd1 sky130_fd_sc_hd__diode_2
XANTENNA__3058__B net169 vssd1 vssd1 vccd1 vccd1 sky130_fd_sc_hd__diode_2
X_1691_ MATMULT_INST.matmult_inst.fsm_inst.rx_data\[6\] net59 net61 MATMULT_INST.matmult_inst.fsm_inst.alu_result\[6\]
+ vssd1 vssd1 vccd1 vccd1 _0491_ sky130_fd_sc_hd__a22o_1
X_3430_ clknet_leaf_3_clk _0382_ vssd1 vssd1 vccd1 vccd1 MATMULT_INST.matmult_inst.alu_inst.adder_inst.r3.fa0.b
+ sky130_fd_sc_hd__dfxtp_1
X_3361_ clknet_leaf_1_clk _0316_ net108 vssd1 vssd1 vccd1 vccd1 MATMULT_INST.matmult_inst.fsm_inst.alu_result\[7\]
+ sky130_fd_sc_hd__dfrtp_1
X_2312_ net215 net231 net233 net213 vssd1 vssd1 vccd1 vccd1 _0858_ sky130_fd_sc_hd__and4_1
XFILLER_32_3 vccd1 vssd1 vccd1 vssd1 sky130_ef_sc_hd__decap_40_12
X_3292_ clknet_leaf_0_clk _0250_ net96 vssd1 vssd1 vccd1 vccd1 MATMULT_INST.matmult_inst.alu_inst.a0_reg\[0\]
+ sky130_fd_sc_hd__dfrtp_1
X_2243_ _0786_ _0788_ _0789_ vssd1 vssd1 vccd1 vccd1 _0791_ sky130_fd_sc_hd__or3_1
XTAP_TAPCELL_ROW_68_749 vssd1 vccd1 sky130_fd_sc_hd__tapvpwrvgnd_1
X_2174_ _0723_ vssd1 vssd1 vccd1 vccd1 _0724_ sky130_fd_sc_hd__inv_2
XANTENNA__3049__B1 net77 vssd1 vssd1 vccd1 vccd1 sky130_fd_sc_hd__diode_2
XFILLER_65_275 vssd1 vssd1 vccd1 vccd1 sky130_fd_sc_hd__fill_1
XFILLER_15_18 vccd1 vssd1 vccd1 vssd1 sky130_ef_sc_hd__decap_40_12
XTAP_TAPCELL_ROW_51_605 vssd1 vccd1 sky130_fd_sc_hd__tapvpwrvgnd_1
XFILLER_33_183 vssd1 vssd1 vccd1 vccd1 sky130_fd_sc_hd__fill_1
XFILLER_31_39 vssd1 vssd1 vccd1 vccd1 sky130_fd_sc_hd__fill_4
X_1958_ MATMULT_INST.matmult_inst.alu_inst.adder_inst.r1.fa1.b MATMULT_INST.matmult_inst.alu_inst.adder_inst.r1.fa1.a
+ vssd1 vssd1 vccd1 vccd1 _0544_ sky130_fd_sc_hd__nand2_1
X_1889_ net567 net46 net10 vssd1 vssd1 vccd1 vccd1 _0219_ sky130_fd_sc_hd__mux2_1
XFILLER_0_216 vssd1 vssd1 vccd1 vccd1 sky130_fd_sc_hd__fill_8
Xteam_02_302 vssd1 vssd1 vccd1 vccd1 gpio_oeb[22] team_02_302/LO sky130_fd_sc_hd__conb_1
Xteam_02_313 vssd1 vssd1 vccd1 vccd1 gpio_oeb[33] team_02_313/LO sky130_fd_sc_hd__conb_1
XFILLER_72_24 vssd1 vssd1 vccd1 vccd1 sky130_fd_sc_hd__fill_4
XFILLER_44_459 vssd1 vssd1 vccd1 vccd1 sky130_fd_sc_hd__fill_1
XFILLER_72_35 vssd1 vssd1 vccd1 vccd1 sky130_fd_sc_hd__fill_1
XFILLER_12_301 vssd1 vssd1 vccd1 vccd1 sky130_fd_sc_hd__fill_4
XFILLER_31_109 vssd1 vssd1 vccd1 vccd1 sky130_fd_sc_hd__fill_2
XFILLER_12_345 vccd1 vssd1 vccd1 vssd1 sky130_ef_sc_hd__decap_40_12
XFILLER_8_305 vssd1 vssd1 vccd1 vccd1 sky130_fd_sc_hd__fill_2
XFILLER_12_389 vccd1 vssd1 vccd1 vssd1 sky130_ef_sc_hd__decap_40_12
XTAP_TAPCELL_ROW_22_362 vssd1 vccd1 sky130_fd_sc_hd__tapvpwrvgnd_1
XFILLER_79_334 vssd1 vssd1 vccd1 vccd1 sky130_fd_sc_hd__fill_2
XANTENNA__2937__S net8 vssd1 vssd1 vccd1 vccd1 sky130_fd_sc_hd__diode_2
XANTENNA__1841__S net28 vssd1 vssd1 vccd1 vccd1 sky130_fd_sc_hd__diode_2
XTAP_TAPCELL_ROW_73_796 vssd1 vccd1 sky130_fd_sc_hd__tapvpwrvgnd_1
X_2930_ net408 net51 net9 vssd1 vssd1 vccd1 vccd1 _0417_ sky130_fd_sc_hd__mux2_1
XFILLER_30_153 vssd1 vssd1 vccd1 vccd1 sky130_fd_sc_hd__fill_1
X_2861_ _1327_ _1328_ vssd1 vssd1 vccd1 vccd1 _1329_ sky130_fd_sc_hd__nand2_1
X_1812_ net611 net47 net16 vssd1 vssd1 vccd1 vccd1 _0146_ sky130_fd_sc_hd__mux2_1
X_2792_ _1254_ _1261_ vssd1 vssd1 vccd1 vccd1 _1262_ sky130_fd_sc_hd__xnor2_1
X_1743_ net389 net35 net21 vssd1 vssd1 vccd1 vccd1 _0083_ sky130_fd_sc_hd__mux2_1
X_1674_ net182 net174 vssd1 vssd1 vccd1 vccd1 _0480_ sky130_fd_sc_hd__or2_2
XFILLER_7_393 vccd1 vssd1 vccd1 vssd1 sky130_ef_sc_hd__decap_40_12
Xhold316 MATMULT_INST.matmult_inst.mem_inst.mem0\[10\] vssd1 vssd1 vccd1 vccd1 net629
+ sky130_fd_sc_hd__dlygate4sd3_1
Xhold305 MATMULT_INST.matmult_inst.mem_inst.mem2\[10\] vssd1 vssd1 vccd1 vccd1 net618
+ sky130_fd_sc_hd__dlygate4sd3_1
Xhold327 MATMULT_INST.matmult_inst.mem_inst.matrixB2\[16\] vssd1 vssd1 vccd1 vccd1
+ net640 sky130_fd_sc_hd__dlygate4sd3_1
Xhold338 MATMULT_INST.matmult_inst.mem_inst.matrixB1\[12\] vssd1 vssd1 vccd1 vccd1
+ net651 sky130_fd_sc_hd__dlygate4sd3_1
X_3413_ clknet_leaf_29_clk _0366_ net95 vssd1 vssd1 vccd1 vccd1 MATMULT_INST.matmult_inst.alu_inst.row0\[6\]
+ sky130_fd_sc_hd__dfrtp_1
Xhold349 MATMULT_INST.matmult_inst.alu_inst.adder_inst.r3.fa0.b vssd1 vssd1 vccd1
+ vccd1 net662 sky130_fd_sc_hd__dlygate4sd3_1
X_3344_ clknet_leaf_2_clk _0299_ vssd1 vssd1 vccd1 vccd1 MATMULT_INST.matmult_inst.alu_inst.adder_inst.r1.fa3.a
+ sky130_fd_sc_hd__dfxtp_1
XANTENNA__1751__S net20 vssd1 vssd1 vccd1 vccd1 sky130_fd_sc_hd__diode_2
X_3275_ clknet_leaf_17_clk _0233_ net121 vssd1 vssd1 vccd1 vccd1 MATMULT_INST.matmult_inst.mem_inst.matrixA1\[10\]
+ sky130_fd_sc_hd__dfrtp_1
X_2226_ _0768_ _0774_ vssd1 vssd1 vccd1 vccd1 _0775_ sky130_fd_sc_hd__xnor2_1
X_2157_ _0691_ _0692_ _0693_ vssd1 vssd1 vccd1 vccd1 _0707_ sky130_fd_sc_hd__o21bai_1
XFILLER_53_223 vssd1 vssd1 vccd1 vccd1 sky130_fd_sc_hd__fill_1
X_2088_ net239 net221 net220 net237 vssd1 vssd1 vccd1 vccd1 _0641_ sky130_fd_sc_hd__and4_1
XTAP_TAPCELL_ROW_36_476 vssd1 vccd1 sky130_fd_sc_hd__tapvpwrvgnd_1
XANTENNA__2435__X _0952_ vssd1 vssd1 vccd1 vccd1 sky130_fd_sc_hd__diode_2
XFILLER_21_164 vssd1 vssd1 vccd1 vccd1 sky130_fd_sc_hd__fill_4
XANTENNA__1926__S net54 vssd1 vssd1 vccd1 vccd1 sky130_fd_sc_hd__diode_2
XPHY_EDGE_ROW_39_Left_119 vssd1 vssd1 vccd1 vccd1 sky130_fd_sc_hd__decap_3
XANTENNA_fanout87_A net88 vssd1 vssd1 vccd1 vccd1 sky130_fd_sc_hd__diode_2
XFILLER_67_13 vssd1 vssd1 vccd1 vccd1 sky130_fd_sc_hd__fill_1
XPHY_EDGE_ROW_48_Left_128 vssd1 vssd1 vccd1 vccd1 sky130_fd_sc_hd__decap_3
XFILLER_16_83 vssd1 vssd1 vccd1 vccd1 sky130_fd_sc_hd__fill_1
XFILLER_12_120 vccd1 vssd1 vccd1 vssd1 sky130_ef_sc_hd__decap_40_12
XTAP_TAPCELL_ROW_70_766 vssd1 vccd1 sky130_fd_sc_hd__tapvpwrvgnd_1
XFILLER_12_153 vccd1 vssd1 vccd1 vssd1 sky130_ef_sc_hd__decap_40_12
XFILLER_12_197 vccd1 vssd1 vccd1 vssd1 sky130_ef_sc_hd__decap_40_12
XFILLER_32_82 vssd1 vssd1 vccd1 vccd1 sky130_fd_sc_hd__fill_2
XPHY_EDGE_ROW_57_Left_137 vssd1 vssd1 vccd1 vccd1 sky130_fd_sc_hd__decap_3
XFILLER_4_363 vssd1 vssd1 vccd1 vccd1 sky130_fd_sc_hd__fill_1
XFILLER_79_153 vccd1 vssd1 vccd1 vssd1 sky130_ef_sc_hd__decap_40_12
XTAP_TAPCELL_ROW_78_833 vssd1 vccd1 sky130_fd_sc_hd__tapvpwrvgnd_1
X_3060_ net178 net169 MATMULT_INST.matmult_inst.mem_inst.matrixA3\[17\] vssd1 vssd1
+ vccd1 vccd1 _1478_ sky130_fd_sc_hd__and3_1
XPHY_EDGE_ROW_66_Left_146 vssd1 vssd1 vccd1 vccd1 sky130_fd_sc_hd__decap_3
X_2011_ MATMULT_INST.matmult_inst.alu_inst.adder_inst.r3.fa1.b MATMULT_INST.matmult_inst.alu_inst.adder_inst.r3.fa1.a
+ vssd1 vssd1 vccd1 vccd1 _0589_ sky130_fd_sc_hd__nand2_1
XANTENNA__2475__B2 net66 vssd1 vssd1 vccd1 vccd1 sky130_fd_sc_hd__diode_2
XFILLER_35_289 vssd1 vssd1 vccd1 vccd1 sky130_fd_sc_hd__fill_1
XPHY_EDGE_ROW_75_Left_155 vssd1 vssd1 vccd1 vccd1 sky130_fd_sc_hd__decap_3
X_2913_ _1375_ _1377_ _1365_ _1369_ vssd1 vssd1 vccd1 vccd1 _1378_ sky130_fd_sc_hd__o211ai_1
X_2844_ _1310_ _1311_ vssd1 vssd1 vccd1 vccd1 _1312_ sky130_fd_sc_hd__or2_1
XANTENNA__1746__S net21 vssd1 vssd1 vccd1 vccd1 sky130_fd_sc_hd__diode_2
X_2775_ net189 net202 vssd1 vssd1 vccd1 vccd1 _1245_ sky130_fd_sc_hd__nand2_1
Xhold124 MATMULT_INST.matmult_inst.alu_inst.row1\[0\] vssd1 vssd1 vccd1 vccd1 net437
+ sky130_fd_sc_hd__dlygate4sd3_1
X_1726_ net561 net52 net22 vssd1 vssd1 vccd1 vccd1 _0069_ sky130_fd_sc_hd__mux2_1
Xhold102 MATMULT_INST.matmult_inst.mem_inst.matrixA2\[3\] vssd1 vssd1 vccd1 vccd1
+ net415 sky130_fd_sc_hd__dlygate4sd3_1
Xhold135 MATMULT_INST.matmult_inst.alu_inst.out\[3\] vssd1 vssd1 vccd1 vccd1 net448
+ sky130_fd_sc_hd__dlygate4sd3_1
Xhold113 MATMULT_INST.matmult_inst.mem_inst.matrixA1\[0\] vssd1 vssd1 vccd1 vccd1
+ net426 sky130_fd_sc_hd__dlygate4sd3_1
Xhold168 MATMULT_INST.matmult_inst.mem_inst.matrixA1\[11\] vssd1 vssd1 vccd1 vccd1
+ net481 sky130_fd_sc_hd__dlygate4sd3_1
X_1657_ MATMULT_INST.matmult_inst.spi_inst.tx_reg_sys\[6\] MATMULT_INST.matmult_inst.spi_inst.miso_shifter\[5\]
+ net154 vssd1 vssd1 vccd1 vccd1 _0018_ sky130_fd_sc_hd__mux2_1
Xhold157 MATMULT_INST.matmult_inst.mem_inst.matrixB0\[3\] vssd1 vssd1 vccd1 vccd1
+ net470 sky130_fd_sc_hd__dlygate4sd3_1
Xhold146 MATMULT_INST.matmult_inst.mem_inst.mem0\[0\] vssd1 vssd1 vccd1 vccd1 net459
+ sky130_fd_sc_hd__dlygate4sd3_1
Xhold179 MATMULT_INST.matmult_inst.mem_inst.matrixB0\[7\] vssd1 vssd1 vccd1 vccd1
+ net492 sky130_fd_sc_hd__dlygate4sd3_1
X_1588_ MATMULT_INST.matmult_inst.fsm_inst.state\[4\] _1504_ vssd1 vssd1 vccd1 vccd1
+ _1506_ sky130_fd_sc_hd__or2_1
X_3327_ clknet_leaf_7_clk _0453_ net108 vssd1 vssd1 vccd1 vccd1 MATMULT_INST.matmult_inst.alu_inst.state\[1\]
+ sky130_fd_sc_hd__dfrtp_1
X_3258_ clknet_leaf_19_clk _0216_ net127 vssd1 vssd1 vccd1 vccd1 MATMULT_INST.matmult_inst.mem_inst.mem0\[11\]
+ sky130_fd_sc_hd__dfrtp_1
XFILLER_37_27 vccd1 vssd1 vccd1 vssd1 sky130_ef_sc_hd__decap_40_12
X_2209_ _0755_ _0756_ _0757_ vssd1 vssd1 vccd1 vccd1 _0758_ sky130_fd_sc_hd__a21oi_1
X_3189_ clknet_leaf_24_clk _0147_ net98 vssd1 vssd1 vccd1 vccd1 MATMULT_INST.matmult_inst.mem_inst.mem2\[14\]
+ sky130_fd_sc_hd__dfrtp_1
XANTENNA_fanout177_X net177 vssd1 vssd1 vccd1 vccd1 sky130_fd_sc_hd__diode_2
XTAP_TAPCELL_ROW_49_590 vssd1 vccd1 sky130_fd_sc_hd__tapvpwrvgnd_1
XFILLER_26_267 vssd1 vssd1 vccd1 vccd1 sky130_fd_sc_hd__fill_1
XFILLER_5_105 vssd1 vssd1 vccd1 vccd1 sky130_fd_sc_hd__fill_4
XFILLER_5_149 vccd1 vssd1 vccd1 vssd1 sky130_ef_sc_hd__decap_40_12
XFILLER_1_333 vssd1 vssd1 vccd1 vccd1 sky130_fd_sc_hd__fill_2
XFILLER_17_212 vccd1 vssd1 vccd1 vssd1 sky130_ef_sc_hd__decap_40_12
XFILLER_72_340 vssd1 vssd1 vccd1 vccd1 sky130_fd_sc_hd__fill_4
XFILLER_27_93 vssd1 vssd1 vccd1 vccd1 sky130_fd_sc_hd__fill_8
Xclkbuf_2_0__f_clk clknet_0_clk vssd1 vssd1 vccd1 vccd1 clknet_2_0__leaf_clk sky130_fd_sc_hd__clkbuf_16
XANTENNA__2516__A net182 vssd1 vssd1 vccd1 vccd1 sky130_fd_sc_hd__diode_2
XTAP_TAPCELL_ROW_30_427 vssd1 vccd1 sky130_fd_sc_hd__tapvpwrvgnd_1
XANTENNA__2950__S net58 vssd1 vssd1 vccd1 vccd1 sky130_fd_sc_hd__diode_2
X_2560_ net407 _1000_ net40 vssd1 vssd1 vccd1 vccd1 _0356_ sky130_fd_sc_hd__mux2_1
X_2491_ net158 MATMULT_INST.matmult_inst.mem_inst.mem0\[5\] MATMULT_INST.matmult_inst.mem_inst.matrixB0\[5\]
+ net163 vssd1 vssd1 vccd1 vccd1 _1003_ sky130_fd_sc_hd__a22o_1
XFILLER_4_193 vssd1 vssd1 vccd1 vccd1 sky130_fd_sc_hd__fill_2
XFILLER_4_53 vccd1 vssd1 vccd1 vssd1 sky130_ef_sc_hd__decap_40_12
XFILLER_4_97 vccd1 vssd1 vccd1 vssd1 sky130_ef_sc_hd__decap_40_12
X_3112_ clknet_leaf_25_clk _0070_ net120 vssd1 vssd1 vccd1 vccd1 MATMULT_INST.matmult_inst.mem_inst.matrixA0\[9\]
+ sky130_fd_sc_hd__dfrtp_1
XFILLER_67_145 vssd1 vssd1 vccd1 vccd1 sky130_fd_sc_hd__fill_1
X_3043_ net155 MATMULT_INST.matmult_inst.mem_inst.mem0\[16\] MATMULT_INST.matmult_inst.mem_inst.matrixB0\[16\]
+ net160 vssd1 vssd1 vccd1 vccd1 _1462_ sky130_fd_sc_hd__a22o_1
XANTENNA__2448__B2 net162 vssd1 vssd1 vccd1 vccd1 sky130_fd_sc_hd__diode_2
XANTENNA__2448__A1 net166 vssd1 vssd1 vccd1 vccd1 sky130_fd_sc_hd__diode_2
XTAP_TAPCELL_ROW_46_560 vssd1 vccd1 sky130_fd_sc_hd__tapvpwrvgnd_1
X_2827_ _1253_ _1261_ vssd1 vssd1 vccd1 vccd1 _1296_ sky130_fd_sc_hd__or2_1
X_2758_ net187 net186 net206 net208 vssd1 vssd1 vccd1 vccd1 _1229_ sky130_fd_sc_hd__nand4_1
X_1709_ MATMULT_INST.matmult_inst.fsm_inst.alu_result\[15\] net60 vssd1 vssd1 vccd1
+ vccd1 _0500_ sky130_fd_sc_hd__and2_1
X_2689_ _1161_ vssd1 vssd1 vccd1 vccd1 _1162_ sky130_fd_sc_hd__inv_2
XFILLER_58_156 vssd1 vssd1 vccd1 vccd1 sky130_fd_sc_hd__fill_2
Xfanout30 _0513_ vssd1 vssd1 vccd1 vccd1 net30 sky130_fd_sc_hd__buf_4
Xfanout52 _0493_ vssd1 vssd1 vccd1 vccd1 net52 sky130_fd_sc_hd__clkbuf_2
Xfanout41 _0923_ vssd1 vssd1 vccd1 vccd1 net41 sky130_fd_sc_hd__buf_2
Xfanout74 _0003_ vssd1 vssd1 vccd1 vccd1 net74 sky130_fd_sc_hd__buf_2
Xfanout63 _0473_ vssd1 vssd1 vccd1 vccd1 net63 sky130_fd_sc_hd__buf_2
XFILLER_10_421 vccd1 vssd1 vccd1 vssd1 sky130_ef_sc_hd__decap_40_12
Xfanout85 net88 vssd1 vssd1 vccd1 vccd1 net85 sky130_fd_sc_hd__clkbuf_4
Xfanout96 net152 vssd1 vssd1 vccd1 vccd1 net96 sky130_fd_sc_hd__clkbuf_4
XFILLER_6_469 vssd1 vssd1 vccd1 vccd1 sky130_fd_sc_hd__fill_4
XANTENNA__2221__D net238 vssd1 vssd1 vccd1 vccd1 sky130_fd_sc_hd__diode_2
XTAP_TAPCELL_ROW_9_252 vssd1 vccd1 sky130_fd_sc_hd__tapvpwrvgnd_1
XANTENNA__2945__S MATMULT_INST.matmult_inst.spi_inst.rx_done_sys vssd1 vssd1 vccd1
+ vccd1 sky130_fd_sc_hd__diode_2
XFILLER_49_178 vssd1 vssd1 vccd1 vccd1 sky130_fd_sc_hd__fill_1
XFILLER_64_148 vssd1 vssd1 vccd1 vccd1 sky130_fd_sc_hd__fill_2
XTAP_TAPCELL_ROW_43_541 vssd1 vccd1 sky130_fd_sc_hd__tapvpwrvgnd_1
XFILLER_60_365 vssd1 vssd1 vccd1 vccd1 sky130_fd_sc_hd__fill_1
X_1991_ net630 _0572_ net73 vssd1 vssd1 vccd1 vccd1 _0267_ sky130_fd_sc_hd__mux2_1
XTAP_TAPCELL_ROW_15_298 vssd1 vccd1 sky130_fd_sc_hd__tapvpwrvgnd_1
XFILLER_13_281 vccd1 vssd1 vccd1 vssd1 sky130_ef_sc_hd__decap_40_12
Xclkload11 clknet_leaf_6_clk vssd1 vssd1 vccd1 vccd1 clkload11/Y sky130_fd_sc_hd__bufinv_16
Xclkload22 clknet_leaf_10_clk vssd1 vssd1 vccd1 vccd1 clkload22/X sky130_fd_sc_hd__clkbuf_8
X_2612_ _1072_ _1075_ _1086_ net72 vssd1 vssd1 vccd1 vccd1 _1088_ sky130_fd_sc_hd__o31a_1
XFILLER_62_3 vccd1 vssd1 vccd1 vssd1 sky130_ef_sc_hd__decap_40_12
X_2543_ MATMULT_INST.matmult_inst.fsm_inst.count\[0\] _1039_ _1042_ _1043_ vssd1 vssd1
+ vccd1 vccd1 _1044_ sky130_fd_sc_hd__or4b_1
X_2474_ net75 _0987_ vssd1 vssd1 vccd1 vccd1 _0988_ sky130_fd_sc_hd__and2_2
XFILLER_70_107 vssd1 vssd1 vccd1 vccd1 sky130_fd_sc_hd__fill_8
X_3026_ net177 net168 MATMULT_INST.matmult_inst.mem_inst.matrixA3\[14\] vssd1 vssd1
+ vccd1 vccd1 _1447_ sky130_fd_sc_hd__and3_1
Xclkload5 clknet_leaf_28_clk vssd1 vssd1 vccd1 vccd1 clkload5/Y sky130_fd_sc_hd__inv_8
XFILLER_3_417 vccd1 vssd1 vccd1 vssd1 sky130_ef_sc_hd__decap_40_12
XANTENNA__2357__B1 net213 vssd1 vssd1 vccd1 vccd1 sky130_fd_sc_hd__diode_2
XFILLER_59_47 vssd1 vssd1 vccd1 vccd1 sky130_fd_sc_hd__fill_8
XTAP_TAPCELL_ROW_6_222 vssd1 vccd1 sky130_fd_sc_hd__tapvpwrvgnd_1
Xfanout220 MATMULT_INST.matmult_inst.alu_inst.a0_reg\[3\] vssd1 vssd1 vccd1 vccd1
+ net220 sky130_fd_sc_hd__clkbuf_2
Xfanout231 MATMULT_INST.matmult_inst.alu_inst.b0_reg\[5\] vssd1 vssd1 vccd1 vccd1
+ net231 sky130_fd_sc_hd__buf_2
XFILLER_59_69 vssd1 vssd1 vccd1 vccd1 sky130_fd_sc_hd__fill_2
Xfanout242 net2 vssd1 vssd1 vccd1 vccd1 net242 sky130_fd_sc_hd__buf_2
XFILLER_75_57 vssd1 vssd1 vccd1 vccd1 sky130_fd_sc_hd__fill_2
XFILLER_74_446 vssd1 vssd1 vccd1 vccd1 sky130_fd_sc_hd__fill_1
XTAP_TAPCELL_ROW_57_655 vssd1 vccd1 sky130_fd_sc_hd__tapvpwrvgnd_1
XTAP_TAPCELL_ROW_40_511 vssd1 vccd1 sky130_fd_sc_hd__tapvpwrvgnd_1
XFILLER_10_251 vssd1 vssd1 vccd1 vccd1 sky130_fd_sc_hd__fill_1
XFILLER_6_233 vccd1 vssd1 vccd1 vssd1 sky130_ef_sc_hd__decap_40_12
XFILLER_6_277 vccd1 vssd1 vccd1 vssd1 sky130_ef_sc_hd__decap_40_12
XFILLER_40_93 vssd1 vssd1 vccd1 vccd1 sky130_fd_sc_hd__fill_8
XANTENNA__1844__S net29 vssd1 vssd1 vccd1 vccd1 sky130_fd_sc_hd__diode_2
X_2190_ _0737_ _0738_ _0723_ vssd1 vssd1 vccd1 vccd1 _0740_ sky130_fd_sc_hd__a21o_1
XFILLER_37_126 vssd1 vssd1 vccd1 vccd1 sky130_fd_sc_hd__fill_1
X_1974_ MATMULT_INST.matmult_inst.alu_inst.adder_inst.r1.fa3.b MATMULT_INST.matmult_inst.alu_inst.adder_inst.r1.fa3.a
+ vssd1 vssd1 vccd1 vccd1 _0558_ sky130_fd_sc_hd__nand2_1
XANTENNA__1754__S net20 vssd1 vssd1 vccd1 vccd1 sky130_fd_sc_hd__diode_2
XANTENNA__3000__B2 net92 vssd1 vssd1 vccd1 vccd1 sky130_fd_sc_hd__diode_2
X_2526_ _0465_ _0953_ _1034_ vssd1 vssd1 vccd1 vccd1 _1035_ sky130_fd_sc_hd__or3_4
X_2457_ MATMULT_INST.matmult_inst.mem_inst.matrixB2\[2\] net89 net82 MATMULT_INST.matmult_inst.mem_inst.matrixB1\[2\]
+ _0971_ vssd1 vssd1 vccd1 vccd1 _0972_ sky130_fd_sc_hd__a221o_1
Xhold17 MATMULT_INST.matmult_inst.spi_inst.mosi_data_sync\[6\] vssd1 vssd1 vccd1 vccd1
+ net330 sky130_fd_sc_hd__dlygate4sd3_1
Xhold28 MATMULT_INST.matmult_inst.mem_inst.mem3\[7\] vssd1 vssd1 vccd1 vccd1 net341
+ sky130_fd_sc_hd__dlygate4sd3_1
XFILLER_68_251 vssd1 vssd1 vccd1 vccd1 sky130_fd_sc_hd__fill_1
Xhold39 MATMULT_INST.matmult_inst.alu_inst.out\[14\] vssd1 vssd1 vccd1 vccd1 net352
+ sky130_fd_sc_hd__dlygate4sd3_1
X_2388_ net544 _0473_ net42 MATMULT_INST.matmult_inst.fsm_inst.alu_result\[4\] vssd1
+ vssd1 vccd1 vccd1 _0313_ sky130_fd_sc_hd__a22o_1
XFILLER_45_38 vssd1 vssd1 vccd1 vccd1 sky130_fd_sc_hd__fill_4
X_3009_ net522 _1431_ net57 vssd1 vssd1 vccd1 vccd1 _0446_ sky130_fd_sc_hd__mux2_1
XANTENNA__2814__A1 MATMULT_INST.matmult_inst.alu_inst.a1_reg\[4\] vssd1 vssd1 vccd1
+ vccd1 sky130_fd_sc_hd__diode_2
XFILLER_51_184 vssd1 vssd1 vccd1 vccd1 sky130_fd_sc_hd__fill_2
XANTENNA__2578__B1 net183 vssd1 vssd1 vccd1 vccd1 sky130_fd_sc_hd__diode_2
XFILLER_3_225 vccd1 vssd1 vccd1 vssd1 sky130_ef_sc_hd__decap_40_12
XFILLER_10_41 vccd1 vssd1 vccd1 vssd1 sky130_ef_sc_hd__decap_40_12
XFILLER_10_85 vccd1 vssd1 vccd1 vssd1 sky130_ef_sc_hd__decap_40_12
XANTENNA__2502__B1 net83 vssd1 vssd1 vccd1 vccd1 sky130_fd_sc_hd__diode_2
XFILLER_19_61 vssd1 vssd1 vccd1 vccd1 sky130_fd_sc_hd__fill_1
XTAP_TAPCELL_ROW_17_316 vssd1 vccd1 sky130_fd_sc_hd__tapvpwrvgnd_1
XFILLER_15_332 vssd1 vssd1 vccd1 vccd1 sky130_fd_sc_hd__fill_4
XFILLER_15_387 vssd1 vssd1 vccd1 vccd1 sky130_fd_sc_hd__fill_1
XANTENNA__1839__S net29 vssd1 vssd1 vccd1 vccd1 sky130_fd_sc_hd__diode_2
XTAP_TAPCELL_ROW_25_382 vssd1 vccd1 sky130_fd_sc_hd__tapvpwrvgnd_1
XANTENNA__2569__A0 _1000_ vssd1 vssd1 vccd1 vccd1 sky130_fd_sc_hd__diode_2
XFILLER_42_195 vssd1 vssd1 vccd1 vccd1 sky130_fd_sc_hd__fill_1
X_1690_ net410 _0490_ net25 vssd1 vssd1 vccd1 vccd1 _0048_ sky130_fd_sc_hd__mux2_1
X_3360_ clknet_leaf_7_clk _0315_ net110 vssd1 vssd1 vccd1 vccd1 MATMULT_INST.matmult_inst.fsm_inst.alu_result\[6\]
+ sky130_fd_sc_hd__dfrtp_1
X_2311_ net231 net213 vssd1 vssd1 vccd1 vccd1 _0857_ sky130_fd_sc_hd__and2_1
X_3291_ clknet_leaf_0_clk _0249_ net95 vssd1 vssd1 vccd1 vccd1 MATMULT_INST.matmult_inst.alu_inst.b0_reg\[7\]
+ sky130_fd_sc_hd__dfrtp_1
X_2242_ _0786_ _0788_ _0789_ vssd1 vssd1 vccd1 vccd1 _0790_ sky130_fd_sc_hd__o21ai_1
XFILLER_25_3 vssd1 vssd1 vccd1 vccd1 sky130_fd_sc_hd__fill_4
X_2173_ _0715_ _0722_ vssd1 vssd1 vccd1 vccd1 _0723_ sky130_fd_sc_hd__xnor2_2
XANTENNA__1749__S net20 vssd1 vssd1 vccd1 vccd1 sky130_fd_sc_hd__diode_2
XTAP_TAPCELL_ROW_51_606 vssd1 vccd1 sky130_fd_sc_hd__tapvpwrvgnd_1
XFILLER_21_335 vssd1 vssd1 vccd1 vccd1 sky130_fd_sc_hd__fill_1
X_1957_ net544 _0543_ net74 vssd1 vssd1 vccd1 vccd1 _0262_ sky130_fd_sc_hd__mux2_1
X_1888_ net602 _0498_ net10 vssd1 vssd1 vccd1 vccd1 _0218_ sky130_fd_sc_hd__mux2_1
X_2509_ net166 _0480_ _1019_ _1017_ net158 vssd1 vssd1 vccd1 vccd1 _1020_ sky130_fd_sc_hd__a32o_1
X_3489_ clknet_leaf_12_clk net334 net149 vssd1 vssd1 vccd1 vccd1 MATMULT_INST.matmult_inst.fsm_inst.rx_data\[7\]
+ sky130_fd_sc_hd__dfrtp_1
Xteam_02_303 vssd1 vssd1 vccd1 vccd1 gpio_oeb[23] team_02_303/LO sky130_fd_sc_hd__conb_1
XFILLER_24_195 vssd1 vssd1 vccd1 vccd1 sky130_fd_sc_hd__fill_1
XFILLER_12_357 vssd1 vssd1 vccd1 vccd1 sky130_fd_sc_hd__fill_4
XTAP_TAPCELL_ROW_22_363 vssd1 vccd1 sky130_fd_sc_hd__tapvpwrvgnd_1
XANTENNA__2971__B1 net78 vssd1 vssd1 vccd1 vccd1 sky130_fd_sc_hd__diode_2
XANTENNA__2953__S net58 vssd1 vssd1 vccd1 vccd1 sky130_fd_sc_hd__diode_2
Xclkbuf_leaf_27_clk clknet_2_0__leaf_clk vssd1 vssd1 vccd1 vccd1 clknet_leaf_27_clk
+ sky130_fd_sc_hd__clkbuf_8
XFILLER_62_257 vssd1 vssd1 vccd1 vccd1 sky130_fd_sc_hd__fill_1
XFILLER_50_419 vssd1 vssd1 vccd1 vccd1 sky130_fd_sc_hd__fill_1
XFILLER_43_493 vssd1 vssd1 vccd1 vccd1 sky130_fd_sc_hd__fill_1
X_2860_ _1297_ _1326_ vssd1 vssd1 vccd1 vccd1 _1328_ sky130_fd_sc_hd__nand2_1
X_1811_ net455 net48 net16 vssd1 vssd1 vccd1 vccd1 _0145_ sky130_fd_sc_hd__mux2_1
XFILLER_62_91 vssd1 vssd1 vccd1 vccd1 sky130_fd_sc_hd__fill_1
X_2791_ _1259_ _1260_ vssd1 vssd1 vccd1 vccd1 _1261_ sky130_fd_sc_hd__nor2_1
X_1742_ net415 net36 net21 vssd1 vssd1 vccd1 vccd1 _0082_ sky130_fd_sc_hd__mux2_1
XFILLER_7_361 vccd1 vssd1 vccd1 vssd1 sky130_ef_sc_hd__decap_40_12
X_1673_ net178 net169 vssd1 vssd1 vccd1 vccd1 _0479_ sky130_fd_sc_hd__nor2_1
Xhold306 MATMULT_INST.matmult_inst.mem_inst.matrixA2\[11\] vssd1 vssd1 vccd1 vccd1
+ net619 sky130_fd_sc_hd__dlygate4sd3_1
Xhold317 MATMULT_INST.matmult_inst.alu_inst.out\[9\] vssd1 vssd1 vccd1 vccd1 net630
+ sky130_fd_sc_hd__dlygate4sd3_1
Xhold328 MATMULT_INST.matmult_inst.fsm_inst.rx_valid_delay vssd1 vssd1 vccd1 vccd1
+ net641 sky130_fd_sc_hd__dlygate4sd3_1
X_3412_ clknet_leaf_28_clk _0365_ net96 vssd1 vssd1 vccd1 vccd1 MATMULT_INST.matmult_inst.alu_inst.row0\[5\]
+ sky130_fd_sc_hd__dfrtp_1
Xhold339 MATMULT_INST.matmult_inst.mem_inst.matrixA2\[10\] vssd1 vssd1 vccd1 vccd1
+ net652 sky130_fd_sc_hd__dlygate4sd3_1
X_3343_ clknet_leaf_0_clk _0298_ vssd1 vssd1 vccd1 vccd1 MATMULT_INST.matmult_inst.alu_inst.adder_inst.r1.fa2.a
+ sky130_fd_sc_hd__dfxtp_1
X_3274_ clknet_leaf_16_clk _0232_ net120 vssd1 vssd1 vccd1 vccd1 MATMULT_INST.matmult_inst.mem_inst.matrixA1\[9\]
+ sky130_fd_sc_hd__dfrtp_1
X_2225_ _0772_ _0773_ vssd1 vssd1 vccd1 vccd1 _0774_ sky130_fd_sc_hd__and2_1
XFILLER_38_221 vssd1 vssd1 vccd1 vccd1 sky130_fd_sc_hd__fill_2
X_2156_ _0687_ _0699_ _0686_ vssd1 vssd1 vccd1 vccd1 _0706_ sky130_fd_sc_hd__a21boi_1
XANTENNA__3507__CLK net242 vssd1 vssd1 vccd1 vccd1 sky130_fd_sc_hd__diode_2
XTAP_TAPCELL_ROW_64_720 vssd1 vccd1 sky130_fd_sc_hd__tapvpwrvgnd_1
X_2087_ net241 net218 vssd1 vssd1 vccd1 vccd1 _0640_ sky130_fd_sc_hd__and2_1
XPHY_EDGE_ROW_5_Right_5 vssd1 vssd1 vccd1 vccd1 sky130_fd_sc_hd__decap_3
XANTENNA_fanout167_A net168 vssd1 vssd1 vccd1 vccd1 sky130_fd_sc_hd__diode_2
Xclkbuf_leaf_18_clk clknet_2_2__leaf_clk vssd1 vssd1 vccd1 vccd1 clknet_leaf_18_clk
+ sky130_fd_sc_hd__clkbuf_8
XTAP_TAPCELL_ROW_36_477 vssd1 vccd1 sky130_fd_sc_hd__tapvpwrvgnd_1
X_2989_ net179 net170 MATMULT_INST.matmult_inst.mem_inst.matrixB3\[11\] vssd1 vssd1
+ vccd1 vccd1 _1413_ sky130_fd_sc_hd__and3_1
XFILLER_29_221 vssd1 vssd1 vccd1 vccd1 sky130_fd_sc_hd__fill_2
XTAP_TAPCELL_ROW_27_400 vssd1 vccd1 sky130_fd_sc_hd__tapvpwrvgnd_1
XANTENNA__2484__A2 net89 vssd1 vssd1 vccd1 vccd1 sky130_fd_sc_hd__diode_2
XFILLER_16_51 vssd1 vssd1 vccd1 vccd1 sky130_fd_sc_hd__fill_1
XTAP_TAPCELL_ROW_70_767 vssd1 vccd1 sky130_fd_sc_hd__tapvpwrvgnd_1
XFILLER_12_132 vssd1 vssd1 vccd1 vccd1 sky130_fd_sc_hd__fill_8
XFILLER_12_165 vccd1 vssd1 vccd1 vssd1 sky130_ef_sc_hd__decap_40_12
XANTENNA__2240__C net222 vssd1 vssd1 vccd1 vccd1 sky130_fd_sc_hd__diode_2
XFILLER_79_132 vssd1 vssd1 vccd1 vccd1 sky130_fd_sc_hd__fill_4
XANTENNA__1852__S net28 vssd1 vssd1 vccd1 vccd1 sky130_fd_sc_hd__diode_2
XANTENNA__2948__S net58 vssd1 vssd1 vccd1 vccd1 sky130_fd_sc_hd__diode_2
XFILLER_79_165 vssd1 vssd1 vccd1 vccd1 sky130_fd_sc_hd__fill_2
XFILLER_79_187 vssd1 vssd1 vccd1 vccd1 sky130_fd_sc_hd__fill_2
XTAP_TAPCELL_ROW_78_834 vssd1 vccd1 sky130_fd_sc_hd__tapvpwrvgnd_1
X_2010_ MATMULT_INST.matmult_inst.alu_inst.adder_inst.r3.fa1.b MATMULT_INST.matmult_inst.alu_inst.adder_inst.r3.fa1.a
+ vssd1 vssd1 vccd1 vccd1 _0588_ sky130_fd_sc_hd__nor2_1
XFILLER_75_371 vssd1 vssd1 vccd1 vccd1 sky130_fd_sc_hd__fill_4
XANTENNA__2475__A2 _0954_ vssd1 vssd1 vccd1 vccd1 sky130_fd_sc_hd__diode_2
XFILLER_35_202 vssd1 vssd1 vccd1 vccd1 sky130_fd_sc_hd__fill_2
XANTENNA__1683__B1 net61 vssd1 vssd1 vccd1 vccd1 sky130_fd_sc_hd__diode_2
XFILLER_35_279 vssd1 vssd1 vccd1 vccd1 sky130_fd_sc_hd__fill_1
X_2912_ _1376_ vssd1 vssd1 vccd1 vccd1 _1377_ sky130_fd_sc_hd__inv_2
X_2843_ net189 net198 net187 net201 vssd1 vssd1 vccd1 vccd1 _1311_ sky130_fd_sc_hd__and4_1
X_2774_ net363 net71 vssd1 vssd1 vccd1 vccd1 _1244_ sky130_fd_sc_hd__nor2_1
X_1725_ net456 _0492_ net23 vssd1 vssd1 vccd1 vccd1 _0068_ sky130_fd_sc_hd__mux2_1
Xhold103 MATMULT_INST.matmult_inst.mem_inst.mem0\[6\] vssd1 vssd1 vccd1 vccd1 net416
+ sky130_fd_sc_hd__dlygate4sd3_1
Xhold125 MATMULT_INST.matmult_inst.spi_inst.tx_reg_sys\[13\] vssd1 vssd1 vccd1 vccd1
+ net438 sky130_fd_sc_hd__dlygate4sd3_1
Xhold114 MATMULT_INST.matmult_inst.mem_inst.mem1\[7\] vssd1 vssd1 vccd1 vccd1 net427
+ sky130_fd_sc_hd__dlygate4sd3_1
Xhold158 MATMULT_INST.matmult_inst.alu_inst.row1\[1\] vssd1 vssd1 vccd1 vccd1 net471
+ sky130_fd_sc_hd__dlygate4sd3_1
X_1656_ MATMULT_INST.matmult_inst.spi_inst.tx_reg_sys\[5\] MATMULT_INST.matmult_inst.spi_inst.miso_shifter\[4\]
+ net154 vssd1 vssd1 vccd1 vccd1 _0017_ sky130_fd_sc_hd__mux2_1
Xhold136 _0312_ vssd1 vssd1 vccd1 vccd1 net449 sky130_fd_sc_hd__dlygate4sd3_1
Xclkbuf_leaf_7_clk clknet_2_1__leaf_clk vssd1 vssd1 vccd1 vccd1 clknet_leaf_7_clk
+ sky130_fd_sc_hd__clkbuf_8
Xhold147 MATMULT_INST.matmult_inst.mem_inst.matrixA0\[6\] vssd1 vssd1 vccd1 vccd1
+ net460 sky130_fd_sc_hd__dlygate4sd3_1
Xhold169 MATMULT_INST.matmult_inst.alu_inst.col1\[3\] vssd1 vssd1 vccd1 vccd1 net482
+ sky130_fd_sc_hd__dlygate4sd3_1
X_1587_ _1498_ _1504_ vssd1 vssd1 vccd1 vccd1 _1505_ sky130_fd_sc_hd__nor2_1
XANTENNA__1762__S net19 vssd1 vssd1 vccd1 vccd1 sky130_fd_sc_hd__diode_2
X_3326_ clknet_leaf_7_clk net55 net111 vssd1 vssd1 vccd1 vccd1 MATMULT_INST.matmult_inst.alu_inst.state\[0\]
+ sky130_fd_sc_hd__dfrtp_1
X_3257_ clknet_leaf_24_clk _0215_ net119 vssd1 vssd1 vccd1 vccd1 MATMULT_INST.matmult_inst.mem_inst.mem0\[10\]
+ sky130_fd_sc_hd__dfrtp_1
XFILLER_37_39 vssd1 vssd1 vccd1 vccd1 sky130_fd_sc_hd__fill_4
X_2208_ _0697_ _0729_ _0730_ _0731_ _0679_ vssd1 vssd1 vccd1 vccd1 _0757_ sky130_fd_sc_hd__a32o_1
X_3188_ clknet_leaf_22_clk _0146_ net117 vssd1 vssd1 vccd1 vccd1 MATMULT_INST.matmult_inst.mem_inst.mem2\[13\]
+ sky130_fd_sc_hd__dfrtp_1
X_2139_ _0688_ _0689_ vssd1 vssd1 vccd1 vccd1 _0690_ sky130_fd_sc_hd__or2_1
XTAP_TAPCELL_ROW_49_591 vssd1 vccd1 sky130_fd_sc_hd__tapvpwrvgnd_1
XFILLER_14_419 vssd1 vssd1 vccd1 vccd1 sky130_fd_sc_hd__fill_1
XFILLER_14_408 vssd1 vssd1 vccd1 vccd1 sky130_fd_sc_hd__fill_1
XPHY_EDGE_ROW_14_Left_94 vssd1 vssd1 vccd1 vccd1 sky130_fd_sc_hd__decap_3
XANTENNA__2622__A net210 vssd1 vssd1 vccd1 vccd1 sky130_fd_sc_hd__diode_2
XANTENNA__2060__C net241 vssd1 vssd1 vccd1 vccd1 sky130_fd_sc_hd__diode_2
XFILLER_1_389 vssd1 vssd1 vccd1 vccd1 sky130_fd_sc_hd__fill_2
XFILLER_49_327 vssd1 vssd1 vccd1 vccd1 sky130_fd_sc_hd__fill_1
XANTENNA__2457__A2 net89 vssd1 vssd1 vccd1 vccd1 sky130_fd_sc_hd__diode_2
XFILLER_72_374 vssd1 vssd1 vccd1 vccd1 sky130_fd_sc_hd__fill_2
XANTENNA__2516__B net173 vssd1 vssd1 vccd1 vccd1 sky130_fd_sc_hd__diode_2
XFILLER_13_463 vssd1 vssd1 vccd1 vccd1 sky130_fd_sc_hd__fill_4
XTAP_TAPCELL_ROW_30_428 vssd1 vccd1 sky130_fd_sc_hd__tapvpwrvgnd_1
XFILLER_9_445 vssd1 vssd1 vccd1 vccd1 sky130_fd_sc_hd__fill_2
XANTENNA__1847__S net28 vssd1 vssd1 vccd1 vccd1 sky130_fd_sc_hd__diode_2
X_2490_ MATMULT_INST.matmult_inst.mem_inst.matrixB2\[5\] net90 net83 MATMULT_INST.matmult_inst.mem_inst.matrixB1\[5\]
+ _1001_ vssd1 vssd1 vccd1 vccd1 _1002_ sky130_fd_sc_hd__a221o_1
XFILLER_4_65 vccd1 vssd1 vccd1 vssd1 sky130_ef_sc_hd__decap_40_12
X_3111_ clknet_leaf_18_clk _0069_ net129 vssd1 vssd1 vccd1 vccd1 MATMULT_INST.matmult_inst.mem_inst.matrixA0\[8\]
+ sky130_fd_sc_hd__dfrtp_1
XFILLER_67_102 vssd1 vssd1 vccd1 vccd1 sky130_fd_sc_hd__fill_2
XFILLER_67_113 vssd1 vssd1 vccd1 vccd1 sky130_fd_sc_hd__fill_2
X_3042_ net413 _1461_ net57 vssd1 vssd1 vccd1 vccd1 _0449_ sky130_fd_sc_hd__mux2_1
XTAP_TAPCELL_ROW_46_561 vssd1 vccd1 sky130_fd_sc_hd__tapvpwrvgnd_1
X_2826_ _1286_ _1294_ vssd1 vssd1 vccd1 vccd1 _1295_ sky130_fd_sc_hd__xnor2_1
X_2757_ net188 net206 net208 net186 vssd1 vssd1 vccd1 vccd1 _1228_ sky130_fd_sc_hd__a22o_1
XFILLER_2_109 vccd1 vssd1 vccd1 vssd1 sky130_ef_sc_hd__decap_40_12
X_1708_ net626 _0499_ net24 vssd1 vssd1 vccd1 vccd1 _0057_ sky130_fd_sc_hd__mux2_1
X_2688_ _1159_ _1160_ _1131_ vssd1 vssd1 vccd1 vccd1 _1161_ sky130_fd_sc_hd__a21o_1
X_1639_ net76 _1530_ _0460_ _0470_ vssd1 vssd1 vccd1 vccd1 _0001_ sky130_fd_sc_hd__a31o_1
XANTENNA_input4_A gpio_in[2] vssd1 vssd1 vccd1 vccd1 sky130_fd_sc_hd__diode_2
XFILLER_58_102 vssd1 vssd1 vccd1 vccd1 sky130_fd_sc_hd__fill_1
XFILLER_58_124 vssd1 vssd1 vccd1 vccd1 sky130_fd_sc_hd__fill_1
X_3309_ clknet_leaf_1_clk _0267_ net100 vssd1 vssd1 vccd1 vccd1 MATMULT_INST.matmult_inst.alu_inst.out\[9\]
+ sky130_fd_sc_hd__dfrtp_1
XFILLER_66_190 vssd1 vssd1 vccd1 vccd1 sky130_fd_sc_hd__fill_1
XFILLER_14_249 vssd1 vssd1 vccd1 vccd1 sky130_fd_sc_hd__fill_2
Xfanout20 _0508_ vssd1 vssd1 vccd1 vccd1 net20 sky130_fd_sc_hd__buf_4
Xfanout31 _0513_ vssd1 vssd1 vccd1 vccd1 net31 sky130_fd_sc_hd__clkbuf_4
Xfanout64 _0944_ vssd1 vssd1 vccd1 vccd1 net64 sky130_fd_sc_hd__clkbuf_4
Xfanout53 net54 vssd1 vssd1 vccd1 vccd1 net53 sky130_fd_sc_hd__clkbuf_4
Xfanout42 _0923_ vssd1 vssd1 vccd1 vccd1 net42 sky130_fd_sc_hd__clkbuf_2
Xfanout75 _1521_ vssd1 vssd1 vccd1 vccd1 net75 sky130_fd_sc_hd__buf_2
XFILLER_10_433 vccd1 vssd1 vccd1 vssd1 sky130_ef_sc_hd__decap_40_12
Xfanout97 net99 vssd1 vssd1 vccd1 vccd1 net97 sky130_fd_sc_hd__clkbuf_4
Xfanout86 net88 vssd1 vssd1 vccd1 vccd1 net86 sky130_fd_sc_hd__clkbuf_2
XFILLER_13_63 vssd1 vssd1 vccd1 vccd1 sky130_fd_sc_hd__fill_4
XFILLER_10_477 vccd1 vssd1 vccd1 vssd1 sky130_ef_sc_hd__decap_40_12
XFILLER_49_135 vssd1 vssd1 vccd1 vccd1 sky130_fd_sc_hd__fill_2
XANTENNA__1638__B1 net59 vssd1 vssd1 vccd1 vccd1 sky130_fd_sc_hd__diode_2
XFILLER_38_82 vssd1 vssd1 vccd1 vccd1 sky130_fd_sc_hd__fill_2
XFILLER_45_330 vssd1 vssd1 vccd1 vccd1 sky130_fd_sc_hd__fill_1
X_1990_ _0570_ _0571_ vssd1 vssd1 vccd1 vccd1 _0572_ sky130_fd_sc_hd__xor2_1
XTAP_TAPCELL_ROW_15_299 vssd1 vccd1 sky130_fd_sc_hd__tapvpwrvgnd_1
XFILLER_13_293 vccd1 vssd1 vccd1 vssd1 sky130_ef_sc_hd__decap_40_12
Xclkload12 clknet_leaf_17_clk vssd1 vssd1 vccd1 vccd1 clkload12/Y sky130_fd_sc_hd__clkinv_8
X_2611_ _1072_ _1075_ _1086_ vssd1 vssd1 vccd1 vccd1 _1087_ sky130_fd_sc_hd__o21ai_2
Xclkload23 clknet_leaf_11_clk vssd1 vssd1 vccd1 vccd1 clkload23/X sky130_fd_sc_hd__clkbuf_4
X_2542_ _1531_ _1535_ vssd1 vssd1 vccd1 vccd1 _1043_ sky130_fd_sc_hd__or2_1
XFILLER_55_3 vssd1 vssd1 vccd1 vccd1 sky130_fd_sc_hd__fill_8
X_2473_ MATMULT_INST.matmult_inst.mem_inst.matrixA0\[3\] net65 _0982_ _0986_ vssd1
+ vssd1 vccd1 vccd1 _0987_ sky130_fd_sc_hd__a211o_1
X_3025_ MATMULT_INST.matmult_inst.mem_inst.mem2\[14\] net86 net78 MATMULT_INST.matmult_inst.mem_inst.mem1\[14\]
+ _1445_ vssd1 vssd1 vccd1 vccd1 _1446_ sky130_fd_sc_hd__a221o_1
Xclkload6 clknet_leaf_29_clk vssd1 vssd1 vccd1 vccd1 clkload6/Y sky130_fd_sc_hd__inv_12
X_2809_ _1274_ _1275_ _1277_ _1217_ vssd1 vssd1 vccd1 vccd1 _1279_ sky130_fd_sc_hd__a22o_1
XANTENNA__2357__A1 net228 vssd1 vssd1 vccd1 vccd1 sky130_fd_sc_hd__diode_2
XFILLER_3_429 vccd1 vssd1 vccd1 vssd1 sky130_ef_sc_hd__decap_40_12
XANTENNA__2109__B2 net241 vssd1 vssd1 vccd1 vccd1 sky130_fd_sc_hd__diode_2
XANTENNA__2109__A1 net239 vssd1 vssd1 vccd1 vccd1 sky130_fd_sc_hd__diode_2
XTAP_TAPCELL_ROW_6_223 vssd1 vccd1 sky130_fd_sc_hd__tapvpwrvgnd_1
Xfanout232 MATMULT_INST.matmult_inst.alu_inst.b0_reg\[5\] vssd1 vssd1 vccd1 vccd1
+ net232 sky130_fd_sc_hd__clkbuf_2
Xfanout221 net222 vssd1 vssd1 vccd1 vccd1 net221 sky130_fd_sc_hd__buf_2
Xfanout210 MATMULT_INST.matmult_inst.alu_inst.b1_reg\[1\] vssd1 vssd1 vccd1 vccd1
+ net210 sky130_fd_sc_hd__buf_2
Xfanout243 net2 vssd1 vssd1 vccd1 vccd1 net243 sky130_fd_sc_hd__buf_1
XFILLER_75_36 vccd1 vssd1 vccd1 vssd1 sky130_ef_sc_hd__decap_40_12
XFILLER_74_414 vssd1 vssd1 vccd1 vccd1 sky130_fd_sc_hd__fill_1
XFILLER_46_116 vssd1 vssd1 vccd1 vccd1 sky130_fd_sc_hd__fill_1
XFILLER_46_127 vccd1 vssd1 vccd1 vssd1 sky130_ef_sc_hd__decap_40_12
XTAP_TAPCELL_ROW_57_656 vssd1 vccd1 sky130_fd_sc_hd__tapvpwrvgnd_1
XFILLER_54_182 vccd1 vssd1 vccd1 vssd1 sky130_ef_sc_hd__decap_40_12
XTAP_TAPCELL_ROW_40_512 vssd1 vccd1 sky130_fd_sc_hd__tapvpwrvgnd_1
XFILLER_6_245 vssd1 vssd1 vccd1 vccd1 sky130_fd_sc_hd__fill_4
XFILLER_6_289 vccd1 vssd1 vccd1 vssd1 sky130_ef_sc_hd__decap_40_12
XFILLER_2_473 vssd1 vssd1 vccd1 vccd1 sky130_fd_sc_hd__fill_2
XANTENNA__2520__A1 net93 vssd1 vssd1 vccd1 vccd1 sky130_fd_sc_hd__diode_2
XANTENNA__1860__S net12 vssd1 vssd1 vccd1 vccd1 sky130_fd_sc_hd__diode_2
XANTENNA__2520__B2 net158 vssd1 vssd1 vccd1 vccd1 sky130_fd_sc_hd__diode_2
XFILLER_1_55 vssd1 vssd1 vccd1 vccd1 sky130_fd_sc_hd__fill_1
XFILLER_65_425 vssd1 vssd1 vccd1 vccd1 sky130_fd_sc_hd__fill_1
XFILLER_18_352 vssd1 vssd1 vccd1 vccd1 sky130_fd_sc_hd__fill_1
XFILLER_18_363 vssd1 vssd1 vccd1 vccd1 sky130_fd_sc_hd__fill_1
X_1973_ _0556_ vssd1 vssd1 vccd1 vccd1 _0557_ sky130_fd_sc_hd__inv_2
XANTENNA__3000__A2 net64 vssd1 vssd1 vccd1 vccd1 sky130_fd_sc_hd__diode_2
X_2525_ MATMULT_INST.matmult_inst.fsm_inst.count\[0\] _1501_ net76 vssd1 vssd1 vccd1
+ vccd1 _1034_ sky130_fd_sc_hd__o21a_1
X_2456_ net181 net172 MATMULT_INST.matmult_inst.mem_inst.matrixB3\[2\] vssd1 vssd1
+ vccd1 vccd1 _0971_ sky130_fd_sc_hd__and3_1
Xhold18 _0432_ vssd1 vssd1 vccd1 vccd1 net331 sky130_fd_sc_hd__dlygate4sd3_1
Xhold29 MATMULT_INST.matmult_inst.mem_inst.matrixB3\[4\] vssd1 vssd1 vccd1 vccd1 net342
+ sky130_fd_sc_hd__dlygate4sd3_1
XANTENNA__1770__S net18 vssd1 vssd1 vccd1 vccd1 sky130_fd_sc_hd__diode_2
X_2387_ net448 net63 net42 MATMULT_INST.matmult_inst.fsm_inst.alu_result\[3\] vssd1
+ vssd1 vccd1 vccd1 _0312_ sky130_fd_sc_hd__a22o_1
XFILLER_28_149 vssd1 vssd1 vccd1 vccd1 sky130_fd_sc_hd__fill_1
X_3008_ net155 _1427_ _1430_ _1423_ vssd1 vssd1 vccd1 vccd1 _1431_ sky130_fd_sc_hd__a211o_1
XANTENNA__2814__A2 net203 vssd1 vssd1 vccd1 vccd1 sky130_fd_sc_hd__diode_2
XANTENNA_fanout152_X net152 vssd1 vssd1 vccd1 vccd1 sky130_fd_sc_hd__diode_2
XFILLER_10_53 vccd1 vssd1 vccd1 vssd1 sky130_ef_sc_hd__decap_40_12
XFILLER_3_237 vccd1 vssd1 vccd1 vssd1 sky130_ef_sc_hd__decap_40_12
XFILLER_10_97 vccd1 vssd1 vccd1 vssd1 sky130_ef_sc_hd__decap_40_12
XANTENNA__1680__S net25 vssd1 vssd1 vccd1 vccd1 sky130_fd_sc_hd__diode_2
XANTENNA_fanout65_X net65 vssd1 vssd1 vccd1 vccd1 sky130_fd_sc_hd__diode_2
XFILLER_74_244 vssd1 vssd1 vccd1 vccd1 sky130_fd_sc_hd__fill_1
XTAP_TAPCELL_ROW_17_317 vssd1 vccd1 sky130_fd_sc_hd__tapvpwrvgnd_1
XTAP_TAPCELL_ROW_25_383 vssd1 vccd1 sky130_fd_sc_hd__tapvpwrvgnd_1
XPHY_EDGE_ROW_2_Left_82 vssd1 vssd1 vccd1 vccd1 sky130_fd_sc_hd__decap_3
X_2310_ _0830_ _0831_ _0829_ vssd1 vssd1 vccd1 vccd1 _0856_ sky130_fd_sc_hd__o21ba_1
X_3290_ clknet_leaf_28_clk _0248_ net95 vssd1 vssd1 vccd1 vccd1 MATMULT_INST.matmult_inst.alu_inst.b0_reg\[6\]
+ sky130_fd_sc_hd__dfrtp_1
X_2241_ net218 net231 vssd1 vssd1 vccd1 vccd1 _0789_ sky130_fd_sc_hd__and2_1
XFILLER_18_3 vssd1 vssd1 vccd1 vccd1 sky130_fd_sc_hd__fill_8
X_2172_ _0716_ _0719_ vssd1 vssd1 vccd1 vccd1 _0722_ sky130_fd_sc_hd__xor2_2
XFILLER_65_200 vssd1 vssd1 vccd1 vccd1 sky130_fd_sc_hd__fill_1
XFILLER_65_233 vssd1 vssd1 vccd1 vccd1 sky130_fd_sc_hd__fill_2
XTAP_TAPCELL_ROW_51_607 vssd1 vccd1 sky130_fd_sc_hd__tapvpwrvgnd_1
X_1956_ _0540_ _0542_ vssd1 vssd1 vccd1 vccd1 _0543_ sky130_fd_sc_hd__xnor2_1
X_1887_ net553 _0497_ net10 vssd1 vssd1 vccd1 vccd1 _0217_ sky130_fd_sc_hd__mux2_1
XANTENNA__1765__S net19 vssd1 vssd1 vccd1 vccd1 sky130_fd_sc_hd__diode_2
XANTENNA__2980__B2 net92 vssd1 vssd1 vccd1 vccd1 sky130_fd_sc_hd__diode_2
X_2508_ MATMULT_INST.matmult_inst.mem_inst.matrixA2\[6\] net90 net83 MATMULT_INST.matmult_inst.mem_inst.matrixA1\[6\]
+ _1018_ vssd1 vssd1 vccd1 vccd1 _1019_ sky130_fd_sc_hd__a221o_1
X_3488_ clknet_leaf_12_clk net331 net146 vssd1 vssd1 vccd1 vccd1 MATMULT_INST.matmult_inst.fsm_inst.rx_data\[6\]
+ sky130_fd_sc_hd__dfrtp_1
Xteam_02_304 vssd1 vssd1 vccd1 vccd1 gpio_oeb[24] team_02_304/LO sky130_fd_sc_hd__conb_1
X_2439_ net181 net172 MATMULT_INST.matmult_inst.mem_inst.mem3\[1\] vssd1 vssd1 vccd1
+ vccd1 _0955_ sky130_fd_sc_hd__and3_1
XANTENNA__2496__B1 net84 vssd1 vssd1 vccd1 vccd1 sky130_fd_sc_hd__diode_2
XFILLER_56_27 vssd1 vssd1 vccd1 vccd1 sky130_fd_sc_hd__fill_1
XFILLER_29_447 vssd1 vssd1 vccd1 vccd1 sky130_fd_sc_hd__fill_1
XTAP_TAPCELL_ROW_67_740 vssd1 vccd1 sky130_fd_sc_hd__tapvpwrvgnd_1
XFILLER_71_225 vssd1 vssd1 vccd1 vccd1 sky130_fd_sc_hd__fill_2
XFILLER_52_450 vssd1 vssd1 vccd1 vccd1 sky130_fd_sc_hd__fill_1
XFILLER_8_307 vssd1 vssd1 vccd1 vccd1 sky130_fd_sc_hd__fill_1
XFILLER_20_380 vssd1 vssd1 vccd1 vccd1 sky130_fd_sc_hd__fill_1
XFILLER_21_30 vccd1 vssd1 vccd1 vssd1 sky130_ef_sc_hd__decap_40_12
XANTENNA__2723__A1 net186 vssd1 vssd1 vccd1 vccd1 sky130_fd_sc_hd__diode_2
XFILLER_46_82 vssd1 vssd1 vccd1 vccd1 sky130_fd_sc_hd__fill_2
XFILLER_15_152 vccd1 vssd1 vccd1 vssd1 sky130_ef_sc_hd__decap_40_12
X_1810_ net494 net49 net16 vssd1 vssd1 vccd1 vccd1 _0144_ sky130_fd_sc_hd__mux2_1
XFILLER_62_81 vssd1 vssd1 vccd1 vccd1 sky130_fd_sc_hd__fill_2
X_2790_ _1258_ net208 MATMULT_INST.matmult_inst.alu_inst.a1_reg\[7\] _1255_ vssd1
+ vssd1 vccd1 vccd1 _1260_ sky130_fd_sc_hd__and4b_1
XFILLER_11_391 vssd1 vssd1 vccd1 vccd1 sky130_fd_sc_hd__fill_1
X_1741_ net398 _0487_ net21 vssd1 vssd1 vccd1 vccd1 _0081_ sky130_fd_sc_hd__mux2_1
X_1672_ net314 _1485_ MATMULT_INST.matmult_inst.spi_inst.rx_done_sys vssd1 vssd1 vccd1
+ vccd1 _0042_ sky130_fd_sc_hd__a21o_1
XFILLER_7_373 vccd1 vssd1 vccd1 vssd1 sky130_ef_sc_hd__decap_40_12
XANTENNA__2962__B2 net165 vssd1 vssd1 vccd1 vccd1 sky130_fd_sc_hd__diode_2
XANTENNA__2962__A1 net92 vssd1 vssd1 vccd1 vccd1 sky130_fd_sc_hd__diode_2
Xhold307 MATMULT_INST.matmult_inst.mem_inst.matrixB1\[8\] vssd1 vssd1 vccd1 vccd1
+ net620 sky130_fd_sc_hd__dlygate4sd3_1
X_3411_ clknet_leaf_26_clk _0364_ net99 vssd1 vssd1 vccd1 vccd1 MATMULT_INST.matmult_inst.alu_inst.row0\[4\]
+ sky130_fd_sc_hd__dfrtp_1
Xhold329 MATMULT_INST.matmult_inst.alu_inst.out\[15\] vssd1 vssd1 vccd1 vccd1 net642
+ sky130_fd_sc_hd__dlygate4sd3_1
Xhold318 MATMULT_INST.matmult_inst.alu_inst.adder_inst.r3.fa3.a vssd1 vssd1 vccd1
+ vccd1 net631 sky130_fd_sc_hd__dlygate4sd3_1
X_3342_ clknet_leaf_0_clk _0297_ vssd1 vssd1 vccd1 vccd1 MATMULT_INST.matmult_inst.alu_inst.adder_inst.r1.fa1.a
+ sky130_fd_sc_hd__dfxtp_1
X_3273_ clknet_leaf_18_clk _0231_ net131 vssd1 vssd1 vccd1 vccd1 MATMULT_INST.matmult_inst.mem_inst.matrixA1\[8\]
+ sky130_fd_sc_hd__dfrtp_1
X_2224_ _0769_ _0770_ _0771_ vssd1 vssd1 vccd1 vccd1 _0773_ sky130_fd_sc_hd__a21o_1
X_2155_ net555 _0705_ net71 vssd1 vssd1 vccd1 vccd1 _0298_ sky130_fd_sc_hd__mux2_1
XFILLER_26_19 vssd1 vssd1 vccd1 vccd1 sky130_fd_sc_hd__fill_2
X_2086_ _0624_ _0636_ _0637_ vssd1 vssd1 vccd1 vccd1 _0639_ sky130_fd_sc_hd__and3_1
XTAP_TAPCELL_ROW_36_478 vssd1 vccd1 sky130_fd_sc_hd__tapvpwrvgnd_1
XFILLER_42_29 vssd1 vssd1 vccd1 vccd1 sky130_fd_sc_hd__fill_4
X_2988_ net156 MATMULT_INST.matmult_inst.mem_inst.mem0\[11\] MATMULT_INST.matmult_inst.mem_inst.matrixB0\[11\]
+ net164 vssd1 vssd1 vccd1 vccd1 _1412_ sky130_fd_sc_hd__a22o_1
X_1939_ MATMULT_INST.matmult_inst.alu_inst.adder_inst.r0.fa2.b MATMULT_INST.matmult_inst.alu_inst.adder_inst.r0.fa2.a
+ vssd1 vssd1 vccd1 vccd1 _0528_ sky130_fd_sc_hd__nand2_1
XANTENNA__2953__A1 _1021_ vssd1 vssd1 vccd1 vccd1 sky130_fd_sc_hd__diode_2
XFILLER_29_233 vssd1 vssd1 vccd1 vccd1 sky130_fd_sc_hd__fill_1
XTAP_TAPCELL_ROW_27_401 vssd1 vccd1 sky130_fd_sc_hd__tapvpwrvgnd_1
XFILLER_16_41 vssd1 vssd1 vccd1 vccd1 sky130_fd_sc_hd__fill_8
XFILLER_16_85 vssd1 vssd1 vccd1 vccd1 sky130_fd_sc_hd__fill_1
XPHY_EDGE_ROW_11_Right_11 vssd1 vssd1 vccd1 vccd1 sky130_fd_sc_hd__decap_3
XTAP_TAPCELL_ROW_70_768 vssd1 vccd1 sky130_fd_sc_hd__tapvpwrvgnd_1
XANTENNA_fanout28_X net28 vssd1 vssd1 vccd1 vccd1 sky130_fd_sc_hd__diode_2
XFILLER_12_177 vccd1 vssd1 vccd1 vssd1 sky130_ef_sc_hd__decap_40_12
XFILLER_8_137 vssd1 vssd1 vccd1 vccd1 sky130_fd_sc_hd__fill_2
XFILLER_4_321 vccd1 vssd1 vccd1 vssd1 sky130_ef_sc_hd__decap_40_12
XFILLER_4_365 vccd1 vssd1 vccd1 vssd1 sky130_ef_sc_hd__decap_40_12
XFILLER_79_111 vssd1 vssd1 vccd1 vccd1 sky130_fd_sc_hd__fill_1
XPHY_EDGE_ROW_20_Right_20 vssd1 vssd1 vccd1 vccd1 sky130_fd_sc_hd__decap_3
XTAP_TAPCELL_ROW_78_835 vssd1 vccd1 sky130_fd_sc_hd__tapvpwrvgnd_1
XFILLER_35_225 vssd1 vssd1 vccd1 vccd1 sky130_fd_sc_hd__fill_1
X_2911_ _1337_ _1361_ _1374_ vssd1 vssd1 vccd1 vccd1 _1376_ sky130_fd_sc_hd__a21o_1
X_2842_ net189 net198 net187 net201 vssd1 vssd1 vccd1 vccd1 _1310_ sky130_fd_sc_hd__a22oi_1
X_2773_ _1242_ _1243_ net590 net71 vssd1 vssd1 vccd1 vccd1 _0378_ sky130_fd_sc_hd__o2bb2a_1
X_1724_ net460 net33 net23 vssd1 vssd1 vccd1 vccd1 _0067_ sky130_fd_sc_hd__mux2_1
XFILLER_7_181 vccd1 vssd1 vccd1 vssd1 sky130_ef_sc_hd__decap_40_12
Xhold126 MATMULT_INST.matmult_inst.mem_inst.mem3\[15\] vssd1 vssd1 vccd1 vccd1 net439
+ sky130_fd_sc_hd__dlygate4sd3_1
Xhold104 MATMULT_INST.matmult_inst.alu_inst.out\[13\] vssd1 vssd1 vccd1 vccd1 net417
+ sky130_fd_sc_hd__dlygate4sd3_1
Xhold115 MATMULT_INST.matmult_inst.mem_inst.matrixB2\[0\] vssd1 vssd1 vccd1 vccd1
+ net428 sky130_fd_sc_hd__dlygate4sd3_1
Xhold159 MATMULT_INST.matmult_inst.mem_inst.matrixB2\[17\] vssd1 vssd1 vccd1 vccd1
+ net472 sky130_fd_sc_hd__dlygate4sd3_1
Xhold148 MATMULT_INST.matmult_inst.mem_inst.matrixA1\[4\] vssd1 vssd1 vccd1 vccd1
+ net461 sky130_fd_sc_hd__dlygate4sd3_1
Xhold137 MATMULT_INST.matmult_inst.mem_inst.matrixB0\[4\] vssd1 vssd1 vccd1 vccd1
+ net450 sky130_fd_sc_hd__dlygate4sd3_1
X_1655_ MATMULT_INST.matmult_inst.spi_inst.tx_reg_sys\[4\] MATMULT_INST.matmult_inst.spi_inst.miso_shifter\[3\]
+ net154 vssd1 vssd1 vccd1 vccd1 _0016_ sky130_fd_sc_hd__mux2_1
X_1586_ MATMULT_INST.matmult_inst.fsm_inst.state\[1\] MATMULT_INST.matmult_inst.fsm_inst.state\[0\]
+ vssd1 vssd1 vccd1 vccd1 _1504_ sky130_fd_sc_hd__nand2b_1
X_3325_ clknet_leaf_3_clk _0283_ net104 vssd1 vssd1 vccd1 vccd1 MATMULT_INST.matmult_inst.alu_inst.b1_reg\[7\]
+ sky130_fd_sc_hd__dfrtp_1
X_3256_ clknet_leaf_25_clk _0214_ net119 vssd1 vssd1 vccd1 vccd1 MATMULT_INST.matmult_inst.mem_inst.mem0\[9\]
+ sky130_fd_sc_hd__dfrtp_1
X_2207_ _0753_ _0754_ _0727_ vssd1 vssd1 vccd1 vccd1 _0756_ sky130_fd_sc_hd__a21bo_1
XANTENNA__3332__Q MATMULT_INST.matmult_inst.alu_inst.a1_reg\[4\] vssd1 vssd1 vccd1
+ vccd1 sky130_fd_sc_hd__diode_2
X_3187_ clknet_leaf_27_clk _0145_ net97 vssd1 vssd1 vccd1 vccd1 MATMULT_INST.matmult_inst.mem_inst.mem2\[12\]
+ sky130_fd_sc_hd__dfrtp_1
X_2138_ net234 net236 net221 net220 vssd1 vssd1 vccd1 vccd1 _0689_ sky130_fd_sc_hd__and4_1
XTAP_TAPCELL_ROW_49_592 vssd1 vccd1 sky130_fd_sc_hd__tapvpwrvgnd_1
X_2069_ _0621_ _0622_ vssd1 vssd1 vccd1 vccd1 _0623_ sky130_fd_sc_hd__or2_1
XANTENNA__2462__X _0977_ vssd1 vssd1 vccd1 vccd1 sky130_fd_sc_hd__diode_2
XANTENNA_fanout92_A _0479_ vssd1 vssd1 vccd1 vccd1 sky130_fd_sc_hd__diode_2
XFILLER_1_335 vssd1 vssd1 vccd1 vccd1 sky130_fd_sc_hd__fill_1
XFILLER_17_225 vssd1 vssd1 vccd1 vccd1 sky130_fd_sc_hd__fill_4
XANTENNA__1701__B net60 vssd1 vssd1 vccd1 vccd1 sky130_fd_sc_hd__diode_2
XFILLER_13_453 vssd1 vssd1 vccd1 vccd1 sky130_fd_sc_hd__fill_1
XTAP_TAPCELL_ROW_30_429 vssd1 vccd1 sky130_fd_sc_hd__tapvpwrvgnd_1
XANTENNA__1863__S net13 vssd1 vssd1 vccd1 vccd1 sky130_fd_sc_hd__diode_2
XFILLER_4_77 vssd1 vssd1 vccd1 vccd1 sky130_fd_sc_hd__fill_4
XFILLER_4_195 vssd1 vssd1 vccd1 vccd1 sky130_fd_sc_hd__fill_1
X_3110_ clknet_leaf_14_clk _0068_ net144 vssd1 vssd1 vccd1 vccd1 MATMULT_INST.matmult_inst.mem_inst.matrixA0\[7\]
+ sky130_fd_sc_hd__dfrtp_1
X_3041_ MATMULT_INST.matmult_inst.mem_inst.matrixA0\[15\] net64 _1459_ _1460_ vssd1
+ vssd1 vccd1 vccd1 _1461_ sky130_fd_sc_hd__a211o_1
XFILLER_67_169 vccd1 vssd1 vccd1 vssd1 sky130_ef_sc_hd__decap_40_12
XTAP_TAPCELL_ROW_46_562 vssd1 vccd1 sky130_fd_sc_hd__tapvpwrvgnd_1
X_2825_ _1287_ _1293_ vssd1 vssd1 vccd1 vccd1 _1294_ sky130_fd_sc_hd__xor2_1
X_2756_ _1224_ _1225_ vssd1 vssd1 vccd1 vccd1 _1227_ sky130_fd_sc_hd__or2_1
X_2687_ _1143_ _1144_ _1156_ vssd1 vssd1 vccd1 vccd1 _1160_ sky130_fd_sc_hd__o21ai_1
XANTENNA__1773__S net18 vssd1 vssd1 vccd1 vccd1 sky130_fd_sc_hd__diode_2
X_1707_ MATMULT_INST.matmult_inst.fsm_inst.alu_result\[14\] net60 vssd1 vssd1 vccd1
+ vccd1 _0499_ sky130_fd_sc_hd__and2_1
X_1638_ net162 _0464_ net59 _0461_ vssd1 vssd1 vccd1 vccd1 _0470_ sky130_fd_sc_hd__a22o_1
X_1569_ MATMULT_INST.matmult_inst.spi_inst.rx_bit_count\[2\] _1490_ vssd1 vssd1 vccd1
+ vccd1 _1492_ sky130_fd_sc_hd__or2_1
X_3308_ clknet_leaf_1_clk _0266_ net103 vssd1 vssd1 vccd1 vccd1 MATMULT_INST.matmult_inst.alu_inst.out\[8\]
+ sky130_fd_sc_hd__dfrtp_1
XANTENNA_fanout182_X net182 vssd1 vssd1 vccd1 vccd1 sky130_fd_sc_hd__diode_2
X_3239_ clknet_leaf_17_clk _0197_ net121 vssd1 vssd1 vccd1 vccd1 MATMULT_INST.matmult_inst.mem_inst.matrixB2\[10\]
+ sky130_fd_sc_hd__dfrtp_1
XFILLER_39_350 vssd1 vssd1 vccd1 vccd1 sky130_fd_sc_hd__fill_1
XFILLER_58_158 vssd1 vssd1 vccd1 vccd1 sky130_fd_sc_hd__fill_1
XFILLER_64_27 vssd1 vssd1 vccd1 vccd1 sky130_fd_sc_hd__fill_1
Xfanout10 _0518_ vssd1 vssd1 vccd1 vccd1 net10 sky130_fd_sc_hd__buf_4
Xfanout21 _0508_ vssd1 vssd1 vccd1 vccd1 net21 sky130_fd_sc_hd__clkbuf_4
XFILLER_10_401 vccd1 vssd1 vccd1 vssd1 sky130_ef_sc_hd__decap_40_12
Xfanout43 _0502_ vssd1 vssd1 vccd1 vccd1 net43 sky130_fd_sc_hd__clkbuf_2
Xfanout54 _0452_ vssd1 vssd1 vccd1 vccd1 net54 sky130_fd_sc_hd__clkbuf_4
Xfanout32 _0492_ vssd1 vssd1 vccd1 vccd1 net32 sky130_fd_sc_hd__clkbuf_2
Xfanout65 _0944_ vssd1 vssd1 vccd1 vccd1 net65 sky130_fd_sc_hd__clkbuf_4
Xfanout76 _1521_ vssd1 vssd1 vccd1 vccd1 net76 sky130_fd_sc_hd__clkbuf_2
XFILLER_13_42 vssd1 vssd1 vccd1 vccd1 sky130_fd_sc_hd__fill_1
XFILLER_13_31 vssd1 vssd1 vccd1 vccd1 sky130_fd_sc_hd__fill_2
Xfanout87 net88 vssd1 vssd1 vccd1 vccd1 net87 sky130_fd_sc_hd__clkbuf_4
Xfanout98 net99 vssd1 vssd1 vccd1 vccd1 net98 sky130_fd_sc_hd__buf_2
XFILLER_10_445 vccd1 vssd1 vccd1 vssd1 sky130_ef_sc_hd__decap_40_12
XFILLER_13_86 vssd1 vssd1 vccd1 vccd1 sky130_fd_sc_hd__fill_1
XFILLER_10_489 vssd1 vssd1 vccd1 vccd1 sky130_fd_sc_hd__fill_4
XFILLER_1_165 vssd1 vssd1 vccd1 vccd1 sky130_fd_sc_hd__fill_2
XFILLER_77_489 vssd1 vssd1 vccd1 vccd1 sky130_fd_sc_hd__fill_2
XFILLER_49_169 vssd1 vssd1 vccd1 vccd1 sky130_fd_sc_hd__fill_4
XANTENNA__1638__A1 net162 vssd1 vssd1 vccd1 vccd1 sky130_fd_sc_hd__diode_2
XANTENNA__1858__S net13 vssd1 vssd1 vccd1 vccd1 sky130_fd_sc_hd__diode_2
XFILLER_13_261 vccd1 vssd1 vccd1 vssd1 sky130_ef_sc_hd__decap_40_12
XFILLER_20_209 vccd1 vssd1 vccd1 vssd1 sky130_ef_sc_hd__decap_40_12
XFILLER_9_221 vssd1 vssd1 vccd1 vccd1 sky130_fd_sc_hd__fill_2
Xclkload24 clknet_leaf_12_clk vssd1 vssd1 vccd1 vccd1 clkload24/X sky130_fd_sc_hd__clkbuf_4
XANTENNA__3012__B1 net79 vssd1 vssd1 vccd1 vccd1 sky130_fd_sc_hd__diode_2
Xclkload13 clknet_leaf_18_clk vssd1 vssd1 vccd1 vccd1 clkload13/Y sky130_fd_sc_hd__bufinv_16
X_2610_ _1079_ _1085_ vssd1 vssd1 vccd1 vccd1 _1086_ sky130_fd_sc_hd__xnor2_1
X_2541_ _1502_ _0459_ _1041_ vssd1 vssd1 vccd1 vccd1 _1042_ sky130_fd_sc_hd__a21oi_1
X_2472_ net163 _0984_ _0985_ net93 vssd1 vssd1 vccd1 vccd1 _0986_ sky130_fd_sc_hd__a22o_1
XFILLER_48_3 vssd1 vssd1 vccd1 vccd1 sky130_fd_sc_hd__fill_4
XFILLER_68_434 vssd1 vssd1 vccd1 vccd1 sky130_fd_sc_hd__fill_1
X_3024_ net176 net167 MATMULT_INST.matmult_inst.mem_inst.mem3\[14\] vssd1 vssd1 vccd1
+ vccd1 _1445_ sky130_fd_sc_hd__and3_1
XFILLER_36_397 vssd1 vssd1 vccd1 vccd1 sky130_fd_sc_hd__fill_1
XANTENNA_fanout142_A net151 vssd1 vssd1 vccd1 vccd1 sky130_fd_sc_hd__diode_2
XANTENNA__1768__S net18 vssd1 vssd1 vccd1 vccd1 sky130_fd_sc_hd__diode_2
Xclkload7 clknet_leaf_30_clk vssd1 vssd1 vccd1 vccd1 clkload7/Y sky130_fd_sc_hd__clkinv_8
XFILLER_50_29 vssd1 vssd1 vccd1 vccd1 sky130_fd_sc_hd__fill_1
X_2808_ _1217_ _1274_ _1275_ _1277_ vssd1 vssd1 vccd1 vccd1 _1278_ sky130_fd_sc_hd__and4_1
X_2739_ _1208_ _1209_ vssd1 vssd1 vccd1 vccd1 _1210_ sky130_fd_sc_hd__xnor2_1
XANTENNA__2109__A2 net218 vssd1 vssd1 vccd1 vccd1 sky130_fd_sc_hd__diode_2
XFILLER_59_38 vssd1 vssd1 vccd1 vccd1 sky130_fd_sc_hd__fill_1
Xfanout200 net201 vssd1 vssd1 vccd1 vccd1 net200 sky130_fd_sc_hd__buf_2
Xfanout211 MATMULT_INST.matmult_inst.alu_inst.b1_reg\[1\] vssd1 vssd1 vccd1 vccd1
+ net211 sky130_fd_sc_hd__clkbuf_2
XTAP_TAPCELL_ROW_6_224 vssd1 vccd1 sky130_fd_sc_hd__tapvpwrvgnd_1
Xfanout222 MATMULT_INST.matmult_inst.alu_inst.a0_reg\[2\] vssd1 vssd1 vccd1 vccd1
+ net222 sky130_fd_sc_hd__buf_2
Xfanout244 net245 vssd1 vssd1 vccd1 vccd1 net244 sky130_fd_sc_hd__buf_4
Xfanout233 MATMULT_INST.matmult_inst.alu_inst.b0_reg\[4\] vssd1 vssd1 vccd1 vccd1
+ net233 sky130_fd_sc_hd__buf_2
XFILLER_75_59 vssd1 vssd1 vccd1 vccd1 sky130_fd_sc_hd__fill_1
XFILLER_75_48 vssd1 vssd1 vccd1 vccd1 sky130_fd_sc_hd__fill_8
XFILLER_46_139 vssd1 vssd1 vccd1 vccd1 sky130_fd_sc_hd__fill_1
XTAP_TAPCELL_ROW_57_657 vssd1 vccd1 sky130_fd_sc_hd__tapvpwrvgnd_1
XANTENNA_fanout55_A _0452_ vssd1 vssd1 vccd1 vccd1 sky130_fd_sc_hd__diode_2
XFILLER_54_194 vssd1 vssd1 vccd1 vccd1 sky130_fd_sc_hd__fill_2
XTAP_TAPCELL_ROW_40_513 vssd1 vccd1 sky130_fd_sc_hd__tapvpwrvgnd_1
XFILLER_10_253 vccd1 vssd1 vccd1 vssd1 sky130_ef_sc_hd__decap_40_12
XANTENNA_fanout10_X net10 vssd1 vssd1 vccd1 vccd1 sky130_fd_sc_hd__diode_2
XANTENNA__3492__CLK net246 vssd1 vssd1 vccd1 vccd1 sky130_fd_sc_hd__diode_2
XFILLER_60_164 vssd1 vssd1 vccd1 vccd1 sky130_fd_sc_hd__fill_2
X_1972_ MATMULT_INST.matmult_inst.alu_inst.adder_inst.r1.fa3.b MATMULT_INST.matmult_inst.alu_inst.adder_inst.r1.fa3.a
+ vssd1 vssd1 vccd1 vccd1 _0556_ sky130_fd_sc_hd__or2_1
XANTENNA__2720__B net184 vssd1 vssd1 vccd1 vccd1 sky130_fd_sc_hd__diode_2
XPHY_EDGE_ROW_49_Right_49 vssd1 vssd1 vccd1 vccd1 sky130_fd_sc_hd__decap_3
X_2524_ net599 _0954_ _1033_ net66 vssd1 vssd1 vccd1 vccd1 _0339_ sky130_fd_sc_hd__a22o_1
X_2455_ MATMULT_INST.matmult_inst.mem_inst.matrixA0\[2\] net65 _0969_ net93 vssd1
+ vssd1 vccd1 vccd1 _0970_ sky130_fd_sc_hd__a22o_1
Xhold19 MATMULT_INST.matmult_inst.spi_inst.rx_done2 vssd1 vssd1 vccd1 vccd1 net332
+ sky130_fd_sc_hd__dlygate4sd3_1
X_2386_ net458 net63 net42 net429 vssd1 vssd1 vccd1 vccd1 _0311_ sky130_fd_sc_hd__a22o_1
XFILLER_56_459 vssd1 vssd1 vccd1 vccd1 sky130_fd_sc_hd__fill_1
XPHY_EDGE_ROW_58_Right_58 vssd1 vssd1 vccd1 vccd1 sky130_fd_sc_hd__decap_3
X_3007_ net165 _1425_ _1429_ net160 vssd1 vssd1 vccd1 vccd1 _1430_ sky130_fd_sc_hd__a22o_1
XFILLER_43_109 vssd1 vssd1 vccd1 vccd1 sky130_fd_sc_hd__fill_2
XTAP_TAPCELL_ROW_54_627 vssd1 vccd1 sky130_fd_sc_hd__tapvpwrvgnd_1
XPHY_EDGE_ROW_67_Right_67 vssd1 vssd1 vccd1 vccd1 sky130_fd_sc_hd__decap_3
XFILLER_3_205 vccd1 vssd1 vccd1 vssd1 sky130_ef_sc_hd__decap_40_12
XFILLER_3_249 vccd1 vssd1 vccd1 vssd1 sky130_ef_sc_hd__decap_40_12
XFILLER_10_65 vccd1 vssd1 vccd1 vssd1 sky130_ef_sc_hd__decap_40_12
XANTENNA__2502__A2 net90 vssd1 vssd1 vccd1 vccd1 sky130_fd_sc_hd__diode_2
XPHY_EDGE_ROW_76_Right_76 vssd1 vssd1 vccd1 vccd1 sky130_fd_sc_hd__decap_3
XANTENNA__2358__A net228 vssd1 vssd1 vccd1 vccd1 sky130_fd_sc_hd__diode_2
XANTENNA_fanout58_X net58 vssd1 vssd1 vccd1 vccd1 sky130_fd_sc_hd__diode_2
XFILLER_19_139 vssd1 vssd1 vccd1 vccd1 sky130_fd_sc_hd__fill_2
XFILLER_74_278 vccd1 vssd1 vccd1 vssd1 sky130_ef_sc_hd__decap_40_12
XTAP_TAPCELL_ROW_17_318 vssd1 vccd1 sky130_fd_sc_hd__tapvpwrvgnd_1
XFILLER_35_51 vssd1 vssd1 vccd1 vccd1 sky130_fd_sc_hd__fill_2
XFILLER_35_73 vssd1 vssd1 vccd1 vccd1 sky130_fd_sc_hd__fill_1
XTAP_TAPCELL_ROW_25_384 vssd1 vccd1 sky130_fd_sc_hd__tapvpwrvgnd_1
XFILLER_42_197 vssd1 vssd1 vccd1 vccd1 sky130_fd_sc_hd__fill_4
XFILLER_51_61 vssd1 vssd1 vccd1 vccd1 sky130_fd_sc_hd__fill_2
XANTENNA__2821__A net187 vssd1 vssd1 vccd1 vccd1 sky130_fd_sc_hd__diode_2
XANTENNA__1871__S net12 vssd1 vssd1 vccd1 vccd1 sky130_fd_sc_hd__diode_2
X_2240_ net227 net229 net222 net219 vssd1 vssd1 vccd1 vccd1 _0788_ sky130_fd_sc_hd__and4_1
X_2171_ _0716_ _0719_ vssd1 vssd1 vccd1 vccd1 _0721_ sky130_fd_sc_hd__or2_1
XTAP_TAPCELL_ROW_51_608 vssd1 vccd1 sky130_fd_sc_hd__tapvpwrvgnd_1
XFILLER_61_462 vssd1 vssd1 vccd1 vccd1 sky130_fd_sc_hd__fill_1
X_1955_ _0533_ _0541_ vssd1 vssd1 vccd1 vccd1 _0542_ sky130_fd_sc_hd__or2_1
X_1886_ net615 net49 net10 vssd1 vssd1 vccd1 vccd1 _0216_ sky130_fd_sc_hd__mux2_1
XANTENNA__2980__A2 net64 vssd1 vssd1 vccd1 vccd1 sky130_fd_sc_hd__diode_2
XANTENNA_fanout105_A net114 vssd1 vssd1 vccd1 vccd1 sky130_fd_sc_hd__diode_2
XANTENNA__1781__S net31 vssd1 vssd1 vccd1 vccd1 sky130_fd_sc_hd__diode_2
X_2507_ net182 net174 MATMULT_INST.matmult_inst.mem_inst.matrixA3\[6\] vssd1 vssd1
+ vccd1 vccd1 _1018_ sky130_fd_sc_hd__and3_1
X_3487_ clknet_leaf_11_clk net325 net147 vssd1 vssd1 vccd1 vccd1 MATMULT_INST.matmult_inst.fsm_inst.rx_data\[5\]
+ sky130_fd_sc_hd__dfrtp_1
X_2438_ net66 _0952_ _0954_ net395 vssd1 vssd1 vccd1 vccd1 _0332_ sky130_fd_sc_hd__a22o_1
Xteam_02_305 vssd1 vssd1 vccd1 vccd1 gpio_oeb[25] team_02_305/LO sky130_fd_sc_hd__conb_1
X_2369_ _0911_ _0912_ vssd1 vssd1 vccd1 vccd1 _0913_ sky130_fd_sc_hd__xnor2_1
XTAP_TAPCELL_ROW_67_741 vssd1 vccd1 sky130_fd_sc_hd__tapvpwrvgnd_1
XANTENNA_fanout18_A net19 vssd1 vssd1 vccd1 vccd1 sky130_fd_sc_hd__diode_2
XFILLER_21_42 vssd1 vssd1 vccd1 vccd1 sky130_fd_sc_hd__fill_4
XFILLER_21_64 vssd1 vssd1 vccd1 vccd1 sky130_fd_sc_hd__fill_4
XFILLER_79_337 vssd1 vssd1 vccd1 vccd1 sky130_fd_sc_hd__fill_4
XFILLER_79_326 vssd1 vssd1 vccd1 vccd1 sky130_fd_sc_hd__fill_8
XANTENNA__2088__A net239 vssd1 vssd1 vccd1 vccd1 sky130_fd_sc_hd__diode_2
Xmax_cap40 _1052_ vssd1 vssd1 vccd1 vccd1 net40 sky130_fd_sc_hd__clkbuf_2
XFILLER_46_94 vssd1 vssd1 vccd1 vccd1 sky130_fd_sc_hd__fill_8
XFILLER_15_164 vssd1 vssd1 vccd1 vccd1 sky130_fd_sc_hd__fill_4
XFILLER_30_156 vssd1 vssd1 vccd1 vccd1 sky130_fd_sc_hd__fill_2
XANTENNA__1866__S net12 vssd1 vssd1 vccd1 vccd1 sky130_fd_sc_hd__diode_2
XFILLER_7_55 vssd1 vssd1 vccd1 vccd1 sky130_fd_sc_hd__fill_1
X_1740_ net469 net38 net20 vssd1 vssd1 vccd1 vccd1 _0080_ sky130_fd_sc_hd__mux2_1
Xhold308 MATMULT_INST.matmult_inst.alu_inst.col0\[1\] vssd1 vssd1 vccd1 vccd1 net621
+ sky130_fd_sc_hd__dlygate4sd3_1
X_1671_ MATMULT_INST.matmult_inst.alu_inst.state\[1\] MATMULT_INST.matmult_inst.alu_inst.state\[0\]
+ vssd1 vssd1 vccd1 vccd1 _0453_ sky130_fd_sc_hd__and2b_1
XFILLER_7_385 vssd1 vssd1 vccd1 vccd1 sky130_fd_sc_hd__fill_4
Xhold319 MATMULT_INST.matmult_inst.mem_inst.mem0\[15\] vssd1 vssd1 vccd1 vccd1 net632
+ sky130_fd_sc_hd__dlygate4sd3_1
X_3410_ clknet_leaf_26_clk _0363_ net99 vssd1 vssd1 vccd1 vccd1 MATMULT_INST.matmult_inst.alu_inst.row0\[3\]
+ sky130_fd_sc_hd__dfrtp_1
XANTENNA__2175__B1 net230 vssd1 vssd1 vccd1 vccd1 sky130_fd_sc_hd__diode_2
X_3341_ clknet_leaf_1_clk _0296_ vssd1 vssd1 vccd1 vccd1 MATMULT_INST.matmult_inst.alu_inst.adder_inst.r1.fa0.a
+ sky130_fd_sc_hd__dfxtp_1
X_3272_ clknet_leaf_13_clk _0230_ net145 vssd1 vssd1 vccd1 vccd1 MATMULT_INST.matmult_inst.mem_inst.matrixA1\[7\]
+ sky130_fd_sc_hd__dfrtp_1
X_2223_ _0769_ _0770_ _0771_ vssd1 vssd1 vccd1 vccd1 _0772_ sky130_fd_sc_hd__nand3_1
X_2154_ _0673_ _0704_ vssd1 vssd1 vccd1 vccd1 _0705_ sky130_fd_sc_hd__xnor2_1
X_2085_ _0636_ _0637_ _0624_ vssd1 vssd1 vccd1 vccd1 _0638_ sky130_fd_sc_hd__a21oi_1
XTAP_TAPCELL_ROW_36_479 vssd1 vccd1 sky130_fd_sc_hd__tapvpwrvgnd_1
XANTENNA__1776__S net18 vssd1 vssd1 vccd1 vccd1 sky130_fd_sc_hd__diode_2
X_2987_ net399 _1411_ net57 vssd1 vssd1 vccd1 vccd1 _0444_ sky130_fd_sc_hd__mux2_1
X_1938_ MATMULT_INST.matmult_inst.alu_inst.adder_inst.r0.fa2.b MATMULT_INST.matmult_inst.alu_inst.adder_inst.r0.fa2.a
+ vssd1 vssd1 vccd1 vccd1 _0527_ sky130_fd_sc_hd__nor2_1
X_1869_ net571 net47 net12 vssd1 vssd1 vccd1 vccd1 _0200_ sky130_fd_sc_hd__mux2_1
XFILLER_29_223 vssd1 vssd1 vccd1 vccd1 sky130_fd_sc_hd__fill_1
XTAP_TAPCELL_ROW_27_402 vssd1 vccd1 sky130_fd_sc_hd__tapvpwrvgnd_1
XFILLER_16_64 vssd1 vssd1 vccd1 vccd1 sky130_fd_sc_hd__fill_1
XTAP_TAPCELL_ROW_70_769 vssd1 vccd1 sky130_fd_sc_hd__tapvpwrvgnd_1
XANTENNA__1686__S net25 vssd1 vssd1 vccd1 vccd1 sky130_fd_sc_hd__diode_2
XFILLER_12_189 vssd1 vssd1 vccd1 vccd1 sky130_fd_sc_hd__fill_4
XFILLER_32_41 vccd1 vssd1 vccd1 vssd1 sky130_ef_sc_hd__decap_40_12
XFILLER_4_333 vccd1 vssd1 vccd1 vssd1 sky130_ef_sc_hd__decap_40_12
XPHY_EDGE_ROW_26_Left_106 vssd1 vssd1 vccd1 vccd1 sky130_fd_sc_hd__decap_3
XFILLER_4_377 vccd1 vssd1 vccd1 vssd1 sky130_ef_sc_hd__decap_40_12
XANTENNA__1715__A net162 vssd1 vssd1 vccd1 vccd1 sky130_fd_sc_hd__diode_2
XFILLER_79_189 vssd1 vssd1 vccd1 vccd1 sky130_fd_sc_hd__fill_1
XFILLER_79_167 vssd1 vssd1 vccd1 vccd1 sky130_fd_sc_hd__fill_1
XTAP_TAPCELL_ROW_78_836 vssd1 vccd1 sky130_fd_sc_hd__tapvpwrvgnd_1
XFILLER_75_351 vccd1 vssd1 vccd1 vssd1 sky130_ef_sc_hd__decap_40_12
XFILLER_35_204 vssd1 vssd1 vccd1 vccd1 sky130_fd_sc_hd__fill_1
XPHY_EDGE_ROW_35_Left_115 vssd1 vssd1 vccd1 vccd1 sky130_fd_sc_hd__decap_3
XANTENNA_clkload0_A clknet_2_0__leaf_clk vssd1 vssd1 vccd1 vccd1 sky130_fd_sc_hd__diode_2
XANTENNA__3426__CLK clknet_2_1__leaf_clk vssd1 vssd1 vccd1 vccd1 sky130_fd_sc_hd__diode_2
XANTENNA__1683__A2 net59 vssd1 vssd1 vccd1 vccd1 sky130_fd_sc_hd__diode_2
X_2910_ _1337_ _1361_ _1374_ vssd1 vssd1 vccd1 vccd1 _1375_ sky130_fd_sc_hd__and3_1
XTAP_TAPCELL_ROW_33_449 vssd1 vccd1 sky130_fd_sc_hd__tapvpwrvgnd_1
X_2841_ net358 _1309_ net70 vssd1 vssd1 vccd1 vccd1 _0380_ sky130_fd_sc_hd__mux2_1
XFILLER_78_3 vccd1 vssd1 vccd1 vssd1 sky130_ef_sc_hd__decap_40_12
X_2772_ _1207_ _1239_ net71 vssd1 vssd1 vccd1 vccd1 _1243_ sky130_fd_sc_hd__o21a_1
X_1723_ net444 net34 net23 vssd1 vssd1 vccd1 vccd1 _0066_ sky130_fd_sc_hd__mux2_1
XFILLER_7_193 vccd1 vssd1 vccd1 vssd1 sky130_ef_sc_hd__decap_40_12
Xhold105 _0322_ vssd1 vssd1 vccd1 vccd1 net418 sky130_fd_sc_hd__dlygate4sd3_1
XPHY_EDGE_ROW_44_Left_124 vssd1 vssd1 vccd1 vccd1 sky130_fd_sc_hd__decap_3
Xhold116 MATMULT_INST.matmult_inst.fsm_inst.alu_result\[2\] vssd1 vssd1 vccd1 vccd1
+ net429 sky130_fd_sc_hd__dlygate4sd3_1
Xhold127 MATMULT_INST.matmult_inst.alu_inst.a1_reg\[0\] vssd1 vssd1 vccd1 vccd1 net440
+ sky130_fd_sc_hd__dlygate4sd3_1
X_1654_ MATMULT_INST.matmult_inst.spi_inst.tx_reg_sys\[3\] MATMULT_INST.matmult_inst.spi_inst.miso_shifter\[2\]
+ net154 vssd1 vssd1 vccd1 vccd1 _0015_ sky130_fd_sc_hd__mux2_1
Xhold149 MATMULT_INST.matmult_inst.alu_inst.row1\[7\] vssd1 vssd1 vccd1 vccd1 net462
+ sky130_fd_sc_hd__dlygate4sd3_1
Xhold138 MATMULT_INST.matmult_inst.mem_inst.matrixA1\[3\] vssd1 vssd1 vccd1 vccd1
+ net451 sky130_fd_sc_hd__dlygate4sd3_1
X_1585_ net641 net316 vssd1 vssd1 vccd1 vccd1 _0004_ sky130_fd_sc_hd__and2b_1
X_3324_ clknet_leaf_2_clk _0282_ net105 vssd1 vssd1 vccd1 vccd1 MATMULT_INST.matmult_inst.alu_inst.b1_reg\[6\]
+ sky130_fd_sc_hd__dfrtp_1
X_3255_ clknet_leaf_18_clk _0213_ net131 vssd1 vssd1 vccd1 vccd1 MATMULT_INST.matmult_inst.mem_inst.mem0\[8\]
+ sky130_fd_sc_hd__dfrtp_1
XFILLER_58_307 vssd1 vssd1 vccd1 vccd1 sky130_fd_sc_hd__fill_1
XANTENNA__2159__C net222 vssd1 vssd1 vccd1 vccd1 sky130_fd_sc_hd__diode_2
X_2206_ _0727_ _0752_ _0754_ vssd1 vssd1 vccd1 vccd1 _0755_ sky130_fd_sc_hd__or3b_1
X_3186_ clknet_leaf_19_clk _0144_ net130 vssd1 vssd1 vccd1 vccd1 MATMULT_INST.matmult_inst.mem_inst.mem2\[11\]
+ sky130_fd_sc_hd__dfrtp_1
XPHY_EDGE_ROW_53_Left_133 vssd1 vssd1 vccd1 vccd1 sky130_fd_sc_hd__decap_3
X_2137_ net234 net221 net219 net236 vssd1 vssd1 vccd1 vccd1 _0688_ sky130_fd_sc_hd__a22oi_1
XANTENNA__2456__A net181 vssd1 vssd1 vccd1 vccd1 sky130_fd_sc_hd__diode_2
X_2068_ net239 net241 net221 net220 vssd1 vssd1 vccd1 vccd1 _0622_ sky130_fd_sc_hd__and4_1
XANTENNA__2623__A1 net210 vssd1 vssd1 vccd1 vccd1 sky130_fd_sc_hd__diode_2
XFILLER_22_421 vssd1 vssd1 vccd1 vccd1 sky130_fd_sc_hd__fill_1
XPHY_EDGE_ROW_62_Left_142 vssd1 vssd1 vccd1 vccd1 sky130_fd_sc_hd__decap_3
XFILLER_78_15 vccd1 vssd1 vccd1 vssd1 sky130_ef_sc_hd__decap_40_12
XANTENNA_fanout85_A net88 vssd1 vssd1 vccd1 vccd1 sky130_fd_sc_hd__diode_2
XPHY_EDGE_ROW_71_Left_151 vssd1 vssd1 vccd1 vccd1 sky130_fd_sc_hd__decap_3
XTAP_TAPCELL_ROW_75_806 vssd1 vccd1 sky130_fd_sc_hd__tapvpwrvgnd_1
XFILLER_40_240 vssd1 vssd1 vccd1 vccd1 sky130_fd_sc_hd__fill_1
XFILLER_9_447 vssd1 vssd1 vccd1 vccd1 sky130_fd_sc_hd__fill_1
XFILLER_4_141 vccd1 vssd1 vccd1 vssd1 sky130_ef_sc_hd__decap_40_12
XANTENNA__2040__S net55 vssd1 vssd1 vccd1 vccd1 sky130_fd_sc_hd__diode_2
XFILLER_68_81 vssd1 vssd1 vccd1 vccd1 sky130_fd_sc_hd__fill_2
XFILLER_0_391 vssd1 vssd1 vccd1 vccd1 sky130_fd_sc_hd__fill_1
XFILLER_67_137 vssd1 vssd1 vccd1 vccd1 sky130_fd_sc_hd__fill_8
X_3040_ net161 _1454_ _1456_ net156 vssd1 vssd1 vccd1 vccd1 _1460_ sky130_fd_sc_hd__a22o_1
XTAP_TAPCELL_ROW_46_563 vssd1 vccd1 sky130_fd_sc_hd__tapvpwrvgnd_1
X_2824_ _1291_ _1292_ vssd1 vssd1 vccd1 vccd1 _1293_ sky130_fd_sc_hd__xor2_1
X_2755_ _1222_ _1223_ _1218_ vssd1 vssd1 vccd1 vccd1 _1226_ sky130_fd_sc_hd__a21o_1
X_1706_ net495 _0498_ net24 vssd1 vssd1 vccd1 vccd1 _0056_ sky130_fd_sc_hd__mux2_1
X_2686_ _1143_ _1144_ _1156_ vssd1 vssd1 vccd1 vccd1 _1159_ sky130_fd_sc_hd__or3_1
X_1637_ MATMULT_INST.matmult_inst.fsm_inst.count\[1\] MATMULT_INST.matmult_inst.fsm_inst.count\[0\]
+ vssd1 vssd1 vccd1 vccd1 _0469_ sky130_fd_sc_hd__and2b_1
X_1568_ MATMULT_INST.matmult_inst.cs _1488_ vssd1 vssd1 vccd1 vccd1 _0390_ sky130_fd_sc_hd__nor2_1
XFILLER_48_29 vssd1 vssd1 vccd1 vccd1 sky130_fd_sc_hd__fill_1
X_3307_ clknet_leaf_1_clk _0265_ net108 vssd1 vssd1 vccd1 vccd1 MATMULT_INST.matmult_inst.alu_inst.out\[7\]
+ sky130_fd_sc_hd__dfrtp_1
X_3238_ clknet_leaf_25_clk _0196_ net101 vssd1 vssd1 vccd1 vccd1 MATMULT_INST.matmult_inst.mem_inst.matrixB2\[9\]
+ sky130_fd_sc_hd__dfrtp_1
X_3169_ clknet_leaf_27_clk _0127_ net97 vssd1 vssd1 vccd1 vccd1 MATMULT_INST.matmult_inst.mem_inst.matrixB1\[12\]
+ sky130_fd_sc_hd__dfrtp_1
XTAP_TAPCELL_ROW_1_177 vssd1 vccd1 sky130_fd_sc_hd__tapvpwrvgnd_1
XANTENNA__2473__X _0987_ vssd1 vssd1 vccd1 vccd1 sky130_fd_sc_hd__diode_2
Xfanout22 _0505_ vssd1 vssd1 vccd1 vccd1 net22 sky130_fd_sc_hd__buf_4
Xfanout11 _0518_ vssd1 vssd1 vccd1 vccd1 net11 sky130_fd_sc_hd__clkbuf_4
Xfanout33 _0491_ vssd1 vssd1 vccd1 vccd1 net33 sky130_fd_sc_hd__clkbuf_2
Xfanout44 _0501_ vssd1 vssd1 vccd1 vccd1 net44 sky130_fd_sc_hd__clkbuf_2
Xfanout55 _0452_ vssd1 vssd1 vccd1 vccd1 net55 sky130_fd_sc_hd__clkbuf_4
Xfanout66 _0927_ vssd1 vssd1 vccd1 vccd1 net66 sky130_fd_sc_hd__clkbuf_4
XFILLER_10_413 vssd1 vssd1 vccd1 vccd1 sky130_fd_sc_hd__fill_4
Xfanout99 net152 vssd1 vssd1 vccd1 vccd1 net99 sky130_fd_sc_hd__clkbuf_2
Xfanout77 net80 vssd1 vssd1 vccd1 vccd1 net77 sky130_fd_sc_hd__clkbuf_4
Xfanout88 _0506_ vssd1 vssd1 vccd1 vccd1 net88 sky130_fd_sc_hd__clkbuf_2
XFILLER_13_54 vssd1 vssd1 vccd1 vccd1 sky130_fd_sc_hd__fill_2
XFILLER_10_457 vccd1 vssd1 vccd1 vssd1 sky130_ef_sc_hd__decap_40_12
XFILLER_6_417 vssd1 vssd1 vccd1 vccd1 sky130_fd_sc_hd__fill_2
XANTENNA__3021__A1 net155 vssd1 vssd1 vccd1 vccd1 sky130_fd_sc_hd__diode_2
XANTENNA__3021__B2 net161 vssd1 vssd1 vccd1 vccd1 sky130_fd_sc_hd__diode_2
XFILLER_8_3 vccd1 vssd1 vccd1 vssd1 sky130_ef_sc_hd__decap_40_12
XFILLER_1_111 vssd1 vssd1 vccd1 vccd1 sky130_fd_sc_hd__fill_1
XANTENNA_fanout88_X net88 vssd1 vssd1 vccd1 vccd1 sky130_fd_sc_hd__diode_2
XANTENNA__2532__A0 _1011_ vssd1 vssd1 vccd1 vccd1 sky130_fd_sc_hd__diode_2
XFILLER_77_446 vssd1 vssd1 vccd1 vccd1 sky130_fd_sc_hd__fill_2
XFILLER_38_62 vssd1 vssd1 vccd1 vccd1 sky130_fd_sc_hd__fill_4
XFILLER_38_73 vssd1 vssd1 vccd1 vccd1 sky130_fd_sc_hd__fill_2
XFILLER_57_192 vssd1 vssd1 vccd1 vccd1 sky130_fd_sc_hd__fill_1
XFILLER_72_151 vssd1 vssd1 vccd1 vccd1 sky130_fd_sc_hd__fill_2
XFILLER_72_195 vssd1 vssd1 vccd1 vccd1 sky130_fd_sc_hd__fill_1
XFILLER_54_61 vssd1 vssd1 vccd1 vccd1 sky130_fd_sc_hd__fill_2
XFILLER_54_83 vssd1 vssd1 vccd1 vccd1 sky130_fd_sc_hd__fill_1
XANTENNA__2035__S net55 vssd1 vssd1 vccd1 vccd1 sky130_fd_sc_hd__diode_2
XFILLER_13_273 vssd1 vssd1 vccd1 vccd1 sky130_fd_sc_hd__fill_4
XFILLER_9_277 vssd1 vssd1 vccd1 vccd1 sky130_fd_sc_hd__fill_2
Xclkload14 clknet_leaf_19_clk vssd1 vssd1 vccd1 vccd1 clkload14/Y sky130_fd_sc_hd__inv_8
Xclkload25 clknet_leaf_13_clk vssd1 vssd1 vccd1 vccd1 clkload25/Y sky130_fd_sc_hd__bufinv_16
X_2540_ _1535_ _0924_ vssd1 vssd1 vccd1 vccd1 _1041_ sky130_fd_sc_hd__nand2_1
XFILLER_5_461 vccd1 vssd1 vccd1 vssd1 sky130_ef_sc_hd__decap_40_12
X_2471_ net158 MATMULT_INST.matmult_inst.mem_inst.mem0\[3\] MATMULT_INST.matmult_inst.mem_inst.matrixB0\[3\]
+ net162 vssd1 vssd1 vccd1 vccd1 _0985_ sky130_fd_sc_hd__a22o_1
X_3023_ MATMULT_INST.matmult_inst.mem_inst.matrixB2\[14\] net85 net77 MATMULT_INST.matmult_inst.mem_inst.matrixB1\[14\]
+ _1443_ vssd1 vssd1 vccd1 vccd1 _1444_ sky130_fd_sc_hd__a221o_1
XFILLER_51_335 vssd1 vssd1 vccd1 vccd1 sky130_fd_sc_hd__fill_1
XANTENNA__2054__A2 net67 vssd1 vssd1 vccd1 vccd1 sky130_fd_sc_hd__diode_2
XTAP_TAPCELL_ROW_14_290 vssd1 vccd1 sky130_fd_sc_hd__tapvpwrvgnd_1
Xclkload8 clknet_leaf_2_clk vssd1 vssd1 vccd1 vccd1 clkload8/Y sky130_fd_sc_hd__clkinv_2
XANTENNA_fanout135_A net142 vssd1 vssd1 vccd1 vccd1 sky130_fd_sc_hd__diode_2
XANTENNA__1784__S net30 vssd1 vssd1 vccd1 vccd1 sky130_fd_sc_hd__diode_2
X_2807_ _1213_ _1214_ _1215_ _1234_ vssd1 vssd1 vccd1 vccd1 _1277_ sky130_fd_sc_hd__a31o_1
X_2738_ net212 MATMULT_INST.matmult_inst.alu_inst.a1_reg\[7\] _1193_ _1194_ net186
+ vssd1 vssd1 vccd1 vccd1 _1209_ sky130_fd_sc_hd__a32oi_2
X_2669_ _1139_ _1140_ _1109_ vssd1 vssd1 vccd1 vccd1 _1142_ sky130_fd_sc_hd__a21o_1
XFILLER_59_28 vssd1 vssd1 vccd1 vccd1 sky130_fd_sc_hd__fill_1
XTAP_TAPCELL_ROW_6_225 vssd1 vccd1 sky130_fd_sc_hd__tapvpwrvgnd_1
Xfanout223 MATMULT_INST.matmult_inst.alu_inst.a0_reg\[1\] vssd1 vssd1 vccd1 vccd1
+ net223 sky130_fd_sc_hd__buf_2
Xfanout201 MATMULT_INST.matmult_inst.alu_inst.b1_reg\[6\] vssd1 vssd1 vccd1 vccd1
+ net201 sky130_fd_sc_hd__buf_2
Xfanout212 MATMULT_INST.matmult_inst.alu_inst.b1_reg\[0\] vssd1 vssd1 vccd1 vccd1
+ net212 sky130_fd_sc_hd__buf_2
Xfanout245 net246 vssd1 vssd1 vccd1 vccd1 net245 sky130_fd_sc_hd__buf_4
Xfanout234 MATMULT_INST.matmult_inst.alu_inst.b0_reg\[4\] vssd1 vssd1 vccd1 vccd1
+ net234 sky130_fd_sc_hd__clkbuf_2
XTAP_TAPCELL_ROW_57_658 vssd1 vccd1 sky130_fd_sc_hd__tapvpwrvgnd_1
XFILLER_54_162 vssd1 vssd1 vccd1 vccd1 sky130_fd_sc_hd__fill_2
XTAP_TAPCELL_ROW_40_514 vssd1 vccd1 sky130_fd_sc_hd__tapvpwrvgnd_1
XFILLER_10_221 vccd1 vssd1 vccd1 vssd1 sky130_ef_sc_hd__decap_40_12
XANTENNA__1694__S net25 vssd1 vssd1 vccd1 vccd1 sky130_fd_sc_hd__diode_2
XFILLER_10_265 vccd1 vssd1 vccd1 vssd1 sky130_ef_sc_hd__decap_40_12
XFILLER_40_41 vssd1 vssd1 vccd1 vccd1 sky130_fd_sc_hd__fill_2
XANTENNA__1707__B net60 vssd1 vssd1 vccd1 vccd1 sky130_fd_sc_hd__diode_2
XFILLER_2_475 vssd1 vssd1 vccd1 vccd1 sky130_fd_sc_hd__fill_1
XFILLER_77_221 vssd1 vssd1 vccd1 vccd1 sky130_fd_sc_hd__fill_2
XFILLER_77_287 vssd1 vssd1 vccd1 vccd1 sky130_fd_sc_hd__fill_1
XFILLER_65_438 vssd1 vssd1 vccd1 vccd1 sky130_fd_sc_hd__fill_1
XFILLER_1_57 vccd1 vssd1 vccd1 vssd1 sky130_ef_sc_hd__decap_40_12
XANTENNA__1869__S net12 vssd1 vssd1 vccd1 vccd1 sky130_fd_sc_hd__diode_2
XFILLER_73_493 vssd1 vssd1 vccd1 vccd1 sky130_fd_sc_hd__fill_1
X_1971_ net661 _0555_ net74 vssd1 vssd1 vccd1 vccd1 _0264_ sky130_fd_sc_hd__mux2_1
XANTENNA__2992__B1 net79 vssd1 vssd1 vccd1 vccd1 sky130_fd_sc_hd__diode_2
XFILLER_60_3 vssd1 vssd1 vccd1 vccd1 sky130_fd_sc_hd__fill_8
X_2523_ net75 _1032_ vssd1 vssd1 vccd1 vccd1 _1033_ sky130_fd_sc_hd__and2_1
X_2454_ net157 MATMULT_INST.matmult_inst.mem_inst.mem0\[2\] MATMULT_INST.matmult_inst.mem_inst.matrixB0\[2\]
+ net162 vssd1 vssd1 vccd1 vccd1 _0969_ sky130_fd_sc_hd__a22o_1
X_2385_ net387 net63 net42 MATMULT_INST.matmult_inst.fsm_inst.alu_result\[1\] vssd1
+ vssd1 vccd1 vccd1 _0310_ sky130_fd_sc_hd__a22o_1
Xinput1 en vssd1 vssd1 vccd1 vccd1 net1 sky130_fd_sc_hd__buf_1
X_3006_ MATMULT_INST.matmult_inst.mem_inst.matrixB2\[12\] net85 net77 MATMULT_INST.matmult_inst.mem_inst.matrixB1\[12\]
+ _1428_ vssd1 vssd1 vccd1 vccd1 _1429_ sky130_fd_sc_hd__a221o_1
XANTENNA__3287__RESET_B net96 vssd1 vssd1 vccd1 vccd1 sky130_fd_sc_hd__diode_2
XTAP_TAPCELL_ROW_54_628 vssd1 vccd1 sky130_fd_sc_hd__tapvpwrvgnd_1
XANTENNA__2464__A net178 vssd1 vssd1 vccd1 vccd1 sky130_fd_sc_hd__diode_2
XFILLER_3_217 vssd1 vssd1 vccd1 vccd1 sky130_fd_sc_hd__fill_4
XFILLER_10_77 vssd1 vssd1 vccd1 vccd1 sky130_fd_sc_hd__fill_4
XFILLER_19_53 vssd1 vssd1 vccd1 vccd1 sky130_fd_sc_hd__fill_2
XFILLER_19_64 vccd1 vssd1 vccd1 vssd1 sky130_ef_sc_hd__decap_40_12
XANTENNA__2358__B net213 vssd1 vssd1 vccd1 vccd1 sky130_fd_sc_hd__diode_2
XFILLER_47_449 vssd1 vssd1 vccd1 vccd1 sky130_fd_sc_hd__fill_1
XFILLER_27_151 vssd1 vssd1 vccd1 vccd1 sky130_fd_sc_hd__fill_1
XTAP_TAPCELL_ROW_17_319 vssd1 vccd1 sky130_fd_sc_hd__tapvpwrvgnd_1
XFILLER_35_41 vssd1 vssd1 vccd1 vccd1 sky130_fd_sc_hd__fill_1
XTAP_TAPCELL_ROW_25_385 vssd1 vccd1 sky130_fd_sc_hd__tapvpwrvgnd_1
XANTENNA__2821__B net186 vssd1 vssd1 vccd1 vccd1 sky130_fd_sc_hd__diode_2
X_2170_ _0716_ _0719_ vssd1 vssd1 vccd1 vccd1 _0720_ sky130_fd_sc_hd__nand2_1
XFILLER_65_268 vssd1 vssd1 vccd1 vccd1 sky130_fd_sc_hd__fill_2
XANTENNA__2284__A net213 vssd1 vssd1 vccd1 vccd1 sky130_fd_sc_hd__diode_2
XFILLER_18_184 vccd1 vssd1 vccd1 vssd1 sky130_ef_sc_hd__decap_40_12
XTAP_TAPCELL_ROW_51_609 vssd1 vccd1 sky130_fd_sc_hd__tapvpwrvgnd_1
X_1954_ _0523_ _0527_ _0530_ _0534_ _0528_ vssd1 vssd1 vccd1 vccd1 _0541_ sky130_fd_sc_hd__o311a_1
X_1885_ net629 net50 net10 vssd1 vssd1 vccd1 vccd1 _0215_ sky130_fd_sc_hd__mux2_1
X_3486_ clknet_leaf_11_clk net319 net146 vssd1 vssd1 vccd1 vccd1 MATMULT_INST.matmult_inst.fsm_inst.rx_data\[4\]
+ sky130_fd_sc_hd__dfrtp_1
XFILLER_0_209 vssd1 vssd1 vccd1 vccd1 sky130_fd_sc_hd__fill_4
X_2506_ MATMULT_INST.matmult_inst.mem_inst.mem2\[6\] net90 net84 MATMULT_INST.matmult_inst.mem_inst.mem1\[6\]
+ _1016_ vssd1 vssd1 vccd1 vccd1 _1017_ sky130_fd_sc_hd__a221o_1
X_2437_ _1522_ _0927_ _0953_ vssd1 vssd1 vccd1 vccd1 _0954_ sky130_fd_sc_hd__o21bai_4
Xteam_02_306 vssd1 vssd1 vccd1 vccd1 gpio_oeb[26] team_02_306/LO sky130_fd_sc_hd__conb_1
X_2368_ _0895_ _0898_ vssd1 vssd1 vccd1 vccd1 _0912_ sky130_fd_sc_hd__nor2_1
XANTENNA__2496__A2 net91 vssd1 vssd1 vccd1 vccd1 sky130_fd_sc_hd__diode_2
X_2299_ _0825_ _0845_ vssd1 vssd1 vccd1 vccd1 _0846_ sky130_fd_sc_hd__xnor2_1
XTAP_TAPCELL_ROW_67_742 vssd1 vccd1 sky130_fd_sc_hd__tapvpwrvgnd_1
XFILLER_71_205 vssd1 vssd1 vccd1 vccd1 sky130_fd_sc_hd__fill_1
XFILLER_12_305 vssd1 vssd1 vccd1 vccd1 sky130_fd_sc_hd__fill_2
XFILLER_8_309 vccd1 vssd1 vccd1 vssd1 sky130_ef_sc_hd__decap_40_12
XTAP_TAPCELL_ROW_22_355 vssd1 vccd1 sky130_fd_sc_hd__tapvpwrvgnd_1
XANTENNA__2956__B1 net80 vssd1 vssd1 vccd1 vccd1 sky130_fd_sc_hd__diode_2
XFILLER_35_419 vssd1 vssd1 vccd1 vccd1 sky130_fd_sc_hd__fill_1
XFILLER_47_279 vssd1 vssd1 vccd1 vccd1 sky130_fd_sc_hd__fill_1
XANTENNA__2239__A2 net222 vssd1 vssd1 vccd1 vccd1 sky130_fd_sc_hd__diode_2
XTAP_TAPCELL_ROW_73_789 vssd1 vccd1 sky130_fd_sc_hd__tapvpwrvgnd_1
XFILLER_62_83 vssd1 vssd1 vccd1 vccd1 sky130_fd_sc_hd__fill_1
XANTENNA__2043__S net55 vssd1 vssd1 vccd1 vccd1 sky130_fd_sc_hd__diode_2
XFILLER_11_393 vccd1 vssd1 vccd1 vssd1 sky130_ef_sc_hd__decap_40_12
X_1670_ MATMULT_INST.matmult_inst.alu_inst.state\[1\] MATMULT_INST.matmult_inst.alu_inst.state\[0\]
+ _0478_ vssd1 vssd1 vccd1 vccd1 _0452_ sky130_fd_sc_hd__nor3_2
XANTENNA__1882__S net11 vssd1 vssd1 vccd1 vccd1 sky130_fd_sc_hd__diode_2
Xhold309 MATMULT_INST.matmult_inst.mem_inst.matrixA0\[10\] vssd1 vssd1 vccd1 vccd1
+ net622 sky130_fd_sc_hd__dlygate4sd3_1
X_3340_ clknet_leaf_26_clk _0295_ vssd1 vssd1 vccd1 vccd1 MATMULT_INST.matmult_inst.alu_inst.adder_inst.r0.fa3.a
+ sky130_fd_sc_hd__dfxtp_1
X_3271_ clknet_leaf_12_clk _0229_ net149 vssd1 vssd1 vccd1 vccd1 MATMULT_INST.matmult_inst.mem_inst.matrixA1\[6\]
+ sky130_fd_sc_hd__dfrtp_1
X_2222_ net239 net213 vssd1 vssd1 vccd1 vccd1 _0771_ sky130_fd_sc_hd__nand2_1
XFILLER_23_3 vssd1 vssd1 vccd1 vccd1 sky130_fd_sc_hd__fill_4
X_2153_ _0702_ _0703_ vssd1 vssd1 vccd1 vccd1 _0704_ sky130_fd_sc_hd__and2b_1
XFILLER_19_493 vssd1 vssd1 vccd1 vccd1 sky130_fd_sc_hd__fill_1
X_2084_ _0634_ _0635_ _0622_ vssd1 vssd1 vccd1 vccd1 _0637_ sky130_fd_sc_hd__a21o_1
XTAP_TAPCELL_ROW_64_712 vssd1 vccd1 sky130_fd_sc_hd__tapvpwrvgnd_1
XFILLER_21_135 vssd1 vssd1 vccd1 vccd1 sky130_fd_sc_hd__fill_1
X_2986_ net165 _1409_ _1410_ _1405_ vssd1 vssd1 vccd1 vccd1 _1411_ sky130_fd_sc_hd__a211o_1
X_1937_ net387 _0526_ net74 vssd1 vssd1 vccd1 vccd1 _0259_ sky130_fd_sc_hd__mux2_1
X_1868_ net483 net48 net12 vssd1 vssd1 vccd1 vccd1 _0199_ sky130_fd_sc_hd__mux2_1
XANTENNA__1792__S net30 vssd1 vssd1 vccd1 vccd1 sky130_fd_sc_hd__diode_2
X_1799_ net517 net39 net17 vssd1 vssd1 vccd1 vccd1 _0133_ sky130_fd_sc_hd__mux2_1
X_3469_ clknet_leaf_17_clk _0413_ net129 vssd1 vssd1 vccd1 vccd1 MATMULT_INST.matmult_inst.mem_inst.matrixB3\[5\]
+ sky130_fd_sc_hd__dfrtp_1
XFILLER_69_382 vssd1 vssd1 vccd1 vccd1 sky130_fd_sc_hd__fill_1
XTAP_TAPCELL_ROW_27_403 vssd1 vccd1 sky130_fd_sc_hd__tapvpwrvgnd_1
XFILLER_44_249 vssd1 vssd1 vccd1 vccd1 sky130_fd_sc_hd__fill_1
XANTENNA_fanout30_A _0513_ vssd1 vssd1 vccd1 vccd1 sky130_fd_sc_hd__diode_2
XFILLER_8_139 vssd1 vssd1 vccd1 vccd1 sky130_fd_sc_hd__fill_1
XFILLER_32_53 vssd1 vssd1 vccd1 vccd1 sky130_fd_sc_hd__fill_4
XANTENNA__2371__B net67 vssd1 vssd1 vccd1 vccd1 sky130_fd_sc_hd__diode_2
XFILLER_4_301 vssd1 vssd1 vccd1 vccd1 sky130_fd_sc_hd__fill_4
XFILLER_4_345 vccd1 vssd1 vccd1 vssd1 sky130_ef_sc_hd__decap_40_12
XFILLER_79_113 vssd1 vssd1 vccd1 vccd1 sky130_fd_sc_hd__fill_4
XFILLER_4_389 vccd1 vssd1 vccd1 vssd1 sky130_ef_sc_hd__decap_40_12
XANTENNA_clkbuf_leaf_19_clk_A clknet_2_2__leaf_clk vssd1 vssd1 vccd1 vccd1 sky130_fd_sc_hd__diode_2
XANTENNA__1715__B net157 vssd1 vssd1 vccd1 vccd1 sky130_fd_sc_hd__diode_2
XTAP_TAPCELL_ROW_78_837 vssd1 vccd1 sky130_fd_sc_hd__tapvpwrvgnd_1
XFILLER_75_363 vssd1 vssd1 vccd1 vccd1 sky130_fd_sc_hd__fill_4
XANTENNA__1877__S net11 vssd1 vssd1 vccd1 vccd1 sky130_fd_sc_hd__diode_2
X_2840_ _1306_ _1308_ vssd1 vssd1 vccd1 vccd1 _1309_ sky130_fd_sc_hd__xnor2_1
X_2771_ _1207_ _1238_ _1241_ vssd1 vssd1 vccd1 vccd1 _1242_ sky130_fd_sc_hd__a21o_1
X_1722_ net516 net35 net23 vssd1 vssd1 vccd1 vccd1 _0065_ sky130_fd_sc_hd__mux2_1
Xhold117 MATMULT_INST.matmult_inst.mem_inst.matrixB3\[17\] vssd1 vssd1 vccd1 vccd1
+ net430 sky130_fd_sc_hd__dlygate4sd3_1
XFILLER_7_161 vssd1 vssd1 vccd1 vccd1 sky130_fd_sc_hd__fill_4
Xhold106 MATMULT_INST.matmult_inst.alu_inst.adder_inst.r2.fa1.a vssd1 vssd1 vccd1
+ vccd1 net419 sky130_fd_sc_hd__dlygate4sd3_1
X_1653_ MATMULT_INST.matmult_inst.spi_inst.tx_reg_sys\[2\] MATMULT_INST.matmult_inst.spi_inst.miso_shifter\[1\]
+ net154 vssd1 vssd1 vccd1 vccd1 _0014_ sky130_fd_sc_hd__mux2_1
XPHY_EDGE_ROW_9_Right_9 vssd1 vssd1 vccd1 vccd1 sky130_fd_sc_hd__decap_3
Xhold139 MATMULT_INST.matmult_inst.alu_inst.col0\[3\] vssd1 vssd1 vccd1 vccd1 net452
+ sky130_fd_sc_hd__dlygate4sd3_1
Xhold128 MATMULT_INST.matmult_inst.spi_inst.tx_reg_sys\[11\] vssd1 vssd1 vccd1 vccd1
+ net441 sky130_fd_sc_hd__dlygate4sd3_1
X_1584_ MATMULT_INST.matmult_inst.fsm_inst.load_delay _1502_ _1503_ vssd1 vssd1 vccd1
+ vccd1 MATMULT_INST.matmult_inst.fsm_inst.transaction_ready sky130_fd_sc_hd__and3_1
X_3323_ clknet_leaf_2_clk _0281_ net105 vssd1 vssd1 vccd1 vccd1 MATMULT_INST.matmult_inst.alu_inst.b1_reg\[5\]
+ sky130_fd_sc_hd__dfrtp_1
X_3254_ clknet_leaf_13_clk _0212_ net145 vssd1 vssd1 vccd1 vccd1 MATMULT_INST.matmult_inst.mem_inst.mem0\[7\]
+ sky130_fd_sc_hd__dfrtp_1
X_2205_ _0714_ _0720_ _0721_ _0751_ _0713_ vssd1 vssd1 vccd1 vccd1 _0754_ sky130_fd_sc_hd__a311o_1
X_3185_ clknet_leaf_24_clk _0143_ net119 vssd1 vssd1 vccd1 vccd1 MATMULT_INST.matmult_inst.mem_inst.mem2\[10\]
+ sky130_fd_sc_hd__dfrtp_1
XFILLER_66_363 vssd1 vssd1 vccd1 vccd1 sky130_fd_sc_hd__fill_1
X_2136_ _0684_ _0685_ _0677_ vssd1 vssd1 vccd1 vccd1 _0687_ sky130_fd_sc_hd__a21o_1
XANTENNA__2456__B net172 vssd1 vssd1 vccd1 vccd1 sky130_fd_sc_hd__diode_2
X_2067_ net239 net222 net220 net241 vssd1 vssd1 vccd1 vccd1 _0621_ sky130_fd_sc_hd__a22oi_1
XANTENNA_fanout165_A MATMULT_INST.matmult_inst.fsm_inst.sel\[0\] vssd1 vssd1 vccd1
+ vccd1 sky130_fd_sc_hd__diode_2
XANTENNA__1787__S net31 vssd1 vssd1 vccd1 vccd1 sky130_fd_sc_hd__diode_2
X_2969_ MATMULT_INST.matmult_inst.mem_inst.matrixA0\[9\] net64 _1394_ net92 vssd1
+ vssd1 vccd1 vccd1 _1395_ sky130_fd_sc_hd__a22o_1
XFILLER_5_109 vssd1 vssd1 vccd1 vccd1 sky130_fd_sc_hd__fill_2
XANTENNA_fanout218_X net218 vssd1 vssd1 vccd1 vccd1 sky130_fd_sc_hd__diode_2
XFILLER_78_27 vssd1 vssd1 vccd1 vccd1 sky130_fd_sc_hd__fill_1
XFILLER_1_337 vccd1 vssd1 vccd1 vssd1 sky130_ef_sc_hd__decap_40_12
XANTENNA__3412__RESET_B net96 vssd1 vssd1 vccd1 vccd1 sky130_fd_sc_hd__diode_2
XANTENNA_fanout78_A net80 vssd1 vssd1 vccd1 vccd1 sky130_fd_sc_hd__diode_2
XTAP_TAPCELL_ROW_75_807 vssd1 vccd1 sky130_fd_sc_hd__tapvpwrvgnd_1
XFILLER_13_411 vssd1 vssd1 vccd1 vccd1 sky130_fd_sc_hd__fill_1
XFILLER_43_85 vssd1 vssd1 vccd1 vccd1 sky130_fd_sc_hd__fill_1
XFILLER_4_153 vccd1 vssd1 vccd1 vssd1 sky130_ef_sc_hd__decap_40_12
XFILLER_4_197 vccd1 vssd1 vccd1 vssd1 sky130_ef_sc_hd__decap_40_12
XFILLER_68_93 vssd1 vssd1 vccd1 vccd1 sky130_fd_sc_hd__fill_4
XFILLER_0_370 vssd1 vssd1 vccd1 vccd1 sky130_fd_sc_hd__fill_4
XFILLER_48_330 vssd1 vssd1 vccd1 vccd1 sky130_fd_sc_hd__fill_1
XFILLER_48_363 vssd1 vssd1 vccd1 vccd1 sky130_fd_sc_hd__fill_1
XTAP_TAPCELL_ROW_46_564 vssd1 vccd1 sky130_fd_sc_hd__tapvpwrvgnd_1
XFILLER_16_282 vssd1 vssd1 vccd1 vccd1 sky130_fd_sc_hd__fill_2
X_2823_ net184 net206 vssd1 vssd1 vccd1 vccd1 _1292_ sky130_fd_sc_hd__nand2_1
X_2754_ _1222_ _1223_ _1218_ vssd1 vssd1 vccd1 vccd1 _1225_ sky130_fd_sc_hd__a21oi_1
XANTENNA__3030__A2 net64 vssd1 vssd1 vccd1 vccd1 sky130_fd_sc_hd__diode_2
X_1705_ MATMULT_INST.matmult_inst.fsm_inst.alu_result\[13\] net60 vssd1 vssd1 vccd1
+ vccd1 _0498_ sky130_fd_sc_hd__and2_1
X_2685_ _1157_ vssd1 vssd1 vccd1 vccd1 _1158_ sky130_fd_sc_hd__inv_2
X_1636_ _0468_ vssd1 vssd1 vccd1 vccd1 MATMULT_INST.nrst sky130_fd_sc_hd__inv_2
X_1567_ _1486_ MATMULT_INST.matmult_inst.spi_inst.mosi_data_spi\[0\] _1491_ vssd1
+ vssd1 vccd1 vccd1 _0391_ sky130_fd_sc_hd__mux2_1
XPHY_EDGE_ROW_18_Left_98 vssd1 vssd1 vccd1 vccd1 sky130_fd_sc_hd__decap_3
X_3306_ clknet_leaf_1_clk _0264_ net108 vssd1 vssd1 vccd1 vccd1 MATMULT_INST.matmult_inst.alu_inst.out\[6\]
+ sky130_fd_sc_hd__dfrtp_1
X_3237_ clknet_leaf_18_clk _0195_ net130 vssd1 vssd1 vccd1 vccd1 MATMULT_INST.matmult_inst.mem_inst.matrixB2\[8\]
+ sky130_fd_sc_hd__dfrtp_1
X_3168_ clknet_leaf_18_clk _0126_ net130 vssd1 vssd1 vccd1 vccd1 MATMULT_INST.matmult_inst.mem_inst.matrixB1\[11\]
+ sky130_fd_sc_hd__dfrtp_1
X_2119_ _0668_ _0669_ vssd1 vssd1 vccd1 vccd1 _0671_ sky130_fd_sc_hd__or2_1
XTAP_TAPCELL_ROW_1_178 vssd1 vccd1 sky130_fd_sc_hd__tapvpwrvgnd_1
X_3099_ clknet_leaf_24_clk _0057_ net101 vssd1 vssd1 vccd1 vccd1 MATMULT_INST.matmult_inst.mem_inst.matrixB0\[14\]
+ sky130_fd_sc_hd__dfrtp_1
XANTENNA_fanout168_X net168 vssd1 vssd1 vccd1 vccd1 sky130_fd_sc_hd__diode_2
Xfanout12 _0517_ vssd1 vssd1 vccd1 vccd1 net12 sky130_fd_sc_hd__buf_4
Xfanout56 _0452_ vssd1 vssd1 vccd1 vccd1 net56 sky130_fd_sc_hd__clkbuf_2
Xfanout45 _0500_ vssd1 vssd1 vccd1 vccd1 net45 sky130_fd_sc_hd__clkbuf_2
Xfanout34 _0490_ vssd1 vssd1 vccd1 vccd1 net34 sky130_fd_sc_hd__clkbuf_2
Xfanout23 _0505_ vssd1 vssd1 vccd1 vccd1 net23 sky130_fd_sc_hd__clkbuf_4
XFILLER_13_33 vssd1 vssd1 vccd1 vccd1 sky130_fd_sc_hd__fill_1
Xfanout78 net80 vssd1 vssd1 vccd1 vccd1 net78 sky130_fd_sc_hd__clkbuf_2
Xfanout89 net91 vssd1 vssd1 vccd1 vccd1 net89 sky130_fd_sc_hd__clkbuf_4
Xfanout67 net68 vssd1 vssd1 vccd1 vccd1 net67 sky130_fd_sc_hd__buf_2
XFILLER_10_469 vssd1 vssd1 vccd1 vccd1 sky130_fd_sc_hd__fill_4
XFILLER_13_77 vssd1 vssd1 vccd1 vccd1 sky130_fd_sc_hd__fill_1
XTAP_TAPCELL_ROW_9_245 vssd1 vccd1 sky130_fd_sc_hd__tapvpwrvgnd_1
XFILLER_1_167 vssd1 vssd1 vccd1 vccd1 sky130_fd_sc_hd__fill_1
XFILLER_72_141 vssd1 vssd1 vccd1 vccd1 sky130_fd_sc_hd__fill_1
XANTENNA__2048__A0 net187 vssd1 vssd1 vccd1 vccd1 sky130_fd_sc_hd__diode_2
XFILLER_72_174 vssd1 vssd1 vccd1 vccd1 sky130_fd_sc_hd__fill_1
XTAP_TAPCELL_ROW_43_534 vssd1 vccd1 sky130_fd_sc_hd__tapvpwrvgnd_1
XANTENNA__3001__A net176 vssd1 vssd1 vccd1 vccd1 sky130_fd_sc_hd__diode_2
XFILLER_54_95 vssd1 vssd1 vccd1 vccd1 sky130_fd_sc_hd__fill_1
XFILLER_9_223 vssd1 vssd1 vccd1 vccd1 sky130_fd_sc_hd__fill_1
XFILLER_70_72 vccd1 vssd1 vccd1 vssd1 sky130_ef_sc_hd__decap_40_12
XANTENNA__3012__A2 net87 vssd1 vssd1 vccd1 vccd1 sky130_fd_sc_hd__diode_2
Xclkload15 clknet_leaf_20_clk vssd1 vssd1 vccd1 vccd1 clkload15/Y sky130_fd_sc_hd__inv_8
Xclkload26 clknet_leaf_14_clk vssd1 vssd1 vccd1 vccd1 clkload26/X sky130_fd_sc_hd__clkbuf_4
XANTENNA__2220__B1 net238 vssd1 vssd1 vccd1 vccd1 sky130_fd_sc_hd__diode_2
XFILLER_5_473 vccd1 vssd1 vccd1 vssd1 sky130_ef_sc_hd__decap_40_12
X_2470_ MATMULT_INST.matmult_inst.mem_inst.matrixB2\[3\] net90 net83 MATMULT_INST.matmult_inst.mem_inst.matrixB1\[3\]
+ _0983_ vssd1 vssd1 vccd1 vccd1 _0984_ sky130_fd_sc_hd__a221o_1
XANTENNA__1890__S net10 vssd1 vssd1 vccd1 vccd1 sky130_fd_sc_hd__diode_2
X_3022_ net176 net167 MATMULT_INST.matmult_inst.mem_inst.matrixB3\[14\] vssd1 vssd1
+ vccd1 vccd1 _1443_ sky130_fd_sc_hd__and3_1
XFILLER_36_311 vssd1 vssd1 vccd1 vccd1 sky130_fd_sc_hd__fill_1
XFILLER_51_303 vssd1 vssd1 vccd1 vccd1 sky130_fd_sc_hd__fill_1
XANTENNA__2039__A0 net204 vssd1 vssd1 vccd1 vccd1 sky130_fd_sc_hd__diode_2
XTAP_TAPCELL_ROW_14_291 vssd1 vccd1 sky130_fd_sc_hd__tapvpwrvgnd_1
Xclkload9 clknet_leaf_3_clk vssd1 vssd1 vccd1 vccd1 clkload9/Y sky130_fd_sc_hd__inv_8
XANTENNA_fanout128_A net132 vssd1 vssd1 vccd1 vccd1 sky130_fd_sc_hd__diode_2
X_2806_ _1262_ _1273_ _1272_ vssd1 vssd1 vccd1 vccd1 _1276_ sky130_fd_sc_hd__a21boi_1
X_2737_ net194 net198 _1134_ vssd1 vssd1 vccd1 vccd1 _1208_ sky130_fd_sc_hd__and3_1
X_2668_ _1109_ _1139_ _1140_ vssd1 vssd1 vccd1 vccd1 _1141_ sky130_fd_sc_hd__nand3_1
X_1619_ _1498_ _1520_ vssd1 vssd1 vccd1 vccd1 _1537_ sky130_fd_sc_hd__nand2_1
Xfanout202 net203 vssd1 vssd1 vccd1 vccd1 net202 sky130_fd_sc_hd__buf_2
Xfanout213 MATMULT_INST.matmult_inst.alu_inst.a0_reg\[7\] vssd1 vssd1 vccd1 vccd1
+ net213 sky130_fd_sc_hd__buf_2
X_2599_ _1068_ _1074_ net72 vssd1 vssd1 vccd1 vccd1 _1076_ sky130_fd_sc_hd__o21ai_1
Xfanout246 net2 vssd1 vssd1 vccd1 vccd1 net246 sky130_fd_sc_hd__clkbuf_2
XTAP_TAPCELL_ROW_6_226 vssd1 vccd1 sky130_fd_sc_hd__tapvpwrvgnd_1
Xfanout235 MATMULT_INST.matmult_inst.alu_inst.b0_reg\[3\] vssd1 vssd1 vccd1 vccd1
+ net235 sky130_fd_sc_hd__clkbuf_4
Xfanout224 MATMULT_INST.matmult_inst.alu_inst.a0_reg\[1\] vssd1 vssd1 vccd1 vccd1
+ net224 sky130_fd_sc_hd__dlymetal6s2s_1
XFILLER_59_447 vssd1 vssd1 vccd1 vccd1 sky130_fd_sc_hd__fill_1
XANTENNA_input2_A gpio_in[0] vssd1 vssd1 vccd1 vccd1 sky130_fd_sc_hd__diode_2
XFILLER_74_417 vssd1 vssd1 vccd1 vccd1 sky130_fd_sc_hd__fill_1
XTAP_TAPCELL_ROW_57_659 vssd1 vccd1 sky130_fd_sc_hd__tapvpwrvgnd_1
XFILLER_24_76 vssd1 vssd1 vccd1 vccd1 sky130_fd_sc_hd__fill_8
XTAP_TAPCELL_ROW_40_515 vssd1 vccd1 sky130_fd_sc_hd__tapvpwrvgnd_1
XFILLER_10_233 vccd1 vssd1 vccd1 vssd1 sky130_ef_sc_hd__decap_40_12
XFILLER_10_277 vccd1 vssd1 vccd1 vssd1 sky130_ef_sc_hd__decap_40_12
XFILLER_2_421 vccd1 vssd1 vccd1 vssd1 sky130_ef_sc_hd__decap_40_12
XFILLER_77_244 vssd1 vssd1 vccd1 vccd1 sky130_fd_sc_hd__fill_2
XFILLER_1_69 vccd1 vssd1 vccd1 vssd1 sky130_ef_sc_hd__decap_40_12
XFILLER_18_311 vssd1 vssd1 vccd1 vccd1 sky130_fd_sc_hd__fill_1
XFILLER_65_50 vssd1 vssd1 vccd1 vccd1 sky130_fd_sc_hd__fill_4
XFILLER_60_122 vssd1 vssd1 vccd1 vccd1 sky130_fd_sc_hd__fill_1
X_1970_ _0552_ _0554_ vssd1 vssd1 vccd1 vccd1 _0555_ sky130_fd_sc_hd__xnor2_1
XFILLER_60_166 vssd1 vssd1 vccd1 vccd1 sky130_fd_sc_hd__fill_1
XANTENNA__1885__S net10 vssd1 vssd1 vccd1 vccd1 sky130_fd_sc_hd__diode_2
XANTENNA__2441__B1 net157 vssd1 vssd1 vccd1 vccd1 sky130_fd_sc_hd__diode_2
XFILLER_53_3 vssd1 vssd1 vccd1 vccd1 sky130_fd_sc_hd__fill_4
X_2522_ MATMULT_INST.matmult_inst.mem_inst.matrixA0\[7\] net65 _1030_ _1031_ vssd1
+ vssd1 vccd1 vccd1 _1032_ sky130_fd_sc_hd__a211o_1
XFILLER_5_281 vccd1 vssd1 vccd1 vssd1 sky130_ef_sc_hd__decap_40_12
X_2453_ MATMULT_INST.matmult_inst.mem_inst.mem2\[2\] net89 net82 MATMULT_INST.matmult_inst.mem_inst.mem1\[2\]
+ _0967_ vssd1 vssd1 vccd1 vccd1 _0968_ sky130_fd_sc_hd__a221o_1
X_2384_ net645 net63 net42 MATMULT_INST.matmult_inst.fsm_inst.alu_result\[0\] vssd1
+ vssd1 vccd1 vccd1 _0309_ sky130_fd_sc_hd__a22o_1
Xinput2 gpio_in[0] vssd1 vssd1 vccd1 vccd1 net2 sky130_fd_sc_hd__clkbuf_2
XFILLER_68_299 vssd1 vssd1 vccd1 vccd1 sky130_fd_sc_hd__fill_1
X_3005_ net176 net167 MATMULT_INST.matmult_inst.mem_inst.matrixB3\[12\] vssd1 vssd1
+ vccd1 vccd1 _1428_ sky130_fd_sc_hd__and3_1
XFILLER_36_141 vssd1 vssd1 vccd1 vccd1 sky130_fd_sc_hd__fill_1
XANTENNA__2464__B net169 vssd1 vssd1 vccd1 vccd1 sky130_fd_sc_hd__diode_2
XTAP_TAPCELL_ROW_54_629 vssd1 vccd1 sky130_fd_sc_hd__tapvpwrvgnd_1
XANTENNA_fanout245_A net246 vssd1 vssd1 vccd1 vccd1 sky130_fd_sc_hd__diode_2
XANTENNA__1795__S net30 vssd1 vssd1 vccd1 vccd1 sky130_fd_sc_hd__diode_2
XTAP_TAPCELL_ROW_62_695 vssd1 vccd1 sky130_fd_sc_hd__tapvpwrvgnd_1
XANTENNA__3084__Q MATMULT_INST.matmult_inst.spi_inst.rx_done_sys vssd1 vssd1 vccd1
+ vccd1 sky130_fd_sc_hd__diode_2
XFILLER_59_200 vssd1 vssd1 vccd1 vccd1 sky130_fd_sc_hd__fill_2
XFILLER_59_222 vssd1 vssd1 vccd1 vccd1 sky130_fd_sc_hd__fill_2
XFILLER_74_203 vssd1 vssd1 vccd1 vccd1 sky130_fd_sc_hd__fill_4
XFILLER_19_76 vssd1 vssd1 vccd1 vccd1 sky130_fd_sc_hd__fill_4
XTAP_TAPCELL_ROW_25_386 vssd1 vccd1 sky130_fd_sc_hd__tapvpwrvgnd_1
XANTENNA__2974__A1 net160 vssd1 vssd1 vccd1 vccd1 sky130_fd_sc_hd__diode_2
XANTENNA__2974__B2 net156 vssd1 vssd1 vccd1 vccd1 sky130_fd_sc_hd__diode_2
XFILLER_51_52 vssd1 vssd1 vccd1 vccd1 sky130_fd_sc_hd__fill_4
XFILLER_51_63 vssd1 vssd1 vccd1 vccd1 sky130_fd_sc_hd__fill_1
XANTENNA__2821__C net203 vssd1 vssd1 vccd1 vccd1 sky130_fd_sc_hd__diode_2
XFILLER_2_251 vssd1 vssd1 vccd1 vccd1 sky130_fd_sc_hd__fill_1
XFILLER_25_7 vssd1 vssd1 vccd1 vccd1 sky130_fd_sc_hd__fill_2
XFILLER_65_225 vssd1 vssd1 vccd1 vccd1 sky130_fd_sc_hd__fill_8
XFILLER_18_141 vssd1 vssd1 vccd1 vccd1 sky130_fd_sc_hd__fill_8
XFILLER_46_450 vssd1 vssd1 vccd1 vccd1 sky130_fd_sc_hd__fill_1
XANTENNA__2284__B net235 vssd1 vssd1 vccd1 vccd1 sky130_fd_sc_hd__diode_2
XFILLER_33_111 vssd1 vssd1 vccd1 vccd1 sky130_fd_sc_hd__fill_1
XFILLER_33_122 vssd1 vssd1 vccd1 vccd1 sky130_fd_sc_hd__fill_1
XFILLER_14_391 vssd1 vssd1 vccd1 vccd1 sky130_fd_sc_hd__fill_4
X_1953_ _0538_ _0539_ vssd1 vssd1 vccd1 vccd1 _0540_ sky130_fd_sc_hd__and2b_1
X_1884_ net558 _0494_ net10 vssd1 vssd1 vccd1 vccd1 _0214_ sky130_fd_sc_hd__mux2_1
X_2505_ net183 net174 MATMULT_INST.matmult_inst.mem_inst.mem3\[6\] vssd1 vssd1 vccd1
+ vccd1 _1016_ sky130_fd_sc_hd__and3_1
X_3485_ clknet_leaf_11_clk net323 net146 vssd1 vssd1 vccd1 vccd1 MATMULT_INST.matmult_inst.fsm_inst.rx_data\[3\]
+ sky130_fd_sc_hd__dfrtp_1
X_2436_ net75 _1524_ vssd1 vssd1 vccd1 vccd1 _0953_ sky130_fd_sc_hd__nor2_1
Xteam_02_307 vssd1 vssd1 vccd1 vccd1 gpio_oeb[27] team_02_307/LO sky130_fd_sc_hd__conb_1
X_2367_ _0908_ _0909_ vssd1 vssd1 vccd1 vccd1 _0911_ sky130_fd_sc_hd__nor2_1
X_2298_ _0841_ _0843_ vssd1 vssd1 vccd1 vccd1 _0845_ sky130_fd_sc_hd__xnor2_1
XTAP_TAPCELL_ROW_67_743 vssd1 vccd1 sky130_fd_sc_hd__tapvpwrvgnd_1
XFILLER_72_29 vssd1 vssd1 vccd1 vccd1 sky130_fd_sc_hd__fill_1
XFILLER_72_18 vssd1 vssd1 vccd1 vccd1 sky130_fd_sc_hd__fill_4
XTAP_TAPCELL_ROW_22_356 vssd1 vccd1 sky130_fd_sc_hd__tapvpwrvgnd_1
XFILLER_21_11 vssd1 vssd1 vccd1 vccd1 sky130_fd_sc_hd__fill_1
XFILLER_21_55 vssd1 vssd1 vccd1 vccd1 sky130_fd_sc_hd__fill_1
XPHY_EDGE_ROW_6_Left_86 vssd1 vssd1 vccd1 vccd1 sky130_fd_sc_hd__decap_3
XFILLER_46_85 vssd1 vssd1 vccd1 vccd1 sky130_fd_sc_hd__fill_4
XFILLER_70_261 vssd1 vssd1 vccd1 vccd1 sky130_fd_sc_hd__fill_1
XFILLER_70_250 vssd1 vssd1 vccd1 vccd1 sky130_fd_sc_hd__fill_2
XFILLER_62_51 vssd1 vssd1 vccd1 vccd1 sky130_fd_sc_hd__fill_1
XFILLER_62_62 vssd1 vssd1 vccd1 vccd1 sky130_fd_sc_hd__fill_1
XFILLER_62_95 vccd1 vssd1 vccd1 vssd1 sky130_ef_sc_hd__decap_40_12
XFILLER_11_361 vccd1 vssd1 vccd1 vssd1 sky130_ef_sc_hd__decap_40_12
XFILLER_7_57 vccd1 vssd1 vccd1 vssd1 sky130_ef_sc_hd__decap_40_12
XANTENNA__2175__A2 net228 vssd1 vssd1 vccd1 vccd1 sky130_fd_sc_hd__diode_2
X_3270_ clknet_leaf_15_clk _0228_ net143 vssd1 vssd1 vccd1 vccd1 MATMULT_INST.matmult_inst.mem_inst.matrixA1\[5\]
+ sky130_fd_sc_hd__dfrtp_1
X_2221_ net216 net214 net235 net238 vssd1 vssd1 vccd1 vccd1 _0770_ sky130_fd_sc_hd__nand4_1
XFILLER_78_361 vssd1 vssd1 vccd1 vccd1 sky130_fd_sc_hd__fill_2
XFILLER_16_3 vccd1 vssd1 vccd1 vssd1 sky130_ef_sc_hd__decap_40_12
X_2152_ _0667_ _0700_ _0701_ vssd1 vssd1 vccd1 vccd1 _0703_ sky130_fd_sc_hd__nand3_1
X_2083_ _0622_ _0634_ _0635_ vssd1 vssd1 vccd1 vccd1 _0636_ sky130_fd_sc_hd__nand3_1
XTAP_TAPCELL_ROW_64_713 vssd1 vccd1 sky130_fd_sc_hd__tapvpwrvgnd_1
X_2985_ net160 _1403_ _1407_ net155 vssd1 vssd1 vccd1 vccd1 _1410_ sky130_fd_sc_hd__a22o_1
X_1936_ _0521_ _0525_ vssd1 vssd1 vccd1 vccd1 _0526_ sky130_fd_sc_hd__xnor2_1
X_1867_ net593 net49 net12 vssd1 vssd1 vccd1 vccd1 _0198_ sky130_fd_sc_hd__mux2_1
X_1798_ _0507_ _0510_ vssd1 vssd1 vccd1 vccd1 _0514_ sky130_fd_sc_hd__nor2_1
X_3468_ clknet_leaf_16_clk _0412_ net122 vssd1 vssd1 vccd1 vccd1 MATMULT_INST.matmult_inst.mem_inst.matrixB3\[4\]
+ sky130_fd_sc_hd__dfrtp_1
X_3399_ clknet_leaf_6_clk _0353_ net112 vssd1 vssd1 vccd1 vccd1 MATMULT_INST.matmult_inst.alu_inst.row1\[1\]
+ sky130_fd_sc_hd__dfrtp_1
X_2419_ _1482_ _0930_ vssd1 vssd1 vccd1 vccd1 _0938_ sky130_fd_sc_hd__nand2_1
XANTENNA__3362__Q MATMULT_INST.matmult_inst.fsm_inst.alu_result\[8\] vssd1 vssd1 vccd1
+ vccd1 sky130_fd_sc_hd__diode_2
XANTENNA_fanout198_X net198 vssd1 vssd1 vccd1 vccd1 sky130_fd_sc_hd__diode_2
XTAP_TAPCELL_ROW_27_404 vssd1 vccd1 sky130_fd_sc_hd__tapvpwrvgnd_1
XFILLER_16_77 vssd1 vssd1 vccd1 vccd1 sky130_fd_sc_hd__fill_4
XFILLER_16_88 vssd1 vssd1 vccd1 vccd1 sky130_fd_sc_hd__fill_2
XTAP_TAPCELL_ROW_35_470 vssd1 vccd1 sky130_fd_sc_hd__tapvpwrvgnd_1
XANTENNA_fanout23_A _0505_ vssd1 vssd1 vccd1 vccd1 sky130_fd_sc_hd__diode_2
XFILLER_32_98 vssd1 vssd1 vccd1 vccd1 sky130_fd_sc_hd__fill_2
XFILLER_4_357 vssd1 vssd1 vccd1 vccd1 sky130_fd_sc_hd__fill_4
XTAP_TAPCELL_ROW_78_838 vssd1 vccd1 sky130_fd_sc_hd__tapvpwrvgnd_1
XFILLER_57_51 vssd1 vssd1 vccd1 vccd1 sky130_fd_sc_hd__fill_4
XFILLER_75_375 vssd1 vssd1 vccd1 vccd1 sky130_fd_sc_hd__fill_2
XFILLER_73_83 vssd1 vssd1 vccd1 vccd1 sky130_fd_sc_hd__fill_2
XFILLER_16_475 vssd1 vssd1 vccd1 vccd1 sky130_fd_sc_hd__fill_1
XANTENNA__2843__A net189 vssd1 vssd1 vccd1 vccd1 sky130_fd_sc_hd__diode_2
XFILLER_31_478 vssd1 vssd1 vccd1 vccd1 sky130_fd_sc_hd__fill_1
X_2770_ _1239_ _1240_ vssd1 vssd1 vccd1 vccd1 _1241_ sky130_fd_sc_hd__nand2_1
X_1721_ net468 net36 net23 vssd1 vssd1 vccd1 vccd1 _0064_ sky130_fd_sc_hd__mux2_1
X_1652_ MATMULT_INST.matmult_inst.spi_inst.tx_reg_sys\[1\] MATMULT_INST.matmult_inst.spi_inst.miso_shifter\[0\]
+ net154 vssd1 vssd1 vccd1 vccd1 _0013_ sky130_fd_sc_hd__mux2_1
Xhold107 MATMULT_INST.matmult_inst.mem_inst.matrixB2\[7\] vssd1 vssd1 vccd1 vccd1
+ net420 sky130_fd_sc_hd__dlygate4sd3_1
Xhold129 MATMULT_INST.matmult_inst.mem_inst.mem3\[13\] vssd1 vssd1 vccd1 vccd1 net442
+ sky130_fd_sc_hd__dlygate4sd3_1
Xhold118 MATMULT_INST.matmult_inst.alu_inst.adder_inst.r3.fa1.a vssd1 vssd1 vccd1
+ vccd1 net431 sky130_fd_sc_hd__dlygate4sd3_1
X_1583_ MATMULT_INST.matmult_inst.fsm_inst.count\[0\] MATMULT_INST.matmult_inst.fsm_inst.count\[1\]
+ vssd1 vssd1 vccd1 vccd1 _1503_ sky130_fd_sc_hd__and2b_1
X_3322_ clknet_leaf_2_clk _0280_ net114 vssd1 vssd1 vccd1 vccd1 MATMULT_INST.matmult_inst.alu_inst.b1_reg\[4\]
+ sky130_fd_sc_hd__dfrtp_1
X_3253_ clknet_leaf_12_clk _0211_ net149 vssd1 vssd1 vccd1 vccd1 MATMULT_INST.matmult_inst.mem_inst.mem0\[6\]
+ sky130_fd_sc_hd__dfrtp_1
X_2204_ _0713_ _0722_ _0751_ _0714_ vssd1 vssd1 vccd1 vccd1 _0753_ sky130_fd_sc_hd__o211ai_1
X_3184_ clknet_leaf_25_clk _0142_ net101 vssd1 vssd1 vccd1 vccd1 MATMULT_INST.matmult_inst.mem_inst.mem2\[9\]
+ sky130_fd_sc_hd__dfrtp_1
XFILLER_78_191 vssd1 vssd1 vccd1 vccd1 sky130_fd_sc_hd__fill_4
X_2135_ _0677_ _0684_ _0685_ vssd1 vssd1 vccd1 vccd1 _0686_ sky130_fd_sc_hd__nand3_1
XANTENNA__2737__B net198 vssd1 vssd1 vccd1 vccd1 sky130_fd_sc_hd__diode_2
X_2066_ _0619_ _0620_ net671 net68 vssd1 vssd1 vccd1 vccd1 _0294_ sky130_fd_sc_hd__a2bb2o_1
XANTENNA_fanout158_A net159 vssd1 vssd1 vccd1 vccd1 sky130_fd_sc_hd__diode_2
XTAP_TAPCELL_ROW_32_440 vssd1 vccd1 sky130_fd_sc_hd__tapvpwrvgnd_1
X_2968_ net155 MATMULT_INST.matmult_inst.mem_inst.mem0\[9\] MATMULT_INST.matmult_inst.mem_inst.matrixB0\[9\]
+ net160 vssd1 vssd1 vccd1 vccd1 _1394_ sky130_fd_sc_hd__a22o_1
X_1919_ net232 net624 net53 vssd1 vssd1 vccd1 vccd1 _0247_ sky130_fd_sc_hd__mux2_1
X_2899_ _1339_ _1356_ _1364_ vssd1 vssd1 vccd1 vccd1 _1365_ sky130_fd_sc_hd__a21o_1
XFILLER_1_305 vccd1 vssd1 vccd1 vssd1 sky130_ef_sc_hd__decap_40_12
XFILLER_1_349 vccd1 vssd1 vccd1 vssd1 sky130_ef_sc_hd__decap_40_12
XANTENNA__2487__X _1000_ vssd1 vssd1 vccd1 vccd1 sky130_fd_sc_hd__diode_2
XTAP_TAPCELL_ROW_75_808 vssd1 vccd1 sky130_fd_sc_hd__tapvpwrvgnd_1
XFILLER_27_43 vccd1 vssd1 vccd1 vssd1 sky130_ef_sc_hd__decap_40_12
XFILLER_13_423 vccd1 vssd1 vccd1 vssd1 sky130_ef_sc_hd__decap_40_12
XFILLER_25_261 vssd1 vssd1 vccd1 vccd1 sky130_fd_sc_hd__fill_2
XFILLER_13_456 vssd1 vssd1 vccd1 vccd1 sky130_fd_sc_hd__fill_1
XFILLER_9_405 vccd1 vssd1 vccd1 vssd1 sky130_ef_sc_hd__decap_40_12
XANTENNA__2382__B net67 vssd1 vssd1 vccd1 vccd1 sky130_fd_sc_hd__diode_2
XFILLER_43_53 vssd1 vssd1 vccd1 vccd1 sky130_fd_sc_hd__fill_2
XANTENNA_fanout26_X net26 vssd1 vssd1 vccd1 vccd1 sky130_fd_sc_hd__diode_2
XFILLER_9_449 vccd1 vssd1 vccd1 vssd1 sky130_ef_sc_hd__decap_40_12
XFILLER_40_286 vssd1 vssd1 vccd1 vccd1 sky130_fd_sc_hd__fill_1
XANTENNA__3495__CLK net242 vssd1 vssd1 vccd1 vccd1 sky130_fd_sc_hd__diode_2
XFILLER_4_121 vccd1 vssd1 vccd1 vssd1 sky130_ef_sc_hd__decap_40_12
XFILLER_4_165 vccd1 vssd1 vccd1 vssd1 sky130_ef_sc_hd__decap_40_12
XFILLER_68_83 vssd1 vssd1 vccd1 vccd1 sky130_fd_sc_hd__fill_1
XFILLER_0_393 vssd1 vssd1 vccd1 vccd1 sky130_fd_sc_hd__fill_2
XANTENNA__2049__S net54 vssd1 vssd1 vccd1 vccd1 sky130_fd_sc_hd__diode_2
XFILLER_63_345 vssd1 vssd1 vccd1 vccd1 sky130_fd_sc_hd__fill_1
XANTENNA__1888__S net10 vssd1 vssd1 vccd1 vccd1 sky130_fd_sc_hd__diode_2
XTAP_TAPCELL_ROW_46_565 vssd1 vccd1 sky130_fd_sc_hd__tapvpwrvgnd_1
XANTENNA__2066__B2 net68 vssd1 vssd1 vccd1 vccd1 sky130_fd_sc_hd__diode_2
X_2822_ net203 _1289_ _1288_ vssd1 vssd1 vccd1 vccd1 _1291_ sky130_fd_sc_hd__a21bo_1
X_2753_ _1218_ _1222_ _1223_ vssd1 vssd1 vccd1 vccd1 _1224_ sky130_fd_sc_hd__and3_1
X_1704_ net585 net48 net24 vssd1 vssd1 vccd1 vccd1 _0055_ sky130_fd_sc_hd__mux2_1
XFILLER_8_493 vssd1 vssd1 vccd1 vccd1 sky130_fd_sc_hd__fill_1
X_2684_ _1144_ _1156_ _1143_ vssd1 vssd1 vccd1 vccd1 _1157_ sky130_fd_sc_hd__o21ba_1
X_1635_ net5 net1 vssd1 vssd1 vccd1 vccd1 _0468_ sky130_fd_sc_hd__nand2_1
X_1566_ MATMULT_INST.matmult_inst.spi_inst.mosi_shifter\[0\] MATMULT_INST.matmult_inst.spi_inst.mosi_data_spi\[1\]
+ _1491_ vssd1 vssd1 vccd1 vccd1 _0392_ sky130_fd_sc_hd__mux2_1
X_3305_ clknet_leaf_1_clk _0263_ net108 vssd1 vssd1 vccd1 vccd1 MATMULT_INST.matmult_inst.alu_inst.out\[5\]
+ sky130_fd_sc_hd__dfrtp_1
XANTENNA__2748__A net189 vssd1 vssd1 vccd1 vccd1 sky130_fd_sc_hd__diode_2
XFILLER_58_139 vssd1 vssd1 vccd1 vccd1 sky130_fd_sc_hd__fill_1
X_3236_ clknet_leaf_14_clk _0194_ net144 vssd1 vssd1 vccd1 vccd1 MATMULT_INST.matmult_inst.mem_inst.matrixB2\[7\]
+ sky130_fd_sc_hd__dfrtp_1
X_3167_ clknet_leaf_17_clk _0125_ net121 vssd1 vssd1 vccd1 vccd1 MATMULT_INST.matmult_inst.mem_inst.matrixB1\[10\]
+ sky130_fd_sc_hd__dfrtp_1
X_3098_ clknet_leaf_22_clk _0056_ net118 vssd1 vssd1 vccd1 vccd1 MATMULT_INST.matmult_inst.mem_inst.matrixB0\[13\]
+ sky130_fd_sc_hd__dfrtp_1
X_2118_ _0668_ _0669_ vssd1 vssd1 vccd1 vccd1 _0670_ sky130_fd_sc_hd__nand2_1
XFILLER_14_209 vccd1 vssd1 vccd1 vssd1 sky130_ef_sc_hd__decap_40_12
XTAP_TAPCELL_ROW_1_179 vssd1 vccd1 sky130_fd_sc_hd__tapvpwrvgnd_1
XANTENNA__2483__A net177 vssd1 vssd1 vccd1 vccd1 sky130_fd_sc_hd__diode_2
X_2049_ net185 net425 net54 vssd1 vssd1 vccd1 vccd1 _0290_ sky130_fd_sc_hd__mux2_1
Xfanout13 _0517_ vssd1 vssd1 vccd1 vccd1 net13 sky130_fd_sc_hd__clkbuf_4
XFILLER_22_231 vssd1 vssd1 vccd1 vccd1 sky130_fd_sc_hd__fill_1
Xfanout46 _0499_ vssd1 vssd1 vccd1 vccd1 net46 sky130_fd_sc_hd__clkbuf_2
Xfanout24 _0484_ vssd1 vssd1 vccd1 vccd1 net24 sky130_fd_sc_hd__buf_4
XANTENNA_clkbuf_leaf_18_clk_A clknet_2_2__leaf_clk vssd1 vssd1 vccd1 vccd1 sky130_fd_sc_hd__diode_2
Xfanout35 _0489_ vssd1 vssd1 vccd1 vccd1 net35 sky130_fd_sc_hd__clkbuf_2
XANTENNA__3006__B1 net77 vssd1 vssd1 vccd1 vccd1 sky130_fd_sc_hd__diode_2
Xfanout79 net80 vssd1 vssd1 vccd1 vccd1 net79 sky130_fd_sc_hd__clkbuf_4
XANTENNA_fanout230_X net230 vssd1 vssd1 vccd1 vccd1 sky130_fd_sc_hd__diode_2
Xfanout57 net58 vssd1 vssd1 vccd1 vccd1 net57 sky130_fd_sc_hd__clkbuf_4
Xfanout68 _0609_ vssd1 vssd1 vccd1 vccd1 net68 sky130_fd_sc_hd__buf_2
XFILLER_13_67 vssd1 vssd1 vccd1 vccd1 sky130_fd_sc_hd__fill_1
XFILLER_6_419 vssd1 vssd1 vccd1 vccd1 sky130_fd_sc_hd__fill_1
XTAP_TAPCELL_ROW_9_246 vssd1 vccd1 sky130_fd_sc_hd__tapvpwrvgnd_1
XFILLER_1_113 vccd1 vssd1 vccd1 vssd1 sky130_ef_sc_hd__decap_40_12
XANTENNA_fanout90_A net91 vssd1 vssd1 vccd1 vccd1 sky130_fd_sc_hd__diode_2
XFILLER_38_20 vssd1 vssd1 vccd1 vccd1 sky130_fd_sc_hd__fill_8
XFILLER_72_153 vssd1 vssd1 vccd1 vccd1 sky130_fd_sc_hd__fill_1
XFILLER_54_63 vssd1 vssd1 vccd1 vccd1 sky130_fd_sc_hd__fill_1
XTAP_TAPCELL_ROW_43_535 vssd1 vccd1 sky130_fd_sc_hd__tapvpwrvgnd_1
XANTENNA__3001__B net167 vssd1 vssd1 vccd1 vccd1 sky130_fd_sc_hd__diode_2
XFILLER_9_279 vssd1 vssd1 vccd1 vccd1 sky130_fd_sc_hd__fill_1
Xclkload16 clknet_leaf_21_clk vssd1 vssd1 vccd1 vccd1 clkload16/Y sky130_fd_sc_hd__clkinv_8
XFILLER_5_441 vssd1 vssd1 vccd1 vccd1 sky130_fd_sc_hd__fill_4
XFILLER_5_485 vssd1 vssd1 vccd1 vccd1 sky130_fd_sc_hd__fill_4
XFILLER_79_93 vssd1 vssd1 vccd1 vccd1 sky130_fd_sc_hd__fill_1
XFILLER_79_82 vssd1 vssd1 vccd1 vccd1 sky130_fd_sc_hd__fill_2
X_3021_ net155 MATMULT_INST.matmult_inst.mem_inst.mem0\[14\] MATMULT_INST.matmult_inst.mem_inst.matrixB0\[14\]
+ net161 vssd1 vssd1 vccd1 vccd1 _1442_ sky130_fd_sc_hd__a22o_1
XFILLER_63_186 vssd1 vssd1 vccd1 vccd1 sky130_fd_sc_hd__fill_2
X_2805_ _1272_ _1273_ _1262_ vssd1 vssd1 vccd1 vccd1 _1275_ sky130_fd_sc_hd__a21o_1
XTAP_TAPCELL_ROW_14_292 vssd1 vccd1 sky130_fd_sc_hd__tapvpwrvgnd_1
X_2736_ _1166_ _1202_ _1204_ vssd1 vssd1 vccd1 vccd1 _1207_ sky130_fd_sc_hd__a21o_1
X_2667_ _1119_ _1136_ _1137_ _1138_ vssd1 vssd1 vccd1 vccd1 _1140_ sky130_fd_sc_hd__nand4_1
X_1618_ MATMULT_INST.matmult_inst.fsm_inst.rx_ready_edge _1528_ _1533_ _1535_ vssd1
+ vssd1 vccd1 vccd1 _1536_ sky130_fd_sc_hd__a211oi_2
Xfanout214 MATMULT_INST.matmult_inst.alu_inst.a0_reg\[6\] vssd1 vssd1 vccd1 vccd1
+ net214 sky130_fd_sc_hd__buf_2
Xfanout203 MATMULT_INST.matmult_inst.alu_inst.b1_reg\[5\] vssd1 vssd1 vccd1 vccd1
+ net203 sky130_fd_sc_hd__buf_2
X_2598_ _1068_ _1074_ vssd1 vssd1 vccd1 vccd1 _1075_ sky130_fd_sc_hd__and2_1
X_1549_ MATMULT_INST.matmult_inst.spi_inst.mosi_shifter\[6\] MATMULT_INST.matmult_inst.spi_inst.mosi_shifter\[5\]
+ _1488_ vssd1 vssd1 vccd1 vccd1 _0407_ sky130_fd_sc_hd__mux2_1
XTAP_TAPCELL_ROW_6_227 vssd1 vccd1 sky130_fd_sc_hd__tapvpwrvgnd_1
Xfanout236 MATMULT_INST.matmult_inst.alu_inst.b0_reg\[3\] vssd1 vssd1 vccd1 vccd1
+ net236 sky130_fd_sc_hd__clkbuf_2
Xfanout225 net226 vssd1 vssd1 vccd1 vccd1 net225 sky130_fd_sc_hd__buf_2
XANTENNA__2478__A net166 vssd1 vssd1 vccd1 vccd1 sky130_fd_sc_hd__diode_2
XFILLER_75_18 vccd1 vssd1 vccd1 vssd1 sky130_ef_sc_hd__decap_40_12
X_3219_ clknet_leaf_17_clk _0177_ net128 vssd1 vssd1 vccd1 vccd1 MATMULT_INST.matmult_inst.mem_inst.mem1\[8\]
+ sky130_fd_sc_hd__dfrtp_1
XANTENNA_fanout180_X net180 vssd1 vssd1 vccd1 vccd1 sky130_fd_sc_hd__diode_2
XANTENNA__2644__C MATMULT_INST.matmult_inst.alu_inst.a1_reg\[4\] vssd1 vssd1 vccd1
+ vccd1 sky130_fd_sc_hd__diode_2
XFILLER_54_164 vssd1 vssd1 vccd1 vccd1 sky130_fd_sc_hd__fill_1
XFILLER_54_197 vssd1 vssd1 vccd1 vccd1 sky130_fd_sc_hd__fill_4
XFILLER_24_44 vssd1 vssd1 vccd1 vccd1 sky130_fd_sc_hd__fill_1
XTAP_TAPCELL_ROW_40_516 vssd1 vccd1 sky130_fd_sc_hd__tapvpwrvgnd_1
XFILLER_10_245 vssd1 vssd1 vccd1 vccd1 sky130_fd_sc_hd__fill_4
XFILLER_10_289 vccd1 vssd1 vccd1 vssd1 sky130_ef_sc_hd__decap_40_12
XFILLER_6_249 vssd1 vssd1 vccd1 vccd1 sky130_fd_sc_hd__fill_2
XANTENNA_fanout93_X net93 vssd1 vssd1 vccd1 vccd1 sky130_fd_sc_hd__diode_2
XFILLER_2_433 vccd1 vssd1 vccd1 vssd1 sky130_ef_sc_hd__decap_40_12
XFILLER_77_223 vssd1 vssd1 vccd1 vccd1 sky130_fd_sc_hd__fill_1
XFILLER_2_477 vccd1 vssd1 vccd1 vssd1 sky130_ef_sc_hd__decap_40_12
Xhold290 MATMULT_INST.matmult_inst.mem_inst.matrixB0\[8\] vssd1 vssd1 vccd1 vccd1
+ net603 sky130_fd_sc_hd__dlygate4sd3_1
XFILLER_1_15 vccd1 vssd1 vccd1 vssd1 sky130_ef_sc_hd__decap_40_12
XFILLER_45_120 vssd1 vssd1 vccd1 vccd1 sky130_fd_sc_hd__fill_8
XANTENNA__1738__Y _0508_ vssd1 vssd1 vccd1 vccd1 sky130_fd_sc_hd__diode_2
XANTENNA__2992__A2 net87 vssd1 vssd1 vccd1 vccd1 sky130_fd_sc_hd__diode_2
XTAP_TAPCELL_ROW_11_262 vssd1 vccd1 sky130_fd_sc_hd__tapvpwrvgnd_1
X_2521_ net163 _1025_ _1029_ net166 vssd1 vssd1 vccd1 vccd1 _1031_ sky130_fd_sc_hd__a22o_1
XFILLER_5_293 vccd1 vssd1 vccd1 vssd1 sky130_ef_sc_hd__decap_40_12
XFILLER_46_3 vccd1 vssd1 vccd1 vssd1 sky130_ef_sc_hd__decap_40_12
X_2452_ net181 net175 MATMULT_INST.matmult_inst.mem_inst.mem3\[2\] vssd1 vssd1 vccd1
+ vccd1 _0967_ sky130_fd_sc_hd__and3_1
XPHY_EDGE_ROW_18_Right_18 vssd1 vssd1 vccd1 vccd1 sky130_fd_sc_hd__decap_3
X_2383_ _1524_ net63 vssd1 vssd1 vccd1 vccd1 _0923_ sky130_fd_sc_hd__nor2_1
Xinput3 gpio_in[1] vssd1 vssd1 vccd1 vccd1 net3 sky130_fd_sc_hd__clkbuf_2
X_3004_ MATMULT_INST.matmult_inst.mem_inst.mem2\[12\] net85 net77 MATMULT_INST.matmult_inst.mem_inst.mem1\[12\]
+ _1426_ vssd1 vssd1 vccd1 vccd1 _1427_ sky130_fd_sc_hd__a221o_1
XFILLER_64_462 vssd1 vssd1 vccd1 vccd1 sky130_fd_sc_hd__fill_1
XPHY_EDGE_ROW_27_Right_27 vssd1 vssd1 vccd1 vccd1 sky130_fd_sc_hd__decap_3
XANTENNA__2432__A1 net93 vssd1 vssd1 vccd1 vccd1 sky130_fd_sc_hd__diode_2
XANTENNA__2432__B2 net166 vssd1 vssd1 vccd1 vccd1 sky130_fd_sc_hd__diode_2
XTAP_TAPCELL_ROW_62_696 vssd1 vccd1 sky130_fd_sc_hd__tapvpwrvgnd_1
X_2719_ _1189_ _1190_ vssd1 vssd1 vccd1 vccd1 _1191_ sky130_fd_sc_hd__nand2b_1
XPHY_EDGE_ROW_36_Right_36 vssd1 vssd1 vccd1 vccd1 sky130_fd_sc_hd__decap_3
XFILLER_19_11 vssd1 vssd1 vccd1 vccd1 sky130_fd_sc_hd__fill_1
XFILLER_19_55 vssd1 vssd1 vccd1 vccd1 sky130_fd_sc_hd__fill_1
XFILLER_74_215 vssd1 vssd1 vccd1 vccd1 sky130_fd_sc_hd__fill_2
XANTENNA_fanout53_A net54 vssd1 vssd1 vccd1 vccd1 sky130_fd_sc_hd__diode_2
XFILLER_55_440 vssd1 vssd1 vccd1 vccd1 sky130_fd_sc_hd__fill_1
XFILLER_27_175 vssd1 vssd1 vccd1 vccd1 sky130_fd_sc_hd__fill_1
XPHY_EDGE_ROW_45_Right_45 vssd1 vssd1 vccd1 vccd1 sky130_fd_sc_hd__decap_3
XFILLER_30_318 vssd1 vssd1 vccd1 vccd1 sky130_fd_sc_hd__fill_1
XTAP_TAPCELL_ROW_25_387 vssd1 vccd1 sky130_fd_sc_hd__tapvpwrvgnd_1
XANTENNA__2821__D net204 vssd1 vssd1 vccd1 vccd1 sky130_fd_sc_hd__diode_2
XPHY_EDGE_ROW_54_Right_54 vssd1 vssd1 vccd1 vccd1 sky130_fd_sc_hd__decap_3
XANTENNA__2846__A net203 vssd1 vssd1 vccd1 vccd1 sky130_fd_sc_hd__diode_2
XPHY_EDGE_ROW_63_Right_63 vssd1 vssd1 vccd1 vccd1 sky130_fd_sc_hd__decap_3
XFILLER_65_248 vccd1 vssd1 vccd1 vssd1 sky130_ef_sc_hd__decap_40_12
XFILLER_73_281 vssd1 vssd1 vccd1 vccd1 sky130_fd_sc_hd__fill_4
XTAP_TAPCELL_ROW_16_310 vssd1 vccd1 sky130_fd_sc_hd__tapvpwrvgnd_1
XFILLER_18_197 vccd1 vssd1 vccd1 vssd1 sky130_ef_sc_hd__decap_40_12
XANTENNA__1896__S net27 vssd1 vssd1 vccd1 vccd1 sky130_fd_sc_hd__diode_2
X_1952_ MATMULT_INST.matmult_inst.alu_inst.adder_inst.r1.fa0.b MATMULT_INST.matmult_inst.alu_inst.adder_inst.r1.fa0.a
+ vssd1 vssd1 vccd1 vccd1 _0539_ sky130_fd_sc_hd__nand2_1
X_1883_ net623 net52 net10 vssd1 vssd1 vccd1 vccd1 _0213_ sky130_fd_sc_hd__mux2_1
XPHY_EDGE_ROW_72_Right_72 vssd1 vssd1 vccd1 vccd1 sky130_fd_sc_hd__decap_3
X_2504_ MATMULT_INST.matmult_inst.mem_inst.matrixA0\[6\] net65 _1014_ net93 vssd1
+ vssd1 vccd1 vccd1 _1015_ sky130_fd_sc_hd__a22o_1
X_3484_ clknet_leaf_11_clk net329 net139 vssd1 vssd1 vccd1 vccd1 MATMULT_INST.matmult_inst.fsm_inst.rx_data\[2\]
+ sky130_fd_sc_hd__dfrtp_1
X_2435_ net75 _0951_ vssd1 vssd1 vccd1 vccd1 _0952_ sky130_fd_sc_hd__and2_2
Xteam_02_308 vssd1 vssd1 vccd1 vccd1 gpio_oeb[28] team_02_308/LO sky130_fd_sc_hd__conb_1
X_2366_ _0909_ vssd1 vssd1 vccd1 vccd1 _0910_ sky130_fd_sc_hd__inv_2
X_2297_ _0841_ _0843_ vssd1 vssd1 vccd1 vccd1 _0844_ sky130_fd_sc_hd__nand2b_1
XTAP_TAPCELL_ROW_67_744 vssd1 vccd1 sky130_fd_sc_hd__tapvpwrvgnd_1
XFILLER_71_218 vssd1 vssd1 vccd1 vccd1 sky130_fd_sc_hd__fill_1
XFILLER_24_101 vssd1 vssd1 vccd1 vccd1 sky130_fd_sc_hd__fill_4
XFILLER_12_307 vssd1 vssd1 vccd1 vccd1 sky130_fd_sc_hd__fill_1
XTAP_TAPCELL_ROW_50_600 vssd1 vccd1 sky130_fd_sc_hd__tapvpwrvgnd_1
XTAP_TAPCELL_ROW_22_357 vssd1 vccd1 sky130_fd_sc_hd__tapvpwrvgnd_1
XANTENNA__2956__A2 net88 vssd1 vssd1 vccd1 vccd1 sky130_fd_sc_hd__diode_2
XFILLER_79_307 vssd1 vssd1 vccd1 vccd1 sky130_fd_sc_hd__fill_1
XFILLER_46_64 vssd1 vssd1 vccd1 vccd1 sky130_fd_sc_hd__fill_1
XFILLER_46_75 vssd1 vssd1 vccd1 vccd1 sky130_fd_sc_hd__fill_1
XFILLER_62_85 vssd1 vssd1 vccd1 vccd1 sky130_fd_sc_hd__fill_4
XFILLER_11_373 vccd1 vssd1 vccd1 vssd1 sky130_ef_sc_hd__decap_40_12
XFILLER_7_333 vssd1 vssd1 vccd1 vccd1 sky130_fd_sc_hd__fill_2
XFILLER_7_69 vccd1 vssd1 vccd1 vssd1 sky130_ef_sc_hd__decap_40_12
X_2220_ net216 net235 net238 net214 vssd1 vssd1 vccd1 vccd1 _0769_ sky130_fd_sc_hd__a22o_1
XANTENNA__2576__A net183 vssd1 vssd1 vccd1 vccd1 sky130_fd_sc_hd__diode_2
X_2151_ _0700_ _0701_ _0667_ vssd1 vssd1 vccd1 vccd1 _0702_ sky130_fd_sc_hd__a21oi_1
X_2082_ net226 net234 net236 net223 vssd1 vssd1 vccd1 vccd1 _0635_ sky130_fd_sc_hd__a22o_1
XTAP_TAPCELL_ROW_64_714 vssd1 vccd1 sky130_fd_sc_hd__tapvpwrvgnd_1
XTAP_TAPCELL_ROW_72_780 vssd1 vccd1 sky130_fd_sc_hd__tapvpwrvgnd_1
XFILLER_21_104 vssd1 vssd1 vccd1 vccd1 sky130_fd_sc_hd__fill_8
X_2984_ MATMULT_INST.matmult_inst.mem_inst.matrixA2\[10\] net86 net78 MATMULT_INST.matmult_inst.mem_inst.matrixA1\[10\]
+ _1408_ vssd1 vssd1 vccd1 vccd1 _1409_ sky130_fd_sc_hd__a221o_1
X_1935_ _0523_ _0524_ vssd1 vssd1 vccd1 vccd1 _0525_ sky130_fd_sc_hd__nor2_1
X_1866_ net476 net50 net12 vssd1 vssd1 vccd1 vccd1 _0197_ sky130_fd_sc_hd__mux2_1
X_1797_ net608 net43 net30 vssd1 vssd1 vccd1 vccd1 _0132_ sky130_fd_sc_hd__mux2_1
XANTENNA_fanout103_A net152 vssd1 vssd1 vccd1 vccd1 sky130_fd_sc_hd__diode_2
XANTENNA__2571__A0 _1022_ vssd1 vssd1 vccd1 vccd1 sky130_fd_sc_hd__diode_2
X_3467_ clknet_leaf_14_clk _0411_ net131 vssd1 vssd1 vccd1 vccd1 MATMULT_INST.matmult_inst.mem_inst.matrixB3\[3\]
+ sky130_fd_sc_hd__dfrtp_1
X_3398_ clknet_leaf_6_clk _0352_ net106 vssd1 vssd1 vccd1 vccd1 MATMULT_INST.matmult_inst.alu_inst.row1\[0\]
+ sky130_fd_sc_hd__dfrtp_1
X_2418_ _0930_ _0937_ _0936_ vssd1 vssd1 vccd1 vccd1 _0329_ sky130_fd_sc_hd__o21ai_1
X_2349_ _0887_ _0893_ vssd1 vssd1 vccd1 vccd1 _0894_ sky130_fd_sc_hd__xnor2_1
XTAP_TAPCELL_ROW_27_405 vssd1 vccd1 sky130_fd_sc_hd__tapvpwrvgnd_1
XPHY_EDGE_ROW_0_Right_0 vssd1 vssd1 vccd1 vccd1 sky130_fd_sc_hd__decap_3
XTAP_TAPCELL_ROW_35_471 vssd1 vccd1 sky130_fd_sc_hd__tapvpwrvgnd_1
XFILLER_32_22 vssd1 vssd1 vccd1 vccd1 sky130_fd_sc_hd__fill_4
XANTENNA__3051__B2 net160 vssd1 vssd1 vccd1 vccd1 sky130_fd_sc_hd__diode_2
XANTENNA__3051__A1 net165 vssd1 vssd1 vccd1 vccd1 sky130_fd_sc_hd__diode_2
XFILLER_32_66 vccd1 vssd1 vccd1 vssd1 sky130_ef_sc_hd__decap_40_12
XTAP_TAPCELL_ROW_78_839 vssd1 vccd1 sky130_fd_sc_hd__tapvpwrvgnd_1
XFILLER_57_41 vssd1 vssd1 vccd1 vccd1 sky130_fd_sc_hd__fill_4
XANTENNA__2843__B net198 vssd1 vssd1 vccd1 vccd1 sky130_fd_sc_hd__diode_2
XFILLER_31_457 vssd1 vssd1 vccd1 vccd1 sky130_fd_sc_hd__fill_1
XFILLER_11_181 vccd1 vssd1 vccd1 vssd1 sky130_ef_sc_hd__decap_40_12
X_1720_ net393 net37 net23 vssd1 vssd1 vccd1 vccd1 _0063_ sky130_fd_sc_hd__mux2_1
Xhold108 MATMULT_INST.matmult_inst.mem_inst.mem0\[3\] vssd1 vssd1 vccd1 vccd1 net421
+ sky130_fd_sc_hd__dlygate4sd3_1
X_1651_ net154 MATMULT_INST.matmult_inst.spi_inst.tx_reg_sys\[0\] vssd1 vssd1 vccd1
+ vccd1 _0006_ sky130_fd_sc_hd__and2b_1
Xhold119 MATMULT_INST.matmult_inst.mem_inst.matrixB0\[2\] vssd1 vssd1 vccd1 vccd1
+ net432 sky130_fd_sc_hd__dlygate4sd3_1
X_3321_ clknet_leaf_5_clk _0279_ net107 vssd1 vssd1 vccd1 vccd1 MATMULT_INST.matmult_inst.alu_inst.b1_reg\[3\]
+ sky130_fd_sc_hd__dfrtp_1
X_1582_ _1500_ _1501_ vssd1 vssd1 vccd1 vccd1 _1502_ sky130_fd_sc_hd__nor2_2
XFILLER_3_391 vssd1 vssd1 vccd1 vccd1 sky130_fd_sc_hd__fill_1
X_3252_ clknet_leaf_15_clk _0210_ net143 vssd1 vssd1 vccd1 vccd1 MATMULT_INST.matmult_inst.mem_inst.mem0\[5\]
+ sky130_fd_sc_hd__dfrtp_1
X_2203_ _0713_ _0722_ _0751_ _0714_ vssd1 vssd1 vccd1 vccd1 _0752_ sky130_fd_sc_hd__o211a_1
X_3183_ clknet_leaf_17_clk _0141_ net128 vssd1 vssd1 vccd1 vccd1 MATMULT_INST.matmult_inst.mem_inst.mem2\[8\]
+ sky130_fd_sc_hd__dfrtp_1
X_2134_ _0682_ _0683_ _0653_ vssd1 vssd1 vccd1 vccd1 _0685_ sky130_fd_sc_hd__a21o_1
X_2065_ _0612_ _0618_ net71 vssd1 vssd1 vccd1 vccd1 _0620_ sky130_fd_sc_hd__o21ai_1
XTAP_TAPCELL_ROW_49_585 vssd1 vccd1 sky130_fd_sc_hd__tapvpwrvgnd_1
XPHY_EDGE_ROW_22_Left_102 vssd1 vssd1 vccd1 vccd1 sky130_fd_sc_hd__decap_3
XTAP_TAPCELL_ROW_32_441 vssd1 vccd1 sky130_fd_sc_hd__tapvpwrvgnd_1
X_2967_ MATMULT_INST.matmult_inst.mem_inst.matrixB2\[9\] net89 net81 MATMULT_INST.matmult_inst.mem_inst.matrixB1\[9\]
+ _1392_ vssd1 vssd1 vccd1 vccd1 _1393_ sky130_fd_sc_hd__a221o_1
X_1918_ net234 net592 net53 vssd1 vssd1 vccd1 vccd1 _0246_ sky130_fd_sc_hd__mux2_1
X_2898_ _1337_ _1363_ vssd1 vssd1 vccd1 vccd1 _1364_ sky130_fd_sc_hd__xnor2_1
X_1849_ net581 net48 net28 vssd1 vssd1 vccd1 vccd1 _0181_ sky130_fd_sc_hd__mux2_1
XFILLER_78_29 vccd1 vssd1 vccd1 vssd1 sky130_ef_sc_hd__decap_40_12
XPHY_EDGE_ROW_31_Left_111 vssd1 vssd1 vccd1 vccd1 sky130_fd_sc_hd__decap_3
XFILLER_1_317 vccd1 vssd1 vccd1 vssd1 sky130_ef_sc_hd__decap_40_12
X_3519_ clknet_leaf_17_clk _0444_ net121 vssd1 vssd1 vccd1 vccd1 MATMULT_INST.matmult_inst.spi_inst.tx_reg_sys\[10\]
+ sky130_fd_sc_hd__dfrtp_1
XTAP_TAPCELL_ROW_75_809 vssd1 vccd1 sky130_fd_sc_hd__tapvpwrvgnd_1
XFILLER_69_181 vccd1 vssd1 vccd1 vssd1 sky130_ef_sc_hd__decap_40_12
XFILLER_17_229 vssd1 vssd1 vccd1 vccd1 sky130_fd_sc_hd__fill_2
XFILLER_27_55 vssd1 vssd1 vccd1 vccd1 sky130_fd_sc_hd__fill_1
XPHY_EDGE_ROW_40_Left_120 vssd1 vssd1 vccd1 vccd1 sky130_fd_sc_hd__decap_3
XANTENNA__2155__S net71 vssd1 vssd1 vccd1 vccd1 sky130_fd_sc_hd__diode_2
XFILLER_13_435 vssd1 vssd1 vccd1 vccd1 sky130_fd_sc_hd__fill_2
XFILLER_9_417 vccd1 vssd1 vccd1 vssd1 sky130_ef_sc_hd__decap_40_12
XANTENNA_fanout19_X net19 vssd1 vssd1 vccd1 vccd1 sky130_fd_sc_hd__diode_2
Xclkbuf_leaf_20_clk clknet_2_2__leaf_clk vssd1 vssd1 vccd1 vccd1 clknet_leaf_20_clk
+ sky130_fd_sc_hd__clkbuf_8
XFILLER_4_133 vssd1 vssd1 vccd1 vccd1 sky130_fd_sc_hd__fill_4
XFILLER_4_15 vccd1 vssd1 vccd1 vssd1 sky130_ef_sc_hd__decap_40_12
XFILLER_4_177 vccd1 vssd1 vccd1 vssd1 sky130_ef_sc_hd__decap_40_12
XFILLER_0_361 vssd1 vssd1 vccd1 vccd1 sky130_fd_sc_hd__fill_2
XANTENNA__3015__A net176 vssd1 vssd1 vccd1 vccd1 sky130_fd_sc_hd__diode_2
XTAP_TAPCELL_ROW_46_566 vssd1 vccd1 sky130_fd_sc_hd__tapvpwrvgnd_1
XFILLER_16_284 vssd1 vssd1 vccd1 vccd1 sky130_fd_sc_hd__fill_1
X_2821_ net187 net186 net203 net204 vssd1 vssd1 vccd1 vccd1 _1290_ sky130_fd_sc_hd__and4_1
Xclkbuf_leaf_11_clk clknet_2_3__leaf_clk vssd1 vssd1 vccd1 vccd1 clknet_leaf_11_clk
+ sky130_fd_sc_hd__clkbuf_8
X_2752_ _1219_ _1220_ _1221_ vssd1 vssd1 vccd1 vccd1 _1223_ sky130_fd_sc_hd__nand3b_1
X_1703_ MATMULT_INST.matmult_inst.fsm_inst.alu_result\[12\] net60 vssd1 vssd1 vccd1
+ vccd1 _0497_ sky130_fd_sc_hd__and2_1
X_2683_ _1147_ _1155_ vssd1 vssd1 vccd1 vccd1 _1156_ sky130_fd_sc_hd__xor2_1
X_1634_ net166 _0464_ net59 _0460_ _0466_ vssd1 vssd1 vccd1 vccd1 _0000_ sky130_fd_sc_hd__a221o_1
X_1565_ MATMULT_INST.matmult_inst.spi_inst.mosi_shifter\[1\] MATMULT_INST.matmult_inst.spi_inst.mosi_data_spi\[2\]
+ _1491_ vssd1 vssd1 vccd1 vccd1 _0393_ sky130_fd_sc_hd__mux2_1
X_3304_ clknet_leaf_1_clk _0262_ net108 vssd1 vssd1 vccd1 vccd1 MATMULT_INST.matmult_inst.alu_inst.out\[4\]
+ sky130_fd_sc_hd__dfrtp_1
X_3235_ clknet_leaf_13_clk _0193_ net146 vssd1 vssd1 vccd1 vccd1 MATMULT_INST.matmult_inst.mem_inst.matrixB2\[6\]
+ sky130_fd_sc_hd__dfrtp_1
X_3166_ clknet_leaf_25_clk _0124_ net102 vssd1 vssd1 vccd1 vccd1 MATMULT_INST.matmult_inst.mem_inst.matrixB1\[9\]
+ sky130_fd_sc_hd__dfrtp_1
XFILLER_66_162 vssd1 vssd1 vccd1 vccd1 sky130_fd_sc_hd__fill_8
X_3097_ clknet_leaf_23_clk _0055_ net98 vssd1 vssd1 vccd1 vccd1 MATMULT_INST.matmult_inst.mem_inst.matrixB0\[12\]
+ sky130_fd_sc_hd__dfrtp_1
X_2117_ _0639_ _0644_ _0638_ vssd1 vssd1 vccd1 vccd1 _0669_ sky130_fd_sc_hd__o21ba_1
XANTENNA_fanout170_A net171 vssd1 vssd1 vccd1 vccd1 sky130_fd_sc_hd__diode_2
XFILLER_54_313 vssd1 vssd1 vccd1 vccd1 sky130_fd_sc_hd__fill_1
XANTENNA__2483__B net168 vssd1 vssd1 vccd1 vccd1 sky130_fd_sc_hd__diode_2
X_2048_ net187 net359 net54 vssd1 vssd1 vccd1 vccd1 _0289_ sky130_fd_sc_hd__mux2_1
XFILLER_22_221 vssd1 vssd1 vccd1 vccd1 sky130_fd_sc_hd__fill_8
Xfanout47 _0498_ vssd1 vssd1 vccd1 vccd1 net47 sky130_fd_sc_hd__clkbuf_2
Xfanout36 _0488_ vssd1 vssd1 vccd1 vccd1 net36 sky130_fd_sc_hd__clkbuf_2
Xfanout14 _0515_ vssd1 vssd1 vccd1 vccd1 net14 sky130_fd_sc_hd__buf_4
Xfanout25 _0484_ vssd1 vssd1 vccd1 vccd1 net25 sky130_fd_sc_hd__clkbuf_4
Xfanout58 MATMULT_INST.matmult_inst.fsm_inst.load vssd1 vssd1 vccd1 vccd1 net58 sky130_fd_sc_hd__clkbuf_4
Xfanout69 net70 vssd1 vssd1 vccd1 vccd1 net69 sky130_fd_sc_hd__buf_2
XANTENNA__2517__B1 net83 vssd1 vssd1 vccd1 vccd1 sky130_fd_sc_hd__diode_2
XTAP_TAPCELL_ROW_9_247 vssd1 vccd1 sky130_fd_sc_hd__tapvpwrvgnd_1
XFILLER_1_125 vccd1 vssd1 vccd1 vssd1 sky130_ef_sc_hd__decap_40_12
XANTENNA__2498__X _1010_ vssd1 vssd1 vccd1 vccd1 sky130_fd_sc_hd__diode_2
XFILLER_1_169 vccd1 vssd1 vccd1 vssd1 sky130_ef_sc_hd__decap_40_12
XANTENNA_fanout83_A net84 vssd1 vssd1 vccd1 vccd1 sky130_fd_sc_hd__diode_2
XFILLER_77_449 vccd1 vssd1 vccd1 vssd1 sky130_ef_sc_hd__decap_40_12
XFILLER_38_43 vccd1 vssd1 vccd1 vssd1 sky130_ef_sc_hd__decap_40_12
XFILLER_57_184 vssd1 vssd1 vccd1 vccd1 sky130_fd_sc_hd__fill_4
XFILLER_54_42 vssd1 vssd1 vccd1 vccd1 sky130_fd_sc_hd__fill_1
XFILLER_60_305 vssd1 vssd1 vccd1 vccd1 sky130_fd_sc_hd__fill_1
XFILLER_13_221 vssd1 vssd1 vccd1 vccd1 sky130_fd_sc_hd__fill_2
XTAP_TAPCELL_ROW_43_536 vssd1 vccd1 sky130_fd_sc_hd__tapvpwrvgnd_1
XFILLER_9_225 vccd1 vssd1 vccd1 vssd1 sky130_ef_sc_hd__decap_40_12
XFILLER_70_85 vccd1 vssd1 vccd1 vssd1 sky130_ef_sc_hd__decap_40_12
Xclkload17 clknet_leaf_22_clk vssd1 vssd1 vccd1 vccd1 clkload17/Y sky130_fd_sc_hd__inv_8
XANTENNA__1737__B net172 vssd1 vssd1 vccd1 vccd1 sky130_fd_sc_hd__diode_2
XANTENNA__2220__A2 net235 vssd1 vssd1 vccd1 vccd1 sky130_fd_sc_hd__diode_2
XANTENNA__2508__B1 net83 vssd1 vssd1 vccd1 vccd1 sky130_fd_sc_hd__diode_2
XFILLER_48_7 vssd1 vssd1 vccd1 vccd1 sky130_fd_sc_hd__fill_1
XFILLER_76_460 vccd1 vssd1 vccd1 vssd1 sky130_ef_sc_hd__decap_40_12
X_3020_ net438 _1441_ net57 vssd1 vssd1 vccd1 vccd1 _0447_ sky130_fd_sc_hd__mux2_1
Xclkbuf_leaf_0_clk clknet_2_0__leaf_clk vssd1 vssd1 vccd1 vccd1 clknet_leaf_0_clk
+ sky130_fd_sc_hd__clkbuf_8
XANTENNA__1899__S net27 vssd1 vssd1 vccd1 vccd1 sky130_fd_sc_hd__diode_2
XFILLER_63_110 vssd1 vssd1 vccd1 vccd1 sky130_fd_sc_hd__fill_2
X_2804_ _1262_ _1272_ _1273_ vssd1 vssd1 vccd1 vccd1 _1274_ sky130_fd_sc_hd__nand3_1
XTAP_TAPCELL_ROW_14_293 vssd1 vccd1 sky130_fd_sc_hd__tapvpwrvgnd_1
XANTENNA__2750__C net192 vssd1 vssd1 vccd1 vccd1 sky130_fd_sc_hd__diode_2
X_2735_ net513 _1206_ net72 vssd1 vssd1 vccd1 vccd1 _0377_ sky130_fd_sc_hd__mux2_1
X_2666_ _1136_ _1137_ _1138_ _1119_ vssd1 vssd1 vccd1 vccd1 _1139_ sky130_fd_sc_hd__a22o_1
X_1617_ _1522_ _1534_ vssd1 vssd1 vccd1 vccd1 _1535_ sky130_fd_sc_hd__nand2_1
XANTENNA__2759__A net210 vssd1 vssd1 vccd1 vccd1 sky130_fd_sc_hd__diode_2
Xfanout204 MATMULT_INST.matmult_inst.alu_inst.b1_reg\[4\] vssd1 vssd1 vccd1 vccd1
+ net204 sky130_fd_sc_hd__buf_2
X_2597_ _1072_ _1073_ vssd1 vssd1 vccd1 vccd1 _1074_ sky130_fd_sc_hd__nor2_1
X_1548_ MATMULT_INST.matmult_inst.spi_inst.rx_bit_count\[3\] net3 _1487_ vssd1 vssd1
+ vccd1 vccd1 _1488_ sky130_fd_sc_hd__and3b_2
Xfanout215 MATMULT_INST.matmult_inst.alu_inst.a0_reg\[6\] vssd1 vssd1 vccd1 vccd1
+ net215 sky130_fd_sc_hd__clkbuf_2
Xfanout237 net238 vssd1 vssd1 vccd1 vccd1 net237 sky130_fd_sc_hd__buf_2
Xfanout226 MATMULT_INST.matmult_inst.alu_inst.a0_reg\[0\] vssd1 vssd1 vccd1 vccd1
+ net226 sky130_fd_sc_hd__clkbuf_2
X_3218_ clknet_leaf_13_clk _0176_ net145 vssd1 vssd1 vccd1 vccd1 MATMULT_INST.matmult_inst.mem_inst.mem1\[7\]
+ sky130_fd_sc_hd__dfrtp_1
X_3149_ clknet_leaf_24_clk _0107_ net119 vssd1 vssd1 vccd1 vccd1 MATMULT_INST.matmult_inst.mem_inst.mem3\[10\]
+ sky130_fd_sc_hd__dfrtp_1
XANTENNA_fanout173_X net173 vssd1 vssd1 vccd1 vccd1 sky130_fd_sc_hd__diode_2
XFILLER_54_176 vssd1 vssd1 vccd1 vccd1 sky130_fd_sc_hd__fill_2
XFILLER_24_34 vssd1 vssd1 vccd1 vccd1 sky130_fd_sc_hd__fill_4
XFILLER_24_89 vccd1 vssd1 vccd1 vssd1 sky130_ef_sc_hd__decap_40_12
XFILLER_2_401 vccd1 vssd1 vccd1 vssd1 sky130_ef_sc_hd__decap_40_12
XFILLER_6_3 vccd1 vssd1 vccd1 vssd1 sky130_ef_sc_hd__decap_40_12
XFILLER_2_445 vccd1 vssd1 vccd1 vssd1 sky130_ef_sc_hd__decap_40_12
Xhold280 MATMULT_INST.matmult_inst.mem_inst.matrixB2\[11\] vssd1 vssd1 vccd1 vccd1
+ net593 sky130_fd_sc_hd__dlygate4sd3_1
XFILLER_77_213 vssd1 vssd1 vccd1 vccd1 sky130_fd_sc_hd__fill_8
XFILLER_2_489 vssd1 vssd1 vccd1 vccd1 sky130_fd_sc_hd__fill_2
Xhold291 MATMULT_INST.matmult_inst.mem_inst.matrixB0\[16\] vssd1 vssd1 vccd1 vccd1
+ net604 sky130_fd_sc_hd__dlygate4sd3_1
XFILLER_49_53 vssd1 vssd1 vccd1 vccd1 sky130_fd_sc_hd__fill_2
XFILLER_77_279 vssd1 vssd1 vccd1 vccd1 sky130_fd_sc_hd__fill_1
XFILLER_77_257 vssd1 vssd1 vccd1 vccd1 sky130_fd_sc_hd__fill_2
XFILLER_1_27 vccd1 vssd1 vccd1 vssd1 sky130_ef_sc_hd__decap_40_12
XTAP_TAPCELL_ROW_56_650 vssd1 vccd1 sky130_fd_sc_hd__tapvpwrvgnd_1
XFILLER_60_146 vssd1 vssd1 vccd1 vccd1 sky130_fd_sc_hd__fill_4
XTAP_TAPCELL_ROW_11_263 vssd1 vccd1 sky130_fd_sc_hd__tapvpwrvgnd_1
X_2520_ net93 _1023_ _1027_ net158 vssd1 vssd1 vccd1 vccd1 _1030_ sky130_fd_sc_hd__a22o_1
X_2451_ net559 _0954_ _0966_ net66 vssd1 vssd1 vccd1 vccd1 _0333_ sky130_fd_sc_hd__a22o_1
XFILLER_5_261 vccd1 vssd1 vccd1 vssd1 sky130_ef_sc_hd__decap_40_12
XFILLER_39_3 vccd1 vssd1 vccd1 vssd1 sky130_ef_sc_hd__decap_40_12
X_2382_ net672 net67 vssd1 vssd1 vccd1 vccd1 _0308_ sky130_fd_sc_hd__and2_1
XANTENNA_clkbuf_leaf_17_clk_A clknet_2_2__leaf_clk vssd1 vssd1 vccd1 vccd1 sky130_fd_sc_hd__diode_2
Xinput4 gpio_in[2] vssd1 vssd1 vccd1 vccd1 net4 sky130_fd_sc_hd__buf_1
X_3003_ net176 net167 MATMULT_INST.matmult_inst.mem_inst.mem3\[12\] vssd1 vssd1 vccd1
+ vccd1 _1426_ sky130_fd_sc_hd__and3_1
XFILLER_49_493 vssd1 vssd1 vccd1 vccd1 sky130_fd_sc_hd__fill_1
XTAP_TAPCELL_ROW_19_330 vssd1 vccd1 sky130_fd_sc_hd__tapvpwrvgnd_1
Xclkbuf_2_1__f_clk clknet_0_clk vssd1 vssd1 vccd1 vccd1 clknet_2_1__leaf_clk sky130_fd_sc_hd__clkbuf_16
XFILLER_51_157 vssd1 vssd1 vccd1 vccd1 sky130_fd_sc_hd__fill_2
XTAP_TAPCELL_ROW_62_697 vssd1 vccd1 sky130_fd_sc_hd__tapvpwrvgnd_1
XANTENNA_fanout133_A net142 vssd1 vssd1 vccd1 vccd1 sky130_fd_sc_hd__diode_2
X_2718_ _1183_ _1187_ _1188_ vssd1 vssd1 vccd1 vccd1 _1190_ sky130_fd_sc_hd__nand3_1
XANTENNA__2489__A net182 vssd1 vssd1 vccd1 vccd1 sky130_fd_sc_hd__diode_2
X_2649_ _1116_ _1122_ vssd1 vssd1 vccd1 vccd1 _1123_ sky130_fd_sc_hd__xnor2_1
XFILLER_59_257 vssd1 vssd1 vccd1 vccd1 sky130_fd_sc_hd__fill_1
XFILLER_59_279 vssd1 vssd1 vccd1 vccd1 sky130_fd_sc_hd__fill_1
XFILLER_27_110 vssd1 vssd1 vccd1 vccd1 sky130_fd_sc_hd__fill_2
XFILLER_27_132 vssd1 vssd1 vccd1 vccd1 sky130_fd_sc_hd__fill_1
XFILLER_70_433 vssd1 vssd1 vccd1 vccd1 sky130_fd_sc_hd__fill_1
XTAP_TAPCELL_ROW_53_620 vssd1 vccd1 sky130_fd_sc_hd__tapvpwrvgnd_1
XANTENNA__2959__B1 net80 vssd1 vssd1 vccd1 vccd1 sky130_fd_sc_hd__diode_2
XTAP_TAPCELL_ROW_25_388 vssd1 vccd1 sky130_fd_sc_hd__tapvpwrvgnd_1
XFILLER_2_253 vccd1 vssd1 vccd1 vssd1 sky130_ef_sc_hd__decap_40_12
XPHY_EDGE_ROW_69_Left_149 vssd1 vssd1 vccd1 vccd1 sky130_fd_sc_hd__decap_3
XANTENNA__2846__B net184 vssd1 vssd1 vccd1 vccd1 sky130_fd_sc_hd__diode_2
XFILLER_65_216 vssd1 vssd1 vccd1 vccd1 sky130_fd_sc_hd__fill_8
XFILLER_73_260 vccd1 vssd1 vccd1 vssd1 sky130_ef_sc_hd__decap_40_12
XTAP_TAPCELL_ROW_16_311 vssd1 vccd1 sky130_fd_sc_hd__tapvpwrvgnd_1
X_1951_ MATMULT_INST.matmult_inst.alu_inst.adder_inst.r1.fa0.b MATMULT_INST.matmult_inst.alu_inst.adder_inst.r1.fa0.a
+ vssd1 vssd1 vccd1 vccd1 _0538_ sky130_fd_sc_hd__nor2_1
X_1882_ net614 net32 net11 vssd1 vssd1 vccd1 vccd1 _0212_ sky130_fd_sc_hd__mux2_1
XPHY_EDGE_ROW_78_Left_158 vssd1 vssd1 vccd1 vccd1 sky130_fd_sc_hd__decap_3
X_2503_ net158 MATMULT_INST.matmult_inst.mem_inst.mem0\[6\] MATMULT_INST.matmult_inst.mem_inst.matrixB0\[6\]
+ net163 vssd1 vssd1 vccd1 vccd1 _1014_ sky130_fd_sc_hd__a22o_1
X_3483_ clknet_leaf_11_clk net321 net138 vssd1 vssd1 vccd1 vccd1 MATMULT_INST.matmult_inst.fsm_inst.rx_data\[1\]
+ sky130_fd_sc_hd__dfrtp_1
X_2434_ MATMULT_INST.matmult_inst.mem_inst.matrixA0\[0\] net65 _0949_ _0950_ vssd1
+ vssd1 vccd1 vccd1 _0951_ sky130_fd_sc_hd__a211o_1
X_2365_ _0886_ _0900_ _0907_ vssd1 vssd1 vccd1 vccd1 _0909_ sky130_fd_sc_hd__and3_1
XANTENNA__1689__B1 net61 vssd1 vssd1 vccd1 vccd1 sky130_fd_sc_hd__diode_2
Xteam_02_309 vssd1 vssd1 vccd1 vccd1 gpio_oeb[29] team_02_309/LO sky130_fd_sc_hd__conb_1
X_2296_ _0805_ _0842_ vssd1 vssd1 vccd1 vccd1 _0843_ sky130_fd_sc_hd__nand2_1
XTAP_TAPCELL_ROW_67_745 vssd1 vccd1 sky130_fd_sc_hd__tapvpwrvgnd_1
XFILLER_2_81 vssd1 vssd1 vccd1 vccd1 sky130_fd_sc_hd__fill_2
XANTENNA__2102__A1 net235 vssd1 vssd1 vccd1 vccd1 sky130_fd_sc_hd__diode_2
XFILLER_24_146 vccd1 vssd1 vccd1 vssd1 sky130_ef_sc_hd__decap_40_12
XTAP_TAPCELL_ROW_50_601 vssd1 vccd1 sky130_fd_sc_hd__tapvpwrvgnd_1
XTAP_TAPCELL_ROW_22_358 vssd1 vccd1 sky130_fd_sc_hd__tapvpwrvgnd_1
XFILLER_21_46 vssd1 vssd1 vccd1 vccd1 sky130_fd_sc_hd__fill_1
XFILLER_21_68 vssd1 vssd1 vccd1 vccd1 sky130_fd_sc_hd__fill_1
XFILLER_28_441 vssd1 vssd1 vccd1 vccd1 sky130_fd_sc_hd__fill_1
XFILLER_15_113 vssd1 vssd1 vccd1 vccd1 sky130_fd_sc_hd__fill_2
XTAP_TAPCELL_ROW_38_491 vssd1 vccd1 sky130_fd_sc_hd__tapvpwrvgnd_1
XFILLER_43_411 vssd1 vssd1 vccd1 vccd1 sky130_fd_sc_hd__fill_1
XFILLER_62_31 vssd1 vssd1 vccd1 vccd1 sky130_fd_sc_hd__fill_1
XFILLER_30_149 vssd1 vssd1 vccd1 vccd1 sky130_fd_sc_hd__fill_4
XFILLER_7_15 vccd1 vssd1 vccd1 vssd1 sky130_ef_sc_hd__decap_40_12
XFILLER_11_385 vssd1 vssd1 vccd1 vccd1 sky130_fd_sc_hd__fill_4
XFILLER_7_389 vssd1 vssd1 vccd1 vccd1 sky130_fd_sc_hd__fill_2
XANTENNA__2580__A1 net183 vssd1 vssd1 vccd1 vccd1 sky130_fd_sc_hd__diode_2
XFILLER_78_363 vssd1 vssd1 vccd1 vccd1 sky130_fd_sc_hd__fill_1
X_2150_ _0686_ _0687_ _0699_ vssd1 vssd1 vccd1 vccd1 _0701_ sky130_fd_sc_hd__a21o_1
X_2081_ net225 net223 net234 net235 vssd1 vssd1 vccd1 vccd1 _0634_ sky130_fd_sc_hd__nand4_2
XTAP_TAPCELL_ROW_64_715 vssd1 vccd1 sky130_fd_sc_hd__tapvpwrvgnd_1
XANTENNA__1700__S net24 vssd1 vssd1 vccd1 vccd1 sky130_fd_sc_hd__diode_2
XFILLER_34_455 vssd1 vssd1 vccd1 vccd1 sky130_fd_sc_hd__fill_1
XFILLER_61_252 vssd1 vssd1 vccd1 vccd1 sky130_fd_sc_hd__fill_4
XTAP_TAPCELL_ROW_72_781 vssd1 vccd1 sky130_fd_sc_hd__tapvpwrvgnd_1
XFILLER_21_116 vssd1 vssd1 vccd1 vccd1 sky130_fd_sc_hd__fill_1
XFILLER_21_127 vssd1 vssd1 vccd1 vccd1 sky130_fd_sc_hd__fill_8
X_2983_ net177 net168 MATMULT_INST.matmult_inst.mem_inst.matrixA3\[10\] vssd1 vssd1
+ vccd1 vccd1 _1408_ sky130_fd_sc_hd__and3_1
X_1934_ MATMULT_INST.matmult_inst.alu_inst.adder_inst.r0.fa1.b MATMULT_INST.matmult_inst.alu_inst.adder_inst.r0.fa1.a
+ vssd1 vssd1 vccd1 vccd1 _0524_ sky130_fd_sc_hd__and2_1
XANTENNA__2531__S _1035_ vssd1 vssd1 vccd1 vccd1 sky130_fd_sc_hd__diode_2
X_1865_ net589 net51 net13 vssd1 vssd1 vccd1 vccd1 _0196_ sky130_fd_sc_hd__mux2_1
X_3604_ MATMULT_INST.matmult_inst.fsm_inst.transaction_ready vssd1 vssd1 vccd1 vccd1
+ net7 sky130_fd_sc_hd__clkbuf_1
X_1796_ net648 net44 net30 vssd1 vssd1 vccd1 vccd1 _0131_ sky130_fd_sc_hd__mux2_1
X_3535_ clknet_leaf_12_clk MATMULT_INST.matmult_inst.spi_inst.mosi_data_spi\[7\] net149
+ vssd1 vssd1 vccd1 vccd1 MATMULT_INST.matmult_inst.spi_inst.mosi_data_sync\[7\] sky130_fd_sc_hd__dfrtp_1
X_3466_ clknet_leaf_8_clk _0410_ net134 vssd1 vssd1 vccd1 vccd1 MATMULT_INST.matmult_inst.mem_inst.matrixB3\[2\]
+ sky130_fd_sc_hd__dfrtp_1
X_2417_ MATMULT_INST.matmult_inst.fsm_inst.state\[2\] _1522_ _0928_ _1515_ vssd1 vssd1
+ vccd1 vccd1 _0937_ sky130_fd_sc_hd__o211a_1
X_3397_ clknet_leaf_6_clk _0351_ net112 vssd1 vssd1 vccd1 vccd1 MATMULT_INST.matmult_inst.fsm_inst.count\[3\]
+ sky130_fd_sc_hd__dfrtp_1
X_2348_ _0857_ _0892_ vssd1 vssd1 vccd1 vccd1 _0893_ sky130_fd_sc_hd__xnor2_1
X_2279_ _0792_ _0800_ _0794_ vssd1 vssd1 vccd1 vccd1 _0826_ sky130_fd_sc_hd__a21o_1
XTAP_TAPCELL_ROW_35_472 vssd1 vccd1 sky130_fd_sc_hd__tapvpwrvgnd_1
XFILLER_8_109 vccd1 vssd1 vccd1 vssd1 sky130_ef_sc_hd__decap_40_12
XFILLER_20_193 vssd1 vssd1 vccd1 vccd1 sky130_fd_sc_hd__fill_2
XFILLER_32_78 vssd1 vssd1 vccd1 vccd1 sky130_fd_sc_hd__fill_4
XANTENNA__2562__A1 _1022_ vssd1 vssd1 vccd1 vccd1 sky130_fd_sc_hd__diode_2
XFILLER_79_127 vssd1 vssd1 vccd1 vccd1 sky130_fd_sc_hd__fill_2
XANTENNA__2677__A net210 vssd1 vssd1 vccd1 vccd1 sky130_fd_sc_hd__diode_2
XFILLER_57_75 vssd1 vssd1 vccd1 vccd1 sky130_fd_sc_hd__fill_1
XANTENNA__2078__B1 net71 vssd1 vssd1 vccd1 vccd1 sky130_fd_sc_hd__diode_2
XANTENNA__2843__C net187 vssd1 vssd1 vccd1 vccd1 sky130_fd_sc_hd__diode_2
X_1650_ MATMULT_INST.matmult_inst.spi_inst.current_state MATMULT_INST.matmult_inst.spi_inst.cs_sync_prev
+ _0477_ vssd1 vssd1 vccd1 vccd1 MATMULT_INST.matmult_inst.spi_inst.next_state sky130_fd_sc_hd__o21a_1
XFILLER_11_193 vccd1 vssd1 vccd1 vssd1 sky130_ef_sc_hd__decap_40_12
X_1581_ MATMULT_INST.matmult_inst.fsm_inst.count\[2\] MATMULT_INST.matmult_inst.fsm_inst.count\[3\]
+ vssd1 vssd1 vccd1 vccd1 _1501_ sky130_fd_sc_hd__or2_2
Xhold109 MATMULT_INST.matmult_inst.spi_inst.tx_reg_sys\[17\] vssd1 vssd1 vccd1 vccd1
+ net422 sky130_fd_sc_hd__dlygate4sd3_1
X_3320_ clknet_leaf_6_clk _0278_ net106 vssd1 vssd1 vccd1 vccd1 MATMULT_INST.matmult_inst.alu_inst.b1_reg\[2\]
+ sky130_fd_sc_hd__dfrtp_1
X_3251_ clknet_leaf_16_clk _0209_ net135 vssd1 vssd1 vccd1 vccd1 MATMULT_INST.matmult_inst.mem_inst.mem0\[4\]
+ sky130_fd_sc_hd__dfrtp_1
X_2202_ _0749_ _0750_ vssd1 vssd1 vccd1 vccd1 _0751_ sky130_fd_sc_hd__xnor2_1
XFILLER_21_3 vssd1 vssd1 vccd1 vccd1 sky130_fd_sc_hd__fill_8
X_3182_ clknet_leaf_13_clk _0140_ net145 vssd1 vssd1 vccd1 vccd1 MATMULT_INST.matmult_inst.mem_inst.mem2\[7\]
+ sky130_fd_sc_hd__dfrtp_1
X_2133_ _0653_ _0682_ _0683_ vssd1 vssd1 vccd1 vccd1 _0684_ sky130_fd_sc_hd__nand3_1
X_2064_ _0612_ _0618_ vssd1 vssd1 vccd1 vccd1 _0619_ sky130_fd_sc_hd__and2_1
XTAP_TAPCELL_ROW_49_586 vssd1 vccd1 sky130_fd_sc_hd__tapvpwrvgnd_1
XTAP_TAPCELL_ROW_32_442 vssd1 vccd1 sky130_fd_sc_hd__tapvpwrvgnd_1
X_2966_ net177 net168 MATMULT_INST.matmult_inst.mem_inst.matrixB3\[9\] vssd1 vssd1
+ vccd1 vccd1 _1392_ sky130_fd_sc_hd__and3_1
X_1917_ net236 net452 net53 vssd1 vssd1 vccd1 vccd1 _0245_ sky130_fd_sc_hd__mux2_1
X_2897_ _1361_ _1362_ vssd1 vssd1 vccd1 vccd1 _1363_ sky130_fd_sc_hd__nand2_1
X_1848_ net486 net49 net28 vssd1 vssd1 vccd1 vccd1 _0180_ sky130_fd_sc_hd__mux2_1
X_1779_ net162 _0482_ net81 vssd1 vssd1 vccd1 vccd1 _0513_ sky130_fd_sc_hd__and3_1
XFILLER_1_329 vssd1 vssd1 vccd1 vccd1 sky130_fd_sc_hd__fill_4
X_3518_ clknet_leaf_25_clk _0443_ net119 vssd1 vssd1 vccd1 vccd1 MATMULT_INST.matmult_inst.spi_inst.tx_reg_sys\[9\]
+ sky130_fd_sc_hd__dfrtp_1
X_3449_ _0030_ _0395_ net140 vssd1 vssd1 vccd1 vccd1 MATMULT_INST.matmult_inst.spi_inst.mosi_data_spi\[4\]
+ sky130_fd_sc_hd__dfrtp_1
XFILLER_69_193 vssd1 vssd1 vccd1 vccd1 sky130_fd_sc_hd__fill_4
XFILLER_13_414 vssd1 vssd1 vccd1 vccd1 sky130_fd_sc_hd__fill_4
XFILLER_43_11 vssd1 vssd1 vccd1 vccd1 sky130_fd_sc_hd__fill_2
XFILLER_13_447 vssd1 vssd1 vccd1 vccd1 sky130_fd_sc_hd__fill_1
XFILLER_43_55 vssd1 vssd1 vccd1 vccd1 sky130_fd_sc_hd__fill_1
XFILLER_9_429 vccd1 vssd1 vccd1 vssd1 sky130_ef_sc_hd__decap_40_12
XFILLER_4_27 vssd1 vssd1 vccd1 vccd1 sky130_fd_sc_hd__fill_1
XFILLER_4_189 vssd1 vssd1 vccd1 vccd1 sky130_fd_sc_hd__fill_4
XFILLER_68_41 vssd1 vssd1 vccd1 vccd1 sky130_fd_sc_hd__fill_2
XFILLER_68_85 vssd1 vssd1 vccd1 vccd1 sky130_fd_sc_hd__fill_4
XANTENNA__3015__B net167 vssd1 vssd1 vccd1 vccd1 sky130_fd_sc_hd__diode_2
XFILLER_0_384 vssd1 vssd1 vccd1 vccd1 sky130_fd_sc_hd__fill_4
XFILLER_48_344 vssd1 vssd1 vccd1 vccd1 sky130_fd_sc_hd__fill_1
XTAP_TAPCELL_ROW_46_567 vssd1 vccd1 sky130_fd_sc_hd__tapvpwrvgnd_1
X_2820_ net187 net185 net204 vssd1 vssd1 vccd1 vccd1 _1289_ sky130_fd_sc_hd__and3_1
X_2751_ _1220_ _1221_ _1219_ vssd1 vssd1 vccd1 vccd1 _1222_ sky130_fd_sc_hd__a21bo_1
X_2682_ _1153_ _1154_ vssd1 vssd1 vccd1 vccd1 _1155_ sky130_fd_sc_hd__nand2_1
XFILLER_8_473 vssd1 vssd1 vccd1 vccd1 sky130_fd_sc_hd__fill_2
X_1702_ net563 net49 net24 vssd1 vssd1 vccd1 vccd1 _0054_ sky130_fd_sc_hd__mux2_1
X_1633_ MATMULT_INST.matmult_inst.fsm_inst.rx_ready_edge _1528_ _1531_ vssd1 vssd1
+ vccd1 vccd1 _0467_ sky130_fd_sc_hd__and3_1
XFILLER_69_3 vccd1 vssd1 vccd1 vssd1 sky130_ef_sc_hd__decap_40_12
X_1564_ MATMULT_INST.matmult_inst.spi_inst.mosi_shifter\[2\] MATMULT_INST.matmult_inst.spi_inst.mosi_data_spi\[3\]
+ _1491_ vssd1 vssd1 vccd1 vccd1 _0394_ sky130_fd_sc_hd__mux2_1
X_3303_ clknet_leaf_7_clk _0261_ net111 vssd1 vssd1 vccd1 vccd1 MATMULT_INST.matmult_inst.alu_inst.out\[3\]
+ sky130_fd_sc_hd__dfrtp_1
XANTENNA__2110__A net239 vssd1 vssd1 vccd1 vccd1 sky130_fd_sc_hd__diode_2
X_3234_ clknet_leaf_14_clk _0192_ net143 vssd1 vssd1 vccd1 vccd1 MATMULT_INST.matmult_inst.mem_inst.matrixB2\[5\]
+ sky130_fd_sc_hd__dfrtp_1
X_3165_ clknet_leaf_18_clk _0123_ net130 vssd1 vssd1 vccd1 vccd1 MATMULT_INST.matmult_inst.mem_inst.matrixB1\[8\]
+ sky130_fd_sc_hd__dfrtp_1
XFILLER_66_141 vssd1 vssd1 vccd1 vccd1 sky130_fd_sc_hd__fill_4
XFILLER_66_152 vssd1 vssd1 vccd1 vccd1 sky130_fd_sc_hd__fill_2
X_2116_ _0660_ _0666_ vssd1 vssd1 vccd1 vccd1 _0668_ sky130_fd_sc_hd__xnor2_1
X_3096_ clknet_leaf_19_clk _0054_ net127 vssd1 vssd1 vccd1 vccd1 MATMULT_INST.matmult_inst.mem_inst.matrixB0\[11\]
+ sky130_fd_sc_hd__dfrtp_1
XANTENNA_fanout163_A net164 vssd1 vssd1 vccd1 vccd1 sky130_fd_sc_hd__diode_2
X_2047_ net189 net407 net55 vssd1 vssd1 vccd1 vccd1 _0288_ sky130_fd_sc_hd__mux2_1
Xfanout37 _0487_ vssd1 vssd1 vccd1 vccd1 net37 sky130_fd_sc_hd__clkbuf_2
Xfanout26 _0519_ vssd1 vssd1 vccd1 vccd1 net26 sky130_fd_sc_hd__buf_4
Xfanout15 _0515_ vssd1 vssd1 vccd1 vccd1 net15 sky130_fd_sc_hd__clkbuf_4
Xfanout59 _0467_ vssd1 vssd1 vccd1 vccd1 net59 sky130_fd_sc_hd__clkbuf_4
XFILLER_10_417 vssd1 vssd1 vccd1 vccd1 sky130_fd_sc_hd__fill_2
Xfanout48 _0497_ vssd1 vssd1 vccd1 vccd1 net48 sky130_fd_sc_hd__clkbuf_2
X_2949_ net360 _0976_ net58 vssd1 vssd1 vccd1 vccd1 _0436_ sky130_fd_sc_hd__mux2_1
XTAP_TAPCELL_ROW_9_248 vssd1 vccd1 sky130_fd_sc_hd__tapvpwrvgnd_1
XFILLER_1_137 vccd1 vssd1 vccd1 vssd1 sky130_ef_sc_hd__decap_40_12
XFILLER_38_55 vssd1 vssd1 vccd1 vccd1 sky130_fd_sc_hd__fill_1
XFILLER_38_66 vssd1 vssd1 vccd1 vccd1 sky130_fd_sc_hd__fill_1
XTAP_TAPCELL_ROW_0_170 vssd1 vccd1 sky130_fd_sc_hd__tapvpwrvgnd_1
XTAP_TAPCELL_ROW_43_537 vssd1 vccd1 sky130_fd_sc_hd__tapvpwrvgnd_1
XANTENNA_fanout31_X net31 vssd1 vssd1 vccd1 vccd1 sky130_fd_sc_hd__diode_2
XFILLER_13_277 vssd1 vssd1 vccd1 vccd1 sky130_fd_sc_hd__fill_2
XFILLER_9_237 vccd1 vssd1 vccd1 vssd1 sky130_ef_sc_hd__decap_40_12
Xclkload18 clknet_leaf_23_clk vssd1 vssd1 vccd1 vccd1 clkload18/Y sky130_fd_sc_hd__clkinv_8
XFILLER_79_62 vccd1 vssd1 vccd1 vssd1 sky130_ef_sc_hd__decap_40_12
XANTENNA__3026__A net177 vssd1 vssd1 vccd1 vccd1 sky130_fd_sc_hd__diode_2
XFILLER_0_181 vccd1 vssd1 vccd1 vssd1 sky130_ef_sc_hd__decap_40_12
XFILLER_76_472 vssd1 vssd1 vccd1 vccd1 sky130_fd_sc_hd__fill_4
XTAP_TAPCELL_ROW_59_670 vssd1 vccd1 sky130_fd_sc_hd__tapvpwrvgnd_1
XFILLER_63_133 vssd1 vssd1 vccd1 vccd1 sky130_fd_sc_hd__fill_4
XFILLER_63_188 vssd1 vssd1 vccd1 vccd1 sky130_fd_sc_hd__fill_1
XFILLER_44_380 vssd1 vssd1 vccd1 vccd1 sky130_fd_sc_hd__fill_1
XANTENNA__2995__A1 net92 vssd1 vssd1 vccd1 vccd1 sky130_fd_sc_hd__diode_2
XANTENNA__2995__B2 net165 vssd1 vssd1 vccd1 vccd1 sky130_fd_sc_hd__diode_2
X_2803_ _1212_ _1263_ _1271_ vssd1 vssd1 vccd1 vccd1 _1273_ sky130_fd_sc_hd__nand3_1
XTAP_TAPCELL_ROW_14_294 vssd1 vccd1 sky130_fd_sc_hd__tapvpwrvgnd_1
X_2734_ _1166_ _1205_ vssd1 vssd1 vccd1 vccd1 _1206_ sky130_fd_sc_hd__xor2_1
X_2665_ net197 net202 _1117_ _1118_ _1089_ vssd1 vssd1 vccd1 vccd1 _1138_ sky130_fd_sc_hd__a41o_1
X_1616_ _1495_ _1497_ _1509_ MATMULT_INST.matmult_inst.fsm_inst.state\[3\] vssd1 vssd1
+ vccd1 vccd1 _1534_ sky130_fd_sc_hd__o22a_1
X_2596_ net196 net209 _1070_ _1071_ vssd1 vssd1 vccd1 vccd1 _1073_ sky130_fd_sc_hd__o2bb2a_1
Xfanout205 MATMULT_INST.matmult_inst.alu_inst.b1_reg\[4\] vssd1 vssd1 vccd1 vccd1
+ net205 sky130_fd_sc_hd__clkbuf_2
XFILLER_5_81 vccd1 vssd1 vccd1 vssd1 sky130_ef_sc_hd__decap_40_12
X_1547_ MATMULT_INST.matmult_inst.spi_inst.rx_bit_count\[2\] MATMULT_INST.matmult_inst.spi_inst.rx_bit_count\[1\]
+ MATMULT_INST.matmult_inst.spi_inst.rx_bit_count\[0\] vssd1 vssd1 vccd1 vccd1 _1487_
+ sky130_fd_sc_hd__nand3_1
Xfanout227 net228 vssd1 vssd1 vccd1 vccd1 net227 sky130_fd_sc_hd__clkbuf_2
Xfanout216 MATMULT_INST.matmult_inst.alu_inst.a0_reg\[5\] vssd1 vssd1 vccd1 vccd1
+ net216 sky130_fd_sc_hd__buf_2
Xfanout238 MATMULT_INST.matmult_inst.alu_inst.b0_reg\[2\] vssd1 vssd1 vccd1 vccd1
+ net238 sky130_fd_sc_hd__buf_2
XFILLER_74_409 vssd1 vssd1 vccd1 vccd1 sky130_fd_sc_hd__fill_1
X_3217_ clknet_leaf_12_clk _0175_ net146 vssd1 vssd1 vccd1 vccd1 MATMULT_INST.matmult_inst.mem_inst.mem1\[6\]
+ sky130_fd_sc_hd__dfrtp_1
XANTENNA__2775__A net189 vssd1 vssd1 vccd1 vccd1 sky130_fd_sc_hd__diode_2
X_3148_ clknet_leaf_25_clk _0106_ net102 vssd1 vssd1 vccd1 vccd1 MATMULT_INST.matmult_inst.mem_inst.mem3\[9\]
+ sky130_fd_sc_hd__dfrtp_1
X_3079_ net244 vssd1 vssd1 vccd1 vccd1 _0037_ sky130_fd_sc_hd__inv_2
XANTENNA_fanout166_X net166 vssd1 vssd1 vccd1 vccd1 sky130_fd_sc_hd__diode_2
XFILLER_35_391 vssd1 vssd1 vccd1 vccd1 sky130_fd_sc_hd__fill_1
XANTENNA__2986__A1 net165 vssd1 vssd1 vccd1 vccd1 sky130_fd_sc_hd__diode_2
XANTENNA__2738__B2 net186 vssd1 vssd1 vccd1 vccd1 sky130_fd_sc_hd__diode_2
XFILLER_40_23 vssd1 vssd1 vccd1 vccd1 sky130_fd_sc_hd__fill_2
XFILLER_40_56 vssd1 vssd1 vccd1 vccd1 sky130_fd_sc_hd__fill_4
XFILLER_2_413 vssd1 vssd1 vccd1 vccd1 sky130_fd_sc_hd__fill_4
XFILLER_2_457 vccd1 vssd1 vccd1 vssd1 sky130_ef_sc_hd__decap_40_12
Xhold270 MATMULT_INST.matmult_inst.mem_inst.matrixB1\[7\] vssd1 vssd1 vccd1 vccd1
+ net583 sky130_fd_sc_hd__dlygate4sd3_1
Xhold281 MATMULT_INST.matmult_inst.mem_inst.matrixA0\[15\] vssd1 vssd1 vccd1 vccd1
+ net594 sky130_fd_sc_hd__dlygate4sd3_1
Xhold292 MATMULT_INST.matmult_inst.alu_inst.col0\[2\] vssd1 vssd1 vccd1 vccd1 net605
+ sky130_fd_sc_hd__dlygate4sd3_1
XFILLER_77_225 vssd1 vssd1 vccd1 vccd1 sky130_fd_sc_hd__fill_2
XANTENNA_fanout79_X net79 vssd1 vssd1 vccd1 vccd1 sky130_fd_sc_hd__diode_2
XFILLER_1_39 vccd1 vssd1 vccd1 vssd1 sky130_ef_sc_hd__decap_40_12
XFILLER_45_111 vssd1 vssd1 vccd1 vccd1 sky130_fd_sc_hd__fill_1
XTAP_TAPCELL_ROW_56_651 vssd1 vccd1 sky130_fd_sc_hd__tapvpwrvgnd_1
XFILLER_65_97 vssd1 vssd1 vccd1 vccd1 sky130_fd_sc_hd__fill_2
XTAP_TAPCELL_ROW_11_264 vssd1 vccd1 sky130_fd_sc_hd__tapvpwrvgnd_1
XFILLER_5_273 vssd1 vssd1 vccd1 vccd1 sky130_fd_sc_hd__fill_4
X_2450_ net75 _0965_ vssd1 vssd1 vccd1 vccd1 _0966_ sky130_fd_sc_hd__and2_1
X_2381_ net69 _0920_ _0922_ _0921_ vssd1 vssd1 vccd1 vccd1 _0307_ sky130_fd_sc_hd__a31oi_1
Xinput5 nrst vssd1 vssd1 vccd1 vccd1 net5 sky130_fd_sc_hd__buf_1
X_3002_ MATMULT_INST.matmult_inst.mem_inst.matrixA2\[12\] net85 net77 MATMULT_INST.matmult_inst.mem_inst.matrixA1\[12\]
+ _1424_ vssd1 vssd1 vccd1 vccd1 _1425_ sky130_fd_sc_hd__a221o_1
XTAP_TAPCELL_ROW_19_331 vssd1 vccd1 sky130_fd_sc_hd__tapvpwrvgnd_1
XFILLER_17_391 vssd1 vssd1 vccd1 vccd1 sky130_fd_sc_hd__fill_1
XFILLER_36_199 vssd1 vssd1 vccd1 vccd1 sky130_fd_sc_hd__fill_1
XANTENNA__2534__S _1035_ vssd1 vssd1 vccd1 vccd1 sky130_fd_sc_hd__diode_2
XANTENNA__2968__A1 net155 vssd1 vssd1 vccd1 vccd1 sky130_fd_sc_hd__diode_2
XANTENNA__2968__B2 net160 vssd1 vssd1 vccd1 vccd1 sky130_fd_sc_hd__diode_2
XTAP_TAPCELL_ROW_62_698 vssd1 vccd1 sky130_fd_sc_hd__tapvpwrvgnd_1
XANTENNA_fanout126_A net132 vssd1 vssd1 vccd1 vccd1 sky130_fd_sc_hd__diode_2
X_2717_ _1187_ _1188_ _1183_ vssd1 vssd1 vccd1 vccd1 _1189_ sky130_fd_sc_hd__a21oi_1
XANTENNA__1674__A net182 vssd1 vssd1 vccd1 vccd1 sky130_fd_sc_hd__diode_2
XFILLER_10_15 vccd1 vssd1 vccd1 vssd1 sky130_ef_sc_hd__decap_40_12
X_2648_ _1089_ _1121_ vssd1 vssd1 vccd1 vccd1 _1122_ sky130_fd_sc_hd__xnor2_1
XANTENNA__2489__B net173 vssd1 vssd1 vccd1 vccd1 sky130_fd_sc_hd__diode_2
X_2579_ _1505_ _1512_ _1058_ _1059_ vssd1 vssd1 vccd1 vccd1 _1060_ sky130_fd_sc_hd__or4b_1
XFILLER_59_225 vssd1 vssd1 vccd1 vccd1 sky130_fd_sc_hd__fill_1
XFILLER_74_217 vssd1 vssd1 vccd1 vccd1 sky130_fd_sc_hd__fill_1
XFILLER_27_155 vccd1 vssd1 vccd1 vssd1 sky130_ef_sc_hd__decap_40_12
XTAP_TAPCELL_ROW_53_621 vssd1 vccd1 sky130_fd_sc_hd__tapvpwrvgnd_1
XFILLER_23_383 vssd1 vssd1 vccd1 vccd1 sky130_fd_sc_hd__fill_1
XFILLER_50_180 vssd1 vssd1 vccd1 vccd1 sky130_fd_sc_hd__fill_2
XANTENNA__1855__Y _0517_ vssd1 vssd1 vccd1 vccd1 sky130_fd_sc_hd__diode_2
XFILLER_2_221 vccd1 vssd1 vccd1 vssd1 sky130_ef_sc_hd__decap_40_12
XFILLER_2_265 vccd1 vssd1 vccd1 vssd1 sky130_ef_sc_hd__decap_40_12
XFILLER_76_41 vccd1 vssd1 vccd1 vssd1 sky130_ef_sc_hd__decap_40_12
XFILLER_18_166 vssd1 vssd1 vccd1 vccd1 sky130_fd_sc_hd__fill_2
XFILLER_73_272 vssd1 vssd1 vccd1 vccd1 sky130_fd_sc_hd__fill_8
XTAP_TAPCELL_ROW_16_312 vssd1 vccd1 sky130_fd_sc_hd__tapvpwrvgnd_1
X_1950_ net448 _0537_ net74 vssd1 vssd1 vccd1 vccd1 _0261_ sky130_fd_sc_hd__mux2_1
X_1881_ net416 net33 net11 vssd1 vssd1 vccd1 vccd1 _0211_ sky130_fd_sc_hd__mux2_1
X_2502_ MATMULT_INST.matmult_inst.mem_inst.matrixB2\[6\] net90 net83 MATMULT_INST.matmult_inst.mem_inst.matrixB1\[6\]
+ _1012_ vssd1 vssd1 vccd1 vccd1 _1013_ sky130_fd_sc_hd__a221o_1
XFILLER_51_3 vccd1 vssd1 vccd1 vssd1 sky130_ef_sc_hd__decap_40_12
X_3482_ clknet_leaf_11_clk net327 net139 vssd1 vssd1 vccd1 vccd1 MATMULT_INST.matmult_inst.fsm_inst.rx_data\[0\]
+ sky130_fd_sc_hd__dfrtp_1
X_2433_ net163 _0942_ _0946_ net158 vssd1 vssd1 vccd1 vccd1 _0950_ sky130_fd_sc_hd__a22o_1
X_2364_ _0886_ _0900_ _0907_ vssd1 vssd1 vccd1 vccd1 _0908_ sky130_fd_sc_hd__a21oi_1
XANTENNA__2529__S _1035_ vssd1 vssd1 vccd1 vccd1 sky130_fd_sc_hd__diode_2
X_2295_ _0806_ _0808_ vssd1 vssd1 vccd1 vccd1 _0842_ sky130_fd_sc_hd__nand2_1
XFILLER_12_309 vccd1 vssd1 vccd1 vssd1 sky130_ef_sc_hd__decap_40_12
XFILLER_24_158 vssd1 vssd1 vccd1 vccd1 sky130_fd_sc_hd__fill_4
XANTENNA_fanout243_A net2 vssd1 vssd1 vccd1 vccd1 sky130_fd_sc_hd__diode_2
XFILLER_32_180 vssd1 vssd1 vccd1 vccd1 sky130_fd_sc_hd__fill_1
XTAP_TAPCELL_ROW_22_359 vssd1 vccd1 sky130_fd_sc_hd__tapvpwrvgnd_1
XFILLER_46_33 vssd1 vssd1 vccd1 vccd1 sky130_fd_sc_hd__fill_2
XFILLER_28_464 vssd1 vssd1 vccd1 vccd1 sky130_fd_sc_hd__fill_1
XFILLER_15_169 vccd1 vssd1 vccd1 vssd1 sky130_ef_sc_hd__decap_40_12
XTAP_TAPCELL_ROW_38_492 vssd1 vccd1 sky130_fd_sc_hd__tapvpwrvgnd_1
XANTENNA_clkbuf_2_0__f_clk_A clknet_0_clk vssd1 vssd1 vccd1 vccd1 sky130_fd_sc_hd__diode_2
XFILLER_30_139 vssd1 vssd1 vccd1 vccd1 sky130_fd_sc_hd__fill_1
XANTENNA_clkbuf_leaf_16_clk_A clknet_2_3__leaf_clk vssd1 vssd1 vccd1 vccd1 sky130_fd_sc_hd__diode_2
XFILLER_7_27 vccd1 vssd1 vccd1 vssd1 sky130_ef_sc_hd__decap_40_12
XANTENNA_fanout8_X net8 vssd1 vssd1 vccd1 vccd1 sky130_fd_sc_hd__diode_2
XFILLER_7_335 vssd1 vssd1 vccd1 vccd1 sky130_fd_sc_hd__fill_1
XFILLER_23_7 vssd1 vssd1 vccd1 vccd1 sky130_fd_sc_hd__fill_2
X_2080_ net223 net233 vssd1 vssd1 vccd1 vccd1 _0633_ sky130_fd_sc_hd__and2_1
XTAP_TAPCELL_ROW_64_716 vssd1 vccd1 sky130_fd_sc_hd__tapvpwrvgnd_1
XFILLER_34_423 vssd1 vssd1 vccd1 vccd1 sky130_fd_sc_hd__fill_1
XTAP_TAPCELL_ROW_72_782 vssd1 vccd1 sky130_fd_sc_hd__tapvpwrvgnd_1
XANTENNA__3045__B1 net77 vssd1 vssd1 vccd1 vccd1 sky130_fd_sc_hd__diode_2
X_2982_ MATMULT_INST.matmult_inst.mem_inst.mem2\[10\] net86 net78 MATMULT_INST.matmult_inst.mem_inst.mem1\[10\]
+ _1406_ vssd1 vssd1 vccd1 vccd1 _1407_ sky130_fd_sc_hd__a221o_1
XFILLER_61_264 vssd1 vssd1 vccd1 vccd1 sky130_fd_sc_hd__fill_1
X_1933_ MATMULT_INST.matmult_inst.alu_inst.adder_inst.r0.fa1.b MATMULT_INST.matmult_inst.alu_inst.adder_inst.r0.fa1.a
+ vssd1 vssd1 vccd1 vccd1 _0523_ sky130_fd_sc_hd__nor2_1
X_3603_ MATMULT_INST.matmult_inst.miso vssd1 vssd1 vccd1 vccd1 net6 sky130_fd_sc_hd__clkbuf_1
X_1864_ net654 _0493_ net12 vssd1 vssd1 vccd1 vccd1 _0195_ sky130_fd_sc_hd__mux2_1
X_1795_ net504 net45 net30 vssd1 vssd1 vccd1 vccd1 _0130_ sky130_fd_sc_hd__mux2_1
X_3534_ clknet_leaf_12_clk MATMULT_INST.matmult_inst.spi_inst.mosi_data_spi\[6\] net147
+ vssd1 vssd1 vccd1 vccd1 MATMULT_INST.matmult_inst.spi_inst.mosi_data_sync\[6\] sky130_fd_sc_hd__dfrtp_1
X_3465_ clknet_leaf_1_clk _0409_ net109 vssd1 vssd1 vccd1 vccd1 MATMULT_INST.matmult_inst.mem_inst.matrixB3\[1\]
+ sky130_fd_sc_hd__dfrtp_1
X_2416_ _1517_ _0933_ MATMULT_INST.matmult_inst.fsm_inst.state\[2\] vssd1 vssd1 vccd1
+ vccd1 _0936_ sky130_fd_sc_hd__o21ai_1
X_3396_ clknet_leaf_6_clk _0350_ net112 vssd1 vssd1 vccd1 vccd1 MATMULT_INST.matmult_inst.fsm_inst.count\[2\]
+ sky130_fd_sc_hd__dfrtp_1
XFILLER_69_353 vssd1 vssd1 vccd1 vccd1 sky130_fd_sc_hd__fill_1
X_2347_ _0890_ _0891_ vssd1 vssd1 vccd1 vccd1 _0892_ sky130_fd_sc_hd__or2_1
X_2278_ _0822_ _0824_ vssd1 vssd1 vccd1 vccd1 _0825_ sky130_fd_sc_hd__or2_1
XANTENNA_fanout246_X net246 vssd1 vssd1 vccd1 vccd1 sky130_fd_sc_hd__diode_2
XANTENNA__3036__B1 net79 vssd1 vssd1 vccd1 vccd1 sky130_fd_sc_hd__diode_2
XFILLER_12_117 vssd1 vssd1 vccd1 vccd1 sky130_fd_sc_hd__fill_1
XTAP_TAPCELL_ROW_35_473 vssd1 vccd1 sky130_fd_sc_hd__tapvpwrvgnd_1
XFILLER_40_437 vssd1 vssd1 vccd1 vccd1 sky130_fd_sc_hd__fill_1
XFILLER_4_305 vssd1 vssd1 vccd1 vccd1 sky130_fd_sc_hd__fill_2
XFILLER_79_139 vssd1 vssd1 vccd1 vccd1 sky130_fd_sc_hd__fill_1
XFILLER_79_117 vssd1 vssd1 vccd1 vccd1 sky130_fd_sc_hd__fill_2
XANTENNA__2677__B net189 vssd1 vssd1 vccd1 vccd1 sky130_fd_sc_hd__diode_2
XFILLER_75_323 vssd1 vssd1 vccd1 vccd1 sky130_fd_sc_hd__fill_1
XANTENNA_fanout61_X net61 vssd1 vssd1 vccd1 vccd1 sky130_fd_sc_hd__diode_2
XFILLER_75_367 vssd1 vssd1 vccd1 vccd1 sky130_fd_sc_hd__fill_1
XANTENNA__1801__S net17 vssd1 vssd1 vccd1 vccd1 sky130_fd_sc_hd__diode_2
XANTENNA__2843__D net201 vssd1 vssd1 vccd1 vccd1 sky130_fd_sc_hd__diode_2
XANTENNA__3027__B1 net77 vssd1 vssd1 vccd1 vccd1 sky130_fd_sc_hd__diode_2
XFILLER_31_415 vssd1 vssd1 vccd1 vccd1 sky130_fd_sc_hd__fill_1
XFILLER_11_161 vssd1 vssd1 vccd1 vccd1 sky130_fd_sc_hd__fill_4
XFILLER_7_165 vssd1 vssd1 vccd1 vccd1 sky130_fd_sc_hd__fill_2
X_1580_ _1495_ _1498_ vssd1 vssd1 vccd1 vccd1 _1500_ sky130_fd_sc_hd__or2_2
XFILLER_3_393 vccd1 vssd1 vccd1 vssd1 sky130_ef_sc_hd__decap_40_12
X_3250_ clknet_leaf_14_clk _0208_ net144 vssd1 vssd1 vccd1 vccd1 MATMULT_INST.matmult_inst.mem_inst.mem0\[3\]
+ sky130_fd_sc_hd__dfrtp_1
X_2201_ net241 net213 _0717_ _0718_ net214 vssd1 vssd1 vccd1 vccd1 _0750_ sky130_fd_sc_hd__a32oi_2
X_3181_ clknet_leaf_12_clk _0139_ net149 vssd1 vssd1 vccd1 vccd1 MATMULT_INST.matmult_inst.mem_inst.mem2\[6\]
+ sky130_fd_sc_hd__dfrtp_1
XTAP_TAPCELL_ROW_77_830 vssd1 vccd1 sky130_fd_sc_hd__tapvpwrvgnd_1
XFILLER_14_3 vccd1 vssd1 vccd1 vssd1 sky130_ef_sc_hd__decap_40_12
X_2132_ _0663_ _0679_ _0680_ _0681_ vssd1 vssd1 vccd1 vccd1 _0683_ sky130_fd_sc_hd__nand4_1
X_2063_ _0616_ _0617_ vssd1 vssd1 vccd1 vccd1 _0618_ sky130_fd_sc_hd__nor2_1
XTAP_TAPCELL_ROW_49_587 vssd1 vccd1 sky130_fd_sc_hd__tapvpwrvgnd_1
XFILLER_34_253 vssd1 vssd1 vccd1 vccd1 sky130_fd_sc_hd__fill_1
XTAP_TAPCELL_ROW_32_443 vssd1 vccd1 sky130_fd_sc_hd__tapvpwrvgnd_1
X_2965_ net378 _1391_ net57 vssd1 vssd1 vccd1 vccd1 _0442_ sky130_fd_sc_hd__mux2_1
X_1916_ net237 net605 net53 vssd1 vssd1 vccd1 vccd1 _0244_ sky130_fd_sc_hd__mux2_1
X_2896_ _1357_ _1359_ _1360_ vssd1 vssd1 vccd1 vccd1 _1362_ sky130_fd_sc_hd__a21o_1
XFILLER_8_81 vssd1 vssd1 vccd1 vccd1 sky130_fd_sc_hd__fill_2
X_1847_ net612 net50 net28 vssd1 vssd1 vccd1 vccd1 _0179_ sky130_fd_sc_hd__mux2_1
X_1778_ net171 net180 vssd1 vssd1 vccd1 vccd1 _0512_ sky130_fd_sc_hd__and2b_1
X_3517_ clknet_leaf_18_clk _0442_ net129 vssd1 vssd1 vccd1 vccd1 MATMULT_INST.matmult_inst.spi_inst.tx_reg_sys\[8\]
+ sky130_fd_sc_hd__dfrtp_1
X_3448_ _0029_ _0394_ net147 vssd1 vssd1 vccd1 vccd1 MATMULT_INST.matmult_inst.spi_inst.mosi_data_spi\[3\]
+ sky130_fd_sc_hd__dfrtp_1
X_3379_ clknet_leaf_6_clk _0333_ net106 vssd1 vssd1 vccd1 vccd1 MATMULT_INST.matmult_inst.alu_inst.col1\[1\]
+ sky130_fd_sc_hd__dfrtp_1
XFILLER_27_57 vccd1 vssd1 vccd1 vssd1 sky130_ef_sc_hd__decap_40_12
XFILLER_25_231 vssd1 vssd1 vccd1 vccd1 sky130_fd_sc_hd__fill_1
XFILLER_43_45 vssd1 vssd1 vccd1 vccd1 sky130_fd_sc_hd__fill_8
XANTENNA__2480__B2 net93 vssd1 vssd1 vccd1 vccd1 sky130_fd_sc_hd__diode_2
XANTENNA_fanout21_A _0508_ vssd1 vssd1 vccd1 vccd1 sky130_fd_sc_hd__diode_2
XFILLER_43_89 vssd1 vssd1 vccd1 vccd1 sky130_fd_sc_hd__fill_1
XFILLER_0_363 vssd1 vssd1 vccd1 vccd1 sky130_fd_sc_hd__fill_1
XFILLER_68_97 vssd1 vssd1 vccd1 vccd1 sky130_fd_sc_hd__fill_1
XTAP_TAPCELL_ROW_74_800 vssd1 vccd1 sky130_fd_sc_hd__tapvpwrvgnd_1
XFILLER_16_231 vssd1 vssd1 vccd1 vccd1 sky130_fd_sc_hd__fill_1
XANTENNA__2471__A1 net158 vssd1 vssd1 vccd1 vccd1 sky130_fd_sc_hd__diode_2
XANTENNA__2471__B2 net162 vssd1 vssd1 vccd1 vccd1 sky130_fd_sc_hd__diode_2
XFILLER_12_481 vssd1 vssd1 vccd1 vccd1 sky130_fd_sc_hd__fill_1
X_2750_ net200 net202 net192 net190 vssd1 vssd1 vccd1 vccd1 _1221_ sky130_fd_sc_hd__nand4_1
X_2681_ _1151_ _1152_ _1118_ vssd1 vssd1 vccd1 vccd1 _1154_ sky130_fd_sc_hd__a21o_1
XFILLER_12_492 vssd1 vssd1 vccd1 vccd1 sky130_fd_sc_hd__fill_2
X_1701_ MATMULT_INST.matmult_inst.fsm_inst.alu_result\[11\] net60 vssd1 vssd1 vccd1
+ vccd1 _0496_ sky130_fd_sc_hd__and2_1
X_1632_ _1496_ _1517_ _1533_ _0465_ _1510_ vssd1 vssd1 vccd1 vccd1 _0466_ sky130_fd_sc_hd__a2111o_1
X_1563_ MATMULT_INST.matmult_inst.spi_inst.mosi_shifter\[3\] MATMULT_INST.matmult_inst.spi_inst.mosi_data_spi\[4\]
+ _1491_ vssd1 vssd1 vccd1 vccd1 _0395_ sky130_fd_sc_hd__mux2_1
XANTENNA__1706__S net24 vssd1 vssd1 vccd1 vccd1 sky130_fd_sc_hd__diode_2
X_3302_ clknet_leaf_7_clk _0260_ net111 vssd1 vssd1 vccd1 vccd1 MATMULT_INST.matmult_inst.alu_inst.out\[2\]
+ sky130_fd_sc_hd__dfrtp_1
XANTENNA__2110__B net241 vssd1 vssd1 vccd1 vccd1 sky130_fd_sc_hd__diode_2
X_3233_ clknet_leaf_16_clk _0191_ net122 vssd1 vssd1 vccd1 vccd1 MATMULT_INST.matmult_inst.mem_inst.matrixB2\[4\]
+ sky130_fd_sc_hd__dfrtp_1
XFILLER_58_109 vssd1 vssd1 vccd1 vccd1 sky130_fd_sc_hd__fill_8
X_3164_ clknet_leaf_14_clk _0122_ net144 vssd1 vssd1 vccd1 vccd1 MATMULT_INST.matmult_inst.mem_inst.matrixB1\[7\]
+ sky130_fd_sc_hd__dfrtp_1
X_2115_ _0658_ _0666_ _0659_ _0636_ vssd1 vssd1 vccd1 vccd1 _0667_ sky130_fd_sc_hd__a2bb2o_1
X_3095_ clknet_leaf_24_clk _0053_ net119 vssd1 vssd1 vccd1 vccd1 MATMULT_INST.matmult_inst.mem_inst.matrixB0\[10\]
+ sky130_fd_sc_hd__dfrtp_1
X_2046_ net191 net377 net56 vssd1 vssd1 vccd1 vccd1 _0287_ sky130_fd_sc_hd__mux2_1
Xfanout16 _0514_ vssd1 vssd1 vccd1 vccd1 net16 sky130_fd_sc_hd__buf_4
XANTENNA_fanout156_A net159 vssd1 vssd1 vccd1 vccd1 sky130_fd_sc_hd__diode_2
Xfanout38 _0486_ vssd1 vssd1 vccd1 vccd1 net38 sky130_fd_sc_hd__clkbuf_2
Xfanout27 _0519_ vssd1 vssd1 vccd1 vccd1 net27 sky130_fd_sc_hd__clkbuf_4
XFILLER_13_15 vccd1 vssd1 vccd1 vssd1 sky130_ef_sc_hd__decap_40_12
Xfanout49 _0496_ vssd1 vssd1 vccd1 vccd1 net49 sky130_fd_sc_hd__clkbuf_2
XANTENNA__1677__A net162 vssd1 vssd1 vccd1 vccd1 sky130_fd_sc_hd__diode_2
X_2948_ net400 _0965_ net58 vssd1 vssd1 vccd1 vccd1 _0435_ sky130_fd_sc_hd__mux2_1
X_2879_ _1314_ _1345_ vssd1 vssd1 vccd1 vccd1 _1346_ sky130_fd_sc_hd__xnor2_1
XANTENNA__2517__A2 net91 vssd1 vssd1 vccd1 vccd1 sky130_fd_sc_hd__diode_2
XTAP_TAPCELL_ROW_9_249 vssd1 vccd1 sky130_fd_sc_hd__tapvpwrvgnd_1
XFILLER_1_105 vssd1 vssd1 vccd1 vccd1 sky130_fd_sc_hd__fill_4
XFILLER_1_149 vccd1 vssd1 vccd1 vssd1 sky130_ef_sc_hd__decap_40_12
XFILLER_38_78 vssd1 vssd1 vccd1 vccd1 sky130_fd_sc_hd__fill_4
XFILLER_57_131 vssd1 vssd1 vccd1 vccd1 sky130_fd_sc_hd__fill_1
XFILLER_45_359 vssd1 vssd1 vccd1 vccd1 sky130_fd_sc_hd__fill_1
XTAP_TAPCELL_ROW_0_160 vssd1 vccd1 sky130_fd_sc_hd__tapvpwrvgnd_1
XTAP_TAPCELL_ROW_0_171 vssd1 vccd1 sky130_fd_sc_hd__tapvpwrvgnd_1
XFILLER_13_223 vssd1 vssd1 vccd1 vccd1 sky130_fd_sc_hd__fill_1
XTAP_TAPCELL_ROW_43_538 vssd1 vccd1 sky130_fd_sc_hd__tapvpwrvgnd_1
XFILLER_70_10 vssd1 vssd1 vccd1 vccd1 sky130_fd_sc_hd__fill_2
XFILLER_9_205 vccd1 vssd1 vccd1 vssd1 sky130_ef_sc_hd__decap_40_12
XANTENNA_fanout24_X net24 vssd1 vssd1 vccd1 vccd1 sky130_fd_sc_hd__diode_2
XFILLER_9_249 vccd1 vssd1 vccd1 vssd1 sky130_ef_sc_hd__decap_40_12
Xclkload19 clknet_leaf_25_clk vssd1 vssd1 vccd1 vccd1 clkload19/Y sky130_fd_sc_hd__bufinv_16
XFILLER_79_41 vccd1 vssd1 vccd1 vssd1 sky130_ef_sc_hd__decap_40_12
XANTENNA__2508__A2 net90 vssd1 vssd1 vccd1 vccd1 sky130_fd_sc_hd__diode_2
XFILLER_79_85 vssd1 vssd1 vccd1 vccd1 sky130_fd_sc_hd__fill_8
XFILLER_79_74 vssd1 vssd1 vccd1 vccd1 sky130_fd_sc_hd__fill_8
XANTENNA__3026__B net168 vssd1 vssd1 vccd1 vccd1 sky130_fd_sc_hd__diode_2
XFILLER_0_193 vssd1 vssd1 vccd1 vccd1 sky130_fd_sc_hd__fill_2
XTAP_TAPCELL_ROW_59_671 vssd1 vccd1 sky130_fd_sc_hd__tapvpwrvgnd_1
Xteam_02_290 vssd1 vssd1 vccd1 vccd1 gpio_oeb[10] team_02_290/LO sky130_fd_sc_hd__conb_1
XFILLER_63_178 vssd1 vssd1 vccd1 vccd1 sky130_fd_sc_hd__fill_2
X_2802_ _1212_ _1263_ _1271_ vssd1 vssd1 vccd1 vccd1 _1272_ sky130_fd_sc_hd__a21o_1
XTAP_TAPCELL_ROW_14_295 vssd1 vccd1 sky130_fd_sc_hd__tapvpwrvgnd_1
X_2733_ _1203_ _1204_ vssd1 vssd1 vccd1 vccd1 _1205_ sky130_fd_sc_hd__or2_1
X_2664_ net197 net200 net202 net194 vssd1 vssd1 vccd1 vccd1 _1137_ sky130_fd_sc_hd__a22o_1
X_1615_ _1528_ _1532_ vssd1 vssd1 vccd1 vccd1 _1533_ sky130_fd_sc_hd__and2_1
X_2595_ _1070_ _1071_ net196 net209 vssd1 vssd1 vccd1 vccd1 _1072_ sky130_fd_sc_hd__and4bb_1
X_1546_ net245 vssd1 vssd1 vccd1 vccd1 _0022_ sky130_fd_sc_hd__inv_2
Xfanout206 MATMULT_INST.matmult_inst.alu_inst.b1_reg\[3\] vssd1 vssd1 vccd1 vccd1
+ net206 sky130_fd_sc_hd__buf_2
XTAP_TAPCELL_ROW_6_219 vssd1 vccd1 sky130_fd_sc_hd__tapvpwrvgnd_1
XFILLER_5_93 vccd1 vssd1 vccd1 vssd1 sky130_ef_sc_hd__decap_40_12
Xfanout217 MATMULT_INST.matmult_inst.alu_inst.a0_reg\[5\] vssd1 vssd1 vccd1 vccd1
+ net217 sky130_fd_sc_hd__clkbuf_2
Xfanout228 MATMULT_INST.matmult_inst.alu_inst.b0_reg\[7\] vssd1 vssd1 vccd1 vccd1
+ net228 sky130_fd_sc_hd__clkbuf_2
Xfanout239 net240 vssd1 vssd1 vccd1 vccd1 net239 sky130_fd_sc_hd__buf_2
X_3216_ clknet_leaf_17_clk _0174_ net129 vssd1 vssd1 vccd1 vccd1 MATMULT_INST.matmult_inst.mem_inst.mem1\[5\]
+ sky130_fd_sc_hd__dfrtp_1
X_3147_ clknet_leaf_18_clk _0105_ net128 vssd1 vssd1 vccd1 vccd1 MATMULT_INST.matmult_inst.mem_inst.mem3\[8\]
+ sky130_fd_sc_hd__dfrtp_1
XFILLER_54_145 vssd1 vssd1 vccd1 vccd1 sky130_fd_sc_hd__fill_1
X_3078_ net245 vssd1 vssd1 vccd1 vccd1 _0036_ sky130_fd_sc_hd__inv_2
X_2029_ _0598_ _0601_ _0599_ vssd1 vssd1 vccd1 vccd1 _0604_ sky130_fd_sc_hd__o21ai_2
XANTENNA_fanout159_X net159 vssd1 vssd1 vccd1 vccd1 sky130_fd_sc_hd__diode_2
XTAP_TAPCELL_ROW_40_508 vssd1 vccd1 sky130_fd_sc_hd__tapvpwrvgnd_1
XANTENNA__1643__C1 net157 vssd1 vssd1 vccd1 vccd1 sky130_fd_sc_hd__diode_2
XFILLER_40_68 vccd1 vssd1 vccd1 vssd1 sky130_ef_sc_hd__decap_40_12
Xhold271 MATMULT_INST.matmult_inst.mem_inst.matrixA2\[12\] vssd1 vssd1 vccd1 vccd1
+ net584 sky130_fd_sc_hd__dlygate4sd3_1
Xhold260 MATMULT_INST.matmult_inst.alu_inst.out\[11\] vssd1 vssd1 vccd1 vccd1 net573
+ sky130_fd_sc_hd__dlygate4sd3_1
XFILLER_2_469 vssd1 vssd1 vccd1 vccd1 sky130_fd_sc_hd__fill_4
Xhold282 MATMULT_INST.matmult_inst.mem_inst.matrixB0\[10\] vssd1 vssd1 vccd1 vccd1
+ net595 sky130_fd_sc_hd__dlygate4sd3_1
Xhold293 MATMULT_INST.matmult_inst.mem_inst.mem2\[3\] vssd1 vssd1 vccd1 vccd1 net606
+ sky130_fd_sc_hd__dlygate4sd3_1
XFILLER_49_55 vssd1 vssd1 vccd1 vccd1 sky130_fd_sc_hd__fill_1
XANTENNA__2966__A net177 vssd1 vssd1 vccd1 vccd1 sky130_fd_sc_hd__diode_2
XFILLER_65_54 vssd1 vssd1 vccd1 vccd1 sky130_fd_sc_hd__fill_2
XTAP_TAPCELL_ROW_56_652 vssd1 vccd1 sky130_fd_sc_hd__tapvpwrvgnd_1
XANTENNA__2426__B2 net163 vssd1 vssd1 vccd1 vccd1 sky130_fd_sc_hd__diode_2
XANTENNA__2426__A1 net157 vssd1 vssd1 vccd1 vccd1 sky130_fd_sc_hd__diode_2
XTAP_TAPCELL_ROW_11_265 vssd1 vccd1 sky130_fd_sc_hd__tapvpwrvgnd_1
XFILLER_53_7 vssd1 vssd1 vccd1 vccd1 sky130_fd_sc_hd__fill_2
X_2380_ _0882_ _0888_ _0905_ _0902_ vssd1 vssd1 vccd1 vccd1 _0922_ sky130_fd_sc_hd__a31o_1
X_3001_ net176 net167 MATMULT_INST.matmult_inst.mem_inst.matrixA3\[12\] vssd1 vssd1
+ vccd1 vccd1 _1424_ sky130_fd_sc_hd__and3_1
XTAP_TAPCELL_ROW_19_332 vssd1 vccd1 sky130_fd_sc_hd__tapvpwrvgnd_1
XANTENNA__1779__X _0513_ vssd1 vssd1 vccd1 vccd1 sky130_fd_sc_hd__diode_2
XTAP_TAPCELL_ROW_62_699 vssd1 vccd1 sky130_fd_sc_hd__tapvpwrvgnd_1
X_2716_ _1184_ _1185_ _1186_ vssd1 vssd1 vccd1 vccd1 _1188_ sky130_fd_sc_hd__o21ai_1
X_2647_ net197 _1120_ _1119_ vssd1 vssd1 vccd1 vccd1 _1121_ sky130_fd_sc_hd__a21bo_1
XFILLER_10_27 vssd1 vssd1 vccd1 vccd1 sky130_fd_sc_hd__fill_1
X_2578_ MATMULT_INST.matmult_inst.fsm_inst.count\[0\] _1532_ _1056_ net183 _1500_
+ vssd1 vssd1 vccd1 vccd1 _1059_ sky130_fd_sc_hd__o32a_1
XFILLER_19_36 vssd1 vssd1 vccd1 vccd1 sky130_fd_sc_hd__fill_2
XFILLER_27_123 vssd1 vssd1 vccd1 vccd1 sky130_fd_sc_hd__fill_2
XFILLER_27_145 vssd1 vssd1 vccd1 vccd1 sky130_fd_sc_hd__fill_4
XFILLER_27_167 vssd1 vssd1 vccd1 vccd1 sky130_fd_sc_hd__fill_1
XFILLER_27_178 vccd1 vssd1 vccd1 vssd1 sky130_ef_sc_hd__decap_40_12
XFILLER_35_35 vssd1 vssd1 vccd1 vccd1 sky130_fd_sc_hd__fill_4
XTAP_TAPCELL_ROW_53_622 vssd1 vccd1 sky130_fd_sc_hd__tapvpwrvgnd_1
XANTENNA__2959__A2 net88 vssd1 vssd1 vccd1 vccd1 sky130_fd_sc_hd__diode_2
XPHY_EDGE_ROW_14_Right_14 vssd1 vssd1 vccd1 vccd1 sky130_fd_sc_hd__decap_3
XFILLER_51_45 vssd1 vssd1 vccd1 vccd1 sky130_fd_sc_hd__fill_2
XFILLER_2_233 vccd1 vssd1 vccd1 vssd1 sky130_ef_sc_hd__decap_40_12
XANTENNA_fanout91_X net91 vssd1 vssd1 vccd1 vccd1 sky130_fd_sc_hd__diode_2
XFILLER_2_277 vccd1 vssd1 vccd1 vssd1 sky130_ef_sc_hd__decap_40_12
XPHY_EDGE_ROW_23_Right_23 vssd1 vssd1 vccd1 vccd1 sky130_fd_sc_hd__decap_3
XANTENNA__1804__S net17 vssd1 vssd1 vccd1 vccd1 sky130_fd_sc_hd__diode_2
XFILLER_76_53 vssd1 vssd1 vccd1 vccd1 sky130_fd_sc_hd__fill_4
XFILLER_18_112 vssd1 vssd1 vccd1 vccd1 sky130_fd_sc_hd__fill_1
XFILLER_18_101 vssd1 vssd1 vccd1 vccd1 sky130_fd_sc_hd__fill_4
XPHY_EDGE_ROW_32_Right_32 vssd1 vssd1 vccd1 vccd1 sky130_fd_sc_hd__decap_3
X_1880_ net479 _0490_ net11 vssd1 vssd1 vccd1 vccd1 _0210_ sky130_fd_sc_hd__mux2_1
X_2501_ net183 net174 MATMULT_INST.matmult_inst.mem_inst.matrixB3\[6\] vssd1 vssd1
+ vccd1 vccd1 _1012_ sky130_fd_sc_hd__and3_1
X_3481_ clknet_leaf_21_clk _0425_ net124 vssd1 vssd1 vccd1 vccd1 MATMULT_INST.matmult_inst.mem_inst.matrixB3\[17\]
+ sky130_fd_sc_hd__dfrtp_1
XPHY_EDGE_ROW_41_Right_41 vssd1 vssd1 vccd1 vccd1 sky130_fd_sc_hd__decap_3
XFILLER_44_3 vccd1 vssd1 vccd1 vssd1 sky130_ef_sc_hd__decap_40_12
X_2432_ net93 _0943_ _0948_ net166 vssd1 vssd1 vccd1 vccd1 _0949_ sky130_fd_sc_hd__a22o_1
XANTENNA__1714__S net24 vssd1 vssd1 vccd1 vccd1 sky130_fd_sc_hd__diode_2
X_2363_ _0882_ _0906_ vssd1 vssd1 vccd1 vccd1 _0907_ sky130_fd_sc_hd__xnor2_1
XANTENNA__1689__A2 net59 vssd1 vssd1 vccd1 vccd1 sky130_fd_sc_hd__diode_2
X_2294_ _0839_ _0840_ vssd1 vssd1 vccd1 vccd1 _0841_ sky130_fd_sc_hd__or2_1
XFILLER_2_83 vssd1 vssd1 vccd1 vccd1 sky130_fd_sc_hd__fill_1
XFILLER_24_115 vccd1 vssd1 vccd1 vssd1 sky130_ef_sc_hd__decap_40_12
XPHY_EDGE_ROW_50_Right_50 vssd1 vssd1 vccd1 vccd1 sky130_fd_sc_hd__decap_3
XANTENNA__3063__A1 net165 vssd1 vssd1 vccd1 vccd1 sky130_fd_sc_hd__diode_2
XFILLER_20_365 vssd1 vssd1 vccd1 vccd1 sky130_fd_sc_hd__fill_1
XFILLER_21_59 vssd1 vssd1 vccd1 vccd1 sky130_fd_sc_hd__fill_2
XFILLER_46_67 vssd1 vssd1 vccd1 vccd1 sky130_fd_sc_hd__fill_8
XFILLER_46_89 vssd1 vssd1 vccd1 vccd1 sky130_fd_sc_hd__fill_1
XTAP_TAPCELL_ROW_38_493 vssd1 vccd1 sky130_fd_sc_hd__tapvpwrvgnd_1
XFILLER_43_468 vssd1 vssd1 vccd1 vccd1 sky130_fd_sc_hd__fill_1
XFILLER_62_77 vssd1 vssd1 vccd1 vccd1 sky130_fd_sc_hd__fill_4
XFILLER_7_39 vccd1 vssd1 vccd1 vssd1 sky130_ef_sc_hd__decap_40_12
XANTENNA__2565__A0 _0952_ vssd1 vssd1 vccd1 vccd1 sky130_fd_sc_hd__diode_2
XFILLER_11_81 vccd1 vssd1 vccd1 vssd1 sky130_ef_sc_hd__decap_40_12
XFILLER_78_365 vssd1 vssd1 vccd1 vccd1 sky130_fd_sc_hd__fill_4
XTAP_TAPCELL_ROW_64_717 vssd1 vccd1 sky130_fd_sc_hd__tapvpwrvgnd_1
XTAP_TAPCELL_ROW_72_783 vssd1 vccd1 sky130_fd_sc_hd__tapvpwrvgnd_1
X_2981_ net177 net168 MATMULT_INST.matmult_inst.mem_inst.mem3\[10\] vssd1 vssd1 vccd1
+ vccd1 _1406_ sky130_fd_sc_hd__and3_1
XFILLER_14_181 vccd1 vssd1 vccd1 vssd1 sky130_ef_sc_hd__decap_40_12
X_1932_ net645 _0476_ _0521_ _0522_ vssd1 vssd1 vccd1 vccd1 _0258_ sky130_fd_sc_hd__a22o_1
X_1863_ net420 net32 net13 vssd1 vssd1 vccd1 vccd1 _0194_ sky130_fd_sc_hd__mux2_1
X_1794_ net532 net46 net30 vssd1 vssd1 vccd1 vccd1 _0129_ sky130_fd_sc_hd__mux2_1
X_3533_ clknet_leaf_11_clk MATMULT_INST.matmult_inst.spi_inst.mosi_data_spi\[5\] net147
+ vssd1 vssd1 vccd1 vccd1 MATMULT_INST.matmult_inst.spi_inst.mosi_data_sync\[5\] sky130_fd_sc_hd__dfrtp_1
X_3464_ clknet_leaf_15_clk _0408_ net143 vssd1 vssd1 vccd1 vccd1 MATMULT_INST.matmult_inst.mem_inst.matrixB3\[0\]
+ sky130_fd_sc_hd__dfrtp_1
X_2415_ _1533_ _0933_ _0935_ _0455_ vssd1 vssd1 vccd1 vccd1 _0328_ sky130_fd_sc_hd__o31a_1
X_3395_ clknet_leaf_10_clk _0349_ net113 vssd1 vssd1 vccd1 vccd1 MATMULT_INST.matmult_inst.fsm_inst.count\[1\]
+ sky130_fd_sc_hd__dfrtp_1
X_2346_ net228 net216 net229 net215 vssd1 vssd1 vccd1 vccd1 _0891_ sky130_fd_sc_hd__and4_1
X_2277_ net227 net219 _0823_ vssd1 vssd1 vccd1 vccd1 _0824_ sky130_fd_sc_hd__and3_1
XFILLER_16_15 vccd1 vssd1 vccd1 vssd1 sky130_ef_sc_hd__decap_40_12
XANTENNA_fanout239_X net239 vssd1 vssd1 vccd1 vccd1 sky130_fd_sc_hd__diode_2
XFILLER_20_195 vssd1 vssd1 vccd1 vccd1 sky130_fd_sc_hd__fill_1
XANTENNA_fanout99_A net152 vssd1 vssd1 vccd1 vccd1 sky130_fd_sc_hd__diode_2
XFILLER_75_335 vssd1 vssd1 vccd1 vccd1 sky130_fd_sc_hd__fill_1
XFILLER_57_55 vssd1 vssd1 vccd1 vccd1 sky130_fd_sc_hd__fill_1
XANTENNA_fanout54_X net54 vssd1 vssd1 vccd1 vccd1 sky130_fd_sc_hd__diode_2
XFILLER_28_251 vssd1 vssd1 vccd1 vccd1 sky130_fd_sc_hd__fill_1
XFILLER_43_221 vssd1 vssd1 vccd1 vccd1 sky130_fd_sc_hd__fill_2
Xclkbuf_leaf_23_clk clknet_2_2__leaf_clk vssd1 vssd1 vccd1 vccd1 clknet_leaf_23_clk
+ sky130_fd_sc_hd__clkbuf_8
XFILLER_7_111 vssd1 vssd1 vccd1 vccd1 sky130_fd_sc_hd__fill_1
XANTENNA__2214__A net218 vssd1 vssd1 vccd1 vccd1 sky130_fd_sc_hd__diode_2
XFILLER_3_361 vccd1 vssd1 vccd1 vssd1 sky130_ef_sc_hd__decap_40_12
X_2200_ net223 net227 _0678_ vssd1 vssd1 vccd1 vccd1 _0749_ sky130_fd_sc_hd__and3_1
XANTENNA__2587__C net71 vssd1 vssd1 vccd1 vccd1 sky130_fd_sc_hd__diode_2
X_3180_ clknet_leaf_15_clk _0138_ net128 vssd1 vssd1 vccd1 vccd1 MATMULT_INST.matmult_inst.mem_inst.mem2\[5\]
+ sky130_fd_sc_hd__dfrtp_1
XFILLER_78_195 vssd1 vssd1 vccd1 vccd1 sky130_fd_sc_hd__fill_1
X_2131_ _0679_ _0680_ _0681_ _0663_ vssd1 vssd1 vccd1 vccd1 _0682_ sky130_fd_sc_hd__a22o_1
X_2062_ net226 net237 _0614_ _0615_ vssd1 vssd1 vccd1 vccd1 _0617_ sky130_fd_sc_hd__o2bb2a_1
XTAP_TAPCELL_ROW_49_588 vssd1 vccd1 sky130_fd_sc_hd__tapvpwrvgnd_1
XANTENNA__3018__A1 net165 vssd1 vssd1 vccd1 vccd1 sky130_fd_sc_hd__diode_2
XANTENNA__3018__B2 net164 vssd1 vssd1 vccd1 vccd1 sky130_fd_sc_hd__diode_2
X_2964_ MATMULT_INST.matmult_inst.mem_inst.matrixA0\[8\] net64 _1389_ _1390_ vssd1
+ vssd1 vccd1 vccd1 _1391_ sky130_fd_sc_hd__a211o_1
XTAP_TAPCELL_ROW_32_444 vssd1 vccd1 sky130_fd_sc_hd__tapvpwrvgnd_1
X_1915_ net240 net621 net54 vssd1 vssd1 vccd1 vccd1 _0243_ sky130_fd_sc_hd__mux2_1
Xclkbuf_leaf_14_clk clknet_2_3__leaf_clk vssd1 vssd1 vccd1 vccd1 clknet_leaf_14_clk
+ sky130_fd_sc_hd__clkbuf_8
X_2895_ _1357_ _1359_ _1360_ vssd1 vssd1 vccd1 vccd1 _1361_ sky130_fd_sc_hd__nand3_1
XANTENNA__2529__A0 _0977_ vssd1 vssd1 vccd1 vccd1 sky130_fd_sc_hd__diode_2
X_1846_ net636 net51 net28 vssd1 vssd1 vccd1 vccd1 _0178_ sky130_fd_sc_hd__mux2_1
X_1777_ net412 net43 net18 vssd1 vssd1 vccd1 vccd1 _0114_ sky130_fd_sc_hd__mux2_1
X_3516_ clknet_leaf_15_clk _0441_ net135 vssd1 vssd1 vccd1 vccd1 MATMULT_INST.matmult_inst.spi_inst.tx_reg_sys\[7\]
+ sky130_fd_sc_hd__dfrtp_1
XPHY_EDGE_ROW_4_Right_4 vssd1 vssd1 vccd1 vccd1 sky130_fd_sc_hd__decap_3
X_3447_ _0028_ _0393_ net140 vssd1 vssd1 vccd1 vccd1 MATMULT_INST.matmult_inst.spi_inst.mosi_data_spi\[2\]
+ sky130_fd_sc_hd__dfrtp_1
XANTENNA_clkbuf_leaf_15_clk_A clknet_2_3__leaf_clk vssd1 vssd1 vccd1 vccd1 sky130_fd_sc_hd__diode_2
X_3378_ clknet_leaf_5_clk _0332_ net106 vssd1 vssd1 vccd1 vccd1 MATMULT_INST.matmult_inst.alu_inst.col1\[0\]
+ sky130_fd_sc_hd__dfrtp_1
X_2329_ _0844_ _0871_ _0872_ vssd1 vssd1 vccd1 vccd1 _0875_ sky130_fd_sc_hd__nand3_1
XANTENNA__1902__S net26 vssd1 vssd1 vccd1 vccd1 sky130_fd_sc_hd__diode_2
XANTENNA_fanout189_X net189 vssd1 vssd1 vccd1 vccd1 sky130_fd_sc_hd__diode_2
XFILLER_72_305 vssd1 vssd1 vccd1 vccd1 sky130_fd_sc_hd__fill_1
XFILLER_27_69 vssd1 vssd1 vccd1 vccd1 sky130_fd_sc_hd__fill_2
XFILLER_13_405 vssd1 vssd1 vccd1 vccd1 sky130_fd_sc_hd__fill_4
XFILLER_43_13 vssd1 vssd1 vccd1 vccd1 sky130_fd_sc_hd__fill_1
XANTENNA__2480__A2 net65 vssd1 vssd1 vccd1 vccd1 sky130_fd_sc_hd__diode_2
XFILLER_43_57 vssd1 vssd1 vccd1 vccd1 sky130_fd_sc_hd__fill_1
XFILLER_21_493 vssd1 vssd1 vccd1 vccd1 sky130_fd_sc_hd__fill_1
XFILLER_4_29 vccd1 vssd1 vccd1 vssd1 sky130_ef_sc_hd__decap_40_12
XFILLER_75_121 vssd1 vssd1 vccd1 vccd1 sky130_fd_sc_hd__fill_1
XANTENNA__1812__S net16 vssd1 vssd1 vccd1 vccd1 sky130_fd_sc_hd__diode_2
XTAP_TAPCELL_ROW_74_801 vssd1 vccd1 sky130_fd_sc_hd__tapvpwrvgnd_1
XFILLER_48_379 vssd1 vssd1 vccd1 vccd1 sky130_fd_sc_hd__fill_1
XFILLER_16_221 vssd1 vssd1 vccd1 vccd1 sky130_fd_sc_hd__fill_8
XFILLER_12_471 vssd1 vssd1 vccd1 vccd1 sky130_fd_sc_hd__fill_2
XFILLER_31_279 vssd1 vssd1 vccd1 vccd1 sky130_fd_sc_hd__fill_1
X_2680_ _1118_ _1151_ _1152_ vssd1 vssd1 vccd1 vccd1 _1153_ sky130_fd_sc_hd__nand3_1
XFILLER_76_6 vccd1 vssd1 vccd1 vssd1 sky130_ef_sc_hd__decap_40_12
X_1700_ net595 net50 net24 vssd1 vssd1 vccd1 vccd1 _0053_ sky130_fd_sc_hd__mux2_1
X_1631_ _1522_ _0463_ vssd1 vssd1 vccd1 vccd1 _0465_ sky130_fd_sc_hd__nor2_2
XFILLER_8_475 vssd1 vssd1 vccd1 vccd1 sky130_fd_sc_hd__fill_1
X_1562_ MATMULT_INST.matmult_inst.spi_inst.mosi_shifter\[4\] MATMULT_INST.matmult_inst.spi_inst.mosi_data_spi\[5\]
+ _1491_ vssd1 vssd1 vccd1 vccd1 _0396_ sky130_fd_sc_hd__mux2_1
X_3301_ clknet_leaf_7_clk _0259_ net108 vssd1 vssd1 vccd1 vccd1 MATMULT_INST.matmult_inst.alu_inst.out\[1\]
+ sky130_fd_sc_hd__dfrtp_1
XANTENNA__2110__C net218 vssd1 vssd1 vccd1 vccd1 sky130_fd_sc_hd__diode_2
X_3232_ clknet_leaf_18_clk _0190_ net131 vssd1 vssd1 vccd1 vccd1 MATMULT_INST.matmult_inst.mem_inst.matrixB2\[3\]
+ sky130_fd_sc_hd__dfrtp_1
Xclkbuf_leaf_3_clk clknet_2_1__leaf_clk vssd1 vssd1 vccd1 vccd1 clknet_leaf_3_clk
+ sky130_fd_sc_hd__clkbuf_8
XFILLER_79_482 vssd1 vssd1 vccd1 vccd1 sky130_fd_sc_hd__fill_2
XFILLER_39_335 vssd1 vssd1 vccd1 vccd1 sky130_fd_sc_hd__fill_1
X_3163_ clknet_leaf_13_clk _0121_ net148 vssd1 vssd1 vccd1 vccd1 MATMULT_INST.matmult_inst.mem_inst.matrixB1\[6\]
+ sky130_fd_sc_hd__dfrtp_1
X_2114_ _0633_ _0665_ vssd1 vssd1 vccd1 vccd1 _0666_ sky130_fd_sc_hd__xnor2_1
XANTENNA_clkbuf_2_2__f_clk_X clknet_2_2__leaf_clk vssd1 vssd1 vccd1 vccd1 sky130_fd_sc_hd__diode_2
XANTENNA__1722__S net23 vssd1 vssd1 vccd1 vccd1 sky130_fd_sc_hd__diode_2
X_3094_ clknet_leaf_25_clk _0052_ net101 vssd1 vssd1 vccd1 vccd1 MATMULT_INST.matmult_inst.mem_inst.matrixB0\[9\]
+ sky130_fd_sc_hd__dfrtp_1
X_2045_ net193 net357 net56 vssd1 vssd1 vccd1 vccd1 _0286_ sky130_fd_sc_hd__mux2_1
XFILLER_54_338 vssd1 vssd1 vccd1 vccd1 sky130_fd_sc_hd__fill_1
Xfanout28 net29 vssd1 vssd1 vccd1 vccd1 net28 sky130_fd_sc_hd__buf_4
Xfanout17 _0514_ vssd1 vssd1 vccd1 vccd1 net17 sky130_fd_sc_hd__clkbuf_4
Xfanout39 _0485_ vssd1 vssd1 vccd1 vccd1 net39 sky130_fd_sc_hd__clkbuf_2
XFILLER_13_27 vssd1 vssd1 vccd1 vccd1 sky130_fd_sc_hd__fill_4
XFILLER_10_419 vssd1 vssd1 vccd1 vccd1 sky130_fd_sc_hd__fill_1
X_2947_ net354 _0951_ net58 vssd1 vssd1 vccd1 vccd1 _0434_ sky130_fd_sc_hd__mux2_1
X_2878_ _1343_ _1344_ vssd1 vssd1 vccd1 vccd1 _1345_ sky130_fd_sc_hd__or2_1
X_1829_ net496 net49 net14 vssd1 vssd1 vccd1 vccd1 _0162_ sky130_fd_sc_hd__mux2_1
XPHY_EDGE_ROW_13_Left_93 vssd1 vssd1 vccd1 vccd1 sky130_fd_sc_hd__decap_3
XPHY_EDGE_ROW_79_Right_79 vssd1 vssd1 vccd1 vccd1 sky130_fd_sc_hd__decap_3
XTAP_TAPCELL_ROW_0_161 vssd1 vccd1 sky130_fd_sc_hd__tapvpwrvgnd_1
XTAP_TAPCELL_ROW_0_172 vssd1 vccd1 sky130_fd_sc_hd__tapvpwrvgnd_1
XANTENNA__3503__CLK net242 vssd1 vssd1 vccd1 vccd1 sky130_fd_sc_hd__diode_2
XANTENNA__2453__A2 net89 vssd1 vssd1 vccd1 vccd1 sky130_fd_sc_hd__diode_2
XTAP_TAPCELL_ROW_43_539 vssd1 vccd1 sky130_fd_sc_hd__tapvpwrvgnd_1
XFILLER_13_279 vssd1 vssd1 vccd1 vccd1 sky130_fd_sc_hd__fill_1
XFILLER_9_217 vssd1 vssd1 vccd1 vccd1 sky130_fd_sc_hd__fill_4
XANTENNA_fanout17_X net17 vssd1 vssd1 vccd1 vccd1 sky130_fd_sc_hd__diode_2
XFILLER_5_445 vssd1 vssd1 vccd1 vccd1 sky130_fd_sc_hd__fill_2
XANTENNA__1807__S net16 vssd1 vssd1 vccd1 vccd1 sky130_fd_sc_hd__diode_2
XFILLER_79_53 vssd1 vssd1 vccd1 vccd1 sky130_fd_sc_hd__fill_2
XFILLER_5_489 vssd1 vssd1 vccd1 vccd1 sky130_fd_sc_hd__fill_2
XFILLER_79_97 vccd1 vssd1 vccd1 vssd1 sky130_ef_sc_hd__decap_40_12
XFILLER_68_419 vssd1 vssd1 vccd1 vccd1 sky130_fd_sc_hd__fill_1
XFILLER_76_441 vssd1 vssd1 vccd1 vccd1 sky130_fd_sc_hd__fill_1
Xteam_02_280 vssd1 vssd1 vccd1 vccd1 team_02_280/HI gpio_out[33] sky130_fd_sc_hd__conb_1
XTAP_TAPCELL_ROW_59_672 vssd1 vccd1 sky130_fd_sc_hd__tapvpwrvgnd_1
Xteam_02_291 vssd1 vssd1 vccd1 vccd1 gpio_oeb[11] team_02_291/LO sky130_fd_sc_hd__conb_1
XFILLER_63_113 vssd1 vssd1 vccd1 vccd1 sky130_fd_sc_hd__fill_4
X_2801_ _1268_ _1270_ vssd1 vssd1 vccd1 vccd1 _1271_ sky130_fd_sc_hd__xnor2_1
X_2732_ _1200_ _1201_ _1158_ vssd1 vssd1 vccd1 vccd1 _1204_ sky130_fd_sc_hd__o21a_1
X_2663_ net197 net194 net200 net202 vssd1 vssd1 vccd1 vccd1 _1136_ sky130_fd_sc_hd__nand4_1
X_1614_ _1531_ vssd1 vssd1 vccd1 vccd1 _1532_ sky130_fd_sc_hd__inv_2
X_2594_ net211 net195 net212 net192 vssd1 vssd1 vccd1 vccd1 _1071_ sky130_fd_sc_hd__and4_1
X_1545_ net4 vssd1 vssd1 vccd1 vccd1 _1486_ sky130_fd_sc_hd__inv_2
Xfanout207 MATMULT_INST.matmult_inst.alu_inst.b1_reg\[3\] vssd1 vssd1 vccd1 vccd1
+ net207 sky130_fd_sc_hd__clkbuf_2
Xfanout218 MATMULT_INST.matmult_inst.alu_inst.a0_reg\[4\] vssd1 vssd1 vccd1 vccd1
+ net218 sky130_fd_sc_hd__buf_2
Xfanout229 net230 vssd1 vssd1 vccd1 vccd1 net229 sky130_fd_sc_hd__buf_2
X_3215_ clknet_leaf_16_clk _0173_ net119 vssd1 vssd1 vccd1 vccd1 MATMULT_INST.matmult_inst.mem_inst.mem1\[4\]
+ sky130_fd_sc_hd__dfrtp_1
XFILLER_39_176 vssd1 vssd1 vccd1 vccd1 sky130_fd_sc_hd__fill_1
X_3146_ clknet_leaf_13_clk _0104_ net145 vssd1 vssd1 vccd1 vccd1 MATMULT_INST.matmult_inst.mem_inst.mem3\[7\]
+ sky130_fd_sc_hd__dfrtp_1
X_3077_ net245 vssd1 vssd1 vccd1 vccd1 _0035_ sky130_fd_sc_hd__inv_2
X_2028_ MATMULT_INST.matmult_inst.alu_inst.adder_inst.fa.b MATMULT_INST.matmult_inst.alu_inst.adder_inst.fa.a
+ vssd1 vssd1 vccd1 vccd1 _0603_ sky130_fd_sc_hd__xnor2_1
XTAP_TAPCELL_ROW_40_509 vssd1 vccd1 sky130_fd_sc_hd__tapvpwrvgnd_1
XFILLER_50_363 vssd1 vssd1 vccd1 vccd1 sky130_fd_sc_hd__fill_1
XFILLER_50_374 vssd1 vssd1 vccd1 vccd1 sky130_fd_sc_hd__fill_1
XFILLER_10_249 vssd1 vssd1 vccd1 vccd1 sky130_fd_sc_hd__fill_2
XFILLER_6_209 vccd1 vssd1 vccd1 vssd1 sky130_ef_sc_hd__decap_40_12
Xhold250 MATMULT_INST.matmult_inst.mem_inst.matrixB0\[11\] vssd1 vssd1 vccd1 vccd1
+ net563 sky130_fd_sc_hd__dlygate4sd3_1
Xhold261 _0320_ vssd1 vssd1 vccd1 vccd1 net574 sky130_fd_sc_hd__dlygate4sd3_1
Xhold272 MATMULT_INST.matmult_inst.mem_inst.matrixB0\[12\] vssd1 vssd1 vccd1 vccd1
+ net585 sky130_fd_sc_hd__dlygate4sd3_1
Xhold294 MATMULT_INST.matmult_inst.mem_inst.matrixA0\[14\] vssd1 vssd1 vccd1 vccd1
+ net607 sky130_fd_sc_hd__dlygate4sd3_1
Xhold283 MATMULT_INST.matmult_inst.mem_inst.matrixB0\[9\] vssd1 vssd1 vccd1 vccd1
+ net596 sky130_fd_sc_hd__dlygate4sd3_1
XFILLER_49_34 vssd1 vssd1 vccd1 vccd1 sky130_fd_sc_hd__fill_1
XFILLER_49_45 vssd1 vssd1 vccd1 vccd1 sky130_fd_sc_hd__fill_4
XANTENNA_fanout81_A net84 vssd1 vssd1 vccd1 vccd1 sky130_fd_sc_hd__diode_2
XANTENNA__2966__B net168 vssd1 vssd1 vccd1 vccd1 sky130_fd_sc_hd__diode_2
XFILLER_73_477 vccd1 vssd1 vccd1 vssd1 sky130_ef_sc_hd__decap_40_12
XFILLER_65_77 vccd1 vssd1 vccd1 vssd1 sky130_ef_sc_hd__decap_40_12
XFILLER_60_138 vssd1 vssd1 vccd1 vccd1 sky130_fd_sc_hd__fill_2
XANTENNA__1634__B1 net59 vssd1 vssd1 vccd1 vccd1 sky130_fd_sc_hd__diode_2
XFILLER_14_70 vssd1 vssd1 vccd1 vccd1 sky130_fd_sc_hd__fill_2
XANTENNA__2921__S net9 vssd1 vssd1 vccd1 vccd1 sky130_fd_sc_hd__diode_2
XTAP_TAPCELL_ROW_11_266 vssd1 vccd1 sky130_fd_sc_hd__tapvpwrvgnd_1
XANTENNA__2222__A net239 vssd1 vssd1 vccd1 vccd1 sky130_fd_sc_hd__diode_2
X_3000_ MATMULT_INST.matmult_inst.mem_inst.matrixA0\[12\] net64 _1422_ net92 vssd1
+ vssd1 vccd1 vccd1 _1423_ sky130_fd_sc_hd__a22o_1
XANTENNA__2892__A net198 vssd1 vssd1 vccd1 vccd1 sky130_fd_sc_hd__diode_2
XFILLER_64_433 vssd1 vssd1 vccd1 vccd1 sky130_fd_sc_hd__fill_1
XTAP_TAPCELL_ROW_19_333 vssd1 vccd1 sky130_fd_sc_hd__tapvpwrvgnd_1
X_2715_ _1184_ _1185_ _1186_ vssd1 vssd1 vccd1 vccd1 _1187_ sky130_fd_sc_hd__or3_1
XANTENNA__2050__A0 net184 vssd1 vssd1 vccd1 vccd1 sky130_fd_sc_hd__diode_2
X_2646_ net202 _1117_ _1118_ vssd1 vssd1 vccd1 vccd1 _1120_ sky130_fd_sc_hd__and3_1
X_2577_ MATMULT_INST.matmult_inst.fsm_inst.state\[2\] _1529_ _0461_ _1057_ net76 vssd1
+ vssd1 vccd1 vccd1 _1058_ sky130_fd_sc_hd__o311a_1
XANTENNA__1910__S net26 vssd1 vssd1 vccd1 vccd1 sky130_fd_sc_hd__diode_2
X_3129_ clknet_leaf_18_clk _0087_ net131 vssd1 vssd1 vccd1 vccd1 MATMULT_INST.matmult_inst.mem_inst.matrixA2\[8\]
+ sky130_fd_sc_hd__dfrtp_1
XANTENNA_fanout171_X net171 vssd1 vssd1 vccd1 vccd1 sky130_fd_sc_hd__diode_2
XTAP_TAPCELL_ROW_53_623 vssd1 vccd1 sky130_fd_sc_hd__tapvpwrvgnd_1
XFILLER_51_57 vssd1 vssd1 vccd1 vccd1 sky130_fd_sc_hd__fill_4
XANTENNA__2041__A0 net201 vssd1 vssd1 vccd1 vccd1 sky130_fd_sc_hd__diode_2
XFILLER_2_245 vssd1 vssd1 vccd1 vccd1 sky130_fd_sc_hd__fill_4
XFILLER_4_3 vccd1 vssd1 vccd1 vssd1 sky130_ef_sc_hd__decap_40_12
XANTENNA__2344__A1 net228 vssd1 vssd1 vccd1 vccd1 sky130_fd_sc_hd__diode_2
XPHY_EDGE_ROW_29_Left_109 vssd1 vssd1 vccd1 vccd1 sky130_fd_sc_hd__decap_3
XANTENNA__2977__A net177 vssd1 vssd1 vccd1 vccd1 sky130_fd_sc_hd__diode_2
XFILLER_2_289 vccd1 vssd1 vccd1 vssd1 sky130_ef_sc_hd__decap_40_12
XANTENNA_fanout84_X net84 vssd1 vssd1 vccd1 vccd1 sky130_fd_sc_hd__diode_2
XFILLER_65_208 vssd1 vssd1 vccd1 vccd1 sky130_fd_sc_hd__fill_1
XFILLER_58_271 vssd1 vssd1 vccd1 vccd1 sky130_fd_sc_hd__fill_1
XANTENNA__1820__S net15 vssd1 vssd1 vccd1 vccd1 sky130_fd_sc_hd__diode_2
XFILLER_73_285 vssd1 vssd1 vccd1 vccd1 sky130_fd_sc_hd__fill_1
XPHY_EDGE_ROW_38_Left_118 vssd1 vssd1 vccd1 vccd1 sky130_fd_sc_hd__decap_3
XFILLER_61_447 vssd1 vssd1 vccd1 vccd1 sky130_fd_sc_hd__fill_1
XFILLER_14_363 vssd1 vssd1 vccd1 vccd1 sky130_fd_sc_hd__fill_1
XTAP_TAPCELL_ROW_24_380 vssd1 vccd1 sky130_fd_sc_hd__tapvpwrvgnd_1
XFILLER_41_193 vssd1 vssd1 vccd1 vccd1 sky130_fd_sc_hd__fill_2
X_3480_ clknet_leaf_23_clk _0424_ net115 vssd1 vssd1 vccd1 vccd1 MATMULT_INST.matmult_inst.mem_inst.matrixB3\[16\]
+ sky130_fd_sc_hd__dfrtp_1
XANTENNA__3048__A net176 vssd1 vssd1 vccd1 vccd1 sky130_fd_sc_hd__diode_2
X_2500_ net473 _0954_ _1011_ net66 vssd1 vssd1 vccd1 vccd1 _0337_ sky130_fd_sc_hd__a22o_1
XPHY_EDGE_ROW_47_Left_127 vssd1 vssd1 vccd1 vccd1 sky130_fd_sc_hd__decap_3
X_2431_ MATMULT_INST.matmult_inst.mem_inst.matrixA2\[0\] net91 net84 MATMULT_INST.matmult_inst.mem_inst.matrixA1\[0\]
+ _0947_ vssd1 vssd1 vccd1 vccd1 _0948_ sky130_fd_sc_hd__a221o_1
X_2362_ _0903_ _0904_ vssd1 vssd1 vccd1 vccd1 _0906_ sky130_fd_sc_hd__xnor2_1
XFILLER_37_3 vccd1 vssd1 vccd1 vssd1 sky130_ef_sc_hd__decap_40_12
X_2293_ _0826_ _0837_ _0838_ vssd1 vssd1 vccd1 vccd1 _0840_ sky130_fd_sc_hd__and3_1
XFILLER_56_219 vssd1 vssd1 vccd1 vccd1 sky130_fd_sc_hd__fill_2
XANTENNA__1730__S net22 vssd1 vssd1 vccd1 vccd1 sky130_fd_sc_hd__diode_2
XPHY_EDGE_ROW_56_Left_136 vssd1 vssd1 vccd1 vccd1 sky130_fd_sc_hd__decap_3
XFILLER_24_105 vssd1 vssd1 vccd1 vccd1 sky130_fd_sc_hd__fill_1
XFILLER_64_263 vssd1 vssd1 vccd1 vccd1 sky130_fd_sc_hd__fill_2
XFILLER_24_127 vccd1 vssd1 vccd1 vssd1 sky130_ef_sc_hd__decap_40_12
XANTENNA_fanout229_A net230 vssd1 vssd1 vccd1 vccd1 sky130_fd_sc_hd__diode_2
XANTENNA_fanout131_A net132 vssd1 vssd1 vccd1 vccd1 sky130_fd_sc_hd__diode_2
XANTENNA__2561__S net40 vssd1 vssd1 vccd1 vccd1 sky130_fd_sc_hd__diode_2
XFILLER_21_16 vssd1 vssd1 vccd1 vccd1 sky130_fd_sc_hd__fill_1
XPHY_EDGE_ROW_65_Left_145 vssd1 vssd1 vccd1 vccd1 sky130_fd_sc_hd__decap_3
XANTENNA__1905__S net26 vssd1 vssd1 vccd1 vccd1 sky130_fd_sc_hd__diode_2
X_2629_ _1101_ _1102_ _1103_ vssd1 vssd1 vccd1 vccd1 _1104_ sky130_fd_sc_hd__and3_1
XPHY_EDGE_ROW_74_Left_154 vssd1 vssd1 vccd1 vccd1 sky130_fd_sc_hd__decap_3
XFILLER_46_35 vssd1 vssd1 vccd1 vccd1 sky130_fd_sc_hd__fill_1
XFILLER_55_285 vssd1 vssd1 vccd1 vccd1 sky130_fd_sc_hd__fill_1
XFILLER_15_138 vssd1 vssd1 vccd1 vccd1 sky130_fd_sc_hd__fill_1
XTAP_TAPCELL_ROW_38_494 vssd1 vccd1 sky130_fd_sc_hd__tapvpwrvgnd_1
XFILLER_70_255 vssd1 vssd1 vccd1 vccd1 sky130_fd_sc_hd__fill_4
XFILLER_62_23 vssd1 vssd1 vccd1 vccd1 sky130_fd_sc_hd__fill_1
XFILLER_62_89 vssd1 vssd1 vccd1 vccd1 sky130_fd_sc_hd__fill_2
XFILLER_11_333 vssd1 vssd1 vccd1 vccd1 sky130_fd_sc_hd__fill_2
XFILLER_7_337 vccd1 vssd1 vccd1 vssd1 sky130_ef_sc_hd__decap_40_12
XTAP_TAPCELL_ROW_21_350 vssd1 vccd1 sky130_fd_sc_hd__tapvpwrvgnd_1
XFILLER_11_93 vccd1 vssd1 vccd1 vssd1 sky130_ef_sc_hd__decap_40_12
XANTENNA__1815__S net16 vssd1 vssd1 vccd1 vccd1 sky130_fd_sc_hd__diode_2
XTAP_TAPCELL_ROW_64_718 vssd1 vccd1 sky130_fd_sc_hd__tapvpwrvgnd_1
XPHY_EDGE_ROW_1_Left_81 vssd1 vssd1 vccd1 vccd1 sky130_fd_sc_hd__decap_3
X_2980_ MATMULT_INST.matmult_inst.mem_inst.matrixA0\[10\] net64 _1404_ net92 vssd1
+ vssd1 vccd1 vccd1 _1405_ sky130_fd_sc_hd__a22o_1
XTAP_TAPCELL_ROW_72_784 vssd1 vccd1 sky130_fd_sc_hd__tapvpwrvgnd_1
X_1931_ MATMULT_INST.matmult_inst.alu_inst.adder_inst.r0.fa0.b MATMULT_INST.matmult_inst.alu_inst.adder_inst.r0.fa0.a
+ net74 vssd1 vssd1 vccd1 vccd1 _0522_ sky130_fd_sc_hd__o21a_1
XFILLER_14_193 vssd1 vssd1 vccd1 vccd1 sky130_fd_sc_hd__fill_2
X_1862_ net524 net33 net13 vssd1 vssd1 vccd1 vccd1 _0193_ sky130_fd_sc_hd__mux2_1
XANTENNA__2556__A1 _0952_ vssd1 vssd1 vccd1 vccd1 sky130_fd_sc_hd__diode_2
X_1793_ net566 net47 net30 vssd1 vssd1 vccd1 vccd1 _0128_ sky130_fd_sc_hd__mux2_1
X_3532_ clknet_leaf_11_clk MATMULT_INST.matmult_inst.spi_inst.mosi_data_spi\[4\] net147
+ vssd1 vssd1 vccd1 vccd1 MATMULT_INST.matmult_inst.spi_inst.mosi_data_sync\[4\] sky130_fd_sc_hd__dfrtp_1
X_3463_ clknet_leaf_12_clk MATMULT_INST.matmult_inst.spi_inst.rx_done_spi net150 vssd1
+ vssd1 vccd1 vccd1 MATMULT_INST.matmult_inst.spi_inst.rx_done1 sky130_fd_sc_hd__dfrtp_1
XANTENNA__1725__S net23 vssd1 vssd1 vccd1 vccd1 sky130_fd_sc_hd__diode_2
X_2414_ _1514_ _0471_ _0932_ _0934_ vssd1 vssd1 vccd1 vccd1 _0935_ sky130_fd_sc_hd__or4_1
X_3394_ clknet_leaf_10_clk _0348_ net112 vssd1 vssd1 vccd1 vccd1 MATMULT_INST.matmult_inst.fsm_inst.count\[0\]
+ sky130_fd_sc_hd__dfrtp_4
X_2345_ _0889_ vssd1 vssd1 vccd1 vccd1 _0890_ sky130_fd_sc_hd__inv_2
X_2276_ net229 net222 _0787_ _0789_ vssd1 vssd1 vccd1 vccd1 _0823_ sky130_fd_sc_hd__a22o_1
XANTENNA_fanout179_A net180 vssd1 vssd1 vccd1 vccd1 sky130_fd_sc_hd__diode_2
XFILLER_16_49 vssd1 vssd1 vccd1 vccd1 sky130_fd_sc_hd__fill_2
XFILLER_16_27 vssd1 vssd1 vccd1 vccd1 sky130_fd_sc_hd__fill_1
XANTENNA__3036__A2 net87 vssd1 vssd1 vccd1 vccd1 sky130_fd_sc_hd__diode_2
XFILLER_25_469 vssd1 vssd1 vccd1 vccd1 sky130_fd_sc_hd__fill_1
XFILLER_20_130 vssd1 vssd1 vccd1 vccd1 sky130_fd_sc_hd__fill_4
XFILLER_20_141 vssd1 vssd1 vccd1 vccd1 sky130_fd_sc_hd__fill_1
XFILLER_32_15 vssd1 vssd1 vccd1 vccd1 sky130_fd_sc_hd__fill_2
XFILLER_32_26 vssd1 vssd1 vccd1 vccd1 sky130_fd_sc_hd__fill_2
XFILLER_20_163 vssd1 vssd1 vccd1 vccd1 sky130_fd_sc_hd__fill_2
XFILLER_4_307 vssd1 vssd1 vccd1 vccd1 sky130_fd_sc_hd__fill_1
XFILLER_20_185 vssd1 vssd1 vccd1 vccd1 sky130_fd_sc_hd__fill_8
XFILLER_73_55 vssd1 vssd1 vccd1 vccd1 sky130_fd_sc_hd__fill_1
XFILLER_7_167 vssd1 vssd1 vccd1 vccd1 sky130_fd_sc_hd__fill_1
XFILLER_3_373 vccd1 vssd1 vccd1 vssd1 sky130_ef_sc_hd__decap_40_12
XFILLER_78_130 vssd1 vssd1 vccd1 vccd1 sky130_fd_sc_hd__fill_1
X_2130_ net225 net232 _0661_ _0662_ _0633_ vssd1 vssd1 vccd1 vccd1 _0681_ sky130_fd_sc_hd__a41o_1
X_2061_ _0614_ _0615_ net226 net238 vssd1 vssd1 vccd1 vccd1 _0616_ sky130_fd_sc_hd__and4bb_1
XTAP_TAPCELL_ROW_49_589 vssd1 vccd1 sky130_fd_sc_hd__tapvpwrvgnd_1
X_2963_ net156 _1384_ _1388_ net161 vssd1 vssd1 vccd1 vccd1 _1390_ sky130_fd_sc_hd__a22o_1
XTAP_TAPCELL_ROW_32_445 vssd1 vccd1 sky130_fd_sc_hd__tapvpwrvgnd_1
X_1914_ MATMULT_INST.matmult_inst.alu_inst.b0_reg\[0\] net527 net54 vssd1 vssd1 vccd1
+ vccd1 _0242_ sky130_fd_sc_hd__mux2_1
X_2894_ _1314_ _1344_ _1342_ vssd1 vssd1 vccd1 vccd1 _1360_ sky130_fd_sc_hd__o21a_1
XFILLER_8_83 vssd1 vssd1 vccd1 vccd1 sky130_fd_sc_hd__fill_1
X_1845_ net570 net52 net28 vssd1 vssd1 vccd1 vccd1 _0177_ sky130_fd_sc_hd__mux2_1
X_1776_ net375 net44 net18 vssd1 vssd1 vccd1 vccd1 _0113_ sky130_fd_sc_hd__mux2_1
X_3515_ clknet_leaf_15_clk _0440_ net135 vssd1 vssd1 vccd1 vccd1 MATMULT_INST.matmult_inst.spi_inst.tx_reg_sys\[6\]
+ sky130_fd_sc_hd__dfrtp_1
XANTENNA__2140__A net241 vssd1 vssd1 vccd1 vccd1 sky130_fd_sc_hd__diode_2
X_3446_ _0027_ _0392_ net137 vssd1 vssd1 vccd1 vccd1 MATMULT_INST.matmult_inst.spi_inst.mosi_data_spi\[1\]
+ sky130_fd_sc_hd__dfrtp_1
X_3377_ clknet_leaf_10_clk net317 net137 vssd1 vssd1 vccd1 vccd1 MATMULT_INST.matmult_inst.fsm_inst.rx_ready_edge_delay
+ sky130_fd_sc_hd__dfrtp_1
XFILLER_69_163 vssd1 vssd1 vccd1 vccd1 sky130_fd_sc_hd__fill_4
X_2328_ _0844_ _0872_ _0871_ vssd1 vssd1 vccd1 vccd1 _0874_ sky130_fd_sc_hd__a21o_1
XFILLER_27_15 vccd1 vssd1 vccd1 vssd1 sky130_ef_sc_hd__decap_40_12
X_2259_ _0678_ _0750_ vssd1 vssd1 vccd1 vccd1 _0807_ sky130_fd_sc_hd__nand2_1
XANTENNA__2465__B1 net83 vssd1 vssd1 vccd1 vccd1 sky130_fd_sc_hd__diode_2
XFILLER_40_203 vssd1 vssd1 vccd1 vccd1 sky130_fd_sc_hd__fill_2
XFILLER_4_137 vssd1 vssd1 vccd1 vccd1 sky130_fd_sc_hd__fill_2
XFILLER_0_321 vccd1 vssd1 vccd1 vssd1 sky130_ef_sc_hd__decap_40_12
XFILLER_68_77 vssd1 vssd1 vccd1 vccd1 sky130_fd_sc_hd__fill_4
XFILLER_0_365 vssd1 vssd1 vccd1 vccd1 sky130_fd_sc_hd__fill_2
XFILLER_0_398 vccd1 vssd1 vccd1 vssd1 sky130_ef_sc_hd__decap_40_12
XTAP_TAPCELL_ROW_74_802 vssd1 vccd1 sky130_fd_sc_hd__tapvpwrvgnd_1
XFILLER_17_92 vccd1 vssd1 vccd1 vssd1 sky130_ef_sc_hd__decap_40_12
XANTENNA__2924__S net9 vssd1 vssd1 vccd1 vccd1 sky130_fd_sc_hd__diode_2
XTAP_TAPCELL_ROW_46_559 vssd1 vccd1 sky130_fd_sc_hd__tapvpwrvgnd_1
XFILLER_31_225 vssd1 vssd1 vccd1 vccd1 sky130_fd_sc_hd__fill_4
XFILLER_8_421 vccd1 vssd1 vccd1 vssd1 sky130_ef_sc_hd__decap_40_12
X_1630_ _1499_ _0463_ _0462_ _0456_ vssd1 vssd1 vccd1 vccd1 _0464_ sky130_fd_sc_hd__a211o_1
X_1561_ MATMULT_INST.matmult_inst.spi_inst.mosi_shifter\[5\] MATMULT_INST.matmult_inst.spi_inst.mosi_data_spi\[6\]
+ _1491_ vssd1 vssd1 vccd1 vccd1 _0397_ sky130_fd_sc_hd__mux2_1
X_3300_ clknet_leaf_7_clk _0258_ net108 vssd1 vssd1 vccd1 vccd1 MATMULT_INST.matmult_inst.alu_inst.out\[0\]
+ sky130_fd_sc_hd__dfrtp_1
XFILLER_3_181 vccd1 vssd1 vccd1 vssd1 sky130_ef_sc_hd__decap_40_12
XFILLER_79_461 vssd1 vssd1 vccd1 vccd1 sky130_fd_sc_hd__fill_4
X_3231_ clknet_leaf_8_clk _0189_ net134 vssd1 vssd1 vccd1 vccd1 MATMULT_INST.matmult_inst.mem_inst.matrixB2\[2\]
+ sky130_fd_sc_hd__dfrtp_1
X_3162_ clknet_leaf_14_clk _0120_ net143 vssd1 vssd1 vccd1 vccd1 MATMULT_INST.matmult_inst.mem_inst.matrixB1\[5\]
+ sky130_fd_sc_hd__dfrtp_1
X_2113_ net225 _0664_ _0663_ vssd1 vssd1 vccd1 vccd1 _0665_ sky130_fd_sc_hd__a21bo_1
X_3093_ clknet_leaf_18_clk _0051_ net131 vssd1 vssd1 vccd1 vccd1 MATMULT_INST.matmult_inst.mem_inst.matrixB0\[8\]
+ sky130_fd_sc_hd__dfrtp_1
X_2044_ net195 net471 net56 vssd1 vssd1 vccd1 vccd1 _0285_ sky130_fd_sc_hd__mux2_1
XANTENNA__2447__B1 net81 vssd1 vssd1 vccd1 vccd1 sky130_fd_sc_hd__diode_2
Xfanout18 net19 vssd1 vssd1 vccd1 vccd1 net18 sky130_fd_sc_hd__buf_4
Xfanout29 _0516_ vssd1 vssd1 vccd1 vccd1 net29 sky130_fd_sc_hd__buf_4
X_2946_ MATMULT_INST.matmult_inst.fsm_inst.rx_data\[7\] net333 MATMULT_INST.matmult_inst.spi_inst.rx_done_sys
+ vssd1 vssd1 vccd1 vccd1 _0433_ sky130_fd_sc_hd__mux2_1
XFILLER_13_39 vssd1 vssd1 vccd1 vccd1 sky130_fd_sc_hd__fill_1
X_2877_ net198 net187 net201 net185 vssd1 vssd1 vccd1 vccd1 _1344_ sky130_fd_sc_hd__and4_1
X_1828_ net434 _0495_ net14 vssd1 vssd1 vccd1 vccd1 _0161_ sky130_fd_sc_hd__mux2_1
X_1759_ _0509_ _0510_ vssd1 vssd1 vccd1 vccd1 _0511_ sky130_fd_sc_hd__nor2_1
X_3429_ clknet_leaf_30_clk _0381_ vssd1 vssd1 vccd1 vccd1 MATMULT_INST.matmult_inst.alu_inst.adder_inst.r2.fa3.b
+ sky130_fd_sc_hd__dfxtp_1
XFILLER_57_111 vssd1 vssd1 vccd1 vccd1 sky130_fd_sc_hd__fill_1
XFILLER_57_177 vssd1 vssd1 vccd1 vccd1 sky130_fd_sc_hd__fill_2
XANTENNA__2438__B1 _0954_ vssd1 vssd1 vccd1 vccd1 sky130_fd_sc_hd__diode_2
XFILLER_57_188 vssd1 vssd1 vccd1 vccd1 sky130_fd_sc_hd__fill_1
XTAP_TAPCELL_ROW_0_162 vssd1 vccd1 sky130_fd_sc_hd__tapvpwrvgnd_1
XFILLER_13_225 vccd1 vssd1 vccd1 vssd1 sky130_ef_sc_hd__decap_40_12
XTAP_TAPCELL_ROW_0_173 vssd1 vccd1 sky130_fd_sc_hd__tapvpwrvgnd_1
XFILLER_70_34 vssd1 vssd1 vccd1 vccd1 sky130_fd_sc_hd__fill_8
XFILLER_70_12 vssd1 vssd1 vccd1 vccd1 sky130_fd_sc_hd__fill_1
XTAP_TAPCELL_ROW_8_240 vssd1 vccd1 sky130_fd_sc_hd__tapvpwrvgnd_1
XANTENNA__1823__S net15 vssd1 vssd1 vccd1 vccd1 sky130_fd_sc_hd__diode_2
XFILLER_0_195 vssd1 vssd1 vccd1 vccd1 sky130_fd_sc_hd__fill_1
XFILLER_48_144 vssd1 vssd1 vccd1 vccd1 sky130_fd_sc_hd__fill_2
Xteam_02_270 vssd1 vssd1 vccd1 vccd1 team_02_270/HI gpio_out[23] sky130_fd_sc_hd__conb_1
XTAP_TAPCELL_ROW_59_673 vssd1 vccd1 sky130_fd_sc_hd__tapvpwrvgnd_1
Xteam_02_292 vssd1 vssd1 vccd1 vccd1 gpio_oeb[12] team_02_292/LO sky130_fd_sc_hd__conb_1
XANTENNA__2429__B1 net81 vssd1 vssd1 vccd1 vccd1 sky130_fd_sc_hd__diode_2
XFILLER_63_158 vssd1 vssd1 vccd1 vccd1 sky130_fd_sc_hd__fill_1
XFILLER_63_169 vssd1 vssd1 vccd1 vccd1 sky130_fd_sc_hd__fill_1
XANTENNA__1778__B net180 vssd1 vssd1 vccd1 vccd1 sky130_fd_sc_hd__diode_2
X_2800_ net194 net199 _1269_ vssd1 vssd1 vccd1 vccd1 _1270_ sky130_fd_sc_hd__and3_1
XANTENNA_clkbuf_leaf_14_clk_A clknet_2_3__leaf_clk vssd1 vssd1 vccd1 vccd1 sky130_fd_sc_hd__diode_2
X_2731_ _1202_ vssd1 vssd1 vccd1 vccd1 _1203_ sky130_fd_sc_hd__inv_2
XFILLER_8_251 vssd1 vssd1 vccd1 vccd1 sky130_fd_sc_hd__fill_1
X_2662_ net197 net194 net200 net202 vssd1 vssd1 vccd1 vccd1 _1135_ sky130_fd_sc_hd__and4_1
XFILLER_67_3 vssd1 vssd1 vccd1 vccd1 sky130_fd_sc_hd__fill_8
X_1613_ MATMULT_INST.matmult_inst.fsm_inst.count\[2\] _1483_ _1530_ vssd1 vssd1 vccd1
+ vccd1 _1531_ sky130_fd_sc_hd__or3_1
XANTENNA_clkbuf_leaf_29_clk_A clknet_2_0__leaf_clk vssd1 vssd1 vccd1 vccd1 sky130_fd_sc_hd__diode_2
X_2593_ net211 net195 MATMULT_INST.matmult_inst.alu_inst.b1_reg\[0\] net193 vssd1
+ vssd1 vccd1 vccd1 _1070_ sky130_fd_sc_hd__a22oi_1
X_1544_ net332 vssd1 vssd1 vccd1 vccd1 _1485_ sky130_fd_sc_hd__inv_2
XFILLER_5_51 vssd1 vssd1 vccd1 vccd1 sky130_fd_sc_hd__fill_4
Xfanout219 net220 vssd1 vssd1 vccd1 vccd1 net219 sky130_fd_sc_hd__buf_2
Xfanout208 MATMULT_INST.matmult_inst.alu_inst.b1_reg\[2\] vssd1 vssd1 vccd1 vccd1
+ net208 sky130_fd_sc_hd__buf_2
XANTENNA__1733__S net22 vssd1 vssd1 vccd1 vccd1 sky130_fd_sc_hd__diode_2
X_3214_ clknet_leaf_18_clk _0172_ net129 vssd1 vssd1 vccd1 vccd1 MATMULT_INST.matmult_inst.mem_inst.mem1\[3\]
+ sky130_fd_sc_hd__dfrtp_1
XFILLER_39_122 vssd1 vssd1 vccd1 vccd1 sky130_fd_sc_hd__fill_1
X_3145_ clknet_leaf_12_clk _0103_ net146 vssd1 vssd1 vccd1 vccd1 MATMULT_INST.matmult_inst.mem_inst.mem3\[6\]
+ sky130_fd_sc_hd__dfrtp_1
X_3076_ net244 vssd1 vssd1 vccd1 vccd1 _0034_ sky130_fd_sc_hd__inv_2
XFILLER_39_199 vssd1 vssd1 vccd1 vccd1 sky130_fd_sc_hd__fill_4
X_2027_ net642 _0602_ net73 vssd1 vssd1 vccd1 vccd1 _0273_ sky130_fd_sc_hd__mux2_1
XANTENNA_fanout161_A net164 vssd1 vssd1 vccd1 vccd1 sky130_fd_sc_hd__diode_2
XFILLER_24_38 vssd1 vssd1 vccd1 vccd1 sky130_fd_sc_hd__fill_1
X_2929_ net384 net52 net8 vssd1 vssd1 vccd1 vccd1 _0416_ sky130_fd_sc_hd__mux2_1
XANTENNA__1908__S net26 vssd1 vssd1 vccd1 vccd1 sky130_fd_sc_hd__diode_2
XFILLER_40_15 vssd1 vssd1 vccd1 vccd1 sky130_fd_sc_hd__fill_8
Xhold240 MATMULT_INST.matmult_inst.mem_inst.mem0\[12\] vssd1 vssd1 vccd1 vccd1 net553
+ sky130_fd_sc_hd__dlygate4sd3_1
Xhold262 MATMULT_INST.matmult_inst.mem_inst.matrixB0\[17\] vssd1 vssd1 vccd1 vccd1
+ net575 sky130_fd_sc_hd__dlygate4sd3_1
Xhold251 MATMULT_INST.matmult_inst.alu_inst.out\[5\] vssd1 vssd1 vccd1 vccd1 net564
+ sky130_fd_sc_hd__dlygate4sd3_1
Xhold295 MATMULT_INST.matmult_inst.mem_inst.matrixB1\[17\] vssd1 vssd1 vccd1 vccd1
+ net608 sky130_fd_sc_hd__dlygate4sd3_1
Xhold284 MATMULT_INST.matmult_inst.mem_inst.matrixA1\[14\] vssd1 vssd1 vccd1 vccd1
+ net597 sky130_fd_sc_hd__dlygate4sd3_1
Xhold273 MATMULT_INST.matmult_inst.mem_inst.matrixB1\[10\] vssd1 vssd1 vccd1 vccd1
+ net586 sky130_fd_sc_hd__dlygate4sd3_1
XFILLER_65_23 vssd1 vssd1 vccd1 vccd1 sky130_fd_sc_hd__fill_2
XFILLER_65_89 vssd1 vssd1 vccd1 vccd1 sky130_fd_sc_hd__fill_8
XFILLER_73_489 vssd1 vssd1 vccd1 vccd1 sky130_fd_sc_hd__fill_4
XFILLER_60_128 vssd1 vssd1 vccd1 vccd1 sky130_fd_sc_hd__fill_4
XANTENNA__1634__A1 net166 vssd1 vssd1 vccd1 vccd1 sky130_fd_sc_hd__diode_2
XANTENNA__1818__S net15 vssd1 vssd1 vccd1 vccd1 sky130_fd_sc_hd__diode_2
XTAP_TAPCELL_ROW_11_267 vssd1 vccd1 sky130_fd_sc_hd__tapvpwrvgnd_1
XFILLER_5_221 vssd1 vssd1 vccd1 vccd1 sky130_fd_sc_hd__fill_2
XANTENNA__2222__B net213 vssd1 vssd1 vccd1 vccd1 sky130_fd_sc_hd__diode_2
XFILLER_53_9 vssd1 vssd1 vccd1 vccd1 sky130_fd_sc_hd__fill_1
XTAP_TAPCELL_ROW_19_334 vssd1 vccd1 sky130_fd_sc_hd__tapvpwrvgnd_1
XANTENNA__2892__B net184 vssd1 vssd1 vccd1 vccd1 sky130_fd_sc_hd__diode_2
XANTENNA__1728__S net22 vssd1 vssd1 vccd1 vccd1 sky130_fd_sc_hd__diode_2
X_2714_ net189 net206 vssd1 vssd1 vccd1 vccd1 _1186_ sky130_fd_sc_hd__and2_1
X_2645_ net197 net203 _1117_ _1118_ vssd1 vssd1 vccd1 vccd1 _1119_ sky130_fd_sc_hd__a22o_1
XFILLER_10_29 vccd1 vssd1 vccd1 vssd1 sky130_ef_sc_hd__decap_40_12
X_2576_ net183 _0460_ vssd1 vssd1 vccd1 vccd1 _1057_ sky130_fd_sc_hd__or2_1
XFILLER_19_38 vssd1 vssd1 vccd1 vccd1 sky130_fd_sc_hd__fill_1
XFILLER_27_125 vssd1 vssd1 vccd1 vccd1 sky130_fd_sc_hd__fill_1
X_3128_ clknet_leaf_13_clk _0086_ net144 vssd1 vssd1 vccd1 vccd1 MATMULT_INST.matmult_inst.mem_inst.matrixA2\[7\]
+ sky130_fd_sc_hd__dfrtp_1
XANTENNA_fanout164_X net164 vssd1 vssd1 vccd1 vccd1 sky130_fd_sc_hd__diode_2
X_3059_ MATMULT_INST.matmult_inst.mem_inst.matrixB2\[17\] net87 net79 MATMULT_INST.matmult_inst.mem_inst.matrixB1\[17\]
+ _1476_ vssd1 vssd1 vccd1 vccd1 _1477_ sky130_fd_sc_hd__a221o_1
XFILLER_27_169 vssd1 vssd1 vccd1 vccd1 sky130_fd_sc_hd__fill_2
XTAP_TAPCELL_ROW_53_624 vssd1 vccd1 sky130_fd_sc_hd__tapvpwrvgnd_1
XFILLER_51_25 vccd1 vssd1 vccd1 vssd1 sky130_ef_sc_hd__decap_40_12
XTAP_TAPCELL_ROW_61_690 vssd1 vccd1 sky130_fd_sc_hd__tapvpwrvgnd_1
XFILLER_51_47 vssd1 vssd1 vccd1 vccd1 sky130_fd_sc_hd__fill_1
XANTENNA__2592__A2 net68 vssd1 vssd1 vccd1 vccd1 sky130_fd_sc_hd__diode_2
XANTENNA__2977__B net168 vssd1 vssd1 vccd1 vccd1 sky130_fd_sc_hd__diode_2
XANTENNA_fanout77_X net77 vssd1 vssd1 vccd1 vccd1 sky130_fd_sc_hd__diode_2
XFILLER_76_66 vssd1 vssd1 vccd1 vccd1 sky130_fd_sc_hd__fill_1
XANTENNA__2993__A net178 vssd1 vssd1 vccd1 vccd1 sky130_fd_sc_hd__diode_2
XFILLER_73_231 vssd1 vssd1 vccd1 vccd1 sky130_fd_sc_hd__fill_1
XFILLER_18_158 vssd1 vssd1 vccd1 vccd1 sky130_fd_sc_hd__fill_8
XTAP_TAPCELL_ROW_16_304 vssd1 vccd1 sky130_fd_sc_hd__tapvpwrvgnd_1
XFILLER_61_404 vssd1 vssd1 vccd1 vccd1 sky130_fd_sc_hd__fill_1
XFILLER_14_320 vssd1 vssd1 vccd1 vccd1 sky130_fd_sc_hd__fill_4
XANTENNA__2932__S net8 vssd1 vssd1 vccd1 vccd1 sky130_fd_sc_hd__diode_2
XANTENNA__3048__B net167 vssd1 vssd1 vccd1 vccd1 sky130_fd_sc_hd__diode_2
X_2430_ net183 net174 MATMULT_INST.matmult_inst.mem_inst.matrixA3\[0\] vssd1 vssd1
+ vccd1 vccd1 _0947_ sky130_fd_sc_hd__and3_1
X_2361_ _0903_ _0904_ vssd1 vssd1 vccd1 vccd1 _0905_ sky130_fd_sc_hd__nand2b_1
X_2292_ _0837_ _0838_ _0826_ vssd1 vssd1 vccd1 vccd1 _0839_ sky130_fd_sc_hd__a21oi_1
XFILLER_2_41 vccd1 vssd1 vccd1 vssd1 sky130_ef_sc_hd__decap_40_12
XFILLER_56_209 vssd1 vssd1 vccd1 vccd1 sky130_fd_sc_hd__fill_1
XFILLER_2_85 vccd1 vssd1 vccd1 vssd1 sky130_ef_sc_hd__decap_40_12
XTAP_TAPCELL_ROW_67_738 vssd1 vccd1 sky130_fd_sc_hd__tapvpwrvgnd_1
XANTENNA__2127__B net230 vssd1 vssd1 vccd1 vccd1 sky130_fd_sc_hd__diode_2
XFILLER_24_139 vssd1 vssd1 vccd1 vccd1 sky130_fd_sc_hd__fill_1
XANTENNA_fanout124_A net132 vssd1 vssd1 vccd1 vccd1 sky130_fd_sc_hd__diode_2
X_2628_ _1079_ _1083_ _1084_ vssd1 vssd1 vccd1 vccd1 _1103_ sky130_fd_sc_hd__o21ba_1
X_2559_ net377 _0988_ _1052_ vssd1 vssd1 vccd1 vccd1 _0355_ sky130_fd_sc_hd__mux2_1
XFILLER_46_47 vssd1 vssd1 vccd1 vccd1 sky130_fd_sc_hd__fill_1
XFILLER_70_223 vssd1 vssd1 vccd1 vccd1 sky130_fd_sc_hd__fill_4
XTAP_TAPCELL_ROW_38_495 vssd1 vccd1 sky130_fd_sc_hd__tapvpwrvgnd_1
XFILLER_7_305 vccd1 vssd1 vccd1 vssd1 sky130_ef_sc_hd__decap_40_12
XFILLER_11_389 vssd1 vssd1 vccd1 vccd1 sky130_fd_sc_hd__fill_2
XTAP_TAPCELL_ROW_21_351 vssd1 vccd1 sky130_fd_sc_hd__tapvpwrvgnd_1
XFILLER_7_349 vccd1 vssd1 vccd1 vssd1 sky130_ef_sc_hd__decap_40_12
XANTENNA__2927__S net9 vssd1 vssd1 vccd1 vccd1 sky130_fd_sc_hd__diode_2
XANTENNA__1831__S net14 vssd1 vssd1 vccd1 vccd1 sky130_fd_sc_hd__diode_2
XTAP_TAPCELL_ROW_64_719 vssd1 vccd1 sky130_fd_sc_hd__tapvpwrvgnd_1
XFILLER_61_223 vssd1 vssd1 vccd1 vccd1 sky130_fd_sc_hd__fill_1
XFILLER_61_256 vssd1 vssd1 vccd1 vccd1 sky130_fd_sc_hd__fill_2
XTAP_TAPCELL_ROW_72_785 vssd1 vccd1 sky130_fd_sc_hd__tapvpwrvgnd_1
X_1930_ MATMULT_INST.matmult_inst.alu_inst.adder_inst.r0.fa0.b MATMULT_INST.matmult_inst.alu_inst.adder_inst.r0.fa0.a
+ vssd1 vssd1 vccd1 vccd1 _0521_ sky130_fd_sc_hd__nand2_1
X_1861_ net502 net34 net13 vssd1 vssd1 vccd1 vccd1 _0192_ sky130_fd_sc_hd__mux2_1
X_3531_ clknet_leaf_11_clk MATMULT_INST.matmult_inst.spi_inst.mosi_data_spi\[3\] net146
+ vssd1 vssd1 vccd1 vccd1 MATMULT_INST.matmult_inst.spi_inst.mosi_data_sync\[3\] sky130_fd_sc_hd__dfrtp_1
X_1792_ net651 net48 net30 vssd1 vssd1 vccd1 vccd1 _0127_ sky130_fd_sc_hd__mux2_1
X_3462_ _0041_ _0407_ net148 vssd1 vssd1 vccd1 vccd1 MATMULT_INST.matmult_inst.spi_inst.mosi_shifter\[6\]
+ sky130_fd_sc_hd__dfrtp_1
XFILLER_69_301 vssd1 vssd1 vccd1 vccd1 sky130_fd_sc_hd__fill_1
XANTENNA__2410__B net66 vssd1 vssd1 vccd1 vccd1 sky130_fd_sc_hd__diode_2
X_2413_ MATMULT_INST.matmult_inst.fsm_inst.state\[2\] _1482_ MATMULT_INST.matmult_inst.fsm_inst.state\[4\]
+ _1516_ _1505_ vssd1 vssd1 vccd1 vccd1 _0934_ sky130_fd_sc_hd__a41o_1
X_3393_ clknet_leaf_0_clk _0347_ net95 vssd1 vssd1 vccd1 vccd1 MATMULT_INST.matmult_inst.alu_inst.col0\[7\]
+ sky130_fd_sc_hd__dfrtp_1
X_2344_ net228 net216 net229 net215 vssd1 vssd1 vccd1 vccd1 _0889_ sky130_fd_sc_hd__a22o_1
X_2275_ net227 net219 _0787_ _0789_ vssd1 vssd1 vccd1 vccd1 _0822_ sky130_fd_sc_hd__a22oi_1
XANTENNA__1741__S net21 vssd1 vssd1 vccd1 vccd1 sky130_fd_sc_hd__diode_2
XANTENNA__2492__B2 net93 vssd1 vssd1 vccd1 vccd1 sky130_fd_sc_hd__diode_2
XFILLER_12_109 vssd1 vssd1 vccd1 vccd1 sky130_fd_sc_hd__fill_8
XANTENNA__2572__S _1053_ vssd1 vssd1 vccd1 vccd1 sky130_fd_sc_hd__diode_2
XFILLER_20_197 vccd1 vssd1 vccd1 vssd1 sky130_ef_sc_hd__decap_40_12
XFILLER_79_109 vssd1 vssd1 vccd1 vccd1 sky130_fd_sc_hd__fill_2
XFILLER_75_337 vssd1 vssd1 vccd1 vccd1 sky130_fd_sc_hd__fill_1
XFILLER_43_223 vssd1 vssd1 vccd1 vccd1 sky130_fd_sc_hd__fill_1
XFILLER_7_113 vccd1 vssd1 vccd1 vssd1 sky130_ef_sc_hd__decap_40_12
XANTENNA__1826__S net14 vssd1 vssd1 vccd1 vccd1 sky130_fd_sc_hd__diode_2
XFILLER_3_385 vssd1 vssd1 vccd1 vccd1 sky130_fd_sc_hd__fill_4
XFILLER_78_197 vssd1 vssd1 vccd1 vccd1 sky130_fd_sc_hd__fill_2
XFILLER_19_220 vssd1 vssd1 vccd1 vccd1 sky130_fd_sc_hd__fill_4
X_2060_ net240 net224 net241 net221 vssd1 vssd1 vccd1 vccd1 _0615_ sky130_fd_sc_hd__and4_1
X_2962_ net92 _1382_ _1386_ net165 vssd1 vssd1 vccd1 vccd1 _1389_ sky130_fd_sc_hd__a22o_1
X_1913_ _0520_ net668 _0468_ vssd1 vssd1 vccd1 vccd1 _0241_ sky130_fd_sc_hd__mux2_1
XTAP_TAPCELL_ROW_32_446 vssd1 vccd1 sky130_fd_sc_hd__tapvpwrvgnd_1
X_2893_ net198 net201 net185 net184 vssd1 vssd1 vccd1 vccd1 _1359_ sky130_fd_sc_hd__nand4_1
X_1844_ net427 net32 net29 vssd1 vssd1 vccd1 vccd1 _0176_ sky130_fd_sc_hd__mux2_1
X_1775_ net439 net45 net18 vssd1 vssd1 vccd1 vccd1 _0112_ sky130_fd_sc_hd__mux2_1
X_3514_ clknet_leaf_15_clk _0439_ net135 vssd1 vssd1 vccd1 vccd1 MATMULT_INST.matmult_inst.spi_inst.tx_reg_sys\[5\]
+ sky130_fd_sc_hd__dfrtp_1
X_3445_ _0026_ _0391_ net140 vssd1 vssd1 vccd1 vccd1 MATMULT_INST.matmult_inst.spi_inst.mosi_data_spi\[0\]
+ sky130_fd_sc_hd__dfrtp_1
XFILLER_69_142 vssd1 vssd1 vccd1 vccd1 sky130_fd_sc_hd__fill_4
X_3376_ clknet_leaf_6_clk _0331_ net112 vssd1 vssd1 vccd1 vccd1 MATMULT_INST.matmult_inst.fsm_inst.state\[4\]
+ sky130_fd_sc_hd__dfrtp_2
X_2327_ _0844_ _0872_ _0871_ vssd1 vssd1 vccd1 vccd1 _0873_ sky130_fd_sc_hd__a21oi_1
XANTENNA__2567__S _1053_ vssd1 vssd1 vccd1 vccd1 sky130_fd_sc_hd__diode_2
X_2258_ _0766_ _0803_ _0804_ vssd1 vssd1 vccd1 vccd1 _0806_ sky130_fd_sc_hd__nand3_1
XFILLER_27_27 vssd1 vssd1 vccd1 vccd1 sky130_fd_sc_hd__fill_1
X_2189_ _0723_ _0737_ _0738_ vssd1 vssd1 vccd1 vccd1 _0739_ sky130_fd_sc_hd__nand3_1
XFILLER_13_418 vssd1 vssd1 vccd1 vccd1 sky130_fd_sc_hd__fill_1
XFILLER_0_333 vssd1 vssd1 vccd1 vccd1 sky130_fd_sc_hd__fill_2
XFILLER_68_89 vssd1 vssd1 vccd1 vccd1 sky130_fd_sc_hd__fill_1
XFILLER_0_377 vssd1 vssd1 vccd1 vccd1 sky130_fd_sc_hd__fill_4
XTAP_TAPCELL_ROW_74_803 vssd1 vccd1 sky130_fd_sc_hd__tapvpwrvgnd_1
XFILLER_16_278 vssd1 vssd1 vccd1 vccd1 sky130_fd_sc_hd__fill_4
XANTENNA__2940__S MATMULT_INST.matmult_inst.spi_inst.rx_done_sys vssd1 vssd1 vccd1
+ vccd1 sky130_fd_sc_hd__diode_2
XFILLER_8_433 vccd1 vssd1 vccd1 vssd1 sky130_ef_sc_hd__decap_40_12
XFILLER_8_477 vccd1 vssd1 vccd1 vssd1 sky130_ef_sc_hd__decap_40_12
X_1560_ MATMULT_INST.matmult_inst.spi_inst.mosi_shifter\[6\] MATMULT_INST.matmult_inst.spi_inst.mosi_data_spi\[7\]
+ _1491_ vssd1 vssd1 vccd1 vccd1 _0398_ sky130_fd_sc_hd__mux2_1
XANTENNA__2241__A net218 vssd1 vssd1 vccd1 vccd1 sky130_fd_sc_hd__diode_2
XFILLER_79_440 vssd1 vssd1 vccd1 vccd1 sky130_fd_sc_hd__fill_4
XFILLER_3_193 vccd1 vssd1 vccd1 vssd1 sky130_ef_sc_hd__decap_40_12
X_3230_ clknet_leaf_1_clk _0188_ net109 vssd1 vssd1 vccd1 vccd1 MATMULT_INST.matmult_inst.mem_inst.matrixB2\[1\]
+ sky130_fd_sc_hd__dfrtp_1
XFILLER_79_484 vssd1 vssd1 vccd1 vccd1 sky130_fd_sc_hd__fill_1
X_3161_ clknet_leaf_16_clk _0119_ net122 vssd1 vssd1 vccd1 vccd1 MATMULT_INST.matmult_inst.mem_inst.matrixB1\[4\]
+ sky130_fd_sc_hd__dfrtp_1
XANTENNA__2695__A1 net71 vssd1 vssd1 vccd1 vccd1 sky130_fd_sc_hd__diode_2
X_2112_ net232 _0661_ _0662_ vssd1 vssd1 vccd1 vccd1 _0664_ sky130_fd_sc_hd__and3_1
XFILLER_12_3 vccd1 vssd1 vccd1 vssd1 sky130_ef_sc_hd__decap_40_12
XFILLER_66_145 vssd1 vssd1 vccd1 vccd1 sky130_fd_sc_hd__fill_1
X_3092_ clknet_leaf_13_clk _0050_ net145 vssd1 vssd1 vccd1 vccd1 MATMULT_INST.matmult_inst.mem_inst.matrixB0\[7\]
+ sky130_fd_sc_hd__dfrtp_1
X_2043_ net440 net437 net55 vssd1 vssd1 vccd1 vccd1 _0284_ sky130_fd_sc_hd__mux2_1
Xfanout19 _0511_ vssd1 vssd1 vccd1 vccd1 net19 sky130_fd_sc_hd__buf_4
X_2945_ MATMULT_INST.matmult_inst.fsm_inst.rx_data\[6\] net330 MATMULT_INST.matmult_inst.spi_inst.rx_done_sys
+ vssd1 vssd1 vccd1 vccd1 _0432_ sky130_fd_sc_hd__mux2_1
X_2876_ _1342_ vssd1 vssd1 vccd1 vccd1 _1343_ sky130_fd_sc_hd__inv_2
X_1827_ net404 net51 net15 vssd1 vssd1 vccd1 vccd1 _0160_ sky130_fd_sc_hd__mux2_1
X_1758_ net157 _0482_ vssd1 vssd1 vccd1 vccd1 _0510_ sky130_fd_sc_hd__nand2_1
X_1689_ MATMULT_INST.matmult_inst.fsm_inst.rx_data\[5\] net59 net61 MATMULT_INST.matmult_inst.fsm_inst.alu_result\[5\]
+ vssd1 vssd1 vccd1 vccd1 _0490_ sky130_fd_sc_hd__a22o_1
X_3428_ clknet_leaf_30_clk _0380_ vssd1 vssd1 vccd1 vccd1 MATMULT_INST.matmult_inst.alu_inst.adder_inst.r2.fa2.b
+ sky130_fd_sc_hd__dfxtp_1
X_3359_ clknet_leaf_7_clk _0314_ net109 vssd1 vssd1 vccd1 vccd1 MATMULT_INST.matmult_inst.fsm_inst.alu_result\[5\]
+ sky130_fd_sc_hd__dfrtp_1
XANTENNA__2438__A1 net66 vssd1 vssd1 vccd1 vccd1 sky130_fd_sc_hd__diode_2
XTAP_TAPCELL_ROW_0_163 vssd1 vccd1 sky130_fd_sc_hd__tapvpwrvgnd_1
XTAP_TAPCELL_ROW_0_174 vssd1 vccd1 sky130_fd_sc_hd__tapvpwrvgnd_1
XFILLER_13_237 vccd1 vssd1 vccd1 vssd1 sky130_ef_sc_hd__decap_40_12
XFILLER_21_281 vssd1 vssd1 vccd1 vccd1 sky130_fd_sc_hd__fill_1
XFILLER_5_447 vssd1 vssd1 vccd1 vccd1 sky130_fd_sc_hd__fill_1
XFILLER_79_55 vssd1 vssd1 vccd1 vccd1 sky130_fd_sc_hd__fill_1
XTAP_TAPCELL_ROW_8_241 vssd1 vccd1 sky130_fd_sc_hd__tapvpwrvgnd_1
XFILLER_0_141 vccd1 vssd1 vccd1 vssd1 sky130_ef_sc_hd__decap_40_12
Xteam_02_271 vssd1 vssd1 vccd1 vccd1 team_02_271/HI gpio_out[24] sky130_fd_sc_hd__conb_1
Xteam_02_260 vssd1 vssd1 vccd1 vccd1 team_02_260/HI gpio_out[13] sky130_fd_sc_hd__conb_1
XTAP_TAPCELL_ROW_59_674 vssd1 vccd1 sky130_fd_sc_hd__tapvpwrvgnd_1
Xteam_02_282 vssd1 vssd1 vccd1 vccd1 gpio_oeb[0] team_02_282/LO sky130_fd_sc_hd__conb_1
Xteam_02_293 vssd1 vssd1 vccd1 vccd1 gpio_oeb[13] team_02_293/LO sky130_fd_sc_hd__conb_1
XANTENNA__2935__S net8 vssd1 vssd1 vccd1 vccd1 sky130_fd_sc_hd__diode_2
XFILLER_63_137 vssd1 vssd1 vccd1 vccd1 sky130_fd_sc_hd__fill_2
XTAP_TAPCELL_ROW_42_530 vssd1 vccd1 sky130_fd_sc_hd__tapvpwrvgnd_1
XTAP_TAPCELL_ROW_14_287 vssd1 vccd1 sky130_fd_sc_hd__tapvpwrvgnd_1
XANTENNA__2523__X _1033_ vssd1 vssd1 vccd1 vccd1 sky130_fd_sc_hd__diode_2
X_2730_ _1158_ _1200_ _1201_ vssd1 vssd1 vccd1 vccd1 _1202_ sky130_fd_sc_hd__or3_1
X_2661_ net197 net200 vssd1 vssd1 vccd1 vccd1 _1134_ sky130_fd_sc_hd__nand2_1
X_1612_ _1529_ vssd1 vssd1 vccd1 vccd1 _1530_ sky130_fd_sc_hd__inv_2
X_2592_ net665 net68 _1067_ _1069_ vssd1 vssd1 vccd1 vccd1 _0371_ sky130_fd_sc_hd__a22o_1
X_1543_ MATMULT_INST.matmult_inst.alu_inst.complete vssd1 vssd1 vccd1 vccd1 _1484_
+ sky130_fd_sc_hd__inv_2
Xfanout209 MATMULT_INST.matmult_inst.alu_inst.b1_reg\[2\] vssd1 vssd1 vccd1 vccd1
+ net209 sky130_fd_sc_hd__buf_2
X_3213_ clknet_leaf_9_clk _0171_ net138 vssd1 vssd1 vccd1 vccd1 MATMULT_INST.matmult_inst.mem_inst.mem1\[2\]
+ sky130_fd_sc_hd__dfrtp_1
XFILLER_39_145 vssd1 vssd1 vccd1 vccd1 sky130_fd_sc_hd__fill_1
X_3144_ clknet_leaf_15_clk _0102_ net121 vssd1 vssd1 vccd1 vccd1 MATMULT_INST.matmult_inst.mem_inst.mem3\[5\]
+ sky130_fd_sc_hd__dfrtp_1
X_3075_ net244 vssd1 vssd1 vccd1 vccd1 _0033_ sky130_fd_sc_hd__inv_2
X_2026_ _0600_ _0601_ vssd1 vssd1 vccd1 vccd1 _0602_ sky130_fd_sc_hd__xnor2_1
X_2928_ net405 net32 net9 vssd1 vssd1 vccd1 vccd1 _0415_ sky130_fd_sc_hd__mux2_1
X_2859_ _1297_ _1326_ vssd1 vssd1 vccd1 vccd1 _1327_ sky130_fd_sc_hd__or2_1
XFILLER_2_417 vssd1 vssd1 vccd1 vccd1 sky130_fd_sc_hd__fill_2
Xhold252 MATMULT_INST.matmult_inst.mem_inst.matrixA1\[8\] vssd1 vssd1 vccd1 vccd1
+ net565 sky130_fd_sc_hd__dlygate4sd3_1
Xhold241 MATMULT_INST.matmult_inst.mem_inst.mem2\[8\] vssd1 vssd1 vccd1 vccd1 net554
+ sky130_fd_sc_hd__dlygate4sd3_1
Xhold230 MATMULT_INST.matmult_inst.alu_inst.adder_inst.r0.fa3.b vssd1 vssd1 vccd1
+ vccd1 net543 sky130_fd_sc_hd__dlygate4sd3_1
Xhold296 MATMULT_INST.matmult_inst.mem_inst.matrixA1\[15\] vssd1 vssd1 vccd1 vccd1
+ net609 sky130_fd_sc_hd__dlygate4sd3_1
Xhold274 MATMULT_INST.matmult_inst.mem_inst.matrixB2\[15\] vssd1 vssd1 vccd1 vccd1
+ net587 sky130_fd_sc_hd__dlygate4sd3_1
Xhold285 MATMULT_INST.matmult_inst.mem_inst.matrixA3\[15\] vssd1 vssd1 vccd1 vccd1
+ net598 sky130_fd_sc_hd__dlygate4sd3_1
Xhold263 MATMULT_INST.matmult_inst.mem_inst.matrixB1\[1\] vssd1 vssd1 vccd1 vccd1
+ net576 sky130_fd_sc_hd__dlygate4sd3_1
XTAP_TAPCELL_ROW_5_211 vssd1 vccd1 sky130_fd_sc_hd__tapvpwrvgnd_1
XFILLER_18_307 vssd1 vssd1 vccd1 vccd1 sky130_fd_sc_hd__fill_1
XANTENNA_fanout67_A net68 vssd1 vssd1 vccd1 vccd1 sky130_fd_sc_hd__diode_2
XFILLER_65_57 vssd1 vssd1 vccd1 vccd1 sky130_fd_sc_hd__fill_2
XTAP_TAPCELL_ROW_56_644 vssd1 vccd1 sky130_fd_sc_hd__tapvpwrvgnd_1
XANTENNA__2056__A net240 vssd1 vssd1 vccd1 vccd1 sky130_fd_sc_hd__diode_2
XFILLER_53_181 vccd1 vssd1 vccd1 vssd1 sky130_ef_sc_hd__decap_40_12
XANTENNA_fanout22_X net22 vssd1 vssd1 vccd1 vccd1 sky130_fd_sc_hd__diode_2
XANTENNA_clkbuf_2_3__f_clk_A clknet_0_clk vssd1 vssd1 vccd1 vccd1 sky130_fd_sc_hd__diode_2
XTAP_TAPCELL_ROW_11_268 vssd1 vccd1 sky130_fd_sc_hd__tapvpwrvgnd_1
XFILLER_5_277 vssd1 vssd1 vccd1 vccd1 sky130_fd_sc_hd__fill_2
XANTENNA__1834__S net14 vssd1 vssd1 vccd1 vccd1 sky130_fd_sc_hd__diode_2
XFILLER_1_461 vccd1 vssd1 vccd1 vssd1 sky130_ef_sc_hd__decap_40_12
XFILLER_39_80 vssd1 vssd1 vccd1 vccd1 sky130_fd_sc_hd__fill_1
XFILLER_64_402 vssd1 vssd1 vccd1 vccd1 sky130_fd_sc_hd__fill_1
XTAP_TAPCELL_ROW_19_335 vssd1 vccd1 sky130_fd_sc_hd__tapvpwrvgnd_1
XFILLER_17_395 vssd1 vssd1 vccd1 vccd1 sky130_fd_sc_hd__fill_1
XFILLER_44_170 vssd1 vssd1 vccd1 vccd1 sky130_fd_sc_hd__fill_1
XANTENNA__2822__A1 net203 vssd1 vssd1 vccd1 vccd1 sky130_fd_sc_hd__diode_2
X_2713_ net202 net204 net192 net190 vssd1 vssd1 vccd1 vccd1 _1185_ sky130_fd_sc_hd__and4_1
X_2644_ net211 net212 MATMULT_INST.matmult_inst.alu_inst.a1_reg\[4\] net188 vssd1
+ vssd1 vccd1 vccd1 _1118_ sky130_fd_sc_hd__nand4_2
X_2575_ _1497_ _1522_ _1526_ vssd1 vssd1 vccd1 vccd1 _1056_ sky130_fd_sc_hd__o21ai_1
XANTENNA__2889__B2 net68 vssd1 vssd1 vccd1 vccd1 sky130_fd_sc_hd__diode_2
XANTENNA__1744__S net21 vssd1 vssd1 vccd1 vccd1 sky130_fd_sc_hd__diode_2
XFILLER_19_28 vssd1 vssd1 vccd1 vccd1 sky130_fd_sc_hd__fill_8
X_3127_ clknet_leaf_12_clk _0085_ net149 vssd1 vssd1 vccd1 vccd1 MATMULT_INST.matmult_inst.mem_inst.matrixA2\[6\]
+ sky130_fd_sc_hd__dfrtp_1
XANTENNA__1699__B net60 vssd1 vssd1 vccd1 vccd1 sky130_fd_sc_hd__diode_2
X_3058_ net178 net169 MATMULT_INST.matmult_inst.mem_inst.matrixB3\[17\] vssd1 vssd1
+ vccd1 vccd1 _1476_ sky130_fd_sc_hd__and3_1
X_2009_ net546 _0587_ net73 vssd1 vssd1 vccd1 vccd1 _0270_ sky130_fd_sc_hd__mux2_1
XTAP_TAPCELL_ROW_53_625 vssd1 vccd1 sky130_fd_sc_hd__tapvpwrvgnd_1
XANTENNA__2813__A1 MATMULT_INST.matmult_inst.alu_inst.a1_reg\[4\] vssd1 vssd1 vccd1
+ vccd1 sky130_fd_sc_hd__diode_2
XANTENNA_fanout157_X net157 vssd1 vssd1 vccd1 vccd1 sky130_fd_sc_hd__diode_2
XFILLER_51_15 vssd1 vssd1 vccd1 vccd1 sky130_fd_sc_hd__fill_4
XFILLER_50_195 vssd1 vssd1 vccd1 vccd1 sky130_fd_sc_hd__fill_1
XFILLER_51_37 vssd1 vssd1 vccd1 vccd1 sky130_fd_sc_hd__fill_8
XTAP_TAPCELL_ROW_61_691 vssd1 vccd1 sky130_fd_sc_hd__tapvpwrvgnd_1
XANTENNA_clkbuf_leaf_13_clk_A clknet_2_3__leaf_clk vssd1 vssd1 vccd1 vccd1 sky130_fd_sc_hd__diode_2
XANTENNA__2993__B net169 vssd1 vssd1 vccd1 vccd1 sky130_fd_sc_hd__diode_2
XTAP_TAPCELL_ROW_16_305 vssd1 vccd1 sky130_fd_sc_hd__tapvpwrvgnd_1
XANTENNA__3057__B2 net92 vssd1 vssd1 vccd1 vccd1 sky130_fd_sc_hd__diode_2
XFILLER_46_479 vssd1 vssd1 vccd1 vccd1 sky130_fd_sc_hd__fill_1
XFILLER_61_427 vssd1 vssd1 vccd1 vccd1 sky130_fd_sc_hd__fill_1
XFILLER_26_181 vssd1 vssd1 vccd1 vccd1 sky130_fd_sc_hd__fill_1
XANTENNA_clkbuf_leaf_28_clk_A clknet_2_0__leaf_clk vssd1 vssd1 vccd1 vccd1 sky130_fd_sc_hd__diode_2
XFILLER_25_71 vssd1 vssd1 vccd1 vccd1 sky130_fd_sc_hd__fill_1
XANTENNA__1829__S net14 vssd1 vssd1 vccd1 vccd1 sky130_fd_sc_hd__diode_2
XANTENNA__2568__A0 _0988_ vssd1 vssd1 vccd1 vccd1 sky130_fd_sc_hd__diode_2
XANTENNA__2514__A net182 vssd1 vssd1 vccd1 vccd1 sky130_fd_sc_hd__diode_2
X_2360_ _0857_ _0891_ _0889_ vssd1 vssd1 vccd1 vccd1 _0904_ sky130_fd_sc_hd__o21a_1
X_2291_ _0827_ _0834_ _0835_ vssd1 vssd1 vccd1 vccd1 _0838_ sky130_fd_sc_hd__or3_1
XPHY_EDGE_ROW_10_Right_10 vssd1 vssd1 vccd1 vccd1 sky130_fd_sc_hd__decap_3
XFILLER_2_53 vccd1 vssd1 vccd1 vssd1 sky130_ef_sc_hd__decap_40_12
XTAP_TAPCELL_ROW_67_739 vssd1 vccd1 sky130_fd_sc_hd__tapvpwrvgnd_1
XFILLER_2_97 vccd1 vssd1 vccd1 vssd1 sky130_ef_sc_hd__decap_40_12
XFILLER_64_221 vccd1 vssd1 vccd1 vssd1 sky130_ef_sc_hd__decap_40_12
XANTENNA__1739__S net21 vssd1 vssd1 vccd1 vccd1 sky130_fd_sc_hd__diode_2
XANTENNA__2424__A net183 vssd1 vssd1 vccd1 vccd1 sky130_fd_sc_hd__diode_2
XFILLER_9_391 vssd1 vssd1 vccd1 vccd1 sky130_fd_sc_hd__fill_1
X_2627_ _1094_ _1095_ _1100_ vssd1 vssd1 vccd1 vccd1 _1102_ sky130_fd_sc_hd__or3_1
X_2558_ net357 _0977_ _1052_ vssd1 vssd1 vccd1 vccd1 _0354_ sky130_fd_sc_hd__mux2_1
X_2489_ net182 net173 MATMULT_INST.matmult_inst.mem_inst.matrixB3\[5\] vssd1 vssd1
+ vccd1 vccd1 _1001_ sky130_fd_sc_hd__and3_1
XFILLER_46_15 vssd1 vssd1 vccd1 vccd1 sky130_fd_sc_hd__fill_1
XANTENNA__3039__B2 net165 vssd1 vssd1 vccd1 vccd1 sky130_fd_sc_hd__diode_2
XANTENNA__3039__A1 net92 vssd1 vssd1 vccd1 vccd1 sky130_fd_sc_hd__diode_2
XFILLER_70_235 vssd1 vssd1 vccd1 vccd1 sky130_fd_sc_hd__fill_1
XTAP_TAPCELL_ROW_38_496 vssd1 vccd1 sky130_fd_sc_hd__tapvpwrvgnd_1
XFILLER_62_47 vssd1 vssd1 vccd1 vccd1 sky130_fd_sc_hd__fill_4
XFILLER_11_335 vssd1 vssd1 vccd1 vccd1 sky130_fd_sc_hd__fill_1
XFILLER_7_317 vccd1 vssd1 vccd1 vssd1 sky130_ef_sc_hd__decap_40_12
XTAP_TAPCELL_ROW_21_352 vssd1 vccd1 sky130_fd_sc_hd__tapvpwrvgnd_1
XFILLER_11_51 vssd1 vssd1 vccd1 vccd1 sky130_fd_sc_hd__fill_4
XANTENNA__2943__S MATMULT_INST.matmult_inst.spi_inst.rx_done_sys vssd1 vssd1 vccd1
+ vccd1 sky130_fd_sc_hd__diode_2
Xclkbuf_leaf_26_clk clknet_2_0__leaf_clk vssd1 vssd1 vccd1 vccd1 clknet_leaf_26_clk
+ sky130_fd_sc_hd__clkbuf_8
XTAP_TAPCELL_ROW_72_786 vssd1 vccd1 sky130_fd_sc_hd__tapvpwrvgnd_1
XFILLER_14_195 vssd1 vssd1 vccd1 vccd1 sky130_fd_sc_hd__fill_1
XFILLER_42_493 vssd1 vssd1 vccd1 vccd1 sky130_fd_sc_hd__fill_1
X_1860_ net538 net35 net12 vssd1 vssd1 vccd1 vccd1 _0191_ sky130_fd_sc_hd__mux2_1
X_1791_ net551 net49 net30 vssd1 vssd1 vccd1 vccd1 _0126_ sky130_fd_sc_hd__mux2_1
X_3530_ clknet_leaf_11_clk MATMULT_INST.matmult_inst.spi_inst.mosi_data_spi\[2\] net139
+ vssd1 vssd1 vccd1 vccd1 MATMULT_INST.matmult_inst.spi_inst.mosi_data_sync\[2\] sky130_fd_sc_hd__dfrtp_1
XFILLER_6_361 vssd1 vssd1 vccd1 vccd1 sky130_fd_sc_hd__fill_2
XANTENNA__2961__B1 net80 vssd1 vssd1 vccd1 vccd1 sky130_fd_sc_hd__diode_2
X_3461_ _0040_ _0406_ net147 vssd1 vssd1 vccd1 vccd1 MATMULT_INST.matmult_inst.spi_inst.mosi_shifter\[5\]
+ sky130_fd_sc_hd__dfrtp_1
X_2412_ MATMULT_INST.matmult_inst.fsm_inst.state\[3\] _1513_ _0930_ vssd1 vssd1 vccd1
+ vccd1 _0933_ sky130_fd_sc_hd__a21o_1
X_3392_ clknet_leaf_28_clk _0346_ net95 vssd1 vssd1 vccd1 vccd1 MATMULT_INST.matmult_inst.alu_inst.col0\[6\]
+ sky130_fd_sc_hd__dfrtp_1
XFILLER_42_3 vssd1 vssd1 vccd1 vccd1 sky130_fd_sc_hd__fill_8
X_2343_ net230 net215 vssd1 vssd1 vccd1 vccd1 _0888_ sky130_fd_sc_hd__nand2_1
X_2274_ net419 _0821_ net70 vssd1 vssd1 vccd1 vccd1 _0301_ sky130_fd_sc_hd__mux2_1
XFILLER_16_29 vccd1 vssd1 vccd1 vssd1 sky130_ef_sc_hd__decap_40_12
XFILLER_25_427 vssd1 vssd1 vccd1 vccd1 sky130_fd_sc_hd__fill_1
XANTENNA__2492__A2 net65 vssd1 vssd1 vccd1 vccd1 sky130_fd_sc_hd__diode_2
Xclkbuf_leaf_17_clk clknet_2_2__leaf_clk vssd1 vssd1 vccd1 vccd1 clknet_leaf_17_clk
+ sky130_fd_sc_hd__clkbuf_8
XTAP_TAPCELL_ROW_35_466 vssd1 vccd1 sky130_fd_sc_hd__tapvpwrvgnd_1
XFILLER_40_419 vssd1 vssd1 vccd1 vccd1 sky130_fd_sc_hd__fill_1
XFILLER_32_17 vssd1 vssd1 vccd1 vccd1 sky130_fd_sc_hd__fill_1
XFILLER_33_493 vssd1 vssd1 vccd1 vccd1 sky130_fd_sc_hd__fill_1
XFILLER_20_165 vssd1 vssd1 vccd1 vccd1 sky130_fd_sc_hd__fill_1
X_1989_ _0557_ _0562_ _0565_ _0563_ vssd1 vssd1 vccd1 vccd1 _0571_ sky130_fd_sc_hd__o31a_1
XFILLER_4_309 vccd1 vssd1 vccd1 vssd1 sky130_ef_sc_hd__decap_40_12
XFILLER_75_327 vssd1 vssd1 vccd1 vccd1 sky130_fd_sc_hd__fill_8
XFILLER_28_221 vssd1 vssd1 vccd1 vccd1 sky130_fd_sc_hd__fill_2
XANTENNA__3506__CLK net242 vssd1 vssd1 vccd1 vccd1 sky130_fd_sc_hd__diode_2
XANTENNA__1691__B1 net61 vssd1 vssd1 vccd1 vccd1 sky130_fd_sc_hd__diode_2
XFILLER_73_57 vccd1 vssd1 vccd1 vssd1 sky130_ef_sc_hd__decap_40_12
XFILLER_11_165 vssd1 vssd1 vccd1 vccd1 sky130_fd_sc_hd__fill_2
XFILLER_7_125 vccd1 vssd1 vccd1 vssd1 sky130_ef_sc_hd__decap_40_12
XFILLER_7_169 vccd1 vssd1 vccd1 vssd1 sky130_ef_sc_hd__decap_40_12
XANTENNA__2511__B _1021_ vssd1 vssd1 vccd1 vccd1 sky130_fd_sc_hd__diode_2
XANTENNA__2938__S net8 vssd1 vssd1 vccd1 vccd1 sky130_fd_sc_hd__diode_2
XANTENNA__1842__S net29 vssd1 vssd1 vccd1 vccd1 sky130_fd_sc_hd__diode_2
XTAP_TAPCELL_ROW_77_823 vssd1 vccd1 sky130_fd_sc_hd__tapvpwrvgnd_1
XFILLER_74_393 vssd1 vssd1 vccd1 vccd1 sky130_fd_sc_hd__fill_1
XANTENNA__2526__X _1035_ vssd1 vssd1 vccd1 vccd1 sky130_fd_sc_hd__diode_2
X_2961_ MATMULT_INST.matmult_inst.mem_inst.matrixB2\[8\] net88 net80 MATMULT_INST.matmult_inst.mem_inst.matrixB1\[8\]
+ _1387_ vssd1 vssd1 vccd1 vccd1 _1388_ sky130_fd_sc_hd__a221o_1
X_1912_ MATMULT_INST.matmult_inst.fsm_inst.tx_ready_delay MATMULT_INST.matmult_inst.spi_inst.current_state
+ vssd1 vssd1 vccd1 vccd1 _0520_ sky130_fd_sc_hd__nor2_1
XTAP_TAPCELL_ROW_32_447 vssd1 vccd1 sky130_fd_sc_hd__tapvpwrvgnd_1
XFILLER_8_41 vccd1 vssd1 vccd1 vssd1 sky130_ef_sc_hd__decap_40_12
X_2892_ net198 net184 vssd1 vssd1 vccd1 vccd1 _1358_ sky130_fd_sc_hd__nand2_1
XFILLER_8_85 vccd1 vssd1 vccd1 vssd1 sky130_ef_sc_hd__decap_40_12
X_1843_ net530 net33 net29 vssd1 vssd1 vccd1 vccd1 _0175_ sky130_fd_sc_hd__mux2_1
X_1774_ net365 net46 net18 vssd1 vssd1 vccd1 vccd1 _0111_ sky130_fd_sc_hd__mux2_1
X_3513_ clknet_leaf_16_clk _0438_ net133 vssd1 vssd1 vccd1 vccd1 MATMULT_INST.matmult_inst.spi_inst.tx_reg_sys\[4\]
+ sky130_fd_sc_hd__dfrtp_1
X_3444_ clknet_leaf_10_clk MATMULT_INST.matmult_inst.cs net137 vssd1 vssd1 vccd1 vccd1
+ MATMULT_INST.matmult_inst.spi_inst.cs_sync sky130_fd_sc_hd__dfstp_1
Xclkbuf_leaf_6_clk clknet_2_1__leaf_clk vssd1 vssd1 vccd1 vccd1 clknet_leaf_6_clk
+ sky130_fd_sc_hd__clkbuf_8
XANTENNA__3009__S net57 vssd1 vssd1 vccd1 vccd1 sky130_fd_sc_hd__diode_2
X_3375_ clknet_leaf_6_clk _0330_ net112 vssd1 vssd1 vccd1 vccd1 MATMULT_INST.matmult_inst.fsm_inst.state\[3\]
+ sky130_fd_sc_hd__dfrtp_4
XFILLER_69_132 vssd1 vssd1 vccd1 vccd1 sky130_fd_sc_hd__fill_8
XANTENNA__1752__S net20 vssd1 vssd1 vccd1 vccd1 sky130_fd_sc_hd__diode_2
X_2326_ _0805_ _0841_ _0842_ _0825_ vssd1 vssd1 vccd1 vccd1 _0872_ sky130_fd_sc_hd__a31o_1
XFILLER_57_316 vssd1 vssd1 vccd1 vccd1 sky130_fd_sc_hd__fill_1
X_2257_ _0766_ _0804_ _0803_ vssd1 vssd1 vccd1 vccd1 _0805_ sky130_fd_sc_hd__a21o_1
X_2188_ _0733_ _0734_ _0736_ vssd1 vssd1 vccd1 vccd1 _0738_ sky130_fd_sc_hd__a21o_1
XANTENNA__2465__A2 net90 vssd1 vssd1 vccd1 vccd1 sky130_fd_sc_hd__diode_2
XTAP_TAPCELL_ROW_48_580 vssd1 vccd1 sky130_fd_sc_hd__tapvpwrvgnd_1
XFILLER_25_257 vssd1 vssd1 vccd1 vccd1 sky130_fd_sc_hd__fill_4
XFILLER_4_139 vssd1 vssd1 vccd1 vccd1 sky130_fd_sc_hd__fill_1
XFILLER_0_345 vssd1 vssd1 vccd1 vccd1 sky130_fd_sc_hd__fill_1
XFILLER_75_102 vssd1 vssd1 vccd1 vccd1 sky130_fd_sc_hd__fill_2
XTAP_TAPCELL_ROW_74_804 vssd1 vccd1 sky130_fd_sc_hd__tapvpwrvgnd_1
XTAP_TAPCELL_ROW_3_194 vssd1 vccd1 sky130_fd_sc_hd__tapvpwrvgnd_1
XFILLER_17_83 vssd1 vssd1 vccd1 vccd1 sky130_fd_sc_hd__fill_2
XFILLER_8_401 vccd1 vssd1 vccd1 vssd1 sky130_ef_sc_hd__decap_40_12
XFILLER_8_445 vccd1 vssd1 vccd1 vssd1 sky130_ef_sc_hd__decap_40_12
XANTENNA__1837__S net29 vssd1 vssd1 vccd1 vccd1 sky130_fd_sc_hd__diode_2
XFILLER_8_489 vssd1 vssd1 vccd1 vccd1 sky130_fd_sc_hd__fill_4
XANTENNA__2392__B2 MATMULT_INST.matmult_inst.fsm_inst.alu_result\[8\] vssd1 vssd1
+ vccd1 vccd1 sky130_fd_sc_hd__diode_2
XFILLER_3_161 vssd1 vssd1 vccd1 vccd1 sky130_fd_sc_hd__fill_4
X_3160_ clknet_leaf_18_clk _0118_ net131 vssd1 vssd1 vccd1 vccd1 MATMULT_INST.matmult_inst.mem_inst.matrixB1\[3\]
+ sky130_fd_sc_hd__dfrtp_1
Xhold1 MATMULT_INST.matmult_inst.spi_inst.rx_done1 vssd1 vssd1 vccd1 vccd1 net314
+ sky130_fd_sc_hd__dlygate4sd3_1
X_3091_ clknet_leaf_12_clk _0049_ net149 vssd1 vssd1 vccd1 vccd1 MATMULT_INST.matmult_inst.mem_inst.matrixB0\[6\]
+ sky130_fd_sc_hd__dfrtp_1
X_2111_ net225 net232 _0661_ _0662_ vssd1 vssd1 vccd1 vccd1 _0663_ sky130_fd_sc_hd__a22o_1
X_2042_ net198 net599 net55 vssd1 vssd1 vccd1 vccd1 _0283_ sky130_fd_sc_hd__mux2_1
XANTENNA__2447__A2 net89 vssd1 vssd1 vccd1 vccd1 sky130_fd_sc_hd__diode_2
XPHY_EDGE_ROW_8_Right_8 vssd1 vssd1 vccd1 vccd1 sky130_fd_sc_hd__decap_3
XFILLER_62_363 vssd1 vssd1 vccd1 vccd1 sky130_fd_sc_hd__fill_1
X_2944_ MATMULT_INST.matmult_inst.fsm_inst.rx_data\[5\] net324 MATMULT_INST.matmult_inst.spi_inst.rx_done_sys
+ vssd1 vssd1 vccd1 vccd1 _0431_ sky130_fd_sc_hd__mux2_1
XANTENNA__1747__S net20 vssd1 vssd1 vccd1 vccd1 sky130_fd_sc_hd__diode_2
X_2875_ net198 net187 net201 net185 vssd1 vssd1 vccd1 vccd1 _1342_ sky130_fd_sc_hd__a22o_1
X_1826_ net383 net52 net14 vssd1 vssd1 vccd1 vccd1 _0159_ sky130_fd_sc_hd__mux2_1
X_1757_ net181 net172 vssd1 vssd1 vccd1 vccd1 _0509_ sky130_fd_sc_hd__nand2_1
XFILLER_1_109 vssd1 vssd1 vccd1 vccd1 sky130_fd_sc_hd__fill_2
X_1688_ net450 net35 net25 vssd1 vssd1 vccd1 vccd1 _0047_ sky130_fd_sc_hd__mux2_1
XPHY_EDGE_ROW_39_Right_39 vssd1 vssd1 vccd1 vccd1 sky130_fd_sc_hd__decap_3
X_3427_ clknet_leaf_30_clk _0379_ vssd1 vssd1 vccd1 vccd1 MATMULT_INST.matmult_inst.alu_inst.adder_inst.r2.fa1.b
+ sky130_fd_sc_hd__dfxtp_1
X_3358_ clknet_leaf_1_clk net545 net109 vssd1 vssd1 vccd1 vccd1 MATMULT_INST.matmult_inst.fsm_inst.alu_result\[4\]
+ sky130_fd_sc_hd__dfrtp_1
X_2309_ _0853_ _0854_ vssd1 vssd1 vccd1 vccd1 _0855_ sky130_fd_sc_hd__or2_1
XFILLER_57_113 vssd1 vssd1 vccd1 vccd1 sky130_fd_sc_hd__fill_1
X_3289_ clknet_leaf_28_clk _0247_ net96 vssd1 vssd1 vccd1 vccd1 MATMULT_INST.matmult_inst.alu_inst.b0_reg\[5\]
+ sky130_fd_sc_hd__dfrtp_1
XANTENNA_fanout187_X net187 vssd1 vssd1 vccd1 vccd1 sky130_fd_sc_hd__diode_2
XANTENNA__2438__A2 _0952_ vssd1 vssd1 vccd1 vccd1 sky130_fd_sc_hd__diode_2
XFILLER_13_205 vccd1 vssd1 vccd1 vssd1 sky130_ef_sc_hd__decap_40_12
XTAP_TAPCELL_ROW_0_164 vssd1 vccd1 sky130_fd_sc_hd__tapvpwrvgnd_1
XTAP_TAPCELL_ROW_0_175 vssd1 vccd1 sky130_fd_sc_hd__tapvpwrvgnd_1
XFILLER_13_249 vccd1 vssd1 vccd1 vssd1 sky130_ef_sc_hd__decap_40_12
XPHY_EDGE_ROW_48_Right_48 vssd1 vssd1 vccd1 vccd1 sky130_fd_sc_hd__decap_3
XFILLER_21_271 vssd1 vssd1 vccd1 vccd1 sky130_fd_sc_hd__fill_1
XANTENNA_fanout12_A _0517_ vssd1 vssd1 vccd1 vccd1 sky130_fd_sc_hd__diode_2
XFILLER_79_34 vssd1 vssd1 vccd1 vccd1 sky130_fd_sc_hd__fill_4
XPHY_EDGE_ROW_57_Right_57 vssd1 vssd1 vccd1 vccd1 sky130_fd_sc_hd__decap_3
XTAP_TAPCELL_ROW_8_242 vssd1 vccd1 sky130_fd_sc_hd__tapvpwrvgnd_1
XFILLER_0_153 vccd1 vssd1 vccd1 vssd1 sky130_ef_sc_hd__decap_40_12
XFILLER_0_197 vccd1 vssd1 vccd1 vssd1 sky130_ef_sc_hd__decap_40_12
Xteam_02_261 vssd1 vssd1 vccd1 vccd1 team_02_261/HI gpio_out[14] sky130_fd_sc_hd__conb_1
XFILLER_76_477 vccd1 vssd1 vccd1 vssd1 sky130_ef_sc_hd__decap_40_12
Xteam_02_250 vssd1 vssd1 vccd1 vccd1 team_02_250/HI gpio_out[1] sky130_fd_sc_hd__conb_1
XFILLER_48_168 vssd1 vssd1 vccd1 vccd1 sky130_fd_sc_hd__fill_2
Xteam_02_283 vssd1 vssd1 vccd1 vccd1 gpio_oeb[1] team_02_283/LO sky130_fd_sc_hd__conb_1
Xteam_02_272 vssd1 vssd1 vccd1 vccd1 team_02_272/HI gpio_out[25] sky130_fd_sc_hd__conb_1
Xteam_02_294 vssd1 vssd1 vccd1 vccd1 gpio_oeb[14] team_02_294/LO sky130_fd_sc_hd__conb_1
XFILLER_28_60 vssd1 vssd1 vccd1 vccd1 sky130_fd_sc_hd__fill_4
XTAP_TAPCELL_ROW_59_675 vssd1 vccd1 sky130_fd_sc_hd__tapvpwrvgnd_1
XANTENNA__2429__A2 net91 vssd1 vssd1 vccd1 vccd1 sky130_fd_sc_hd__diode_2
XPHY_EDGE_ROW_66_Right_66 vssd1 vssd1 vccd1 vccd1 sky130_fd_sc_hd__decap_3
XFILLER_44_363 vssd1 vssd1 vccd1 vccd1 sky130_fd_sc_hd__fill_1
XANTENNA__2951__S net58 vssd1 vssd1 vccd1 vccd1 sky130_fd_sc_hd__diode_2
XTAP_TAPCELL_ROW_42_531 vssd1 vccd1 sky130_fd_sc_hd__tapvpwrvgnd_1
XTAP_TAPCELL_ROW_14_288 vssd1 vccd1 sky130_fd_sc_hd__tapvpwrvgnd_1
XFILLER_74_6 vccd1 vssd1 vccd1 vssd1 sky130_ef_sc_hd__decap_40_12
X_2660_ _1111_ _1112_ _1132_ vssd1 vssd1 vccd1 vccd1 _1133_ sky130_fd_sc_hd__o21a_1
XFILLER_8_253 vccd1 vssd1 vccd1 vssd1 sky130_ef_sc_hd__decap_40_12
X_1611_ MATMULT_INST.matmult_inst.fsm_inst.count\[1\] MATMULT_INST.matmult_inst.fsm_inst.count\[0\]
+ vssd1 vssd1 vccd1 vccd1 _1529_ sky130_fd_sc_hd__nor2_1
XPHY_EDGE_ROW_75_Right_75 vssd1 vssd1 vccd1 vccd1 sky130_fd_sc_hd__decap_3
X_2591_ net68 _1068_ vssd1 vssd1 vccd1 vccd1 _1069_ sky130_fd_sc_hd__nor2_1
X_1542_ MATMULT_INST.matmult_inst.fsm_inst.count\[3\] vssd1 vssd1 vccd1 vccd1 _1483_
+ sky130_fd_sc_hd__inv_2
XANTENNA__3083__A net246 vssd1 vssd1 vccd1 vccd1 sky130_fd_sc_hd__diode_2
X_3212_ clknet_leaf_8_clk _0170_ net109 vssd1 vssd1 vccd1 vccd1 MATMULT_INST.matmult_inst.mem_inst.mem1\[1\]
+ sky130_fd_sc_hd__dfrtp_1
X_3143_ clknet_leaf_16_clk _0101_ net120 vssd1 vssd1 vccd1 vccd1 MATMULT_INST.matmult_inst.mem_inst.mem3\[4\]
+ sky130_fd_sc_hd__dfrtp_1
X_3074_ net244 vssd1 vssd1 vccd1 vccd1 _0032_ sky130_fd_sc_hd__inv_2
X_2025_ _0593_ _0596_ _0594_ vssd1 vssd1 vccd1 vccd1 _0601_ sky130_fd_sc_hd__a21boi_1
XFILLER_62_160 vssd1 vssd1 vccd1 vccd1 sky130_fd_sc_hd__fill_2
X_2927_ net335 net33 net9 vssd1 vssd1 vccd1 vccd1 _0414_ sky130_fd_sc_hd__mux2_1
XPHY_EDGE_ROW_17_Left_97 vssd1 vssd1 vccd1 vccd1 sky130_fd_sc_hd__decap_3
X_2858_ _1322_ _1324_ vssd1 vssd1 vccd1 vccd1 _1326_ sky130_fd_sc_hd__xor2_1
Xhold220 MATMULT_INST.matmult_inst.mem_inst.mem1\[15\] vssd1 vssd1 vccd1 vccd1 net533
+ sky130_fd_sc_hd__dlygate4sd3_1
XANTENNA__2312__D net213 vssd1 vssd1 vccd1 vccd1 sky130_fd_sc_hd__diode_2
X_1809_ net618 net50 net16 vssd1 vssd1 vccd1 vccd1 _0143_ sky130_fd_sc_hd__mux2_1
X_2789_ MATMULT_INST.matmult_inst.alu_inst.a1_reg\[7\] net208 _1256_ _1258_ vssd1
+ vssd1 vccd1 vccd1 _1259_ sky130_fd_sc_hd__o2bb2a_1
Xhold253 MATMULT_INST.matmult_inst.mem_inst.matrixB1\[13\] vssd1 vssd1 vccd1 vccd1
+ net566 sky130_fd_sc_hd__dlygate4sd3_1
Xhold242 MATMULT_INST.matmult_inst.alu_inst.adder_inst.r1.fa2.a vssd1 vssd1 vccd1
+ vccd1 net555 sky130_fd_sc_hd__dlygate4sd3_1
Xhold231 MATMULT_INST.matmult_inst.alu_inst.out\[4\] vssd1 vssd1 vccd1 vccd1 net544
+ sky130_fd_sc_hd__dlygate4sd3_1
Xhold275 MATMULT_INST.matmult_inst.mem_inst.mem1\[5\] vssd1 vssd1 vccd1 vccd1 net588
+ sky130_fd_sc_hd__dlygate4sd3_1
Xhold264 MATMULT_INST.matmult_inst.mem_inst.matrixA1\[5\] vssd1 vssd1 vccd1 vccd1
+ net577 sky130_fd_sc_hd__dlygate4sd3_1
Xhold286 MATMULT_INST.matmult_inst.alu_inst.col1\[7\] vssd1 vssd1 vccd1 vccd1 net599
+ sky130_fd_sc_hd__dlygate4sd3_1
Xhold297 MATMULT_INST.matmult_inst.mem_inst.matrixA3\[12\] vssd1 vssd1 vccd1 vccd1
+ net610 sky130_fd_sc_hd__dlygate4sd3_1
XTAP_TAPCELL_ROW_5_212 vssd1 vccd1 sky130_fd_sc_hd__tapvpwrvgnd_1
XFILLER_73_447 vssd1 vssd1 vccd1 vccd1 sky130_fd_sc_hd__fill_1
XTAP_TAPCELL_ROW_56_645 vssd1 vccd1 sky130_fd_sc_hd__tapvpwrvgnd_1
XFILLER_53_193 vssd1 vssd1 vccd1 vccd1 sky130_fd_sc_hd__fill_4
XANTENNA_fanout15_X net15 vssd1 vssd1 vccd1 vccd1 sky130_fd_sc_hd__diode_2
XTAP_TAPCELL_ROW_11_269 vssd1 vccd1 sky130_fd_sc_hd__tapvpwrvgnd_1
XFILLER_5_223 vssd1 vssd1 vccd1 vccd1 sky130_fd_sc_hd__fill_1
XFILLER_30_50 vssd1 vssd1 vccd1 vccd1 sky130_fd_sc_hd__fill_1
XFILLER_1_473 vccd1 vssd1 vccd1 vssd1 sky130_ef_sc_hd__decap_40_12
XANTENNA__2946__S MATMULT_INST.matmult_inst.spi_inst.rx_done_sys vssd1 vssd1 vccd1
+ vccd1 sky130_fd_sc_hd__diode_2
XANTENNA__1850__S net29 vssd1 vssd1 vccd1 vccd1 sky130_fd_sc_hd__diode_2
XTAP_TAPCELL_ROW_19_336 vssd1 vccd1 sky130_fd_sc_hd__tapvpwrvgnd_1
X_2712_ net202 net192 net190 net205 vssd1 vssd1 vccd1 vccd1 _1184_ sky130_fd_sc_hd__a22oi_1
XANTENNA__2586__A1 net172 vssd1 vssd1 vccd1 vccd1 sky130_fd_sc_hd__diode_2
X_2643_ net211 MATMULT_INST.matmult_inst.alu_inst.a1_reg\[4\] net188 net212 vssd1
+ vssd1 vccd1 vccd1 _1117_ sky130_fd_sc_hd__a22o_1
X_2574_ _1484_ _1508_ _0456_ _0932_ _1054_ vssd1 vssd1 vccd1 vccd1 _1055_ sky130_fd_sc_hd__a2111o_1
XANTENNA__1760__S net19 vssd1 vssd1 vccd1 vccd1 sky130_fd_sc_hd__diode_2
XANTENNA__2510__A1 net163 vssd1 vssd1 vccd1 vccd1 sky130_fd_sc_hd__diode_2
X_3126_ clknet_leaf_15_clk _0084_ net143 vssd1 vssd1 vccd1 vccd1 MATMULT_INST.matmult_inst.mem_inst.matrixA2\[5\]
+ sky130_fd_sc_hd__dfrtp_1
XFILLER_27_149 vssd1 vssd1 vccd1 vccd1 sky130_fd_sc_hd__fill_2
X_3057_ MATMULT_INST.matmult_inst.mem_inst.matrixA0\[17\] net64 _1474_ net92 vssd1
+ vssd1 vccd1 vccd1 _1475_ sky130_fd_sc_hd__a22o_1
XFILLER_35_39 vssd1 vssd1 vccd1 vccd1 sky130_fd_sc_hd__fill_2
X_2008_ _0585_ _0586_ vssd1 vssd1 vccd1 vccd1 _0587_ sky130_fd_sc_hd__xnor2_1
XTAP_TAPCELL_ROW_53_626 vssd1 vccd1 sky130_fd_sc_hd__tapvpwrvgnd_1
XANTENNA__2813__A2 net203 vssd1 vssd1 vccd1 vccd1 sky130_fd_sc_hd__diode_2
XTAP_TAPCELL_ROW_61_692 vssd1 vccd1 sky130_fd_sc_hd__tapvpwrvgnd_1
XFILLER_76_57 vssd1 vssd1 vccd1 vccd1 sky130_fd_sc_hd__fill_2
XFILLER_73_222 vssd1 vssd1 vccd1 vccd1 sky130_fd_sc_hd__fill_2
XANTENNA__3057__A2 net64 vssd1 vssd1 vccd1 vccd1 sky130_fd_sc_hd__diode_2
XANTENNA__3292__RESET_B net96 vssd1 vssd1 vccd1 vccd1 sky130_fd_sc_hd__diode_2
XTAP_TAPCELL_ROW_16_306 vssd1 vccd1 sky130_fd_sc_hd__tapvpwrvgnd_1
XFILLER_14_377 vssd1 vssd1 vccd1 vccd1 sky130_fd_sc_hd__fill_2
XTAP_TAPCELL_ROW_24_372 vssd1 vccd1 sky130_fd_sc_hd__tapvpwrvgnd_1
XANTENNA__2514__B net173 vssd1 vssd1 vccd1 vccd1 sky130_fd_sc_hd__diode_2
XANTENNA__1845__S net28 vssd1 vssd1 vccd1 vccd1 sky130_fd_sc_hd__diode_2
XFILLER_41_71 vssd1 vssd1 vccd1 vccd1 sky130_fd_sc_hd__fill_4
X_2290_ _0834_ _0835_ _0827_ vssd1 vssd1 vccd1 vccd1 _0837_ sky130_fd_sc_hd__o21ai_1
XFILLER_1_281 vccd1 vssd1 vccd1 vssd1 sky130_ef_sc_hd__decap_40_12
XFILLER_2_65 vccd1 vssd1 vccd1 vssd1 sky130_ef_sc_hd__decap_40_12
XFILLER_37_436 vssd1 vssd1 vccd1 vccd1 sky130_fd_sc_hd__fill_1
XFILLER_49_296 vssd1 vssd1 vccd1 vccd1 sky130_fd_sc_hd__fill_1
XFILLER_64_233 vccd1 vssd1 vccd1 vssd1 sky130_ef_sc_hd__decap_40_12
XFILLER_64_255 vssd1 vssd1 vccd1 vccd1 sky130_fd_sc_hd__fill_8
XPHY_EDGE_ROW_25_Left_105 vssd1 vssd1 vccd1 vccd1 sky130_fd_sc_hd__decap_3
XANTENNA__2559__A1 _0988_ vssd1 vssd1 vccd1 vccd1 sky130_fd_sc_hd__diode_2
XANTENNA__2424__B net173 vssd1 vssd1 vccd1 vccd1 sky130_fd_sc_hd__diode_2
XANTENNA__1755__S net20 vssd1 vssd1 vccd1 vccd1 sky130_fd_sc_hd__diode_2
X_2626_ _1094_ _1095_ _1100_ vssd1 vssd1 vccd1 vccd1 _1101_ sky130_fd_sc_hd__o21ai_1
X_2557_ net471 _0966_ _1052_ vssd1 vssd1 vccd1 vccd1 _0353_ sky130_fd_sc_hd__mux2_1
XPHY_EDGE_ROW_34_Left_114 vssd1 vssd1 vccd1 vccd1 sky130_fd_sc_hd__decap_3
X_2488_ net500 _0954_ _1000_ net66 vssd1 vssd1 vccd1 vccd1 _0336_ sky130_fd_sc_hd__a22o_1
XFILLER_46_27 vssd1 vssd1 vccd1 vccd1 sky130_fd_sc_hd__fill_1
XFILLER_15_108 vssd1 vssd1 vccd1 vccd1 sky130_fd_sc_hd__fill_4
X_3109_ clknet_leaf_12_clk _0067_ net149 vssd1 vssd1 vccd1 vccd1 MATMULT_INST.matmult_inst.mem_inst.matrixA0\[6\]
+ sky130_fd_sc_hd__dfrtp_1
XTAP_TAPCELL_ROW_38_497 vssd1 vccd1 sky130_fd_sc_hd__tapvpwrvgnd_1
XPHY_EDGE_ROW_43_Left_123 vssd1 vssd1 vccd1 vccd1 sky130_fd_sc_hd__decap_3
XFILLER_62_15 vssd1 vssd1 vccd1 vccd1 sky130_fd_sc_hd__fill_1
XFILLER_7_329 vssd1 vssd1 vccd1 vccd1 sky130_fd_sc_hd__fill_4
XTAP_TAPCELL_ROW_21_353 vssd1 vccd1 sky130_fd_sc_hd__tapvpwrvgnd_1
XPHY_EDGE_ROW_52_Left_132 vssd1 vssd1 vccd1 vccd1 sky130_fd_sc_hd__decap_3
XTAP_TAPCELL_ROW_29_420 vssd1 vccd1 sky130_fd_sc_hd__tapvpwrvgnd_1
XPHY_EDGE_ROW_61_Left_141 vssd1 vssd1 vccd1 vccd1 sky130_fd_sc_hd__decap_3
XTAP_TAPCELL_ROW_72_787 vssd1 vccd1 sky130_fd_sc_hd__tapvpwrvgnd_1
X_1790_ net586 net50 net30 vssd1 vssd1 vccd1 vccd1 _0125_ sky130_fd_sc_hd__mux2_1
XPHY_EDGE_ROW_70_Left_150 vssd1 vssd1 vccd1 vccd1 sky130_fd_sc_hd__decap_3
X_3460_ _0039_ _0405_ net147 vssd1 vssd1 vccd1 vccd1 MATMULT_INST.matmult_inst.spi_inst.mosi_shifter\[4\]
+ sky130_fd_sc_hd__dfrtp_1
X_3391_ clknet_leaf_28_clk _0345_ net96 vssd1 vssd1 vccd1 vccd1 MATMULT_INST.matmult_inst.alu_inst.col0\[5\]
+ sky130_fd_sc_hd__dfrtp_1
X_2411_ net61 _0930_ _0932_ _0931_ vssd1 vssd1 vccd1 vccd1 _0327_ sky130_fd_sc_hd__or4b_1
X_2342_ _0885_ _0886_ vssd1 vssd1 vccd1 vccd1 _0887_ sky130_fd_sc_hd__nand2_1
XFILLER_35_3 vssd1 vssd1 vccd1 vccd1 sky130_fd_sc_hd__fill_1
X_2273_ _0784_ _0817_ _0819_ _0820_ vssd1 vssd1 vccd1 vccd1 _0821_ sky130_fd_sc_hd__o22a_1
XFILLER_77_391 vssd1 vssd1 vccd1 vccd1 sky130_fd_sc_hd__fill_1
XFILLER_37_222 vssd1 vssd1 vccd1 vccd1 sky130_fd_sc_hd__fill_2
XANTENNA__2477__B1 net81 vssd1 vssd1 vccd1 vccd1 sky130_fd_sc_hd__diode_2
XTAP_TAPCELL_ROW_63_710 vssd1 vccd1 sky130_fd_sc_hd__tapvpwrvgnd_1
XTAP_TAPCELL_ROW_35_467 vssd1 vccd1 sky130_fd_sc_hd__tapvpwrvgnd_1
XFILLER_32_29 vccd1 vssd1 vccd1 vssd1 sky130_ef_sc_hd__decap_40_12
XFILLER_60_280 vssd1 vssd1 vccd1 vccd1 sky130_fd_sc_hd__fill_1
XFILLER_20_155 vssd1 vssd1 vccd1 vccd1 sky130_fd_sc_hd__fill_8
XANTENNA_clkbuf_leaf_12_clk_A clknet_2_3__leaf_clk vssd1 vssd1 vccd1 vccd1 sky130_fd_sc_hd__diode_2
XANTENNA_fanout227_A net228 vssd1 vssd1 vccd1 vccd1 sky130_fd_sc_hd__diode_2
X_1988_ _0568_ _0569_ vssd1 vssd1 vccd1 vccd1 _0570_ sky130_fd_sc_hd__nand2b_1
XANTENNA__2952__A1 _1010_ vssd1 vssd1 vccd1 vccd1 sky130_fd_sc_hd__diode_2
X_2609_ _1083_ _1084_ vssd1 vssd1 vccd1 vccd1 _1085_ sky130_fd_sc_hd__nor2_1
XANTENNA_clkbuf_leaf_27_clk_A clknet_2_0__leaf_clk vssd1 vssd1 vccd1 vccd1 sky130_fd_sc_hd__diode_2
Xclkbuf_2_2__f_clk clknet_0_clk vssd1 vssd1 vccd1 vccd1 clknet_2_2__leaf_clk sky130_fd_sc_hd__clkbuf_16
XFILLER_28_277 vssd1 vssd1 vccd1 vccd1 sky130_fd_sc_hd__fill_1
XANTENNA__1691__B2 MATMULT_INST.matmult_inst.fsm_inst.alu_result\[6\] vssd1 vssd1
+ vccd1 vccd1 sky130_fd_sc_hd__diode_2
XFILLER_73_69 vssd1 vssd1 vccd1 vccd1 sky130_fd_sc_hd__fill_4
XFILLER_11_111 vssd1 vssd1 vccd1 vccd1 sky130_fd_sc_hd__fill_1
XFILLER_7_137 vccd1 vssd1 vccd1 vssd1 sky130_ef_sc_hd__decap_40_12
XFILLER_22_62 vssd1 vssd1 vccd1 vccd1 sky130_fd_sc_hd__fill_2
XPHY_EDGE_ROW_5_Left_85 vssd1 vssd1 vccd1 vccd1 sky130_fd_sc_hd__decap_3
XANTENNA__3326__D net55 vssd1 vssd1 vccd1 vccd1 sky130_fd_sc_hd__diode_2
XTAP_TAPCELL_ROW_77_824 vssd1 vccd1 sky130_fd_sc_hd__tapvpwrvgnd_1
XFILLER_78_199 vssd1 vssd1 vccd1 vccd1 sky130_fd_sc_hd__fill_1
Xfanout190 MATMULT_INST.matmult_inst.alu_inst.a1_reg\[3\] vssd1 vssd1 vccd1 vccd1
+ net190 sky130_fd_sc_hd__buf_2
XANTENNA__2954__S net58 vssd1 vssd1 vccd1 vccd1 sky130_fd_sc_hd__diode_2
XFILLER_15_472 vssd1 vssd1 vccd1 vccd1 sky130_fd_sc_hd__fill_1
X_2960_ net179 net170 MATMULT_INST.matmult_inst.mem_inst.matrixB3\[8\] vssd1 vssd1
+ vccd1 vccd1 _1387_ sky130_fd_sc_hd__and3_1
X_1911_ net505 net43 net26 vssd1 vssd1 vccd1 vccd1 _0240_ sky130_fd_sc_hd__mux2_1
XTAP_TAPCELL_ROW_32_448 vssd1 vccd1 sky130_fd_sc_hd__tapvpwrvgnd_1
X_2891_ net198 net185 net184 net201 vssd1 vssd1 vccd1 vccd1 _1357_ sky130_fd_sc_hd__a22o_1
X_1842_ net588 net34 net29 vssd1 vssd1 vccd1 vccd1 _0174_ sky130_fd_sc_hd__mux2_1
XFILLER_8_53 vccd1 vssd1 vccd1 vssd1 sky130_ef_sc_hd__decap_40_12
XFILLER_8_97 vccd1 vssd1 vccd1 vssd1 sky130_ef_sc_hd__decap_40_12
X_1773_ net442 net47 net18 vssd1 vssd1 vccd1 vccd1 _0110_ sky130_fd_sc_hd__mux2_1
X_3512_ clknet_leaf_16_clk _0437_ net133 vssd1 vssd1 vccd1 vccd1 MATMULT_INST.matmult_inst.spi_inst.tx_reg_sys\[3\]
+ sky130_fd_sc_hd__dfrtp_1
X_3443_ _0025_ _0390_ net137 vssd1 vssd1 vccd1 vccd1 MATMULT_INST.matmult_inst.spi_inst.rx_bit_count\[3\]
+ sky130_fd_sc_hd__dfrtp_1
X_3374_ clknet_leaf_6_clk _0329_ net112 vssd1 vssd1 vccd1 vccd1 MATMULT_INST.matmult_inst.fsm_inst.state\[2\]
+ sky130_fd_sc_hd__dfrtp_4
XFILLER_69_111 vssd1 vssd1 vccd1 vccd1 sky130_fd_sc_hd__fill_1
X_2325_ _0855_ _0870_ vssd1 vssd1 vccd1 vccd1 _0871_ sky130_fd_sc_hd__xnor2_1
X_2256_ _0760_ _0764_ _0765_ _0772_ _0773_ vssd1 vssd1 vccd1 vccd1 _0804_ sky130_fd_sc_hd__a32o_1
X_2187_ _0733_ _0734_ _0736_ vssd1 vssd1 vccd1 vccd1 _0737_ sky130_fd_sc_hd__nand3_1
XANTENNA_fanout177_A net180 vssd1 vssd1 vccd1 vccd1 sky130_fd_sc_hd__diode_2
XFILLER_65_361 vssd1 vssd1 vccd1 vccd1 sky130_fd_sc_hd__fill_1
XFILLER_25_225 vssd1 vssd1 vccd1 vccd1 sky130_fd_sc_hd__fill_4
XTAP_TAPCELL_ROW_48_581 vssd1 vccd1 sky130_fd_sc_hd__tapvpwrvgnd_1
XFILLER_13_409 vssd1 vssd1 vccd1 vccd1 sky130_fd_sc_hd__fill_2
XANTENNA_fanout132_X net132 vssd1 vssd1 vccd1 vccd1 sky130_fd_sc_hd__diode_2
XFILLER_0_335 vssd1 vssd1 vccd1 vccd1 sky130_fd_sc_hd__fill_1
XTAP_TAPCELL_ROW_74_805 vssd1 vccd1 sky130_fd_sc_hd__tapvpwrvgnd_1
XTAP_TAPCELL_ROW_3_195 vssd1 vccd1 sky130_fd_sc_hd__tapvpwrvgnd_1
XFILLER_8_413 vssd1 vssd1 vccd1 vccd1 sky130_fd_sc_hd__fill_4
XFILLER_12_475 vssd1 vssd1 vccd1 vccd1 sky130_fd_sc_hd__fill_1
XFILLER_8_457 vccd1 vssd1 vccd1 vssd1 sky130_ef_sc_hd__decap_40_12
XANTENNA__2949__S net58 vssd1 vssd1 vccd1 vccd1 sky130_fd_sc_hd__diode_2
XANTENNA__1853__S net28 vssd1 vssd1 vccd1 vccd1 sky130_fd_sc_hd__diode_2
XFILLER_79_475 vssd1 vssd1 vccd1 vccd1 sky130_fd_sc_hd__fill_1
Xhold2 MATMULT_INST.matmult_inst.spi_inst.cs_sync vssd1 vssd1 vccd1 vccd1 net315 sky130_fd_sc_hd__dlygate4sd3_1
X_2110_ net239 net241 net218 net217 vssd1 vssd1 vccd1 vccd1 _0662_ sky130_fd_sc_hd__nand4_2
X_3090_ clknet_leaf_14_clk _0048_ net143 vssd1 vssd1 vccd1 vccd1 MATMULT_INST.matmult_inst.mem_inst.matrixB0\[5\]
+ sky130_fd_sc_hd__dfrtp_1
XFILLER_66_114 vssd1 vssd1 vccd1 vccd1 sky130_fd_sc_hd__fill_8
X_2041_ net201 net491 net55 vssd1 vssd1 vccd1 vccd1 _0282_ sky130_fd_sc_hd__mux2_1
XTAP_TAPCELL_ROW_45_551 vssd1 vccd1 sky130_fd_sc_hd__tapvpwrvgnd_1
X_2943_ MATMULT_INST.matmult_inst.fsm_inst.rx_data\[4\] net318 MATMULT_INST.matmult_inst.spi_inst.rx_done_sys
+ vssd1 vssd1 vccd1 vccd1 _0430_ sky130_fd_sc_hd__mux2_1
X_2874_ _1339_ _1340_ vssd1 vssd1 vccd1 vccd1 _1341_ sky130_fd_sc_hd__nand2_1
X_1825_ net390 net32 net15 vssd1 vssd1 vccd1 vccd1 _0158_ sky130_fd_sc_hd__mux2_1
X_1756_ net655 net43 net20 vssd1 vssd1 vccd1 vccd1 _0096_ sky130_fd_sc_hd__mux2_1
XANTENNA__1763__S net19 vssd1 vssd1 vccd1 vccd1 sky130_fd_sc_hd__diode_2
X_1687_ MATMULT_INST.matmult_inst.fsm_inst.rx_data\[4\] net59 net61 MATMULT_INST.matmult_inst.fsm_inst.alu_result\[4\]
+ vssd1 vssd1 vccd1 vccd1 _0489_ sky130_fd_sc_hd__a22o_1
X_3426_ clknet_2_1__leaf_clk _0378_ vssd1 vssd1 vccd1 vccd1 MATMULT_INST.matmult_inst.alu_inst.adder_inst.r2.fa0.b
+ sky130_fd_sc_hd__dfxtp_1
X_3357_ clknet_leaf_7_clk net449 net110 vssd1 vssd1 vccd1 vccd1 MATMULT_INST.matmult_inst.fsm_inst.alu_result\[3\]
+ sky130_fd_sc_hd__dfrtp_1
X_2308_ net227 net216 _0827_ vssd1 vssd1 vccd1 vccd1 _0854_ sky130_fd_sc_hd__and3_1
X_3288_ clknet_leaf_28_clk _0246_ net96 vssd1 vssd1 vccd1 vccd1 MATMULT_INST.matmult_inst.alu_inst.b0_reg\[4\]
+ sky130_fd_sc_hd__dfrtp_1
X_2239_ net227 net222 net219 net229 vssd1 vssd1 vccd1 vccd1 _0787_ sky130_fd_sc_hd__a22o_1
XTAP_TAPCELL_ROW_0_165 vssd1 vccd1 sky130_fd_sc_hd__tapvpwrvgnd_1
XTAP_TAPCELL_ROW_0_176 vssd1 vccd1 sky130_fd_sc_hd__tapvpwrvgnd_1
XFILLER_54_49 vccd1 vssd1 vccd1 vssd1 sky130_ef_sc_hd__decap_40_12
XFILLER_13_217 vssd1 vssd1 vccd1 vccd1 sky130_fd_sc_hd__fill_4
XFILLER_5_405 vccd1 vssd1 vccd1 vssd1 sky130_ef_sc_hd__decap_40_12
XFILLER_5_449 vccd1 vssd1 vccd1 vssd1 sky130_ef_sc_hd__decap_40_12
XFILLER_79_57 vssd1 vssd1 vccd1 vccd1 sky130_fd_sc_hd__fill_2
XTAP_TAPCELL_ROW_8_243 vssd1 vccd1 sky130_fd_sc_hd__tapvpwrvgnd_1
XFILLER_0_132 vssd1 vssd1 vccd1 vccd1 sky130_fd_sc_hd__fill_4
XFILLER_0_165 vssd1 vssd1 vccd1 vccd1 sky130_fd_sc_hd__fill_2
Xteam_02_251 vssd1 vssd1 vccd1 vccd1 team_02_251/HI gpio_out[2] sky130_fd_sc_hd__conb_1
Xteam_02_262 vssd1 vssd1 vccd1 vccd1 team_02_262/HI gpio_out[15] sky130_fd_sc_hd__conb_1
XFILLER_48_158 vssd1 vssd1 vccd1 vccd1 sky130_fd_sc_hd__fill_8
Xteam_02_284 vssd1 vssd1 vccd1 vccd1 gpio_oeb[2] team_02_284/LO sky130_fd_sc_hd__conb_1
XFILLER_76_489 vssd1 vssd1 vccd1 vccd1 sky130_fd_sc_hd__fill_2
Xteam_02_295 vssd1 vssd1 vccd1 vccd1 gpio_oeb[15] team_02_295/LO sky130_fd_sc_hd__conb_1
Xteam_02_273 vssd1 vssd1 vccd1 vccd1 team_02_273/HI gpio_out[26] sky130_fd_sc_hd__conb_1
XFILLER_28_72 vssd1 vssd1 vccd1 vccd1 sky130_fd_sc_hd__fill_2
XTAP_TAPCELL_ROW_59_676 vssd1 vccd1 sky130_fd_sc_hd__tapvpwrvgnd_1
XFILLER_71_194 vssd1 vssd1 vccd1 vccd1 sky130_fd_sc_hd__fill_1
XANTENNA__1848__S net28 vssd1 vssd1 vccd1 vccd1 sky130_fd_sc_hd__diode_2
XTAP_TAPCELL_ROW_42_532 vssd1 vccd1 sky130_fd_sc_hd__tapvpwrvgnd_1
XFILLER_44_82 vssd1 vssd1 vccd1 vccd1 sky130_fd_sc_hd__fill_2
XFILLER_44_93 vssd1 vssd1 vccd1 vccd1 sky130_fd_sc_hd__fill_4
XTAP_TAPCELL_ROW_14_289 vssd1 vccd1 sky130_fd_sc_hd__tapvpwrvgnd_1
XFILLER_8_221 vccd1 vssd1 vccd1 vssd1 sky130_ef_sc_hd__decap_40_12
X_1610_ MATMULT_INST.matmult_inst.fsm_inst.rx_ready_edge_delay _1527_ vssd1 vssd1
+ vccd1 vccd1 _1528_ sky130_fd_sc_hd__nor2_1
XFILLER_8_265 vccd1 vssd1 vccd1 vssd1 sky130_ef_sc_hd__decap_40_12
XFILLER_60_70 vssd1 vssd1 vccd1 vccd1 sky130_fd_sc_hd__fill_1
X_2590_ net196 net210 net195 net212 vssd1 vssd1 vccd1 vccd1 _1068_ sky130_fd_sc_hd__and4_1
X_1541_ MATMULT_INST.matmult_inst.fsm_inst.state\[3\] vssd1 vssd1 vccd1 vccd1 _1482_
+ sky130_fd_sc_hd__inv_2
XFILLER_79_250 vssd1 vssd1 vccd1 vccd1 sky130_fd_sc_hd__fill_2
X_3211_ clknet_leaf_15_clk _0169_ net135 vssd1 vssd1 vccd1 vccd1 MATMULT_INST.matmult_inst.mem_inst.mem1\[0\]
+ sky130_fd_sc_hd__dfrtp_1
X_3142_ clknet_leaf_18_clk _0100_ net129 vssd1 vssd1 vccd1 vccd1 MATMULT_INST.matmult_inst.mem_inst.mem3\[3\]
+ sky130_fd_sc_hd__dfrtp_1
X_3073_ net244 vssd1 vssd1 vccd1 vccd1 _0031_ sky130_fd_sc_hd__inv_2
X_2024_ _0598_ _0599_ vssd1 vssd1 vccd1 vccd1 _0600_ sky130_fd_sc_hd__and2b_1
XFILLER_62_150 vssd1 vssd1 vccd1 vccd1 sky130_fd_sc_hd__fill_2
XFILLER_10_209 vccd1 vssd1 vccd1 vssd1 sky130_ef_sc_hd__decap_40_12
X_2926_ net364 net34 net9 vssd1 vssd1 vccd1 vccd1 _0413_ sky130_fd_sc_hd__mux2_1
X_2857_ _1321_ _1324_ vssd1 vssd1 vccd1 vccd1 _1325_ sky130_fd_sc_hd__nor2_1
XFILLER_40_29 vssd1 vssd1 vccd1 vccd1 sky130_fd_sc_hd__fill_1
X_1808_ net572 net51 net16 vssd1 vssd1 vccd1 vccd1 _0142_ sky130_fd_sc_hd__mux2_1
XANTENNA__3002__B1 net77 vssd1 vssd1 vccd1 vccd1 sky130_fd_sc_hd__diode_2
Xhold210 MATMULT_INST.matmult_inst.mem_inst.matrixA1\[1\] vssd1 vssd1 vccd1 vccd1
+ net523 sky130_fd_sc_hd__dlygate4sd3_1
X_2788_ net187 net206 _1257_ vssd1 vssd1 vccd1 vccd1 _1258_ sky130_fd_sc_hd__and3_1
XFILLER_2_419 vssd1 vssd1 vccd1 vccd1 sky130_fd_sc_hd__fill_1
Xhold243 MATMULT_INST.matmult_inst.mem_inst.matrixA0\[12\] vssd1 vssd1 vccd1 vccd1
+ net556 sky130_fd_sc_hd__dlygate4sd3_1
Xhold232 _0313_ vssd1 vssd1 vccd1 vccd1 net545 sky130_fd_sc_hd__dlygate4sd3_1
Xhold221 MATMULT_INST.matmult_inst.mem_inst.mem2\[2\] vssd1 vssd1 vccd1 vccd1 net534
+ sky130_fd_sc_hd__dlygate4sd3_1
X_1739_ net569 _0485_ net21 vssd1 vssd1 vccd1 vccd1 _0079_ sky130_fd_sc_hd__mux2_1
Xhold265 MATMULT_INST.matmult_inst.mem_inst.matrixA0\[17\] vssd1 vssd1 vccd1 vccd1
+ net578 sky130_fd_sc_hd__dlygate4sd3_1
Xhold254 MATMULT_INST.matmult_inst.mem_inst.mem0\[14\] vssd1 vssd1 vccd1 vccd1 net567
+ sky130_fd_sc_hd__dlygate4sd3_1
Xhold276 MATMULT_INST.matmult_inst.mem_inst.matrixB2\[9\] vssd1 vssd1 vccd1 vccd1
+ net589 sky130_fd_sc_hd__dlygate4sd3_1
Xhold287 MATMULT_INST.matmult_inst.mem_inst.matrixB1\[3\] vssd1 vssd1 vccd1 vccd1
+ net600 sky130_fd_sc_hd__dlygate4sd3_1
Xhold298 MATMULT_INST.matmult_inst.mem_inst.mem2\[13\] vssd1 vssd1 vccd1 vccd1 net611
+ sky130_fd_sc_hd__dlygate4sd3_1
X_3409_ clknet_leaf_0_clk _0362_ net94 vssd1 vssd1 vccd1 vccd1 MATMULT_INST.matmult_inst.alu_inst.row0\[2\]
+ sky130_fd_sc_hd__dfrtp_1
XTAP_TAPCELL_ROW_5_213 vssd1 vccd1 sky130_fd_sc_hd__tapvpwrvgnd_1
XFILLER_65_15 vssd1 vssd1 vccd1 vccd1 sky130_fd_sc_hd__fill_8
XFILLER_45_128 vssd1 vssd1 vccd1 vccd1 sky130_fd_sc_hd__fill_2
XTAP_TAPCELL_ROW_56_646 vssd1 vccd1 sky130_fd_sc_hd__tapvpwrvgnd_1
XFILLER_65_59 vssd1 vssd1 vccd1 vccd1 sky130_fd_sc_hd__fill_1
XFILLER_26_386 vssd1 vssd1 vccd1 vccd1 sky130_fd_sc_hd__fill_1
XFILLER_14_63 vssd1 vssd1 vccd1 vccd1 sky130_fd_sc_hd__fill_1
XFILLER_5_279 vssd1 vssd1 vccd1 vccd1 sky130_fd_sc_hd__fill_1
XFILLER_1_441 vssd1 vssd1 vccd1 vccd1 sky130_fd_sc_hd__fill_4
XFILLER_1_485 vssd1 vssd1 vccd1 vccd1 sky130_fd_sc_hd__fill_4
XTAP_TAPCELL_ROW_19_337 vssd1 vccd1 sky130_fd_sc_hd__tapvpwrvgnd_1
X_2711_ _1148_ _1150_ _1149_ vssd1 vssd1 vccd1 vccd1 _1183_ sky130_fd_sc_hd__a21bo_1
XFILLER_65_3 vccd1 vssd1 vccd1 vssd1 sky130_ef_sc_hd__decap_40_12
X_2642_ _1092_ _1114_ _1115_ vssd1 vssd1 vccd1 vccd1 _1116_ sky130_fd_sc_hd__a21oi_1
X_2573_ MATMULT_INST.matmult_inst.fsm_inst.tx_start_send _0509_ _1500_ vssd1 vssd1
+ vccd1 vccd1 _1054_ sky130_fd_sc_hd__a21oi_1
X_3125_ clknet_leaf_16_clk _0083_ net133 vssd1 vssd1 vccd1 vccd1 MATMULT_INST.matmult_inst.mem_inst.matrixA2\[4\]
+ sky130_fd_sc_hd__dfrtp_1
XFILLER_27_128 vssd1 vssd1 vccd1 vccd1 sky130_fd_sc_hd__fill_4
X_3056_ net156 MATMULT_INST.matmult_inst.mem_inst.mem0\[17\] MATMULT_INST.matmult_inst.mem_inst.matrixB0\[17\]
+ net161 vssd1 vssd1 vccd1 vccd1 _1474_ sky130_fd_sc_hd__a22o_1
X_2007_ _0578_ _0581_ _0579_ vssd1 vssd1 vccd1 vccd1 _0586_ sky130_fd_sc_hd__a21bo_1
XFILLER_42_109 vssd1 vssd1 vccd1 vccd1 sky130_fd_sc_hd__fill_2
XFILLER_50_164 vssd1 vssd1 vccd1 vccd1 sky130_fd_sc_hd__fill_1
XTAP_TAPCELL_ROW_61_693 vssd1 vccd1 sky130_fd_sc_hd__tapvpwrvgnd_1
X_2909_ net201 net185 _1358_ vssd1 vssd1 vccd1 vccd1 _1374_ sky130_fd_sc_hd__a21o_1
XFILLER_2_249 vssd1 vssd1 vccd1 vccd1 sky130_fd_sc_hd__fill_2
XFILLER_58_231 vssd1 vssd1 vccd1 vccd1 sky130_fd_sc_hd__fill_1
XTAP_TAPCELL_ROW_69_760 vssd1 vccd1 sky130_fd_sc_hd__tapvpwrvgnd_1
XFILLER_18_139 vssd1 vssd1 vccd1 vccd1 sky130_fd_sc_hd__fill_1
XTAP_TAPCELL_ROW_16_307 vssd1 vccd1 sky130_fd_sc_hd__tapvpwrvgnd_1
XTAP_TAPCELL_ROW_24_373 vssd1 vccd1 sky130_fd_sc_hd__tapvpwrvgnd_1
XANTENNA__1861__S net13 vssd1 vssd1 vccd1 vccd1 sky130_fd_sc_hd__diode_2
XFILLER_1_293 vccd1 vssd1 vccd1 vssd1 sky130_ef_sc_hd__decap_40_12
XFILLER_2_77 vssd1 vssd1 vccd1 vccd1 sky130_fd_sc_hd__fill_4
XFILLER_66_80 vssd1 vssd1 vccd1 vccd1 sky130_fd_sc_hd__fill_4
XFILLER_64_245 vssd1 vssd1 vccd1 vccd1 sky130_fd_sc_hd__fill_2
XFILLER_24_109 vssd1 vssd1 vccd1 vccd1 sky130_fd_sc_hd__fill_1
XFILLER_20_326 vssd1 vssd1 vccd1 vccd1 sky130_fd_sc_hd__fill_1
XFILLER_32_197 vssd1 vssd1 vccd1 vccd1 sky130_fd_sc_hd__fill_2
XFILLER_9_393 vccd1 vssd1 vccd1 vssd1 sky130_ef_sc_hd__decap_40_12
X_2625_ _1096_ _1099_ vssd1 vssd1 vccd1 vccd1 _1100_ sky130_fd_sc_hd__xnor2_1
X_2556_ net437 _0952_ _1052_ vssd1 vssd1 vccd1 vccd1 _0352_ sky130_fd_sc_hd__mux2_1
XANTENNA__1771__S net19 vssd1 vssd1 vccd1 vccd1 sky130_fd_sc_hd__diode_2
X_2487_ net75 _0999_ vssd1 vssd1 vccd1 vccd1 _1000_ sky130_fd_sc_hd__and2_2
XANTENNA__2168__A net239 vssd1 vssd1 vccd1 vccd1 sky130_fd_sc_hd__diode_2
XFILLER_46_39 vssd1 vssd1 vccd1 vccd1 sky130_fd_sc_hd__fill_8
X_3108_ clknet_leaf_14_clk _0066_ net143 vssd1 vssd1 vccd1 vccd1 MATMULT_INST.matmult_inst.mem_inst.matrixA0\[5\]
+ sky130_fd_sc_hd__dfrtp_1
XFILLER_55_223 vssd1 vssd1 vccd1 vccd1 sky130_fd_sc_hd__fill_1
XTAP_TAPCELL_ROW_66_730 vssd1 vccd1 sky130_fd_sc_hd__tapvpwrvgnd_1
XFILLER_55_245 vssd1 vssd1 vccd1 vccd1 sky130_fd_sc_hd__fill_4
X_3039_ net92 _1452_ _1458_ net165 vssd1 vssd1 vccd1 vccd1 _1459_ sky130_fd_sc_hd__a22o_1
XANTENNA_fanout162_X net162 vssd1 vssd1 vccd1 vccd1 sky130_fd_sc_hd__diode_2
XFILLER_70_259 vssd1 vssd1 vccd1 vccd1 sky130_fd_sc_hd__fill_2
XFILLER_23_131 vssd1 vssd1 vccd1 vccd1 sky130_fd_sc_hd__fill_4
XTAP_TAPCELL_ROW_38_498 vssd1 vccd1 sky130_fd_sc_hd__tapvpwrvgnd_1
XFILLER_62_27 vssd1 vssd1 vccd1 vccd1 sky130_fd_sc_hd__fill_1
XFILLER_11_337 vccd1 vssd1 vccd1 vssd1 sky130_ef_sc_hd__decap_40_12
XFILLER_23_186 vccd1 vssd1 vccd1 vssd1 sky130_ef_sc_hd__decap_40_12
XTAP_TAPCELL_ROW_21_354 vssd1 vccd1 sky130_fd_sc_hd__tapvpwrvgnd_1
XTAP_TAPCELL_ROW_29_421 vssd1 vccd1 sky130_fd_sc_hd__tapvpwrvgnd_1
XFILLER_36_94 vssd1 vssd1 vccd1 vccd1 sky130_fd_sc_hd__fill_4
XTAP_TAPCELL_ROW_72_788 vssd1 vccd1 sky130_fd_sc_hd__tapvpwrvgnd_1
XFILLER_14_197 vccd1 vssd1 vccd1 vssd1 sky130_ef_sc_hd__decap_40_12
XANTENNA__1856__S net13 vssd1 vssd1 vccd1 vccd1 sky130_fd_sc_hd__diode_2
XANTENNA__2961__A2 net88 vssd1 vssd1 vccd1 vccd1 sky130_fd_sc_hd__diode_2
X_2410_ _1500_ net66 vssd1 vssd1 vccd1 vccd1 _0932_ sky130_fd_sc_hd__nor2_1
XFILLER_6_363 vssd1 vssd1 vccd1 vccd1 sky130_fd_sc_hd__fill_1
X_3390_ clknet_leaf_28_clk _0344_ net96 vssd1 vssd1 vccd1 vccd1 MATMULT_INST.matmult_inst.alu_inst.col0\[4\]
+ sky130_fd_sc_hd__dfrtp_1
X_2341_ _0883_ _0884_ vssd1 vssd1 vccd1 vccd1 _0886_ sky130_fd_sc_hd__or2_1
XANTENNA__1921__A0 net228 vssd1 vssd1 vccd1 vccd1 sky130_fd_sc_hd__diode_2
X_2272_ _0784_ _0818_ vssd1 vssd1 vccd1 vccd1 _0820_ sky130_fd_sc_hd__and2_1
XFILLER_77_90 vccd1 vssd1 vccd1 vssd1 sky130_ef_sc_hd__decap_40_12
XFILLER_28_3 vssd1 vssd1 vccd1 vccd1 sky130_fd_sc_hd__fill_8
XTAP_TAPCELL_ROW_63_711 vssd1 vccd1 sky130_fd_sc_hd__tapvpwrvgnd_1
XTAP_TAPCELL_ROW_35_468 vssd1 vccd1 sky130_fd_sc_hd__tapvpwrvgnd_1
XANTENNA__1766__S net19 vssd1 vssd1 vccd1 vccd1 sky130_fd_sc_hd__diode_2
XFILLER_20_134 vssd1 vssd1 vccd1 vccd1 sky130_fd_sc_hd__fill_2
X_1987_ MATMULT_INST.matmult_inst.alu_inst.adder_inst.r2.fa1.b MATMULT_INST.matmult_inst.alu_inst.adder_inst.r2.fa1.a
+ vssd1 vssd1 vccd1 vccd1 _0569_ sky130_fd_sc_hd__nand2_1
X_2608_ _1071_ _1081_ _1082_ vssd1 vssd1 vccd1 vccd1 _1084_ sky130_fd_sc_hd__and3_1
X_2539_ _1039_ vssd1 vssd1 vccd1 vccd1 _1040_ sky130_fd_sc_hd__inv_2
XFILLER_28_223 vssd1 vssd1 vccd1 vccd1 sky130_fd_sc_hd__fill_1
XANTENNA__2468__B2 net166 vssd1 vssd1 vccd1 vccd1 sky130_fd_sc_hd__diode_2
XANTENNA__2468__A1 net158 vssd1 vssd1 vccd1 vccd1 sky130_fd_sc_hd__diode_2
XFILLER_73_15 vssd1 vssd1 vccd1 vccd1 sky130_fd_sc_hd__fill_2
XANTENNA__1691__A2 net59 vssd1 vssd1 vccd1 vccd1 sky130_fd_sc_hd__diode_2
XFILLER_7_105 vssd1 vssd1 vccd1 vccd1 sky130_fd_sc_hd__fill_4
XFILLER_11_167 vssd1 vssd1 vccd1 vccd1 sky130_fd_sc_hd__fill_1
XFILLER_22_41 vssd1 vssd1 vccd1 vccd1 sky130_fd_sc_hd__fill_4
XFILLER_7_149 vccd1 vssd1 vccd1 vssd1 sky130_ef_sc_hd__decap_40_12
XFILLER_3_333 vssd1 vssd1 vccd1 vccd1 sky130_fd_sc_hd__fill_2
XFILLER_78_101 vssd1 vssd1 vccd1 vccd1 sky130_fd_sc_hd__fill_2
XTAP_TAPCELL_ROW_77_825 vssd1 vccd1 sky130_fd_sc_hd__tapvpwrvgnd_1
Xfanout191 MATMULT_INST.matmult_inst.alu_inst.a1_reg\[3\] vssd1 vssd1 vccd1 vccd1
+ net191 sky130_fd_sc_hd__clkbuf_2
Xfanout180 MATMULT_INST.matmult_inst.addr\[0\] vssd1 vssd1 vccd1 vccd1 net180 sky130_fd_sc_hd__clkbuf_2
XFILLER_74_362 vssd1 vssd1 vccd1 vccd1 sky130_fd_sc_hd__fill_2
X_1910_ net582 net44 net26 vssd1 vssd1 vccd1 vccd1 _0239_ sky130_fd_sc_hd__mux2_1
XFILLER_30_410 vssd1 vssd1 vccd1 vccd1 sky130_fd_sc_hd__fill_1
XFILLER_30_421 vssd1 vssd1 vccd1 vccd1 sky130_fd_sc_hd__fill_1
XFILLER_42_270 vssd1 vssd1 vccd1 vccd1 sky130_fd_sc_hd__fill_1
X_2890_ _1340_ _1346_ vssd1 vssd1 vccd1 vccd1 _1356_ sky130_fd_sc_hd__nand2_1
XFILLER_63_92 vssd1 vssd1 vccd1 vccd1 sky130_fd_sc_hd__fill_2
X_1841_ net536 net35 net28 vssd1 vssd1 vccd1 vccd1 _0173_ sky130_fd_sc_hd__mux2_1
XFILLER_8_65 vccd1 vssd1 vccd1 vssd1 sky130_ef_sc_hd__decap_40_12
X_1772_ net484 net48 net18 vssd1 vssd1 vccd1 vccd1 _0109_ sky130_fd_sc_hd__mux2_1
X_3511_ clknet_leaf_8_clk _0436_ net134 vssd1 vssd1 vccd1 vccd1 MATMULT_INST.matmult_inst.spi_inst.tx_reg_sys\[2\]
+ sky130_fd_sc_hd__dfrtp_1
X_3442_ _0024_ _0389_ net139 vssd1 vssd1 vccd1 vccd1 MATMULT_INST.matmult_inst.spi_inst.rx_bit_count\[2\]
+ sky130_fd_sc_hd__dfrtp_1
XFILLER_6_193 vssd1 vssd1 vccd1 vccd1 sky130_fd_sc_hd__fill_2
X_3373_ clknet_leaf_7_clk _0328_ net112 vssd1 vssd1 vccd1 vccd1 MATMULT_INST.matmult_inst.fsm_inst.state\[1\]
+ sky130_fd_sc_hd__dfrtp_1
XFILLER_69_123 vssd1 vssd1 vccd1 vccd1 sky130_fd_sc_hd__fill_2
X_2324_ _0867_ _0869_ vssd1 vssd1 vccd1 vccd1 _0870_ sky130_fd_sc_hd__nand2_1
XFILLER_69_167 vssd1 vssd1 vccd1 vccd1 sky130_fd_sc_hd__fill_1
X_2255_ _0770_ _0771_ _0769_ vssd1 vssd1 vccd1 vccd1 _0803_ sky130_fd_sc_hd__a21bo_1
X_2186_ _0682_ _0735_ vssd1 vssd1 vccd1 vccd1 _0736_ sky130_fd_sc_hd__nand2_1
XANTENNA__2446__A net181 vssd1 vssd1 vccd1 vccd1 sky130_fd_sc_hd__diode_2
XTAP_TAPCELL_ROW_48_582 vssd1 vccd1 sky130_fd_sc_hd__tapvpwrvgnd_1
XFILLER_48_307 vssd1 vssd1 vccd1 vccd1 sky130_fd_sc_hd__fill_1
XFILLER_75_115 vssd1 vssd1 vccd1 vccd1 sky130_fd_sc_hd__fill_1
XTAP_TAPCELL_ROW_3_196 vssd1 vccd1 sky130_fd_sc_hd__tapvpwrvgnd_1
XFILLER_56_373 vssd1 vssd1 vccd1 vccd1 sky130_fd_sc_hd__fill_1
XFILLER_12_421 vccd1 vssd1 vccd1 vssd1 sky130_ef_sc_hd__decap_40_12
XFILLER_33_73 vssd1 vssd1 vccd1 vccd1 sky130_fd_sc_hd__fill_4
XFILLER_8_469 vssd1 vssd1 vccd1 vccd1 sky130_fd_sc_hd__fill_4
XFILLER_79_421 vccd1 vssd1 vccd1 vssd1 sky130_ef_sc_hd__decap_40_12
XFILLER_79_454 vssd1 vssd1 vccd1 vccd1 sky130_fd_sc_hd__fill_4
Xhold3 MATMULT_INST.matmult_inst.fsm_inst.rx_valid vssd1 vssd1 vccd1 vccd1 net316
+ sky130_fd_sc_hd__dlygate4sd3_1
XANTENNA__2965__S net57 vssd1 vssd1 vccd1 vccd1 sky130_fd_sc_hd__diode_2
XFILLER_66_126 vccd1 vssd1 vccd1 vssd1 sky130_ef_sc_hd__decap_40_12
X_2040_ net203 net473 net55 vssd1 vssd1 vccd1 vccd1 _0281_ sky130_fd_sc_hd__mux2_1
XFILLER_66_148 vssd1 vssd1 vccd1 vccd1 sky130_fd_sc_hd__fill_4
XANTENNA_clkbuf_leaf_11_clk_A clknet_2_3__leaf_clk vssd1 vssd1 vccd1 vccd1 sky130_fd_sc_hd__diode_2
XTAP_TAPCELL_ROW_45_552 vssd1 vccd1 sky130_fd_sc_hd__tapvpwrvgnd_1
X_2942_ MATMULT_INST.matmult_inst.fsm_inst.rx_data\[3\] net322 MATMULT_INST.matmult_inst.spi_inst.rx_done_sys
+ vssd1 vssd1 vccd1 vccd1 _0429_ sky130_fd_sc_hd__mux2_1
XFILLER_22_229 vssd1 vssd1 vccd1 vccd1 sky130_fd_sc_hd__fill_2
XANTENNA_clkbuf_leaf_26_clk_A clknet_2_0__leaf_clk vssd1 vssd1 vccd1 vccd1 sky130_fd_sc_hd__diode_2
XANTENNA__2713__B net204 vssd1 vssd1 vccd1 vccd1 sky130_fd_sc_hd__diode_2
X_2873_ _1337_ _1338_ _1320_ _1325_ vssd1 vssd1 vccd1 vccd1 _1340_ sky130_fd_sc_hd__a211o_1
X_1824_ net392 _0491_ net15 vssd1 vssd1 vccd1 vccd1 _0157_ sky130_fd_sc_hd__mux2_1
X_1755_ net497 net44 net20 vssd1 vssd1 vccd1 vccd1 _0095_ sky130_fd_sc_hd__mux2_1
XANTENNA__2907__A2 net67 vssd1 vssd1 vccd1 vccd1 sky130_fd_sc_hd__diode_2
X_1686_ net470 net36 net25 vssd1 vssd1 vccd1 vccd1 _0046_ sky130_fd_sc_hd__mux2_1
X_3425_ clknet_leaf_2_clk _0377_ vssd1 vssd1 vccd1 vccd1 MATMULT_INST.matmult_inst.alu_inst.adder_inst.r1.fa3.b
+ sky130_fd_sc_hd__dfxtp_1
X_3356_ clknet_leaf_7_clk _0311_ net110 vssd1 vssd1 vccd1 vccd1 MATMULT_INST.matmult_inst.fsm_inst.alu_result\[2\]
+ sky130_fd_sc_hd__dfrtp_1
X_2307_ net218 net227 net216 net230 vssd1 vssd1 vccd1 vccd1 _0853_ sky130_fd_sc_hd__a22oi_1
X_3287_ clknet_leaf_28_clk _0245_ net96 vssd1 vssd1 vccd1 vccd1 MATMULT_INST.matmult_inst.alu_inst.b0_reg\[3\]
+ sky130_fd_sc_hd__dfrtp_1
X_2238_ net227 net222 net219 net229 vssd1 vssd1 vccd1 vccd1 _0786_ sky130_fd_sc_hd__a22oi_1
X_2169_ net214 _0718_ _0717_ vssd1 vssd1 vccd1 vccd1 _0719_ sky130_fd_sc_hd__a21bo_1
XTAP_TAPCELL_ROW_0_166 vssd1 vccd1 sky130_fd_sc_hd__tapvpwrvgnd_1
XANTENNA_fanout242_X net242 vssd1 vssd1 vccd1 vccd1 sky130_fd_sc_hd__diode_2
XFILLER_5_417 vccd1 vssd1 vccd1 vssd1 sky130_ef_sc_hd__decap_40_12
XANTENNA__2061__D net238 vssd1 vssd1 vccd1 vccd1 sky130_fd_sc_hd__diode_2
XTAP_TAPCELL_ROW_8_244 vssd1 vccd1 sky130_fd_sc_hd__tapvpwrvgnd_1
XFILLER_0_111 vssd1 vssd1 vccd1 vccd1 sky130_fd_sc_hd__fill_1
XANTENNA__2531__A0 _1000_ vssd1 vssd1 vccd1 vccd1 sky130_fd_sc_hd__diode_2
Xteam_02_252 vssd1 vssd1 vccd1 vccd1 team_02_252/HI gpio_out[5] sky130_fd_sc_hd__conb_1
Xteam_02_285 vssd1 vssd1 vccd1 vccd1 gpio_oeb[5] team_02_285/LO sky130_fd_sc_hd__conb_1
Xteam_02_263 vssd1 vssd1 vccd1 vccd1 team_02_263/HI gpio_out[16] sky130_fd_sc_hd__conb_1
Xteam_02_296 vssd1 vssd1 vccd1 vccd1 gpio_oeb[16] team_02_296/LO sky130_fd_sc_hd__conb_1
Xteam_02_274 vssd1 vssd1 vccd1 vccd1 team_02_274/HI gpio_out[27] sky130_fd_sc_hd__conb_1
XTAP_TAPCELL_ROW_59_677 vssd1 vccd1 sky130_fd_sc_hd__tapvpwrvgnd_1
XFILLER_71_173 vssd1 vssd1 vccd1 vccd1 sky130_fd_sc_hd__fill_2
XTAP_TAPCELL_ROW_42_533 vssd1 vccd1 sky130_fd_sc_hd__tapvpwrvgnd_1
XFILLER_44_72 vssd1 vssd1 vccd1 vccd1 sky130_fd_sc_hd__fill_1
XFILLER_12_251 vssd1 vssd1 vccd1 vccd1 sky130_fd_sc_hd__fill_1
XFILLER_8_233 vccd1 vssd1 vccd1 vssd1 sky130_ef_sc_hd__decap_40_12
XFILLER_8_277 vccd1 vssd1 vccd1 vssd1 sky130_ef_sc_hd__decap_40_12
X_1540_ net3 vssd1 vssd1 vccd1 vccd1 MATMULT_INST.matmult_inst.cs sky130_fd_sc_hd__inv_2
XANTENNA__1864__S net12 vssd1 vssd1 vccd1 vccd1 sky130_fd_sc_hd__diode_2
XFILLER_5_55 vssd1 vssd1 vccd1 vccd1 sky130_fd_sc_hd__fill_1
XFILLER_69_80 vccd1 vssd1 vccd1 vssd1 sky130_ef_sc_hd__decap_40_12
X_3210_ clknet_leaf_20_clk _0168_ net126 vssd1 vssd1 vccd1 vccd1 MATMULT_INST.matmult_inst.mem_inst.matrixA3\[17\]
+ sky130_fd_sc_hd__dfrtp_1
X_3141_ clknet_leaf_9_clk _0099_ net138 vssd1 vssd1 vccd1 vccd1 MATMULT_INST.matmult_inst.mem_inst.mem3\[2\]
+ sky130_fd_sc_hd__dfrtp_1
XFILLER_10_3 vccd1 vssd1 vccd1 vssd1 sky130_ef_sc_hd__decap_40_12
X_3072_ net244 vssd1 vssd1 vccd1 vccd1 _0030_ sky130_fd_sc_hd__inv_2
X_2023_ MATMULT_INST.matmult_inst.alu_inst.adder_inst.r3.fa3.b MATMULT_INST.matmult_inst.alu_inst.adder_inst.r3.fa3.a
+ vssd1 vssd1 vccd1 vccd1 _0599_ sky130_fd_sc_hd__nand2_1
XFILLER_62_162 vssd1 vssd1 vccd1 vccd1 sky130_fd_sc_hd__fill_1
XFILLER_62_195 vssd1 vssd1 vccd1 vccd1 sky130_fd_sc_hd__fill_1
X_2925_ net342 _0489_ net9 vssd1 vssd1 vccd1 vccd1 _0412_ sky130_fd_sc_hd__mux2_1
X_2856_ _1287_ _1293_ _1323_ vssd1 vssd1 vccd1 vccd1 _1324_ sky130_fd_sc_hd__o21ai_1
X_1807_ net554 net52 net16 vssd1 vssd1 vccd1 vccd1 _0141_ sky130_fd_sc_hd__mux2_1
XANTENNA__1774__S net18 vssd1 vssd1 vccd1 vccd1 sky130_fd_sc_hd__diode_2
X_2787_ net185 net204 vssd1 vssd1 vccd1 vccd1 _1257_ sky130_fd_sc_hd__and2_1
Xhold200 MATMULT_INST.matmult_inst.alu_inst.adder_inst.r1.fa3.b vssd1 vssd1 vccd1
+ vccd1 net513 sky130_fd_sc_hd__dlygate4sd3_1
Xhold211 MATMULT_INST.matmult_inst.mem_inst.matrixB2\[6\] vssd1 vssd1 vccd1 vccd1
+ net524 sky130_fd_sc_hd__dlygate4sd3_1
XANTENNA_fanout202_A net203 vssd1 vssd1 vccd1 vccd1 sky130_fd_sc_hd__diode_2
Xhold233 MATMULT_INST.matmult_inst.alu_inst.out\[12\] vssd1 vssd1 vccd1 vccd1 net546
+ sky130_fd_sc_hd__dlygate4sd3_1
Xhold244 MATMULT_INST.matmult_inst.alu_inst.row0\[1\] vssd1 vssd1 vccd1 vccd1 net557
+ sky130_fd_sc_hd__dlygate4sd3_1
Xhold222 MATMULT_INST.matmult_inst.alu_inst.row0\[0\] vssd1 vssd1 vccd1 vccd1 net535
+ sky130_fd_sc_hd__dlygate4sd3_1
X_1738_ _0504_ _0507_ vssd1 vssd1 vccd1 vccd1 _0508_ sky130_fd_sc_hd__nor2_1
Xhold255 MATMULT_INST.matmult_inst.mem_inst.matrixA1\[13\] vssd1 vssd1 vccd1 vccd1
+ net568 sky130_fd_sc_hd__dlygate4sd3_1
Xhold266 MATMULT_INST.matmult_inst.fsm_inst.alu_result\[16\] vssd1 vssd1 vccd1 vccd1
+ net579 sky130_fd_sc_hd__dlygate4sd3_1
Xhold277 MATMULT_INST.matmult_inst.alu_inst.adder_inst.r2.fa0.b vssd1 vssd1 vccd1
+ vccd1 net590 sky130_fd_sc_hd__dlygate4sd3_1
X_1669_ _1516_ _1537_ vssd1 vssd1 vccd1 vccd1 _0478_ sky130_fd_sc_hd__nand2_1
Xhold288 MATMULT_INST.matmult_inst.alu_inst.col0\[7\] vssd1 vssd1 vccd1 vccd1 net601
+ sky130_fd_sc_hd__dlygate4sd3_1
X_3408_ clknet_leaf_0_clk _0361_ net94 vssd1 vssd1 vccd1 vccd1 MATMULT_INST.matmult_inst.alu_inst.row0\[1\]
+ sky130_fd_sc_hd__dfrtp_1
Xhold299 MATMULT_INST.matmult_inst.mem_inst.mem1\[10\] vssd1 vssd1 vccd1 vccd1 net612
+ sky130_fd_sc_hd__dlygate4sd3_1
XTAP_TAPCELL_ROW_5_214 vssd1 vccd1 sky130_fd_sc_hd__tapvpwrvgnd_1
XANTENNA_fanout192_X net192 vssd1 vssd1 vccd1 vccd1 sky130_fd_sc_hd__diode_2
X_3339_ clknet_leaf_0_clk _0294_ vssd1 vssd1 vccd1 vccd1 MATMULT_INST.matmult_inst.alu_inst.adder_inst.r0.fa2.a
+ sky130_fd_sc_hd__dfxtp_1
XFILLER_45_107 vssd1 vssd1 vccd1 vccd1 sky130_fd_sc_hd__fill_4
XFILLER_65_38 vccd1 vssd1 vccd1 vssd1 sky130_ef_sc_hd__decap_40_12
XTAP_TAPCELL_ROW_56_647 vssd1 vccd1 sky130_fd_sc_hd__tapvpwrvgnd_1
XFILLER_5_225 vccd1 vssd1 vccd1 vssd1 sky130_ef_sc_hd__decap_40_12
XANTENNA__1684__S net25 vssd1 vssd1 vccd1 vccd1 sky130_fd_sc_hd__diode_2
XFILLER_30_85 vssd1 vssd1 vccd1 vccd1 sky130_fd_sc_hd__fill_1
XANTENNA__1859__S net13 vssd1 vssd1 vccd1 vccd1 sky130_fd_sc_hd__diode_2
X_2710_ _1177_ _1178_ _1180_ vssd1 vssd1 vccd1 vccd1 _1182_ sky130_fd_sc_hd__nand3_1
XFILLER_71_92 vssd1 vssd1 vccd1 vccd1 sky130_fd_sc_hd__fill_2
XTAP_TAPCELL_ROW_10_260 vssd1 vccd1 sky130_fd_sc_hd__tapvpwrvgnd_1
X_2641_ _1092_ _1113_ vssd1 vssd1 vccd1 vccd1 _1115_ sky130_fd_sc_hd__nor2_1
X_2572_ _1033_ net361 _1053_ vssd1 vssd1 vccd1 vccd1 _0367_ sky130_fd_sc_hd__mux2_1
XFILLER_58_3 vssd1 vssd1 vccd1 vccd1 sky130_fd_sc_hd__fill_2
X_3124_ clknet_leaf_14_clk _0082_ net130 vssd1 vssd1 vccd1 vccd1 MATMULT_INST.matmult_inst.mem_inst.matrixA2\[3\]
+ sky130_fd_sc_hd__dfrtp_1
X_3055_ MATMULT_INST.matmult_inst.mem_inst.mem2\[17\] net87 net79 MATMULT_INST.matmult_inst.mem_inst.mem1\[17\]
+ _1472_ vssd1 vssd1 vccd1 vccd1 _1473_ sky130_fd_sc_hd__a221o_1
X_2006_ _0583_ _0584_ vssd1 vssd1 vccd1 vccd1 _0585_ sky130_fd_sc_hd__nand2_1
XANTENNA__1769__S net18 vssd1 vssd1 vccd1 vccd1 sky130_fd_sc_hd__diode_2
XFILLER_50_154 vssd1 vssd1 vccd1 vccd1 sky130_fd_sc_hd__fill_2
X_2908_ MATMULT_INST.matmult_inst.alu_inst.adder_inst.r3.fa2.b net67 vssd1 vssd1 vccd1
+ vccd1 _1373_ sky130_fd_sc_hd__and2_1
XFILLER_50_176 vssd1 vssd1 vccd1 vccd1 sky130_fd_sc_hd__fill_4
XTAP_TAPCELL_ROW_61_694 vssd1 vccd1 sky130_fd_sc_hd__tapvpwrvgnd_1
XANTENNA__2982__B1 net78 vssd1 vssd1 vccd1 vccd1 sky130_fd_sc_hd__diode_2
X_2839_ _1304_ _1307_ vssd1 vssd1 vccd1 vccd1 _1308_ sky130_fd_sc_hd__nand2b_1
XFILLER_76_26 vssd1 vssd1 vccd1 vccd1 sky130_fd_sc_hd__fill_2
XFILLER_58_210 vssd1 vssd1 vccd1 vccd1 sky130_fd_sc_hd__fill_1
XTAP_TAPCELL_ROW_69_761 vssd1 vccd1 sky130_fd_sc_hd__tapvpwrvgnd_1
XANTENNA_fanout65_A _0944_ vssd1 vssd1 vccd1 vccd1 sky130_fd_sc_hd__diode_2
XFILLER_73_235 vssd1 vssd1 vccd1 vccd1 sky130_fd_sc_hd__fill_4
XTAP_TAPCELL_ROW_16_308 vssd1 vccd1 sky130_fd_sc_hd__tapvpwrvgnd_1
XFILLER_14_313 vssd1 vssd1 vccd1 vccd1 sky130_fd_sc_hd__fill_1
XFILLER_14_302 vssd1 vssd1 vccd1 vccd1 sky130_fd_sc_hd__fill_2
XFILLER_26_162 vssd1 vssd1 vccd1 vccd1 sky130_fd_sc_hd__fill_2
XFILLER_14_324 vssd1 vssd1 vccd1 vccd1 sky130_fd_sc_hd__fill_2
XFILLER_26_184 vssd1 vssd1 vccd1 vccd1 sky130_fd_sc_hd__fill_1
XFILLER_25_96 vssd1 vssd1 vccd1 vccd1 sky130_fd_sc_hd__fill_1
XANTENNA_fanout20_X net20 vssd1 vssd1 vccd1 vccd1 sky130_fd_sc_hd__diode_2
XTAP_TAPCELL_ROW_24_374 vssd1 vccd1 sky130_fd_sc_hd__tapvpwrvgnd_1
XANTENNA__2973__B1 net81 vssd1 vssd1 vccd1 vccd1 sky130_fd_sc_hd__diode_2
XFILLER_1_261 vccd1 vssd1 vccd1 vssd1 sky130_ef_sc_hd__decap_40_12
Xclkbuf_leaf_29_clk clknet_2_0__leaf_clk vssd1 vssd1 vccd1 vccd1 clknet_leaf_29_clk
+ sky130_fd_sc_hd__clkbuf_8
XFILLER_32_121 vccd1 vssd1 vccd1 vssd1 sky130_ef_sc_hd__decap_40_12
XFILLER_45_493 vssd1 vssd1 vccd1 vccd1 sky130_fd_sc_hd__fill_1
XANTENNA__3389__RESET_B net96 vssd1 vssd1 vccd1 vccd1 sky130_fd_sc_hd__diode_2
XFILLER_9_361 vccd1 vssd1 vccd1 vssd1 sky130_ef_sc_hd__decap_40_12
X_2624_ _1097_ _1098_ vssd1 vssd1 vccd1 vccd1 _1099_ sky130_fd_sc_hd__nand2b_1
X_2555_ net75 _0457_ _0465_ _0953_ vssd1 vssd1 vccd1 vccd1 _1052_ sky130_fd_sc_hd__a211oi_4
X_2486_ _0991_ _0993_ _0998_ vssd1 vssd1 vccd1 vccd1 _0999_ sky130_fd_sc_hd__or3_1
XFILLER_46_29 vssd1 vssd1 vccd1 vccd1 sky130_fd_sc_hd__fill_4
X_3107_ clknet_leaf_15_clk _0065_ net135 vssd1 vssd1 vccd1 vccd1 MATMULT_INST.matmult_inst.mem_inst.matrixA0\[4\]
+ sky130_fd_sc_hd__dfrtp_1
XTAP_TAPCELL_ROW_66_731 vssd1 vccd1 sky130_fd_sc_hd__tapvpwrvgnd_1
XFILLER_70_227 vssd1 vssd1 vccd1 vccd1 sky130_fd_sc_hd__fill_2
X_3038_ net178 net169 MATMULT_INST.matmult_inst.mem_inst.matrixA3\[15\] _1457_ vssd1
+ vssd1 vccd1 vccd1 _1458_ sky130_fd_sc_hd__a31o_1
XANTENNA_fanout155_X net155 vssd1 vssd1 vccd1 vccd1 sky130_fd_sc_hd__diode_2
XTAP_TAPCELL_ROW_38_499 vssd1 vccd1 sky130_fd_sc_hd__tapvpwrvgnd_1
XFILLER_11_305 vccd1 vssd1 vccd1 vssd1 sky130_ef_sc_hd__decap_40_12
XFILLER_23_165 vssd1 vssd1 vccd1 vccd1 sky130_fd_sc_hd__fill_1
XFILLER_23_198 vccd1 vssd1 vccd1 vssd1 sky130_ef_sc_hd__decap_40_12
XFILLER_11_349 vccd1 vssd1 vccd1 vssd1 sky130_ef_sc_hd__decap_40_12
XANTENNA_fanout68_X net68 vssd1 vssd1 vccd1 vccd1 sky130_fd_sc_hd__diode_2
XTAP_TAPCELL_ROW_29_422 vssd1 vccd1 sky130_fd_sc_hd__tapvpwrvgnd_1
XANTENNA__2238__A2 net222 vssd1 vssd1 vccd1 vccd1 sky130_fd_sc_hd__diode_2
XANTENNA__1872__S net12 vssd1 vssd1 vccd1 vccd1 sky130_fd_sc_hd__diode_2
X_2340_ _0883_ _0884_ vssd1 vssd1 vccd1 vccd1 _0885_ sky130_fd_sc_hd__nand2_1
X_2271_ _0784_ _0818_ _0817_ vssd1 vssd1 vccd1 vccd1 _0819_ sky130_fd_sc_hd__o21ai_1
XANTENNA__2477__A2 net89 vssd1 vssd1 vccd1 vccd1 sky130_fd_sc_hd__diode_2
XANTENNA__1685__B1 net61 vssd1 vssd1 vccd1 vccd1 sky130_fd_sc_hd__diode_2
XTAP_TAPCELL_ROW_35_469 vssd1 vccd1 sky130_fd_sc_hd__tapvpwrvgnd_1
XFILLER_20_102 vssd1 vssd1 vccd1 vccd1 sky130_fd_sc_hd__fill_2
X_1986_ MATMULT_INST.matmult_inst.alu_inst.adder_inst.r2.fa1.b MATMULT_INST.matmult_inst.alu_inst.adder_inst.r2.fa1.a
+ vssd1 vssd1 vccd1 vccd1 _0568_ sky130_fd_sc_hd__nor2_1
Xclkbuf_leaf_9_clk clknet_2_3__leaf_clk vssd1 vssd1 vccd1 vccd1 clknet_leaf_9_clk
+ sky130_fd_sc_hd__clkbuf_8
X_2607_ _1081_ _1082_ _1071_ vssd1 vssd1 vccd1 vccd1 _1083_ sky130_fd_sc_hd__a21oi_1
XANTENNA__1782__S net31 vssd1 vssd1 vccd1 vccd1 sky130_fd_sc_hd__diode_2
X_2538_ _1536_ _1036_ _1038_ vssd1 vssd1 vccd1 vccd1 _1039_ sky130_fd_sc_hd__or3_2
XFILLER_75_319 vssd1 vssd1 vccd1 vccd1 sky130_fd_sc_hd__fill_1
X_2469_ net182 net173 MATMULT_INST.matmult_inst.mem_inst.matrixB3\[3\] vssd1 vssd1
+ vccd1 vccd1 _0983_ sky130_fd_sc_hd__and3_1
XFILLER_16_419 vssd1 vssd1 vccd1 vccd1 sky130_fd_sc_hd__fill_1
XFILLER_43_205 vssd1 vssd1 vccd1 vccd1 sky130_fd_sc_hd__fill_1
XFILLER_11_113 vccd1 vssd1 vccd1 vssd1 sky130_ef_sc_hd__decap_40_12
XANTENNA_fanout28_A net29 vssd1 vssd1 vccd1 vccd1 sky130_fd_sc_hd__diode_2
XFILLER_22_31 vssd1 vssd1 vccd1 vccd1 sky130_fd_sc_hd__fill_1
XFILLER_22_64 vssd1 vssd1 vccd1 vccd1 sky130_fd_sc_hd__fill_1
XANTENNA__1692__S net25 vssd1 vssd1 vccd1 vccd1 sky130_fd_sc_hd__diode_2
XFILLER_78_124 vssd1 vssd1 vccd1 vccd1 sky130_fd_sc_hd__fill_4
XFILLER_3_389 vssd1 vssd1 vccd1 vccd1 sky130_fd_sc_hd__fill_2
XANTENNA__1705__B net60 vssd1 vssd1 vccd1 vccd1 sky130_fd_sc_hd__diode_2
XTAP_TAPCELL_ROW_77_826 vssd1 vccd1 sky130_fd_sc_hd__tapvpwrvgnd_1
Xfanout192 MATMULT_INST.matmult_inst.alu_inst.a1_reg\[2\] vssd1 vssd1 vccd1 vccd1
+ net192 sky130_fd_sc_hd__buf_2
XANTENNA__2459__A2 net89 vssd1 vssd1 vccd1 vccd1 sky130_fd_sc_hd__diode_2
Xfanout181 net183 vssd1 vssd1 vccd1 vccd1 net181 sky130_fd_sc_hd__buf_2
Xfanout170 net171 vssd1 vssd1 vccd1 vccd1 net170 sky130_fd_sc_hd__buf_1
XANTENNA__2817__A net189 vssd1 vssd1 vccd1 vccd1 sky130_fd_sc_hd__diode_2
XFILLER_19_257 vssd1 vssd1 vccd1 vccd1 sky130_fd_sc_hd__fill_1
XFILLER_34_216 vssd1 vssd1 vccd1 vccd1 sky130_fd_sc_hd__fill_1
XANTENNA__1867__S net12 vssd1 vssd1 vccd1 vccd1 sky130_fd_sc_hd__diode_2
X_1840_ net508 net36 net29 vssd1 vssd1 vccd1 vccd1 _0172_ sky130_fd_sc_hd__mux2_1
XFILLER_8_77 vssd1 vssd1 vccd1 vccd1 sky130_fd_sc_hd__fill_4
X_1771_ net394 net49 net19 vssd1 vssd1 vccd1 vccd1 _0108_ sky130_fd_sc_hd__mux2_1
X_3510_ clknet_leaf_8_clk _0435_ net133 vssd1 vssd1 vccd1 vccd1 MATMULT_INST.matmult_inst.spi_inst.tx_reg_sys\[1\]
+ sky130_fd_sc_hd__dfrtp_1
X_3441_ _0023_ _0388_ net139 vssd1 vssd1 vccd1 vccd1 MATMULT_INST.matmult_inst.spi_inst.rx_bit_count\[1\]
+ sky130_fd_sc_hd__dfrtp_1
XFILLER_40_3 vccd1 vssd1 vccd1 vssd1 sky130_ef_sc_hd__decap_40_12
X_3372_ clknet_leaf_7_clk _0327_ net112 vssd1 vssd1 vccd1 vccd1 MATMULT_INST.matmult_inst.fsm_inst.state\[0\]
+ sky130_fd_sc_hd__dfrtp_1
X_2323_ _0839_ _0866_ vssd1 vssd1 vccd1 vccd1 _0869_ sky130_fd_sc_hd__nand2_1
X_2254_ _0727_ _0754_ _0752_ vssd1 vssd1 vccd1 vccd1 _0802_ sky130_fd_sc_hd__a21o_1
X_2185_ _0653_ _0683_ vssd1 vssd1 vccd1 vccd1 _0735_ sky130_fd_sc_hd__nand2_1
XFILLER_25_216 vssd1 vssd1 vccd1 vccd1 sky130_fd_sc_hd__fill_8
XTAP_TAPCELL_ROW_48_583 vssd1 vccd1 sky130_fd_sc_hd__tapvpwrvgnd_1
XANTENNA__2446__B net172 vssd1 vssd1 vccd1 vccd1 sky130_fd_sc_hd__diode_2
XANTENNA__1777__S net18 vssd1 vssd1 vccd1 vccd1 sky130_fd_sc_hd__diode_2
X_1969_ _0545_ _0553_ vssd1 vssd1 vccd1 vccd1 _0554_ sky130_fd_sc_hd__or2_1
XFILLER_4_109 vccd1 vssd1 vccd1 vssd1 sky130_ef_sc_hd__decap_40_12
XFILLER_0_337 vssd1 vssd1 vccd1 vccd1 sky130_fd_sc_hd__fill_8
XFILLER_56_363 vssd1 vssd1 vccd1 vccd1 sky130_fd_sc_hd__fill_1
XTAP_TAPCELL_ROW_3_197 vssd1 vccd1 sky130_fd_sc_hd__tapvpwrvgnd_1
XANTENNA__2613__A2 net68 vssd1 vssd1 vccd1 vccd1 sky130_fd_sc_hd__diode_2
XFILLER_12_455 vccd1 vssd1 vccd1 vssd1 sky130_ef_sc_hd__decap_40_12
XFILLER_12_433 vccd1 vssd1 vccd1 vssd1 sky130_ef_sc_hd__decap_40_12
XFILLER_33_41 vssd1 vssd1 vccd1 vccd1 sky130_fd_sc_hd__fill_4
XFILLER_12_488 vssd1 vssd1 vccd1 vccd1 sky130_fd_sc_hd__fill_4
XFILLER_79_433 vssd1 vssd1 vccd1 vccd1 sky130_fd_sc_hd__fill_4
XFILLER_79_477 vssd1 vssd1 vccd1 vccd1 sky130_fd_sc_hd__fill_2
Xhold4 MATMULT_INST.matmult_inst.fsm_inst.rx_ready_edge vssd1 vssd1 vccd1 vccd1 net317
+ sky130_fd_sc_hd__dlygate4sd3_1
XFILLER_58_71 vccd1 vssd1 vccd1 vssd1 sky130_ef_sc_hd__decap_40_12
XFILLER_66_105 vssd1 vssd1 vccd1 vccd1 sky130_fd_sc_hd__fill_4
XFILLER_66_138 vssd1 vssd1 vccd1 vccd1 sky130_fd_sc_hd__fill_2
XTAP_TAPCELL_ROW_45_553 vssd1 vccd1 sky130_fd_sc_hd__tapvpwrvgnd_1
X_2941_ MATMULT_INST.matmult_inst.fsm_inst.rx_data\[2\] net328 MATMULT_INST.matmult_inst.spi_inst.rx_done_sys
+ vssd1 vssd1 vccd1 vccd1 _0428_ sky130_fd_sc_hd__mux2_1
XFILLER_15_271 vssd1 vssd1 vccd1 vccd1 sky130_fd_sc_hd__fill_1
XANTENNA__2065__B1 net71 vssd1 vssd1 vccd1 vccd1 sky130_fd_sc_hd__diode_2
XFILLER_62_399 vssd1 vssd1 vccd1 vccd1 sky130_fd_sc_hd__fill_1
XANTENNA__2713__C net192 vssd1 vssd1 vccd1 vccd1 sky130_fd_sc_hd__diode_2
X_2872_ _1320_ _1325_ _1337_ _1338_ vssd1 vssd1 vccd1 vccd1 _1339_ sky130_fd_sc_hd__o211ai_2
X_1823_ net355 net34 net15 vssd1 vssd1 vccd1 vccd1 _0156_ sky130_fd_sc_hd__mux2_1
X_1754_ net657 net45 net20 vssd1 vssd1 vccd1 vccd1 _0094_ sky130_fd_sc_hd__mux2_1
X_3424_ clknet_leaf_2_clk _0376_ vssd1 vssd1 vccd1 vccd1 MATMULT_INST.matmult_inst.alu_inst.adder_inst.r1.fa2.b
+ sky130_fd_sc_hd__dfxtp_1
X_1685_ MATMULT_INST.matmult_inst.fsm_inst.rx_data\[3\] net59 net61 MATMULT_INST.matmult_inst.fsm_inst.alu_result\[3\]
+ vssd1 vssd1 vccd1 vccd1 _0488_ sky130_fd_sc_hd__a22o_1
X_3355_ clknet_leaf_7_clk net388 net110 vssd1 vssd1 vccd1 vccd1 MATMULT_INST.matmult_inst.fsm_inst.alu_result\[1\]
+ sky130_fd_sc_hd__dfrtp_1
X_3286_ clknet_leaf_0_clk _0244_ net94 vssd1 vssd1 vccd1 vccd1 MATMULT_INST.matmult_inst.alu_inst.b0_reg\[2\]
+ sky130_fd_sc_hd__dfrtp_1
X_2306_ net356 _0852_ net70 vssd1 vssd1 vccd1 vccd1 _0302_ sky130_fd_sc_hd__mux2_1
X_2237_ _0762_ _0763_ _0761_ vssd1 vssd1 vccd1 vccd1 _0785_ sky130_fd_sc_hd__a21bo_1
XANTENNA_fanout182_A net183 vssd1 vssd1 vccd1 vccd1 sky130_fd_sc_hd__diode_2
XFILLER_38_363 vssd1 vssd1 vccd1 vccd1 sky130_fd_sc_hd__fill_1
X_2168_ net239 net217 net238 vssd1 vssd1 vccd1 vccd1 _0718_ sky130_fd_sc_hd__and3_1
XFILLER_38_374 vssd1 vssd1 vccd1 vccd1 sky130_fd_sc_hd__fill_1
XFILLER_54_29 vssd1 vssd1 vccd1 vccd1 sky130_fd_sc_hd__fill_1
XTAP_TAPCELL_ROW_0_167 vssd1 vccd1 sky130_fd_sc_hd__tapvpwrvgnd_1
X_2099_ net649 _0651_ net70 vssd1 vssd1 vccd1 vccd1 _0296_ sky130_fd_sc_hd__mux2_1
XFILLER_21_252 vssd1 vssd1 vccd1 vccd1 sky130_fd_sc_hd__fill_2
XANTENNA_fanout235_X net235 vssd1 vssd1 vccd1 vccd1 sky130_fd_sc_hd__diode_2
XPHY_EDGE_ROW_17_Right_17 vssd1 vssd1 vccd1 vccd1 sky130_fd_sc_hd__decap_3
XFILLER_5_429 vccd1 vssd1 vccd1 vssd1 sky130_ef_sc_hd__decap_40_12
XFILLER_79_15 vccd1 vssd1 vccd1 vssd1 sky130_ef_sc_hd__decap_40_12
XANTENNA_fanout95_A net96 vssd1 vssd1 vccd1 vccd1 sky130_fd_sc_hd__diode_2
XFILLER_0_167 vssd1 vssd1 vccd1 vccd1 sky130_fd_sc_hd__fill_1
XPHY_EDGE_ROW_26_Right_26 vssd1 vssd1 vccd1 vccd1 sky130_fd_sc_hd__decap_3
Xteam_02_253 vssd1 vssd1 vccd1 vccd1 team_02_253/HI gpio_out[6] sky130_fd_sc_hd__conb_1
Xteam_02_275 vssd1 vssd1 vccd1 vccd1 team_02_275/HI gpio_out[28] sky130_fd_sc_hd__conb_1
Xteam_02_264 vssd1 vssd1 vccd1 vccd1 team_02_264/HI gpio_out[17] sky130_fd_sc_hd__conb_1
Xteam_02_286 vssd1 vssd1 vccd1 vccd1 gpio_oeb[6] team_02_286/LO sky130_fd_sc_hd__conb_1
XFILLER_28_74 vssd1 vssd1 vccd1 vccd1 sky130_fd_sc_hd__fill_1
Xteam_02_297 vssd1 vssd1 vccd1 vccd1 gpio_oeb[17] team_02_297/LO sky130_fd_sc_hd__conb_1
XFILLER_28_85 vssd1 vssd1 vccd1 vccd1 sky130_fd_sc_hd__fill_4
XFILLER_56_160 vssd1 vssd1 vccd1 vccd1 sky130_fd_sc_hd__fill_1
XFILLER_44_344 vssd1 vssd1 vccd1 vccd1 sky130_fd_sc_hd__fill_1
XANTENNA__2047__A0 net189 vssd1 vssd1 vccd1 vccd1 sky130_fd_sc_hd__diode_2
XPHY_EDGE_ROW_35_Right_35 vssd1 vssd1 vccd1 vccd1 sky130_fd_sc_hd__decap_3
XFILLER_8_245 vssd1 vssd1 vccd1 vccd1 sky130_fd_sc_hd__fill_4
XFILLER_8_289 vccd1 vssd1 vccd1 vssd1 sky130_ef_sc_hd__decap_40_12
XANTENNA__1717__Y _0505_ vssd1 vssd1 vccd1 vccd1 sky130_fd_sc_hd__diode_2
XANTENNA__2041__S net55 vssd1 vssd1 vccd1 vccd1 sky130_fd_sc_hd__diode_2
XFILLER_4_473 vssd1 vssd1 vccd1 vccd1 sky130_fd_sc_hd__fill_2
XFILLER_69_92 vssd1 vssd1 vccd1 vccd1 sky130_fd_sc_hd__fill_4
XANTENNA__2976__S net57 vssd1 vssd1 vccd1 vccd1 sky130_fd_sc_hd__diode_2
XPHY_EDGE_ROW_44_Right_44 vssd1 vssd1 vccd1 vccd1 sky130_fd_sc_hd__decap_3
XANTENNA__1880__S net11 vssd1 vssd1 vccd1 vccd1 sky130_fd_sc_hd__diode_2
X_3140_ clknet_leaf_8_clk _0098_ net109 vssd1 vssd1 vccd1 vccd1 MATMULT_INST.matmult_inst.mem_inst.mem3\[1\]
+ sky130_fd_sc_hd__dfrtp_1
X_3071_ net244 vssd1 vssd1 vccd1 vccd1 _0029_ sky130_fd_sc_hd__inv_2
X_2022_ MATMULT_INST.matmult_inst.alu_inst.adder_inst.r3.fa3.b MATMULT_INST.matmult_inst.alu_inst.adder_inst.r3.fa3.a
+ vssd1 vssd1 vccd1 vccd1 _0598_ sky130_fd_sc_hd__nor2_1
XFILLER_47_193 vssd1 vssd1 vccd1 vccd1 sky130_fd_sc_hd__fill_1
XFILLER_62_141 vssd1 vssd1 vccd1 vccd1 sky130_fd_sc_hd__fill_2
XFILLER_62_152 vssd1 vssd1 vccd1 vccd1 sky130_fd_sc_hd__fill_1
XPHY_EDGE_ROW_53_Right_53 vssd1 vssd1 vccd1 vccd1 sky130_fd_sc_hd__decap_3
X_2924_ net345 _0488_ net9 vssd1 vssd1 vccd1 vccd1 _0411_ sky130_fd_sc_hd__mux2_1
X_2855_ _1287_ _1293_ _1286_ vssd1 vssd1 vccd1 vccd1 _1323_ sky130_fd_sc_hd__a21bo_1
XTAP_TAPCELL_ROW_13_280 vssd1 vccd1 sky130_fd_sc_hd__tapvpwrvgnd_1
X_1806_ net552 net32 net17 vssd1 vssd1 vccd1 vccd1 _0140_ sky130_fd_sc_hd__mux2_1
Xhold201 MATMULT_INST.matmult_inst.alu_inst.out\[8\] vssd1 vssd1 vccd1 vccd1 net514
+ sky130_fd_sc_hd__dlygate4sd3_1
X_2786_ _1255_ vssd1 vssd1 vccd1 vccd1 _1256_ sky130_fd_sc_hd__inv_2
Xhold212 MATMULT_INST.matmult_inst.mem_inst.matrixA0\[9\] vssd1 vssd1 vccd1 vccd1
+ net525 sky130_fd_sc_hd__dlygate4sd3_1
Xhold234 MATMULT_INST.matmult_inst.mem_inst.matrixB2\[3\] vssd1 vssd1 vccd1 vccd1
+ net547 sky130_fd_sc_hd__dlygate4sd3_1
Xhold223 MATMULT_INST.matmult_inst.mem_inst.mem1\[4\] vssd1 vssd1 vccd1 vccd1 net536
+ sky130_fd_sc_hd__dlygate4sd3_1
X_1737_ net181 net172 vssd1 vssd1 vccd1 vccd1 _0507_ sky130_fd_sc_hd__nand2b_1
X_1668_ MATMULT_INST.matmult_inst.spi_inst.tx_reg_sys\[17\] MATMULT_INST.matmult_inst.spi_inst.miso_bit
+ net153 vssd1 vssd1 vccd1 vccd1 MATMULT_INST.matmult_inst.miso sky130_fd_sc_hd__mux2_1
Xhold267 _0325_ vssd1 vssd1 vccd1 vccd1 net580 sky130_fd_sc_hd__dlygate4sd3_1
Xhold278 MATMULT_INST.matmult_inst.mem_inst.matrixA0\[11\] vssd1 vssd1 vccd1 vccd1
+ net591 sky130_fd_sc_hd__dlygate4sd3_1
Xhold245 MATMULT_INST.matmult_inst.mem_inst.mem0\[9\] vssd1 vssd1 vccd1 vccd1 net558
+ sky130_fd_sc_hd__dlygate4sd3_1
Xhold256 MATMULT_INST.matmult_inst.mem_inst.matrixA2\[0\] vssd1 vssd1 vccd1 vccd1
+ net569 sky130_fd_sc_hd__dlygate4sd3_1
XPHY_EDGE_ROW_62_Right_62 vssd1 vssd1 vccd1 vccd1 sky130_fd_sc_hd__decap_3
Xhold289 MATMULT_INST.matmult_inst.mem_inst.mem0\[13\] vssd1 vssd1 vccd1 vccd1 net602
+ sky130_fd_sc_hd__dlygate4sd3_1
XANTENNA__1790__S net30 vssd1 vssd1 vccd1 vccd1 sky130_fd_sc_hd__diode_2
X_3407_ clknet_leaf_0_clk _0360_ net95 vssd1 vssd1 vccd1 vccd1 MATMULT_INST.matmult_inst.alu_inst.row0\[0\]
+ sky130_fd_sc_hd__dfrtp_1
XANTENNA__2513__A1 net158 vssd1 vssd1 vccd1 vccd1 sky130_fd_sc_hd__diode_2
XANTENNA__2513__B2 net163 vssd1 vssd1 vccd1 vccd1 sky130_fd_sc_hd__diode_2
XTAP_TAPCELL_ROW_5_215 vssd1 vccd1 sky130_fd_sc_hd__tapvpwrvgnd_1
X_3338_ clknet_leaf_0_clk _0293_ vssd1 vssd1 vccd1 vccd1 MATMULT_INST.matmult_inst.alu_inst.adder_inst.r0.fa1.a
+ sky130_fd_sc_hd__dfxtp_1
XFILLER_58_414 vssd1 vssd1 vccd1 vccd1 sky130_fd_sc_hd__fill_1
X_1599_ MATMULT_INST.matmult_inst.fsm_inst.state\[4\] _1516_ vssd1 vssd1 vccd1 vccd1
+ _1517_ sky130_fd_sc_hd__and2b_1
X_3269_ clknet_leaf_16_clk _0227_ net120 vssd1 vssd1 vccd1 vccd1 MATMULT_INST.matmult_inst.mem_inst.matrixA1\[4\]
+ sky130_fd_sc_hd__dfrtp_1
XANTENNA__2474__X _0988_ vssd1 vssd1 vccd1 vccd1 sky130_fd_sc_hd__diode_2
XTAP_TAPCELL_ROW_56_648 vssd1 vccd1 sky130_fd_sc_hd__tapvpwrvgnd_1
XPHY_EDGE_ROW_71_Right_71 vssd1 vssd1 vccd1 vccd1 sky130_fd_sc_hd__decap_3
XFILLER_53_152 vccd1 vssd1 vccd1 vssd1 sky130_ef_sc_hd__decap_40_12
XANTENNA_clkbuf_leaf_10_clk_A clknet_2_3__leaf_clk vssd1 vssd1 vccd1 vccd1 sky130_fd_sc_hd__diode_2
XFILLER_5_237 vccd1 vssd1 vccd1 vssd1 sky130_ef_sc_hd__decap_40_12
XFILLER_30_64 vssd1 vssd1 vccd1 vccd1 sky130_fd_sc_hd__fill_2
XANTENNA__2504__B2 net93 vssd1 vssd1 vccd1 vccd1 sky130_fd_sc_hd__diode_2
XANTENNA_clkbuf_leaf_25_clk_A clknet_2_2__leaf_clk vssd1 vssd1 vccd1 vccd1 sky130_fd_sc_hd__diode_2
XANTENNA__1713__B net60 vssd1 vssd1 vccd1 vccd1 sky130_fd_sc_hd__diode_2
XFILLER_49_447 vssd1 vssd1 vccd1 vccd1 sky130_fd_sc_hd__fill_1
XANTENNA__1737__A_N net181 vssd1 vssd1 vccd1 vccd1 sky130_fd_sc_hd__diode_2
XFILLER_36_119 vssd1 vssd1 vccd1 vccd1 sky130_fd_sc_hd__fill_1
XFILLER_44_141 vssd1 vssd1 vccd1 vccd1 sky130_fd_sc_hd__fill_1
XANTENNA__2036__S net55 vssd1 vssd1 vccd1 vccd1 sky130_fd_sc_hd__diode_2
XANTENNA__1875__S net11 vssd1 vssd1 vccd1 vccd1 sky130_fd_sc_hd__diode_2
XFILLER_72_6 vccd1 vssd1 vccd1 vssd1 sky130_ef_sc_hd__decap_40_12
X_2640_ _1090_ _1113_ vssd1 vssd1 vccd1 vccd1 _1114_ sky130_fd_sc_hd__xnor2_1
XTAP_TAPCELL_ROW_10_261 vssd1 vccd1 sky130_fd_sc_hd__tapvpwrvgnd_1
X_2571_ _1022_ net474 _1053_ vssd1 vssd1 vccd1 vccd1 _0366_ sky130_fd_sc_hd__mux2_1
X_3123_ clknet_leaf_9_clk _0081_ net136 vssd1 vssd1 vccd1 vccd1 MATMULT_INST.matmult_inst.mem_inst.matrixA2\[2\]
+ sky130_fd_sc_hd__dfrtp_1
X_3054_ net178 net169 MATMULT_INST.matmult_inst.mem_inst.mem3\[17\] vssd1 vssd1 vccd1
+ vccd1 _1472_ sky130_fd_sc_hd__and3_1
XFILLER_27_119 vssd1 vssd1 vccd1 vccd1 sky130_fd_sc_hd__fill_4
X_2005_ MATMULT_INST.matmult_inst.alu_inst.adder_inst.r3.fa0.b MATMULT_INST.matmult_inst.alu_inst.adder_inst.r3.fa0.a
+ vssd1 vssd1 vccd1 vccd1 _0584_ sky130_fd_sc_hd__nand2_1
XANTENNA_fanout145_A net151 vssd1 vssd1 vccd1 vccd1 sky130_fd_sc_hd__diode_2
X_2907_ net540 net67 _1371_ _1372_ vssd1 vssd1 vccd1 vccd1 _0383_ sky130_fd_sc_hd__a22o_1
XANTENNA__2431__B1 net84 vssd1 vssd1 vccd1 vccd1 sky130_fd_sc_hd__diode_2
XANTENNA__1785__S net31 vssd1 vssd1 vccd1 vccd1 sky130_fd_sc_hd__diode_2
X_2838_ _1276_ _1303_ vssd1 vssd1 vccd1 vccd1 _1307_ sky130_fd_sc_hd__nand2_1
X_2769_ _1166_ _1202_ _1204_ _1238_ vssd1 vssd1 vccd1 vccd1 _1240_ sky130_fd_sc_hd__a211o_1
XTAP_TAPCELL_ROW_69_762 vssd1 vccd1 sky130_fd_sc_hd__tapvpwrvgnd_1
XFILLER_73_225 vssd1 vssd1 vccd1 vccd1 sky130_fd_sc_hd__fill_4
XFILLER_73_214 vssd1 vssd1 vccd1 vccd1 sky130_fd_sc_hd__fill_2
XTAP_TAPCELL_ROW_16_309 vssd1 vccd1 sky130_fd_sc_hd__tapvpwrvgnd_1
XFILLER_41_100 vssd1 vssd1 vccd1 vccd1 sky130_fd_sc_hd__fill_1
XFILLER_14_369 vssd1 vssd1 vccd1 vccd1 sky130_fd_sc_hd__fill_8
XTAP_TAPCELL_ROW_24_375 vssd1 vccd1 sky130_fd_sc_hd__tapvpwrvgnd_1
XANTENNA_fanout13_X net13 vssd1 vssd1 vccd1 vccd1 sky130_fd_sc_hd__diode_2
XFILLER_1_273 vssd1 vssd1 vccd1 vccd1 sky130_fd_sc_hd__fill_4
XFILLER_45_461 vssd1 vssd1 vccd1 vccd1 sky130_fd_sc_hd__fill_1
XFILLER_32_100 vssd1 vssd1 vccd1 vccd1 sky130_fd_sc_hd__fill_1
XFILLER_32_133 vssd1 vssd1 vccd1 vccd1 sky130_fd_sc_hd__fill_1
XFILLER_32_199 vssd1 vssd1 vccd1 vccd1 sky130_fd_sc_hd__fill_1
XFILLER_13_391 vssd1 vssd1 vccd1 vccd1 sky130_fd_sc_hd__fill_1
XFILLER_9_373 vccd1 vssd1 vccd1 vssd1 sky130_ef_sc_hd__decap_40_12
X_2623_ net210 net191 net209 net193 vssd1 vssd1 vccd1 vccd1 _1098_ sky130_fd_sc_hd__a22o_1
X_2554_ _1049_ _1051_ vssd1 vssd1 vccd1 vccd1 _0351_ sky130_fd_sc_hd__and2_1
X_2485_ net155 _0995_ _0997_ net160 vssd1 vssd1 vccd1 vccd1 _0998_ sky130_fd_sc_hd__a22o_1
XANTENNA__2168__C net238 vssd1 vssd1 vccd1 vccd1 sky130_fd_sc_hd__diode_2
X_3106_ clknet_leaf_14_clk _0064_ net144 vssd1 vssd1 vccd1 vccd1 MATMULT_INST.matmult_inst.mem_inst.matrixA0\[3\]
+ sky130_fd_sc_hd__dfrtp_1
XTAP_TAPCELL_ROW_66_732 vssd1 vccd1 sky130_fd_sc_hd__tapvpwrvgnd_1
X_3037_ MATMULT_INST.matmult_inst.mem_inst.matrixA2\[15\] net87 net79 MATMULT_INST.matmult_inst.mem_inst.matrixA1\[15\]
+ vssd1 vssd1 vccd1 vccd1 _1457_ sky130_fd_sc_hd__a22o_1
XANTENNA__2615__D net206 vssd1 vssd1 vccd1 vccd1 sky130_fd_sc_hd__diode_2
XFILLER_11_317 vccd1 vssd1 vccd1 vssd1 sky130_ef_sc_hd__decap_40_12
XANTENNA__2955__A1 net156 vssd1 vssd1 vccd1 vccd1 sky130_fd_sc_hd__diode_2
XANTENNA__2955__B2 net161 vssd1 vssd1 vccd1 vccd1 sky130_fd_sc_hd__diode_2
XFILLER_11_55 vssd1 vssd1 vccd1 vccd1 sky130_fd_sc_hd__fill_1
XFILLER_2_6 vccd1 vssd1 vccd1 vssd1 sky130_ef_sc_hd__decap_40_12
XFILLER_78_317 vssd1 vssd1 vccd1 vccd1 sky130_fd_sc_hd__fill_1
XPHY_EDGE_ROW_21_Left_101 vssd1 vssd1 vccd1 vccd1 sky130_fd_sc_hd__decap_3
XFILLER_46_225 vssd1 vssd1 vccd1 vccd1 sky130_fd_sc_hd__fill_1
XANTENNA__2891__B1 net184 vssd1 vssd1 vccd1 vccd1 sky130_fd_sc_hd__diode_2
XFILLER_36_74 vssd1 vssd1 vccd1 vccd1 sky130_fd_sc_hd__fill_2
XPHY_EDGE_ROW_30_Left_110 vssd1 vssd1 vccd1 vccd1 sky130_fd_sc_hd__decap_3
XFILLER_42_475 vssd1 vssd1 vccd1 vccd1 sky130_fd_sc_hd__fill_1
XFILLER_52_51 vssd1 vssd1 vccd1 vccd1 sky130_fd_sc_hd__fill_1
XFILLER_10_361 vssd1 vssd1 vccd1 vccd1 sky130_fd_sc_hd__fill_2
XFILLER_6_321 vccd1 vssd1 vccd1 vssd1 sky130_ef_sc_hd__decap_40_12
XFILLER_6_365 vccd1 vssd1 vccd1 vssd1 sky130_ef_sc_hd__decap_40_12
X_2270_ _0813_ _0815_ _0816_ vssd1 vssd1 vccd1 vccd1 _0818_ sky130_fd_sc_hd__and3_1
XFILLER_37_225 vssd1 vssd1 vccd1 vccd1 sky130_fd_sc_hd__fill_4
XFILLER_60_261 vssd1 vssd1 vccd1 vccd1 sky130_fd_sc_hd__fill_2
XFILLER_20_136 vssd1 vssd1 vccd1 vccd1 sky130_fd_sc_hd__fill_1
X_1985_ net514 _0567_ net73 vssd1 vssd1 vccd1 vccd1 _0266_ sky130_fd_sc_hd__mux2_1
XFILLER_9_181 vccd1 vssd1 vccd1 vssd1 sky130_ef_sc_hd__decap_40_12
X_2606_ net196 net207 net209 net194 vssd1 vssd1 vccd1 vccd1 _1082_ sky130_fd_sc_hd__a22o_1
X_2537_ MATMULT_INST.matmult_inst.spi_inst.current_state _1502_ _0469_ _1037_ vssd1
+ vssd1 vccd1 vccd1 _1038_ sky130_fd_sc_hd__a31o_1
X_2468_ net158 _0979_ _0981_ net166 vssd1 vssd1 vccd1 vccd1 _0982_ sky130_fd_sc_hd__a22o_1
X_2399_ net642 net62 net41 MATMULT_INST.matmult_inst.fsm_inst.alu_result\[15\] vssd1
+ vssd1 vccd1 vccd1 _0324_ sky130_fd_sc_hd__a22o_1
XFILLER_11_125 vccd1 vssd1 vccd1 vssd1 sky130_ef_sc_hd__decap_40_12
XFILLER_11_169 vccd1 vssd1 vccd1 vssd1 sky130_ef_sc_hd__decap_40_12
XFILLER_22_54 vssd1 vssd1 vccd1 vccd1 sky130_fd_sc_hd__fill_8
XFILLER_3_335 vssd1 vssd1 vccd1 vccd1 sky130_fd_sc_hd__fill_1
XFILLER_0_3 vccd1 vssd1 vccd1 vssd1 sky130_ef_sc_hd__decap_40_12
XFILLER_78_103 vssd1 vssd1 vccd1 vccd1 sky130_fd_sc_hd__fill_1
XANTENNA_fanout80_X net80 vssd1 vssd1 vccd1 vccd1 sky130_fd_sc_hd__diode_2
XTAP_TAPCELL_ROW_77_827 vssd1 vccd1 sky130_fd_sc_hd__tapvpwrvgnd_1
Xfanout182 net183 vssd1 vssd1 vccd1 vccd1 net182 sky130_fd_sc_hd__buf_2
Xfanout160 net161 vssd1 vssd1 vccd1 vccd1 net160 sky130_fd_sc_hd__clkbuf_4
Xfanout171 MATMULT_INST.matmult_inst.addr\[1\] vssd1 vssd1 vccd1 vccd1 net171 sky130_fd_sc_hd__clkbuf_2
Xfanout193 MATMULT_INST.matmult_inst.alu_inst.a1_reg\[2\] vssd1 vssd1 vccd1 vccd1
+ net193 sky130_fd_sc_hd__clkbuf_2
XFILLER_19_225 vssd1 vssd1 vccd1 vccd1 sky130_fd_sc_hd__fill_8
X_3508__281 vssd1 vssd1 vccd1 vccd1 net281 _3508__281/LO sky130_fd_sc_hd__conb_1
XANTENNA__2817__B net201 vssd1 vssd1 vccd1 vccd1 sky130_fd_sc_hd__diode_2
XFILLER_34_206 vssd1 vssd1 vccd1 vccd1 sky130_fd_sc_hd__fill_2
XANTENNA__2616__B1 net206 vssd1 vssd1 vccd1 vccd1 sky130_fd_sc_hd__diode_2
X_1770_ net397 net50 net18 vssd1 vssd1 vccd1 vccd1 _0107_ sky130_fd_sc_hd__mux2_1
XANTENNA__3437__Q MATMULT_INST.matmult_inst.fsm_inst.sel\[0\] vssd1 vssd1 vccd1 vccd1
+ sky130_fd_sc_hd__diode_2
XANTENNA__1883__S net10 vssd1 vssd1 vccd1 vccd1 sky130_fd_sc_hd__diode_2
X_3440_ _0022_ _0387_ net140 vssd1 vssd1 vccd1 vccd1 MATMULT_INST.matmult_inst.spi_inst.rx_bit_count\[0\]
+ sky130_fd_sc_hd__dfrtp_1
XFILLER_6_195 vssd1 vssd1 vccd1 vccd1 sky130_fd_sc_hd__fill_1
X_3371_ clknet_leaf_25_clk net638 net101 vssd1 vssd1 vccd1 vccd1 MATMULT_INST.matmult_inst.fsm_inst.alu_result\[17\]
+ sky130_fd_sc_hd__dfrtp_1
XFILLER_69_125 vssd1 vssd1 vccd1 vccd1 sky130_fd_sc_hd__fill_1
X_2322_ _0867_ vssd1 vssd1 vccd1 vccd1 _0868_ sky130_fd_sc_hd__inv_2
XFILLER_33_3 vssd1 vssd1 vccd1 vccd1 sky130_fd_sc_hd__fill_2
XFILLER_69_169 vccd1 vssd1 vccd1 vssd1 sky130_ef_sc_hd__decap_40_12
X_2253_ _0795_ _0800_ vssd1 vssd1 vccd1 vccd1 _0801_ sky130_fd_sc_hd__xnor2_1
X_2184_ _0731_ _0732_ _0679_ vssd1 vssd1 vccd1 vccd1 _0734_ sky130_fd_sc_hd__a21o_1
XTAP_TAPCELL_ROW_48_584 vssd1 vccd1 sky130_fd_sc_hd__tapvpwrvgnd_1
X_1968_ _0533_ _0538_ _0541_ _0544_ _0539_ vssd1 vssd1 vccd1 vccd1 _0553_ sky130_fd_sc_hd__o311a_1
XANTENNA__1793__S net30 vssd1 vssd1 vccd1 vccd1 sky130_fd_sc_hd__diode_2
X_1899_ net577 net34 net27 vssd1 vssd1 vccd1 vccd1 _0228_ sky130_fd_sc_hd__mux2_1
XFILLER_0_305 vssd1 vssd1 vccd1 vccd1 sky130_fd_sc_hd__fill_2
XFILLER_0_349 vccd1 vssd1 vccd1 vssd1 sky130_ef_sc_hd__decap_40_12
XFILLER_75_106 vssd1 vssd1 vccd1 vccd1 sky130_fd_sc_hd__fill_2
XFILLER_68_191 vssd1 vssd1 vccd1 vccd1 sky130_fd_sc_hd__fill_1
XFILLER_17_43 vssd1 vssd1 vccd1 vccd1 sky130_fd_sc_hd__fill_1
XTAP_TAPCELL_ROW_3_198 vssd1 vccd1 sky130_fd_sc_hd__tapvpwrvgnd_1
XPHY_EDGE_ROW_9_Left_89 vssd1 vssd1 vccd1 vccd1 sky130_fd_sc_hd__decap_3
XFILLER_12_401 vccd1 vssd1 vccd1 vssd1 sky130_ef_sc_hd__decap_40_12
XFILLER_12_445 vssd1 vssd1 vccd1 vccd1 sky130_fd_sc_hd__fill_2
XFILLER_12_467 vssd1 vssd1 vccd1 vccd1 sky130_fd_sc_hd__fill_4
XANTENNA__3023__B1 net77 vssd1 vssd1 vccd1 vccd1 sky130_fd_sc_hd__diode_2
XANTENNA__2129__A2 net230 vssd1 vssd1 vccd1 vccd1 sky130_fd_sc_hd__diode_2
XFILLER_79_412 vssd1 vssd1 vccd1 vccd1 sky130_fd_sc_hd__fill_4
XFILLER_3_165 vssd1 vssd1 vccd1 vccd1 sky130_fd_sc_hd__fill_2
XFILLER_58_83 vssd1 vssd1 vccd1 vccd1 sky130_fd_sc_hd__fill_1
Xhold5 MATMULT_INST.matmult_inst.spi_inst.mosi_data_sync\[4\] vssd1 vssd1 vccd1 vccd1
+ net318 sky130_fd_sc_hd__dlygate4sd3_1
XANTENNA__2039__S net55 vssd1 vssd1 vccd1 vccd1 sky130_fd_sc_hd__diode_2
XFILLER_74_161 vssd1 vssd1 vccd1 vccd1 sky130_fd_sc_hd__fill_8
XFILLER_74_93 vssd1 vssd1 vccd1 vccd1 sky130_fd_sc_hd__fill_2
XFILLER_74_82 vssd1 vssd1 vccd1 vccd1 sky130_fd_sc_hd__fill_2
XTAP_TAPCELL_ROW_45_554 vssd1 vccd1 sky130_fd_sc_hd__tapvpwrvgnd_1
XANTENNA__1878__S net11 vssd1 vssd1 vccd1 vccd1 sky130_fd_sc_hd__diode_2
XFILLER_15_250 vssd1 vssd1 vccd1 vccd1 sky130_fd_sc_hd__fill_4
XFILLER_22_209 vccd1 vssd1 vccd1 vssd1 sky130_ef_sc_hd__decap_40_12
X_2940_ MATMULT_INST.matmult_inst.fsm_inst.rx_data\[1\] net320 MATMULT_INST.matmult_inst.spi_inst.rx_done_sys
+ vssd1 vssd1 vccd1 vccd1 _0427_ sky130_fd_sc_hd__mux2_1
X_2871_ _1311_ _1315_ _1318_ vssd1 vssd1 vccd1 vccd1 _1338_ sky130_fd_sc_hd__or3_1
X_1822_ net381 net35 net15 vssd1 vssd1 vccd1 vccd1 _0155_ sky130_fd_sc_hd__mux2_1
XANTENNA__3494__CLK net246 vssd1 vssd1 vccd1 vccd1 sky130_fd_sc_hd__diode_2
XANTENNA__3014__B1 net77 vssd1 vssd1 vccd1 vccd1 sky130_fd_sc_hd__diode_2
X_1753_ net635 net46 net20 vssd1 vssd1 vccd1 vccd1 _0093_ sky130_fd_sc_hd__mux2_1
XFILLER_7_493 vssd1 vssd1 vccd1 vccd1 sky130_fd_sc_hd__fill_1
X_1684_ net432 net37 net25 vssd1 vssd1 vccd1 vccd1 _0045_ sky130_fd_sc_hd__mux2_1
X_3423_ clknet_leaf_2_clk _0375_ vssd1 vssd1 vccd1 vccd1 MATMULT_INST.matmult_inst.alu_inst.adder_inst.r1.fa1.b
+ sky130_fd_sc_hd__dfxtp_1
X_3354_ clknet_leaf_7_clk net646 net110 vssd1 vssd1 vccd1 vccd1 MATMULT_INST.matmult_inst.fsm_inst.alu_result\[0\]
+ sky130_fd_sc_hd__dfrtp_1
X_2305_ _0819_ _0849_ vssd1 vssd1 vccd1 vccd1 _0852_ sky130_fd_sc_hd__xnor2_1
X_3285_ clknet_leaf_0_clk _0243_ net94 vssd1 vssd1 vccd1 vccd1 MATMULT_INST.matmult_inst.alu_inst.b0_reg\[1\]
+ sky130_fd_sc_hd__dfrtp_1
X_2236_ _0778_ _0783_ vssd1 vssd1 vccd1 vccd1 _0784_ sky130_fd_sc_hd__or2_1
X_2167_ net239 net214 net238 net217 vssd1 vssd1 vccd1 vccd1 _0717_ sky130_fd_sc_hd__a22o_1
XFILLER_53_323 vssd1 vssd1 vccd1 vccd1 sky130_fd_sc_hd__fill_1
XFILLER_54_19 vssd1 vssd1 vccd1 vccd1 sky130_fd_sc_hd__fill_2
XFILLER_65_161 vssd1 vssd1 vccd1 vccd1 sky130_fd_sc_hd__fill_2
XTAP_TAPCELL_ROW_0_168 vssd1 vccd1 sky130_fd_sc_hd__tapvpwrvgnd_1
X_2098_ _0631_ _0650_ vssd1 vssd1 vccd1 vccd1 _0651_ sky130_fd_sc_hd__xnor2_1
XANTENNA__1788__S net30 vssd1 vssd1 vccd1 vccd1 sky130_fd_sc_hd__diode_2
XFILLER_21_231 vssd1 vssd1 vccd1 vccd1 sky130_fd_sc_hd__fill_1
XANTENNA_fanout228_X net228 vssd1 vssd1 vccd1 vccd1 sky130_fd_sc_hd__diode_2
XFILLER_79_27 vssd1 vssd1 vccd1 vccd1 sky130_fd_sc_hd__fill_1
XFILLER_0_113 vssd1 vssd1 vccd1 vccd1 sky130_fd_sc_hd__fill_2
XFILLER_76_448 vccd1 vssd1 vccd1 vssd1 sky130_ef_sc_hd__decap_40_12
XFILLER_48_139 vssd1 vssd1 vccd1 vccd1 sky130_fd_sc_hd__fill_1
XANTENNA__2819__B1 net204 vssd1 vssd1 vccd1 vccd1 sky130_fd_sc_hd__diode_2
Xteam_02_287 vssd1 vssd1 vccd1 vccd1 gpio_oeb[7] team_02_287/LO sky130_fd_sc_hd__conb_1
Xteam_02_265 vssd1 vssd1 vccd1 vccd1 team_02_265/HI gpio_out[18] sky130_fd_sc_hd__conb_1
Xteam_02_254 vssd1 vssd1 vccd1 vccd1 team_02_254/HI gpio_out[7] sky130_fd_sc_hd__conb_1
Xteam_02_276 vssd1 vssd1 vccd1 vccd1 team_02_276/HI gpio_out[29] sky130_fd_sc_hd__conb_1
XFILLER_28_64 vssd1 vssd1 vccd1 vccd1 sky130_fd_sc_hd__fill_1
Xteam_02_298 vssd1 vssd1 vccd1 vccd1 gpio_oeb[18] team_02_298/LO sky130_fd_sc_hd__conb_1
XFILLER_56_183 vssd1 vssd1 vccd1 vccd1 sky130_fd_sc_hd__fill_1
XANTENNA__1698__S net24 vssd1 vssd1 vccd1 vccd1 sky130_fd_sc_hd__diode_2
XFILLER_56_194 vssd1 vssd1 vccd1 vccd1 sky130_fd_sc_hd__fill_2
XFILLER_12_253 vccd1 vssd1 vccd1 vssd1 sky130_ef_sc_hd__decap_40_12
XFILLER_5_57 vccd1 vssd1 vccd1 vssd1 sky130_ef_sc_hd__decap_40_12
XFILLER_79_253 vccd1 vssd1 vccd1 vssd1 sky130_ef_sc_hd__decap_40_12
XANTENNA__2522__A2 net65 vssd1 vssd1 vccd1 vccd1 sky130_fd_sc_hd__diode_2
X_3070_ net245 vssd1 vssd1 vccd1 vccd1 _0028_ sky130_fd_sc_hd__inv_2
X_2021_ net352 _0597_ net73 vssd1 vssd1 vccd1 vccd1 _0272_ sky130_fd_sc_hd__mux2_1
XFILLER_54_109 vssd1 vssd1 vccd1 vccd1 sky130_fd_sc_hd__fill_1
XANTENNA__2564__Y _1053_ vssd1 vssd1 vccd1 vccd1 sky130_fd_sc_hd__diode_2
XPHY_EDGE_ROW_59_Left_139 vssd1 vssd1 vccd1 vccd1 sky130_fd_sc_hd__decap_3
XANTENNA__2589__A2 net210 vssd1 vssd1 vccd1 vccd1 sky130_fd_sc_hd__diode_2
X_2923_ net366 net37 net9 vssd1 vssd1 vccd1 vccd1 _0410_ sky130_fd_sc_hd__mux2_1
X_2854_ _1320_ _1321_ vssd1 vssd1 vccd1 vccd1 _1322_ sky130_fd_sc_hd__or2_1
XTAP_TAPCELL_ROW_13_281 vssd1 vccd1 sky130_fd_sc_hd__tapvpwrvgnd_1
X_2785_ net188 net204 net206 net186 vssd1 vssd1 vccd1 vccd1 _1255_ sky130_fd_sc_hd__a22o_1
X_1805_ net401 net33 net17 vssd1 vssd1 vccd1 vccd1 _0139_ sky130_fd_sc_hd__mux2_1
X_1736_ net177 net167 vssd1 vssd1 vccd1 vccd1 _0506_ sky130_fd_sc_hd__and2b_1
Xhold202 _0317_ vssd1 vssd1 vccd1 vccd1 net515 sky130_fd_sc_hd__dlygate4sd3_1
XPHY_EDGE_ROW_68_Left_148 vssd1 vssd1 vccd1 vccd1 sky130_fd_sc_hd__decap_3
Xhold224 MATMULT_INST.matmult_inst.mem_inst.mem1\[13\] vssd1 vssd1 vccd1 vccd1 net537
+ sky130_fd_sc_hd__dlygate4sd3_1
Xhold235 MATMULT_INST.matmult_inst.mem_inst.matrixA0\[13\] vssd1 vssd1 vccd1 vccd1
+ net548 sky130_fd_sc_hd__dlygate4sd3_1
Xhold213 MATMULT_INST.matmult_inst.mem_inst.matrixB2\[1\] vssd1 vssd1 vccd1 vccd1
+ net526 sky130_fd_sc_hd__dlygate4sd3_1
Xhold246 MATMULT_INST.matmult_inst.alu_inst.col1\[1\] vssd1 vssd1 vccd1 vccd1 net559
+ sky130_fd_sc_hd__dlygate4sd3_1
Xhold268 MATMULT_INST.matmult_inst.mem_inst.mem1\[12\] vssd1 vssd1 vccd1 vccd1 net581
+ sky130_fd_sc_hd__dlygate4sd3_1
X_1667_ MATMULT_INST.matmult_inst.spi_inst.tx_reg_sys\[16\] MATMULT_INST.matmult_inst.spi_inst.miso_shifter\[15\]
+ net153 vssd1 vssd1 vccd1 vccd1 _0005_ sky130_fd_sc_hd__mux2_1
Xhold257 MATMULT_INST.matmult_inst.mem_inst.mem1\[8\] vssd1 vssd1 vccd1 vccd1 net570
+ sky130_fd_sc_hd__dlygate4sd3_1
X_3406_ clknet_leaf_10_clk _0004_ net137 vssd1 vssd1 vccd1 vccd1 MATMULT_INST.matmult_inst.fsm_inst.rx_ready_edge
+ sky130_fd_sc_hd__dfrtp_1
Xhold279 MATMULT_INST.matmult_inst.alu_inst.col0\[4\] vssd1 vssd1 vccd1 vccd1 net592
+ sky130_fd_sc_hd__dlygate4sd3_1
X_1598_ MATMULT_INST.matmult_inst.fsm_inst.state\[0\] MATMULT_INST.matmult_inst.fsm_inst.state\[1\]
+ vssd1 vssd1 vccd1 vccd1 _1516_ sky130_fd_sc_hd__nor2_1
XTAP_TAPCELL_ROW_5_216 vssd1 vccd1 sky130_fd_sc_hd__tapvpwrvgnd_1
X_3337_ clknet_leaf_1_clk _0292_ vssd1 vssd1 vccd1 vccd1 MATMULT_INST.matmult_inst.alu_inst.adder_inst.r0.fa0.a
+ sky130_fd_sc_hd__dfxtp_1
X_3268_ clknet_leaf_14_clk _0226_ net144 vssd1 vssd1 vccd1 vccd1 MATMULT_INST.matmult_inst.mem_inst.matrixA1\[3\]
+ sky130_fd_sc_hd__dfrtp_1
X_3199_ clknet_leaf_12_clk _0157_ net149 vssd1 vssd1 vccd1 vccd1 MATMULT_INST.matmult_inst.mem_inst.matrixA3\[6\]
+ sky130_fd_sc_hd__dfrtp_1
X_2219_ _0766_ _0767_ vssd1 vssd1 vccd1 vccd1 _0768_ sky130_fd_sc_hd__nand2_1
XANTENNA_fanout178_X net178 vssd1 vssd1 vccd1 vccd1 sky130_fd_sc_hd__diode_2
XANTENNA__3360__Q MATMULT_INST.matmult_inst.fsm_inst.alu_result\[6\] vssd1 vssd1 vccd1
+ vccd1 sky130_fd_sc_hd__diode_2
XPHY_EDGE_ROW_77_Left_157 vssd1 vssd1 vccd1 vccd1 sky130_fd_sc_hd__decap_3
XTAP_TAPCELL_ROW_56_649 vssd1 vccd1 sky130_fd_sc_hd__tapvpwrvgnd_1
XFILLER_53_164 vssd1 vssd1 vccd1 vccd1 sky130_fd_sc_hd__fill_4
XFILLER_53_197 vssd1 vssd1 vccd1 vccd1 sky130_fd_sc_hd__fill_2
XANTENNA__2201__A1 net241 vssd1 vssd1 vccd1 vccd1 sky130_fd_sc_hd__diode_2
XFILLER_5_205 vccd1 vssd1 vccd1 vssd1 sky130_ef_sc_hd__decap_40_12
XFILLER_5_249 vccd1 vssd1 vccd1 vssd1 sky130_ef_sc_hd__decap_40_12
XANTENNA__2504__A2 net65 vssd1 vssd1 vccd1 vccd1 sky130_fd_sc_hd__diode_2
XFILLER_17_312 vssd1 vssd1 vccd1 vccd1 sky130_fd_sc_hd__fill_1
XFILLER_55_62 vssd1 vssd1 vccd1 vccd1 sky130_fd_sc_hd__fill_4
XFILLER_71_94 vssd1 vssd1 vccd1 vccd1 sky130_fd_sc_hd__fill_1
X_2570_ _1011_ net490 _1053_ vssd1 vssd1 vccd1 vccd1 _0365_ sky130_fd_sc_hd__mux2_1
XANTENNA__1891__S net10 vssd1 vssd1 vccd1 vccd1 sky130_fd_sc_hd__diode_2
XANTENNA__2987__S net57 vssd1 vssd1 vccd1 vccd1 sky130_fd_sc_hd__diode_2
X_3122_ clknet_leaf_16_clk _0080_ net133 vssd1 vssd1 vccd1 vccd1 MATMULT_INST.matmult_inst.mem_inst.matrixA2\[1\]
+ sky130_fd_sc_hd__dfrtp_1
X_3053_ net660 _1471_ net57 vssd1 vssd1 vccd1 vccd1 _0450_ sky130_fd_sc_hd__mux2_1
X_2004_ MATMULT_INST.matmult_inst.alu_inst.adder_inst.r3.fa0.b MATMULT_INST.matmult_inst.alu_inst.adder_inst.r3.fa0.a
+ vssd1 vssd1 vccd1 vccd1 _0583_ sky130_fd_sc_hd__or2_1
XFILLER_35_153 vssd1 vssd1 vccd1 vccd1 sky130_fd_sc_hd__fill_1
XTAP_TAPCELL_ROW_53_619 vssd1 vccd1 sky130_fd_sc_hd__tapvpwrvgnd_1
X_2906_ _1366_ _1370_ net67 vssd1 vssd1 vccd1 vccd1 _1372_ sky130_fd_sc_hd__a21oi_1
X_2837_ _1279_ _1305_ vssd1 vssd1 vccd1 vccd1 _1306_ sky130_fd_sc_hd__nand2_1
X_2768_ _1235_ _1236_ _1237_ vssd1 vssd1 vccd1 vccd1 _1239_ sky130_fd_sc_hd__a21o_1
X_2699_ _1146_ _1168_ _1169_ vssd1 vssd1 vccd1 vccd1 _1171_ sky130_fd_sc_hd__nand3_1
X_1719_ net406 net38 net23 vssd1 vssd1 vccd1 vccd1 _0062_ sky130_fd_sc_hd__mux2_1
XANTENNA__2498__A1 net166 vssd1 vssd1 vccd1 vccd1 sky130_fd_sc_hd__diode_2
XFILLER_73_248 vccd1 vssd1 vccd1 vssd1 sky130_ef_sc_hd__decap_40_12
XFILLER_14_304 vssd1 vssd1 vccd1 vccd1 sky130_fd_sc_hd__fill_1
XFILLER_14_326 vssd1 vssd1 vccd1 vccd1 sky130_fd_sc_hd__fill_1
XFILLER_26_197 vssd1 vssd1 vccd1 vccd1 sky130_fd_sc_hd__fill_1
XFILLER_14_359 vssd1 vssd1 vccd1 vccd1 sky130_fd_sc_hd__fill_2
XFILLER_25_65 vssd1 vssd1 vccd1 vccd1 sky130_fd_sc_hd__fill_4
XTAP_TAPCELL_ROW_24_376 vssd1 vccd1 sky130_fd_sc_hd__tapvpwrvgnd_1
XFILLER_41_167 vssd1 vssd1 vccd1 vccd1 sky130_fd_sc_hd__fill_1
XANTENNA__2973__A2 net89 vssd1 vssd1 vccd1 vccd1 sky130_fd_sc_hd__diode_2
XFILLER_41_31 vssd1 vssd1 vccd1 vccd1 sky130_fd_sc_hd__fill_2
XFILLER_41_53 vssd1 vssd1 vccd1 vccd1 sky130_fd_sc_hd__fill_2
XFILLER_41_75 vssd1 vssd1 vccd1 vccd1 sky130_fd_sc_hd__fill_2
XFILLER_49_234 vssd1 vssd1 vccd1 vccd1 sky130_fd_sc_hd__fill_1
XFILLER_17_120 vssd1 vssd1 vccd1 vccd1 sky130_fd_sc_hd__fill_4
XFILLER_17_164 vssd1 vssd1 vccd1 vccd1 sky130_fd_sc_hd__fill_4
XFILLER_72_270 vssd1 vssd1 vccd1 vccd1 sky130_fd_sc_hd__fill_2
XANTENNA__2047__S net55 vssd1 vssd1 vccd1 vccd1 sky130_fd_sc_hd__diode_2
XANTENNA__1886__S net10 vssd1 vssd1 vccd1 vccd1 sky130_fd_sc_hd__diode_2
XFILLER_9_385 vssd1 vssd1 vccd1 vccd1 sky130_fd_sc_hd__fill_4
XANTENNA__2964__A2 net64 vssd1 vssd1 vccd1 vccd1 sky130_fd_sc_hd__diode_2
XFILLER_63_3 vssd1 vssd1 vccd1 vccd1 sky130_fd_sc_hd__fill_8
X_2622_ net210 net193 net191 net208 vssd1 vssd1 vccd1 vccd1 _1097_ sky130_fd_sc_hd__and4_1
X_2553_ _1043_ _1045_ _1050_ _1039_ vssd1 vssd1 vccd1 vccd1 _1051_ sky130_fd_sc_hd__a31o_1
X_2484_ MATMULT_INST.matmult_inst.mem_inst.matrixB2\[4\] net89 net81 MATMULT_INST.matmult_inst.mem_inst.matrixB1\[4\]
+ _0996_ vssd1 vssd1 vccd1 vccd1 _0997_ sky130_fd_sc_hd__a221o_1
X_3105_ clknet_leaf_9_clk _0063_ net138 vssd1 vssd1 vccd1 vccd1 MATMULT_INST.matmult_inst.mem_inst.matrixA0\[2\]
+ sky130_fd_sc_hd__dfrtp_1
X_3036_ MATMULT_INST.matmult_inst.mem_inst.mem2\[15\] net87 net79 MATMULT_INST.matmult_inst.mem_inst.mem1\[15\]
+ _1455_ vssd1 vssd1 vccd1 vccd1 _1456_ sky130_fd_sc_hd__a221o_1
XTAP_TAPCELL_ROW_66_733 vssd1 vccd1 sky130_fd_sc_hd__tapvpwrvgnd_1
XFILLER_70_229 vssd1 vssd1 vccd1 vccd1 sky130_fd_sc_hd__fill_1
XFILLER_23_145 vccd1 vssd1 vccd1 vssd1 sky130_ef_sc_hd__decap_40_12
XANTENNA__1796__S net30 vssd1 vssd1 vccd1 vccd1 sky130_fd_sc_hd__diode_2
XFILLER_11_329 vssd1 vssd1 vccd1 vccd1 sky130_fd_sc_hd__fill_4
XANTENNA_clkbuf_leaf_24_clk_A clknet_2_2__leaf_clk vssd1 vssd1 vccd1 vccd1 sky130_fd_sc_hd__diode_2
XANTENNA__2481__A net180 vssd1 vssd1 vccd1 vccd1 sky130_fd_sc_hd__diode_2
XANTENNA_fanout210_X net210 vssd1 vssd1 vccd1 vccd1 sky130_fd_sc_hd__diode_2
XANTENNA__1915__A0 net240 vssd1 vssd1 vccd1 vccd1 sky130_fd_sc_hd__diode_2
XANTENNA_fanout70_A net71 vssd1 vssd1 vccd1 vccd1 sky130_fd_sc_hd__diode_2
XANTENNA__2891__A1 net198 vssd1 vssd1 vccd1 vccd1 sky130_fd_sc_hd__diode_2
XANTENNA__2891__B2 net201 vssd1 vssd1 vccd1 vccd1 sky130_fd_sc_hd__diode_2
XTAP_TAPCELL_ROW_37_490 vssd1 vccd1 sky130_fd_sc_hd__tapvpwrvgnd_1
XFILLER_52_41 vssd1 vssd1 vccd1 vccd1 sky130_fd_sc_hd__fill_1
XFILLER_6_333 vccd1 vssd1 vccd1 vssd1 sky130_ef_sc_hd__decap_40_12
XFILLER_6_377 vccd1 vssd1 vccd1 vssd1 sky130_ef_sc_hd__decap_40_12
XANTENNA__1685__A2 net59 vssd1 vssd1 vccd1 vccd1 sky130_fd_sc_hd__diode_2
XFILLER_37_259 vssd1 vssd1 vccd1 vccd1 sky130_fd_sc_hd__fill_1
XFILLER_20_104 vssd1 vssd1 vccd1 vccd1 sky130_fd_sc_hd__fill_1
XFILLER_60_251 vssd1 vssd1 vccd1 vccd1 sky130_fd_sc_hd__fill_1
X_1984_ _0564_ _0566_ vssd1 vssd1 vccd1 vccd1 _0567_ sky130_fd_sc_hd__xnor2_1
XFILLER_9_193 vccd1 vssd1 vccd1 vssd1 sky130_ef_sc_hd__decap_40_12
X_2605_ net196 net194 net207 net209 vssd1 vssd1 vccd1 vccd1 _1081_ sky130_fd_sc_hd__nand4_1
X_2536_ MATMULT_INST.matmult_inst.fsm_inst.tx_start_send _0928_ _1501_ _0925_ vssd1
+ vssd1 vccd1 vccd1 _1037_ sky130_fd_sc_hd__a2bb2o_1
XANTENNA__2570__A0 _1011_ vssd1 vssd1 vccd1 vccd1 sky130_fd_sc_hd__diode_2
X_2467_ MATMULT_INST.matmult_inst.mem_inst.matrixA2\[3\] net90 net83 MATMULT_INST.matmult_inst.mem_inst.matrixA1\[3\]
+ _0980_ vssd1 vssd1 vccd1 vccd1 _0981_ sky130_fd_sc_hd__a221o_1
X_2398_ net352 net62 net41 MATMULT_INST.matmult_inst.fsm_inst.alu_result\[14\] vssd1
+ vssd1 vccd1 vccd1 _0323_ sky130_fd_sc_hd__a22o_1
XANTENNA__2476__A net181 vssd1 vssd1 vccd1 vccd1 sky130_fd_sc_hd__diode_2
X_3019_ MATMULT_INST.matmult_inst.mem_inst.matrixA0\[13\] net64 _1439_ _1440_ vssd1
+ vssd1 vccd1 vccd1 _1441_ sky130_fd_sc_hd__a211o_1
XFILLER_36_270 vssd1 vssd1 vccd1 vccd1 sky130_fd_sc_hd__fill_1
XANTENNA_fanout160_X net160 vssd1 vssd1 vccd1 vccd1 sky130_fd_sc_hd__diode_2
XTAP_TAPCELL_ROW_34_460 vssd1 vccd1 sky130_fd_sc_hd__tapvpwrvgnd_1
XFILLER_11_137 vccd1 vssd1 vccd1 vssd1 sky130_ef_sc_hd__decap_40_12
XANTENNA__3050__A1 net92 vssd1 vssd1 vccd1 vccd1 sky130_fd_sc_hd__diode_2
XANTENNA__3050__B2 net155 vssd1 vssd1 vccd1 vccd1 sky130_fd_sc_hd__diode_2
Xfanout150 net151 vssd1 vssd1 vccd1 vccd1 net150 sky130_fd_sc_hd__clkbuf_2
XTAP_TAPCELL_ROW_77_828 vssd1 vccd1 sky130_fd_sc_hd__tapvpwrvgnd_1
Xfanout183 MATMULT_INST.matmult_inst.addr\[0\] vssd1 vssd1 vccd1 vccd1 net183 sky130_fd_sc_hd__buf_2
Xfanout172 net175 vssd1 vssd1 vccd1 vccd1 net172 sky130_fd_sc_hd__buf_2
Xfanout161 net164 vssd1 vssd1 vccd1 vccd1 net161 sky130_fd_sc_hd__clkbuf_4
Xfanout194 MATMULT_INST.matmult_inst.alu_inst.a1_reg\[1\] vssd1 vssd1 vccd1 vccd1
+ net194 sky130_fd_sc_hd__buf_2
XFILLER_63_73 vssd1 vssd1 vccd1 vccd1 sky130_fd_sc_hd__fill_4
XFILLER_6_141 vccd1 vssd1 vccd1 vssd1 sky130_ef_sc_hd__decap_40_12
X_3370_ clknet_leaf_26_clk net580 net99 vssd1 vssd1 vccd1 vccd1 MATMULT_INST.matmult_inst.fsm_inst.alu_result\[16\]
+ sky130_fd_sc_hd__dfrtp_1
X_2321_ _0839_ _0866_ vssd1 vssd1 vccd1 vccd1 _0867_ sky130_fd_sc_hd__or2_1
X_2252_ _0796_ _0799_ vssd1 vssd1 vccd1 vccd1 _0800_ sky130_fd_sc_hd__xnor2_1
XFILLER_26_3 vccd1 vssd1 vccd1 vssd1 sky130_ef_sc_hd__decap_40_12
X_2183_ _0679_ _0731_ _0732_ vssd1 vssd1 vccd1 vccd1 _0733_ sky130_fd_sc_hd__nand3_1
XFILLER_25_229 vssd1 vssd1 vccd1 vccd1 sky130_fd_sc_hd__fill_2
XANTENNA__3032__A1 net156 vssd1 vssd1 vccd1 vccd1 sky130_fd_sc_hd__diode_2
XANTENNA__3032__B2 net161 vssd1 vssd1 vccd1 vccd1 sky130_fd_sc_hd__diode_2
X_1967_ _0550_ _0551_ vssd1 vssd1 vccd1 vccd1 _0552_ sky130_fd_sc_hd__and2b_1
X_1898_ net461 net35 net27 vssd1 vssd1 vccd1 vccd1 _0227_ sky130_fd_sc_hd__mux2_1
X_2519_ MATMULT_INST.matmult_inst.mem_inst.matrixA2\[7\] net90 net83 MATMULT_INST.matmult_inst.mem_inst.matrixA1\[7\]
+ _1028_ vssd1 vssd1 vccd1 vccd1 _1029_ sky130_fd_sc_hd__a221o_1
X_3499_ net243 _0019_ net121 vssd1 vssd1 vccd1 vccd1 MATMULT_INST.matmult_inst.spi_inst.miso_shifter\[7\]
+ sky130_fd_sc_hd__dfrtp_1
XANTENNA__2918__B net67 vssd1 vssd1 vccd1 vccd1 sky130_fd_sc_hd__diode_2
XFILLER_16_229 vssd1 vssd1 vccd1 vccd1 sky130_fd_sc_hd__fill_2
XTAP_TAPCELL_ROW_3_199 vssd1 vccd1 sky130_fd_sc_hd__tapvpwrvgnd_1
XFILLER_71_346 vssd1 vssd1 vccd1 vccd1 sky130_fd_sc_hd__fill_1
XFILLER_24_251 vssd1 vssd1 vccd1 vccd1 sky130_fd_sc_hd__fill_1
XFILLER_12_413 vssd1 vssd1 vccd1 vccd1 sky130_fd_sc_hd__fill_4
XFILLER_8_417 vssd1 vssd1 vccd1 vccd1 sky130_fd_sc_hd__fill_2
XFILLER_3_111 vssd1 vssd1 vccd1 vccd1 sky130_fd_sc_hd__fill_1
XANTENNA__2534__A0 _1033_ vssd1 vssd1 vccd1 vccd1 sky130_fd_sc_hd__diode_2
XFILLER_79_468 vssd1 vssd1 vccd1 vccd1 sky130_fd_sc_hd__fill_4
Xhold6 _0430_ vssd1 vssd1 vccd1 vccd1 net319 sky130_fd_sc_hd__dlygate4sd3_1
XANTENNA__3005__A net176 vssd1 vssd1 vccd1 vccd1 sky130_fd_sc_hd__diode_2
XFILLER_74_184 vccd1 vssd1 vccd1 vssd1 sky130_ef_sc_hd__decap_40_12
XFILLER_74_61 vssd1 vssd1 vccd1 vccd1 sky130_fd_sc_hd__fill_1
XTAP_TAPCELL_ROW_45_555 vssd1 vccd1 sky130_fd_sc_hd__tapvpwrvgnd_1
X_2870_ _1315_ _1318_ _1311_ vssd1 vssd1 vccd1 vccd1 _1337_ sky130_fd_sc_hd__o21ai_2
X_1821_ net346 net36 net15 vssd1 vssd1 vccd1 vccd1 _0154_ sky130_fd_sc_hd__mux2_1
XANTENNA__1894__S net27 vssd1 vssd1 vccd1 vccd1 sky130_fd_sc_hd__diode_2
Xclkbuf_leaf_10_clk clknet_2_3__leaf_clk vssd1 vssd1 vccd1 vccd1 clknet_leaf_10_clk
+ sky130_fd_sc_hd__clkbuf_8
X_1752_ net549 net47 net20 vssd1 vssd1 vccd1 vccd1 _0092_ sky130_fd_sc_hd__mux2_1
XFILLER_7_461 vccd1 vssd1 vccd1 vssd1 sky130_ef_sc_hd__decap_40_12
X_1683_ MATMULT_INST.matmult_inst.fsm_inst.rx_data\[2\] net59 net61 MATMULT_INST.matmult_inst.fsm_inst.alu_result\[2\]
+ vssd1 vssd1 vccd1 vccd1 _0487_ sky130_fd_sc_hd__a22o_1
X_3422_ clknet_leaf_2_clk _0374_ vssd1 vssd1 vccd1 vccd1 MATMULT_INST.matmult_inst.alu_inst.adder_inst.r1.fa0.b
+ sky130_fd_sc_hd__dfxtp_1
X_3353_ clknet_leaf_1_clk _0308_ vssd1 vssd1 vccd1 vccd1 MATMULT_INST.matmult_inst.alu_inst.adder_inst.fa.a
+ sky130_fd_sc_hd__dfxtp_1
X_2304_ _0847_ _0850_ vssd1 vssd1 vccd1 vccd1 _0851_ sky130_fd_sc_hd__nor2_1
X_3284_ clknet_leaf_0_clk _0242_ net94 vssd1 vssd1 vccd1 vccd1 MATMULT_INST.matmult_inst.alu_inst.b0_reg\[0\]
+ sky130_fd_sc_hd__dfrtp_1
X_2235_ _0702_ _0744_ _0746_ _0779_ _0742_ vssd1 vssd1 vccd1 vccd1 _0783_ sky130_fd_sc_hd__o311a_1
X_2166_ net241 net213 vssd1 vssd1 vccd1 vccd1 _0716_ sky130_fd_sc_hd__nand2_1
XANTENNA__2176__D net230 vssd1 vssd1 vccd1 vccd1 sky130_fd_sc_hd__diode_2
XFILLER_65_173 vssd1 vssd1 vccd1 vccd1 sky130_fd_sc_hd__fill_1
XTAP_TAPCELL_ROW_0_169 vssd1 vccd1 sky130_fd_sc_hd__tapvpwrvgnd_1
X_2097_ _0648_ _0649_ vssd1 vssd1 vccd1 vccd1 _0650_ sky130_fd_sc_hd__and2b_1
XANTENNA_fanout168_A net171 vssd1 vssd1 vccd1 vccd1 sky130_fd_sc_hd__diode_2
XFILLER_21_221 vssd1 vssd1 vccd1 vccd1 sky130_fd_sc_hd__fill_2
XPHY_EDGE_ROW_3_Right_3 vssd1 vssd1 vccd1 vccd1 sky130_fd_sc_hd__decap_3
XFILLER_21_254 vssd1 vssd1 vccd1 vccd1 sky130_fd_sc_hd__fill_1
X_2999_ net155 MATMULT_INST.matmult_inst.mem_inst.mem0\[12\] MATMULT_INST.matmult_inst.mem_inst.matrixB0\[12\]
+ net160 vssd1 vssd1 vccd1 vccd1 _1422_ sky130_fd_sc_hd__a22o_1
XTAP_TAPCELL_ROW_8_236 vssd1 vccd1 sky130_fd_sc_hd__tapvpwrvgnd_1
XFILLER_0_125 vssd1 vssd1 vccd1 vccd1 sky130_fd_sc_hd__fill_4
XFILLER_0_169 vccd1 vssd1 vccd1 vssd1 sky130_ef_sc_hd__decap_40_12
XANTENNA__2819__A1 net187 vssd1 vssd1 vccd1 vccd1 sky130_fd_sc_hd__diode_2
Xteam_02_277 vssd1 vssd1 vccd1 vccd1 team_02_277/HI gpio_out[30] sky130_fd_sc_hd__conb_1
Xteam_02_266 vssd1 vssd1 vccd1 vccd1 team_02_266/HI gpio_out[19] sky130_fd_sc_hd__conb_1
Xteam_02_255 vssd1 vssd1 vccd1 vccd1 team_02_255/HI gpio_out[8] sky130_fd_sc_hd__conb_1
Xteam_02_288 vssd1 vssd1 vccd1 vccd1 gpio_oeb[8] team_02_288/LO sky130_fd_sc_hd__conb_1
Xteam_02_299 vssd1 vssd1 vccd1 vccd1 gpio_oeb[19] team_02_299/LO sky130_fd_sc_hd__conb_1
XFILLER_12_221 vccd1 vssd1 vccd1 vssd1 sky130_ef_sc_hd__decap_40_12
XTAP_TAPCELL_ROW_42_525 vssd1 vccd1 sky130_fd_sc_hd__tapvpwrvgnd_1
XFILLER_44_97 vssd1 vssd1 vccd1 vccd1 sky130_fd_sc_hd__fill_1
XFILLER_12_265 vccd1 vssd1 vccd1 vssd1 sky130_ef_sc_hd__decap_40_12
XFILLER_5_69 vccd1 vssd1 vccd1 vssd1 sky130_ef_sc_hd__decap_40_12
XFILLER_4_475 vssd1 vssd1 vccd1 vccd1 sky130_fd_sc_hd__fill_1
XFILLER_79_265 vccd1 vssd1 vccd1 vssd1 sky130_ef_sc_hd__decap_40_12
X_2020_ _0595_ _0596_ vssd1 vssd1 vccd1 vccd1 _0597_ sky130_fd_sc_hd__xnor2_1
XANTENNA__1889__S net10 vssd1 vssd1 vccd1 vccd1 sky130_fd_sc_hd__diode_2
XFILLER_35_335 vssd1 vssd1 vccd1 vccd1 sky130_fd_sc_hd__fill_1
XFILLER_62_121 vssd1 vssd1 vccd1 vccd1 sky130_fd_sc_hd__fill_1
X_2922_ net539 net38 net8 vssd1 vssd1 vccd1 vccd1 _0409_ sky130_fd_sc_hd__mux2_1
XFILLER_62_176 vssd1 vssd1 vccd1 vccd1 sky130_fd_sc_hd__fill_1
XANTENNA__2994__B1 net79 vssd1 vssd1 vccd1 vccd1 sky130_fd_sc_hd__diode_2
X_2853_ _1284_ _1319_ vssd1 vssd1 vccd1 vccd1 _1321_ sky130_fd_sc_hd__nor2_1
XTAP_TAPCELL_ROW_13_282 vssd1 vccd1 sky130_fd_sc_hd__tapvpwrvgnd_1
X_1804_ net531 net34 net17 vssd1 vssd1 vccd1 vccd1 _0138_ sky130_fd_sc_hd__mux2_1
X_2784_ _1252_ _1253_ vssd1 vssd1 vccd1 vccd1 _1254_ sky130_fd_sc_hd__nor2_1
X_1735_ net578 net43 net22 vssd1 vssd1 vccd1 vccd1 _0078_ sky130_fd_sc_hd__mux2_1
Xhold225 MATMULT_INST.matmult_inst.mem_inst.matrixB2\[4\] vssd1 vssd1 vccd1 vccd1
+ net538 sky130_fd_sc_hd__dlygate4sd3_1
Xhold214 MATMULT_INST.matmult_inst.alu_inst.col0\[0\] vssd1 vssd1 vccd1 vccd1 net527
+ sky130_fd_sc_hd__dlygate4sd3_1
Xhold203 MATMULT_INST.matmult_inst.mem_inst.matrixA0\[4\] vssd1 vssd1 vccd1 vccd1
+ net516 sky130_fd_sc_hd__dlygate4sd3_1
Xhold258 MATMULT_INST.matmult_inst.mem_inst.matrixB2\[13\] vssd1 vssd1 vccd1 vccd1
+ net571 sky130_fd_sc_hd__dlygate4sd3_1
Xhold236 MATMULT_INST.matmult_inst.mem_inst.matrixA2\[13\] vssd1 vssd1 vccd1 vccd1
+ net549 sky130_fd_sc_hd__dlygate4sd3_1
Xhold269 MATMULT_INST.matmult_inst.mem_inst.matrixA1\[16\] vssd1 vssd1 vccd1 vccd1
+ net582 sky130_fd_sc_hd__dlygate4sd3_1
X_1666_ MATMULT_INST.matmult_inst.spi_inst.tx_reg_sys\[15\] MATMULT_INST.matmult_inst.spi_inst.miso_shifter\[14\]
+ net153 vssd1 vssd1 vccd1 vccd1 _0012_ sky130_fd_sc_hd__mux2_1
Xhold247 MATMULT_INST.matmult_inst.mem_inst.matrixB1\[0\] vssd1 vssd1 vccd1 vccd1
+ net560 sky130_fd_sc_hd__dlygate4sd3_1
X_1597_ _1514_ vssd1 vssd1 vccd1 vccd1 _1515_ sky130_fd_sc_hd__inv_2
X_3405_ clknet_leaf_3_clk _0359_ net104 vssd1 vssd1 vccd1 vccd1 MATMULT_INST.matmult_inst.alu_inst.row1\[7\]
+ sky130_fd_sc_hd__dfrtp_1
XTAP_TAPCELL_ROW_5_217 vssd1 vccd1 sky130_fd_sc_hd__tapvpwrvgnd_1
X_3336_ clknet_leaf_7_clk net74 net108 vssd1 vssd1 vccd1 vccd1 MATMULT_INST.matmult_inst.alu_inst.complete
+ sky130_fd_sc_hd__dfrtp_1
X_3267_ clknet_leaf_9_clk _0225_ net136 vssd1 vssd1 vccd1 vccd1 MATMULT_INST.matmult_inst.mem_inst.matrixA1\[2\]
+ sky130_fd_sc_hd__dfrtp_1
X_2218_ _0760_ _0764_ _0765_ vssd1 vssd1 vccd1 vccd1 _0767_ sky130_fd_sc_hd__nand3_1
X_3198_ clknet_leaf_15_clk _0156_ net143 vssd1 vssd1 vccd1 vccd1 MATMULT_INST.matmult_inst.mem_inst.matrixA3\[5\]
+ sky130_fd_sc_hd__dfrtp_1
XANTENNA__1799__S net17 vssd1 vssd1 vccd1 vccd1 sky130_fd_sc_hd__diode_2
X_2149_ _0686_ _0687_ _0699_ vssd1 vssd1 vccd1 vccd1 _0700_ sky130_fd_sc_hd__nand3_1
XANTENNA_fanout240_X net240 vssd1 vssd1 vccd1 vccd1 sky130_fd_sc_hd__diode_2
XPHY_EDGE_ROW_12_Left_92 vssd1 vssd1 vccd1 vccd1 sky130_fd_sc_hd__decap_3
XFILLER_5_217 vssd1 vssd1 vccd1 vccd1 sky130_fd_sc_hd__fill_4
XANTENNA__2201__A2 net213 vssd1 vssd1 vccd1 vccd1 sky130_fd_sc_hd__diode_2
XFILLER_30_66 vssd1 vssd1 vccd1 vccd1 sky130_fd_sc_hd__fill_1
XFILLER_1_445 vssd1 vssd1 vccd1 vccd1 sky130_fd_sc_hd__fill_2
XFILLER_1_489 vssd1 vssd1 vccd1 vccd1 sky130_fd_sc_hd__fill_2
XFILLER_76_246 vssd1 vssd1 vccd1 vccd1 sky130_fd_sc_hd__fill_1
XFILLER_17_335 vssd1 vssd1 vccd1 vccd1 sky130_fd_sc_hd__fill_1
XFILLER_29_184 vssd1 vssd1 vccd1 vccd1 sky130_fd_sc_hd__fill_2
XFILLER_72_441 vssd1 vssd1 vccd1 vccd1 sky130_fd_sc_hd__fill_1
XFILLER_72_485 vssd1 vssd1 vccd1 vccd1 sky130_fd_sc_hd__fill_4
XANTENNA__2440__A2 net91 vssd1 vssd1 vccd1 vccd1 sky130_fd_sc_hd__diode_2
X_3121_ clknet_leaf_9_clk _0079_ net139 vssd1 vssd1 vccd1 vccd1 MATMULT_INST.matmult_inst.mem_inst.matrixA2\[0\]
+ sky130_fd_sc_hd__dfrtp_1
X_3052_ MATMULT_INST.matmult_inst.mem_inst.matrixA0\[16\] net64 _1469_ _1470_ vssd1
+ vssd1 vccd1 vccd1 _1471_ sky130_fd_sc_hd__a211o_1
X_2003_ net573 _0582_ net73 vssd1 vssd1 vccd1 vccd1 _0269_ sky130_fd_sc_hd__mux2_1
XANTENNA__2967__B1 net81 vssd1 vssd1 vccd1 vccd1 sky130_fd_sc_hd__diode_2
X_2905_ _1366_ _1370_ vssd1 vssd1 vccd1 vccd1 _1371_ sky130_fd_sc_hd__or2_1
XFILLER_50_168 vssd1 vssd1 vccd1 vccd1 sky130_fd_sc_hd__fill_1
XANTENNA__2431__A2 net91 vssd1 vssd1 vccd1 vccd1 sky130_fd_sc_hd__diode_2
X_2836_ _1239_ _1240_ _1278_ vssd1 vssd1 vccd1 vccd1 _1305_ sky130_fd_sc_hd__a21o_1
X_2767_ _1235_ _1236_ _1237_ vssd1 vssd1 vccd1 vccd1 _1238_ sky130_fd_sc_hd__and3_1
XANTENNA_fanout200_A net201 vssd1 vssd1 vccd1 vccd1 sky130_fd_sc_hd__diode_2
X_2698_ _1146_ _1168_ _1169_ vssd1 vssd1 vccd1 vccd1 _1170_ sky130_fd_sc_hd__and3_1
XFILLER_2_209 vccd1 vssd1 vccd1 vssd1 sky130_ef_sc_hd__decap_40_12
X_1718_ net562 net39 net23 vssd1 vssd1 vccd1 vccd1 _0061_ sky130_fd_sc_hd__mux2_1
X_1649_ MATMULT_INST.matmult_inst.spi_inst.current_state MATMULT_INST.matmult_inst.spi_inst.cs_sync_prev
+ MATMULT_INST.matmult_inst.spi_inst.cs_sync vssd1 vssd1 vccd1 vccd1 _0477_ sky130_fd_sc_hd__a21bo_1
XANTENNA_input5_A nrst vssd1 vssd1 vccd1 vccd1 sky130_fd_sc_hd__diode_2
XFILLER_76_29 vccd1 vssd1 vccd1 vssd1 sky130_ef_sc_hd__decap_40_12
XFILLER_76_18 vssd1 vssd1 vccd1 vccd1 sky130_fd_sc_hd__fill_8
X_3319_ clknet_leaf_6_clk _0277_ net106 vssd1 vssd1 vccd1 vccd1 MATMULT_INST.matmult_inst.alu_inst.b1_reg\[1\]
+ sky130_fd_sc_hd__dfrtp_1
XFILLER_73_216 vssd1 vssd1 vccd1 vccd1 sky130_fd_sc_hd__fill_1
XFILLER_39_493 vssd1 vssd1 vccd1 vccd1 sky130_fd_sc_hd__fill_1
XFILLER_25_33 vssd1 vssd1 vccd1 vccd1 sky130_fd_sc_hd__fill_2
XFILLER_25_77 vssd1 vssd1 vccd1 vccd1 sky130_fd_sc_hd__fill_1
XTAP_TAPCELL_ROW_24_377 vssd1 vccd1 sky130_fd_sc_hd__tapvpwrvgnd_1
XFILLER_2_26 vssd1 vssd1 vccd1 vccd1 sky130_fd_sc_hd__fill_2
XFILLER_64_205 vssd1 vssd1 vccd1 vccd1 sky130_fd_sc_hd__fill_1
XFILLER_66_51 vssd1 vssd1 vccd1 vccd1 sky130_fd_sc_hd__fill_2
XANTENNA__3013__A net176 vssd1 vssd1 vccd1 vccd1 sky130_fd_sc_hd__diode_2
XTAP_TAPCELL_ROW_15_300 vssd1 vccd1 sky130_fd_sc_hd__tapvpwrvgnd_1
XFILLER_72_293 vssd1 vssd1 vccd1 vccd1 sky130_fd_sc_hd__fill_4
XFILLER_13_393 vccd1 vssd1 vccd1 vssd1 sky130_ef_sc_hd__decap_40_12
XANTENNA__2998__S net57 vssd1 vssd1 vccd1 vccd1 sky130_fd_sc_hd__diode_2
X_2621_ net212 net189 vssd1 vssd1 vccd1 vccd1 _1096_ sky130_fd_sc_hd__and2_1
X_2552_ MATMULT_INST.matmult_inst.fsm_inst.count\[2\] MATMULT_INST.matmult_inst.fsm_inst.count\[3\]
+ _0458_ vssd1 vssd1 vccd1 vccd1 _1050_ sky130_fd_sc_hd__nand3_1
XFILLER_56_3 vssd1 vssd1 vccd1 vccd1 sky130_fd_sc_hd__fill_4
X_2483_ net177 net168 MATMULT_INST.matmult_inst.mem_inst.matrixB3\[4\] vssd1 vssd1
+ vccd1 vccd1 _0996_ sky130_fd_sc_hd__and3_1
X_3104_ clknet_leaf_8_clk _0062_ net133 vssd1 vssd1 vccd1 vccd1 MATMULT_INST.matmult_inst.mem_inst.matrixA0\[1\]
+ sky130_fd_sc_hd__dfrtp_1
X_3035_ net178 net169 MATMULT_INST.matmult_inst.mem_inst.mem3\[15\] vssd1 vssd1 vccd1
+ vccd1 _1455_ sky130_fd_sc_hd__and3_1
XFILLER_55_249 vssd1 vssd1 vccd1 vccd1 sky130_fd_sc_hd__fill_1
XTAP_TAPCELL_ROW_66_734 vssd1 vccd1 sky130_fd_sc_hd__tapvpwrvgnd_1
XANTENNA_fanout150_A net151 vssd1 vssd1 vccd1 vccd1 sky130_fd_sc_hd__diode_2
XFILLER_23_135 vssd1 vssd1 vccd1 vccd1 sky130_fd_sc_hd__fill_2
XFILLER_23_157 vssd1 vssd1 vccd1 vccd1 sky130_fd_sc_hd__fill_1
XANTENNA__2481__B net171 vssd1 vssd1 vccd1 vccd1 sky130_fd_sc_hd__diode_2
XTAP_TAPCELL_ROW_21_347 vssd1 vccd1 sky130_fd_sc_hd__tapvpwrvgnd_1
X_2819_ net187 net203 net204 net185 vssd1 vssd1 vccd1 vccd1 _1288_ sky130_fd_sc_hd__a22o_1
XFILLER_11_57 vccd1 vssd1 vccd1 vssd1 sky130_ef_sc_hd__decap_40_12
XANTENNA_fanout203_X net203 vssd1 vssd1 vccd1 vccd1 sky130_fd_sc_hd__diode_2
XANTENNA__1679__B1 net61 vssd1 vssd1 vccd1 vccd1 sky130_fd_sc_hd__diode_2
XANTENNA__2643__A2 MATMULT_INST.matmult_inst.alu_inst.a1_reg\[4\] vssd1 vssd1 vccd1
+ vccd1 sky130_fd_sc_hd__diode_2
XFILLER_61_219 vssd1 vssd1 vccd1 vccd1 sky130_fd_sc_hd__fill_4
XFILLER_36_98 vssd1 vssd1 vccd1 vccd1 sky130_fd_sc_hd__fill_1
XFILLER_14_157 vccd1 vssd1 vccd1 vssd1 sky130_ef_sc_hd__decap_40_12
XFILLER_6_301 vssd1 vssd1 vccd1 vccd1 sky130_fd_sc_hd__fill_4
XFILLER_10_363 vssd1 vssd1 vccd1 vccd1 sky130_fd_sc_hd__fill_1
XFILLER_6_345 vccd1 vssd1 vccd1 vssd1 sky130_ef_sc_hd__decap_40_12
XFILLER_6_389 vccd1 vssd1 vccd1 vssd1 sky130_ef_sc_hd__decap_40_12
XFILLER_77_72 vssd1 vssd1 vccd1 vccd1 sky130_fd_sc_hd__fill_4
XFILLER_37_238 vssd1 vssd1 vccd1 vccd1 sky130_fd_sc_hd__fill_1
XTAP_TAPCELL_ROW_63_704 vssd1 vccd1 sky130_fd_sc_hd__tapvpwrvgnd_1
XANTENNA__1897__S net27 vssd1 vssd1 vccd1 vccd1 sky130_fd_sc_hd__diode_2
X_1983_ _0557_ _0565_ vssd1 vssd1 vccd1 vccd1 _0566_ sky130_fd_sc_hd__nor2_1
XFILLER_9_161 vssd1 vssd1 vccd1 vccd1 sky130_fd_sc_hd__fill_4
X_2604_ net196 net195 net207 net209 vssd1 vssd1 vccd1 vccd1 _1080_ sky130_fd_sc_hd__and4_1
X_2535_ MATMULT_INST.matmult_inst.fsm_inst.load_delay _1502_ _1503_ vssd1 vssd1 vccd1
+ vccd1 _1036_ sky130_fd_sc_hd__and3b_1
X_2466_ net182 net173 MATMULT_INST.matmult_inst.mem_inst.matrixA3\[3\] vssd1 vssd1
+ vccd1 vccd1 _0980_ sky130_fd_sc_hd__and3_1
X_2397_ net417 net62 net41 MATMULT_INST.matmult_inst.fsm_inst.alu_result\[13\] vssd1
+ vssd1 vccd1 vccd1 _0322_ sky130_fd_sc_hd__a22o_1
XANTENNA__2476__B net172 vssd1 vssd1 vccd1 vccd1 sky130_fd_sc_hd__diode_2
X_3018_ net165 _1434_ _1438_ net164 vssd1 vssd1 vccd1 vccd1 _1440_ sky130_fd_sc_hd__a22o_1
XFILLER_11_105 vssd1 vssd1 vccd1 vccd1 sky130_fd_sc_hd__fill_4
XTAP_TAPCELL_ROW_34_461 vssd1 vccd1 sky130_fd_sc_hd__tapvpwrvgnd_1
XFILLER_11_149 vccd1 vssd1 vccd1 vssd1 sky130_ef_sc_hd__decap_40_12
XFILLER_7_109 vssd1 vssd1 vccd1 vccd1 sky130_fd_sc_hd__fill_2
XFILLER_22_45 vssd1 vssd1 vccd1 vccd1 sky130_fd_sc_hd__fill_2
XANTENNA__1836__A net157 vssd1 vssd1 vccd1 vccd1 sky130_fd_sc_hd__diode_2
XFILLER_3_337 vccd1 vssd1 vccd1 vssd1 sky130_ef_sc_hd__decap_40_12
XANTENNA__2561__A1 _1011_ vssd1 vssd1 vccd1 vccd1 sky130_fd_sc_hd__diode_2
Xfanout140 net141 vssd1 vssd1 vccd1 vccd1 net140 sky130_fd_sc_hd__buf_2
XANTENNA__3289__RESET_B net96 vssd1 vssd1 vccd1 vccd1 sky130_fd_sc_hd__diode_2
Xfanout151 net152 vssd1 vssd1 vccd1 vccd1 net151 sky130_fd_sc_hd__clkbuf_2
XTAP_TAPCELL_ROW_77_829 vssd1 vccd1 sky130_fd_sc_hd__tapvpwrvgnd_1
XANTENNA__2313__B2 net213 vssd1 vssd1 vccd1 vccd1 sky130_fd_sc_hd__diode_2
Xfanout173 net175 vssd1 vssd1 vccd1 vccd1 net173 sky130_fd_sc_hd__clkbuf_2
Xfanout162 net164 vssd1 vssd1 vccd1 vccd1 net162 sky130_fd_sc_hd__clkbuf_4
Xfanout195 MATMULT_INST.matmult_inst.alu_inst.a1_reg\[1\] vssd1 vssd1 vccd1 vccd1
+ net195 sky130_fd_sc_hd__clkbuf_2
XANTENNA_fanout66_X net66 vssd1 vssd1 vccd1 vccd1 sky130_fd_sc_hd__diode_2
Xfanout184 MATMULT_INST.matmult_inst.alu_inst.a1_reg\[7\] vssd1 vssd1 vccd1 vccd1
+ net184 sky130_fd_sc_hd__buf_2
XFILLER_74_377 vccd1 vssd1 vccd1 vssd1 sky130_ef_sc_hd__decap_40_12
XANTENNA__2616__A2 net204 vssd1 vssd1 vccd1 vccd1 sky130_fd_sc_hd__diode_2
XFILLER_63_63 vssd1 vssd1 vccd1 vccd1 sky130_fd_sc_hd__fill_4
XANTENNA__3041__A2 net64 vssd1 vssd1 vccd1 vccd1 sky130_fd_sc_hd__diode_2
XFILLER_10_193 vssd1 vssd1 vccd1 vccd1 sky130_fd_sc_hd__fill_2
XFILLER_6_153 vccd1 vssd1 vccd1 vssd1 sky130_ef_sc_hd__decap_40_12
XFILLER_6_197 vccd1 vssd1 vccd1 vssd1 sky130_ef_sc_hd__decap_40_12
X_2320_ _0864_ _0865_ vssd1 vssd1 vccd1 vccd1 _0866_ sky130_fd_sc_hd__xnor2_1
XPHY_EDGE_ROW_0_Left_80 vssd1 vssd1 vccd1 vccd1 sky130_fd_sc_hd__decap_3
X_2251_ _0797_ _0798_ vssd1 vssd1 vccd1 vccd1 _0799_ sky130_fd_sc_hd__nand2_1
XFILLER_33_5 vssd1 vssd1 vccd1 vccd1 sky130_fd_sc_hd__fill_1
XANTENNA_clkbuf_leaf_23_clk_A clknet_2_2__leaf_clk vssd1 vssd1 vccd1 vccd1 sky130_fd_sc_hd__diode_2
X_2182_ _0697_ _0729_ _0730_ vssd1 vssd1 vccd1 vccd1 _0732_ sky130_fd_sc_hd__nand3_1
XFILLER_19_3 vssd1 vssd1 vccd1 vccd1 sky130_fd_sc_hd__fill_8
X_1966_ MATMULT_INST.matmult_inst.alu_inst.adder_inst.r1.fa2.a MATMULT_INST.matmult_inst.alu_inst.adder_inst.r1.fa2.b
+ vssd1 vssd1 vccd1 vccd1 _0551_ sky130_fd_sc_hd__nand2_1
X_1897_ net451 net36 net27 vssd1 vssd1 vccd1 vccd1 _0226_ sky130_fd_sc_hd__mux2_1
XANTENNA_fanout113_A net114 vssd1 vssd1 vccd1 vccd1 sky130_fd_sc_hd__diode_2
XFILLER_0_307 vssd1 vssd1 vccd1 vccd1 sky130_fd_sc_hd__fill_1
X_2518_ net182 net173 MATMULT_INST.matmult_inst.mem_inst.matrixA3\[7\] vssd1 vssd1
+ vccd1 vccd1 _1028_ sky130_fd_sc_hd__and3_1
X_3498_ net243 _0018_ net135 vssd1 vssd1 vccd1 vccd1 MATMULT_INST.matmult_inst.spi_inst.miso_shifter\[6\]
+ sky130_fd_sc_hd__dfrtp_1
XANTENNA__3382__RESET_B net114 vssd1 vssd1 vccd1 vccd1 sky130_fd_sc_hd__diode_2
X_2449_ _0957_ _0959_ _0964_ vssd1 vssd1 vccd1 vccd1 _0965_ sky130_fd_sc_hd__or3_1
XANTENNA__2059__B1 net241 vssd1 vssd1 vccd1 vccd1 sky130_fd_sc_hd__diode_2
XFILLER_17_67 vccd1 vssd1 vccd1 vssd1 sky130_ef_sc_hd__decap_40_12
XFILLER_33_77 vssd1 vssd1 vccd1 vccd1 sky130_fd_sc_hd__fill_2
XFILLER_3_167 vssd1 vssd1 vccd1 vccd1 sky130_fd_sc_hd__fill_1
XFILLER_79_447 vssd1 vssd1 vccd1 vccd1 sky130_fd_sc_hd__fill_1
Xhold7 MATMULT_INST.matmult_inst.spi_inst.mosi_data_sync\[1\] vssd1 vssd1 vccd1 vccd1
+ net320 sky130_fd_sc_hd__dlygate4sd3_1
XFILLER_58_85 vssd1 vssd1 vccd1 vccd1 sky130_fd_sc_hd__fill_1
XANTENNA__3005__B net167 vssd1 vssd1 vccd1 vccd1 sky130_fd_sc_hd__diode_2
XFILLER_74_152 vssd1 vssd1 vccd1 vccd1 sky130_fd_sc_hd__fill_4
XFILLER_74_95 vssd1 vssd1 vccd1 vccd1 sky130_fd_sc_hd__fill_1
XFILLER_15_241 vssd1 vssd1 vccd1 vccd1 sky130_fd_sc_hd__fill_1
XTAP_TAPCELL_ROW_45_556 vssd1 vccd1 sky130_fd_sc_hd__tapvpwrvgnd_1
XFILLER_15_263 vssd1 vssd1 vccd1 vccd1 sky130_fd_sc_hd__fill_8
XANTENNA__2470__B1 net83 vssd1 vssd1 vccd1 vccd1 sky130_fd_sc_hd__diode_2
X_1820_ net373 net37 net15 vssd1 vssd1 vccd1 vccd1 _0153_ sky130_fd_sc_hd__mux2_1
X_1751_ net584 net48 net20 vssd1 vssd1 vccd1 vccd1 _0091_ sky130_fd_sc_hd__mux2_1
XFILLER_7_473 vccd1 vssd1 vccd1 vssd1 sky130_ef_sc_hd__decap_40_12
X_1682_ net475 net38 net25 vssd1 vssd1 vccd1 vccd1 _0044_ sky130_fd_sc_hd__mux2_1
XANTENNA__2773__B2 net71 vssd1 vssd1 vccd1 vccd1 sky130_fd_sc_hd__diode_2
X_3421_ clknet_leaf_2_clk _0373_ vssd1 vssd1 vccd1 vccd1 MATMULT_INST.matmult_inst.alu_inst.adder_inst.r0.fa3.b
+ sky130_fd_sc_hd__dfxtp_1
X_3352_ clknet_leaf_29_clk _0307_ vssd1 vssd1 vccd1 vccd1 MATMULT_INST.matmult_inst.alu_inst.adder_inst.r3.fa3.a
+ sky130_fd_sc_hd__dfxtp_1
X_2303_ _0778_ _0783_ _0818_ _0848_ _0817_ vssd1 vssd1 vccd1 vccd1 _0850_ sky130_fd_sc_hd__o311a_1
X_3283_ clknet_leaf_6_clk _0241_ vssd1 vssd1 vccd1 vccd1 MATMULT_INST.matmult_inst.fsm_inst.tx_start_send
+ sky130_fd_sc_hd__dfxtp_1
X_2234_ net658 _0782_ net70 vssd1 vssd1 vccd1 vccd1 _0300_ sky130_fd_sc_hd__mux2_1
X_2165_ _0713_ _0714_ vssd1 vssd1 vccd1 vccd1 _0715_ sky130_fd_sc_hd__nand2b_1
X_2096_ _0645_ _0646_ _0647_ vssd1 vssd1 vccd1 vccd1 _0649_ sky130_fd_sc_hd__a21o_1
X_2998_ net441 _1421_ net57 vssd1 vssd1 vccd1 vccd1 _0445_ sky130_fd_sc_hd__mux2_1
X_1949_ _0535_ _0536_ vssd1 vssd1 vccd1 vccd1 _0537_ sky130_fd_sc_hd__xnor2_1
XFILLER_79_29 vssd1 vssd1 vccd1 vccd1 sky130_fd_sc_hd__fill_2
XTAP_TAPCELL_ROW_8_237 vssd1 vccd1 sky130_fd_sc_hd__tapvpwrvgnd_1
XFILLER_69_480 vssd1 vssd1 vccd1 vccd1 sky130_fd_sc_hd__fill_1
XANTENNA__2819__A2 net203 vssd1 vssd1 vccd1 vccd1 sky130_fd_sc_hd__diode_2
Xteam_02_267 vssd1 vssd1 vccd1 vccd1 team_02_267/HI gpio_out[20] sky130_fd_sc_hd__conb_1
Xteam_02_256 vssd1 vssd1 vccd1 vccd1 team_02_256/HI gpio_out[9] sky130_fd_sc_hd__conb_1
Xteam_02_278 vssd1 vssd1 vccd1 vccd1 team_02_278/HI gpio_out[31] sky130_fd_sc_hd__conb_1
XFILLER_28_44 vssd1 vssd1 vccd1 vccd1 sky130_fd_sc_hd__fill_8
Xteam_02_289 vssd1 vssd1 vccd1 vccd1 gpio_oeb[9] team_02_289/LO sky130_fd_sc_hd__conb_1
XFILLER_29_399 vssd1 vssd1 vccd1 vccd1 sky130_fd_sc_hd__fill_1
XTAP_TAPCELL_ROW_42_526 vssd1 vccd1 sky130_fd_sc_hd__tapvpwrvgnd_1
XANTENNA_fanout29_X net29 vssd1 vssd1 vccd1 vccd1 sky130_fd_sc_hd__diode_2
XFILLER_12_233 vccd1 vssd1 vccd1 vssd1 sky130_ef_sc_hd__decap_40_12
XFILLER_12_277 vccd1 vssd1 vccd1 vssd1 sky130_ef_sc_hd__decap_40_12
XFILLER_60_31 vssd1 vssd1 vccd1 vccd1 sky130_fd_sc_hd__fill_4
XFILLER_60_42 vccd1 vssd1 vccd1 vssd1 sky130_ef_sc_hd__decap_40_12
XFILLER_5_15 vccd1 vssd1 vccd1 vssd1 sky130_ef_sc_hd__decap_40_12
XFILLER_4_421 vccd1 vssd1 vccd1 vssd1 sky130_ef_sc_hd__decap_40_12
XFILLER_79_277 vssd1 vssd1 vccd1 vccd1 sky130_fd_sc_hd__fill_2
XPHY_EDGE_ROW_13_Right_13 vssd1 vssd1 vccd1 vccd1 sky130_fd_sc_hd__decap_3
XFILLER_35_358 vssd1 vssd1 vccd1 vccd1 sky130_fd_sc_hd__fill_1
XFILLER_62_166 vssd1 vssd1 vccd1 vccd1 sky130_fd_sc_hd__fill_1
X_2921_ net350 net39 net9 vssd1 vssd1 vccd1 vccd1 _0408_ sky130_fd_sc_hd__mux2_1
X_2852_ _1284_ _1319_ vssd1 vssd1 vccd1 vccd1 _1320_ sky130_fd_sc_hd__and2_1
XTAP_TAPCELL_ROW_13_283 vssd1 vccd1 sky130_fd_sc_hd__tapvpwrvgnd_1
XPHY_EDGE_ROW_22_Right_22 vssd1 vssd1 vccd1 vccd1 sky130_fd_sc_hd__decap_3
X_1803_ net499 net35 net17 vssd1 vssd1 vccd1 vccd1 _0137_ sky130_fd_sc_hd__mux2_1
X_2783_ _1220_ _1249_ _1250_ vssd1 vssd1 vccd1 vccd1 _1253_ sky130_fd_sc_hd__and3_1
X_1734_ net550 _0501_ net22 vssd1 vssd1 vccd1 vccd1 _0077_ sky130_fd_sc_hd__mux2_1
Xhold215 MATMULT_INST.matmult_inst.mem_inst.matrixB0\[6\] vssd1 vssd1 vccd1 vccd1
+ net528 sky130_fd_sc_hd__dlygate4sd3_1
XFILLER_7_281 vccd1 vssd1 vccd1 vssd1 sky130_ef_sc_hd__decap_40_12
Xhold226 MATMULT_INST.matmult_inst.mem_inst.matrixB3\[1\] vssd1 vssd1 vccd1 vccd1
+ net539 sky130_fd_sc_hd__dlygate4sd3_1
Xhold204 MATMULT_INST.matmult_inst.mem_inst.mem2\[0\] vssd1 vssd1 vccd1 vccd1 net517
+ sky130_fd_sc_hd__dlygate4sd3_1
Xhold237 MATMULT_INST.matmult_inst.mem_inst.matrixA0\[16\] vssd1 vssd1 vccd1 vccd1
+ net550 sky130_fd_sc_hd__dlygate4sd3_1
X_1665_ MATMULT_INST.matmult_inst.spi_inst.tx_reg_sys\[14\] MATMULT_INST.matmult_inst.spi_inst.miso_shifter\[13\]
+ net153 vssd1 vssd1 vccd1 vccd1 _0011_ sky130_fd_sc_hd__mux2_1
Xhold259 MATMULT_INST.matmult_inst.mem_inst.mem2\[9\] vssd1 vssd1 vccd1 vccd1 net572
+ sky130_fd_sc_hd__dlygate4sd3_1
Xhold248 MATMULT_INST.matmult_inst.mem_inst.matrixA0\[8\] vssd1 vssd1 vccd1 vccd1
+ net561 sky130_fd_sc_hd__dlygate4sd3_1
X_3404_ clknet_leaf_3_clk _0358_ net104 vssd1 vssd1 vccd1 vccd1 MATMULT_INST.matmult_inst.alu_inst.row1\[6\]
+ sky130_fd_sc_hd__dfrtp_1
X_1596_ MATMULT_INST.matmult_inst.fsm_inst.state\[2\] _1482_ _1513_ vssd1 vssd1 vccd1
+ vccd1 _1514_ sky130_fd_sc_hd__and3_1
XTAP_TAPCELL_ROW_5_218 vssd1 vccd1 sky130_fd_sc_hd__tapvpwrvgnd_1
X_3335_ clknet_leaf_3_clk _0291_ net104 vssd1 vssd1 vccd1 vccd1 MATMULT_INST.matmult_inst.alu_inst.a1_reg\[7\]
+ sky130_fd_sc_hd__dfrtp_2
XPHY_EDGE_ROW_31_Right_31 vssd1 vssd1 vccd1 vccd1 sky130_fd_sc_hd__decap_3
X_3266_ clknet_leaf_16_clk _0224_ net133 vssd1 vssd1 vccd1 vccd1 MATMULT_INST.matmult_inst.mem_inst.matrixA1\[1\]
+ sky130_fd_sc_hd__dfrtp_1
X_2217_ _0764_ _0765_ _0760_ vssd1 vssd1 vccd1 vccd1 _0766_ sky130_fd_sc_hd__a21o_1
X_3197_ clknet_leaf_16_clk _0155_ net120 vssd1 vssd1 vccd1 vccd1 MATMULT_INST.matmult_inst.mem_inst.matrixA3\[4\]
+ sky130_fd_sc_hd__dfrtp_1
X_2148_ _0690_ _0698_ vssd1 vssd1 vccd1 vccd1 _0699_ sky130_fd_sc_hd__xnor2_1
X_2079_ net670 net68 _0631_ _0632_ vssd1 vssd1 vccd1 vccd1 _0295_ sky130_fd_sc_hd__a22o_1
XFILLER_53_199 vssd1 vssd1 vccd1 vccd1 sky130_fd_sc_hd__fill_1
XANTENNA__2985__A1 net160 vssd1 vssd1 vccd1 vccd1 sky130_fd_sc_hd__diode_2
XANTENNA__2985__B2 net155 vssd1 vssd1 vccd1 vccd1 sky130_fd_sc_hd__diode_2
XPHY_EDGE_ROW_40_Right_40 vssd1 vssd1 vccd1 vccd1 sky130_fd_sc_hd__decap_3
XANTENNA__2499__X _1011_ vssd1 vssd1 vccd1 vccd1 sky130_fd_sc_hd__diode_2
XANTENNA_fanout93_A _0479_ vssd1 vssd1 vccd1 vccd1 sky130_fd_sc_hd__diode_2
XFILLER_39_54 vssd1 vssd1 vccd1 vccd1 sky130_fd_sc_hd__fill_2
XFILLER_44_122 vssd1 vssd1 vccd1 vccd1 sky130_fd_sc_hd__fill_1
XTAP_TAPCELL_ROW_55_640 vssd1 vccd1 sky130_fd_sc_hd__tapvpwrvgnd_1
XANTENNA__2425__B1 net83 vssd1 vssd1 vccd1 vccd1 sky130_fd_sc_hd__diode_2
XFILLER_71_63 vccd1 vssd1 vccd1 vssd1 sky130_ef_sc_hd__decap_40_12
XTAP_TAPCELL_ROW_10_253 vssd1 vccd1 sky130_fd_sc_hd__tapvpwrvgnd_1
XFILLER_4_251 vssd1 vssd1 vccd1 vccd1 sky130_fd_sc_hd__fill_1
X_3120_ clknet_leaf_19_clk _0078_ net126 vssd1 vssd1 vccd1 vccd1 MATMULT_INST.matmult_inst.mem_inst.matrixA0\[17\]
+ sky130_fd_sc_hd__dfrtp_1
X_3051_ net165 _1464_ _1468_ net160 vssd1 vssd1 vccd1 vccd1 _1470_ sky130_fd_sc_hd__a22o_1
X_2002_ _0580_ _0581_ vssd1 vssd1 vccd1 vccd1 _0582_ sky130_fd_sc_hd__xnor2_1
XFILLER_50_136 vssd1 vssd1 vccd1 vccd1 sky130_fd_sc_hd__fill_2
XFILLER_50_147 vssd1 vssd1 vccd1 vccd1 sky130_fd_sc_hd__fill_1
X_2904_ _1365_ _1367_ vssd1 vssd1 vccd1 vccd1 _1370_ sky130_fd_sc_hd__nand2_1
XANTENNA_clkbuf_0_clk_X clknet_0_clk vssd1 vssd1 vccd1 vccd1 sky130_fd_sc_hd__diode_2
XTAP_TAPCELL_ROW_61_687 vssd1 vccd1 sky130_fd_sc_hd__tapvpwrvgnd_1
X_2835_ _1276_ _1303_ vssd1 vssd1 vccd1 vccd1 _1304_ sky130_fd_sc_hd__nor2_1
X_2766_ _1182_ _1199_ _1181_ vssd1 vssd1 vccd1 vccd1 _1237_ sky130_fd_sc_hd__a21boi_1
X_2697_ net197 net194 net198 MATMULT_INST.matmult_inst.alu_inst.b1_reg\[6\] vssd1
+ vssd1 vccd1 vccd1 _1169_ sky130_fd_sc_hd__nand4_1
X_1717_ _0480_ _0504_ vssd1 vssd1 vccd1 vccd1 _0505_ sky130_fd_sc_hd__nor2_1
X_1648_ MATMULT_INST.matmult_inst.fsm_inst.tx_ready _1502_ _0469_ vssd1 vssd1 vccd1
+ vccd1 MATMULT_INST.matmult_inst.fsm_inst.load sky130_fd_sc_hd__and3_1
X_3318_ clknet_leaf_5_clk _0276_ net106 vssd1 vssd1 vccd1 vccd1 MATMULT_INST.matmult_inst.alu_inst.b1_reg\[0\]
+ sky130_fd_sc_hd__dfrtp_1
X_1579_ _1495_ _1498_ vssd1 vssd1 vccd1 vccd1 _1499_ sky130_fd_sc_hd__nor2_1
XANTENNA__1670__Y _0452_ vssd1 vssd1 vccd1 vccd1 sky130_fd_sc_hd__diode_2
XANTENNA_fanout183_X net183 vssd1 vssd1 vccd1 vccd1 sky130_fd_sc_hd__diode_2
XANTENNA__2495__A net182 vssd1 vssd1 vccd1 vccd1 sky130_fd_sc_hd__diode_2
X_3249_ clknet_leaf_9_clk _0207_ net139 vssd1 vssd1 vccd1 vccd1 MATMULT_INST.matmult_inst.mem_inst.mem0\[2\]
+ sky130_fd_sc_hd__dfrtp_1
XFILLER_73_239 vssd1 vssd1 vccd1 vccd1 sky130_fd_sc_hd__fill_1
XTAP_TAPCELL_ROW_52_610 vssd1 vccd1 sky130_fd_sc_hd__tapvpwrvgnd_1
XTAP_TAPCELL_ROW_24_378 vssd1 vccd1 sky130_fd_sc_hd__tapvpwrvgnd_1
XFILLER_41_169 vssd1 vssd1 vccd1 vccd1 sky130_fd_sc_hd__fill_1
XFILLER_41_33 vssd1 vssd1 vccd1 vccd1 sky130_fd_sc_hd__fill_1
XFILLER_41_55 vssd1 vssd1 vccd1 vccd1 sky130_fd_sc_hd__fill_1
XFILLER_1_221 vssd1 vssd1 vccd1 vccd1 sky130_fd_sc_hd__fill_2
XANTENNA_fanout96_X net96 vssd1 vssd1 vccd1 vccd1 sky130_fd_sc_hd__diode_2
XFILLER_49_203 vssd1 vssd1 vccd1 vccd1 sky130_fd_sc_hd__fill_1
XFILLER_66_96 vssd1 vssd1 vccd1 vccd1 sky130_fd_sc_hd__fill_4
XANTENNA__3013__B net167 vssd1 vssd1 vccd1 vccd1 sky130_fd_sc_hd__diode_2
XFILLER_72_272 vssd1 vssd1 vccd1 vccd1 sky130_fd_sc_hd__fill_1
XFILLER_17_188 vccd1 vssd1 vccd1 vssd1 sky130_ef_sc_hd__decap_40_12
XTAP_TAPCELL_ROW_15_301 vssd1 vccd1 sky130_fd_sc_hd__tapvpwrvgnd_1
XFILLER_13_361 vccd1 vssd1 vccd1 vssd1 sky130_ef_sc_hd__decap_40_12
XFILLER_32_158 vssd1 vssd1 vccd1 vccd1 sky130_fd_sc_hd__fill_1
XFILLER_70_6 vssd1 vssd1 vccd1 vccd1 sky130_fd_sc_hd__fill_4
X_2620_ _1080_ _1092_ _1093_ vssd1 vssd1 vccd1 vccd1 _1095_ sky130_fd_sc_hd__and3_1
X_2551_ MATMULT_INST.matmult_inst.fsm_inst.count\[2\] _0458_ _1040_ MATMULT_INST.matmult_inst.fsm_inst.count\[3\]
+ vssd1 vssd1 vccd1 vccd1 _1049_ sky130_fd_sc_hd__a31o_1
X_2482_ MATMULT_INST.matmult_inst.mem_inst.mem2\[4\] net89 net81 MATMULT_INST.matmult_inst.mem_inst.mem1\[4\]
+ _0994_ vssd1 vssd1 vccd1 vccd1 _0995_ sky130_fd_sc_hd__a221o_1
XFILLER_49_3 vssd1 vssd1 vccd1 vccd1 sky130_fd_sc_hd__fill_2
X_3103_ clknet_leaf_15_clk _0061_ net136 vssd1 vssd1 vccd1 vccd1 MATMULT_INST.matmult_inst.mem_inst.matrixA0\[0\]
+ sky130_fd_sc_hd__dfrtp_1
X_3034_ MATMULT_INST.matmult_inst.mem_inst.matrixB2\[15\] net87 net79 MATMULT_INST.matmult_inst.mem_inst.matrixB1\[15\]
+ _1453_ vssd1 vssd1 vccd1 vccd1 _1454_ sky130_fd_sc_hd__a221o_1
XTAP_TAPCELL_ROW_66_735 vssd1 vccd1 sky130_fd_sc_hd__tapvpwrvgnd_1
XTAP_TAPCELL_ROW_21_348 vssd1 vccd1 sky130_fd_sc_hd__tapvpwrvgnd_1
XFILLER_31_180 vssd1 vssd1 vccd1 vccd1 sky130_fd_sc_hd__fill_4
X_2818_ net184 net208 _1255_ _1258_ vssd1 vssd1 vccd1 vccd1 _1287_ sky130_fd_sc_hd__a31o_1
X_2749_ net200 net192 net190 net202 vssd1 vssd1 vccd1 vccd1 _1220_ sky130_fd_sc_hd__a22o_1
XFILLER_11_69 vccd1 vssd1 vccd1 vssd1 sky130_ef_sc_hd__decap_40_12
XTAP_TAPCELL_ROW_29_415 vssd1 vccd1 sky130_fd_sc_hd__tapvpwrvgnd_1
XFILLER_36_11 vssd1 vssd1 vccd1 vccd1 sky130_fd_sc_hd__fill_1
XANTENNA_fanout56_A _0452_ vssd1 vssd1 vccd1 vccd1 sky130_fd_sc_hd__diode_2
XFILLER_36_33 vssd1 vssd1 vccd1 vccd1 sky130_fd_sc_hd__fill_4
XFILLER_36_66 vssd1 vssd1 vccd1 vccd1 sky130_fd_sc_hd__fill_1
XFILLER_14_169 vccd1 vssd1 vccd1 vssd1 sky130_ef_sc_hd__decap_40_12
XANTENNA_fanout11_X net11 vssd1 vssd1 vccd1 vccd1 sky130_fd_sc_hd__diode_2
XFILLER_6_357 vssd1 vssd1 vccd1 vccd1 sky130_fd_sc_hd__fill_4
XANTENNA__3024__A net176 vssd1 vssd1 vccd1 vccd1 sky130_fd_sc_hd__diode_2
XTAP_TAPCELL_ROW_63_705 vssd1 vccd1 sky130_fd_sc_hd__tapvpwrvgnd_1
XFILLER_60_253 vssd1 vssd1 vccd1 vccd1 sky130_fd_sc_hd__fill_8
X_1982_ _0545_ _0550_ _0553_ _0558_ _0551_ vssd1 vssd1 vccd1 vccd1 _0565_ sky130_fd_sc_hd__o311a_1
X_2603_ _1077_ _1078_ vssd1 vssd1 vccd1 vccd1 _1079_ sky130_fd_sc_hd__or2_1
X_2534_ _1033_ net601 _1035_ vssd1 vssd1 vccd1 vccd1 _0347_ sky130_fd_sc_hd__mux2_1
X_2465_ MATMULT_INST.matmult_inst.mem_inst.mem2\[3\] net90 net83 MATMULT_INST.matmult_inst.mem_inst.mem1\[3\]
+ _0978_ vssd1 vssd1 vccd1 vccd1 _0979_ sky130_fd_sc_hd__a221o_1
X_2396_ MATMULT_INST.matmult_inst.alu_inst.out\[12\] net62 net41 net423 vssd1 vssd1
+ vccd1 vccd1 _0321_ sky130_fd_sc_hd__a22o_1
XFILLER_3_81 vccd1 vssd1 vccd1 vssd1 sky130_ef_sc_hd__decap_40_12
X_3017_ net92 _1432_ _1436_ net159 vssd1 vssd1 vccd1 vccd1 _1439_ sky130_fd_sc_hd__a22o_1
XFILLER_24_423 vssd1 vssd1 vccd1 vccd1 sky130_fd_sc_hd__fill_1
XTAP_TAPCELL_ROW_34_462 vssd1 vccd1 sky130_fd_sc_hd__tapvpwrvgnd_1
XFILLER_3_305 vccd1 vssd1 vccd1 vssd1 sky130_ef_sc_hd__decap_40_12
XFILLER_3_349 vccd1 vssd1 vccd1 vssd1 sky130_ef_sc_hd__decap_40_12
XFILLER_78_128 vssd1 vssd1 vccd1 vccd1 sky130_fd_sc_hd__fill_2
Xfanout130 net132 vssd1 vssd1 vccd1 vccd1 net130 sky130_fd_sc_hd__clkbuf_4
Xfanout152 MATMULT_INST.nrst vssd1 vssd1 vccd1 vccd1 net152 sky130_fd_sc_hd__buf_2
Xfanout141 net142 vssd1 vssd1 vccd1 vccd1 net141 sky130_fd_sc_hd__dlymetal6s2s_1
Xfanout174 net175 vssd1 vssd1 vccd1 vccd1 net174 sky130_fd_sc_hd__buf_1
Xfanout163 net164 vssd1 vssd1 vccd1 vccd1 net163 sky130_fd_sc_hd__buf_2
Xfanout185 net186 vssd1 vssd1 vccd1 vccd1 net185 sky130_fd_sc_hd__clkbuf_2
Xfanout196 net197 vssd1 vssd1 vccd1 vccd1 net196 sky130_fd_sc_hd__clkbuf_2
XANTENNA_fanout59_X net59 vssd1 vssd1 vccd1 vccd1 sky130_fd_sc_hd__diode_2
XFILLER_47_65 vssd1 vssd1 vccd1 vccd1 sky130_fd_sc_hd__fill_1
XFILLER_74_389 vssd1 vssd1 vccd1 vccd1 sky130_fd_sc_hd__fill_4
XFILLER_27_283 vssd1 vssd1 vccd1 vccd1 sky130_fd_sc_hd__fill_1
XPHY_EDGE_ROW_69_Right_69 vssd1 vssd1 vccd1 vccd1 sky130_fd_sc_hd__decap_3
XFILLER_8_15 vccd1 vssd1 vccd1 vssd1 sky130_ef_sc_hd__decap_40_12
XFILLER_6_121 vccd1 vssd1 vccd1 vssd1 sky130_ef_sc_hd__decap_40_12
XFILLER_6_165 vccd1 vssd1 vccd1 vssd1 sky130_ef_sc_hd__decap_40_12
XPHY_EDGE_ROW_78_Right_78 vssd1 vssd1 vccd1 vccd1 sky130_fd_sc_hd__decap_3
X_2250_ net216 net214 net233 net235 vssd1 vssd1 vccd1 vccd1 _0798_ sky130_fd_sc_hd__nand4_1
X_2181_ _0697_ _0730_ _0729_ vssd1 vssd1 vccd1 vccd1 _0731_ sky130_fd_sc_hd__a21o_1
XTAP_TAPCELL_ROW_48_576 vssd1 vccd1 sky130_fd_sc_hd__tapvpwrvgnd_1
XTAP_TAPCELL_ROW_31_432 vssd1 vccd1 sky130_fd_sc_hd__tapvpwrvgnd_1
X_1965_ MATMULT_INST.matmult_inst.alu_inst.adder_inst.r1.fa2.a MATMULT_INST.matmult_inst.alu_inst.adder_inst.r1.fa2.b
+ vssd1 vssd1 vccd1 vccd1 _0550_ sky130_fd_sc_hd__nor2_1
XANTENNA__2532__S _1035_ vssd1 vssd1 vccd1 vccd1 sky130_fd_sc_hd__diode_2
X_1896_ net541 _0487_ net27 vssd1 vssd1 vccd1 vccd1 _0225_ sky130_fd_sc_hd__mux2_1
X_3497_ net243 _0017_ net135 vssd1 vssd1 vccd1 vccd1 MATMULT_INST.matmult_inst.spi_inst.miso_shifter\[5\]
+ sky130_fd_sc_hd__dfrtp_1
X_2517_ MATMULT_INST.matmult_inst.mem_inst.mem2\[7\] net91 net83 MATMULT_INST.matmult_inst.mem_inst.mem1\[7\]
+ _1026_ vssd1 vssd1 vccd1 vccd1 _1027_ sky130_fd_sc_hd__a221o_1
X_2448_ net166 _0961_ _0963_ net162 vssd1 vssd1 vccd1 vccd1 _0964_ sky130_fd_sc_hd__a22o_1
X_2379_ net631 net69 vssd1 vssd1 vccd1 vccd1 _0921_ sky130_fd_sc_hd__nor2_1
XFILLER_17_35 vssd1 vssd1 vccd1 vccd1 sky130_fd_sc_hd__fill_8
XFILLER_16_209 vccd1 vssd1 vccd1 vssd1 sky130_ef_sc_hd__decap_40_12
XANTENNA__2059__A1 net240 vssd1 vssd1 vccd1 vccd1 sky130_fd_sc_hd__diode_2
XFILLER_17_79 vssd1 vssd1 vccd1 vccd1 sky130_fd_sc_hd__fill_4
XFILLER_8_419 vssd1 vssd1 vccd1 vccd1 sky130_fd_sc_hd__fill_1
XFILLER_33_45 vssd1 vssd1 vccd1 vccd1 sky130_fd_sc_hd__fill_2
XFILLER_3_113 vccd1 vssd1 vccd1 vssd1 sky130_ef_sc_hd__decap_40_12
XFILLER_58_20 vssd1 vssd1 vccd1 vccd1 sky130_fd_sc_hd__fill_1
Xhold8 _0427_ vssd1 vssd1 vccd1 vccd1 net321 sky130_fd_sc_hd__dlygate4sd3_1
XFILLER_74_197 vssd1 vssd1 vccd1 vccd1 sky130_fd_sc_hd__fill_2
XFILLER_74_85 vssd1 vssd1 vccd1 vccd1 sky130_fd_sc_hd__fill_8
XTAP_TAPCELL_ROW_2_190 vssd1 vccd1 sky130_fd_sc_hd__tapvpwrvgnd_1
XTAP_TAPCELL_ROW_45_557 vssd1 vccd1 sky130_fd_sc_hd__tapvpwrvgnd_1
X_1750_ net619 _0496_ net20 vssd1 vssd1 vccd1 vccd1 _0090_ sky130_fd_sc_hd__mux2_1
XANTENNA__1757__A net181 vssd1 vssd1 vccd1 vccd1 sky130_fd_sc_hd__diode_2
XFILLER_7_441 vssd1 vssd1 vccd1 vccd1 sky130_fd_sc_hd__fill_4
XFILLER_7_485 vssd1 vssd1 vccd1 vccd1 sky130_fd_sc_hd__fill_8
X_1681_ MATMULT_INST.matmult_inst.fsm_inst.rx_data\[1\] net59 net61 MATMULT_INST.matmult_inst.fsm_inst.alu_result\[1\]
+ vssd1 vssd1 vccd1 vccd1 _0486_ sky130_fd_sc_hd__a22o_1
X_3420_ clknet_leaf_2_clk _0372_ vssd1 vssd1 vccd1 vccd1 MATMULT_INST.matmult_inst.alu_inst.adder_inst.r0.fa2.b
+ sky130_fd_sc_hd__dfxtp_1
X_3351_ clknet_leaf_29_clk _0306_ vssd1 vssd1 vccd1 vccd1 MATMULT_INST.matmult_inst.alu_inst.adder_inst.r3.fa2.a
+ sky130_fd_sc_hd__dfxtp_1
X_2302_ _0847_ _0848_ vssd1 vssd1 vccd1 vccd1 _0849_ sky130_fd_sc_hd__and2b_1
XFILLER_31_3 vssd1 vssd1 vccd1 vccd1 sky130_fd_sc_hd__fill_8
X_3282_ clknet_leaf_20_clk _0240_ net126 vssd1 vssd1 vccd1 vccd1 MATMULT_INST.matmult_inst.mem_inst.matrixA1\[17\]
+ sky130_fd_sc_hd__dfrtp_1
X_2233_ _0780_ _0781_ vssd1 vssd1 vccd1 vccd1 _0782_ sky130_fd_sc_hd__xnor2_1
X_2164_ _0707_ _0711_ _0712_ vssd1 vssd1 vccd1 vccd1 _0714_ sky130_fd_sc_hd__nand3_1
XANTENNA__2527__S _1035_ vssd1 vssd1 vccd1 vccd1 sky130_fd_sc_hd__diode_2
X_2095_ _0645_ _0646_ _0647_ vssd1 vssd1 vccd1 vccd1 _0648_ sky130_fd_sc_hd__and3_1
XFILLER_0_93 vssd1 vssd1 vccd1 vccd1 sky130_fd_sc_hd__fill_1
XANTENNA__2461__A1 net157 vssd1 vssd1 vccd1 vccd1 sky130_fd_sc_hd__diode_2
XFILLER_21_223 vssd1 vssd1 vccd1 vccd1 sky130_fd_sc_hd__fill_1
X_2997_ MATMULT_INST.matmult_inst.mem_inst.matrixA0\[11\] net64 _1419_ _1420_ vssd1
+ vssd1 vccd1 vccd1 _1421_ sky130_fd_sc_hd__a211o_1
X_1948_ _0527_ _0531_ _0528_ vssd1 vssd1 vccd1 vccd1 _0536_ sky130_fd_sc_hd__o21ai_1
X_1879_ net498 net35 net11 vssd1 vssd1 vccd1 vccd1 _0209_ sky130_fd_sc_hd__mux2_1
XANTENNA__1673__Y _0479_ vssd1 vssd1 vccd1 vccd1 sky130_fd_sc_hd__diode_2
XTAP_TAPCELL_ROW_8_238 vssd1 vccd1 sky130_fd_sc_hd__tapvpwrvgnd_1
XFILLER_0_105 vssd1 vssd1 vccd1 vccd1 sky130_fd_sc_hd__fill_2
XFILLER_48_109 vssd1 vssd1 vccd1 vccd1 sky130_fd_sc_hd__fill_1
Xteam_02_268 vssd1 vssd1 vccd1 vccd1 team_02_268/HI gpio_out[21] sky130_fd_sc_hd__conb_1
Xteam_02_257 vssd1 vssd1 vccd1 vccd1 team_02_257/HI gpio_out[10] sky130_fd_sc_hd__conb_1
Xteam_02_279 vssd1 vssd1 vccd1 vccd1 team_02_279/HI gpio_out[32] sky130_fd_sc_hd__conb_1
XFILLER_28_89 vssd1 vssd1 vccd1 vccd1 sky130_fd_sc_hd__fill_1
XFILLER_56_197 vccd1 vssd1 vccd1 vssd1 sky130_ef_sc_hd__decap_40_12
XFILLER_44_44 vssd1 vssd1 vccd1 vccd1 sky130_fd_sc_hd__fill_2
XTAP_TAPCELL_ROW_42_527 vssd1 vccd1 sky130_fd_sc_hd__tapvpwrvgnd_1
XFILLER_12_245 vssd1 vssd1 vccd1 vccd1 sky130_fd_sc_hd__fill_4
XANTENNA_clkbuf_leaf_22_clk_A clknet_2_2__leaf_clk vssd1 vssd1 vccd1 vccd1 sky130_fd_sc_hd__diode_2
XFILLER_12_289 vccd1 vssd1 vccd1 vssd1 sky130_ef_sc_hd__decap_40_12
XFILLER_8_249 vssd1 vssd1 vccd1 vccd1 sky130_fd_sc_hd__fill_2
XTAP_TAPCELL_ROW_50_593 vssd1 vccd1 sky130_fd_sc_hd__tapvpwrvgnd_1
XFILLER_60_54 vccd1 vssd1 vccd1 vssd1 sky130_ef_sc_hd__decap_40_12
XFILLER_5_27 vccd1 vssd1 vccd1 vssd1 sky130_ef_sc_hd__decap_40_12
XFILLER_4_433 vccd1 vssd1 vccd1 vssd1 sky130_ef_sc_hd__decap_40_12
XFILLER_4_477 vccd1 vssd1 vccd1 vssd1 sky130_ef_sc_hd__decap_40_12
XFILLER_79_223 vssd1 vssd1 vccd1 vccd1 sky130_fd_sc_hd__fill_1
XFILLER_69_96 vssd1 vssd1 vccd1 vccd1 sky130_fd_sc_hd__fill_2
Xclkbuf_2_3__f_clk clknet_0_clk vssd1 vssd1 vccd1 vccd1 clknet_2_3__leaf_clk sky130_fd_sc_hd__clkbuf_16
XANTENNA_clkload1_A clknet_2_1__leaf_clk vssd1 vssd1 vccd1 vccd1 sky130_fd_sc_hd__diode_2
XFILLER_62_156 vssd1 vssd1 vccd1 vccd1 sky130_fd_sc_hd__fill_4
X_2920_ _0483_ _0509_ vssd1 vssd1 vccd1 vccd1 _1381_ sky130_fd_sc_hd__nor2_1
XANTENNA__2994__A2 net87 vssd1 vssd1 vccd1 vccd1 sky130_fd_sc_hd__diode_2
XANTENNA__2443__B2 net93 vssd1 vssd1 vccd1 vccd1 sky130_fd_sc_hd__diode_2
XPHY_EDGE_ROW_28_Left_108 vssd1 vssd1 vccd1 vccd1 sky130_fd_sc_hd__decap_3
X_2851_ _1316_ _1317_ vssd1 vssd1 vccd1 vccd1 _1319_ sky130_fd_sc_hd__xnor2_1
XANTENNA__2590__B net210 vssd1 vssd1 vccd1 vccd1 sky130_fd_sc_hd__diode_2
XFILLER_79_3 vccd1 vssd1 vccd1 vssd1 sky130_ef_sc_hd__decap_40_12
XTAP_TAPCELL_ROW_13_284 vssd1 vccd1 sky130_fd_sc_hd__tapvpwrvgnd_1
X_1802_ net606 net36 net17 vssd1 vssd1 vccd1 vccd1 _0136_ sky130_fd_sc_hd__mux2_1
X_2782_ _1251_ vssd1 vssd1 vccd1 vccd1 _1252_ sky130_fd_sc_hd__inv_2
X_1733_ net594 net45 net22 vssd1 vssd1 vccd1 vccd1 _0076_ sky130_fd_sc_hd__mux2_1
XFILLER_7_293 vccd1 vssd1 vccd1 vssd1 sky130_ef_sc_hd__decap_40_12
Xhold205 MATMULT_INST.matmult_inst.alu_inst.row0\[2\] vssd1 vssd1 vccd1 vccd1 net518
+ sky130_fd_sc_hd__dlygate4sd3_1
Xhold216 MATMULT_INST.matmult_inst.mem_inst.matrixB2\[2\] vssd1 vssd1 vccd1 vccd1
+ net529 sky130_fd_sc_hd__dlygate4sd3_1
Xhold238 MATMULT_INST.matmult_inst.mem_inst.matrixB1\[11\] vssd1 vssd1 vccd1 vccd1
+ net551 sky130_fd_sc_hd__dlygate4sd3_1
X_1664_ MATMULT_INST.matmult_inst.spi_inst.tx_reg_sys\[13\] MATMULT_INST.matmult_inst.spi_inst.miso_shifter\[12\]
+ net153 vssd1 vssd1 vccd1 vccd1 _0010_ sky130_fd_sc_hd__mux2_1
Xhold227 MATMULT_INST.matmult_inst.alu_inst.adder_inst.r3.fa1.b vssd1 vssd1 vccd1
+ vccd1 net540 sky130_fd_sc_hd__dlygate4sd3_1
X_3403_ clknet_leaf_3_clk _0357_ net104 vssd1 vssd1 vccd1 vccd1 MATMULT_INST.matmult_inst.alu_inst.row1\[5\]
+ sky130_fd_sc_hd__dfrtp_1
Xhold249 MATMULT_INST.matmult_inst.mem_inst.matrixA0\[0\] vssd1 vssd1 vccd1 vccd1
+ net562 sky130_fd_sc_hd__dlygate4sd3_1
X_1595_ _1506_ _1509_ vssd1 vssd1 vccd1 vccd1 _1513_ sky130_fd_sc_hd__nand2_1
XPHY_EDGE_ROW_37_Left_117 vssd1 vssd1 vccd1 vccd1 sky130_fd_sc_hd__decap_3
X_3334_ clknet_leaf_3_clk _0290_ net104 vssd1 vssd1 vccd1 vccd1 MATMULT_INST.matmult_inst.alu_inst.a1_reg\[6\]
+ sky130_fd_sc_hd__dfrtp_1
X_3265_ clknet_leaf_11_clk _0223_ net139 vssd1 vssd1 vccd1 vccd1 MATMULT_INST.matmult_inst.mem_inst.matrixA1\[0\]
+ sky130_fd_sc_hd__dfrtp_1
X_2216_ _0761_ _0762_ _0763_ vssd1 vssd1 vccd1 vccd1 _0765_ sky130_fd_sc_hd__a21o_1
X_3196_ clknet_leaf_14_clk _0154_ net144 vssd1 vssd1 vccd1 vccd1 MATMULT_INST.matmult_inst.mem_inst.matrixA3\[3\]
+ sky130_fd_sc_hd__dfrtp_1
X_2147_ _0696_ _0697_ vssd1 vssd1 vccd1 vccd1 _0698_ sky130_fd_sc_hd__nand2_1
X_2078_ _0616_ _0619_ _0630_ net71 vssd1 vssd1 vccd1 vccd1 _0632_ sky130_fd_sc_hd__o31a_1
XFILLER_34_370 vssd1 vssd1 vccd1 vccd1 sky130_fd_sc_hd__fill_1
XPHY_EDGE_ROW_46_Left_126 vssd1 vssd1 vccd1 vccd1 sky130_fd_sc_hd__decap_3
XPHY_EDGE_ROW_55_Left_135 vssd1 vssd1 vccd1 vccd1 sky130_fd_sc_hd__decap_3
XFILLER_1_447 vssd1 vssd1 vccd1 vccd1 sky130_fd_sc_hd__fill_1
XANTENNA_fanout86_A net88 vssd1 vssd1 vccd1 vccd1 sky130_fd_sc_hd__diode_2
XFILLER_39_88 vssd1 vssd1 vccd1 vccd1 sky130_fd_sc_hd__fill_8
XANTENNA__2675__B net186 vssd1 vssd1 vccd1 vccd1 sky130_fd_sc_hd__diode_2
XFILLER_55_32 vccd1 vssd1 vccd1 vssd1 sky130_ef_sc_hd__decap_40_12
XTAP_TAPCELL_ROW_55_641 vssd1 vccd1 sky130_fd_sc_hd__tapvpwrvgnd_1
XPHY_EDGE_ROW_64_Left_144 vssd1 vssd1 vccd1 vccd1 sky130_fd_sc_hd__decap_3
XTAP_TAPCELL_ROW_27_398 vssd1 vccd1 sky130_fd_sc_hd__tapvpwrvgnd_1
XFILLER_71_75 vssd1 vssd1 vccd1 vccd1 sky130_fd_sc_hd__fill_2
XTAP_TAPCELL_ROW_10_254 vssd1 vccd1 sky130_fd_sc_hd__tapvpwrvgnd_1
XPHY_EDGE_ROW_73_Left_153 vssd1 vssd1 vccd1 vccd1 sky130_fd_sc_hd__decap_3
X_3050_ net92 _1462_ _1466_ net155 vssd1 vssd1 vccd1 vccd1 _1469_ sky130_fd_sc_hd__a22o_1
XFILLER_67_248 vssd1 vssd1 vccd1 vccd1 sky130_fd_sc_hd__fill_1
X_2001_ _0573_ _0576_ _0574_ vssd1 vssd1 vccd1 vccd1 _0581_ sky130_fd_sc_hd__a21bo_1
XTAP_TAPCELL_ROW_18_321 vssd1 vccd1 sky130_fd_sc_hd__tapvpwrvgnd_1
XFILLER_63_465 vssd1 vssd1 vccd1 vccd1 sky130_fd_sc_hd__fill_1
XANTENNA__2967__A2 net89 vssd1 vssd1 vccd1 vccd1 sky130_fd_sc_hd__diode_2
X_2903_ _1333_ _1349_ _1350_ _1352_ _1368_ vssd1 vssd1 vccd1 vccd1 _1369_ sky130_fd_sc_hd__a311o_1
X_2834_ _1285_ _1302_ vssd1 vssd1 vccd1 vccd1 _1303_ sky130_fd_sc_hd__xor2_1
XTAP_TAPCELL_ROW_61_688 vssd1 vccd1 sky130_fd_sc_hd__tapvpwrvgnd_1
X_2765_ _1216_ _1217_ _1234_ vssd1 vssd1 vccd1 vccd1 _1236_ sky130_fd_sc_hd__nand3_1
X_2696_ net197 net199 net200 net194 vssd1 vssd1 vccd1 vccd1 _1168_ sky130_fd_sc_hd__a22o_1
X_1716_ _0482_ _0503_ vssd1 vssd1 vccd1 vccd1 _0504_ sky130_fd_sc_hd__nand2_1
XFILLER_6_81 vssd1 vssd1 vccd1 vccd1 sky130_fd_sc_hd__fill_2
X_1647_ _0476_ vssd1 vssd1 vccd1 vccd1 _0003_ sky130_fd_sc_hd__inv_2
X_3317_ clknet_leaf_1_clk _0275_ net103 vssd1 vssd1 vccd1 vccd1 MATMULT_INST.matmult_inst.alu_inst.out\[17\]
+ sky130_fd_sc_hd__dfrtp_1
XFILLER_58_204 vssd1 vssd1 vccd1 vccd1 sky130_fd_sc_hd__fill_4
X_1578_ MATMULT_INST.matmult_inst.fsm_inst.state\[4\] _1496_ vssd1 vssd1 vccd1 vccd1
+ _1498_ sky130_fd_sc_hd__nand2_1
XTAP_TAPCELL_ROW_69_755 vssd1 vccd1 sky130_fd_sc_hd__tapvpwrvgnd_1
XFILLER_39_451 vssd1 vssd1 vccd1 vccd1 sky130_fd_sc_hd__fill_1
XANTENNA__2495__B net173 vssd1 vssd1 vccd1 vccd1 sky130_fd_sc_hd__diode_2
X_3248_ clknet_leaf_8_clk _0206_ net109 vssd1 vssd1 vccd1 vccd1 MATMULT_INST.matmult_inst.mem_inst.mem0\[1\]
+ sky130_fd_sc_hd__dfrtp_1
XFILLER_58_259 vssd1 vssd1 vccd1 vccd1 sky130_fd_sc_hd__fill_1
XFILLER_73_229 vssd1 vssd1 vccd1 vccd1 sky130_fd_sc_hd__fill_2
XANTENNA_fanout176_X net176 vssd1 vssd1 vccd1 vccd1 sky130_fd_sc_hd__diode_2
X_3179_ clknet_leaf_16_clk _0137_ net122 vssd1 vssd1 vccd1 vccd1 MATMULT_INST.matmult_inst.mem_inst.mem2\[4\]
+ sky130_fd_sc_hd__dfrtp_1
XFILLER_54_410 vssd1 vssd1 vccd1 vccd1 sky130_fd_sc_hd__fill_1
XFILLER_14_307 vssd1 vssd1 vccd1 vccd1 sky130_fd_sc_hd__fill_1
XFILLER_25_13 vssd1 vssd1 vccd1 vccd1 sky130_fd_sc_hd__fill_2
XTAP_TAPCELL_ROW_52_611 vssd1 vccd1 sky130_fd_sc_hd__tapvpwrvgnd_1
XFILLER_25_57 vssd1 vssd1 vccd1 vccd1 sky130_fd_sc_hd__fill_1
XTAP_TAPCELL_ROW_24_379 vssd1 vccd1 sky130_fd_sc_hd__tapvpwrvgnd_1
XFILLER_9_3 vccd1 vssd1 vccd1 vssd1 sky130_ef_sc_hd__decap_40_12
XFILLER_1_277 vssd1 vssd1 vccd1 vccd1 sky130_fd_sc_hd__fill_2
XANTENNA_fanout89_X net89 vssd1 vssd1 vccd1 vccd1 sky130_fd_sc_hd__diode_2
XFILLER_66_42 vssd1 vssd1 vccd1 vccd1 sky130_fd_sc_hd__fill_2
XTAP_TAPCELL_ROW_15_302 vssd1 vccd1 sky130_fd_sc_hd__tapvpwrvgnd_1
XFILLER_13_373 vccd1 vssd1 vccd1 vssd1 sky130_ef_sc_hd__decap_40_12
XFILLER_9_333 vssd1 vssd1 vccd1 vccd1 sky130_fd_sc_hd__fill_2
X_2550_ net673 _1047_ _1048_ vssd1 vssd1 vccd1 vccd1 _0350_ sky130_fd_sc_hd__a21boi_1
X_2481_ net180 net171 MATMULT_INST.matmult_inst.mem_inst.mem3\[4\] vssd1 vssd1 vccd1
+ vccd1 _0994_ sky130_fd_sc_hd__and3_1
XANTENNA__1704__S net24 vssd1 vssd1 vccd1 vccd1 sky130_fd_sc_hd__diode_2
X_3102_ clknet_leaf_19_clk _0060_ net125 vssd1 vssd1 vccd1 vccd1 MATMULT_INST.matmult_inst.mem_inst.matrixB0\[17\]
+ sky130_fd_sc_hd__dfrtp_1
X_3033_ net178 net169 MATMULT_INST.matmult_inst.mem_inst.matrixB3\[15\] vssd1 vssd1
+ vccd1 vccd1 _1453_ sky130_fd_sc_hd__and3_1
XTAP_TAPCELL_ROW_66_736 vssd1 vccd1 sky130_fd_sc_hd__tapvpwrvgnd_1
XANTENNA__3062__B2 net161 vssd1 vssd1 vccd1 vccd1 sky130_fd_sc_hd__diode_2
XANTENNA__3062__A1 net156 vssd1 vssd1 vccd1 vccd1 sky130_fd_sc_hd__diode_2
XTAP_TAPCELL_ROW_21_349 vssd1 vccd1 sky130_fd_sc_hd__tapvpwrvgnd_1
XANTENNA_fanout136_A net142 vssd1 vssd1 vccd1 vccd1 sky130_fd_sc_hd__diode_2
XFILLER_11_15 vccd1 vssd1 vccd1 vssd1 sky130_ef_sc_hd__decap_40_12
X_2817_ net189 net201 vssd1 vssd1 vccd1 vccd1 _1286_ sky130_fd_sc_hd__nand2_1
X_2748_ net189 net205 vssd1 vssd1 vccd1 vccd1 _1219_ sky130_fd_sc_hd__nand2_1
X_2679_ _1149_ _1150_ _1148_ vssd1 vssd1 vccd1 vccd1 _1152_ sky130_fd_sc_hd__a21o_1
XANTENNA__1679__A2 net59 vssd1 vssd1 vccd1 vccd1 sky130_fd_sc_hd__diode_2
XTAP_TAPCELL_ROW_29_416 vssd1 vccd1 sky130_fd_sc_hd__tapvpwrvgnd_1
XFILLER_52_11 vssd1 vssd1 vccd1 vccd1 sky130_fd_sc_hd__fill_2
XFILLER_10_321 vccd1 vssd1 vccd1 vssd1 sky130_ef_sc_hd__decap_40_12
XFILLER_10_365 vccd1 vssd1 vccd1 vssd1 sky130_ef_sc_hd__decap_40_12
XFILLER_77_30 vccd1 vssd1 vccd1 vssd1 sky130_ef_sc_hd__decap_40_12
XANTENNA__3024__B net167 vssd1 vssd1 vccd1 vccd1 sky130_fd_sc_hd__diode_2
XFILLER_37_229 vssd1 vssd1 vccd1 vccd1 sky130_fd_sc_hd__fill_1
XTAP_TAPCELL_ROW_63_706 vssd1 vccd1 sky130_fd_sc_hd__tapvpwrvgnd_1
XTAP_TAPCELL_ROW_71_772 vssd1 vccd1 sky130_fd_sc_hd__tapvpwrvgnd_1
X_1981_ _0562_ _0563_ vssd1 vssd1 vccd1 vccd1 _0564_ sky130_fd_sc_hd__nand2b_1
XFILLER_13_181 vccd1 vssd1 vccd1 vssd1 sky130_ef_sc_hd__decap_40_12
XFILLER_61_3 vssd1 vssd1 vccd1 vccd1 sky130_fd_sc_hd__fill_4
X_2602_ net210 MATMULT_INST.matmult_inst.alu_inst.b1_reg\[0\] net193 net191 vssd1
+ vssd1 vccd1 vccd1 _1078_ sky130_fd_sc_hd__and4_1
X_2533_ _1022_ net453 _1035_ vssd1 vssd1 vccd1 vccd1 _0346_ sky130_fd_sc_hd__mux2_1
XFILLER_5_391 vssd1 vssd1 vccd1 vccd1 sky130_fd_sc_hd__fill_1
X_2464_ net178 net169 MATMULT_INST.matmult_inst.mem_inst.mem3\[3\] vssd1 vssd1 vccd1
+ vccd1 _0978_ sky130_fd_sc_hd__and3_1
X_2395_ net573 net62 net41 MATMULT_INST.matmult_inst.fsm_inst.alu_result\[11\] vssd1
+ vssd1 vccd1 vccd1 _0320_ sky130_fd_sc_hd__a22o_1
XTAP_TAPCELL_ROW_79_850 vssd1 vccd1 sky130_fd_sc_hd__tapvpwrvgnd_1
XFILLER_3_93 vccd1 vssd1 vccd1 vssd1 sky130_ef_sc_hd__decap_40_12
X_3016_ MATMULT_INST.matmult_inst.mem_inst.matrixB2\[13\] net85 net77 MATMULT_INST.matmult_inst.mem_inst.matrixB1\[13\]
+ _1437_ vssd1 vssd1 vccd1 vccd1 _1438_ sky130_fd_sc_hd__a221o_1
XTAP_TAPCELL_ROW_34_463 vssd1 vccd1 sky130_fd_sc_hd__tapvpwrvgnd_1
XFILLER_3_317 vccd1 vssd1 vccd1 vssd1 sky130_ef_sc_hd__decap_40_12
XANTENNA_clkbuf_2_1__f_clk_X clknet_2_1__leaf_clk vssd1 vssd1 vccd1 vccd1 sky130_fd_sc_hd__diode_2
Xfanout131 net132 vssd1 vssd1 vccd1 vccd1 net131 sky130_fd_sc_hd__buf_2
Xfanout120 net122 vssd1 vssd1 vccd1 vccd1 net120 sky130_fd_sc_hd__clkbuf_2
XANTENNA__2849__A1 net184 vssd1 vssd1 vccd1 vccd1 sky130_fd_sc_hd__diode_2
Xfanout142 net151 vssd1 vssd1 vccd1 vccd1 net142 sky130_fd_sc_hd__clkbuf_2
Xfanout164 MATMULT_INST.matmult_inst.fsm_inst.sel\[1\] vssd1 vssd1 vccd1 vccd1 net164
+ sky130_fd_sc_hd__buf_2
Xfanout153 MATMULT_INST.matmult_inst.spi_inst.first_bit_sent vssd1 vssd1 vccd1 vccd1
+ net153 sky130_fd_sc_hd__clkbuf_4
Xfanout175 MATMULT_INST.matmult_inst.addr\[1\] vssd1 vssd1 vccd1 vccd1 net175 sky130_fd_sc_hd__dlymetal6s2s_1
Xfanout186 MATMULT_INST.matmult_inst.alu_inst.a1_reg\[6\] vssd1 vssd1 vccd1 vccd1
+ net186 sky130_fd_sc_hd__buf_2
Xfanout197 MATMULT_INST.matmult_inst.alu_inst.a1_reg\[0\] vssd1 vssd1 vccd1 vccd1
+ net197 sky130_fd_sc_hd__buf_2
XFILLER_74_346 vccd1 vssd1 vccd1 vssd1 sky130_ef_sc_hd__decap_40_12
XFILLER_42_221 vssd1 vssd1 vccd1 vccd1 sky130_fd_sc_hd__fill_4
XFILLER_63_54 vssd1 vssd1 vccd1 vccd1 sky130_fd_sc_hd__fill_2
XFILLER_8_27 vssd1 vssd1 vccd1 vccd1 sky130_fd_sc_hd__fill_1
Xclkbuf_leaf_22_clk clknet_2_2__leaf_clk vssd1 vssd1 vccd1 vccd1 clknet_leaf_22_clk
+ sky130_fd_sc_hd__clkbuf_8
XANTENNA__2785__B1 net206 vssd1 vssd1 vccd1 vccd1 sky130_fd_sc_hd__diode_2
XFILLER_10_195 vssd1 vssd1 vccd1 vccd1 sky130_fd_sc_hd__fill_1
XFILLER_6_133 vssd1 vssd1 vccd1 vccd1 sky130_fd_sc_hd__fill_4
XFILLER_6_177 vccd1 vssd1 vccd1 vssd1 sky130_ef_sc_hd__decap_40_12
XFILLER_69_107 vssd1 vssd1 vccd1 vccd1 sky130_fd_sc_hd__fill_4
XFILLER_2_361 vssd1 vssd1 vccd1 vccd1 sky130_fd_sc_hd__fill_2
X_2180_ _0662_ _0694_ _0695_ _0690_ vssd1 vssd1 vccd1 vccd1 _0730_ sky130_fd_sc_hd__a31o_1
XANTENNA__3035__A net178 vssd1 vssd1 vccd1 vccd1 sky130_fd_sc_hd__diode_2
XTAP_TAPCELL_ROW_76_820 vssd1 vccd1 sky130_fd_sc_hd__tapvpwrvgnd_1
XFILLER_65_335 vssd1 vssd1 vccd1 vccd1 sky130_fd_sc_hd__fill_1
XFILLER_18_251 vssd1 vssd1 vccd1 vccd1 sky130_fd_sc_hd__fill_1
XTAP_TAPCELL_ROW_48_577 vssd1 vccd1 sky130_fd_sc_hd__tapvpwrvgnd_1
XANTENNA__3017__B2 net159 vssd1 vssd1 vccd1 vccd1 sky130_fd_sc_hd__diode_2
XANTENNA__3017__A1 net92 vssd1 vssd1 vccd1 vccd1 sky130_fd_sc_hd__diode_2
XTAP_TAPCELL_ROW_31_433 vssd1 vccd1 sky130_fd_sc_hd__tapvpwrvgnd_1
X_1964_ net564 _0549_ net74 vssd1 vssd1 vccd1 vccd1 _0263_ sky130_fd_sc_hd__mux2_1
Xclkbuf_leaf_13_clk clknet_2_3__leaf_clk vssd1 vssd1 vccd1 vccd1 clknet_leaf_13_clk
+ sky130_fd_sc_hd__clkbuf_8
X_1895_ net523 net38 net26 vssd1 vssd1 vccd1 vccd1 _0224_ sky130_fd_sc_hd__mux2_1
XANTENNA__2528__A0 _0966_ vssd1 vssd1 vccd1 vccd1 sky130_fd_sc_hd__diode_2
XFILLER_0_309 vccd1 vssd1 vccd1 vssd1 sky130_ef_sc_hd__decap_40_12
X_3496_ net242 _0016_ net135 vssd1 vssd1 vccd1 vccd1 MATMULT_INST.matmult_inst.spi_inst.miso_shifter\[4\]
+ sky130_fd_sc_hd__dfrtp_1
X_2516_ net182 net173 MATMULT_INST.matmult_inst.mem_inst.mem3\[7\] vssd1 vssd1 vccd1
+ vccd1 _1026_ sky130_fd_sc_hd__and3_1
X_2447_ MATMULT_INST.matmult_inst.mem_inst.matrixB2\[1\] net89 net81 MATMULT_INST.matmult_inst.mem_inst.matrixB1\[1\]
+ _0962_ vssd1 vssd1 vccd1 vccd1 _0963_ sky130_fd_sc_hd__a221o_1
X_2378_ net69 _0919_ _0920_ _0914_ vssd1 vssd1 vccd1 vccd1 _0306_ sky130_fd_sc_hd__a31o_1
XTAP_TAPCELL_ROW_39_500 vssd1 vccd1 sky130_fd_sc_hd__tapvpwrvgnd_1
XANTENNA__3008__A1 net155 vssd1 vssd1 vccd1 vccd1 sky130_fd_sc_hd__diode_2
XANTENNA__3391__RESET_B net96 vssd1 vssd1 vccd1 vccd1 sky130_fd_sc_hd__diode_2
XFILLER_33_13 vssd1 vssd1 vccd1 vccd1 sky130_fd_sc_hd__fill_1
XANTENNA__2519__B1 net83 vssd1 vssd1 vccd1 vccd1 sky130_fd_sc_hd__diode_2
XFILLER_3_125 vccd1 vssd1 vccd1 vssd1 sky130_ef_sc_hd__decap_40_12
XFILLER_3_169 vccd1 vssd1 vccd1 vssd1 sky130_ef_sc_hd__decap_40_12
XFILLER_79_449 vssd1 vssd1 vccd1 vccd1 sky130_fd_sc_hd__fill_2
Xhold9 MATMULT_INST.matmult_inst.spi_inst.mosi_data_sync\[3\] vssd1 vssd1 vccd1 vccd1
+ net322 sky130_fd_sc_hd__dlygate4sd3_1
XFILLER_59_151 vssd1 vssd1 vccd1 vccd1 sky130_fd_sc_hd__fill_1
XANTENNA_fanout71_X net71 vssd1 vssd1 vccd1 vccd1 sky130_fd_sc_hd__diode_2
XANTENNA__1802__S net17 vssd1 vssd1 vccd1 vccd1 sky130_fd_sc_hd__diode_2
XFILLER_47_335 vssd1 vssd1 vccd1 vccd1 sky130_fd_sc_hd__fill_1
XTAP_TAPCELL_ROW_2_191 vssd1 vccd1 sky130_fd_sc_hd__tapvpwrvgnd_1
XFILLER_15_221 vssd1 vssd1 vccd1 vccd1 sky130_fd_sc_hd__fill_2
XTAP_TAPCELL_ROW_45_558 vssd1 vccd1 sky130_fd_sc_hd__tapvpwrvgnd_1
XFILLER_15_254 vssd1 vssd1 vccd1 vccd1 sky130_fd_sc_hd__fill_1
XANTENNA__2470__A2 net90 vssd1 vssd1 vccd1 vccd1 sky130_fd_sc_hd__diode_2
XANTENNA__1757__B net172 vssd1 vssd1 vccd1 vccd1 sky130_fd_sc_hd__diode_2
XFILLER_11_493 vssd1 vssd1 vccd1 vccd1 sky130_fd_sc_hd__fill_1
X_1680_ net382 net39 net25 vssd1 vssd1 vccd1 vccd1 _0043_ sky130_fd_sc_hd__mux2_1
X_3350_ clknet_leaf_29_clk _0305_ vssd1 vssd1 vccd1 vccd1 MATMULT_INST.matmult_inst.alu_inst.adder_inst.r3.fa1.a
+ sky130_fd_sc_hd__dfxtp_1
X_2301_ _0814_ _0846_ vssd1 vssd1 vccd1 vccd1 _0848_ sky130_fd_sc_hd__or2_1
X_3281_ clknet_leaf_22_clk _0239_ net115 vssd1 vssd1 vccd1 vccd1 MATMULT_INST.matmult_inst.mem_inst.matrixA1\[16\]
+ sky130_fd_sc_hd__dfrtp_1
X_2232_ _0742_ _0747_ _0744_ vssd1 vssd1 vccd1 vccd1 _0781_ sky130_fd_sc_hd__a21o_1
Xclkbuf_leaf_2_clk clknet_2_1__leaf_clk vssd1 vssd1 vccd1 vccd1 clknet_leaf_2_clk
+ sky130_fd_sc_hd__clkbuf_8
XFILLER_78_493 vssd1 vssd1 vccd1 vccd1 sky130_fd_sc_hd__fill_1
X_2163_ _0711_ _0712_ _0707_ vssd1 vssd1 vccd1 vccd1 _0713_ sky130_fd_sc_hd__a21oi_1
XANTENNA__1712__S net24 vssd1 vssd1 vccd1 vccd1 sky130_fd_sc_hd__diode_2
XFILLER_65_121 vssd1 vssd1 vccd1 vccd1 sky130_fd_sc_hd__fill_1
X_2094_ _0623_ _0627_ _0628_ vssd1 vssd1 vccd1 vccd1 _0647_ sky130_fd_sc_hd__o21ba_1
XFILLER_0_83 vssd1 vssd1 vccd1 vccd1 sky130_fd_sc_hd__fill_1
XFILLER_9_81 vccd1 vssd1 vccd1 vssd1 sky130_ef_sc_hd__decap_40_12
X_2996_ net161 _1414_ _1416_ net159 vssd1 vssd1 vccd1 vccd1 _1420_ sky130_fd_sc_hd__a22o_1
X_1947_ _0533_ _0534_ vssd1 vssd1 vccd1 vccd1 _0535_ sky130_fd_sc_hd__nand2b_1
X_1878_ net421 net36 net11 vssd1 vssd1 vccd1 vccd1 _0208_ sky130_fd_sc_hd__mux2_1
XTAP_TAPCELL_ROW_8_239 vssd1 vccd1 sky130_fd_sc_hd__tapvpwrvgnd_1
X_3479_ clknet_leaf_21_clk _0423_ net124 vssd1 vssd1 vccd1 vccd1 MATMULT_INST.matmult_inst.mem_inst.matrixB3\[15\]
+ sky130_fd_sc_hd__dfrtp_1
XFILLER_0_139 vssd1 vssd1 vccd1 vccd1 sky130_fd_sc_hd__fill_1
Xteam_02_269 vssd1 vssd1 vccd1 vccd1 team_02_269/HI gpio_out[22] sky130_fd_sc_hd__conb_1
XFILLER_69_493 vssd1 vssd1 vccd1 vccd1 sky130_fd_sc_hd__fill_1
Xteam_02_247 vssd1 vssd1 vccd1 vccd1 team_02_247/HI gpio_oeb[3] sky130_fd_sc_hd__conb_1
Xteam_02_258 vssd1 vssd1 vccd1 vccd1 team_02_258/HI gpio_out[11] sky130_fd_sc_hd__conb_1
XFILLER_28_68 vssd1 vssd1 vccd1 vccd1 sky130_fd_sc_hd__fill_4
XFILLER_71_113 vssd1 vssd1 vccd1 vccd1 sky130_fd_sc_hd__fill_1
XFILLER_44_23 vssd1 vssd1 vccd1 vccd1 sky130_fd_sc_hd__fill_1
XTAP_TAPCELL_ROW_42_528 vssd1 vccd1 sky130_fd_sc_hd__tapvpwrvgnd_1
XANTENNA_fanout31_A _0513_ vssd1 vssd1 vccd1 vccd1 sky130_fd_sc_hd__diode_2
XFILLER_60_11 vssd1 vssd1 vccd1 vccd1 sky130_fd_sc_hd__fill_2
XTAP_TAPCELL_ROW_50_594 vssd1 vccd1 sky130_fd_sc_hd__tapvpwrvgnd_1
XFILLER_60_66 vssd1 vssd1 vccd1 vccd1 sky130_fd_sc_hd__fill_4
XFILLER_4_401 vccd1 vssd1 vccd1 vssd1 sky130_ef_sc_hd__decap_40_12
XFILLER_69_31 vssd1 vssd1 vccd1 vccd1 sky130_fd_sc_hd__fill_1
XFILLER_5_39 vccd1 vssd1 vccd1 vssd1 sky130_ef_sc_hd__decap_40_12
XFILLER_4_445 vccd1 vssd1 vccd1 vssd1 sky130_ef_sc_hd__decap_40_12
XFILLER_4_489 vssd1 vssd1 vccd1 vccd1 sky130_fd_sc_hd__fill_2
XFILLER_79_246 vssd1 vssd1 vccd1 vccd1 sky130_fd_sc_hd__fill_4
XFILLER_79_279 vssd1 vssd1 vccd1 vccd1 sky130_fd_sc_hd__fill_1
XTAP_TAPCELL_ROW_58_661 vssd1 vccd1 sky130_fd_sc_hd__tapvpwrvgnd_1
XFILLER_35_349 vssd1 vssd1 vccd1 vccd1 sky130_fd_sc_hd__fill_1
XANTENNA__3502__CLK net242 vssd1 vssd1 vccd1 vccd1 sky130_fd_sc_hd__diode_2
XANTENNA__2443__A2 net65 vssd1 vssd1 vccd1 vccd1 sky130_fd_sc_hd__diode_2
X_2850_ _1313_ _1317_ vssd1 vssd1 vccd1 vccd1 _1318_ sky130_fd_sc_hd__and2_1
X_1801_ net534 net37 net17 vssd1 vssd1 vccd1 vccd1 _0135_ sky130_fd_sc_hd__mux2_1
X_2781_ _1220_ _1250_ _1249_ vssd1 vssd1 vccd1 vccd1 _1251_ sky130_fd_sc_hd__a21o_1
XTAP_TAPCELL_ROW_13_285 vssd1 vccd1 sky130_fd_sc_hd__tapvpwrvgnd_1
X_1732_ net607 net46 net22 vssd1 vssd1 vccd1 vccd1 _0075_ sky130_fd_sc_hd__mux2_1
XFILLER_7_261 vccd1 vssd1 vccd1 vssd1 sky130_ef_sc_hd__decap_40_12
Xhold206 MATMULT_INST.matmult_inst.mem_inst.mem2\[16\] vssd1 vssd1 vccd1 vccd1 net519
+ sky130_fd_sc_hd__dlygate4sd3_1
X_1663_ MATMULT_INST.matmult_inst.spi_inst.tx_reg_sys\[12\] MATMULT_INST.matmult_inst.spi_inst.miso_shifter\[11\]
+ net153 vssd1 vssd1 vccd1 vccd1 _0009_ sky130_fd_sc_hd__mux2_1
Xhold217 MATMULT_INST.matmult_inst.mem_inst.mem1\[6\] vssd1 vssd1 vccd1 vccd1 net530
+ sky130_fd_sc_hd__dlygate4sd3_1
X_3402_ clknet_leaf_2_clk _0356_ net104 vssd1 vssd1 vccd1 vccd1 MATMULT_INST.matmult_inst.alu_inst.row1\[4\]
+ sky130_fd_sc_hd__dfrtp_1
Xhold228 MATMULT_INST.matmult_inst.mem_inst.matrixA1\[2\] vssd1 vssd1 vccd1 vccd1
+ net541 sky130_fd_sc_hd__dlygate4sd3_1
Xhold239 MATMULT_INST.matmult_inst.mem_inst.mem2\[7\] vssd1 vssd1 vccd1 vccd1 net552
+ sky130_fd_sc_hd__dlygate4sd3_1
X_1594_ MATMULT_INST.matmult_inst.fsm_inst.state\[2\] _1482_ _1506_ vssd1 vssd1 vccd1
+ vccd1 _1512_ sky130_fd_sc_hd__nor3_1
X_3333_ clknet_leaf_3_clk _0289_ net105 vssd1 vssd1 vccd1 vccd1 MATMULT_INST.matmult_inst.alu_inst.a1_reg\[5\]
+ sky130_fd_sc_hd__dfrtp_1
XPHY_EDGE_ROW_7_Right_7 vssd1 vssd1 vccd1 vccd1 sky130_fd_sc_hd__decap_3
X_3264_ clknet_leaf_19_clk _0222_ net125 vssd1 vssd1 vccd1 vccd1 MATMULT_INST.matmult_inst.mem_inst.mem0\[17\]
+ sky130_fd_sc_hd__dfrtp_1
X_2215_ _0761_ _0762_ _0763_ vssd1 vssd1 vccd1 vccd1 _0764_ sky130_fd_sc_hd__nand3_1
X_3195_ clknet_leaf_9_clk _0153_ net134 vssd1 vssd1 vccd1 vccd1 MATMULT_INST.matmult_inst.mem_inst.matrixA3\[2\]
+ sky130_fd_sc_hd__dfrtp_1
X_2146_ _0694_ _0695_ _0662_ vssd1 vssd1 vccd1 vccd1 _0697_ sky130_fd_sc_hd__a21o_1
XANTENNA_fanout166_A MATMULT_INST.matmult_inst.fsm_inst.sel\[0\] vssd1 vssd1 vccd1
+ vccd1 sky130_fd_sc_hd__diode_2
X_2077_ _0616_ _0619_ _0630_ vssd1 vssd1 vccd1 vccd1 _0631_ sky130_fd_sc_hd__o21ai_2
XANTENNA__2434__A2 net65 vssd1 vssd1 vccd1 vccd1 sky130_fd_sc_hd__diode_2
XFILLER_14_15 vccd1 vssd1 vccd1 vssd1 sky130_ef_sc_hd__decap_40_12
XANTENNA__1678__A _0480_ vssd1 vssd1 vccd1 vccd1 sky130_fd_sc_hd__diode_2
X_2979_ net155 MATMULT_INST.matmult_inst.mem_inst.mem0\[10\] MATMULT_INST.matmult_inst.mem_inst.matrixB0\[10\]
+ net161 vssd1 vssd1 vccd1 vccd1 _1404_ sky130_fd_sc_hd__a22o_1
XFILLER_30_36 vssd1 vssd1 vccd1 vccd1 sky130_fd_sc_hd__fill_2
XFILLER_76_238 vssd1 vssd1 vccd1 vccd1 sky130_fd_sc_hd__fill_1
XANTENNA_fanout79_A net80 vssd1 vssd1 vccd1 vccd1 sky130_fd_sc_hd__diode_2
XFILLER_55_44 vccd1 vssd1 vccd1 vssd1 sky130_ef_sc_hd__decap_40_12
XANTENNA__2972__A net177 vssd1 vssd1 vccd1 vccd1 sky130_fd_sc_hd__diode_2
XFILLER_55_66 vssd1 vssd1 vccd1 vccd1 sky130_fd_sc_hd__fill_2
XTAP_TAPCELL_ROW_55_642 vssd1 vccd1 sky130_fd_sc_hd__tapvpwrvgnd_1
XTAP_TAPCELL_ROW_27_399 vssd1 vccd1 sky130_fd_sc_hd__tapvpwrvgnd_1
XANTENNA__2425__A2 net91 vssd1 vssd1 vccd1 vccd1 sky130_fd_sc_hd__diode_2
XTAP_TAPCELL_ROW_10_255 vssd1 vccd1 sky130_fd_sc_hd__tapvpwrvgnd_1
XFILLER_4_253 vccd1 vssd1 vccd1 vssd1 sky130_ef_sc_hd__decap_40_12
X_2000_ _0578_ _0579_ vssd1 vssd1 vccd1 vccd1 _0580_ sky130_fd_sc_hd__nand2_1
XTAP_TAPCELL_ROW_18_322 vssd1 vccd1 sky130_fd_sc_hd__tapvpwrvgnd_1
X_2902_ _1367_ vssd1 vssd1 vccd1 vccd1 _1368_ sky130_fd_sc_hd__inv_2
X_2833_ _1299_ _1300_ vssd1 vssd1 vccd1 vccd1 _1302_ sky130_fd_sc_hd__xnor2_1
XTAP_TAPCELL_ROW_61_689 vssd1 vccd1 sky130_fd_sc_hd__tapvpwrvgnd_1
X_2764_ _1216_ _1217_ _1234_ vssd1 vssd1 vccd1 vccd1 _1235_ sky130_fd_sc_hd__a21o_1
X_1715_ net162 net157 vssd1 vssd1 vccd1 vccd1 _0503_ sky130_fd_sc_hd__nor2_1
X_2695_ net71 _1167_ _1165_ vssd1 vssd1 vccd1 vccd1 _0376_ sky130_fd_sc_hd__a21oi_1
X_1646_ MATMULT_INST.matmult_inst.alu_inst.state\[0\] MATMULT_INST.matmult_inst.alu_inst.state\[1\]
+ vssd1 vssd1 vccd1 vccd1 _0476_ sky130_fd_sc_hd__nand2b_1
X_1577_ MATMULT_INST.matmult_inst.fsm_inst.state\[2\] MATMULT_INST.matmult_inst.fsm_inst.state\[3\]
+ vssd1 vssd1 vccd1 vccd1 _1497_ sky130_fd_sc_hd__or2_2
X_3316_ clknet_leaf_26_clk _0274_ net100 vssd1 vssd1 vccd1 vccd1 MATMULT_INST.matmult_inst.alu_inst.out\[16\]
+ sky130_fd_sc_hd__dfrtp_1
XTAP_TAPCELL_ROW_69_756 vssd1 vccd1 sky130_fd_sc_hd__tapvpwrvgnd_1
XANTENNA_clkbuf_leaf_21_clk_A clknet_2_2__leaf_clk vssd1 vssd1 vccd1 vccd1 sky130_fd_sc_hd__diode_2
X_3247_ clknet_leaf_11_clk _0205_ net146 vssd1 vssd1 vccd1 vccd1 MATMULT_INST.matmult_inst.mem_inst.mem0\[0\]
+ sky130_fd_sc_hd__dfrtp_1
XPHY_EDGE_ROW_16_Left_96 vssd1 vssd1 vccd1 vccd1 sky130_fd_sc_hd__decap_3
X_3178_ clknet_leaf_18_clk _0136_ net131 vssd1 vssd1 vccd1 vccd1 MATMULT_INST.matmult_inst.mem_inst.mem2\[3\]
+ sky130_fd_sc_hd__dfrtp_1
X_2129_ net225 net230 net232 net223 vssd1 vssd1 vccd1 vccd1 _0680_ sky130_fd_sc_hd__a22o_1
XANTENNA__1900__S net27 vssd1 vssd1 vccd1 vccd1 sky130_fd_sc_hd__diode_2
XANTENNA_fanout169_X net169 vssd1 vssd1 vccd1 vccd1 sky130_fd_sc_hd__diode_2
XFILLER_25_69 vssd1 vssd1 vccd1 vccd1 sky130_fd_sc_hd__fill_2
XTAP_TAPCELL_ROW_52_612 vssd1 vccd1 sky130_fd_sc_hd__tapvpwrvgnd_1
XFILLER_41_57 vssd1 vssd1 vccd1 vccd1 sky130_fd_sc_hd__fill_1
XANTENNA__2040__A0 net203 vssd1 vssd1 vccd1 vccd1 sky130_fd_sc_hd__diode_2
XFILLER_1_223 vssd1 vssd1 vccd1 vccd1 sky130_fd_sc_hd__fill_1
XFILLER_2_18 vssd1 vssd1 vccd1 vccd1 sky130_fd_sc_hd__fill_8
XFILLER_2_29 vccd1 vssd1 vccd1 vssd1 sky130_ef_sc_hd__decap_40_12
XFILLER_17_124 vssd1 vssd1 vccd1 vccd1 sky130_fd_sc_hd__fill_1
XANTENNA__1810__S net16 vssd1 vssd1 vccd1 vccd1 sky130_fd_sc_hd__diode_2
XTAP_TAPCELL_ROW_15_303 vssd1 vccd1 sky130_fd_sc_hd__tapvpwrvgnd_1
XFILLER_13_385 vssd1 vssd1 vccd1 vccd1 sky130_fd_sc_hd__fill_4
XFILLER_9_389 vssd1 vssd1 vccd1 vccd1 sky130_fd_sc_hd__fill_2
XANTENNA__2582__B2 net172 vssd1 vssd1 vccd1 vccd1 sky130_fd_sc_hd__diode_2
X_2480_ MATMULT_INST.matmult_inst.mem_inst.matrixA0\[4\] net65 _0992_ net93 vssd1
+ vssd1 vccd1 vccd1 _0993_ sky130_fd_sc_hd__a22o_1
XFILLER_49_5 vssd1 vssd1 vccd1 vccd1 sky130_fd_sc_hd__fill_1
XANTENNA__2877__A net198 vssd1 vssd1 vccd1 vccd1 sky130_fd_sc_hd__diode_2
X_3101_ clknet_leaf_24_clk _0059_ net115 vssd1 vssd1 vccd1 vccd1 MATMULT_INST.matmult_inst.mem_inst.matrixB0\[16\]
+ sky130_fd_sc_hd__dfrtp_1
XTAP_TAPCELL_ROW_66_737 vssd1 vccd1 sky130_fd_sc_hd__tapvpwrvgnd_1
X_3032_ net156 MATMULT_INST.matmult_inst.mem_inst.mem0\[15\] MATMULT_INST.matmult_inst.mem_inst.matrixB0\[15\]
+ net161 vssd1 vssd1 vccd1 vccd1 _1452_ sky130_fd_sc_hd__a22o_1
XFILLER_55_219 vssd1 vssd1 vccd1 vccd1 sky130_fd_sc_hd__fill_4
XANTENNA__1720__S net23 vssd1 vssd1 vccd1 vccd1 sky130_fd_sc_hd__diode_2
X_2816_ _1282_ _1284_ vssd1 vssd1 vccd1 vccd1 _1285_ sky130_fd_sc_hd__or2_1
XANTENNA_fanout129_A net132 vssd1 vssd1 vccd1 vccd1 sky130_fd_sc_hd__diode_2
X_2747_ _1185_ _1186_ _1184_ vssd1 vssd1 vccd1 vccd1 _1218_ sky130_fd_sc_hd__o21ba_1
XFILLER_11_27 vccd1 vssd1 vccd1 vssd1 sky130_ef_sc_hd__decap_40_12
X_2678_ _1148_ _1149_ _1150_ vssd1 vssd1 vccd1 vccd1 _1151_ sky130_fd_sc_hd__nand3_1
X_1629_ _1501_ _1530_ vssd1 vssd1 vccd1 vccd1 _0463_ sky130_fd_sc_hd__or2_1
XANTENNA_input3_A gpio_in[1] vssd1 vssd1 vccd1 vccd1 sky130_fd_sc_hd__diode_2
XTAP_TAPCELL_ROW_29_417 vssd1 vccd1 sky130_fd_sc_hd__tapvpwrvgnd_1
XFILLER_27_433 vssd1 vssd1 vccd1 vccd1 sky130_fd_sc_hd__fill_1
XTAP_TAPCELL_ROW_37_483 vssd1 vccd1 sky130_fd_sc_hd__tapvpwrvgnd_1
XFILLER_52_56 vssd1 vssd1 vccd1 vccd1 sky130_fd_sc_hd__fill_1
XFILLER_10_333 vccd1 vssd1 vccd1 vssd1 sky130_ef_sc_hd__decap_40_12
XFILLER_10_377 vccd1 vssd1 vccd1 vssd1 sky130_ef_sc_hd__decap_40_12
XANTENNA__1805__S net17 vssd1 vssd1 vccd1 vccd1 sky130_fd_sc_hd__diode_2
XFILLER_77_42 vccd1 vssd1 vccd1 vssd1 sky130_ef_sc_hd__decap_40_12
XTAP_TAPCELL_ROW_63_707 vssd1 vccd1 sky130_fd_sc_hd__tapvpwrvgnd_1
X_1980_ MATMULT_INST.matmult_inst.alu_inst.adder_inst.r2.fa0.b MATMULT_INST.matmult_inst.alu_inst.adder_inst.r2.fa0.a
+ vssd1 vssd1 vccd1 vccd1 _0563_ sky130_fd_sc_hd__nand2_1
XFILLER_60_233 vssd1 vssd1 vccd1 vccd1 sky130_fd_sc_hd__fill_1
XTAP_TAPCELL_ROW_71_773 vssd1 vccd1 sky130_fd_sc_hd__tapvpwrvgnd_1
XFILLER_13_193 vccd1 vssd1 vccd1 vssd1 sky130_ef_sc_hd__decap_40_12
X_2601_ net211 net193 net191 net212 vssd1 vssd1 vccd1 vccd1 _1077_ sky130_fd_sc_hd__a22oi_1
X_2532_ _1011_ net624 _1035_ vssd1 vssd1 vccd1 vccd1 _0345_ sky130_fd_sc_hd__mux2_1
XFILLER_54_3 vssd1 vssd1 vccd1 vccd1 sky130_fd_sc_hd__fill_1
X_2463_ net396 _0954_ _0977_ net66 vssd1 vssd1 vccd1 vccd1 _0334_ sky130_fd_sc_hd__a22o_1
XANTENNA__2307__A1 net218 vssd1 vssd1 vccd1 vccd1 sky130_fd_sc_hd__diode_2
XANTENNA__2307__B2 net230 vssd1 vssd1 vccd1 vccd1 sky130_fd_sc_hd__diode_2
X_2394_ net336 net62 net41 MATMULT_INST.matmult_inst.fsm_inst.alu_result\[10\] vssd1
+ vssd1 vccd1 vccd1 _0319_ sky130_fd_sc_hd__a22o_1
XTAP_TAPCELL_ROW_79_851 vssd1 vccd1 sky130_fd_sc_hd__tapvpwrvgnd_1
XTAP_TAPCELL_ROW_79_840 vssd1 vccd1 sky130_fd_sc_hd__tapvpwrvgnd_1
X_3015_ net176 net167 MATMULT_INST.matmult_inst.mem_inst.matrixB3\[13\] vssd1 vssd1
+ vccd1 vccd1 _1437_ sky130_fd_sc_hd__and3_1
XFILLER_36_230 vssd1 vssd1 vccd1 vccd1 sky130_fd_sc_hd__fill_1
XFILLER_24_458 vssd1 vssd1 vccd1 vccd1 sky130_fd_sc_hd__fill_1
XANTENNA_fanout246_A net2 vssd1 vssd1 vccd1 vccd1 sky130_fd_sc_hd__diode_2
XTAP_TAPCELL_ROW_34_464 vssd1 vccd1 sky130_fd_sc_hd__tapvpwrvgnd_1
XFILLER_22_15 vssd1 vssd1 vccd1 vccd1 sky130_fd_sc_hd__fill_4
XFILLER_22_26 vssd1 vssd1 vccd1 vccd1 sky130_fd_sc_hd__fill_2
XANTENNA_fanout201_X net201 vssd1 vssd1 vccd1 vccd1 sky130_fd_sc_hd__diode_2
XFILLER_3_329 vssd1 vssd1 vccd1 vccd1 sky130_fd_sc_hd__fill_4
Xfanout121 net122 vssd1 vssd1 vccd1 vccd1 net121 sky130_fd_sc_hd__clkbuf_4
XANTENNA__2849__A2 net206 vssd1 vssd1 vccd1 vccd1 sky130_fd_sc_hd__diode_2
Xfanout110 net111 vssd1 vssd1 vccd1 vccd1 net110 sky130_fd_sc_hd__clkbuf_2
Xfanout165 MATMULT_INST.matmult_inst.fsm_inst.sel\[0\] vssd1 vssd1 vccd1 vccd1 net165
+ sky130_fd_sc_hd__clkbuf_4
Xfanout132 net151 vssd1 vssd1 vccd1 vccd1 net132 sky130_fd_sc_hd__buf_2
Xfanout154 MATMULT_INST.matmult_inst.spi_inst.first_bit_sent vssd1 vssd1 vccd1 vccd1
+ net154 sky130_fd_sc_hd__buf_2
Xfanout143 net145 vssd1 vssd1 vccd1 vccd1 net143 sky130_fd_sc_hd__clkbuf_4
XFILLER_19_208 vccd1 vssd1 vccd1 vssd1 sky130_ef_sc_hd__decap_40_12
Xfanout176 net177 vssd1 vssd1 vccd1 vccd1 net176 sky130_fd_sc_hd__clkbuf_2
Xfanout187 MATMULT_INST.matmult_inst.alu_inst.a1_reg\[5\] vssd1 vssd1 vccd1 vccd1
+ net187 sky130_fd_sc_hd__buf_2
Xfanout198 MATMULT_INST.matmult_inst.alu_inst.b1_reg\[7\] vssd1 vssd1 vccd1 vccd1
+ net198 sky130_fd_sc_hd__buf_2
XFILLER_74_325 vssd1 vssd1 vccd1 vccd1 sky130_fd_sc_hd__fill_1
XFILLER_74_358 vssd1 vssd1 vccd1 vccd1 sky130_fd_sc_hd__fill_4
XANTENNA__2482__B1 net81 vssd1 vssd1 vccd1 vccd1 sky130_fd_sc_hd__diode_2
XFILLER_63_11 vssd1 vssd1 vccd1 vccd1 sky130_fd_sc_hd__fill_2
XFILLER_30_417 vssd1 vssd1 vccd1 vccd1 sky130_fd_sc_hd__fill_1
XFILLER_63_88 vssd1 vssd1 vccd1 vccd1 sky130_fd_sc_hd__fill_4
XFILLER_10_141 vccd1 vssd1 vccd1 vssd1 sky130_ef_sc_hd__decap_40_12
XANTENNA__2785__B2 net186 vssd1 vssd1 vccd1 vccd1 sky130_fd_sc_hd__diode_2
XFILLER_12_70 vccd1 vssd1 vccd1 vssd1 sky130_ef_sc_hd__decap_40_12
XFILLER_6_189 vssd1 vssd1 vccd1 vccd1 sky130_fd_sc_hd__fill_4
XFILLER_69_119 vssd1 vssd1 vccd1 vccd1 sky130_fd_sc_hd__fill_4
XANTENNA__3035__B net169 vssd1 vssd1 vccd1 vccd1 sky130_fd_sc_hd__diode_2
XTAP_TAPCELL_ROW_76_821 vssd1 vccd1 sky130_fd_sc_hd__tapvpwrvgnd_1
XTAP_TAPCELL_ROW_48_578 vssd1 vccd1 sky130_fd_sc_hd__tapvpwrvgnd_1
XFILLER_21_417 vssd1 vssd1 vccd1 vccd1 sky130_fd_sc_hd__fill_1
XTAP_TAPCELL_ROW_31_434 vssd1 vccd1 sky130_fd_sc_hd__tapvpwrvgnd_1
X_1963_ _0547_ _0548_ vssd1 vssd1 vccd1 vccd1 _0549_ sky130_fd_sc_hd__xnor2_1
X_1894_ net426 _0485_ net27 vssd1 vssd1 vccd1 vccd1 _0223_ sky130_fd_sc_hd__mux2_1
X_3495_ net242 _0015_ net133 vssd1 vssd1 vccd1 vccd1 MATMULT_INST.matmult_inst.spi_inst.miso_shifter\[3\]
+ sky130_fd_sc_hd__dfrtp_1
X_2515_ MATMULT_INST.matmult_inst.mem_inst.matrixB2\[7\] net90 net84 MATMULT_INST.matmult_inst.mem_inst.matrixB1\[7\]
+ _1024_ vssd1 vssd1 vccd1 vccd1 _1025_ sky130_fd_sc_hd__a221o_1
X_2446_ net181 net172 MATMULT_INST.matmult_inst.mem_inst.matrixB3\[1\] vssd1 vssd1
+ vccd1 vccd1 _0962_ sky130_fd_sc_hd__and3_1
X_2377_ _0916_ _0917_ _0910_ _0915_ vssd1 vssd1 vccd1 vccd1 _0920_ sky130_fd_sc_hd__a2bb2o_1
XTAP_TAPCELL_ROW_39_501 vssd1 vccd1 sky130_fd_sc_hd__tapvpwrvgnd_1
XFILLER_56_347 vssd1 vssd1 vccd1 vccd1 sky130_fd_sc_hd__fill_1
XFILLER_17_15 vssd1 vssd1 vccd1 vccd1 sky130_fd_sc_hd__fill_4
XANTENNA_fanout151_X net151 vssd1 vssd1 vccd1 vccd1 sky130_fd_sc_hd__diode_2
XFILLER_12_417 vssd1 vssd1 vccd1 vccd1 sky130_fd_sc_hd__fill_2
XFILLER_33_36 vssd1 vssd1 vccd1 vccd1 sky130_fd_sc_hd__fill_2
XFILLER_3_137 vccd1 vssd1 vccd1 vssd1 sky130_ef_sc_hd__decap_40_12
XANTENNA_fanout64_X net64 vssd1 vssd1 vccd1 vccd1 sky130_fd_sc_hd__diode_2
XTAP_TAPCELL_ROW_2_192 vssd1 vccd1 sky130_fd_sc_hd__tapvpwrvgnd_1
XPHY_EDGE_ROW_4_Left_84 vssd1 vssd1 vccd1 vccd1 sky130_fd_sc_hd__decap_3
XFILLER_11_461 vccd1 vssd1 vccd1 vssd1 sky130_ef_sc_hd__decap_40_12
X_3280_ clknet_leaf_20_clk _0238_ net126 vssd1 vssd1 vccd1 vccd1 MATMULT_INST.matmult_inst.mem_inst.matrixA1\[15\]
+ sky130_fd_sc_hd__dfrtp_1
XANTENNA__3046__A net176 vssd1 vssd1 vccd1 vccd1 sky130_fd_sc_hd__diode_2
X_2300_ _0814_ _0846_ vssd1 vssd1 vccd1 vccd1 _0847_ sky130_fd_sc_hd__and2_1
X_2231_ _0778_ _0779_ vssd1 vssd1 vccd1 vccd1 _0780_ sky130_fd_sc_hd__nand2b_1
XFILLER_17_3 vccd1 vssd1 vccd1 vssd1 sky130_ef_sc_hd__decap_40_12
X_2162_ _0708_ _0709_ _0710_ vssd1 vssd1 vccd1 vccd1 _0712_ sky130_fd_sc_hd__o21ai_1
X_2093_ _0638_ _0639_ _0644_ vssd1 vssd1 vccd1 vccd1 _0646_ sky130_fd_sc_hd__or3_1
XFILLER_53_328 vssd1 vssd1 vccd1 vccd1 sky130_fd_sc_hd__fill_1
XFILLER_21_225 vssd1 vssd1 vccd1 vccd1 sky130_fd_sc_hd__fill_4
X_2995_ net92 _1412_ _1418_ net165 vssd1 vssd1 vccd1 vccd1 _1419_ sky130_fd_sc_hd__a22o_1
XFILLER_9_93 vccd1 vssd1 vccd1 vssd1 sky130_ef_sc_hd__decap_40_12
X_1946_ MATMULT_INST.matmult_inst.alu_inst.adder_inst.r0.fa3.b MATMULT_INST.matmult_inst.alu_inst.adder_inst.r0.fa3.a
+ vssd1 vssd1 vccd1 vccd1 _0534_ sky130_fd_sc_hd__nand2_1
X_1877_ net512 net37 net11 vssd1 vssd1 vccd1 vccd1 _0207_ sky130_fd_sc_hd__mux2_1
XFILLER_0_118 vssd1 vssd1 vccd1 vccd1 sky130_fd_sc_hd__fill_4
XFILLER_0_107 vssd1 vssd1 vccd1 vccd1 sky130_fd_sc_hd__fill_1
X_3478_ clknet_leaf_26_clk _0422_ net98 vssd1 vssd1 vccd1 vccd1 MATMULT_INST.matmult_inst.mem_inst.matrixB3\[14\]
+ sky130_fd_sc_hd__dfrtp_1
XANTENNA__1903__S net27 vssd1 vssd1 vccd1 vccd1 sky130_fd_sc_hd__diode_2
X_2429_ MATMULT_INST.matmult_inst.mem_inst.mem2\[0\] net91 net81 MATMULT_INST.matmult_inst.mem_inst.mem1\[0\]
+ _0945_ vssd1 vssd1 vccd1 vccd1 _0946_ sky130_fd_sc_hd__a221o_1
Xteam_02_259 vssd1 vssd1 vccd1 vccd1 team_02_259/HI gpio_out[12] sky130_fd_sc_hd__conb_1
Xteam_02_248 vssd1 vssd1 vccd1 vccd1 team_02_248/HI gpio_oeb[4] sky130_fd_sc_hd__conb_1
XFILLER_28_25 vssd1 vssd1 vccd1 vccd1 sky130_fd_sc_hd__fill_2
XANTENNA__2988__A1 net156 vssd1 vssd1 vccd1 vccd1 sky130_fd_sc_hd__diode_2
XFILLER_37_391 vssd1 vssd1 vccd1 vccd1 sky130_fd_sc_hd__fill_1
XFILLER_71_169 vssd1 vssd1 vccd1 vccd1 sky130_fd_sc_hd__fill_4
XANTENNA__2988__B2 net164 vssd1 vssd1 vccd1 vccd1 sky130_fd_sc_hd__diode_2
XFILLER_44_46 vssd1 vssd1 vccd1 vccd1 sky130_fd_sc_hd__fill_1
XTAP_TAPCELL_ROW_42_529 vssd1 vccd1 sky130_fd_sc_hd__tapvpwrvgnd_1
XTAP_TAPCELL_ROW_50_595 vssd1 vccd1 sky130_fd_sc_hd__tapvpwrvgnd_1
XANTENNA__1874__A _0480_ vssd1 vssd1 vccd1 vccd1 sky130_fd_sc_hd__diode_2
XFILLER_4_413 vssd1 vssd1 vccd1 vccd1 sky130_fd_sc_hd__fill_4
XFILLER_4_457 vccd1 vssd1 vccd1 vssd1 sky130_ef_sc_hd__decap_40_12
XFILLER_79_225 vssd1 vssd1 vccd1 vccd1 sky130_fd_sc_hd__fill_1
XANTENNA__1813__S net16 vssd1 vssd1 vccd1 vccd1 sky130_fd_sc_hd__diode_2
XTAP_TAPCELL_ROW_58_662 vssd1 vccd1 sky130_fd_sc_hd__tapvpwrvgnd_1
XANTENNA__2979__B2 net161 vssd1 vssd1 vccd1 vccd1 sky130_fd_sc_hd__diode_2
XANTENNA__2979__A1 net155 vssd1 vssd1 vccd1 vccd1 sky130_fd_sc_hd__diode_2
X_1800_ net454 _0486_ net17 vssd1 vssd1 vccd1 vccd1 _0134_ sky130_fd_sc_hd__mux2_1
X_2780_ _1219_ _1221_ vssd1 vssd1 vccd1 vccd1 _1250_ sky130_fd_sc_hd__nand2_1
XTAP_TAPCELL_ROW_13_286 vssd1 vccd1 sky130_fd_sc_hd__tapvpwrvgnd_1
X_1731_ net548 net47 net22 vssd1 vssd1 vccd1 vccd1 _0074_ sky130_fd_sc_hd__mux2_1
XFILLER_7_273 vssd1 vssd1 vccd1 vccd1 sky130_fd_sc_hd__fill_4
X_1662_ MATMULT_INST.matmult_inst.spi_inst.tx_reg_sys\[11\] MATMULT_INST.matmult_inst.spi_inst.miso_shifter\[10\]
+ net153 vssd1 vssd1 vccd1 vccd1 _0008_ sky130_fd_sc_hd__mux2_1
Xhold207 MATMULT_INST.matmult_inst.mem_inst.matrixA1\[10\] vssd1 vssd1 vccd1 vccd1
+ net520 sky130_fd_sc_hd__dlygate4sd3_1
X_3401_ clknet_leaf_5_clk _0355_ net107 vssd1 vssd1 vccd1 vccd1 MATMULT_INST.matmult_inst.alu_inst.row1\[3\]
+ sky130_fd_sc_hd__dfrtp_1
Xhold229 MATMULT_INST.matmult_inst.mem_inst.matrixB1\[4\] vssd1 vssd1 vccd1 vccd1
+ net542 sky130_fd_sc_hd__dlygate4sd3_1
Xhold218 MATMULT_INST.matmult_inst.mem_inst.mem2\[5\] vssd1 vssd1 vccd1 vccd1 net531
+ sky130_fd_sc_hd__dlygate4sd3_1
X_1593_ MATMULT_INST.matmult_inst.fsm_inst.state\[3\] _1510_ _1508_ vssd1 vssd1 vccd1
+ vccd1 _1511_ sky130_fd_sc_hd__a21o_1
X_3332_ clknet_leaf_3_clk _0288_ net104 vssd1 vssd1 vccd1 vccd1 MATMULT_INST.matmult_inst.alu_inst.a1_reg\[4\]
+ sky130_fd_sc_hd__dfrtp_2
X_3263_ clknet_leaf_24_clk _0221_ net115 vssd1 vssd1 vccd1 vccd1 MATMULT_INST.matmult_inst.mem_inst.mem0\[16\]
+ sky130_fd_sc_hd__dfrtp_1
XANTENNA__1723__S net23 vssd1 vssd1 vccd1 vccd1 sky130_fd_sc_hd__diode_2
X_2214_ net218 net233 vssd1 vssd1 vccd1 vccd1 _0763_ sky130_fd_sc_hd__nand2_1
X_3194_ clknet_leaf_8_clk _0152_ net109 vssd1 vssd1 vccd1 vccd1 MATMULT_INST.matmult_inst.mem_inst.matrixA3\[1\]
+ sky130_fd_sc_hd__dfrtp_1
X_2145_ _0662_ _0694_ _0695_ vssd1 vssd1 vccd1 vccd1 _0696_ sky130_fd_sc_hd__nand3_1
XFILLER_19_391 vssd1 vssd1 vccd1 vccd1 sky130_fd_sc_hd__fill_1
X_2076_ _0623_ _0629_ vssd1 vssd1 vccd1 vccd1 _0630_ sky130_fd_sc_hd__xnor2_1
XFILLER_38_199 vssd1 vssd1 vccd1 vccd1 sky130_fd_sc_hd__fill_2
XFILLER_53_169 vccd1 vssd1 vccd1 vssd1 sky130_ef_sc_hd__decap_40_12
XFILLER_14_27 vssd1 vssd1 vccd1 vccd1 sky130_fd_sc_hd__fill_1
X_2978_ MATMULT_INST.matmult_inst.mem_inst.matrixB2\[10\] net86 net78 MATMULT_INST.matmult_inst.mem_inst.matrixB1\[10\]
+ _1402_ vssd1 vssd1 vccd1 vccd1 _1403_ sky130_fd_sc_hd__a221o_1
X_1929_ MATMULT_INST.matmult_inst.alu_inst.a0_reg\[7\] net361 net53 vssd1 vssd1 vccd1
+ vccd1 _0257_ sky130_fd_sc_hd__mux2_1
XANTENNA_fanout114_X net114 vssd1 vssd1 vccd1 vccd1 sky130_fd_sc_hd__diode_2
XFILLER_1_405 vccd1 vssd1 vccd1 vssd1 sky130_ef_sc_hd__decap_40_12
XFILLER_1_449 vccd1 vssd1 vccd1 vssd1 sky130_ef_sc_hd__decap_40_12
XTAP_TAPCELL_ROW_4_210 vssd1 vccd1 sky130_fd_sc_hd__tapvpwrvgnd_1
XFILLER_55_23 vssd1 vssd1 vccd1 vccd1 sky130_fd_sc_hd__fill_1
XANTENNA__2972__B net168 vssd1 vssd1 vccd1 vccd1 sky130_fd_sc_hd__diode_2
XFILLER_44_114 vssd1 vssd1 vccd1 vccd1 sky130_fd_sc_hd__fill_8
XTAP_TAPCELL_ROW_55_643 vssd1 vccd1 sky130_fd_sc_hd__tapvpwrvgnd_1
XFILLER_72_489 vssd1 vssd1 vccd1 vccd1 sky130_fd_sc_hd__fill_2
XFILLER_71_55 vssd1 vssd1 vccd1 vccd1 sky130_fd_sc_hd__fill_1
XANTENNA_fanout27_X net27 vssd1 vssd1 vccd1 vccd1 sky130_fd_sc_hd__diode_2
XFILLER_71_88 vssd1 vssd1 vccd1 vccd1 sky130_fd_sc_hd__fill_4
XFILLER_71_77 vssd1 vssd1 vccd1 vccd1 sky130_fd_sc_hd__fill_1
XTAP_TAPCELL_ROW_10_256 vssd1 vccd1 sky130_fd_sc_hd__tapvpwrvgnd_1
XANTENNA__1808__S net16 vssd1 vssd1 vccd1 vccd1 sky130_fd_sc_hd__diode_2
XFILLER_4_221 vccd1 vssd1 vccd1 vssd1 sky130_ef_sc_hd__decap_40_12
XFILLER_4_265 vccd1 vssd1 vccd1 vssd1 sky130_ef_sc_hd__decap_40_12
XFILLER_20_81 vssd1 vssd1 vccd1 vccd1 sky130_fd_sc_hd__fill_2
XFILLER_0_471 vssd1 vssd1 vccd1 vccd1 sky130_fd_sc_hd__fill_1
Xhold90 MATMULT_INST.matmult_inst.mem_inst.mem3\[9\] vssd1 vssd1 vccd1 vccd1 net403
+ sky130_fd_sc_hd__dlygate4sd3_1
XFILLER_48_475 vssd1 vssd1 vccd1 vccd1 sky130_fd_sc_hd__fill_1
XTAP_TAPCELL_ROW_18_323 vssd1 vccd1 sky130_fd_sc_hd__tapvpwrvgnd_1
XANTENNA__1779__A net162 vssd1 vssd1 vccd1 vccd1 sky130_fd_sc_hd__diode_2
X_2901_ _1339_ _1356_ _1364_ vssd1 vssd1 vccd1 vccd1 _1367_ sky130_fd_sc_hd__nand3_1
XFILLER_50_128 vssd1 vssd1 vccd1 vccd1 sky130_fd_sc_hd__fill_1
X_2832_ _1299_ _1300_ vssd1 vssd1 vccd1 vccd1 _1301_ sky130_fd_sc_hd__nand2_1
X_2763_ _1227_ _1233_ vssd1 vssd1 vccd1 vccd1 _1234_ sky130_fd_sc_hd__xnor2_1
X_1714_ net575 _0502_ net24 vssd1 vssd1 vccd1 vccd1 _0060_ sky130_fd_sc_hd__mux2_1
XANTENNA__1718__S net23 vssd1 vssd1 vccd1 vccd1 sky130_fd_sc_hd__diode_2
X_2694_ _1130_ _1164_ vssd1 vssd1 vccd1 vccd1 _1167_ sky130_fd_sc_hd__xnor2_1
XFILLER_6_83 vssd1 vssd1 vccd1 vccd1 sky130_fd_sc_hd__fill_1
X_1645_ _0471_ _0475_ vssd1 vssd1 vccd1 vccd1 _0002_ sky130_fd_sc_hd__or2_1
X_1576_ MATMULT_INST.matmult_inst.fsm_inst.state\[2\] MATMULT_INST.matmult_inst.fsm_inst.state\[3\]
+ vssd1 vssd1 vccd1 vccd1 _1496_ sky130_fd_sc_hd__nor2_1
XANTENNA__2888__B1 net68 vssd1 vssd1 vccd1 vccd1 sky130_fd_sc_hd__diode_2
X_3315_ clknet_leaf_25_clk _0273_ net100 vssd1 vssd1 vccd1 vccd1 MATMULT_INST.matmult_inst.alu_inst.out\[15\]
+ sky130_fd_sc_hd__dfrtp_1
X_3246_ clknet_leaf_21_clk _0204_ net124 vssd1 vssd1 vccd1 vccd1 MATMULT_INST.matmult_inst.mem_inst.matrixB2\[17\]
+ sky130_fd_sc_hd__dfrtp_1
XTAP_TAPCELL_ROW_69_757 vssd1 vccd1 sky130_fd_sc_hd__tapvpwrvgnd_1
X_3177_ clknet_leaf_9_clk _0135_ net138 vssd1 vssd1 vccd1 vccd1 MATMULT_INST.matmult_inst.mem_inst.mem2\[2\]
+ sky130_fd_sc_hd__dfrtp_1
XFILLER_66_261 vssd1 vssd1 vccd1 vccd1 sky130_fd_sc_hd__fill_1
X_2128_ net225 net223 net230 net232 vssd1 vssd1 vccd1 vccd1 _0679_ sky130_fd_sc_hd__nand4_2
XFILLER_26_114 vccd1 vssd1 vccd1 vssd1 sky130_ef_sc_hd__decap_40_12
X_2059_ net240 net224 net241 net221 vssd1 vssd1 vccd1 vccd1 _0614_ sky130_fd_sc_hd__a22oi_1
XFILLER_25_37 vccd1 vssd1 vccd1 vssd1 sky130_ef_sc_hd__decap_40_12
XTAP_TAPCELL_ROW_52_613 vssd1 vccd1 sky130_fd_sc_hd__tapvpwrvgnd_1
XFILLER_1_279 vssd1 vssd1 vccd1 vccd1 sky130_fd_sc_hd__fill_1
XFILLER_66_11 vssd1 vssd1 vccd1 vccd1 sky130_fd_sc_hd__fill_1
XANTENNA__2983__A net177 vssd1 vssd1 vccd1 vccd1 sky130_fd_sc_hd__diode_2
XFILLER_64_209 vccd1 vssd1 vccd1 vssd1 sky130_ef_sc_hd__decap_40_12
XFILLER_17_169 vssd1 vssd1 vccd1 vccd1 sky130_fd_sc_hd__fill_1
XFILLER_25_191 vssd1 vssd1 vccd1 vccd1 sky130_fd_sc_hd__fill_1
XANTENNA__2922__S net8 vssd1 vssd1 vccd1 vccd1 sky130_fd_sc_hd__diode_2
XFILLER_9_335 vssd1 vssd1 vccd1 vccd1 sky130_fd_sc_hd__fill_1
XTAP_TAPCELL_ROW_23_370 vssd1 vccd1 sky130_fd_sc_hd__tapvpwrvgnd_1
XFILLER_56_7 vssd1 vssd1 vccd1 vccd1 sky130_fd_sc_hd__fill_2
XANTENNA__2510__X _1021_ vssd1 vssd1 vccd1 vccd1 sky130_fd_sc_hd__diode_2
XANTENNA__2877__B net187 vssd1 vssd1 vccd1 vccd1 sky130_fd_sc_hd__diode_2
XANTENNA__3054__A net178 vssd1 vssd1 vccd1 vccd1 sky130_fd_sc_hd__diode_2
X_3100_ clknet_leaf_20_clk _0058_ net127 vssd1 vssd1 vccd1 vccd1 MATMULT_INST.matmult_inst.mem_inst.matrixB0\[15\]
+ sky130_fd_sc_hd__dfrtp_1
X_3031_ net613 _1451_ net57 vssd1 vssd1 vccd1 vccd1 _0448_ sky130_fd_sc_hd__mux2_1
XANTENNA__2893__A net198 vssd1 vssd1 vccd1 vccd1 sky130_fd_sc_hd__diode_2
XFILLER_23_106 vssd1 vssd1 vccd1 vccd1 sky130_fd_sc_hd__fill_1
XANTENNA__3047__B1 net77 vssd1 vssd1 vccd1 vccd1 sky130_fd_sc_hd__diode_2
XFILLER_16_180 vccd1 vssd1 vccd1 vssd1 sky130_ef_sc_hd__decap_40_12
XFILLER_31_150 vssd1 vssd1 vccd1 vccd1 sky130_fd_sc_hd__fill_2
X_2815_ net199 net190 _1283_ vssd1 vssd1 vccd1 vccd1 _1284_ sky130_fd_sc_hd__and3_1
XFILLER_11_39 vccd1 vssd1 vccd1 vssd1 sky130_ef_sc_hd__decap_40_12
X_2746_ _1213_ _1214_ _1215_ vssd1 vssd1 vccd1 vccd1 _1217_ sky130_fd_sc_hd__a21o_1
X_2677_ net210 net189 net188 net208 vssd1 vssd1 vccd1 vccd1 _1150_ sky130_fd_sc_hd__nand4_1
X_1628_ _1522_ _0460_ vssd1 vssd1 vccd1 vccd1 _0462_ sky130_fd_sc_hd__nor2_1
XANTENNA__2787__B net204 vssd1 vssd1 vccd1 vccd1 sky130_fd_sc_hd__diode_2
X_1559_ MATMULT_INST.matmult_inst.spi_inst.rx_done_spi _1491_ vssd1 vssd1 vccd1 vccd1
+ _0399_ sky130_fd_sc_hd__nand2b_1
XANTENNA_fanout181_X net181 vssd1 vssd1 vccd1 vccd1 sky130_fd_sc_hd__diode_2
XANTENNA__2089__A1 net239 vssd1 vssd1 vccd1 vccd1 sky130_fd_sc_hd__diode_2
XANTENNA__1911__S net26 vssd1 vssd1 vccd1 vccd1 sky130_fd_sc_hd__diode_2
XTAP_TAPCELL_ROW_29_418 vssd1 vccd1 sky130_fd_sc_hd__tapvpwrvgnd_1
X_3229_ clknet_leaf_13_clk _0187_ net145 vssd1 vssd1 vccd1 vccd1 MATMULT_INST.matmult_inst.mem_inst.matrixB2\[0\]
+ sky130_fd_sc_hd__dfrtp_1
XTAP_TAPCELL_ROW_37_484 vssd1 vccd1 sky130_fd_sc_hd__tapvpwrvgnd_1
XFILLER_14_139 vssd1 vssd1 vccd1 vccd1 sky130_fd_sc_hd__fill_1
XFILLER_52_13 vssd1 vssd1 vccd1 vccd1 sky130_fd_sc_hd__fill_1
XFILLER_10_301 vssd1 vssd1 vccd1 vccd1 sky130_fd_sc_hd__fill_4
XFILLER_22_172 vssd1 vssd1 vccd1 vccd1 sky130_fd_sc_hd__fill_1
XFILLER_22_183 vccd1 vssd1 vccd1 vssd1 sky130_ef_sc_hd__decap_40_12
XFILLER_10_345 vccd1 vssd1 vccd1 vssd1 sky130_ef_sc_hd__decap_40_12
XFILLER_6_305 vssd1 vssd1 vccd1 vccd1 sky130_fd_sc_hd__fill_2
XTAP_TAPCELL_ROW_20_340 vssd1 vccd1 sky130_fd_sc_hd__tapvpwrvgnd_1
XFILLER_10_389 vccd1 vssd1 vccd1 vssd1 sky130_ef_sc_hd__decap_40_12
XFILLER_77_54 vssd1 vssd1 vccd1 vccd1 sky130_fd_sc_hd__fill_2
XFILLER_77_76 vssd1 vssd1 vccd1 vccd1 sky130_fd_sc_hd__fill_2
XFILLER_77_65 vssd1 vssd1 vccd1 vccd1 sky130_fd_sc_hd__fill_1
XANTENNA__1821__S net15 vssd1 vssd1 vccd1 vccd1 sky130_fd_sc_hd__diode_2
XTAP_TAPCELL_ROW_63_708 vssd1 vccd1 sky130_fd_sc_hd__tapvpwrvgnd_1
XTAP_TAPCELL_ROW_71_774 vssd1 vccd1 sky130_fd_sc_hd__tapvpwrvgnd_1
XFILLER_60_289 vssd1 vssd1 vccd1 vccd1 sky130_fd_sc_hd__fill_1
XFILLER_13_161 vssd1 vssd1 vccd1 vccd1 sky130_fd_sc_hd__fill_4
XFILLER_9_165 vssd1 vssd1 vccd1 vccd1 sky130_fd_sc_hd__fill_2
XANTENNA_clkbuf_leaf_20_clk_A clknet_2_2__leaf_clk vssd1 vssd1 vccd1 vccd1 sky130_fd_sc_hd__diode_2
X_2600_ _1075_ _1076_ net493 net68 vssd1 vssd1 vccd1 vccd1 _0372_ sky130_fd_sc_hd__a2bb2o_1
X_2531_ _1000_ net592 _1035_ vssd1 vssd1 vccd1 vccd1 _0344_ sky130_fd_sc_hd__mux2_1
XFILLER_5_393 vccd1 vssd1 vccd1 vssd1 sky130_ef_sc_hd__decap_40_12
XFILLER_47_3 vssd1 vssd1 vccd1 vccd1 sky130_fd_sc_hd__fill_4
X_2462_ net75 _0976_ vssd1 vssd1 vccd1 vccd1 _0977_ sky130_fd_sc_hd__and2_2
X_2393_ MATMULT_INST.matmult_inst.alu_inst.out\[9\] net62 net41 net371 vssd1 vssd1
+ vccd1 vccd1 _0318_ sky130_fd_sc_hd__a22o_1
XTAP_TAPCELL_ROW_79_852 vssd1 vccd1 sky130_fd_sc_hd__tapvpwrvgnd_1
XTAP_TAPCELL_ROW_79_841 vssd1 vccd1 sky130_fd_sc_hd__tapvpwrvgnd_1
XFILLER_3_51 vssd1 vssd1 vccd1 vccd1 sky130_fd_sc_hd__fill_4
X_3014_ MATMULT_INST.matmult_inst.mem_inst.mem2\[13\] net85 net77 MATMULT_INST.matmult_inst.mem_inst.mem1\[13\]
+ _1435_ vssd1 vssd1 vccd1 vccd1 _1436_ sky130_fd_sc_hd__a221o_1
XANTENNA__1731__S net22 vssd1 vssd1 vccd1 vccd1 sky130_fd_sc_hd__diode_2
XANTENNA__2491__B2 net163 vssd1 vssd1 vccd1 vccd1 sky130_fd_sc_hd__diode_2
XANTENNA__2491__A1 net158 vssd1 vssd1 vccd1 vccd1 sky130_fd_sc_hd__diode_2
XANTENNA_fanout141_A net142 vssd1 vssd1 vccd1 vccd1 sky130_fd_sc_hd__diode_2
XFILLER_11_109 vssd1 vssd1 vccd1 vccd1 sky130_fd_sc_hd__fill_2
XTAP_TAPCELL_ROW_34_465 vssd1 vccd1 sky130_fd_sc_hd__tapvpwrvgnd_1
XANTENNA__2562__S net40 vssd1 vssd1 vccd1 vccd1 sky130_fd_sc_hd__diode_2
XANTENNA_fanout239_A net240 vssd1 vssd1 vccd1 vccd1 sky130_fd_sc_hd__diode_2
X_2729_ _1181_ _1182_ _1199_ vssd1 vssd1 vccd1 vccd1 _1201_ sky130_fd_sc_hd__a21oi_1
XANTENNA__1906__S net26 vssd1 vssd1 vccd1 vccd1 sky130_fd_sc_hd__diode_2
Xfanout100 net103 vssd1 vssd1 vccd1 vccd1 net100 sky130_fd_sc_hd__clkbuf_4
Xfanout122 net123 vssd1 vssd1 vccd1 vccd1 net122 sky130_fd_sc_hd__buf_2
Xfanout111 net113 vssd1 vssd1 vccd1 vccd1 net111 sky130_fd_sc_hd__clkbuf_2
Xfanout155 net156 vssd1 vssd1 vccd1 vccd1 net155 sky130_fd_sc_hd__clkbuf_4
Xfanout133 net142 vssd1 vssd1 vccd1 vccd1 net133 sky130_fd_sc_hd__clkbuf_4
Xfanout144 net145 vssd1 vssd1 vccd1 vccd1 net144 sky130_fd_sc_hd__clkbuf_4
Xfanout188 MATMULT_INST.matmult_inst.alu_inst.a1_reg\[5\] vssd1 vssd1 vccd1 vccd1
+ net188 sky130_fd_sc_hd__buf_2
Xfanout166 MATMULT_INST.matmult_inst.fsm_inst.sel\[0\] vssd1 vssd1 vccd1 vccd1 net166
+ sky130_fd_sc_hd__clkbuf_4
Xfanout199 MATMULT_INST.matmult_inst.alu_inst.b1_reg\[7\] vssd1 vssd1 vccd1 vccd1
+ net199 sky130_fd_sc_hd__dlymetal6s2s_1
Xfanout177 net180 vssd1 vssd1 vccd1 vccd1 net177 sky130_fd_sc_hd__buf_2
XPHY_EDGE_ROW_29_Right_29 vssd1 vssd1 vccd1 vccd1 sky130_fd_sc_hd__decap_3
XANTENNA_fanout54_A _0452_ vssd1 vssd1 vccd1 vccd1 sky130_fd_sc_hd__diode_2
XFILLER_8_29 vccd1 vssd1 vccd1 vssd1 sky130_ef_sc_hd__decap_40_12
XPHY_EDGE_ROW_38_Right_38 vssd1 vssd1 vccd1 vccd1 sky130_fd_sc_hd__decap_3
XANTENNA__2785__A2 net204 vssd1 vssd1 vccd1 vccd1 sky130_fd_sc_hd__diode_2
XFILLER_10_153 vccd1 vssd1 vccd1 vssd1 sky130_ef_sc_hd__decap_40_12
XFILLER_10_197 vccd1 vssd1 vccd1 vssd1 sky130_ef_sc_hd__decap_40_12
XFILLER_12_82 vssd1 vssd1 vccd1 vccd1 sky130_fd_sc_hd__fill_2
XANTENNA__1816__S net16 vssd1 vssd1 vccd1 vccd1 sky130_fd_sc_hd__diode_2
XANTENNA__2501__A net183 vssd1 vssd1 vccd1 vccd1 sky130_fd_sc_hd__diode_2
XFILLER_2_363 vssd1 vssd1 vccd1 vccd1 sky130_fd_sc_hd__fill_1
XPHY_EDGE_ROW_47_Right_47 vssd1 vssd1 vccd1 vccd1 sky130_fd_sc_hd__decap_3
XTAP_TAPCELL_ROW_76_822 vssd1 vccd1 sky130_fd_sc_hd__tapvpwrvgnd_1
XFILLER_65_315 vssd1 vssd1 vccd1 vccd1 sky130_fd_sc_hd__fill_1
XFILLER_18_264 vssd1 vssd1 vccd1 vccd1 sky130_fd_sc_hd__fill_1
XTAP_TAPCELL_ROW_48_579 vssd1 vccd1 sky130_fd_sc_hd__tapvpwrvgnd_1
X_1962_ _0538_ _0542_ _0539_ vssd1 vssd1 vccd1 vccd1 _0548_ sky130_fd_sc_hd__o21ai_1
XPHY_EDGE_ROW_56_Right_56 vssd1 vssd1 vccd1 vccd1 sky130_fd_sc_hd__decap_3
XTAP_TAPCELL_ROW_31_435 vssd1 vccd1 sky130_fd_sc_hd__tapvpwrvgnd_1
X_1893_ _0482_ _0503_ net81 vssd1 vssd1 vccd1 vccd1 _0519_ sky130_fd_sc_hd__and3_1
XANTENNA__2776__A2 net192 vssd1 vssd1 vccd1 vccd1 sky130_fd_sc_hd__diode_2
XANTENNA__1726__S net22 vssd1 vssd1 vccd1 vccd1 sky130_fd_sc_hd__diode_2
X_3494_ net246 _0014_ net133 vssd1 vssd1 vccd1 vccd1 MATMULT_INST.matmult_inst.spi_inst.miso_shifter\[2\]
+ sky130_fd_sc_hd__dfrtp_1
X_2514_ net182 net173 MATMULT_INST.matmult_inst.mem_inst.matrixB3\[7\] vssd1 vssd1
+ vccd1 vccd1 _1024_ sky130_fd_sc_hd__and3_1
XANTENNA__2411__A net61 vssd1 vssd1 vccd1 vccd1 sky130_fd_sc_hd__diode_2
X_2445_ MATMULT_INST.matmult_inst.mem_inst.matrixA2\[1\] net89 net81 MATMULT_INST.matmult_inst.mem_inst.matrixA1\[1\]
+ _0960_ vssd1 vssd1 vccd1 vccd1 _0961_ sky130_fd_sc_hd__a221o_1
XPHY_EDGE_ROW_65_Right_65 vssd1 vssd1 vccd1 vccd1 sky130_fd_sc_hd__decap_3
X_2376_ _0910_ _0915_ _0918_ vssd1 vssd1 vccd1 vccd1 _0919_ sky130_fd_sc_hd__nand3_1
XTAP_TAPCELL_ROW_39_502 vssd1 vccd1 sky130_fd_sc_hd__tapvpwrvgnd_1
XANTENNA_fanout189_A MATMULT_INST.matmult_inst.alu_inst.a1_reg\[4\] vssd1 vssd1 vccd1
+ vccd1 sky130_fd_sc_hd__diode_2
XPHY_EDGE_ROW_74_Right_74 vssd1 vssd1 vccd1 vccd1 sky130_fd_sc_hd__decap_3
XANTENNA__2519__A2 net90 vssd1 vssd1 vccd1 vccd1 sky130_fd_sc_hd__diode_2
XFILLER_3_105 vssd1 vssd1 vccd1 vccd1 sky130_fd_sc_hd__fill_4
XFILLER_79_407 vssd1 vssd1 vccd1 vccd1 sky130_fd_sc_hd__fill_2
XFILLER_3_149 vccd1 vssd1 vccd1 vssd1 sky130_ef_sc_hd__decap_40_12
XFILLER_79_418 vssd1 vssd1 vccd1 vccd1 sky130_fd_sc_hd__fill_2
XFILLER_74_156 vssd1 vssd1 vccd1 vccd1 sky130_fd_sc_hd__fill_2
XFILLER_74_22 vssd1 vssd1 vccd1 vccd1 sky130_fd_sc_hd__fill_1
XANTENNA_fanout57_X net57 vssd1 vssd1 vccd1 vccd1 sky130_fd_sc_hd__diode_2
XFILLER_74_44 vssd1 vssd1 vccd1 vccd1 sky130_fd_sc_hd__fill_1
XANTENNA__2455__B2 net93 vssd1 vssd1 vccd1 vccd1 sky130_fd_sc_hd__diode_2
XFILLER_15_223 vssd1 vssd1 vccd1 vccd1 sky130_fd_sc_hd__fill_1
XTAP_TAPCELL_ROW_2_193 vssd1 vccd1 sky130_fd_sc_hd__tapvpwrvgnd_1
XFILLER_30_259 vssd1 vssd1 vccd1 vccd1 sky130_fd_sc_hd__fill_1
XFILLER_11_473 vccd1 vssd1 vccd1 vssd1 sky130_ef_sc_hd__decap_40_12
XANTENNA__2930__S net9 vssd1 vssd1 vccd1 vccd1 sky130_fd_sc_hd__diode_2
XANTENNA__3046__B net167 vssd1 vssd1 vccd1 vccd1 sky130_fd_sc_hd__diode_2
X_2230_ _0776_ _0777_ _0741_ vssd1 vssd1 vccd1 vccd1 _0779_ sky130_fd_sc_hd__a21o_1
XFILLER_2_193 vssd1 vssd1 vccd1 vccd1 sky130_fd_sc_hd__fill_2
X_2161_ _0708_ _0709_ _0710_ vssd1 vssd1 vccd1 vccd1 _0711_ sky130_fd_sc_hd__or3_1
XANTENNA_clkbuf_2_2__f_clk_A clknet_0_clk vssd1 vssd1 vccd1 vccd1 sky130_fd_sc_hd__diode_2
X_2092_ _0638_ _0639_ _0644_ vssd1 vssd1 vccd1 vccd1 _0645_ sky130_fd_sc_hd__o21ai_1
XFILLER_0_41 vssd1 vssd1 vccd1 vccd1 sky130_fd_sc_hd__fill_4
XFILLER_65_167 vssd1 vssd1 vccd1 vccd1 sky130_fd_sc_hd__fill_1
XFILLER_0_85 vssd1 vssd1 vccd1 vccd1 sky130_fd_sc_hd__fill_8
XANTENNA__2997__A2 net64 vssd1 vssd1 vccd1 vccd1 sky130_fd_sc_hd__diode_2
X_2994_ MATMULT_INST.matmult_inst.mem_inst.matrixA2\[11\] net87 net79 MATMULT_INST.matmult_inst.mem_inst.matrixA1\[11\]
+ _1417_ vssd1 vssd1 vccd1 vccd1 _1418_ sky130_fd_sc_hd__a221o_1
X_1945_ MATMULT_INST.matmult_inst.alu_inst.adder_inst.r0.fa3.b MATMULT_INST.matmult_inst.alu_inst.adder_inst.r0.fa3.a
+ vssd1 vssd1 vccd1 vccd1 _0533_ sky130_fd_sc_hd__nor2_1
XANTENNA__2749__A2 net192 vssd1 vssd1 vccd1 vccd1 sky130_fd_sc_hd__diode_2
X_1876_ net478 net38 net11 vssd1 vssd1 vccd1 vccd1 _0206_ sky130_fd_sc_hd__mux2_1
XANTENNA__2141__A net240 vssd1 vssd1 vccd1 vccd1 sky130_fd_sc_hd__diode_2
X_3477_ clknet_leaf_22_clk _0421_ net117 vssd1 vssd1 vccd1 vccd1 MATMULT_INST.matmult_inst.mem_inst.matrixB3\[13\]
+ sky130_fd_sc_hd__dfrtp_1
X_2428_ net181 net173 MATMULT_INST.matmult_inst.mem_inst.mem3\[0\] vssd1 vssd1 vccd1
+ vccd1 _0945_ sky130_fd_sc_hd__and3_1
Xteam_02_249 vssd1 vssd1 vccd1 vccd1 team_02_249/HI gpio_out[0] sky130_fd_sc_hd__conb_1
X_2359_ _0888_ _0902_ _0901_ vssd1 vssd1 vccd1 vccd1 _0903_ sky130_fd_sc_hd__o21ai_1
XFILLER_44_36 vssd1 vssd1 vccd1 vccd1 sky130_fd_sc_hd__fill_8
XFILLER_60_13 vssd1 vssd1 vccd1 vccd1 sky130_fd_sc_hd__fill_1
XFILLER_60_35 vssd1 vssd1 vccd1 vccd1 sky130_fd_sc_hd__fill_2
XTAP_TAPCELL_ROW_50_596 vssd1 vccd1 sky130_fd_sc_hd__tapvpwrvgnd_1
XFILLER_4_469 vssd1 vssd1 vccd1 vccd1 sky130_fd_sc_hd__fill_4
XTAP_TAPCELL_ROW_7_230 vssd1 vccd1 sky130_fd_sc_hd__tapvpwrvgnd_1
XANTENNA__2676__B2 net189 vssd1 vssd1 vccd1 vccd1 sky130_fd_sc_hd__diode_2
XANTENNA__2676__A1 net210 vssd1 vssd1 vccd1 vccd1 sky130_fd_sc_hd__diode_2
XANTENNA__2925__S net9 vssd1 vssd1 vccd1 vccd1 sky130_fd_sc_hd__diode_2
XTAP_TAPCELL_ROW_58_663 vssd1 vccd1 sky130_fd_sc_hd__tapvpwrvgnd_1
XFILLER_11_281 vccd1 vssd1 vccd1 vssd1 sky130_ef_sc_hd__decap_40_12
X_1730_ net556 _0497_ net22 vssd1 vssd1 vccd1 vccd1 _0073_ sky130_fd_sc_hd__mux2_1
XANTENNA__2600__B2 net68 vssd1 vssd1 vccd1 vccd1 sky130_fd_sc_hd__diode_2
Xhold208 MATMULT_INST.matmult_inst.mem_inst.mem2\[14\] vssd1 vssd1 vccd1 vccd1 net521
+ sky130_fd_sc_hd__dlygate4sd3_1
X_1661_ MATMULT_INST.matmult_inst.spi_inst.tx_reg_sys\[10\] MATMULT_INST.matmult_inst.spi_inst.miso_shifter\[9\]
+ net153 vssd1 vssd1 vccd1 vccd1 _0007_ sky130_fd_sc_hd__mux2_1
X_3400_ clknet_leaf_5_clk _0354_ net107 vssd1 vssd1 vccd1 vccd1 MATMULT_INST.matmult_inst.alu_inst.row1\[2\]
+ sky130_fd_sc_hd__dfrtp_1
Xhold219 MATMULT_INST.matmult_inst.mem_inst.matrixB1\[14\] vssd1 vssd1 vccd1 vccd1
+ net532 sky130_fd_sc_hd__dlygate4sd3_1
X_3331_ clknet_leaf_5_clk _0287_ net107 vssd1 vssd1 vccd1 vccd1 MATMULT_INST.matmult_inst.alu_inst.a1_reg\[3\]
+ sky130_fd_sc_hd__dfrtp_1
X_1592_ _1509_ vssd1 vssd1 vccd1 vccd1 _1510_ sky130_fd_sc_hd__inv_2
X_3262_ clknet_leaf_20_clk _0220_ net127 vssd1 vssd1 vccd1 vccd1 MATMULT_INST.matmult_inst.mem_inst.mem0\[15\]
+ sky130_fd_sc_hd__dfrtp_1
X_2213_ net229 net231 net222 net219 vssd1 vssd1 vccd1 vccd1 _0762_ sky130_fd_sc_hd__nand4_1
X_3193_ clknet_leaf_9_clk _0151_ net139 vssd1 vssd1 vccd1 vccd1 MATMULT_INST.matmult_inst.mem_inst.matrixA3\[0\]
+ sky130_fd_sc_hd__dfrtp_1
XFILLER_66_443 vssd1 vssd1 vccd1 vccd1 sky130_fd_sc_hd__fill_1
X_2144_ _0692_ _0693_ _0691_ vssd1 vssd1 vccd1 vccd1 _0695_ sky130_fd_sc_hd__o21ai_1
XFILLER_26_329 vssd1 vssd1 vccd1 vccd1 sky130_fd_sc_hd__fill_1
X_2075_ _0627_ _0628_ vssd1 vssd1 vccd1 vccd1 _0629_ sky130_fd_sc_hd__nor2_1
XANTENNA__2570__S _1053_ vssd1 vssd1 vccd1 vccd1 sky130_fd_sc_hd__diode_2
X_2977_ net177 net168 MATMULT_INST.matmult_inst.mem_inst.matrixB3\[10\] vssd1 vssd1
+ vccd1 vccd1 _1402_ sky130_fd_sc_hd__and3_1
XANTENNA_fanout221_A net222 vssd1 vssd1 vccd1 vccd1 sky130_fd_sc_hd__diode_2
X_1928_ net215 net474 net54 vssd1 vssd1 vccd1 vccd1 _0256_ sky130_fd_sc_hd__mux2_1
XFILLER_30_38 vssd1 vssd1 vccd1 vccd1 sky130_fd_sc_hd__fill_1
X_1859_ net547 _0488_ net13 vssd1 vssd1 vccd1 vccd1 _0190_ sky130_fd_sc_hd__mux2_1
XFILLER_1_417 vccd1 vssd1 vccd1 vssd1 sky130_ef_sc_hd__decap_40_12
X_3529_ clknet_leaf_11_clk MATMULT_INST.matmult_inst.spi_inst.mosi_data_spi\[1\] net138
+ vssd1 vssd1 vccd1 vccd1 MATMULT_INST.matmult_inst.spi_inst.mosi_data_sync\[1\] sky130_fd_sc_hd__dfrtp_1
XANTENNA__1914__S net54 vssd1 vssd1 vccd1 vccd1 sky130_fd_sc_hd__diode_2
XPHY_EDGE_ROW_24_Left_104 vssd1 vssd1 vccd1 vccd1 sky130_fd_sc_hd__decap_3
XFILLER_44_104 vssd1 vssd1 vccd1 vccd1 sky130_fd_sc_hd__fill_1
XFILLER_55_68 vssd1 vssd1 vccd1 vccd1 sky130_fd_sc_hd__fill_1
XPHY_EDGE_ROW_33_Left_113 vssd1 vssd1 vccd1 vccd1 sky130_fd_sc_hd__decap_3
XTAP_TAPCELL_ROW_10_257 vssd1 vccd1 sky130_fd_sc_hd__tapvpwrvgnd_1
XFILLER_4_233 vccd1 vssd1 vccd1 vssd1 sky130_ef_sc_hd__decap_40_12
XANTENNA__1824__S net15 vssd1 vssd1 vccd1 vccd1 sky130_fd_sc_hd__diode_2
XFILLER_4_277 vccd1 vssd1 vccd1 vssd1 sky130_ef_sc_hd__decap_40_12
XPHY_EDGE_ROW_42_Left_122 vssd1 vssd1 vccd1 vccd1 sky130_fd_sc_hd__decap_3
XFILLER_0_461 vssd1 vssd1 vccd1 vccd1 sky130_fd_sc_hd__fill_8
XFILLER_75_251 vssd1 vssd1 vccd1 vccd1 sky130_fd_sc_hd__fill_1
XFILLER_75_240 vssd1 vssd1 vccd1 vccd1 sky130_fd_sc_hd__fill_2
Xhold91 MATMULT_INST.matmult_inst.mem_inst.matrixA3\[9\] vssd1 vssd1 vccd1 vccd1 net404
+ sky130_fd_sc_hd__dlygate4sd3_1
Xhold80 MATMULT_INST.matmult_inst.mem_inst.matrixA0\[2\] vssd1 vssd1 vccd1 vccd1 net393
+ sky130_fd_sc_hd__dlygate4sd3_1
XTAP_TAPCELL_ROW_18_324 vssd1 vccd1 sky130_fd_sc_hd__tapvpwrvgnd_1
XFILLER_35_115 vssd1 vssd1 vccd1 vccd1 sky130_fd_sc_hd__fill_1
X_2900_ _1333_ _1349_ _1350_ _1352_ vssd1 vssd1 vccd1 vccd1 _1366_ sky130_fd_sc_hd__a31o_1
XTAP_TAPCELL_ROW_26_390 vssd1 vccd1 sky130_fd_sc_hd__tapvpwrvgnd_1
XPHY_EDGE_ROW_51_Left_131 vssd1 vssd1 vccd1 vccd1 sky130_fd_sc_hd__decap_3
X_2831_ _1267_ _1270_ _1266_ vssd1 vssd1 vccd1 vccd1 _1300_ sky130_fd_sc_hd__a21o_1
X_2762_ _1231_ _1232_ vssd1 vssd1 vccd1 vccd1 _1233_ sky130_fd_sc_hd__nor2_1
X_1713_ MATMULT_INST.matmult_inst.fsm_inst.alu_result\[17\] net60 vssd1 vssd1 vccd1
+ vccd1 _0502_ sky130_fd_sc_hd__and2_1
X_2693_ _1125_ _1129_ _1163_ _1161_ vssd1 vssd1 vccd1 vccd1 _1166_ sky130_fd_sc_hd__o31a_1
X_1644_ _1499_ _0472_ _0474_ vssd1 vssd1 vccd1 vccd1 _0475_ sky130_fd_sc_hd__o21a_1
XANTENNA__1734__S net22 vssd1 vssd1 vccd1 vccd1 sky130_fd_sc_hd__diode_2
XPHY_EDGE_ROW_60_Left_140 vssd1 vssd1 vccd1 vccd1 sky130_fd_sc_hd__decap_3
X_1575_ MATMULT_INST.matmult_inst.fsm_inst.state\[0\] MATMULT_INST.matmult_inst.fsm_inst.state\[1\]
+ vssd1 vssd1 vccd1 vccd1 _1495_ sky130_fd_sc_hd__nand2_1
X_3314_ clknet_leaf_0_clk _0272_ net100 vssd1 vssd1 vccd1 vccd1 MATMULT_INST.matmult_inst.alu_inst.out\[14\]
+ sky130_fd_sc_hd__dfrtp_1
X_3245_ clknet_leaf_23_clk _0203_ net115 vssd1 vssd1 vccd1 vccd1 MATMULT_INST.matmult_inst.mem_inst.matrixB2\[16\]
+ sky130_fd_sc_hd__dfrtp_1
XTAP_TAPCELL_ROW_69_758 vssd1 vccd1 sky130_fd_sc_hd__tapvpwrvgnd_1
X_3176_ clknet_leaf_8_clk _0134_ net109 vssd1 vssd1 vccd1 vccd1 MATMULT_INST.matmult_inst.mem_inst.mem2\[1\]
+ sky130_fd_sc_hd__dfrtp_1
X_2127_ net225 net230 vssd1 vssd1 vccd1 vccd1 _0678_ sky130_fd_sc_hd__nand2_1
XFILLER_26_126 vssd1 vssd1 vccd1 vccd1 sky130_fd_sc_hd__fill_2
XANTENNA__2565__S _1053_ vssd1 vssd1 vccd1 vccd1 sky130_fd_sc_hd__diode_2
X_2058_ net674 net67 _0611_ _0613_ vssd1 vssd1 vccd1 vccd1 _0293_ sky130_fd_sc_hd__a22o_1
XTAP_TAPCELL_ROW_52_614 vssd1 vccd1 sky130_fd_sc_hd__tapvpwrvgnd_1
XANTENNA__1909__S net26 vssd1 vssd1 vccd1 vccd1 sky130_fd_sc_hd__diode_2
XFILLER_41_15 vccd1 vssd1 vccd1 vssd1 sky130_ef_sc_hd__decap_40_12
XTAP_TAPCELL_ROW_60_680 vssd1 vccd1 sky130_fd_sc_hd__tapvpwrvgnd_1
XFILLER_1_225 vccd1 vssd1 vccd1 vssd1 sky130_ef_sc_hd__decap_40_12
XANTENNA__2983__B net168 vssd1 vssd1 vccd1 vccd1 sky130_fd_sc_hd__diode_2
XANTENNA__2500__B1 _1011_ vssd1 vssd1 vccd1 vccd1 sky130_fd_sc_hd__diode_2
XFILLER_66_56 vccd1 vssd1 vccd1 vssd1 sky130_ef_sc_hd__decap_40_12
XFILLER_17_104 vssd1 vssd1 vccd1 vccd1 sky130_fd_sc_hd__fill_8
XANTENNA__3056__A1 net156 vssd1 vssd1 vccd1 vccd1 sky130_fd_sc_hd__diode_2
XANTENNA__3056__B2 net161 vssd1 vssd1 vccd1 vccd1 sky130_fd_sc_hd__diode_2
XFILLER_60_427 vssd1 vssd1 vccd1 vccd1 sky130_fd_sc_hd__fill_1
XANTENNA__1819__S net14 vssd1 vssd1 vccd1 vccd1 sky130_fd_sc_hd__diode_2
XTAP_TAPCELL_ROW_23_371 vssd1 vccd1 sky130_fd_sc_hd__tapvpwrvgnd_1
XFILLER_40_195 vssd1 vssd1 vccd1 vccd1 sky130_fd_sc_hd__fill_1
XANTENNA__2567__A0 _0977_ vssd1 vssd1 vccd1 vccd1 sky130_fd_sc_hd__diode_2
XANTENNA__2877__C net201 vssd1 vssd1 vccd1 vccd1 sky130_fd_sc_hd__diode_2
XANTENNA__3054__B net169 vssd1 vssd1 vccd1 vccd1 sky130_fd_sc_hd__diode_2
X_3030_ MATMULT_INST.matmult_inst.mem_inst.matrixA0\[14\] net64 _1449_ _1450_ vssd1
+ vssd1 vccd1 vccd1 _1451_ sky130_fd_sc_hd__a211o_1
XANTENNA__2893__B net201 vssd1 vssd1 vccd1 vccd1 sky130_fd_sc_hd__diode_2
XFILLER_16_192 vssd1 vssd1 vccd1 vccd1 sky130_fd_sc_hd__fill_4
XFILLER_51_449 vssd1 vssd1 vccd1 vccd1 sky130_fd_sc_hd__fill_1
XANTENNA_clkbuf_leaf_9_clk_A clknet_2_3__leaf_clk vssd1 vssd1 vccd1 vccd1 sky130_fd_sc_hd__diode_2
XANTENNA__1729__S net22 vssd1 vssd1 vccd1 vccd1 sky130_fd_sc_hd__diode_2
X_2814_ MATMULT_INST.matmult_inst.alu_inst.a1_reg\[4\] net203 _1246_ net192 net200
+ vssd1 vssd1 vccd1 vccd1 _1283_ sky130_fd_sc_hd__a32o_1
X_2745_ _1213_ _1214_ _1215_ vssd1 vssd1 vccd1 vccd1 _1216_ sky130_fd_sc_hd__nand3_1
X_2676_ net210 net188 net208 net189 vssd1 vssd1 vccd1 vccd1 _1149_ sky130_fd_sc_hd__a22o_1
X_1627_ _0460_ vssd1 vssd1 vccd1 vccd1 _0461_ sky130_fd_sc_hd__inv_2
X_1558_ MATMULT_INST.matmult_inst.spi_inst.rx_bit_count\[3\] MATMULT_INST.matmult_inst.cs
+ _1487_ vssd1 vssd1 vccd1 vccd1 _1491_ sky130_fd_sc_hd__or3_4
X_3228_ clknet_leaf_21_clk _0186_ net124 vssd1 vssd1 vccd1 vccd1 MATMULT_INST.matmult_inst.mem_inst.mem1\[17\]
+ sky130_fd_sc_hd__dfrtp_1
XTAP_TAPCELL_ROW_29_419 vssd1 vccd1 sky130_fd_sc_hd__tapvpwrvgnd_1
X_3159_ clknet_leaf_8_clk _0117_ net134 vssd1 vssd1 vccd1 vccd1 MATMULT_INST.matmult_inst.mem_inst.matrixB1\[2\]
+ sky130_fd_sc_hd__dfrtp_1
XANTENNA__3038__A1 net178 vssd1 vssd1 vccd1 vccd1 sky130_fd_sc_hd__diode_2
XTAP_TAPCELL_ROW_37_485 vssd1 vccd1 sky130_fd_sc_hd__tapvpwrvgnd_1
XFILLER_10_357 vssd1 vssd1 vccd1 vccd1 sky130_fd_sc_hd__fill_4
XTAP_TAPCELL_ROW_20_341 vssd1 vccd1 sky130_fd_sc_hd__tapvpwrvgnd_1
XFILLER_22_195 vssd1 vssd1 vccd1 vccd1 sky130_fd_sc_hd__fill_1
XANTENNA__2697__C net198 vssd1 vssd1 vccd1 vccd1 sky130_fd_sc_hd__diode_2
XFILLER_7_3 vccd1 vssd1 vccd1 vssd1 sky130_ef_sc_hd__decap_40_12
XANTENNA_fanout87_X net87 vssd1 vssd1 vccd1 vccd1 sky130_fd_sc_hd__diode_2
XFILLER_77_346 vssd1 vssd1 vccd1 vccd1 sky130_fd_sc_hd__fill_1
XTAP_TAPCELL_ROW_63_709 vssd1 vccd1 sky130_fd_sc_hd__tapvpwrvgnd_1
XANTENNA__3029__A1 net160 vssd1 vssd1 vccd1 vccd1 sky130_fd_sc_hd__diode_2
XANTENNA__3029__B2 net155 vssd1 vssd1 vccd1 vccd1 sky130_fd_sc_hd__diode_2
XANTENNA__2933__S net8 vssd1 vssd1 vccd1 vccd1 sky130_fd_sc_hd__diode_2
XFILLER_26_92 vssd1 vssd1 vccd1 vccd1 sky130_fd_sc_hd__fill_8
Xclkbuf_leaf_25_clk clknet_2_2__leaf_clk vssd1 vssd1 vccd1 vccd1 clknet_leaf_25_clk
+ sky130_fd_sc_hd__clkbuf_8
XTAP_TAPCELL_ROW_71_775 vssd1 vccd1 sky130_fd_sc_hd__tapvpwrvgnd_1
XFILLER_9_111 vssd1 vssd1 vccd1 vccd1 sky130_fd_sc_hd__fill_1
XFILLER_41_493 vssd1 vssd1 vccd1 vccd1 sky130_fd_sc_hd__fill_1
X_2530_ _0988_ net452 _1035_ vssd1 vssd1 vccd1 vccd1 _0343_ sky130_fd_sc_hd__mux2_1
XFILLER_5_361 vccd1 vssd1 vccd1 vssd1 sky130_ef_sc_hd__decap_40_12
X_2461_ net157 _0968_ _0970_ _0975_ vssd1 vssd1 vccd1 vccd1 _0976_ sky130_fd_sc_hd__a211o_1
X_2392_ net514 net62 net41 MATMULT_INST.matmult_inst.fsm_inst.alu_result\[8\] vssd1
+ vssd1 vccd1 vccd1 _0317_ sky130_fd_sc_hd__a22o_1
XTAP_TAPCELL_ROW_79_842 vssd1 vccd1 sky130_fd_sc_hd__tapvpwrvgnd_1
XTAP_TAPCELL_ROW_79_853 vssd1 vccd1 sky130_fd_sc_hd__tapvpwrvgnd_1
X_3013_ net176 net167 MATMULT_INST.matmult_inst.mem_inst.mem3\[13\] vssd1 vssd1 vccd1
+ vccd1 _1435_ sky130_fd_sc_hd__and3_1
Xclkbuf_leaf_16_clk clknet_2_3__leaf_clk vssd1 vssd1 vccd1 vccd1 clknet_leaf_16_clk
+ sky130_fd_sc_hd__clkbuf_8
XANTENNA_fanout134_A net142 vssd1 vssd1 vccd1 vccd1 sky130_fd_sc_hd__diode_2
X_2728_ _1181_ _1182_ _1199_ vssd1 vssd1 vccd1 vccd1 _1200_ sky130_fd_sc_hd__and3_1
X_2659_ _1111_ _1112_ _1090_ vssd1 vssd1 vccd1 vccd1 _1132_ sky130_fd_sc_hd__a21o_1
Xfanout112 net113 vssd1 vssd1 vccd1 vccd1 net112 sky130_fd_sc_hd__clkbuf_4
Xfanout101 net103 vssd1 vssd1 vccd1 vccd1 net101 sky130_fd_sc_hd__clkbuf_4
XFILLER_59_313 vssd1 vssd1 vccd1 vccd1 sky130_fd_sc_hd__fill_1
Xfanout156 net159 vssd1 vssd1 vccd1 vccd1 net156 sky130_fd_sc_hd__clkbuf_4
XANTENNA__1922__S net54 vssd1 vssd1 vccd1 vccd1 sky130_fd_sc_hd__diode_2
Xfanout123 net151 vssd1 vssd1 vccd1 vccd1 net123 sky130_fd_sc_hd__dlymetal6s2s_1
Xfanout134 net142 vssd1 vssd1 vccd1 vccd1 net134 sky130_fd_sc_hd__buf_2
Xfanout145 net151 vssd1 vssd1 vccd1 vccd1 net145 sky130_fd_sc_hd__clkbuf_4
Xfanout167 net168 vssd1 vssd1 vccd1 vccd1 net167 sky130_fd_sc_hd__buf_2
Xfanout178 net180 vssd1 vssd1 vccd1 vccd1 net178 sky130_fd_sc_hd__buf_2
Xfanout189 MATMULT_INST.matmult_inst.alu_inst.a1_reg\[4\] vssd1 vssd1 vccd1 vccd1
+ net189 sky130_fd_sc_hd__buf_2
XANTENNA__2482__A2 net89 vssd1 vssd1 vccd1 vccd1 sky130_fd_sc_hd__diode_2
XFILLER_63_46 vssd1 vssd1 vccd1 vccd1 sky130_fd_sc_hd__fill_8
XFILLER_23_493 vssd1 vssd1 vccd1 vccd1 sky130_fd_sc_hd__fill_1
XFILLER_10_121 vccd1 vssd1 vccd1 vssd1 sky130_ef_sc_hd__decap_40_12
XFILLER_10_165 vccd1 vssd1 vccd1 vssd1 sky130_ef_sc_hd__decap_40_12
XANTENNA__2928__S net9 vssd1 vssd1 vccd1 vccd1 sky130_fd_sc_hd__diode_2
XANTENNA__1832__S net14 vssd1 vssd1 vccd1 vccd1 sky130_fd_sc_hd__diode_2
XFILLER_18_221 vssd1 vssd1 vccd1 vccd1 sky130_fd_sc_hd__fill_8
XANTENNA__3505__CLK net242 vssd1 vssd1 vccd1 vccd1 sky130_fd_sc_hd__diode_2
XANTENNA__2473__A2 net65 vssd1 vssd1 vccd1 vccd1 sky130_fd_sc_hd__diode_2
XFILLER_73_393 vssd1 vssd1 vccd1 vccd1 sky130_fd_sc_hd__fill_1
XFILLER_33_213 vssd1 vssd1 vccd1 vccd1 sky130_fd_sc_hd__fill_2
XANTENNA__1681__B1 net61 vssd1 vssd1 vccd1 vccd1 sky130_fd_sc_hd__diode_2
X_1961_ _0544_ _0546_ vssd1 vssd1 vccd1 vccd1 _0547_ sky130_fd_sc_hd__nand2_1
XFILLER_14_493 vssd1 vssd1 vccd1 vccd1 sky130_fd_sc_hd__fill_1
X_1892_ net644 _0502_ net10 vssd1 vssd1 vccd1 vccd1 _0222_ sky130_fd_sc_hd__mux2_1
XTAP_TAPCELL_ROW_31_436 vssd1 vccd1 sky130_fd_sc_hd__tapvpwrvgnd_1
X_2513_ net158 MATMULT_INST.matmult_inst.mem_inst.mem0\[7\] MATMULT_INST.matmult_inst.mem_inst.matrixB0\[7\]
+ net163 vssd1 vssd1 vccd1 vccd1 _1023_ sky130_fd_sc_hd__a22o_1
X_3493_ net246 _0013_ net133 vssd1 vssd1 vccd1 vccd1 MATMULT_INST.matmult_inst.spi_inst.miso_shifter\[1\]
+ sky130_fd_sc_hd__dfrtp_1
Xclkbuf_leaf_5_clk clknet_2_1__leaf_clk vssd1 vssd1 vccd1 vccd1 clknet_leaf_5_clk
+ sky130_fd_sc_hd__clkbuf_8
X_2444_ net181 net172 MATMULT_INST.matmult_inst.mem_inst.matrixA3\[1\] vssd1 vssd1
+ vccd1 vccd1 _0960_ sky130_fd_sc_hd__and3_1
X_2375_ _0916_ _0917_ vssd1 vssd1 vccd1 vccd1 _0918_ sky130_fd_sc_hd__xnor2_1
XANTENNA__1742__S net21 vssd1 vssd1 vccd1 vccd1 sky130_fd_sc_hd__diode_2
XTAP_TAPCELL_ROW_39_503 vssd1 vccd1 sky130_fd_sc_hd__tapvpwrvgnd_1
XANTENNA__1672__B1 MATMULT_INST.matmult_inst.spi_inst.rx_done_sys vssd1 vssd1 vccd1
+ vccd1 sky130_fd_sc_hd__diode_2
XFILLER_12_419 vssd1 vssd1 vccd1 vccd1 sky130_fd_sc_hd__fill_1
XANTENNA__1697__B net60 vssd1 vssd1 vccd1 vccd1 sky130_fd_sc_hd__diode_2
XANTENNA__2602__A net210 vssd1 vssd1 vccd1 vccd1 sky130_fd_sc_hd__diode_2
XFILLER_74_135 vssd1 vssd1 vccd1 vccd1 sky130_fd_sc_hd__fill_1
XANTENNA__2455__A2 net65 vssd1 vssd1 vccd1 vccd1 sky130_fd_sc_hd__diode_2
XFILLER_11_441 vssd1 vssd1 vccd1 vccd1 sky130_fd_sc_hd__fill_4
XFILLER_11_485 vssd1 vssd1 vccd1 vccd1 sky130_fd_sc_hd__fill_8
XFILLER_7_445 vssd1 vssd1 vccd1 vccd1 sky130_fd_sc_hd__fill_2
XFILLER_23_93 vssd1 vssd1 vccd1 vccd1 sky130_fd_sc_hd__fill_2
XANTENNA__1827__S net15 vssd1 vssd1 vccd1 vccd1 sky130_fd_sc_hd__diode_2
XANTENNA__2391__B2 MATMULT_INST.matmult_inst.fsm_inst.alu_result\[7\] vssd1 vssd1
+ vccd1 vccd1 sky130_fd_sc_hd__diode_2
XFILLER_78_430 vccd1 vssd1 vccd1 vssd1 sky130_ef_sc_hd__decap_40_12
XFILLER_78_474 vssd1 vssd1 vccd1 vccd1 sky130_fd_sc_hd__fill_2
X_2160_ net218 net235 vssd1 vssd1 vccd1 vccd1 _0710_ sky130_fd_sc_hd__and2_1
XFILLER_65_113 vssd1 vssd1 vccd1 vccd1 sky130_fd_sc_hd__fill_8
X_2091_ _0640_ _0643_ vssd1 vssd1 vccd1 vccd1 _0644_ sky130_fd_sc_hd__xnor2_1
XFILLER_0_97 vssd1 vssd1 vccd1 vccd1 sky130_fd_sc_hd__fill_8
XTAP_TAPCELL_ROW_44_550 vssd1 vccd1 sky130_fd_sc_hd__tapvpwrvgnd_1
XANTENNA__2406__B net66 vssd1 vssd1 vccd1 vccd1 sky130_fd_sc_hd__diode_2
XFILLER_21_205 vccd1 vssd1 vccd1 vssd1 sky130_ef_sc_hd__decap_40_12
X_2993_ net178 net169 MATMULT_INST.matmult_inst.mem_inst.matrixA3\[11\] vssd1 vssd1
+ vccd1 vccd1 _1417_ sky130_fd_sc_hd__and3_1
XFILLER_9_51 vssd1 vssd1 vccd1 vccd1 sky130_fd_sc_hd__fill_4
X_1944_ net458 _0532_ net74 vssd1 vssd1 vccd1 vccd1 _0260_ sky130_fd_sc_hd__mux2_1
X_1875_ net459 net39 net11 vssd1 vssd1 vccd1 vccd1 _0205_ sky130_fd_sc_hd__mux2_1
XANTENNA__2906__B1 net67 vssd1 vssd1 vccd1 vccd1 sky130_fd_sc_hd__diode_2
XANTENNA__2141__B net218 vssd1 vssd1 vccd1 vccd1 sky130_fd_sc_hd__diode_2
X_3476_ clknet_leaf_27_clk _0420_ net97 vssd1 vssd1 vccd1 vccd1 MATMULT_INST.matmult_inst.mem_inst.matrixB3\[12\]
+ sky130_fd_sc_hd__dfrtp_1
XANTENNA__2568__S _1053_ vssd1 vssd1 vccd1 vccd1 sky130_fd_sc_hd__diode_2
X_2427_ _0503_ net93 net166 vssd1 vssd1 vccd1 vccd1 _0944_ sky130_fd_sc_hd__mux2_1
XFILLER_28_27 vssd1 vssd1 vccd1 vccd1 sky130_fd_sc_hd__fill_1
X_2358_ net228 net213 vssd1 vssd1 vccd1 vccd1 _0902_ sky130_fd_sc_hd__nand2_1
X_2289_ _0828_ _0832_ _0833_ vssd1 vssd1 vccd1 vccd1 _0836_ sky130_fd_sc_hd__nand3_1
XFILLER_44_15 vssd1 vssd1 vccd1 vccd1 sky130_fd_sc_hd__fill_8
XFILLER_52_363 vssd1 vssd1 vccd1 vccd1 sky130_fd_sc_hd__fill_1
XFILLER_12_249 vssd1 vssd1 vccd1 vccd1 sky130_fd_sc_hd__fill_2
XFILLER_8_209 vccd1 vssd1 vccd1 vssd1 sky130_ef_sc_hd__decap_40_12
XTAP_TAPCELL_ROW_50_597 vssd1 vccd1 sky130_fd_sc_hd__tapvpwrvgnd_1
XFILLER_69_45 vssd1 vssd1 vccd1 vccd1 sky130_fd_sc_hd__fill_1
XTAP_TAPCELL_ROW_7_231 vssd1 vccd1 sky130_fd_sc_hd__tapvpwrvgnd_1
XFILLER_47_113 vssd1 vssd1 vccd1 vccd1 sky130_fd_sc_hd__fill_2
XFILLER_75_455 vccd1 vssd1 vccd1 vssd1 sky130_ef_sc_hd__decap_40_12
XFILLER_47_157 vssd1 vssd1 vccd1 vccd1 sky130_fd_sc_hd__fill_2
XTAP_TAPCELL_ROW_58_664 vssd1 vccd1 sky130_fd_sc_hd__tapvpwrvgnd_1
XFILLER_62_127 vccd1 vssd1 vccd1 vssd1 sky130_ef_sc_hd__decap_40_12
XANTENNA__2507__A net182 vssd1 vssd1 vccd1 vccd1 sky130_fd_sc_hd__diode_2
XANTENNA__2941__S MATMULT_INST.matmult_inst.spi_inst.rx_done_sys vssd1 vssd1 vccd1
+ vccd1 sky130_fd_sc_hd__diode_2
XFILLER_70_193 vssd1 vssd1 vccd1 vccd1 sky130_fd_sc_hd__fill_2
XTAP_TAPCELL_ROW_41_520 vssd1 vccd1 sky130_fd_sc_hd__tapvpwrvgnd_1
XFILLER_11_293 vccd1 vssd1 vccd1 vssd1 sky130_ef_sc_hd__decap_40_12
X_1660_ MATMULT_INST.matmult_inst.spi_inst.tx_reg_sys\[9\] MATMULT_INST.matmult_inst.spi_inst.miso_shifter\[8\]
+ net153 vssd1 vssd1 vccd1 vccd1 _0021_ sky130_fd_sc_hd__mux2_1
Xhold209 MATMULT_INST.matmult_inst.spi_inst.tx_reg_sys\[12\] vssd1 vssd1 vccd1 vccd1
+ net522 sky130_fd_sc_hd__dlygate4sd3_1
X_1591_ MATMULT_INST.matmult_inst.fsm_inst.state\[0\] MATMULT_INST.matmult_inst.fsm_inst.state\[4\]
+ MATMULT_INST.matmult_inst.fsm_inst.state\[1\] vssd1 vssd1 vccd1 vccd1 _1509_ sky130_fd_sc_hd__or3b_2
X_3330_ clknet_leaf_6_clk _0286_ net106 vssd1 vssd1 vccd1 vccd1 MATMULT_INST.matmult_inst.alu_inst.a1_reg\[2\]
+ sky130_fd_sc_hd__dfrtp_1
X_3261_ clknet_leaf_24_clk _0219_ net101 vssd1 vssd1 vccd1 vccd1 MATMULT_INST.matmult_inst.mem_inst.mem0\[14\]
+ sky130_fd_sc_hd__dfrtp_1
X_2212_ net229 net222 net219 net231 vssd1 vssd1 vccd1 vccd1 _0761_ sky130_fd_sc_hd__a22o_1
X_3192_ clknet_leaf_21_clk _0150_ net124 vssd1 vssd1 vccd1 vccd1 MATMULT_INST.matmult_inst.mem_inst.mem2\[17\]
+ sky130_fd_sc_hd__dfrtp_1
XFILLER_22_3 vccd1 vssd1 vccd1 vssd1 sky130_ef_sc_hd__decap_40_12
X_2143_ _0691_ _0692_ _0693_ vssd1 vssd1 vccd1 vccd1 _0694_ sky130_fd_sc_hd__or3_1
XFILLER_19_393 vssd1 vssd1 vccd1 vccd1 sky130_fd_sc_hd__fill_1
X_2074_ _0615_ _0625_ _0626_ vssd1 vssd1 vccd1 vccd1 _0628_ sky130_fd_sc_hd__and3_1
XFILLER_14_29 vssd1 vssd1 vccd1 vccd1 sky130_fd_sc_hd__fill_4
X_2976_ net663 _1401_ net57 vssd1 vssd1 vccd1 vccd1 _0443_ sky130_fd_sc_hd__mux2_1
X_1927_ net217 net490 net53 vssd1 vssd1 vccd1 vccd1 _0255_ sky130_fd_sc_hd__mux2_1
X_1858_ net529 net37 net13 vssd1 vssd1 vccd1 vccd1 _0189_ sky130_fd_sc_hd__mux2_1
X_1789_ net634 net51 net31 vssd1 vssd1 vccd1 vccd1 _0124_ sky130_fd_sc_hd__mux2_1
X_3528_ clknet_leaf_11_clk MATMULT_INST.matmult_inst.spi_inst.mosi_data_spi\[0\] net139
+ vssd1 vssd1 vccd1 vccd1 MATMULT_INST.matmult_inst.spi_inst.mosi_data_sync\[0\] sky130_fd_sc_hd__dfrtp_1
XFILLER_1_429 vccd1 vssd1 vccd1 vssd1 sky130_ef_sc_hd__decap_40_12
XFILLER_39_15 vssd1 vssd1 vccd1 vccd1 sky130_fd_sc_hd__fill_4
X_3459_ _0038_ _0404_ net147 vssd1 vssd1 vccd1 vccd1 MATMULT_INST.matmult_inst.spi_inst.mosi_shifter\[3\]
+ sky130_fd_sc_hd__dfrtp_1
XFILLER_29_124 vssd1 vssd1 vccd1 vccd1 sky130_fd_sc_hd__fill_1
XFILLER_71_35 vccd1 vssd1 vccd1 vssd1 sky130_ef_sc_hd__decap_40_12
XTAP_TAPCELL_ROW_10_258 vssd1 vccd1 sky130_fd_sc_hd__tapvpwrvgnd_1
XFILLER_4_245 vssd1 vssd1 vccd1 vccd1 sky130_fd_sc_hd__fill_4
XFILLER_4_289 vccd1 vssd1 vccd1 vssd1 sky130_ef_sc_hd__decap_40_12
XFILLER_20_83 vssd1 vssd1 vccd1 vccd1 sky130_fd_sc_hd__fill_1
XFILLER_0_440 vssd1 vssd1 vccd1 vccd1 sky130_fd_sc_hd__fill_8
XANTENNA__2936__S net8 vssd1 vssd1 vccd1 vccd1 sky130_fd_sc_hd__diode_2
Xhold81 MATMULT_INST.matmult_inst.mem_inst.mem3\[11\] vssd1 vssd1 vccd1 vccd1 net394
+ sky130_fd_sc_hd__dlygate4sd3_1
Xhold70 MATMULT_INST.matmult_inst.mem_inst.matrixA3\[8\] vssd1 vssd1 vccd1 vccd1 net383
+ sky130_fd_sc_hd__dlygate4sd3_1
XANTENNA__1840__S net29 vssd1 vssd1 vccd1 vccd1 sky130_fd_sc_hd__diode_2
Xhold92 MATMULT_INST.matmult_inst.mem_inst.matrixB3\[7\] vssd1 vssd1 vccd1 vccd1 net405
+ sky130_fd_sc_hd__dlygate4sd3_1
XTAP_TAPCELL_ROW_18_325 vssd1 vccd1 sky130_fd_sc_hd__tapvpwrvgnd_1
XFILLER_63_447 vssd1 vssd1 vccd1 vccd1 sky130_fd_sc_hd__fill_1
XANTENNA__1779__C net81 vssd1 vssd1 vccd1 vccd1 sky130_fd_sc_hd__diode_2
XTAP_TAPCELL_ROW_26_391 vssd1 vccd1 sky130_fd_sc_hd__tapvpwrvgnd_1
XFILLER_43_193 vssd1 vssd1 vccd1 vccd1 sky130_fd_sc_hd__fill_1
X_2830_ _1297_ _1298_ vssd1 vssd1 vccd1 vccd1 _1299_ sky130_fd_sc_hd__nor2_1
X_2761_ _1228_ _1229_ _1230_ vssd1 vssd1 vccd1 vccd1 _1232_ sky130_fd_sc_hd__a21oi_1
X_1712_ net604 _0501_ net24 vssd1 vssd1 vccd1 vccd1 _0059_ sky130_fd_sc_hd__mux2_1
X_2692_ net379 net71 vssd1 vssd1 vccd1 vccd1 _1165_ sky130_fd_sc_hd__nor2_1
XFILLER_6_41 vccd1 vssd1 vccd1 vssd1 sky130_ef_sc_hd__decap_40_12
X_1643_ _1502_ _1529_ net63 net157 vssd1 vssd1 vccd1 vccd1 _0474_ sky130_fd_sc_hd__a211o_1
XFILLER_6_85 vccd1 vssd1 vccd1 vssd1 sky130_ef_sc_hd__decap_40_12
X_1574_ _1489_ _1494_ net3 vssd1 vssd1 vccd1 vccd1 _0387_ sky130_fd_sc_hd__and3b_1
X_3313_ clknet_leaf_26_clk _0271_ net100 vssd1 vssd1 vccd1 vccd1 MATMULT_INST.matmult_inst.alu_inst.out\[13\]
+ sky130_fd_sc_hd__dfrtp_1
X_3244_ clknet_leaf_20_clk _0202_ net126 vssd1 vssd1 vccd1 vccd1 MATMULT_INST.matmult_inst.mem_inst.matrixB2\[15\]
+ sky130_fd_sc_hd__dfrtp_1
XFILLER_58_208 vssd1 vssd1 vccd1 vccd1 sky130_fd_sc_hd__fill_2
XTAP_TAPCELL_ROW_69_759 vssd1 vccd1 sky130_fd_sc_hd__tapvpwrvgnd_1
XANTENNA__1750__S net20 vssd1 vssd1 vccd1 vccd1 sky130_fd_sc_hd__diode_2
X_3175_ clknet_leaf_15_clk _0133_ net136 vssd1 vssd1 vccd1 vccd1 MATMULT_INST.matmult_inst.mem_inst.mem2\[0\]
+ sky130_fd_sc_hd__dfrtp_1
X_2126_ _0655_ _0656_ _0676_ vssd1 vssd1 vccd1 vccd1 _0677_ sky130_fd_sc_hd__o21a_1
XFILLER_26_138 vssd1 vssd1 vccd1 vccd1 sky130_fd_sc_hd__fill_2
X_2057_ net67 _0612_ vssd1 vssd1 vccd1 vccd1 _0613_ sky130_fd_sc_hd__nor2_1
XFILLER_54_447 vssd1 vssd1 vccd1 vccd1 sky130_fd_sc_hd__fill_1
XFILLER_41_108 vssd1 vssd1 vccd1 vccd1 sky130_fd_sc_hd__fill_4
XTAP_TAPCELL_ROW_52_615 vssd1 vccd1 sky130_fd_sc_hd__tapvpwrvgnd_1
X_2959_ MATMULT_INST.matmult_inst.mem_inst.matrixA2\[8\] net88 net80 MATMULT_INST.matmult_inst.mem_inst.matrixA1\[8\]
+ _1385_ vssd1 vssd1 vccd1 vccd1 _1386_ sky130_fd_sc_hd__a221o_1
XFILLER_41_27 vssd1 vssd1 vccd1 vccd1 sky130_fd_sc_hd__fill_4
XTAP_TAPCELL_ROW_60_681 vssd1 vccd1 sky130_fd_sc_hd__tapvpwrvgnd_1
XANTENNA__1925__S net54 vssd1 vssd1 vccd1 vccd1 sky130_fd_sc_hd__diode_2
XFILLER_1_237 vccd1 vssd1 vccd1 vssd1 sky130_ef_sc_hd__decap_40_12
XANTENNA_fanout77_A net80 vssd1 vssd1 vccd1 vccd1 sky130_fd_sc_hd__diode_2
XFILLER_66_68 vccd1 vssd1 vccd1 vssd1 sky130_ef_sc_hd__decap_40_12
XANTENNA__2500__B2 net66 vssd1 vssd1 vccd1 vccd1 sky130_fd_sc_hd__diode_2
XANTENNA__2057__A net67 vssd1 vssd1 vccd1 vccd1 sky130_fd_sc_hd__diode_2
XFILLER_45_447 vssd1 vssd1 vccd1 vccd1 sky130_fd_sc_hd__fill_1
XFILLER_13_333 vssd1 vssd1 vccd1 vccd1 sky130_fd_sc_hd__fill_2
XFILLER_60_439 vssd1 vssd1 vccd1 vccd1 sky130_fd_sc_hd__fill_1
XFILLER_40_141 vssd1 vssd1 vccd1 vccd1 sky130_fd_sc_hd__fill_1
XFILLER_9_337 vccd1 vssd1 vccd1 vssd1 sky130_ef_sc_hd__decap_40_12
XANTENNA__1835__S net14 vssd1 vssd1 vccd1 vccd1 sky130_fd_sc_hd__diode_2
XFILLER_31_93 vssd1 vssd1 vccd1 vccd1 sky130_fd_sc_hd__fill_1
XFILLER_0_270 vssd1 vssd1 vccd1 vccd1 sky130_fd_sc_hd__fill_8
XFILLER_0_281 vccd1 vssd1 vccd1 vssd1 sky130_ef_sc_hd__decap_40_12
XFILLER_63_211 vccd1 vssd1 vccd1 vssd1 sky130_ef_sc_hd__decap_40_12
XTAP_TAPCELL_ROW_66_729 vssd1 vccd1 sky130_fd_sc_hd__tapvpwrvgnd_1
XFILLER_23_119 vccd1 vssd1 vccd1 vssd1 sky130_ef_sc_hd__decap_40_12
XFILLER_31_152 vssd1 vssd1 vccd1 vccd1 sky130_fd_sc_hd__fill_1
X_2813_ MATMULT_INST.matmult_inst.alu_inst.a1_reg\[4\] net203 _1246_ net190 net199
+ vssd1 vssd1 vccd1 vccd1 _1282_ sky130_fd_sc_hd__a32oi_1
XANTENNA__2558__A1 _0977_ vssd1 vssd1 vccd1 vccd1 sky130_fd_sc_hd__diode_2
X_2744_ _1135_ _1176_ _1174_ vssd1 vssd1 vccd1 vccd1 _1215_ sky130_fd_sc_hd__a21oi_1
XANTENNA__1745__S net21 vssd1 vssd1 vccd1 vccd1 sky130_fd_sc_hd__diode_2
X_2675_ net212 net186 vssd1 vssd1 vccd1 vccd1 _1148_ sky130_fd_sc_hd__nand2_1
X_1626_ _1501_ _0458_ vssd1 vssd1 vccd1 vccd1 _0460_ sky130_fd_sc_hd__nor2_1
XANTENNA__2430__A net183 vssd1 vssd1 vccd1 vccd1 sky130_fd_sc_hd__diode_2
X_1557_ MATMULT_INST.matmult_inst.spi_inst.rx_bit_count\[1\] _1489_ vssd1 vssd1 vccd1
+ vccd1 _1490_ sky130_fd_sc_hd__and2_1
X_3227_ clknet_leaf_23_clk _0185_ net116 vssd1 vssd1 vccd1 vccd1 MATMULT_INST.matmult_inst.mem_inst.mem1\[16\]
+ sky130_fd_sc_hd__dfrtp_1
XFILLER_36_27 vssd1 vssd1 vccd1 vccd1 sky130_fd_sc_hd__fill_1
X_3158_ clknet_leaf_1_clk _0116_ net109 vssd1 vssd1 vccd1 vccd1 MATMULT_INST.matmult_inst.mem_inst.matrixB1\[1\]
+ sky130_fd_sc_hd__dfrtp_1
XANTENNA__2494__B1 net83 vssd1 vssd1 vccd1 vccd1 sky130_fd_sc_hd__diode_2
X_2109_ net239 net218 net217 net241 vssd1 vssd1 vccd1 vccd1 _0661_ sky130_fd_sc_hd__a22o_1
XANTENNA__3038__A2 net169 vssd1 vssd1 vccd1 vccd1 sky130_fd_sc_hd__diode_2
XANTENNA_fanout167_X net167 vssd1 vssd1 vccd1 vccd1 sky130_fd_sc_hd__diode_2
X_3089_ clknet_leaf_16_clk _0047_ net135 vssd1 vssd1 vccd1 vccd1 MATMULT_INST.matmult_inst.mem_inst.matrixB0\[4\]
+ sky130_fd_sc_hd__dfrtp_1
XTAP_TAPCELL_ROW_37_486 vssd1 vccd1 sky130_fd_sc_hd__tapvpwrvgnd_1
XFILLER_22_130 vssd1 vssd1 vccd1 vccd1 sky130_fd_sc_hd__fill_2
XFILLER_22_163 vssd1 vssd1 vccd1 vccd1 sky130_fd_sc_hd__fill_1
XFILLER_6_307 vssd1 vssd1 vccd1 vccd1 sky130_fd_sc_hd__fill_1
XTAP_TAPCELL_ROW_20_342 vssd1 vccd1 sky130_fd_sc_hd__tapvpwrvgnd_1
XANTENNA__2721__A1 net210 vssd1 vssd1 vccd1 vccd1 sky130_fd_sc_hd__diode_2
XFILLER_45_244 vssd1 vssd1 vccd1 vccd1 sky130_fd_sc_hd__fill_1
XTAP_TAPCELL_ROW_71_776 vssd1 vccd1 sky130_fd_sc_hd__tapvpwrvgnd_1
XFILLER_9_167 vssd1 vssd1 vccd1 vccd1 sky130_fd_sc_hd__fill_1
XFILLER_61_7 vssd1 vssd1 vccd1 vccd1 sky130_fd_sc_hd__fill_2
XFILLER_5_373 vccd1 vssd1 vccd1 vssd1 sky130_ef_sc_hd__decap_40_12
X_2460_ net162 _0972_ _0974_ net166 vssd1 vssd1 vccd1 vccd1 _0975_ sky130_fd_sc_hd__a22o_1
X_2391_ net503 net63 net42 MATMULT_INST.matmult_inst.fsm_inst.alu_result\[7\] vssd1
+ vssd1 vccd1 vccd1 _0316_ sky130_fd_sc_hd__a22o_1
XTAP_TAPCELL_ROW_79_843 vssd1 vccd1 sky130_fd_sc_hd__tapvpwrvgnd_1
XTAP_TAPCELL_ROW_79_854 vssd1 vccd1 sky130_fd_sc_hd__tapvpwrvgnd_1
X_3012_ MATMULT_INST.matmult_inst.mem_inst.matrixA2\[13\] net87 net79 MATMULT_INST.matmult_inst.mem_inst.matrixA1\[13\]
+ _1433_ vssd1 vssd1 vccd1 vccd1 _1434_ sky130_fd_sc_hd__a221o_1
XANTENNA__2128__C net230 vssd1 vssd1 vccd1 vccd1 sky130_fd_sc_hd__diode_2
XANTENNA__3020__S net57 vssd1 vssd1 vccd1 vccd1 sky130_fd_sc_hd__diode_2
XFILLER_22_29 vssd1 vssd1 vccd1 vccd1 sky130_fd_sc_hd__fill_2
XANTENNA_fanout127_A net132 vssd1 vssd1 vccd1 vccd1 sky130_fd_sc_hd__diode_2
X_2727_ _1191_ _1198_ vssd1 vssd1 vccd1 vccd1 _1199_ sky130_fd_sc_hd__xnor2_1
XANTENNA__2160__A net218 vssd1 vssd1 vccd1 vccd1 sky130_fd_sc_hd__diode_2
X_2658_ _1115_ _1122_ _1092_ _1114_ vssd1 vssd1 vccd1 vccd1 _1131_ sky130_fd_sc_hd__a2bb2o_1
Xfanout113 net114 vssd1 vssd1 vccd1 vccd1 net113 sky130_fd_sc_hd__clkbuf_2
X_1609_ _1497_ _1506_ vssd1 vssd1 vccd1 vccd1 _1527_ sky130_fd_sc_hd__or2_1
Xfanout102 net103 vssd1 vssd1 vccd1 vccd1 net102 sky130_fd_sc_hd__clkbuf_2
X_2589_ net196 net210 net195 net212 vssd1 vssd1 vccd1 vccd1 _1067_ sky130_fd_sc_hd__a22o_1
Xfanout146 net148 vssd1 vssd1 vccd1 vccd1 net146 sky130_fd_sc_hd__clkbuf_4
Xfanout124 net132 vssd1 vssd1 vccd1 vccd1 net124 sky130_fd_sc_hd__clkbuf_4
Xfanout135 net142 vssd1 vssd1 vccd1 vccd1 net135 sky130_fd_sc_hd__clkbuf_4
XANTENNA_input1_A en vssd1 vssd1 vccd1 vccd1 sky130_fd_sc_hd__diode_2
Xfanout179 net180 vssd1 vssd1 vccd1 vccd1 net179 sky130_fd_sc_hd__buf_1
Xfanout168 net171 vssd1 vssd1 vccd1 vccd1 net168 sky130_fd_sc_hd__buf_2
Xfanout157 net159 vssd1 vssd1 vccd1 vccd1 net157 sky130_fd_sc_hd__clkbuf_4
XANTENNA__2467__B1 net83 vssd1 vssd1 vccd1 vccd1 sky130_fd_sc_hd__diode_2
XFILLER_42_225 vssd1 vssd1 vccd1 vccd1 sky130_fd_sc_hd__fill_1
XFILLER_10_133 vssd1 vssd1 vccd1 vccd1 sky130_fd_sc_hd__fill_4
XFILLER_10_177 vccd1 vssd1 vccd1 vssd1 sky130_ef_sc_hd__decap_40_12
XFILLER_6_137 vssd1 vssd1 vccd1 vccd1 sky130_fd_sc_hd__fill_2
XFILLER_2_321 vccd1 vssd1 vccd1 vssd1 sky130_ef_sc_hd__decap_40_12
XFILLER_2_365 vccd1 vssd1 vccd1 vssd1 sky130_ef_sc_hd__decap_40_12
XANTENNA_clkbuf_leaf_8_clk_A clknet_2_3__leaf_clk vssd1 vssd1 vccd1 vccd1 sky130_fd_sc_hd__diode_2
XANTENNA__2944__S MATMULT_INST.matmult_inst.spi_inst.rx_done_sys vssd1 vssd1 vccd1
+ vccd1 sky130_fd_sc_hd__diode_2
XFILLER_33_225 vssd1 vssd1 vccd1 vccd1 sky130_fd_sc_hd__fill_4
XFILLER_14_461 vssd1 vssd1 vccd1 vccd1 sky130_fd_sc_hd__fill_1
X_1960_ MATMULT_INST.matmult_inst.alu_inst.adder_inst.r1.fa1.b MATMULT_INST.matmult_inst.alu_inst.adder_inst.r1.fa1.a
+ vssd1 vssd1 vccd1 vccd1 _0546_ sky130_fd_sc_hd__or2_1
X_1891_ net625 net44 net10 vssd1 vssd1 vccd1 vccd1 _0221_ sky130_fd_sc_hd__mux2_1
XTAP_TAPCELL_ROW_31_437 vssd1 vccd1 sky130_fd_sc_hd__tapvpwrvgnd_1
XFILLER_52_3 vssd1 vssd1 vccd1 vccd1 sky130_fd_sc_hd__fill_8
X_2512_ net491 _0954_ _1022_ net66 vssd1 vssd1 vccd1 vccd1 _0338_ sky130_fd_sc_hd__a22o_1
XFILLER_5_181 vccd1 vssd1 vccd1 vssd1 sky130_ef_sc_hd__decap_40_12
X_3492_ net246 _0006_ net134 vssd1 vssd1 vccd1 vccd1 MATMULT_INST.matmult_inst.spi_inst.miso_shifter\[0\]
+ sky130_fd_sc_hd__dfrtp_1
X_2443_ MATMULT_INST.matmult_inst.mem_inst.matrixA0\[1\] net65 _0958_ net93 vssd1
+ vssd1 vccd1 vccd1 _0959_ sky130_fd_sc_hd__a22o_1
X_2374_ _0882_ _0905_ vssd1 vssd1 vccd1 vccd1 _0917_ sky130_fd_sc_hd__nand2_1
XTAP_TAPCELL_ROW_39_504 vssd1 vccd1 sky130_fd_sc_hd__tapvpwrvgnd_1
XTAP_TAPCELL_ROW_47_570 vssd1 vccd1 sky130_fd_sc_hd__tapvpwrvgnd_1
XFILLER_59_111 vssd1 vssd1 vccd1 vccd1 sky130_fd_sc_hd__fill_1
XFILLER_74_169 vssd1 vssd1 vccd1 vccd1 sky130_fd_sc_hd__fill_2
XFILLER_74_158 vssd1 vssd1 vccd1 vccd1 sky130_fd_sc_hd__fill_1
XFILLER_15_225 vccd1 vssd1 vccd1 vssd1 sky130_ef_sc_hd__decap_40_12
XFILLER_70_375 vssd1 vssd1 vccd1 vccd1 sky130_fd_sc_hd__fill_1
XANTENNA_fanout9_X net9 vssd1 vssd1 vccd1 vccd1 sky130_fd_sc_hd__diode_2
XANTENNA__1843__S net29 vssd1 vssd1 vccd1 vccd1 sky130_fd_sc_hd__diode_2
XANTENNA__2939__S MATMULT_INST.matmult_inst.spi_inst.rx_done_sys vssd1 vssd1 vccd1
+ vccd1 sky130_fd_sc_hd__diode_2
XFILLER_78_442 vccd1 vssd1 vccd1 vssd1 sky130_ef_sc_hd__decap_40_12
XFILLER_2_195 vssd1 vssd1 vccd1 vccd1 sky130_fd_sc_hd__fill_1
X_2090_ _0641_ _0642_ vssd1 vssd1 vccd1 vccd1 _0643_ sky130_fd_sc_hd__nand2b_1
XFILLER_38_339 vssd1 vssd1 vccd1 vccd1 sky130_fd_sc_hd__fill_1
XFILLER_21_217 vssd1 vssd1 vccd1 vccd1 sky130_fd_sc_hd__fill_4
X_2992_ MATMULT_INST.matmult_inst.mem_inst.mem2\[11\] net87 net79 MATMULT_INST.matmult_inst.mem_inst.mem1\[11\]
+ _1415_ vssd1 vssd1 vccd1 vccd1 _1416_ sky130_fd_sc_hd__a221o_1
X_1943_ _0529_ _0531_ vssd1 vssd1 vccd1 vccd1 _0532_ sky130_fd_sc_hd__xnor2_1
X_1874_ _0480_ _0510_ vssd1 vssd1 vccd1 vccd1 _0518_ sky130_fd_sc_hd__nor2_1
XANTENNA__1753__S net20 vssd1 vssd1 vccd1 vccd1 sky130_fd_sc_hd__diode_2
X_3475_ clknet_leaf_18_clk _0419_ net130 vssd1 vssd1 vccd1 vccd1 MATMULT_INST.matmult_inst.mem_inst.matrixB3\[11\]
+ sky130_fd_sc_hd__dfrtp_1
X_2426_ net157 MATMULT_INST.matmult_inst.mem_inst.mem0\[0\] MATMULT_INST.matmult_inst.mem_inst.matrixB0\[0\]
+ net163 vssd1 vssd1 vccd1 vccd1 _0943_ sky130_fd_sc_hd__a22o_1
X_2357_ net228 net215 net213 net229 vssd1 vssd1 vccd1 vccd1 _0901_ sky130_fd_sc_hd__a22o_1
X_2288_ _0828_ _0832_ _0833_ vssd1 vssd1 vccd1 vccd1 _0835_ sky130_fd_sc_hd__and3_1
XFILLER_44_27 vssd1 vssd1 vccd1 vccd1 sky130_fd_sc_hd__fill_1
XANTENNA__2842__B1 net187 vssd1 vssd1 vccd1 vccd1 sky130_fd_sc_hd__diode_2
XFILLER_20_250 vssd1 vssd1 vccd1 vccd1 sky130_fd_sc_hd__fill_2
XANTENNA__1928__S net54 vssd1 vssd1 vccd1 vccd1 sky130_fd_sc_hd__diode_2
XFILLER_60_37 vssd1 vssd1 vccd1 vccd1 sky130_fd_sc_hd__fill_1
XFILLER_20_272 vssd1 vssd1 vccd1 vccd1 sky130_fd_sc_hd__fill_1
XTAP_TAPCELL_ROW_50_598 vssd1 vccd1 sky130_fd_sc_hd__tapvpwrvgnd_1
XTAP_TAPCELL_ROW_7_232 vssd1 vccd1 sky130_fd_sc_hd__tapvpwrvgnd_1
XPHY_EDGE_ROW_8_Left_88 vssd1 vssd1 vccd1 vccd1 sky130_fd_sc_hd__decap_3
XFILLER_75_423 vssd1 vssd1 vccd1 vccd1 sky130_fd_sc_hd__fill_2
XFILLER_75_467 vccd1 vssd1 vccd1 vssd1 sky130_ef_sc_hd__decap_40_12
XFILLER_18_61 vccd1 vssd1 vccd1 vssd1 sky130_ef_sc_hd__decap_40_12
XTAP_TAPCELL_ROW_58_665 vssd1 vccd1 sky130_fd_sc_hd__tapvpwrvgnd_1
XFILLER_62_139 vssd1 vssd1 vccd1 vccd1 sky130_fd_sc_hd__fill_1
XTAP_TAPCELL_ROW_41_521 vssd1 vccd1 sky130_fd_sc_hd__tapvpwrvgnd_1
XANTENNA__1838__S net29 vssd1 vssd1 vccd1 vccd1 sky130_fd_sc_hd__diode_2
XFILLER_11_261 vccd1 vssd1 vccd1 vssd1 sky130_ef_sc_hd__decap_40_12
XFILLER_7_221 vssd1 vssd1 vccd1 vccd1 sky130_fd_sc_hd__fill_2
X_1590_ _1506_ _1507_ _1505_ vssd1 vssd1 vccd1 vccd1 _1508_ sky130_fd_sc_hd__o21bai_1
XFILLER_3_493 vssd1 vssd1 vccd1 vccd1 sky130_fd_sc_hd__fill_1
X_3260_ clknet_leaf_21_clk _0218_ net118 vssd1 vssd1 vccd1 vccd1 MATMULT_INST.matmult_inst.mem_inst.mem0\[13\]
+ sky130_fd_sc_hd__dfrtp_1
X_2211_ _0709_ _0710_ _0708_ vssd1 vssd1 vccd1 vccd1 _0760_ sky130_fd_sc_hd__o21bai_1
X_3191_ clknet_leaf_23_clk _0149_ net115 vssd1 vssd1 vccd1 vccd1 MATMULT_INST.matmult_inst.mem_inst.mem2\[16\]
+ sky130_fd_sc_hd__dfrtp_1
X_2142_ net239 net217 net237 MATMULT_INST.matmult_inst.alu_inst.a0_reg\[4\] vssd1
+ vssd1 vccd1 vccd1 _0693_ sky130_fd_sc_hd__a22oi_1
X_2073_ _0625_ _0626_ _0615_ vssd1 vssd1 vccd1 vccd1 _0627_ sky130_fd_sc_hd__a21oi_1
X_2975_ net165 _1399_ _1400_ _1395_ vssd1 vssd1 vccd1 vccd1 _1401_ sky130_fd_sc_hd__a211o_1
XANTENNA__1748__S net21 vssd1 vssd1 vccd1 vccd1 sky130_fd_sc_hd__diode_2
X_1926_ net218 net507 net54 vssd1 vssd1 vccd1 vccd1 _0254_ sky130_fd_sc_hd__mux2_1
X_1857_ net526 net38 net13 vssd1 vssd1 vccd1 vccd1 _0188_ sky130_fd_sc_hd__mux2_1
X_3527_ net242 _0005_ net125 vssd1 vssd1 vccd1 vccd1 MATMULT_INST.matmult_inst.spi_inst.miso_bit
+ sky130_fd_sc_hd__dfrtp_1
X_1788_ net620 _0493_ net30 vssd1 vssd1 vccd1 vccd1 _0123_ sky130_fd_sc_hd__mux2_1
X_3458_ _0037_ _0403_ net140 vssd1 vssd1 vccd1 vccd1 MATMULT_INST.matmult_inst.spi_inst.mosi_shifter\[2\]
+ sky130_fd_sc_hd__dfrtp_1
XFILLER_76_209 vssd1 vssd1 vccd1 vccd1 sky130_fd_sc_hd__fill_4
XTAP_TAPCELL_ROW_4_202 vssd1 vccd1 sky130_fd_sc_hd__tapvpwrvgnd_1
X_3389_ clknet_leaf_28_clk _0343_ net96 vssd1 vssd1 vccd1 vccd1 MATMULT_INST.matmult_inst.alu_inst.col0\[3\]
+ sky130_fd_sc_hd__dfrtp_1
X_2409_ _1518_ _1527_ _0478_ vssd1 vssd1 vccd1 vccd1 _0931_ sky130_fd_sc_hd__and3_1
XFILLER_71_47 vssd1 vssd1 vccd1 vccd1 sky130_fd_sc_hd__fill_1
XFILLER_71_14 vssd1 vssd1 vccd1 vccd1 sky130_fd_sc_hd__fill_1
XANTENNA_fanout22_A _0505_ vssd1 vssd1 vccd1 vccd1 sky130_fd_sc_hd__diode_2
XANTENNA__2343__A net230 vssd1 vssd1 vccd1 vccd1 sky130_fd_sc_hd__diode_2
XTAP_TAPCELL_ROW_10_259 vssd1 vccd1 sky130_fd_sc_hd__tapvpwrvgnd_1
XFILLER_20_62 vssd1 vssd1 vccd1 vccd1 sky130_fd_sc_hd__fill_1
XFILLER_20_73 vssd1 vssd1 vccd1 vccd1 sky130_fd_sc_hd__fill_8
XFILLER_75_220 vssd1 vssd1 vccd1 vccd1 sky130_fd_sc_hd__fill_4
XFILLER_0_485 vssd1 vssd1 vccd1 vccd1 sky130_fd_sc_hd__fill_2
Xhold71 MATMULT_INST.matmult_inst.mem_inst.matrixB3\[8\] vssd1 vssd1 vccd1 vccd1 net384
+ sky130_fd_sc_hd__dlygate4sd3_1
Xhold60 MATMULT_INST.matmult_inst.mem_inst.matrixA3\[2\] vssd1 vssd1 vccd1 vccd1 net373
+ sky130_fd_sc_hd__dlygate4sd3_1
Xhold82 MATMULT_INST.matmult_inst.alu_inst.col1\[0\] vssd1 vssd1 vccd1 vccd1 net395
+ sky130_fd_sc_hd__dlygate4sd3_1
XANTENNA__2518__A net182 vssd1 vssd1 vccd1 vccd1 sky130_fd_sc_hd__diode_2
XANTENNA__3059__B1 net79 vssd1 vssd1 vccd1 vccd1 sky130_fd_sc_hd__diode_2
Xhold93 MATMULT_INST.matmult_inst.mem_inst.matrixA0\[1\] vssd1 vssd1 vccd1 vccd1 net406
+ sky130_fd_sc_hd__dlygate4sd3_1
XTAP_TAPCELL_ROW_18_326 vssd1 vccd1 sky130_fd_sc_hd__tapvpwrvgnd_1
XFILLER_45_81 vssd1 vssd1 vccd1 vccd1 sky130_fd_sc_hd__fill_1
XANTENNA__2952__S net58 vssd1 vssd1 vccd1 vccd1 sky130_fd_sc_hd__diode_2
XTAP_TAPCELL_ROW_26_392 vssd1 vccd1 sky130_fd_sc_hd__tapvpwrvgnd_1
X_2760_ _1228_ _1229_ _1230_ vssd1 vssd1 vccd1 vccd1 _1231_ sky130_fd_sc_hd__and3_1
X_1711_ MATMULT_INST.matmult_inst.fsm_inst.alu_result\[16\] net60 vssd1 vssd1 vccd1
+ vccd1 _0501_ sky130_fd_sc_hd__and2_1
X_2691_ _1162_ _1163_ vssd1 vssd1 vccd1 vccd1 _1164_ sky130_fd_sc_hd__nor2_1
X_1642_ MATMULT_INST.matmult_inst.alu_inst.complete _0454_ vssd1 vssd1 vccd1 vccd1
+ _0473_ sky130_fd_sc_hd__and2_1
XFILLER_6_53 vccd1 vssd1 vccd1 vssd1 sky130_ef_sc_hd__decap_40_12
X_1573_ MATMULT_INST.matmult_inst.spi_inst.rx_bit_count\[0\] MATMULT_INST.matmult_inst.spi_inst.rx_bit_count\[3\]
+ vssd1 vssd1 vccd1 vccd1 _1494_ sky130_fd_sc_hd__nand2b_1
XFILLER_6_97 vccd1 vssd1 vccd1 vssd1 sky130_ef_sc_hd__decap_40_12
X_3312_ clknet_leaf_26_clk _0270_ net100 vssd1 vssd1 vccd1 vccd1 MATMULT_INST.matmult_inst.alu_inst.out\[12\]
+ sky130_fd_sc_hd__dfrtp_1
X_3243_ clknet_leaf_26_clk _0201_ net98 vssd1 vssd1 vccd1 vccd1 MATMULT_INST.matmult_inst.mem_inst.matrixB2\[14\]
+ sky130_fd_sc_hd__dfrtp_1
X_3174_ clknet_leaf_21_clk _0132_ net124 vssd1 vssd1 vccd1 vccd1 MATMULT_INST.matmult_inst.mem_inst.matrixB1\[17\]
+ sky130_fd_sc_hd__dfrtp_1
X_2125_ _0655_ _0656_ _0634_ vssd1 vssd1 vccd1 vccd1 _0676_ sky130_fd_sc_hd__a21o_1
XFILLER_26_128 vssd1 vssd1 vccd1 vccd1 sky130_fd_sc_hd__fill_1
XANTENNA__2428__A net181 vssd1 vssd1 vccd1 vccd1 sky130_fd_sc_hd__diode_2
X_2056_ net240 net226 net224 MATMULT_INST.matmult_inst.alu_inst.b0_reg\[0\] vssd1
+ vssd1 vccd1 vccd1 _0612_ sky130_fd_sc_hd__and4_1
XTAP_TAPCELL_ROW_52_616 vssd1 vccd1 sky130_fd_sc_hd__tapvpwrvgnd_1
XANTENNA_fanout157_A net159 vssd1 vssd1 vccd1 vccd1 sky130_fd_sc_hd__diode_2
X_2958_ net179 net170 MATMULT_INST.matmult_inst.mem_inst.matrixA3\[8\] vssd1 vssd1
+ vccd1 vccd1 _1385_ sky130_fd_sc_hd__and3_1
XTAP_TAPCELL_ROW_60_682 vssd1 vccd1 sky130_fd_sc_hd__tapvpwrvgnd_1
X_1909_ net609 _0500_ net26 vssd1 vssd1 vccd1 vccd1 _0238_ sky130_fd_sc_hd__mux2_1
X_2889_ _1354_ _1355_ net662 net68 vssd1 vssd1 vccd1 vccd1 _0382_ sky130_fd_sc_hd__a2bb2o_1
XANTENNA__2450__X _0966_ vssd1 vssd1 vccd1 vccd1 sky130_fd_sc_hd__diode_2
XFILLER_1_205 vccd1 vssd1 vccd1 vssd1 sky130_ef_sc_hd__decap_40_12
XFILLER_1_249 vccd1 vssd1 vccd1 vssd1 sky130_ef_sc_hd__decap_40_12
XANTENNA__2500__A2 _0954_ vssd1 vssd1 vccd1 vccd1 sky130_fd_sc_hd__diode_2
XFILLER_72_234 vssd1 vssd1 vccd1 vccd1 sky130_fd_sc_hd__fill_2
XFILLER_9_305 vccd1 vssd1 vccd1 vssd1 sky130_ef_sc_hd__decap_40_12
XANTENNA_fanout25_X net25 vssd1 vssd1 vccd1 vccd1 sky130_fd_sc_hd__diode_2
XFILLER_13_389 vssd1 vssd1 vccd1 vccd1 sky130_fd_sc_hd__fill_2
XFILLER_9_349 vccd1 vssd1 vccd1 vssd1 sky130_ef_sc_hd__decap_40_12
XANTENNA__2947__S net58 vssd1 vssd1 vccd1 vccd1 sky130_fd_sc_hd__diode_2
XANTENNA__1851__S net28 vssd1 vssd1 vccd1 vccd1 sky130_fd_sc_hd__diode_2
XFILLER_0_293 vccd1 vssd1 vccd1 vssd1 sky130_ef_sc_hd__decap_40_12
XANTENNA__2893__D net184 vssd1 vssd1 vccd1 vccd1 sky130_fd_sc_hd__diode_2
XANTENNA__2248__A net213 vssd1 vssd1 vccd1 vccd1 sky130_fd_sc_hd__diode_2
XFILLER_63_223 vssd1 vssd1 vccd1 vccd1 sky130_fd_sc_hd__fill_1
XFILLER_63_234 vssd1 vssd1 vccd1 vccd1 sky130_fd_sc_hd__fill_2
XFILLER_31_164 vssd1 vssd1 vccd1 vccd1 sky130_fd_sc_hd__fill_1
X_2812_ net69 _1281_ _1244_ vssd1 vssd1 vccd1 vccd1 _0379_ sky130_fd_sc_hd__a21oi_1
X_2743_ _1211_ _1212_ _1171_ vssd1 vssd1 vccd1 vccd1 _1214_ sky130_fd_sc_hd__a21o_1
X_2674_ _1145_ _1146_ vssd1 vssd1 vccd1 vccd1 _1147_ sky130_fd_sc_hd__or2_1
X_1625_ MATMULT_INST.matmult_inst.fsm_inst.count\[1\] MATMULT_INST.matmult_inst.fsm_inst.count\[0\]
+ vssd1 vssd1 vccd1 vccd1 _0459_ sky130_fd_sc_hd__nand2_1
X_1556_ MATMULT_INST.matmult_inst.spi_inst.rx_bit_count\[3\] MATMULT_INST.matmult_inst.spi_inst.rx_bit_count\[0\]
+ vssd1 vssd1 vccd1 vccd1 _1489_ sky130_fd_sc_hd__and2b_1
XANTENNA__1761__S net19 vssd1 vssd1 vccd1 vccd1 sky130_fd_sc_hd__diode_2
X_3226_ clknet_leaf_21_clk _0184_ net125 vssd1 vssd1 vccd1 vccd1 MATMULT_INST.matmult_inst.mem_inst.mem1\[15\]
+ sky130_fd_sc_hd__dfrtp_1
XFILLER_54_201 vssd1 vssd1 vccd1 vccd1 sky130_fd_sc_hd__fill_1
X_3157_ clknet_leaf_15_clk _0115_ net143 vssd1 vssd1 vccd1 vccd1 MATMULT_INST.matmult_inst.mem_inst.matrixB1\[0\]
+ sky130_fd_sc_hd__dfrtp_1
X_2108_ _0636_ _0659_ _0658_ vssd1 vssd1 vccd1 vccd1 _0660_ sky130_fd_sc_hd__a21o_1
XFILLER_27_459 vssd1 vssd1 vccd1 vccd1 sky130_fd_sc_hd__fill_1
XFILLER_54_245 vssd1 vssd1 vccd1 vccd1 sky130_fd_sc_hd__fill_2
X_3088_ clknet_leaf_14_clk _0046_ net144 vssd1 vssd1 vccd1 vccd1 MATMULT_INST.matmult_inst.mem_inst.matrixB0\[3\]
+ sky130_fd_sc_hd__dfrtp_1
XFILLER_35_470 vssd1 vssd1 vccd1 vccd1 sky130_fd_sc_hd__fill_1
XTAP_TAPCELL_ROW_37_487 vssd1 vccd1 sky130_fd_sc_hd__tapvpwrvgnd_1
X_2039_ net204 net500 net55 vssd1 vssd1 vccd1 vccd1 _0280_ sky130_fd_sc_hd__mux2_1
XFILLER_22_197 vccd1 vssd1 vccd1 vssd1 sky130_ef_sc_hd__decap_40_12
XTAP_TAPCELL_ROW_20_343 vssd1 vccd1 sky130_fd_sc_hd__tapvpwrvgnd_1
Xhold360 MATMULT_INST.matmult_inst.fsm_inst.count\[2\] vssd1 vssd1 vccd1 vccd1 net673
+ sky130_fd_sc_hd__dlygate4sd3_1
XANTENNA__2721__A2 net186 vssd1 vssd1 vccd1 vccd1 sky130_fd_sc_hd__diode_2
XFILLER_77_326 vssd1 vssd1 vccd1 vccd1 sky130_fd_sc_hd__fill_2
XFILLER_77_57 vssd1 vssd1 vccd1 vccd1 sky130_fd_sc_hd__fill_8
XANTENNA__2068__A net239 vssd1 vssd1 vccd1 vccd1 sky130_fd_sc_hd__diode_2
XANTENNA__2485__B2 net160 vssd1 vssd1 vccd1 vccd1 sky130_fd_sc_hd__diode_2
XANTENNA__2485__A1 net155 vssd1 vssd1 vccd1 vccd1 sky130_fd_sc_hd__diode_2
XTAP_TAPCELL_ROW_28_410 vssd1 vccd1 sky130_fd_sc_hd__tapvpwrvgnd_1
XFILLER_45_256 vssd1 vssd1 vccd1 vccd1 sky130_fd_sc_hd__fill_1
XFILLER_26_83 vssd1 vssd1 vccd1 vccd1 sky130_fd_sc_hd__fill_1
XFILLER_26_470 vssd1 vssd1 vccd1 vccd1 sky130_fd_sc_hd__fill_1
XTAP_TAPCELL_ROW_71_777 vssd1 vccd1 sky130_fd_sc_hd__tapvpwrvgnd_1
XFILLER_9_113 vccd1 vssd1 vccd1 vssd1 sky130_ef_sc_hd__decap_40_12
XANTENNA__1846__S net28 vssd1 vssd1 vccd1 vccd1 sky130_fd_sc_hd__diode_2
XFILLER_5_385 vssd1 vssd1 vccd1 vccd1 sky130_fd_sc_hd__fill_4
XANTENNA__2712__A2 net192 vssd1 vssd1 vccd1 vccd1 sky130_fd_sc_hd__diode_2
X_2390_ net661 net63 net42 MATMULT_INST.matmult_inst.fsm_inst.alu_result\[6\] vssd1
+ vssd1 vccd1 vccd1 _0315_ sky130_fd_sc_hd__a22o_1
XANTENNA__1920__A0 net230 vssd1 vssd1 vccd1 vccd1 sky130_fd_sc_hd__diode_2
XTAP_TAPCELL_ROW_79_855 vssd1 vccd1 sky130_fd_sc_hd__tapvpwrvgnd_1
XTAP_TAPCELL_ROW_79_844 vssd1 vccd1 sky130_fd_sc_hd__tapvpwrvgnd_1
X_3011_ net178 net169 MATMULT_INST.matmult_inst.mem_inst.matrixA3\[13\] vssd1 vssd1
+ vccd1 vccd1 _1433_ sky130_fd_sc_hd__and3_1
XTAP_TAPCELL_ROW_62_700 vssd1 vccd1 sky130_fd_sc_hd__tapvpwrvgnd_1
XTAP_TAPCELL_ROW_34_457 vssd1 vccd1 sky130_fd_sc_hd__tapvpwrvgnd_1
XFILLER_22_19 vssd1 vssd1 vccd1 vccd1 sky130_fd_sc_hd__fill_1
XANTENNA__1756__S net20 vssd1 vssd1 vccd1 vccd1 sky130_fd_sc_hd__diode_2
X_2726_ _1192_ _1195_ vssd1 vssd1 vccd1 vccd1 _1198_ sky130_fd_sc_hd__xor2_1
XANTENNA__2160__B net235 vssd1 vssd1 vccd1 vccd1 sky130_fd_sc_hd__diode_2
X_2657_ _1125_ _1129_ vssd1 vssd1 vccd1 vccd1 _1130_ sky130_fd_sc_hd__nor2_1
X_1608_ _1525_ _1523_ _1519_ _1518_ vssd1 vssd1 vccd1 vccd1 _1526_ sky130_fd_sc_hd__and4b_1
Xfanout103 net152 vssd1 vssd1 vccd1 vccd1 net103 sky130_fd_sc_hd__clkbuf_2
X_2588_ net447 net68 _1066_ vssd1 vssd1 vccd1 vccd1 _0370_ sky130_fd_sc_hd__a21o_1
Xfanout147 net148 vssd1 vssd1 vccd1 vccd1 net147 sky130_fd_sc_hd__clkbuf_4
X_1539_ net667 vssd1 vssd1 vccd1 vccd1 MATMULT_INST.matmult_inst.fsm_inst.tx_ready
+ sky130_fd_sc_hd__inv_2
Xfanout114 net152 vssd1 vssd1 vccd1 vccd1 net114 sky130_fd_sc_hd__clkbuf_2
Xfanout125 net132 vssd1 vssd1 vccd1 vccd1 net125 sky130_fd_sc_hd__buf_2
Xfanout136 net142 vssd1 vssd1 vccd1 vccd1 net136 sky130_fd_sc_hd__clkbuf_2
Xfanout169 net171 vssd1 vssd1 vccd1 vccd1 net169 sky130_fd_sc_hd__buf_2
XFILLER_47_27 vssd1 vssd1 vccd1 vccd1 sky130_fd_sc_hd__fill_1
Xfanout158 net159 vssd1 vssd1 vccd1 vccd1 net158 sky130_fd_sc_hd__buf_2
XFILLER_74_307 vssd1 vssd1 vccd1 vccd1 sky130_fd_sc_hd__fill_1
X_3209_ clknet_leaf_23_clk _0167_ net115 vssd1 vssd1 vccd1 vccd1 MATMULT_INST.matmult_inst.mem_inst.matrixA3\[16\]
+ sky130_fd_sc_hd__dfrtp_1
XFILLER_47_38 vssd1 vssd1 vccd1 vccd1 sky130_fd_sc_hd__fill_2
XFILLER_27_245 vssd1 vssd1 vccd1 vccd1 sky130_fd_sc_hd__fill_1
XFILLER_23_484 vssd1 vssd1 vccd1 vccd1 sky130_fd_sc_hd__fill_1
XFILLER_10_189 vssd1 vssd1 vccd1 vccd1 sky130_fd_sc_hd__fill_4
XANTENNA__1893__C net81 vssd1 vssd1 vccd1 vccd1 sky130_fd_sc_hd__diode_2
XFILLER_12_85 vssd1 vssd1 vccd1 vccd1 sky130_fd_sc_hd__fill_1
XANTENNA_fanout92_X net92 vssd1 vssd1 vccd1 vccd1 sky130_fd_sc_hd__diode_2
XFILLER_2_333 vccd1 vssd1 vccd1 vssd1 sky130_ef_sc_hd__decap_40_12
XFILLER_2_377 vccd1 vssd1 vccd1 vssd1 sky130_ef_sc_hd__decap_40_12
Xhold190 MATMULT_INST.matmult_inst.alu_inst.out\[7\] vssd1 vssd1 vccd1 vccd1 net503
+ sky130_fd_sc_hd__dlygate4sd3_1
XTAP_TAPCELL_ROW_76_814 vssd1 vccd1 sky130_fd_sc_hd__tapvpwrvgnd_1
XFILLER_73_351 vssd1 vssd1 vccd1 vccd1 sky130_fd_sc_hd__fill_4
XPHY_EDGE_ROW_16_Right_16 vssd1 vssd1 vccd1 vccd1 sky130_fd_sc_hd__decap_3
XFILLER_73_384 vssd1 vssd1 vccd1 vccd1 sky130_fd_sc_hd__fill_4
XFILLER_33_215 vssd1 vssd1 vccd1 vccd1 sky130_fd_sc_hd__fill_1
XANTENNA__1681__A2 net59 vssd1 vssd1 vccd1 vccd1 sky130_fd_sc_hd__diode_2
XFILLER_14_473 vssd1 vssd1 vccd1 vccd1 sky130_fd_sc_hd__fill_1
X_1890_ net632 net45 net10 vssd1 vssd1 vccd1 vccd1 _0220_ sky130_fd_sc_hd__mux2_1
XTAP_TAPCELL_ROW_31_438 vssd1 vccd1 sky130_fd_sc_hd__tapvpwrvgnd_1
XPHY_EDGE_ROW_25_Right_25 vssd1 vssd1 vccd1 vccd1 sky130_fd_sc_hd__decap_3
X_2511_ net75 _1021_ vssd1 vssd1 vccd1 vccd1 _1022_ sky130_fd_sc_hd__and2_2
X_3491_ clknet_leaf_10_clk MATMULT_INST.matmult_inst.spi_inst.next_state net141 vssd1
+ vssd1 vccd1 vccd1 MATMULT_INST.matmult_inst.spi_inst.current_state sky130_fd_sc_hd__dfrtp_1
XFILLER_5_193 vccd1 vssd1 vccd1 vssd1 sky130_ef_sc_hd__decap_40_12
XFILLER_45_3 vccd1 vssd1 vccd1 vssd1 sky130_ef_sc_hd__decap_40_12
X_2442_ net157 MATMULT_INST.matmult_inst.mem_inst.mem0\[1\] MATMULT_INST.matmult_inst.mem_inst.matrixB0\[1\]
+ net162 vssd1 vssd1 vccd1 vccd1 _0958_ sky130_fd_sc_hd__a22o_1
X_2373_ net228 MATMULT_INST.matmult_inst.alu_inst.a0_reg\[7\] _0888_ vssd1 vssd1 vccd1
+ vccd1 _0916_ sky130_fd_sc_hd__and3_1
XFILLER_68_189 vssd1 vssd1 vccd1 vccd1 sky130_fd_sc_hd__fill_2
XTAP_TAPCELL_ROW_39_505 vssd1 vccd1 sky130_fd_sc_hd__tapvpwrvgnd_1
XFILLER_56_307 vssd1 vssd1 vccd1 vccd1 sky130_fd_sc_hd__fill_1
XPHY_EDGE_ROW_34_Right_34 vssd1 vssd1 vccd1 vccd1 sky130_fd_sc_hd__decap_3
XANTENNA__3031__S net57 vssd1 vssd1 vccd1 vccd1 sky130_fd_sc_hd__diode_2
XTAP_TAPCELL_ROW_47_571 vssd1 vccd1 sky130_fd_sc_hd__tapvpwrvgnd_1
XFILLER_24_237 vssd1 vssd1 vccd1 vccd1 sky130_fd_sc_hd__fill_2
XFILLER_32_281 vssd1 vssd1 vccd1 vccd1 sky130_fd_sc_hd__fill_1
XANTENNA_fanout237_A net238 vssd1 vssd1 vccd1 vccd1 sky130_fd_sc_hd__diode_2
XPHY_EDGE_ROW_43_Right_43 vssd1 vssd1 vccd1 vccd1 sky130_fd_sc_hd__decap_3
X_2709_ _1177_ _1178_ _1180_ vssd1 vssd1 vccd1 vccd1 _1181_ sky130_fd_sc_hd__a21o_1
XPHY_EDGE_ROW_52_Right_52 vssd1 vssd1 vccd1 vccd1 sky130_fd_sc_hd__decap_3
XFILLER_74_25 vssd1 vssd1 vccd1 vccd1 sky130_fd_sc_hd__fill_2
XFILLER_59_189 vssd1 vssd1 vccd1 vccd1 sky130_fd_sc_hd__fill_1
XFILLER_74_47 vssd1 vssd1 vccd1 vccd1 sky130_fd_sc_hd__fill_2
XTAP_TAPCELL_ROW_2_185 vssd1 vccd1 sky130_fd_sc_hd__tapvpwrvgnd_1
XANTENNA__2346__A net228 vssd1 vssd1 vccd1 vccd1 sky130_fd_sc_hd__diode_2
XFILLER_15_237 vssd1 vssd1 vccd1 vccd1 sky130_fd_sc_hd__fill_4
XPHY_EDGE_ROW_61_Right_61 vssd1 vssd1 vccd1 vccd1 sky130_fd_sc_hd__decap_3
XFILLER_23_51 vssd1 vssd1 vccd1 vccd1 sky130_fd_sc_hd__fill_1
XFILLER_7_447 vssd1 vssd1 vccd1 vccd1 sky130_fd_sc_hd__fill_1
XPHY_EDGE_ROW_70_Right_70 vssd1 vssd1 vccd1 vccd1 sky130_fd_sc_hd__decap_3
XFILLER_2_141 vccd1 vssd1 vccd1 vssd1 sky130_ef_sc_hd__decap_40_12
XFILLER_78_454 vccd1 vssd1 vccd1 vssd1 sky130_ef_sc_hd__decap_40_12
XFILLER_38_307 vssd1 vssd1 vccd1 vccd1 sky130_fd_sc_hd__fill_1
XFILLER_48_81 vssd1 vssd1 vccd1 vccd1 sky130_fd_sc_hd__fill_1
XFILLER_65_137 vssd1 vssd1 vccd1 vccd1 sky130_fd_sc_hd__fill_1
XFILLER_0_77 vssd1 vssd1 vccd1 vccd1 sky130_fd_sc_hd__fill_2
X_2991_ net179 net170 MATMULT_INST.matmult_inst.mem_inst.mem3\[11\] vssd1 vssd1 vccd1
+ vccd1 _1415_ sky130_fd_sc_hd__and3_1
XFILLER_21_229 vssd1 vssd1 vccd1 vccd1 sky130_fd_sc_hd__fill_2
X_1942_ _0523_ _0530_ vssd1 vssd1 vccd1 vccd1 _0531_ sky130_fd_sc_hd__or2_1
X_1873_ net472 net43 net12 vssd1 vssd1 vccd1 vccd1 _0204_ sky130_fd_sc_hd__mux2_1
X_3474_ clknet_leaf_17_clk _0418_ net121 vssd1 vssd1 vccd1 vccd1 MATMULT_INST.matmult_inst.mem_inst.matrixB3\[10\]
+ sky130_fd_sc_hd__dfrtp_1
X_2425_ MATMULT_INST.matmult_inst.mem_inst.matrixB2\[0\] net91 net83 MATMULT_INST.matmult_inst.mem_inst.matrixB1\[0\]
+ _0941_ vssd1 vssd1 vccd1 vccd1 _0942_ sky130_fd_sc_hd__a221o_1
XFILLER_28_29 vssd1 vssd1 vccd1 vccd1 sky130_fd_sc_hd__fill_8
X_2356_ _0883_ _0884_ _0893_ vssd1 vssd1 vccd1 vccd1 _0900_ sky130_fd_sc_hd__a21o_1
X_2287_ _0832_ _0833_ _0828_ vssd1 vssd1 vccd1 vccd1 _0834_ sky130_fd_sc_hd__a21oi_1
XANTENNA__2437__Y _0954_ vssd1 vssd1 vccd1 vccd1 sky130_fd_sc_hd__diode_2
XANTENNA__2166__A net241 vssd1 vssd1 vccd1 vccd1 sky130_fd_sc_hd__diode_2
XANTENNA__2842__A1 net189 vssd1 vssd1 vccd1 vccd1 sky130_fd_sc_hd__diode_2
XANTENNA__2842__B2 net201 vssd1 vssd1 vccd1 vccd1 sky130_fd_sc_hd__diode_2
XFILLER_64_181 vccd1 vssd1 vccd1 vssd1 sky130_ef_sc_hd__decap_40_12
XANTENNA_fanout142_X net142 vssd1 vssd1 vccd1 vccd1 sky130_fd_sc_hd__diode_2
XFILLER_60_27 vssd1 vssd1 vccd1 vccd1 sky130_fd_sc_hd__fill_1
XTAP_TAPCELL_ROW_50_599 vssd1 vccd1 sky130_fd_sc_hd__tapvpwrvgnd_1
XANTENNA_clkbuf_leaf_7_clk_A clknet_2_1__leaf_clk vssd1 vssd1 vccd1 vccd1 sky130_fd_sc_hd__diode_2
XFILLER_4_417 vssd1 vssd1 vccd1 vccd1 sky130_fd_sc_hd__fill_2
XTAP_TAPCELL_ROW_7_233 vssd1 vccd1 sky130_fd_sc_hd__tapvpwrvgnd_1
XFILLER_75_413 vssd1 vssd1 vccd1 vccd1 sky130_fd_sc_hd__fill_4
XANTENNA__2530__A0 _0988_ vssd1 vssd1 vccd1 vccd1 sky130_fd_sc_hd__diode_2
XFILLER_47_137 vccd1 vssd1 vccd1 vssd1 sky130_ef_sc_hd__decap_40_12
XFILLER_75_479 vccd1 vssd1 vccd1 vssd1 sky130_ef_sc_hd__decap_40_12
XFILLER_47_159 vssd1 vssd1 vccd1 vccd1 sky130_fd_sc_hd__fill_1
XTAP_TAPCELL_ROW_58_666 vssd1 vccd1 sky130_fd_sc_hd__tapvpwrvgnd_1
XANTENNA_fanout55_X net55 vssd1 vssd1 vccd1 vccd1 sky130_fd_sc_hd__diode_2
XFILLER_18_95 vssd1 vssd1 vccd1 vccd1 sky130_fd_sc_hd__fill_1
XFILLER_18_73 vssd1 vssd1 vccd1 vccd1 sky130_fd_sc_hd__fill_8
XFILLER_62_107 vccd1 vssd1 vccd1 vssd1 sky130_ef_sc_hd__decap_40_12
XFILLER_70_151 vssd1 vssd1 vccd1 vccd1 sky130_fd_sc_hd__fill_4
XFILLER_70_195 vssd1 vssd1 vccd1 vccd1 sky130_fd_sc_hd__fill_1
XTAP_TAPCELL_ROW_41_522 vssd1 vccd1 sky130_fd_sc_hd__tapvpwrvgnd_1
XFILLER_34_83 vssd1 vssd1 vccd1 vccd1 sky130_fd_sc_hd__fill_1
XTAP_TAPCELL_ROW_13_279 vssd1 vccd1 sky130_fd_sc_hd__tapvpwrvgnd_1
XFILLER_11_273 vssd1 vssd1 vccd1 vccd1 sky130_fd_sc_hd__fill_4
XANTENNA__2523__B _1032_ vssd1 vssd1 vccd1 vccd1 sky130_fd_sc_hd__diode_2
XFILLER_7_277 vssd1 vssd1 vccd1 vccd1 sky130_fd_sc_hd__fill_2
XANTENNA__1854__S net28 vssd1 vssd1 vccd1 vccd1 sky130_fd_sc_hd__diode_2
XANTENNA__3010__A1 net156 vssd1 vssd1 vccd1 vccd1 sky130_fd_sc_hd__diode_2
XANTENNA__3010__B2 net160 vssd1 vssd1 vccd1 vccd1 sky130_fd_sc_hd__diode_2
XFILLER_3_461 vccd1 vssd1 vccd1 vssd1 sky130_ef_sc_hd__decap_40_12
X_2210_ _0755_ _0756_ _0757_ vssd1 vssd1 vccd1 vccd1 _0759_ sky130_fd_sc_hd__and3_1
XFILLER_78_251 vssd1 vssd1 vccd1 vccd1 sky130_fd_sc_hd__fill_1
X_3190_ clknet_leaf_20_clk _0148_ net124 vssd1 vssd1 vccd1 vccd1 MATMULT_INST.matmult_inst.mem_inst.mem2\[15\]
+ sky130_fd_sc_hd__dfrtp_1
X_2141_ net240 net218 net217 net237 vssd1 vssd1 vccd1 vccd1 _0692_ sky130_fd_sc_hd__and4_1
X_2072_ net226 net236 net237 net224 vssd1 vssd1 vccd1 vccd1 _0626_ sky130_fd_sc_hd__a22o_1
XFILLER_75_90 vssd1 vssd1 vccd1 vccd1 sky130_fd_sc_hd__fill_1
XFILLER_34_365 vssd1 vssd1 vccd1 vccd1 sky130_fd_sc_hd__fill_1
XANTENNA__2714__A net189 vssd1 vssd1 vccd1 vccd1 sky130_fd_sc_hd__diode_2
X_2974_ net160 _1393_ _1397_ net156 vssd1 vssd1 vccd1 vccd1 _1400_ sky130_fd_sc_hd__a22o_1
X_1925_ net220 net617 net54 vssd1 vssd1 vccd1 vccd1 _0253_ sky130_fd_sc_hd__mux2_1
X_1856_ net428 net39 net13 vssd1 vssd1 vccd1 vccd1 _0187_ sky130_fd_sc_hd__mux2_1
XANTENNA__1764__S net18 vssd1 vssd1 vccd1 vccd1 sky130_fd_sc_hd__diode_2
X_1787_ net583 net32 net31 vssd1 vssd1 vccd1 vccd1 _0122_ sky130_fd_sc_hd__mux2_1
X_3526_ clknet_leaf_21_clk _0451_ net125 vssd1 vssd1 vccd1 vccd1 MATMULT_INST.matmult_inst.spi_inst.tx_reg_sys\[17\]
+ sky130_fd_sc_hd__dfrtp_1
X_3457_ _0036_ _0402_ net140 vssd1 vssd1 vccd1 vccd1 MATMULT_INST.matmult_inst.spi_inst.mosi_shifter\[1\]
+ sky130_fd_sc_hd__dfrtp_1
X_2408_ _0455_ _0924_ _0929_ vssd1 vssd1 vccd1 vccd1 _0930_ sky130_fd_sc_hd__nand3_2
XTAP_TAPCELL_ROW_4_203 vssd1 vccd1 sky130_fd_sc_hd__tapvpwrvgnd_1
X_3388_ clknet_leaf_0_clk _0342_ net94 vssd1 vssd1 vccd1 vccd1 MATMULT_INST.matmult_inst.alu_inst.col0\[2\]
+ sky130_fd_sc_hd__dfrtp_1
X_2339_ _0863_ _0865_ _0862_ vssd1 vssd1 vccd1 vccd1 _0884_ sky130_fd_sc_hd__a21o_1
XANTENNA__2512__B1 _1022_ vssd1 vssd1 vccd1 vccd1 sky130_fd_sc_hd__diode_2
XPHY_EDGE_ROW_2_Right_2 vssd1 vssd1 vccd1 vccd1 sky130_fd_sc_hd__decap_3
XTAP_TAPCELL_ROW_55_636 vssd1 vccd1 sky130_fd_sc_hd__tapvpwrvgnd_1
XFILLER_20_85 vssd1 vssd1 vccd1 vccd1 sky130_fd_sc_hd__fill_4
XFILLER_0_475 vssd1 vssd1 vccd1 vccd1 sky130_fd_sc_hd__fill_1
Xhold50 MATMULT_INST.matmult_inst.alu_inst.adder_inst.r2.fa1.b vssd1 vssd1 vccd1 vccd1
+ net363 sky130_fd_sc_hd__dlygate4sd3_1
Xhold83 MATMULT_INST.matmult_inst.alu_inst.col1\[2\] vssd1 vssd1 vccd1 vccd1 net396
+ sky130_fd_sc_hd__dlygate4sd3_1
Xhold72 MATMULT_INST.matmult_inst.mem_inst.matrixA3\[13\] vssd1 vssd1 vccd1 vccd1
+ net385 sky130_fd_sc_hd__dlygate4sd3_1
Xhold61 MATMULT_INST.matmult_inst.mem_inst.mem3\[5\] vssd1 vssd1 vccd1 vccd1 net374
+ sky130_fd_sc_hd__dlygate4sd3_1
XFILLER_48_446 vssd1 vssd1 vccd1 vccd1 sky130_fd_sc_hd__fill_1
XANTENNA__2518__B net173 vssd1 vssd1 vccd1 vccd1 sky130_fd_sc_hd__diode_2
XFILLER_35_107 vssd1 vssd1 vccd1 vccd1 sky130_fd_sc_hd__fill_1
Xhold94 MATMULT_INST.matmult_inst.alu_inst.row1\[4\] vssd1 vssd1 vccd1 vccd1 net407
+ sky130_fd_sc_hd__dlygate4sd3_1
XTAP_TAPCELL_ROW_18_327 vssd1 vccd1 sky130_fd_sc_hd__tapvpwrvgnd_1
XANTENNA__1849__S net28 vssd1 vssd1 vccd1 vccd1 sky130_fd_sc_hd__diode_2
XTAP_TAPCELL_ROW_26_393 vssd1 vccd1 sky130_fd_sc_hd__tapvpwrvgnd_1
XFILLER_77_6 vccd1 vssd1 vccd1 vssd1 sky130_ef_sc_hd__decap_40_12
XPHY_EDGE_ROW_20_Left_100 vssd1 vssd1 vccd1 vccd1 sky130_fd_sc_hd__decap_3
X_1710_ net464 net45 net24 vssd1 vssd1 vccd1 vccd1 _0058_ sky130_fd_sc_hd__mux2_1
XFILLER_61_81 vssd1 vssd1 vccd1 vccd1 sky130_fd_sc_hd__fill_4
X_2690_ _1131_ _1159_ _1160_ vssd1 vssd1 vccd1 vccd1 _1163_ sky130_fd_sc_hd__and3_1
XANTENNA__2990__B1 net79 vssd1 vssd1 vccd1 vccd1 sky130_fd_sc_hd__diode_2
X_1641_ _1526_ _1536_ _0454_ _0462_ vssd1 vssd1 vccd1 vccd1 _0472_ sky130_fd_sc_hd__a211o_1
XFILLER_6_65 vccd1 vssd1 vccd1 vssd1 sky130_ef_sc_hd__decap_40_12
X_1572_ _1490_ _1493_ vssd1 vssd1 vccd1 vccd1 _0388_ sky130_fd_sc_hd__nor2_1
X_3311_ clknet_leaf_25_clk _0269_ net100 vssd1 vssd1 vccd1 vccd1 MATMULT_INST.matmult_inst.alu_inst.out\[11\]
+ sky130_fd_sc_hd__dfrtp_1
X_3242_ clknet_leaf_22_clk _0200_ net117 vssd1 vssd1 vccd1 vccd1 MATMULT_INST.matmult_inst.mem_inst.matrixB2\[13\]
+ sky130_fd_sc_hd__dfrtp_1
X_3173_ clknet_leaf_23_clk _0131_ net115 vssd1 vssd1 vccd1 vccd1 MATMULT_INST.matmult_inst.mem_inst.matrixB1\[16\]
+ sky130_fd_sc_hd__dfrtp_1
X_2124_ net666 _0675_ net70 vssd1 vssd1 vccd1 vccd1 _0297_ sky130_fd_sc_hd__mux2_1
XANTENNA__2428__B net173 vssd1 vssd1 vccd1 vccd1 sky130_fd_sc_hd__diode_2
X_2055_ net240 net226 net224 MATMULT_INST.matmult_inst.alu_inst.b0_reg\[0\] vssd1
+ vssd1 vccd1 vccd1 _0611_ sky130_fd_sc_hd__a22o_1
XTAP_TAPCELL_ROW_52_617 vssd1 vccd1 sky130_fd_sc_hd__tapvpwrvgnd_1
XANTENNA__2444__A net181 vssd1 vssd1 vccd1 vccd1 sky130_fd_sc_hd__diode_2
XFILLER_34_195 vssd1 vssd1 vccd1 vccd1 sky130_fd_sc_hd__fill_1
X_2957_ net179 net170 MATMULT_INST.matmult_inst.mem_inst.mem3\[8\] _1383_ vssd1 vssd1
+ vccd1 vccd1 _1384_ sky130_fd_sc_hd__a31o_1
XTAP_TAPCELL_ROW_60_683 vssd1 vccd1 sky130_fd_sc_hd__tapvpwrvgnd_1
X_1908_ net597 net46 net26 vssd1 vssd1 vccd1 vccd1 _0237_ sky130_fd_sc_hd__mux2_1
X_2888_ _1333_ _1350_ _1353_ net68 vssd1 vssd1 vccd1 vccd1 _1355_ sky130_fd_sc_hd__a31o_1
X_1839_ net487 net37 net29 vssd1 vssd1 vccd1 vccd1 _0171_ sky130_fd_sc_hd__mux2_1
XFILLER_1_217 vssd1 vssd1 vccd1 vccd1 sky130_fd_sc_hd__fill_4
X_3509_ clknet_leaf_8_clk _0434_ net134 vssd1 vssd1 vccd1 vccd1 MATMULT_INST.matmult_inst.spi_inst.tx_reg_sys\[0\]
+ sky130_fd_sc_hd__dfrtp_1
XTAP_TAPCELL_ROW_68_750 vssd1 vccd1 sky130_fd_sc_hd__tapvpwrvgnd_1
XFILLER_57_254 vssd1 vssd1 vccd1 vccd1 sky130_fd_sc_hd__fill_1
XFILLER_17_129 vccd1 vssd1 vccd1 vssd1 sky130_ef_sc_hd__decap_40_12
XPHY_EDGE_ROW_11_Left_91 vssd1 vssd1 vccd1 vccd1 sky130_fd_sc_hd__decap_3
XFILLER_15_30 vccd1 vssd1 vccd1 vssd1 sky130_ef_sc_hd__decap_40_12
XFILLER_13_335 vssd1 vssd1 vccd1 vccd1 sky130_fd_sc_hd__fill_1
XFILLER_9_317 vccd1 vssd1 vccd1 vssd1 sky130_ef_sc_hd__decap_40_12
XANTENNA_fanout18_X net18 vssd1 vssd1 vccd1 vccd1 sky130_fd_sc_hd__diode_2
XANTENNA__2248__B net238 vssd1 vssd1 vccd1 vccd1 sky130_fd_sc_hd__diode_2
Xclkbuf_leaf_28_clk clknet_2_0__leaf_clk vssd1 vssd1 vccd1 vccd1 clknet_leaf_28_clk
+ sky130_fd_sc_hd__clkbuf_8
XTAP_TAPCELL_ROW_74_797 vssd1 vccd1 sky130_fd_sc_hd__tapvpwrvgnd_1
X_2811_ _1241_ _1280_ vssd1 vssd1 vccd1 vccd1 _1281_ sky130_fd_sc_hd__xnor2_1
X_2742_ _1171_ _1211_ _1212_ vssd1 vssd1 vccd1 vccd1 _1213_ sky130_fd_sc_hd__nand3_1
XFILLER_8_361 vssd1 vssd1 vccd1 vccd1 sky130_fd_sc_hd__fill_2
X_2673_ net204 net206 net192 net190 vssd1 vssd1 vccd1 vccd1 _1146_ sky130_fd_sc_hd__and4_1
X_1624_ MATMULT_INST.matmult_inst.fsm_inst.count\[1\] MATMULT_INST.matmult_inst.fsm_inst.count\[0\]
+ vssd1 vssd1 vccd1 vccd1 _0458_ sky130_fd_sc_hd__and2_1
X_1555_ MATMULT_INST.matmult_inst.spi_inst.mosi_shifter\[0\] _1486_ _1488_ vssd1 vssd1
+ vccd1 vccd1 _0401_ sky130_fd_sc_hd__mux2_1
X_3225_ clknet_leaf_24_clk _0183_ net98 vssd1 vssd1 vccd1 vccd1 MATMULT_INST.matmult_inst.mem_inst.mem1\[14\]
+ sky130_fd_sc_hd__dfrtp_1
XANTENNA__2439__A net181 vssd1 vssd1 vccd1 vccd1 sky130_fd_sc_hd__diode_2
X_3156_ clknet_leaf_21_clk _0114_ net124 vssd1 vssd1 vccd1 vccd1 MATMULT_INST.matmult_inst.mem_inst.mem3\[17\]
+ sky130_fd_sc_hd__dfrtp_1
XANTENNA__2494__A2 net90 vssd1 vssd1 vccd1 vccd1 sky130_fd_sc_hd__diode_2
X_2107_ _0634_ _0657_ vssd1 vssd1 vccd1 vccd1 _0659_ sky130_fd_sc_hd__xnor2_1
Xclkbuf_leaf_19_clk clknet_2_2__leaf_clk vssd1 vssd1 vccd1 vccd1 clknet_leaf_19_clk
+ sky130_fd_sc_hd__clkbuf_8
XFILLER_54_213 vssd1 vssd1 vccd1 vccd1 sky130_fd_sc_hd__fill_2
X_3087_ clknet_leaf_9_clk _0045_ net138 vssd1 vssd1 vccd1 vccd1 MATMULT_INST.matmult_inst.mem_inst.matrixB0\[2\]
+ sky130_fd_sc_hd__dfrtp_1
X_2038_ net207 net482 net56 vssd1 vssd1 vccd1 vccd1 _0279_ sky130_fd_sc_hd__mux2_1
XFILLER_35_493 vssd1 vssd1 vccd1 vccd1 sky130_fd_sc_hd__fill_1
XTAP_TAPCELL_ROW_37_488 vssd1 vccd1 sky130_fd_sc_hd__tapvpwrvgnd_1
XFILLER_22_132 vssd1 vssd1 vccd1 vccd1 sky130_fd_sc_hd__fill_1
XFILLER_10_305 vssd1 vssd1 vccd1 vccd1 sky130_fd_sc_hd__fill_2
XANTENNA_fanout222_X net222 vssd1 vssd1 vccd1 vccd1 sky130_fd_sc_hd__diode_2
XFILLER_6_309 vccd1 vssd1 vccd1 vssd1 sky130_ef_sc_hd__decap_40_12
XTAP_TAPCELL_ROW_20_344 vssd1 vccd1 sky130_fd_sc_hd__tapvpwrvgnd_1
XANTENNA__2621__B net189 vssd1 vssd1 vccd1 vccd1 sky130_fd_sc_hd__diode_2
Xhold361 MATMULT_INST.matmult_inst.alu_inst.adder_inst.r0.fa1.a vssd1 vssd1 vccd1
+ vccd1 net674 sky130_fd_sc_hd__dlygate4sd3_1
Xhold350 MATMULT_INST.matmult_inst.spi_inst.tx_reg_sys\[9\] vssd1 vssd1 vccd1 vccd1
+ net663 sky130_fd_sc_hd__dlygate4sd3_1
XANTENNA_fanout82_A net84 vssd1 vssd1 vccd1 vccd1 sky130_fd_sc_hd__diode_2
XANTENNA__2068__B net241 vssd1 vssd1 vccd1 vccd1 sky130_fd_sc_hd__diode_2
XTAP_TAPCELL_ROW_28_411 vssd1 vccd1 sky130_fd_sc_hd__tapvpwrvgnd_1
XANTENNA__1693__B1 net61 vssd1 vssd1 vccd1 vccd1 sky130_fd_sc_hd__diode_2
XFILLER_45_279 vssd1 vssd1 vccd1 vccd1 sky130_fd_sc_hd__fill_1
XTAP_TAPCELL_ROW_71_778 vssd1 vccd1 sky130_fd_sc_hd__tapvpwrvgnd_1
XFILLER_13_165 vssd1 vssd1 vccd1 vccd1 sky130_fd_sc_hd__fill_2
XFILLER_9_125 vccd1 vssd1 vccd1 vssd1 sky130_ef_sc_hd__decap_40_12
XFILLER_9_169 vccd1 vssd1 vccd1 vssd1 sky130_ef_sc_hd__decap_40_12
XANTENNA__1862__S net13 vssd1 vssd1 vccd1 vccd1 sky130_fd_sc_hd__diode_2
XFILLER_3_55 vssd1 vssd1 vccd1 vccd1 sky130_fd_sc_hd__fill_1
XTAP_TAPCELL_ROW_79_856 vssd1 vccd1 sky130_fd_sc_hd__tapvpwrvgnd_1
XTAP_TAPCELL_ROW_79_845 vssd1 vccd1 sky130_fd_sc_hd__tapvpwrvgnd_1
XFILLER_76_360 vssd1 vssd1 vccd1 vccd1 sky130_fd_sc_hd__fill_4
X_3010_ net156 MATMULT_INST.matmult_inst.mem_inst.mem0\[13\] MATMULT_INST.matmult_inst.mem_inst.matrixB0\[13\]
+ net160 vssd1 vssd1 vccd1 vccd1 _1432_ sky130_fd_sc_hd__a22o_1
XTAP_TAPCELL_ROW_62_701 vssd1 vccd1 sky130_fd_sc_hd__tapvpwrvgnd_1
XTAP_TAPCELL_ROW_34_458 vssd1 vccd1 sky130_fd_sc_hd__tapvpwrvgnd_1
XANTENNA__2722__A net210 vssd1 vssd1 vccd1 vccd1 sky130_fd_sc_hd__diode_2
X_2725_ _1192_ _1195_ vssd1 vssd1 vccd1 vccd1 _1197_ sky130_fd_sc_hd__or2_1
Xclkbuf_leaf_8_clk clknet_2_3__leaf_clk vssd1 vssd1 vccd1 vccd1 clknet_leaf_8_clk
+ sky130_fd_sc_hd__clkbuf_8
X_2656_ _1108_ _1123_ _1127_ vssd1 vssd1 vccd1 vccd1 _1129_ sky130_fd_sc_hd__o21ba_1
X_1607_ _1511_ _1512_ _1514_ _1524_ vssd1 vssd1 vccd1 vccd1 _1525_ sky130_fd_sc_hd__or4_1
XANTENNA__1772__S net18 vssd1 vssd1 vccd1 vccd1 sky130_fd_sc_hd__diode_2
Xfanout104 net105 vssd1 vssd1 vccd1 vccd1 net104 sky130_fd_sc_hd__clkbuf_4
X_2587_ net196 MATMULT_INST.matmult_inst.alu_inst.b1_reg\[0\] net71 vssd1 vssd1 vccd1
+ vccd1 _1066_ sky130_fd_sc_hd__and3_1
Xfanout137 net138 vssd1 vssd1 vccd1 vccd1 net137 sky130_fd_sc_hd__clkbuf_4
Xfanout126 net132 vssd1 vssd1 vccd1 vccd1 net126 sky130_fd_sc_hd__clkbuf_4
Xfanout115 net123 vssd1 vssd1 vccd1 vccd1 net115 sky130_fd_sc_hd__clkbuf_4
Xfanout148 net150 vssd1 vssd1 vccd1 vccd1 net148 sky130_fd_sc_hd__clkbuf_2
Xfanout159 MATMULT_INST.matmult_inst.fsm_inst.sel\[2\] vssd1 vssd1 vccd1 vccd1 net159
+ sky130_fd_sc_hd__buf_2
X_3208_ clknet_leaf_20_clk _0166_ net126 vssd1 vssd1 vccd1 vccd1 MATMULT_INST.matmult_inst.mem_inst.matrixA3\[15\]
+ sky130_fd_sc_hd__dfrtp_1
XANTENNA__2467__A2 net90 vssd1 vssd1 vccd1 vccd1 sky130_fd_sc_hd__diode_2
X_3139_ clknet_leaf_15_clk _0097_ net136 vssd1 vssd1 vccd1 vccd1 MATMULT_INST.matmult_inst.mem_inst.mem3\[0\]
+ sky130_fd_sc_hd__dfrtp_1
XANTENNA_fanout172_X net172 vssd1 vssd1 vccd1 vccd1 sky130_fd_sc_hd__diode_2
XFILLER_6_139 vssd1 vssd1 vccd1 vccd1 sky130_fd_sc_hd__fill_1
XFILLER_12_97 vccd1 vssd1 vccd1 vssd1 sky130_ef_sc_hd__decap_40_12
XANTENNA__2070__C net235 vssd1 vssd1 vccd1 vccd1 sky130_fd_sc_hd__diode_2
XFILLER_2_301 vssd1 vssd1 vccd1 vccd1 sky130_fd_sc_hd__fill_4
XFILLER_5_3 vccd1 vssd1 vccd1 vssd1 sky130_ef_sc_hd__decap_40_12
XFILLER_2_345 vccd1 vssd1 vccd1 vssd1 sky130_ef_sc_hd__decap_40_12
Xhold180 MATMULT_INST.matmult_inst.alu_inst.adder_inst.r0.fa2.b vssd1 vssd1 vccd1
+ vccd1 net493 sky130_fd_sc_hd__dlygate4sd3_1
XANTENNA__1682__S net25 vssd1 vssd1 vccd1 vccd1 sky130_fd_sc_hd__diode_2
XFILLER_77_102 vssd1 vssd1 vccd1 vccd1 sky130_fd_sc_hd__fill_1
Xhold191 MATMULT_INST.matmult_inst.mem_inst.matrixB1\[15\] vssd1 vssd1 vccd1 vccd1
+ net504 sky130_fd_sc_hd__dlygate4sd3_1
XFILLER_2_389 vccd1 vssd1 vccd1 vssd1 sky130_ef_sc_hd__decap_40_12
XTAP_TAPCELL_ROW_76_815 vssd1 vccd1 sky130_fd_sc_hd__tapvpwrvgnd_1
XFILLER_37_72 vssd1 vssd1 vccd1 vccd1 sky130_fd_sc_hd__fill_4
XTAP_TAPCELL_ROW_31_439 vssd1 vccd1 sky130_fd_sc_hd__tapvpwrvgnd_1
XANTENNA__1857__S net13 vssd1 vssd1 vccd1 vccd1 sky130_fd_sc_hd__diode_2
X_3490_ clknet_leaf_12_clk net314 net150 vssd1 vssd1 vccd1 vccd1 MATMULT_INST.matmult_inst.spi_inst.rx_done2
+ sky130_fd_sc_hd__dfrtp_1
X_2510_ net163 _1013_ _1015_ _1020_ vssd1 vssd1 vccd1 vccd1 _1021_ sky130_fd_sc_hd__a211o_1
XFILLER_5_161 vssd1 vssd1 vccd1 vccd1 sky130_fd_sc_hd__fill_4
X_2441_ _0955_ _0956_ net157 vssd1 vssd1 vccd1 vccd1 _0957_ sky130_fd_sc_hd__o21a_1
XFILLER_68_102 vssd1 vssd1 vccd1 vccd1 sky130_fd_sc_hd__fill_2
X_2372_ _0895_ _0898_ _0908_ vssd1 vssd1 vccd1 vccd1 _0915_ sky130_fd_sc_hd__o21bai_1
XFILLER_38_3 vccd1 vssd1 vccd1 vssd1 sky130_ef_sc_hd__decap_40_12
XTAP_TAPCELL_ROW_39_506 vssd1 vccd1 sky130_fd_sc_hd__tapvpwrvgnd_1
XTAP_TAPCELL_ROW_47_572 vssd1 vccd1 sky130_fd_sc_hd__tapvpwrvgnd_1
XFILLER_64_374 vssd1 vssd1 vccd1 vccd1 sky130_fd_sc_hd__fill_1
XPHY_EDGE_ROW_49_Left_129 vssd1 vssd1 vccd1 vccd1 sky130_fd_sc_hd__decap_3
XANTENNA__1767__S net19 vssd1 vssd1 vccd1 vccd1 sky130_fd_sc_hd__diode_2
XANTENNA__2452__A net181 vssd1 vssd1 vccd1 vccd1 sky130_fd_sc_hd__diode_2
XANTENNA_fanout132_A net151 vssd1 vssd1 vccd1 vccd1 sky130_fd_sc_hd__diode_2
X_2708_ _1139_ _1179_ vssd1 vssd1 vccd1 vccd1 _1180_ sky130_fd_sc_hd__nand2_1
XFILLER_3_109 vssd1 vssd1 vccd1 vccd1 sky130_fd_sc_hd__fill_2
X_2639_ _1111_ _1112_ vssd1 vssd1 vccd1 vccd1 _1113_ sky130_fd_sc_hd__xnor2_1
XPHY_EDGE_ROW_58_Left_138 vssd1 vssd1 vccd1 vccd1 sky130_fd_sc_hd__decap_3
XFILLER_74_59 vssd1 vssd1 vccd1 vccd1 sky130_fd_sc_hd__fill_2
XFILLER_70_300 vssd1 vssd1 vccd1 vccd1 sky130_fd_sc_hd__fill_1
XFILLER_15_205 vccd1 vssd1 vccd1 vssd1 sky130_ef_sc_hd__decap_40_12
XTAP_TAPCELL_ROW_2_186 vssd1 vccd1 sky130_fd_sc_hd__tapvpwrvgnd_1
XPHY_EDGE_ROW_67_Left_147 vssd1 vssd1 vccd1 vccd1 sky130_fd_sc_hd__decap_3
XPHY_EDGE_ROW_76_Left_156 vssd1 vssd1 vccd1 vccd1 sky130_fd_sc_hd__decap_3
XFILLER_2_153 vccd1 vssd1 vccd1 vssd1 sky130_ef_sc_hd__decap_40_12
XFILLER_2_197 vccd1 vssd1 vccd1 vssd1 sky130_ef_sc_hd__decap_40_12
XFILLER_78_477 vccd1 vssd1 vccd1 vssd1 sky130_ef_sc_hd__decap_40_12
XFILLER_78_466 vssd1 vssd1 vccd1 vccd1 sky130_fd_sc_hd__fill_8
X_2990_ MATMULT_INST.matmult_inst.mem_inst.matrixB2\[11\] net87 net79 MATMULT_INST.matmult_inst.mem_inst.matrixB1\[11\]
+ _1413_ vssd1 vssd1 vccd1 vccd1 _1414_ sky130_fd_sc_hd__a221o_1
XTAP_TAPCELL_ROW_44_542 vssd1 vccd1 sky130_fd_sc_hd__tapvpwrvgnd_1
X_1941_ MATMULT_INST.matmult_inst.alu_inst.adder_inst.r0.fa0.b MATMULT_INST.matmult_inst.alu_inst.adder_inst.r0.fa0.a
+ MATMULT_INST.matmult_inst.alu_inst.adder_inst.r0.fa1.b MATMULT_INST.matmult_inst.alu_inst.adder_inst.r0.fa1.a
+ vssd1 vssd1 vccd1 vccd1 _0530_ sky130_fd_sc_hd__a22oi_1
X_1872_ net640 net44 net12 vssd1 vssd1 vccd1 vccd1 _0203_ sky130_fd_sc_hd__mux2_1
XFILLER_14_293 vssd1 vssd1 vccd1 vccd1 sky130_fd_sc_hd__fill_1
X_3473_ clknet_leaf_25_clk _0417_ net102 vssd1 vssd1 vccd1 vccd1 MATMULT_INST.matmult_inst.mem_inst.matrixB3\[9\]
+ sky130_fd_sc_hd__dfrtp_1
X_2424_ net183 net173 MATMULT_INST.matmult_inst.mem_inst.matrixB3\[0\] vssd1 vssd1
+ vccd1 vccd1 _0941_ sky130_fd_sc_hd__and3_1
X_2355_ net411 _0899_ net69 vssd1 vssd1 vccd1 vccd1 _0304_ sky130_fd_sc_hd__mux2_1
X_2286_ _0829_ _0830_ _0831_ vssd1 vssd1 vccd1 vccd1 _0833_ sky130_fd_sc_hd__o21ai_1
XANTENNA__3042__S net57 vssd1 vssd1 vccd1 vccd1 sky130_fd_sc_hd__diode_2
XANTENNA__2166__B net213 vssd1 vssd1 vccd1 vccd1 sky130_fd_sc_hd__diode_2
XANTENNA__2842__A2 net198 vssd1 vssd1 vccd1 vccd1 sky130_fd_sc_hd__diode_2
XFILLER_64_193 vssd1 vssd1 vccd1 vccd1 sky130_fd_sc_hd__fill_2
XFILLER_69_37 vssd1 vssd1 vccd1 vccd1 sky130_fd_sc_hd__fill_8
XFILLER_69_15 vssd1 vssd1 vccd1 vccd1 sky130_fd_sc_hd__fill_2
XTAP_TAPCELL_ROW_7_234 vssd1 vccd1 sky130_fd_sc_hd__tapvpwrvgnd_1
XFILLER_75_425 vssd1 vssd1 vccd1 vccd1 sky130_fd_sc_hd__fill_1
XFILLER_18_52 vssd1 vssd1 vccd1 vccd1 sky130_fd_sc_hd__fill_2
XTAP_TAPCELL_ROW_58_667 vssd1 vccd1 sky130_fd_sc_hd__tapvpwrvgnd_1
XFILLER_62_119 vssd1 vssd1 vccd1 vccd1 sky130_fd_sc_hd__fill_2
XFILLER_55_193 vssd1 vssd1 vccd1 vccd1 sky130_fd_sc_hd__fill_4
XFILLER_70_141 vssd1 vssd1 vccd1 vccd1 sky130_fd_sc_hd__fill_1
XTAP_TAPCELL_ROW_41_523 vssd1 vccd1 sky130_fd_sc_hd__tapvpwrvgnd_1
XFILLER_7_223 vssd1 vssd1 vccd1 vccd1 sky130_fd_sc_hd__fill_1
XFILLER_50_94 vssd1 vssd1 vccd1 vccd1 sky130_fd_sc_hd__fill_1
XANTENNA__2820__A net187 vssd1 vssd1 vccd1 vccd1 sky130_fd_sc_hd__diode_2
XFILLER_3_473 vccd1 vssd1 vccd1 vssd1 sky130_ef_sc_hd__decap_40_12
XANTENNA__2521__A1 net163 vssd1 vssd1 vccd1 vccd1 sky130_fd_sc_hd__diode_2
XANTENNA__1870__S net12 vssd1 vssd1 vccd1 vccd1 sky130_fd_sc_hd__diode_2
XANTENNA__2521__B2 net166 vssd1 vssd1 vccd1 vccd1 sky130_fd_sc_hd__diode_2
X_2140_ net241 net214 vssd1 vssd1 vccd1 vccd1 _0691_ sky130_fd_sc_hd__and2_1
X_2071_ net225 net224 net236 net237 vssd1 vssd1 vccd1 vccd1 _0625_ sky130_fd_sc_hd__nand4_1
XFILLER_61_152 vssd1 vssd1 vccd1 vccd1 sky130_fd_sc_hd__fill_1
XANTENNA__2714__B net206 vssd1 vssd1 vccd1 vccd1 sky130_fd_sc_hd__diode_2
XFILLER_34_399 vssd1 vssd1 vccd1 vccd1 sky130_fd_sc_hd__fill_1
X_2973_ MATMULT_INST.matmult_inst.mem_inst.matrixA2\[9\] net89 net81 MATMULT_INST.matmult_inst.mem_inst.matrixA1\[9\]
+ _1398_ vssd1 vssd1 vccd1 vccd1 _1399_ sky130_fd_sc_hd__a221o_1
X_1924_ net221 net518 net53 vssd1 vssd1 vccd1 vccd1 _0252_ sky130_fd_sc_hd__mux2_1
X_1855_ _0483_ _0507_ vssd1 vssd1 vccd1 vccd1 _0517_ sky130_fd_sc_hd__nor2_1
X_1786_ net485 net33 net31 vssd1 vssd1 vccd1 vccd1 _0121_ sky130_fd_sc_hd__mux2_1
X_3525_ clknet_leaf_24_clk _0450_ net118 vssd1 vssd1 vccd1 vccd1 MATMULT_INST.matmult_inst.spi_inst.tx_reg_sys\[16\]
+ sky130_fd_sc_hd__dfrtp_1
X_3456_ _0035_ _0401_ net140 vssd1 vssd1 vccd1 vccd1 MATMULT_INST.matmult_inst.spi_inst.mosi_shifter\[0\]
+ sky130_fd_sc_hd__dfrtp_1
XANTENNA__1633__X _0467_ vssd1 vssd1 vccd1 vccd1 sky130_fd_sc_hd__diode_2
X_2407_ _0458_ _0926_ _1500_ _1501_ vssd1 vssd1 vccd1 vccd1 _0929_ sky130_fd_sc_hd__a211o_1
XTAP_TAPCELL_ROW_4_204 vssd1 vccd1 sky130_fd_sc_hd__tapvpwrvgnd_1
X_3387_ clknet_leaf_0_clk _0341_ net94 vssd1 vssd1 vccd1 vccd1 MATMULT_INST.matmult_inst.alu_inst.col0\[1\]
+ sky130_fd_sc_hd__dfrtp_1
XANTENNA__1780__S net31 vssd1 vssd1 vccd1 vccd1 sky130_fd_sc_hd__diode_2
X_2338_ _0854_ _0881_ vssd1 vssd1 vccd1 vccd1 _0883_ sky130_fd_sc_hd__xnor2_1
XANTENNA__2512__B2 net66 vssd1 vssd1 vccd1 vccd1 sky130_fd_sc_hd__diode_2
X_2269_ _0813_ _0815_ _0816_ vssd1 vssd1 vccd1 vccd1 _0817_ sky130_fd_sc_hd__a21o_1
XFILLER_57_447 vssd1 vssd1 vccd1 vccd1 sky130_fd_sc_hd__fill_1
XFILLER_57_469 vssd1 vssd1 vccd1 vccd1 sky130_fd_sc_hd__fill_1
XTAP_TAPCELL_ROW_55_637 vssd1 vccd1 sky130_fd_sc_hd__tapvpwrvgnd_1
XFILLER_52_163 vssd1 vssd1 vccd1 vccd1 sky130_fd_sc_hd__fill_2
XFILLER_52_174 vccd1 vssd1 vccd1 vssd1 sky130_ef_sc_hd__decap_40_12
XFILLER_0_410 vssd1 vssd1 vccd1 vccd1 sky130_fd_sc_hd__fill_4
XFILLER_0_421 vssd1 vssd1 vccd1 vccd1 sky130_fd_sc_hd__fill_2
XANTENNA__2503__A1 net158 vssd1 vssd1 vccd1 vccd1 sky130_fd_sc_hd__diode_2
XANTENNA__1690__S net25 vssd1 vssd1 vccd1 vccd1 sky130_fd_sc_hd__diode_2
XANTENNA__2503__B2 net163 vssd1 vssd1 vccd1 vccd1 sky130_fd_sc_hd__diode_2
XFILLER_0_487 vssd1 vssd1 vccd1 vccd1 sky130_fd_sc_hd__fill_1
Xhold40 _0323_ vssd1 vssd1 vccd1 vccd1 net353 sky130_fd_sc_hd__dlygate4sd3_1
XFILLER_48_425 vssd1 vssd1 vccd1 vccd1 sky130_fd_sc_hd__fill_1
XFILLER_75_255 vssd1 vssd1 vccd1 vccd1 sky130_fd_sc_hd__fill_2
XANTENNA__2087__A net241 vssd1 vssd1 vccd1 vccd1 sky130_fd_sc_hd__diode_2
Xhold62 MATMULT_INST.matmult_inst.mem_inst.mem3\[16\] vssd1 vssd1 vccd1 vccd1 net375
+ sky130_fd_sc_hd__dlygate4sd3_1
XANTENNA__1703__B net60 vssd1 vssd1 vccd1 vccd1 sky130_fd_sc_hd__diode_2
Xhold73 MATMULT_INST.matmult_inst.mem_inst.matrixA3\[14\] vssd1 vssd1 vccd1 vccd1
+ net386 sky130_fd_sc_hd__dlygate4sd3_1
Xhold51 MATMULT_INST.matmult_inst.mem_inst.matrixB3\[5\] vssd1 vssd1 vccd1 vccd1 net364
+ sky130_fd_sc_hd__dlygate4sd3_1
XFILLER_75_277 vssd1 vssd1 vccd1 vccd1 sky130_fd_sc_hd__fill_2
XANTENNA__3059__A2 net87 vssd1 vssd1 vccd1 vccd1 sky130_fd_sc_hd__diode_2
Xhold84 MATMULT_INST.matmult_inst.mem_inst.mem3\[10\] vssd1 vssd1 vccd1 vccd1 net397
+ sky130_fd_sc_hd__dlygate4sd3_1
Xhold95 MATMULT_INST.matmult_inst.mem_inst.matrixB3\[9\] vssd1 vssd1 vccd1 vccd1 net408
+ sky130_fd_sc_hd__dlygate4sd3_1
XTAP_TAPCELL_ROW_18_328 vssd1 vccd1 sky130_fd_sc_hd__tapvpwrvgnd_1
XFILLER_28_182 vccd1 vssd1 vccd1 vssd1 sky130_ef_sc_hd__decap_40_12
XTAP_TAPCELL_ROW_26_394 vssd1 vccd1 sky130_fd_sc_hd__tapvpwrvgnd_1
XANTENNA__1865__S net13 vssd1 vssd1 vccd1 vccd1 sky130_fd_sc_hd__diode_2
X_1640_ MATMULT_INST.matmult_inst.fsm_inst.state\[0\] _1519_ vssd1 vssd1 vccd1 vccd1
+ _0471_ sky130_fd_sc_hd__nor2_1
X_1571_ MATMULT_INST.matmult_inst.spi_inst.rx_bit_count\[1\] _1489_ net3 vssd1 vssd1
+ vccd1 vccd1 _1493_ sky130_fd_sc_hd__o21ai_1
XFILLER_6_77 vssd1 vssd1 vccd1 vccd1 sky130_fd_sc_hd__fill_4
X_3310_ clknet_leaf_1_clk _0268_ net100 vssd1 vssd1 vccd1 vccd1 MATMULT_INST.matmult_inst.alu_inst.out\[10\]
+ sky130_fd_sc_hd__dfrtp_1
XFILLER_3_281 vccd1 vssd1 vccd1 vssd1 sky130_ef_sc_hd__decap_40_12
X_3241_ clknet_leaf_27_clk _0199_ net97 vssd1 vssd1 vccd1 vccd1 MATMULT_INST.matmult_inst.mem_inst.matrixB2\[12\]
+ sky130_fd_sc_hd__dfrtp_1
X_3172_ clknet_leaf_20_clk _0130_ net124 vssd1 vssd1 vccd1 vccd1 MATMULT_INST.matmult_inst.mem_inst.matrixB1\[15\]
+ sky130_fd_sc_hd__dfrtp_1
XFILLER_20_3 vssd1 vssd1 vccd1 vccd1 sky130_fd_sc_hd__fill_4
XANTENNA_clkbuf_leaf_6_clk_A clknet_2_1__leaf_clk vssd1 vssd1 vccd1 vccd1 sky130_fd_sc_hd__diode_2
X_2123_ _0652_ _0674_ vssd1 vssd1 vccd1 vccd1 _0675_ sky130_fd_sc_hd__xnor2_1
XFILLER_66_233 vssd1 vssd1 vccd1 vccd1 sky130_fd_sc_hd__fill_2
XANTENNA__1736__A_N net177 vssd1 vssd1 vccd1 vccd1 sky130_fd_sc_hd__diode_2
X_2054_ net669 net67 _0610_ vssd1 vssd1 vccd1 vccd1 _0292_ sky130_fd_sc_hd__a21o_1
XFILLER_34_130 vssd1 vssd1 vccd1 vccd1 sky130_fd_sc_hd__fill_1
XTAP_TAPCELL_ROW_52_618 vssd1 vccd1 sky130_fd_sc_hd__tapvpwrvgnd_1
XANTENNA__2444__B net172 vssd1 vssd1 vccd1 vccd1 sky130_fd_sc_hd__diode_2
X_2956_ MATMULT_INST.matmult_inst.mem_inst.mem2\[8\] net88 net80 MATMULT_INST.matmult_inst.mem_inst.mem1\[8\]
+ vssd1 vssd1 vccd1 vccd1 _1383_ sky130_fd_sc_hd__a22o_1
XANTENNA__1775__S net18 vssd1 vssd1 vccd1 vccd1 sky130_fd_sc_hd__diode_2
X_1907_ net568 net47 net26 vssd1 vssd1 vccd1 vccd1 _0236_ sky130_fd_sc_hd__mux2_1
X_2887_ _1333_ _1350_ _1353_ vssd1 vssd1 vccd1 vccd1 _1354_ sky130_fd_sc_hd__a21oi_1
XTAP_TAPCELL_ROW_60_684 vssd1 vccd1 sky130_fd_sc_hd__tapvpwrvgnd_1
X_1838_ net616 _0486_ net29 vssd1 vssd1 vccd1 vccd1 _0170_ sky130_fd_sc_hd__mux2_1
X_1769_ net403 net51 net18 vssd1 vssd1 vccd1 vccd1 _0106_ sky130_fd_sc_hd__mux2_1
X_3508_ net243 net281 net129 vssd1 vssd1 vccd1 vccd1 MATMULT_INST.matmult_inst.spi_inst.first_bit_sent
+ sky130_fd_sc_hd__dfrtp_1
X_3439_ clknet_leaf_7_clk _0002_ net113 vssd1 vssd1 vccd1 vccd1 MATMULT_INST.matmult_inst.fsm_inst.sel\[2\]
+ sky130_fd_sc_hd__dfrtp_1
XFILLER_57_200 vssd1 vssd1 vccd1 vccd1 sky130_fd_sc_hd__fill_4
XFILLER_66_27 vssd1 vssd1 vccd1 vccd1 sky130_fd_sc_hd__fill_1
XFILLER_66_38 vssd1 vssd1 vccd1 vccd1 sky130_fd_sc_hd__fill_4
XTAP_TAPCELL_ROW_68_751 vssd1 vccd1 sky130_fd_sc_hd__tapvpwrvgnd_1
XANTENNA__2249__B1 net235 vssd1 vssd1 vccd1 vccd1 sky130_fd_sc_hd__diode_2
XFILLER_72_258 vssd1 vssd1 vccd1 vccd1 sky130_fd_sc_hd__fill_2
XFILLER_25_152 vssd1 vssd1 vccd1 vccd1 sky130_fd_sc_hd__fill_2
XFILLER_15_64 vssd1 vssd1 vccd1 vccd1 sky130_fd_sc_hd__fill_1
XFILLER_9_329 vssd1 vssd1 vccd1 vccd1 sky130_fd_sc_hd__fill_4
XTAP_TAPCELL_ROW_23_364 vssd1 vccd1 sky130_fd_sc_hd__tapvpwrvgnd_1
XFILLER_40_199 vssd1 vssd1 vccd1 vccd1 sky130_fd_sc_hd__fill_4
Xoutput6 net6 vssd1 vssd1 vccd1 vccd1 gpio_out[3] sky130_fd_sc_hd__buf_2
XFILLER_0_251 vssd1 vssd1 vccd1 vccd1 sky130_fd_sc_hd__fill_1
XANTENNA__2488__B1 _1000_ vssd1 vssd1 vccd1 vccd1 sky130_fd_sc_hd__diode_2
XFILLER_63_225 vssd1 vssd1 vccd1 vccd1 sky130_fd_sc_hd__fill_4
XFILLER_63_236 vssd1 vssd1 vccd1 vccd1 sky130_fd_sc_hd__fill_1
XFILLER_16_141 vssd1 vssd1 vccd1 vccd1 sky130_fd_sc_hd__fill_2
XTAP_TAPCELL_ROW_74_798 vssd1 vccd1 sky130_fd_sc_hd__tapvpwrvgnd_1
XFILLER_71_291 vssd1 vssd1 vccd1 vccd1 sky130_fd_sc_hd__fill_1
XFILLER_31_111 vssd1 vssd1 vccd1 vccd1 sky130_fd_sc_hd__fill_1
X_2810_ _1278_ _1279_ vssd1 vssd1 vccd1 vccd1 _1280_ sky130_fd_sc_hd__and2b_1
X_2741_ _1190_ _1196_ _1197_ _1210_ _1189_ vssd1 vssd1 vccd1 vccd1 _1212_ sky130_fd_sc_hd__a311o_1
XANTENNA__2280__A net218 vssd1 vssd1 vccd1 vccd1 sky130_fd_sc_hd__diode_2
XANTENNA__2963__A1 net156 vssd1 vssd1 vccd1 vccd1 sky130_fd_sc_hd__diode_2
XANTENNA__2963__B2 net161 vssd1 vssd1 vccd1 vccd1 sky130_fd_sc_hd__diode_2
X_2672_ net205 net192 net191 net207 vssd1 vssd1 vccd1 vccd1 _1145_ sky130_fd_sc_hd__a22oi_1
XFILLER_68_3 vssd1 vssd1 vccd1 vccd1 sky130_fd_sc_hd__fill_4
X_1623_ MATMULT_INST.matmult_inst.fsm_inst.count\[1\] _1501_ vssd1 vssd1 vccd1 vccd1
+ _0457_ sky130_fd_sc_hd__or2_1
X_1554_ MATMULT_INST.matmult_inst.spi_inst.mosi_shifter\[1\] MATMULT_INST.matmult_inst.spi_inst.mosi_shifter\[0\]
+ _1488_ vssd1 vssd1 vccd1 vccd1 _0402_ sky130_fd_sc_hd__mux2_1
X_3224_ clknet_leaf_22_clk _0182_ net117 vssd1 vssd1 vccd1 vccd1 MATMULT_INST.matmult_inst.mem_inst.mem1\[13\]
+ sky130_fd_sc_hd__dfrtp_1
.ends
