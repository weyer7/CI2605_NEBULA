* NGSPICE file created from team_02.ext - technology: sky130A

* Black-box entry subcircuit for sky130_fd_sc_hd__diode_2 abstract view
.subckt sky130_fd_sc_hd__diode_2 DIODE VGND VNB VPB VPWR
.ends

* Black-box entry subcircuit for sky130_fd_sc_hd__fill_2 abstract view
.subckt sky130_fd_sc_hd__fill_2 VGND VNB VPB VPWR
.ends

* Black-box entry subcircuit for sky130_fd_sc_hd__dfrtp_2 abstract view
.subckt sky130_fd_sc_hd__dfrtp_2 CLK D RESET_B VGND VNB VPB VPWR Q
.ends

* Black-box entry subcircuit for sky130_fd_sc_hd__dfxtp_2 abstract view
.subckt sky130_fd_sc_hd__dfxtp_2 CLK D VGND VNB VPB VPWR Q
.ends

* Black-box entry subcircuit for sky130_fd_sc_hd__nor2_2 abstract view
.subckt sky130_fd_sc_hd__nor2_2 A B VGND VNB VPB VPWR Y
.ends

* Black-box entry subcircuit for sky130_fd_sc_hd__tapvpwrvgnd_1 abstract view
.subckt sky130_fd_sc_hd__tapvpwrvgnd_1 VGND VPWR
.ends

* Black-box entry subcircuit for sky130_fd_sc_hd__a21o_2 abstract view
.subckt sky130_fd_sc_hd__a21o_2 A1 A2 B1 VGND VNB VPB VPWR X
.ends

* Black-box entry subcircuit for sky130_fd_sc_hd__fill_8 abstract view
.subckt sky130_fd_sc_hd__fill_8 VGND VNB VPB VPWR
.ends

* Black-box entry subcircuit for sky130_fd_sc_hd__a221o_2 abstract view
.subckt sky130_fd_sc_hd__a221o_2 A1 A2 B1 B2 C1 VGND VNB VPB VPWR X
.ends

* Black-box entry subcircuit for sky130_fd_sc_hd__dlygate4sd3_1 abstract view
.subckt sky130_fd_sc_hd__dlygate4sd3_1 A VGND VNB VPB VPWR X
.ends

* Black-box entry subcircuit for sky130_fd_sc_hd__fill_1 abstract view
.subckt sky130_fd_sc_hd__fill_1 VGND VNB VPB VPWR
.ends

* Black-box entry subcircuit for sky130_fd_sc_hd__and3_2 abstract view
.subckt sky130_fd_sc_hd__and3_2 A B C VGND VNB VPB VPWR X
.ends

* Black-box entry subcircuit for sky130_fd_sc_hd__mux2_1 abstract view
.subckt sky130_fd_sc_hd__mux2_1 A0 A1 S VGND VNB VPB VPWR X
.ends

* Black-box entry subcircuit for sky130_fd_sc_hd__or4_2 abstract view
.subckt sky130_fd_sc_hd__or4_2 A B C D VGND VNB VPB VPWR X
.ends

* Black-box entry subcircuit for sky130_fd_sc_hd__a22o_2 abstract view
.subckt sky130_fd_sc_hd__a22o_2 A1 A2 B1 B2 VGND VNB VPB VPWR X
.ends

* Black-box entry subcircuit for sky130_fd_sc_hd__clkdlybuf4s25_1 abstract view
.subckt sky130_fd_sc_hd__clkdlybuf4s25_1 A VGND VNB VPB VPWR X
.ends

* Black-box entry subcircuit for sky130_fd_sc_hd__and2b_2 abstract view
.subckt sky130_fd_sc_hd__and2b_2 A_N B VGND VNB VPB VPWR X
.ends

* Black-box entry subcircuit for sky130_fd_sc_hd__fill_4 abstract view
.subckt sky130_fd_sc_hd__fill_4 VGND VNB VPB VPWR
.ends

* Black-box entry subcircuit for sky130_fd_sc_hd__a311o_2 abstract view
.subckt sky130_fd_sc_hd__a311o_2 A1 A2 A3 B1 C1 VGND VNB VPB VPWR X
.ends

* Black-box entry subcircuit for sky130_ef_sc_hd__decap_40_12 abstract view
.subckt sky130_ef_sc_hd__decap_40_12 VNB VPB VGND VPWR
.ends

* Black-box entry subcircuit for sky130_fd_sc_hd__and2_2 abstract view
.subckt sky130_fd_sc_hd__and2_2 A B VGND VNB VPB VPWR X
.ends

* Black-box entry subcircuit for sky130_fd_sc_hd__a21oi_2 abstract view
.subckt sky130_fd_sc_hd__a21oi_2 A1 A2 B1 VGND VNB VPB VPWR Y
.ends

* Black-box entry subcircuit for sky130_fd_sc_hd__nand2_2 abstract view
.subckt sky130_fd_sc_hd__nand2_2 A B VGND VNB VPB VPWR Y
.ends

* Black-box entry subcircuit for sky130_fd_sc_hd__buf_2 abstract view
.subckt sky130_fd_sc_hd__buf_2 A VGND VNB VPB VPWR X
.ends

* Black-box entry subcircuit for sky130_fd_sc_hd__dfstp_2 abstract view
.subckt sky130_fd_sc_hd__dfstp_2 CLK D SET_B VGND VNB VPB VPWR Q
.ends

* Black-box entry subcircuit for sky130_fd_sc_hd__or3b_2 abstract view
.subckt sky130_fd_sc_hd__or3b_2 A B C_N VGND VNB VPB VPWR X
.ends

* Black-box entry subcircuit for sky130_fd_sc_hd__a21boi_2 abstract view
.subckt sky130_fd_sc_hd__a21boi_2 A1 A2 B1_N VGND VNB VPB VPWR Y
.ends

* Black-box entry subcircuit for sky130_fd_sc_hd__and4_2 abstract view
.subckt sky130_fd_sc_hd__and4_2 A B C D VGND VNB VPB VPWR X
.ends

* Black-box entry subcircuit for sky130_fd_sc_hd__a41o_2 abstract view
.subckt sky130_fd_sc_hd__a41o_2 A1 A2 A3 A4 B1 VGND VNB VPB VPWR X
.ends

* Black-box entry subcircuit for sky130_fd_sc_hd__o2bb2a_2 abstract view
.subckt sky130_fd_sc_hd__o2bb2a_2 A1_N A2_N B1 B2 VGND VNB VPB VPWR X
.ends

* Black-box entry subcircuit for sky130_fd_sc_hd__o21ai_2 abstract view
.subckt sky130_fd_sc_hd__o21ai_2 A1 A2 B1 VGND VNB VPB VPWR Y
.ends

* Black-box entry subcircuit for sky130_fd_sc_hd__xnor2_2 abstract view
.subckt sky130_fd_sc_hd__xnor2_2 A B VGND VNB VPB VPWR Y
.ends

* Black-box entry subcircuit for sky130_fd_sc_hd__o21a_2 abstract view
.subckt sky130_fd_sc_hd__o21a_2 A1 A2 B1 VGND VNB VPB VPWR X
.ends

* Black-box entry subcircuit for sky130_fd_sc_hd__nand4_2 abstract view
.subckt sky130_fd_sc_hd__nand4_2 A B C D VGND VNB VPB VPWR Y
.ends

* Black-box entry subcircuit for sky130_fd_sc_hd__conb_1 abstract view
.subckt sky130_fd_sc_hd__conb_1 VGND VNB VPB VPWR HI LO
.ends

* Black-box entry subcircuit for sky130_fd_sc_hd__or3_2 abstract view
.subckt sky130_fd_sc_hd__or3_2 A B C VGND VNB VPB VPWR X
.ends

* Black-box entry subcircuit for sky130_fd_sc_hd__o211a_2 abstract view
.subckt sky130_fd_sc_hd__o211a_2 A1 A2 B1 C1 VGND VNB VPB VPWR X
.ends

* Black-box entry subcircuit for sky130_fd_sc_hd__a211o_2 abstract view
.subckt sky130_fd_sc_hd__a211o_2 A1 A2 B1 C1 VGND VNB VPB VPWR X
.ends

* Black-box entry subcircuit for sky130_fd_sc_hd__clkbuf_16 abstract view
.subckt sky130_fd_sc_hd__clkbuf_16 A VGND VNB VPB VPWR X
.ends

* Black-box entry subcircuit for sky130_fd_sc_hd__or2_2 abstract view
.subckt sky130_fd_sc_hd__or2_2 A B VGND VNB VPB VPWR X
.ends

* Black-box entry subcircuit for sky130_fd_sc_hd__decap_3 abstract view
.subckt sky130_fd_sc_hd__decap_3 VGND VNB VPB VPWR
.ends

* Black-box entry subcircuit for sky130_fd_sc_hd__a2111oi_1 abstract view
.subckt sky130_fd_sc_hd__a2111oi_1 A1 A2 B1 C1 D1 VGND VNB VPB VPWR Y
.ends

* Black-box entry subcircuit for sky130_fd_sc_hd__and4bb_2 abstract view
.subckt sky130_fd_sc_hd__and4bb_2 A_N B_N C D VGND VNB VPB VPWR X
.ends

* Black-box entry subcircuit for sky130_fd_sc_hd__a21bo_2 abstract view
.subckt sky130_fd_sc_hd__a21bo_2 A1 A2 B1_N VGND VNB VPB VPWR X
.ends

* Black-box entry subcircuit for sky130_fd_sc_hd__a221oi_2 abstract view
.subckt sky130_fd_sc_hd__a221oi_2 A1 A2 B1 B2 C1 VGND VNB VPB VPWR Y
.ends

* Black-box entry subcircuit for sky130_fd_sc_hd__o31a_2 abstract view
.subckt sky130_fd_sc_hd__o31a_2 A1 A2 A3 B1 VGND VNB VPB VPWR X
.ends

* Black-box entry subcircuit for sky130_fd_sc_hd__nand2b_2 abstract view
.subckt sky130_fd_sc_hd__nand2b_2 A_N B VGND VNB VPB VPWR Y
.ends

* Black-box entry subcircuit for sky130_fd_sc_hd__a31o_2 abstract view
.subckt sky130_fd_sc_hd__a31o_2 A1 A2 A3 B1 VGND VNB VPB VPWR X
.ends

* Black-box entry subcircuit for sky130_fd_sc_hd__inv_2 abstract view
.subckt sky130_fd_sc_hd__inv_2 A VGND VNB VPB VPWR Y
.ends

* Black-box entry subcircuit for sky130_fd_sc_hd__nor4_2 abstract view
.subckt sky130_fd_sc_hd__nor4_2 A B C D VGND VNB VPB VPWR Y
.ends

* Black-box entry subcircuit for sky130_fd_sc_hd__o22a_2 abstract view
.subckt sky130_fd_sc_hd__o22a_2 A1 A2 B1 B2 VGND VNB VPB VPWR X
.ends

* Black-box entry subcircuit for sky130_fd_sc_hd__and3b_2 abstract view
.subckt sky130_fd_sc_hd__and3b_2 A_N B C VGND VNB VPB VPWR X
.ends

* Black-box entry subcircuit for sky130_fd_sc_hd__xor2_2 abstract view
.subckt sky130_fd_sc_hd__xor2_2 A B VGND VNB VPB VPWR X
.ends

* Black-box entry subcircuit for sky130_fd_sc_hd__a32o_2 abstract view
.subckt sky130_fd_sc_hd__a32o_2 A1 A2 A3 B1 B2 VGND VNB VPB VPWR X
.ends

* Black-box entry subcircuit for sky130_fd_sc_hd__a22oi_2 abstract view
.subckt sky130_fd_sc_hd__a22oi_2 A1 A2 B1 B2 VGND VNB VPB VPWR Y
.ends

* Black-box entry subcircuit for sky130_fd_sc_hd__nand3_2 abstract view
.subckt sky130_fd_sc_hd__nand3_2 A B C VGND VNB VPB VPWR Y
.ends

* Black-box entry subcircuit for sky130_fd_sc_hd__nand3b_2 abstract view
.subckt sky130_fd_sc_hd__nand3b_2 A_N B C VGND VNB VPB VPWR Y
.ends

* Black-box entry subcircuit for sky130_fd_sc_hd__clkbuf_8 abstract view
.subckt sky130_fd_sc_hd__clkbuf_8 A VGND VNB VPB VPWR X
.ends

* Black-box entry subcircuit for sky130_fd_sc_hd__clkbuf_4 abstract view
.subckt sky130_fd_sc_hd__clkbuf_4 A VGND VNB VPB VPWR X
.ends

* Black-box entry subcircuit for sky130_fd_sc_hd__o21ba_2 abstract view
.subckt sky130_fd_sc_hd__o21ba_2 A1 A2 B1_N VGND VNB VPB VPWR X
.ends

* Black-box entry subcircuit for sky130_fd_sc_hd__o211ai_2 abstract view
.subckt sky130_fd_sc_hd__o211ai_2 A1 A2 B1 C1 VGND VNB VPB VPWR Y
.ends

* Black-box entry subcircuit for sky130_fd_sc_hd__clkbuf_2 abstract view
.subckt sky130_fd_sc_hd__clkbuf_2 A VGND VNB VPB VPWR X
.ends

* Black-box entry subcircuit for sky130_fd_sc_hd__buf_4 abstract view
.subckt sky130_fd_sc_hd__buf_4 A VGND VNB VPB VPWR X
.ends

* Black-box entry subcircuit for sky130_fd_sc_hd__o311a_2 abstract view
.subckt sky130_fd_sc_hd__o311a_2 A1 A2 A3 B1 C1 VGND VNB VPB VPWR X
.ends

* Black-box entry subcircuit for sky130_fd_sc_hd__o2111ai_2 abstract view
.subckt sky130_fd_sc_hd__o2111ai_2 A1 A2 B1 C1 D1 VGND VNB VPB VPWR Y
.ends

* Black-box entry subcircuit for sky130_fd_sc_hd__o221ai_2 abstract view
.subckt sky130_fd_sc_hd__o221ai_2 A1 A2 B1 B2 C1 VGND VNB VPB VPWR Y
.ends

* Black-box entry subcircuit for sky130_fd_sc_hd__clkinv_2 abstract view
.subckt sky130_fd_sc_hd__clkinv_2 A VGND VNB VPB VPWR Y
.ends

* Black-box entry subcircuit for sky130_fd_sc_hd__nor3_2 abstract view
.subckt sky130_fd_sc_hd__nor3_2 A B C VGND VNB VPB VPWR Y
.ends

* Black-box entry subcircuit for sky130_fd_sc_hd__o21bai_2 abstract view
.subckt sky130_fd_sc_hd__o21bai_2 A1 A2 B1_N VGND VNB VPB VPWR Y
.ends

* Black-box entry subcircuit for sky130_fd_sc_hd__a31oi_2 abstract view
.subckt sky130_fd_sc_hd__a31oi_2 A1 A2 A3 B1 VGND VNB VPB VPWR Y
.ends

* Black-box entry subcircuit for sky130_fd_sc_hd__a2bb2o_2 abstract view
.subckt sky130_fd_sc_hd__a2bb2o_2 A1_N A2_N B1 B2 VGND VNB VPB VPWR X
.ends

* Black-box entry subcircuit for sky130_fd_sc_hd__or4b_2 abstract view
.subckt sky130_fd_sc_hd__or4b_2 A B C D_N VGND VNB VPB VPWR X
.ends

* Black-box entry subcircuit for sky130_fd_sc_hd__o221a_2 abstract view
.subckt sky130_fd_sc_hd__o221a_2 A1 A2 B1 B2 C1 VGND VNB VPB VPWR X
.ends

* Black-box entry subcircuit for sky130_fd_sc_hd__buf_1 abstract view
.subckt sky130_fd_sc_hd__buf_1 A VGND VNB VPB VPWR X
.ends

* Black-box entry subcircuit for sky130_fd_sc_hd__o31ai_2 abstract view
.subckt sky130_fd_sc_hd__o31ai_2 A1 A2 A3 B1 VGND VNB VPB VPWR Y
.ends

* Black-box entry subcircuit for sky130_fd_sc_hd__a311oi_2 abstract view
.subckt sky130_fd_sc_hd__a311oi_2 A1 A2 A3 B1 C1 VGND VNB VPB VPWR Y
.ends

* Black-box entry subcircuit for sky130_fd_sc_hd__o32a_2 abstract view
.subckt sky130_fd_sc_hd__o32a_2 A1 A2 A3 B1 B2 VGND VNB VPB VPWR X
.ends

* Black-box entry subcircuit for sky130_fd_sc_hd__and4b_2 abstract view
.subckt sky130_fd_sc_hd__and4b_2 A_N B C D VGND VNB VPB VPWR X
.ends

* Black-box entry subcircuit for sky130_fd_sc_hd__a2111o_2 abstract view
.subckt sky130_fd_sc_hd__a2111o_2 A1 A2 B1 C1 D1 VGND VNB VPB VPWR X
.ends

* Black-box entry subcircuit for sky130_fd_sc_hd__nor4_4 abstract view
.subckt sky130_fd_sc_hd__nor4_4 A B C D VGND VNB VPB VPWR Y
.ends

.subckt team_02 clk en gpio_in[0] gpio_in[10] gpio_in[11] gpio_in[12] gpio_in[13]
+ gpio_in[14] gpio_in[15] gpio_in[16] gpio_in[17] gpio_in[18] gpio_in[19] gpio_in[1]
+ gpio_in[20] gpio_in[21] gpio_in[22] gpio_in[23] gpio_in[24] gpio_in[25] gpio_in[26]
+ gpio_in[27] gpio_in[28] gpio_in[29] gpio_in[2] gpio_in[30] gpio_in[31] gpio_in[32]
+ gpio_in[33] gpio_in[3] gpio_in[4] gpio_in[5] gpio_in[6] gpio_in[7] gpio_in[8] gpio_in[9]
+ gpio_oeb[0] gpio_oeb[10] gpio_oeb[11] gpio_oeb[12] gpio_oeb[13] gpio_oeb[14] gpio_oeb[15]
+ gpio_oeb[16] gpio_oeb[17] gpio_oeb[18] gpio_oeb[19] gpio_oeb[1] gpio_oeb[20] gpio_oeb[21]
+ gpio_oeb[22] gpio_oeb[23] gpio_oeb[24] gpio_oeb[25] gpio_oeb[26] gpio_oeb[27] gpio_oeb[28]
+ gpio_oeb[29] gpio_oeb[2] gpio_oeb[30] gpio_oeb[31] gpio_oeb[32] gpio_oeb[33] gpio_oeb[3]
+ gpio_oeb[4] gpio_oeb[5] gpio_oeb[6] gpio_oeb[7] gpio_oeb[8] gpio_oeb[9] gpio_out[0]
+ gpio_out[10] gpio_out[11] gpio_out[12] gpio_out[13] gpio_out[14] gpio_out[15] gpio_out[16]
+ gpio_out[17] gpio_out[18] gpio_out[19] gpio_out[1] gpio_out[20] gpio_out[21] gpio_out[22]
+ gpio_out[23] gpio_out[24] gpio_out[25] gpio_out[26] gpio_out[27] gpio_out[28] gpio_out[29]
+ gpio_out[2] gpio_out[30] gpio_out[31] gpio_out[32] gpio_out[33] gpio_out[3] gpio_out[4]
+ gpio_out[5] gpio_out[6] gpio_out[7] gpio_out[8] gpio_out[9] nrst vccd1 vssd1
XANTENNA__2439__B _2533_/B vssd1 vssd1 vccd1 vccd1 sky130_fd_sc_hd__diode_2
XFILLER_39_222 vssd1 vssd1 vccd1 vccd1 sky130_fd_sc_hd__fill_2
X_3155_ _3302_/CLK _3155_/D load_slew273/X vssd1 vssd1 vccd1 vccd1 _3155_/Q sky130_fd_sc_hd__dfrtp_2
X_3086_ clkload9/A _3086_/D vssd1 vssd1 vccd1 vccd1 _3086_/Q sky130_fd_sc_hd__dfxtp_2
X_2106_ _2106_/A _2106_/B vssd1 vssd1 vccd1 vccd1 _2107_/B sky130_fd_sc_hd__nor2_2
XTAP_TAPCELL_ROW_65_721 vssd1 vccd1 sky130_fd_sc_hd__tapvpwrvgnd_1
XANTENNA__2455__A _2926_/B vssd1 vssd1 vccd1 vccd1 sky130_fd_sc_hd__diode_2
X_2037_ _2009_/A _2009_/B _2036_/X vssd1 vssd1 vccd1 vccd1 _2038_/B sky130_fd_sc_hd__a21o_2
XTAP_TAPCELL_ROW_37_489 vssd1 vccd1 sky130_fd_sc_hd__tapvpwrvgnd_1
XFILLER_52_29 vssd1 vssd1 vccd1 vccd1 sky130_fd_sc_hd__fill_8
XFILLER_10_306 vssd1 vssd1 vccd1 vccd1 sky130_fd_sc_hd__fill_2
XANTENNA__2902__B _2970_/C vssd1 vssd1 vccd1 vccd1 sky130_fd_sc_hd__diode_2
X_2939_ _3339_/Q _2971_/A2 _2971_/B1 _3321_/Q _2938_/X vssd1 vssd1 vccd1 vccd1 _2939_/X
+ sky130_fd_sc_hd__a221o_2
XANTENNA__2954__B2 _2520_/A vssd1 vssd1 vccd1 vccd1 sky130_fd_sc_hd__diode_2
XTAP_TAPCELL_ROW_20_345 vssd1 vccd1 sky130_fd_sc_hd__tapvpwrvgnd_1
Xhold373 _3417_/Q vssd1 vssd1 vccd1 vccd1 hold373/X sky130_fd_sc_hd__dlygate4sd3_1
Xhold384 _1598_/X vssd1 vssd1 vccd1 vccd1 _3422_/D sky130_fd_sc_hd__dlygate4sd3_1
Xhold395 _3356_/Q vssd1 vssd1 vccd1 vccd1 hold395/X sky130_fd_sc_hd__dlygate4sd3_1
XFILLER_77_59 vssd1 vssd1 vccd1 vccd1 sky130_fd_sc_hd__fill_2
XANTENNA_fanout75_A _2440_/Y vssd1 vssd1 vccd1 vccd1 sky130_fd_sc_hd__diode_2
XANTENNA__2890__B1 _2894_/B1 vssd1 vssd1 vccd1 vccd1 sky130_fd_sc_hd__diode_2
XTAP_TAPCELL_ROW_28_412 vssd1 vccd1 sky130_fd_sc_hd__tapvpwrvgnd_1
XFILLER_45_269 vssd1 vssd1 vccd1 vccd1 sky130_fd_sc_hd__fill_2
XANTENNA_fanout30_X _2681_/S vssd1 vssd1 vccd1 vccd1 sky130_fd_sc_hd__diode_2
XTAP_TAPCELL_ROW_71_779 vssd1 vccd1 sky130_fd_sc_hd__tapvpwrvgnd_1
XFILLER_68_317 vssd1 vssd1 vccd1 vccd1 sky130_fd_sc_hd__fill_1
XTAP_TAPCELL_ROW_79_846 vssd1 vccd1 sky130_fd_sc_hd__tapvpwrvgnd_1
XFILLER_3_67 vssd1 vssd1 vccd1 vccd1 sky130_fd_sc_hd__fill_2
XTAP_TAPCELL_ROW_62_702 vssd1 vccd1 sky130_fd_sc_hd__tapvpwrvgnd_1
XTAP_TAPCELL_ROW_34_459 vssd1 vccd1 sky130_fd_sc_hd__tapvpwrvgnd_1
XANTENNA__2936__A1 _2966_/A1 vssd1 vssd1 vccd1 vccd1 sky130_fd_sc_hd__diode_2
XANTENNA__2936__B2 _2942_/B2 vssd1 vssd1 vccd1 vccd1 sky130_fd_sc_hd__diode_2
X_2724_ _2800_/B _2762_/B _2800_/C vssd1 vssd1 vccd1 vccd1 _2724_/X sky130_fd_sc_hd__and3_2
X_2655_ hold557/X _2845_/A1 _2666_/S vssd1 vssd1 vccd1 vccd1 _3169_/D sky130_fd_sc_hd__mux2_1
X_1606_ _3421_/Q _3424_/Q _3422_/Q _1613_/C vssd1 vssd1 vccd1 vccd1 _1606_/X sky130_fd_sc_hd__or4_2
X_2586_ hold704/X _2587_/A2 _2587_/B1 hold705/X vssd1 vssd1 vccd1 vccd1 _3138_/D sky130_fd_sc_hd__a22o_2
Xfanout116 _2942_/B2 vssd1 vssd1 vccd1 vccd1 _2961_/A1 sky130_fd_sc_hd__clkdlybuf4s25_1
Xfanout127 _2964_/C vssd1 vssd1 vccd1 vccd1 _2970_/C sky130_fd_sc_hd__clkdlybuf4s25_1
Xfanout138 _2472_/A vssd1 vssd1 vccd1 vccd1 _2926_/B sky130_fd_sc_hd__clkdlybuf4s25_1
X_1537_ _1546_/S _3381_/Q vssd1 vssd1 vccd1 vccd1 _3454_/D sky130_fd_sc_hd__and2b_2
Xfanout149 _3049_/Q vssd1 vssd1 vccd1 vccd1 _2326_/B sky130_fd_sc_hd__clkdlybuf4s25_1
X_3207_ _3404_/CLK _3207_/D load_slew281/X vssd1 vssd1 vccd1 vccd1 _3207_/Q sky130_fd_sc_hd__dfrtp_2
XFILLER_74_309 vssd1 vssd1 vccd1 vccd1 sky130_fd_sc_hd__fill_8
X_3138_ clkload7/A _3138_/D load_slew210/X vssd1 vssd1 vccd1 vccd1 _3138_/Q sky130_fd_sc_hd__dfrtp_2
X_3069_ clkload9/A _3069_/D vssd1 vssd1 vccd1 vccd1 _3069_/Q sky130_fd_sc_hd__dfxtp_2
XANTENNA__2624__B1 _2644_/B vssd1 vssd1 vccd1 vccd1 sky130_fd_sc_hd__diode_2
XANTENNA__2632__B _2644_/B vssd1 vssd1 vccd1 vccd1 sky130_fd_sc_hd__diode_2
XANTENNA_clkbuf_leaf_31_clk_A clkbuf_3_4__f_clk/X vssd1 vssd1 vccd1 vccd1 sky130_fd_sc_hd__diode_2
XANTENNA__2794__S _2798_/S vssd1 vssd1 vccd1 vccd1 sky130_fd_sc_hd__diode_2
XTAP_TAPCELL_ROW_76_816 vssd1 vccd1 sky130_fd_sc_hd__tapvpwrvgnd_1
XFILLER_77_169 vssd1 vssd1 vccd1 vccd1 sky130_fd_sc_hd__fill_4
XFILLER_73_397 vssd1 vssd1 vccd1 vccd1 sky130_fd_sc_hd__fill_1
XFILLER_41_261 vssd1 vssd1 vccd1 vccd1 sky130_fd_sc_hd__fill_4
XANTENNA__2918__A1 _2973_/A1 vssd1 vssd1 vccd1 vccd1 sky130_fd_sc_hd__diode_2
X_2440_ _2440_/A _2533_/B vssd1 vssd1 vccd1 vccd1 _2440_/Y sky130_fd_sc_hd__nor2_2
X_2371_ _2311_/A _2309_/A _2311_/B _2344_/B _2308_/A vssd1 vssd1 vccd1 vccd1 _2372_/B
+ sky130_fd_sc_hd__a311o_2
XFILLER_68_114 vssd1 vccd1 vssd1 vccd1 sky130_ef_sc_hd__decap_40_12
XTAP_TAPCELL_ROW_39_507 vssd1 vccd1 sky130_fd_sc_hd__tapvpwrvgnd_1
XTAP_TAPCELL_ROW_47_573 vssd1 vccd1 sky130_fd_sc_hd__tapvpwrvgnd_1
XANTENNA__2909__A1 _2966_/A1 vssd1 vssd1 vccd1 vccd1 sky130_fd_sc_hd__diode_2
XANTENNA__2909__B2 _2942_/B2 vssd1 vssd1 vccd1 vccd1 sky130_fd_sc_hd__diode_2
XANTENNA_fanout125_A _2959_/C vssd1 vssd1 vccd1 vccd1 sky130_fd_sc_hd__diode_2
XANTENNA__2385__A2 _2383_/B vssd1 vssd1 vccd1 vccd1 sky130_fd_sc_hd__diode_2
X_2707_ hold451/X _2802_/A1 _2719_/S vssd1 vssd1 vccd1 vccd1 _3218_/D sky130_fd_sc_hd__mux2_1
X_2638_ _3135_/Q _2646_/B vssd1 vssd1 vccd1 vccd1 _2638_/X sky130_fd_sc_hd__and2_2
X_2569_ _3415_/Q _1623_/B _1622_/C vssd1 vssd1 vccd1 vccd1 _2569_/Y sky130_fd_sc_hd__a21oi_2
XFILLER_59_125 vssd1 vssd1 vccd1 vccd1 sky130_fd_sc_hd__fill_2
XANTENNA__1812__A _1906_/A vssd1 vssd1 vccd1 vccd1 sky130_fd_sc_hd__diode_2
XFILLER_74_139 vssd1 vssd1 vccd1 vccd1 sky130_fd_sc_hd__fill_1
XFILLER_74_106 vssd1 vssd1 vccd1 vccd1 sky130_fd_sc_hd__fill_8
XTAP_TAPCELL_ROW_2_187 vssd1 vccd1 sky130_fd_sc_hd__tapvpwrvgnd_1
XANTENNA__2789__S _2799_/S vssd1 vssd1 vccd1 vccd1 sky130_fd_sc_hd__diode_2
XFILLER_38_309 vssd1 vssd1 vccd1 vccd1 sky130_fd_sc_hd__fill_4
XFILLER_0_57 vssd1 vccd1 vssd1 vccd1 sky130_ef_sc_hd__decap_40_12
XFILLER_64_82 vssd1 vssd1 vccd1 vccd1 sky130_fd_sc_hd__fill_2
XTAP_TAPCELL_ROW_44_543 vssd1 vccd1 sky130_fd_sc_hd__tapvpwrvgnd_1
X_1940_ _1939_/A _1939_/B _1939_/C vssd1 vssd1 vccd1 vccd1 _1942_/C sky130_fd_sc_hd__a21o_2
X_1871_ _1871_/A _1871_/B vssd1 vssd1 vccd1 vccd1 _1872_/B sky130_fd_sc_hd__nand2_2
XFILLER_9_55 vssd1 vssd1 vccd1 vccd1 sky130_fd_sc_hd__fill_1
XANTENNA__2699__S _2704_/S vssd1 vssd1 vccd1 vccd1 sky130_fd_sc_hd__diode_2
X_3541_ _3541_/A vssd1 vssd1 vccd1 vccd1 _3541_/X sky130_fd_sc_hd__buf_2
X_3472_ _3472_/CLK _3472_/D _3472_/SET_B vssd1 vssd1 vccd1 vccd1 _3472_/Q sky130_fd_sc_hd__dfstp_2
XFILLER_50_3 vssd1 vssd1 vccd1 vccd1 sky130_fd_sc_hd__fill_8
X_2423_ _3429_/Q _3428_/Q _1625_/Y vssd1 vssd1 vccd1 vccd1 _2423_/X sky130_fd_sc_hd__or3b_2
X_2354_ _2327_/A _2327_/C _2327_/B vssd1 vssd1 vccd1 vccd1 _2355_/B sky130_fd_sc_hd__a21boi_2
XFILLER_69_434 vssd1 vssd1 vccd1 vccd1 sky130_fd_sc_hd__fill_4
X_2285_ _2383_/B _2384_/B _2352_/C _2326_/B vssd1 vssd1 vccd1 vccd1 _2285_/X sky130_fd_sc_hd__and4_2
XANTENNA__2447__B _2533_/B vssd1 vssd1 vccd1 vccd1 sky130_fd_sc_hd__diode_2
XFILLER_49_180 vssd1 vccd1 vssd1 vccd1 sky130_ef_sc_hd__decap_40_12
XFILLER_52_378 vssd1 vssd1 vccd1 vccd1 sky130_fd_sc_hd__fill_1
XFILLER_12_209 vssd1 vssd1 vccd1 vccd1 sky130_fd_sc_hd__fill_2
XANTENNA_fanout242_A fanout290/X vssd1 vssd1 vccd1 vccd1 sky130_fd_sc_hd__diode_2
XFILLER_60_29 vssd1 vssd1 vccd1 vccd1 sky130_fd_sc_hd__fill_1
XANTENNA_fanout128_X _2964_/C vssd1 vssd1 vccd1 vccd1 sky130_fd_sc_hd__diode_2
XFILLER_4_419 vssd1 vssd1 vccd1 vccd1 sky130_fd_sc_hd__fill_1
XFILLER_79_209 vssd1 vssd1 vccd1 vccd1 sky130_fd_sc_hd__fill_8
XTAP_TAPCELL_ROW_7_235 vssd1 vccd1 sky130_fd_sc_hd__tapvpwrvgnd_1
XANTENNA_input2_X input2/X vssd1 vssd1 vccd1 vccd1 sky130_fd_sc_hd__diode_2
XFILLER_18_53 vssd1 vccd1 vssd1 vccd1 sky130_ef_sc_hd__decap_40_12
XTAP_TAPCELL_ROW_58_668 vssd1 vccd1 sky130_fd_sc_hd__tapvpwrvgnd_1
XFILLER_62_109 vssd1 vssd1 vccd1 vccd1 sky130_fd_sc_hd__fill_4
XFILLER_70_120 vssd1 vssd1 vccd1 vccd1 sky130_fd_sc_hd__fill_4
XFILLER_55_183 vssd1 vssd1 vccd1 vccd1 sky130_fd_sc_hd__fill_2
XFILLER_43_356 vssd1 vssd1 vccd1 vccd1 sky130_fd_sc_hd__fill_1
XTAP_TAPCELL_ROW_41_524 vssd1 vccd1 sky130_fd_sc_hd__tapvpwrvgnd_1
XFILLER_70_186 vssd1 vssd1 vccd1 vccd1 sky130_fd_sc_hd__fill_2
XFILLER_70_197 vssd1 vssd1 vccd1 vccd1 sky130_fd_sc_hd__fill_1
XFILLER_11_220 vssd1 vssd1 vccd1 vccd1 sky130_fd_sc_hd__fill_1
XFILLER_7_279 vssd1 vssd1 vccd1 vccd1 sky130_fd_sc_hd__fill_1
XANTENNA__2521__A2 _2967_/A2 vssd1 vssd1 vccd1 vccd1 sky130_fd_sc_hd__diode_2
XFILLER_78_253 vssd1 vssd1 vccd1 vccd1 sky130_fd_sc_hd__fill_2
X_2070_ _2070_/A _2091_/B _2068_/X vssd1 vssd1 vccd1 vccd1 _2070_/X sky130_fd_sc_hd__or3b_2
X_2972_ _2972_/A1 _2965_/X _2969_/X _2972_/B2 vssd1 vssd1 vccd1 vccd1 _2972_/X sky130_fd_sc_hd__a22o_2
XFILLER_34_389 vssd1 vssd1 vccd1 vccd1 sky130_fd_sc_hd__fill_1
X_1923_ hold690/X _2091_/B _1920_/X _1922_/Y vssd1 vssd1 vccd1 vccd1 _3061_/D sky130_fd_sc_hd__a22o_2
X_1854_ _1884_/A _2029_/B _1839_/B _1869_/A _1841_/A vssd1 vssd1 vccd1 vccd1 _1856_/D
+ sky130_fd_sc_hd__a41o_2
XTAP_TAPCELL_ROW_12_270 vssd1 vccd1 sky130_fd_sc_hd__tapvpwrvgnd_1
Xhold703 _3152_/Q vssd1 vssd1 vccd1 vccd1 hold703/X sky130_fd_sc_hd__dlygate4sd3_1
X_1785_ _1805_/A _1828_/D _1782_/Y _1797_/A vssd1 vssd1 vccd1 vccd1 _1786_/B sky130_fd_sc_hd__o2bb2a_2
Xhold736 _3423_/Q vssd1 vssd1 vccd1 vccd1 _1556_/A sky130_fd_sc_hd__dlygate4sd3_1
Xhold725 _3074_/Q vssd1 vssd1 vccd1 vccd1 hold725/X sky130_fd_sc_hd__dlygate4sd3_1
Xhold714 _2570_/X vssd1 vssd1 vccd1 vccd1 _3122_/D sky130_fd_sc_hd__dlygate4sd3_1
X_3455_ _3463_/CLK _3455_/D load_slew261/X vssd1 vssd1 vccd1 vccd1 _3455_/Q sky130_fd_sc_hd__dfrtp_2
XANTENNA_clkbuf_3_0__f_clk_X clkbuf_leaf_2_clk/A vssd1 vssd1 vccd1 vccd1 sky130_fd_sc_hd__diode_2
X_2406_ _2406_/A _2406_/B _2406_/C vssd1 vssd1 vccd1 vccd1 _2406_/X sky130_fd_sc_hd__and3_2
X_3386_ _3386_/CLK _3386_/D load_slew237/X vssd1 vssd1 vccd1 vccd1 _3386_/Q sky130_fd_sc_hd__dfrtp_2
XTAP_TAPCELL_ROW_4_205 vssd1 vccd1 sky130_fd_sc_hd__tapvpwrvgnd_1
XANTENNA__2458__A _2926_/B vssd1 vssd1 vccd1 vccd1 sky130_fd_sc_hd__diode_2
XANTENNA__2512__A2 _2901_/A2 vssd1 vssd1 vccd1 vccd1 sky130_fd_sc_hd__diode_2
X_2337_ _2295_/A _2295_/B _2336_/X vssd1 vssd1 vccd1 vccd1 _2339_/B sky130_fd_sc_hd__o21ai_2
X_2268_ _2268_/A _2268_/B vssd1 vssd1 vccd1 vccd1 _2305_/B sky130_fd_sc_hd__xnor2_2
X_2199_ _2199_/A _2199_/B vssd1 vssd1 vccd1 vccd1 _2200_/B sky130_fd_sc_hd__nor2_2
XTAP_TAPCELL_ROW_55_638 vssd1 vccd1 sky130_fd_sc_hd__tapvpwrvgnd_1
XFILLER_25_312 vssd1 vssd1 vccd1 vccd1 sky130_fd_sc_hd__fill_2
XANTENNA__2640__B _2644_/B vssd1 vssd1 vccd1 vccd1 sky130_fd_sc_hd__diode_2
XFILLER_4_249 vssd1 vssd1 vccd1 vccd1 sky130_fd_sc_hd__fill_2
XFILLER_0_455 vssd1 vssd1 vccd1 vccd1 sky130_fd_sc_hd__fill_1
XFILLER_0_444 vssd1 vssd1 vccd1 vccd1 sky130_fd_sc_hd__fill_1
XFILLER_0_433 vssd1 vssd1 vccd1 vccd1 sky130_fd_sc_hd__fill_4
XANTENNA_fanout60_X _1585_/A vssd1 vssd1 vccd1 vccd1 sky130_fd_sc_hd__diode_2
XFILLER_29_96 vssd1 vssd1 vccd1 vccd1 sky130_fd_sc_hd__fill_1
XFILLER_29_74 vssd1 vssd1 vccd1 vccd1 sky130_fd_sc_hd__fill_1
XTAP_TAPCELL_ROW_18_329 vssd1 vccd1 sky130_fd_sc_hd__tapvpwrvgnd_1
XFILLER_45_51 vssd1 vssd1 vccd1 vccd1 sky130_fd_sc_hd__fill_4
XFILLER_43_164 vssd1 vssd1 vccd1 vccd1 sky130_fd_sc_hd__fill_4
XTAP_TAPCELL_ROW_26_395 vssd1 vccd1 sky130_fd_sc_hd__tapvpwrvgnd_1
X_1570_ _3425_/Q _1572_/B vssd1 vssd1 vccd1 vccd1 _3412_/D sky130_fd_sc_hd__and2_2
XANTENNA__1881__S _1993_/S vssd1 vssd1 vccd1 vccd1 sky130_fd_sc_hd__diode_2
X_3240_ _3387_/CLK _3240_/D load_slew237/X vssd1 vssd1 vccd1 vccd1 _3240_/Q sky130_fd_sc_hd__dfrtp_2
X_3171_ _3389_/CLK _3171_/D fanout274/X vssd1 vssd1 vccd1 vccd1 _3171_/Q sky130_fd_sc_hd__dfrtp_2
X_2122_ hold725/X _2421_/B _2143_/A _2121_/X vssd1 vssd1 vccd1 vccd1 _3074_/D sky130_fd_sc_hd__a22o_2
XFILLER_66_212 vssd1 vssd1 vccd1 vccd1 sky130_fd_sc_hd__fill_1
XFILLER_13_3 vssd1 vccd1 vssd1 vccd1 sky130_ef_sc_hd__decap_40_12
XFILLER_19_150 vssd1 vssd1 vccd1 vccd1 sky130_fd_sc_hd__fill_8
X_2053_ _2053_/A _2053_/B vssd1 vssd1 vccd1 vccd1 _2062_/A sky130_fd_sc_hd__xnor2_2
XFILLER_47_492 vssd1 vssd1 vccd1 vccd1 sky130_fd_sc_hd__fill_2
XFILLER_19_194 vssd1 vssd1 vccd1 vccd1 sky130_fd_sc_hd__fill_1
XFILLER_34_197 vssd1 vssd1 vccd1 vccd1 sky130_fd_sc_hd__fill_2
XFILLER_34_186 vssd1 vssd1 vccd1 vccd1 sky130_fd_sc_hd__fill_1
XANTENNA__1769__A0 _2326_/B vssd1 vssd1 vccd1 vccd1 sky130_fd_sc_hd__diode_2
X_2955_ _3215_/Q _2970_/B _2957_/C vssd1 vssd1 vccd1 vccd1 _2955_/X sky130_fd_sc_hd__and3_2
X_2886_ hold635/X _3437_/D _2885_/X vssd1 vssd1 vccd1 vccd1 _3390_/D sky130_fd_sc_hd__o21a_2
X_1906_ _1906_/A _2029_/D vssd1 vssd1 vccd1 vccd1 _1911_/A sky130_fd_sc_hd__nand2_2
XTAP_TAPCELL_ROW_60_685 vssd1 vccd1 sky130_fd_sc_hd__tapvpwrvgnd_1
X_1837_ _1906_/A _1947_/A _1865_/B _2005_/A vssd1 vssd1 vccd1 vccd1 _1869_/A sky130_fd_sc_hd__nand4_2
Xhold511 _3145_/Q vssd1 vssd1 vccd1 vccd1 hold511/X sky130_fd_sc_hd__dlygate4sd3_1
Xhold500 _3240_/Q vssd1 vssd1 vccd1 vccd1 hold500/X sky130_fd_sc_hd__dlygate4sd3_1
Xhold544 _3259_/Q vssd1 vssd1 vccd1 vccd1 hold544/X sky130_fd_sc_hd__dlygate4sd3_1
Xhold533 _3316_/Q vssd1 vssd1 vccd1 vccd1 hold533/X sky130_fd_sc_hd__dlygate4sd3_1
Xhold522 _3113_/Q vssd1 vssd1 vccd1 vccd1 hold522/X sky130_fd_sc_hd__dlygate4sd3_1
X_1768_ _2284_/B hold625/X _1771_/S vssd1 vssd1 vccd1 vccd1 _3048_/D sky130_fd_sc_hd__mux2_1
Xhold588 _3295_/Q vssd1 vssd1 vccd1 vccd1 hold588/X sky130_fd_sc_hd__dlygate4sd3_1
Xhold577 _2975_/X vssd1 vssd1 vccd1 vccd1 _3399_/D sky130_fd_sc_hd__dlygate4sd3_1
Xhold566 _3187_/Q vssd1 vssd1 vccd1 vccd1 hold566/X sky130_fd_sc_hd__dlygate4sd3_1
Xhold555 _3299_/Q vssd1 vssd1 vccd1 vccd1 hold555/X sky130_fd_sc_hd__dlygate4sd3_1
X_1699_ _1699_/A _1699_/B vssd1 vssd1 vccd1 vccd1 _1701_/A sky130_fd_sc_hd__nand2_2
X_3438_ _3441_/CLK _3438_/D fanout268/X vssd1 vssd1 vccd1 vccd1 _3438_/Q sky130_fd_sc_hd__dfrtp_2
Xhold599 _3319_/Q vssd1 vssd1 vccd1 vccd1 hold599/X sky130_fd_sc_hd__dlygate4sd3_1
X_3369_ _2992_/Y _3369_/D _3472_/SET_B vssd1 vssd1 vccd1 vccd1 _3445_/D sky130_fd_sc_hd__dfrtp_2
XFILLER_57_212 vssd1 vssd1 vccd1 vccd1 sky130_fd_sc_hd__fill_1
XTAP_TAPCELL_ROW_68_752 vssd1 vccd1 sky130_fd_sc_hd__tapvpwrvgnd_1
XFILLER_17_109 vssd1 vssd1 vccd1 vccd1 sky130_fd_sc_hd__fill_2
XTAP_TAPCELL_ROW_23_365 vssd1 vccd1 sky130_fd_sc_hd__tapvpwrvgnd_1
XFILLER_31_31 vssd1 vssd1 vccd1 vccd1 sky130_fd_sc_hd__fill_1
XANTENNA__2185__B1 _2284_/B vssd1 vssd1 vccd1 vccd1 sky130_fd_sc_hd__diode_2
XANTENNA__2797__S _2798_/S vssd1 vssd1 vccd1 vccd1 sky130_fd_sc_hd__diode_2
Xoutput7 _3541_/X vssd1 vssd1 vccd1 vccd1 gpio_out[4] sky130_fd_sc_hd__clkdlybuf4s25_1
XANTENNA__2488__A1 _2445_/S vssd1 vssd1 vccd1 vccd1 sky130_fd_sc_hd__diode_2
XFILLER_48_201 vssd1 vssd1 vccd1 vccd1 sky130_fd_sc_hd__fill_1
Xteam_02_360 vssd1 vssd1 vccd1 vccd1 gpio_oeb[30] team_02_360/LO sky130_fd_sc_hd__conb_1
XFILLER_63_237 vssd1 vssd1 vccd1 vccd1 sky130_fd_sc_hd__fill_1
XTAP_TAPCELL_ROW_74_799 vssd1 vccd1 sky130_fd_sc_hd__tapvpwrvgnd_1
XFILLER_16_153 vssd1 vssd1 vccd1 vccd1 sky130_fd_sc_hd__fill_8
XANTENNA__2264__C _2326_/B vssd1 vssd1 vccd1 vccd1 sky130_fd_sc_hd__diode_2
XFILLER_71_292 vssd1 vssd1 vccd1 vccd1 sky130_fd_sc_hd__fill_1
XFILLER_71_281 vssd1 vssd1 vccd1 vccd1 sky130_fd_sc_hd__fill_2
XFILLER_31_134 vssd1 vssd1 vccd1 vccd1 sky130_fd_sc_hd__fill_2
XFILLER_16_197 vssd1 vssd1 vccd1 vccd1 sky130_fd_sc_hd__fill_2
X_2740_ hold513/X _2816_/A1 _2742_/S vssd1 vssd1 vccd1 vccd1 _3250_/D sky130_fd_sc_hd__mux2_1
XANTENNA__2963__A2 _2864_/S vssd1 vssd1 vccd1 vccd1 sky130_fd_sc_hd__diode_2
X_2671_ hold489/X _2842_/A1 _2681_/S vssd1 vssd1 vccd1 vccd1 _3184_/D sky130_fd_sc_hd__mux2_1
X_1622_ _1622_/A _1622_/B _1622_/C vssd1 vssd1 vccd1 vccd1 _3432_/D sky130_fd_sc_hd__or3_2
XANTENNA__1905__A _1906_/A vssd1 vssd1 vccd1 vccd1 sky130_fd_sc_hd__diode_2
X_1553_ _3397_/Q _3469_/Q _1554_/S vssd1 vssd1 vccd1 vccd1 _3471_/D sky130_fd_sc_hd__mux2_1
X_3223_ _3331_/CLK _3223_/D load_slew234/X vssd1 vssd1 vccd1 vccd1 _3223_/Q sky130_fd_sc_hd__dfrtp_2
X_3154_ _3352_/CLK _3154_/D load_slew253/X vssd1 vssd1 vccd1 vccd1 _3154_/Q sky130_fd_sc_hd__dfrtp_2
X_3085_ clkload9/A _3085_/D vssd1 vssd1 vccd1 vccd1 _3085_/Q sky130_fd_sc_hd__dfxtp_2
X_2105_ _2124_/A _2146_/D _2102_/Y _2117_/A vssd1 vssd1 vccd1 vccd1 _2106_/B sky130_fd_sc_hd__o2bb2a_2
XTAP_TAPCELL_ROW_65_722 vssd1 vccd1 sky130_fd_sc_hd__tapvpwrvgnd_1
XANTENNA__2455__B _2926_/C vssd1 vssd1 vccd1 vccd1 sky130_fd_sc_hd__diode_2
X_2036_ _2009_/A _2009_/B _2025_/A _2002_/B vssd1 vssd1 vccd1 vccd1 _2036_/X sky130_fd_sc_hd__o211a_2
XANTENNA_fanout155_A _3046_/Q vssd1 vssd1 vccd1 vccd1 sky130_fd_sc_hd__diode_2
X_2938_ _3357_/Q _2970_/B _2970_/C vssd1 vssd1 vccd1 vccd1 _2938_/X sky130_fd_sc_hd__and3_2
XANTENNA__2954__A2 _2967_/A2 vssd1 vssd1 vccd1 vccd1 sky130_fd_sc_hd__diode_2
XTAP_TAPCELL_ROW_20_346 vssd1 vccd1 sky130_fd_sc_hd__tapvpwrvgnd_1
XANTENNA_fanout110_X _1690_/S vssd1 vssd1 vccd1 vccd1 sky130_fd_sc_hd__diode_2
X_2869_ _2686_/A _2868_/X _2866_/X _1585_/A vssd1 vssd1 vccd1 vccd1 _2869_/X sky130_fd_sc_hd__a211o_2
Xhold374 _3078_/Q vssd1 vssd1 vccd1 vccd1 hold374/X sky130_fd_sc_hd__dlygate4sd3_1
Xhold385 _3414_/Q vssd1 vssd1 vccd1 vccd1 hold385/X sky130_fd_sc_hd__dlygate4sd3_1
Xhold396 _3412_/Q vssd1 vssd1 vccd1 vccd1 hold396/X sky130_fd_sc_hd__dlygate4sd3_1
XTAP_TAPCELL_ROW_28_413 vssd1 vccd1 sky130_fd_sc_hd__tapvpwrvgnd_1
XFILLER_26_42 vssd1 vssd1 vccd1 vccd1 sky130_fd_sc_hd__fill_4
XFILLER_26_31 vssd1 vssd1 vccd1 vccd1 sky130_fd_sc_hd__fill_4
Xclkbuf_3_6__f_clk clkbuf_0_clk/X vssd1 vssd1 vccd1 vccd1 clkload4/A sky130_fd_sc_hd__clkbuf_16
XANTENNA_fanout23_X _2742_/S vssd1 vssd1 vccd1 vccd1 sky130_fd_sc_hd__diode_2
XFILLER_9_105 vssd1 vssd1 vccd1 vccd1 sky130_fd_sc_hd__fill_4
XFILLER_41_443 vssd1 vssd1 vccd1 vccd1 sky130_fd_sc_hd__fill_1
XANTENNA__2945__A2 _2971_/A2 vssd1 vssd1 vccd1 vccd1 sky130_fd_sc_hd__diode_2
XANTENNA_clkbuf_leaf_5_clk_A clkload1/A vssd1 vssd1 vccd1 vccd1 sky130_fd_sc_hd__diode_2
XFILLER_5_333 vssd1 vssd1 vccd1 vccd1 sky130_fd_sc_hd__fill_2
XFILLER_68_307 vssd1 vssd1 vccd1 vccd1 sky130_fd_sc_hd__fill_1
XTAP_TAPCELL_ROW_79_847 vssd1 vccd1 sky130_fd_sc_hd__tapvpwrvgnd_1
XFILLER_67_82 vssd1 vccd1 vssd1 vccd1 sky130_ef_sc_hd__decap_40_12
XTAP_TAPCELL_ROW_62_703 vssd1 vccd1 sky130_fd_sc_hd__tapvpwrvgnd_1
XANTENNA__2397__B1 _2399_/B vssd1 vssd1 vccd1 vccd1 sky130_fd_sc_hd__diode_2
X_2723_ hold539/X _2818_/A1 _2723_/S vssd1 vssd1 vccd1 vccd1 _3234_/D sky130_fd_sc_hd__mux2_1
X_2654_ hold587/X _2844_/A1 _2666_/S vssd1 vssd1 vccd1 vccd1 _3168_/D sky130_fd_sc_hd__mux2_1
XFILLER_8_193 vssd1 vssd1 vccd1 vccd1 sky130_fd_sc_hd__fill_2
X_2585_ hold722/X _2587_/A2 _2587_/B1 hold723/X vssd1 vssd1 vccd1 vccd1 _3137_/D sky130_fd_sc_hd__a22o_2
X_1605_ _2588_/A _3423_/Q vssd1 vssd1 vccd1 vccd1 _1613_/C sky130_fd_sc_hd__or2_2
X_1536_ _3444_/Q _3472_/Q _1535_/X vssd1 vssd1 vccd1 vccd1 _3444_/D sky130_fd_sc_hd__o21a_2
Xfanout117 _2972_/B2 vssd1 vssd1 vccd1 vccd1 _2942_/B2 sky130_fd_sc_hd__clkdlybuf4s25_1
Xfanout128 _3089_/Q vssd1 vssd1 vccd1 vccd1 _2964_/C sky130_fd_sc_hd__clkdlybuf4s25_1
Xfanout139 _2472_/A vssd1 vssd1 vccd1 vccd1 _2924_/B sky130_fd_sc_hd__clkdlybuf4s25_1
X_3206_ _3388_/CLK _3206_/D fanout241/X vssd1 vssd1 vccd1 vccd1 _3206_/Q sky130_fd_sc_hd__dfrtp_2
XANTENNA_fanout272_A fanout279/X vssd1 vssd1 vccd1 vccd1 sky130_fd_sc_hd__diode_2
X_3137_ clkload7/A _3137_/D fanout236/X vssd1 vssd1 vccd1 vccd1 _3137_/Q sky130_fd_sc_hd__dfrtp_2
X_3068_ clkload9/A _3068_/D vssd1 vssd1 vccd1 vccd1 _3068_/Q sky130_fd_sc_hd__dfxtp_2
XANTENNA__2624__A1 _3405_/Q vssd1 vssd1 vccd1 vccd1 sky130_fd_sc_hd__diode_2
X_2019_ _2019_/A _2019_/B vssd1 vssd1 vccd1 vccd1 _2020_/B sky130_fd_sc_hd__nand2_2
XANTENNA__2913__B _2964_/C vssd1 vssd1 vccd1 vccd1 sky130_fd_sc_hd__diode_2
XFILLER_50_251 vssd1 vssd1 vccd1 vccd1 sky130_fd_sc_hd__fill_1
XFILLER_10_115 vssd1 vssd1 vccd1 vccd1 sky130_fd_sc_hd__fill_4
XFILLER_12_33 vssd1 vssd1 vccd1 vccd1 sky130_fd_sc_hd__fill_2
XTAP_TAPCELL_ROW_76_817 vssd1 vccd1 sky130_fd_sc_hd__tapvpwrvgnd_1
XANTENNA__2095__B _2421_/B vssd1 vssd1 vccd1 vccd1 sky130_fd_sc_hd__diode_2
XFILLER_53_84 vssd1 vssd1 vccd1 vccd1 sky130_fd_sc_hd__fill_1
XFILLER_5_185 vssd1 vssd1 vccd1 vccd1 sky130_fd_sc_hd__fill_2
X_2370_ _2370_/A _2370_/B vssd1 vssd1 vccd1 vccd1 _2373_/A sky130_fd_sc_hd__nor2_2
XFILLER_38_5 vssd1 vssd1 vccd1 vccd1 sky130_fd_sc_hd__fill_1
XANTENNA__2838__X _2838_/X vssd1 vssd1 vccd1 vccd1 sky130_fd_sc_hd__diode_2
XFILLER_68_126 vssd1 vssd1 vccd1 vccd1 sky130_fd_sc_hd__fill_4
XFILLER_1_391 vssd1 vssd1 vccd1 vccd1 sky130_fd_sc_hd__fill_1
XTAP_TAPCELL_ROW_47_574 vssd1 vccd1 sky130_fd_sc_hd__tapvpwrvgnd_1
XFILLER_64_365 vssd1 vssd1 vccd1 vccd1 sky130_fd_sc_hd__fill_1
XFILLER_17_281 vssd1 vssd1 vccd1 vccd1 sky130_fd_sc_hd__fill_2
XTAP_TAPCELL_ROW_30_430 vssd1 vccd1 sky130_fd_sc_hd__tapvpwrvgnd_1
X_2706_ hold664/X _2839_/A1 _2723_/S vssd1 vssd1 vccd1 vccd1 _3217_/D sky130_fd_sc_hd__mux2_1
XANTENNA_fanout118_A _2838_/A vssd1 vssd1 vccd1 vccd1 sky130_fd_sc_hd__diode_2
X_2637_ hold508/X _2813_/A1 _2645_/S vssd1 vssd1 vccd1 vccd1 _3157_/D sky130_fd_sc_hd__mux2_1
XPHY_EDGE_ROW_12_Right_12 vssd1 vssd1 vccd1 vccd1 sky130_fd_sc_hd__decap_3
X_2568_ _1569_/D _2540_/X _2560_/Y hold659/X vssd1 vssd1 vccd1 vccd1 _3121_/D sky130_fd_sc_hd__a22o_2
XFILLER_58_29 vssd1 vssd1 vccd1 vccd1 sky130_fd_sc_hd__fill_8
X_2499_ _3257_/Q _2960_/A2 wire66/X _3239_/Q _2498_/X vssd1 vssd1 vccd1 vccd1 _2499_/X
+ sky130_fd_sc_hd__a221o_2
X_1519_ _3366_/Q _3451_/D _1525_/S vssd1 vssd1 vccd1 vccd1 _3375_/D sky130_fd_sc_hd__mux2_1
XFILLER_74_129 vssd1 vssd1 vccd1 vccd1 sky130_fd_sc_hd__fill_8
XFILLER_55_321 vssd1 vssd1 vccd1 vccd1 sky130_fd_sc_hd__fill_2
XTAP_TAPCELL_ROW_2_188 vssd1 vccd1 sky130_fd_sc_hd__tapvpwrvgnd_1
XPHY_EDGE_ROW_21_Right_21 vssd1 vssd1 vccd1 vccd1 sky130_fd_sc_hd__decap_3
XFILLER_70_324 vssd1 vssd1 vccd1 vccd1 sky130_fd_sc_hd__fill_1
XFILLER_70_346 vssd1 vssd1 vccd1 vccd1 sky130_fd_sc_hd__fill_1
XFILLER_11_446 vssd1 vssd1 vccd1 vccd1 sky130_fd_sc_hd__fill_2
XPHY_EDGE_ROW_30_Right_30 vssd1 vssd1 vccd1 vccd1 sky130_fd_sc_hd__decap_3
XFILLER_78_424 vssd1 vssd1 vccd1 vccd1 sky130_fd_sc_hd__fill_4
XFILLER_48_62 vssd1 vssd1 vccd1 vccd1 sky130_fd_sc_hd__fill_2
XFILLER_73_151 vssd1 vccd1 vssd1 vccd1 sky130_ef_sc_hd__decap_40_12
XFILLER_0_69 vssd1 vssd1 vccd1 vccd1 sky130_fd_sc_hd__fill_4
XFILLER_46_398 vssd1 vssd1 vccd1 vccd1 sky130_fd_sc_hd__fill_1
XTAP_TAPCELL_ROW_44_544 vssd1 vccd1 sky130_fd_sc_hd__tapvpwrvgnd_1
XFILLER_14_251 vssd1 vssd1 vccd1 vccd1 sky130_fd_sc_hd__fill_1
X_1870_ _1869_/B _1869_/C _1869_/A vssd1 vssd1 vccd1 vccd1 _1871_/B sky130_fd_sc_hd__a21o_2
X_3540_ _3540_/A vssd1 vssd1 vccd1 vccd1 _3540_/X sky130_fd_sc_hd__buf_2
X_3471_ _3471_/CLK _3471_/D fanout251/X vssd1 vssd1 vccd1 vccd1 _3471_/Q sky130_fd_sc_hd__dfrtp_2
X_2422_ _3426_/Q _2838_/B _1590_/Y _1618_/Y _1623_/Y vssd1 vssd1 vccd1 vccd1 wire10/A
+ sky130_fd_sc_hd__a2111oi_1
XFILLER_43_3 vssd1 vssd1 vccd1 vccd1 sky130_fd_sc_hd__fill_1
X_2353_ _2353_/A _2353_/B vssd1 vssd1 vccd1 vccd1 _2355_/A sky130_fd_sc_hd__or2_2
X_2284_ _3037_/Q _2284_/B vssd1 vssd1 vccd1 vccd1 _2288_/A sky130_fd_sc_hd__nand2_2
XFILLER_49_192 vssd1 vssd1 vccd1 vccd1 sky130_fd_sc_hd__fill_4
XFILLER_64_162 vssd1 vssd1 vccd1 vccd1 sky130_fd_sc_hd__fill_2
XANTENNA_fanout235_A fanout242/X vssd1 vssd1 vccd1 vccd1 sky130_fd_sc_hd__diode_2
XANTENNA_clkbuf_leaf_30_clk_A clkload3/A vssd1 vssd1 vccd1 vccd1 sky130_fd_sc_hd__diode_2
X_1999_ _1999_/A _2034_/A vssd1 vssd1 vccd1 vccd1 _2043_/A sky130_fd_sc_hd__or2_2
XFILLER_69_28 vssd1 vssd1 vccd1 vccd1 sky130_fd_sc_hd__fill_4
XANTENNA__2638__B _2646_/B vssd1 vssd1 vccd1 vccd1 sky130_fd_sc_hd__diode_2
XANTENNA__3114__RESET_B fanout223/X vssd1 vssd1 vccd1 vccd1 sky130_fd_sc_hd__diode_2
XFILLER_75_438 vssd1 vssd1 vccd1 vccd1 sky130_fd_sc_hd__fill_2
XANTENNA_fanout50_A _2620_/X vssd1 vssd1 vccd1 vccd1 sky130_fd_sc_hd__diode_2
XTAP_TAPCELL_ROW_58_669 vssd1 vccd1 sky130_fd_sc_hd__tapvpwrvgnd_1
XFILLER_28_354 vssd1 vssd1 vccd1 vccd1 sky130_fd_sc_hd__fill_1
XFILLER_18_65 vssd1 vssd1 vccd1 vccd1 sky130_fd_sc_hd__fill_2
XFILLER_28_398 vssd1 vssd1 vccd1 vccd1 sky130_fd_sc_hd__fill_1
XFILLER_34_64 vssd1 vssd1 vccd1 vccd1 sky130_fd_sc_hd__fill_1
XFILLER_34_53 vssd1 vssd1 vccd1 vccd1 sky130_fd_sc_hd__fill_2
XFILLER_11_210 vssd1 vssd1 vccd1 vccd1 sky130_fd_sc_hd__fill_8
XFILLER_7_225 vssd1 vssd1 vccd1 vccd1 sky130_fd_sc_hd__fill_4
XFILLER_78_298 vssd1 vssd1 vccd1 vccd1 sky130_fd_sc_hd__fill_1
XFILLER_46_195 vssd1 vssd1 vccd1 vccd1 sky130_fd_sc_hd__fill_1
X_2971_ _3270_/Q _2971_/A2 _2971_/B1 _3252_/Q _2970_/X vssd1 vssd1 vccd1 vccd1 _2971_/X
+ sky130_fd_sc_hd__a221o_2
XFILLER_34_379 vssd1 vssd1 vccd1 vccd1 sky130_fd_sc_hd__fill_1
X_1922_ _2091_/B _1922_/B vssd1 vssd1 vccd1 vccd1 _1922_/Y sky130_fd_sc_hd__nor2_2
X_1853_ _1884_/A _2002_/B _2029_/B _1979_/A vssd1 vssd1 vccd1 vccd1 _1856_/C sky130_fd_sc_hd__a22o_2
XTAP_TAPCELL_ROW_12_271 vssd1 vccd1 sky130_fd_sc_hd__tapvpwrvgnd_1
X_1784_ _1782_/Y _1797_/A _1805_/A _1970_/B vssd1 vssd1 vccd1 vccd1 _1800_/A sky130_fd_sc_hd__and4bb_2
XANTENNA__1627__B _2610_/A vssd1 vssd1 vccd1 vccd1 sky130_fd_sc_hd__diode_2
Xhold737 _3069_/Q vssd1 vssd1 vccd1 vccd1 hold737/X sky130_fd_sc_hd__dlygate4sd3_1
Xhold726 _3389_/Q vssd1 vssd1 vccd1 vccd1 hold726/X sky130_fd_sc_hd__dlygate4sd3_1
Xhold715 _3004_/Q vssd1 vssd1 vccd1 vccd1 hold715/X sky130_fd_sc_hd__dlygate4sd3_1
Xhold704 _3020_/Q vssd1 vssd1 vccd1 vccd1 hold704/X sky130_fd_sc_hd__dlygate4sd3_1
XFILLER_6_280 vssd1 vccd1 vssd1 vccd1 sky130_ef_sc_hd__decap_40_12
X_3454_ _3463_/CLK _3454_/D load_slew261/X vssd1 vssd1 vccd1 vccd1 _3454_/Q sky130_fd_sc_hd__dfrtp_2
X_2405_ _2405_/A _2405_/B vssd1 vssd1 vccd1 vccd1 _2406_/C sky130_fd_sc_hd__xnor2_2
X_3385_ _3386_/CLK _3385_/D load_slew237/X vssd1 vssd1 vccd1 vccd1 _3385_/Q sky130_fd_sc_hd__dfrtp_2
XTAP_TAPCELL_ROW_4_206 vssd1 vccd1 sky130_fd_sc_hd__tapvpwrvgnd_1
XANTENNA__2458__B _2926_/C vssd1 vssd1 vccd1 vccd1 sky130_fd_sc_hd__diode_2
X_2336_ _2295_/A _2295_/B _2298_/B vssd1 vssd1 vccd1 vccd1 _2336_/X sky130_fd_sc_hd__a21bo_2
X_2267_ _2291_/A _2267_/B vssd1 vssd1 vccd1 vccd1 _2268_/B sky130_fd_sc_hd__xnor2_2
XFILLER_72_419 vssd1 vssd1 vccd1 vccd1 sky130_fd_sc_hd__fill_1
X_2198_ _2143_/A _2142_/B _2163_/A _2163_/B _2140_/Y vssd1 vssd1 vccd1 vccd1 _2199_/B
+ sky130_fd_sc_hd__a221oi_2
XTAP_TAPCELL_ROW_55_639 vssd1 vccd1 sky130_fd_sc_hd__tapvpwrvgnd_1
XFILLER_65_493 vssd1 vssd1 vccd1 vccd1 sky130_fd_sc_hd__fill_1
XANTENNA__3460__CLK _3463_/CLK vssd1 vssd1 vccd1 vccd1 sky130_fd_sc_hd__diode_2
XANTENNA_fanout140_X _2472_/A vssd1 vssd1 vccd1 vccd1 sky130_fd_sc_hd__diode_2
XFILLER_40_327 vssd1 vssd1 vccd1 vccd1 sky130_fd_sc_hd__fill_1
XFILLER_20_55 vssd1 vssd1 vccd1 vccd1 sky130_fd_sc_hd__fill_4
XFILLER_29_42 vssd1 vssd1 vccd1 vccd1 sky130_fd_sc_hd__fill_1
XFILLER_56_471 vssd1 vssd1 vccd1 vccd1 sky130_fd_sc_hd__fill_1
XFILLER_16_302 vssd1 vssd1 vccd1 vccd1 sky130_fd_sc_hd__fill_4
XANTENNA__2424__C1 _2540_/A vssd1 vssd1 vccd1 vccd1 sky130_fd_sc_hd__diode_2
XTAP_TAPCELL_ROW_26_396 vssd1 vccd1 sky130_fd_sc_hd__tapvpwrvgnd_1
XANTENNA__1778__A1 _1805_/A vssd1 vssd1 vccd1 vccd1 sky130_fd_sc_hd__diode_2
XFILLER_3_283 vssd1 vssd1 vccd1 vccd1 sky130_fd_sc_hd__fill_1
X_3170_ _3388_/CLK _3170_/D fanout239/X vssd1 vssd1 vccd1 vccd1 _3170_/Q sky130_fd_sc_hd__dfrtp_2
XANTENNA__1613__D _2540_/A vssd1 vssd1 vccd1 vccd1 sky130_fd_sc_hd__diode_2
X_2121_ _2106_/A _2107_/X _2119_/Y _2374_/S vssd1 vssd1 vccd1 vccd1 _2121_/X sky130_fd_sc_hd__o31a_2
XFILLER_39_427 vssd1 vssd1 vccd1 vccd1 sky130_fd_sc_hd__fill_4
X_2052_ _2049_/X _2052_/B vssd1 vssd1 vccd1 vccd1 _2053_/B sky130_fd_sc_hd__nand2b_2
XFILLER_66_257 vssd1 vssd1 vccd1 vccd1 sky130_fd_sc_hd__fill_1
XFILLER_34_154 vssd1 vssd1 vccd1 vccd1 sky130_fd_sc_hd__fill_2
XFILLER_34_143 vssd1 vssd1 vccd1 vccd1 sky130_fd_sc_hd__fill_1
X_2954_ _3233_/Q _2967_/A2 _2953_/X _2520_/A vssd1 vssd1 vccd1 vccd1 _2954_/X sky130_fd_sc_hd__a22o_2
X_2885_ _2686_/A _2879_/X _2881_/X _2445_/S _2884_/X vssd1 vssd1 vccd1 vccd1 _2885_/X
+ sky130_fd_sc_hd__a221o_2
X_1905_ _1906_/A _2029_/D vssd1 vssd1 vccd1 vccd1 _1912_/A sky130_fd_sc_hd__and2_2
XTAP_TAPCELL_ROW_60_686 vssd1 vccd1 sky130_fd_sc_hd__tapvpwrvgnd_1
X_1836_ _1947_/A _1865_/B _2005_/A _1906_/A vssd1 vssd1 vccd1 vccd1 _1839_/B sky130_fd_sc_hd__a22o_2
XPHY_EDGE_ROW_6_Right_6 vssd1 vssd1 vccd1 vccd1 sky130_fd_sc_hd__decap_3
Xhold501 _3298_/Q vssd1 vssd1 vccd1 vccd1 hold501/X sky130_fd_sc_hd__dlygate4sd3_1
X_1767_ _2263_/A hold717/X _1773_/S vssd1 vssd1 vccd1 vccd1 _3047_/D sky130_fd_sc_hd__mux2_1
Xhold545 _3243_/Q vssd1 vssd1 vccd1 vccd1 hold545/X sky130_fd_sc_hd__dlygate4sd3_1
Xhold534 _3080_/Q vssd1 vssd1 vccd1 vccd1 hold534/X sky130_fd_sc_hd__dlygate4sd3_1
Xhold523 _3266_/Q vssd1 vssd1 vccd1 vccd1 hold523/X sky130_fd_sc_hd__dlygate4sd3_1
Xhold512 _3079_/Q vssd1 vssd1 vccd1 vccd1 hold512/X sky130_fd_sc_hd__dlygate4sd3_1
Xhold578 _3239_/Q vssd1 vssd1 vccd1 vccd1 hold578/X sky130_fd_sc_hd__dlygate4sd3_1
Xhold567 _3322_/Q vssd1 vssd1 vccd1 vccd1 hold567/X sky130_fd_sc_hd__dlygate4sd3_1
Xhold556 _3306_/Q vssd1 vssd1 vccd1 vccd1 hold556/X sky130_fd_sc_hd__dlygate4sd3_1
X_1698_ _3081_/Q _3064_/Q vssd1 vssd1 vccd1 vccd1 _1699_/B sky130_fd_sc_hd__nand2_2
X_3437_ _3437_/CLK _3437_/D fanout262/X vssd1 vssd1 vccd1 vccd1 _3437_/Q sky130_fd_sc_hd__dfrtp_2
Xhold589 _3192_/Q vssd1 vssd1 vccd1 vccd1 hold589/X sky130_fd_sc_hd__dlygate4sd3_1
XANTENNA__2497__A2 _2960_/A2 vssd1 vssd1 vccd1 vccd1 sky130_fd_sc_hd__diode_2
X_3368_ _2991_/Y _3368_/D load_slew286/X vssd1 vssd1 vccd1 vccd1 _3453_/D sky130_fd_sc_hd__dfrtp_2
X_2319_ _2319_/A _2357_/A vssd1 vssd1 vccd1 vccd1 _2340_/A sky130_fd_sc_hd__or2_2
XFILLER_66_29 vssd1 vccd1 vssd1 vccd1 sky130_ef_sc_hd__decap_40_12
XANTENNA_fanout188_X _2073_/C vssd1 vssd1 vccd1 vccd1 sky130_fd_sc_hd__diode_2
X_3299_ _3302_/CLK _3299_/D load_slew273/X vssd1 vssd1 vccd1 vccd1 _3299_/Q sky130_fd_sc_hd__dfrtp_2
XTAP_TAPCELL_ROW_68_753 vssd1 vccd1 sky130_fd_sc_hd__tapvpwrvgnd_1
XFILLER_57_279 vssd1 vssd1 vccd1 vccd1 sky130_fd_sc_hd__fill_1
XFILLER_38_493 vssd1 vssd1 vccd1 vccd1 sky130_fd_sc_hd__fill_1
XFILLER_40_102 vssd1 vssd1 vccd1 vccd1 sky130_fd_sc_hd__fill_2
XANTENNA_fanout13_A _2819_/X vssd1 vssd1 vccd1 vccd1 sky130_fd_sc_hd__diode_2
XTAP_TAPCELL_ROW_23_366 vssd1 vccd1 sky130_fd_sc_hd__tapvpwrvgnd_1
XANTENNA__2185__A1 _2263_/A vssd1 vssd1 vccd1 vccd1 sky130_fd_sc_hd__diode_2
Xteam_02_350 vssd1 vssd1 vccd1 vccd1 gpio_oeb[20] team_02_350/LO sky130_fd_sc_hd__conb_1
Xteam_02_361 vssd1 vssd1 vccd1 vccd1 gpio_oeb[31] team_02_361/LO sky130_fd_sc_hd__conb_1
XFILLER_29_493 vssd1 vssd1 vccd1 vccd1 sky130_fd_sc_hd__fill_1
XFILLER_16_121 vssd1 vssd1 vccd1 vccd1 sky130_fd_sc_hd__fill_2
XANTENNA__2264__D _2284_/B vssd1 vssd1 vccd1 vccd1 sky130_fd_sc_hd__diode_2
XFILLER_31_113 vssd1 vssd1 vccd1 vccd1 sky130_fd_sc_hd__fill_2
XANTENNA__2948__B1 _2971_/B1 vssd1 vssd1 vccd1 vccd1 sky130_fd_sc_hd__diode_2
XFILLER_72_83 vssd1 vssd1 vccd1 vccd1 sky130_fd_sc_hd__fill_1
XPHY_EDGE_ROW_59_Right_59 vssd1 vssd1 vccd1 vccd1 sky130_fd_sc_hd__decap_3
XFILLER_8_320 vssd1 vssd1 vccd1 vccd1 sky130_fd_sc_hd__fill_2
XFILLER_12_371 vssd1 vssd1 vccd1 vccd1 sky130_fd_sc_hd__fill_1
X_2670_ hold636/X _2803_/A1 _2681_/S vssd1 vssd1 vccd1 vccd1 _3183_/D sky130_fd_sc_hd__mux2_1
X_1621_ _1621_/A _1621_/B vssd1 vssd1 vccd1 vccd1 _1621_/Y sky130_fd_sc_hd__nor2_2
X_1552_ _3396_/Q _3468_/Q _1554_/S vssd1 vssd1 vccd1 vccd1 _3469_/D sky130_fd_sc_hd__mux2_1
XANTENNA__1905__B _2029_/D vssd1 vssd1 vccd1 vccd1 sky130_fd_sc_hd__diode_2
X_3222_ _3331_/CLK _3222_/D load_slew232/X vssd1 vssd1 vccd1 vccd1 _3222_/Q sky130_fd_sc_hd__dfrtp_2
X_3153_ _3297_/CLK _3153_/D load_slew273/X vssd1 vssd1 vccd1 vccd1 _3153_/Q sky130_fd_sc_hd__dfrtp_2
XPHY_EDGE_ROW_68_Right_68 vssd1 vssd1 vccd1 vccd1 sky130_fd_sc_hd__decap_3
XFILLER_79_393 vssd1 vssd1 vccd1 vccd1 sky130_fd_sc_hd__fill_4
XFILLER_79_371 vssd1 vssd1 vccd1 vccd1 sky130_fd_sc_hd__fill_1
XANTENNA__2884__C1 _1585_/A vssd1 vssd1 vccd1 vccd1 sky130_fd_sc_hd__diode_2
X_2104_ _2102_/Y _2117_/A _2124_/A _2284_/B vssd1 vssd1 vccd1 vccd1 _2106_/A sky130_fd_sc_hd__and4bb_2
X_3084_ clkload9/A _3084_/D vssd1 vssd1 vccd1 vccd1 _3084_/Q sky130_fd_sc_hd__dfxtp_2
XTAP_TAPCELL_ROW_65_723 vssd1 vccd1 sky130_fd_sc_hd__tapvpwrvgnd_1
X_2035_ _2033_/X _2035_/B vssd1 vssd1 vccd1 vccd1 _2038_/A sky130_fd_sc_hd__and2b_2
XFILLER_50_411 vssd1 vssd1 vccd1 vccd1 sky130_fd_sc_hd__fill_1
XANTENNA__2939__B1 _2971_/B1 vssd1 vssd1 vccd1 vccd1 sky130_fd_sc_hd__diode_2
XPHY_EDGE_ROW_77_Right_77 vssd1 vssd1 vccd1 vccd1 sky130_fd_sc_hd__decap_3
XFILLER_22_157 vssd1 vssd1 vccd1 vccd1 sky130_fd_sc_hd__fill_1
X_2937_ _3231_/Q _2967_/A2 _2936_/X _2520_/A vssd1 vssd1 vccd1 vccd1 _2937_/X sky130_fd_sc_hd__a22o_2
X_2868_ _3189_/Q _2927_/A2 _2927_/B1 _3171_/Q _2867_/X vssd1 vssd1 vccd1 vccd1 _2868_/X
+ sky130_fd_sc_hd__a221o_2
X_2799_ hold556/X _2818_/A1 _2799_/S vssd1 vssd1 vccd1 vccd1 _3306_/D sky130_fd_sc_hd__mux2_1
X_1819_ _1819_/A _1819_/B vssd1 vssd1 vccd1 vccd1 _1820_/B sky130_fd_sc_hd__nor2_2
XANTENNA_fanout103_X _2540_/A vssd1 vssd1 vccd1 vccd1 sky130_fd_sc_hd__diode_2
XPHY_EDGE_ROW_15_Left_95 vssd1 vssd1 vccd1 vccd1 sky130_fd_sc_hd__decap_3
Xhold364 _3413_/Q vssd1 vssd1 vccd1 vccd1 _3415_/D sky130_fd_sc_hd__dlygate4sd3_1
Xhold375 _3081_/Q vssd1 vssd1 vccd1 vccd1 hold375/X sky130_fd_sc_hd__dlygate4sd3_1
Xhold386 _1596_/X vssd1 vssd1 vccd1 vccd1 _3424_/D sky130_fd_sc_hd__dlygate4sd3_1
Xhold397 _1597_/X vssd1 vssd1 vccd1 vccd1 _3423_/D sky130_fd_sc_hd__dlygate4sd3_1
XFILLER_77_39 vssd1 vssd1 vccd1 vccd1 sky130_fd_sc_hd__fill_1
XANTENNA__2646__B _2646_/B vssd1 vssd1 vccd1 vccd1 sky130_fd_sc_hd__diode_2
XANTENNA__2890__A2 _2894_/A2 vssd1 vssd1 vccd1 vccd1 sky130_fd_sc_hd__diode_2
XTAP_TAPCELL_ROW_28_414 vssd1 vccd1 sky130_fd_sc_hd__tapvpwrvgnd_1
XFILLER_26_452 vssd1 vssd1 vccd1 vccd1 sky130_fd_sc_hd__fill_2
XTAP_TAPCELL_ROW_36_480 vssd1 vccd1 sky130_fd_sc_hd__tapvpwrvgnd_1
XFILLER_13_113 vssd1 vssd1 vccd1 vccd1 sky130_fd_sc_hd__fill_4
XANTENNA_fanout16_X _2814_/S vssd1 vssd1 vccd1 vccd1 sky130_fd_sc_hd__diode_2
XFILLER_42_97 vssd1 vssd1 vccd1 vccd1 sky130_fd_sc_hd__fill_1
XTAP_TAPCELL_ROW_79_848 vssd1 vccd1 sky130_fd_sc_hd__tapvpwrvgnd_1
XFILLER_3_69 vssd1 vssd1 vccd1 vccd1 sky130_fd_sc_hd__fill_1
XFILLER_67_72 vssd1 vssd1 vccd1 vccd1 sky130_fd_sc_hd__fill_1
XFILLER_67_61 vssd1 vssd1 vccd1 vccd1 sky130_fd_sc_hd__fill_2
XFILLER_67_94 vssd1 vssd1 vccd1 vccd1 sky130_fd_sc_hd__fill_8
XTAP_TAPCELL_ROW_70_770 vssd1 vccd1 sky130_fd_sc_hd__tapvpwrvgnd_1
XANTENNA__2397__A1 _2399_/A vssd1 vssd1 vccd1 vccd1 sky130_fd_sc_hd__diode_2
X_2722_ hold654/X _2817_/A1 _2723_/S vssd1 vssd1 vccd1 vccd1 _3233_/D sky130_fd_sc_hd__mux2_1
XFILLER_73_3 vssd1 vccd1 vssd1 vccd1 sky130_ef_sc_hd__decap_40_12
X_2653_ hold575/X _2805_/A1 _2666_/S vssd1 vssd1 vccd1 vccd1 _3167_/D sky130_fd_sc_hd__mux2_1
X_2584_ hold650/X _2587_/A2 _2587_/B1 hold666/X vssd1 vssd1 vccd1 vccd1 _3136_/D sky130_fd_sc_hd__a22o_2
X_1604_ _2588_/A _1603_/A _1609_/B _2611_/A vssd1 vssd1 vccd1 vccd1 _1604_/X sky130_fd_sc_hd__a31o_2
X_1535_ _3444_/Q _3472_/Q _3442_/Q vssd1 vssd1 vccd1 vccd1 _1535_/X sky130_fd_sc_hd__a21bo_2
Xfanout107 _3470_/Q vssd1 vssd1 vccd1 vccd1 _1546_/S sky130_fd_sc_hd__clkdlybuf4s25_1
Xfanout118 _2838_/A vssd1 vssd1 vccd1 vccd1 _2800_/A sky130_fd_sc_hd__clkdlybuf4s25_1
Xfanout129 _2472_/B vssd1 vssd1 vccd1 vccd1 _2533_/B sky130_fd_sc_hd__clkdlybuf4s25_1
X_3205_ _3349_/CLK _3205_/D load_slew205/X vssd1 vssd1 vccd1 vccd1 _3205_/Q sky130_fd_sc_hd__dfrtp_2
X_3136_ clkload7/A _3136_/D load_slew210/X vssd1 vssd1 vccd1 vccd1 _3136_/Q sky130_fd_sc_hd__dfrtp_2
XFILLER_27_205 vssd1 vssd1 vccd1 vccd1 sky130_fd_sc_hd__fill_1
X_3067_ clkload9/A _3067_/D vssd1 vssd1 vccd1 vccd1 _3067_/Q sky130_fd_sc_hd__dfxtp_2
XANTENNA_fanout265_A fanout290/X vssd1 vssd1 vccd1 vccd1 sky130_fd_sc_hd__diode_2
X_2018_ _2019_/A _2019_/B vssd1 vssd1 vccd1 vccd1 _2018_/Y sky130_fd_sc_hd__nor2_2
XANTENNA__2624__A2 _2610_/A vssd1 vssd1 vccd1 vccd1 sky130_fd_sc_hd__diode_2
XFILLER_23_444 vssd1 vssd1 vccd1 vccd1 sky130_fd_sc_hd__fill_2
XTAP_TAPCELL_ROW_33_450 vssd1 vccd1 sky130_fd_sc_hd__tapvpwrvgnd_1
XFILLER_10_105 vssd1 vssd1 vccd1 vccd1 sky130_fd_sc_hd__fill_2
XFILLER_12_89 vssd1 vssd1 vccd1 vccd1 sky130_fd_sc_hd__fill_2
XANTENNA__2560__A1 _1569_/D vssd1 vssd1 vccd1 vccd1 sky130_fd_sc_hd__diode_2
XANTENNA_fanout80_A _2438_/X vssd1 vssd1 vccd1 vccd1 sky130_fd_sc_hd__diode_2
XTAP_TAPCELL_ROW_76_818 vssd1 vccd1 sky130_fd_sc_hd__tapvpwrvgnd_1
XFILLER_73_311 vssd1 vssd1 vccd1 vccd1 sky130_fd_sc_hd__fill_1
XFILLER_73_333 vssd1 vssd1 vccd1 vccd1 sky130_fd_sc_hd__fill_2
XFILLER_14_477 vssd1 vssd1 vccd1 vccd1 sky130_fd_sc_hd__fill_2
XFILLER_5_197 vssd1 vssd1 vccd1 vccd1 sky130_fd_sc_hd__fill_2
XFILLER_24_208 vssd1 vssd1 vccd1 vccd1 sky130_fd_sc_hd__fill_1
XTAP_TAPCELL_ROW_47_575 vssd1 vccd1 sky130_fd_sc_hd__tapvpwrvgnd_1
XTAP_TAPCELL_ROW_30_431 vssd1 vccd1 sky130_fd_sc_hd__tapvpwrvgnd_1
X_2705_ _2781_/B _2762_/B _2800_/C vssd1 vssd1 vccd1 vccd1 _2705_/X sky130_fd_sc_hd__and3_2
X_2636_ _3134_/Q _2644_/B vssd1 vssd1 vccd1 vccd1 _2636_/X sky130_fd_sc_hd__and2_2
X_2567_ _1569_/D _2528_/X _2560_/Y hold496/X vssd1 vssd1 vccd1 vccd1 _3120_/D sky130_fd_sc_hd__a22o_2
X_2498_ _2959_/B _2957_/C _3275_/Q vssd1 vssd1 vccd1 vccd1 _2498_/X sky130_fd_sc_hd__and3_2
X_1518_ _3367_/Q _3452_/D _1525_/S vssd1 vssd1 vccd1 vccd1 _3376_/D sky130_fd_sc_hd__mux2_1
XFILLER_59_127 vssd1 vssd1 vccd1 vccd1 sky130_fd_sc_hd__fill_1
XFILLER_4_90 vssd1 vssd1 vccd1 vccd1 sky130_fd_sc_hd__fill_4
XANTENNA_clkbuf_leaf_4_clk_A clkload1/A vssd1 vssd1 vccd1 vccd1 sky130_fd_sc_hd__diode_2
XPHY_EDGE_ROW_27_Left_107 vssd1 vssd1 vccd1 vccd1 sky130_fd_sc_hd__decap_3
XFILLER_67_182 vssd1 vssd1 vccd1 vccd1 sky130_fd_sc_hd__fill_4
XANTENNA_fanout170_X _1906_/A vssd1 vssd1 vccd1 vccd1 sky130_fd_sc_hd__diode_2
X_3119_ _3119_/CLK _3119_/D fanout217/X vssd1 vssd1 vccd1 vccd1 _3119_/Q sky130_fd_sc_hd__dfrtp_2
XTAP_TAPCELL_ROW_2_189 vssd1 vccd1 sky130_fd_sc_hd__tapvpwrvgnd_1
XFILLER_55_344 vssd1 vssd1 vccd1 vccd1 sky130_fd_sc_hd__fill_1
XFILLER_15_219 vssd1 vssd1 vccd1 vccd1 sky130_fd_sc_hd__fill_1
XPHY_EDGE_ROW_36_Left_116 vssd1 vssd1 vccd1 vccd1 sky130_fd_sc_hd__decap_3
XFILLER_3_3 vssd1 vccd1 vssd1 vccd1 sky130_ef_sc_hd__decap_40_12
XPHY_EDGE_ROW_45_Left_125 vssd1 vssd1 vccd1 vccd1 sky130_fd_sc_hd__decap_3
XFILLER_73_163 vssd1 vssd1 vccd1 vccd1 sky130_fd_sc_hd__fill_4
XFILLER_64_62 vssd1 vssd1 vccd1 vccd1 sky130_fd_sc_hd__fill_2
XTAP_TAPCELL_ROW_44_545 vssd1 vccd1 sky130_fd_sc_hd__tapvpwrvgnd_1
XFILLER_9_35 vssd1 vccd1 vssd1 vccd1 sky130_ef_sc_hd__decap_40_12
XPHY_EDGE_ROW_54_Left_134 vssd1 vssd1 vccd1 vccd1 sky130_fd_sc_hd__decap_3
XFILLER_9_57 vssd1 vccd1 vssd1 vccd1 sky130_ef_sc_hd__decap_40_12
X_3470_ _3471_/CLK _3470_/D fanout251/X vssd1 vssd1 vccd1 vccd1 _3470_/Q sky130_fd_sc_hd__dfrtp_2
X_2421_ _2421_/A _2421_/B vssd1 vssd1 vccd1 vccd1 _3087_/D sky130_fd_sc_hd__and2_2
X_2352_ _2384_/B _2352_/B _2352_/C _2399_/B vssd1 vssd1 vccd1 vccd1 _2353_/B sky130_fd_sc_hd__and4_2
XANTENNA__2297__A _2297_/A vssd1 vssd1 vccd1 vccd1 sky130_fd_sc_hd__diode_2
X_2283_ _2283_/A _2283_/B vssd1 vssd1 vccd1 vccd1 _2289_/A sky130_fd_sc_hd__xnor2_2
XPHY_EDGE_ROW_63_Left_143 vssd1 vssd1 vccd1 vccd1 sky130_fd_sc_hd__decap_3
XFILLER_69_447 vssd1 vssd1 vccd1 vccd1 sky130_fd_sc_hd__fill_1
XPHY_EDGE_ROW_72_Left_152 vssd1 vssd1 vccd1 vccd1 sky130_fd_sc_hd__decap_3
XANTENNA_fanout130_A _2472_/B vssd1 vssd1 vccd1 vccd1 sky130_fd_sc_hd__diode_2
XANTENNA_fanout228_A fanout291/X vssd1 vssd1 vccd1 vccd1 sky130_fd_sc_hd__diode_2
X_1998_ _2073_/A _1998_/B _1998_/C vssd1 vssd1 vccd1 vccd1 _2034_/A sky130_fd_sc_hd__and3_2
X_2619_ hold689/X _2842_/A1 _2645_/S vssd1 vssd1 vccd1 vccd1 _3148_/D sky130_fd_sc_hd__mux2_1
XFILLER_75_417 vssd1 vssd1 vccd1 vccd1 sky130_fd_sc_hd__fill_4
XFILLER_55_185 vssd1 vssd1 vccd1 vccd1 sky130_fd_sc_hd__fill_1
XFILLER_70_166 vssd1 vssd1 vccd1 vccd1 sky130_fd_sc_hd__fill_2
XFILLER_7_215 vssd1 vssd1 vccd1 vccd1 sky130_fd_sc_hd__fill_8
XFILLER_11_299 vssd1 vssd1 vccd1 vccd1 sky130_fd_sc_hd__fill_8
XANTENNA__2506__A1 _2962_/A1 vssd1 vssd1 vccd1 vccd1 sky130_fd_sc_hd__diode_2
XANTENNA__2506__B2 _2961_/A1 vssd1 vssd1 vccd1 vccd1 sky130_fd_sc_hd__diode_2
XFILLER_78_255 vssd1 vssd1 vccd1 vccd1 sky130_fd_sc_hd__fill_1
Xfanout290 fanout291/X vssd1 vssd1 vccd1 vccd1 fanout290/X sky130_fd_sc_hd__clkdlybuf4s25_1
XPHY_EDGE_ROW_3_Left_83 vssd1 vssd1 vccd1 vccd1 sky130_fd_sc_hd__decap_3
XFILLER_61_144 vssd1 vssd1 vccd1 vccd1 sky130_fd_sc_hd__fill_2
XFILLER_61_111 vssd1 vssd1 vccd1 vccd1 sky130_fd_sc_hd__fill_1
X_2970_ _3288_/Q _2970_/B _2970_/C vssd1 vssd1 vccd1 vccd1 _2970_/X sky130_fd_sc_hd__and3_2
X_1921_ _1920_/A _1920_/C _1920_/B vssd1 vssd1 vccd1 vccd1 _1922_/B sky130_fd_sc_hd__o21a_2
X_1852_ _1884_/A _1979_/A _2002_/B _2029_/B vssd1 vssd1 vccd1 vccd1 _1890_/A sky130_fd_sc_hd__nand4_2
X_1783_ _3038_/Q _1813_/A _1805_/B _1962_/B vssd1 vssd1 vccd1 vccd1 _1797_/A sky130_fd_sc_hd__and4_2
XTAP_TAPCELL_ROW_12_272 vssd1 vccd1 sky130_fd_sc_hd__tapvpwrvgnd_1
Xhold727 _3394_/Q vssd1 vssd1 vccd1 vccd1 hold727/X sky130_fd_sc_hd__dlygate4sd3_1
Xhold716 _3104_/Q vssd1 vssd1 vccd1 vccd1 hold716/X sky130_fd_sc_hd__dlygate4sd3_1
Xhold705 _3138_/Q vssd1 vssd1 vccd1 vccd1 hold705/X sky130_fd_sc_hd__dlygate4sd3_1
X_3453_ _3453_/CLK _3453_/D fanout289/X vssd1 vssd1 vccd1 vccd1 _3453_/Q sky130_fd_sc_hd__dfrtp_2
Xhold738 _3086_/Q vssd1 vssd1 vccd1 vccd1 hold738/X sky130_fd_sc_hd__dlygate4sd3_1
XFILLER_6_292 vssd1 vssd1 vccd1 vccd1 sky130_fd_sc_hd__fill_4
X_2404_ _2404_/A _2404_/B vssd1 vssd1 vccd1 vccd1 _2405_/B sky130_fd_sc_hd__nand2_2
XFILLER_69_211 vssd1 vssd1 vccd1 vccd1 sky130_fd_sc_hd__fill_1
X_3384_ _3386_/CLK _3384_/D fanout238/X vssd1 vssd1 vccd1 vccd1 _3384_/Q sky130_fd_sc_hd__dfrtp_2
X_2335_ _2339_/A vssd1 vssd1 vccd1 vccd1 _2338_/A sky130_fd_sc_hd__inv_2
XTAP_TAPCELL_ROW_4_207 vssd1 vccd1 sky130_fd_sc_hd__tapvpwrvgnd_1
X_2266_ _2292_/A _2291_/B vssd1 vssd1 vccd1 vccd1 _2267_/B sky130_fd_sc_hd__nand2_2
X_2197_ _2197_/A _2197_/B vssd1 vssd1 vccd1 vccd1 _2200_/A sky130_fd_sc_hd__nor2_2
XFILLER_20_34 vssd1 vssd1 vccd1 vccd1 sky130_fd_sc_hd__fill_4
XANTENNA__2489__X _2489_/X vssd1 vssd1 vccd1 vccd1 sky130_fd_sc_hd__diode_2
XFILLER_48_417 vssd1 vssd1 vccd1 vccd1 sky130_fd_sc_hd__fill_2
XFILLER_29_32 vssd1 vssd1 vccd1 vccd1 sky130_fd_sc_hd__fill_8
XFILLER_28_141 vssd1 vssd1 vccd1 vccd1 sky130_fd_sc_hd__fill_1
XFILLER_43_111 vssd1 vssd1 vccd1 vccd1 sky130_fd_sc_hd__fill_1
XTAP_TAPCELL_ROW_26_397 vssd1 vccd1 sky130_fd_sc_hd__tapvpwrvgnd_1
XANTENNA__1778__A2 _1947_/A vssd1 vssd1 vccd1 vccd1 sky130_fd_sc_hd__diode_2
X_2120_ _2106_/A _2107_/X _2119_/Y vssd1 vssd1 vccd1 vccd1 _2143_/A sky130_fd_sc_hd__o21ai_2
X_2051_ _2073_/A _2049_/B _2073_/B _2073_/C vssd1 vssd1 vccd1 vccd1 _2052_/B sky130_fd_sc_hd__a22o_2
XTAP_TAPCELL_ROW_17_320 vssd1 vccd1 sky130_fd_sc_hd__tapvpwrvgnd_1
X_2953_ _2962_/A1 _3161_/Q _3305_/Q _2961_/A1 vssd1 vssd1 vccd1 vccd1 _2953_/X sky130_fd_sc_hd__a22o_2
XFILLER_34_199 vssd1 vssd1 vccd1 vccd1 sky130_fd_sc_hd__fill_1
XFILLER_22_317 vssd1 vssd1 vccd1 vccd1 sky130_fd_sc_hd__fill_1
XANTENNA__2966__A1 _2966_/A1 vssd1 vssd1 vccd1 vccd1 sky130_fd_sc_hd__diode_2
XANTENNA__2966__B2 _2972_/B2 vssd1 vssd1 vccd1 vccd1 sky130_fd_sc_hd__diode_2
X_1904_ _1902_/Y _1904_/B vssd1 vssd1 vccd1 vccd1 _1913_/A sky130_fd_sc_hd__nand2b_2
X_2884_ _2942_/B2 _2883_/X _2877_/X _1585_/A vssd1 vssd1 vccd1 vccd1 _2884_/X sky130_fd_sc_hd__a211o_2
X_1835_ _1834_/A _1833_/Y _1834_/Y vssd1 vssd1 vccd1 vccd1 _1842_/A sky130_fd_sc_hd__a21oi_2
Xhold502 _3275_/Q vssd1 vssd1 vccd1 vccd1 hold502/X sky130_fd_sc_hd__dlygate4sd3_1
X_1766_ _2154_/B hold561/X _1773_/S vssd1 vssd1 vccd1 vccd1 _3046_/D sky130_fd_sc_hd__mux2_1
Xhold535 _3110_/Q vssd1 vssd1 vccd1 vccd1 hold535/X sky130_fd_sc_hd__dlygate4sd3_1
Xhold524 _3160_/Q vssd1 vssd1 vccd1 vccd1 hold524/X sky130_fd_sc_hd__dlygate4sd3_1
Xhold513 _3250_/Q vssd1 vssd1 vccd1 vccd1 hold513/X sky130_fd_sc_hd__dlygate4sd3_1
Xhold579 _3237_/Q vssd1 vssd1 vccd1 vccd1 hold579/X sky130_fd_sc_hd__dlygate4sd3_1
Xhold568 _3260_/Q vssd1 vssd1 vccd1 vccd1 hold568/X sky130_fd_sc_hd__dlygate4sd3_1
Xhold557 _3169_/Q vssd1 vssd1 vccd1 vccd1 hold557/X sky130_fd_sc_hd__dlygate4sd3_1
Xhold546 _3227_/Q vssd1 vssd1 vccd1 vccd1 hold546/X sky130_fd_sc_hd__dlygate4sd3_1
X_1697_ _3081_/Q _3064_/Q vssd1 vssd1 vccd1 vccd1 _1699_/A sky130_fd_sc_hd__or2_2
X_3436_ _3436_/CLK _3436_/D fanout226/X vssd1 vssd1 vccd1 vccd1 _3436_/Q sky130_fd_sc_hd__dfrtp_2
X_3367_ _2990_/Y _3367_/D load_slew286/X vssd1 vssd1 vccd1 vccd1 _3367_/Q sky130_fd_sc_hd__dfrtp_2
X_2318_ _2318_/A _2318_/B _2318_/C vssd1 vssd1 vccd1 vccd1 _2357_/A sky130_fd_sc_hd__and3_2
XFILLER_57_225 vssd1 vssd1 vccd1 vccd1 sky130_fd_sc_hd__fill_2
X_3298_ _3352_/CLK _3298_/D fanout254/X vssd1 vssd1 vccd1 vccd1 _3298_/Q sky130_fd_sc_hd__dfrtp_2
XTAP_TAPCELL_ROW_68_754 vssd1 vccd1 sky130_fd_sc_hd__tapvpwrvgnd_1
X_2249_ _2248_/B _2248_/C _2206_/X vssd1 vssd1 vccd1 vccd1 _2252_/C sky130_fd_sc_hd__a21bo_2
XFILLER_25_111 vssd1 vssd1 vccd1 vccd1 sky130_fd_sc_hd__fill_1
XFILLER_25_166 vssd1 vssd1 vccd1 vccd1 sky130_fd_sc_hd__fill_2
XANTENNA__3089__Q _3089_/Q vssd1 vssd1 vccd1 vccd1 sky130_fd_sc_hd__diode_2
XFILLER_25_177 vssd1 vssd1 vccd1 vccd1 sky130_fd_sc_hd__fill_2
XTAP_TAPCELL_ROW_23_367 vssd1 vccd1 sky130_fd_sc_hd__tapvpwrvgnd_1
XFILLER_31_11 vssd1 vssd1 vccd1 vccd1 sky130_fd_sc_hd__fill_1
XANTENNA__1564__A _2533_/A vssd1 vssd1 vccd1 vccd1 sky130_fd_sc_hd__diode_2
XFILLER_0_221 vssd1 vssd1 vccd1 vccd1 sky130_fd_sc_hd__fill_2
Xteam_02_340 vssd1 vssd1 vccd1 vccd1 gpio_oeb[10] team_02_340/LO sky130_fd_sc_hd__conb_1
Xteam_02_351 vssd1 vssd1 vccd1 vccd1 gpio_oeb[21] team_02_351/LO sky130_fd_sc_hd__conb_1
Xteam_02_362 vssd1 vssd1 vccd1 vccd1 gpio_oeb[32] team_02_362/LO sky130_fd_sc_hd__conb_1
XFILLER_56_74 vssd1 vssd1 vccd1 vccd1 sky130_fd_sc_hd__fill_8
XANTENNA_clkbuf_3_1__f_clk_A clkbuf_0_clk/X vssd1 vssd1 vccd1 vccd1 sky130_fd_sc_hd__diode_2
XFILLER_56_85 vssd1 vssd1 vccd1 vccd1 sky130_fd_sc_hd__fill_2
XFILLER_44_475 vssd1 vssd1 vccd1 vccd1 sky130_fd_sc_hd__fill_1
XFILLER_31_169 vssd1 vssd1 vccd1 vccd1 sky130_fd_sc_hd__fill_2
X_1620_ _3423_/Q _3421_/Q _3424_/Q _3422_/Q vssd1 vssd1 vccd1 vccd1 _1621_/B sky130_fd_sc_hd__nor4_2
XFILLER_8_365 vssd1 vssd1 vccd1 vccd1 sky130_fd_sc_hd__fill_2
XANTENNA__1923__A2 _2091_/B vssd1 vssd1 vccd1 vccd1 sky130_fd_sc_hd__diode_2
X_1551_ _3395_/Q _3467_/Q _1554_/S vssd1 vssd1 vccd1 vccd1 _3468_/D sky130_fd_sc_hd__mux2_1
X_3221_ _3331_/CLK _3221_/D load_slew230/X vssd1 vssd1 vccd1 vccd1 _3221_/Q sky130_fd_sc_hd__dfrtp_2
XFILLER_79_361 vssd1 vssd1 vccd1 vccd1 sky130_fd_sc_hd__fill_2
X_3152_ _3383_/CLK _3152_/D fanout263/X vssd1 vssd1 vccd1 vccd1 _3152_/Q sky130_fd_sc_hd__dfrtp_2
X_2103_ _2132_/A _2124_/B _2154_/B _2146_/B vssd1 vssd1 vccd1 vccd1 _2117_/A sky130_fd_sc_hd__and4_2
X_3083_ _3101_/CLK _3083_/D vssd1 vssd1 vccd1 vccd1 _3083_/Q sky130_fd_sc_hd__dfxtp_2
XTAP_TAPCELL_ROW_65_724 vssd1 vccd1 sky130_fd_sc_hd__tapvpwrvgnd_1
X_2034_ _2034_/A _2034_/B vssd1 vssd1 vccd1 vccd1 _2035_/B sky130_fd_sc_hd__or2_2
XTAP_TAPCELL_ROW_73_790 vssd1 vccd1 sky130_fd_sc_hd__tapvpwrvgnd_1
XFILLER_50_423 vssd1 vssd1 vccd1 vccd1 sky130_fd_sc_hd__fill_1
X_2936_ _2966_/A1 _3159_/Q _3303_/Q _2942_/B2 vssd1 vssd1 vccd1 vccd1 _2936_/X sky130_fd_sc_hd__a22o_2
X_2867_ _2924_/B _2924_/C _3207_/Q vssd1 vssd1 vccd1 vccd1 _2867_/X sky130_fd_sc_hd__and3_2
XFILLER_30_191 vssd1 vssd1 vccd1 vccd1 sky130_fd_sc_hd__fill_1
X_1818_ _1818_/A _1818_/B vssd1 vssd1 vccd1 vccd1 _1822_/A sky130_fd_sc_hd__xnor2_2
X_2798_ hold627/X _2817_/A1 _2798_/S vssd1 vssd1 vccd1 vccd1 _3305_/D sky130_fd_sc_hd__mux2_1
X_1749_ _2029_/D hold699/X _3435_/D vssd1 vssd1 vccd1 vccd1 _3029_/D sky130_fd_sc_hd__mux2_1
Xhold365 _3442_/Q vssd1 vssd1 vccd1 vccd1 _3472_/D sky130_fd_sc_hd__dlygate4sd3_1
Xhold376 _3449_/Q vssd1 vssd1 vccd1 vccd1 hold376/X sky130_fd_sc_hd__dlygate4sd3_1
Xhold387 _3447_/Q vssd1 vssd1 vccd1 vccd1 hold387/X sky130_fd_sc_hd__dlygate4sd3_1
XFILLER_77_18 vssd1 vssd1 vccd1 vccd1 sky130_fd_sc_hd__fill_2
X_3419_ _3429_/CLK _3419_/D load_slew225/X vssd1 vssd1 vccd1 vccd1 _3419_/Q sky130_fd_sc_hd__dfrtp_2
Xhold398 _3214_/Q vssd1 vssd1 vccd1 vccd1 hold398/X sky130_fd_sc_hd__dlygate4sd3_1
XFILLER_26_431 vssd1 vssd1 vccd1 vccd1 sky130_fd_sc_hd__fill_2
XTAP_TAPCELL_ROW_36_481 vssd1 vccd1 sky130_fd_sc_hd__tapvpwrvgnd_1
XANTENNA__1993__S _1993_/S vssd1 vssd1 vccd1 vccd1 sky130_fd_sc_hd__diode_2
XFILLER_5_335 vssd1 vssd1 vccd1 vccd1 sky130_fd_sc_hd__fill_1
XFILLER_3_15 vssd1 vccd1 vssd1 vccd1 sky130_ef_sc_hd__decap_40_12
XTAP_TAPCELL_ROW_79_849 vssd1 vccd1 sky130_fd_sc_hd__tapvpwrvgnd_1
XFILLER_67_40 vssd1 vssd1 vccd1 vccd1 sky130_fd_sc_hd__fill_2
XFILLER_3_59 vssd1 vssd1 vccd1 vccd1 sky130_fd_sc_hd__fill_8
XFILLER_76_386 vssd1 vssd1 vccd1 vccd1 sky130_fd_sc_hd__fill_1
XANTENNA__2618__B1 _2646_/B vssd1 vssd1 vccd1 vccd1 sky130_fd_sc_hd__diode_2
XFILLER_32_423 vssd1 vssd1 vccd1 vccd1 sky130_fd_sc_hd__fill_1
XTAP_TAPCELL_ROW_70_771 vssd1 vccd1 sky130_fd_sc_hd__tapvpwrvgnd_1
X_2721_ hold554/X _2816_/A1 _2723_/S vssd1 vssd1 vccd1 vccd1 _3232_/D sky130_fd_sc_hd__mux2_1
X_2652_ hold668/X _2842_/A1 _2662_/S vssd1 vssd1 vccd1 vccd1 _3166_/D sky130_fd_sc_hd__mux2_1
XFILLER_8_195 vssd1 vssd1 vccd1 vccd1 sky130_fd_sc_hd__fill_1
XFILLER_66_3 vssd1 vssd1 vccd1 vccd1 sky130_fd_sc_hd__fill_4
X_2583_ hold731/X _1622_/C _2583_/B1 _3135_/Q vssd1 vssd1 vccd1 vccd1 _2583_/X sky130_fd_sc_hd__a22o_2
X_1603_ _1603_/A _1609_/B vssd1 vssd1 vccd1 vccd1 _1629_/A sky130_fd_sc_hd__nand2_2
X_1534_ _1503_/Y _3361_/Q _1534_/S vssd1 vssd1 vccd1 vccd1 _3361_/D sky130_fd_sc_hd__mux2_1
Xfanout108 _3470_/Q vssd1 vssd1 vccd1 vccd1 _1554_/S sky130_fd_sc_hd__clkdlybuf4s25_1
Xfanout119 _2972_/B2 vssd1 vssd1 vccd1 vccd1 _2838_/A sky130_fd_sc_hd__clkdlybuf4s25_1
XFILLER_4_390 vssd1 vssd1 vccd1 vccd1 sky130_fd_sc_hd__fill_4
X_3204_ _3204_/CLK _3204_/D fanout206/X vssd1 vssd1 vccd1 vccd1 _3204_/Q sky130_fd_sc_hd__dfrtp_2
XFILLER_67_331 vssd1 vssd1 vccd1 vccd1 sky130_fd_sc_hd__fill_4
X_3135_ _3199_/CLK _3135_/D fanout260/X vssd1 vssd1 vccd1 vccd1 _3135_/Q sky130_fd_sc_hd__dfrtp_2
X_3066_ clkload9/A _3066_/D vssd1 vssd1 vccd1 vccd1 _3066_/Q sky130_fd_sc_hd__dfxtp_2
X_2017_ _2043_/A _2017_/B vssd1 vssd1 vccd1 vccd1 _2019_/B sky130_fd_sc_hd__xnor2_2
XANTENNA_fanout160_A _2029_/B vssd1 vssd1 vccd1 vccd1 sky130_fd_sc_hd__diode_2
XFILLER_23_401 vssd1 vssd1 vccd1 vccd1 sky130_fd_sc_hd__fill_1
XFILLER_50_220 vssd1 vssd1 vccd1 vccd1 sky130_fd_sc_hd__fill_4
XTAP_TAPCELL_ROW_33_451 vssd1 vccd1 sky130_fd_sc_hd__tapvpwrvgnd_1
XFILLER_23_489 vssd1 vssd1 vccd1 vccd1 sky130_fd_sc_hd__fill_4
X_2919_ hold562/X _2864_/S _2917_/X _2918_/X vssd1 vssd1 vccd1 vccd1 _3393_/D sky130_fd_sc_hd__o22a_2
XFILLER_10_139 vssd1 vssd1 vccd1 vccd1 sky130_fd_sc_hd__fill_1
XANTENNA__2702__S _2704_/S vssd1 vssd1 vccd1 vccd1 sky130_fd_sc_hd__diode_2
XTAP_TAPCELL_ROW_76_819 vssd1 vccd1 sky130_fd_sc_hd__tapvpwrvgnd_1
XFILLER_37_65 vssd1 vssd1 vccd1 vccd1 sky130_fd_sc_hd__fill_8
XFILLER_41_220 vssd1 vssd1 vccd1 vccd1 sky130_fd_sc_hd__fill_2
XFILLER_5_187 vssd1 vssd1 vccd1 vccd1 sky130_fd_sc_hd__fill_1
XFILLER_5_165 vssd1 vssd1 vccd1 vccd1 sky130_fd_sc_hd__fill_2
X_2704_ hold450/X _2818_/A1 _2704_/S vssd1 vssd1 vccd1 vccd1 _3216_/D sky130_fd_sc_hd__mux2_1
XFILLER_9_493 vssd1 vssd1 vccd1 vccd1 sky130_fd_sc_hd__fill_1
X_2635_ hold667/X _2850_/A1 _2645_/S vssd1 vssd1 vccd1 vccd1 _3156_/D sky130_fd_sc_hd__mux2_1
X_2566_ _1569_/D _2515_/X _2560_/Y hold560/X vssd1 vssd1 vccd1 vccd1 _3119_/D sky130_fd_sc_hd__a22o_2
X_2497_ _3185_/Q _2960_/A2 wire66/X _3167_/Q _2496_/X vssd1 vssd1 vccd1 vccd1 _2497_/X
+ sky130_fd_sc_hd__a221o_2
X_1517_ _1509_/B _1517_/B input3/X vssd1 vssd1 vccd1 vccd1 _3377_/D sky130_fd_sc_hd__and3b_2
X_3118_ _3423_/CLK _3118_/D fanout218/X vssd1 vssd1 vccd1 vccd1 _3118_/Q sky130_fd_sc_hd__dfrtp_2
XFILLER_55_323 vssd1 vssd1 vccd1 vccd1 sky130_fd_sc_hd__fill_1
XFILLER_55_312 vssd1 vssd1 vccd1 vccd1 sky130_fd_sc_hd__fill_1
X_3049_ _3423_/CLK _3049_/D load_slew216/X vssd1 vssd1 vccd1 vccd1 _3049_/Q sky130_fd_sc_hd__dfrtp_2
XANTENNA__1837__A _1906_/A vssd1 vssd1 vccd1 vccd1 sky130_fd_sc_hd__diode_2
XANTENNA_fanout76_X _2960_/A2 vssd1 vssd1 vccd1 vccd1 sky130_fd_sc_hd__diode_2
XFILLER_0_38 vssd1 vssd1 vccd1 vccd1 sky130_fd_sc_hd__fill_4
XTAP_TAPCELL_ROW_44_546 vssd1 vccd1 sky130_fd_sc_hd__tapvpwrvgnd_1
XFILLER_64_85 vssd1 vssd1 vccd1 vccd1 sky130_fd_sc_hd__fill_4
XFILLER_9_69 vssd1 vccd1 vssd1 vccd1 sky130_ef_sc_hd__decap_40_12
XFILLER_9_47 vssd1 vssd1 vccd1 vccd1 sky130_fd_sc_hd__fill_8
Xfanout90 _1574_/X vssd1 vssd1 vccd1 vccd1 _1763_/S sky130_fd_sc_hd__clkdlybuf4s25_1
X_2420_ _2417_/X _2419_/X hold738/X _1993_/S vssd1 vssd1 vccd1 vccd1 _3086_/D sky130_fd_sc_hd__o2bb2a_2
X_2351_ _2352_/B _2399_/B vssd1 vssd1 vccd1 vccd1 _2387_/A sky130_fd_sc_hd__and2_2
X_2282_ _2282_/A _2282_/B vssd1 vssd1 vccd1 vccd1 _2283_/B sky130_fd_sc_hd__xor2_2
XFILLER_29_3 vssd1 vssd1 vccd1 vccd1 sky130_fd_sc_hd__fill_8
XFILLER_64_164 vssd1 vssd1 vccd1 vccd1 sky130_fd_sc_hd__fill_1
XANTENNA__3453__RESET_B fanout289/X vssd1 vssd1 vccd1 vccd1 sky130_fd_sc_hd__diode_2
X_1997_ _2025_/A _2005_/C _1961_/X _1962_/B _2073_/B vssd1 vssd1 vccd1 vccd1 _1998_/C
+ sky130_fd_sc_hd__a32o_2
X_2618_ _3402_/Q _2610_/A _2646_/B _3125_/Q vssd1 vssd1 vccd1 vccd1 _2618_/X sky130_fd_sc_hd__a22o_2
X_2549_ _2550_/A1 _2528_/X _2550_/B1 hold716/X vssd1 vssd1 vccd1 vccd1 _3104_/D sky130_fd_sc_hd__a22o_2
XFILLER_18_67 vssd1 vssd1 vccd1 vccd1 sky130_fd_sc_hd__fill_1
XFILLER_18_89 vssd1 vssd1 vccd1 vccd1 sky130_fd_sc_hd__fill_1
XFILLER_18_78 vssd1 vssd1 vccd1 vccd1 sky130_fd_sc_hd__fill_4
XFILLER_70_134 vssd1 vssd1 vccd1 vccd1 sky130_fd_sc_hd__fill_4
XANTENNA__2451__A1 _2611_/A vssd1 vssd1 vccd1 vccd1 sky130_fd_sc_hd__diode_2
XANTENNA__2451__B2 _2800_/A vssd1 vssd1 vccd1 vccd1 sky130_fd_sc_hd__diode_2
XFILLER_11_223 vssd1 vssd1 vccd1 vccd1 sky130_fd_sc_hd__fill_1
XFILLER_11_267 vssd1 vssd1 vccd1 vccd1 sky130_fd_sc_hd__fill_2
XANTENNA__2398__A _2399_/A vssd1 vssd1 vccd1 vccd1 sky130_fd_sc_hd__diode_2
XFILLER_59_63 vssd1 vccd1 vssd1 vccd1 sky130_ef_sc_hd__decap_40_12
Xfanout280 fanout284/X vssd1 vssd1 vccd1 vccd1 fanout280/X sky130_fd_sc_hd__clkdlybuf4s25_1
Xfanout291 _1575_/X vssd1 vssd1 vccd1 vccd1 fanout291/X sky130_fd_sc_hd__clkdlybuf4s25_1
XFILLER_19_323 vssd1 vssd1 vccd1 vccd1 sky130_fd_sc_hd__fill_1
XTAP_TAPCELL_ROW_57_660 vssd1 vccd1 sky130_fd_sc_hd__tapvpwrvgnd_1
XFILLER_74_473 vssd1 vssd1 vccd1 vccd1 sky130_fd_sc_hd__fill_2
XFILLER_46_197 vssd1 vssd1 vccd1 vccd1 sky130_fd_sc_hd__fill_4
XANTENNA__2442__A1 _2611_/A vssd1 vssd1 vccd1 vccd1 sky130_fd_sc_hd__diode_2
XANTENNA__2442__B2 _2800_/A vssd1 vssd1 vccd1 vccd1 sky130_fd_sc_hd__diode_2
X_1920_ _1920_/A _1920_/B _1920_/C vssd1 vssd1 vccd1 vccd1 _1920_/X sky130_fd_sc_hd__or3_2
X_1851_ _1884_/A _2002_/B vssd1 vssd1 vccd1 vccd1 _1978_/A sky130_fd_sc_hd__nand2_2
X_1782_ _1813_/A _1805_/B _1862_/C _3038_/Q vssd1 vssd1 vccd1 vccd1 _1782_/Y sky130_fd_sc_hd__a22oi_2
XTAP_TAPCELL_ROW_12_273 vssd1 vccd1 sky130_fd_sc_hd__tapvpwrvgnd_1
XANTENNA_clkbuf_leaf_3_clk_A clkload0/A vssd1 vssd1 vccd1 vccd1 sky130_fd_sc_hd__diode_2
Xhold728 _3021_/Q vssd1 vssd1 vccd1 vccd1 hold728/X sky130_fd_sc_hd__dlygate4sd3_1
Xhold717 _3115_/Q vssd1 vssd1 vccd1 vccd1 hold717/X sky130_fd_sc_hd__dlygate4sd3_1
Xhold706 _3099_/Q vssd1 vssd1 vccd1 vccd1 hold706/X sky130_fd_sc_hd__dlygate4sd3_1
XFILLER_6_271 vssd1 vssd1 vccd1 vccd1 sky130_fd_sc_hd__fill_1
X_3452_ _3453_/CLK _3452_/D load_slew286/X vssd1 vssd1 vccd1 vccd1 _3452_/Q sky130_fd_sc_hd__dfrtp_2
Xhold739 _3433_/Q vssd1 vssd1 vccd1 vccd1 hold739/X sky130_fd_sc_hd__dlygate4sd3_1
XANTENNA__1924__B _1979_/B vssd1 vssd1 vccd1 vccd1 sky130_fd_sc_hd__diode_2
X_3383_ _3383_/CLK _3383_/D fanout263/X vssd1 vssd1 vccd1 vccd1 _3383_/Q sky130_fd_sc_hd__dfrtp_2
X_2403_ _2402_/B _2403_/B vssd1 vssd1 vccd1 vccd1 _2404_/B sky130_fd_sc_hd__nand2b_2
X_2334_ _2334_/A _2334_/B vssd1 vssd1 vccd1 vccd1 _2339_/A sky130_fd_sc_hd__xnor2_2
XFILLER_69_223 vssd1 vssd1 vccd1 vccd1 sky130_fd_sc_hd__fill_1
XTAP_TAPCELL_ROW_4_208 vssd1 vccd1 sky130_fd_sc_hd__tapvpwrvgnd_1
XFILLER_69_278 vssd1 vssd1 vccd1 vccd1 sky130_fd_sc_hd__fill_2
XFILLER_69_256 vssd1 vssd1 vccd1 vccd1 sky130_fd_sc_hd__fill_1
X_2265_ _2264_/A _2326_/B _2284_/B _2264_/B vssd1 vssd1 vccd1 vccd1 _2291_/B sky130_fd_sc_hd__a22o_2
X_2196_ _2195_/B _2195_/C _2195_/A vssd1 vssd1 vccd1 vccd1 _2197_/B sky130_fd_sc_hd__a21oi_2
XFILLER_65_440 vssd1 vssd1 vccd1 vccd1 sky130_fd_sc_hd__fill_4
XFILLER_37_120 vssd1 vssd1 vccd1 vccd1 sky130_fd_sc_hd__fill_2
XFILLER_65_462 vssd1 vssd1 vccd1 vccd1 sky130_fd_sc_hd__fill_1
XANTENNA_fanout126_X _2959_/C vssd1 vssd1 vccd1 vccd1 sky130_fd_sc_hd__diode_2
XANTENNA__2710__S _2723_/S vssd1 vssd1 vccd1 vccd1 sky130_fd_sc_hd__diode_2
XFILLER_29_11 vssd1 vssd1 vccd1 vccd1 sky130_fd_sc_hd__fill_2
XFILLER_0_469 vssd1 vssd1 vccd1 vccd1 sky130_fd_sc_hd__fill_4
XFILLER_75_259 vssd1 vssd1 vccd1 vccd1 sky130_fd_sc_hd__fill_2
XTAP_TAPCELL_ROW_54_630 vssd1 vccd1 sky130_fd_sc_hd__tapvpwrvgnd_1
XFILLER_71_421 vssd1 vssd1 vccd1 vccd1 sky130_fd_sc_hd__fill_2
XFILLER_28_197 vssd1 vssd1 vccd1 vccd1 sky130_fd_sc_hd__fill_1
XFILLER_43_156 vssd1 vssd1 vccd1 vccd1 sky130_fd_sc_hd__fill_1
XANTENNA__2424__A1 _2533_/A vssd1 vssd1 vccd1 vccd1 sky130_fd_sc_hd__diode_2
XANTENNA__1584__X _1584_/X vssd1 vssd1 vccd1 vccd1 sky130_fd_sc_hd__diode_2
X_2050_ _2073_/B _2073_/C vssd1 vssd1 vccd1 vccd1 _2050_/Y sky130_fd_sc_hd__nand2_2
X_2952_ hold453/X _2864_/S _2946_/X _2951_/X vssd1 vssd1 vccd1 vccd1 _3396_/D sky130_fd_sc_hd__o22a_2
X_1903_ _1903_/A _1903_/B _1903_/C vssd1 vssd1 vccd1 vccd1 _1904_/B sky130_fd_sc_hd__nand3_2
X_2883_ _3334_/Q _2894_/A2 _2894_/B1 _3316_/Q _2882_/X vssd1 vssd1 vccd1 vccd1 _2883_/X
+ sky130_fd_sc_hd__a221o_2
XFILLER_30_373 vssd1 vssd1 vccd1 vccd1 sky130_fd_sc_hd__fill_1
X_1834_ _1834_/A _1834_/B vssd1 vssd1 vccd1 vccd1 _1834_/Y sky130_fd_sc_hd__nor2_2
X_1765_ _1979_/B hold522/X _3435_/D vssd1 vssd1 vccd1 vccd1 _3045_/D sky130_fd_sc_hd__mux2_1
Xhold536 _3171_/Q vssd1 vssd1 vccd1 vccd1 hold536/X sky130_fd_sc_hd__dlygate4sd3_1
Xhold525 _3177_/Q vssd1 vssd1 vccd1 vccd1 hold525/X sky130_fd_sc_hd__dlygate4sd3_1
Xhold514 _3289_/Q vssd1 vssd1 vccd1 vccd1 hold514/X sky130_fd_sc_hd__dlygate4sd3_1
Xhold503 _3202_/Q vssd1 vssd1 vccd1 vccd1 hold503/X sky130_fd_sc_hd__dlygate4sd3_1
X_3435_ clkload6/A _3435_/D _1775_/B vssd1 vssd1 vccd1 vccd1 _3435_/Q sky130_fd_sc_hd__dfrtp_2
Xhold569 _3170_/Q vssd1 vssd1 vccd1 vccd1 hold569/X sky130_fd_sc_hd__dlygate4sd3_1
Xhold558 _3009_/Q vssd1 vssd1 vccd1 vccd1 hold558/X sky130_fd_sc_hd__dlygate4sd3_1
Xhold547 _3238_/Q vssd1 vssd1 vccd1 vccd1 hold547/X sky130_fd_sc_hd__dlygate4sd3_1
X_1696_ hold571/X _1695_/X _1738_/S vssd1 vssd1 vccd1 vccd1 _3013_/D sky130_fd_sc_hd__mux2_1
X_3366_ _2989_/Y _3366_/D fanout285/X vssd1 vssd1 vccd1 vccd1 _3366_/Q sky130_fd_sc_hd__dfrtp_2
X_3297_ _3297_/CLK _3297_/D fanout274/X vssd1 vssd1 vccd1 vccd1 _3297_/Q sky130_fd_sc_hd__dfrtp_2
X_2317_ _2347_/A _2352_/B _2278_/X _2279_/B _2384_/A vssd1 vssd1 vccd1 vccd1 _2318_/C
+ sky130_fd_sc_hd__a32o_2
X_2248_ _2206_/X _2248_/B _2248_/C vssd1 vssd1 vccd1 vccd1 _2252_/B sky130_fd_sc_hd__nand3b_2
XFILLER_72_218 vssd1 vssd1 vccd1 vccd1 sky130_fd_sc_hd__fill_4
X_2179_ _2179_/A _2179_/B _2179_/C vssd1 vssd1 vccd1 vccd1 _2193_/B sky130_fd_sc_hd__and3_2
XFILLER_40_104 vssd1 vssd1 vccd1 vccd1 sky130_fd_sc_hd__fill_1
XFILLER_40_148 vssd1 vssd1 vccd1 vccd1 sky130_fd_sc_hd__fill_2
XTAP_TAPCELL_ROW_23_368 vssd1 vccd1 sky130_fd_sc_hd__tapvpwrvgnd_1
XANTENNA__1564__B _2533_/B vssd1 vssd1 vccd1 vccd1 sky130_fd_sc_hd__diode_2
XFILLER_0_255 vssd1 vssd1 vccd1 vccd1 sky130_fd_sc_hd__fill_2
Xteam_02_330 vssd1 vssd1 vccd1 vccd1 team_02_330/HI gpio_out[33] sky130_fd_sc_hd__conb_1
Xteam_02_341 vssd1 vssd1 vccd1 vccd1 gpio_oeb[11] team_02_341/LO sky130_fd_sc_hd__conb_1
Xteam_02_352 vssd1 vssd1 vccd1 vccd1 gpio_oeb[22] team_02_352/LO sky130_fd_sc_hd__conb_1
XFILLER_48_248 vssd1 vssd1 vccd1 vccd1 sky130_fd_sc_hd__fill_2
Xteam_02_363 vssd1 vssd1 vccd1 vccd1 gpio_oeb[33] team_02_363/LO sky130_fd_sc_hd__conb_1
XFILLER_29_451 vssd1 vssd1 vccd1 vccd1 sky130_fd_sc_hd__fill_1
XFILLER_44_421 vssd1 vssd1 vccd1 vccd1 sky130_fd_sc_hd__fill_4
XANTENNA__2615__S _2647_/S vssd1 vssd1 vccd1 vccd1 sky130_fd_sc_hd__diode_2
XFILLER_31_115 vssd1 vssd1 vccd1 vccd1 sky130_fd_sc_hd__fill_1
XANTENNA__2948__A2 _2971_/A2 vssd1 vssd1 vccd1 vccd1 sky130_fd_sc_hd__diode_2
XFILLER_72_85 vssd1 vssd1 vccd1 vccd1 sky130_fd_sc_hd__fill_4
XFILLER_31_126 vssd1 vssd1 vccd1 vccd1 sky130_fd_sc_hd__fill_8
XFILLER_12_362 vssd1 vssd1 vccd1 vccd1 sky130_fd_sc_hd__fill_2
XFILLER_8_344 vssd1 vssd1 vccd1 vccd1 sky130_fd_sc_hd__fill_1
XFILLER_8_322 vssd1 vssd1 vccd1 vccd1 sky130_fd_sc_hd__fill_1
XFILLER_68_7 vssd1 vssd1 vccd1 vccd1 sky130_fd_sc_hd__fill_1
XANTENNA__1908__B1 _1970_/B vssd1 vssd1 vccd1 vccd1 sky130_fd_sc_hd__diode_2
X_1550_ _3394_/Q _3466_/Q _1554_/S vssd1 vssd1 vccd1 vccd1 _3467_/D sky130_fd_sc_hd__mux2_1
X_3220_ _3388_/CLK _3220_/D fanout238/X vssd1 vssd1 vccd1 vccd1 _3220_/Q sky130_fd_sc_hd__dfrtp_2
XANTENNA_max_cap88_X _2550_/A1 vssd1 vssd1 vccd1 vccd1 sky130_fd_sc_hd__diode_2
X_3151_ _3331_/CLK _3151_/D load_slew232/X vssd1 vssd1 vccd1 vccd1 _3151_/Q sky130_fd_sc_hd__dfrtp_2
XANTENNA__2884__A1 _2942_/B2 vssd1 vssd1 vccd1 vccd1 sky130_fd_sc_hd__diode_2
X_2102_ _2263_/A _2124_/B _2154_/B _2146_/B vssd1 vssd1 vccd1 vccd1 _2102_/Y sky130_fd_sc_hd__a22oi_2
X_3082_ _3101_/CLK _3082_/D vssd1 vssd1 vccd1 vccd1 _3082_/Q sky130_fd_sc_hd__dfxtp_2
XFILLER_54_207 vssd1 vssd1 vccd1 vccd1 sky130_fd_sc_hd__fill_4
X_2033_ _2034_/A _2034_/B vssd1 vssd1 vccd1 vccd1 _2033_/X sky130_fd_sc_hd__and2_2
XTAP_TAPCELL_ROW_65_725 vssd1 vccd1 sky130_fd_sc_hd__tapvpwrvgnd_1
XANTENNA__2939__A2 _2971_/A2 vssd1 vssd1 vccd1 vccd1 sky130_fd_sc_hd__diode_2
XTAP_TAPCELL_ROW_73_791 vssd1 vccd1 sky130_fd_sc_hd__tapvpwrvgnd_1
X_2935_ _2973_/A1 _2932_/X _2934_/X _2966_/A1 vssd1 vssd1 vccd1 vccd1 _2935_/X sky130_fd_sc_hd__a22o_2
X_2866_ _3225_/Q _2923_/A2 _2865_/X _2923_/B2 vssd1 vssd1 vccd1 vccd1 _2866_/X sky130_fd_sc_hd__a22o_2
XTAP_TAPCELL_ROW_20_338 vssd1 vccd1 sky130_fd_sc_hd__tapvpwrvgnd_1
X_1817_ _1817_/A _1818_/B vssd1 vssd1 vccd1 vccd1 _1827_/B sky130_fd_sc_hd__nor2_2
X_2797_ hold629/X _2816_/A1 _2798_/S vssd1 vssd1 vccd1 vccd1 _3304_/D sky130_fd_sc_hd__mux2_1
XANTENNA_fanout203_A fanout214/X vssd1 vssd1 vccd1 vccd1 sky130_fd_sc_hd__diode_2
X_1748_ _2073_/C hold675/X _3435_/D vssd1 vssd1 vccd1 vccd1 _3028_/D sky130_fd_sc_hd__mux2_1
Xhold366 _3453_/Q vssd1 vssd1 vccd1 vccd1 _3443_/D sky130_fd_sc_hd__dlygate4sd3_1
Xhold377 _2979_/X vssd1 vssd1 vccd1 vccd1 _3403_/D sky130_fd_sc_hd__dlygate4sd3_1
X_1679_ _3078_/Q _3061_/Q vssd1 vssd1 vccd1 vccd1 _1680_/B sky130_fd_sc_hd__nand2_2
X_3418_ _3436_/CLK _3418_/D load_slew227/X vssd1 vssd1 vccd1 vccd1 _3418_/Q sky130_fd_sc_hd__dfrtp_2
Xhold388 _2977_/X vssd1 vssd1 vccd1 vccd1 _3401_/D sky130_fd_sc_hd__dlygate4sd3_1
Xhold399 _3288_/Q vssd1 vssd1 vccd1 vccd1 hold399/X sky130_fd_sc_hd__dlygate4sd3_1
X_3349_ _3349_/CLK _3349_/D load_slew205/X vssd1 vssd1 vccd1 vccd1 _3349_/Q sky130_fd_sc_hd__dfrtp_2
XANTENNA_fanout193_X _1998_/B vssd1 vssd1 vccd1 vccd1 sky130_fd_sc_hd__diode_2
XFILLER_26_454 vssd1 vssd1 vccd1 vccd1 sky130_fd_sc_hd__fill_1
XFILLER_41_402 vssd1 vssd1 vccd1 vccd1 sky130_fd_sc_hd__fill_4
XTAP_TAPCELL_ROW_36_482 vssd1 vccd1 sky130_fd_sc_hd__tapvpwrvgnd_1
XFILLER_42_44 vssd1 vssd1 vccd1 vccd1 sky130_fd_sc_hd__fill_1
XFILLER_3_27 vssd1 vccd1 vssd1 vccd1 sky130_ef_sc_hd__decap_40_12
XANTENNA__2866__B2 _2923_/B2 vssd1 vssd1 vccd1 vccd1 sky130_fd_sc_hd__diode_2
XANTENNA__2618__A1 _3402_/Q vssd1 vssd1 vccd1 vccd1 sky130_fd_sc_hd__diode_2
X_2720_ hold574/X _2815_/A1 _2723_/S vssd1 vssd1 vccd1 vccd1 _3231_/D sky130_fd_sc_hd__mux2_1
X_2651_ hold537/X _2803_/A1 _2662_/S vssd1 vssd1 vccd1 vccd1 _3165_/D sky130_fd_sc_hd__mux2_1
XFILLER_8_141 vssd1 vccd1 vssd1 vccd1 sky130_ef_sc_hd__decap_40_12
X_1602_ _1603_/A _1609_/B vssd1 vssd1 vccd1 vccd1 _1602_/X sky130_fd_sc_hd__and2_2
X_2582_ hold656/X _2587_/A2 _2587_/B1 hold685/X vssd1 vssd1 vccd1 vccd1 _3134_/D sky130_fd_sc_hd__a22o_2
XFILLER_59_3 vssd1 vssd1 vccd1 vccd1 sky130_fd_sc_hd__fill_4
X_1533_ _3361_/Q _3362_/Q _1534_/S vssd1 vssd1 vccd1 vccd1 _3362_/D sky130_fd_sc_hd__mux2_1
Xfanout109 _1690_/S vssd1 vssd1 vccd1 vccd1 _1738_/S sky130_fd_sc_hd__clkdlybuf4s25_1
X_3203_ _3349_/CLK _3203_/D load_slew205/X vssd1 vssd1 vccd1 vccd1 _3203_/Q sky130_fd_sc_hd__dfrtp_2
XFILLER_79_181 vssd1 vccd1 vssd1 vccd1 sky130_ef_sc_hd__decap_40_12
X_3134_ clkload7/A _3134_/D load_slew212/X vssd1 vssd1 vccd1 vccd1 _3134_/Q sky130_fd_sc_hd__dfrtp_2
X_3065_ clkload6/A _3065_/D vssd1 vssd1 vccd1 vccd1 _3065_/Q sky130_fd_sc_hd__dfxtp_2
X_2016_ _2045_/A _2043_/B vssd1 vssd1 vccd1 vccd1 _2017_/B sky130_fd_sc_hd__or2_2
XFILLER_50_210 vssd1 vssd1 vccd1 vccd1 sky130_fd_sc_hd__fill_2
XTAP_TAPCELL_ROW_33_452 vssd1 vccd1 sky130_fd_sc_hd__tapvpwrvgnd_1
XFILLER_10_107 vssd1 vssd1 vccd1 vccd1 sky130_fd_sc_hd__fill_1
X_2918_ _2973_/A1 _2914_/X _2910_/X _1585_/A vssd1 vssd1 vccd1 vccd1 _2918_/X sky130_fd_sc_hd__a211o_2
Xclkbuf_leaf_30_clk clkload3/A vssd1 vssd1 vccd1 vccd1 _3397_/CLK sky130_fd_sc_hd__clkbuf_8
X_2849_ hold436/X _2632_/X _2852_/S vssd1 vssd1 vccd1 vccd1 _3353_/D sky130_fd_sc_hd__mux2_1
XANTENNA__2938__B _2970_/B vssd1 vssd1 vccd1 vccd1 sky130_fd_sc_hd__diode_2
XFILLER_73_335 vssd1 vssd1 vccd1 vccd1 sky130_fd_sc_hd__fill_1
XANTENNA_fanout21_X _2761_/S vssd1 vssd1 vccd1 vccd1 sky130_fd_sc_hd__diode_2
XFILLER_53_65 vssd1 vssd1 vccd1 vccd1 sky130_fd_sc_hd__fill_1
Xclkbuf_leaf_21_clk clkload5/A vssd1 vssd1 vccd1 vccd1 _3302_/CLK sky130_fd_sc_hd__clkbuf_8
XFILLER_5_100 vssd1 vssd1 vccd1 vccd1 sky130_fd_sc_hd__fill_1
XFILLER_5_133 vssd1 vccd1 vssd1 vccd1 sky130_ef_sc_hd__decap_40_12
XANTENNA__2536__B1 _2894_/B1 vssd1 vssd1 vccd1 vccd1 sky130_fd_sc_hd__diode_2
XFILLER_5_199 vssd1 vssd1 vccd1 vccd1 sky130_fd_sc_hd__fill_1
XFILLER_1_361 vssd1 vssd1 vccd1 vccd1 sky130_fd_sc_hd__fill_1
XFILLER_64_313 vssd1 vssd1 vccd1 vccd1 sky130_fd_sc_hd__fill_2
XFILLER_17_273 vssd1 vssd1 vccd1 vccd1 sky130_fd_sc_hd__fill_4
XANTENNA__2803__S _2814_/S vssd1 vssd1 vccd1 vccd1 sky130_fd_sc_hd__diode_2
Xclkbuf_leaf_12_clk clkload2/A vssd1 vssd1 vccd1 vccd1 _3437_/CLK sky130_fd_sc_hd__clkbuf_8
X_2703_ hold422/X _2817_/A1 _2704_/S vssd1 vssd1 vccd1 vccd1 _3215_/D sky130_fd_sc_hd__mux2_1
X_2634_ _3133_/Q _2644_/B vssd1 vssd1 vccd1 vccd1 _2634_/X sky130_fd_sc_hd__and2_2
X_2565_ _1569_/D _2502_/X _2560_/Y hold488/X vssd1 vssd1 vccd1 vccd1 _3118_/D sky130_fd_sc_hd__a22o_2
X_1516_ _3377_/Q _3380_/Q vssd1 vssd1 vccd1 vccd1 _1517_/B sky130_fd_sc_hd__nand2b_2
X_2496_ _2959_/B _2957_/C _3203_/Q vssd1 vssd1 vccd1 vccd1 _2496_/X sky130_fd_sc_hd__and3_2
XANTENNA_clkbuf_3_3__f_clk_X clkload2/A vssd1 vssd1 vccd1 vccd1 sky130_fd_sc_hd__diode_2
X_3117_ _3119_/CLK _3117_/D fanout217/X vssd1 vssd1 vccd1 vccd1 _3117_/Q sky130_fd_sc_hd__dfrtp_2
XANTENNA__3463__CLK _3463_/CLK vssd1 vssd1 vccd1 vccd1 sky130_fd_sc_hd__diode_2
X_3048_ _3436_/CLK _3048_/D fanout228/X vssd1 vssd1 vccd1 vccd1 _3048_/Q sky130_fd_sc_hd__dfrtp_2
XANTENNA__2713__S _2719_/S vssd1 vssd1 vccd1 vccd1 sky130_fd_sc_hd__diode_2
XFILLER_23_57 vssd1 vccd1 vssd1 vccd1 sky130_ef_sc_hd__decap_40_12
XFILLER_11_449 vssd1 vccd1 vssd1 vccd1 sky130_ef_sc_hd__decap_40_12
XANTENNA__1837__B _1947_/A vssd1 vssd1 vccd1 vccd1 sky130_fd_sc_hd__diode_2
XANTENNA__2518__B1 wire66/X vssd1 vssd1 vccd1 vccd1 sky130_fd_sc_hd__diode_2
XANTENNA__3329__RESET_B fanout242/X vssd1 vssd1 vccd1 vccd1 sky130_fd_sc_hd__diode_2
XFILLER_78_416 vssd1 vssd1 vccd1 vccd1 sky130_fd_sc_hd__fill_4
XFILLER_73_110 vssd1 vssd1 vccd1 vccd1 sky130_fd_sc_hd__fill_2
Xmax_cap9 wire8/A vssd1 vssd1 vccd1 vccd1 _2435_/S sky130_fd_sc_hd__clkdlybuf4s25_1
XTAP_TAPCELL_ROW_44_547 vssd1 vccd1 sky130_fd_sc_hd__tapvpwrvgnd_1
XTAP_TAPCELL_ROW_1_180 vssd1 vccd1 sky130_fd_sc_hd__tapvpwrvgnd_1
XANTENNA__2623__S _2645_/S vssd1 vssd1 vccd1 vccd1 sky130_fd_sc_hd__diode_2
Xfanout80 _2438_/X vssd1 vssd1 vccd1 vccd1 _2901_/A2 sky130_fd_sc_hd__clkdlybuf4s25_1
Xfanout91 _1771_/S vssd1 vssd1 vccd1 vccd1 _1773_/S sky130_fd_sc_hd__clkdlybuf4s25_1
XFILLER_10_471 vssd1 vssd1 vccd1 vccd1 sky130_fd_sc_hd__fill_4
XFILLER_10_493 vssd1 vssd1 vccd1 vccd1 sky130_fd_sc_hd__fill_1
X_2350_ _2384_/B _2352_/B _2352_/C _2399_/B vssd1 vssd1 vccd1 vccd1 _2353_/A sky130_fd_sc_hd__a22oi_2
X_2281_ _2347_/A _2352_/B vssd1 vssd1 vccd1 vccd1 _2282_/B sky130_fd_sc_hd__nand2_2
Xclkbuf_leaf_1_clk clkbuf_leaf_2_clk/A vssd1 vssd1 vccd1 vccd1 _3112_/CLK sky130_fd_sc_hd__clkbuf_8
XFILLER_1_180 vssd1 vssd1 vccd1 vccd1 sky130_fd_sc_hd__fill_2
XFILLER_49_162 vssd1 vssd1 vccd1 vccd1 sky130_fd_sc_hd__fill_4
XFILLER_64_154 vssd1 vssd1 vccd1 vccd1 sky130_fd_sc_hd__fill_8
XANTENNA__1938__A _2025_/A vssd1 vssd1 vccd1 vccd1 sky130_fd_sc_hd__diode_2
XFILLER_20_202 vssd1 vssd1 vccd1 vccd1 sky130_fd_sc_hd__fill_1
X_1996_ _1996_/A vssd1 vssd1 vccd1 vccd1 _1999_/A sky130_fd_sc_hd__inv_2
XANTENNA_fanout116_A _2942_/B2 vssd1 vssd1 vccd1 vccd1 sky130_fd_sc_hd__diode_2
X_2617_ hold515/X _2803_/A1 _2647_/S vssd1 vssd1 vccd1 vccd1 _3147_/D sky130_fd_sc_hd__mux2_1
X_2548_ _2550_/A1 _2515_/X _2550_/B1 hold517/X vssd1 vssd1 vccd1 vccd1 _3103_/D sky130_fd_sc_hd__a22o_2
XTAP_TAPCELL_ROW_7_228 vssd1 vccd1 sky130_fd_sc_hd__tapvpwrvgnd_1
X_2479_ _2900_/A _2959_/C _3346_/Q vssd1 vssd1 vccd1 vccd1 _2479_/X sky130_fd_sc_hd__and3_2
XANTENNA__2708__S _2719_/S vssd1 vssd1 vccd1 vccd1 sky130_fd_sc_hd__diode_2
XFILLER_70_124 vssd1 vssd1 vccd1 vccd1 sky130_fd_sc_hd__fill_2
XFILLER_70_168 vssd1 vssd1 vccd1 vccd1 sky130_fd_sc_hd__fill_1
XTAP_TAPCELL_ROW_41_517 vssd1 vccd1 sky130_fd_sc_hd__tapvpwrvgnd_1
Xclkload0 clkload0/A vssd1 vssd1 vccd1 vccd1 clkload0/X sky130_fd_sc_hd__clkbuf_8
XFILLER_50_33 vssd1 vssd1 vccd1 vccd1 sky130_fd_sc_hd__fill_2
XFILLER_50_11 vssd1 vssd1 vccd1 vccd1 sky130_fd_sc_hd__fill_2
XANTENNA__2398__B _2399_/B vssd1 vssd1 vccd1 vccd1 sky130_fd_sc_hd__diode_2
XFILLER_59_75 vssd1 vssd1 vccd1 vccd1 sky130_fd_sc_hd__fill_8
Xfanout270 fanout271/X vssd1 vssd1 vccd1 vccd1 fanout270/X sky130_fd_sc_hd__clkdlybuf4s25_1
Xfanout292 input2/X vssd1 vssd1 vccd1 vccd1 _3463_/CLK sky130_fd_sc_hd__clkdlybuf4s25_1
XFILLER_59_493 vssd1 vssd1 vccd1 vccd1 sky130_fd_sc_hd__fill_1
XFILLER_19_335 vssd1 vssd1 vccd1 vccd1 sky130_fd_sc_hd__fill_1
XFILLER_74_485 vssd1 vssd1 vccd1 vccd1 sky130_fd_sc_hd__fill_2
Xload_slew78 _2881_/A2 vssd1 vssd1 vccd1 vccd1 _2971_/A2 sky130_fd_sc_hd__clkbuf_4
XANTENNA__2978__A0 _3402_/Q vssd1 vssd1 vccd1 vccd1 sky130_fd_sc_hd__diode_2
X_1850_ _1832_/A _1832_/B _1849_/X vssd1 vssd1 vccd1 vccd1 _1859_/A sky130_fd_sc_hd__o21ai_2
X_1781_ hold735/X _2091_/B _1778_/X _1780_/Y vssd1 vssd1 vccd1 vccd1 _3055_/D sky130_fd_sc_hd__a22o_2
XTAP_TAPCELL_ROW_12_274 vssd1 vccd1 sky130_fd_sc_hd__tapvpwrvgnd_1
Xhold718 _3058_/Q vssd1 vssd1 vccd1 vccd1 hold718/X sky130_fd_sc_hd__dlygate4sd3_1
Xhold707 _3312_/Q vssd1 vssd1 vccd1 vccd1 hold707/X sky130_fd_sc_hd__dlygate4sd3_1
X_3451_ _3453_/CLK _3451_/D load_slew288/X vssd1 vssd1 vccd1 vccd1 _3451_/Q sky130_fd_sc_hd__dfrtp_2
Xhold729 _2587_/X vssd1 vssd1 vccd1 vccd1 _3139_/D sky130_fd_sc_hd__dlygate4sd3_1
X_3382_ _3437_/CLK _3382_/D load_slew261/X vssd1 vssd1 vccd1 vccd1 _3382_/Q sky130_fd_sc_hd__dfrtp_2
X_2402_ _2403_/B _2402_/B vssd1 vssd1 vccd1 vccd1 _2404_/A sky130_fd_sc_hd__nand2b_2
XFILLER_41_3 vssd1 vssd1 vccd1 vccd1 sky130_fd_sc_hd__fill_8
X_2333_ _2334_/A _2334_/B vssd1 vssd1 vccd1 vccd1 _2363_/A sky130_fd_sc_hd__and2_2
XTAP_TAPCELL_ROW_4_209 vssd1 vccd1 sky130_fd_sc_hd__tapvpwrvgnd_1
X_2264_ _2264_/A _2264_/B _2326_/B _2284_/B vssd1 vssd1 vccd1 vccd1 _2292_/A sky130_fd_sc_hd__nand4_2
X_2195_ _2195_/A _2195_/B _2195_/C vssd1 vssd1 vccd1 vccd1 _2195_/Y sky130_fd_sc_hd__nand3_2
XFILLER_25_316 vssd1 vssd1 vccd1 vccd1 sky130_fd_sc_hd__fill_4
XFILLER_1_60 vssd1 vssd1 vccd1 vccd1 sky130_fd_sc_hd__fill_8
XFILLER_52_124 vssd1 vssd1 vccd1 vccd1 sky130_fd_sc_hd__fill_2
X_1979_ _1979_/A _1979_/B _1979_/C vssd1 vssd1 vccd1 vccd1 _1980_/B sky130_fd_sc_hd__and3_2
XANTENNA_fanout119_X _2838_/A vssd1 vssd1 vccd1 vccd1 sky130_fd_sc_hd__diode_2
XFILLER_0_437 vssd1 vssd1 vccd1 vccd1 sky130_fd_sc_hd__fill_1
XFILLER_0_415 vssd1 vssd1 vccd1 vccd1 sky130_fd_sc_hd__fill_4
XFILLER_48_419 vssd1 vssd1 vccd1 vccd1 sky130_fd_sc_hd__fill_1
XFILLER_45_55 vssd1 vssd1 vccd1 vccd1 sky130_fd_sc_hd__fill_1
XFILLER_43_113 vssd1 vssd1 vccd1 vccd1 sky130_fd_sc_hd__fill_4
XTAP_TAPCELL_ROW_54_631 vssd1 vccd1 sky130_fd_sc_hd__tapvpwrvgnd_1
XFILLER_71_444 vssd1 vssd1 vccd1 vccd1 sky130_fd_sc_hd__fill_1
XFILLER_31_319 vssd1 vssd1 vccd1 vccd1 sky130_fd_sc_hd__fill_2
XFILLER_6_38 vssd1 vssd1 vccd1 vccd1 sky130_fd_sc_hd__fill_4
XANTENNA__2896__C1 _1585_/A vssd1 vssd1 vccd1 vccd1 sky130_fd_sc_hd__diode_2
X_2951_ _2972_/B2 _2948_/X _2950_/X _2966_/A1 vssd1 vssd1 vccd1 vccd1 _2951_/X sky130_fd_sc_hd__a22o_2
X_1902_ _1903_/B _1903_/C _1903_/A vssd1 vssd1 vccd1 vccd1 _1902_/Y sky130_fd_sc_hd__a21oi_2
XANTENNA_clkbuf_0_clk_A clk vssd1 vssd1 vccd1 vccd1 sky130_fd_sc_hd__diode_2
X_2882_ _2926_/B _2926_/C _3352_/Q vssd1 vssd1 vccd1 vccd1 _2882_/X sky130_fd_sc_hd__and3_2
XTAP_TAPCELL_ROW_60_678 vssd1 vccd1 sky130_fd_sc_hd__tapvpwrvgnd_1
X_1833_ _1833_/A _1834_/B vssd1 vssd1 vccd1 vccd1 _1833_/Y sky130_fd_sc_hd__xnor2_2
XANTENNA__2811__S _2814_/S vssd1 vssd1 vccd1 vccd1 sky130_fd_sc_hd__diode_2
X_1764_ hold526/X hold466/X _3435_/D vssd1 vssd1 vccd1 vccd1 _3044_/D sky130_fd_sc_hd__mux2_1
Xhold526 _3044_/Q vssd1 vssd1 vccd1 vccd1 hold526/X sky130_fd_sc_hd__dlygate4sd3_1
Xhold515 _3147_/Q vssd1 vssd1 vccd1 vccd1 hold515/X sky130_fd_sc_hd__dlygate4sd3_1
Xhold504 _3236_/Q vssd1 vssd1 vccd1 vccd1 hold504/X sky130_fd_sc_hd__dlygate4sd3_1
X_3434_ clkload6/A _3434_/D _1775_/B vssd1 vssd1 vccd1 vccd1 _3434_/Q sky130_fd_sc_hd__dfrtp_2
Xhold559 _2575_/X vssd1 vssd1 vccd1 vccd1 _3127_/D sky130_fd_sc_hd__dlygate4sd3_1
Xhold548 _3303_/Q vssd1 vssd1 vccd1 vccd1 hold548/X sky130_fd_sc_hd__dlygate4sd3_1
Xhold537 _3165_/Q vssd1 vssd1 vccd1 vccd1 hold537/X sky130_fd_sc_hd__dlygate4sd3_1
X_1695_ _1695_/A _1695_/B vssd1 vssd1 vccd1 vccd1 _1695_/X sky130_fd_sc_hd__xor2_2
X_3365_ _2988_/Y _3365_/D load_slew283/X vssd1 vssd1 vccd1 vccd1 _3365_/Q sky130_fd_sc_hd__dfrtp_2
X_3296_ _3383_/CLK _3296_/D fanout263/X vssd1 vssd1 vccd1 vccd1 _3296_/Q sky130_fd_sc_hd__dfrtp_2
X_2316_ _2316_/A vssd1 vssd1 vccd1 vccd1 _2319_/A sky130_fd_sc_hd__inv_2
X_2247_ _2225_/B _2231_/Y _2232_/X _2245_/Y _2223_/Y vssd1 vssd1 vccd1 vccd1 _2248_/C
+ sky130_fd_sc_hd__a311o_2
XFILLER_57_227 vssd1 vssd1 vccd1 vccd1 sky130_fd_sc_hd__fill_1
X_2178_ _2179_/B _2179_/C _2179_/A vssd1 vssd1 vccd1 vccd1 _2193_/A sky130_fd_sc_hd__a21oi_2
XFILLER_25_113 vssd1 vssd1 vccd1 vccd1 sky130_fd_sc_hd__fill_4
XFILLER_40_138 vssd1 vssd1 vccd1 vccd1 sky130_fd_sc_hd__fill_2
XTAP_TAPCELL_ROW_23_369 vssd1 vccd1 sky130_fd_sc_hd__tapvpwrvgnd_1
XANTENNA__2721__S _2723_/S vssd1 vssd1 vccd1 vccd1 sky130_fd_sc_hd__diode_2
XFILLER_31_57 vssd1 vccd1 vssd1 vccd1 sky130_ef_sc_hd__decap_40_12
XFILLER_0_223 vssd1 vssd1 vccd1 vccd1 sky130_fd_sc_hd__fill_1
Xteam_02_320 vssd1 vssd1 vccd1 vccd1 team_02_320/HI gpio_out[23] sky130_fd_sc_hd__conb_1
Xteam_02_342 vssd1 vssd1 vccd1 vccd1 gpio_oeb[12] team_02_342/LO sky130_fd_sc_hd__conb_1
Xteam_02_353 vssd1 vssd1 vccd1 vccd1 gpio_oeb[23] team_02_353/LO sky130_fd_sc_hd__conb_1
XFILLER_29_463 vssd1 vssd1 vccd1 vccd1 sky130_fd_sc_hd__fill_1
XANTENNA_clkbuf_leaf_2_clk_A clkbuf_leaf_2_clk/A vssd1 vssd1 vccd1 vccd1 sky130_fd_sc_hd__diode_2
XFILLER_56_87 vssd1 vssd1 vccd1 vccd1 sky130_fd_sc_hd__fill_1
XFILLER_29_485 vssd1 vssd1 vccd1 vccd1 sky130_fd_sc_hd__fill_8
XANTENNA__1853__B1 _2029_/B vssd1 vssd1 vccd1 vccd1 sky130_fd_sc_hd__diode_2
XPHY_EDGE_ROW_19_Right_19 vssd1 vssd1 vccd1 vccd1 sky130_fd_sc_hd__decap_3
XFILLER_72_31 vssd1 vssd1 vccd1 vccd1 sky130_fd_sc_hd__fill_8
XANTENNA__2631__S _2645_/S vssd1 vssd1 vccd1 vccd1 sky130_fd_sc_hd__diode_2
Xclkbuf_3_1__f_clk clkbuf_0_clk/X vssd1 vssd1 vccd1 vccd1 clkload0/A sky130_fd_sc_hd__clkbuf_16
XFILLER_8_367 vssd1 vssd1 vccd1 vccd1 sky130_fd_sc_hd__fill_1
XANTENNA__1908__A1 _1947_/A vssd1 vssd1 vccd1 vccd1 sky130_fd_sc_hd__diode_2
XANTENNA__1908__B2 _2049_/B vssd1 vssd1 vccd1 vccd1 sky130_fd_sc_hd__diode_2
XPHY_EDGE_ROW_28_Right_28 vssd1 vssd1 vccd1 vccd1 sky130_fd_sc_hd__decap_3
XANTENNA__2869__C1 _1585_/A vssd1 vssd1 vccd1 vccd1 sky130_fd_sc_hd__diode_2
X_3150_ _3386_/CLK _3150_/D load_slew232/X vssd1 vssd1 vccd1 vccd1 _3150_/Q sky130_fd_sc_hd__dfrtp_2
XFILLER_79_363 vssd1 vssd1 vccd1 vccd1 sky130_fd_sc_hd__fill_1
X_3081_ _3121_/CLK _3081_/D vssd1 vssd1 vccd1 vccd1 _3081_/Q sky130_fd_sc_hd__dfxtp_2
X_2101_ hold730/X _2421_/B _2098_/X _2100_/Y vssd1 vssd1 vccd1 vccd1 _3072_/D sky130_fd_sc_hd__a22o_2
X_2032_ _2032_/A _2032_/B vssd1 vssd1 vccd1 vccd1 _2034_/B sky130_fd_sc_hd__xnor2_2
XTAP_TAPCELL_ROW_65_726 vssd1 vccd1 sky130_fd_sc_hd__tapvpwrvgnd_1
XPHY_EDGE_ROW_37_Right_37 vssd1 vssd1 vccd1 vccd1 sky130_fd_sc_hd__decap_3
XANTENNA__2806__S _2818_/S vssd1 vssd1 vccd1 vccd1 sky130_fd_sc_hd__diode_2
XTAP_TAPCELL_ROW_73_792 vssd1 vccd1 sky130_fd_sc_hd__tapvpwrvgnd_1
X_2934_ _3195_/Q _2971_/A2 _2971_/B1 _3177_/Q _2933_/X vssd1 vssd1 vccd1 vccd1 _2934_/X
+ sky130_fd_sc_hd__a221o_2
X_2865_ _2686_/A _3153_/Q _3297_/Q _2838_/A vssd1 vssd1 vccd1 vccd1 _2865_/X sky130_fd_sc_hd__a22o_2
XTAP_TAPCELL_ROW_20_339 vssd1 vccd1 sky130_fd_sc_hd__tapvpwrvgnd_1
X_1816_ _1816_/A _1816_/B vssd1 vssd1 vccd1 vccd1 _1818_/B sky130_fd_sc_hd__xnor2_2
XPHY_EDGE_ROW_46_Right_46 vssd1 vssd1 vccd1 vccd1 sky130_fd_sc_hd__decap_3
X_2796_ hold548/X _2815_/A1 _2798_/S vssd1 vssd1 vccd1 vccd1 _3303_/D sky130_fd_sc_hd__mux2_1
X_1747_ _2049_/B hold434/X _3435_/D vssd1 vssd1 vccd1 vccd1 _3027_/D sky130_fd_sc_hd__mux2_1
Xhold367 _3407_/Q vssd1 vssd1 vccd1 vccd1 _3441_/D sky130_fd_sc_hd__dlygate4sd3_1
Xhold378 _3083_/Q vssd1 vssd1 vccd1 vccd1 hold378/X sky130_fd_sc_hd__dlygate4sd3_1
X_1678_ _1680_/A vssd1 vssd1 vccd1 vccd1 _1688_/A sky130_fd_sc_hd__inv_2
X_3417_ _3429_/CLK _3417_/D load_slew225/X vssd1 vssd1 vccd1 vccd1 _3417_/Q sky130_fd_sc_hd__dfrtp_2
Xhold389 _3082_/Q vssd1 vssd1 vccd1 vccd1 hold389/X sky130_fd_sc_hd__dlygate4sd3_1
XANTENNA__2496__B _2957_/C vssd1 vssd1 vccd1 vccd1 sky130_fd_sc_hd__diode_2
X_3348_ clkload7/A _3348_/D fanout213/X vssd1 vssd1 vccd1 vccd1 _3348_/Q sky130_fd_sc_hd__dfrtp_2
XANTENNA__2875__A2 _3437_/D vssd1 vssd1 vccd1 vccd1 sky130_fd_sc_hd__diode_2
Xload_slew281 fanout280/X vssd1 vssd1 vccd1 vccd1 load_slew281/X sky130_fd_sc_hd__clkbuf_4
XANTENNA_fanout186_X _2029_/D vssd1 vssd1 vccd1 vccd1 sky130_fd_sc_hd__diode_2
X_3279_ _3389_/CLK _3279_/D load_slew278/X vssd1 vssd1 vccd1 vccd1 _3279_/Q sky130_fd_sc_hd__dfrtp_2
XPHY_EDGE_ROW_55_Right_55 vssd1 vssd1 vccd1 vccd1 sky130_fd_sc_hd__decap_3
XANTENNA__2088__B1 _1979_/B vssd1 vssd1 vccd1 vccd1 sky130_fd_sc_hd__diode_2
XTAP_TAPCELL_ROW_28_406 vssd1 vccd1 sky130_fd_sc_hd__tapvpwrvgnd_1
XANTENNA__2716__S _2719_/S vssd1 vssd1 vccd1 vccd1 sky130_fd_sc_hd__diode_2
XFILLER_26_46 vssd1 vssd1 vccd1 vccd1 sky130_fd_sc_hd__fill_2
XFILLER_26_35 vssd1 vssd1 vccd1 vccd1 sky130_fd_sc_hd__fill_1
XFILLER_26_68 vssd1 vssd1 vccd1 vccd1 sky130_fd_sc_hd__fill_4
XFILLER_9_109 vssd1 vssd1 vccd1 vccd1 sky130_fd_sc_hd__fill_2
XANTENNA_fanout11_A _2838_/X vssd1 vssd1 vccd1 vccd1 sky130_fd_sc_hd__diode_2
XPHY_EDGE_ROW_64_Right_64 vssd1 vssd1 vccd1 vccd1 sky130_fd_sc_hd__decap_3
XFILLER_42_56 vssd1 vccd1 vssd1 vccd1 sky130_ef_sc_hd__decap_40_12
XFILLER_5_337 vssd1 vssd1 vccd1 vccd1 sky130_fd_sc_hd__fill_4
XANTENNA__2563__A1 _1569_/D vssd1 vssd1 vccd1 vccd1 sky130_fd_sc_hd__diode_2
XANTENNA__2315__A1 _2347_/A vssd1 vssd1 vccd1 vccd1 sky130_fd_sc_hd__diode_2
XFILLER_3_39 vssd1 vssd1 vccd1 vccd1 sky130_fd_sc_hd__fill_2
XANTENNA__2866__A2 _2923_/A2 vssd1 vssd1 vccd1 vccd1 sky130_fd_sc_hd__diode_2
XPHY_EDGE_ROW_73_Right_73 vssd1 vssd1 vccd1 vccd1 sky130_fd_sc_hd__decap_3
XANTENNA__2618__A2 _2610_/A vssd1 vssd1 vccd1 vccd1 sky130_fd_sc_hd__diode_2
XFILLER_44_241 vssd1 vssd1 vccd1 vccd1 sky130_fd_sc_hd__fill_2
X_2650_ hold521/X _2802_/A1 _2662_/S vssd1 vssd1 vccd1 vccd1 _3164_/D sky130_fd_sc_hd__mux2_1
XFILLER_8_153 vssd1 vssd1 vccd1 vccd1 sky130_fd_sc_hd__fill_1
X_1601_ _3409_/Q _1601_/B vssd1 vssd1 vccd1 vccd1 _3420_/D sky130_fd_sc_hd__or2_2
XFILLER_8_197 vssd1 vssd1 vccd1 vccd1 sky130_fd_sc_hd__fill_4
XANTENNA__2554__A1 _2477_/X vssd1 vssd1 vccd1 vccd1 sky130_fd_sc_hd__diode_2
X_2581_ hold686/X _2587_/A2 _2587_/B1 hold695/X vssd1 vssd1 vccd1 vccd1 _3133_/D sky130_fd_sc_hd__a22o_2
X_1532_ _3362_/Q _3363_/Q _1534_/S vssd1 vssd1 vccd1 vccd1 _3363_/D sky130_fd_sc_hd__mux2_1
X_3202_ clkload7/A _3202_/D load_slew212/X vssd1 vssd1 vccd1 vccd1 _3202_/Q sky130_fd_sc_hd__dfrtp_2
XFILLER_79_193 vssd1 vssd1 vccd1 vccd1 sky130_fd_sc_hd__fill_2
X_3133_ clkload7/A _3133_/D load_slew210/X vssd1 vssd1 vccd1 vccd1 _3133_/Q sky130_fd_sc_hd__dfrtp_2
X_3064_ clkload9/A _3064_/D vssd1 vssd1 vccd1 vccd1 _3064_/Q sky130_fd_sc_hd__dfxtp_2
X_2015_ _2015_/A _2015_/B _2015_/C vssd1 vssd1 vccd1 vccd1 _2043_/B sky130_fd_sc_hd__and3_2
XPHY_EDGE_ROW_19_Left_99 vssd1 vssd1 vccd1 vccd1 sky130_fd_sc_hd__decap_3
XFILLER_35_263 vssd1 vssd1 vccd1 vccd1 sky130_fd_sc_hd__fill_1
XANTENNA__2490__B1 _2489_/X vssd1 vssd1 vccd1 vccd1 sky130_fd_sc_hd__diode_2
XTAP_TAPCELL_ROW_33_453 vssd1 vccd1 sky130_fd_sc_hd__tapvpwrvgnd_1
X_2917_ _2942_/B2 _2912_/X _2916_/X _2966_/A1 vssd1 vssd1 vccd1 vccd1 _2917_/X sky130_fd_sc_hd__a22o_2
XFILLER_31_491 vssd1 vssd1 vccd1 vccd1 sky130_fd_sc_hd__fill_2
X_2848_ hold439/X _2848_/A1 _2852_/S vssd1 vssd1 vccd1 vccd1 _3352_/D sky130_fd_sc_hd__mux2_1
XANTENNA__2545__A1 _2550_/A1 vssd1 vssd1 vccd1 vccd1 sky130_fd_sc_hd__diode_2
X_2779_ hold443/X _2817_/A1 _2780_/S vssd1 vssd1 vccd1 vccd1 _3287_/D sky130_fd_sc_hd__mux2_1
XFILLER_5_9 vssd1 vccd1 vssd1 vccd1 sky130_ef_sc_hd__decap_40_12
XANTENNA__2938__C _2970_/C vssd1 vssd1 vccd1 vccd1 sky130_fd_sc_hd__diode_2
XFILLER_77_108 vssd1 vssd1 vccd1 vccd1 sky130_fd_sc_hd__fill_4
XFILLER_53_44 vssd1 vccd1 vssd1 vccd1 sky130_ef_sc_hd__decap_40_12
XANTENNA_fanout14_X _2833_/S vssd1 vssd1 vccd1 vccd1 sky130_fd_sc_hd__diode_2
XFILLER_5_145 vssd1 vccd1 vssd1 vccd1 sky130_ef_sc_hd__decap_40_12
XFILLER_5_167 vssd1 vssd1 vccd1 vccd1 sky130_fd_sc_hd__fill_1
XFILLER_78_74 vssd1 vssd1 vccd1 vccd1 sky130_fd_sc_hd__fill_4
XFILLER_49_322 vssd1 vssd1 vccd1 vccd1 sky130_fd_sc_hd__fill_1
XTAP_TAPCELL_ROW_75_810 vssd1 vccd1 sky130_fd_sc_hd__tapvpwrvgnd_1
XFILLER_76_174 vssd1 vssd1 vccd1 vccd1 sky130_fd_sc_hd__fill_1
XFILLER_49_388 vssd1 vssd1 vccd1 vccd1 sky130_fd_sc_hd__fill_1
XANTENNA__2880__A _2970_/B vssd1 vssd1 vccd1 vccd1 sky130_fd_sc_hd__diode_2
X_2702_ hold398/X _2816_/A1 _2704_/S vssd1 vssd1 vccd1 vccd1 _3214_/D sky130_fd_sc_hd__mux2_1
XTAP_TAPCELL_ROW_30_423 vssd1 vccd1 sky130_fd_sc_hd__tapvpwrvgnd_1
XFILLER_71_3 vssd1 vssd1 vccd1 vccd1 sky130_fd_sc_hd__fill_4
X_2633_ hold671/X _2811_/A1 _2647_/S vssd1 vssd1 vccd1 vccd1 _3155_/D sky130_fd_sc_hd__mux2_1
X_2564_ _1569_/D _2489_/X _2560_/Y hold469/X vssd1 vssd1 vccd1 vccd1 _3117_/D sky130_fd_sc_hd__a22o_2
X_1515_ _1515_/A _1515_/B vssd1 vssd1 vccd1 vccd1 _3378_/D sky130_fd_sc_hd__nor2_2
X_2495_ _3221_/Q _2967_/A2 _2492_/X _2961_/A1 _2494_/X vssd1 vssd1 vccd1 vccd1 _2501_/A
+ sky130_fd_sc_hd__a221o_2
X_3116_ _3436_/CLK _3116_/D fanout228/X vssd1 vssd1 vccd1 vccd1 _3116_/Q sky130_fd_sc_hd__dfrtp_2
X_3047_ _3119_/CLK _3047_/D fanout223/X vssd1 vssd1 vccd1 vccd1 _3047_/Q sky130_fd_sc_hd__dfrtp_2
XANTENNA_fanout149_X _2326_/B vssd1 vssd1 vccd1 vccd1 sky130_fd_sc_hd__diode_2
XFILLER_23_69 vssd1 vccd1 vssd1 vccd1 sky130_ef_sc_hd__decap_40_12
XANTENNA__2949__B _2970_/B vssd1 vssd1 vccd1 vccd1 sky130_fd_sc_hd__diode_2
XFILLER_78_439 vssd1 vssd1 vccd1 vccd1 sky130_fd_sc_hd__fill_1
XFILLER_78_428 vssd1 vssd1 vccd1 vccd1 sky130_fd_sc_hd__fill_2
XFILLER_48_33 vssd1 vssd1 vccd1 vccd1 sky130_fd_sc_hd__fill_1
XFILLER_48_11 vssd1 vssd1 vccd1 vccd1 sky130_fd_sc_hd__fill_1
XFILLER_58_141 vssd1 vssd1 vccd1 vccd1 sky130_fd_sc_hd__fill_1
XFILLER_58_130 vssd1 vssd1 vccd1 vccd1 sky130_fd_sc_hd__fill_4
XFILLER_73_133 vssd1 vssd1 vccd1 vccd1 sky130_fd_sc_hd__fill_4
XANTENNA__2454__B1 _2453_/X vssd1 vssd1 vccd1 vccd1 sky130_fd_sc_hd__diode_2
XTAP_TAPCELL_ROW_1_181 vssd1 vccd1 sky130_fd_sc_hd__tapvpwrvgnd_1
XTAP_TAPCELL_ROW_44_548 vssd1 vccd1 sky130_fd_sc_hd__tapvpwrvgnd_1
XFILLER_9_16 vssd1 vssd1 vccd1 vccd1 sky130_fd_sc_hd__fill_4
Xfanout70 _2440_/Y vssd1 vssd1 vccd1 vccd1 _2901_/B1 sky130_fd_sc_hd__clkdlybuf4s25_1
Xfanout81 _2819_/B vssd1 vssd1 vccd1 vccd1 _2667_/B sky130_fd_sc_hd__clkdlybuf4s25_1
Xfanout92 _1574_/X vssd1 vssd1 vccd1 vccd1 _1771_/S sky130_fd_sc_hd__clkdlybuf4s25_1
XPHY_EDGE_ROW_23_Left_103 vssd1 vssd1 vccd1 vccd1 sky130_fd_sc_hd__decap_3
X_2280_ _2255_/A _2279_/X _2278_/X vssd1 vssd1 vccd1 vccd1 _2282_/A sky130_fd_sc_hd__a21bo_2
XPHY_EDGE_ROW_32_Left_112 vssd1 vssd1 vccd1 vccd1 sky130_fd_sc_hd__decap_3
XFILLER_49_196 vssd1 vssd1 vccd1 vccd1 sky130_fd_sc_hd__fill_1
XFILLER_64_177 vssd1 vssd1 vccd1 vccd1 sky130_fd_sc_hd__fill_4
XFILLER_64_199 vssd1 vssd1 vccd1 vccd1 sky130_fd_sc_hd__fill_2
XANTENNA__2814__S _2814_/S vssd1 vssd1 vccd1 vccd1 sky130_fd_sc_hd__diode_2
XANTENNA__1938__B _2029_/C vssd1 vssd1 vccd1 vccd1 sky130_fd_sc_hd__diode_2
X_1995_ _2025_/A _2005_/C _1961_/X _1998_/B _2073_/A vssd1 vssd1 vccd1 vccd1 _1996_/A
+ sky130_fd_sc_hd__a32o_2
XPHY_EDGE_ROW_41_Left_121 vssd1 vssd1 vccd1 vccd1 sky130_fd_sc_hd__decap_3
X_2616_ _3401_/Q _1626_/X _2646_/B _3124_/Q vssd1 vssd1 vccd1 vccd1 _2616_/X sky130_fd_sc_hd__a22o_2
XANTENNA_fanout109_A _1690_/S vssd1 vssd1 vccd1 vccd1 sky130_fd_sc_hd__diode_2
X_2547_ _2550_/A1 _2502_/X _2550_/B1 hold570/X vssd1 vssd1 vccd1 vccd1 _3102_/D sky130_fd_sc_hd__a22o_2
XTAP_TAPCELL_ROW_7_229 vssd1 vccd1 sky130_fd_sc_hd__tapvpwrvgnd_1
X_2478_ hold708/X wire59/X _2477_/X _1602_/X vssd1 vssd1 vccd1 vccd1 _3092_/D sky130_fd_sc_hd__a22o_2
XPHY_EDGE_ROW_50_Left_130 vssd1 vssd1 vccd1 vccd1 sky130_fd_sc_hd__decap_3
XFILLER_18_25 vssd1 vssd1 vccd1 vccd1 sky130_fd_sc_hd__fill_2
XFILLER_70_158 vssd1 vssd1 vccd1 vccd1 sky130_fd_sc_hd__fill_2
XFILLER_70_147 vssd1 vssd1 vccd1 vccd1 sky130_fd_sc_hd__fill_4
XTAP_TAPCELL_ROW_41_518 vssd1 vccd1 sky130_fd_sc_hd__tapvpwrvgnd_1
XANTENNA__2025__A _2025_/A vssd1 vssd1 vccd1 vccd1 sky130_fd_sc_hd__diode_2
Xclkload1 clkload1/A vssd1 vssd1 vccd1 vccd1 clkload1/X sky130_fd_sc_hd__clkbuf_8
XFILLER_7_229 vssd1 vssd1 vccd1 vccd1 sky130_fd_sc_hd__fill_2
XFILLER_11_269 vssd1 vssd1 vccd1 vccd1 sky130_fd_sc_hd__fill_1
XANTENNA__1864__A _1906_/A vssd1 vssd1 vccd1 vccd1 sky130_fd_sc_hd__diode_2
XFILLER_59_32 vssd1 vssd1 vccd1 vccd1 sky130_fd_sc_hd__fill_2
XFILLER_3_457 vssd1 vssd1 vccd1 vccd1 sky130_fd_sc_hd__fill_2
XFILLER_1_3 vssd1 vssd1 vccd1 vccd1 sky130_fd_sc_hd__fill_1
XANTENNA_fanout81_X _2667_/B vssd1 vssd1 vccd1 vccd1 sky130_fd_sc_hd__diode_2
XFILLER_78_203 vssd1 vssd1 vccd1 vccd1 sky130_fd_sc_hd__fill_4
Xfanout260 fanout265/X vssd1 vssd1 vccd1 vccd1 fanout260/X sky130_fd_sc_hd__clkdlybuf4s25_1
Xfanout271 fanout290/X vssd1 vssd1 vccd1 vccd1 fanout271/X sky130_fd_sc_hd__clkdlybuf4s25_1
Xfanout282 fanout284/X vssd1 vssd1 vccd1 vccd1 fanout282/X sky130_fd_sc_hd__clkdlybuf4s25_1
Xfanout293 input2/X vssd1 vssd1 vccd1 vccd1 _3471_/CLK sky130_fd_sc_hd__clkdlybuf4s25_1
XFILLER_74_431 vssd1 vssd1 vccd1 vccd1 sky130_fd_sc_hd__fill_1
XFILLER_75_86 vssd1 vssd1 vccd1 vccd1 sky130_fd_sc_hd__fill_4
XFILLER_74_475 vssd1 vssd1 vccd1 vccd1 sky130_fd_sc_hd__fill_1
Xload_slew68 _2881_/B1 vssd1 vssd1 vccd1 vccd1 _2971_/B1 sky130_fd_sc_hd__clkbuf_4
XFILLER_61_103 vssd1 vssd1 vccd1 vccd1 sky130_fd_sc_hd__fill_8
XFILLER_46_177 vssd1 vssd1 vccd1 vccd1 sky130_fd_sc_hd__fill_1
XFILLER_61_169 vssd1 vssd1 vccd1 vccd1 sky130_fd_sc_hd__fill_1
XFILLER_42_350 vssd1 vssd1 vccd1 vccd1 sky130_fd_sc_hd__fill_2
X_1780_ _2091_/B _1787_/A vssd1 vssd1 vccd1 vccd1 _1780_/Y sky130_fd_sc_hd__nor2_2
XTAP_TAPCELL_ROW_12_275 vssd1 vccd1 sky130_fd_sc_hd__tapvpwrvgnd_1
Xhold719 _3392_/Q vssd1 vssd1 vccd1 vccd1 hold719/X sky130_fd_sc_hd__dlygate4sd3_1
Xhold708 _3092_/Q vssd1 vssd1 vccd1 vccd1 hold708/X sky130_fd_sc_hd__dlygate4sd3_1
XFILLER_6_251 vssd1 vssd1 vccd1 vccd1 sky130_fd_sc_hd__fill_1
X_3450_ _3450_/CLK _3450_/D fanout284/X vssd1 vssd1 vccd1 vccd1 _3450_/Q sky130_fd_sc_hd__dfrtp_2
X_3381_ _3437_/CLK _3381_/D load_slew261/X vssd1 vssd1 vccd1 vccd1 _3381_/Q sky130_fd_sc_hd__dfrtp_2
X_2401_ _2387_/A _2386_/A _2386_/B vssd1 vssd1 vccd1 vccd1 _2402_/B sky130_fd_sc_hd__o21ba_2
X_2332_ _2332_/A _2332_/B vssd1 vssd1 vccd1 vccd1 _2334_/B sky130_fd_sc_hd__xnor2_2
XFILLER_69_225 vssd1 vssd1 vccd1 vccd1 sky130_fd_sc_hd__fill_4
XANTENNA__2809__S _2814_/S vssd1 vssd1 vccd1 vccd1 sky130_fd_sc_hd__diode_2
X_2263_ _2263_/A _3037_/Q vssd1 vssd1 vccd1 vccd1 _2291_/A sky130_fd_sc_hd__and2_2
X_2194_ _2195_/A _2195_/B _2195_/C vssd1 vssd1 vccd1 vccd1 _2197_/A sky130_fd_sc_hd__and3_2
XFILLER_37_122 vssd1 vssd1 vccd1 vccd1 sky130_fd_sc_hd__fill_1
XFILLER_60_191 vssd1 vssd1 vccd1 vccd1 sky130_fd_sc_hd__fill_1
XFILLER_33_383 vssd1 vssd1 vccd1 vccd1 sky130_fd_sc_hd__fill_1
XANTENNA_fanout226_A fanout228/X vssd1 vssd1 vccd1 vccd1 sky130_fd_sc_hd__diode_2
X_1978_ _1978_/A _1978_/B vssd1 vssd1 vccd1 vccd1 _1979_/C sky130_fd_sc_hd__nand2_2
XFILLER_20_59 vssd1 vssd1 vccd1 vccd1 sky130_fd_sc_hd__fill_2
XFILLER_0_405 vssd1 vssd1 vccd1 vccd1 sky130_fd_sc_hd__fill_2
XFILLER_0_449 vssd1 vssd1 vccd1 vccd1 sky130_fd_sc_hd__fill_4
XANTENNA__2719__S _2719_/S vssd1 vssd1 vccd1 vccd1 sky130_fd_sc_hd__diode_2
XFILLER_75_206 vssd1 vssd1 vccd1 vccd1 sky130_fd_sc_hd__fill_1
XFILLER_16_306 vssd1 vssd1 vccd1 vccd1 sky130_fd_sc_hd__fill_2
XANTENNA_fanout41_A _2638_/X vssd1 vssd1 vccd1 vccd1 sky130_fd_sc_hd__diode_2
XTAP_TAPCELL_ROW_54_632 vssd1 vccd1 sky130_fd_sc_hd__tapvpwrvgnd_1
XFILLER_45_78 vssd1 vssd1 vccd1 vccd1 sky130_fd_sc_hd__fill_1
XFILLER_43_136 vssd1 vssd1 vccd1 vccd1 sky130_fd_sc_hd__fill_4
XFILLER_43_169 vssd1 vssd1 vccd1 vccd1 sky130_fd_sc_hd__fill_8
XTAP_TAPCELL_ROW_26_389 vssd1 vccd1 sky130_fd_sc_hd__tapvpwrvgnd_1
XPHY_EDGE_ROW_7_Left_87 vssd1 vssd1 vccd1 vccd1 sky130_fd_sc_hd__decap_3
XFILLER_6_17 vssd1 vssd1 vccd1 vccd1 sky130_fd_sc_hd__fill_2
XFILLER_3_210 vssd1 vccd1 vssd1 vccd1 sky130_ef_sc_hd__decap_40_12
XANTENNA__2629__S _2647_/S vssd1 vssd1 vccd1 vccd1 sky130_fd_sc_hd__diode_2
XFILLER_19_100 vssd1 vccd1 vssd1 vccd1 sky130_ef_sc_hd__decap_40_12
XFILLER_47_453 vssd1 vssd1 vccd1 vccd1 sky130_fd_sc_hd__fill_1
XANTENNA_clkload4_A clkload4/A vssd1 vssd1 vccd1 vccd1 sky130_fd_sc_hd__diode_2
X_2950_ _3196_/Q _2971_/A2 _2971_/B1 _3178_/Q _2949_/X vssd1 vssd1 vccd1 vccd1 _2950_/X
+ sky130_fd_sc_hd__a221o_2
X_2881_ _3262_/Q _2881_/A2 _2881_/B1 _3244_/Q _2880_/X vssd1 vssd1 vccd1 vccd1 _2881_/X
+ sky130_fd_sc_hd__a221o_2
X_1901_ _1900_/A _1900_/B _1900_/C vssd1 vssd1 vccd1 vccd1 _1903_/C sky130_fd_sc_hd__a21o_2
X_1832_ _1832_/A _1832_/B vssd1 vssd1 vccd1 vccd1 _1834_/B sky130_fd_sc_hd__xnor2_2
XTAP_TAPCELL_ROW_60_679 vssd1 vccd1 sky130_fd_sc_hd__tapvpwrvgnd_1
X_1763_ _2029_/B hold471/X _1763_/S vssd1 vssd1 vccd1 vccd1 _3043_/D sky130_fd_sc_hd__mux2_1
Xhold527 _3180_/Q vssd1 vssd1 vccd1 vccd1 hold527/X sky130_fd_sc_hd__dlygate4sd3_1
Xhold516 _3311_/Q vssd1 vssd1 vccd1 vccd1 hold516/X sky130_fd_sc_hd__dlygate4sd3_1
Xhold505 _3174_/Q vssd1 vssd1 vccd1 vccd1 hold505/X sky130_fd_sc_hd__dlygate4sd3_1
X_1694_ _1688_/A _1684_/Y _1688_/B _1686_/B vssd1 vssd1 vccd1 vccd1 _1695_/B sky130_fd_sc_hd__o31a_2
X_3433_ _3436_/CLK _3433_/D fanout226/X vssd1 vssd1 vccd1 vccd1 _3433_/Q sky130_fd_sc_hd__dfstp_2
Xhold549 _3229_/Q vssd1 vssd1 vccd1 vccd1 hold549/X sky130_fd_sc_hd__dlygate4sd3_1
Xhold538 _3317_/Q vssd1 vssd1 vccd1 vccd1 hold538/X sky130_fd_sc_hd__dlygate4sd3_1
X_3364_ _2987_/Y _3364_/D load_slew283/X vssd1 vssd1 vccd1 vccd1 _3364_/Q sky130_fd_sc_hd__dfrtp_2
X_3295_ _3331_/CLK _3295_/D load_slew232/X vssd1 vssd1 vccd1 vccd1 _3295_/Q sky130_fd_sc_hd__dfrtp_2
X_2315_ _2347_/A _2352_/B _2278_/X _2318_/B _2318_/A vssd1 vssd1 vccd1 vccd1 _2316_/A
+ sky130_fd_sc_hd__a32o_2
X_2246_ _2223_/Y _2234_/B _2245_/Y _2225_/B vssd1 vssd1 vccd1 vccd1 _2248_/B sky130_fd_sc_hd__o211ai_2
XTAP_TAPCELL_ROW_68_746 vssd1 vccd1 sky130_fd_sc_hd__tapvpwrvgnd_1
X_2177_ _2214_/A _2213_/B _2213_/A vssd1 vssd1 vccd1 vccd1 _2179_/C sky130_fd_sc_hd__a21o_2
XTAP_TAPCELL_ROW_51_602 vssd1 vccd1 sky130_fd_sc_hd__tapvpwrvgnd_1
XFILLER_21_320 vssd1 vssd1 vccd1 vccd1 sky130_fd_sc_hd__fill_2
XFILLER_31_69 vssd1 vssd1 vccd1 vccd1 sky130_fd_sc_hd__fill_8
XANTENNA__2878__B1 _2894_/B1 vssd1 vssd1 vccd1 vccd1 sky130_fd_sc_hd__diode_2
XANTENNA_fanout89_A _1574_/X vssd1 vssd1 vccd1 vccd1 sky130_fd_sc_hd__diode_2
Xteam_02_310 vssd1 vssd1 vccd1 vccd1 team_02_310/HI gpio_out[13] sky130_fd_sc_hd__conb_1
XFILLER_0_257 vssd1 vssd1 vccd1 vccd1 sky130_fd_sc_hd__fill_1
Xteam_02_321 vssd1 vssd1 vccd1 vccd1 team_02_321/HI gpio_out[24] sky130_fd_sc_hd__conb_1
Xteam_02_332 vssd1 vssd1 vccd1 vccd1 gpio_oeb[0] team_02_332/LO sky130_fd_sc_hd__conb_1
Xteam_02_343 vssd1 vssd1 vccd1 vccd1 gpio_oeb[13] team_02_343/LO sky130_fd_sc_hd__conb_1
XFILLER_56_11 vssd1 vssd1 vccd1 vccd1 sky130_fd_sc_hd__fill_1
Xteam_02_354 vssd1 vssd1 vccd1 vccd1 gpio_oeb[24] team_02_354/LO sky130_fd_sc_hd__conb_1
XFILLER_63_209 vssd1 vssd1 vccd1 vccd1 sky130_fd_sc_hd__fill_1
XFILLER_56_55 vssd1 vssd1 vccd1 vccd1 sky130_fd_sc_hd__fill_2
XFILLER_71_253 vssd1 vssd1 vccd1 vccd1 sky130_fd_sc_hd__fill_2
XFILLER_44_489 vssd1 vssd1 vccd1 vccd1 sky130_fd_sc_hd__fill_4
XANTENNA__1908__A2 _2073_/C vssd1 vssd1 vccd1 vccd1 sky130_fd_sc_hd__diode_2
XFILLER_79_375 vssd1 vssd1 vccd1 vccd1 sky130_fd_sc_hd__fill_2
X_3080_ _3121_/CLK _3080_/D vssd1 vssd1 vccd1 vccd1 _3080_/Q sky130_fd_sc_hd__dfxtp_2
X_2100_ _2421_/B _2107_/A vssd1 vssd1 vccd1 vccd1 _2100_/Y sky130_fd_sc_hd__nor2_2
X_2031_ _2008_/A _2007_/A _2007_/B vssd1 vssd1 vccd1 vccd1 _2032_/B sky130_fd_sc_hd__a21boi_2
XTAP_TAPCELL_ROW_65_727 vssd1 vccd1 sky130_fd_sc_hd__tapvpwrvgnd_1
X_2933_ _3213_/Q _2970_/B _2970_/C vssd1 vssd1 vccd1 vccd1 _2933_/X sky130_fd_sc_hd__and3_2
XTAP_TAPCELL_ROW_73_793 vssd1 vccd1 sky130_fd_sc_hd__tapvpwrvgnd_1
XANTENNA__2822__S _2833_/S vssd1 vssd1 vccd1 vccd1 sky130_fd_sc_hd__diode_2
X_2864_ hold429/X _2540_/B _2864_/S vssd1 vssd1 vccd1 vccd1 _3388_/D sky130_fd_sc_hd__mux2_1
X_2795_ hold470/X _2814_/A1 _2799_/S vssd1 vssd1 vccd1 vccd1 _3302_/D sky130_fd_sc_hd__mux2_1
X_1815_ _1813_/X _1815_/B vssd1 vssd1 vccd1 vccd1 _1816_/B sky130_fd_sc_hd__nand2b_2
XANTENNA__2123__A _2297_/A vssd1 vssd1 vccd1 vccd1 sky130_fd_sc_hd__diode_2
X_1746_ _2025_/A hold640/X _3435_/D vssd1 vssd1 vccd1 vccd1 _3026_/D sky130_fd_sc_hd__mux2_1
XANTENNA__2572__A2 _1622_/C vssd1 vssd1 vccd1 vccd1 sky130_fd_sc_hd__diode_2
Xhold368 _3438_/Q vssd1 vssd1 vccd1 vccd1 _3440_/D sky130_fd_sc_hd__dlygate4sd3_1
X_1677_ _3078_/Q _3061_/Q vssd1 vssd1 vccd1 vccd1 _1680_/A sky130_fd_sc_hd__or2_2
X_3416_ _3436_/CLK _3416_/D load_slew227/X vssd1 vssd1 vccd1 vccd1 _3416_/Q sky130_fd_sc_hd__dfrtp_2
Xhold379 _3446_/Q vssd1 vssd1 vccd1 vccd1 hold379/X sky130_fd_sc_hd__dlygate4sd3_1
XANTENNA_fanout293_A input2/X vssd1 vssd1 vccd1 vccd1 sky130_fd_sc_hd__diode_2
X_3347_ _3349_/CLK _3347_/D load_slew205/X vssd1 vssd1 vccd1 vccd1 _3347_/Q sky130_fd_sc_hd__dfrtp_2
X_3278_ _3383_/CLK _3278_/D fanout272/X vssd1 vssd1 vccd1 vccd1 _3278_/Q sky130_fd_sc_hd__dfrtp_2
X_2229_ _2263_/A _2264_/B _2284_/B _2264_/A vssd1 vssd1 vccd1 vccd1 _2230_/B sky130_fd_sc_hd__a22o_2
XTAP_TAPCELL_ROW_28_407 vssd1 vccd1 sky130_fd_sc_hd__tapvpwrvgnd_1
XFILLER_38_294 vssd1 vssd1 vccd1 vccd1 sky130_fd_sc_hd__fill_1
XFILLER_26_58 vssd1 vssd1 vccd1 vccd1 sky130_fd_sc_hd__fill_1
XFILLER_13_117 vssd1 vssd1 vccd1 vccd1 sky130_fd_sc_hd__fill_2
XFILLER_42_24 vssd1 vssd1 vccd1 vccd1 sky130_fd_sc_hd__fill_4
XANTENNA__2732__S _2738_/S vssd1 vssd1 vccd1 vccd1 sky130_fd_sc_hd__diode_2
XFILLER_42_68 vssd1 vssd1 vccd1 vccd1 sky130_fd_sc_hd__fill_4
XANTENNA__2563__A2 _2477_/X vssd1 vssd1 vccd1 vccd1 sky130_fd_sc_hd__diode_2
XANTENNA__1771__A0 _2352_/B vssd1 vssd1 vccd1 vccd1 sky130_fd_sc_hd__diode_2
XANTENNA__2315__A2 _2352_/B vssd1 vssd1 vccd1 vccd1 sky130_fd_sc_hd__diode_2
XPHY_EDGE_ROW_79_Left_159 vssd1 vssd1 vccd1 vccd1 sky130_fd_sc_hd__decap_3
XFILLER_36_209 vssd1 vssd1 vccd1 vccd1 sky130_fd_sc_hd__fill_1
XFILLER_29_283 vssd1 vssd1 vccd1 vccd1 sky130_fd_sc_hd__fill_1
XFILLER_44_253 vssd1 vssd1 vccd1 vccd1 sky130_fd_sc_hd__fill_4
XFILLER_17_478 vssd1 vssd1 vccd1 vccd1 sky130_fd_sc_hd__fill_2
XTAP_TAPCELL_ROW_70_763 vssd1 vccd1 sky130_fd_sc_hd__tapvpwrvgnd_1
XFILLER_40_492 vssd1 vssd1 vccd1 vccd1 sky130_fd_sc_hd__fill_2
XFILLER_12_194 vssd1 vssd1 vccd1 vccd1 sky130_fd_sc_hd__fill_2
XANTENNA__2003__A1 _2029_/D vssd1 vssd1 vccd1 vccd1 sky130_fd_sc_hd__diode_2
X_1600_ _3440_/Q _1626_/C _3420_/Q vssd1 vssd1 vccd1 vccd1 _1601_/B sky130_fd_sc_hd__o21a_2
X_2580_ hold532/X _1622_/C _2583_/B1 hold610/X vssd1 vssd1 vccd1 vccd1 _3132_/D sky130_fd_sc_hd__a22o_2
XANTENNA__1762__A0 _2029_/C vssd1 vssd1 vccd1 vccd1 sky130_fd_sc_hd__diode_2
X_1531_ _3363_/Q _3364_/Q _1534_/S vssd1 vssd1 vccd1 vccd1 _3364_/D sky130_fd_sc_hd__mux2_1
X_3201_ _3437_/CLK _3201_/D fanout262/X vssd1 vssd1 vccd1 vccd1 _3201_/Q sky130_fd_sc_hd__dfrtp_2
X_3132_ _3132_/CLK _3132_/D load_slew212/X vssd1 vssd1 vccd1 vccd1 _3132_/Q sky130_fd_sc_hd__dfrtp_2
XANTENNA__2817__S _2818_/S vssd1 vssd1 vccd1 vccd1 sky130_fd_sc_hd__diode_2
X_3063_ clkload6/A _3063_/D vssd1 vssd1 vccd1 vccd1 _3063_/Q sky130_fd_sc_hd__dfxtp_2
X_2014_ _2015_/A _2015_/C _2015_/B vssd1 vssd1 vccd1 vccd1 _2045_/A sky130_fd_sc_hd__a21oi_2
XANTENNA__2490__B2 _1602_/X vssd1 vssd1 vccd1 vccd1 sky130_fd_sc_hd__diode_2
XTAP_TAPCELL_ROW_33_454 vssd1 vccd1 sky130_fd_sc_hd__tapvpwrvgnd_1
XANTENNA__2552__S _2559_/S vssd1 vssd1 vccd1 vccd1 sky130_fd_sc_hd__diode_2
X_2916_ _3193_/Q _2968_/A2 _2968_/B1 _3175_/Q _2915_/X vssd1 vssd1 vccd1 vccd1 _2916_/X
+ sky130_fd_sc_hd__a221o_2
XANTENNA_fanout139_A _2472_/A vssd1 vssd1 vccd1 vccd1 sky130_fd_sc_hd__diode_2
X_2847_ hold419/X _2628_/X _2852_/S vssd1 vssd1 vccd1 vccd1 _3351_/D sky130_fd_sc_hd__mux2_1
XFILLER_12_27 vssd1 vssd1 vccd1 vccd1 sky130_fd_sc_hd__fill_1
X_2778_ hold401/X _2816_/A1 _2780_/S vssd1 vssd1 vccd1 vccd1 _3286_/D sky130_fd_sc_hd__mux2_1
XANTENNA__2545__A2 _2477_/X vssd1 vssd1 vccd1 vccd1 sky130_fd_sc_hd__diode_2
XANTENNA_clkbuf_leaf_1_clk_A clkbuf_leaf_2_clk/A vssd1 vssd1 vccd1 vccd1 sky130_fd_sc_hd__diode_2
X_1729_ _1727_/Y _1729_/B vssd1 vssd1 vccd1 vccd1 _1731_/A sky130_fd_sc_hd__and2b_2
XANTENNA__2727__S _2738_/S vssd1 vssd1 vccd1 vccd1 sky130_fd_sc_hd__diode_2
XFILLER_26_253 vssd1 vssd1 vccd1 vccd1 sky130_fd_sc_hd__fill_1
XANTENNA__2028__A _2029_/B vssd1 vssd1 vccd1 vccd1 sky130_fd_sc_hd__diode_2
XFILLER_53_34 vssd1 vssd1 vccd1 vccd1 sky130_fd_sc_hd__fill_2
XANTENNA__2970__B _2970_/B vssd1 vssd1 vccd1 vccd1 sky130_fd_sc_hd__diode_2
XFILLER_41_234 vssd1 vssd1 vccd1 vccd1 sky130_fd_sc_hd__fill_4
XFILLER_5_113 vssd1 vssd1 vccd1 vccd1 sky130_fd_sc_hd__fill_4
XANTENNA__2536__A2 _2894_/A2 vssd1 vssd1 vccd1 vccd1 sky130_fd_sc_hd__diode_2
XFILLER_5_157 vssd1 vssd1 vccd1 vccd1 sky130_fd_sc_hd__fill_8
XFILLER_1_385 vssd1 vssd1 vccd1 vccd1 sky130_fd_sc_hd__fill_4
XANTENNA__1541__S _1546_/S vssd1 vssd1 vccd1 vccd1 sky130_fd_sc_hd__diode_2
XANTENNA__2637__S _2645_/S vssd1 vssd1 vccd1 vccd1 sky130_fd_sc_hd__diode_2
XTAP_TAPCELL_ROW_75_811 vssd1 vccd1 sky130_fd_sc_hd__tapvpwrvgnd_1
XFILLER_64_315 vssd1 vssd1 vccd1 vccd1 sky130_fd_sc_hd__fill_1
XTAP_TAPCELL_ROW_47_568 vssd1 vccd1 sky130_fd_sc_hd__tapvpwrvgnd_1
XANTENNA__2880__B _2970_/C vssd1 vssd1 vccd1 vccd1 sky130_fd_sc_hd__diode_2
XFILLER_20_429 vssd1 vssd1 vccd1 vccd1 sky130_fd_sc_hd__fill_1
X_2701_ hold424/X _2815_/A1 _2704_/S vssd1 vssd1 vccd1 vccd1 _3213_/D sky130_fd_sc_hd__mux2_1
XTAP_TAPCELL_ROW_30_424 vssd1 vccd1 sky130_fd_sc_hd__tapvpwrvgnd_1
X_2632_ _3132_/Q _2644_/B vssd1 vssd1 vccd1 vccd1 _2632_/X sky130_fd_sc_hd__and2_2
XFILLER_64_3 vssd1 vssd1 vccd1 vccd1 sky130_fd_sc_hd__fill_2
X_2563_ _1569_/D _2477_/X _2560_/Y hold625/X vssd1 vssd1 vccd1 vccd1 _3116_/D sky130_fd_sc_hd__a22o_2
X_1514_ _3378_/Q _1509_/B input3/X vssd1 vssd1 vccd1 vccd1 _1515_/B sky130_fd_sc_hd__o21ai_2
X_2494_ _2520_/A _2494_/B vssd1 vssd1 vccd1 vccd1 _2494_/X sky130_fd_sc_hd__and2_2
XFILLER_4_94 vssd1 vssd1 vccd1 vccd1 sky130_fd_sc_hd__fill_2
XFILLER_67_131 vssd1 vssd1 vccd1 vccd1 sky130_fd_sc_hd__fill_4
X_3115_ _3343_/CLK _3115_/D wire222/X vssd1 vssd1 vccd1 vccd1 _3115_/Q sky130_fd_sc_hd__dfrtp_2
X_3046_ _3119_/CLK _3046_/D fanout223/X vssd1 vssd1 vccd1 vccd1 _3046_/Q sky130_fd_sc_hd__dfrtp_2
XFILLER_67_186 vssd1 vssd1 vccd1 vccd1 sky130_fd_sc_hd__fill_2
XFILLER_55_337 vssd1 vssd1 vccd1 vccd1 sky130_fd_sc_hd__fill_1
XANTENNA__2463__A1 _2781_/B vssd1 vssd1 vccd1 vccd1 sky130_fd_sc_hd__diode_2
XANTENNA__2463__B2 _2445_/S vssd1 vssd1 vccd1 vccd1 sky130_fd_sc_hd__diode_2
XFILLER_23_15 vssd1 vccd1 vssd1 vccd1 sky130_ef_sc_hd__decap_40_12
XFILLER_23_48 vssd1 vssd1 vccd1 vccd1 sky130_fd_sc_hd__fill_2
XANTENNA__2518__A2 _2960_/A2 vssd1 vssd1 vccd1 vccd1 sky130_fd_sc_hd__diode_2
XANTENNA__2949__C _2970_/C vssd1 vssd1 vccd1 vccd1 sky130_fd_sc_hd__diode_2
XFILLER_73_167 vssd1 vssd1 vccd1 vccd1 sky130_fd_sc_hd__fill_1
XANTENNA__2454__B2 _1602_/X vssd1 vssd1 vccd1 vccd1 sky130_fd_sc_hd__diode_2
XTAP_TAPCELL_ROW_1_182 vssd1 vccd1 sky130_fd_sc_hd__tapvpwrvgnd_1
XTAP_TAPCELL_ROW_44_549 vssd1 vccd1 sky130_fd_sc_hd__tapvpwrvgnd_1
XFILLER_14_245 vssd1 vssd1 vccd1 vccd1 sky130_fd_sc_hd__fill_4
Xfanout60 _1584_/X vssd1 vssd1 vccd1 vccd1 _1585_/A sky130_fd_sc_hd__clkdlybuf4s25_1
Xfanout71 _2800_/B vssd1 vssd1 vccd1 vccd1 _2648_/B sky130_fd_sc_hd__clkdlybuf4s25_1
Xfanout82 _2819_/B vssd1 vssd1 vccd1 vccd1 _2894_/A2 sky130_fd_sc_hd__clkdlybuf4s25_1
XANTENNA__2205__B _2297_/A vssd1 vssd1 vccd1 vccd1 sky130_fd_sc_hd__diode_2
Xfanout93 _1568_/Y vssd1 vssd1 vccd1 vccd1 _1569_/D sky130_fd_sc_hd__clkdlybuf4s25_1
XFILLER_6_455 vssd1 vssd1 vccd1 vccd1 sky130_fd_sc_hd__fill_2
XFILLER_6_488 vssd1 vssd1 vccd1 vccd1 sky130_fd_sc_hd__fill_4
XFILLER_69_407 vssd1 vssd1 vccd1 vccd1 sky130_fd_sc_hd__fill_2
XFILLER_1_171 vssd1 vssd1 vccd1 vccd1 sky130_fd_sc_hd__fill_1
XANTENNA__2445__A1 _2781_/B vssd1 vssd1 vccd1 vccd1 sky130_fd_sc_hd__diode_2
XANTENNA__2891__A _2926_/B vssd1 vssd1 vccd1 vccd1 sky130_fd_sc_hd__diode_2
X_1994_ _1994_/A _1994_/B vssd1 vssd1 vccd1 vccd1 _2022_/A sky130_fd_sc_hd__nand2_2
XANTENNA__2830__S _2833_/S vssd1 vssd1 vccd1 vccd1 sky130_fd_sc_hd__diode_2
X_2615_ hold647/X _2802_/A1 _2647_/S vssd1 vssd1 vccd1 vccd1 _3146_/D sky130_fd_sc_hd__mux2_1
XANTENNA__2131__A _2154_/B vssd1 vssd1 vccd1 vccd1 sky130_fd_sc_hd__diode_2
X_2546_ _2550_/A1 _2489_/X _2550_/B1 hold482/X vssd1 vssd1 vccd1 vccd1 _3101_/D sky130_fd_sc_hd__a22o_2
XANTENNA__1970__A _2029_/D vssd1 vssd1 vccd1 vccd1 sky130_fd_sc_hd__diode_2
X_2477_ _2590_/B _2477_/B vssd1 vssd1 vccd1 vccd1 _2477_/X sky130_fd_sc_hd__and2_2
XFILLER_18_15 vssd1 vssd1 vccd1 vccd1 sky130_fd_sc_hd__fill_1
XFILLER_55_167 vssd1 vssd1 vccd1 vccd1 sky130_fd_sc_hd__fill_1
XANTENNA_fanout161_X _2029_/B vssd1 vssd1 vccd1 vccd1 sky130_fd_sc_hd__diode_2
X_3029_ clkload6/A _3029_/D load_slew202/X vssd1 vssd1 vccd1 vccd1 _3029_/Q sky130_fd_sc_hd__dfrtp_2
XFILLER_34_36 vssd1 vssd1 vccd1 vccd1 sky130_fd_sc_hd__fill_4
XTAP_TAPCELL_ROW_41_519 vssd1 vccd1 sky130_fd_sc_hd__tapvpwrvgnd_1
Xclkload2 clkload2/A vssd1 vssd1 vccd1 vccd1 clkload2/X sky130_fd_sc_hd__clkbuf_8
Xwire106 _1607_/Y vssd1 vssd1 vccd1 vccd1 wire106/X sky130_fd_sc_hd__clkbuf_2
XFILLER_50_13 vssd1 vssd1 vccd1 vccd1 sky130_fd_sc_hd__fill_1
XANTENNA__2740__S _2742_/S vssd1 vssd1 vccd1 vccd1 sky130_fd_sc_hd__diode_2
XFILLER_50_35 vssd1 vssd1 vccd1 vccd1 sky130_fd_sc_hd__fill_1
XFILLER_59_88 vssd1 vssd1 vccd1 vccd1 sky130_fd_sc_hd__fill_2
Xfanout272 fanout279/X vssd1 vssd1 vccd1 vccd1 fanout272/X sky130_fd_sc_hd__clkdlybuf4s25_1
Xfanout294 _3001_/A vssd1 vssd1 vccd1 vccd1 _3003_/A sky130_fd_sc_hd__clkdlybuf4s25_1
XFILLER_75_54 vssd1 vssd1 vccd1 vccd1 sky130_fd_sc_hd__fill_2
XFILLER_74_421 vssd1 vssd1 vccd1 vccd1 sky130_fd_sc_hd__fill_8
XFILLER_19_337 vssd1 vssd1 vccd1 vccd1 sky130_fd_sc_hd__fill_1
XFILLER_74_465 vssd1 vssd1 vccd1 vccd1 sky130_fd_sc_hd__fill_8
XFILLER_74_487 vssd1 vssd1 vccd1 vccd1 sky130_fd_sc_hd__fill_1
XANTENNA_clkbuf_3_4__f_clk_A clkbuf_0_clk/X vssd1 vssd1 vccd1 vccd1 sky130_fd_sc_hd__diode_2
XANTENNA__2650__S _2662_/S vssd1 vssd1 vccd1 vccd1 sky130_fd_sc_hd__diode_2
XTAP_TAPCELL_ROW_12_276 vssd1 vccd1 sky130_fd_sc_hd__tapvpwrvgnd_1
Xhold709 _3416_/Q vssd1 vssd1 vccd1 vccd1 _1622_/A sky130_fd_sc_hd__dlygate4sd3_1
X_2400_ _2400_/A _2419_/A vssd1 vssd1 vccd1 vccd1 _2403_/B sky130_fd_sc_hd__nand2_2
XFILLER_6_296 vssd1 vssd1 vccd1 vccd1 sky130_fd_sc_hd__fill_1
X_3380_ _3003_/Y _3380_/D fanout285/X vssd1 vssd1 vccd1 vccd1 _3380_/Q sky130_fd_sc_hd__dfrtp_2
X_2331_ _2331_/A _2360_/A vssd1 vssd1 vccd1 vccd1 _2332_/B sky130_fd_sc_hd__nor2_2
XANTENNA_clkbuf_leaf_41_clk_A clkbuf_leaf_2_clk/A vssd1 vssd1 vccd1 vccd1 sky130_fd_sc_hd__diode_2
X_2262_ _2260_/Y _2262_/B vssd1 vssd1 vccd1 vccd1 _2268_/A sky130_fd_sc_hd__nand2b_2
XFILLER_69_248 vssd1 vssd1 vccd1 vccd1 sky130_fd_sc_hd__fill_8
XFILLER_27_3 vssd1 vssd1 vccd1 vccd1 sky130_fd_sc_hd__fill_4
X_2193_ _2193_/A _2193_/B _2193_/C vssd1 vssd1 vccd1 vccd1 _2195_/C sky130_fd_sc_hd__or3_2
XFILLER_77_281 vssd1 vssd1 vccd1 vccd1 sky130_fd_sc_hd__fill_4
XANTENNA__2825__S _2837_/S vssd1 vssd1 vccd1 vccd1 sky130_fd_sc_hd__diode_2
XFILLER_37_189 vssd1 vssd1 vccd1 vccd1 sky130_fd_sc_hd__fill_1
XFILLER_37_167 vssd1 vssd1 vccd1 vccd1 sky130_fd_sc_hd__fill_1
XFILLER_1_95 vssd1 vssd1 vccd1 vccd1 sky130_fd_sc_hd__fill_4
XANTENNA__2969__A2 _2838_/B vssd1 vssd1 vccd1 vccd1 sky130_fd_sc_hd__diode_2
XFILLER_52_126 vssd1 vssd1 vccd1 vccd1 sky130_fd_sc_hd__fill_1
XFILLER_33_395 vssd1 vssd1 vccd1 vccd1 sky130_fd_sc_hd__fill_2
XANTENNA_fanout121_A _2973_/A1 vssd1 vssd1 vccd1 vccd1 sky130_fd_sc_hd__diode_2
X_1977_ _1977_/A _1977_/B vssd1 vssd1 vccd1 vccd1 _1980_/A sky130_fd_sc_hd__xor2_2
X_2529_ hold675/X wire59/X _2528_/X _1602_/X vssd1 vssd1 vccd1 vccd1 _3096_/D sky130_fd_sc_hd__a22o_2
XTAP_TAPCELL_ROW_3_200 vssd1 vccd1 sky130_fd_sc_hd__tapvpwrvgnd_1
XANTENNA__2735__S _2738_/S vssd1 vssd1 vccd1 vccd1 sky130_fd_sc_hd__diode_2
XFILLER_45_24 vssd1 vccd1 vssd1 vccd1 sky130_ef_sc_hd__decap_40_12
XFILLER_16_329 vssd1 vssd1 vccd1 vccd1 sky130_fd_sc_hd__fill_2
XTAP_TAPCELL_ROW_54_633 vssd1 vccd1 sky130_fd_sc_hd__tapvpwrvgnd_1
XFILLER_43_148 vssd1 vssd1 vccd1 vccd1 sky130_fd_sc_hd__fill_8
XFILLER_3_233 vssd1 vssd1 vccd1 vccd1 sky130_fd_sc_hd__fill_2
XFILLER_3_222 vssd1 vssd1 vccd1 vccd1 sky130_fd_sc_hd__fill_2
XFILLER_10_71 vssd1 vssd1 vccd1 vccd1 sky130_fd_sc_hd__fill_8
XANTENNA__2896__A1 _2972_/A1 vssd1 vssd1 vccd1 vccd1 sky130_fd_sc_hd__diode_2
XFILLER_47_465 vssd1 vssd1 vccd1 vccd1 sky130_fd_sc_hd__fill_2
XFILLER_19_91 vssd1 vssd1 vccd1 vccd1 sky130_fd_sc_hd__fill_2
XANTENNA__2645__S _2645_/S vssd1 vssd1 vccd1 vccd1 sky130_fd_sc_hd__diode_2
XFILLER_74_251 vssd1 vssd1 vccd1 vccd1 sky130_fd_sc_hd__fill_1
XFILLER_19_167 vssd1 vssd1 vccd1 vccd1 sky130_fd_sc_hd__fill_1
XTAP_TAPCELL_ROW_17_313 vssd1 vccd1 sky130_fd_sc_hd__tapvpwrvgnd_1
X_2880_ _2970_/B _2970_/C _3280_/Q vssd1 vssd1 vccd1 vccd1 _2880_/X sky130_fd_sc_hd__and3_2
X_1900_ _1900_/A _1900_/B _1900_/C vssd1 vssd1 vccd1 vccd1 _1903_/B sky130_fd_sc_hd__nand3_2
X_1831_ _1816_/A _1813_/X _1815_/B vssd1 vssd1 vccd1 vccd1 _1832_/B sky130_fd_sc_hd__o21ai_2
X_1762_ _2029_/C hold535/X _1763_/S vssd1 vssd1 vccd1 vccd1 _3042_/D sky130_fd_sc_hd__mux2_1
Xhold517 _3103_/Q vssd1 vssd1 vccd1 vccd1 hold517/X sky130_fd_sc_hd__dlygate4sd3_1
Xhold506 _3333_/Q vssd1 vssd1 vccd1 vccd1 hold506/X sky130_fd_sc_hd__dlygate4sd3_1
X_1693_ _1691_/Y _1693_/B vssd1 vssd1 vccd1 vccd1 _1695_/A sky130_fd_sc_hd__nand2b_2
X_3432_ _3436_/CLK _3432_/D fanout271/X vssd1 vssd1 vccd1 vccd1 _3432_/Q sky130_fd_sc_hd__dfrtp_2
Xhold539 _3234_/Q vssd1 vssd1 vccd1 vccd1 hold539/X sky130_fd_sc_hd__dlygate4sd3_1
Xhold528 _3343_/Q vssd1 vssd1 vccd1 vccd1 hold528/X sky130_fd_sc_hd__dlygate4sd3_1
X_3363_ _2986_/Y _3363_/D load_slew283/X vssd1 vssd1 vccd1 vccd1 _3363_/Q sky130_fd_sc_hd__dfrtp_2
XANTENNA__2887__A1 _2686_/A vssd1 vssd1 vccd1 vccd1 sky130_fd_sc_hd__diode_2
XANTENNA__2887__B2 _2838_/A vssd1 vssd1 vccd1 vccd1 sky130_fd_sc_hd__diode_2
X_3294_ _3331_/CLK _3294_/D load_slew232/X vssd1 vssd1 vccd1 vccd1 _3294_/Q sky130_fd_sc_hd__dfrtp_2
X_2314_ _2311_/A _2309_/A _2311_/B _2308_/A vssd1 vssd1 vccd1 vccd1 _2345_/A sky130_fd_sc_hd__a31o_2
X_2245_ _2245_/A _2296_/B vssd1 vssd1 vccd1 vccd1 _2245_/Y sky130_fd_sc_hd__xnor2_2
XTAP_TAPCELL_ROW_68_747 vssd1 vccd1 sky130_fd_sc_hd__tapvpwrvgnd_1
XFILLER_38_421 vssd1 vssd1 vccd1 vccd1 sky130_fd_sc_hd__fill_2
X_2176_ _2213_/A _2214_/A _2213_/B vssd1 vssd1 vccd1 vccd1 _2179_/B sky130_fd_sc_hd__nand3_2
XANTENNA__2555__S _2559_/S vssd1 vssd1 vccd1 vccd1 sky130_fd_sc_hd__diode_2
XFILLER_65_251 vssd1 vssd1 vccd1 vccd1 sky130_fd_sc_hd__fill_1
XFILLER_53_457 vssd1 vssd1 vccd1 vccd1 sky130_fd_sc_hd__fill_2
XTAP_TAPCELL_ROW_51_603 vssd1 vccd1 sky130_fd_sc_hd__tapvpwrvgnd_1
XFILLER_53_479 vssd1 vccd1 vssd1 vccd1 sky130_ef_sc_hd__decap_40_12
XFILLER_31_37 vssd1 vssd1 vccd1 vccd1 sky130_fd_sc_hd__fill_2
XPHY_EDGE_ROW_1_Right_1 vssd1 vssd1 vccd1 vccd1 sky130_fd_sc_hd__decap_3
XANTENNA__2957__C _2957_/C vssd1 vssd1 vccd1 vccd1 sky130_fd_sc_hd__diode_2
XFILLER_0_225 vssd1 vssd1 vccd1 vccd1 sky130_fd_sc_hd__fill_2
Xteam_02_300 vssd1 vssd1 vccd1 vccd1 team_02_300/HI gpio_out[1] sky130_fd_sc_hd__conb_1
Xteam_02_311 vssd1 vssd1 vccd1 vccd1 team_02_311/HI gpio_out[14] sky130_fd_sc_hd__conb_1
XFILLER_0_269 vssd1 vssd1 vccd1 vccd1 sky130_fd_sc_hd__fill_2
Xteam_02_322 vssd1 vssd1 vccd1 vccd1 team_02_322/HI gpio_out[25] sky130_fd_sc_hd__conb_1
Xteam_02_333 vssd1 vssd1 vccd1 vccd1 gpio_oeb[1] team_02_333/LO sky130_fd_sc_hd__conb_1
Xteam_02_344 vssd1 vssd1 vccd1 vccd1 gpio_oeb[14] team_02_344/LO sky130_fd_sc_hd__conb_1
Xteam_02_355 vssd1 vssd1 vccd1 vccd1 gpio_oeb[25] team_02_355/LO sky130_fd_sc_hd__conb_1
XFILLER_56_34 vssd1 vccd1 vssd1 vccd1 sky130_ef_sc_hd__decap_40_12
XFILLER_29_443 vssd1 vssd1 vccd1 vccd1 sky130_fd_sc_hd__fill_4
XANTENNA__1853__A2 _2002_/B vssd1 vssd1 vccd1 vccd1 sky130_fd_sc_hd__diode_2
XFILLER_72_11 vssd1 vssd1 vccd1 vccd1 sky130_fd_sc_hd__fill_2
XFILLER_24_170 vssd1 vssd1 vccd1 vccd1 sky130_fd_sc_hd__fill_2
XTAP_TAPCELL_ROW_22_360 vssd1 vccd1 sky130_fd_sc_hd__tapvpwrvgnd_1
XFILLER_12_365 vssd1 vssd1 vccd1 vccd1 sky130_fd_sc_hd__fill_4
XANTENNA__1544__S _1546_/S vssd1 vssd1 vccd1 vccd1 sky130_fd_sc_hd__diode_2
XANTENNA__2869__A1 _2686_/A vssd1 vssd1 vccd1 vccd1 sky130_fd_sc_hd__diode_2
XFILLER_79_321 vssd1 vccd1 vssd1 vccd1 sky130_ef_sc_hd__decap_40_12
XFILLER_79_365 vssd1 vssd1 vccd1 vccd1 sky130_fd_sc_hd__fill_4
XFILLER_79_387 vssd1 vssd1 vccd1 vccd1 sky130_fd_sc_hd__fill_2
XFILLER_39_218 vssd1 vssd1 vccd1 vccd1 sky130_fd_sc_hd__fill_4
X_2030_ _2030_/A _2030_/B vssd1 vssd1 vccd1 vccd1 _2032_/A sky130_fd_sc_hd__or2_2
XANTENNA__2097__A2 _2421_/B vssd1 vssd1 vccd1 vccd1 sky130_fd_sc_hd__diode_2
XTAP_TAPCELL_ROW_65_728 vssd1 vccd1 sky130_fd_sc_hd__tapvpwrvgnd_1
XFILLER_62_243 vssd1 vssd1 vccd1 vccd1 sky130_fd_sc_hd__fill_1
X_2932_ _3267_/Q _2971_/A2 _2971_/B1 _3249_/Q _2931_/X vssd1 vssd1 vccd1 vccd1 _2932_/X
+ sky130_fd_sc_hd__a221o_2
XTAP_TAPCELL_ROW_73_794 vssd1 vccd1 sky130_fd_sc_hd__tapvpwrvgnd_1
XFILLER_22_118 vssd1 vssd1 vccd1 vccd1 sky130_fd_sc_hd__fill_1
X_2863_ hold449/X _2528_/B _2864_/S vssd1 vssd1 vccd1 vccd1 _3387_/D sky130_fd_sc_hd__mux2_1
XFILLER_30_151 vssd1 vssd1 vccd1 vccd1 sky130_fd_sc_hd__fill_4
X_2794_ hold616/X _2813_/A1 _2798_/S vssd1 vssd1 vccd1 vccd1 _3301_/D sky130_fd_sc_hd__mux2_1
X_1814_ _1813_/A _1862_/D _1828_/D _1862_/C vssd1 vssd1 vccd1 vccd1 _1815_/B sky130_fd_sc_hd__a22o_2
XANTENNA__2123__B _2352_/C vssd1 vssd1 vccd1 vccd1 sky130_fd_sc_hd__diode_2
X_1745_ _1998_/B hold688/X _1763_/S vssd1 vssd1 vccd1 vccd1 _3025_/D sky130_fd_sc_hd__mux2_1
XANTENNA__1962__B _1962_/B vssd1 vssd1 vccd1 vccd1 sky130_fd_sc_hd__diode_2
Xhold369 _3434_/Q vssd1 vssd1 vccd1 vccd1 _3436_/D sky130_fd_sc_hd__dlygate4sd3_1
X_1676_ hold698/X _1675_/Y _1690_/S vssd1 vssd1 vccd1 vccd1 _3010_/D sky130_fd_sc_hd__mux2_1
X_3415_ _3441_/CLK _3415_/D _2608_/S vssd1 vssd1 vccd1 vccd1 _3415_/Q sky130_fd_sc_hd__dfrtp_2
X_3346_ clkload7/A _3346_/D fanout213/X vssd1 vssd1 vccd1 vccd1 _3346_/Q sky130_fd_sc_hd__dfrtp_2
Xload_slew261 fanout260/X vssd1 vssd1 vccd1 vccd1 load_slew261/X sky130_fd_sc_hd__buf_4
Xload_slew250 fanout249/X vssd1 vssd1 vccd1 vccd1 load_slew250/X sky130_fd_sc_hd__buf_2
X_3277_ _3287_/CLK _3277_/D load_slew232/X vssd1 vssd1 vccd1 vccd1 _3277_/Q sky130_fd_sc_hd__dfrtp_2
Xload_slew283 fanout282/X vssd1 vssd1 vccd1 vccd1 load_slew283/X sky130_fd_sc_hd__clkbuf_4
X_2228_ _2263_/A _2264_/A _2264_/B _2284_/B vssd1 vssd1 vccd1 vccd1 _2228_/X sky130_fd_sc_hd__and4_2
XTAP_TAPCELL_ROW_28_408 vssd1 vccd1 sky130_fd_sc_hd__tapvpwrvgnd_1
XFILLER_38_251 vssd1 vssd1 vccd1 vccd1 sky130_fd_sc_hd__fill_1
X_2159_ _2159_/A _2159_/B vssd1 vssd1 vccd1 vccd1 _2160_/B sky130_fd_sc_hd__xnor2_2
XFILLER_53_210 vssd1 vccd1 vssd1 vccd1 sky130_ef_sc_hd__decap_40_12
XFILLER_26_48 vssd1 vssd1 vccd1 vccd1 sky130_fd_sc_hd__fill_1
XFILLER_53_243 vssd1 vssd1 vccd1 vccd1 sky130_fd_sc_hd__fill_1
XTAP_TAPCELL_ROW_36_474 vssd1 vccd1 sky130_fd_sc_hd__tapvpwrvgnd_1
Xclkbuf_leaf_33_clk clkbuf_3_4__f_clk/X vssd1 vssd1 vccd1 vccd1 _3287_/CLK sky130_fd_sc_hd__clkbuf_8
XPHY_EDGE_ROW_10_Left_90 vssd1 vssd1 vccd1 vccd1 sky130_fd_sc_hd__decap_3
XFILLER_67_55 vssd1 vssd1 vccd1 vccd1 sky130_fd_sc_hd__fill_1
XFILLER_44_243 vssd1 vssd1 vccd1 vccd1 sky130_fd_sc_hd__fill_1
Xclkbuf_leaf_24_clk clkload0/A vssd1 vssd1 vccd1 vccd1 _3388_/CLK sky130_fd_sc_hd__clkbuf_8
XTAP_TAPCELL_ROW_70_764 vssd1 vccd1 sky130_fd_sc_hd__tapvpwrvgnd_1
XANTENNA__1539__S _1546_/S vssd1 vssd1 vccd1 vccd1 sky130_fd_sc_hd__diode_2
XANTENNA__2003__A2 _1970_/B vssd1 vssd1 vccd1 vccd1 sky130_fd_sc_hd__diode_2
XFILLER_8_177 vssd1 vssd1 vccd1 vccd1 sky130_fd_sc_hd__fill_1
XFILLER_66_7 vssd1 vssd1 vccd1 vccd1 sky130_fd_sc_hd__fill_1
X_1530_ _3364_/Q _3365_/Q _1534_/S vssd1 vssd1 vccd1 vccd1 _3365_/D sky130_fd_sc_hd__mux2_1
XFILLER_4_394 vssd1 vssd1 vccd1 vccd1 sky130_fd_sc_hd__fill_2
X_3200_ _3450_/CLK _3200_/D fanout266/X vssd1 vssd1 vccd1 vccd1 _3200_/Q sky130_fd_sc_hd__dfrtp_2
X_3131_ _3132_/CLK _3131_/D load_slew212/X vssd1 vssd1 vccd1 vccd1 _3131_/Q sky130_fd_sc_hd__dfrtp_2
XTAP_TAPCELL_ROW_78_831 vssd1 vccd1 sky130_fd_sc_hd__tapvpwrvgnd_1
XFILLER_79_195 vssd1 vssd1 vccd1 vccd1 sky130_fd_sc_hd__fill_1
XFILLER_67_335 vssd1 vssd1 vccd1 vccd1 sky130_fd_sc_hd__fill_1
X_3062_ clkload6/A _3062_/D vssd1 vssd1 vccd1 vccd1 _3062_/Q sky130_fd_sc_hd__dfxtp_2
X_2013_ _1977_/A _1977_/B _1980_/B vssd1 vssd1 vccd1 vccd1 _2015_/C sky130_fd_sc_hd__o21ai_2
XANTENNA__2833__S _2833_/S vssd1 vssd1 vccd1 vccd1 sky130_fd_sc_hd__diode_2
Xclkbuf_leaf_15_clk clkload4/A vssd1 vssd1 vccd1 vccd1 _3441_/CLK sky130_fd_sc_hd__clkbuf_8
XFILLER_23_449 vssd1 vssd1 vccd1 vccd1 sky130_fd_sc_hd__fill_1
X_2915_ _2964_/B _2964_/C _3211_/Q vssd1 vssd1 vccd1 vccd1 _2915_/X sky130_fd_sc_hd__and3_2
XTAP_TAPCELL_ROW_33_455 vssd1 vccd1 sky130_fd_sc_hd__tapvpwrvgnd_1
X_2846_ hold432/X _2626_/X _2852_/S vssd1 vssd1 vccd1 vccd1 _3350_/D sky130_fd_sc_hd__mux2_1
XFILLER_31_493 vssd1 vssd1 vccd1 vccd1 sky130_fd_sc_hd__fill_1
X_2777_ hold408/X _2815_/A1 _2780_/S vssd1 vssd1 vccd1 vccd1 _3285_/D sky130_fd_sc_hd__mux2_1
X_1728_ _3086_/Q _3069_/Q vssd1 vssd1 vccd1 vccd1 _1729_/B sky130_fd_sc_hd__nand2_2
XFILLER_2_309 vssd1 vssd1 vccd1 vccd1 sky130_fd_sc_hd__fill_1
XANTENNA__2950__B1 _2971_/B1 vssd1 vssd1 vccd1 vccd1 sky130_fd_sc_hd__diode_2
X_1659_ _1646_/A _1642_/Y _1646_/B _1651_/B _1644_/B vssd1 vssd1 vccd1 vccd1 _1660_/B
+ sky130_fd_sc_hd__o311a_2
XANTENNA_fanout191_X _2025_/A vssd1 vssd1 vccd1 vccd1 sky130_fd_sc_hd__diode_2
XANTENNA_fanout289_X fanout289/X vssd1 vssd1 vccd1 vccd1 sky130_fd_sc_hd__diode_2
X_3329_ _3349_/CLK _3329_/D fanout242/X vssd1 vssd1 vccd1 vccd1 _3329_/Q sky130_fd_sc_hd__dfrtp_2
XANTENNA__2028__B _2029_/D vssd1 vssd1 vccd1 vccd1 sky130_fd_sc_hd__diode_2
XANTENNA__2970__C _2970_/C vssd1 vssd1 vccd1 vccd1 sky130_fd_sc_hd__diode_2
XFILLER_53_57 vssd1 vssd1 vccd1 vccd1 sky130_fd_sc_hd__fill_8
XFILLER_22_493 vssd1 vssd1 vccd1 vccd1 sky130_fd_sc_hd__fill_1
XFILLER_5_169 vssd1 vccd1 vssd1 vccd1 sky130_ef_sc_hd__decap_40_12
XFILLER_78_65 vssd1 vssd1 vccd1 vccd1 sky130_fd_sc_hd__fill_1
XFILLER_49_302 vssd1 vccd1 vssd1 vccd1 sky130_ef_sc_hd__decap_40_12
XTAP_TAPCELL_ROW_75_812 vssd1 vccd1 sky130_fd_sc_hd__tapvpwrvgnd_1
XTAP_TAPCELL_ROW_47_569 vssd1 vccd1 sky130_fd_sc_hd__tapvpwrvgnd_1
XANTENNA__2653__S _2666_/S vssd1 vssd1 vccd1 vccd1 sky130_fd_sc_hd__diode_2
X_2700_ hold485/X _2814_/A1 _2700_/S vssd1 vssd1 vccd1 vccd1 _3212_/D sky130_fd_sc_hd__mux2_1
XTAP_TAPCELL_ROW_30_425 vssd1 vccd1 sky130_fd_sc_hd__tapvpwrvgnd_1
XFILLER_13_493 vssd1 vssd1 vccd1 vccd1 sky130_fd_sc_hd__fill_1
XANTENNA__2104__D _2284_/B vssd1 vssd1 vccd1 vccd1 sky130_fd_sc_hd__diode_2
XANTENNA__2889__A _2926_/B vssd1 vssd1 vccd1 vccd1 sky130_fd_sc_hd__diode_2
X_2631_ hold596/X _2848_/A1 _2645_/S vssd1 vssd1 vccd1 vccd1 _3154_/D sky130_fd_sc_hd__mux2_1
X_2562_ _1569_/D _2465_/X _2560_/Y hold717/X vssd1 vssd1 vccd1 vccd1 _3115_/D sky130_fd_sc_hd__a22o_2
XFILLER_57_3 vssd1 vccd1 vssd1 vccd1 sky130_ef_sc_hd__decap_40_12
XANTENNA__2932__B1 _2971_/B1 vssd1 vssd1 vccd1 vccd1 sky130_fd_sc_hd__diode_2
X_1513_ _3379_/Q _1515_/A _1512_/Y vssd1 vssd1 vccd1 vccd1 _3379_/D sky130_fd_sc_hd__o21a_2
X_2493_ _2962_/A1 _3149_/Q _3293_/Q _2961_/A1 vssd1 vssd1 vccd1 vccd1 _2494_/B sky130_fd_sc_hd__a22o_2
Xclkbuf_leaf_4_clk clkload1/A vssd1 vssd1 vccd1 vccd1 _3119_/CLK sky130_fd_sc_hd__clkbuf_8
XFILLER_4_62 vssd1 vccd1 vssd1 vccd1 sky130_ef_sc_hd__decap_40_12
XANTENNA__2828__S _2833_/S vssd1 vssd1 vccd1 vccd1 sky130_fd_sc_hd__diode_2
X_3114_ _3119_/CLK _3114_/D fanout223/X vssd1 vssd1 vccd1 vccd1 _3114_/Q sky130_fd_sc_hd__dfrtp_2
X_3045_ clkload6/A _3045_/D fanout201/X vssd1 vssd1 vccd1 vccd1 _3045_/Q sky130_fd_sc_hd__dfrtp_2
XFILLER_63_382 vssd1 vssd1 vccd1 vccd1 sky130_fd_sc_hd__fill_1
XANTENNA_fanout249_A fanout251/X vssd1 vssd1 vccd1 vccd1 sky130_fd_sc_hd__diode_2
XFILLER_23_27 vssd1 vssd1 vccd1 vccd1 sky130_fd_sc_hd__fill_1
X_2829_ hold572/X _2848_/A1 _2833_/S vssd1 vssd1 vccd1 vccd1 _3334_/D sky130_fd_sc_hd__mux2_1
XANTENNA__2738__S _2738_/S vssd1 vssd1 vccd1 vccd1 sky130_fd_sc_hd__diode_2
XFILLER_73_113 vssd1 vssd1 vccd1 vccd1 sky130_fd_sc_hd__fill_4
XFILLER_73_102 vssd1 vssd1 vccd1 vccd1 sky130_fd_sc_hd__fill_8
XTAP_TAPCELL_ROW_1_183 vssd1 vccd1 sky130_fd_sc_hd__tapvpwrvgnd_1
XFILLER_64_89 vssd1 vssd1 vccd1 vccd1 sky130_fd_sc_hd__fill_2
XFILLER_14_268 vssd1 vssd1 vccd1 vccd1 sky130_fd_sc_hd__fill_1
Xfanout50 _2620_/X vssd1 vssd1 vccd1 vccd1 _2805_/A1 sky130_fd_sc_hd__clkdlybuf4s25_1
Xfanout61 _2646_/B vssd1 vssd1 vccd1 vccd1 _2644_/B sky130_fd_sc_hd__clkdlybuf4s25_1
Xfanout72 _2800_/B vssd1 vssd1 vccd1 vccd1 _2456_/B1 sky130_fd_sc_hd__clkdlybuf4s25_1
Xfanout83 _2819_/B vssd1 vssd1 vccd1 vccd1 _2927_/A2 sky130_fd_sc_hd__clkdlybuf4s25_1
XANTENNA__2205__C _2399_/A vssd1 vssd1 vccd1 vccd1 sky130_fd_sc_hd__diode_2
Xfanout94 _2923_/B2 vssd1 vssd1 vccd1 vccd1 _2520_/A sky130_fd_sc_hd__clkdlybuf4s25_1
XANTENNA__2502__A _2540_/A vssd1 vssd1 vccd1 vccd1 sky130_fd_sc_hd__diode_2
XTAP_TAPCELL_ROW_9_250 vssd1 vccd1 sky130_fd_sc_hd__tapvpwrvgnd_1
XFILLER_49_121 vssd1 vssd1 vccd1 vccd1 sky130_fd_sc_hd__fill_2
XFILLER_49_110 vssd1 vssd1 vccd1 vccd1 sky130_fd_sc_hd__fill_2
Xclkbuf_3_7__f_clk clkbuf_0_clk/X vssd1 vssd1 vccd1 vccd1 clkload5/A sky130_fd_sc_hd__clkbuf_16
XANTENNA__2891__B _2926_/C vssd1 vssd1 vccd1 vccd1 sky130_fd_sc_hd__diode_2
XANTENNA_clkbuf_leaf_0_clk_A clkbuf_leaf_2_clk/A vssd1 vssd1 vccd1 vccd1 sky130_fd_sc_hd__diode_2
XANTENNA__3048__RESET_B fanout228/X vssd1 vssd1 vccd1 vccd1 sky130_fd_sc_hd__diode_2
XFILLER_60_352 vssd1 vssd1 vccd1 vccd1 sky130_fd_sc_hd__fill_1
XFILLER_20_205 vssd1 vssd1 vccd1 vccd1 sky130_fd_sc_hd__fill_2
X_1993_ hold679/X _1992_/Y _1993_/S vssd1 vssd1 vccd1 vccd1 _3063_/D sky130_fd_sc_hd__mux2_1
XTAP_TAPCELL_ROW_15_296 vssd1 vccd1 sky130_fd_sc_hd__tapvpwrvgnd_1
X_2614_ _3400_/Q _2610_/A _2646_/B _3123_/Q vssd1 vssd1 vccd1 vccd1 _2614_/X sky130_fd_sc_hd__a22o_2
XANTENNA__2905__B1 _2971_/B1 vssd1 vssd1 vccd1 vccd1 sky130_fd_sc_hd__diode_2
XANTENNA__2131__B _2347_/A vssd1 vssd1 vccd1 vccd1 sky130_fd_sc_hd__diode_2
X_2545_ _2550_/A1 _2477_/X _2550_/B1 hold632/X vssd1 vssd1 vccd1 vccd1 _3100_/D sky130_fd_sc_hd__a22o_2
X_2476_ _3219_/Q _2923_/A2 _2474_/X _2475_/X vssd1 vssd1 vccd1 vccd1 _2477_/B sky130_fd_sc_hd__a211o_2
XANTENNA__1970__B _1970_/B vssd1 vssd1 vccd1 vccd1 sky130_fd_sc_hd__diode_2
XANTENNA__2558__S _2559_/S vssd1 vssd1 vccd1 vccd1 sky130_fd_sc_hd__diode_2
XANTENNA_fanout199_A _1805_/A vssd1 vssd1 vccd1 vccd1 sky130_fd_sc_hd__diode_2
XFILLER_68_485 vssd1 vssd1 vccd1 vccd1 sky130_fd_sc_hd__fill_4
XFILLER_18_27 vssd1 vssd1 vccd1 vccd1 sky130_fd_sc_hd__fill_1
X_3028_ _3112_/CLK _3028_/D load_slew202/X vssd1 vssd1 vccd1 vccd1 _3028_/Q sky130_fd_sc_hd__dfrtp_2
XFILLER_55_179 vssd1 vssd1 vccd1 vccd1 sky130_fd_sc_hd__fill_4
XANTENNA__3471__RESET_B fanout251/X vssd1 vssd1 vccd1 vccd1 sky130_fd_sc_hd__diode_2
XFILLER_70_138 vssd1 vssd1 vccd1 vccd1 sky130_fd_sc_hd__fill_2
XANTENNA__2025__C _2049_/B vssd1 vssd1 vccd1 vccd1 sky130_fd_sc_hd__diode_2
Xclkload3 clkload3/A vssd1 vssd1 vccd1 vccd1 clkload3/X sky130_fd_sc_hd__clkbuf_8
XANTENNA__2322__A _2347_/A vssd1 vssd1 vccd1 vccd1 sky130_fd_sc_hd__diode_2
XFILLER_59_34 vssd1 vssd1 vccd1 vccd1 sky130_fd_sc_hd__fill_1
XFILLER_3_459 vssd1 vssd1 vccd1 vccd1 sky130_fd_sc_hd__fill_1
XTAP_TAPCELL_ROW_6_220 vssd1 vccd1 sky130_fd_sc_hd__tapvpwrvgnd_1
Xfanout251 fanout290/X vssd1 vssd1 vccd1 vccd1 fanout251/X sky130_fd_sc_hd__clkdlybuf4s25_1
Xfanout262 fanout265/X vssd1 vssd1 vccd1 vccd1 fanout262/X sky130_fd_sc_hd__clkdlybuf4s25_1
XFILLER_75_11 vssd1 vssd1 vccd1 vccd1 sky130_fd_sc_hd__fill_2
Xfanout284 fanout289/X vssd1 vssd1 vccd1 vccd1 fanout284/X sky130_fd_sc_hd__clkdlybuf4s25_1
XANTENNA__1883__B1 _2002_/B vssd1 vssd1 vccd1 vccd1 sky130_fd_sc_hd__diode_2
XTAP_TAPCELL_ROW_57_653 vssd1 vccd1 sky130_fd_sc_hd__tapvpwrvgnd_1
XFILLER_74_477 vssd1 vssd1 vccd1 vccd1 sky130_fd_sc_hd__fill_8
XANTENNA__1635__B1 _1690_/S vssd1 vssd1 vccd1 vccd1 sky130_fd_sc_hd__diode_2
XFILLER_42_352 vssd1 vssd1 vccd1 vccd1 sky130_fd_sc_hd__fill_1
XFILLER_24_81 vssd1 vssd1 vccd1 vccd1 sky130_fd_sc_hd__fill_2
XTAP_TAPCELL_ROW_12_277 vssd1 vccd1 sky130_fd_sc_hd__tapvpwrvgnd_1
XFILLER_6_253 vssd1 vssd1 vccd1 vccd1 sky130_fd_sc_hd__fill_2
X_2330_ _2330_/A _2330_/B _2330_/C vssd1 vssd1 vccd1 vccd1 _2360_/A sky130_fd_sc_hd__and3_2
X_2261_ _2261_/A _2261_/B _2261_/C vssd1 vssd1 vccd1 vccd1 _2262_/B sky130_fd_sc_hd__nand3_2
XFILLER_69_238 vssd1 vssd1 vccd1 vccd1 sky130_fd_sc_hd__fill_4
X_2192_ _2193_/A _2193_/B _2193_/C vssd1 vssd1 vccd1 vccd1 _2195_/B sky130_fd_sc_hd__o21ai_2
XFILLER_65_444 vssd1 vssd1 vccd1 vccd1 sky130_fd_sc_hd__fill_2
XANTENNA__2418__A2 _2091_/B vssd1 vssd1 vccd1 vccd1 sky130_fd_sc_hd__diode_2
XFILLER_25_308 vssd1 vssd1 vccd1 vccd1 sky130_fd_sc_hd__fill_4
XFILLER_60_182 vssd1 vssd1 vccd1 vccd1 sky130_fd_sc_hd__fill_1
XANTENNA__2841__S _2852_/S vssd1 vssd1 vccd1 vccd1 sky130_fd_sc_hd__diode_2
X_1976_ _1977_/A _1977_/B vssd1 vssd1 vccd1 vccd1 _2015_/A sky130_fd_sc_hd__nand2_2
XANTENNA_fanout114_A _2972_/A1 vssd1 vssd1 vccd1 vccd1 sky130_fd_sc_hd__diode_2
XFILLER_20_17 vssd1 vssd1 vccd1 vccd1 sky130_fd_sc_hd__fill_1
X_2528_ _2540_/A _2528_/B vssd1 vssd1 vccd1 vccd1 _2528_/X sky130_fd_sc_hd__and2_2
XFILLER_0_429 vssd1 vssd1 vccd1 vccd1 sky130_fd_sc_hd__fill_2
X_2459_ _3182_/Q _2894_/A2 _2894_/B1 _3164_/Q _2458_/X vssd1 vssd1 vccd1 vccd1 _2459_/X
+ sky130_fd_sc_hd__a221o_2
XTAP_TAPCELL_ROW_3_201 vssd1 vccd1 sky130_fd_sc_hd__tapvpwrvgnd_1
XFILLER_28_146 vssd1 vssd1 vccd1 vccd1 sky130_fd_sc_hd__fill_1
XFILLER_45_36 vssd1 vssd1 vccd1 vccd1 sky130_fd_sc_hd__fill_4
XTAP_TAPCELL_ROW_54_634 vssd1 vccd1 sky130_fd_sc_hd__tapvpwrvgnd_1
XFILLER_71_458 vssd1 vccd1 vssd1 vccd1 sky130_ef_sc_hd__decap_40_12
XANTENNA__2751__S _2757_/S vssd1 vssd1 vccd1 vccd1 sky130_fd_sc_hd__diode_2
XFILLER_6_19 vssd1 vssd1 vccd1 vccd1 sky130_fd_sc_hd__fill_1
XFILLER_47_433 vssd1 vssd1 vccd1 vccd1 sky130_fd_sc_hd__fill_2
XFILLER_47_488 vssd1 vssd1 vccd1 vccd1 sky130_fd_sc_hd__fill_4
XFILLER_19_179 vssd1 vssd1 vccd1 vccd1 sky130_fd_sc_hd__fill_2
XTAP_TAPCELL_ROW_17_314 vssd1 vccd1 sky130_fd_sc_hd__tapvpwrvgnd_1
XFILLER_74_296 vssd1 vssd1 vccd1 vccd1 sky130_fd_sc_hd__fill_2
XANTENNA__2227__A _3046_/Q vssd1 vssd1 vccd1 vccd1 sky130_fd_sc_hd__diode_2
XFILLER_15_363 vssd1 vssd1 vccd1 vccd1 sky130_fd_sc_hd__fill_2
XFILLER_42_182 vssd1 vssd1 vccd1 vccd1 sky130_fd_sc_hd__fill_1
XFILLER_42_171 vssd1 vssd1 vccd1 vccd1 sky130_fd_sc_hd__fill_2
XFILLER_15_385 vssd1 vssd1 vccd1 vccd1 sky130_fd_sc_hd__fill_1
XANTENNA__2661__S _2666_/S vssd1 vssd1 vccd1 vccd1 sky130_fd_sc_hd__diode_2
X_1830_ _1892_/A _1830_/B vssd1 vssd1 vccd1 vccd1 _1832_/A sky130_fd_sc_hd__nand2_2
X_1761_ _2004_/B hold483/X _1763_/S vssd1 vssd1 vccd1 vccd1 _3041_/D sky130_fd_sc_hd__mux2_1
Xhold518 _3219_/Q vssd1 vssd1 vccd1 vccd1 hold518/X sky130_fd_sc_hd__dlygate4sd3_1
Xhold507 _3225_/Q vssd1 vssd1 vccd1 vccd1 hold507/X sky130_fd_sc_hd__dlygate4sd3_1
X_1692_ _3080_/Q _3063_/Q vssd1 vssd1 vccd1 vccd1 _1693_/B sky130_fd_sc_hd__nand2_2
X_3431_ _3431_/CLK _3431_/D fanout271/X vssd1 vssd1 vccd1 vccd1 _3431_/Q sky130_fd_sc_hd__dfrtp_2
Xhold529 _3342_/Q vssd1 vssd1 vccd1 vccd1 hold529/X sky130_fd_sc_hd__dlygate4sd3_1
X_3362_ _2985_/Y _3362_/D load_slew283/X vssd1 vssd1 vccd1 vccd1 _3362_/Q sky130_fd_sc_hd__dfrtp_2
X_2313_ hold534/X _2312_/Y _2313_/S vssd1 vssd1 vccd1 vccd1 _3080_/D sky130_fd_sc_hd__mux2_1
X_3293_ _3331_/CLK _3293_/D load_slew232/X vssd1 vssd1 vccd1 vccd1 _3293_/Q sky130_fd_sc_hd__dfrtp_2
X_2244_ _2233_/A _2228_/X _2230_/B vssd1 vssd1 vccd1 vccd1 _2296_/B sky130_fd_sc_hd__o21ai_2
XANTENNA__2836__S _2837_/S vssd1 vssd1 vccd1 vccd1 sky130_fd_sc_hd__diode_2
X_2175_ _2175_/A _2211_/A _2175_/C _2175_/D vssd1 vssd1 vccd1 vccd1 _2213_/B sky130_fd_sc_hd__nand4_2
XTAP_TAPCELL_ROW_68_748 vssd1 vccd1 sky130_fd_sc_hd__tapvpwrvgnd_1
XFILLER_65_285 vssd1 vssd1 vccd1 vccd1 sky130_fd_sc_hd__fill_1
XFILLER_53_447 vssd1 vssd1 vccd1 vccd1 sky130_fd_sc_hd__fill_1
XTAP_TAPCELL_ROW_51_604 vssd1 vccd1 sky130_fd_sc_hd__tapvpwrvgnd_1
XANTENNA_fanout231_A fanout242/X vssd1 vssd1 vccd1 vccd1 sky130_fd_sc_hd__diode_2
XANTENNA__2024__B1 _2049_/B vssd1 vssd1 vccd1 vccd1 sky130_fd_sc_hd__diode_2
X_1959_ _1959_/A _1959_/B vssd1 vssd1 vccd1 vccd1 _1989_/A sky130_fd_sc_hd__or2_2
XANTENNA_fanout117_X _2942_/B2 vssd1 vssd1 vccd1 vccd1 sky130_fd_sc_hd__diode_2
XANTENNA__2878__A2 _2894_/A2 vssd1 vssd1 vccd1 vccd1 sky130_fd_sc_hd__diode_2
Xteam_02_301 vssd1 vssd1 vccd1 vccd1 team_02_301/HI gpio_out[2] sky130_fd_sc_hd__conb_1
XFILLER_0_248 vssd1 vssd1 vccd1 vccd1 sky130_fd_sc_hd__fill_4
Xteam_02_312 vssd1 vssd1 vccd1 vccd1 team_02_312/HI gpio_out[15] sky130_fd_sc_hd__conb_1
Xteam_02_323 vssd1 vssd1 vccd1 vccd1 team_02_323/HI gpio_out[26] sky130_fd_sc_hd__conb_1
Xteam_02_334 vssd1 vssd1 vccd1 vccd1 gpio_oeb[2] team_02_334/LO sky130_fd_sc_hd__conb_1
XANTENNA__2746__S _2757_/S vssd1 vssd1 vccd1 vccd1 sky130_fd_sc_hd__diode_2
Xteam_02_345 vssd1 vssd1 vccd1 vccd1 gpio_oeb[15] team_02_345/LO sky130_fd_sc_hd__conb_1
Xteam_02_356 vssd1 vssd1 vccd1 vccd1 gpio_oeb[26] team_02_356/LO sky130_fd_sc_hd__conb_1
XFILLER_56_46 vssd1 vssd1 vccd1 vccd1 sky130_fd_sc_hd__fill_4
XFILLER_71_222 vssd1 vssd1 vccd1 vccd1 sky130_fd_sc_hd__fill_2
XFILLER_71_266 vssd1 vccd1 vssd1 vccd1 sky130_ef_sc_hd__decap_40_12
XFILLER_44_458 vssd1 vssd1 vccd1 vccd1 sky130_fd_sc_hd__fill_1
XFILLER_12_300 vssd1 vssd1 vccd1 vccd1 sky130_fd_sc_hd__fill_2
XANTENNA_clkbuf_leaf_40_clk_A clkload0/A vssd1 vssd1 vccd1 vccd1 sky130_fd_sc_hd__diode_2
XFILLER_72_89 vssd1 vssd1 vccd1 vccd1 sky130_fd_sc_hd__fill_2
XTAP_TAPCELL_ROW_22_361 vssd1 vccd1 sky130_fd_sc_hd__tapvpwrvgnd_1
XANTENNA__2566__A1 _1569_/D vssd1 vssd1 vccd1 vccd1 sky130_fd_sc_hd__diode_2
XANTENNA__1825__S _1993_/S vssd1 vssd1 vccd1 vccd1 sky130_fd_sc_hd__diode_2
XANTENNA__3118__CLK _3423_/CLK vssd1 vssd1 vccd1 vccd1 sky130_fd_sc_hd__diode_2
XFILLER_79_333 vssd1 vssd1 vccd1 vccd1 sky130_fd_sc_hd__fill_2
XFILLER_79_377 vssd1 vssd1 vccd1 vccd1 sky130_fd_sc_hd__fill_1
XANTENNA__2656__S _2662_/S vssd1 vssd1 vccd1 vccd1 sky130_fd_sc_hd__diode_2
XFILLER_35_447 vssd1 vssd1 vccd1 vccd1 sky130_fd_sc_hd__fill_1
X_2931_ _3285_/Q _2970_/B _2970_/C vssd1 vssd1 vccd1 vccd1 _2931_/X sky130_fd_sc_hd__and3_2
XTAP_TAPCELL_ROW_73_795 vssd1 vccd1 sky130_fd_sc_hd__tapvpwrvgnd_1
Xclkbuf_0_clk clk vssd1 vssd1 vccd1 vccd1 clkbuf_0_clk/X sky130_fd_sc_hd__clkbuf_16
X_2862_ hold444/X _2515_/B _2864_/S vssd1 vssd1 vccd1 vccd1 _3386_/D sky130_fd_sc_hd__mux2_1
XANTENNA__2006__B1 _2029_/C vssd1 vssd1 vccd1 vccd1 sky130_fd_sc_hd__diode_2
XANTENNA__2557__A1 _2515_/X vssd1 vssd1 vccd1 vccd1 sky130_fd_sc_hd__diode_2
X_2793_ hold543/X _2850_/A1 _2798_/S vssd1 vssd1 vccd1 vccd1 _3300_/D sky130_fd_sc_hd__mux2_1
X_1813_ _1813_/A _1862_/C _1862_/D _1828_/D vssd1 vssd1 vccd1 vccd1 _1813_/X sky130_fd_sc_hd__and4_2
X_1744_ _1862_/C hold708/X _1763_/S vssd1 vssd1 vccd1 vccd1 _3024_/D sky130_fd_sc_hd__mux2_1
XFILLER_7_73 vssd1 vssd1 vccd1 vccd1 sky130_fd_sc_hd__fill_8
XANTENNA__1962__C _1998_/B vssd1 vssd1 vccd1 vccd1 sky130_fd_sc_hd__diode_2
X_3414_ _3429_/CLK _3414_/D load_slew225/X vssd1 vssd1 vccd1 vccd1 _3414_/Q sky130_fd_sc_hd__dfrtp_2
X_1675_ _1675_/A _1675_/B vssd1 vssd1 vccd1 vccd1 _1675_/Y sky130_fd_sc_hd__xnor2_2
XPHY_EDGE_ROW_15_Right_15 vssd1 vssd1 vccd1 vccd1 sky130_fd_sc_hd__decap_3
X_3345_ _3431_/CLK _3345_/D fanout266/X vssd1 vssd1 vccd1 vccd1 _3345_/Q sky130_fd_sc_hd__dfrtp_2
Xload_slew240 fanout239/X vssd1 vssd1 vccd1 vccd1 load_slew240/X sky130_fd_sc_hd__buf_4
XANTENNA_clkbuf_3_6__f_clk_X clkload4/A vssd1 vssd1 vccd1 vccd1 sky130_fd_sc_hd__diode_2
X_3276_ _3386_/CLK _3276_/D load_slew237/X vssd1 vssd1 vccd1 vccd1 _3276_/Q sky130_fd_sc_hd__dfrtp_2
Xload_slew273 fanout272/X vssd1 vssd1 vccd1 vccd1 load_slew273/X sky130_fd_sc_hd__clkbuf_4
Xload_slew295 _3003_/A vssd1 vssd1 vccd1 vccd1 _2997_/A sky130_fd_sc_hd__buf_2
X_2227_ _3046_/Q _2399_/B vssd1 vssd1 vccd1 vccd1 _2232_/A sky130_fd_sc_hd__nand2_2
XANTENNA_fanout279_A fanout289/X vssd1 vssd1 vccd1 vccd1 sky130_fd_sc_hd__diode_2
XTAP_TAPCELL_ROW_28_409 vssd1 vccd1 sky130_fd_sc_hd__tapvpwrvgnd_1
X_2158_ _2205_/A _2157_/X _2175_/A vssd1 vssd1 vccd1 vccd1 _2159_/B sky130_fd_sc_hd__a21bo_2
XFILLER_26_27 vssd1 vssd1 vccd1 vccd1 sky130_fd_sc_hd__fill_1
X_2089_ _2089_/A _2089_/B _2089_/C vssd1 vssd1 vccd1 vccd1 _2089_/Y sky130_fd_sc_hd__nand3_2
XPHY_EDGE_ROW_24_Right_24 vssd1 vssd1 vccd1 vccd1 sky130_fd_sc_hd__decap_3
XFILLER_41_406 vssd1 vssd1 vccd1 vccd1 sky130_fd_sc_hd__fill_1
XTAP_TAPCELL_ROW_36_475 vssd1 vccd1 sky130_fd_sc_hd__tapvpwrvgnd_1
XANTENNA__2548__A1 _2550_/A1 vssd1 vssd1 vccd1 vccd1 sky130_fd_sc_hd__diode_2
XFILLER_5_329 vssd1 vssd1 vccd1 vccd1 sky130_fd_sc_hd__fill_4
XPHY_EDGE_ROW_33_Right_33 vssd1 vssd1 vccd1 vccd1 sky130_fd_sc_hd__decap_3
XANTENNA_fanout94_A _2923_/B2 vssd1 vssd1 vccd1 vccd1 sky130_fd_sc_hd__diode_2
XANTENNA__3410__CLK _3423_/CLK vssd1 vssd1 vccd1 vccd1 sky130_fd_sc_hd__diode_2
XFILLER_76_347 vssd1 vssd1 vccd1 vccd1 sky130_fd_sc_hd__fill_8
XANTENNA__2484__B1 _2648_/B vssd1 vssd1 vccd1 vccd1 sky130_fd_sc_hd__diode_2
XPHY_EDGE_ROW_42_Right_42 vssd1 vssd1 vccd1 vccd1 sky130_fd_sc_hd__decap_3
XTAP_TAPCELL_ROW_70_765 vssd1 vccd1 sky130_fd_sc_hd__tapvpwrvgnd_1
XFILLER_12_141 vssd1 vssd1 vccd1 vccd1 sky130_fd_sc_hd__fill_2
XPHY_EDGE_ROW_51_Right_51 vssd1 vssd1 vccd1 vccd1 sky130_fd_sc_hd__decap_3
XFILLER_8_189 vssd1 vssd1 vccd1 vccd1 sky130_fd_sc_hd__fill_4
XFILLER_59_7 vssd1 vssd1 vccd1 vccd1 sky130_fd_sc_hd__fill_2
XFILLER_4_362 vssd1 vssd1 vccd1 vccd1 sky130_fd_sc_hd__fill_2
XFILLER_79_141 vssd1 vccd1 vssd1 vccd1 sky130_ef_sc_hd__decap_40_12
X_3130_ _3199_/CLK _3130_/D wire222/X vssd1 vssd1 vccd1 vccd1 _3130_/Q sky130_fd_sc_hd__dfrtp_2
XTAP_TAPCELL_ROW_78_832 vssd1 vccd1 sky130_fd_sc_hd__tapvpwrvgnd_1
X_3061_ _3204_/CLK _3061_/D vssd1 vssd1 vccd1 vccd1 _3061_/Q sky130_fd_sc_hd__dfxtp_2
XPHY_EDGE_ROW_60_Right_60 vssd1 vssd1 vccd1 vccd1 sky130_fd_sc_hd__decap_3
X_2012_ _2012_/A _2012_/B vssd1 vssd1 vccd1 vccd1 _2015_/B sky130_fd_sc_hd__xnor2_2
XFILLER_75_391 vssd1 vssd1 vccd1 vccd1 sky130_fd_sc_hd__fill_1
XFILLER_50_247 vssd1 vssd1 vccd1 vccd1 sky130_fd_sc_hd__fill_2
X_2914_ _3265_/Q _2968_/A2 _2968_/B1 _3247_/Q _2913_/X vssd1 vssd1 vccd1 vccd1 _2914_/X
+ sky130_fd_sc_hd__a221o_2
XTAP_TAPCELL_ROW_33_456 vssd1 vccd1 sky130_fd_sc_hd__tapvpwrvgnd_1
X_2845_ hold426/X _2845_/A1 _2856_/S vssd1 vssd1 vccd1 vccd1 _3349_/D sky130_fd_sc_hd__mux2_1
XFILLER_12_29 vssd1 vssd1 vccd1 vccd1 sky130_fd_sc_hd__fill_4
X_2776_ hold421/X _2814_/A1 _2776_/S vssd1 vssd1 vccd1 vccd1 _3284_/D sky130_fd_sc_hd__mux2_1
X_1727_ _3086_/Q _3069_/Q vssd1 vssd1 vccd1 vccd1 _1727_/Y sky130_fd_sc_hd__nor2_2
X_1658_ _3075_/Q _3058_/Q vssd1 vssd1 vccd1 vccd1 _1658_/Y sky130_fd_sc_hd__nand2_2
X_3328_ _3386_/CLK _3328_/D fanout238/X vssd1 vssd1 vccd1 vccd1 _3328_/Q sky130_fd_sc_hd__dfrtp_2
X_1589_ _3427_/Q _2590_/A hold373/X vssd1 vssd1 vccd1 vccd1 _3427_/D sky130_fd_sc_hd__a21o_2
X_3259_ _3287_/CLK _3259_/D load_slew234/X vssd1 vssd1 vccd1 vccd1 _3259_/Q sky130_fd_sc_hd__dfrtp_2
XFILLER_37_37 vssd1 vssd1 vccd1 vccd1 sky130_fd_sc_hd__fill_2
XANTENNA__2466__B1 _2465_/X vssd1 vssd1 vccd1 vccd1 sky130_fd_sc_hd__diode_2
XFILLER_53_36 vssd1 vssd1 vccd1 vccd1 sky130_fd_sc_hd__fill_1
XFILLER_26_266 vssd1 vssd1 vccd1 vccd1 sky130_fd_sc_hd__fill_1
XANTENNA__2769__A1 _2624_/X vssd1 vssd1 vccd1 vccd1 sky130_fd_sc_hd__diode_2
XFILLER_53_69 vssd1 vssd1 vccd1 vccd1 sky130_fd_sc_hd__fill_2
XANTENNA_fanout97_X _2091_/B vssd1 vssd1 vccd1 vccd1 sky130_fd_sc_hd__diode_2
Xhold690 _3061_/Q vssd1 vssd1 vccd1 vccd1 hold690/X sky130_fd_sc_hd__dlygate4sd3_1
XFILLER_78_99 vssd1 vccd1 vssd1 vccd1 sky130_ef_sc_hd__decap_40_12
XFILLER_49_314 vssd1 vssd1 vccd1 vccd1 sky130_fd_sc_hd__fill_8
XFILLER_76_122 vssd1 vssd1 vccd1 vccd1 sky130_fd_sc_hd__fill_8
XFILLER_49_347 vssd1 vssd1 vccd1 vccd1 sky130_fd_sc_hd__fill_1
XTAP_TAPCELL_ROW_75_813 vssd1 vccd1 sky130_fd_sc_hd__tapvpwrvgnd_1
XFILLER_64_306 vssd1 vssd1 vccd1 vccd1 sky130_fd_sc_hd__fill_2
XFILLER_57_391 vssd1 vssd1 vccd1 vccd1 sky130_fd_sc_hd__fill_1
XFILLER_17_277 vssd1 vssd1 vccd1 vccd1 sky130_fd_sc_hd__fill_2
XTAP_TAPCELL_ROW_30_426 vssd1 vccd1 sky130_fd_sc_hd__tapvpwrvgnd_1
XANTENNA__3456__CLK _3463_/CLK vssd1 vssd1 vccd1 vccd1 sky130_fd_sc_hd__diode_2
X_2630_ _3131_/Q _2644_/B vssd1 vssd1 vccd1 vccd1 _2630_/X sky130_fd_sc_hd__and2_2
XANTENNA__2889__B _2926_/C vssd1 vssd1 vccd1 vccd1 sky130_fd_sc_hd__diode_2
X_2561_ _1569_/D _2453_/X _2560_/Y hold561/X vssd1 vssd1 vccd1 vccd1 _3114_/D sky130_fd_sc_hd__a22o_2
X_2492_ _3329_/Q _2960_/A2 wire66/X _3311_/Q _2491_/X vssd1 vssd1 vccd1 vccd1 _2492_/X
+ sky130_fd_sc_hd__a221o_2
X_1512_ _3379_/Q _1515_/A _3442_/D vssd1 vssd1 vccd1 vccd1 _1512_/Y sky130_fd_sc_hd__a21oi_2
XFILLER_4_85 vssd1 vssd1 vccd1 vccd1 sky130_fd_sc_hd__fill_1
XFILLER_4_74 vssd1 vssd1 vccd1 vccd1 sky130_fd_sc_hd__fill_2
XFILLER_4_96 vssd1 vssd1 vccd1 vccd1 sky130_fd_sc_hd__fill_1
X_3113_ clkload6/A _3113_/D _1775_/B vssd1 vssd1 vccd1 vccd1 _3113_/Q sky130_fd_sc_hd__dfrtp_2
XANTENNA__2448__B1 _2648_/B vssd1 vssd1 vccd1 vccd1 sky130_fd_sc_hd__diode_2
X_3044_ _3112_/CLK _3044_/D fanout201/X vssd1 vssd1 vccd1 vccd1 _3044_/Q sky130_fd_sc_hd__dfrtp_2
XANTENNA__2844__S _2856_/S vssd1 vssd1 vccd1 vccd1 sky130_fd_sc_hd__diode_2
XFILLER_70_309 vssd1 vssd1 vccd1 vccd1 sky130_fd_sc_hd__fill_8
XFILLER_23_225 vssd1 vssd1 vccd1 vccd1 sky130_fd_sc_hd__fill_1
XANTENNA__2620__B1 _2646_/B vssd1 vssd1 vccd1 vccd1 sky130_fd_sc_hd__diode_2
X_2828_ hold506/X _2628_/X _2833_/S vssd1 vssd1 vccd1 vccd1 _3333_/D sky130_fd_sc_hd__mux2_1
X_2759_ hold573/X _2816_/A1 _2761_/S vssd1 vssd1 vccd1 vccd1 _3268_/D sky130_fd_sc_hd__mux2_1
XANTENNA__2923__B2 _2923_/B2 vssd1 vssd1 vccd1 vccd1 sky130_fd_sc_hd__diode_2
XFILLER_48_58 vssd1 vssd1 vccd1 vccd1 sky130_fd_sc_hd__fill_4
XFILLER_58_155 vssd1 vssd1 vccd1 vccd1 sky130_fd_sc_hd__fill_4
XFILLER_58_177 vssd1 vssd1 vccd1 vccd1 sky130_fd_sc_hd__fill_2
XANTENNA__2754__S _2757_/S vssd1 vssd1 vccd1 vccd1 sky130_fd_sc_hd__diode_2
XFILLER_61_309 vssd1 vssd1 vccd1 vccd1 sky130_fd_sc_hd__fill_1
XTAP_TAPCELL_ROW_1_184 vssd1 vccd1 sky130_fd_sc_hd__tapvpwrvgnd_1
XFILLER_73_169 vssd1 vccd1 vssd1 vccd1 sky130_ef_sc_hd__decap_40_12
Xfanout40 _2640_/X vssd1 vssd1 vccd1 vccd1 _2815_/A1 sky130_fd_sc_hd__clkdlybuf4s25_1
XANTENNA_fanout12_X _2852_/S vssd1 vssd1 vccd1 vccd1 sky130_fd_sc_hd__diode_2
Xfanout51 _2618_/X vssd1 vssd1 vccd1 vccd1 _2842_/A1 sky130_fd_sc_hd__clkdlybuf4s25_1
Xfanout62 _2609_/X vssd1 vssd1 vccd1 vccd1 _2646_/B sky130_fd_sc_hd__clkdlybuf4s25_1
Xfanout84 _2438_/X vssd1 vssd1 vccd1 vccd1 _2819_/B sky130_fd_sc_hd__clkdlybuf4s25_1
Xfanout95 _2923_/B2 vssd1 vssd1 vccd1 vccd1 _2781_/B sky130_fd_sc_hd__clkdlybuf4s25_1
XFILLER_13_61 vssd1 vssd1 vccd1 vccd1 sky130_fd_sc_hd__fill_1
XFILLER_10_475 vssd1 vssd1 vccd1 vccd1 sky130_fd_sc_hd__fill_1
XFILLER_6_457 vssd1 vssd1 vccd1 vccd1 sky130_fd_sc_hd__fill_1
XTAP_TAPCELL_ROW_9_251 vssd1 vccd1 sky130_fd_sc_hd__tapvpwrvgnd_1
XFILLER_69_409 vssd1 vssd1 vccd1 vccd1 sky130_fd_sc_hd__fill_1
XFILLER_77_453 vssd1 vssd1 vccd1 vccd1 sky130_fd_sc_hd__fill_1
XFILLER_49_166 vssd1 vssd1 vccd1 vccd1 sky130_fd_sc_hd__fill_2
XFILLER_77_486 vssd1 vssd1 vccd1 vccd1 sky130_fd_sc_hd__fill_2
XANTENNA__2664__S _2666_/S vssd1 vssd1 vccd1 vccd1 sky130_fd_sc_hd__diode_2
XFILLER_38_91 vssd1 vssd1 vccd1 vccd1 sky130_fd_sc_hd__fill_1
XFILLER_52_309 vssd1 vssd1 vccd1 vccd1 sky130_fd_sc_hd__fill_1
XTAP_TAPCELL_ROW_43_540 vssd1 vccd1 sky130_fd_sc_hd__tapvpwrvgnd_1
XFILLER_54_90 vssd1 vssd1 vccd1 vccd1 sky130_fd_sc_hd__fill_4
X_1992_ _1992_/A _1992_/B vssd1 vssd1 vccd1 vccd1 _1992_/Y sky130_fd_sc_hd__xnor2_2
XTAP_TAPCELL_ROW_15_297 vssd1 vccd1 sky130_fd_sc_hd__tapvpwrvgnd_1
Xclkload10 _3132_/CLK vssd1 vssd1 vccd1 vccd1 clkload10/X sky130_fd_sc_hd__clkbuf_8
X_2613_ hold511/X _2839_/A1 _2647_/S vssd1 vssd1 vccd1 vccd1 _3145_/D sky130_fd_sc_hd__mux2_1
X_2544_ _2550_/A1 _2465_/X _2542_/Y hold706/X vssd1 vssd1 vccd1 vccd1 _3099_/D sky130_fd_sc_hd__a22o_2
XANTENNA__1743__S _3435_/D vssd1 vssd1 vccd1 vccd1 sky130_fd_sc_hd__diode_2
XANTENNA__2839__S _2852_/S vssd1 vssd1 vccd1 vccd1 sky130_fd_sc_hd__diode_2
X_2475_ _2781_/B _2469_/X _2473_/X _2445_/S vssd1 vssd1 vccd1 vccd1 _2475_/X sky130_fd_sc_hd__a22o_2
X_3027_ clkload9/A _3027_/D load_slew202/X vssd1 vssd1 vccd1 vccd1 _3027_/Q sky130_fd_sc_hd__dfrtp_2
XFILLER_55_169 vssd1 vssd1 vccd1 vccd1 sky130_fd_sc_hd__fill_2
XFILLER_34_49 vssd1 vssd1 vccd1 vccd1 sky130_fd_sc_hd__fill_4
XANTENNA_fanout147_X _2352_/C vssd1 vssd1 vccd1 vccd1 sky130_fd_sc_hd__diode_2
Xclkload4 clkload4/A vssd1 vssd1 vccd1 vccd1 clkload4/X sky130_fd_sc_hd__clkbuf_8
XFILLER_50_48 vssd1 vssd1 vccd1 vccd1 sky130_fd_sc_hd__fill_2
XFILLER_59_24 vssd1 vssd1 vccd1 vccd1 sky130_fd_sc_hd__fill_8
XANTENNA__2749__S _2761_/S vssd1 vssd1 vccd1 vccd1 sky130_fd_sc_hd__diode_2
Xfanout241 fanout242/X vssd1 vssd1 vccd1 vccd1 fanout241/X sky130_fd_sc_hd__clkdlybuf4s25_1
XTAP_TAPCELL_ROW_6_221 vssd1 vccd1 sky130_fd_sc_hd__tapvpwrvgnd_1
Xfanout252 fanout259/X vssd1 vssd1 vccd1 vccd1 fanout252/X sky130_fd_sc_hd__clkdlybuf4s25_1
Xfanout263 fanout265/X vssd1 vssd1 vccd1 vccd1 fanout263/X sky130_fd_sc_hd__clkdlybuf4s25_1
Xfanout274 fanout279/X vssd1 vssd1 vccd1 vccd1 fanout274/X sky130_fd_sc_hd__clkdlybuf4s25_1
Xfanout285 fanout289/X vssd1 vssd1 vccd1 vccd1 fanout285/X sky130_fd_sc_hd__clkdlybuf4s25_1
Xfanout296 _2995_/A vssd1 vssd1 vccd1 vccd1 _3001_/A sky130_fd_sc_hd__clkdlybuf4s25_1
XFILLER_75_45 vssd1 vssd1 vccd1 vccd1 sky130_fd_sc_hd__fill_1
XFILLER_75_34 vssd1 vssd1 vccd1 vccd1 sky130_fd_sc_hd__fill_2
XTAP_TAPCELL_ROW_57_654 vssd1 vccd1 sky130_fd_sc_hd__tapvpwrvgnd_1
XFILLER_46_158 vssd1 vssd1 vccd1 vccd1 sky130_fd_sc_hd__fill_2
XFILLER_34_309 vssd1 vssd1 vccd1 vccd1 sky130_fd_sc_hd__fill_1
XTAP_TAPCELL_ROW_40_510 vssd1 vccd1 sky130_fd_sc_hd__tapvpwrvgnd_1
XFILLER_42_386 vssd1 vssd1 vccd1 vccd1 sky130_fd_sc_hd__fill_1
XTAP_TAPCELL_ROW_12_278 vssd1 vccd1 sky130_fd_sc_hd__tapvpwrvgnd_1
XFILLER_6_221 vssd1 vssd1 vccd1 vccd1 sky130_fd_sc_hd__fill_4
XANTENNA__2800__X _2800_/X vssd1 vssd1 vccd1 vccd1 sky130_fd_sc_hd__diode_2
XANTENNA_load_slew68_X _2971_/B1 vssd1 vssd1 vccd1 vccd1 sky130_fd_sc_hd__diode_2
XANTENNA__2659__S _2662_/S vssd1 vssd1 vccd1 vccd1 sky130_fd_sc_hd__diode_2
X_2260_ _2261_/B _2261_/C _2261_/A vssd1 vssd1 vccd1 vccd1 _2260_/Y sky130_fd_sc_hd__a21oi_2
X_2191_ _2191_/A _2191_/B vssd1 vssd1 vccd1 vccd1 _2193_/C sky130_fd_sc_hd__xor2_2
XFILLER_77_272 vssd1 vssd1 vccd1 vccd1 sky130_fd_sc_hd__fill_8
XFILLER_1_53 vssd1 vssd1 vccd1 vccd1 sky130_fd_sc_hd__fill_1
XFILLER_37_169 vssd1 vssd1 vccd1 vccd1 sky130_fd_sc_hd__fill_2
X_1975_ _1943_/A _1949_/B _1943_/B vssd1 vssd1 vccd1 vccd1 _1977_/B sky130_fd_sc_hd__o21ba_2
XANTENNA__2051__B2 _2073_/C vssd1 vssd1 vccd1 vccd1 sky130_fd_sc_hd__diode_2
XFILLER_20_29 vssd1 vssd1 vccd1 vccd1 sky130_fd_sc_hd__fill_1
X_2527_ _2527_/A _2527_/B vssd1 vssd1 vccd1 vccd1 _2528_/B sky130_fd_sc_hd__or2_2
XFILLER_0_419 vssd1 vssd1 vccd1 vccd1 sky130_fd_sc_hd__fill_1
X_2458_ _2926_/B _2926_/C _3200_/Q vssd1 vssd1 vccd1 vccd1 _2458_/X sky130_fd_sc_hd__and3_2
X_2389_ _2365_/A _2364_/A _2364_/B vssd1 vssd1 vccd1 vccd1 _2392_/B sky130_fd_sc_hd__o21ba_2
XFILLER_68_261 vssd1 vssd1 vccd1 vccd1 sky130_fd_sc_hd__fill_4
XFILLER_68_250 vssd1 vssd1 vccd1 vccd1 sky130_fd_sc_hd__fill_2
XANTENNA__1502__A _2533_/A vssd1 vssd1 vccd1 vccd1 sky130_fd_sc_hd__diode_2
XTAP_TAPCELL_ROW_54_635 vssd1 vccd1 sky130_fd_sc_hd__tapvpwrvgnd_1
XFILLER_43_117 vssd1 vssd1 vccd1 vccd1 sky130_fd_sc_hd__fill_2
XFILLER_36_191 vssd1 vssd1 vccd1 vccd1 sky130_fd_sc_hd__fill_1
XANTENNA__1648__S _1690_/S vssd1 vssd1 vccd1 vccd1 sky130_fd_sc_hd__diode_2
XFILLER_61_36 vssd1 vssd1 vccd1 vccd1 sky130_fd_sc_hd__fill_1
XANTENNA__2620__X _2620_/X vssd1 vssd1 vccd1 vccd1 sky130_fd_sc_hd__diode_2
XFILLER_3_279 vssd1 vssd1 vccd1 vccd1 sky130_fd_sc_hd__fill_1
XFILLER_74_264 vssd1 vccd1 vssd1 vccd1 sky130_ef_sc_hd__decap_40_12
XFILLER_74_253 vssd1 vssd1 vccd1 vccd1 sky130_fd_sc_hd__fill_2
XFILLER_19_93 vssd1 vssd1 vccd1 vccd1 sky130_fd_sc_hd__fill_1
XTAP_TAPCELL_ROW_17_315 vssd1 vccd1 sky130_fd_sc_hd__tapvpwrvgnd_1
XANTENNA__2227__B _2399_/B vssd1 vssd1 vccd1 vccd1 sky130_fd_sc_hd__diode_2
XFILLER_15_331 vssd1 vssd1 vccd1 vccd1 sky130_fd_sc_hd__fill_2
XFILLER_35_81 vssd1 vssd1 vccd1 vccd1 sky130_fd_sc_hd__fill_1
XTAP_TAPCELL_ROW_25_381 vssd1 vccd1 sky130_fd_sc_hd__tapvpwrvgnd_1
XANTENNA__2243__A _2297_/A vssd1 vssd1 vccd1 vccd1 sky130_fd_sc_hd__diode_2
X_1760_ _1970_/B hold463/X _1763_/S vssd1 vssd1 vccd1 vccd1 _3040_/D sky130_fd_sc_hd__mux2_1
Xhold508 _3157_/Q vssd1 vssd1 vccd1 vccd1 hold508/X sky130_fd_sc_hd__dlygate4sd3_1
X_1691_ _3080_/Q _3063_/Q vssd1 vssd1 vccd1 vccd1 _1691_/Y sky130_fd_sc_hd__nor2_2
X_3430_ _3431_/CLK _3430_/D fanout271/X vssd1 vssd1 vccd1 vccd1 _3430_/Q sky130_fd_sc_hd__dfstp_2
Xhold519 _3194_/Q vssd1 vssd1 vccd1 vccd1 hold519/X sky130_fd_sc_hd__dlygate4sd3_1
X_3361_ _1507_/Y _3361_/D load_slew283/X vssd1 vssd1 vccd1 vccd1 _3361_/Q sky130_fd_sc_hd__dfrtp_2
X_2312_ _2312_/A _2312_/B vssd1 vssd1 vccd1 vccd1 _2312_/Y sky130_fd_sc_hd__xnor2_2
XFILLER_32_3 vssd1 vssd1 vccd1 vccd1 sky130_fd_sc_hd__fill_4
X_3292_ _3388_/CLK _3292_/D fanout238/X vssd1 vssd1 vccd1 vccd1 _3292_/Q sky130_fd_sc_hd__dfrtp_2
X_2243_ _2297_/A _2318_/A _2296_/A vssd1 vssd1 vccd1 vccd1 _2245_/A sky130_fd_sc_hd__and3_2
X_2174_ _2211_/A _2175_/C _2175_/D _2175_/A vssd1 vssd1 vccd1 vccd1 _2214_/A sky130_fd_sc_hd__a22o_2
XTAP_TAPCELL_ROW_68_749 vssd1 vccd1 sky130_fd_sc_hd__tapvpwrvgnd_1
XFILLER_38_423 vssd1 vssd1 vccd1 vccd1 sky130_fd_sc_hd__fill_1
XFILLER_25_117 vssd1 vssd1 vccd1 vccd1 sky130_fd_sc_hd__fill_2
XFILLER_53_459 vssd1 vssd1 vccd1 vccd1 sky130_fd_sc_hd__fill_1
XANTENNA__2852__S _2852_/S vssd1 vssd1 vccd1 vccd1 sky130_fd_sc_hd__diode_2
XTAP_TAPCELL_ROW_51_605 vssd1 vccd1 sky130_fd_sc_hd__tapvpwrvgnd_1
XFILLER_61_470 vssd1 vssd1 vccd1 vccd1 sky130_fd_sc_hd__fill_1
XFILLER_61_492 vssd1 vssd1 vccd1 vccd1 sky130_fd_sc_hd__fill_2
XANTENNA__2024__A1 _2025_/A vssd1 vssd1 vccd1 vccd1 sky130_fd_sc_hd__diode_2
X_1958_ _1958_/A _1958_/B vssd1 vssd1 vccd1 vccd1 _1959_/B sky130_fd_sc_hd__nor2_2
X_1889_ _1981_/A _1886_/Y _1887_/X _1871_/B vssd1 vssd1 vccd1 vccd1 _1931_/B sky130_fd_sc_hd__o211ai_2
Xteam_02_302 vssd1 vssd1 vccd1 vccd1 team_02_302/HI gpio_out[5] sky130_fd_sc_hd__conb_1
Xteam_02_313 vssd1 vssd1 vccd1 vccd1 team_02_313/HI gpio_out[16] sky130_fd_sc_hd__conb_1
Xteam_02_324 vssd1 vssd1 vccd1 vccd1 team_02_324/HI gpio_out[27] sky130_fd_sc_hd__conb_1
Xteam_02_335 vssd1 vssd1 vccd1 vccd1 gpio_oeb[5] team_02_335/LO sky130_fd_sc_hd__conb_1
Xteam_02_346 vssd1 vssd1 vccd1 vccd1 gpio_oeb[16] team_02_346/LO sky130_fd_sc_hd__conb_1
Xteam_02_357 vssd1 vssd1 vccd1 vccd1 gpio_oeb[27] team_02_357/LO sky130_fd_sc_hd__conb_1
XFILLER_71_212 vssd1 vssd1 vccd1 vccd1 sky130_fd_sc_hd__fill_2
XFILLER_44_415 vssd1 vssd1 vccd1 vccd1 sky130_fd_sc_hd__fill_4
XFILLER_16_139 vssd1 vssd1 vccd1 vccd1 sky130_fd_sc_hd__fill_1
XFILLER_16_117 vssd1 vssd1 vccd1 vccd1 sky130_fd_sc_hd__fill_4
XFILLER_71_245 vssd1 vssd1 vccd1 vccd1 sky130_fd_sc_hd__fill_8
XFILLER_72_57 vssd1 vssd1 vccd1 vccd1 sky130_fd_sc_hd__fill_8
XFILLER_72_46 vssd1 vssd1 vccd1 vccd1 sky130_fd_sc_hd__fill_1
XFILLER_71_278 vssd1 vssd1 vccd1 vccd1 sky130_fd_sc_hd__fill_2
XFILLER_72_79 vssd1 vssd1 vccd1 vccd1 sky130_fd_sc_hd__fill_4
XTAP_TAPCELL_ROW_22_362 vssd1 vccd1 sky130_fd_sc_hd__tapvpwrvgnd_1
XANTENNA__2566__A2 _2515_/X vssd1 vssd1 vccd1 vccd1 sky130_fd_sc_hd__diode_2
XFILLER_47_220 vssd1 vssd1 vccd1 vccd1 sky130_fd_sc_hd__fill_4
XFILLER_47_264 vssd1 vssd1 vccd1 vccd1 sky130_fd_sc_hd__fill_4
XFILLER_47_242 vssd1 vssd1 vccd1 vccd1 sky130_fd_sc_hd__fill_1
XANTENNA_clkload2_A clkload2/A vssd1 vssd1 vccd1 vccd1 sky130_fd_sc_hd__diode_2
XFILLER_62_223 vssd1 vssd1 vccd1 vccd1 sky130_fd_sc_hd__fill_2
XFILLER_35_426 vssd1 vssd1 vccd1 vccd1 sky130_fd_sc_hd__fill_1
XANTENNA__2672__S _2685_/S vssd1 vssd1 vccd1 vccd1 sky130_fd_sc_hd__diode_2
X_2930_ hold727/X _3437_/D _2928_/X _2929_/X vssd1 vssd1 vccd1 vccd1 _3394_/D sky130_fd_sc_hd__o22a_2
XTAP_TAPCELL_ROW_73_796 vssd1 vccd1 sky130_fd_sc_hd__tapvpwrvgnd_1
XFILLER_15_150 vssd1 vccd1 vssd1 vccd1 sky130_ef_sc_hd__decap_40_12
X_2861_ hold462/X _2502_/B _2864_/S vssd1 vssd1 vccd1 vccd1 _3385_/D sky130_fd_sc_hd__mux2_1
X_2792_ hold555/X _2811_/A1 _2799_/S vssd1 vssd1 vccd1 vccd1 _3299_/D sky130_fd_sc_hd__mux2_1
X_1812_ _1906_/A _1865_/B vssd1 vssd1 vccd1 vccd1 _1816_/A sky130_fd_sc_hd__and2_2
XANTENNA__1765__A0 _1979_/B vssd1 vssd1 vccd1 vccd1 sky130_fd_sc_hd__diode_2
X_1743_ _1805_/B hold702/X _3435_/D vssd1 vssd1 vccd1 vccd1 _3023_/D sky130_fd_sc_hd__mux2_1
X_1674_ _1674_/A _1674_/B vssd1 vssd1 vccd1 vccd1 _1675_/B sky130_fd_sc_hd__or2_2
XFILLER_7_393 vssd1 vssd1 vccd1 vccd1 sky130_fd_sc_hd__fill_4
X_3413_ _3431_/CLK _3413_/D _2608_/S vssd1 vssd1 vccd1 vccd1 _3413_/Q sky130_fd_sc_hd__dfrtp_2
X_3344_ _3441_/CLK _3344_/D fanout280/X vssd1 vssd1 vccd1 vccd1 _3344_/Q sky130_fd_sc_hd__dfrtp_2
Xload_slew230 fanout229/X vssd1 vssd1 vccd1 vccd1 load_slew230/X sky130_fd_sc_hd__clkbuf_4
XANTENNA__2847__S _2852_/S vssd1 vssd1 vccd1 vccd1 sky130_fd_sc_hd__diode_2
X_3275_ _3287_/CLK _3275_/D load_slew230/X vssd1 vssd1 vccd1 vccd1 _3275_/Q sky130_fd_sc_hd__dfrtp_2
X_2226_ _3046_/Q _2399_/B vssd1 vssd1 vccd1 vccd1 _2233_/A sky130_fd_sc_hd__and2_2
XANTENNA__2493__A1 _2962_/A1 vssd1 vssd1 vccd1 vccd1 sky130_fd_sc_hd__diode_2
XANTENNA__2493__B2 _2961_/A1 vssd1 vssd1 vccd1 vccd1 sky130_fd_sc_hd__diode_2
X_2157_ _2255_/B _2188_/A _2157_/C vssd1 vssd1 vccd1 vccd1 _2157_/X sky130_fd_sc_hd__and3_2
X_2088_ _2078_/A _2077_/A _1979_/B _3029_/Q _2050_/Y vssd1 vssd1 vccd1 vccd1 _2093_/C
+ sky130_fd_sc_hd__o2111ai_2
XTAP_TAPCELL_ROW_36_476 vssd1 vccd1 sky130_fd_sc_hd__tapvpwrvgnd_1
XANTENNA__2548__A2 _2515_/X vssd1 vssd1 vccd1 vccd1 sky130_fd_sc_hd__diode_2
XANTENNA__2611__A _2611_/A vssd1 vssd1 vccd1 vccd1 sky130_fd_sc_hd__diode_2
XPHY_EDGE_ROW_39_Left_119 vssd1 vssd1 vccd1 vccd1 sky130_fd_sc_hd__decap_3
XANTENNA__2757__S _2757_/S vssd1 vssd1 vccd1 vccd1 sky130_fd_sc_hd__diode_2
XFILLER_76_315 vssd1 vssd1 vccd1 vccd1 sky130_fd_sc_hd__fill_8
XFILLER_67_57 vssd1 vssd1 vccd1 vccd1 sky130_fd_sc_hd__fill_4
XFILLER_67_24 vssd1 vccd1 vssd1 vccd1 sky130_ef_sc_hd__decap_40_12
XFILLER_67_68 vssd1 vssd1 vccd1 vccd1 sky130_fd_sc_hd__fill_4
XPHY_EDGE_ROW_48_Left_128 vssd1 vssd1 vccd1 vccd1 sky130_fd_sc_hd__decap_3
XFILLER_29_297 vssd1 vssd1 vccd1 vccd1 sky130_fd_sc_hd__fill_1
XANTENNA__1995__B1 _1998_/B vssd1 vssd1 vccd1 vccd1 sky130_fd_sc_hd__diode_2
XTAP_TAPCELL_ROW_70_766 vssd1 vccd1 sky130_fd_sc_hd__tapvpwrvgnd_1
XFILLER_40_440 vssd1 vssd1 vccd1 vccd1 sky130_fd_sc_hd__fill_1
XANTENNA__1747__A0 _2049_/B vssd1 vssd1 vccd1 vccd1 sky130_fd_sc_hd__diode_2
XANTENNA__2539__A2 _2923_/A2 vssd1 vssd1 vccd1 vccd1 sky130_fd_sc_hd__diode_2
XPHY_EDGE_ROW_57_Left_137 vssd1 vssd1 vccd1 vccd1 sky130_fd_sc_hd__decap_3
XFILLER_32_82 vssd1 vssd1 vccd1 vccd1 sky130_fd_sc_hd__fill_2
XFILLER_12_197 vssd1 vssd1 vccd1 vccd1 sky130_fd_sc_hd__fill_8
XFILLER_79_153 vssd1 vccd1 vssd1 vccd1 sky130_ef_sc_hd__decap_40_12
X_3060_ _3090_/CLK _3060_/D vssd1 vssd1 vccd1 vccd1 _3060_/Q sky130_fd_sc_hd__dfxtp_2
XTAP_TAPCELL_ROW_78_833 vssd1 vccd1 sky130_fd_sc_hd__tapvpwrvgnd_1
XPHY_EDGE_ROW_66_Left_146 vssd1 vssd1 vccd1 vccd1 sky130_fd_sc_hd__decap_3
XFILLER_79_197 vssd1 vccd1 vssd1 vccd1 sky130_ef_sc_hd__decap_40_12
XFILLER_67_337 vssd1 vssd1 vccd1 vccd1 sky130_fd_sc_hd__fill_2
X_2011_ _2012_/A _2012_/B vssd1 vssd1 vccd1 vccd1 _2040_/A sky130_fd_sc_hd__nand2_2
XANTENNA__2475__A1 _2781_/B vssd1 vssd1 vccd1 vccd1 sky130_fd_sc_hd__diode_2
XANTENNA__2475__B2 _2445_/S vssd1 vssd1 vccd1 vccd1 sky130_fd_sc_hd__diode_2
XFILLER_57_90 vssd1 vssd1 vccd1 vccd1 sky130_fd_sc_hd__fill_2
XFILLER_35_223 vssd1 vssd1 vccd1 vccd1 sky130_fd_sc_hd__fill_1
X_2913_ _2964_/B _2964_/C _3283_/Q vssd1 vssd1 vccd1 vccd1 _2913_/X sky130_fd_sc_hd__and3_2
XPHY_EDGE_ROW_75_Left_155 vssd1 vssd1 vccd1 vccd1 sky130_fd_sc_hd__decap_3
X_2844_ hold464/X _2844_/A1 _2856_/S vssd1 vssd1 vccd1 vccd1 _3348_/D sky130_fd_sc_hd__mux2_1
XANTENNA__1746__S _3435_/D vssd1 vssd1 vccd1 vccd1 sky130_fd_sc_hd__diode_2
X_2775_ hold456/X _2813_/A1 _2776_/S vssd1 vssd1 vccd1 vccd1 _3283_/D sky130_fd_sc_hd__mux2_1
X_1726_ hold650/X _1725_/Y _1738_/S vssd1 vssd1 vccd1 vccd1 _3018_/D sky130_fd_sc_hd__mux2_1
XANTENNA__2950__A2 _2971_/A2 vssd1 vssd1 vccd1 vccd1 sky130_fd_sc_hd__diode_2
X_1657_ _3075_/Q _3058_/Q vssd1 vssd1 vccd1 vccd1 _1657_/X sky130_fd_sc_hd__or2_2
X_1588_ _3428_/Q _2590_/A hold724/X vssd1 vssd1 vccd1 vccd1 _3428_/D sky130_fd_sc_hd__a21o_2
X_3327_ _3431_/CLK _3327_/D fanout266/X vssd1 vssd1 vccd1 vccd1 _3327_/Q sky130_fd_sc_hd__dfrtp_2
X_3258_ _3387_/CLK _3258_/D load_slew237/X vssd1 vssd1 vccd1 vccd1 _3258_/Q sky130_fd_sc_hd__dfrtp_2
XANTENNA__2466__B2 _1602_/X vssd1 vssd1 vccd1 vccd1 sky130_fd_sc_hd__diode_2
X_3189_ _3389_/CLK _3189_/D fanout274/X vssd1 vssd1 vccd1 vccd1 _3189_/Q sky130_fd_sc_hd__dfrtp_2
X_2209_ _2190_/B _2208_/X _2207_/Y _2206_/X vssd1 vssd1 vccd1 vccd1 _2252_/A sky130_fd_sc_hd__a211o_2
XFILLER_73_329 vssd1 vssd1 vccd1 vccd1 sky130_fd_sc_hd__fill_4
XTAP_TAPCELL_ROW_49_590 vssd1 vccd1 sky130_fd_sc_hd__tapvpwrvgnd_1
XFILLER_53_26 vssd1 vssd1 vccd1 vccd1 sky130_fd_sc_hd__fill_8
XANTENNA__2941__A2 _2864_/S vssd1 vssd1 vccd1 vccd1 sky130_fd_sc_hd__diode_2
XFILLER_78_12 vssd1 vccd1 vssd1 vccd1 sky130_ef_sc_hd__decap_40_12
Xhold680 _3264_/Q vssd1 vssd1 vccd1 vccd1 hold680/X sky130_fd_sc_hd__dlygate4sd3_1
Xhold691 _3124_/Q vssd1 vssd1 vccd1 vccd1 hold691/X sky130_fd_sc_hd__dlygate4sd3_1
XANTENNA__2457__A1 _2686_/A vssd1 vssd1 vccd1 vccd1 sky130_fd_sc_hd__diode_2
XANTENNA__2457__B2 _2838_/A vssd1 vssd1 vccd1 vccd1 sky130_fd_sc_hd__diode_2
XFILLER_17_223 vssd1 vssd1 vccd1 vccd1 sky130_fd_sc_hd__fill_1
XANTENNA__1968__B1 _2004_/B vssd1 vssd1 vccd1 vccd1 sky130_fd_sc_hd__diode_2
XTAP_TAPCELL_ROW_30_427 vssd1 vccd1 sky130_fd_sc_hd__tapvpwrvgnd_1
XFILLER_71_7 vssd1 vssd1 vccd1 vccd1 sky130_fd_sc_hd__fill_1
XANTENNA__1793__C _2004_/B vssd1 vssd1 vccd1 vccd1 sky130_fd_sc_hd__diode_2
X_2560_ _1569_/D wire106/X _2588_/C vssd1 vssd1 vccd1 vccd1 _2560_/Y sky130_fd_sc_hd__o21ai_2
XANTENNA__2932__A2 _2971_/A2 vssd1 vssd1 vccd1 vccd1 sky130_fd_sc_hd__diode_2
X_2491_ _2959_/B _2957_/C _3347_/Q vssd1 vssd1 vccd1 vccd1 _2491_/X sky130_fd_sc_hd__and3_2
X_1511_ _3380_/Q input3/X _1525_/S vssd1 vssd1 vccd1 vccd1 _3380_/D sky130_fd_sc_hd__a21bo_2
XFILLER_4_31 vssd1 vccd1 vssd1 vccd1 sky130_ef_sc_hd__decap_40_12
XFILLER_4_193 vssd1 vssd1 vccd1 vccd1 sky130_fd_sc_hd__fill_2
X_3112_ _3112_/CLK _3112_/D fanout201/X vssd1 vssd1 vccd1 vccd1 _3112_/Q sky130_fd_sc_hd__dfrtp_2
X_3043_ clkload8/A _3043_/D load_slew210/X vssd1 vssd1 vccd1 vccd1 _3043_/Q sky130_fd_sc_hd__dfrtp_2
XTAP_TAPCELL_ROW_46_560 vssd1 vccd1 sky130_fd_sc_hd__tapvpwrvgnd_1
XANTENNA__2620__A1 _3403_/Q vssd1 vssd1 vccd1 vccd1 sky130_fd_sc_hd__diode_2
XANTENNA__2860__S _3437_/D vssd1 vssd1 vccd1 vccd1 sky130_fd_sc_hd__diode_2
XANTENNA_fanout137_A _2472_/A vssd1 vssd1 vccd1 vccd1 sky130_fd_sc_hd__diode_2
X_2827_ hold607/X _2626_/X _2833_/S vssd1 vssd1 vccd1 vccd1 _3332_/D sky130_fd_sc_hd__mux2_1
X_2758_ hold542/X _2815_/A1 _2761_/S vssd1 vssd1 vccd1 vccd1 _3267_/D sky130_fd_sc_hd__mux2_1
XANTENNA__2923__A2 _2923_/A2 vssd1 vssd1 vccd1 vccd1 sky130_fd_sc_hd__diode_2
X_1709_ _3083_/Q _3066_/Q vssd1 vssd1 vccd1 vccd1 _1711_/A sky130_fd_sc_hd__or2_2
X_2689_ hold438/X _2803_/A1 _2700_/S vssd1 vssd1 vccd1 vccd1 _3201_/D sky130_fd_sc_hd__mux2_1
XFILLER_58_134 vssd1 vssd1 vccd1 vccd1 sky130_fd_sc_hd__fill_2
XFILLER_73_126 vssd1 vssd1 vccd1 vccd1 sky130_fd_sc_hd__fill_1
XFILLER_73_137 vssd1 vssd1 vccd1 vccd1 sky130_fd_sc_hd__fill_2
Xfanout30 _2667_/X vssd1 vssd1 vccd1 vccd1 _2681_/S sky130_fd_sc_hd__clkdlybuf4s25_1
XANTENNA__2770__S _2776_/S vssd1 vssd1 vccd1 vccd1 sky130_fd_sc_hd__diode_2
Xfanout41 _2638_/X vssd1 vssd1 vccd1 vccd1 _2814_/A1 sky130_fd_sc_hd__clkdlybuf4s25_1
Xfanout52 _2616_/X vssd1 vssd1 vccd1 vccd1 _2803_/A1 sky130_fd_sc_hd__clkdlybuf4s25_1
Xfanout63 _2445_/X vssd1 vssd1 vccd1 vccd1 _2967_/A2 sky130_fd_sc_hd__clkdlybuf4s25_1
Xfanout74 _2800_/B vssd1 vssd1 vccd1 vccd1 _2927_/B1 sky130_fd_sc_hd__clkdlybuf4s25_1
Xfanout85 _1626_/X vssd1 vssd1 vccd1 vccd1 _2610_/A sky130_fd_sc_hd__clkdlybuf4s25_1
Xfanout96 _2430_/Y vssd1 vssd1 vccd1 vccd1 _2923_/B2 sky130_fd_sc_hd__clkdlybuf4s25_1
XFILLER_22_281 vssd1 vssd1 vccd1 vccd1 sky130_fd_sc_hd__fill_2
XFILLER_6_447 vssd1 vssd1 vccd1 vccd1 sky130_fd_sc_hd__fill_8
XTAP_TAPCELL_ROW_9_252 vssd1 vccd1 sky130_fd_sc_hd__tapvpwrvgnd_1
XANTENNA__3403__Q _3403_/Q vssd1 vssd1 vccd1 vccd1 sky130_fd_sc_hd__diode_2
XFILLER_64_115 vssd1 vssd1 vccd1 vccd1 sky130_fd_sc_hd__fill_1
XANTENNA__3423__CLK _3423_/CLK vssd1 vssd1 vccd1 vccd1 sky130_fd_sc_hd__diode_2
XTAP_TAPCELL_ROW_43_541 vssd1 vccd1 sky130_fd_sc_hd__tapvpwrvgnd_1
XFILLER_54_80 vssd1 vssd1 vccd1 vccd1 sky130_fd_sc_hd__fill_4
XANTENNA__2680__S _2685_/S vssd1 vssd1 vccd1 vccd1 sky130_fd_sc_hd__diode_2
X_1991_ _1994_/A _1991_/B vssd1 vssd1 vccd1 vccd1 _1992_/B sky130_fd_sc_hd__and2_2
XTAP_TAPCELL_ROW_15_298 vssd1 vccd1 sky130_fd_sc_hd__tapvpwrvgnd_1
Xclkload11 _3386_/CLK vssd1 vssd1 vccd1 vccd1 clkload11/X sky130_fd_sc_hd__clkbuf_8
X_2612_ _3399_/Q _2610_/A _2646_/B _3122_/Q vssd1 vssd1 vccd1 vccd1 _2612_/X sky130_fd_sc_hd__a22o_2
XFILLER_62_3 vssd1 vssd1 vccd1 vccd1 sky130_fd_sc_hd__fill_8
XANTENNA__2905__A2 _2971_/A2 vssd1 vssd1 vccd1 vccd1 sky130_fd_sc_hd__diode_2
X_2543_ _2550_/A1 _2453_/X _2550_/B1 hold474/X vssd1 vssd1 vccd1 vccd1 _3098_/D sky130_fd_sc_hd__a22o_2
X_2474_ _2611_/A _2468_/X _2471_/X _2800_/A vssd1 vssd1 vccd1 vccd1 _2474_/X sky130_fd_sc_hd__a22o_2
XFILLER_68_421 vssd1 vssd1 vccd1 vccd1 sky130_fd_sc_hd__fill_1
XFILLER_68_454 vssd1 vssd1 vccd1 vccd1 sky130_fd_sc_hd__fill_1
XANTENNA__2855__S _2856_/S vssd1 vssd1 vccd1 vccd1 sky130_fd_sc_hd__diode_2
XFILLER_18_29 vssd1 vccd1 vssd1 vccd1 sky130_ef_sc_hd__decap_40_12
XANTENNA__1979__B _1979_/B vssd1 vssd1 vccd1 vccd1 sky130_fd_sc_hd__diode_2
X_3026_ _3112_/CLK _3026_/D wire208/X vssd1 vssd1 vccd1 vccd1 _3026_/Q sky130_fd_sc_hd__dfrtp_2
XFILLER_55_159 vssd1 vssd1 vccd1 vccd1 sky130_fd_sc_hd__fill_8
XFILLER_11_218 vssd1 vssd1 vccd1 vccd1 sky130_fd_sc_hd__fill_2
Xclkload5 clkload5/A vssd1 vssd1 vccd1 vccd1 clkload5/X sky130_fd_sc_hd__clkbuf_8
XFILLER_50_27 vssd1 vssd1 vccd1 vccd1 sky130_fd_sc_hd__fill_1
XFILLER_78_207 vssd1 vssd1 vccd1 vccd1 sky130_fd_sc_hd__fill_2
Xfanout231 fanout242/X vssd1 vssd1 vccd1 vccd1 fanout231/X sky130_fd_sc_hd__clkdlybuf4s25_1
XTAP_TAPCELL_ROW_6_222 vssd1 vccd1 sky130_fd_sc_hd__tapvpwrvgnd_1
Xfanout242 fanout290/X vssd1 vssd1 vccd1 vccd1 fanout242/X sky130_fd_sc_hd__clkdlybuf4s25_1
XFILLER_59_465 vssd1 vssd1 vccd1 vccd1 sky130_fd_sc_hd__fill_2
XANTENNA__2765__S _2776_/S vssd1 vssd1 vccd1 vccd1 sky130_fd_sc_hd__diode_2
Xfanout275 fanout277/X vssd1 vssd1 vccd1 vccd1 fanout275/X sky130_fd_sc_hd__clkdlybuf4s25_1
Xfanout297 input2/X vssd1 vssd1 vccd1 vccd1 _2995_/A sky130_fd_sc_hd__clkdlybuf4s25_1
XFILLER_75_13 vssd1 vssd1 vccd1 vccd1 sky130_fd_sc_hd__fill_1
XANTENNA__1883__A2 _1979_/B vssd1 vssd1 vccd1 vccd1 sky130_fd_sc_hd__diode_2
XFILLER_75_57 vssd1 vccd1 vssd1 vccd1 sky130_ef_sc_hd__decap_40_12
XTAP_TAPCELL_ROW_57_655 vssd1 vccd1 sky130_fd_sc_hd__tapvpwrvgnd_1
XTAP_TAPCELL_ROW_40_511 vssd1 vccd1 sky130_fd_sc_hd__tapvpwrvgnd_1
XFILLER_24_83 vssd1 vssd1 vccd1 vccd1 sky130_fd_sc_hd__fill_1
XANTENNA__2348__B1 _2383_/B vssd1 vssd1 vccd1 vccd1 sky130_fd_sc_hd__diode_2
XFILLER_6_255 vssd1 vssd1 vccd1 vccd1 sky130_fd_sc_hd__fill_1
XANTENNA__2899__B2 _2520_/A vssd1 vssd1 vccd1 vccd1 sky130_fd_sc_hd__diode_2
XFILLER_2_450 vssd1 vssd1 vccd1 vccd1 sky130_fd_sc_hd__fill_2
XFILLER_69_229 vssd1 vssd1 vccd1 vccd1 sky130_fd_sc_hd__fill_2
XFILLER_2_472 vssd1 vssd1 vccd1 vccd1 sky130_fd_sc_hd__fill_4
X_2190_ _2190_/A _2190_/B vssd1 vssd1 vccd1 vccd1 _2191_/B sky130_fd_sc_hd__nand2_2
XANTENNA__2675__S _2681_/S vssd1 vssd1 vccd1 vccd1 sky130_fd_sc_hd__diode_2
XFILLER_77_262 vssd1 vssd1 vccd1 vccd1 sky130_fd_sc_hd__fill_1
XFILLER_1_10 vssd1 vssd1 vccd1 vccd1 sky130_fd_sc_hd__fill_2
XANTENNA__2528__X _2528_/X vssd1 vssd1 vccd1 vccd1 sky130_fd_sc_hd__diode_2
XANTENNA__2036__C1 _2002_/B vssd1 vssd1 vccd1 vccd1 sky130_fd_sc_hd__diode_2
X_1974_ _1974_/A _1974_/B vssd1 vssd1 vccd1 vccd1 _1977_/A sky130_fd_sc_hd__and2_2
XANTENNA__2051__A2 _2049_/B vssd1 vssd1 vccd1 vccd1 sky130_fd_sc_hd__diode_2
X_2526_ _2961_/A1 _2523_/X _2525_/X _2962_/A1 vssd1 vssd1 vccd1 vccd1 _2527_/B sky130_fd_sc_hd__a22o_2
X_2457_ _2686_/A _3146_/Q _3290_/Q _2838_/A vssd1 vssd1 vccd1 vccd1 _2457_/X sky130_fd_sc_hd__a22o_2
X_2388_ _2388_/A _2388_/B vssd1 vssd1 vccd1 vccd1 _2392_/A sky130_fd_sc_hd__xnor2_2
XANTENNA__2438__X _2438_/X vssd1 vssd1 vccd1 vccd1 sky130_fd_sc_hd__diode_2
XFILLER_43_107 vssd1 vssd1 vccd1 vccd1 sky130_fd_sc_hd__fill_4
X_3009_ _3132_/CLK _3009_/D load_slew220/X vssd1 vssd1 vccd1 vccd1 _3009_/Q sky130_fd_sc_hd__dfrtp_2
XFILLER_61_59 vssd1 vccd1 vssd1 vccd1 sky130_ef_sc_hd__decap_40_12
XFILLER_3_225 vssd1 vssd1 vccd1 vccd1 sky130_fd_sc_hd__fill_8
XFILLER_10_52 vssd1 vccd1 vssd1 vccd1 sky130_ef_sc_hd__decap_40_12
XFILLER_10_85 vssd1 vssd1 vccd1 vccd1 sky130_fd_sc_hd__fill_2
XFILLER_47_446 vssd1 vssd1 vccd1 vccd1 sky130_fd_sc_hd__fill_2
XFILLER_47_435 vssd1 vssd1 vccd1 vccd1 sky130_fd_sc_hd__fill_1
XFILLER_19_83 vssd1 vssd1 vccd1 vccd1 sky130_fd_sc_hd__fill_8
XFILLER_19_61 vssd1 vssd1 vccd1 vccd1 sky130_fd_sc_hd__fill_2
XFILLER_19_50 vssd1 vssd1 vccd1 vccd1 sky130_fd_sc_hd__fill_4
XFILLER_19_126 vssd1 vssd1 vccd1 vccd1 sky130_fd_sc_hd__fill_8
XTAP_TAPCELL_ROW_17_316 vssd1 vccd1 sky130_fd_sc_hd__tapvpwrvgnd_1
XFILLER_74_298 vssd1 vssd1 vccd1 vccd1 sky130_fd_sc_hd__fill_1
XFILLER_74_276 vssd1 vccd1 vssd1 vccd1 sky130_ef_sc_hd__decap_40_12
XFILLER_15_365 vssd1 vssd1 vccd1 vccd1 sky130_fd_sc_hd__fill_1
XTAP_TAPCELL_ROW_25_382 vssd1 vccd1 sky130_fd_sc_hd__tapvpwrvgnd_1
XFILLER_70_493 vssd1 vssd1 vccd1 vccd1 sky130_fd_sc_hd__fill_1
XANTENNA__2569__B1 _1622_/C vssd1 vssd1 vccd1 vccd1 sky130_fd_sc_hd__diode_2
Xhold509 _3245_/Q vssd1 vssd1 vccd1 vccd1 hold509/X sky130_fd_sc_hd__dlygate4sd3_1
X_1690_ hold631/X _1689_/Y _1690_/S vssd1 vssd1 vccd1 vccd1 _3012_/D sky130_fd_sc_hd__mux2_1
X_3360_ _3393_/CLK _3360_/D load_slew256/X vssd1 vssd1 vccd1 vccd1 _3360_/Q sky130_fd_sc_hd__dfrtp_2
X_2311_ _2311_/A _2311_/B vssd1 vssd1 vccd1 vccd1 _2312_/B sky130_fd_sc_hd__nand2_2
X_3291_ _3437_/CLK _3291_/D fanout262/X vssd1 vssd1 vccd1 vccd1 _3291_/Q sky130_fd_sc_hd__dfrtp_2
X_2242_ hold374/X _2241_/Y _2374_/S vssd1 vssd1 vccd1 vccd1 _3078_/D sky130_fd_sc_hd__mux2_1
XFILLER_25_3 vssd1 vssd1 vccd1 vccd1 sky130_fd_sc_hd__fill_4
X_2173_ _2205_/A _2255_/B _2188_/A _2157_/C _2159_/A vssd1 vssd1 vccd1 vccd1 _2175_/D
+ sky130_fd_sc_hd__a41o_2
XFILLER_38_435 vssd1 vssd1 vccd1 vccd1 sky130_fd_sc_hd__fill_1
XFILLER_38_479 vssd1 vssd1 vccd1 vccd1 sky130_fd_sc_hd__fill_1
XANTENNA__1749__S _3435_/D vssd1 vssd1 vccd1 vccd1 sky130_fd_sc_hd__diode_2
XTAP_TAPCELL_ROW_51_606 vssd1 vccd1 sky130_fd_sc_hd__tapvpwrvgnd_1
X_1957_ hold673/X _1956_/Y _1993_/S vssd1 vssd1 vccd1 vccd1 _3062_/D sky130_fd_sc_hd__mux2_1
XFILLER_31_29 vssd1 vssd1 vccd1 vccd1 sky130_fd_sc_hd__fill_2
XANTENNA__2980__A0 _3404_/Q vssd1 vssd1 vccd1 vccd1 sky130_fd_sc_hd__diode_2
X_1888_ _1871_/B _1887_/X _1886_/Y _1981_/A vssd1 vssd1 vccd1 vccd1 _1933_/A sky130_fd_sc_hd__a211o_2
XANTENNA__2440__Y _2440_/Y vssd1 vssd1 vccd1 vccd1 sky130_fd_sc_hd__diode_2
X_2509_ _2900_/A _2959_/C _3348_/Q vssd1 vssd1 vccd1 vccd1 _2509_/X sky130_fd_sc_hd__and3_2
Xteam_02_303 vssd1 vssd1 vccd1 vccd1 team_02_303/HI gpio_out[6] sky130_fd_sc_hd__conb_1
Xteam_02_314 vssd1 vssd1 vccd1 vccd1 team_02_314/HI gpio_out[17] sky130_fd_sc_hd__conb_1
Xteam_02_325 vssd1 vssd1 vccd1 vccd1 team_02_325/HI gpio_out[28] sky130_fd_sc_hd__conb_1
XANTENNA__1838__A2 _2029_/B vssd1 vssd1 vccd1 vccd1 sky130_fd_sc_hd__diode_2
Xteam_02_336 vssd1 vssd1 vccd1 vccd1 gpio_oeb[6] team_02_336/LO sky130_fd_sc_hd__conb_1
Xteam_02_347 vssd1 vssd1 vccd1 vccd1 gpio_oeb[17] team_02_347/LO sky130_fd_sc_hd__conb_1
Xteam_02_358 vssd1 vssd1 vccd1 vccd1 gpio_oeb[28] team_02_358/LO sky130_fd_sc_hd__conb_1
Xclkbuf_leaf_36_clk clkload0/A vssd1 vssd1 vccd1 vccd1 _3386_/CLK sky130_fd_sc_hd__clkbuf_8
XFILLER_72_25 vssd1 vssd1 vccd1 vccd1 sky130_fd_sc_hd__fill_1
XFILLER_52_493 vssd1 vssd1 vccd1 vccd1 sky130_fd_sc_hd__fill_1
XTAP_TAPCELL_ROW_22_363 vssd1 vccd1 sky130_fd_sc_hd__tapvpwrvgnd_1
XANTENNA__2971__B1 _2971_/B1 vssd1 vssd1 vccd1 vccd1 sky130_fd_sc_hd__diode_2
XFILLER_79_335 vssd1 vssd1 vccd1 vccd1 sky130_fd_sc_hd__fill_1
Xclkbuf_leaf_27_clk clkload3/A vssd1 vssd1 vccd1 vccd1 _3393_/CLK sky130_fd_sc_hd__clkbuf_8
XFILLER_35_449 vssd1 vssd1 vccd1 vccd1 sky130_fd_sc_hd__fill_1
XFILLER_28_490 vssd1 vssd1 vccd1 vccd1 sky130_fd_sc_hd__fill_4
X_2860_ hold423/X _2489_/B _3437_/D vssd1 vssd1 vccd1 vccd1 _3384_/D sky130_fd_sc_hd__mux2_1
X_1811_ _1827_/A _1817_/A vssd1 vssd1 vccd1 vccd1 _1818_/A sky130_fd_sc_hd__or2_2
X_2791_ hold501/X _2848_/A1 _2798_/S vssd1 vssd1 vccd1 vccd1 _3298_/D sky130_fd_sc_hd__mux2_1
XFILLER_30_176 vssd1 vssd1 vccd1 vccd1 sky130_fd_sc_hd__fill_4
X_1742_ _1805_/A hold662/X _3435_/D vssd1 vssd1 vccd1 vccd1 _3022_/D sky130_fd_sc_hd__mux2_1
X_1673_ _1660_/A _1656_/Y _1660_/B _1666_/B _1658_/Y vssd1 vssd1 vccd1 vccd1 _1674_/B
+ sky130_fd_sc_hd__o311a_2
XFILLER_7_383 vssd1 vssd1 vccd1 vccd1 sky130_fd_sc_hd__fill_1
X_3412_ _3423_/CLK _3412_/D load_slew225/X vssd1 vssd1 vccd1 vccd1 _3412_/Q sky130_fd_sc_hd__dfrtp_2
X_3343_ _3343_/CLK _3343_/D fanout223/X vssd1 vssd1 vccd1 vccd1 _3343_/Q sky130_fd_sc_hd__dfrtp_2
Xload_slew220 fanout219/X vssd1 vssd1 vccd1 vccd1 load_slew220/X sky130_fd_sc_hd__clkbuf_4
X_3274_ _3388_/CLK _3274_/D load_slew261/X vssd1 vssd1 vccd1 vccd1 _3274_/Q sky130_fd_sc_hd__dfrtp_2
Xload_slew264 fanout263/X vssd1 vssd1 vccd1 vccd1 load_slew264/X sky130_fd_sc_hd__buf_2
Xload_slew253 fanout252/X vssd1 vssd1 vccd1 vccd1 load_slew253/X sky130_fd_sc_hd__clkbuf_2
Xload_slew286 fanout285/X vssd1 vssd1 vccd1 vccd1 load_slew286/X sky130_fd_sc_hd__clkbuf_4
X_2225_ _2223_/Y _2225_/B vssd1 vssd1 vccd1 vccd1 _2234_/A sky130_fd_sc_hd__nand2b_2
X_2156_ _2205_/A _2352_/B _2188_/A _2157_/C vssd1 vssd1 vccd1 vccd1 _2175_/A sky130_fd_sc_hd__a22o_2
XTAP_TAPCELL_ROW_64_720 vssd1 vccd1 sky130_fd_sc_hd__tapvpwrvgnd_1
XFILLER_26_427 vssd1 vssd1 vccd1 vccd1 sky130_fd_sc_hd__fill_4
XANTENNA__2863__S _2864_/S vssd1 vssd1 vccd1 vccd1 sky130_fd_sc_hd__diode_2
Xclkbuf_leaf_18_clk clkload5/A vssd1 vssd1 vccd1 vccd1 _3404_/CLK sky130_fd_sc_hd__clkbuf_8
X_2087_ _1979_/B _3029_/Q _2050_/Y _2078_/A _2077_/A vssd1 vssd1 vccd1 vccd1 _2089_/C
+ sky130_fd_sc_hd__a311o_2
XPHY_EDGE_ROW_5_Right_5 vssd1 vssd1 vccd1 vccd1 sky130_fd_sc_hd__decap_3
XTAP_TAPCELL_ROW_36_477 vssd1 vccd1 sky130_fd_sc_hd__tapvpwrvgnd_1
XFILLER_34_493 vssd1 vssd1 vccd1 vccd1 sky130_fd_sc_hd__fill_1
X_2989_ _2997_/A vssd1 vssd1 vccd1 vccd1 _2989_/Y sky130_fd_sc_hd__inv_2
XANTENNA_fanout122_X _2973_/A1 vssd1 vssd1 vccd1 vccd1 sky130_fd_sc_hd__diode_2
XANTENNA__2611__B _2781_/B vssd1 vssd1 vccd1 vccd1 sky130_fd_sc_hd__diode_2
XFILLER_67_36 vssd1 vssd1 vccd1 vccd1 sky130_fd_sc_hd__fill_4
XFILLER_69_390 vssd1 vssd1 vccd1 vccd1 sky130_fd_sc_hd__fill_2
XANTENNA__2484__A2 _2667_/B vssd1 vssd1 vccd1 vccd1 sky130_fd_sc_hd__diode_2
XTAP_TAPCELL_ROW_27_400 vssd1 vccd1 sky130_fd_sc_hd__tapvpwrvgnd_1
XANTENNA__2773__S _2776_/S vssd1 vssd1 vccd1 vccd1 sky130_fd_sc_hd__diode_2
XANTENNA__1897__B _2029_/C vssd1 vssd1 vccd1 vccd1 sky130_fd_sc_hd__diode_2
XANTENNA_fanout35_X _2864_/S vssd1 vssd1 vccd1 vccd1 sky130_fd_sc_hd__diode_2
XFILLER_44_279 vssd1 vssd1 vccd1 vccd1 sky130_fd_sc_hd__fill_1
XFILLER_44_268 vssd1 vssd1 vccd1 vccd1 sky130_fd_sc_hd__fill_1
XFILLER_44_257 vssd1 vssd1 vccd1 vccd1 sky130_fd_sc_hd__fill_2
XFILLER_25_471 vssd1 vssd1 vccd1 vccd1 sky130_fd_sc_hd__fill_2
XANTENNA__1995__A1 _2025_/A vssd1 vssd1 vccd1 vccd1 sky130_fd_sc_hd__diode_2
XTAP_TAPCELL_ROW_70_767 vssd1 vccd1 sky130_fd_sc_hd__tapvpwrvgnd_1
XFILLER_12_143 vssd1 vssd1 vccd1 vccd1 sky130_fd_sc_hd__fill_1
XFILLER_8_136 vssd1 vssd1 vccd1 vccd1 sky130_fd_sc_hd__fill_4
XFILLER_59_9 vssd1 vssd1 vccd1 vccd1 sky130_fd_sc_hd__fill_1
XANTENNA__3406__Q _3406_/Q vssd1 vssd1 vccd1 vccd1 sky130_fd_sc_hd__diode_2
XANTENNA__2172__B2 _2297_/A vssd1 vssd1 vccd1 vccd1 sky130_fd_sc_hd__diode_2
XFILLER_79_165 vssd1 vssd1 vccd1 vccd1 sky130_fd_sc_hd__fill_2
XTAP_TAPCELL_ROW_78_834 vssd1 vccd1 sky130_fd_sc_hd__tapvpwrvgnd_1
XFILLER_67_349 vssd1 vssd1 vccd1 vccd1 sky130_fd_sc_hd__fill_2
X_2010_ _2010_/A _2010_/B vssd1 vssd1 vccd1 vccd1 _2012_/B sky130_fd_sc_hd__xor2_2
XANTENNA__2683__S _2685_/S vssd1 vssd1 vccd1 vccd1 sky130_fd_sc_hd__diode_2
XFILLER_75_393 vssd1 vssd1 vccd1 vccd1 sky130_fd_sc_hd__fill_2
X_2912_ _3337_/Q _2968_/A2 _2968_/B1 _3319_/Q _2911_/X vssd1 vssd1 vccd1 vccd1 _2912_/X
+ sky130_fd_sc_hd__a221o_2
XFILLER_16_493 vssd1 vssd1 vccd1 vccd1 sky130_fd_sc_hd__fill_1
X_2843_ hold407/X _2620_/X _2856_/S vssd1 vssd1 vccd1 vccd1 _3347_/D sky130_fd_sc_hd__mux2_1
X_2774_ hold480/X _2634_/X _2780_/S vssd1 vssd1 vccd1 vccd1 _3282_/D sky130_fd_sc_hd__mux2_1
X_1725_ _1725_/A _1725_/B vssd1 vssd1 vccd1 vccd1 _1725_/Y sky130_fd_sc_hd__xnor2_2
Xclkbuf_leaf_7_clk clkload1/A vssd1 vssd1 vccd1 vccd1 _3423_/CLK sky130_fd_sc_hd__clkbuf_8
X_1656_ _3075_/Q _3058_/Q vssd1 vssd1 vccd1 vccd1 _1656_/Y sky130_fd_sc_hd__nor2_2
XANTENNA__2858__S _3437_/D vssd1 vssd1 vccd1 vccd1 sky130_fd_sc_hd__diode_2
X_1587_ _3429_/Q _2590_/A hold372/X vssd1 vssd1 vccd1 vccd1 _3429_/D sky130_fd_sc_hd__a21o_2
X_3326_ _3404_/CLK _3326_/D load_slew281/X vssd1 vssd1 vccd1 vccd1 _3326_/Q sky130_fd_sc_hd__dfrtp_2
XFILLER_58_349 vssd1 vssd1 vccd1 vccd1 sky130_fd_sc_hd__fill_1
XANTENNA_fanout284_A fanout289/X vssd1 vssd1 vccd1 vccd1 sky130_fd_sc_hd__diode_2
X_3257_ _3287_/CLK _3257_/D load_slew230/X vssd1 vssd1 vccd1 vccd1 _3257_/Q sky130_fd_sc_hd__dfrtp_2
X_3188_ _3388_/CLK _3188_/D fanout239/X vssd1 vssd1 vccd1 vccd1 _3188_/Q sky130_fd_sc_hd__dfrtp_2
X_2208_ _2188_/A _2188_/B _2188_/C _2191_/A vssd1 vssd1 vccd1 vccd1 _2208_/X sky130_fd_sc_hd__a31o_2
X_2139_ _2139_/A _2139_/B vssd1 vssd1 vccd1 vccd1 _2141_/B sky130_fd_sc_hd__nor2_2
XTAP_TAPCELL_ROW_49_591 vssd1 vccd1 sky130_fd_sc_hd__tapvpwrvgnd_1
XFILLER_41_238 vssd1 vssd1 vccd1 vccd1 sky130_fd_sc_hd__fill_2
XPHY_EDGE_ROW_14_Left_94 vssd1 vssd1 vccd1 vccd1 sky130_fd_sc_hd__decap_3
XFILLER_22_452 vssd1 vssd1 vccd1 vccd1 sky130_fd_sc_hd__fill_1
XFILLER_22_485 vssd1 vssd1 vccd1 vccd1 sky130_fd_sc_hd__fill_8
XFILLER_5_117 vssd1 vssd1 vccd1 vccd1 sky130_fd_sc_hd__fill_2
XFILLER_78_24 vssd1 vssd1 vccd1 vccd1 sky130_fd_sc_hd__fill_4
XANTENNA__2768__S _2780_/S vssd1 vssd1 vccd1 vccd1 sky130_fd_sc_hd__diode_2
Xhold681 _3191_/Q vssd1 vssd1 vccd1 vccd1 hold681/X sky130_fd_sc_hd__dlygate4sd3_1
Xhold670 _2576_/X vssd1 vssd1 vccd1 vccd1 _3128_/D sky130_fd_sc_hd__dlygate4sd3_1
XFILLER_78_57 vssd1 vssd1 vccd1 vccd1 sky130_fd_sc_hd__fill_8
Xhold692 _3159_/Q vssd1 vssd1 vccd1 vccd1 hold692/X sky130_fd_sc_hd__dlygate4sd3_1
XFILLER_1_389 vssd1 vssd1 vccd1 vccd1 sky130_fd_sc_hd__fill_2
XFILLER_76_146 vssd1 vssd1 vccd1 vccd1 sky130_fd_sc_hd__fill_1
XFILLER_27_72 vssd1 vssd1 vccd1 vccd1 sky130_fd_sc_hd__fill_4
XFILLER_27_50 vssd1 vssd1 vccd1 vccd1 sky130_fd_sc_hd__fill_4
XFILLER_17_279 vssd1 vssd1 vccd1 vccd1 sky130_fd_sc_hd__fill_1
XANTENNA_clkbuf_3_7__f_clk_A clkbuf_0_clk/X vssd1 vssd1 vccd1 vccd1 sky130_fd_sc_hd__diode_2
XTAP_TAPCELL_ROW_30_428 vssd1 vccd1 sky130_fd_sc_hd__tapvpwrvgnd_1
XFILLER_43_71 vssd1 vssd1 vccd1 vccd1 sky130_fd_sc_hd__fill_1
X_2490_ hold688/X wire59/X _2489_/X _1602_/X vssd1 vssd1 vccd1 vccd1 _3093_/D sky130_fd_sc_hd__a22o_2
X_1510_ _3379_/Q input3/X _1515_/A vssd1 vssd1 vccd1 vccd1 _1525_/S sky130_fd_sc_hd__nand3_2
XANTENNA__2678__S _2681_/S vssd1 vssd1 vccd1 vccd1 sky130_fd_sc_hd__diode_2
XFILLER_4_43 vssd1 vssd1 vccd1 vccd1 sky130_fd_sc_hd__fill_2
XFILLER_4_21 vssd1 vssd1 vccd1 vccd1 sky130_fd_sc_hd__fill_4
X_3111_ clkload8/A _3111_/D load_slew210/X vssd1 vssd1 vccd1 vccd1 _3111_/Q sky130_fd_sc_hd__dfrtp_2
XFILLER_67_102 vssd1 vssd1 vccd1 vccd1 sky130_fd_sc_hd__fill_2
XFILLER_67_135 vssd1 vssd1 vccd1 vccd1 sky130_fd_sc_hd__fill_1
XANTENNA__2448__A2 _2667_/B vssd1 vssd1 vccd1 vccd1 sky130_fd_sc_hd__diode_2
X_3042_ _3349_/CLK _3042_/D load_slew205/X vssd1 vssd1 vccd1 vccd1 _3042_/Q sky130_fd_sc_hd__dfrtp_2
XFILLER_55_308 vssd1 vssd1 vccd1 vccd1 sky130_fd_sc_hd__fill_4
XFILLER_48_371 vssd1 vssd1 vccd1 vccd1 sky130_fd_sc_hd__fill_1
XTAP_TAPCELL_ROW_46_561 vssd1 vccd1 sky130_fd_sc_hd__tapvpwrvgnd_1
XANTENNA__1757__S _1773_/S vssd1 vssd1 vccd1 vccd1 sky130_fd_sc_hd__diode_2
XANTENNA__2620__A2 _2610_/A vssd1 vssd1 vccd1 vccd1 sky130_fd_sc_hd__diode_2
X_2826_ hold552/X _2845_/A1 _2837_/S vssd1 vssd1 vccd1 vccd1 _3331_/D sky130_fd_sc_hd__mux2_1
X_2757_ hold523/X _2814_/A1 _2757_/S vssd1 vssd1 vccd1 vccd1 _3266_/D sky130_fd_sc_hd__mux2_1
X_2688_ hold459/X _2802_/A1 _2700_/S vssd1 vssd1 vccd1 vccd1 _3200_/D sky130_fd_sc_hd__mux2_1
X_1708_ hold686/X _1707_/Y _1738_/S vssd1 vssd1 vccd1 vccd1 _3015_/D sky130_fd_sc_hd__mux2_1
XANTENNA__3046__Q _3046_/Q vssd1 vssd1 vccd1 vccd1 sky130_fd_sc_hd__diode_2
X_1639_ _1646_/A _1639_/B vssd1 vssd1 vccd1 vccd1 _1640_/B sky130_fd_sc_hd__nor2_2
XANTENNA_input4_A gpio_in[2] vssd1 vssd1 vccd1 vccd1 sky130_fd_sc_hd__diode_2
XFILLER_48_27 vssd1 vssd1 vccd1 vccd1 sky130_fd_sc_hd__fill_1
X_3309_ _3441_/CLK _3309_/D fanout266/X vssd1 vssd1 vccd1 vccd1 _3309_/Q sky130_fd_sc_hd__dfrtp_2
XFILLER_58_179 vssd1 vssd1 vccd1 vccd1 sky130_fd_sc_hd__fill_1
XFILLER_64_37 vssd1 vccd1 vssd1 vccd1 sky130_ef_sc_hd__decap_40_12
Xfanout20 _2762_/X vssd1 vssd1 vccd1 vccd1 _2776_/S sky130_fd_sc_hd__clkdlybuf4s25_1
Xfanout31 _2648_/X vssd1 vssd1 vccd1 vccd1 _2666_/S sky130_fd_sc_hd__clkdlybuf4s25_1
XFILLER_14_249 vssd1 vssd1 vccd1 vccd1 sky130_fd_sc_hd__fill_2
Xfanout42 _2636_/X vssd1 vssd1 vccd1 vccd1 _2813_/A1 sky130_fd_sc_hd__clkdlybuf4s25_1
Xfanout53 _2614_/X vssd1 vssd1 vccd1 vccd1 _2802_/A1 sky130_fd_sc_hd__clkdlybuf4s25_1
Xfanout64 _2445_/X vssd1 vssd1 vccd1 vccd1 _2923_/A2 sky130_fd_sc_hd__clkdlybuf4s25_1
Xfanout75 _2440_/Y vssd1 vssd1 vccd1 vccd1 _2800_/B sky130_fd_sc_hd__clkdlybuf4s25_1
Xfanout86 _1622_/C vssd1 vssd1 vccd1 vccd1 _2587_/A2 sky130_fd_sc_hd__clkdlybuf4s25_1
Xfanout97 _2421_/B vssd1 vssd1 vccd1 vccd1 _2091_/B sky130_fd_sc_hd__clkdlybuf4s25_1
XFILLER_22_293 vssd1 vssd1 vccd1 vccd1 sky130_fd_sc_hd__fill_4
XFILLER_10_477 vssd1 vssd1 vccd1 vccd1 sky130_fd_sc_hd__fill_4
XFILLER_1_142 vssd1 vccd1 vssd1 vccd1 sky130_ef_sc_hd__decap_40_12
XFILLER_49_113 vssd1 vssd1 vccd1 vccd1 sky130_fd_sc_hd__fill_8
XFILLER_72_160 vssd1 vssd1 vccd1 vccd1 sky130_fd_sc_hd__fill_2
X_1990_ _1952_/Y _1956_/B _1989_/A _1989_/B _1954_/B vssd1 vssd1 vccd1 vccd1 _1994_/B
+ sky130_fd_sc_hd__o221ai_2
XTAP_TAPCELL_ROW_15_299 vssd1 vccd1 sky130_fd_sc_hd__tapvpwrvgnd_1
Xclkload12 _3101_/CLK vssd1 vssd1 vccd1 vccd1 clkload12/Y sky130_fd_sc_hd__clkinv_2
X_2611_ _2611_/A _2781_/B _2800_/C vssd1 vssd1 vccd1 vccd1 _2611_/X sky130_fd_sc_hd__and3_2
X_2542_ _1582_/Y wire106/X _2588_/C vssd1 vssd1 vccd1 vccd1 _2542_/Y sky130_fd_sc_hd__o21ai_2
XFILLER_5_492 vssd1 vssd1 vccd1 vccd1 sky130_fd_sc_hd__fill_2
X_2473_ _3255_/Q _2667_/B _2648_/B _3237_/Q _2472_/X vssd1 vssd1 vccd1 vccd1 _2473_/X
+ sky130_fd_sc_hd__a221o_2
XFILLER_68_411 vssd1 vssd1 vccd1 vccd1 sky130_fd_sc_hd__fill_2
X_3025_ _3204_/CLK _3025_/D fanout206/X vssd1 vssd1 vccd1 vccd1 _3025_/Q sky130_fd_sc_hd__dfrtp_2
Xclkload6 clkload6/A vssd1 vssd1 vccd1 vccd1 clkload6/X sky130_fd_sc_hd__clkbuf_4
X_2809_ hold613/X _2809_/A1 _2814_/S vssd1 vssd1 vccd1 vccd1 _3315_/D sky130_fd_sc_hd__mux2_1
XANTENNA__2900__A _2900_/A vssd1 vssd1 vccd1 vccd1 sky130_fd_sc_hd__diode_2
XANTENNA__2109__B2 _2421_/B vssd1 vssd1 vccd1 vccd1 sky130_fd_sc_hd__diode_2
Xfanout221 fanout223/X vssd1 vssd1 vccd1 vccd1 wire222/A sky130_fd_sc_hd__clkdlybuf4s25_1
XTAP_TAPCELL_ROW_6_223 vssd1 vccd1 sky130_fd_sc_hd__tapvpwrvgnd_1
Xfanout243 fanout251/X vssd1 vssd1 vccd1 vccd1 fanout243/X sky130_fd_sc_hd__clkdlybuf4s25_1
Xfanout254 fanout259/X vssd1 vssd1 vccd1 vccd1 fanout254/X sky130_fd_sc_hd__clkdlybuf4s25_1
Xfanout265 fanout290/X vssd1 vssd1 vccd1 vccd1 fanout265/X sky130_fd_sc_hd__clkdlybuf4s25_1
Xfanout287 fanout289/X vssd1 vssd1 vccd1 vccd1 fanout287/X sky130_fd_sc_hd__clkdlybuf4s25_1
XFILLER_75_36 vssd1 vssd1 vccd1 vccd1 sky130_fd_sc_hd__fill_1
XFILLER_19_319 vssd1 vssd1 vccd1 vccd1 sky130_fd_sc_hd__fill_4
XANTENNA__2347__A _2347_/A vssd1 vssd1 vccd1 vccd1 sky130_fd_sc_hd__diode_2
XTAP_TAPCELL_ROW_57_656 vssd1 vccd1 sky130_fd_sc_hd__tapvpwrvgnd_1
XTAP_TAPCELL_ROW_40_512 vssd1 vccd1 sky130_fd_sc_hd__tapvpwrvgnd_1
XANTENNA__2348__A1 _2347_/A vssd1 vssd1 vccd1 vccd1 sky130_fd_sc_hd__diode_2
XANTENNA__2899__A2 _2967_/A2 vssd1 vssd1 vccd1 vccd1 sky130_fd_sc_hd__diode_2
XFILLER_69_219 vssd1 vssd1 vccd1 vccd1 sky130_fd_sc_hd__fill_4
XFILLER_77_285 vssd1 vssd1 vccd1 vccd1 sky130_fd_sc_hd__fill_2
XFILLER_1_99 vssd1 vssd1 vccd1 vccd1 sky130_fd_sc_hd__fill_2
XANTENNA__2691__S _2704_/S vssd1 vssd1 vccd1 vccd1 sky130_fd_sc_hd__diode_2
XANTENNA__2036__B1 _2025_/A vssd1 vssd1 vccd1 vccd1 sky130_fd_sc_hd__diode_2
X_1973_ _1973_/A _1973_/B vssd1 vssd1 vccd1 vccd1 _1974_/B sky130_fd_sc_hd__nand2_2
X_2525_ _3187_/Q _2960_/A2 wire66/X _3169_/Q _2524_/X vssd1 vssd1 vccd1 vccd1 _2525_/X
+ sky130_fd_sc_hd__a221o_2
X_2456_ _3326_/Q _2894_/A2 _2456_/B1 _3308_/Q _2455_/X vssd1 vssd1 vccd1 vccd1 _2456_/X
+ sky130_fd_sc_hd__a221o_2
X_2387_ _2387_/A _2387_/B vssd1 vssd1 vccd1 vccd1 _2388_/B sky130_fd_sc_hd__xnor2_2
XFILLER_28_127 vssd1 vssd1 vccd1 vccd1 sky130_fd_sc_hd__fill_2
X_3008_ _3132_/CLK _3008_/D load_slew220/X vssd1 vssd1 vccd1 vccd1 _3008_/Q sky130_fd_sc_hd__dfrtp_2
XFILLER_36_160 vssd1 vssd1 vccd1 vccd1 sky130_fd_sc_hd__fill_4
XANTENNA__2027__B1 _2029_/C vssd1 vssd1 vccd1 vccd1 sky130_fd_sc_hd__diode_2
XFILLER_10_97 vssd1 vssd1 vccd1 vccd1 sky130_fd_sc_hd__fill_8
XANTENNA__2776__S _2776_/S vssd1 vssd1 vccd1 vccd1 sky130_fd_sc_hd__diode_2
XFILLER_74_255 vssd1 vssd1 vccd1 vccd1 sky130_fd_sc_hd__fill_1
XTAP_TAPCELL_ROW_17_317 vssd1 vccd1 sky130_fd_sc_hd__tapvpwrvgnd_1
XFILLER_74_288 vssd1 vssd1 vccd1 vccd1 sky130_fd_sc_hd__fill_8
XFILLER_15_333 vssd1 vssd1 vccd1 vccd1 sky130_fd_sc_hd__fill_1
XFILLER_42_141 vssd1 vssd1 vccd1 vccd1 sky130_fd_sc_hd__fill_2
XANTENNA__2524__B _2957_/C vssd1 vssd1 vccd1 vccd1 sky130_fd_sc_hd__diode_2
XTAP_TAPCELL_ROW_25_383 vssd1 vccd1 sky130_fd_sc_hd__tapvpwrvgnd_1
XPHY_EDGE_ROW_2_Left_82 vssd1 vssd1 vccd1 vccd1 sky130_fd_sc_hd__decap_3
XANTENNA__2540__A _2540_/A vssd1 vssd1 vccd1 vccd1 sky130_fd_sc_hd__diode_2
XANTENNA_load_slew73_X _2894_/B1 vssd1 vssd1 vccd1 vccd1 sky130_fd_sc_hd__diode_2
X_3290_ _3297_/CLK _3290_/D load_slew273/X vssd1 vssd1 vccd1 vccd1 _3290_/Q sky130_fd_sc_hd__dfrtp_2
X_2310_ _2237_/X _2241_/B _2272_/A _2272_/B _2239_/B vssd1 vssd1 vccd1 vccd1 _2311_/B
+ sky130_fd_sc_hd__o221ai_2
X_2241_ _2241_/A _2241_/B vssd1 vssd1 vccd1 vccd1 _2241_/Y sky130_fd_sc_hd__xnor2_2
X_2172_ _2205_/A _2255_/A _2255_/B _2297_/A vssd1 vssd1 vccd1 vccd1 _2175_/C sky130_fd_sc_hd__a22o_2
XFILLER_18_3 vssd1 vccd1 vssd1 vccd1 sky130_ef_sc_hd__decap_40_12
XFILLER_65_266 vssd1 vssd1 vccd1 vccd1 sky130_fd_sc_hd__fill_1
XTAP_TAPCELL_ROW_51_607 vssd1 vccd1 sky130_fd_sc_hd__tapvpwrvgnd_1
XFILLER_33_163 vssd1 vssd1 vccd1 vccd1 sky130_fd_sc_hd__fill_2
X_1956_ _1956_/A _1956_/B vssd1 vssd1 vccd1 vccd1 _1956_/Y sky130_fd_sc_hd__xnor2_2
XFILLER_21_347 vssd1 vssd1 vccd1 vccd1 sky130_fd_sc_hd__fill_1
XANTENNA__1765__S _3435_/D vssd1 vssd1 vccd1 vccd1 sky130_fd_sc_hd__diode_2
X_1887_ _1869_/A _1869_/B _1869_/C _1872_/A vssd1 vssd1 vccd1 vccd1 _1887_/X sky130_fd_sc_hd__a31o_2
XANTENNA_fanout112_A _2972_/A1 vssd1 vssd1 vccd1 vccd1 sky130_fd_sc_hd__diode_2
X_2508_ _3222_/Q _2967_/A2 _2505_/X _2973_/A1 _2507_/X vssd1 vssd1 vccd1 vccd1 _2514_/A
+ sky130_fd_sc_hd__a221o_2
Xteam_02_304 vssd1 vssd1 vccd1 vccd1 team_02_304/HI gpio_out[7] sky130_fd_sc_hd__conb_1
Xteam_02_315 vssd1 vssd1 vccd1 vccd1 team_02_315/HI gpio_out[18] sky130_fd_sc_hd__conb_1
Xteam_02_326 vssd1 vssd1 vccd1 vccd1 team_02_326/HI gpio_out[29] sky130_fd_sc_hd__conb_1
X_2439_ _2533_/A _2533_/B _3271_/Q vssd1 vssd1 vccd1 vccd1 _2439_/X sky130_fd_sc_hd__and3_2
Xteam_02_337 vssd1 vssd1 vccd1 vccd1 gpio_oeb[7] team_02_337/LO sky130_fd_sc_hd__conb_1
Xteam_02_348 vssd1 vssd1 vccd1 vccd1 gpio_oeb[18] team_02_348/LO sky130_fd_sc_hd__conb_1
Xteam_02_359 vssd1 vssd1 vccd1 vccd1 gpio_oeb[29] team_02_359/LO sky130_fd_sc_hd__conb_1
XFILLER_56_27 vssd1 vssd1 vccd1 vccd1 sky130_fd_sc_hd__fill_1
XFILLER_29_425 vssd1 vssd1 vccd1 vccd1 sky130_fd_sc_hd__fill_1
XTAP_TAPCELL_ROW_67_740 vssd1 vccd1 sky130_fd_sc_hd__tapvpwrvgnd_1
XFILLER_29_447 vssd1 vssd1 vccd1 vccd1 sky130_fd_sc_hd__fill_1
XFILLER_12_369 vssd1 vssd1 vccd1 vccd1 sky130_fd_sc_hd__fill_2
XFILLER_79_369 vssd1 vssd1 vccd1 vccd1 sky130_fd_sc_hd__fill_2
XFILLER_62_225 vssd1 vssd1 vccd1 vccd1 sky130_fd_sc_hd__fill_1
XFILLER_35_439 vssd1 vssd1 vccd1 vccd1 sky130_fd_sc_hd__fill_8
XANTENNA__2535__A _2926_/B vssd1 vssd1 vccd1 vccd1 sky130_fd_sc_hd__diode_2
XANTENNA__3459__CLK _3463_/CLK vssd1 vssd1 vccd1 vccd1 sky130_fd_sc_hd__diode_2
X_1810_ _1810_/A _1834_/A _1810_/C vssd1 vssd1 vccd1 vccd1 _1817_/A sky130_fd_sc_hd__and3_2
XFILLER_62_81 vssd1 vssd1 vccd1 vccd1 sky130_fd_sc_hd__fill_2
X_2790_ hold457/X _2809_/A1 _2799_/S vssd1 vssd1 vccd1 vccd1 _3297_/D sky130_fd_sc_hd__mux2_1
XFILLER_7_21 vssd1 vssd1 vccd1 vccd1 sky130_fd_sc_hd__fill_1
X_1741_ _1738_/S _1735_/B _1740_/X _1739_/X vssd1 vssd1 vccd1 vccd1 _3021_/D sky130_fd_sc_hd__a31o_2
XANTENNA__2962__A1 _2962_/A1 vssd1 vssd1 vccd1 vccd1 sky130_fd_sc_hd__diode_2
XANTENNA__2962__B2 _2973_/A1 vssd1 vssd1 vccd1 vccd1 sky130_fd_sc_hd__diode_2
X_1672_ _1670_/Y _1672_/B vssd1 vssd1 vccd1 vccd1 _1675_/A sky130_fd_sc_hd__and2b_2
X_3411_ _3423_/CLK _3411_/D load_slew225/X vssd1 vssd1 vccd1 vccd1 _3411_/Q sky130_fd_sc_hd__dfrtp_2
X_3342_ _3398_/CLK _3342_/D load_slew256/X vssd1 vssd1 vccd1 vccd1 _3342_/Q sky130_fd_sc_hd__dfrtp_2
Xload_slew210 fanout209/X vssd1 vssd1 vccd1 vccd1 load_slew210/X sky130_fd_sc_hd__clkbuf_4
X_3273_ _3437_/CLK _3273_/D fanout262/X vssd1 vssd1 vccd1 vccd1 _3273_/Q sky130_fd_sc_hd__dfrtp_2
Xload_slew232 fanout231/X vssd1 vssd1 vccd1 vccd1 load_slew232/X sky130_fd_sc_hd__clkbuf_4
XANTENNA__2478__B1 _2477_/X vssd1 vssd1 vccd1 vccd1 sky130_fd_sc_hd__diode_2
Xload_slew276 fanout275/X vssd1 vssd1 vccd1 vccd1 load_slew276/X sky130_fd_sc_hd__buf_2
X_2224_ _2224_/A _2224_/B _2224_/C vssd1 vssd1 vccd1 vccd1 _2225_/B sky130_fd_sc_hd__nand3_2
X_2155_ _2132_/A _2257_/A _2264_/A _3046_/Q vssd1 vssd1 vccd1 vccd1 _2157_/C sky130_fd_sc_hd__a22o_2
X_2086_ hold701/X _2085_/Y _2412_/S vssd1 vssd1 vccd1 vccd1 _3067_/D sky130_fd_sc_hd__mux2_1
XFILLER_53_225 vssd1 vssd1 vccd1 vccd1 sky130_fd_sc_hd__fill_4
XTAP_TAPCELL_ROW_36_478 vssd1 vccd1 sky130_fd_sc_hd__tapvpwrvgnd_1
XFILLER_21_100 vssd1 vssd1 vccd1 vccd1 sky130_fd_sc_hd__fill_1
XFILLER_42_29 vssd1 vssd1 vccd1 vccd1 sky130_fd_sc_hd__fill_8
X_2988_ _2997_/A vssd1 vssd1 vccd1 vccd1 _2988_/Y sky130_fd_sc_hd__inv_2
X_1939_ _1939_/A _1939_/B _1939_/C vssd1 vssd1 vccd1 vccd1 _1942_/B sky130_fd_sc_hd__nand3_2
XANTENNA__2953__A1 _2962_/A1 vssd1 vssd1 vccd1 vccd1 sky130_fd_sc_hd__diode_2
XANTENNA__2953__B2 _2961_/A1 vssd1 vssd1 vccd1 vccd1 sky130_fd_sc_hd__diode_2
XANTENNA_fanout115_X _2972_/A1 vssd1 vssd1 vccd1 vccd1 sky130_fd_sc_hd__diode_2
XFILLER_67_15 vssd1 vssd1 vccd1 vccd1 sky130_fd_sc_hd__fill_2
XTAP_TAPCELL_ROW_27_401 vssd1 vccd1 sky130_fd_sc_hd__tapvpwrvgnd_1
XFILLER_29_277 vssd1 vssd1 vccd1 vccd1 sky130_fd_sc_hd__fill_1
XFILLER_29_255 vssd1 vssd1 vccd1 vccd1 sky130_fd_sc_hd__fill_1
XFILLER_17_439 vssd1 vssd1 vccd1 vccd1 sky130_fd_sc_hd__fill_1
XANTENNA__1897__C _1962_/B vssd1 vssd1 vccd1 vccd1 sky130_fd_sc_hd__diode_2
XPHY_EDGE_ROW_11_Right_11 vssd1 vssd1 vccd1 vccd1 sky130_fd_sc_hd__decap_3
XFILLER_16_85 vssd1 vccd1 vssd1 vccd1 sky130_ef_sc_hd__decap_40_12
XANTENNA_fanout28_X _2700_/S vssd1 vssd1 vccd1 vccd1 sky130_fd_sc_hd__diode_2
XTAP_TAPCELL_ROW_70_768 vssd1 vccd1 sky130_fd_sc_hd__tapvpwrvgnd_1
XFILLER_8_115 vssd1 vccd1 vssd1 vccd1 sky130_ef_sc_hd__decap_40_12
XFILLER_32_62 vssd1 vccd1 vssd1 vccd1 sky130_ef_sc_hd__decap_40_12
XFILLER_4_365 vssd1 vssd1 vccd1 vccd1 sky130_fd_sc_hd__fill_2
XPHY_EDGE_ROW_20_Right_20 vssd1 vssd1 vccd1 vccd1 sky130_fd_sc_hd__decap_3
XFILLER_79_111 vssd1 vssd1 vccd1 vccd1 sky130_fd_sc_hd__fill_1
XTAP_TAPCELL_ROW_78_835 vssd1 vccd1 sky130_fd_sc_hd__tapvpwrvgnd_1
XFILLER_67_339 vssd1 vssd1 vccd1 vccd1 sky130_fd_sc_hd__fill_1
XFILLER_57_92 vssd1 vssd1 vccd1 vccd1 sky130_fd_sc_hd__fill_1
XFILLER_35_225 vssd1 vssd1 vccd1 vccd1 sky130_fd_sc_hd__fill_1
XFILLER_50_206 vssd1 vssd1 vccd1 vccd1 sky130_fd_sc_hd__fill_4
X_2911_ _2964_/B _2964_/C _3355_/Q vssd1 vssd1 vccd1 vccd1 _2911_/X sky130_fd_sc_hd__and3_2
XFILLER_73_80 vssd1 vccd1 vssd1 vccd1 sky130_ef_sc_hd__decap_40_12
XFILLER_16_472 vssd1 vssd1 vccd1 vccd1 sky130_fd_sc_hd__fill_2
XFILLER_43_291 vssd1 vssd1 vccd1 vccd1 sky130_fd_sc_hd__fill_1
X_2842_ hold624/X _2842_/A1 _2856_/S vssd1 vssd1 vccd1 vccd1 _3346_/D sky130_fd_sc_hd__mux2_1
X_2773_ hold411/X _2811_/A1 _2776_/S vssd1 vssd1 vccd1 vccd1 _3281_/D sky130_fd_sc_hd__mux2_1
XANTENNA__2935__A1 _2973_/A1 vssd1 vssd1 vccd1 vccd1 sky130_fd_sc_hd__diode_2
XANTENNA__2935__B2 _2966_/A1 vssd1 vssd1 vccd1 vccd1 sky130_fd_sc_hd__diode_2
X_1724_ _1715_/Y _1719_/B _1717_/B vssd1 vssd1 vccd1 vccd1 _1725_/B sky130_fd_sc_hd__o21ai_2
X_1655_ hold710/X _1739_/B _1653_/X _1654_/Y vssd1 vssd1 vccd1 vccd1 _3007_/D sky130_fd_sc_hd__a22o_2
X_1586_ _3441_/Q _3441_/D vssd1 vssd1 vccd1 vccd1 _3438_/D sky130_fd_sc_hd__and2b_2
X_3325_ _3437_/CLK _3325_/D fanout262/X vssd1 vssd1 vccd1 vccd1 _3325_/Q sky130_fd_sc_hd__dfrtp_2
X_3256_ _3383_/CLK _3256_/D fanout238/X vssd1 vssd1 vccd1 vccd1 _3256_/Q sky130_fd_sc_hd__dfrtp_2
X_2207_ _2206_/B _2206_/C _2206_/A vssd1 vssd1 vccd1 vccd1 _2207_/Y sky130_fd_sc_hd__a21oi_2
XANTENNA_fanout277_A fanout279/X vssd1 vssd1 vccd1 vccd1 sky130_fd_sc_hd__diode_2
X_3187_ _3287_/CLK _3187_/D load_slew230/X vssd1 vssd1 vccd1 vccd1 _3187_/Q sky130_fd_sc_hd__dfrtp_2
XFILLER_73_309 vssd1 vssd1 vccd1 vccd1 sky130_fd_sc_hd__fill_2
XANTENNA__1998__B _1998_/B vssd1 vssd1 vccd1 vccd1 sky130_fd_sc_hd__diode_2
X_2138_ _2138_/A _2138_/B vssd1 vssd1 vccd1 vccd1 _2139_/B sky130_fd_sc_hd__nor2_2
XTAP_TAPCELL_ROW_49_592 vssd1 vccd1 sky130_fd_sc_hd__tapvpwrvgnd_1
X_2069_ _2065_/Y _2067_/X _2066_/X _2046_/B vssd1 vssd1 vccd1 vccd1 _2070_/A sky130_fd_sc_hd__o211a_2
Xteam_02 vssd1 vssd1 vccd1 vccd1 team_02/HI gpio_oeb[3] sky130_fd_sc_hd__conb_1
XANTENNA_fanout92_A _1574_/X vssd1 vssd1 vccd1 vccd1 sky130_fd_sc_hd__diode_2
Xhold671 _3155_/Q vssd1 vssd1 vccd1 vccd1 hold671/X sky130_fd_sc_hd__dlygate4sd3_1
Xhold660 _3059_/Q vssd1 vssd1 vccd1 vccd1 hold660/X sky130_fd_sc_hd__dlygate4sd3_1
Xhold693 _3163_/Q vssd1 vssd1 vccd1 vccd1 hold693/X sky130_fd_sc_hd__dlygate4sd3_1
Xhold682 _3087_/Q vssd1 vssd1 vccd1 vccd1 _2421_/A sky130_fd_sc_hd__dlygate4sd3_1
XANTENNA__2784__S _2799_/S vssd1 vssd1 vccd1 vccd1 sky130_fd_sc_hd__diode_2
XANTENNA__2614__B1 _2646_/B vssd1 vssd1 vccd1 vccd1 sky130_fd_sc_hd__diode_2
XANTENNA__1968__A2 _2029_/C vssd1 vssd1 vccd1 vccd1 sky130_fd_sc_hd__diode_2
XFILLER_43_83 vssd1 vssd1 vccd1 vccd1 sky130_fd_sc_hd__fill_1
XTAP_TAPCELL_ROW_30_429 vssd1 vccd1 sky130_fd_sc_hd__tapvpwrvgnd_1
XANTENNA__2917__A1 _2942_/B2 vssd1 vssd1 vccd1 vccd1 sky130_fd_sc_hd__diode_2
XANTENNA__2917__B2 _2966_/A1 vssd1 vssd1 vccd1 vccd1 sky130_fd_sc_hd__diode_2
XFILLER_4_195 vssd1 vssd1 vccd1 vccd1 sky130_fd_sc_hd__fill_1
X_3110_ _3204_/CLK _3110_/D fanout206/X vssd1 vssd1 vccd1 vccd1 _3110_/Q sky130_fd_sc_hd__dfrtp_2
XANTENNA__2694__S _2700_/S vssd1 vssd1 vccd1 vccd1 sky130_fd_sc_hd__diode_2
X_3041_ _3204_/CLK _3041_/D load_slew205/X vssd1 vssd1 vccd1 vccd1 _3041_/Q sky130_fd_sc_hd__dfrtp_2
XTAP_TAPCELL_ROW_46_562 vssd1 vccd1 sky130_fd_sc_hd__tapvpwrvgnd_1
X_2825_ hold499/X _2844_/A1 _2837_/S vssd1 vssd1 vccd1 vccd1 _3330_/D sky130_fd_sc_hd__mux2_1
Xclkbuf_3_2__f_clk clkbuf_0_clk/X vssd1 vssd1 vccd1 vccd1 clkload1/A sky130_fd_sc_hd__clkbuf_16
X_2756_ hold608/X _2813_/A1 _2757_/S vssd1 vssd1 vccd1 vccd1 _3265_/D sky130_fd_sc_hd__mux2_1
XANTENNA__1773__S _1773_/S vssd1 vssd1 vccd1 vccd1 sky130_fd_sc_hd__diode_2
X_2687_ hold446/X _2839_/A1 _2704_/S vssd1 vssd1 vccd1 vccd1 _3199_/D sky130_fd_sc_hd__mux2_1
X_1707_ _1707_/A _1707_/B vssd1 vssd1 vccd1 vccd1 _1707_/Y sky130_fd_sc_hd__xnor2_2
X_1638_ _3072_/Q _3055_/Q vssd1 vssd1 vccd1 vccd1 _1639_/B sky130_fd_sc_hd__and2_2
X_1569_ _2588_/A _3144_/Q _2838_/B _1569_/D vssd1 vssd1 vccd1 vccd1 _3413_/D sky130_fd_sc_hd__and4_2
X_3308_ _3450_/CLK _3308_/D load_slew281/X vssd1 vssd1 vccd1 vccd1 _3308_/Q sky130_fd_sc_hd__dfrtp_2
XANTENNA_fanout182_X _2297_/A vssd1 vssd1 vccd1 vccd1 sky130_fd_sc_hd__diode_2
X_3239_ _3287_/CLK _3239_/D load_slew230/X vssd1 vssd1 vccd1 vccd1 _3239_/Q sky130_fd_sc_hd__dfrtp_2
XFILLER_73_117 vssd1 vssd1 vccd1 vccd1 sky130_fd_sc_hd__fill_2
XFILLER_46_309 vssd1 vssd1 vccd1 vccd1 sky130_fd_sc_hd__fill_1
Xfanout21 _2743_/X vssd1 vssd1 vccd1 vccd1 _2761_/S sky130_fd_sc_hd__clkdlybuf4s25_1
Xfanout32 _2648_/X vssd1 vssd1 vccd1 vccd1 _2662_/S sky130_fd_sc_hd__clkdlybuf4s25_1
Xfanout43 _2634_/X vssd1 vssd1 vccd1 vccd1 _2850_/A1 sky130_fd_sc_hd__clkdlybuf4s25_1
Xfanout54 _2612_/X vssd1 vssd1 vccd1 vccd1 _2839_/A1 sky130_fd_sc_hd__clkdlybuf4s25_1
Xfanout65 _2901_/B1 vssd1 vssd1 vccd1 vccd1 wire66/A sky130_fd_sc_hd__clkdlybuf4s25_1
Xfanout76 _2901_/A2 vssd1 vssd1 vccd1 vccd1 _2960_/A2 sky130_fd_sc_hd__clkdlybuf4s25_1
Xfanout87 _1621_/Y vssd1 vssd1 vccd1 vccd1 _1622_/C sky130_fd_sc_hd__clkdlybuf4s25_1
Xfanout98 _1775_/Y vssd1 vssd1 vccd1 vccd1 _2421_/B sky130_fd_sc_hd__clkdlybuf4s25_1
XANTENNA__2352__B _2352_/B vssd1 vssd1 vccd1 vccd1 sky130_fd_sc_hd__diode_2
XFILLER_10_489 vssd1 vssd1 vccd1 vccd1 sky130_fd_sc_hd__fill_4
XANTENNA__1683__S _1690_/S vssd1 vssd1 vccd1 vccd1 sky130_fd_sc_hd__diode_2
XANTENNA__2779__S _2780_/S vssd1 vssd1 vccd1 vccd1 sky130_fd_sc_hd__diode_2
XANTENNA_fanout95_X _2781_/B vssd1 vssd1 vccd1 vccd1 sky130_fd_sc_hd__diode_2
Xhold490 _3176_/Q vssd1 vssd1 vccd1 vccd1 hold490/X sky130_fd_sc_hd__dlygate4sd3_1
XFILLER_1_154 vssd1 vssd1 vccd1 vccd1 sky130_fd_sc_hd__fill_8
XFILLER_49_169 vssd1 vssd1 vccd1 vccd1 sky130_fd_sc_hd__fill_2
XFILLER_45_320 vssd1 vssd1 vccd1 vccd1 sky130_fd_sc_hd__fill_1
XFILLER_38_83 vssd1 vssd1 vccd1 vccd1 sky130_fd_sc_hd__fill_1
XFILLER_9_221 vssd1 vssd1 vccd1 vccd1 sky130_fd_sc_hd__fill_1
XFILLER_9_276 vssd1 vssd1 vccd1 vccd1 sky130_fd_sc_hd__fill_4
Xclkload13 _3423_/CLK vssd1 vssd1 vccd1 vccd1 clkload13/Y sky130_fd_sc_hd__clkinv_2
X_2610_ _2610_/A _2646_/B vssd1 vssd1 vccd1 vccd1 _2838_/C sky130_fd_sc_hd__or2_2
XANTENNA__2689__S _2700_/S vssd1 vssd1 vccd1 vccd1 sky130_fd_sc_hd__diode_2
X_2541_ hold699/X wire59/X _2540_/X _1602_/X vssd1 vssd1 vccd1 vccd1 _3097_/D sky130_fd_sc_hd__a22o_2
X_2472_ _2472_/A _2472_/B _3273_/Q vssd1 vssd1 vccd1 vccd1 _2472_/X sky130_fd_sc_hd__and3_2
XFILLER_48_3 vssd1 vssd1 vccd1 vccd1 sky130_fd_sc_hd__fill_8
XFILLER_68_489 vssd1 vssd1 vccd1 vccd1 sky130_fd_sc_hd__fill_1
X_3024_ _3204_/CLK _3024_/D fanout206/X vssd1 vssd1 vccd1 vccd1 _3024_/Q sky130_fd_sc_hd__dfrtp_2
XANTENNA__2453__A _2540_/A vssd1 vssd1 vccd1 vccd1 sky130_fd_sc_hd__diode_2
XFILLER_51_389 vssd1 vssd1 vccd1 vccd1 sky130_fd_sc_hd__fill_1
Xclkload7 clkload7/A vssd1 vssd1 vccd1 vccd1 clkload7/X sky130_fd_sc_hd__clkbuf_4
XFILLER_50_29 vssd1 vssd1 vccd1 vccd1 sky130_fd_sc_hd__fill_4
X_2808_ hold592/X _2808_/A1 _2814_/S vssd1 vssd1 vccd1 vccd1 _3314_/D sky130_fd_sc_hd__mux2_1
XANTENNA__2900__B _2959_/C vssd1 vssd1 vccd1 vccd1 sky130_fd_sc_hd__diode_2
X_2739_ hold465/X _2815_/A1 _2742_/S vssd1 vssd1 vccd1 vccd1 _3249_/D sky130_fd_sc_hd__mux2_1
XFILLER_78_209 vssd1 vssd1 vccd1 vccd1 sky130_fd_sc_hd__fill_1
Xfanout200 _3022_/Q vssd1 vssd1 vccd1 vccd1 _1805_/A sky130_fd_sc_hd__clkdlybuf4s25_1
Xfanout211 fanout213/X vssd1 vssd1 vccd1 vccd1 fanout211/X sky130_fd_sc_hd__clkdlybuf4s25_1
XTAP_TAPCELL_ROW_6_224 vssd1 vccd1 sky130_fd_sc_hd__tapvpwrvgnd_1
Xfanout233 fanout235/X vssd1 vssd1 vccd1 vccd1 fanout233/X sky130_fd_sc_hd__clkdlybuf4s25_1
Xfanout255 fanout259/X vssd1 vssd1 vccd1 vccd1 fanout255/X sky130_fd_sc_hd__clkdlybuf4s25_1
Xfanout266 fanout270/X vssd1 vssd1 vccd1 vccd1 fanout266/X sky130_fd_sc_hd__clkdlybuf4s25_1
Xfanout277 fanout279/X vssd1 vssd1 vccd1 vccd1 fanout277/X sky130_fd_sc_hd__clkdlybuf4s25_1
XFILLER_74_404 vssd1 vccd1 vssd1 vccd1 sky130_ef_sc_hd__decap_40_12
XFILLER_59_489 vssd1 vssd1 vccd1 vccd1 sky130_fd_sc_hd__fill_4
XFILLER_59_467 vssd1 vssd1 vccd1 vccd1 sky130_fd_sc_hd__fill_1
XANTENNA__2347__B _2399_/A vssd1 vssd1 vccd1 vccd1 sky130_fd_sc_hd__diode_2
XTAP_TAPCELL_ROW_57_657 vssd1 vccd1 sky130_fd_sc_hd__tapvpwrvgnd_1
XFILLER_39_180 vssd1 vssd1 vccd1 vccd1 sky130_fd_sc_hd__fill_1
XFILLER_54_183 vssd1 vssd1 vccd1 vccd1 sky130_fd_sc_hd__fill_2
XTAP_TAPCELL_ROW_40_513 vssd1 vccd1 sky130_fd_sc_hd__tapvpwrvgnd_1
XFILLER_24_85 vssd1 vssd1 vccd1 vccd1 sky130_fd_sc_hd__fill_2
XANTENNA__2348__A2 _2399_/A vssd1 vssd1 vccd1 vccd1 sky130_fd_sc_hd__diode_2
XFILLER_2_463 vssd1 vssd1 vccd1 vccd1 sky130_fd_sc_hd__fill_1
XFILLER_2_485 vssd1 vssd1 vccd1 vccd1 sky130_fd_sc_hd__fill_2
XFILLER_49_93 vssd1 vssd1 vccd1 vccd1 sky130_fd_sc_hd__fill_1
XFILLER_1_12 vssd1 vssd1 vccd1 vccd1 sky130_fd_sc_hd__fill_1
XANTENNA__3430__Q _3430_/Q vssd1 vssd1 vccd1 vccd1 sky130_fd_sc_hd__diode_2
XFILLER_73_481 vssd1 vssd1 vccd1 vccd1 sky130_fd_sc_hd__fill_4
X_1972_ _1972_/A _1972_/B vssd1 vssd1 vccd1 vccd1 _1986_/A sky130_fd_sc_hd__xnor2_2
XPHY_EDGE_ROW_49_Right_49 vssd1 vssd1 vccd1 vccd1 sky130_fd_sc_hd__decap_3
X_2524_ _2959_/B _2957_/C _3205_/Q vssd1 vssd1 vccd1 vccd1 _2524_/X sky130_fd_sc_hd__and3_2
X_2455_ _2926_/B _2926_/C _3344_/Q vssd1 vssd1 vccd1 vccd1 _2455_/X sky130_fd_sc_hd__and3_2
X_2386_ _2386_/A _2386_/B vssd1 vssd1 vccd1 vccd1 _2387_/B sky130_fd_sc_hd__or2_2
XFILLER_68_231 vssd1 vssd1 vccd1 vccd1 sky130_fd_sc_hd__fill_2
XFILLER_68_253 vssd1 vssd1 vccd1 vccd1 sky130_fd_sc_hd__fill_2
XPHY_EDGE_ROW_58_Right_58 vssd1 vssd1 vccd1 vccd1 sky130_fd_sc_hd__decap_3
X_3007_ _3199_/CLK _3007_/D load_slew220/X vssd1 vssd1 vccd1 vccd1 _3007_/Q sky130_fd_sc_hd__dfrtp_2
XTAP_TAPCELL_ROW_54_627 vssd1 vccd1 sky130_fd_sc_hd__tapvpwrvgnd_1
XANTENNA__2183__A _3046_/Q vssd1 vssd1 vccd1 vccd1 sky130_fd_sc_hd__diode_2
XANTENNA__2027__B2 _2029_/D vssd1 vssd1 vccd1 vccd1 sky130_fd_sc_hd__diode_2
XANTENNA_fanout145_X _2352_/B vssd1 vssd1 vccd1 vccd1 sky130_fd_sc_hd__diode_2
XFILLER_61_28 vssd1 vssd1 vccd1 vccd1 sky130_fd_sc_hd__fill_8
XPHY_EDGE_ROW_67_Right_67 vssd1 vssd1 vccd1 vccd1 sky130_fd_sc_hd__decap_3
XANTENNA__2630__B _2644_/B vssd1 vssd1 vccd1 vccd1 sky130_fd_sc_hd__diode_2
XPHY_EDGE_ROW_76_Right_76 vssd1 vssd1 vccd1 vccd1 sky130_fd_sc_hd__decap_3
XFILLER_74_245 vssd1 vssd1 vccd1 vccd1 sky130_fd_sc_hd__fill_4
XANTENNA__2792__S _2799_/S vssd1 vssd1 vccd1 vccd1 sky130_fd_sc_hd__diode_2
XTAP_TAPCELL_ROW_17_318 vssd1 vccd1 sky130_fd_sc_hd__tapvpwrvgnd_1
XFILLER_55_470 vssd1 vssd1 vccd1 vccd1 sky130_fd_sc_hd__fill_2
XFILLER_35_73 vssd1 vssd1 vccd1 vccd1 sky130_fd_sc_hd__fill_1
XTAP_TAPCELL_ROW_25_384 vssd1 vccd1 sky130_fd_sc_hd__tapvpwrvgnd_1
XFILLER_42_197 vssd1 vssd1 vccd1 vccd1 sky130_fd_sc_hd__fill_1
X_2240_ _2199_/A _2197_/B _2199_/B _2195_/Y vssd1 vssd1 vccd1 vccd1 _2241_/B sky130_fd_sc_hd__o31a_2
X_2171_ _2205_/A _2297_/A _2255_/A _2255_/B vssd1 vssd1 vccd1 vccd1 _2211_/A sky130_fd_sc_hd__nand4_2
XANTENNA__1537__A_N _1546_/S vssd1 vssd1 vccd1 vccd1 sky130_fd_sc_hd__diode_2
XTAP_TAPCELL_ROW_51_608 vssd1 vccd1 sky130_fd_sc_hd__tapvpwrvgnd_1
XANTENNA__1768__A0 _2284_/B vssd1 vssd1 vccd1 vccd1 sky130_fd_sc_hd__diode_2
X_1955_ _1917_/Y _1920_/B _1920_/C vssd1 vssd1 vccd1 vccd1 _1956_/B sky130_fd_sc_hd__a21o_2
X_1886_ _1885_/B _1885_/C _1885_/A vssd1 vssd1 vccd1 vccd1 _1886_/Y sky130_fd_sc_hd__a21oi_2
X_2507_ _2520_/A _2507_/B vssd1 vssd1 vccd1 vccd1 _2507_/X sky130_fd_sc_hd__and2_2
Xteam_02_305 vssd1 vssd1 vccd1 vccd1 team_02_305/HI gpio_out[8] sky130_fd_sc_hd__conb_1
Xteam_02_316 vssd1 vssd1 vccd1 vccd1 team_02_316/HI gpio_out[19] sky130_fd_sc_hd__conb_1
X_2438_ _2440_/A _2533_/B vssd1 vssd1 vccd1 vccd1 _2438_/X sky130_fd_sc_hd__and2_2
Xteam_02_327 vssd1 vssd1 vccd1 vccd1 team_02_327/HI gpio_out[30] sky130_fd_sc_hd__conb_1
Xteam_02_338 vssd1 vssd1 vccd1 vccd1 gpio_oeb[8] team_02_338/LO sky130_fd_sc_hd__conb_1
Xteam_02_349 vssd1 vssd1 vccd1 vccd1 gpio_oeb[19] team_02_349/LO sky130_fd_sc_hd__conb_1
X_2369_ _2369_/A _2369_/B _2369_/C vssd1 vssd1 vccd1 vccd1 _2370_/B sky130_fd_sc_hd__nor3_2
XTAP_TAPCELL_ROW_67_741 vssd1 vccd1 sky130_fd_sc_hd__tapvpwrvgnd_1
XANTENNA__2465__X _2465_/X vssd1 vssd1 vccd1 vccd1 sky130_fd_sc_hd__diode_2
XFILLER_56_278 vssd1 vssd1 vccd1 vccd1 sky130_fd_sc_hd__fill_2
XANTENNA__1759__A0 _1947_/A vssd1 vssd1 vccd1 vccd1 sky130_fd_sc_hd__diode_2
XANTENNA__2420__B2 _1993_/S vssd1 vssd1 vccd1 vccd1 sky130_fd_sc_hd__diode_2
XANTENNA__2971__A2 _2971_/A2 vssd1 vssd1 vccd1 vccd1 sky130_fd_sc_hd__diode_2
XANTENNA__2787__S _2798_/S vssd1 vssd1 vccd1 vccd1 sky130_fd_sc_hd__diode_2
XFILLER_79_337 vssd1 vccd1 vssd1 vccd1 sky130_ef_sc_hd__decap_40_12
XANTENNA__2487__A1 _2942_/B2 vssd1 vssd1 vccd1 vccd1 sky130_fd_sc_hd__diode_2
XANTENNA__2487__B2 _2611_/A vssd1 vssd1 vccd1 vccd1 sky130_fd_sc_hd__diode_2
XANTENNA__2535__B _2926_/C vssd1 vssd1 vccd1 vccd1 sky130_fd_sc_hd__diode_2
XFILLER_15_131 vssd1 vssd1 vccd1 vccd1 sky130_fd_sc_hd__fill_1
XFILLER_70_281 vssd1 vssd1 vccd1 vccd1 sky130_fd_sc_hd__fill_4
X_1740_ _3087_/Q _3070_/Q _1737_/B vssd1 vssd1 vccd1 vccd1 _1740_/X sky130_fd_sc_hd__a21o_2
XFILLER_7_44 vssd1 vssd1 vccd1 vccd1 sky130_fd_sc_hd__fill_4
XFILLER_30_189 vssd1 vssd1 vccd1 vccd1 sky130_fd_sc_hd__fill_2
X_1671_ _3077_/Q _3060_/Q vssd1 vssd1 vccd1 vccd1 _1672_/B sky130_fd_sc_hd__nand2_2
X_3410_ _3423_/CLK _3410_/D fanout228/X vssd1 vssd1 vccd1 vccd1 _3410_/Q sky130_fd_sc_hd__dfrtp_2
XANTENNA__2697__S _2700_/S vssd1 vssd1 vccd1 vccd1 sky130_fd_sc_hd__diode_2
X_3341_ _3359_/CLK _3341_/D fanout235/X vssd1 vssd1 vccd1 vccd1 _3341_/Q sky130_fd_sc_hd__dfrtp_2
X_3272_ _3297_/CLK _3272_/D fanout265/X vssd1 vssd1 vccd1 vccd1 _3272_/Q sky130_fd_sc_hd__dfrtp_2
Xload_slew244 fanout243/X vssd1 vssd1 vccd1 vccd1 load_slew244/X sky130_fd_sc_hd__buf_2
XFILLER_30_3 vssd1 vssd1 vccd1 vccd1 sky130_fd_sc_hd__fill_2
XANTENNA__2478__B2 _1602_/X vssd1 vssd1 vccd1 vccd1 sky130_fd_sc_hd__diode_2
Xload_slew288 fanout287/X vssd1 vssd1 vccd1 vccd1 load_slew288/X sky130_fd_sc_hd__buf_2
X_2223_ _2224_/B _2224_/C _2224_/A vssd1 vssd1 vccd1 vccd1 _2223_/Y sky130_fd_sc_hd__a21oi_2
X_2154_ _2263_/A _2154_/B _2347_/A _2383_/B vssd1 vssd1 vccd1 vccd1 _2188_/A sky130_fd_sc_hd__nand4_2
X_2085_ _2085_/A _2085_/B vssd1 vssd1 vccd1 vccd1 _2085_/Y sky130_fd_sc_hd__xnor2_2
XTAP_TAPCELL_ROW_36_479 vssd1 vccd1 sky130_fd_sc_hd__tapvpwrvgnd_1
XFILLER_34_473 vssd1 vssd1 vccd1 vccd1 sky130_fd_sc_hd__fill_1
XFILLER_21_123 vssd1 vssd1 vccd1 vccd1 sky130_fd_sc_hd__fill_2
X_2987_ _3003_/A vssd1 vssd1 vccd1 vccd1 _2987_/Y sky130_fd_sc_hd__inv_2
X_1938_ _2025_/A _2029_/C vssd1 vssd1 vccd1 vccd1 _1939_/C sky130_fd_sc_hd__nand2_2
X_3470__331 vssd1 vssd1 vccd1 vccd1 _3470_/D _3470__331/LO sky130_fd_sc_hd__conb_1
X_1869_ _1869_/A _1869_/B _1869_/C vssd1 vssd1 vccd1 vccd1 _1871_/A sky130_fd_sc_hd__nand3_2
XANTENNA__1805__A _1805_/A vssd1 vssd1 vccd1 vccd1 sky130_fd_sc_hd__diode_2
XANTENNA__2469__A1 _2611_/A vssd1 vssd1 vccd1 vccd1 sky130_fd_sc_hd__diode_2
XANTENNA__2469__B2 _2800_/A vssd1 vssd1 vccd1 vccd1 sky130_fd_sc_hd__diode_2
XTAP_TAPCELL_ROW_27_402 vssd1 vccd1 sky130_fd_sc_hd__tapvpwrvgnd_1
XANTENNA__1897__D _1998_/B vssd1 vssd1 vccd1 vccd1 sky130_fd_sc_hd__diode_2
XFILLER_44_259 vssd1 vssd1 vccd1 vccd1 sky130_fd_sc_hd__fill_1
XTAP_TAPCELL_ROW_70_769 vssd1 vccd1 sky130_fd_sc_hd__tapvpwrvgnd_1
XFILLER_16_97 vssd1 vssd1 vccd1 vccd1 sky130_fd_sc_hd__fill_2
XANTENNA__2929__C1 _1584_/X vssd1 vssd1 vccd1 vccd1 sky130_fd_sc_hd__diode_2
XFILLER_8_127 vssd1 vssd1 vccd1 vccd1 sky130_fd_sc_hd__fill_4
XFILLER_12_156 vssd1 vssd1 vccd1 vccd1 sky130_fd_sc_hd__fill_1
XFILLER_32_74 vssd1 vssd1 vccd1 vccd1 sky130_fd_sc_hd__fill_8
XFILLER_32_85 vssd1 vssd1 vccd1 vccd1 sky130_fd_sc_hd__fill_4
XFILLER_4_311 vssd1 vssd1 vccd1 vccd1 sky130_fd_sc_hd__fill_4
XPHY_EDGE_ROW_26_Left_106 vssd1 vssd1 vccd1 vccd1 sky130_fd_sc_hd__decap_3
XTAP_TAPCELL_ROW_78_836 vssd1 vccd1 sky130_fd_sc_hd__tapvpwrvgnd_1
XFILLER_79_167 vssd1 vssd1 vccd1 vccd1 sky130_fd_sc_hd__fill_1
XANTENNA_clkload0_A clkload0/A vssd1 vssd1 vccd1 vccd1 sky130_fd_sc_hd__diode_2
XPHY_EDGE_ROW_35_Left_115 vssd1 vssd1 vccd1 vccd1 sky130_fd_sc_hd__decap_3
XFILLER_75_395 vssd1 vssd1 vccd1 vccd1 sky130_fd_sc_hd__fill_1
X_2910_ _3229_/Q _2967_/A2 _2909_/X _2923_/B2 vssd1 vssd1 vccd1 vccd1 _2910_/X sky130_fd_sc_hd__a22o_2
XFILLER_73_92 vssd1 vssd1 vccd1 vccd1 sky130_fd_sc_hd__fill_8
XTAP_TAPCELL_ROW_33_449 vssd1 vccd1 sky130_fd_sc_hd__tapvpwrvgnd_1
XFILLER_31_443 vssd1 vssd1 vccd1 vccd1 sky130_fd_sc_hd__fill_4
X_2841_ hold405/X _2616_/X _2852_/S vssd1 vssd1 vccd1 vccd1 _3345_/D sky130_fd_sc_hd__mux2_1
XANTENNA__2281__A _2347_/A vssd1 vssd1 vccd1 vccd1 sky130_fd_sc_hd__diode_2
X_2772_ hold430/X _2848_/A1 _2776_/S vssd1 vssd1 vccd1 vccd1 _3280_/D sky130_fd_sc_hd__mux2_1
XFILLER_78_3 vssd1 vssd1 vccd1 vccd1 sky130_fd_sc_hd__fill_2
X_1723_ _1723_/A _1723_/B vssd1 vssd1 vccd1 vccd1 _1725_/A sky130_fd_sc_hd__nand2_2
XPHY_EDGE_ROW_44_Left_124 vssd1 vssd1 vccd1 vccd1 sky130_fd_sc_hd__decap_3
X_1654_ _1653_/A _1653_/B _1739_/B vssd1 vssd1 vccd1 vccd1 _1654_/Y sky130_fd_sc_hd__a21oi_2
X_1585_ _1585_/A vssd1 vssd1 vccd1 vccd1 _1585_/Y sky130_fd_sc_hd__inv_2
X_3324_ _3393_/CLK _3324_/D load_slew256/X vssd1 vssd1 vccd1 vccd1 _3324_/Q sky130_fd_sc_hd__dfrtp_2
X_3255_ _3437_/CLK _3255_/D fanout262/X vssd1 vssd1 vccd1 vccd1 _3255_/Q sky130_fd_sc_hd__dfrtp_2
X_2206_ _2206_/A _2206_/B _2206_/C vssd1 vssd1 vccd1 vccd1 _2206_/X sky130_fd_sc_hd__and3_2
X_3186_ _3331_/CLK _3186_/D fanout231/X vssd1 vssd1 vccd1 vccd1 _3186_/Q sky130_fd_sc_hd__dfrtp_2
XPHY_EDGE_ROW_53_Left_133 vssd1 vssd1 vccd1 vccd1 sky130_fd_sc_hd__decap_3
X_2137_ _2137_/A _2137_/B vssd1 vssd1 vccd1 vccd1 _2141_/A sky130_fd_sc_hd__xnor2_2
X_2068_ _2046_/B _2066_/X _2067_/X _2065_/Y vssd1 vssd1 vccd1 vccd1 _2068_/X sky130_fd_sc_hd__a211o_2
XANTENNA__3437__D _3437_/D vssd1 vssd1 vccd1 vccd1 sky130_fd_sc_hd__diode_2
XPHY_EDGE_ROW_62_Left_142 vssd1 vssd1 vccd1 vccd1 sky130_fd_sc_hd__decap_3
XFILLER_5_119 vssd1 vssd1 vccd1 vccd1 sky130_fd_sc_hd__fill_1
Xhold672 _3123_/Q vssd1 vssd1 vccd1 vccd1 hold672/X sky130_fd_sc_hd__dlygate4sd3_1
Xhold661 _3144_/Q vssd1 vssd1 vccd1 vccd1 hold661/X sky130_fd_sc_hd__dlygate4sd3_1
Xhold650 _3018_/Q vssd1 vssd1 vccd1 vccd1 hold650/X sky130_fd_sc_hd__dlygate4sd3_1
XFILLER_78_37 vssd1 vssd1 vccd1 vccd1 sky130_fd_sc_hd__fill_2
Xhold694 _3341_/Q vssd1 vssd1 vccd1 vccd1 hold694/X sky130_fd_sc_hd__dlygate4sd3_1
Xhold683 _3161_/Q vssd1 vssd1 vccd1 vccd1 hold683/X sky130_fd_sc_hd__dlygate4sd3_1
XPHY_EDGE_ROW_71_Left_151 vssd1 vssd1 vccd1 vccd1 sky130_fd_sc_hd__decap_3
XTAP_TAPCELL_ROW_75_806 vssd1 vccd1 sky130_fd_sc_hd__tapvpwrvgnd_1
XFILLER_13_421 vssd1 vssd1 vccd1 vccd1 sky130_fd_sc_hd__fill_4
XFILLER_40_262 vssd1 vssd1 vccd1 vccd1 sky130_fd_sc_hd__fill_4
XFILLER_40_251 vssd1 vssd1 vccd1 vccd1 sky130_fd_sc_hd__fill_1
XFILLER_9_447 vssd1 vssd1 vccd1 vccd1 sky130_fd_sc_hd__fill_1
XFILLER_4_141 vssd1 vccd1 vssd1 vccd1 sky130_ef_sc_hd__decap_40_12
XFILLER_4_45 vssd1 vssd1 vccd1 vccd1 sky130_fd_sc_hd__fill_1
XFILLER_67_104 vssd1 vssd1 vccd1 vccd1 sky130_fd_sc_hd__fill_1
XFILLER_0_391 vssd1 vssd1 vccd1 vccd1 sky130_fd_sc_hd__fill_1
X_3040_ _3204_/CLK _3040_/D load_slew205/X vssd1 vssd1 vccd1 vccd1 _3040_/Q sky130_fd_sc_hd__dfrtp_2
XTAP_TAPCELL_ROW_46_563 vssd1 vccd1 sky130_fd_sc_hd__tapvpwrvgnd_1
XFILLER_31_240 vssd1 vssd1 vccd1 vccd1 sky130_fd_sc_hd__fill_1
X_2824_ hold491/X _2620_/X _2837_/S vssd1 vssd1 vccd1 vccd1 _3329_/D sky130_fd_sc_hd__mux2_1
XANTENNA__2908__A2 _2864_/S vssd1 vssd1 vccd1 vccd1 sky130_fd_sc_hd__diode_2
X_2755_ hold680/X _2634_/X _2761_/S vssd1 vssd1 vccd1 vccd1 _3264_/D sky130_fd_sc_hd__mux2_1
X_2686_ _2686_/A _2838_/B _2800_/C vssd1 vssd1 vccd1 vccd1 _2686_/X sky130_fd_sc_hd__and3_2
X_1706_ _1699_/A _1701_/B _1699_/B vssd1 vssd1 vccd1 vccd1 _1707_/B sky130_fd_sc_hd__a21bo_2
X_1637_ _3072_/Q _3055_/Q vssd1 vssd1 vccd1 vccd1 _1646_/A sky130_fd_sc_hd__nor2_2
XANTENNA__2541__B1 _2540_/X vssd1 vssd1 vccd1 vccd1 sky130_fd_sc_hd__diode_2
X_3307_ _3343_/CLK _3307_/D fanout262/X vssd1 vssd1 vccd1 vccd1 _3307_/Q sky130_fd_sc_hd__dfrtp_2
X_1568_ _1609_/A _1583_/A vssd1 vssd1 vccd1 vccd1 _1568_/Y sky130_fd_sc_hd__nor2_2
XFILLER_48_29 vssd1 vssd1 vccd1 vccd1 sky130_fd_sc_hd__fill_4
X_1499_ _2588_/A vssd1 vssd1 vccd1 vccd1 _1584_/A sky130_fd_sc_hd__inv_2
XFILLER_58_148 vssd1 vssd1 vccd1 vccd1 sky130_fd_sc_hd__fill_1
X_3238_ _3388_/CLK _3238_/D fanout238/X vssd1 vssd1 vccd1 vccd1 _3238_/Q sky130_fd_sc_hd__dfrtp_2
XFILLER_58_159 vssd1 vssd1 vccd1 vccd1 sky130_fd_sc_hd__fill_1
XANTENNA__1802__B _2091_/B vssd1 vssd1 vccd1 vccd1 sky130_fd_sc_hd__diode_2
X_3169_ _3349_/CLK _3169_/D load_slew205/X vssd1 vssd1 vccd1 vccd1 _3169_/Q sky130_fd_sc_hd__dfrtp_2
XTAP_TAPCELL_ROW_1_177 vssd1 vccd1 sky130_fd_sc_hd__tapvpwrvgnd_1
Xfanout11 _2838_/X vssd1 vssd1 vccd1 vccd1 _2856_/S sky130_fd_sc_hd__clkdlybuf4s25_1
Xfanout22 _2743_/X vssd1 vssd1 vccd1 vccd1 _2757_/S sky130_fd_sc_hd__clkdlybuf4s25_1
XANTENNA__2072__A2 _2073_/C vssd1 vssd1 vccd1 vccd1 sky130_fd_sc_hd__diode_2
Xfanout33 _2647_/S vssd1 vssd1 vccd1 vccd1 _2645_/S sky130_fd_sc_hd__clkdlybuf4s25_1
Xfanout44 _2632_/X vssd1 vssd1 vccd1 vccd1 _2811_/A1 sky130_fd_sc_hd__clkdlybuf4s25_1
Xfanout55 _2838_/C vssd1 vssd1 vccd1 vccd1 _2800_/C sky130_fd_sc_hd__clkdlybuf4s25_1
Xfanout77 _2901_/A2 vssd1 vssd1 vccd1 vccd1 _2881_/A2 sky130_fd_sc_hd__clkdlybuf4s25_1
Xfanout99 _1993_/S vssd1 vssd1 vccd1 vccd1 _2412_/S sky130_fd_sc_hd__clkdlybuf4s25_1
XANTENNA__2352__C _2352_/C vssd1 vssd1 vccd1 vccd1 sky130_fd_sc_hd__diode_2
Xhold480 _3282_/Q vssd1 vssd1 vccd1 vccd1 hold480/X sky130_fd_sc_hd__dlygate4sd3_1
XFILLER_8_3 vssd1 vccd1 vssd1 vccd1 sky130_ef_sc_hd__decap_40_12
XANTENNA__2795__S _2799_/S vssd1 vssd1 vccd1 vccd1 sky130_fd_sc_hd__diode_2
Xhold491 _3329_/Q vssd1 vssd1 vccd1 vccd1 hold491/X sky130_fd_sc_hd__dlygate4sd3_1
XFILLER_45_332 vssd1 vssd1 vccd1 vccd1 sky130_fd_sc_hd__fill_2
XFILLER_72_162 vssd1 vssd1 vccd1 vccd1 sky130_fd_sc_hd__fill_1
XFILLER_72_151 vssd1 vssd1 vccd1 vccd1 sky130_fd_sc_hd__fill_1
XFILLER_9_200 vssd1 vssd1 vccd1 vccd1 sky130_fd_sc_hd__fill_1
XFILLER_54_94 vssd1 vssd1 vccd1 vccd1 sky130_fd_sc_hd__fill_1
XFILLER_13_273 vssd1 vssd1 vccd1 vccd1 sky130_fd_sc_hd__fill_4
Xclkload14 _3343_/CLK vssd1 vssd1 vccd1 vccd1 clkload14/X sky130_fd_sc_hd__clkbuf_4
XFILLER_70_82 vssd1 vssd1 vccd1 vccd1 sky130_fd_sc_hd__fill_2
X_2540_ _2540_/A _2540_/B vssd1 vssd1 vccd1 vccd1 _2540_/X sky130_fd_sc_hd__and2_2
X_2471_ _3327_/Q _2667_/B _2648_/B _3309_/Q _2470_/X vssd1 vssd1 vccd1 vccd1 _2471_/X
+ sky130_fd_sc_hd__a221o_2
XANTENNA__2523__B1 wire66/X vssd1 vssd1 vccd1 vccd1 sky130_fd_sc_hd__diode_2
XFILLER_68_413 vssd1 vssd1 vccd1 vccd1 sky130_fd_sc_hd__fill_1
X_3023_ clkload8/A _3023_/D fanout209/X vssd1 vssd1 vccd1 vccd1 _3023_/Q sky130_fd_sc_hd__dfrtp_2
XFILLER_48_170 vssd1 vssd1 vccd1 vccd1 sky130_fd_sc_hd__fill_2
XFILLER_63_140 vssd1 vssd1 vccd1 vccd1 sky130_fd_sc_hd__fill_4
XANTENNA_fanout135_A _2900_/A vssd1 vssd1 vccd1 vccd1 sky130_fd_sc_hd__diode_2
Xclkload8 clkload8/A vssd1 vssd1 vccd1 vccd1 clkload8/X sky130_fd_sc_hd__clkbuf_4
XTAP_TAPCELL_ROW_14_290 vssd1 vccd1 sky130_fd_sc_hd__tapvpwrvgnd_1
X_2807_ hold657/X _2845_/A1 _2818_/S vssd1 vssd1 vccd1 vccd1 _3313_/D sky130_fd_sc_hd__mux2_1
X_2738_ hold461/X _2814_/A1 _2738_/S vssd1 vssd1 vccd1 vccd1 _3248_/D sky130_fd_sc_hd__mux2_1
X_2669_ hold623/X _2802_/A1 _2681_/S vssd1 vssd1 vccd1 vccd1 _3182_/D sky130_fd_sc_hd__mux2_1
Xfanout201 _1775_/B vssd1 vssd1 vccd1 vccd1 fanout201/X sky130_fd_sc_hd__clkdlybuf4s25_1
Xfanout223 fanout291/X vssd1 vssd1 vccd1 vccd1 fanout223/X sky130_fd_sc_hd__clkdlybuf4s25_1
XTAP_TAPCELL_ROW_6_225 vssd1 vccd1 sky130_fd_sc_hd__tapvpwrvgnd_1
XANTENNA_fanout292_X _3463_/CLK vssd1 vssd1 vccd1 vccd1 sky130_fd_sc_hd__diode_2
Xfanout245 fanout251/X vssd1 vssd1 vccd1 vccd1 fanout245/X sky130_fd_sc_hd__clkdlybuf4s25_1
Xfanout289 fanout290/X vssd1 vssd1 vccd1 vccd1 fanout289/X sky130_fd_sc_hd__clkdlybuf4s25_1
XANTENNA__2628__B _2646_/B vssd1 vssd1 vccd1 vccd1 sky130_fd_sc_hd__diode_2
XFILLER_74_416 vssd1 vssd1 vccd1 vccd1 sky130_fd_sc_hd__fill_4
XANTENNA__2347__C _2383_/B vssd1 vssd1 vccd1 vccd1 sky130_fd_sc_hd__diode_2
XTAP_TAPCELL_ROW_57_658 vssd1 vccd1 sky130_fd_sc_hd__tapvpwrvgnd_1
XANTENNA_fanout48_A _2624_/X vssd1 vssd1 vccd1 vccd1 sky130_fd_sc_hd__diode_2
XTAP_TAPCELL_ROW_40_514 vssd1 vccd1 sky130_fd_sc_hd__tapvpwrvgnd_1
XFILLER_10_221 vssd1 vssd1 vccd1 vccd1 sky130_fd_sc_hd__fill_4
XFILLER_6_225 vssd1 vssd1 vccd1 vccd1 sky130_fd_sc_hd__fill_2
XFILLER_10_276 vssd1 vssd1 vccd1 vccd1 sky130_fd_sc_hd__fill_1
XANTENNA__2505__B1 _2901_/B1 vssd1 vssd1 vccd1 vccd1 sky130_fd_sc_hd__diode_2
XANTENNA__2819__A _2838_/A vssd1 vssd1 vccd1 vccd1 sky130_fd_sc_hd__diode_2
XFILLER_77_210 vssd1 vssd1 vccd1 vccd1 sky130_fd_sc_hd__fill_4
XFILLER_77_254 vssd1 vssd1 vccd1 vccd1 sky130_fd_sc_hd__fill_8
XFILLER_77_287 vssd1 vssd1 vccd1 vccd1 sky130_fd_sc_hd__fill_1
XFILLER_1_24 vssd1 vssd1 vccd1 vccd1 sky130_fd_sc_hd__fill_1
XFILLER_1_68 vssd1 vssd1 vccd1 vccd1 sky130_fd_sc_hd__fill_2
XFILLER_1_57 vssd1 vssd1 vccd1 vccd1 sky130_fd_sc_hd__fill_1
X_1971_ _1971_/A _1971_/B vssd1 vssd1 vccd1 vccd1 _1972_/B sky130_fd_sc_hd__xnor2_2
XANTENNA__1795__A1 _1805_/A vssd1 vssd1 vccd1 vccd1 sky130_fd_sc_hd__diode_2
X_2523_ _3331_/Q _2960_/A2 wire66/X _3313_/Q _2522_/X vssd1 vssd1 vccd1 vccd1 _2523_/X
+ sky130_fd_sc_hd__a221o_2
X_2454_ hold662/X wire59/X _2453_/X _1602_/X vssd1 vssd1 vccd1 vccd1 _3090_/D sky130_fd_sc_hd__a22o_2
X_2385_ _2399_/A _2383_/B _2399_/C vssd1 vssd1 vccd1 vccd1 _2386_/B sky130_fd_sc_hd__a21oi_2
Xinput1 en vssd1 vssd1 vccd1 vccd1 input1/X sky130_fd_sc_hd__clkdlybuf4s25_1
X_3006_ _3436_/CLK _3006_/D fanout226/X vssd1 vssd1 vccd1 vccd1 _3006_/Q sky130_fd_sc_hd__dfrtp_2
XTAP_TAPCELL_ROW_54_628 vssd1 vccd1 sky130_fd_sc_hd__tapvpwrvgnd_1
XANTENNA_fanout138_X _2926_/B vssd1 vssd1 vccd1 vccd1 sky130_fd_sc_hd__diode_2
XANTENNA__2911__B _2964_/C vssd1 vssd1 vccd1 vccd1 sky130_fd_sc_hd__diode_2
Xclkbuf_leaf_39_clk clkload0/A vssd1 vssd1 vccd1 vccd1 _3204_/CLK sky130_fd_sc_hd__clkbuf_8
XFILLER_74_235 vssd1 vssd1 vccd1 vccd1 sky130_fd_sc_hd__fill_4
XFILLER_47_449 vssd1 vssd1 vccd1 vccd1 sky130_fd_sc_hd__fill_4
XTAP_TAPCELL_ROW_17_319 vssd1 vccd1 sky130_fd_sc_hd__tapvpwrvgnd_1
XFILLER_35_41 vssd1 vssd1 vccd1 vccd1 sky130_fd_sc_hd__fill_8
XFILLER_42_143 vssd1 vssd1 vccd1 vccd1 sky130_fd_sc_hd__fill_1
XFILLER_30_327 vssd1 vssd1 vccd1 vccd1 sky130_fd_sc_hd__fill_1
XTAP_TAPCELL_ROW_25_385 vssd1 vccd1 sky130_fd_sc_hd__tapvpwrvgnd_1
XFILLER_30_338 vssd1 vssd1 vccd1 vccd1 sky130_fd_sc_hd__fill_1
X_2170_ _2205_/A _2255_/A vssd1 vssd1 vccd1 vccd1 _2296_/A sky130_fd_sc_hd__nand2_2
XFILLER_38_416 vssd1 vssd1 vccd1 vccd1 sky130_fd_sc_hd__fill_4
XTAP_TAPCELL_ROW_51_609 vssd1 vccd1 sky130_fd_sc_hd__tapvpwrvgnd_1
XFILLER_33_165 vssd1 vssd1 vccd1 vccd1 sky130_fd_sc_hd__fill_1
XFILLER_21_316 vssd1 vssd1 vccd1 vccd1 sky130_fd_sc_hd__fill_4
X_1954_ _1952_/Y _1954_/B vssd1 vssd1 vccd1 vccd1 _1956_/A sky130_fd_sc_hd__and2b_2
X_1885_ _1885_/A _1885_/B _1885_/C vssd1 vssd1 vccd1 vccd1 _1981_/A sky130_fd_sc_hd__and3_2
X_2506_ _2962_/A1 _3150_/Q _3294_/Q _2961_/A1 vssd1 vssd1 vccd1 vccd1 _2507_/B sky130_fd_sc_hd__a22o_2
XFILLER_0_209 vssd1 vccd1 vssd1 vccd1 sky130_ef_sc_hd__decap_40_12
X_2437_ _1602_/X wire106/X _2588_/C vssd1 vssd1 vccd1 vccd1 wire59/A sky130_fd_sc_hd__o21ai_2
Xteam_02_306 vssd1 vssd1 vccd1 vccd1 team_02_306/HI gpio_out[9] sky130_fd_sc_hd__conb_1
Xteam_02_317 vssd1 vssd1 vccd1 vccd1 team_02_317/HI gpio_out[20] sky130_fd_sc_hd__conb_1
Xteam_02_328 vssd1 vssd1 vccd1 vccd1 team_02_328/HI gpio_out[31] sky130_fd_sc_hd__conb_1
Xteam_02_339 vssd1 vssd1 vccd1 vccd1 gpio_oeb[9] team_02_339/LO sky130_fd_sc_hd__conb_1
X_2368_ _2368_/A vssd1 vssd1 vccd1 vccd1 _2370_/A sky130_fd_sc_hd__inv_2
XFILLER_56_29 vssd1 vssd1 vccd1 vccd1 sky130_fd_sc_hd__fill_1
X_2299_ _2303_/B _2303_/C vssd1 vssd1 vccd1 vccd1 _2302_/A sky130_fd_sc_hd__nor2_2
XTAP_TAPCELL_ROW_67_742 vssd1 vccd1 sky130_fd_sc_hd__tapvpwrvgnd_1
XFILLER_29_449 vssd1 vssd1 vccd1 vccd1 sky130_fd_sc_hd__fill_2
XFILLER_44_419 vssd1 vssd1 vccd1 vccd1 sky130_fd_sc_hd__fill_1
XFILLER_37_493 vssd1 vssd1 vccd1 vccd1 sky130_fd_sc_hd__fill_1
XFILLER_72_39 vssd1 vssd1 vccd1 vccd1 sky130_fd_sc_hd__fill_2
XFILLER_52_430 vssd1 vssd1 vccd1 vccd1 sky130_fd_sc_hd__fill_1
XANTENNA__2956__B1 wire66/X vssd1 vssd1 vccd1 vccd1 sky130_fd_sc_hd__diode_2
XTAP_TAPCELL_ROW_22_355 vssd1 vccd1 sky130_fd_sc_hd__tapvpwrvgnd_1
XFILLER_21_65 vssd1 vssd1 vccd1 vccd1 sky130_fd_sc_hd__fill_2
XFILLER_79_349 vssd1 vccd1 vssd1 vccd1 sky130_ef_sc_hd__decap_40_12
XANTENNA_fanout70_X _2901_/B1 vssd1 vssd1 vccd1 vccd1 sky130_fd_sc_hd__diode_2
XFILLER_47_268 vssd1 vssd1 vccd1 vccd1 sky130_fd_sc_hd__fill_2
XTAP_TAPCELL_ROW_73_789 vssd1 vccd1 sky130_fd_sc_hd__tapvpwrvgnd_1
XFILLER_62_83 vssd1 vssd1 vccd1 vccd1 sky130_fd_sc_hd__fill_1
XFILLER_7_331 vssd1 vssd1 vccd1 vccd1 sky130_fd_sc_hd__fill_2
X_1670_ _3077_/Q _3060_/Q vssd1 vssd1 vccd1 vccd1 _1670_/Y sky130_fd_sc_hd__nor2_2
XFILLER_7_397 vssd1 vssd1 vccd1 vccd1 sky130_fd_sc_hd__fill_1
X_3340_ _3398_/CLK _3340_/D load_slew250/X vssd1 vssd1 vccd1 vccd1 _3340_/Q sky130_fd_sc_hd__dfrtp_2
Xload_slew212 fanout211/X vssd1 vssd1 vccd1 vccd1 load_slew212/X sky130_fd_sc_hd__clkbuf_2
X_3271_ _3437_/CLK _3271_/D load_slew261/X vssd1 vssd1 vccd1 vccd1 _3271_/Q sky130_fd_sc_hd__dfrtp_2
Xload_slew234 fanout233/X vssd1 vssd1 vccd1 vccd1 load_slew234/X sky130_fd_sc_hd__clkbuf_4
Xload_slew267 fanout266/X vssd1 vssd1 vccd1 vccd1 _2608_/S sky130_fd_sc_hd__clkbuf_2
Xload_slew278 fanout277/X vssd1 vssd1 vccd1 vccd1 load_slew278/X sky130_fd_sc_hd__clkbuf_4
Xload_slew256 fanout255/X vssd1 vssd1 vccd1 vccd1 load_slew256/X sky130_fd_sc_hd__clkbuf_4
X_2222_ _2221_/A _2221_/B _2221_/C vssd1 vssd1 vccd1 vccd1 _2224_/C sky130_fd_sc_hd__a21o_2
XFILLER_23_3 vssd1 vccd1 vssd1 vccd1 sky130_ef_sc_hd__decap_40_12
X_2153_ _2152_/A _2151_/Y _2152_/Y vssd1 vssd1 vccd1 vccd1 _2160_/A sky130_fd_sc_hd__a21oi_2
X_2084_ _2089_/A _2084_/B vssd1 vssd1 vccd1 vccd1 _2085_/B sky130_fd_sc_hd__nand2_2
XTAP_TAPCELL_ROW_64_712 vssd1 vccd1 sky130_fd_sc_hd__tapvpwrvgnd_1
X_2986_ _3003_/A vssd1 vssd1 vccd1 vccd1 _2986_/Y sky130_fd_sc_hd__inv_2
X_1937_ _2002_/B _1962_/B _1998_/B _2005_/C vssd1 vssd1 vccd1 vccd1 _1939_/B sky130_fd_sc_hd__a22o_2
X_1868_ _1867_/B _1867_/C _1867_/A vssd1 vssd1 vccd1 vccd1 _1869_/C sky130_fd_sc_hd__o21ai_2
X_1799_ _1819_/A _1799_/B vssd1 vssd1 vccd1 vccd1 _1800_/C sky130_fd_sc_hd__xnor2_2
X_3469_ _3471_/CLK _3469_/D load_slew250/X vssd1 vssd1 vccd1 vccd1 _3469_/Q sky130_fd_sc_hd__dfrtp_2
XANTENNA__2636__B _2644_/B vssd1 vssd1 vccd1 vccd1 sky130_fd_sc_hd__diode_2
XTAP_TAPCELL_ROW_27_403 vssd1 vccd1 sky130_fd_sc_hd__tapvpwrvgnd_1
XANTENNA__2798__S _2798_/S vssd1 vssd1 vccd1 vccd1 sky130_fd_sc_hd__diode_2
XFILLER_79_113 vssd1 vccd1 vssd1 vccd1 sky130_ef_sc_hd__decap_40_12
XTAP_TAPCELL_ROW_78_837 vssd1 vccd1 sky130_fd_sc_hd__tapvpwrvgnd_1
XFILLER_75_385 vssd1 vssd1 vccd1 vccd1 sky130_fd_sc_hd__fill_4
XFILLER_75_374 vssd1 vssd1 vccd1 vccd1 sky130_fd_sc_hd__fill_2
X_2840_ hold418/X _2614_/X _2852_/S vssd1 vssd1 vccd1 vccd1 _3344_/D sky130_fd_sc_hd__mux2_1
XFILLER_31_433 vssd1 vssd1 vccd1 vccd1 sky130_fd_sc_hd__fill_1
XANTENNA__2281__B _2352_/B vssd1 vssd1 vccd1 vccd1 sky130_fd_sc_hd__diode_2
X_2771_ hold431/X _2809_/A1 _2776_/S vssd1 vssd1 vccd1 vccd1 _3279_/D sky130_fd_sc_hd__mux2_1
X_1722_ _3085_/Q _3068_/Q vssd1 vssd1 vccd1 vccd1 _1723_/B sky130_fd_sc_hd__nand2_2
X_1653_ _1653_/A _1653_/B vssd1 vssd1 vccd1 vccd1 _1653_/X sky130_fd_sc_hd__or2_2
XANTENNA__1906__A _1906_/A vssd1 vssd1 vccd1 vccd1 sky130_fd_sc_hd__diode_2
XPHY_EDGE_ROW_9_Right_9 vssd1 vssd1 vccd1 vccd1 sky130_fd_sc_hd__decap_3
X_1584_ _1584_/A _3444_/Q _1625_/B vssd1 vssd1 vccd1 vccd1 _1584_/X sky130_fd_sc_hd__or3_2
X_3323_ _3359_/CLK _3323_/D fanout233/X vssd1 vssd1 vccd1 vccd1 _3323_/Q sky130_fd_sc_hd__dfrtp_2
X_3254_ _3297_/CLK _3254_/D fanout274/X vssd1 vssd1 vccd1 vccd1 _3254_/Q sky130_fd_sc_hd__dfrtp_2
X_2205_ _2205_/A _2297_/A _2399_/A _2255_/A vssd1 vssd1 vccd1 vccd1 _2206_/C sky130_fd_sc_hd__nand4_2
XFILLER_66_330 vssd1 vssd1 vccd1 vccd1 sky130_fd_sc_hd__fill_4
X_3185_ _3287_/CLK _3185_/D load_slew230/X vssd1 vssd1 vccd1 vccd1 _3185_/Q sky130_fd_sc_hd__dfrtp_2
X_2136_ _2136_/A _2137_/B vssd1 vssd1 vccd1 vccd1 _2145_/B sky130_fd_sc_hd__nor2_2
X_2067_ _2067_/A _2067_/B _2067_/C vssd1 vssd1 vccd1 vccd1 _2067_/X sky130_fd_sc_hd__and3_2
XANTENNA__2472__A _2472_/A vssd1 vssd1 vccd1 vccd1 sky130_fd_sc_hd__diode_2
X_2969_ _3360_/Q _2838_/B _2968_/X vssd1 vssd1 vccd1 vccd1 _2969_/X sky130_fd_sc_hd__a21o_2
XANTENNA_fanout120_X _2972_/B2 vssd1 vssd1 vccd1 vccd1 sky130_fd_sc_hd__diode_2
Xhold662 _3090_/Q vssd1 vssd1 vccd1 vccd1 hold662/X sky130_fd_sc_hd__dlygate4sd3_1
Xhold651 _3158_/Q vssd1 vssd1 vccd1 vccd1 hold651/X sky130_fd_sc_hd__dlygate4sd3_1
Xhold640 _3094_/Q vssd1 vssd1 vccd1 vccd1 hold640/X sky130_fd_sc_hd__dlygate4sd3_1
XANTENNA__1898__B1 _1998_/B vssd1 vssd1 vccd1 vccd1 sky130_fd_sc_hd__diode_2
Xhold695 _3133_/Q vssd1 vssd1 vccd1 vccd1 hold695/X sky130_fd_sc_hd__dlygate4sd3_1
Xhold684 _3131_/Q vssd1 vssd1 vccd1 vccd1 hold684/X sky130_fd_sc_hd__dlygate4sd3_1
Xhold673 _3062_/Q vssd1 vssd1 vccd1 vccd1 hold673/X sky130_fd_sc_hd__dlygate4sd3_1
XFILLER_1_337 vssd1 vssd1 vccd1 vccd1 sky130_fd_sc_hd__fill_1
XANTENNA__3050__CLK _3423_/CLK vssd1 vssd1 vccd1 vccd1 sky130_fd_sc_hd__diode_2
XTAP_TAPCELL_ROW_75_807 vssd1 vccd1 sky130_fd_sc_hd__tapvpwrvgnd_1
XANTENNA_fanout33_X _2645_/S vssd1 vssd1 vccd1 vccd1 sky130_fd_sc_hd__diode_2
XFILLER_32_208 vssd1 vssd1 vccd1 vccd1 sky130_fd_sc_hd__fill_4
XANTENNA__2614__A2 _2610_/A vssd1 vssd1 vccd1 vccd1 sky130_fd_sc_hd__diode_2
XFILLER_9_459 vssd1 vssd1 vccd1 vccd1 sky130_fd_sc_hd__fill_1
XFILLER_4_197 vssd1 vssd1 vccd1 vccd1 sky130_fd_sc_hd__fill_4
XANTENNA__2550__A1 _2550_/A1 vssd1 vssd1 vccd1 vccd1 sky130_fd_sc_hd__diode_2
XFILLER_75_182 vssd1 vssd1 vccd1 vccd1 sky130_fd_sc_hd__fill_1
XTAP_TAPCELL_ROW_46_564 vssd1 vccd1 sky130_fd_sc_hd__tapvpwrvgnd_1
X_2823_ hold531/X _2842_/A1 _2837_/S vssd1 vssd1 vccd1 vccd1 _3328_/D sky130_fd_sc_hd__mux2_1
X_2754_ hold594/X _2811_/A1 _2757_/S vssd1 vssd1 vccd1 vccd1 _3263_/D sky130_fd_sc_hd__mux2_1
X_1705_ _1705_/A _1705_/B vssd1 vssd1 vccd1 vccd1 _1707_/A sky130_fd_sc_hd__nand2_2
X_2685_ hold493/X _2818_/A1 _2685_/S vssd1 vssd1 vccd1 vccd1 _3198_/D sky130_fd_sc_hd__mux2_1
X_1636_ hold715/X _1739_/B _1640_/A _1635_/X vssd1 vssd1 vccd1 vccd1 _3004_/D sky130_fd_sc_hd__a22o_2
X_1567_ _3142_/Q _3143_/Q vssd1 vssd1 vccd1 vccd1 _1583_/A sky130_fd_sc_hd__or2_2
XANTENNA__2541__B2 _1602_/X vssd1 vssd1 vccd1 vccd1 sky130_fd_sc_hd__diode_2
X_3306_ _3337_/CLK _3306_/D fanout251/X vssd1 vssd1 vccd1 vccd1 _3306_/Q sky130_fd_sc_hd__dfrtp_2
XPHY_EDGE_ROW_18_Left_98 vssd1 vssd1 vccd1 vccd1 sky130_fd_sc_hd__decap_3
XANTENNA__2467__A _2472_/A vssd1 vssd1 vccd1 vccd1 sky130_fd_sc_hd__diode_2
X_3237_ _3437_/CLK _3237_/D fanout262/X vssd1 vssd1 vccd1 vccd1 _3237_/Q sky130_fd_sc_hd__dfrtp_2
X_3168_ _3204_/CLK _3168_/D fanout206/X vssd1 vssd1 vccd1 vccd1 _3168_/Q sky130_fd_sc_hd__dfrtp_2
XFILLER_73_119 vssd1 vssd1 vccd1 vccd1 sky130_fd_sc_hd__fill_1
X_2119_ _2138_/A _2119_/B vssd1 vssd1 vccd1 vccd1 _2119_/Y sky130_fd_sc_hd__xnor2_2
XFILLER_66_193 vssd1 vssd1 vccd1 vccd1 sky130_fd_sc_hd__fill_2
XFILLER_54_344 vssd1 vssd1 vccd1 vccd1 sky130_fd_sc_hd__fill_1
XFILLER_54_333 vssd1 vssd1 vccd1 vccd1 sky130_fd_sc_hd__fill_1
XANTENNA_fanout168_X _1947_/A vssd1 vssd1 vccd1 vccd1 sky130_fd_sc_hd__diode_2
X_3099_ _3343_/CLK _3099_/D wire222/X vssd1 vssd1 vccd1 vccd1 _3099_/Q sky130_fd_sc_hd__dfrtp_2
XTAP_TAPCELL_ROW_1_178 vssd1 vccd1 sky130_fd_sc_hd__tapvpwrvgnd_1
Xfanout12 _2838_/X vssd1 vssd1 vccd1 vccd1 _2852_/S sky130_fd_sc_hd__clkdlybuf4s25_1
Xfanout23 _2724_/X vssd1 vssd1 vccd1 vccd1 _2742_/S sky130_fd_sc_hd__clkdlybuf4s25_1
Xfanout34 _2611_/X vssd1 vssd1 vccd1 vccd1 _2647_/S sky130_fd_sc_hd__clkdlybuf4s25_1
Xfanout45 _2630_/X vssd1 vssd1 vccd1 vccd1 _2848_/A1 sky130_fd_sc_hd__clkdlybuf4s25_1
Xfanout56 _2583_/B1 vssd1 vssd1 vccd1 vccd1 _2587_/B1 sky130_fd_sc_hd__clkdlybuf4s25_1
Xfanout67 _2901_/B1 vssd1 vssd1 vccd1 vccd1 _2881_/B1 sky130_fd_sc_hd__clkdlybuf4s25_1
Xfanout89 _1574_/X vssd1 vssd1 vccd1 vccd1 _3435_/D sky130_fd_sc_hd__clkdlybuf4s25_1
XANTENNA__2352__D _2399_/B vssd1 vssd1 vccd1 vccd1 sky130_fd_sc_hd__diode_2
XFILLER_13_55 vssd1 vssd1 vccd1 vccd1 sky130_fd_sc_hd__fill_1
XFILLER_13_88 vssd1 vccd1 vssd1 vccd1 sky130_ef_sc_hd__decap_40_12
Xhold470 _3302_/Q vssd1 vssd1 vccd1 vccd1 hold470/X sky130_fd_sc_hd__dlygate4sd3_1
Xhold481 _3278_/Q vssd1 vssd1 vccd1 vccd1 hold481/X sky130_fd_sc_hd__dlygate4sd3_1
XTAP_TAPCELL_ROW_9_245 vssd1 vccd1 sky130_fd_sc_hd__tapvpwrvgnd_1
XANTENNA__2532__A1 _2611_/A vssd1 vssd1 vccd1 vccd1 sky130_fd_sc_hd__diode_2
XANTENNA__2532__B2 _2800_/A vssd1 vssd1 vccd1 vccd1 sky130_fd_sc_hd__diode_2
Xhold492 _3173_/Q vssd1 vssd1 vccd1 vccd1 hold492/X sky130_fd_sc_hd__dlygate4sd3_1
XFILLER_77_447 vssd1 vssd1 vccd1 vccd1 sky130_fd_sc_hd__fill_1
XFILLER_38_63 vssd1 vssd1 vccd1 vccd1 sky130_fd_sc_hd__fill_2
XANTENNA__2096__B _2154_/B vssd1 vssd1 vccd1 vccd1 sky130_fd_sc_hd__diode_2
XFILLER_38_85 vssd1 vssd1 vccd1 vccd1 sky130_fd_sc_hd__fill_4
XFILLER_72_141 vssd1 vssd1 vccd1 vccd1 sky130_fd_sc_hd__fill_8
XFILLER_45_366 vssd1 vssd1 vccd1 vccd1 sky130_fd_sc_hd__fill_1
XTAP_TAPCELL_ROW_43_534 vssd1 vccd1 sky130_fd_sc_hd__tapvpwrvgnd_1
Xclkload15 _3199_/CLK vssd1 vssd1 vccd1 vccd1 clkload15/X sky130_fd_sc_hd__clkbuf_4
X_2470_ _2472_/A _2472_/B _3345_/Q vssd1 vssd1 vccd1 vccd1 _2470_/X sky130_fd_sc_hd__and3_2
XFILLER_79_81 vssd1 vssd1 vccd1 vccd1 sky130_fd_sc_hd__fill_2
XFILLER_5_484 vssd1 vssd1 vccd1 vccd1 sky130_fd_sc_hd__fill_8
XANTENNA__1622__C _1622_/C vssd1 vssd1 vccd1 vccd1 sky130_fd_sc_hd__diode_2
X_3022_ clkload8/A _3022_/D wire208/X vssd1 vssd1 vccd1 vccd1 _3022_/Q sky130_fd_sc_hd__dfrtp_2
XFILLER_63_152 vssd1 vccd1 vssd1 vccd1 sky130_ef_sc_hd__decap_40_12
Xclkload9 clkload9/A vssd1 vssd1 vccd1 vccd1 clkload9/Y sky130_fd_sc_hd__clkinv_2
XTAP_TAPCELL_ROW_14_291 vssd1 vccd1 sky130_fd_sc_hd__tapvpwrvgnd_1
XANTENNA_fanout128_A _3089_/Q vssd1 vssd1 vccd1 vccd1 sky130_fd_sc_hd__diode_2
X_2806_ hold707/X _2844_/A1 _2818_/S vssd1 vssd1 vccd1 vccd1 _3312_/D sky130_fd_sc_hd__mux2_1
X_2737_ hold595/X _2813_/A1 _2738_/S vssd1 vssd1 vccd1 vccd1 _3247_/D sky130_fd_sc_hd__mux2_1
X_2668_ hold614/X _2839_/A1 _2685_/S vssd1 vssd1 vccd1 vccd1 _3181_/D sky130_fd_sc_hd__mux2_1
X_1619_ _1606_/X _1610_/Y _1618_/Y _1604_/X vssd1 vssd1 vccd1 vccd1 _1622_/B sky130_fd_sc_hd__o31a_2
Xfanout213 fanout214/X vssd1 vssd1 vccd1 vccd1 fanout213/X sky130_fd_sc_hd__clkdlybuf4s25_1
X_2599_ _1578_/B _1583_/B _2594_/B _2598_/Y vssd1 vssd1 vccd1 vccd1 _2599_/Y sky130_fd_sc_hd__a22oi_2
Xfanout224 fanout226/X vssd1 vssd1 vccd1 vccd1 fanout224/X sky130_fd_sc_hd__clkdlybuf4s25_1
Xfanout235 fanout242/X vssd1 vssd1 vccd1 vccd1 fanout235/X sky130_fd_sc_hd__clkdlybuf4s25_1
XTAP_TAPCELL_ROW_6_226 vssd1 vccd1 sky130_fd_sc_hd__tapvpwrvgnd_1
XFILLER_59_447 vssd1 vssd1 vccd1 vccd1 sky130_fd_sc_hd__fill_1
XANTENNA_input2_A gpio_in[0] vssd1 vssd1 vccd1 vccd1 sky130_fd_sc_hd__diode_2
Xfanout257 fanout259/X vssd1 vssd1 vccd1 vccd1 fanout257/X sky130_fd_sc_hd__clkdlybuf4s25_1
Xfanout268 fanout270/X vssd1 vssd1 vccd1 vccd1 fanout268/X sky130_fd_sc_hd__clkdlybuf4s25_1
Xfanout279 fanout289/X vssd1 vssd1 vccd1 vccd1 fanout279/X sky130_fd_sc_hd__clkdlybuf4s25_1
XTAP_TAPCELL_ROW_57_659 vssd1 vccd1 sky130_fd_sc_hd__tapvpwrvgnd_1
XANTENNA__2644__B _2644_/B vssd1 vssd1 vccd1 vccd1 sky130_fd_sc_hd__diode_2
XFILLER_54_185 vssd1 vssd1 vccd1 vccd1 sky130_fd_sc_hd__fill_1
XTAP_TAPCELL_ROW_40_515 vssd1 vccd1 sky130_fd_sc_hd__tapvpwrvgnd_1
XFILLER_24_65 vssd1 vccd1 vssd1 vccd1 sky130_ef_sc_hd__decap_40_12
XANTENNA__2450__B1 _2648_/B vssd1 vssd1 vccd1 vccd1 sky130_fd_sc_hd__diode_2
XFILLER_2_421 vssd1 vssd1 vccd1 vccd1 sky130_fd_sc_hd__fill_1
XANTENNA__1563__X _2838_/B vssd1 vssd1 vccd1 vccd1 sky130_fd_sc_hd__diode_2
XFILLER_49_62 vssd1 vssd1 vccd1 vccd1 sky130_fd_sc_hd__fill_4
XFILLER_2_487 vssd1 vssd1 vccd1 vccd1 sky130_fd_sc_hd__fill_1
XFILLER_37_108 vssd1 vssd1 vccd1 vccd1 sky130_fd_sc_hd__fill_4
XFILLER_65_94 vssd1 vssd1 vccd1 vccd1 sky130_fd_sc_hd__fill_4
XFILLER_45_163 vssd1 vssd1 vccd1 vccd1 sky130_fd_sc_hd__fill_4
X_1970_ _2029_/D _1970_/B vssd1 vssd1 vccd1 vccd1 _1971_/B sky130_fd_sc_hd__nand2_2
XANTENNA__1795__A2 _2004_/B vssd1 vssd1 vccd1 vccd1 sky130_fd_sc_hd__diode_2
XANTENNA__2441__B1 _2648_/B vssd1 vssd1 vccd1 vccd1 sky130_fd_sc_hd__diode_2
X_2522_ _2959_/B _2957_/C _3349_/Q vssd1 vssd1 vccd1 vccd1 _2522_/X sky130_fd_sc_hd__and3_2
XFILLER_53_3 vssd1 vssd1 vccd1 vccd1 sky130_fd_sc_hd__fill_8
XANTENNA_clkbuf_3_0__f_clk_A clkbuf_0_clk/X vssd1 vssd1 vccd1 vccd1 sky130_fd_sc_hd__diode_2
X_2453_ _2540_/A _2453_/B vssd1 vssd1 vccd1 vccd1 _2453_/X sky130_fd_sc_hd__and2_2
X_2384_ _2384_/A _2384_/B vssd1 vssd1 vccd1 vccd1 _2399_/C sky130_fd_sc_hd__and2_2
XFILLER_68_233 vssd1 vssd1 vccd1 vccd1 sky130_fd_sc_hd__fill_1
Xinput2 gpio_in[0] vssd1 vssd1 vccd1 vccd1 input2/X sky130_fd_sc_hd__clkdlybuf4s25_1
X_3005_ _3343_/CLK _3005_/D wire222/X vssd1 vssd1 vccd1 vccd1 _3005_/Q sky130_fd_sc_hd__dfrtp_2
XFILLER_49_491 vssd1 vssd1 vccd1 vccd1 sky130_fd_sc_hd__fill_2
XFILLER_36_141 vssd1 vssd1 vccd1 vccd1 sky130_fd_sc_hd__fill_2
XTAP_TAPCELL_ROW_54_629 vssd1 vccd1 sky130_fd_sc_hd__tapvpwrvgnd_1
XFILLER_51_111 vssd1 vssd1 vccd1 vccd1 sky130_fd_sc_hd__fill_1
XANTENNA_fanout245_A fanout251/X vssd1 vssd1 vccd1 vccd1 sky130_fd_sc_hd__diode_2
XFILLER_51_166 vssd1 vssd1 vccd1 vccd1 sky130_fd_sc_hd__fill_2
XTAP_TAPCELL_ROW_62_695 vssd1 vccd1 sky130_fd_sc_hd__tapvpwrvgnd_1
XANTENNA_fanout200_X _1805_/A vssd1 vssd1 vccd1 vccd1 sky130_fd_sc_hd__diode_2
XANTENNA__2499__B1 wire66/X vssd1 vssd1 vccd1 vccd1 sky130_fd_sc_hd__diode_2
XFILLER_19_54 vssd1 vssd1 vccd1 vccd1 sky130_fd_sc_hd__fill_2
XANTENNA_fanout60_A _1584_/X vssd1 vssd1 vccd1 vccd1 sky130_fd_sc_hd__diode_2
XFILLER_55_472 vssd1 vssd1 vccd1 vccd1 sky130_fd_sc_hd__fill_1
XTAP_TAPCELL_ROW_25_386 vssd1 vccd1 sky130_fd_sc_hd__tapvpwrvgnd_1
XANTENNA__1777__A2 _2091_/B vssd1 vssd1 vccd1 vccd1 sky130_fd_sc_hd__diode_2
XFILLER_18_152 vssd1 vssd1 vccd1 vccd1 sky130_fd_sc_hd__fill_1
XFILLER_18_130 vssd1 vssd1 vccd1 vccd1 sky130_fd_sc_hd__fill_2
XANTENNA__2284__B _2284_/B vssd1 vssd1 vccd1 vccd1 sky130_fd_sc_hd__diode_2
X_1953_ _1953_/A _1953_/B vssd1 vssd1 vccd1 vccd1 _1954_/B sky130_fd_sc_hd__nand2_2
X_1884_ _1884_/A _1979_/A _1979_/B _2002_/B vssd1 vssd1 vccd1 vccd1 _1885_/C sky130_fd_sc_hd__nand4_2
X_2505_ _3258_/Q _2901_/A2 _2901_/B1 _3240_/Q _2504_/X vssd1 vssd1 vccd1 vccd1 _2505_/X
+ sky130_fd_sc_hd__a221o_2
X_2436_ _3415_/Q _2590_/B vssd1 vssd1 vccd1 vccd1 _2588_/C sky130_fd_sc_hd__or2_2
Xteam_02_307 vssd1 vssd1 vccd1 vccd1 team_02_307/HI gpio_out[10] sky130_fd_sc_hd__conb_1
XANTENNA_fanout195_A _1962_/B vssd1 vssd1 vccd1 vccd1 sky130_fd_sc_hd__diode_2
Xteam_02_318 vssd1 vssd1 vccd1 vccd1 team_02_318/HI gpio_out[21] sky130_fd_sc_hd__conb_1
Xteam_02_329 vssd1 vssd1 vccd1 vccd1 team_02_329/HI gpio_out[32] sky130_fd_sc_hd__conb_1
X_2367_ _2369_/A _2369_/C _2369_/B vssd1 vssd1 vccd1 vccd1 _2368_/A sky130_fd_sc_hd__o21ai_2
X_2298_ _2298_/A _2298_/B vssd1 vssd1 vccd1 vccd1 _2303_/C sky130_fd_sc_hd__xnor2_2
XTAP_TAPCELL_ROW_67_743 vssd1 vccd1 sky130_fd_sc_hd__tapvpwrvgnd_1
XTAP_TAPCELL_ROW_22_356 vssd1 vccd1 sky130_fd_sc_hd__tapvpwrvgnd_1
XFILLER_21_33 vssd1 vssd1 vccd1 vccd1 sky130_fd_sc_hd__fill_4
XFILLER_21_88 vssd1 vccd1 vssd1 vccd1 sky130_ef_sc_hd__decap_40_12
XANTENNA__2892__B1 _2894_/B1 vssd1 vssd1 vccd1 vccd1 sky130_fd_sc_hd__diode_2
XANTENNA_fanout63_X _2967_/A2 vssd1 vssd1 vccd1 vccd1 sky130_fd_sc_hd__diode_2
XFILLER_47_225 vssd1 vssd1 vccd1 vccd1 sky130_fd_sc_hd__fill_2
XPHY_EDGE_ROW_6_Left_86 vssd1 vssd1 vccd1 vccd1 sky130_fd_sc_hd__decap_3
XFILLER_46_41 vssd1 vccd1 vssd1 vccd1 sky130_ef_sc_hd__decap_40_12
XFILLER_35_409 vssd1 vssd1 vccd1 vccd1 sky130_fd_sc_hd__fill_1
XFILLER_15_111 vssd1 vssd1 vccd1 vccd1 sky130_fd_sc_hd__fill_1
XFILLER_11_372 vssd1 vssd1 vccd1 vccd1 sky130_fd_sc_hd__fill_1
XFILLER_7_57 vssd1 vssd1 vccd1 vccd1 sky130_fd_sc_hd__fill_2
XFILLER_7_343 vssd1 vssd1 vccd1 vccd1 sky130_fd_sc_hd__fill_1
X_3270_ _3398_/CLK _3270_/D fanout249/X vssd1 vssd1 vccd1 vccd1 _3270_/Q sky130_fd_sc_hd__dfrtp_2
Xload_slew202 fanout201/X vssd1 vssd1 vccd1 vccd1 load_slew202/X sky130_fd_sc_hd__buf_2
XANTENNA__2279__B _2279_/B vssd1 vssd1 vccd1 vccd1 sky130_fd_sc_hd__diode_2
Xload_slew246 fanout245/X vssd1 vssd1 vccd1 vccd1 load_slew246/X sky130_fd_sc_hd__clkbuf_2
X_2221_ _2221_/A _2221_/B _2221_/C vssd1 vssd1 vccd1 vccd1 _2224_/B sky130_fd_sc_hd__nand3_2
XFILLER_30_5 vssd1 vssd1 vccd1 vccd1 sky130_fd_sc_hd__fill_1
XANTENNA__2883__B1 _2894_/B1 vssd1 vssd1 vccd1 vccd1 sky130_fd_sc_hd__diode_2
X_2152_ _2152_/A _2152_/B vssd1 vssd1 vccd1 vccd1 _2152_/Y sky130_fd_sc_hd__nor2_2
XFILLER_16_3 vssd1 vssd1 vccd1 vccd1 sky130_fd_sc_hd__fill_4
X_2083_ _2046_/B _2065_/A _2066_/X _2067_/X _2082_/A vssd1 vssd1 vccd1 vccd1 _2089_/B
+ sky130_fd_sc_hd__a311o_2
XFILLER_26_409 vssd1 vssd1 vccd1 vccd1 sky130_fd_sc_hd__fill_1
XTAP_TAPCELL_ROW_64_713 vssd1 vccd1 sky130_fd_sc_hd__tapvpwrvgnd_1
XFILLER_21_125 vssd1 vssd1 vccd1 vccd1 sky130_fd_sc_hd__fill_1
X_2985_ _2995_/A vssd1 vssd1 vccd1 vccd1 _2985_/Y sky130_fd_sc_hd__inv_2
X_1936_ _2002_/B _2005_/C _1962_/B _1998_/B vssd1 vssd1 vccd1 vccd1 _1939_/A sky130_fd_sc_hd__nand4_2
X_1867_ _1867_/A _1867_/B _1867_/C vssd1 vssd1 vccd1 vccd1 _1869_/B sky130_fd_sc_hd__or3_2
X_1798_ _1820_/A _1819_/B vssd1 vssd1 vccd1 vccd1 _1799_/B sky130_fd_sc_hd__or2_2
X_3468_ _3471_/CLK _3468_/D load_slew250/X vssd1 vssd1 vccd1 vccd1 _3468_/Q sky130_fd_sc_hd__dfrtp_2
X_3399_ _3450_/CLK _3399_/D _2608_/S vssd1 vssd1 vccd1 vccd1 _3399_/Q sky130_fd_sc_hd__dfrtp_2
X_2419_ _2419_/A _2419_/B vssd1 vssd1 vccd1 vccd1 _2419_/X sky130_fd_sc_hd__and2_2
XTAP_TAPCELL_ROW_27_404 vssd1 vccd1 sky130_fd_sc_hd__tapvpwrvgnd_1
XANTENNA__2626__B1 _2644_/B vssd1 vssd1 vccd1 vccd1 sky130_fd_sc_hd__diode_2
XFILLER_16_33 vssd1 vssd1 vccd1 vccd1 sky130_fd_sc_hd__fill_2
XTAP_TAPCELL_ROW_35_470 vssd1 vccd1 sky130_fd_sc_hd__tapvpwrvgnd_1
XANTENNA__2929__A1 _3430_/Q vssd1 vssd1 vccd1 vccd1 sky130_fd_sc_hd__diode_2
XANTENNA__2099__B _2263_/A vssd1 vssd1 vccd1 vccd1 sky130_fd_sc_hd__diode_2
XFILLER_79_125 vssd1 vccd1 vssd1 vccd1 sky130_ef_sc_hd__decap_40_12
XFILLER_79_169 vssd1 vccd1 vssd1 vccd1 sky130_ef_sc_hd__decap_40_12
XTAP_TAPCELL_ROW_78_838 vssd1 vccd1 sky130_fd_sc_hd__tapvpwrvgnd_1
XFILLER_28_291 vssd1 vssd1 vccd1 vccd1 sky130_fd_sc_hd__fill_4
X_2770_ hold481/X _2808_/A1 _2776_/S vssd1 vssd1 vccd1 vccd1 _3278_/D sky130_fd_sc_hd__mux2_1
X_1721_ _3085_/Q _3068_/Q vssd1 vssd1 vccd1 vccd1 _1723_/A sky130_fd_sc_hd__or2_2
X_1652_ _1642_/Y _1647_/B _1644_/B vssd1 vssd1 vccd1 vccd1 _1653_/B sky130_fd_sc_hd__o21a_2
XANTENNA__1906__B _2029_/D vssd1 vssd1 vccd1 vccd1 sky130_fd_sc_hd__diode_2
X_1583_ _1583_/A _1583_/B vssd1 vssd1 vccd1 vccd1 _1625_/B sky130_fd_sc_hd__or2_2
X_3322_ _3398_/CLK _3322_/D fanout247/X vssd1 vssd1 vccd1 vccd1 _3322_/Q sky130_fd_sc_hd__dfrtp_2
X_3253_ _3383_/CLK _3253_/D load_slew264/X vssd1 vssd1 vccd1 vccd1 _3253_/Q sky130_fd_sc_hd__dfrtp_2
XANTENNA__1922__A _2091_/B vssd1 vssd1 vccd1 vccd1 sky130_fd_sc_hd__diode_2
X_3184_ _3386_/CLK _3184_/D fanout238/X vssd1 vssd1 vccd1 vccd1 _3184_/Q sky130_fd_sc_hd__dfrtp_2
X_2204_ _2205_/A _2399_/A _2255_/A _2297_/A vssd1 vssd1 vccd1 vccd1 _2206_/B sky130_fd_sc_hd__a22o_2
X_2135_ _2135_/A _2135_/B vssd1 vssd1 vccd1 vccd1 _2137_/B sky130_fd_sc_hd__xnor2_2
X_2066_ _1994_/A _1994_/B _2020_/B _2044_/X _2018_/Y vssd1 vssd1 vccd1 vccd1 _2066_/X
+ sky130_fd_sc_hd__a311o_2
XANTENNA_fanout158_A _2002_/B vssd1 vssd1 vccd1 vccd1 sky130_fd_sc_hd__diode_2
XANTENNA__2472__B _2472_/B vssd1 vssd1 vccd1 vccd1 sky130_fd_sc_hd__diode_2
XTAP_TAPCELL_ROW_32_440 vssd1 vccd1 sky130_fd_sc_hd__tapvpwrvgnd_1
X_2968_ _3342_/Q _2968_/A2 _2968_/B1 _3324_/Q vssd1 vssd1 vccd1 vccd1 _2968_/X sky130_fd_sc_hd__a22o_2
X_1919_ _1917_/B _1917_/C _1917_/A vssd1 vssd1 vccd1 vccd1 _1920_/C sky130_fd_sc_hd__a21oi_2
XANTENNA_fanout113_X _2611_/A vssd1 vssd1 vccd1 vccd1 sky130_fd_sc_hd__diode_2
X_2899_ _3228_/Q _2967_/A2 _2898_/X _2520_/A vssd1 vssd1 vccd1 vccd1 _2899_/X sky130_fd_sc_hd__a22o_2
Xhold630 _3070_/Q vssd1 vssd1 vccd1 vccd1 _2095_/A sky130_fd_sc_hd__dlygate4sd3_1
Xhold663 _3150_/Q vssd1 vssd1 vccd1 vccd1 hold663/X sky130_fd_sc_hd__dlygate4sd3_1
Xhold652 _3253_/Q vssd1 vssd1 vccd1 vccd1 hold652/X sky130_fd_sc_hd__dlygate4sd3_1
Xhold641 _3076_/Q vssd1 vssd1 vccd1 vccd1 hold641/X sky130_fd_sc_hd__dlygate4sd3_1
XFILLER_78_39 vssd1 vssd1 vccd1 vccd1 sky130_fd_sc_hd__fill_1
XANTENNA__1898__B2 _2029_/C vssd1 vssd1 vccd1 vccd1 sky130_fd_sc_hd__diode_2
Xhold696 _3307_/Q vssd1 vssd1 vccd1 vccd1 hold696/X sky130_fd_sc_hd__dlygate4sd3_1
Xhold685 _3134_/Q vssd1 vssd1 vccd1 vccd1 hold685/X sky130_fd_sc_hd__dlygate4sd3_1
Xhold674 _3130_/Q vssd1 vssd1 vccd1 vccd1 hold674/X sky130_fd_sc_hd__dlygate4sd3_1
XTAP_TAPCELL_ROW_75_808 vssd1 vccd1 sky130_fd_sc_hd__tapvpwrvgnd_1
XFILLER_27_54 vssd1 vssd1 vccd1 vccd1 sky130_fd_sc_hd__fill_2
XFILLER_27_43 vssd1 vssd1 vccd1 vccd1 sky130_fd_sc_hd__fill_4
XFILLER_27_21 vssd1 vssd1 vccd1 vccd1 sky130_fd_sc_hd__fill_2
XFILLER_27_76 vssd1 vssd1 vccd1 vccd1 sky130_fd_sc_hd__fill_1
XANTENNA_fanout26_X _2719_/S vssd1 vssd1 vccd1 vccd1 sky130_fd_sc_hd__diode_2
XFILLER_43_53 vssd1 vssd1 vccd1 vccd1 sky130_fd_sc_hd__fill_2
XFILLER_40_253 vssd1 vssd1 vccd1 vccd1 sky130_fd_sc_hd__fill_1
XFILLER_4_25 vssd1 vssd1 vccd1 vccd1 sky130_fd_sc_hd__fill_2
XFILLER_4_165 vssd1 vccd1 vssd1 vccd1 sky130_ef_sc_hd__decap_40_12
XANTENNA__2550__A2 _2540_/X vssd1 vssd1 vccd1 vccd1 sky130_fd_sc_hd__diode_2
XANTENNA__2838__A _2838_/A vssd1 vssd1 vccd1 vccd1 sky130_fd_sc_hd__diode_2
XFILLER_0_393 vssd1 vssd1 vccd1 vccd1 sky130_fd_sc_hd__fill_1
XTAP_TAPCELL_ROW_46_565 vssd1 vccd1 sky130_fd_sc_hd__tapvpwrvgnd_1
XFILLER_16_294 vssd1 vssd1 vccd1 vccd1 sky130_fd_sc_hd__fill_4
X_2822_ hold477/X _2616_/X _2833_/S vssd1 vssd1 vccd1 vccd1 _3327_/D sky130_fd_sc_hd__mux2_1
X_2753_ hold677/X _2630_/X _2757_/S vssd1 vssd1 vccd1 vccd1 _3262_/D sky130_fd_sc_hd__mux2_1
X_1704_ _3082_/Q _3065_/Q vssd1 vssd1 vccd1 vccd1 _1705_/B sky130_fd_sc_hd__nand2_2
X_2684_ hold612/X _2817_/A1 _2685_/S vssd1 vssd1 vccd1 vccd1 _3197_/D sky130_fd_sc_hd__mux2_1
X_1635_ _3071_/Q _3054_/Q _1690_/S vssd1 vssd1 vccd1 vccd1 _1635_/X sky130_fd_sc_hd__o21a_2
X_1566_ _3142_/Q _3143_/Q vssd1 vssd1 vccd1 vccd1 _1609_/B sky130_fd_sc_hd__nor2_2
X_3305_ _3387_/CLK _3305_/D fanout235/X vssd1 vssd1 vccd1 vccd1 _3305_/Q sky130_fd_sc_hd__dfrtp_2
XANTENNA__2467__B _2472_/B vssd1 vssd1 vccd1 vccd1 sky130_fd_sc_hd__diode_2
X_3236_ _3297_/CLK _3236_/D fanout274/X vssd1 vssd1 vccd1 vccd1 _3236_/Q sky130_fd_sc_hd__dfrtp_2
X_3167_ _3349_/CLK _3167_/D load_slew230/X vssd1 vssd1 vccd1 vccd1 _3167_/Q sky130_fd_sc_hd__dfrtp_2
X_3098_ _3119_/CLK _3098_/D load_slew216/X vssd1 vssd1 vccd1 vccd1 _3098_/Q sky130_fd_sc_hd__dfrtp_2
X_2118_ _2139_/A _2138_/B vssd1 vssd1 vccd1 vccd1 _2119_/B sky130_fd_sc_hd__or2_2
XANTENNA__2483__A _2533_/A vssd1 vssd1 vccd1 vccd1 sky130_fd_sc_hd__diode_2
X_2049_ _2073_/A _2049_/B _2073_/B _2073_/C vssd1 vssd1 vccd1 vccd1 _2049_/X sky130_fd_sc_hd__and4_2
XTAP_TAPCELL_ROW_1_179 vssd1 vccd1 sky130_fd_sc_hd__tapvpwrvgnd_1
Xfanout13 _2819_/X vssd1 vssd1 vccd1 vccd1 _2837_/S sky130_fd_sc_hd__clkdlybuf4s25_1
Xfanout24 _2724_/X vssd1 vssd1 vccd1 vccd1 _2738_/S sky130_fd_sc_hd__clkdlybuf4s25_1
Xfanout35 _1585_/Y vssd1 vssd1 vccd1 vccd1 _2864_/S sky130_fd_sc_hd__clkdlybuf4s25_1
Xfanout46 _2628_/X vssd1 vssd1 vccd1 vccd1 _2809_/A1 sky130_fd_sc_hd__clkdlybuf4s25_1
Xfanout57 _2569_/Y vssd1 vssd1 vccd1 vccd1 _2583_/B1 sky130_fd_sc_hd__clkdlybuf4s25_1
Xfanout79 _2901_/A2 vssd1 vssd1 vccd1 vccd1 _2968_/A2 sky130_fd_sc_hd__clkdlybuf4s25_1
XFILLER_22_297 vssd1 vssd1 vccd1 vccd1 sky130_fd_sc_hd__fill_2
XFILLER_6_419 vssd1 vssd1 vccd1 vccd1 sky130_fd_sc_hd__fill_1
XANTENNA_fanout90_A _1574_/X vssd1 vssd1 vccd1 vccd1 sky130_fd_sc_hd__diode_2
Xhold460 _3290_/Q vssd1 vssd1 vccd1 vccd1 hold460/X sky130_fd_sc_hd__dlygate4sd3_1
Xhold471 _3111_/Q vssd1 vssd1 vccd1 vccd1 hold471/X sky130_fd_sc_hd__dlygate4sd3_1
XTAP_TAPCELL_ROW_9_246 vssd1 vccd1 sky130_fd_sc_hd__tapvpwrvgnd_1
XFILLER_1_113 vssd1 vssd1 vccd1 vccd1 sky130_fd_sc_hd__fill_1
Xhold493 _3198_/Q vssd1 vssd1 vccd1 vccd1 hold493/X sky130_fd_sc_hd__dlygate4sd3_1
Xhold482 _3101_/Q vssd1 vssd1 vccd1 vccd1 hold482/X sky130_fd_sc_hd__dlygate4sd3_1
XFILLER_72_120 vssd1 vssd1 vccd1 vccd1 sky130_fd_sc_hd__fill_4
XTAP_TAPCELL_ROW_43_535 vssd1 vccd1 sky130_fd_sc_hd__tapvpwrvgnd_1
Xclkload16 _3437_/CLK vssd1 vssd1 vccd1 vccd1 clkload16/X sky130_fd_sc_hd__clkbuf_4
XFILLER_70_95 vssd1 vssd1 vccd1 vccd1 sky130_fd_sc_hd__fill_2
XANTENNA__2523__A2 _2960_/A2 vssd1 vssd1 vccd1 vccd1 sky130_fd_sc_hd__diode_2
X_3021_ _3090_/CLK _3021_/D fanout214/X vssd1 vssd1 vccd1 vccd1 _3021_/Q sky130_fd_sc_hd__dfrtp_2
XFILLER_48_172 vssd1 vssd1 vccd1 vccd1 sky130_fd_sc_hd__fill_1
XFILLER_63_164 vssd1 vssd1 vccd1 vccd1 sky130_fd_sc_hd__fill_2
XFILLER_51_359 vssd1 vssd1 vccd1 vccd1 sky130_fd_sc_hd__fill_1
X_2805_ hold516/X _2805_/A1 _2818_/S vssd1 vssd1 vccd1 vccd1 _3311_/D sky130_fd_sc_hd__mux2_1
XTAP_TAPCELL_ROW_14_292 vssd1 vccd1 sky130_fd_sc_hd__tapvpwrvgnd_1
X_2736_ hold643/X _2850_/A1 _2742_/S vssd1 vssd1 vccd1 vccd1 _3246_/D sky130_fd_sc_hd__mux2_1
X_2667_ _2686_/A _2667_/B _2800_/C vssd1 vssd1 vccd1 vccd1 _2667_/X sky130_fd_sc_hd__and3_2
X_1618_ _3420_/Q _2426_/C _1612_/Y vssd1 vssd1 vccd1 vccd1 _1618_/Y sky130_fd_sc_hd__o21ai_2
Xfanout203 fanout214/X vssd1 vssd1 vccd1 vccd1 _1775_/B sky130_fd_sc_hd__clkdlybuf4s25_1
Xfanout214 fanout291/X vssd1 vssd1 vccd1 vccd1 fanout214/X sky130_fd_sc_hd__clkdlybuf4s25_1
X_2598_ _2588_/A _1609_/B _2590_/B vssd1 vssd1 vccd1 vccd1 _2598_/Y sky130_fd_sc_hd__a21oi_2
Xfanout236 fanout242/X vssd1 vssd1 vccd1 vccd1 fanout236/X sky130_fd_sc_hd__clkdlybuf4s25_1
Xfanout247 fanout249/X vssd1 vssd1 vccd1 vccd1 fanout247/X sky130_fd_sc_hd__clkdlybuf4s25_1
X_1549_ _3393_/Q _3465_/Q _1554_/S vssd1 vssd1 vccd1 vccd1 _3466_/D sky130_fd_sc_hd__mux2_1
XTAP_TAPCELL_ROW_6_227 vssd1 vccd1 sky130_fd_sc_hd__tapvpwrvgnd_1
XFILLER_59_415 vssd1 vssd1 vccd1 vccd1 sky130_fd_sc_hd__fill_1
XANTENNA_fanout180_X _2279_/B vssd1 vssd1 vccd1 vccd1 sky130_fd_sc_hd__diode_2
X_3219_ _3431_/CLK _3219_/D fanout265/X vssd1 vssd1 vccd1 vccd1 _3219_/Q sky130_fd_sc_hd__dfrtp_2
XFILLER_74_429 vssd1 vssd1 vccd1 vccd1 sky130_fd_sc_hd__fill_2
XFILLER_46_109 vssd1 vssd1 vccd1 vccd1 sky130_fd_sc_hd__fill_1
XFILLER_24_22 vssd1 vssd1 vccd1 vccd1 sky130_fd_sc_hd__fill_4
XFILLER_24_11 vssd1 vssd1 vccd1 vccd1 sky130_fd_sc_hd__fill_2
XTAP_TAPCELL_ROW_40_516 vssd1 vccd1 sky130_fd_sc_hd__tapvpwrvgnd_1
XFILLER_24_55 vssd1 vssd1 vccd1 vccd1 sky130_fd_sc_hd__fill_2
XFILLER_24_77 vssd1 vssd1 vccd1 vccd1 sky130_fd_sc_hd__fill_4
XFILLER_6_249 vssd1 vssd1 vccd1 vccd1 sky130_fd_sc_hd__fill_2
XFILLER_40_32 vssd1 vssd1 vccd1 vccd1 sky130_fd_sc_hd__fill_8
XANTENNA__1961__B1 _1998_/B vssd1 vssd1 vccd1 vccd1 sky130_fd_sc_hd__diode_2
XANTENNA__2505__A2 _2901_/A2 vssd1 vssd1 vccd1 vccd1 sky130_fd_sc_hd__diode_2
XANTENNA_fanout93_X _1569_/D vssd1 vssd1 vccd1 vccd1 sky130_fd_sc_hd__diode_2
XFILLER_2_477 vssd1 vssd1 vccd1 vccd1 sky130_fd_sc_hd__fill_8
XFILLER_65_73 vssd1 vssd1 vccd1 vccd1 sky130_fd_sc_hd__fill_2
XFILLER_18_367 vssd1 vssd1 vccd1 vccd1 sky130_fd_sc_hd__fill_1
XTAP_TAPCELL_ROW_11_262 vssd1 vccd1 sky130_fd_sc_hd__tapvpwrvgnd_1
X_2521_ _3223_/Q _2967_/A2 _2518_/X _2973_/A1 _2520_/X vssd1 vssd1 vccd1 vccd1 _2527_/A
+ sky130_fd_sc_hd__a221o_2
X_2452_ _2452_/A _2452_/B vssd1 vssd1 vccd1 vccd1 _2453_/B sky130_fd_sc_hd__or2_2
XFILLER_5_293 vssd1 vssd1 vccd1 vccd1 sky130_fd_sc_hd__fill_4
XFILLER_46_3 vssd1 vssd1 vccd1 vccd1 sky130_fd_sc_hd__fill_8
X_2383_ _2399_/A _2383_/B _2384_/A _2384_/B vssd1 vssd1 vccd1 vccd1 _2386_/A sky130_fd_sc_hd__and4_2
XPHY_EDGE_ROW_18_Right_18 vssd1 vssd1 vccd1 vccd1 sky130_fd_sc_hd__decap_3
XFILLER_68_201 vssd1 vssd1 vccd1 vccd1 sky130_fd_sc_hd__fill_1
XFILLER_68_278 vssd1 vssd1 vccd1 vccd1 sky130_fd_sc_hd__fill_1
XFILLER_56_429 vssd1 vssd1 vccd1 vccd1 sky130_fd_sc_hd__fill_1
X_3004_ _3199_/CLK _3004_/D wire222/X vssd1 vssd1 vccd1 vccd1 _3004_/Q sky130_fd_sc_hd__dfrtp_2
Xinput3 gpio_in[1] vssd1 vssd1 vccd1 vccd1 input3/X sky130_fd_sc_hd__clkdlybuf4s25_1
XFILLER_36_131 vssd1 vssd1 vccd1 vccd1 sky130_fd_sc_hd__fill_8
XFILLER_36_164 vssd1 vssd1 vccd1 vccd1 sky130_fd_sc_hd__fill_2
XPHY_EDGE_ROW_27_Right_27 vssd1 vssd1 vccd1 vccd1 sky130_fd_sc_hd__decap_3
XANTENNA_fanout140_A _3088_/Q vssd1 vssd1 vccd1 vccd1 sky130_fd_sc_hd__diode_2
XANTENNA_fanout238_A fanout242/X vssd1 vssd1 vccd1 vccd1 sky130_fd_sc_hd__diode_2
XTAP_TAPCELL_ROW_62_696 vssd1 vccd1 sky130_fd_sc_hd__tapvpwrvgnd_1
X_2719_ hold467/X _2814_/A1 _2719_/S vssd1 vssd1 vccd1 vccd1 _3230_/D sky130_fd_sc_hd__mux2_1
XANTENNA__2700__S _2700_/S vssd1 vssd1 vccd1 vccd1 sky130_fd_sc_hd__diode_2
XPHY_EDGE_ROW_36_Right_36 vssd1 vssd1 vccd1 vccd1 sky130_fd_sc_hd__decap_3
XFILLER_47_429 vssd1 vssd1 vccd1 vccd1 sky130_fd_sc_hd__fill_4
XFILLER_19_77 vssd1 vssd1 vccd1 vccd1 sky130_fd_sc_hd__fill_1
XPHY_EDGE_ROW_45_Right_45 vssd1 vssd1 vccd1 vccd1 sky130_fd_sc_hd__decap_3
XFILLER_35_65 vssd1 vssd1 vccd1 vccd1 sky130_fd_sc_hd__fill_8
XFILLER_42_167 vssd1 vssd1 vccd1 vccd1 sky130_fd_sc_hd__fill_4
XFILLER_35_87 vssd1 vssd1 vccd1 vccd1 sky130_fd_sc_hd__fill_1
XTAP_TAPCELL_ROW_25_387 vssd1 vccd1 sky130_fd_sc_hd__tapvpwrvgnd_1
XANTENNA__2974__A2 _2864_/S vssd1 vssd1 vccd1 vccd1 sky130_fd_sc_hd__diode_2
XFILLER_51_31 vssd1 vssd1 vccd1 vccd1 sky130_fd_sc_hd__fill_2
XANTENNA__1574__X _1574_/X vssd1 vssd1 vccd1 vccd1 sky130_fd_sc_hd__diode_2
XPHY_EDGE_ROW_54_Right_54 vssd1 vssd1 vccd1 vccd1 sky130_fd_sc_hd__decap_3
XFILLER_76_61 vssd1 vssd1 vccd1 vccd1 sky130_fd_sc_hd__fill_2
XPHY_EDGE_ROW_63_Right_63 vssd1 vssd1 vccd1 vccd1 sky130_fd_sc_hd__decap_3
XFILLER_18_175 vssd1 vssd1 vccd1 vccd1 sky130_fd_sc_hd__fill_1
XTAP_TAPCELL_ROW_16_310 vssd1 vccd1 sky130_fd_sc_hd__tapvpwrvgnd_1
X_1952_ _1953_/A _1953_/B vssd1 vssd1 vccd1 vccd1 _1952_/Y sky130_fd_sc_hd__nor2_2
X_1883_ _1884_/A _1979_/B _2002_/B _1979_/A vssd1 vssd1 vccd1 vccd1 _1885_/B sky130_fd_sc_hd__a22o_2
XPHY_EDGE_ROW_72_Right_72 vssd1 vssd1 vccd1 vccd1 sky130_fd_sc_hd__decap_3
X_2504_ _2900_/A _2959_/C _3276_/Q vssd1 vssd1 vccd1 vccd1 _2504_/X sky130_fd_sc_hd__and3_2
X_2435_ _2533_/B _2434_/X _2435_/S vssd1 vssd1 vccd1 vccd1 _3089_/D sky130_fd_sc_hd__mux2_1
Xteam_02_308 vssd1 vssd1 vccd1 vccd1 team_02_308/HI gpio_out[11] sky130_fd_sc_hd__conb_1
XANTENNA__2350__B1 _2352_/C vssd1 vssd1 vccd1 vccd1 sky130_fd_sc_hd__diode_2
Xteam_02_319 vssd1 vssd1 vccd1 vccd1 team_02_319/HI gpio_out[22] sky130_fd_sc_hd__conb_1
X_2366_ _2338_/A _2339_/B _2340_/A vssd1 vssd1 vccd1 vccd1 _2369_/C sky130_fd_sc_hd__o21ba_2
X_2297_ _2297_/A _2318_/A _2297_/C vssd1 vssd1 vccd1 vccd1 _2298_/B sky130_fd_sc_hd__and3_2
XTAP_TAPCELL_ROW_67_744 vssd1 vccd1 sky130_fd_sc_hd__tapvpwrvgnd_1
XANTENNA__2102__B1 _2154_/B vssd1 vssd1 vccd1 vccd1 sky130_fd_sc_hd__diode_2
XTAP_TAPCELL_ROW_50_600 vssd1 vccd1 sky130_fd_sc_hd__tapvpwrvgnd_1
XANTENNA__2956__A2 _2960_/A2 vssd1 vssd1 vccd1 vccd1 sky130_fd_sc_hd__diode_2
XTAP_TAPCELL_ROW_22_357 vssd1 vccd1 sky130_fd_sc_hd__tapvpwrvgnd_1
XFILLER_21_67 vssd1 vssd1 vccd1 vccd1 sky130_fd_sc_hd__fill_1
XFILLER_46_53 vssd1 vssd1 vccd1 vccd1 sky130_fd_sc_hd__fill_2
XFILLER_55_281 vssd1 vssd1 vccd1 vccd1 sky130_fd_sc_hd__fill_1
XFILLER_70_251 vssd1 vssd1 vccd1 vccd1 sky130_fd_sc_hd__fill_1
XFILLER_70_273 vssd1 vssd1 vccd1 vccd1 sky130_fd_sc_hd__fill_2
XFILLER_30_126 vssd1 vssd1 vccd1 vccd1 sky130_fd_sc_hd__fill_2
XFILLER_62_85 vssd1 vccd1 vssd1 vccd1 sky130_ef_sc_hd__decap_40_12
XFILLER_7_333 vssd1 vssd1 vccd1 vccd1 sky130_fd_sc_hd__fill_1
Xload_slew225 fanout224/X vssd1 vssd1 vccd1 vccd1 load_slew225/X sky130_fd_sc_hd__clkbuf_4
X_2220_ _2257_/A _2326_/B vssd1 vssd1 vccd1 vccd1 _2221_/C sky130_fd_sc_hd__nand2_2
Xload_slew258 fanout257/X vssd1 vssd1 vccd1 vccd1 load_slew258/X sky130_fd_sc_hd__clkbuf_4
Xload_slew269 fanout268/X vssd1 vssd1 vccd1 vccd1 _3472_/SET_B sky130_fd_sc_hd__clkbuf_2
X_2151_ _2151_/A _2152_/B vssd1 vssd1 vccd1 vccd1 _2151_/Y sky130_fd_sc_hd__xnor2_2
XFILLER_78_373 vssd1 vssd1 vccd1 vccd1 sky130_fd_sc_hd__fill_2
X_2082_ _2082_/A vssd1 vssd1 vccd1 vccd1 _2084_/B sky130_fd_sc_hd__inv_2
XTAP_TAPCELL_ROW_64_714 vssd1 vccd1 sky130_fd_sc_hd__tapvpwrvgnd_1
XFILLER_53_229 vssd1 vssd1 vccd1 vccd1 sky130_fd_sc_hd__fill_2
X_2984_ _3443_/D _1506_/Y _3408_/Q vssd1 vssd1 vccd1 vccd1 _3408_/D sky130_fd_sc_hd__a21o_2
XTAP_TAPCELL_ROW_72_780 vssd1 vccd1 sky130_fd_sc_hd__tapvpwrvgnd_1
XFILLER_21_115 vssd1 vssd1 vccd1 vccd1 sky130_fd_sc_hd__fill_8
X_1935_ _1900_/A _1900_/C _1900_/B vssd1 vssd1 vccd1 vccd1 _1942_/A sky130_fd_sc_hd__a21bo_2
X_1866_ _1947_/A _2005_/A _1970_/B _1865_/B vssd1 vssd1 vccd1 vccd1 _1867_/C sky130_fd_sc_hd__a22oi_2
X_1797_ _1797_/A _1797_/B _1797_/C vssd1 vssd1 vccd1 vccd1 _1819_/B sky130_fd_sc_hd__and3_2
X_3467_ _3471_/CLK _3467_/D fanout259/X vssd1 vssd1 vccd1 vccd1 _3467_/Q sky130_fd_sc_hd__dfrtp_2
X_3398_ _3398_/CLK _3398_/D load_slew250/X vssd1 vssd1 vccd1 vccd1 _3398_/Q sky130_fd_sc_hd__dfrtp_2
X_2418_ hold406/X _2091_/B _2416_/X _2417_/X vssd1 vssd1 vccd1 vccd1 _3085_/D sky130_fd_sc_hd__a22o_2
XANTENNA__2874__A1 _2445_/S vssd1 vssd1 vccd1 vccd1 sky130_fd_sc_hd__diode_2
X_2349_ _2377_/A _2349_/B vssd1 vssd1 vccd1 vccd1 _2365_/A sky130_fd_sc_hd__or2_2
XANTENNA__2874__B2 _2838_/A vssd1 vssd1 vccd1 vccd1 sky130_fd_sc_hd__diode_2
XTAP_TAPCELL_ROW_27_405 vssd1 vccd1 sky130_fd_sc_hd__tapvpwrvgnd_1
XANTENNA__2626__A1 _3406_/Q vssd1 vssd1 vccd1 vccd1 sky130_fd_sc_hd__diode_2
XANTENNA__2933__B _2970_/B vssd1 vssd1 vccd1 vccd1 sky130_fd_sc_hd__diode_2
XPHY_EDGE_ROW_0_Right_0 vssd1 vssd1 vccd1 vccd1 sky130_fd_sc_hd__decap_3
XFILLER_52_251 vssd1 vssd1 vccd1 vccd1 sky130_fd_sc_hd__fill_1
XTAP_TAPCELL_ROW_35_471 vssd1 vccd1 sky130_fd_sc_hd__tapvpwrvgnd_1
XFILLER_12_148 vssd1 vssd1 vccd1 vccd1 sky130_fd_sc_hd__fill_8
XFILLER_12_137 vssd1 vssd1 vccd1 vccd1 sky130_fd_sc_hd__fill_2
XANTENNA_fanout16_A _2800_/X vssd1 vssd1 vccd1 vccd1 sky130_fd_sc_hd__diode_2
XANTENNA_clkbuf_3_2__f_clk_X clkload1/A vssd1 vssd1 vccd1 vccd1 sky130_fd_sc_hd__diode_2
XFILLER_4_336 vssd1 vssd1 vccd1 vccd1 sky130_fd_sc_hd__fill_2
XANTENNA__2099__C _2297_/A vssd1 vssd1 vccd1 vccd1 sky130_fd_sc_hd__diode_2
XFILLER_79_137 vssd1 vssd1 vccd1 vccd1 sky130_fd_sc_hd__fill_2
XANTENNA__2865__A1 _2686_/A vssd1 vssd1 vccd1 vccd1 sky130_fd_sc_hd__diode_2
XTAP_TAPCELL_ROW_78_839 vssd1 vccd1 sky130_fd_sc_hd__tapvpwrvgnd_1
XANTENNA__2865__B2 _2838_/A vssd1 vssd1 vccd1 vccd1 sky130_fd_sc_hd__diode_2
XFILLER_31_402 vssd1 vssd1 vccd1 vccd1 sky130_fd_sc_hd__fill_1
X_1720_ hold731/X _1719_/Y _1738_/S vssd1 vssd1 vccd1 vccd1 _3017_/D sky130_fd_sc_hd__mux2_1
X_1651_ _1660_/A _1651_/B vssd1 vssd1 vccd1 vccd1 _1653_/A sky130_fd_sc_hd__nand2b_2
X_3321_ _3359_/CLK _3321_/D load_slew244/X vssd1 vssd1 vccd1 vccd1 _3321_/Q sky130_fd_sc_hd__dfrtp_2
X_1582_ _1583_/A _1583_/B vssd1 vssd1 vccd1 vccd1 _1582_/Y sky130_fd_sc_hd__nor2_2
X_3252_ _3398_/CLK _3252_/D fanout249/X vssd1 vssd1 vccd1 vccd1 _3252_/Q sky130_fd_sc_hd__dfrtp_2
XFILLER_3_391 vssd1 vssd1 vccd1 vccd1 sky130_fd_sc_hd__fill_1
X_3183_ _3431_/CLK _3183_/D fanout265/X vssd1 vssd1 vccd1 vccd1 _3183_/Q sky130_fd_sc_hd__dfrtp_2
X_2203_ _2193_/A _2193_/C _2193_/B vssd1 vssd1 vccd1 vccd1 _2237_/A sky130_fd_sc_hd__o21ba_2
X_2134_ _2132_/X _2134_/B vssd1 vssd1 vccd1 vccd1 _2135_/B sky130_fd_sc_hd__nand2b_2
X_2065_ _2065_/A vssd1 vssd1 vccd1 vccd1 _2065_/Y sky130_fd_sc_hd__inv_2
XTAP_TAPCELL_ROW_49_585 vssd1 vccd1 sky130_fd_sc_hd__tapvpwrvgnd_1
XPHY_EDGE_ROW_22_Left_102 vssd1 vssd1 vccd1 vccd1 sky130_fd_sc_hd__decap_3
XTAP_TAPCELL_ROW_32_441 vssd1 vccd1 sky130_fd_sc_hd__tapvpwrvgnd_1
X_2967_ _3234_/Q _2967_/A2 _2966_/X _2520_/A vssd1 vssd1 vccd1 vccd1 _2967_/X sky130_fd_sc_hd__a22o_2
X_2898_ _2962_/A1 _3156_/Q _3300_/Q _2961_/A1 vssd1 vssd1 vccd1 vccd1 _2898_/X sky130_fd_sc_hd__a22o_2
X_1918_ _1879_/A _1879_/B _1878_/B _1876_/X vssd1 vssd1 vccd1 vccd1 _1920_/B sky130_fd_sc_hd__a31o_2
X_1849_ _1832_/A _1832_/B _1833_/A vssd1 vssd1 vccd1 vccd1 _1849_/X sky130_fd_sc_hd__a21o_2
Xhold620 _3269_/Q vssd1 vssd1 vccd1 vccd1 hold620/X sky130_fd_sc_hd__dlygate4sd3_1
Xhold653 _3310_/Q vssd1 vssd1 vccd1 vccd1 hold653/X sky130_fd_sc_hd__dlygate4sd3_1
Xhold642 _3321_/Q vssd1 vssd1 vccd1 vccd1 hold642/X sky130_fd_sc_hd__dlygate4sd3_1
Xhold631 _3012_/Q vssd1 vssd1 vccd1 vccd1 hold631/X sky130_fd_sc_hd__dlygate4sd3_1
XPHY_EDGE_ROW_31_Left_111 vssd1 vssd1 vccd1 vccd1 sky130_fd_sc_hd__decap_3
XFILLER_78_29 vssd1 vssd1 vccd1 vccd1 sky130_fd_sc_hd__fill_8
XANTENNA__1898__A2 _1962_/B vssd1 vssd1 vccd1 vccd1 sky130_fd_sc_hd__diode_2
Xhold697 _3060_/Q vssd1 vssd1 vccd1 vccd1 hold697/X sky130_fd_sc_hd__dlygate4sd3_1
Xhold686 _3015_/Q vssd1 vssd1 vccd1 vccd1 hold686/X sky130_fd_sc_hd__dlygate4sd3_1
Xhold675 _3096_/Q vssd1 vssd1 vccd1 vccd1 hold675/X sky130_fd_sc_hd__dlygate4sd3_1
Xhold664 _3217_/Q vssd1 vssd1 vccd1 vccd1 hold664/X sky130_fd_sc_hd__dlygate4sd3_1
XTAP_TAPCELL_ROW_75_809 vssd1 vccd1 sky130_fd_sc_hd__tapvpwrvgnd_1
XPHY_EDGE_ROW_40_Left_120 vssd1 vssd1 vccd1 vccd1 sky130_fd_sc_hd__decap_3
XFILLER_40_210 vssd1 vssd1 vccd1 vccd1 sky130_fd_sc_hd__fill_1
XFILLER_40_232 vssd1 vssd1 vccd1 vccd1 sky130_fd_sc_hd__fill_1
XANTENNA_fanout19_X _2780_/S vssd1 vssd1 vccd1 vccd1 sky130_fd_sc_hd__diode_2
Xclkbuf_leaf_20_clk clkload5/A vssd1 vssd1 vccd1 vccd1 _3394_/CLK sky130_fd_sc_hd__clkbuf_8
XFILLER_4_133 vssd1 vssd1 vccd1 vccd1 sky130_fd_sc_hd__fill_2
XFILLER_4_177 vssd1 vccd1 vssd1 vccd1 sky130_ef_sc_hd__decap_40_12
XANTENNA__2838__B _2838_/B vssd1 vssd1 vccd1 vccd1 sky130_fd_sc_hd__diode_2
XFILLER_0_361 vssd1 vssd1 vccd1 vccd1 sky130_fd_sc_hd__fill_2
XFILLER_48_365 vssd1 vssd1 vccd1 vccd1 sky130_fd_sc_hd__fill_2
XTAP_TAPCELL_ROW_46_566 vssd1 vccd1 sky130_fd_sc_hd__tapvpwrvgnd_1
XFILLER_71_390 vssd1 vssd1 vccd1 vccd1 sky130_fd_sc_hd__fill_2
X_2821_ hold452/X _2614_/X _2833_/S vssd1 vssd1 vccd1 vccd1 _3326_/D sky130_fd_sc_hd__mux2_1
X_2752_ hold510/X _2809_/A1 _2757_/S vssd1 vssd1 vccd1 vccd1 _3261_/D sky130_fd_sc_hd__mux2_1
Xclkbuf_leaf_11_clk clkload2/A vssd1 vssd1 vccd1 vccd1 _3199_/CLK sky130_fd_sc_hd__clkbuf_8
XFILLER_76_3 vssd1 vssd1 vccd1 vccd1 sky130_fd_sc_hd__fill_8
X_1703_ _3082_/Q _3065_/Q vssd1 vssd1 vccd1 vccd1 _1705_/A sky130_fd_sc_hd__or2_2
X_2683_ hold590/X _2816_/A1 _2685_/S vssd1 vssd1 vccd1 vccd1 _3196_/D sky130_fd_sc_hd__mux2_1
X_1634_ _3071_/Q _3054_/Q vssd1 vssd1 vccd1 vccd1 _1640_/A sky130_fd_sc_hd__nand2_2
X_1565_ _2426_/A _3141_/Q vssd1 vssd1 vccd1 vccd1 _1609_/A sky130_fd_sc_hd__nand2_2
X_3304_ _3395_/CLK _3304_/D load_slew246/X vssd1 vssd1 vccd1 vccd1 _3304_/Q sky130_fd_sc_hd__dfrtp_2
X_3235_ _3383_/CLK _3235_/D load_slew264/X vssd1 vssd1 vccd1 vccd1 _3235_/Q sky130_fd_sc_hd__dfrtp_2
X_3166_ _3386_/CLK _3166_/D load_slew212/X vssd1 vssd1 vccd1 vccd1 _3166_/Q sky130_fd_sc_hd__dfrtp_2
X_3097_ clkload6/A _3097_/D load_slew202/X vssd1 vssd1 vccd1 vccd1 _3097_/Q sky130_fd_sc_hd__dfrtp_2
X_2117_ _2117_/A _2117_/B _2117_/C vssd1 vssd1 vccd1 vccd1 _2138_/B sky130_fd_sc_hd__and3_2
XFILLER_66_195 vssd1 vssd1 vccd1 vccd1 sky130_fd_sc_hd__fill_1
XANTENNA__2483__B _2533_/B vssd1 vssd1 vccd1 vccd1 sky130_fd_sc_hd__diode_2
X_2048_ hold394/X _2047_/Y _2412_/S vssd1 vssd1 vccd1 vccd1 _3065_/D sky130_fd_sc_hd__mux2_1
Xfanout14 _2819_/X vssd1 vssd1 vccd1 vccd1 _2833_/S sky130_fd_sc_hd__clkdlybuf4s25_1
Xfanout25 _2705_/X vssd1 vssd1 vccd1 vccd1 _2723_/S sky130_fd_sc_hd__clkdlybuf4s25_1
Xfanout36 _1585_/Y vssd1 vssd1 vccd1 vccd1 _3437_/D sky130_fd_sc_hd__clkdlybuf4s25_1
Xfanout47 _2626_/X vssd1 vssd1 vccd1 vccd1 _2808_/A1 sky130_fd_sc_hd__clkdlybuf4s25_1
Xfanout69 _2901_/B1 vssd1 vssd1 vccd1 vccd1 _2968_/B1 sky130_fd_sc_hd__clkdlybuf4s25_1
XFILLER_10_405 vssd1 vssd1 vccd1 vccd1 sky130_fd_sc_hd__fill_1
XANTENNA__2703__S _2704_/S vssd1 vssd1 vccd1 vccd1 sky130_fd_sc_hd__diode_2
XANTENNA_fanout223_X fanout223/X vssd1 vssd1 vccd1 vccd1 sky130_fd_sc_hd__diode_2
XFILLER_13_57 vssd1 vssd1 vccd1 vccd1 sky130_fd_sc_hd__fill_4
XFILLER_13_35 vssd1 vssd1 vccd1 vccd1 sky130_fd_sc_hd__fill_1
XANTENNA__2004__A _2029_/D vssd1 vssd1 vccd1 vccd1 sky130_fd_sc_hd__diode_2
Xhold450 _3216_/Q vssd1 vssd1 vccd1 vccd1 hold450/X sky130_fd_sc_hd__dlygate4sd3_1
Xhold461 _3248_/Q vssd1 vssd1 vccd1 vccd1 hold461/X sky130_fd_sc_hd__dlygate4sd3_1
Xhold472 _3277_/Q vssd1 vssd1 vccd1 vccd1 hold472/X sky130_fd_sc_hd__dlygate4sd3_1
XTAP_TAPCELL_ROW_9_247 vssd1 vccd1 sky130_fd_sc_hd__tapvpwrvgnd_1
Xhold494 _3252_/Q vssd1 vssd1 vccd1 vccd1 hold494/X sky130_fd_sc_hd__dlygate4sd3_1
Xhold483 _3109_/Q vssd1 vssd1 vccd1 vccd1 hold483/X sky130_fd_sc_hd__dlygate4sd3_1
XFILLER_77_449 vssd1 vssd1 vccd1 vccd1 sky130_fd_sc_hd__fill_4
XFILLER_38_43 vssd1 vccd1 vssd1 vccd1 sky130_ef_sc_hd__decap_40_12
XFILLER_38_65 vssd1 vssd1 vccd1 vccd1 sky130_fd_sc_hd__fill_1
XANTENNA__3462__CLK _3463_/CLK vssd1 vssd1 vccd1 vccd1 sky130_fd_sc_hd__diode_2
XFILLER_57_173 vssd1 vssd1 vccd1 vccd1 sky130_fd_sc_hd__fill_2
XFILLER_45_357 vssd1 vssd1 vccd1 vccd1 sky130_fd_sc_hd__fill_1
XTAP_TAPCELL_ROW_43_536 vssd1 vccd1 sky130_fd_sc_hd__tapvpwrvgnd_1
XFILLER_13_243 vssd1 vssd1 vccd1 vccd1 sky130_fd_sc_hd__fill_1
XFILLER_13_221 vssd1 vssd1 vccd1 vccd1 sky130_fd_sc_hd__fill_1
XANTENNA__2613__S _2647_/S vssd1 vssd1 vccd1 vccd1 sky130_fd_sc_hd__diode_2
Xclkload17 _3383_/CLK vssd1 vssd1 vccd1 vccd1 clkload17/Y sky130_fd_sc_hd__clkinv_2
XFILLER_70_85 vssd1 vssd1 vccd1 vccd1 sky130_fd_sc_hd__fill_2
XFILLER_70_63 vssd1 vssd1 vccd1 vccd1 sky130_fd_sc_hd__fill_4
XFILLER_79_50 vssd1 vssd1 vccd1 vccd1 sky130_fd_sc_hd__fill_4
XFILLER_79_83 vssd1 vssd1 vccd1 vccd1 sky130_fd_sc_hd__fill_1
XFILLER_68_416 vssd1 vssd1 vccd1 vccd1 sky130_fd_sc_hd__fill_2
X_3020_ _3090_/CLK _3020_/D wire208/X vssd1 vssd1 vccd1 vccd1 _3020_/Q sky130_fd_sc_hd__dfrtp_2
Xclkbuf_leaf_0_clk clkbuf_leaf_2_clk/A vssd1 vssd1 vccd1 vccd1 clkload6/A sky130_fd_sc_hd__clkbuf_8
XANTENNA__3343__RESET_B fanout223/X vssd1 vssd1 vccd1 vccd1 sky130_fd_sc_hd__diode_2
X_2804_ hold653/X _2842_/A1 _2818_/S vssd1 vssd1 vccd1 vccd1 _3310_/D sky130_fd_sc_hd__mux2_1
XTAP_TAPCELL_ROW_14_293 vssd1 vccd1 sky130_fd_sc_hd__tapvpwrvgnd_1
X_2735_ hold509/X _2811_/A1 _2738_/S vssd1 vssd1 vccd1 vccd1 _3245_/D sky130_fd_sc_hd__mux2_1
X_2666_ hold527/X _2818_/A1 _2666_/S vssd1 vssd1 vccd1 vccd1 _3180_/D sky130_fd_sc_hd__mux2_1
X_1617_ _1617_/A _2434_/A _1630_/B vssd1 vssd1 vccd1 vccd1 _2426_/C sky130_fd_sc_hd__or3_2
Xfanout204 fanout206/X vssd1 vssd1 vccd1 vccd1 fanout204/X sky130_fd_sc_hd__clkdlybuf4s25_1
X_2597_ _2426_/A _2596_/Y _2601_/C vssd1 vssd1 vccd1 vccd1 _3140_/D sky130_fd_sc_hd__mux2_1
Xfanout215 fanout217/X vssd1 vssd1 vccd1 vccd1 fanout215/X sky130_fd_sc_hd__clkdlybuf4s25_1
Xfanout226 fanout228/X vssd1 vssd1 vccd1 vccd1 fanout226/X sky130_fd_sc_hd__clkdlybuf4s25_1
X_1548_ _3392_/Q _3464_/Q _1554_/S vssd1 vssd1 vccd1 vccd1 _3465_/D sky130_fd_sc_hd__mux2_1
Xfanout259 fanout290/X vssd1 vssd1 vccd1 vccd1 fanout259/X sky130_fd_sc_hd__clkdlybuf4s25_1
XANTENNA__2278__A2 _2279_/B vssd1 vssd1 vccd1 vccd1 sky130_fd_sc_hd__diode_2
X_3218_ _3297_/CLK _3218_/D fanout274/X vssd1 vssd1 vccd1 vccd1 _3218_/Q sky130_fd_sc_hd__dfrtp_2
XANTENNA__2494__A _2520_/A vssd1 vssd1 vccd1 vccd1 sky130_fd_sc_hd__diode_2
X_3149_ _3331_/CLK _3149_/D load_slew232/X vssd1 vssd1 vccd1 vccd1 _3149_/Q sky130_fd_sc_hd__dfrtp_2
XFILLER_67_493 vssd1 vssd1 vccd1 vccd1 sky130_fd_sc_hd__fill_1
XFILLER_39_173 vssd1 vssd1 vccd1 vccd1 sky130_fd_sc_hd__fill_2
XANTENNA__1789__B2 _2091_/B vssd1 vssd1 vccd1 vccd1 sky130_fd_sc_hd__diode_2
XANTENNA__2450__A2 _2667_/B vssd1 vssd1 vccd1 vccd1 sky130_fd_sc_hd__diode_2
XFILLER_40_11 vssd1 vssd1 vccd1 vccd1 sky130_fd_sc_hd__fill_2
XFILLER_1_16 vssd1 vssd1 vccd1 vccd1 sky130_fd_sc_hd__fill_8
XFILLER_18_313 vssd1 vssd1 vccd1 vccd1 sky130_fd_sc_hd__fill_4
XTAP_TAPCELL_ROW_56_650 vssd1 vccd1 sky130_fd_sc_hd__tapvpwrvgnd_1
XFILLER_65_52 vssd1 vssd1 vccd1 vccd1 sky130_fd_sc_hd__fill_4
XFILLER_73_485 vssd1 vssd1 vccd1 vccd1 sky130_fd_sc_hd__fill_2
XANTENNA__2441__A2 _2667_/B vssd1 vssd1 vccd1 vccd1 sky130_fd_sc_hd__diode_2
XTAP_TAPCELL_ROW_11_263 vssd1 vccd1 sky130_fd_sc_hd__tapvpwrvgnd_1
X_2520_ _2520_/A _2520_/B vssd1 vssd1 vccd1 vccd1 _2520_/X sky130_fd_sc_hd__and2_2
X_2451_ _2611_/A _2448_/X _2450_/X _2800_/A vssd1 vssd1 vccd1 vccd1 _2452_/B sky130_fd_sc_hd__a22o_2
X_2382_ _2382_/A _2382_/B vssd1 vssd1 vccd1 vccd1 _2388_/A sky130_fd_sc_hd__nor2_2
XFILLER_39_3 vssd1 vccd1 vssd1 vccd1 sky130_ef_sc_hd__decap_40_12
XANTENNA__2901__B1 _2901_/B1 vssd1 vssd1 vccd1 vccd1 sky130_fd_sc_hd__diode_2
XFILLER_68_246 vssd1 vssd1 vccd1 vccd1 sky130_fd_sc_hd__fill_4
X_3003_ _3003_/A vssd1 vssd1 vccd1 vccd1 _3003_/Y sky130_fd_sc_hd__inv_2
Xinput4 gpio_in[2] vssd1 vssd1 vccd1 vccd1 input4/X sky130_fd_sc_hd__clkdlybuf4s25_1
XFILLER_49_493 vssd1 vssd1 vccd1 vccd1 sky130_fd_sc_hd__fill_1
XTAP_TAPCELL_ROW_19_330 vssd1 vccd1 sky130_fd_sc_hd__tapvpwrvgnd_1
XFILLER_51_113 vssd1 vssd1 vccd1 vccd1 sky130_fd_sc_hd__fill_4
XFILLER_51_179 vssd1 vssd1 vccd1 vccd1 sky130_fd_sc_hd__fill_4
XTAP_TAPCELL_ROW_62_697 vssd1 vccd1 sky130_fd_sc_hd__tapvpwrvgnd_1
XANTENNA_fanout133_A _2900_/A vssd1 vssd1 vccd1 vccd1 sky130_fd_sc_hd__diode_2
X_2718_ hold549/X _2813_/A1 _2723_/S vssd1 vssd1 vccd1 vccd1 _3229_/D sky130_fd_sc_hd__mux2_1
XANTENNA__2489__A _2540_/A vssd1 vssd1 vccd1 vccd1 sky130_fd_sc_hd__diode_2
X_2649_ hold693/X _2839_/A1 _2666_/S vssd1 vssd1 vccd1 vccd1 _3163_/D sky130_fd_sc_hd__mux2_1
XANTENNA__2499__A2 _2960_/A2 vssd1 vssd1 vccd1 vccd1 sky130_fd_sc_hd__diode_2
XANTENNA_fanout290_X fanout290/X vssd1 vssd1 vccd1 vccd1 sky130_fd_sc_hd__diode_2
XFILLER_59_279 vssd1 vssd1 vccd1 vccd1 sky130_fd_sc_hd__fill_1
XFILLER_27_110 vssd1 vssd1 vccd1 vccd1 sky130_fd_sc_hd__fill_2
XFILLER_74_249 vssd1 vssd1 vccd1 vccd1 sky130_fd_sc_hd__fill_2
XFILLER_70_400 vssd1 vssd1 vccd1 vccd1 sky130_fd_sc_hd__fill_4
XFILLER_27_165 vssd1 vssd1 vccd1 vccd1 sky130_fd_sc_hd__fill_2
XTAP_TAPCELL_ROW_53_620 vssd1 vccd1 sky130_fd_sc_hd__tapvpwrvgnd_1
XFILLER_70_477 vssd1 vssd1 vccd1 vccd1 sky130_fd_sc_hd__fill_1
XFILLER_70_455 vssd1 vssd1 vccd1 vccd1 sky130_fd_sc_hd__fill_2
XTAP_TAPCELL_ROW_25_388 vssd1 vccd1 sky130_fd_sc_hd__tapvpwrvgnd_1
XANTENNA__1631__B1 _2610_/A vssd1 vssd1 vccd1 vccd1 sky130_fd_sc_hd__diode_2
XFILLER_51_54 vssd1 vssd1 vccd1 vccd1 sky130_fd_sc_hd__fill_2
XANTENNA__2399__A _2399_/A vssd1 vssd1 vccd1 vccd1 sky130_fd_sc_hd__diode_2
XPHY_EDGE_ROW_69_Left_149 vssd1 vssd1 vccd1 vccd1 sky130_fd_sc_hd__decap_3
XFILLER_18_132 vssd1 vssd1 vccd1 vccd1 sky130_fd_sc_hd__fill_1
XTAP_TAPCELL_ROW_16_311 vssd1 vccd1 sky130_fd_sc_hd__tapvpwrvgnd_1
XFILLER_61_466 vssd1 vssd1 vccd1 vccd1 sky130_fd_sc_hd__fill_4
X_1951_ _1914_/B _1914_/C _1914_/A vssd1 vssd1 vccd1 vccd1 _1953_/B sky130_fd_sc_hd__o21bai_2
X_1882_ _1873_/B _1873_/C _1873_/A vssd1 vssd1 vccd1 vccd1 _1917_/A sky130_fd_sc_hd__a21boi_2
XPHY_EDGE_ROW_78_Left_158 vssd1 vssd1 vccd1 vccd1 sky130_fd_sc_hd__decap_3
XANTENNA__2801__S _2814_/S vssd1 vssd1 vccd1 vccd1 sky130_fd_sc_hd__diode_2
X_2503_ hold640/X wire59/X _2502_/X _1602_/X vssd1 vssd1 vccd1 vccd1 _3094_/D sky130_fd_sc_hd__a22o_2
X_2434_ _2434_/A _2434_/B _2434_/C vssd1 vssd1 vccd1 vccd1 _2434_/X sky130_fd_sc_hd__or3_2
X_2365_ _2365_/A _2365_/B vssd1 vssd1 vccd1 vccd1 _2369_/B sky130_fd_sc_hd__xnor2_2
XANTENNA__2350__B2 _2399_/B vssd1 vssd1 vccd1 vccd1 sky130_fd_sc_hd__diode_2
Xteam_02_309 vssd1 vssd1 vccd1 vccd1 team_02_309/HI gpio_out[12] sky130_fd_sc_hd__conb_1
X_2296_ _2296_/A _2296_/B vssd1 vssd1 vccd1 vccd1 _2297_/C sky130_fd_sc_hd__nand2_2
XANTENNA__2102__A1 _2263_/A vssd1 vssd1 vccd1 vccd1 sky130_fd_sc_hd__diode_2
XTAP_TAPCELL_ROW_67_745 vssd1 vccd1 sky130_fd_sc_hd__tapvpwrvgnd_1
XFILLER_52_477 vssd1 vccd1 vssd1 vccd1 sky130_ef_sc_hd__decap_40_12
XANTENNA__2491__B _2957_/C vssd1 vssd1 vccd1 vccd1 sky130_fd_sc_hd__diode_2
XTAP_TAPCELL_ROW_50_601 vssd1 vccd1 sky130_fd_sc_hd__tapvpwrvgnd_1
XANTENNA_fanout136_X _2900_/A vssd1 vssd1 vccd1 vccd1 sky130_fd_sc_hd__diode_2
XTAP_TAPCELL_ROW_22_358 vssd1 vccd1 sky130_fd_sc_hd__tapvpwrvgnd_1
XFILLER_20_363 vssd1 vssd1 vccd1 vccd1 sky130_fd_sc_hd__fill_1
XANTENNA__2711__S _2723_/S vssd1 vssd1 vccd1 vccd1 sky130_fd_sc_hd__diode_2
XFILLER_21_57 vssd1 vssd1 vccd1 vccd1 sky130_fd_sc_hd__fill_8
XANTENNA__2892__A2 _2894_/A2 vssd1 vssd1 vccd1 vccd1 sky130_fd_sc_hd__diode_2
Xmax_cap88 _1582_/Y vssd1 vssd1 vccd1 vccd1 _2550_/A1 sky130_fd_sc_hd__buf_2
XTAP_TAPCELL_ROW_38_491 vssd1 vccd1 sky130_fd_sc_hd__tapvpwrvgnd_1
XFILLER_15_113 vssd1 vccd1 vssd1 vccd1 sky130_ef_sc_hd__decap_40_12
XANTENNA__1604__B1 _2611_/A vssd1 vssd1 vccd1 vccd1 sky130_fd_sc_hd__diode_2
XFILLER_62_97 vssd1 vccd1 vssd1 vccd1 sky130_ef_sc_hd__decap_40_12
XFILLER_7_301 vssd1 vssd1 vccd1 vccd1 sky130_fd_sc_hd__fill_1
XFILLER_7_15 vssd1 vssd1 vccd1 vccd1 sky130_fd_sc_hd__fill_4
XANTENNA__2621__S _2645_/S vssd1 vssd1 vccd1 vccd1 sky130_fd_sc_hd__diode_2
XFILLER_7_59 vssd1 vssd1 vccd1 vccd1 sky130_fd_sc_hd__fill_1
XFILLER_7_48 vssd1 vssd1 vccd1 vccd1 sky130_fd_sc_hd__fill_2
XFILLER_7_378 vssd1 vssd1 vccd1 vccd1 sky130_fd_sc_hd__fill_1
XANTENNA__3116__RESET_B fanout228/X vssd1 vssd1 vccd1 vccd1 sky130_fd_sc_hd__diode_2
XFILLER_11_90 vssd1 vssd1 vccd1 vccd1 sky130_fd_sc_hd__fill_4
Xload_slew237 fanout236/X vssd1 vssd1 vccd1 vccd1 load_slew237/X sky130_fd_sc_hd__clkbuf_4
Xload_slew248 fanout247/X vssd1 vssd1 vccd1 vccd1 load_slew248/X sky130_fd_sc_hd__buf_2
XANTENNA__2883__A2 _2894_/A2 vssd1 vssd1 vccd1 vccd1 sky130_fd_sc_hd__diode_2
X_2150_ _2150_/A _2150_/B vssd1 vssd1 vccd1 vccd1 _2152_/B sky130_fd_sc_hd__xnor2_2
X_2081_ _2081_/A _2081_/B _2081_/C vssd1 vssd1 vccd1 vccd1 _2082_/A sky130_fd_sc_hd__and3_2
XTAP_TAPCELL_ROW_64_715 vssd1 vccd1 sky130_fd_sc_hd__tapvpwrvgnd_1
X_2983_ _3441_/D _3408_/Q vssd1 vssd1 vccd1 vccd1 _3407_/D sky130_fd_sc_hd__or2_2
XTAP_TAPCELL_ROW_72_781 vssd1 vccd1 sky130_fd_sc_hd__tapvpwrvgnd_1
X_1934_ _1958_/A _1959_/A vssd1 vssd1 vccd1 vccd1 _1950_/A sky130_fd_sc_hd__or2_2
XANTENNA__1936__A _2002_/B vssd1 vssd1 vccd1 vccd1 sky130_fd_sc_hd__diode_2
X_1865_ _1947_/A _1865_/B _2005_/A _1970_/B vssd1 vssd1 vccd1 vccd1 _1867_/B sky130_fd_sc_hd__and4_2
X_1796_ _1797_/B _1797_/C _1797_/A vssd1 vssd1 vccd1 vccd1 _1820_/A sky130_fd_sc_hd__a21oi_2
X_3466_ _3471_/CLK _3466_/D load_slew256/X vssd1 vssd1 vccd1 vccd1 _3466_/Q sky130_fd_sc_hd__dfrtp_2
X_2417_ _2406_/X _2409_/X _2414_/A _2412_/S vssd1 vssd1 vccd1 vccd1 _2417_/X sky130_fd_sc_hd__o31a_2
X_3397_ _3397_/CLK _3397_/D load_slew248/X vssd1 vssd1 vccd1 vccd1 _3397_/Q sky130_fd_sc_hd__dfrtp_2
X_2348_ _2347_/A _2399_/A _2383_/B _2384_/A vssd1 vssd1 vccd1 vccd1 _2349_/B sky130_fd_sc_hd__a22oi_2
X_2279_ _2318_/A _2279_/B _2318_/B vssd1 vssd1 vccd1 vccd1 _2279_/X sky130_fd_sc_hd__and3_2
XANTENNA__2626__A2 _2610_/A vssd1 vssd1 vccd1 vccd1 sky130_fd_sc_hd__diode_2
XFILLER_16_35 vssd1 vssd1 vccd1 vccd1 sky130_fd_sc_hd__fill_1
XANTENNA__2706__S _2723_/S vssd1 vssd1 vccd1 vccd1 sky130_fd_sc_hd__diode_2
XANTENNA__2933__C _2970_/C vssd1 vssd1 vccd1 vccd1 sky130_fd_sc_hd__diode_2
XTAP_TAPCELL_ROW_35_472 vssd1 vccd1 sky130_fd_sc_hd__tapvpwrvgnd_1
XANTENNA__2562__A1 _1569_/D vssd1 vssd1 vccd1 vccd1 sky130_fd_sc_hd__diode_2
XANTENNA__2099__D _2154_/B vssd1 vssd1 vccd1 vccd1 sky130_fd_sc_hd__diode_2
XFILLER_57_42 vssd1 vssd1 vccd1 vccd1 sky130_fd_sc_hd__fill_1
XFILLER_75_366 vssd1 vssd1 vccd1 vccd1 sky130_fd_sc_hd__fill_8
XFILLER_31_447 vssd1 vssd1 vccd1 vccd1 sky130_fd_sc_hd__fill_1
X_1650_ _3074_/Q _3057_/Q vssd1 vssd1 vccd1 vccd1 _1651_/B sky130_fd_sc_hd__nand2_2
X_1581_ _3141_/Q _2426_/A vssd1 vssd1 vccd1 vccd1 _1583_/B sky130_fd_sc_hd__nand2b_2
XANTENNA__2553__A1 _2465_/X vssd1 vssd1 vccd1 vccd1 sky130_fd_sc_hd__diode_2
X_3320_ _3453_/CLK _3320_/D load_slew288/X vssd1 vssd1 vccd1 vccd1 _3320_/Q sky130_fd_sc_hd__dfrtp_2
X_3251_ _3287_/CLK _3251_/D load_slew234/X vssd1 vssd1 vccd1 vccd1 _3251_/Q sky130_fd_sc_hd__dfrtp_2
X_3182_ _3389_/CLK _3182_/D fanout274/X vssd1 vssd1 vccd1 vccd1 _3182_/Q sky130_fd_sc_hd__dfrtp_2
X_2202_ _2374_/S _2200_/X _2201_/Y vssd1 vssd1 vccd1 vccd1 _3077_/D sky130_fd_sc_hd__a21oi_2
X_2133_ _2132_/A _2146_/C _2146_/D _2146_/B vssd1 vssd1 vccd1 vccd1 _2134_/B sky130_fd_sc_hd__a22o_2
X_2064_ _2067_/A _2067_/C _2067_/B vssd1 vssd1 vccd1 vccd1 _2065_/A sky130_fd_sc_hd__a21o_2
XTAP_TAPCELL_ROW_49_586 vssd1 vccd1 sky130_fd_sc_hd__tapvpwrvgnd_1
X_2966_ _2966_/A1 _3162_/Q _3306_/Q _2972_/B2 vssd1 vssd1 vccd1 vccd1 _2966_/X sky130_fd_sc_hd__a22o_2
XTAP_TAPCELL_ROW_32_442 vssd1 vccd1 sky130_fd_sc_hd__tapvpwrvgnd_1
X_2897_ hold617/X _3437_/D _2895_/X _2896_/X vssd1 vssd1 vccd1 vccd1 _3391_/D sky130_fd_sc_hd__o22a_2
X_1917_ _1917_/A _1917_/B _1917_/C vssd1 vssd1 vccd1 vccd1 _1917_/Y sky130_fd_sc_hd__nand3_2
XANTENNA_fanout213_A fanout214/X vssd1 vssd1 vccd1 vccd1 sky130_fd_sc_hd__diode_2
X_1848_ hold660/X _1847_/Y _1993_/S vssd1 vssd1 vccd1 vccd1 _3059_/D sky130_fd_sc_hd__mux2_1
Xhold621 _3075_/Q vssd1 vssd1 vccd1 vccd1 hold621/X sky130_fd_sc_hd__dlygate4sd3_1
Xhold610 _3132_/Q vssd1 vssd1 vccd1 vccd1 hold610/X sky130_fd_sc_hd__dlygate4sd3_1
XANTENNA__2544__A1 _2550_/A1 vssd1 vssd1 vccd1 vccd1 sky130_fd_sc_hd__diode_2
Xhold654 _3233_/Q vssd1 vssd1 vccd1 vccd1 hold654/X sky130_fd_sc_hd__dlygate4sd3_1
Xhold643 _3246_/Q vssd1 vssd1 vccd1 vccd1 hold643/X sky130_fd_sc_hd__dlygate4sd3_1
Xhold632 _3100_/Q vssd1 vssd1 vccd1 vccd1 hold632/X sky130_fd_sc_hd__dlygate4sd3_1
X_1779_ _3038_/Q _1805_/A _1947_/A _1805_/B vssd1 vssd1 vccd1 vccd1 _1787_/A sky130_fd_sc_hd__and4_2
Xhold687 _3335_/Q vssd1 vssd1 vccd1 vccd1 hold687/X sky130_fd_sc_hd__dlygate4sd3_1
Xhold676 _3270_/Q vssd1 vssd1 vccd1 vccd1 hold676/X sky130_fd_sc_hd__dlygate4sd3_1
Xhold665 _3190_/Q vssd1 vssd1 vccd1 vccd1 hold665/X sky130_fd_sc_hd__dlygate4sd3_1
X_3449_ _3450_/CLK _3449_/D fanout284/X vssd1 vssd1 vccd1 vccd1 _3449_/Q sky130_fd_sc_hd__dfrtp_2
Xhold698 _3010_/Q vssd1 vssd1 vccd1 vccd1 hold698/X sky130_fd_sc_hd__dlygate4sd3_1
XFILLER_57_322 vssd1 vssd1 vccd1 vccd1 sky130_fd_sc_hd__fill_1
XANTENNA__2944__B _2970_/B vssd1 vssd1 vccd1 vccd1 sky130_fd_sc_hd__diode_2
XFILLER_57_399 vssd1 vssd1 vccd1 vccd1 sky130_fd_sc_hd__fill_1
XANTENNA__2480__B1 wire66/X vssd1 vssd1 vccd1 vccd1 sky130_fd_sc_hd__diode_2
XFILLER_43_55 vssd1 vssd1 vccd1 vccd1 sky130_fd_sc_hd__fill_1
XFILLER_21_491 vssd1 vssd1 vccd1 vccd1 sky130_fd_sc_hd__fill_2
XFILLER_4_27 vssd1 vssd1 vccd1 vccd1 sky130_fd_sc_hd__fill_1
XFILLER_4_189 vssd1 vssd1 vccd1 vccd1 sky130_fd_sc_hd__fill_4
XFILLER_68_85 vssd1 vccd1 vssd1 vccd1 sky130_ef_sc_hd__decap_40_12
XFILLER_67_119 vssd1 vccd1 vssd1 vccd1 sky130_ef_sc_hd__decap_40_12
XFILLER_75_141 vssd1 vssd1 vccd1 vccd1 sky130_fd_sc_hd__fill_8
XTAP_TAPCELL_ROW_46_567 vssd1 vccd1 sky130_fd_sc_hd__tapvpwrvgnd_1
XANTENNA__2471__B1 _2648_/B vssd1 vssd1 vccd1 vccd1 sky130_fd_sc_hd__diode_2
X_2820_ hold615/X _2839_/A1 _2833_/S vssd1 vssd1 vccd1 vccd1 _3325_/D sky130_fd_sc_hd__mux2_1
XFILLER_31_266 vssd1 vssd1 vccd1 vccd1 sky130_fd_sc_hd__fill_1
X_2751_ hold568/X _2808_/A1 _2757_/S vssd1 vssd1 vccd1 vccd1 _3260_/D sky130_fd_sc_hd__mux2_1
X_2682_ hold628/X _2815_/A1 _2685_/S vssd1 vssd1 vccd1 vccd1 _3195_/D sky130_fd_sc_hd__mux2_1
X_1702_ hold532/X _1701_/Y _1738_/S vssd1 vssd1 vccd1 vccd1 _3014_/D sky130_fd_sc_hd__mux2_1
X_1633_ hold739/X _1573_/Y _1690_/S vssd1 vssd1 vccd1 vccd1 _3433_/D sky130_fd_sc_hd__a21o_2
XFILLER_69_3 vssd1 vssd1 vccd1 vccd1 sky130_fd_sc_hd__fill_2
XANTENNA__2526__A1 _2961_/A1 vssd1 vssd1 vccd1 vccd1 sky130_fd_sc_hd__diode_2
XANTENNA__2526__B2 _2962_/A1 vssd1 vssd1 vccd1 vccd1 sky130_fd_sc_hd__diode_2
X_1564_ _2533_/A _2533_/B vssd1 vssd1 vccd1 vccd1 _2431_/C sky130_fd_sc_hd__nand2_2
X_3303_ _3395_/CLK _3303_/D fanout245/X vssd1 vssd1 vccd1 vccd1 _3303_/Q sky130_fd_sc_hd__dfrtp_2
X_3234_ _3337_/CLK _3234_/D load_slew246/X vssd1 vssd1 vccd1 vccd1 _3234_/Q sky130_fd_sc_hd__dfrtp_2
XFILLER_39_311 vssd1 vccd1 vssd1 vccd1 sky130_ef_sc_hd__decap_40_12
X_3165_ _3431_/CLK _3165_/D fanout265/X vssd1 vssd1 vccd1 vccd1 _3165_/Q sky130_fd_sc_hd__dfrtp_2
XFILLER_66_163 vssd1 vssd1 vccd1 vccd1 sky130_fd_sc_hd__fill_2
X_3096_ clkload6/A _3096_/D load_slew202/X vssd1 vssd1 vccd1 vccd1 _3096_/Q sky130_fd_sc_hd__dfrtp_2
X_2116_ _2117_/B _2117_/C _2117_/A vssd1 vssd1 vccd1 vccd1 _2139_/A sky130_fd_sc_hd__a21oi_2
X_2047_ _2047_/A _2047_/B vssd1 vssd1 vccd1 vccd1 _2047_/Y sky130_fd_sc_hd__xnor2_2
XFILLER_22_200 vssd1 vssd1 vccd1 vccd1 sky130_fd_sc_hd__fill_1
Xfanout15 _2800_/X vssd1 vssd1 vccd1 vccd1 _2818_/S sky130_fd_sc_hd__clkdlybuf4s25_1
Xfanout26 _2705_/X vssd1 vssd1 vccd1 vccd1 _2719_/S sky130_fd_sc_hd__clkdlybuf4s25_1
Xfanout37 _2646_/X vssd1 vssd1 vccd1 vccd1 _2818_/A1 sky130_fd_sc_hd__clkdlybuf4s25_1
Xfanout48 _2624_/X vssd1 vssd1 vccd1 vccd1 _2845_/A1 sky130_fd_sc_hd__clkdlybuf4s25_1
X_2949_ _3214_/Q _2970_/B _2970_/C vssd1 vssd1 vccd1 vccd1 _2949_/X sky130_fd_sc_hd__and3_2
XFILLER_13_47 vssd1 vssd1 vccd1 vccd1 sky130_fd_sc_hd__fill_8
XFILLER_13_69 vssd1 vssd1 vccd1 vccd1 sky130_fd_sc_hd__fill_4
XANTENNA__2004__B _2004_/B vssd1 vssd1 vccd1 vccd1 sky130_fd_sc_hd__diode_2
Xhold440 _3011_/Q vssd1 vssd1 vccd1 vccd1 hold440/X sky130_fd_sc_hd__dlygate4sd3_1
Xhold451 _3218_/Q vssd1 vssd1 vccd1 vccd1 hold451/X sky130_fd_sc_hd__dlygate4sd3_1
Xhold462 _3385_/Q vssd1 vssd1 vccd1 vccd1 hold462/X sky130_fd_sc_hd__dlygate4sd3_1
XTAP_TAPCELL_ROW_9_248 vssd1 vccd1 sky130_fd_sc_hd__tapvpwrvgnd_1
Xhold473 _3064_/Q vssd1 vssd1 vccd1 vccd1 hold473/X sky130_fd_sc_hd__dlygate4sd3_1
Xhold495 _3208_/Q vssd1 vssd1 vccd1 vccd1 hold495/X sky130_fd_sc_hd__dlygate4sd3_1
Xhold484 _3204_/Q vssd1 vssd1 vccd1 vccd1 hold484/X sky130_fd_sc_hd__dlygate4sd3_1
XFILLER_1_126 vssd1 vssd1 vccd1 vccd1 sky130_fd_sc_hd__fill_1
XANTENNA_fanout76_A _2901_/A2 vssd1 vssd1 vccd1 vccd1 sky130_fd_sc_hd__diode_2
XFILLER_45_303 vssd1 vssd1 vccd1 vccd1 sky130_fd_sc_hd__fill_2
XFILLER_38_55 vssd1 vssd1 vccd1 vccd1 sky130_fd_sc_hd__fill_8
XFILLER_38_99 vssd1 vssd1 vccd1 vccd1 sky130_fd_sc_hd__fill_2
XFILLER_72_133 vssd1 vssd1 vccd1 vccd1 sky130_fd_sc_hd__fill_4
XFILLER_45_347 vssd1 vssd1 vccd1 vccd1 sky130_fd_sc_hd__fill_1
XTAP_TAPCELL_ROW_0_170 vssd1 vccd1 sky130_fd_sc_hd__tapvpwrvgnd_1
XANTENNA_fanout31_X _2666_/S vssd1 vssd1 vccd1 vccd1 sky130_fd_sc_hd__diode_2
XTAP_TAPCELL_ROW_43_537 vssd1 vccd1 sky130_fd_sc_hd__tapvpwrvgnd_1
XFILLER_53_391 vssd1 vssd1 vccd1 vccd1 sky130_fd_sc_hd__fill_1
XFILLER_13_277 vssd1 vssd1 vccd1 vccd1 sky130_fd_sc_hd__fill_2
Xclkload18 _3393_/CLK vssd1 vssd1 vccd1 vccd1 clkload18/X sky130_fd_sc_hd__clkbuf_8
XFILLER_5_421 vssd1 vssd1 vccd1 vccd1 sky130_fd_sc_hd__fill_2
XANTENNA__2508__B2 _2973_/A1 vssd1 vssd1 vccd1 vccd1 sky130_fd_sc_hd__diode_2
XFILLER_79_95 vssd1 vccd1 vssd1 vccd1 sky130_ef_sc_hd__decap_40_12
XFILLER_0_181 vssd1 vccd1 vssd1 vccd1 sky130_ef_sc_hd__decap_40_12
XFILLER_76_450 vssd1 vssd1 vccd1 vccd1 sky130_fd_sc_hd__fill_2
XFILLER_48_141 vssd1 vssd1 vccd1 vccd1 sky130_fd_sc_hd__fill_1
XTAP_TAPCELL_ROW_59_670 vssd1 vccd1 sky130_fd_sc_hd__tapvpwrvgnd_1
XFILLER_76_472 vssd1 vssd1 vccd1 vccd1 sky130_fd_sc_hd__fill_4
XFILLER_63_111 vssd1 vssd1 vccd1 vccd1 sky130_fd_sc_hd__fill_1
XFILLER_48_185 vssd1 vssd1 vccd1 vccd1 sky130_fd_sc_hd__fill_4
XANTENNA__2804__S _2818_/S vssd1 vssd1 vccd1 vccd1 sky130_fd_sc_hd__diode_2
X_2803_ hold626/X _2803_/A1 _2814_/S vssd1 vssd1 vccd1 vccd1 _3309_/D sky130_fd_sc_hd__mux2_1
XTAP_TAPCELL_ROW_14_294 vssd1 vccd1 sky130_fd_sc_hd__tapvpwrvgnd_1
X_2734_ hold649/X _2630_/X _2738_/S vssd1 vssd1 vccd1 vccd1 _3244_/D sky130_fd_sc_hd__mux2_1
X_2665_ hold530/X _2817_/A1 _2666_/S vssd1 vssd1 vccd1 vccd1 _3179_/D sky130_fd_sc_hd__mux2_1
X_2596_ _2590_/Y _2594_/X _2595_/Y _2426_/A vssd1 vssd1 vccd1 vccd1 _2596_/Y sky130_fd_sc_hd__a31oi_2
X_1616_ _3409_/Q _3415_/Q _3418_/Q vssd1 vssd1 vccd1 vccd1 _1630_/B sky130_fd_sc_hd__or3_2
Xfanout238 fanout242/X vssd1 vssd1 vccd1 vccd1 fanout238/X sky130_fd_sc_hd__clkdlybuf4s25_1
X_1547_ _3391_/Q _3463_/Q _1554_/S vssd1 vssd1 vccd1 vccd1 _3464_/D sky130_fd_sc_hd__mux2_1
Xfanout249 fanout251/X vssd1 vssd1 vccd1 vccd1 fanout249/X sky130_fd_sc_hd__clkdlybuf4s25_1
X_3217_ _3297_/CLK _3217_/D load_slew264/X vssd1 vssd1 vccd1 vccd1 _3217_/Q sky130_fd_sc_hd__dfrtp_2
XFILLER_39_130 vssd1 vccd1 vssd1 vccd1 sky130_ef_sc_hd__decap_40_12
X_3148_ _3388_/CLK _3148_/D load_slew237/X vssd1 vssd1 vccd1 vccd1 _3148_/Q sky130_fd_sc_hd__dfrtp_2
XFILLER_27_369 vssd1 vssd1 vccd1 vccd1 sky130_fd_sc_hd__fill_1
XANTENNA_fanout166_X _1970_/B vssd1 vssd1 vccd1 vccd1 sky130_fd_sc_hd__diode_2
X_3079_ _3121_/CLK _3079_/D vssd1 vssd1 vccd1 vccd1 _3079_/Q sky130_fd_sc_hd__dfxtp_2
XFILLER_42_328 vssd1 vssd1 vccd1 vccd1 sky130_fd_sc_hd__fill_1
XANTENNA__2435__A0 _2533_/B vssd1 vssd1 vccd1 vccd1 sky130_fd_sc_hd__diode_2
XFILLER_35_391 vssd1 vssd1 vccd1 vccd1 sky130_fd_sc_hd__fill_1
XANTENNA__2714__S _2719_/S vssd1 vssd1 vccd1 vccd1 sky130_fd_sc_hd__diode_2
XANTENNA__1961__A2 _1962_/B vssd1 vssd1 vccd1 vccd1 sky130_fd_sc_hd__diode_2
XFILLER_77_214 vssd1 vssd1 vccd1 vccd1 sky130_fd_sc_hd__fill_2
XANTENNA__2910__B2 _2923_/B2 vssd1 vssd1 vccd1 vccd1 sky130_fd_sc_hd__diode_2
XFILLER_77_225 vssd1 vssd1 vccd1 vccd1 sky130_fd_sc_hd__fill_1
XFILLER_1_28 vssd1 vccd1 vssd1 vccd1 sky130_ef_sc_hd__decap_40_12
XFILLER_45_100 vssd1 vssd1 vccd1 vccd1 sky130_fd_sc_hd__fill_1
XFILLER_65_75 vssd1 vssd1 vccd1 vccd1 sky130_fd_sc_hd__fill_1
XTAP_TAPCELL_ROW_56_651 vssd1 vccd1 sky130_fd_sc_hd__tapvpwrvgnd_1
XFILLER_45_188 vssd1 vccd1 vssd1 vccd1 sky130_ef_sc_hd__decap_40_12
XTAP_TAPCELL_ROW_11_264 vssd1 vccd1 sky130_fd_sc_hd__tapvpwrvgnd_1
X_2450_ _3325_/Q _2667_/B _2648_/B _3307_/Q _2449_/X vssd1 vssd1 vccd1 vccd1 _2450_/X
+ sky130_fd_sc_hd__a221o_2
X_2381_ _2381_/A _2381_/B vssd1 vssd1 vccd1 vccd1 _2382_/B sky130_fd_sc_hd__nor2_2
X_3002_ _3003_/A vssd1 vssd1 vccd1 vccd1 _3002_/Y sky130_fd_sc_hd__inv_2
Xinput5 nrst vssd1 vssd1 vccd1 vccd1 input5/X sky130_fd_sc_hd__clkdlybuf4s25_1
XTAP_TAPCELL_ROW_19_331 vssd1 vccd1 sky130_fd_sc_hd__tapvpwrvgnd_1
XFILLER_64_475 vssd1 vssd1 vccd1 vccd1 sky130_fd_sc_hd__fill_1
XFILLER_51_125 vssd1 vssd1 vccd1 vccd1 sky130_fd_sc_hd__fill_1
XTAP_TAPCELL_ROW_62_698 vssd1 vccd1 sky130_fd_sc_hd__tapvpwrvgnd_1
XFILLER_32_361 vssd1 vssd1 vccd1 vccd1 sky130_fd_sc_hd__fill_1
XANTENNA_fanout126_A _2964_/C vssd1 vssd1 vccd1 vccd1 sky130_fd_sc_hd__diode_2
X_2717_ hold497/X _2850_/A1 _2723_/S vssd1 vssd1 vccd1 vccd1 _3228_/D sky130_fd_sc_hd__mux2_1
X_2648_ _2686_/A _2648_/B _2800_/C vssd1 vssd1 vccd1 vccd1 _2648_/X sky130_fd_sc_hd__and3_2
X_2579_ hold571/X _2587_/A2 _2587_/B1 hold684/X vssd1 vssd1 vccd1 vccd1 _3131_/D sky130_fd_sc_hd__a22o_2
XANTENNA__2709__S _2719_/S vssd1 vssd1 vccd1 vccd1 sky130_fd_sc_hd__diode_2
XFILLER_74_239 vssd1 vssd1 vccd1 vccd1 sky130_fd_sc_hd__fill_1
XFILLER_19_57 vssd1 vssd1 vccd1 vccd1 sky130_fd_sc_hd__fill_4
XTAP_TAPCELL_ROW_53_621 vssd1 vccd1 sky130_fd_sc_hd__tapvpwrvgnd_1
XFILLER_70_489 vssd1 vssd1 vccd1 vccd1 sky130_fd_sc_hd__fill_4
XANTENNA__1631__A1 _2445_/S vssd1 vssd1 vccd1 vccd1 sky130_fd_sc_hd__diode_2
XFILLER_51_33 vssd1 vssd1 vccd1 vccd1 sky130_fd_sc_hd__fill_1
XANTENNA__2399__B _2399_/B vssd1 vssd1 vccd1 vccd1 sky130_fd_sc_hd__diode_2
XFILLER_2_232 vssd1 vssd1 vccd1 vccd1 sky130_fd_sc_hd__fill_2
XANTENNA__2619__S _2645_/S vssd1 vssd1 vccd1 vccd1 sky130_fd_sc_hd__diode_2
XFILLER_76_41 vssd1 vssd1 vccd1 vccd1 sky130_fd_sc_hd__fill_1
XFILLER_76_63 vssd1 vssd1 vccd1 vccd1 sky130_fd_sc_hd__fill_1
XFILLER_65_228 vssd1 vssd1 vccd1 vccd1 sky130_fd_sc_hd__fill_1
XFILLER_65_217 vssd1 vssd1 vccd1 vccd1 sky130_fd_sc_hd__fill_2
XFILLER_65_239 vssd1 vssd1 vccd1 vccd1 sky130_fd_sc_hd__fill_4
XFILLER_46_475 vssd1 vssd1 vccd1 vccd1 sky130_fd_sc_hd__fill_1
XTAP_TAPCELL_ROW_16_312 vssd1 vccd1 sky130_fd_sc_hd__tapvpwrvgnd_1
XFILLER_73_294 vssd1 vssd1 vccd1 vccd1 sky130_fd_sc_hd__fill_2
XFILLER_18_199 vssd1 vssd1 vccd1 vccd1 sky130_fd_sc_hd__fill_2
XFILLER_33_147 vssd1 vssd1 vccd1 vccd1 sky130_fd_sc_hd__fill_2
X_1950_ _1950_/A _1958_/B vssd1 vssd1 vccd1 vccd1 _1953_/A sky130_fd_sc_hd__xnor2_2
X_1881_ hold697/X _1880_/Y _1993_/S vssd1 vssd1 vccd1 vccd1 _3060_/D sky130_fd_sc_hd__mux2_1
XFILLER_14_394 vssd1 vssd1 vccd1 vccd1 sky130_fd_sc_hd__fill_1
X_2502_ _2540_/A _2502_/B vssd1 vssd1 vccd1 vccd1 _2502_/X sky130_fd_sc_hd__and2_2
XFILLER_51_3 vssd1 vssd1 vccd1 vccd1 sky130_fd_sc_hd__fill_4
X_2433_ _1578_/B _1583_/B _2426_/C vssd1 vssd1 vccd1 vccd1 _2434_/C sky130_fd_sc_hd__a21oi_2
X_2364_ _2364_/A _2364_/B vssd1 vssd1 vccd1 vccd1 _2365_/B sky130_fd_sc_hd__nor2_2
XANTENNA__2350__A2 _2352_/B vssd1 vssd1 vccd1 vccd1 sky130_fd_sc_hd__diode_2
X_2295_ _2295_/A _2295_/B vssd1 vssd1 vccd1 vccd1 _2298_/A sky130_fd_sc_hd__xnor2_2
XFILLER_64_250 vssd1 vssd1 vccd1 vccd1 sky130_fd_sc_hd__fill_2
XFILLER_64_294 vssd1 vssd1 vccd1 vccd1 sky130_fd_sc_hd__fill_1
XANTENNA_fanout243_A fanout251/X vssd1 vssd1 vccd1 vccd1 sky130_fd_sc_hd__diode_2
XFILLER_52_489 vssd1 vssd1 vccd1 vccd1 sky130_fd_sc_hd__fill_4
XTAP_TAPCELL_ROW_22_359 vssd1 vccd1 sky130_fd_sc_hd__tapvpwrvgnd_1
XANTENNA_fanout129_X _2533_/B vssd1 vssd1 vccd1 vccd1 sky130_fd_sc_hd__diode_2
XFILLER_79_309 vssd1 vccd1 vssd1 vccd1 sky130_ef_sc_hd__decap_40_12
XANTENNA__1851__B _2002_/B vssd1 vssd1 vccd1 vccd1 sky130_fd_sc_hd__diode_2
XANTENNA__2947__B _2970_/B vssd1 vssd1 vccd1 vccd1 sky130_fd_sc_hd__diode_2
XFILLER_46_77 vssd1 vssd1 vccd1 vccd1 sky130_fd_sc_hd__fill_1
XFILLER_46_55 vssd1 vssd1 vccd1 vccd1 sky130_fd_sc_hd__fill_1
XFILLER_28_475 vssd1 vssd1 vccd1 vccd1 sky130_fd_sc_hd__fill_1
XFILLER_15_125 vssd1 vssd1 vccd1 vccd1 sky130_fd_sc_hd__fill_4
XTAP_TAPCELL_ROW_38_492 vssd1 vccd1 sky130_fd_sc_hd__tapvpwrvgnd_1
XFILLER_70_231 vssd1 vccd1 vssd1 vccd1 sky130_ef_sc_hd__decap_40_12
XFILLER_70_275 vssd1 vssd1 vccd1 vccd1 sky130_fd_sc_hd__fill_1
XFILLER_70_264 vssd1 vssd1 vccd1 vccd1 sky130_fd_sc_hd__fill_2
XFILLER_30_128 vssd1 vssd1 vccd1 vccd1 sky130_fd_sc_hd__fill_1
XANTENNA_clkbuf_leaf_16_clk_A clkload4/A vssd1 vssd1 vccd1 vccd1 sky130_fd_sc_hd__diode_2
Xwire222 wire222/A vssd1 vssd1 vccd1 vccd1 wire222/X sky130_fd_sc_hd__clkbuf_4
XANTENNA__2580__A2 _1622_/C vssd1 vssd1 vccd1 vccd1 sky130_fd_sc_hd__diode_2
Xload_slew227 fanout226/X vssd1 vssd1 vccd1 vccd1 load_slew227/X sky130_fd_sc_hd__clkbuf_2
Xload_slew216 fanout215/X vssd1 vssd1 vccd1 vccd1 load_slew216/X sky130_fd_sc_hd__clkbuf_4
Xload_slew205 fanout204/X vssd1 vssd1 vccd1 vccd1 load_slew205/X sky130_fd_sc_hd__clkbuf_4
X_2080_ _2046_/B _2065_/A _2066_/X _2067_/X vssd1 vssd1 vccd1 vccd1 _2085_/A sky130_fd_sc_hd__a31o_2
XTAP_TAPCELL_ROW_64_716 vssd1 vccd1 sky130_fd_sc_hd__tapvpwrvgnd_1
XFILLER_46_261 vssd1 vssd1 vccd1 vccd1 sky130_fd_sc_hd__fill_2
XFILLER_34_423 vssd1 vssd1 vccd1 vccd1 sky130_fd_sc_hd__fill_4
X_2982_ _3406_/Q hold381/X _3408_/Q vssd1 vssd1 vccd1 vccd1 _2982_/X sky130_fd_sc_hd__mux2_1
XTAP_TAPCELL_ROW_72_782 vssd1 vccd1 sky130_fd_sc_hd__tapvpwrvgnd_1
XFILLER_34_489 vssd1 vssd1 vccd1 vccd1 sky130_fd_sc_hd__fill_4
X_1933_ _1933_/A _1933_/B _1933_/C _1933_/D vssd1 vssd1 vccd1 vccd1 _1959_/A sky130_fd_sc_hd__and4_2
XANTENNA__2812__S _2818_/S vssd1 vssd1 vccd1 vccd1 sky130_fd_sc_hd__diode_2
X_1864_ _1906_/A _2029_/A vssd1 vssd1 vccd1 vccd1 _1867_/A sky130_fd_sc_hd__and2_2
X_1795_ _1805_/A _2004_/B _1828_/D _1979_/A vssd1 vssd1 vccd1 vccd1 _1797_/C sky130_fd_sc_hd__a22o_2
XANTENNA__2571__A2 _1622_/C vssd1 vssd1 vccd1 vccd1 sky130_fd_sc_hd__diode_2
X_3465_ _3471_/CLK _3465_/D load_slew256/X vssd1 vssd1 vccd1 vccd1 _3465_/Q sky130_fd_sc_hd__dfrtp_2
X_2416_ _2406_/X _2409_/X _2414_/Y _2419_/B vssd1 vssd1 vccd1 vccd1 _2416_/X sky130_fd_sc_hd__a2bb2o_2
XANTENNA__2323__A2 _2284_/B vssd1 vssd1 vccd1 vccd1 sky130_fd_sc_hd__diode_2
X_3396_ _3398_/CLK _3396_/D fanout247/X vssd1 vssd1 vccd1 vccd1 _3396_/Q sky130_fd_sc_hd__dfrtp_2
X_2347_ _2347_/A _2399_/A _2383_/B _2384_/A vssd1 vssd1 vccd1 vccd1 _2377_/A sky130_fd_sc_hd__and4_2
X_2278_ _2318_/A _2279_/B _2318_/B _2384_/A vssd1 vssd1 vccd1 vccd1 _2278_/X sky130_fd_sc_hd__a22o_2
XANTENNA__2087__A1 _1979_/B vssd1 vssd1 vccd1 vccd1 sky130_fd_sc_hd__diode_2
XFILLER_25_423 vssd1 vccd1 vssd1 vccd1 sky130_ef_sc_hd__decap_40_12
XFILLER_52_253 vssd1 vssd1 vccd1 vccd1 sky130_fd_sc_hd__fill_1
XTAP_TAPCELL_ROW_35_473 vssd1 vccd1 sky130_fd_sc_hd__tapvpwrvgnd_1
XFILLER_12_106 vssd1 vccd1 vssd1 vccd1 sky130_ef_sc_hd__decap_40_12
XFILLER_12_139 vssd1 vssd1 vccd1 vccd1 sky130_fd_sc_hd__fill_1
XANTENNA__2722__S _2723_/S vssd1 vssd1 vccd1 vccd1 sky130_fd_sc_hd__diode_2
XFILLER_4_338 vssd1 vssd1 vccd1 vccd1 sky130_fd_sc_hd__fill_1
XANTENNA__2562__A2 _2465_/X vssd1 vssd1 vccd1 vccd1 sky130_fd_sc_hd__diode_2
XANTENNA__1770__A0 _2352_/C vssd1 vssd1 vccd1 vccd1 sky130_fd_sc_hd__diode_2
XFILLER_79_139 vssd1 vssd1 vccd1 vccd1 sky130_fd_sc_hd__fill_1
XANTENNA_fanout61_X _2644_/B vssd1 vssd1 vccd1 vccd1 sky130_fd_sc_hd__diode_2
XFILLER_57_76 vssd1 vssd1 vccd1 vccd1 sky130_fd_sc_hd__fill_1
XFILLER_75_389 vssd1 vssd1 vccd1 vccd1 sky130_fd_sc_hd__fill_2
XFILLER_73_53 vssd1 vssd1 vccd1 vccd1 sky130_fd_sc_hd__fill_2
XFILLER_43_220 vssd1 vssd1 vccd1 vccd1 sky130_fd_sc_hd__fill_4
XFILLER_78_8 vssd1 vssd1 vccd1 vccd1 sky130_fd_sc_hd__fill_1
X_1580_ _2588_/A _3437_/Q _1580_/C vssd1 vssd1 vccd1 vccd1 _3541_/A sky130_fd_sc_hd__and3_2
XANTENNA__1761__A0 _2004_/B vssd1 vssd1 vccd1 vccd1 sky130_fd_sc_hd__diode_2
X_3250_ _3397_/CLK _3250_/D load_slew248/X vssd1 vssd1 vccd1 vccd1 _3250_/Q sky130_fd_sc_hd__dfrtp_2
XFILLER_3_393 vssd1 vssd1 vccd1 vccd1 sky130_fd_sc_hd__fill_2
X_3181_ _3437_/CLK _3181_/D fanout260/X vssd1 vssd1 vccd1 vccd1 _3181_/Q sky130_fd_sc_hd__dfrtp_2
X_2201_ _2201_/A _2374_/S vssd1 vssd1 vccd1 vccd1 _2201_/Y sky130_fd_sc_hd__nor2_2
X_2132_ _2132_/A _2146_/B _2146_/C _2146_/D vssd1 vssd1 vccd1 vccd1 _2132_/X sky130_fd_sc_hd__and4_2
XTAP_TAPCELL_ROW_77_830 vssd1 vccd1 sky130_fd_sc_hd__tapvpwrvgnd_1
XFILLER_66_334 vssd1 vssd1 vccd1 vccd1 sky130_fd_sc_hd__fill_2
XFILLER_14_3 vssd1 vssd1 vccd1 vccd1 sky130_fd_sc_hd__fill_4
XANTENNA__2807__S _2818_/S vssd1 vssd1 vccd1 vccd1 sky130_fd_sc_hd__diode_2
X_2063_ _2063_/A _2063_/B vssd1 vssd1 vccd1 vccd1 _2067_/C sky130_fd_sc_hd__nand2_2
XTAP_TAPCELL_ROW_49_587 vssd1 vccd1 sky130_fd_sc_hd__tapvpwrvgnd_1
XFILLER_34_253 vssd1 vssd1 vccd1 vccd1 sky130_fd_sc_hd__fill_1
XANTENNA__1947__A _1947_/A vssd1 vssd1 vccd1 vccd1 sky130_fd_sc_hd__diode_2
X_2965_ _3198_/Q _2968_/A2 _2968_/B1 _3180_/Q _2964_/X vssd1 vssd1 vccd1 vccd1 _2965_/X
+ sky130_fd_sc_hd__a221o_2
XTAP_TAPCELL_ROW_32_443 vssd1 vccd1 sky130_fd_sc_hd__tapvpwrvgnd_1
X_2896_ _2972_/A1 _2892_/X _2888_/X _1585_/A vssd1 vssd1 vccd1 vccd1 _2896_/X sky130_fd_sc_hd__a211o_2
X_1916_ _1917_/A _1917_/B _1917_/C vssd1 vssd1 vccd1 vccd1 _1920_/A sky130_fd_sc_hd__and3_2
X_1847_ _1847_/A _1847_/B vssd1 vssd1 vccd1 vccd1 _1847_/Y sky130_fd_sc_hd__xnor2_2
XFILLER_8_70 vssd1 vssd1 vccd1 vccd1 sky130_fd_sc_hd__fill_8
XANTENNA_fanout206_A fanout214/X vssd1 vssd1 vccd1 vccd1 sky130_fd_sc_hd__diode_2
Xhold611 _3292_/Q vssd1 vssd1 vccd1 vccd1 hold611/X sky130_fd_sc_hd__dlygate4sd3_1
Xhold600 _3221_/Q vssd1 vssd1 vccd1 vccd1 hold600/X sky130_fd_sc_hd__dlygate4sd3_1
XANTENNA__2544__A2 _2465_/X vssd1 vssd1 vccd1 vccd1 sky130_fd_sc_hd__diode_2
Xhold644 _3153_/Q vssd1 vssd1 vccd1 vccd1 hold644/X sky130_fd_sc_hd__dlygate4sd3_1
Xhold633 _3223_/Q vssd1 vssd1 vccd1 vccd1 hold633/X sky130_fd_sc_hd__dlygate4sd3_1
Xhold622 _3444_/Q vssd1 vssd1 vccd1 vccd1 _1500_/A sky130_fd_sc_hd__dlygate4sd3_1
X_1778_ _1805_/A _1947_/A _1805_/B _3038_/Q vssd1 vssd1 vccd1 vccd1 _1778_/X sky130_fd_sc_hd__a22o_2
XANTENNA__1752__A0 _2279_/B vssd1 vssd1 vccd1 vccd1 sky130_fd_sc_hd__diode_2
Xhold688 _3093_/Q vssd1 vssd1 vccd1 vccd1 hold688/X sky130_fd_sc_hd__dlygate4sd3_1
Xhold677 _3262_/Q vssd1 vssd1 vccd1 vccd1 hold677/X sky130_fd_sc_hd__dlygate4sd3_1
Xhold666 _3136_/Q vssd1 vssd1 vccd1 vccd1 hold666/X sky130_fd_sc_hd__dlygate4sd3_1
Xhold655 _3193_/Q vssd1 vssd1 vccd1 vccd1 hold655/X sky130_fd_sc_hd__dlygate4sd3_1
X_3448_ _3450_/CLK _3448_/D fanout282/X vssd1 vssd1 vccd1 vccd1 _3448_/Q sky130_fd_sc_hd__dfrtp_2
Xhold699 _3097_/Q vssd1 vssd1 vccd1 vccd1 hold699/X sky130_fd_sc_hd__dlygate4sd3_1
XANTENNA_fanout196_X _1962_/B vssd1 vssd1 vccd1 vccd1 sky130_fd_sc_hd__diode_2
X_3379_ _3002_/Y _3379_/D fanout284/X vssd1 vssd1 vccd1 vccd1 _3379_/Q sky130_fd_sc_hd__dfrtp_2
XFILLER_76_109 vssd1 vssd1 vccd1 vccd1 sky130_fd_sc_hd__fill_1
XANTENNA__2717__S _2723_/S vssd1 vssd1 vccd1 vccd1 sky130_fd_sc_hd__diode_2
XANTENNA__2944__C _2970_/C vssd1 vssd1 vccd1 vccd1 sky130_fd_sc_hd__diode_2
XFILLER_72_337 vssd1 vssd1 vccd1 vccd1 sky130_fd_sc_hd__fill_1
XFILLER_43_45 vssd1 vssd1 vccd1 vccd1 sky130_fd_sc_hd__fill_1
XANTENNA__2940__C1 _1585_/A vssd1 vssd1 vccd1 vccd1 sky130_fd_sc_hd__diode_2
XFILLER_0_363 vssd1 vssd1 vccd1 vccd1 sky130_fd_sc_hd__fill_1
XFILLER_0_341 vssd1 vssd1 vccd1 vccd1 sky130_fd_sc_hd__fill_1
XFILLER_68_97 vssd1 vssd1 vccd1 vccd1 sky130_fd_sc_hd__fill_1
XTAP_TAPCELL_ROW_74_800 vssd1 vccd1 sky130_fd_sc_hd__tapvpwrvgnd_1
XANTENNA__2627__S _2647_/S vssd1 vssd1 vccd1 vccd1 sky130_fd_sc_hd__diode_2
XFILLER_63_315 vssd1 vssd1 vccd1 vccd1 sky130_fd_sc_hd__fill_2
XFILLER_16_253 vssd1 vccd1 vssd1 vccd1 sky130_ef_sc_hd__decap_40_12
X_2750_ hold544/X _2845_/A1 _2761_/S vssd1 vssd1 vccd1 vccd1 _3259_/D sky130_fd_sc_hd__mux2_1
XFILLER_31_289 vssd1 vssd1 vccd1 vccd1 sky130_fd_sc_hd__fill_1
X_2681_ hold519/X _2814_/A1 _2681_/S vssd1 vssd1 vccd1 vccd1 _3194_/D sky130_fd_sc_hd__mux2_1
X_1701_ _1701_/A _1701_/B vssd1 vssd1 vccd1 vccd1 _1701_/Y sky130_fd_sc_hd__xnor2_2
X_1632_ _1632_/A _1632_/B vssd1 vssd1 vccd1 vccd1 _3430_/D sky130_fd_sc_hd__or2_2
X_1563_ _2926_/B _2926_/C vssd1 vssd1 vccd1 vccd1 _2838_/B sky130_fd_sc_hd__and2_2
X_3302_ _3302_/CLK _3302_/D load_slew273/X vssd1 vssd1 vccd1 vccd1 _3302_/Q sky130_fd_sc_hd__dfrtp_2
XANTENNA_clkbuf_3_3__f_clk_A clkbuf_0_clk/X vssd1 vssd1 vccd1 vccd1 sky130_fd_sc_hd__diode_2
X_3233_ _3359_/CLK _3233_/D fanout235/X vssd1 vssd1 vccd1 vccd1 _3233_/Q sky130_fd_sc_hd__dfrtp_2
XFILLER_79_492 vssd1 vssd1 vccd1 vccd1 sky130_fd_sc_hd__fill_2
XFILLER_39_323 vssd1 vssd1 vccd1 vccd1 sky130_fd_sc_hd__fill_1
X_3164_ _3431_/CLK _3164_/D fanout274/X vssd1 vssd1 vccd1 vccd1 _3164_/Q sky130_fd_sc_hd__dfrtp_2
XFILLER_66_131 vssd1 vssd1 vccd1 vccd1 sky130_fd_sc_hd__fill_1
XFILLER_39_367 vssd1 vssd1 vccd1 vccd1 sky130_fd_sc_hd__fill_1
X_3095_ _3112_/CLK _3095_/D load_slew202/X vssd1 vssd1 vccd1 vccd1 _3095_/Q sky130_fd_sc_hd__dfrtp_2
X_2115_ _2124_/A _2146_/A _2146_/D _2124_/B vssd1 vssd1 vccd1 vccd1 _2117_/C sky130_fd_sc_hd__a22o_2
X_2046_ _2044_/X _2046_/B vssd1 vssd1 vccd1 vccd1 _2047_/B sky130_fd_sc_hd__nand2b_2
XFILLER_66_197 vssd1 vssd1 vccd1 vccd1 sky130_fd_sc_hd__fill_4
XANTENNA__2462__A1 _2838_/A vssd1 vssd1 vccd1 vccd1 sky130_fd_sc_hd__diode_2
XANTENNA__2462__B2 _2686_/A vssd1 vssd1 vccd1 vccd1 sky130_fd_sc_hd__diode_2
XANTENNA_fanout156_A _1979_/B vssd1 vssd1 vccd1 vccd1 sky130_fd_sc_hd__diode_2
Xfanout16 _2800_/X vssd1 vssd1 vccd1 vccd1 _2814_/S sky130_fd_sc_hd__clkdlybuf4s25_1
Xfanout27 _2686_/X vssd1 vssd1 vccd1 vccd1 _2704_/S sky130_fd_sc_hd__clkdlybuf4s25_1
Xfanout38 _2644_/X vssd1 vssd1 vccd1 vccd1 _2817_/A1 sky130_fd_sc_hd__clkdlybuf4s25_1
Xfanout49 _2622_/X vssd1 vssd1 vccd1 vccd1 _2844_/A1 sky130_fd_sc_hd__clkdlybuf4s25_1
XFILLER_13_15 vssd1 vccd1 vssd1 vccd1 sky130_ef_sc_hd__decap_40_12
X_2948_ _3340_/Q _2971_/A2 _2971_/B1 _3322_/Q _2947_/X vssd1 vssd1 vccd1 vccd1 _2948_/X
+ sky130_fd_sc_hd__a221o_2
XANTENNA_fanout111_X _2962_/A1 vssd1 vssd1 vccd1 vccd1 sky130_fd_sc_hd__diode_2
X_2879_ _3208_/Q _2838_/B _2878_/X vssd1 vssd1 vccd1 vccd1 _2879_/X sky130_fd_sc_hd__a21o_2
Xhold430 _3280_/Q vssd1 vssd1 vccd1 vccd1 hold430/X sky130_fd_sc_hd__dlygate4sd3_1
Xhold441 _2577_/X vssd1 vssd1 vccd1 vccd1 _3129_/D sky130_fd_sc_hd__dlygate4sd3_1
Xhold452 _3326_/Q vssd1 vssd1 vccd1 vccd1 hold452/X sky130_fd_sc_hd__dlygate4sd3_1
Xhold463 _3108_/Q vssd1 vssd1 vccd1 vccd1 hold463/X sky130_fd_sc_hd__dlygate4sd3_1
XTAP_TAPCELL_ROW_9_249 vssd1 vccd1 sky130_fd_sc_hd__tapvpwrvgnd_1
Xhold474 _3098_/Q vssd1 vssd1 vccd1 vccd1 hold474/X sky130_fd_sc_hd__dlygate4sd3_1
Xhold496 _3120_/Q vssd1 vssd1 vccd1 vccd1 hold496/X sky130_fd_sc_hd__dlygate4sd3_1
Xhold485 _3212_/Q vssd1 vssd1 vccd1 vccd1 hold485/X sky130_fd_sc_hd__dlygate4sd3_1
XANTENNA__2955__B _2970_/B vssd1 vssd1 vccd1 vccd1 sky130_fd_sc_hd__diode_2
XANTENNA_fanout69_A _2901_/B1 vssd1 vssd1 vccd1 vccd1 sky130_fd_sc_hd__diode_2
XFILLER_38_89 vssd1 vssd1 vccd1 vccd1 sky130_fd_sc_hd__fill_2
XFILLER_54_11 vssd1 vssd1 vccd1 vccd1 sky130_fd_sc_hd__fill_1
XTAP_TAPCELL_ROW_0_171 vssd1 vccd1 sky130_fd_sc_hd__tapvpwrvgnd_1
XTAP_TAPCELL_ROW_0_160 vssd1 vccd1 sky130_fd_sc_hd__tapvpwrvgnd_1
XFILLER_72_178 vssd1 vssd1 vccd1 vccd1 sky130_fd_sc_hd__fill_2
XFILLER_60_307 vssd1 vssd1 vccd1 vccd1 sky130_fd_sc_hd__fill_1
XFILLER_54_55 vssd1 vssd1 vccd1 vccd1 sky130_fd_sc_hd__fill_4
XTAP_TAPCELL_ROW_43_538 vssd1 vccd1 sky130_fd_sc_hd__tapvpwrvgnd_1
XANTENNA_fanout24_X _2738_/S vssd1 vssd1 vccd1 vccd1 sky130_fd_sc_hd__diode_2
XFILLER_70_87 vssd1 vssd1 vccd1 vccd1 sky130_fd_sc_hd__fill_1
Xclkload19 _3472_/CLK vssd1 vssd1 vccd1 vccd1 clkload19/X sky130_fd_sc_hd__clkbuf_8
XANTENNA__2508__A2 _2967_/A2 vssd1 vssd1 vccd1 vccd1 sky130_fd_sc_hd__diode_2
XFILLER_79_41 vssd1 vssd1 vccd1 vccd1 sky130_fd_sc_hd__fill_4
XFILLER_79_85 vssd1 vssd1 vccd1 vccd1 sky130_fd_sc_hd__fill_8
XFILLER_0_193 vssd1 vssd1 vccd1 vccd1 sky130_fd_sc_hd__fill_2
XTAP_TAPCELL_ROW_59_671 vssd1 vccd1 sky130_fd_sc_hd__tapvpwrvgnd_1
XFILLER_48_197 vssd1 vssd1 vccd1 vccd1 sky130_fd_sc_hd__fill_4
X_2802_ hold540/X _2802_/A1 _2814_/S vssd1 vssd1 vccd1 vccd1 _3308_/D sky130_fd_sc_hd__mux2_1
X_2733_ hold545/X _2809_/A1 _2738_/S vssd1 vssd1 vccd1 vccd1 _3243_/D sky130_fd_sc_hd__mux2_1
XTAP_TAPCELL_ROW_14_295 vssd1 vccd1 sky130_fd_sc_hd__tapvpwrvgnd_1
XANTENNA__2820__S _2833_/S vssd1 vssd1 vccd1 vccd1 sky130_fd_sc_hd__diode_2
XFILLER_8_282 vssd1 vssd1 vccd1 vccd1 sky130_fd_sc_hd__fill_1
X_2664_ hold486/X _2816_/A1 _2666_/S vssd1 vssd1 vccd1 vccd1 _3178_/D sky130_fd_sc_hd__mux2_1
X_2595_ _3426_/Q _2595_/B vssd1 vssd1 vccd1 vccd1 _2595_/Y sky130_fd_sc_hd__nand2_2
X_1615_ _3421_/Q _3424_/Q _2609_/C vssd1 vssd1 vccd1 vccd1 _2434_/A sky130_fd_sc_hd__or3_2
X_1546_ _3390_/Q _3462_/Q _1546_/S vssd1 vssd1 vccd1 vccd1 _3463_/D sky130_fd_sc_hd__mux2_1
Xfanout206 fanout214/X vssd1 vssd1 vccd1 vccd1 fanout206/X sky130_fd_sc_hd__clkdlybuf4s25_1
Xfanout217 fanout218/X vssd1 vssd1 vccd1 vccd1 fanout217/X sky130_fd_sc_hd__clkdlybuf4s25_1
Xfanout228 fanout291/X vssd1 vssd1 vccd1 vccd1 fanout228/X sky130_fd_sc_hd__clkdlybuf4s25_1
XTAP_TAPCELL_ROW_6_219 vssd1 vccd1 sky130_fd_sc_hd__tapvpwrvgnd_1
Xfanout239 fanout242/X vssd1 vssd1 vccd1 vccd1 fanout239/X sky130_fd_sc_hd__clkdlybuf4s25_1
X_3216_ _3337_/CLK _3216_/D fanout249/X vssd1 vssd1 vccd1 vccd1 _3216_/Q sky130_fd_sc_hd__dfrtp_2
XFILLER_39_142 vssd1 vssd1 vccd1 vccd1 sky130_fd_sc_hd__fill_4
X_3147_ _3431_/CLK _3147_/D load_slew264/X vssd1 vssd1 vccd1 vccd1 _3147_/Q sky130_fd_sc_hd__dfrtp_2
XFILLER_39_175 vssd1 vssd1 vccd1 vccd1 sky130_fd_sc_hd__fill_1
XFILLER_27_337 vssd1 vssd1 vccd1 vccd1 sky130_fd_sc_hd__fill_1
X_3078_ _3121_/CLK _3078_/D vssd1 vssd1 vccd1 vccd1 _3078_/Q sky130_fd_sc_hd__dfxtp_2
XANTENNA_fanout159_X _2002_/B vssd1 vssd1 vccd1 vccd1 sky130_fd_sc_hd__diode_2
X_2029_ _2029_/A _2029_/B _2029_/C _2029_/D vssd1 vssd1 vccd1 vccd1 _2030_/B sky130_fd_sc_hd__and4_2
XTAP_TAPCELL_ROW_40_508 vssd1 vccd1 sky130_fd_sc_hd__tapvpwrvgnd_1
XFILLER_10_248 vssd1 vssd1 vccd1 vccd1 sky130_fd_sc_hd__fill_2
XANTENNA__2730__S _2742_/S vssd1 vssd1 vccd1 vccd1 sky130_fd_sc_hd__diode_2
XFILLER_2_414 vssd1 vssd1 vccd1 vccd1 sky130_fd_sc_hd__fill_4
XANTENNA__2910__A2 _2967_/A2 vssd1 vssd1 vccd1 vccd1 sky130_fd_sc_hd__diode_2
XFILLER_49_66 vssd1 vssd1 vccd1 vccd1 sky130_fd_sc_hd__fill_2
XFILLER_73_432 vssd1 vssd1 vccd1 vccd1 sky130_fd_sc_hd__fill_2
XFILLER_45_123 vssd1 vssd1 vccd1 vccd1 sky130_fd_sc_hd__fill_4
XTAP_TAPCELL_ROW_56_652 vssd1 vccd1 sky130_fd_sc_hd__tapvpwrvgnd_1
XFILLER_73_487 vssd1 vssd1 vccd1 vccd1 sky130_fd_sc_hd__fill_1
XFILLER_45_167 vssd1 vssd1 vccd1 vccd1 sky130_fd_sc_hd__fill_1
XANTENNA__1937__B1 _1998_/B vssd1 vssd1 vccd1 vccd1 sky130_fd_sc_hd__diode_2
XTAP_TAPCELL_ROW_11_265 vssd1 vccd1 sky130_fd_sc_hd__tapvpwrvgnd_1
X_2380_ _2382_/A vssd1 vssd1 vccd1 vccd1 _2406_/A sky130_fd_sc_hd__inv_2
XANTENNA__1780__A _2091_/B vssd1 vssd1 vccd1 vccd1 sky130_fd_sc_hd__diode_2
XANTENNA__2901__A2 _2901_/A2 vssd1 vssd1 vccd1 vccd1 sky130_fd_sc_hd__diode_2
XFILLER_1_480 vssd1 vssd1 vccd1 vccd1 sky130_fd_sc_hd__fill_1
XFILLER_49_451 vssd1 vssd1 vccd1 vccd1 sky130_fd_sc_hd__fill_1
X_3001_ _3001_/A vssd1 vssd1 vccd1 vccd1 _3001_/Y sky130_fd_sc_hd__inv_2
XTAP_TAPCELL_ROW_19_332 vssd1 vccd1 sky130_fd_sc_hd__tapvpwrvgnd_1
XFILLER_24_307 vssd1 vssd1 vccd1 vccd1 sky130_fd_sc_hd__fill_1
XANTENNA__2815__S _2818_/S vssd1 vssd1 vccd1 vccd1 sky130_fd_sc_hd__diode_2
XTAP_TAPCELL_ROW_62_699 vssd1 vccd1 sky130_fd_sc_hd__tapvpwrvgnd_1
X_2716_ hold546/X _2811_/A1 _2719_/S vssd1 vssd1 vccd1 vccd1 _3227_/D sky130_fd_sc_hd__mux2_1
XANTENNA_fanout119_A _2972_/B2 vssd1 vssd1 vccd1 vccd1 sky130_fd_sc_hd__diode_2
X_2647_ hold475/X _2818_/A1 _2647_/S vssd1 vssd1 vccd1 vccd1 _3162_/D sky130_fd_sc_hd__mux2_1
X_2578_ hold631/X _1621_/Y _2583_/B1 hold674/X vssd1 vssd1 vccd1 vccd1 _3130_/D sky130_fd_sc_hd__a22o_2
X_1529_ _3365_/Q _3366_/Q _1534_/S vssd1 vssd1 vccd1 vccd1 _3366_/D sky130_fd_sc_hd__mux2_1
XFILLER_59_237 vssd1 vssd1 vccd1 vccd1 sky130_fd_sc_hd__fill_1
XFILLER_67_270 vssd1 vssd1 vccd1 vccd1 sky130_fd_sc_hd__fill_1
XFILLER_19_69 vssd1 vssd1 vccd1 vccd1 sky130_fd_sc_hd__fill_8
XFILLER_27_167 vssd1 vssd1 vccd1 vccd1 sky130_fd_sc_hd__fill_1
XANTENNA__2725__S _2742_/S vssd1 vssd1 vccd1 vccd1 sky130_fd_sc_hd__diode_2
XTAP_TAPCELL_ROW_53_622 vssd1 vccd1 sky130_fd_sc_hd__tapvpwrvgnd_1
XFILLER_70_424 vssd1 vssd1 vccd1 vccd1 sky130_fd_sc_hd__fill_2
XFILLER_42_126 vssd1 vssd1 vccd1 vccd1 sky130_fd_sc_hd__fill_1
XFILLER_35_57 vssd1 vssd1 vccd1 vccd1 sky130_fd_sc_hd__fill_1
XFILLER_70_468 vssd1 vssd1 vccd1 vccd1 sky130_fd_sc_hd__fill_8
XFILLER_35_79 vssd1 vssd1 vccd1 vccd1 sky130_fd_sc_hd__fill_2
XFILLER_23_362 vssd1 vssd1 vccd1 vccd1 sky130_fd_sc_hd__fill_1
Xclkbuf_3_3__f_clk clkbuf_0_clk/X vssd1 vssd1 vccd1 vccd1 clkload2/A sky130_fd_sc_hd__clkbuf_16
XPHY_EDGE_ROW_14_Right_14 vssd1 vssd1 vccd1 vccd1 sky130_fd_sc_hd__decap_3
XFILLER_50_192 vssd1 vssd1 vccd1 vccd1 sky130_fd_sc_hd__fill_2
XANTENNA__1865__A _1947_/A vssd1 vssd1 vccd1 vccd1 sky130_fd_sc_hd__diode_2
XANTENNA_fanout91_X _1773_/S vssd1 vssd1 vccd1 vccd1 sky130_fd_sc_hd__diode_2
XANTENNA__2895__A1 _2445_/S vssd1 vssd1 vccd1 vccd1 sky130_fd_sc_hd__diode_2
XPHY_EDGE_ROW_23_Right_23 vssd1 vssd1 vccd1 vccd1 sky130_fd_sc_hd__decap_3
XANTENNA__2895__B2 _2838_/A vssd1 vssd1 vccd1 vccd1 sky130_fd_sc_hd__diode_2
XFILLER_76_53 vssd1 vssd1 vccd1 vccd1 sky130_fd_sc_hd__fill_8
XFILLER_65_207 vssd1 vssd1 vccd1 vccd1 sky130_fd_sc_hd__fill_4
XANTENNA__2635__S _2645_/S vssd1 vssd1 vccd1 vccd1 sky130_fd_sc_hd__diode_2
XPHY_EDGE_ROW_32_Right_32 vssd1 vssd1 vccd1 vccd1 sky130_fd_sc_hd__decap_3
X_1880_ _1880_/A _1880_/B vssd1 vssd1 vccd1 vccd1 _1880_/Y sky130_fd_sc_hd__xnor2_2
X_2501_ _2501_/A _2501_/B vssd1 vssd1 vccd1 vccd1 _2502_/B sky130_fd_sc_hd__or2_2
X_2432_ _1625_/B _2590_/B _2429_/X _2431_/X vssd1 vssd1 vccd1 vccd1 _2434_/B sky130_fd_sc_hd__a31o_2
XPHY_EDGE_ROW_41_Right_41 vssd1 vssd1 vccd1 vccd1 sky130_fd_sc_hd__decap_3
XFILLER_44_3 vssd1 vssd1 vccd1 vccd1 sky130_fd_sc_hd__fill_8
X_2363_ _2363_/A _2363_/B vssd1 vssd1 vccd1 vccd1 _2364_/B sky130_fd_sc_hd__and2_2
X_2294_ _2260_/Y _2268_/B _2262_/B vssd1 vssd1 vccd1 vccd1 _2295_/B sky130_fd_sc_hd__o21ai_2
XPHY_EDGE_ROW_50_Right_50 vssd1 vssd1 vccd1 vccd1 sky130_fd_sc_hd__decap_3
XANTENNA_fanout236_A fanout242/X vssd1 vssd1 vccd1 vccd1 sky130_fd_sc_hd__diode_2
XFILLER_21_37 vssd1 vssd1 vccd1 vccd1 sky130_fd_sc_hd__fill_1
XANTENNA__2877__B2 _2520_/A vssd1 vssd1 vccd1 vccd1 sky130_fd_sc_hd__diode_2
XANTENNA__2947__C _2970_/C vssd1 vssd1 vccd1 vccd1 sky130_fd_sc_hd__diode_2
XTAP_TAPCELL_ROW_38_493 vssd1 vccd1 sky130_fd_sc_hd__tapvpwrvgnd_1
XFILLER_70_243 vssd1 vssd1 vccd1 vccd1 sky130_fd_sc_hd__fill_8
XFILLER_62_11 vssd1 vssd1 vccd1 vccd1 sky130_fd_sc_hd__fill_2
XFILLER_62_77 vssd1 vssd1 vccd1 vccd1 sky130_fd_sc_hd__fill_4
XFILLER_11_81 vssd1 vssd1 vccd1 vccd1 sky130_fd_sc_hd__fill_1
XANTENNA__2317__B1 _2279_/B vssd1 vssd1 vccd1 vccd1 sky130_fd_sc_hd__diode_2
XFILLER_16_7 vssd1 vssd1 vccd1 vccd1 sky130_fd_sc_hd__fill_2
XTAP_TAPCELL_ROW_64_717 vssd1 vccd1 sky130_fd_sc_hd__tapvpwrvgnd_1
XFILLER_46_251 vssd1 vssd1 vccd1 vccd1 sky130_fd_sc_hd__fill_1
X_2981_ _3405_/Q hold390/X _3408_/Q vssd1 vssd1 vccd1 vccd1 _2981_/X sky130_fd_sc_hd__mux2_1
XTAP_TAPCELL_ROW_72_783 vssd1 vccd1 sky130_fd_sc_hd__tapvpwrvgnd_1
Xclkbuf_leaf_41_clk clkbuf_leaf_2_clk/A vssd1 vssd1 vccd1 vccd1 clkload9/A sky130_fd_sc_hd__clkbuf_8
X_1932_ _1933_/B _1933_/C _1933_/D _1933_/A vssd1 vssd1 vccd1 vccd1 _1958_/A sky130_fd_sc_hd__a22oi_2
X_1863_ _1863_/A _1885_/A vssd1 vssd1 vccd1 vccd1 _1872_/A sky130_fd_sc_hd__or2_2
XANTENNA__1936__C _1962_/B vssd1 vssd1 vccd1 vccd1 sky130_fd_sc_hd__diode_2
X_1794_ _1884_/A _1979_/A _2004_/B _1828_/D vssd1 vssd1 vccd1 vccd1 _1797_/B sky130_fd_sc_hd__nand4_2
X_3464_ _3471_/CLK _3464_/D fanout259/X vssd1 vssd1 vccd1 vccd1 _3464_/Q sky130_fd_sc_hd__dfrtp_2
X_2415_ _2405_/A _2404_/A _2398_/Y _2399_/C vssd1 vssd1 vccd1 vccd1 _2419_/B sky130_fd_sc_hd__a211o_2
X_3395_ _3395_/CLK _3395_/D fanout251/X vssd1 vssd1 vccd1 vccd1 _3395_/Q sky130_fd_sc_hd__dfrtp_2
X_2346_ hold375/X _2345_/Y _2374_/S vssd1 vssd1 vccd1 vccd1 _3081_/D sky130_fd_sc_hd__mux2_1
X_2277_ _2258_/A _2258_/C _2258_/B vssd1 vssd1 vccd1 vccd1 _2283_/A sky130_fd_sc_hd__a21boi_2
XFILLER_37_240 vssd1 vssd1 vccd1 vccd1 sky130_fd_sc_hd__fill_2
XFILLER_52_210 vssd1 vccd1 vssd1 vccd1 sky130_ef_sc_hd__decap_40_12
XFILLER_25_435 vssd1 vssd1 vccd1 vccd1 sky130_fd_sc_hd__fill_1
XFILLER_40_416 vssd1 vssd1 vccd1 vccd1 sky130_fd_sc_hd__fill_1
XFILLER_12_118 vssd1 vssd1 vccd1 vccd1 sky130_fd_sc_hd__fill_4
XANTENNA_fanout141_X _2399_/A vssd1 vssd1 vccd1 vccd1 sky130_fd_sc_hd__diode_2
Xclkbuf_leaf_32_clk clkbuf_3_4__f_clk/X vssd1 vssd1 vccd1 vccd1 _3359_/CLK sky130_fd_sc_hd__clkbuf_8
XFILLER_4_306 vssd1 vssd1 vccd1 vccd1 sky130_fd_sc_hd__fill_2
XFILLER_20_195 vssd1 vssd1 vccd1 vccd1 sky130_fd_sc_hd__fill_1
XANTENNA_fanout99_A _1993_/S vssd1 vssd1 vccd1 vccd1 sky130_fd_sc_hd__diode_2
XFILLER_79_107 vssd1 vssd1 vccd1 vccd1 sky130_fd_sc_hd__fill_4
XFILLER_16_402 vssd1 vssd1 vccd1 vccd1 sky130_fd_sc_hd__fill_1
XFILLER_73_43 vssd1 vssd1 vccd1 vccd1 sky130_fd_sc_hd__fill_2
Xclkbuf_leaf_23_clk clkload2/A vssd1 vssd1 vccd1 vccd1 _3383_/CLK sky130_fd_sc_hd__clkbuf_8
XFILLER_7_111 vssd1 vssd1 vccd1 vccd1 sky130_fd_sc_hd__fill_1
X_2200_ _2200_/A _2200_/B vssd1 vssd1 vccd1 vccd1 _2200_/X sky130_fd_sc_hd__xor2_2
X_3180_ _3398_/CLK _3180_/D load_slew250/X vssd1 vssd1 vccd1 vccd1 _3180_/Q sky130_fd_sc_hd__dfrtp_2
XANTENNA__3306__RESET_B fanout251/X vssd1 vssd1 vccd1 vccd1 sky130_fd_sc_hd__diode_2
X_2131_ _2154_/B _2347_/A vssd1 vssd1 vccd1 vccd1 _2135_/A sky130_fd_sc_hd__and2_2
XFILLER_78_173 vssd1 vccd1 vssd1 vccd1 sky130_ef_sc_hd__decap_40_12
X_2062_ _2062_/A _2062_/B vssd1 vssd1 vccd1 vccd1 _2067_/B sky130_fd_sc_hd__xnor2_2
XTAP_TAPCELL_ROW_49_588 vssd1 vccd1 sky130_fd_sc_hd__tapvpwrvgnd_1
XANTENNA__2823__S _2837_/S vssd1 vssd1 vccd1 vccd1 sky130_fd_sc_hd__diode_2
X_2964_ _3216_/Q _2964_/B _2964_/C vssd1 vssd1 vccd1 vccd1 _2964_/X sky130_fd_sc_hd__and3_2
XANTENNA__1947__B _2029_/D vssd1 vssd1 vccd1 vccd1 sky130_fd_sc_hd__diode_2
Xclkbuf_leaf_14_clk clkload4/A vssd1 vssd1 vccd1 vccd1 _3472_/CLK sky130_fd_sc_hd__clkbuf_8
X_1915_ _1914_/A _1914_/B _1914_/C vssd1 vssd1 vccd1 vccd1 _1917_/C sky130_fd_sc_hd__o21ai_2
XTAP_TAPCELL_ROW_32_444 vssd1 vccd1 sky130_fd_sc_hd__tapvpwrvgnd_1
X_2895_ _2445_/S _2890_/X _2894_/X _2838_/A vssd1 vssd1 vccd1 vccd1 _2895_/X sky130_fd_sc_hd__a22o_2
XFILLER_8_60 vssd1 vssd1 vccd1 vccd1 sky130_fd_sc_hd__fill_1
XANTENNA__2529__B1 _2528_/X vssd1 vssd1 vccd1 vccd1 sky130_fd_sc_hd__diode_2
X_1846_ _1824_/A _1823_/B _1844_/A _1844_/B _1821_/Y vssd1 vssd1 vccd1 vccd1 _1879_/B
+ sky130_fd_sc_hd__a221o_2
Xhold612 _3197_/Q vssd1 vssd1 vccd1 vccd1 hold612/X sky130_fd_sc_hd__dlygate4sd3_1
Xhold601 _3324_/Q vssd1 vssd1 vccd1 vccd1 hold601/X sky130_fd_sc_hd__dlygate4sd3_1
X_1777_ hold733/X _2091_/B _1776_/X vssd1 vssd1 vccd1 vccd1 _3054_/D sky130_fd_sc_hd__a21o_2
Xhold645 _3242_/Q vssd1 vssd1 vccd1 vccd1 hold645/X sky130_fd_sc_hd__dlygate4sd3_1
Xhold634 _3107_/Q vssd1 vssd1 vccd1 vccd1 hold634/X sky130_fd_sc_hd__dlygate4sd3_1
Xhold623 _3182_/Q vssd1 vssd1 vccd1 vccd1 hold623/X sky130_fd_sc_hd__dlygate4sd3_1
Xhold678 _3151_/Q vssd1 vssd1 vccd1 vccd1 hold678/X sky130_fd_sc_hd__dlygate4sd3_1
Xhold667 _3156_/Q vssd1 vssd1 vccd1 vccd1 hold667/X sky130_fd_sc_hd__dlygate4sd3_1
Xhold656 _3016_/Q vssd1 vssd1 vccd1 vccd1 hold656/X sky130_fd_sc_hd__dlygate4sd3_1
XPHY_EDGE_ROW_4_Right_4 vssd1 vssd1 vccd1 vccd1 sky130_fd_sc_hd__decap_3
X_3447_ _3450_/CLK _3447_/D fanout270/X vssd1 vssd1 vccd1 vccd1 _3447_/Q sky130_fd_sc_hd__dfrtp_2
Xhold689 _3148_/Q vssd1 vssd1 vccd1 vccd1 hold689/X sky130_fd_sc_hd__dlygate4sd3_1
XANTENNA_clkbuf_leaf_15_clk_A clkload4/A vssd1 vssd1 vccd1 vccd1 sky130_fd_sc_hd__diode_2
X_3378_ _3001_/Y _3378_/D load_slew286/X vssd1 vssd1 vccd1 vccd1 _3378_/Q sky130_fd_sc_hd__dfrtp_2
XANTENNA__3047__RESET_B fanout223/X vssd1 vssd1 vccd1 vccd1 sky130_fd_sc_hd__diode_2
X_2329_ _2330_/B _2330_/C _2330_/A vssd1 vssd1 vccd1 vccd1 _2331_/A sky130_fd_sc_hd__a21oi_2
XANTENNA__2480__A2 _2960_/A2 vssd1 vssd1 vccd1 vccd1 sky130_fd_sc_hd__diode_2
XANTENNA__2733__S _2738_/S vssd1 vssd1 vccd1 vccd1 sky130_fd_sc_hd__diode_2
XFILLER_43_57 vssd1 vccd1 vssd1 vccd1 sky130_ef_sc_hd__decap_40_12
XANTENNA_fanout14_A _2819_/X vssd1 vssd1 vccd1 vccd1 sky130_fd_sc_hd__diode_2
XFILLER_21_493 vssd1 vssd1 vccd1 vccd1 sky130_fd_sc_hd__fill_1
XFILLER_68_32 vssd1 vssd1 vccd1 vccd1 sky130_fd_sc_hd__fill_8
XFILLER_68_21 vssd1 vssd1 vccd1 vccd1 sky130_fd_sc_hd__fill_4
XANTENNA__3470__RESET_B fanout251/X vssd1 vssd1 vccd1 vccd1 sky130_fd_sc_hd__diode_2
XFILLER_68_65 vssd1 vssd1 vccd1 vccd1 sky130_fd_sc_hd__fill_1
XFILLER_48_313 vssd1 vssd1 vccd1 vccd1 sky130_fd_sc_hd__fill_1
XTAP_TAPCELL_ROW_74_801 vssd1 vccd1 sky130_fd_sc_hd__tapvpwrvgnd_1
XANTENNA__2471__A2 _2667_/B vssd1 vssd1 vccd1 vccd1 sky130_fd_sc_hd__diode_2
XANTENNA__2643__S _2645_/S vssd1 vssd1 vccd1 vccd1 sky130_fd_sc_hd__diode_2
XFILLER_71_393 vssd1 vssd1 vccd1 vccd1 sky130_fd_sc_hd__fill_4
XFILLER_31_213 vssd1 vssd1 vccd1 vccd1 sky130_fd_sc_hd__fill_2
XFILLER_16_298 vssd1 vssd1 vccd1 vccd1 sky130_fd_sc_hd__fill_2
X_2680_ hold655/X _2813_/A1 _2685_/S vssd1 vssd1 vccd1 vccd1 _3193_/D sky130_fd_sc_hd__mux2_1
X_1700_ _1691_/Y _1695_/B _1693_/B vssd1 vssd1 vccd1 vccd1 _1701_/B sky130_fd_sc_hd__o21ai_2
XFILLER_12_493 vssd1 vssd1 vccd1 vccd1 sky130_fd_sc_hd__fill_1
X_1631_ _2445_/S _1624_/X _2610_/A _2595_/B _1630_/X vssd1 vssd1 vccd1 vccd1 _1632_/B
+ sky130_fd_sc_hd__a221o_2
X_3301_ _3392_/CLK _3301_/D load_slew240/X vssd1 vssd1 vccd1 vccd1 _3301_/Q sky130_fd_sc_hd__dfrtp_2
X_1562_ _3427_/Q _1572_/B vssd1 vssd1 vccd1 vccd1 _3414_/D sky130_fd_sc_hd__and2_2
X_3232_ _3395_/CLK _3232_/D fanout243/X vssd1 vssd1 vccd1 vccd1 _3232_/Q sky130_fd_sc_hd__dfrtp_2
Xclkbuf_leaf_3_clk clkload0/A vssd1 vssd1 vccd1 vccd1 _3132_/CLK sky130_fd_sc_hd__clkbuf_8
XANTENNA__2818__S _2818_/S vssd1 vssd1 vccd1 vccd1 sky130_fd_sc_hd__diode_2
X_3163_ _3199_/CLK _3163_/D wire222/X vssd1 vssd1 vccd1 vccd1 _3163_/Q sky130_fd_sc_hd__dfrtp_2
XFILLER_39_335 vssd1 vssd1 vccd1 vccd1 sky130_fd_sc_hd__fill_1
X_2114_ _2205_/A _2124_/B _2146_/A _2146_/D vssd1 vssd1 vccd1 vccd1 _2117_/B sky130_fd_sc_hd__nand4_2
X_3094_ _3112_/CLK _3094_/D fanout201/X vssd1 vssd1 vccd1 vccd1 _3094_/Q sky130_fd_sc_hd__dfrtp_2
X_2045_ _2045_/A _2045_/B _2045_/C vssd1 vssd1 vccd1 vccd1 _2046_/B sky130_fd_sc_hd__or3_2
XANTENNA__2553__S _2559_/S vssd1 vssd1 vccd1 vccd1 sky130_fd_sc_hd__diode_2
Xfanout17 _2799_/S vssd1 vssd1 vccd1 vccd1 _2798_/S sky130_fd_sc_hd__clkdlybuf4s25_1
Xfanout28 _2686_/X vssd1 vssd1 vccd1 vccd1 _2700_/S sky130_fd_sc_hd__clkdlybuf4s25_1
Xfanout39 _2642_/X vssd1 vssd1 vccd1 vccd1 _2816_/A1 sky130_fd_sc_hd__clkdlybuf4s25_1
X_2947_ _3358_/Q _2970_/B _2970_/C vssd1 vssd1 vccd1 vccd1 _2947_/X sky130_fd_sc_hd__and3_2
XFILLER_13_38 vssd1 vssd1 vccd1 vccd1 sky130_fd_sc_hd__fill_4
XFILLER_13_27 vssd1 vssd1 vccd1 vccd1 sky130_fd_sc_hd__fill_8
XFILLER_30_290 vssd1 vssd1 vccd1 vccd1 sky130_fd_sc_hd__fill_1
X_2878_ _3190_/Q _2894_/A2 _2894_/B1 _3172_/Q vssd1 vssd1 vccd1 vccd1 _2878_/X sky130_fd_sc_hd__a22o_2
Xhold420 _3355_/Q vssd1 vssd1 vccd1 vccd1 hold420/X sky130_fd_sc_hd__dlygate4sd3_1
X_1829_ _1862_/B _1862_/C _1862_/D _1828_/D vssd1 vssd1 vccd1 vccd1 _1830_/B sky130_fd_sc_hd__a22o_2
Xhold431 _3279_/Q vssd1 vssd1 vccd1 vccd1 hold431/X sky130_fd_sc_hd__dlygate4sd3_1
Xhold442 _3209_/Q vssd1 vssd1 vccd1 vccd1 hold442/X sky130_fd_sc_hd__dlygate4sd3_1
Xhold453 _3396_/Q vssd1 vssd1 vccd1 vccd1 hold453/X sky130_fd_sc_hd__dlygate4sd3_1
Xhold464 _3348_/Q vssd1 vssd1 vccd1 vccd1 hold464/X sky130_fd_sc_hd__dlygate4sd3_1
Xhold475 _3162_/Q vssd1 vssd1 vccd1 vccd1 hold475/X sky130_fd_sc_hd__dlygate4sd3_1
Xhold486 _3178_/Q vssd1 vssd1 vccd1 vccd1 hold486/X sky130_fd_sc_hd__dlygate4sd3_1
Xhold497 _3228_/Q vssd1 vssd1 vccd1 vccd1 hold497/X sky130_fd_sc_hd__dlygate4sd3_1
XANTENNA__2728__S _2738_/S vssd1 vssd1 vccd1 vccd1 sky130_fd_sc_hd__diode_2
XANTENNA__2955__C _2957_/C vssd1 vssd1 vccd1 vccd1 sky130_fd_sc_hd__diode_2
XPHY_EDGE_ROW_13_Left_93 vssd1 vssd1 vccd1 vccd1 sky130_fd_sc_hd__decap_3
XFILLER_57_121 vssd1 vssd1 vccd1 vccd1 sky130_fd_sc_hd__fill_8
XPHY_EDGE_ROW_79_Right_79 vssd1 vssd1 vccd1 vccd1 sky130_fd_sc_hd__decap_3
XFILLER_45_305 vssd1 vssd1 vccd1 vccd1 sky130_fd_sc_hd__fill_1
XFILLER_72_124 vssd1 vssd1 vccd1 vccd1 sky130_fd_sc_hd__fill_1
XTAP_TAPCELL_ROW_0_172 vssd1 vccd1 sky130_fd_sc_hd__tapvpwrvgnd_1
XTAP_TAPCELL_ROW_0_161 vssd1 vccd1 sky130_fd_sc_hd__tapvpwrvgnd_1
XFILLER_60_319 vssd1 vssd1 vccd1 vccd1 sky130_fd_sc_hd__fill_1
XTAP_TAPCELL_ROW_43_539 vssd1 vccd1 sky130_fd_sc_hd__tapvpwrvgnd_1
XANTENNA_fanout17_X _2798_/S vssd1 vssd1 vccd1 vccd1 sky130_fd_sc_hd__diode_2
XFILLER_13_279 vssd1 vssd1 vccd1 vccd1 sky130_fd_sc_hd__fill_1
XFILLER_48_110 vssd1 vssd1 vccd1 vccd1 sky130_fd_sc_hd__fill_8
XANTENNA__1542__S _1546_/S vssd1 vssd1 vccd1 vccd1 sky130_fd_sc_hd__diode_2
XTAP_TAPCELL_ROW_59_672 vssd1 vccd1 sky130_fd_sc_hd__tapvpwrvgnd_1
XFILLER_63_113 vssd1 vssd1 vccd1 vccd1 sky130_fd_sc_hd__fill_4
XFILLER_63_179 vssd1 vssd1 vccd1 vccd1 sky130_fd_sc_hd__fill_1
X_2801_ hold696/X _2839_/A1 _2814_/S vssd1 vssd1 vccd1 vccd1 _3307_/D sky130_fd_sc_hd__mux2_1
X_2732_ hold645/X _2808_/A1 _2738_/S vssd1 vssd1 vccd1 vccd1 _3242_/D sky130_fd_sc_hd__mux2_1
XFILLER_74_3 vssd1 vccd1 vssd1 vccd1 sky130_ef_sc_hd__decap_40_12
X_2663_ hold525/X _2815_/A1 _2666_/S vssd1 vssd1 vccd1 vccd1 _3177_/D sky130_fd_sc_hd__mux2_1
XANTENNA__1944__C _2004_/B vssd1 vssd1 vccd1 vccd1 sky130_fd_sc_hd__diode_2
X_2594_ _2594_/A _2594_/B vssd1 vssd1 vccd1 vccd1 _2594_/X sky130_fd_sc_hd__or2_2
X_1614_ _3419_/Q _3417_/Q vssd1 vssd1 vccd1 vccd1 _2609_/C sky130_fd_sc_hd__or2_2
X_1545_ _3389_/Q _3461_/Q _1546_/S vssd1 vssd1 vccd1 vccd1 _3462_/D sky130_fd_sc_hd__mux2_1
Xfanout207 fanout214/X vssd1 vssd1 vccd1 vccd1 wire208/A sky130_fd_sc_hd__clkdlybuf4s25_1
Xfanout218 fanout291/X vssd1 vssd1 vccd1 vccd1 fanout218/X sky130_fd_sc_hd__clkdlybuf4s25_1
Xfanout229 fanout231/X vssd1 vssd1 vccd1 vccd1 fanout229/X sky130_fd_sc_hd__clkdlybuf4s25_1
X_3215_ _3287_/CLK _3215_/D load_slew234/X vssd1 vssd1 vccd1 vccd1 _3215_/Q sky130_fd_sc_hd__dfrtp_2
X_3146_ _3302_/CLK _3146_/D load_slew273/X vssd1 vssd1 vccd1 vccd1 _3146_/Q sky130_fd_sc_hd__dfrtp_2
XFILLER_27_305 vssd1 vssd1 vccd1 vccd1 sky130_fd_sc_hd__fill_2
X_3077_ _3119_/CLK _3077_/D vssd1 vssd1 vccd1 vccd1 _3077_/Q sky130_fd_sc_hd__dfxtp_2
X_2028_ _2029_/B _2029_/D vssd1 vssd1 vccd1 vccd1 _2053_/A sky130_fd_sc_hd__and2_2
XFILLER_54_179 vssd1 vssd1 vccd1 vccd1 sky130_fd_sc_hd__fill_4
XFILLER_24_26 vssd1 vssd1 vccd1 vccd1 sky130_fd_sc_hd__fill_2
XTAP_TAPCELL_ROW_40_509 vssd1 vccd1 sky130_fd_sc_hd__tapvpwrvgnd_1
XFILLER_65_22 vssd1 vssd1 vccd1 vccd1 sky130_fd_sc_hd__fill_2
XANTENNA__1937__A1 _2002_/B vssd1 vssd1 vccd1 vccd1 sky130_fd_sc_hd__diode_2
XTAP_TAPCELL_ROW_11_266 vssd1 vccd1 sky130_fd_sc_hd__tapvpwrvgnd_1
XFILLER_5_297 vssd1 vssd1 vccd1 vccd1 sky130_fd_sc_hd__fill_1
XFILLER_5_275 vssd1 vssd1 vccd1 vccd1 sky130_fd_sc_hd__fill_4
XFILLER_68_227 vssd1 vssd1 vccd1 vccd1 sky130_fd_sc_hd__fill_4
XFILLER_1_470 vssd1 vssd1 vccd1 vccd1 sky130_fd_sc_hd__fill_8
X_3000_ _3001_/A vssd1 vssd1 vccd1 vccd1 _3000_/Y sky130_fd_sc_hd__inv_2
XFILLER_49_474 vssd1 vssd1 vccd1 vccd1 sky130_fd_sc_hd__fill_2
XTAP_TAPCELL_ROW_19_333 vssd1 vccd1 sky130_fd_sc_hd__tapvpwrvgnd_1
XANTENNA__2831__S _2837_/S vssd1 vssd1 vccd1 vccd1 sky130_fd_sc_hd__diode_2
XFILLER_32_396 vssd1 vssd1 vccd1 vccd1 sky130_fd_sc_hd__fill_1
X_2715_ hold618/X _2848_/A1 _2719_/S vssd1 vssd1 vccd1 vccd1 _3226_/D sky130_fd_sc_hd__mux2_1
X_2646_ _3139_/Q _2646_/B vssd1 vssd1 vccd1 vccd1 _2646_/X sky130_fd_sc_hd__and2_2
X_2577_ hold440/X _1622_/C _2587_/B1 _3129_/Q vssd1 vssd1 vccd1 vccd1 _2577_/X sky130_fd_sc_hd__a22o_2
X_1528_ _3366_/Q _3367_/Q _1534_/S vssd1 vssd1 vccd1 vccd1 _3367_/D sky130_fd_sc_hd__mux2_1
XFILLER_59_216 vssd1 vssd1 vccd1 vccd1 sky130_fd_sc_hd__fill_1
XFILLER_19_37 vssd1 vssd1 vccd1 vccd1 sky130_fd_sc_hd__fill_1
XFILLER_27_113 vssd1 vssd1 vccd1 vccd1 sky130_fd_sc_hd__fill_8
XANTENNA_fanout171_X _2399_/B vssd1 vssd1 vccd1 vccd1 sky130_fd_sc_hd__diode_2
X_3129_ _3199_/CLK _3129_/D fanout260/X vssd1 vssd1 vccd1 vccd1 _3129_/Q sky130_fd_sc_hd__dfrtp_2
XTAP_TAPCELL_ROW_53_623 vssd1 vccd1 sky130_fd_sc_hd__tapvpwrvgnd_1
XFILLER_27_179 vssd1 vssd1 vccd1 vccd1 sky130_fd_sc_hd__fill_1
XANTENNA__2741__S _2742_/S vssd1 vssd1 vccd1 vccd1 sky130_fd_sc_hd__diode_2
XFILLER_51_57 vssd1 vccd1 vssd1 vccd1 sky130_ef_sc_hd__decap_40_12
XANTENNA_clkbuf_3_5__f_clk_X clkload3/A vssd1 vssd1 vccd1 vccd1 sky130_fd_sc_hd__diode_2
XFILLER_2_212 vssd1 vccd1 vssd1 vccd1 sky130_ef_sc_hd__decap_40_12
XPHY_EDGE_ROW_29_Left_109 vssd1 vssd1 vccd1 vccd1 sky130_fd_sc_hd__decap_3
XFILLER_2_245 vssd1 vssd1 vccd1 vccd1 sky130_fd_sc_hd__fill_1
XFILLER_76_87 vssd1 vssd1 vccd1 vccd1 sky130_fd_sc_hd__fill_2
XPHY_EDGE_ROW_38_Left_118 vssd1 vssd1 vccd1 vccd1 sky130_fd_sc_hd__decap_3
XFILLER_33_149 vssd1 vssd1 vccd1 vccd1 sky130_fd_sc_hd__fill_1
XANTENNA__2651__S _2662_/S vssd1 vssd1 vccd1 vccd1 sky130_fd_sc_hd__diode_2
XTAP_TAPCELL_ROW_24_380 vssd1 vccd1 sky130_fd_sc_hd__tapvpwrvgnd_1
X_2500_ _2962_/A1 _2497_/X _2499_/X _2973_/A1 vssd1 vssd1 vccd1 vccd1 _2501_/B sky130_fd_sc_hd__a22o_2
X_2431_ _2781_/B _3426_/Q _2431_/C vssd1 vssd1 vccd1 vccd1 _2431_/X sky130_fd_sc_hd__and3b_2
XPHY_EDGE_ROW_47_Left_127 vssd1 vssd1 vccd1 vccd1 sky130_fd_sc_hd__decap_3
XANTENNA__1791__A _1906_/A vssd1 vssd1 vccd1 vccd1 sky130_fd_sc_hd__diode_2
XANTENNA__2886__A2 _3437_/D vssd1 vssd1 vccd1 vccd1 sky130_fd_sc_hd__diode_2
X_2362_ _2363_/A _2363_/B vssd1 vssd1 vccd1 vccd1 _2364_/A sky130_fd_sc_hd__nor2_2
X_2293_ _2293_/A vssd1 vssd1 vccd1 vccd1 _2295_/A sky130_fd_sc_hd__inv_2
XANTENNA__2826__S _2837_/S vssd1 vssd1 vccd1 vccd1 sky130_fd_sc_hd__diode_2
XPHY_EDGE_ROW_56_Left_136 vssd1 vssd1 vccd1 vccd1 sky130_fd_sc_hd__decap_3
XANTENNA_fanout131_A _2472_/B vssd1 vssd1 vccd1 vccd1 sky130_fd_sc_hd__diode_2
XPHY_EDGE_ROW_65_Left_145 vssd1 vssd1 vccd1 vccd1 sky130_fd_sc_hd__decap_3
X_2629_ hold644/X _2809_/A1 _2647_/S vssd1 vssd1 vccd1 vccd1 _3153_/D sky130_fd_sc_hd__mux2_1
XANTENNA__2877__A2 _2923_/A2 vssd1 vssd1 vccd1 vccd1 sky130_fd_sc_hd__diode_2
XPHY_EDGE_ROW_74_Left_154 vssd1 vssd1 vccd1 vccd1 sky130_fd_sc_hd__decap_3
XANTENNA__2736__S _2742_/S vssd1 vssd1 vccd1 vccd1 sky130_fd_sc_hd__diode_2
Xmax_cap58 _2542_/Y vssd1 vssd1 vccd1 vccd1 _2550_/B1 sky130_fd_sc_hd__buf_2
XFILLER_43_414 vssd1 vssd1 vccd1 vccd1 sky130_fd_sc_hd__fill_1
XFILLER_28_477 vssd1 vssd1 vccd1 vccd1 sky130_fd_sc_hd__fill_4
XTAP_TAPCELL_ROW_38_494 vssd1 vccd1 sky130_fd_sc_hd__tapvpwrvgnd_1
XFILLER_15_138 vssd1 vccd1 vssd1 vccd1 sky130_ef_sc_hd__decap_40_12
XFILLER_62_45 vssd1 vssd1 vccd1 vccd1 sky130_fd_sc_hd__fill_1
XTAP_TAPCELL_ROW_21_350 vssd1 vccd1 sky130_fd_sc_hd__tapvpwrvgnd_1
XANTENNA__2565__A1 _1569_/D vssd1 vssd1 vccd1 vccd1 sky130_fd_sc_hd__diode_2
XANTENNA__2317__A1 _2347_/A vssd1 vssd1 vccd1 vccd1 sky130_fd_sc_hd__diode_2
XFILLER_78_322 vssd1 vssd1 vccd1 vccd1 sky130_fd_sc_hd__fill_1
XFILLER_78_399 vssd1 vccd1 vssd1 vccd1 sky130_ef_sc_hd__decap_40_12
XTAP_TAPCELL_ROW_64_718 vssd1 vccd1 sky130_fd_sc_hd__tapvpwrvgnd_1
XPHY_EDGE_ROW_1_Left_81 vssd1 vssd1 vccd1 vccd1 sky130_fd_sc_hd__decap_3
XFILLER_46_296 vssd1 vssd1 vccd1 vccd1 sky130_fd_sc_hd__fill_1
XFILLER_34_436 vssd1 vssd1 vccd1 vccd1 sky130_fd_sc_hd__fill_2
X_2980_ _3404_/Q hold392/X _3408_/Q vssd1 vssd1 vccd1 vccd1 _2980_/X sky130_fd_sc_hd__mux2_1
X_1931_ _1890_/A _1931_/B vssd1 vssd1 vccd1 vccd1 _1933_/D sky130_fd_sc_hd__nand2b_2
XTAP_TAPCELL_ROW_72_784 vssd1 vccd1 sky130_fd_sc_hd__tapvpwrvgnd_1
X_1862_ _1862_/A _1862_/B _1862_/C _1862_/D vssd1 vssd1 vccd1 vccd1 _1885_/A sky130_fd_sc_hd__and4_2
XANTENNA__1936__D _1998_/B vssd1 vssd1 vccd1 vccd1 sky130_fd_sc_hd__diode_2
XANTENNA__2556__A1 _2502_/X vssd1 vssd1 vccd1 vccd1 sky130_fd_sc_hd__diode_2
X_1793_ _1884_/A _1979_/A _2004_/B _1828_/D vssd1 vssd1 vccd1 vccd1 _1810_/A sky130_fd_sc_hd__and4_2
XANTENNA__2113__C _2326_/B vssd1 vssd1 vccd1 vccd1 sky130_fd_sc_hd__diode_2
X_3463_ _3463_/CLK _3463_/D load_slew258/X vssd1 vssd1 vccd1 vccd1 _3463_/Q sky130_fd_sc_hd__dfrtp_2
X_2414_ _2414_/A vssd1 vssd1 vccd1 vccd1 _2414_/Y sky130_fd_sc_hd__inv_2
X_3394_ _3394_/CLK _3394_/D fanout279/X vssd1 vssd1 vccd1 vccd1 _3394_/Q sky130_fd_sc_hd__dfrtp_2
X_2345_ _2345_/A _2345_/B vssd1 vssd1 vccd1 vccd1 _2345_/Y sky130_fd_sc_hd__xnor2_2
X_2276_ hold512/X _2275_/Y _2313_/S vssd1 vssd1 vccd1 vccd1 _3079_/D sky130_fd_sc_hd__mux2_1
XANTENNA__2556__S _2559_/S vssd1 vssd1 vccd1 vccd1 sky130_fd_sc_hd__diode_2
XANTENNA__2492__B1 wire66/X vssd1 vssd1 vccd1 vccd1 sky130_fd_sc_hd__diode_2
XFILLER_52_222 vssd1 vssd1 vccd1 vccd1 sky130_fd_sc_hd__fill_2
XFILLER_25_447 vssd1 vssd1 vccd1 vccd1 sky130_fd_sc_hd__fill_1
XFILLER_16_27 vssd1 vssd1 vccd1 vccd1 sky130_fd_sc_hd__fill_1
XANTENNA_fanout134_X _2970_/B vssd1 vssd1 vccd1 vccd1 sky130_fd_sc_hd__diode_2
XFILLER_32_26 vssd1 vssd1 vccd1 vccd1 sky130_fd_sc_hd__fill_2
XANTENNA__2547__A1 _2550_/A1 vssd1 vssd1 vccd1 vccd1 sky130_fd_sc_hd__diode_2
XFILLER_73_55 vssd1 vssd1 vccd1 vccd1 sky130_fd_sc_hd__fill_1
XFILLER_7_101 vssd1 vssd1 vccd1 vccd1 sky130_fd_sc_hd__fill_8
XANTENNA__2538__A1 _2781_/B vssd1 vssd1 vccd1 vccd1 sky130_fd_sc_hd__diode_2
XANTENNA__2538__B2 _2445_/S vssd1 vssd1 vccd1 vccd1 sky130_fd_sc_hd__diode_2
XANTENNA__1545__S _1546_/S vssd1 vssd1 vccd1 vccd1 sky130_fd_sc_hd__diode_2
XFILLER_78_141 vssd1 vccd1 vssd1 vccd1 sky130_ef_sc_hd__decap_40_12
X_2130_ _2145_/A _2136_/A vssd1 vssd1 vccd1 vccd1 _2137_/A sky130_fd_sc_hd__or2_2
XFILLER_78_185 vssd1 vssd1 vccd1 vccd1 sky130_fd_sc_hd__fill_4
X_2061_ _2059_/A _2059_/B _2062_/A vssd1 vssd1 vccd1 vccd1 _2081_/B sky130_fd_sc_hd__a21o_2
XFILLER_66_369 vssd1 vssd1 vccd1 vccd1 sky130_fd_sc_hd__fill_1
XTAP_TAPCELL_ROW_49_589 vssd1 vccd1 sky130_fd_sc_hd__tapvpwrvgnd_1
X_2963_ hold720/X _2864_/S _2962_/X vssd1 vssd1 vccd1 vccd1 _3397_/D sky130_fd_sc_hd__o21a_2
X_1914_ _1914_/A _1914_/B _1914_/C vssd1 vssd1 vccd1 vccd1 _1917_/B sky130_fd_sc_hd__or3_2
XTAP_TAPCELL_ROW_32_445 vssd1 vccd1 sky130_fd_sc_hd__tapvpwrvgnd_1
X_2894_ _3335_/Q _2894_/A2 _2894_/B1 _3317_/Q _2893_/X vssd1 vssd1 vccd1 vccd1 _2894_/X
+ sky130_fd_sc_hd__a221o_2
XFILLER_30_450 vssd1 vssd1 vccd1 vccd1 sky130_fd_sc_hd__fill_1
X_1845_ _1879_/A _1845_/B vssd1 vssd1 vccd1 vccd1 _1847_/B sky130_fd_sc_hd__and2_2
XANTENNA__2529__B2 _1602_/X vssd1 vssd1 vccd1 vccd1 sky130_fd_sc_hd__diode_2
Xhold602 _3291_/Q vssd1 vssd1 vccd1 vccd1 hold602/X sky130_fd_sc_hd__dlygate4sd3_1
X_1776_ _1906_/A _1805_/A _1993_/S vssd1 vssd1 vccd1 vccd1 _1776_/X sky130_fd_sc_hd__and3_2
Xhold635 _3390_/Q vssd1 vssd1 vccd1 vccd1 hold635/X sky130_fd_sc_hd__dlygate4sd3_1
Xhold624 _3346_/Q vssd1 vssd1 vccd1 vccd1 hold624/X sky130_fd_sc_hd__dlygate4sd3_1
Xhold613 _3315_/Q vssd1 vssd1 vccd1 vccd1 hold613/X sky130_fd_sc_hd__dlygate4sd3_1
Xhold679 _3063_/Q vssd1 vssd1 vccd1 vccd1 hold679/X sky130_fd_sc_hd__dlygate4sd3_1
Xhold668 _3166_/Q vssd1 vssd1 vccd1 vccd1 hold668/X sky130_fd_sc_hd__dlygate4sd3_1
Xhold657 _3313_/Q vssd1 vssd1 vccd1 vccd1 hold657/X sky130_fd_sc_hd__dlygate4sd3_1
Xhold646 _3185_/Q vssd1 vssd1 vccd1 vccd1 hold646/X sky130_fd_sc_hd__dlygate4sd3_1
X_3446_ _3450_/CLK _3446_/D load_slew281/X vssd1 vssd1 vccd1 vccd1 _3446_/Q sky130_fd_sc_hd__dfrtp_2
X_3377_ _3000_/Y _3377_/D load_slew286/X vssd1 vssd1 vccd1 vccd1 _3377_/Q sky130_fd_sc_hd__dfrtp_2
X_2328_ _2327_/A _2327_/B _2327_/C vssd1 vssd1 vccd1 vccd1 _2330_/C sky130_fd_sc_hd__a21o_2
X_2259_ _2258_/A _2258_/B _2258_/C vssd1 vssd1 vccd1 vccd1 _2261_/C sky130_fd_sc_hd__a21o_2
XANTENNA_fanout251_X fanout251/X vssd1 vssd1 vccd1 vccd1 sky130_fd_sc_hd__diode_2
XFILLER_43_69 vssd1 vssd1 vccd1 vccd1 sky130_fd_sc_hd__fill_2
XFILLER_4_137 vssd1 vssd1 vccd1 vccd1 sky130_fd_sc_hd__fill_2
XANTENNA__2940__A1 _2942_/B2 vssd1 vssd1 vccd1 vccd1 sky130_fd_sc_hd__diode_2
XFILLER_75_111 vssd1 vssd1 vccd1 vccd1 sky130_fd_sc_hd__fill_1
XFILLER_0_387 vssd1 vssd1 vccd1 vccd1 sky130_fd_sc_hd__fill_4
XFILLER_0_365 vssd1 vssd1 vccd1 vccd1 sky130_fd_sc_hd__fill_2
XFILLER_48_369 vssd1 vssd1 vccd1 vccd1 sky130_fd_sc_hd__fill_2
XTAP_TAPCELL_ROW_74_802 vssd1 vccd1 sky130_fd_sc_hd__tapvpwrvgnd_1
XTAP_TAPCELL_ROW_46_559 vssd1 vccd1 sky130_fd_sc_hd__tapvpwrvgnd_1
XFILLER_31_225 vssd1 vssd1 vccd1 vccd1 sky130_fd_sc_hd__fill_1
XFILLER_12_450 vssd1 vssd1 vccd1 vccd1 sky130_fd_sc_hd__fill_4
X_1630_ _2609_/C _1630_/B _1630_/C vssd1 vssd1 vccd1 vccd1 _1630_/X sky130_fd_sc_hd__or3_2
X_3300_ _3387_/CLK _3300_/D fanout235/X vssd1 vssd1 vccd1 vccd1 _3300_/Q sky130_fd_sc_hd__dfrtp_2
X_1561_ _2426_/A _3143_/Q _3141_/Q _3142_/Q vssd1 vssd1 vccd1 vccd1 _2590_/A sky130_fd_sc_hd__or4b_2
X_3231_ _3395_/CLK _3231_/D fanout245/X vssd1 vssd1 vccd1 vccd1 _3231_/Q sky130_fd_sc_hd__dfrtp_2
X_3162_ _3337_/CLK _3162_/D load_slew246/X vssd1 vssd1 vccd1 vccd1 _3162_/Q sky130_fd_sc_hd__dfrtp_2
X_2113_ _2205_/A _2124_/B _2326_/B _2146_/D vssd1 vssd1 vccd1 vccd1 _2129_/A sky130_fd_sc_hd__and4_2
X_3093_ clkload8/A _3093_/D wire208/X vssd1 vssd1 vccd1 vccd1 _3093_/Q sky130_fd_sc_hd__dfrtp_2
XFILLER_66_177 vssd1 vccd1 vssd1 vccd1 sky130_ef_sc_hd__decap_40_12
X_2044_ _2045_/A _2045_/C _2045_/B vssd1 vssd1 vccd1 vccd1 _2044_/X sky130_fd_sc_hd__o21a_2
XANTENNA__2834__S _2837_/S vssd1 vssd1 vccd1 vccd1 sky130_fd_sc_hd__diode_2
Xfanout18 _2781_/X vssd1 vssd1 vccd1 vccd1 _2799_/S sky130_fd_sc_hd__clkdlybuf4s25_1
Xfanout29 _2667_/X vssd1 vssd1 vccd1 vccd1 _2685_/S sky130_fd_sc_hd__clkdlybuf4s25_1
X_2946_ _2973_/A1 _2945_/X _2943_/X _1585_/A vssd1 vssd1 vccd1 vccd1 _2946_/X sky130_fd_sc_hd__a211o_2
X_2877_ _3226_/Q _2923_/A2 _2876_/X _2520_/A vssd1 vssd1 vccd1 vccd1 _2877_/X sky130_fd_sc_hd__a22o_2
XANTENNA__3455__CLK _3463_/CLK vssd1 vssd1 vccd1 vccd1 sky130_fd_sc_hd__diode_2
X_1828_ _1862_/B _1862_/C _1862_/D _1828_/D vssd1 vssd1 vccd1 vccd1 _1892_/A sky130_fd_sc_hd__nand4_2
Xhold410 _3211_/Q vssd1 vssd1 vccd1 vccd1 hold410/X sky130_fd_sc_hd__dlygate4sd3_1
Xhold421 _3284_/Q vssd1 vssd1 vccd1 vccd1 hold421/X sky130_fd_sc_hd__dlygate4sd3_1
Xhold432 _3350_/Q vssd1 vssd1 vccd1 vccd1 hold432/X sky130_fd_sc_hd__dlygate4sd3_1
Xhold443 _3287_/Q vssd1 vssd1 vccd1 vccd1 hold443/X sky130_fd_sc_hd__dlygate4sd3_1
Xhold454 _3077_/Q vssd1 vssd1 vccd1 vccd1 _2201_/A sky130_fd_sc_hd__dlygate4sd3_1
X_1759_ _1947_/A hold634/X _1763_/S vssd1 vssd1 vccd1 vccd1 _3039_/D sky130_fd_sc_hd__mux2_1
XANTENNA__2922__B2 _2838_/A vssd1 vssd1 vccd1 vccd1 sky130_fd_sc_hd__diode_2
Xhold465 _3249_/Q vssd1 vssd1 vccd1 vccd1 hold465/X sky130_fd_sc_hd__dlygate4sd3_1
Xhold476 _3338_/Q vssd1 vssd1 vccd1 vccd1 hold476/X sky130_fd_sc_hd__dlygate4sd3_1
Xhold487 _3084_/Q vssd1 vssd1 vccd1 vccd1 hold487/X sky130_fd_sc_hd__dlygate4sd3_1
X_3429_ _3429_/CLK _3429_/D load_slew227/X vssd1 vssd1 vccd1 vccd1 _3429_/Q sky130_fd_sc_hd__dfrtp_2
Xhold498 _3318_/Q vssd1 vssd1 vccd1 vccd1 hold498/X sky130_fd_sc_hd__dlygate4sd3_1
XANTENNA__2029__B _2029_/B vssd1 vssd1 vccd1 vccd1 sky130_fd_sc_hd__diode_2
XANTENNA__2744__S _2761_/S vssd1 vssd1 vccd1 vccd1 sky130_fd_sc_hd__diode_2
XTAP_TAPCELL_ROW_0_162 vssd1 vccd1 sky130_fd_sc_hd__tapvpwrvgnd_1
XTAP_TAPCELL_ROW_0_173 vssd1 vccd1 sky130_fd_sc_hd__tapvpwrvgnd_1
XFILLER_70_67 vssd1 vssd1 vccd1 vccd1 sky130_fd_sc_hd__fill_1
XFILLER_79_54 vssd1 vssd1 vccd1 vccd1 sky130_fd_sc_hd__fill_2
XFILLER_5_457 vssd1 vssd1 vccd1 vccd1 sky130_fd_sc_hd__fill_1
XTAP_TAPCELL_ROW_8_240 vssd1 vccd1 sky130_fd_sc_hd__tapvpwrvgnd_1
XFILLER_0_195 vssd1 vssd1 vccd1 vccd1 sky130_fd_sc_hd__fill_1
XTAP_TAPCELL_ROW_59_673 vssd1 vccd1 sky130_fd_sc_hd__tapvpwrvgnd_1
XFILLER_63_103 vssd1 vssd1 vccd1 vccd1 sky130_fd_sc_hd__fill_8
XANTENNA__2654__S _2666_/S vssd1 vssd1 vccd1 vccd1 sky130_fd_sc_hd__diode_2
XFILLER_44_383 vssd1 vssd1 vccd1 vccd1 sky130_fd_sc_hd__fill_1
XFILLER_44_361 vssd1 vssd1 vccd1 vccd1 sky130_fd_sc_hd__fill_1
X_2800_ _2800_/A _2800_/B _2800_/C vssd1 vssd1 vccd1 vccd1 _2800_/X sky130_fd_sc_hd__and3_2
XANTENNA_clkbuf_leaf_14_clk_A clkload4/A vssd1 vssd1 vccd1 vccd1 sky130_fd_sc_hd__diode_2
X_2731_ hold609/X _2845_/A1 _2742_/S vssd1 vssd1 vccd1 vccd1 _3241_/D sky130_fd_sc_hd__mux2_1
X_2662_ hold490/X _2814_/A1 _2662_/S vssd1 vssd1 vccd1 vccd1 _3176_/D sky130_fd_sc_hd__mux2_1
XFILLER_67_3 vssd1 vccd1 vssd1 vccd1 sky130_ef_sc_hd__decap_40_12
XANTENNA__1944__D _1970_/B vssd1 vssd1 vccd1 vccd1 sky130_fd_sc_hd__diode_2
XANTENNA_clkbuf_leaf_29_clk_A clkload3/A vssd1 vssd1 vccd1 vccd1 sky130_fd_sc_hd__diode_2
X_2593_ _1584_/A _3437_/Q _1625_/A _2592_/X vssd1 vssd1 vccd1 vccd1 _2601_/C sky130_fd_sc_hd__o31a_2
X_1613_ _3422_/Q _3416_/Q _1613_/C _2540_/A vssd1 vssd1 vccd1 vccd1 _1617_/A sky130_fd_sc_hd__or4_2
X_1544_ _3388_/Q _3460_/Q _1546_/S vssd1 vssd1 vccd1 vccd1 _3461_/D sky130_fd_sc_hd__mux2_1
XANTENNA__2829__S _2833_/S vssd1 vssd1 vccd1 vccd1 sky130_fd_sc_hd__diode_2
Xfanout219 wire222/A vssd1 vssd1 vccd1 vccd1 fanout219/X sky130_fd_sc_hd__clkdlybuf4s25_1
X_3214_ _3397_/CLK _3214_/D load_slew248/X vssd1 vssd1 vccd1 vccd1 _3214_/Q sky130_fd_sc_hd__dfrtp_2
X_3145_ _3297_/CLK _3145_/D load_slew264/X vssd1 vssd1 vccd1 vccd1 _3145_/Q sky130_fd_sc_hd__dfrtp_2
XFILLER_39_166 vssd1 vssd1 vccd1 vccd1 sky130_fd_sc_hd__fill_2
X_3076_ _3119_/CLK _3076_/D vssd1 vssd1 vccd1 vccd1 _3076_/Q sky130_fd_sc_hd__dfxtp_2
XFILLER_27_328 vssd1 vssd1 vccd1 vccd1 sky130_fd_sc_hd__fill_4
X_2027_ _2029_/A _2005_/C _2029_/C _2029_/D vssd1 vssd1 vccd1 vccd1 _2030_/A sky130_fd_sc_hd__a22oi_2
XANTENNA_fanout259_A fanout290/X vssd1 vssd1 vccd1 vccd1 sky130_fd_sc_hd__diode_2
X_2929_ _3430_/Q _2927_/X _2923_/X _1584_/X vssd1 vssd1 vccd1 vccd1 _2929_/X sky130_fd_sc_hd__a211o_2
XANTENNA_fanout214_X fanout214/X vssd1 vssd1 vccd1 vccd1 sky130_fd_sc_hd__diode_2
XANTENNA__2739__S _2742_/S vssd1 vssd1 vccd1 vccd1 sky130_fd_sc_hd__diode_2
XANTENNA__3031__RESET_B fanout223/X vssd1 vssd1 vccd1 vccd1 sky130_fd_sc_hd__diode_2
XFILLER_73_456 vssd1 vssd1 vccd1 vccd1 sky130_fd_sc_hd__fill_2
XFILLER_45_169 vssd1 vssd1 vccd1 vccd1 sky130_fd_sc_hd__fill_2
XFILLER_41_397 vssd1 vssd1 vccd1 vccd1 sky130_fd_sc_hd__fill_1
XANTENNA__1937__A2 _1962_/B vssd1 vssd1 vccd1 vccd1 sky130_fd_sc_hd__diode_2
XTAP_TAPCELL_ROW_11_267 vssd1 vccd1 sky130_fd_sc_hd__tapvpwrvgnd_1
XFILLER_5_221 vssd1 vssd1 vccd1 vccd1 sky130_fd_sc_hd__fill_2
XANTENNA__2649__S _2666_/S vssd1 vssd1 vccd1 vccd1 sky130_fd_sc_hd__diode_2
XFILLER_49_442 vssd1 vssd1 vccd1 vccd1 sky130_fd_sc_hd__fill_4
XFILLER_1_493 vssd1 vssd1 vccd1 vccd1 sky130_fd_sc_hd__fill_1
XFILLER_39_90 vssd1 vssd1 vccd1 vccd1 sky130_fd_sc_hd__fill_4
XTAP_TAPCELL_ROW_19_334 vssd1 vccd1 sky130_fd_sc_hd__tapvpwrvgnd_1
XFILLER_17_350 vssd1 vccd1 vssd1 vccd1 sky130_ef_sc_hd__decap_40_12
X_2714_ hold507/X _2809_/A1 _2719_/S vssd1 vssd1 vccd1 vccd1 _3225_/D sky130_fd_sc_hd__mux2_1
X_2645_ hold683/X _2817_/A1 _2645_/S vssd1 vssd1 vccd1 vccd1 _3161_/D sky130_fd_sc_hd__mux2_1
XFILLER_10_29 vssd1 vssd1 vccd1 vccd1 sky130_fd_sc_hd__fill_2
XANTENNA__2559__S _2559_/S vssd1 vssd1 vccd1 vccd1 sky130_fd_sc_hd__diode_2
X_2576_ _3010_/Q _2587_/A2 _2587_/B1 hold669/X vssd1 vssd1 vccd1 vccd1 _2576_/X sky130_fd_sc_hd__a22o_2
X_1527_ _3379_/Q _3378_/Q _3377_/Q _3442_/D _3380_/Q vssd1 vssd1 vccd1 vccd1 _1534_/S
+ sky130_fd_sc_hd__a311o_2
XFILLER_67_250 vssd1 vssd1 vccd1 vccd1 sky130_fd_sc_hd__fill_4
X_3128_ _3132_/CLK _3128_/D load_slew220/X vssd1 vssd1 vccd1 vccd1 _3128_/Q sky130_fd_sc_hd__dfrtp_2
XANTENNA_fanout164_X _2004_/B vssd1 vssd1 vccd1 vccd1 sky130_fd_sc_hd__diode_2
X_3059_ _3090_/CLK _3059_/D vssd1 vssd1 vccd1 vccd1 _3059_/Q sky130_fd_sc_hd__dfxtp_2
XTAP_TAPCELL_ROW_53_624 vssd1 vccd1 sky130_fd_sc_hd__tapvpwrvgnd_1
XFILLER_70_404 vssd1 vssd1 vccd1 vccd1 sky130_fd_sc_hd__fill_2
XFILLER_27_169 vssd1 vssd1 vccd1 vccd1 sky130_fd_sc_hd__fill_1
XTAP_TAPCELL_ROW_61_690 vssd1 vccd1 sky130_fd_sc_hd__tapvpwrvgnd_1
XFILLER_51_69 vssd1 vssd1 vccd1 vccd1 sky130_fd_sc_hd__fill_4
XFILLER_2_224 vssd1 vssd1 vccd1 vccd1 sky130_fd_sc_hd__fill_8
XFILLER_76_11 vssd1 vssd1 vccd1 vccd1 sky130_fd_sc_hd__fill_2
XFILLER_18_114 vssd1 vccd1 vssd1 vccd1 sky130_ef_sc_hd__decap_40_12
XTAP_TAPCELL_ROW_16_304 vssd1 vccd1 sky130_fd_sc_hd__tapvpwrvgnd_1
XFILLER_73_286 vssd1 vssd1 vccd1 vccd1 sky130_fd_sc_hd__fill_8
XFILLER_25_70 vssd1 vssd1 vccd1 vccd1 sky130_fd_sc_hd__fill_4
XANTENNA__2583__A2 _1622_/C vssd1 vssd1 vccd1 vccd1 sky130_fd_sc_hd__diode_2
X_2430_ _2959_/B _2957_/C vssd1 vssd1 vccd1 vccd1 _2430_/Y sky130_fd_sc_hd__nor2_2
X_2361_ _2361_/A _2361_/B vssd1 vssd1 vccd1 vccd1 _2363_/B sky130_fd_sc_hd__xnor2_2
X_2292_ _2292_/A _2292_/B vssd1 vssd1 vccd1 vccd1 _2293_/A sky130_fd_sc_hd__nand2_2
XTAP_TAPCELL_ROW_67_738 vssd1 vccd1 sky130_fd_sc_hd__tapvpwrvgnd_1
XFILLER_2_85 vssd1 vssd1 vccd1 vccd1 sky130_fd_sc_hd__fill_1
XFILLER_37_489 vssd1 vssd1 vccd1 vccd1 sky130_fd_sc_hd__fill_4
XFILLER_24_139 vssd1 vssd1 vccd1 vccd1 sky130_fd_sc_hd__fill_1
XANTENNA__2842__S _2856_/S vssd1 vssd1 vccd1 vccd1 sky130_fd_sc_hd__diode_2
X_2628_ _3130_/Q _2646_/B vssd1 vssd1 vccd1 vccd1 _2628_/X sky130_fd_sc_hd__and2_2
X_2559_ hold522/X _2540_/X _2559_/S vssd1 vssd1 vccd1 vccd1 _3113_/D sky130_fd_sc_hd__mux2_1
XTAP_TAPCELL_ROW_38_495 vssd1 vccd1 sky130_fd_sc_hd__tapvpwrvgnd_1
XANTENNA__2752__S _2757_/S vssd1 vssd1 vccd1 vccd1 sky130_fd_sc_hd__diode_2
XFILLER_62_24 vssd1 vssd1 vccd1 vccd1 sky130_fd_sc_hd__fill_2
XFILLER_62_13 vssd1 vssd1 vccd1 vccd1 sky130_fd_sc_hd__fill_1
XFILLER_51_470 vssd1 vssd1 vccd1 vccd1 sky130_fd_sc_hd__fill_1
XFILLER_7_19 vssd1 vssd1 vccd1 vccd1 sky130_fd_sc_hd__fill_2
XTAP_TAPCELL_ROW_21_351 vssd1 vccd1 sky130_fd_sc_hd__tapvpwrvgnd_1
XANTENNA__2565__A2 _2502_/X vssd1 vssd1 vccd1 vccd1 sky130_fd_sc_hd__diode_2
XANTENNA__1773__A0 _2399_/A vssd1 vssd1 vccd1 vccd1 sky130_fd_sc_hd__diode_2
XFILLER_11_94 vssd1 vssd1 vccd1 vccd1 sky130_fd_sc_hd__fill_2
XANTENNA__2317__A2 _2352_/B vssd1 vssd1 vccd1 vccd1 sky130_fd_sc_hd__diode_2
XANTENNA__2228__A _2263_/A vssd1 vssd1 vccd1 vccd1 sky130_fd_sc_hd__diode_2
XTAP_TAPCELL_ROW_64_719 vssd1 vccd1 sky130_fd_sc_hd__tapvpwrvgnd_1
XFILLER_46_253 vssd1 vssd1 vccd1 vccd1 sky130_fd_sc_hd__fill_8
XFILLER_61_223 vssd1 vssd1 vccd1 vccd1 sky130_fd_sc_hd__fill_1
XANTENNA__2662__S _2662_/S vssd1 vssd1 vccd1 vccd1 sky130_fd_sc_hd__diode_2
XANTENNA__2515__X _2515_/X vssd1 vssd1 vccd1 vccd1 sky130_fd_sc_hd__diode_2
X_1930_ _1982_/A _1981_/B _1981_/A vssd1 vssd1 vccd1 vccd1 _1933_/C sky130_fd_sc_hd__a21bo_2
XTAP_TAPCELL_ROW_72_785 vssd1 vccd1 sky130_fd_sc_hd__tapvpwrvgnd_1
X_1861_ _1862_/A _1862_/C _1862_/D _1862_/B vssd1 vssd1 vccd1 vccd1 _1863_/A sky130_fd_sc_hd__a22oi_2
X_1792_ _1792_/A _1807_/A vssd1 vssd1 vccd1 vccd1 _1819_/A sky130_fd_sc_hd__nor2_2
XANTENNA__2961__C1 _1585_/A vssd1 vssd1 vccd1 vccd1 sky130_fd_sc_hd__diode_2
X_3462_ _3463_/CLK _3462_/D load_slew258/X vssd1 vssd1 vccd1 vccd1 _3462_/Q sky130_fd_sc_hd__dfrtp_2
X_3393_ _3393_/CLK _3393_/D load_slew256/X vssd1 vssd1 vccd1 vccd1 _3393_/Q sky130_fd_sc_hd__dfrtp_2
X_2413_ _2399_/C _2398_/Y _2404_/A _2405_/A vssd1 vssd1 vccd1 vccd1 _2414_/A sky130_fd_sc_hd__o211a_2
X_2344_ _2344_/A _2344_/B vssd1 vssd1 vccd1 vccd1 _2345_/B sky130_fd_sc_hd__nor2_2
XFILLER_69_345 vssd1 vssd1 vccd1 vccd1 sky130_fd_sc_hd__fill_2
XANTENNA__2837__S _2837_/S vssd1 vssd1 vccd1 vccd1 sky130_fd_sc_hd__diode_2
X_2275_ _2275_/A _2275_/B vssd1 vssd1 vccd1 vccd1 _2275_/Y sky130_fd_sc_hd__xnor2_2
XFILLER_52_256 vssd1 vssd1 vccd1 vccd1 sky130_fd_sc_hd__fill_1
XFILLER_25_459 vssd1 vssd1 vccd1 vccd1 sky130_fd_sc_hd__fill_4
XANTENNA_fanout241_A fanout242/X vssd1 vssd1 vccd1 vccd1 sky130_fd_sc_hd__diode_2
XFILLER_40_429 vssd1 vssd1 vccd1 vccd1 sky130_fd_sc_hd__fill_1
XANTENNA__2547__A2 _2502_/X vssd1 vssd1 vccd1 vccd1 sky130_fd_sc_hd__diode_2
XANTENNA_fanout127_X _2970_/C vssd1 vssd1 vccd1 vccd1 sky130_fd_sc_hd__diode_2
XFILLER_20_197 vssd1 vssd1 vccd1 vccd1 sky130_fd_sc_hd__fill_1
XANTENNA__1755__A0 _2383_/B vssd1 vssd1 vccd1 vccd1 sky130_fd_sc_hd__diode_2
XANTENNA__2747__S _2757_/S vssd1 vssd1 vccd1 vccd1 sky130_fd_sc_hd__diode_2
XFILLER_75_337 vssd1 vssd1 vccd1 vccd1 sky130_fd_sc_hd__fill_8
XFILLER_57_57 vssd1 vssd1 vccd1 vccd1 sky130_fd_sc_hd__fill_2
XFILLER_73_45 vssd1 vssd1 vccd1 vccd1 sky130_fd_sc_hd__fill_1
XFILLER_24_481 vssd1 vssd1 vccd1 vccd1 sky130_fd_sc_hd__fill_2
XFILLER_24_492 vssd1 vssd1 vccd1 vccd1 sky130_fd_sc_hd__fill_2
XFILLER_7_113 vssd1 vccd1 vssd1 vccd1 sky130_ef_sc_hd__decap_40_12
XFILLER_7_146 vssd1 vssd1 vccd1 vccd1 sky130_fd_sc_hd__fill_4
XANTENNA__1746__A0 _2025_/A vssd1 vssd1 vccd1 vccd1 sky130_fd_sc_hd__diode_2
XFILLER_7_179 vssd1 vssd1 vccd1 vccd1 sky130_fd_sc_hd__fill_1
XFILLER_3_363 vssd1 vssd1 vccd1 vccd1 sky130_fd_sc_hd__fill_1
XFILLER_3_341 vssd1 vssd1 vccd1 vccd1 sky130_fd_sc_hd__fill_1
XANTENNA__2657__S _2662_/S vssd1 vssd1 vccd1 vccd1 sky130_fd_sc_hd__diode_2
X_2060_ _2081_/A _2060_/B vssd1 vssd1 vccd1 vccd1 _2062_/B sky130_fd_sc_hd__nand2_2
XANTENNA__2474__A1 _2611_/A vssd1 vssd1 vccd1 vccd1 sky130_fd_sc_hd__diode_2
XANTENNA__2474__B2 _2800_/A vssd1 vssd1 vccd1 vccd1 sky130_fd_sc_hd__diode_2
XFILLER_74_392 vssd1 vccd1 vssd1 vccd1 sky130_ef_sc_hd__decap_40_12
X_2962_ _2962_/A1 _2956_/X _2960_/X _2973_/A1 _2961_/X vssd1 vssd1 vccd1 vccd1 _2962_/X
+ sky130_fd_sc_hd__a221o_2
X_1913_ _1913_/A _1913_/B vssd1 vssd1 vccd1 vccd1 _1914_/C sky130_fd_sc_hd__xor2_2
XTAP_TAPCELL_ROW_32_446 vssd1 vccd1 sky130_fd_sc_hd__tapvpwrvgnd_1
X_2893_ _2926_/B _2926_/C _3353_/Q vssd1 vssd1 vccd1 vccd1 _2893_/X sky130_fd_sc_hd__and3_2
XFILLER_30_473 vssd1 vssd1 vccd1 vccd1 sky130_fd_sc_hd__fill_1
XANTENNA__2124__C _2352_/C vssd1 vssd1 vccd1 vccd1 sky130_fd_sc_hd__diode_2
X_1844_ _1844_/A _1844_/B vssd1 vssd1 vccd1 vccd1 _1845_/B sky130_fd_sc_hd__nand2_2
Xhold603 _3323_/Q vssd1 vssd1 vccd1 vccd1 hold603/X sky130_fd_sc_hd__dlygate4sd3_1
X_1775_ _3435_/Q _1775_/B vssd1 vssd1 vccd1 vccd1 _1775_/Y sky130_fd_sc_hd__nand2_2
Xhold636 _3183_/Q vssd1 vssd1 vccd1 vccd1 hold636/X sky130_fd_sc_hd__dlygate4sd3_1
Xhold625 _3116_/Q vssd1 vssd1 vccd1 vccd1 hold625/X sky130_fd_sc_hd__dlygate4sd3_1
Xhold614 _3181_/Q vssd1 vssd1 vccd1 vccd1 hold614/X sky130_fd_sc_hd__dlygate4sd3_1
X_3445_ _3453_/CLK _3445_/D fanout270/X vssd1 vssd1 vccd1 vccd1 _3445_/Q sky130_fd_sc_hd__dfrtp_2
Xhold669 _3128_/Q vssd1 vssd1 vccd1 vccd1 hold669/X sky130_fd_sc_hd__dlygate4sd3_1
Xhold658 _3006_/Q vssd1 vssd1 vccd1 vccd1 hold658/X sky130_fd_sc_hd__dlygate4sd3_1
Xhold647 _3146_/Q vssd1 vssd1 vccd1 vccd1 hold647/X sky130_fd_sc_hd__dlygate4sd3_1
X_3376_ _2999_/Y _3376_/D load_slew286/X vssd1 vssd1 vccd1 vccd1 _3452_/D sky130_fd_sc_hd__dfrtp_2
X_2327_ _2327_/A _2327_/B _2327_/C vssd1 vssd1 vccd1 vccd1 _2330_/B sky130_fd_sc_hd__nand3_2
XFILLER_69_175 vssd1 vccd1 vssd1 vccd1 sky130_ef_sc_hd__decap_40_12
XANTENNA_fanout289_A fanout290/X vssd1 vssd1 vccd1 vccd1 sky130_fd_sc_hd__diode_2
X_2258_ _2258_/A _2258_/B _2258_/C vssd1 vssd1 vccd1 vccd1 _2261_/B sky130_fd_sc_hd__nand3_2
XFILLER_72_307 vssd1 vssd1 vccd1 vccd1 sky130_fd_sc_hd__fill_1
X_2189_ _2188_/B _2188_/C _2188_/A vssd1 vssd1 vccd1 vccd1 _2190_/B sky130_fd_sc_hd__a21o_2
XFILLER_13_418 vssd1 vssd1 vccd1 vccd1 sky130_fd_sc_hd__fill_1
XANTENNA__2050__B _2073_/C vssd1 vssd1 vccd1 vccd1 sky130_fd_sc_hd__diode_2
XTAP_TAPCELL_ROW_74_803 vssd1 vccd1 sky130_fd_sc_hd__tapvpwrvgnd_1
XFILLER_31_215 vssd1 vssd1 vccd1 vccd1 sky130_fd_sc_hd__fill_1
XFILLER_16_267 vssd1 vccd1 vssd1 vccd1 sky130_ef_sc_hd__decap_40_12
XFILLER_8_400 vssd1 vssd1 vccd1 vccd1 sky130_fd_sc_hd__fill_1
X_1560_ _3143_/Q _1603_/A _3142_/Q vssd1 vssd1 vccd1 vccd1 _1572_/B sky130_fd_sc_hd__and3b_2
X_3230_ _3302_/CLK _3230_/D load_slew276/X vssd1 vssd1 vccd1 vccd1 _3230_/Q sky130_fd_sc_hd__dfrtp_2
X_3161_ _3359_/CLK _3161_/D fanout235/X vssd1 vssd1 vccd1 vccd1 _3161_/Q sky130_fd_sc_hd__dfrtp_2
XFILLER_66_101 vssd1 vssd1 vccd1 vccd1 sky130_fd_sc_hd__fill_2
X_2112_ _2112_/A _2126_/A vssd1 vssd1 vccd1 vccd1 _2138_/A sky130_fd_sc_hd__nor2_2
XFILLER_12_3 vssd1 vssd1 vccd1 vccd1 sky130_fd_sc_hd__fill_4
X_3092_ clkload8/A _3092_/D load_slew210/X vssd1 vssd1 vccd1 vccd1 _3092_/Q sky130_fd_sc_hd__dfrtp_2
X_2043_ _2043_/A _2043_/B vssd1 vssd1 vccd1 vccd1 _2045_/C sky130_fd_sc_hd__nor2_2
XFILLER_66_189 vssd1 vssd1 vccd1 vccd1 sky130_fd_sc_hd__fill_4
Xfanout19 _2762_/X vssd1 vssd1 vccd1 vccd1 _2780_/S sky130_fd_sc_hd__clkdlybuf4s25_1
X_2945_ _3268_/Q _2971_/A2 _2971_/B1 _3250_/Q _2944_/X vssd1 vssd1 vccd1 vccd1 _2945_/X
+ sky130_fd_sc_hd__a221o_2
XANTENNA__2850__S _2856_/S vssd1 vssd1 vccd1 vccd1 sky130_fd_sc_hd__diode_2
X_2876_ _2966_/A1 _3154_/Q _3298_/Q _2942_/B2 vssd1 vssd1 vccd1 vccd1 _2876_/X sky130_fd_sc_hd__a22o_2
XFILLER_30_281 vssd1 vssd1 vccd1 vccd1 sky130_fd_sc_hd__fill_1
X_1827_ _1827_/A _1827_/B vssd1 vssd1 vccd1 vccd1 _1844_/A sky130_fd_sc_hd__or2_2
Xhold400 _3358_/Q vssd1 vssd1 vccd1 vccd1 hold400/X sky130_fd_sc_hd__dlygate4sd3_1
Xhold411 _3281_/Q vssd1 vssd1 vccd1 vccd1 hold411/X sky130_fd_sc_hd__dlygate4sd3_1
Xhold422 _3215_/Q vssd1 vssd1 vccd1 vccd1 hold422/X sky130_fd_sc_hd__dlygate4sd3_1
Xhold433 _3276_/Q vssd1 vssd1 vccd1 vccd1 hold433/X sky130_fd_sc_hd__dlygate4sd3_1
Xhold444 _3386_/Q vssd1 vssd1 vccd1 vccd1 hold444/X sky130_fd_sc_hd__dlygate4sd3_1
X_1758_ _1906_/A hold435/X _3435_/D vssd1 vssd1 vccd1 vccd1 _3038_/D sky130_fd_sc_hd__mux2_1
XANTENNA__2922__A2 _2972_/A1 vssd1 vssd1 vccd1 vccd1 sky130_fd_sc_hd__diode_2
Xhold455 _3271_/Q vssd1 vssd1 vccd1 vccd1 hold455/X sky130_fd_sc_hd__dlygate4sd3_1
Xhold466 _3112_/Q vssd1 vssd1 vccd1 vccd1 hold466/X sky130_fd_sc_hd__dlygate4sd3_1
Xhold477 _3327_/Q vssd1 vssd1 vccd1 vccd1 hold477/X sky130_fd_sc_hd__dlygate4sd3_1
X_1689_ _1689_/A _1689_/B vssd1 vssd1 vccd1 vccd1 _1689_/Y sky130_fd_sc_hd__xnor2_2
X_3428_ _3429_/CLK _3428_/D load_slew225/X vssd1 vssd1 vccd1 vccd1 _3428_/Q sky130_fd_sc_hd__dfrtp_2
Xhold499 _3330_/Q vssd1 vssd1 vccd1 vccd1 hold499/X sky130_fd_sc_hd__dlygate4sd3_1
Xhold488 _3118_/Q vssd1 vssd1 vccd1 vccd1 hold488/X sky130_fd_sc_hd__dlygate4sd3_1
X_3359_ _3359_/CLK _3359_/D fanout233/X vssd1 vssd1 vccd1 vccd1 _3359_/Q sky130_fd_sc_hd__dfrtp_2
XANTENNA__2029__C _2029_/C vssd1 vssd1 vccd1 vccd1 sky130_fd_sc_hd__diode_2
XFILLER_72_137 vssd1 vssd1 vccd1 vccd1 sky130_fd_sc_hd__fill_2
XTAP_TAPCELL_ROW_0_163 vssd1 vccd1 sky130_fd_sc_hd__tapvpwrvgnd_1
XANTENNA__2326__A _2399_/B vssd1 vssd1 vccd1 vccd1 sky130_fd_sc_hd__diode_2
XTAP_TAPCELL_ROW_0_174 vssd1 vccd1 sky130_fd_sc_hd__tapvpwrvgnd_1
XFILLER_53_395 vssd1 vssd1 vccd1 vccd1 sky130_fd_sc_hd__fill_1
XFILLER_9_219 vssd1 vssd1 vccd1 vccd1 sky130_fd_sc_hd__fill_2
XANTENNA__2760__S _2761_/S vssd1 vssd1 vccd1 vccd1 sky130_fd_sc_hd__diode_2
XFILLER_21_281 vssd1 vssd1 vccd1 vccd1 sky130_fd_sc_hd__fill_4
XFILLER_5_447 vssd1 vssd1 vccd1 vccd1 sky130_fd_sc_hd__fill_1
XTAP_TAPCELL_ROW_8_241 vssd1 vccd1 sky130_fd_sc_hd__tapvpwrvgnd_1
XFILLER_0_130 vssd1 vssd1 vccd1 vccd1 sky130_fd_sc_hd__fill_1
XFILLER_0_141 vssd1 vccd1 vssd1 vccd1 sky130_ef_sc_hd__decap_40_12
XTAP_TAPCELL_ROW_59_674 vssd1 vccd1 sky130_fd_sc_hd__tapvpwrvgnd_1
XFILLER_36_307 vssd1 vssd1 vccd1 vccd1 sky130_fd_sc_hd__fill_1
XANTENNA__2429__B2 _2533_/B vssd1 vssd1 vccd1 vccd1 sky130_fd_sc_hd__diode_2
XFILLER_29_381 vssd1 vssd1 vccd1 vccd1 sky130_fd_sc_hd__fill_2
XFILLER_28_81 vssd1 vssd1 vccd1 vccd1 sky130_fd_sc_hd__fill_2
XTAP_TAPCELL_ROW_42_530 vssd1 vccd1 sky130_fd_sc_hd__tapvpwrvgnd_1
XANTENNA__2670__S _2681_/S vssd1 vssd1 vccd1 vccd1 sky130_fd_sc_hd__diode_2
X_2730_ hold500/X _2844_/A1 _2742_/S vssd1 vssd1 vccd1 vccd1 _3240_/D sky130_fd_sc_hd__mux2_1
XTAP_TAPCELL_ROW_14_287 vssd1 vccd1 sky130_fd_sc_hd__tapvpwrvgnd_1
X_2661_ hold468/X _2813_/A1 _2666_/S vssd1 vssd1 vccd1 vccd1 _3175_/D sky130_fd_sc_hd__mux2_1
X_1612_ _3440_/Q _1611_/Y _3420_/Q vssd1 vssd1 vccd1 vccd1 _1612_/Y sky130_fd_sc_hd__o21ai_2
X_2592_ _1584_/A _1583_/A _2589_/X _2591_/X vssd1 vssd1 vccd1 vccd1 _2592_/X sky130_fd_sc_hd__o31a_2
X_1543_ _3387_/Q _3459_/Q _1546_/S vssd1 vssd1 vccd1 vccd1 _3460_/D sky130_fd_sc_hd__mux2_1
Xfanout209 fanout213/X vssd1 vssd1 vccd1 vccd1 fanout209/X sky130_fd_sc_hd__clkdlybuf4s25_1
X_3213_ _3359_/CLK _3213_/D load_slew244/X vssd1 vssd1 vccd1 vccd1 _3213_/Q sky130_fd_sc_hd__dfrtp_2
XFILLER_79_281 vssd1 vccd1 vssd1 vccd1 sky130_ef_sc_hd__decap_40_12
X_3144_ _3441_/CLK _3144_/D vssd1 vssd1 vccd1 vccd1 _3144_/Q sky130_fd_sc_hd__dfxtp_2
XANTENNA__1602__X _1602_/X vssd1 vssd1 vccd1 vccd1 sky130_fd_sc_hd__diode_2
XANTENNA__2845__S _2856_/S vssd1 vssd1 vccd1 vccd1 sky130_fd_sc_hd__diode_2
X_3075_ _3132_/CLK _3075_/D vssd1 vssd1 vccd1 vccd1 _3075_/Q sky130_fd_sc_hd__dfxtp_2
XFILLER_39_178 vssd1 vssd1 vccd1 vccd1 sky130_fd_sc_hd__fill_2
XFILLER_27_318 vssd1 vssd1 vccd1 vccd1 sky130_fd_sc_hd__fill_2
X_2026_ _2026_/A _2056_/A vssd1 vssd1 vccd1 vccd1 _2063_/A sky130_fd_sc_hd__or2_2
X_2928_ _2972_/A1 _2921_/X _2925_/X _2972_/B2 vssd1 vssd1 vccd1 vccd1 _2928_/X sky130_fd_sc_hd__a22o_2
X_2859_ hold458/X _2477_/B _3437_/D vssd1 vssd1 vccd1 vccd1 _3383_/D sky130_fd_sc_hd__mux2_1
XTAP_TAPCELL_ROW_5_211 vssd1 vccd1 sky130_fd_sc_hd__tapvpwrvgnd_1
XANTENNA_fanout67_A _2901_/B1 vssd1 vssd1 vccd1 vccd1 sky130_fd_sc_hd__diode_2
XANTENNA__2755__S _2761_/S vssd1 vssd1 vccd1 vccd1 sky130_fd_sc_hd__diode_2
XFILLER_65_57 vssd1 vccd1 vssd1 vccd1 sky130_ef_sc_hd__decap_40_12
XTAP_TAPCELL_ROW_56_644 vssd1 vccd1 sky130_fd_sc_hd__tapvpwrvgnd_1
XANTENNA_fanout22_X _2757_/S vssd1 vssd1 vccd1 vccd1 sky130_fd_sc_hd__diode_2
XFILLER_14_83 vssd1 vssd1 vccd1 vccd1 sky130_fd_sc_hd__fill_1
XTAP_TAPCELL_ROW_11_268 vssd1 vccd1 sky130_fd_sc_hd__tapvpwrvgnd_1
XANTENNA__2898__A1 _2962_/A1 vssd1 vssd1 vccd1 vccd1 sky130_fd_sc_hd__diode_2
XANTENNA__2898__B2 _2961_/A1 vssd1 vssd1 vccd1 vccd1 sky130_fd_sc_hd__diode_2
XFILLER_76_251 vssd1 vssd1 vccd1 vccd1 sky130_fd_sc_hd__fill_1
XANTENNA__2665__S _2666_/S vssd1 vssd1 vccd1 vccd1 sky130_fd_sc_hd__diode_2
XFILLER_49_487 vssd1 vssd1 vccd1 vccd1 sky130_fd_sc_hd__fill_4
XTAP_TAPCELL_ROW_19_335 vssd1 vccd1 sky130_fd_sc_hd__tapvpwrvgnd_1
XFILLER_17_362 vssd1 vssd1 vccd1 vccd1 sky130_fd_sc_hd__fill_2
X_2713_ hold565/X _2808_/A1 _2719_/S vssd1 vssd1 vccd1 vccd1 _3224_/D sky130_fd_sc_hd__mux2_1
X_2644_ _3138_/Q _2644_/B vssd1 vssd1 vccd1 vccd1 _2644_/X sky130_fd_sc_hd__and2_2
X_2575_ hold558/X _2587_/A2 _2587_/B1 _3127_/Q vssd1 vssd1 vccd1 vccd1 _2575_/X sky130_fd_sc_hd__a22o_2
X_1526_ _3379_/Q input3/X _1515_/A _3453_/D vssd1 vssd1 vccd1 vccd1 _3368_/D sky130_fd_sc_hd__a31o_2
XFILLER_19_17 vssd1 vssd1 vccd1 vccd1 sky130_fd_sc_hd__fill_1
XANTENNA__2510__B1 _2901_/B1 vssd1 vssd1 vccd1 vccd1 sky130_fd_sc_hd__diode_2
XANTENNA_fanout271_A fanout290/X vssd1 vssd1 vccd1 vccd1 sky130_fd_sc_hd__diode_2
X_3127_ _3199_/CLK _3127_/D load_slew220/X vssd1 vssd1 vccd1 vccd1 _3127_/Q sky130_fd_sc_hd__dfrtp_2
X_3058_ _3090_/CLK _3058_/D vssd1 vssd1 vccd1 vccd1 _3058_/Q sky130_fd_sc_hd__dfxtp_2
XFILLER_42_107 vssd1 vssd1 vccd1 vccd1 sky130_fd_sc_hd__fill_2
XFILLER_35_49 vssd1 vssd1 vccd1 vccd1 sky130_fd_sc_hd__fill_2
XANTENNA_fanout157_X _1979_/B vssd1 vssd1 vccd1 vccd1 sky130_fd_sc_hd__diode_2
X_2009_ _2009_/A _2009_/B vssd1 vssd1 vccd1 vccd1 _2010_/B sky130_fd_sc_hd__xnor2_2
XTAP_TAPCELL_ROW_53_625 vssd1 vccd1 sky130_fd_sc_hd__tapvpwrvgnd_1
XTAP_TAPCELL_ROW_61_691 vssd1 vccd1 sky130_fd_sc_hd__tapvpwrvgnd_1
XANTENNA__1865__D _1970_/B vssd1 vssd1 vccd1 vccd1 sky130_fd_sc_hd__diode_2
XANTENNA_clkbuf_leaf_13_clk_A clkload4/A vssd1 vssd1 vccd1 vccd1 sky130_fd_sc_hd__diode_2
XFILLER_76_89 vssd1 vssd1 vccd1 vccd1 sky130_fd_sc_hd__fill_1
XFILLER_18_148 vssd1 vssd1 vccd1 vccd1 sky130_fd_sc_hd__fill_4
XFILLER_18_126 vssd1 vssd1 vccd1 vccd1 sky130_fd_sc_hd__fill_4
XTAP_TAPCELL_ROW_16_305 vssd1 vccd1 sky130_fd_sc_hd__tapvpwrvgnd_1
XFILLER_73_254 vssd1 vssd1 vccd1 vccd1 sky130_fd_sc_hd__fill_2
XANTENNA_clkbuf_leaf_28_clk_A clkload3/A vssd1 vssd1 vccd1 vccd1 sky130_fd_sc_hd__diode_2
XFILLER_51_7 vssd1 vssd1 vccd1 vccd1 sky130_fd_sc_hd__fill_1
XANTENNA_load_slew78_X _2971_/A2 vssd1 vssd1 vccd1 vccd1 sky130_fd_sc_hd__diode_2
X_2360_ _2360_/A _2360_/B vssd1 vssd1 vccd1 vccd1 _2361_/B sky130_fd_sc_hd__nor2_2
X_2291_ _2291_/A _2291_/B vssd1 vssd1 vccd1 vccd1 _2292_/B sky130_fd_sc_hd__nand2_2
XPHY_EDGE_ROW_10_Right_10 vssd1 vssd1 vccd1 vccd1 sky130_fd_sc_hd__decap_3
XTAP_TAPCELL_ROW_67_739 vssd1 vccd1 sky130_fd_sc_hd__tapvpwrvgnd_1
XFILLER_60_493 vssd1 vssd1 vccd1 vccd1 sky130_fd_sc_hd__fill_1
XFILLER_32_195 vssd1 vssd1 vccd1 vccd1 sky130_fd_sc_hd__fill_1
XFILLER_9_391 vssd1 vssd1 vccd1 vccd1 sky130_fd_sc_hd__fill_1
XANTENNA_fanout117_A _2972_/B2 vssd1 vssd1 vccd1 vccd1 sky130_fd_sc_hd__diode_2
X_2627_ hold703/X _2808_/A1 _2647_/S vssd1 vssd1 vccd1 vccd1 _3152_/D sky130_fd_sc_hd__mux2_1
X_2558_ hold466/X _2528_/X _2559_/S vssd1 vssd1 vccd1 vccd1 _3112_/D sky130_fd_sc_hd__mux2_1
X_2489_ _2540_/A _2489_/B vssd1 vssd1 vccd1 vccd1 _2489_/X sky130_fd_sc_hd__and2_2
X_1509_ _3378_/Q _1509_/B vssd1 vssd1 vccd1 vccd1 _1515_/A sky130_fd_sc_hd__and2_2
XTAP_TAPCELL_ROW_38_496 vssd1 vccd1 sky130_fd_sc_hd__tapvpwrvgnd_1
XFILLER_15_129 vssd1 vssd1 vccd1 vccd1 sky130_fd_sc_hd__fill_2
Xclkbuf_leaf_35_clk clkbuf_3_4__f_clk/X vssd1 vssd1 vccd1 vccd1 _3387_/CLK sky130_fd_sc_hd__clkbuf_8
XTAP_TAPCELL_ROW_21_352 vssd1 vccd1 sky130_fd_sc_hd__tapvpwrvgnd_1
XANTENNA__2509__A _2900_/A vssd1 vssd1 vccd1 vccd1 sky130_fd_sc_hd__diode_2
XFILLER_34_427 vssd1 vssd1 vccd1 vccd1 sky130_fd_sc_hd__fill_1
Xclkbuf_leaf_26_clk clkload3/A vssd1 vssd1 vccd1 vccd1 _3352_/CLK sky130_fd_sc_hd__clkbuf_8
XFILLER_61_246 vssd1 vssd1 vccd1 vccd1 sky130_fd_sc_hd__fill_1
XTAP_TAPCELL_ROW_72_786 vssd1 vccd1 sky130_fd_sc_hd__tapvpwrvgnd_1
X_1860_ _1859_/B _1859_/C _1859_/A vssd1 vssd1 vccd1 vccd1 _1873_/B sky130_fd_sc_hd__o21ai_2
X_1791_ _1906_/A _1813_/A _1862_/C _1862_/D vssd1 vssd1 vccd1 vccd1 _1807_/A sky130_fd_sc_hd__and4_2
X_3461_ _3463_/CLK _3461_/D fanout241/X vssd1 vssd1 vccd1 vccd1 _3461_/Q sky130_fd_sc_hd__dfrtp_2
X_3392_ _3392_/CLK _3392_/D load_slew253/X vssd1 vssd1 vccd1 vccd1 _3392_/Q sky130_fd_sc_hd__dfrtp_2
X_2412_ hold487/X _2411_/Y _2412_/S vssd1 vssd1 vccd1 vccd1 _3084_/D sky130_fd_sc_hd__mux2_1
X_2343_ _2343_/A _2343_/B vssd1 vssd1 vccd1 vccd1 _2344_/B sky130_fd_sc_hd__and2_2
XANTENNA_clkbuf_3_6__f_clk_A clkbuf_0_clk/X vssd1 vssd1 vccd1 vccd1 sky130_fd_sc_hd__diode_2
X_2274_ _2237_/X _2241_/B _2239_/B vssd1 vssd1 vccd1 vccd1 _2275_/B sky130_fd_sc_hd__o21a_2
XANTENNA__2492__A2 _2960_/A2 vssd1 vssd1 vccd1 vccd1 sky130_fd_sc_hd__diode_2
XANTENNA__2853__S _2856_/S vssd1 vssd1 vccd1 vccd1 sky130_fd_sc_hd__diode_2
XFILLER_52_224 vssd1 vssd1 vccd1 vccd1 sky130_fd_sc_hd__fill_1
XFILLER_16_29 vssd1 vssd1 vccd1 vccd1 sky130_fd_sc_hd__fill_4
Xclkbuf_leaf_17_clk clkload5/A vssd1 vssd1 vccd1 vccd1 _3453_/CLK sky130_fd_sc_hd__clkbuf_8
XTAP_TAPCELL_ROW_35_466 vssd1 vccd1 sky130_fd_sc_hd__tapvpwrvgnd_1
XFILLER_40_419 vssd1 vssd1 vccd1 vccd1 sky130_fd_sc_hd__fill_1
XFILLER_33_460 vssd1 vssd1 vccd1 vccd1 sky130_fd_sc_hd__fill_1
XANTENNA__2154__A _2263_/A vssd1 vssd1 vccd1 vccd1 sky130_fd_sc_hd__diode_2
XFILLER_20_165 vssd1 vssd1 vccd1 vccd1 sky130_fd_sc_hd__fill_1
XFILLER_20_143 vssd1 vccd1 vssd1 vccd1 sky130_ef_sc_hd__decap_40_12
X_1989_ _1989_/A _1989_/B vssd1 vssd1 vccd1 vccd1 _1991_/B sky130_fd_sc_hd__or2_2
XANTENNA__2180__B2 _2326_/B vssd1 vssd1 vccd1 vccd1 sky130_fd_sc_hd__diode_2
XFILLER_75_327 vssd1 vssd1 vccd1 vccd1 sky130_fd_sc_hd__fill_1
XANTENNA__2763__S _2780_/S vssd1 vssd1 vccd1 vccd1 sky130_fd_sc_hd__diode_2
XFILLER_73_57 vssd1 vccd1 vssd1 vccd1 sky130_ef_sc_hd__decap_40_12
XFILLER_43_268 vssd1 vssd1 vccd1 vccd1 sky130_fd_sc_hd__fill_1
XFILLER_43_279 vssd1 vssd1 vccd1 vccd1 sky130_fd_sc_hd__fill_1
XFILLER_22_61 vssd1 vssd1 vccd1 vccd1 sky130_fd_sc_hd__fill_2
XFILLER_11_198 vssd1 vccd1 vssd1 vccd1 sky130_ef_sc_hd__decap_40_12
XANTENNA__2511__B _2957_/C vssd1 vssd1 vccd1 vccd1 sky130_fd_sc_hd__diode_2
XFILLER_3_397 vssd1 vssd1 vccd1 vccd1 sky130_fd_sc_hd__fill_1
XTAP_TAPCELL_ROW_77_823 vssd1 vccd1 sky130_fd_sc_hd__tapvpwrvgnd_1
XFILLER_14_7 vssd1 vssd1 vccd1 vccd1 sky130_fd_sc_hd__fill_2
XFILLER_74_360 vssd1 vssd1 vccd1 vccd1 sky130_fd_sc_hd__fill_1
XANTENNA__2673__S _2685_/S vssd1 vssd1 vccd1 vccd1 sky130_fd_sc_hd__diode_2
XFILLER_74_382 vssd1 vssd1 vccd1 vccd1 sky130_fd_sc_hd__fill_1
XFILLER_74_371 vssd1 vssd1 vccd1 vccd1 sky130_fd_sc_hd__fill_2
XFILLER_34_224 vssd1 vssd1 vccd1 vccd1 sky130_fd_sc_hd__fill_1
X_2961_ _2961_/A1 _2958_/X _2954_/X _1585_/A vssd1 vssd1 vccd1 vccd1 _2961_/X sky130_fd_sc_hd__a211o_2
XFILLER_22_419 vssd1 vssd1 vccd1 vccd1 sky130_fd_sc_hd__fill_1
XFILLER_15_471 vssd1 vssd1 vccd1 vccd1 sky130_fd_sc_hd__fill_2
X_1912_ _1912_/A _1912_/B vssd1 vssd1 vccd1 vccd1 _1913_/B sky130_fd_sc_hd__xnor2_2
XTAP_TAPCELL_ROW_32_447 vssd1 vccd1 sky130_fd_sc_hd__tapvpwrvgnd_1
XFILLER_63_90 vssd1 vssd1 vccd1 vccd1 sky130_fd_sc_hd__fill_8
XFILLER_30_430 vssd1 vssd1 vccd1 vccd1 sky130_fd_sc_hd__fill_2
X_2892_ _3191_/Q _2894_/A2 _2894_/B1 _3173_/Q _2891_/X vssd1 vssd1 vccd1 vccd1 _2892_/X
+ sky130_fd_sc_hd__a221o_2
XFILLER_8_41 vssd1 vccd1 vssd1 vccd1 sky130_ef_sc_hd__decap_40_12
X_1843_ _1844_/A _1844_/B vssd1 vssd1 vccd1 vccd1 _1879_/A sky130_fd_sc_hd__or2_2
XFILLER_8_85 vssd1 vssd1 vccd1 vccd1 sky130_fd_sc_hd__fill_1
X_1774_ input5/X input1/X _3435_/Q vssd1 vssd1 vccd1 vccd1 _2313_/S sky130_fd_sc_hd__and3_2
XANTENNA__2421__B _2421_/B vssd1 vssd1 vccd1 vccd1 sky130_fd_sc_hd__diode_2
XANTENNA__2934__B1 _2971_/B1 vssd1 vssd1 vccd1 vccd1 sky130_fd_sc_hd__diode_2
Xhold626 _3309_/Q vssd1 vssd1 vccd1 vccd1 hold626/X sky130_fd_sc_hd__dlygate4sd3_1
Xhold615 _3325_/Q vssd1 vssd1 vccd1 vccd1 hold615/X sky130_fd_sc_hd__dlygate4sd3_1
Xhold604 _3206_/Q vssd1 vssd1 vccd1 vccd1 hold604/X sky130_fd_sc_hd__dlygate4sd3_1
X_3444_ _3472_/CLK _3444_/D _3472_/SET_B vssd1 vssd1 vccd1 vccd1 _3444_/Q sky130_fd_sc_hd__dfrtp_2
Xclkbuf_leaf_6_clk clkload1/A vssd1 vssd1 vccd1 vccd1 _3101_/CLK sky130_fd_sc_hd__clkbuf_8
Xhold659 _3121_/Q vssd1 vssd1 vccd1 vccd1 hold659/X sky130_fd_sc_hd__dlygate4sd3_1
Xhold648 _3293_/Q vssd1 vssd1 vccd1 vccd1 hold648/X sky130_fd_sc_hd__dlygate4sd3_1
Xhold637 _3189_/Q vssd1 vssd1 vccd1 vccd1 hold637/X sky130_fd_sc_hd__dlygate4sd3_1
XANTENNA__2848__S _2852_/S vssd1 vssd1 vccd1 vccd1 sky130_fd_sc_hd__diode_2
XANTENNA__1752__S _1773_/S vssd1 vssd1 vccd1 vccd1 sky130_fd_sc_hd__diode_2
X_3375_ _2998_/Y _3375_/D load_slew288/X vssd1 vssd1 vccd1 vccd1 _3451_/D sky130_fd_sc_hd__dfrtp_2
X_2326_ _2399_/B _2326_/B vssd1 vssd1 vccd1 vccd1 _2327_/C sky130_fd_sc_hd__nand2_2
X_2257_ _2257_/A _2257_/B vssd1 vssd1 vccd1 vccd1 _2258_/C sky130_fd_sc_hd__nand2_2
XFILLER_69_187 vssd1 vssd1 vccd1 vccd1 sky130_fd_sc_hd__fill_1
X_2188_ _2188_/A _2188_/B _2188_/C vssd1 vssd1 vccd1 vccd1 _2190_/A sky130_fd_sc_hd__nand3_2
XTAP_TAPCELL_ROW_48_580 vssd1 vccd1 sky130_fd_sc_hd__tapvpwrvgnd_1
XFILLER_43_49 vssd1 vssd1 vccd1 vccd1 sky130_fd_sc_hd__fill_4
XFILLER_40_249 vssd1 vssd1 vccd1 vccd1 sky130_fd_sc_hd__fill_2
XFILLER_4_139 vssd1 vssd1 vccd1 vccd1 sky130_fd_sc_hd__fill_1
XFILLER_4_117 vssd1 vccd1 vssd1 vccd1 sky130_ef_sc_hd__decap_40_12
XANTENNA_fanout97_A _2421_/B vssd1 vssd1 vccd1 vccd1 sky130_fd_sc_hd__diode_2
XANTENNA__2758__S _2761_/S vssd1 vssd1 vccd1 vccd1 sky130_fd_sc_hd__diode_2
XFILLER_68_57 vssd1 vssd1 vccd1 vccd1 sky130_fd_sc_hd__fill_8
XFILLER_48_305 vssd1 vssd1 vccd1 vccd1 sky130_fd_sc_hd__fill_2
XFILLER_0_367 vssd1 vssd1 vccd1 vccd1 sky130_fd_sc_hd__fill_1
XFILLER_75_113 vssd1 vccd1 vssd1 vccd1 sky130_ef_sc_hd__decap_40_12
XTAP_TAPCELL_ROW_74_804 vssd1 vccd1 sky130_fd_sc_hd__tapvpwrvgnd_1
XANTENNA__2456__A2 _2894_/A2 vssd1 vssd1 vccd1 vccd1 sky130_fd_sc_hd__diode_2
XTAP_TAPCELL_ROW_3_194 vssd1 vccd1 sky130_fd_sc_hd__tapvpwrvgnd_1
XFILLER_71_341 vssd1 vssd1 vccd1 vccd1 sky130_fd_sc_hd__fill_1
XFILLER_71_363 vssd1 vssd1 vccd1 vccd1 sky130_fd_sc_hd__fill_2
XFILLER_12_485 vssd1 vssd1 vccd1 vccd1 sky130_fd_sc_hd__fill_8
XANTENNA__1783__D _1962_/B vssd1 vssd1 vccd1 vccd1 sky130_fd_sc_hd__diode_2
XFILLER_3_150 vssd1 vssd1 vccd1 vccd1 sky130_fd_sc_hd__fill_1
XANTENNA__2668__S _2685_/S vssd1 vssd1 vccd1 vccd1 sky130_fd_sc_hd__diode_2
X_3160_ _3395_/CLK _3160_/D load_slew246/X vssd1 vssd1 vccd1 vccd1 _3160_/Q sky130_fd_sc_hd__dfrtp_2
X_3091_ clkload8/A _3091_/D wire208/X vssd1 vssd1 vccd1 vccd1 _3091_/Q sky130_fd_sc_hd__dfrtp_2
X_2111_ _2132_/A _2154_/B _2146_/B _2146_/C vssd1 vssd1 vccd1 vccd1 _2126_/A sky130_fd_sc_hd__and4_2
X_2042_ _2063_/A _2042_/B vssd1 vssd1 vccd1 vccd1 _2045_/B sky130_fd_sc_hd__xor2_2
XFILLER_47_393 vssd1 vssd1 vccd1 vccd1 sky130_fd_sc_hd__fill_4
XPHY_EDGE_ROW_8_Right_8 vssd1 vssd1 vccd1 vccd1 sky130_fd_sc_hd__decap_3
XFILLER_22_238 vssd1 vssd1 vccd1 vccd1 sky130_fd_sc_hd__fill_1
X_2944_ _3286_/Q _2970_/B _2970_/C vssd1 vssd1 vccd1 vccd1 _2944_/X sky130_fd_sc_hd__and3_2
XANTENNA__1747__S _3435_/D vssd1 vssd1 vccd1 vccd1 sky130_fd_sc_hd__diode_2
X_2875_ hold726/X _3437_/D _2869_/X _2874_/X vssd1 vssd1 vccd1 vccd1 _3389_/D sky130_fd_sc_hd__o22a_2
X_1826_ _1824_/A _1823_/B _1821_/Y vssd1 vssd1 vccd1 vccd1 _1847_/A sky130_fd_sc_hd__a21o_2
Xhold401 _3286_/Q vssd1 vssd1 vccd1 vccd1 hold401/X sky130_fd_sc_hd__dlygate4sd3_1
Xhold412 _3448_/Q vssd1 vssd1 vccd1 vccd1 hold412/X sky130_fd_sc_hd__dlygate4sd3_1
Xhold423 _3384_/Q vssd1 vssd1 vccd1 vccd1 hold423/X sky130_fd_sc_hd__dlygate4sd3_1
Xhold434 _3095_/Q vssd1 vssd1 vccd1 vccd1 hold434/X sky130_fd_sc_hd__dlygate4sd3_1
Xhold445 _3273_/Q vssd1 vssd1 vccd1 vccd1 hold445/X sky130_fd_sc_hd__dlygate4sd3_1
X_1757_ _2399_/B hold593/X _1773_/S vssd1 vssd1 vccd1 vccd1 _3037_/D sky130_fd_sc_hd__mux2_1
Xhold456 _3283_/Q vssd1 vssd1 vccd1 vccd1 hold456/X sky130_fd_sc_hd__dlygate4sd3_1
Xhold467 _3230_/Q vssd1 vssd1 vccd1 vccd1 hold467/X sky130_fd_sc_hd__dlygate4sd3_1
Xhold478 _3220_/Q vssd1 vssd1 vccd1 vccd1 hold478/X sky130_fd_sc_hd__dlygate4sd3_1
X_1688_ _1688_/A _1688_/B vssd1 vssd1 vccd1 vccd1 _1689_/B sky130_fd_sc_hd__nor2_2
XFILLER_1_109 vssd1 vssd1 vccd1 vccd1 sky130_fd_sc_hd__fill_1
X_3427_ _3429_/CLK _3427_/D fanout228/X vssd1 vssd1 vccd1 vccd1 _3427_/Q sky130_fd_sc_hd__dfrtp_2
Xhold489 _3184_/Q vssd1 vssd1 vccd1 vccd1 hold489/X sky130_fd_sc_hd__dlygate4sd3_1
XPHY_EDGE_ROW_39_Right_39 vssd1 vssd1 vccd1 vccd1 sky130_fd_sc_hd__decap_3
X_3358_ _3398_/CLK _3358_/D fanout247/X vssd1 vssd1 vccd1 vccd1 _3358_/Q sky130_fd_sc_hd__dfrtp_2
X_2309_ _2309_/A _2309_/B vssd1 vssd1 vccd1 vccd1 _2312_/A sky130_fd_sc_hd__nand2_2
X_3289_ _3297_/CLK _3289_/D load_slew264/X vssd1 vssd1 vccd1 vccd1 _3289_/Q sky130_fd_sc_hd__dfrtp_2
XANTENNA__2029__D _2029_/D vssd1 vssd1 vccd1 vccd1 sky130_fd_sc_hd__diode_2
XFILLER_72_149 vssd1 vssd1 vccd1 vccd1 sky130_fd_sc_hd__fill_2
XTAP_TAPCELL_ROW_0_175 vssd1 vccd1 sky130_fd_sc_hd__tapvpwrvgnd_1
XTAP_TAPCELL_ROW_0_164 vssd1 vccd1 sky130_fd_sc_hd__tapvpwrvgnd_1
XANTENNA__2326__B _2326_/B vssd1 vssd1 vccd1 vccd1 sky130_fd_sc_hd__diode_2
XPHY_EDGE_ROW_48_Right_48 vssd1 vssd1 vccd1 vccd1 sky130_fd_sc_hd__decap_3
XANTENNA_clkbuf_leaf_7_clk_X _3423_/CLK vssd1 vssd1 vccd1 vccd1 sky130_fd_sc_hd__diode_2
XANTENNA_fanout12_A _2838_/X vssd1 vssd1 vccd1 vccd1 sky130_fd_sc_hd__diode_2
XANTENNA__1884__C _1979_/B vssd1 vssd1 vccd1 vccd1 sky130_fd_sc_hd__diode_2
XFILLER_79_45 vssd1 vssd1 vccd1 vccd1 sky130_fd_sc_hd__fill_2
XPHY_EDGE_ROW_57_Right_57 vssd1 vssd1 vccd1 vccd1 sky130_fd_sc_hd__decap_3
XTAP_TAPCELL_ROW_8_242 vssd1 vccd1 sky130_fd_sc_hd__tapvpwrvgnd_1
XFILLER_0_153 vssd1 vccd1 vssd1 vccd1 sky130_ef_sc_hd__decap_40_12
XFILLER_0_197 vssd1 vccd1 vssd1 vccd1 sky130_ef_sc_hd__decap_40_12
XFILLER_76_477 vssd1 vccd1 vssd1 vccd1 sky130_ef_sc_hd__decap_40_12
XTAP_TAPCELL_ROW_59_675 vssd1 vccd1 sky130_fd_sc_hd__tapvpwrvgnd_1
XPHY_EDGE_ROW_66_Right_66 vssd1 vssd1 vccd1 vccd1 sky130_fd_sc_hd__decap_3
XFILLER_44_352 vssd1 vssd1 vccd1 vccd1 sky130_fd_sc_hd__fill_4
XFILLER_71_182 vssd1 vssd1 vccd1 vccd1 sky130_fd_sc_hd__fill_2
XTAP_TAPCELL_ROW_42_531 vssd1 vccd1 sky130_fd_sc_hd__tapvpwrvgnd_1
XTAP_TAPCELL_ROW_14_288 vssd1 vccd1 sky130_fd_sc_hd__tapvpwrvgnd_1
XANTENNA__1794__C _2004_/B vssd1 vssd1 vccd1 vccd1 sky130_fd_sc_hd__diode_2
X_2660_ hold505/X _2850_/A1 _2666_/S vssd1 vssd1 vccd1 vccd1 _3174_/D sky130_fd_sc_hd__mux2_1
X_1611_ _3438_/Q _2594_/A vssd1 vssd1 vccd1 vccd1 _1611_/Y sky130_fd_sc_hd__nor2_2
X_2591_ _3420_/Q _2594_/B _2590_/Y _1609_/B _1612_/Y vssd1 vssd1 vccd1 vccd1 _2591_/X
+ sky130_fd_sc_hd__o221a_2
XPHY_EDGE_ROW_75_Right_75 vssd1 vssd1 vccd1 vccd1 sky130_fd_sc_hd__decap_3
X_1542_ _3386_/Q _3458_/Q _1546_/S vssd1 vssd1 vccd1 vccd1 _3459_/D sky130_fd_sc_hd__mux2_1
XFILLER_5_86 vssd1 vssd1 vccd1 vccd1 sky130_fd_sc_hd__fill_1
X_3212_ _3404_/CLK _3212_/D load_slew288/X vssd1 vssd1 vccd1 vccd1 _3212_/Q sky130_fd_sc_hd__dfrtp_2
XFILLER_79_293 vssd1 vssd1 vccd1 vccd1 sky130_fd_sc_hd__fill_2
XFILLER_39_113 vssd1 vssd1 vccd1 vccd1 sky130_fd_sc_hd__fill_4
X_3143_ _3472_/CLK _3143_/D fanout271/X vssd1 vssd1 vccd1 vccd1 _3143_/Q sky130_fd_sc_hd__dfrtp_2
XFILLER_39_146 vssd1 vssd1 vccd1 vccd1 sky130_fd_sc_hd__fill_2
X_3074_ _3343_/CLK _3074_/D vssd1 vssd1 vccd1 vccd1 _3074_/Q sky130_fd_sc_hd__dfxtp_2
X_2025_ _2025_/A _2073_/A _2049_/B _2073_/B vssd1 vssd1 vccd1 vccd1 _2056_/A sky130_fd_sc_hd__and4_2
XANTENNA__2861__S _2864_/S vssd1 vssd1 vccd1 vccd1 sky130_fd_sc_hd__diode_2
XFILLER_50_333 vssd1 vssd1 vccd1 vccd1 sky130_fd_sc_hd__fill_1
XFILLER_24_29 vssd1 vssd1 vccd1 vccd1 sky130_fd_sc_hd__fill_1
X_2927_ _3266_/Q _2927_/A2 _2927_/B1 _3248_/Q _2926_/X vssd1 vssd1 vccd1 vccd1 _2927_/X
+ sky130_fd_sc_hd__a221o_2
XPHY_EDGE_ROW_17_Left_97 vssd1 vssd1 vccd1 vccd1 sky130_fd_sc_hd__decap_3
X_2858_ hold520/X _2465_/B _3437_/D vssd1 vssd1 vccd1 vccd1 _3382_/D sky130_fd_sc_hd__mux2_1
X_2789_ hold605/X _2808_/A1 _2799_/S vssd1 vssd1 vccd1 vccd1 _3296_/D sky130_fd_sc_hd__mux2_1
X_1809_ _1834_/A _1810_/C _1810_/A vssd1 vssd1 vccd1 vccd1 _1827_/A sky130_fd_sc_hd__a21oi_2
XFILLER_2_418 vssd1 vssd1 vccd1 vccd1 sky130_fd_sc_hd__fill_2
XFILLER_6_9 vssd1 vssd1 vccd1 vccd1 sky130_fd_sc_hd__fill_8
XTAP_TAPCELL_ROW_5_212 vssd1 vccd1 sky130_fd_sc_hd__tapvpwrvgnd_1
XTAP_TAPCELL_ROW_56_645 vssd1 vccd1 sky130_fd_sc_hd__tapvpwrvgnd_1
XFILLER_73_447 vssd1 vssd1 vccd1 vccd1 sky130_fd_sc_hd__fill_1
XFILLER_65_69 vssd1 vssd1 vccd1 vccd1 sky130_fd_sc_hd__fill_4
XFILLER_26_363 vssd1 vssd1 vccd1 vccd1 sky130_fd_sc_hd__fill_1
XFILLER_41_300 vssd1 vssd1 vccd1 vccd1 sky130_fd_sc_hd__fill_1
XANTENNA__2624__X _2624_/X vssd1 vssd1 vccd1 vccd1 sky130_fd_sc_hd__diode_2
XANTENNA__2771__S _2776_/S vssd1 vssd1 vccd1 vccd1 sky130_fd_sc_hd__diode_2
XANTENNA_fanout15_X _2818_/S vssd1 vssd1 vccd1 vccd1 sky130_fd_sc_hd__diode_2
XTAP_TAPCELL_ROW_11_269 vssd1 vccd1 sky130_fd_sc_hd__tapvpwrvgnd_1
XFILLER_5_223 vssd1 vssd1 vccd1 vccd1 sky130_fd_sc_hd__fill_1
XANTENNA__2800__A _2800_/A vssd1 vssd1 vccd1 vccd1 sky130_fd_sc_hd__diode_2
XANTENNA__3404__Q _3404_/Q vssd1 vssd1 vccd1 vccd1 sky130_fd_sc_hd__diode_2
XFILLER_39_81 vssd1 vssd1 vccd1 vccd1 sky130_fd_sc_hd__fill_1
XFILLER_64_425 vssd1 vssd1 vccd1 vccd1 sky130_fd_sc_hd__fill_4
XTAP_TAPCELL_ROW_19_336 vssd1 vccd1 sky130_fd_sc_hd__tapvpwrvgnd_1
XANTENNA__2681__S _2681_/S vssd1 vssd1 vccd1 vccd1 sky130_fd_sc_hd__diode_2
XFILLER_44_193 vssd1 vssd1 vccd1 vccd1 sky130_fd_sc_hd__fill_2
X_2712_ hold633/X _2845_/A1 _2723_/S vssd1 vssd1 vccd1 vccd1 _3223_/D sky130_fd_sc_hd__mux2_1
XFILLER_72_3 vssd1 vssd1 vccd1 vccd1 sky130_fd_sc_hd__fill_8
X_2643_ hold524/X _2816_/A1 _2645_/S vssd1 vssd1 vccd1 vccd1 _3160_/D sky130_fd_sc_hd__mux2_1
X_2574_ hold580/X _2587_/A2 _2583_/B1 _3126_/Q vssd1 vssd1 vccd1 vccd1 _2574_/X sky130_fd_sc_hd__a22o_2
X_1525_ _1503_/Y _3445_/D _1525_/S vssd1 vssd1 vccd1 vccd1 _3369_/D sky130_fd_sc_hd__mux2_1
XFILLER_19_29 vssd1 vssd1 vccd1 vccd1 sky130_fd_sc_hd__fill_8
XANTENNA__2856__S _2856_/S vssd1 vssd1 vccd1 vccd1 sky130_fd_sc_hd__diode_2
X_3126_ _3199_/CLK _3126_/D load_slew220/X vssd1 vssd1 vccd1 vccd1 _3126_/Q sky130_fd_sc_hd__dfrtp_2
XFILLER_55_403 vssd1 vssd1 vccd1 vccd1 sky130_fd_sc_hd__fill_2
X_3057_ clkload8/A _3057_/D vssd1 vssd1 vccd1 vccd1 _3057_/Q sky130_fd_sc_hd__dfxtp_2
XANTENNA__1785__A1_N _1805_/A vssd1 vssd1 vccd1 vccd1 sky130_fd_sc_hd__diode_2
X_2008_ _2008_/A _2008_/B vssd1 vssd1 vccd1 vccd1 _2009_/B sky130_fd_sc_hd__xor2_2
XTAP_TAPCELL_ROW_53_626 vssd1 vccd1 sky130_fd_sc_hd__tapvpwrvgnd_1
XFILLER_63_491 vssd1 vssd1 vccd1 vccd1 sky130_fd_sc_hd__fill_2
XFILLER_35_160 vssd1 vssd1 vccd1 vccd1 sky130_fd_sc_hd__fill_1
XFILLER_50_174 vssd1 vssd1 vccd1 vccd1 sky130_fd_sc_hd__fill_4
XTAP_TAPCELL_ROW_61_692 vssd1 vccd1 sky130_fd_sc_hd__tapvpwrvgnd_1
XANTENNA__2766__S _2776_/S vssd1 vssd1 vccd1 vccd1 sky130_fd_sc_hd__diode_2
XFILLER_58_274 vssd1 vssd1 vccd1 vccd1 sky130_fd_sc_hd__fill_1
XFILLER_73_222 vssd1 vssd1 vccd1 vccd1 sky130_fd_sc_hd__fill_2
XFILLER_46_447 vssd1 vssd1 vccd1 vccd1 sky130_fd_sc_hd__fill_2
XFILLER_73_266 vssd1 vccd1 vssd1 vccd1 sky130_ef_sc_hd__decap_40_12
XANTENNA__2265__B1 _2284_/B vssd1 vssd1 vccd1 vccd1 sky130_fd_sc_hd__diode_2
XTAP_TAPCELL_ROW_16_306 vssd1 vccd1 sky130_fd_sc_hd__tapvpwrvgnd_1
XFILLER_54_491 vssd1 vssd1 vccd1 vccd1 sky130_fd_sc_hd__fill_2
XANTENNA__2568__A1 _1569_/D vssd1 vssd1 vccd1 vccd1 sky130_fd_sc_hd__diode_2
XTAP_TAPCELL_ROW_24_372 vssd1 vccd1 sky130_fd_sc_hd__tapvpwrvgnd_1
XANTENNA__2530__A _2926_/B vssd1 vssd1 vccd1 vccd1 sky130_fd_sc_hd__diode_2
XANTENNA__3412__CLK _3423_/CLK vssd1 vssd1 vccd1 vccd1 sky130_fd_sc_hd__diode_2
X_2290_ _2206_/X _2248_/C _2248_/B vssd1 vssd1 vccd1 vccd1 _2303_/B sky130_fd_sc_hd__a21bo_2
XANTENNA__2676__S _2681_/S vssd1 vssd1 vccd1 vccd1 sky130_fd_sc_hd__diode_2
XFILLER_1_281 vssd1 vssd1 vccd1 vccd1 sky130_fd_sc_hd__fill_4
XFILLER_37_447 vssd1 vssd1 vccd1 vccd1 sky130_fd_sc_hd__fill_1
XFILLER_2_98 vssd1 vssd1 vccd1 vccd1 sky130_fd_sc_hd__fill_2
XANTENNA__2705__A _2781_/B vssd1 vssd1 vccd1 vccd1 sky130_fd_sc_hd__diode_2
XFILLER_32_141 vssd1 vssd1 vccd1 vccd1 sky130_fd_sc_hd__fill_1
XPHY_EDGE_ROW_25_Left_105 vssd1 vssd1 vccd1 vccd1 sky130_fd_sc_hd__decap_3
XFILLER_60_461 vssd1 vssd1 vccd1 vccd1 sky130_fd_sc_hd__fill_4
XFILLER_32_163 vssd1 vssd1 vccd1 vccd1 sky130_fd_sc_hd__fill_2
XANTENNA__2559__A1 _2540_/X vssd1 vssd1 vccd1 vccd1 sky130_fd_sc_hd__diode_2
XANTENNA__1755__S _1773_/S vssd1 vssd1 vccd1 vccd1 sky130_fd_sc_hd__diode_2
X_2626_ _3406_/Q _2610_/A _2644_/B _3129_/Q vssd1 vssd1 vccd1 vccd1 _2626_/X sky130_fd_sc_hd__a22o_2
X_2557_ hold471/X _2515_/X _2559_/S vssd1 vssd1 vccd1 vccd1 _3111_/D sky130_fd_sc_hd__mux2_1
XPHY_EDGE_ROW_34_Left_114 vssd1 vssd1 vccd1 vccd1 sky130_fd_sc_hd__decap_3
X_2488_ _2445_/S _2482_/X _2486_/X _2487_/X vssd1 vssd1 vccd1 vccd1 _2489_/B sky130_fd_sc_hd__a211o_2
X_1508_ _3380_/Q _3377_/Q vssd1 vssd1 vccd1 vccd1 _1509_/B sky130_fd_sc_hd__and2b_2
X_3109_ _3204_/CLK _3109_/D load_slew205/X vssd1 vssd1 vccd1 vccd1 _3109_/Q sky130_fd_sc_hd__dfrtp_2
XTAP_TAPCELL_ROW_38_497 vssd1 vccd1 sky130_fd_sc_hd__tapvpwrvgnd_1
XPHY_EDGE_ROW_43_Left_123 vssd1 vssd1 vccd1 vccd1 sky130_fd_sc_hd__decap_3
XFILLER_62_37 vssd1 vssd1 vccd1 vccd1 sky130_fd_sc_hd__fill_1
XFILLER_62_59 vssd1 vssd1 vccd1 vccd1 sky130_fd_sc_hd__fill_2
XFILLER_11_347 vssd1 vssd1 vccd1 vccd1 sky130_fd_sc_hd__fill_1
XTAP_TAPCELL_ROW_21_353 vssd1 vccd1 sky130_fd_sc_hd__tapvpwrvgnd_1
XPHY_EDGE_ROW_52_Left_132 vssd1 vssd1 vccd1 vccd1 sky130_fd_sc_hd__decap_3
XFILLER_2_3 vssd1 vccd1 vssd1 vccd1 sky130_ef_sc_hd__decap_40_12
XANTENNA_fanout82_X _2894_/A2 vssd1 vssd1 vccd1 vccd1 sky130_fd_sc_hd__diode_2
XFILLER_78_314 vssd1 vssd1 vccd1 vccd1 sky130_fd_sc_hd__fill_8
XFILLER_78_347 vssd1 vssd1 vccd1 vccd1 sky130_fd_sc_hd__fill_8
XANTENNA__2509__B _2959_/C vssd1 vssd1 vccd1 vccd1 sky130_fd_sc_hd__diode_2
XTAP_TAPCELL_ROW_29_420 vssd1 vccd1 sky130_fd_sc_hd__tapvpwrvgnd_1
XPHY_EDGE_ROW_61_Left_141 vssd1 vssd1 vccd1 vccd1 sky130_fd_sc_hd__decap_3
XFILLER_36_82 vssd1 vssd1 vccd1 vccd1 sky130_fd_sc_hd__fill_2
XTAP_TAPCELL_ROW_72_787 vssd1 vccd1 sky130_fd_sc_hd__tapvpwrvgnd_1
XFILLER_14_141 vssd1 vccd1 vssd1 vccd1 sky130_ef_sc_hd__decap_40_12
X_1790_ _1813_/A _1862_/C _1998_/B _1906_/A vssd1 vssd1 vccd1 vccd1 _1792_/A sky130_fd_sc_hd__a22oi_2
XANTENNA__2961__A1 _2961_/A1 vssd1 vssd1 vccd1 vccd1 sky130_fd_sc_hd__diode_2
XPHY_EDGE_ROW_70_Left_150 vssd1 vssd1 vccd1 vccd1 sky130_fd_sc_hd__decap_3
X_3460_ _3463_/CLK _3460_/D fanout241/X vssd1 vssd1 vccd1 vccd1 _3460_/Q sky130_fd_sc_hd__dfrtp_2
XFILLER_6_373 vssd1 vssd1 vccd1 vccd1 sky130_fd_sc_hd__fill_2
X_3391_ _3394_/CLK _3391_/D fanout277/X vssd1 vssd1 vccd1 vccd1 _3391_/Q sky130_fd_sc_hd__dfrtp_2
X_2411_ _2411_/A _2411_/B vssd1 vssd1 vccd1 vccd1 _2411_/Y sky130_fd_sc_hd__xnor2_2
X_2342_ _2372_/A vssd1 vssd1 vccd1 vccd1 _2344_/A sky130_fd_sc_hd__inv_2
X_2273_ _2273_/A _2311_/A vssd1 vssd1 vccd1 vccd1 _2275_/A sky130_fd_sc_hd__nand2_2
XANTENNA__2229__B1 _2284_/B vssd1 vssd1 vccd1 vccd1 sky130_fd_sc_hd__diode_2
XTAP_TAPCELL_ROW_63_710 vssd1 vccd1 sky130_fd_sc_hd__tapvpwrvgnd_1
XFILLER_52_247 vssd1 vssd1 vccd1 vccd1 sky130_fd_sc_hd__fill_4
XFILLER_18_491 vssd1 vssd1 vccd1 vccd1 sky130_fd_sc_hd__fill_2
XTAP_TAPCELL_ROW_35_467 vssd1 vccd1 sky130_fd_sc_hd__tapvpwrvgnd_1
XANTENNA__2154__B _2154_/B vssd1 vssd1 vccd1 vccd1 sky130_fd_sc_hd__diode_2
XFILLER_32_29 vssd1 vssd1 vccd1 vccd1 sky130_fd_sc_hd__fill_2
XFILLER_20_111 vssd1 vccd1 vssd1 vccd1 sky130_ef_sc_hd__decap_40_12
XANTENNA__3458__CLK _3463_/CLK vssd1 vssd1 vccd1 vccd1 sky130_fd_sc_hd__diode_2
XFILLER_20_155 vssd1 vssd1 vccd1 vccd1 sky130_fd_sc_hd__fill_4
XANTENNA_clkbuf_leaf_12_clk_A clkload2/A vssd1 vssd1 vccd1 vccd1 sky130_fd_sc_hd__diode_2
X_1988_ _1952_/Y _1956_/B _1954_/B vssd1 vssd1 vccd1 vccd1 _1992_/A sky130_fd_sc_hd__o21a_2
X_2609_ _3416_/Q _3418_/Q _2609_/C vssd1 vssd1 vccd1 vccd1 _2609_/X sky130_fd_sc_hd__or3_2
XANTENNA_clkbuf_leaf_27_clk_A clkload3/A vssd1 vssd1 vccd1 vccd1 sky130_fd_sc_hd__diode_2
XANTENNA__2180__A2 _2279_/B vssd1 vssd1 vccd1 vccd1 sky130_fd_sc_hd__diode_2
XFILLER_57_26 vssd1 vccd1 vssd1 vccd1 sky130_ef_sc_hd__decap_40_12
XFILLER_57_15 vssd1 vssd1 vccd1 vccd1 sky130_fd_sc_hd__fill_4
XFILLER_57_59 vssd1 vssd1 vccd1 vccd1 sky130_fd_sc_hd__fill_1
XANTENNA__2468__B1 _2648_/B vssd1 vssd1 vccd1 vccd1 sky130_fd_sc_hd__diode_2
XFILLER_28_255 vssd1 vssd1 vccd1 vccd1 sky130_fd_sc_hd__fill_1
XFILLER_28_233 vssd1 vssd1 vccd1 vccd1 sky130_fd_sc_hd__fill_1
XFILLER_43_225 vssd1 vccd1 vssd1 vccd1 sky130_ef_sc_hd__decap_40_12
XFILLER_73_69 vssd1 vssd1 vccd1 vccd1 sky130_fd_sc_hd__fill_4
XFILLER_24_483 vssd1 vssd1 vccd1 vccd1 sky130_fd_sc_hd__fill_1
XFILLER_11_177 vssd1 vssd1 vccd1 vccd1 sky130_fd_sc_hd__fill_2
XANTENNA__2943__B2 _2520_/A vssd1 vssd1 vccd1 vccd1 sky130_fd_sc_hd__diode_2
XPHY_EDGE_ROW_5_Left_85 vssd1 vssd1 vccd1 vccd1 sky130_fd_sc_hd__decap_3
XFILLER_78_111 vssd1 vssd1 vccd1 vccd1 sky130_fd_sc_hd__fill_2
XTAP_TAPCELL_ROW_77_824 vssd1 vccd1 sky130_fd_sc_hd__tapvpwrvgnd_1
XANTENNA__2459__B1 _2894_/B1 vssd1 vssd1 vccd1 vccd1 sky130_fd_sc_hd__diode_2
Xfanout190 _3027_/Q vssd1 vssd1 vccd1 vccd1 _2049_/B sky130_fd_sc_hd__clkdlybuf4s25_1
XFILLER_47_81 vssd1 vssd1 vccd1 vccd1 sky130_fd_sc_hd__fill_1
XFILLER_19_233 vssd1 vssd1 vccd1 vccd1 sky130_fd_sc_hd__fill_1
X_2960_ _3269_/Q _2960_/A2 wire66/X _3251_/Q _2959_/X vssd1 vssd1 vccd1 vccd1 _2960_/X
+ sky130_fd_sc_hd__a221o_2
X_2891_ _2926_/B _2926_/C _3209_/Q vssd1 vssd1 vccd1 vccd1 _2891_/X sky130_fd_sc_hd__and3_2
X_1911_ _1911_/A _1912_/B vssd1 vssd1 vccd1 vccd1 _1911_/X sky130_fd_sc_hd__or2_2
XTAP_TAPCELL_ROW_32_448 vssd1 vccd1 sky130_fd_sc_hd__tapvpwrvgnd_1
X_1842_ _1842_/A _1842_/B vssd1 vssd1 vccd1 vccd1 _1844_/B sky130_fd_sc_hd__xnor2_2
XFILLER_8_53 vssd1 vssd1 vccd1 vccd1 sky130_fd_sc_hd__fill_2
X_1773_ _2399_/A hold659/X _1773_/S vssd1 vssd1 vccd1 vccd1 _3053_/D sky130_fd_sc_hd__mux2_1
Xhold627 _3305_/Q vssd1 vssd1 vccd1 vccd1 hold627/X sky130_fd_sc_hd__dlygate4sd3_1
Xhold616 _3301_/Q vssd1 vssd1 vccd1 vccd1 hold616/X sky130_fd_sc_hd__dlygate4sd3_1
Xhold605 _3296_/Q vssd1 vssd1 vccd1 vccd1 hold605/X sky130_fd_sc_hd__dlygate4sd3_1
X_3443_ _3453_/CLK _3443_/D load_slew286/X vssd1 vssd1 vccd1 vccd1 _3443_/Q sky130_fd_sc_hd__dfrtp_2
Xhold649 _3244_/Q vssd1 vssd1 vccd1 vccd1 hold649/X sky130_fd_sc_hd__dlygate4sd3_1
Xhold638 _3255_/Q vssd1 vssd1 vccd1 vccd1 hold638/X sky130_fd_sc_hd__dlygate4sd3_1
XFILLER_6_181 vssd1 vssd1 vccd1 vccd1 sky130_fd_sc_hd__fill_2
XANTENNA__3395__RESET_B fanout251/X vssd1 vssd1 vccd1 vccd1 sky130_fd_sc_hd__diode_2
X_3374_ _2997_/Y _3374_/D load_slew283/X vssd1 vssd1 vccd1 vccd1 _3450_/D sky130_fd_sc_hd__dfrtp_2
X_2325_ _2383_/B _2352_/B _2352_/C _2384_/B vssd1 vssd1 vccd1 vccd1 _2327_/B sky130_fd_sc_hd__a22o_2
XFILLER_69_155 vssd1 vssd1 vccd1 vccd1 sky130_fd_sc_hd__fill_8
X_2256_ _2255_/A _2279_/B _2318_/B _2255_/B vssd1 vssd1 vccd1 vccd1 _2258_/B sky130_fd_sc_hd__a22o_2
XANTENNA__2864__S _2864_/S vssd1 vssd1 vccd1 vccd1 sky130_fd_sc_hd__diode_2
X_2187_ _2186_/B _2186_/C _2186_/A vssd1 vssd1 vccd1 vccd1 _2188_/C sky130_fd_sc_hd__o21ai_2
XTAP_TAPCELL_ROW_48_581 vssd1 vccd1 sky130_fd_sc_hd__tapvpwrvgnd_1
XFILLER_43_28 vssd1 vccd1 vssd1 vccd1 sky130_ef_sc_hd__decap_40_12
XANTENNA__2622__B1 _2644_/B vssd1 vssd1 vccd1 vccd1 sky130_fd_sc_hd__diode_2
XANTENNA_fanout132_X _2472_/B vssd1 vssd1 vccd1 vccd1 sky130_fd_sc_hd__diode_2
XFILLER_4_129 vssd1 vssd1 vccd1 vccd1 sky130_fd_sc_hd__fill_4
XFILLER_68_25 vssd1 vssd1 vccd1 vccd1 sky130_fd_sc_hd__fill_2
XFILLER_0_335 vssd1 vssd1 vccd1 vccd1 sky130_fd_sc_hd__fill_1
XFILLER_75_125 vssd1 vssd1 vccd1 vccd1 sky130_fd_sc_hd__fill_8
XANTENNA__2774__S _2780_/S vssd1 vssd1 vccd1 vccd1 sky130_fd_sc_hd__diode_2
XTAP_TAPCELL_ROW_74_805 vssd1 vccd1 sky130_fd_sc_hd__tapvpwrvgnd_1
XTAP_TAPCELL_ROW_3_195 vssd1 vccd1 sky130_fd_sc_hd__tapvpwrvgnd_1
XFILLER_71_386 vssd1 vssd1 vccd1 vccd1 sky130_fd_sc_hd__fill_4
XANTENNA__2522__B _2957_/C vssd1 vssd1 vccd1 vccd1 sky130_fd_sc_hd__diode_2
X_3090_ _3090_/CLK _3090_/D wire208/X vssd1 vssd1 vccd1 vccd1 _3090_/Q sky130_fd_sc_hd__dfrtp_2
X_2110_ _2132_/A _2146_/B _2146_/C _2154_/B vssd1 vssd1 vccd1 vccd1 _2112_/A sky130_fd_sc_hd__a22oi_2
XANTENNA__2684__S _2685_/S vssd1 vssd1 vccd1 vccd1 sky130_fd_sc_hd__diode_2
X_2041_ _2067_/A _2063_/B vssd1 vssd1 vccd1 vccd1 _2042_/B sky130_fd_sc_hd__nand2_2
XFILLER_74_180 vssd1 vssd1 vccd1 vccd1 sky130_fd_sc_hd__fill_1
XTAP_TAPCELL_ROW_45_551 vssd1 vccd1 sky130_fd_sc_hd__tapvpwrvgnd_1
X_2943_ _3232_/Q _2967_/A2 _2942_/X _2520_/A vssd1 vssd1 vccd1 vccd1 _2943_/X sky130_fd_sc_hd__a22o_2
X_2874_ _2445_/S _2871_/X _2873_/X _2838_/A vssd1 vssd1 vccd1 vccd1 _2874_/X sky130_fd_sc_hd__a22o_2
X_1825_ hold718/X _1824_/Y _1993_/S vssd1 vssd1 vccd1 vccd1 _3058_/D sky130_fd_sc_hd__mux2_1
XANTENNA__2907__A1 _2942_/B2 vssd1 vssd1 vccd1 vccd1 sky130_fd_sc_hd__diode_2
XANTENNA__2907__B2 _2966_/A1 vssd1 vssd1 vccd1 vccd1 sky130_fd_sc_hd__diode_2
Xhold402 _3410_/Q vssd1 vssd1 vccd1 vccd1 hold402/X sky130_fd_sc_hd__dlygate4sd3_1
X_1756_ _2384_/B hold716/X _1773_/S vssd1 vssd1 vccd1 vccd1 _3036_/D sky130_fd_sc_hd__mux2_1
XANTENNA__2859__S _3437_/D vssd1 vssd1 vccd1 vccd1 sky130_fd_sc_hd__diode_2
Xhold413 _2978_/X vssd1 vssd1 vccd1 vccd1 _3402_/D sky130_fd_sc_hd__dlygate4sd3_1
Xhold424 _3213_/Q vssd1 vssd1 vccd1 vccd1 hold424/X sky130_fd_sc_hd__dlygate4sd3_1
Xhold435 _3106_/Q vssd1 vssd1 vccd1 vccd1 hold435/X sky130_fd_sc_hd__dlygate4sd3_1
Xhold446 _3199_/Q vssd1 vssd1 vccd1 vccd1 hold446/X sky130_fd_sc_hd__dlygate4sd3_1
Xhold457 _3297_/Q vssd1 vssd1 vccd1 vccd1 hold457/X sky130_fd_sc_hd__dlygate4sd3_1
Xhold468 _3175_/Q vssd1 vssd1 vccd1 vccd1 hold468/X sky130_fd_sc_hd__dlygate4sd3_1
X_1687_ _1674_/A _1670_/Y _1674_/B _1680_/B _1672_/B vssd1 vssd1 vccd1 vccd1 _1688_/B
+ sky130_fd_sc_hd__o311a_2
X_3426_ _3472_/CLK _3426_/D fanout271/X vssd1 vssd1 vccd1 vccd1 _3426_/Q sky130_fd_sc_hd__dfrtp_2
Xhold479 _3337_/Q vssd1 vssd1 vccd1 vccd1 hold479/X sky130_fd_sc_hd__dlygate4sd3_1
X_3357_ _3359_/CLK _3357_/D load_slew244/X vssd1 vssd1 vccd1 vccd1 _3357_/Q sky130_fd_sc_hd__dfrtp_2
X_2308_ _2308_/A vssd1 vssd1 vccd1 vccd1 _2309_/B sky130_fd_sc_hd__inv_2
X_3288_ _3337_/CLK _3288_/D load_slew246/X vssd1 vssd1 vccd1 vccd1 _3288_/Q sky130_fd_sc_hd__dfrtp_2
XFILLER_57_169 vssd1 vssd1 vccd1 vccd1 sky130_fd_sc_hd__fill_4
X_2239_ _2237_/X _2239_/B vssd1 vssd1 vccd1 vccd1 _2241_/A sky130_fd_sc_hd__nand2b_2
XFILLER_72_139 vssd1 vssd1 vccd1 vccd1 sky130_fd_sc_hd__fill_1
XFILLER_54_27 vssd1 vssd1 vccd1 vccd1 sky130_fd_sc_hd__fill_1
XFILLER_38_394 vssd1 vssd1 vccd1 vccd1 sky130_fd_sc_hd__fill_1
XTAP_TAPCELL_ROW_0_176 vssd1 vccd1 sky130_fd_sc_hd__tapvpwrvgnd_1
XTAP_TAPCELL_ROW_0_165 vssd1 vccd1 sky130_fd_sc_hd__tapvpwrvgnd_1
XFILLER_53_386 vssd1 vssd1 vccd1 vccd1 sky130_fd_sc_hd__fill_1
XFILLER_70_37 vssd1 vssd1 vccd1 vccd1 sky130_fd_sc_hd__fill_2
XFILLER_21_261 vssd1 vssd1 vccd1 vccd1 sky130_fd_sc_hd__fill_1
XANTENNA__1884__D _2002_/B vssd1 vssd1 vccd1 vccd1 sky130_fd_sc_hd__diode_2
XANTENNA__2769__S _2780_/S vssd1 vssd1 vccd1 vccd1 sky130_fd_sc_hd__diode_2
XFILLER_79_24 vssd1 vssd1 vccd1 vccd1 sky130_fd_sc_hd__fill_4
XFILLER_79_57 vssd1 vccd1 vssd1 vccd1 sky130_ef_sc_hd__decap_40_12
XTAP_TAPCELL_ROW_8_243 vssd1 vccd1 sky130_fd_sc_hd__tapvpwrvgnd_1
XFILLER_0_121 vssd1 vssd1 vccd1 vccd1 sky130_fd_sc_hd__fill_1
XFILLER_0_165 vssd1 vssd1 vccd1 vccd1 sky130_fd_sc_hd__fill_2
XFILLER_48_158 vssd1 vccd1 vssd1 vccd1 sky130_ef_sc_hd__decap_40_12
XTAP_TAPCELL_ROW_59_676 vssd1 vccd1 sky130_fd_sc_hd__tapvpwrvgnd_1
XFILLER_76_489 vssd1 vssd1 vccd1 vccd1 sky130_fd_sc_hd__fill_2
XFILLER_63_117 vssd1 vssd1 vccd1 vccd1 sky130_fd_sc_hd__fill_2
XFILLER_28_83 vssd1 vssd1 vccd1 vccd1 sky130_fd_sc_hd__fill_1
XANTENNA__2517__B _2957_/C vssd1 vssd1 vccd1 vccd1 sky130_fd_sc_hd__diode_2
XFILLER_44_60 vssd1 vssd1 vccd1 vccd1 sky130_fd_sc_hd__fill_2
XANTENNA__1848__S _1993_/S vssd1 vssd1 vccd1 vccd1 sky130_fd_sc_hd__diode_2
XTAP_TAPCELL_ROW_42_532 vssd1 vccd1 sky130_fd_sc_hd__tapvpwrvgnd_1
XANTENNA__2533__A _2533_/A vssd1 vssd1 vccd1 vccd1 sky130_fd_sc_hd__diode_2
XTAP_TAPCELL_ROW_14_289 vssd1 vccd1 sky130_fd_sc_hd__tapvpwrvgnd_1
X_1610_ _1629_/B _2595_/B vssd1 vssd1 vccd1 vccd1 _1610_/Y sky130_fd_sc_hd__nor2_2
X_2590_ _2590_/A _2590_/B vssd1 vssd1 vccd1 vccd1 _2590_/Y sky130_fd_sc_hd__nand2_2
XANTENNA__2679__S _2685_/S vssd1 vssd1 vccd1 vccd1 sky130_fd_sc_hd__diode_2
X_1541_ _3385_/Q _3457_/Q _1546_/S vssd1 vssd1 vccd1 vccd1 _3458_/D sky130_fd_sc_hd__mux2_1
XFILLER_5_98 vssd1 vssd1 vccd1 vccd1 sky130_fd_sc_hd__fill_2
XFILLER_5_65 vssd1 vssd1 vccd1 vccd1 sky130_fd_sc_hd__fill_4
X_3211_ _3337_/CLK _3211_/D load_slew253/X vssd1 vssd1 vccd1 vccd1 _3211_/Q sky130_fd_sc_hd__dfrtp_2
X_3142_ _3472_/CLK _3142_/D _3472_/SET_B vssd1 vssd1 vccd1 vccd1 _3142_/Q sky130_fd_sc_hd__dfrtp_2
XFILLER_67_445 vssd1 vssd1 vccd1 vccd1 sky130_fd_sc_hd__fill_2
XFILLER_39_158 vssd1 vssd1 vccd1 vccd1 sky130_fd_sc_hd__fill_1
X_3073_ _3343_/CLK _3073_/D vssd1 vssd1 vccd1 vccd1 _3073_/Q sky130_fd_sc_hd__dfxtp_2
XFILLER_39_169 vssd1 vssd1 vccd1 vccd1 sky130_fd_sc_hd__fill_4
XANTENNA__1628__A1 _2800_/A vssd1 vssd1 vccd1 vccd1 sky130_fd_sc_hd__diode_2
XANTENNA__1628__B2 _2540_/A vssd1 vssd1 vccd1 vccd1 sky130_fd_sc_hd__diode_2
X_2024_ _2025_/A _2073_/A _2049_/B _2073_/B vssd1 vssd1 vccd1 vccd1 _2026_/A sky130_fd_sc_hd__a22oi_2
XFILLER_54_128 vssd1 vssd1 vccd1 vccd1 sky130_fd_sc_hd__fill_2
XANTENNA__3049__CLK _3423_/CLK vssd1 vssd1 vccd1 vccd1 sky130_fd_sc_hd__diode_2
XFILLER_50_323 vssd1 vssd1 vccd1 vccd1 sky130_fd_sc_hd__fill_2
XFILLER_50_301 vssd1 vssd1 vccd1 vccd1 sky130_fd_sc_hd__fill_4
XFILLER_35_397 vssd1 vssd1 vccd1 vccd1 sky130_fd_sc_hd__fill_1
XANTENNA__1758__S _3435_/D vssd1 vssd1 vccd1 vccd1 sky130_fd_sc_hd__diode_2
XANTENNA__2443__A _2781_/B vssd1 vssd1 vccd1 vccd1 sky130_fd_sc_hd__diode_2
X_2926_ _3284_/Q _2926_/B _2926_/C vssd1 vssd1 vccd1 vccd1 _2926_/X sky130_fd_sc_hd__and3_2
XFILLER_10_209 vssd1 vccd1 vssd1 vccd1 sky130_ef_sc_hd__decap_40_12
X_2857_ hold448/X _2453_/B _3437_/D vssd1 vssd1 vccd1 vccd1 _3381_/D sky130_fd_sc_hd__mux2_1
X_1808_ _1833_/A _1807_/C _1807_/A vssd1 vssd1 vccd1 vccd1 _1810_/C sky130_fd_sc_hd__a21o_2
X_2788_ hold588/X _2624_/X _2798_/S vssd1 vssd1 vccd1 vccd1 _3295_/D sky130_fd_sc_hd__mux2_1
X_1739_ _3021_/Q _1739_/B vssd1 vssd1 vccd1 vccd1 _1739_/X sky130_fd_sc_hd__and2_2
XFILLER_49_27 vssd1 vccd1 vssd1 vccd1 sky130_ef_sc_hd__decap_40_12
X_3409_ _3441_/CLK _3409_/D _2608_/S vssd1 vssd1 vccd1 vccd1 _3409_/Q sky130_fd_sc_hd__dfstp_2
XTAP_TAPCELL_ROW_5_213 vssd1 vccd1 sky130_fd_sc_hd__tapvpwrvgnd_1
XFILLER_58_467 vssd1 vssd1 vccd1 vccd1 sky130_fd_sc_hd__fill_1
XTAP_TAPCELL_ROW_56_646 vssd1 vccd1 sky130_fd_sc_hd__tapvpwrvgnd_1
XFILLER_41_356 vssd1 vssd1 vccd1 vccd1 sky130_fd_sc_hd__fill_2
XANTENNA__3427__RESET_B fanout228/X vssd1 vssd1 vccd1 vccd1 sky130_fd_sc_hd__diode_2
XFILLER_14_85 vssd1 vccd1 vssd1 vccd1 sky130_ef_sc_hd__decap_40_12
XFILLER_5_279 vssd1 vssd1 vccd1 vccd1 sky130_fd_sc_hd__fill_1
XFILLER_30_62 vssd1 vssd1 vccd1 vccd1 sky130_fd_sc_hd__fill_4
XFILLER_1_441 vssd1 vssd1 vccd1 vccd1 sky130_fd_sc_hd__fill_1
XANTENNA__2528__A _2540_/A vssd1 vssd1 vccd1 vccd1 sky130_fd_sc_hd__diode_2
XFILLER_76_253 vssd1 vssd1 vccd1 vccd1 sky130_fd_sc_hd__fill_1
XFILLER_36_106 vssd1 vssd1 vccd1 vccd1 sky130_fd_sc_hd__fill_4
XTAP_TAPCELL_ROW_19_337 vssd1 vccd1 sky130_fd_sc_hd__tapvpwrvgnd_1
XFILLER_36_139 vssd1 vssd1 vccd1 vccd1 sky130_fd_sc_hd__fill_1
XFILLER_51_109 vssd1 vssd1 vccd1 vccd1 sky130_fd_sc_hd__fill_2
XFILLER_72_492 vssd1 vssd1 vccd1 vccd1 sky130_fd_sc_hd__fill_2
XFILLER_44_172 vssd1 vssd1 vccd1 vccd1 sky130_fd_sc_hd__fill_2
XFILLER_17_397 vssd1 vssd1 vccd1 vccd1 sky130_fd_sc_hd__fill_1
XFILLER_32_345 vssd1 vssd1 vccd1 vccd1 sky130_fd_sc_hd__fill_1
XANTENNA__2263__A _2263_/A vssd1 vssd1 vccd1 vccd1 sky130_fd_sc_hd__diode_2
X_2711_ hold586/X _2844_/A1 _2723_/S vssd1 vssd1 vccd1 vccd1 _3222_/D sky130_fd_sc_hd__mux2_1
X_2642_ _3137_/Q _2644_/B vssd1 vssd1 vccd1 vccd1 _2642_/X sky130_fd_sc_hd__and2_2
XFILLER_65_3 vssd1 vssd1 vccd1 vccd1 sky130_fd_sc_hd__fill_4
X_2573_ hold710/X _1622_/C _2583_/B1 hold712/X vssd1 vssd1 vccd1 vccd1 _3125_/D sky130_fd_sc_hd__a22o_2
X_1524_ _3361_/Q _3446_/D _1525_/S vssd1 vssd1 vccd1 vccd1 _3370_/D sky130_fd_sc_hd__mux2_1
XANTENNA__2510__A2 _2901_/A2 vssd1 vssd1 vccd1 vccd1 sky130_fd_sc_hd__diode_2
X_3125_ _3199_/CLK _3125_/D load_slew220/X vssd1 vssd1 vccd1 vccd1 _3125_/Q sky130_fd_sc_hd__dfrtp_2
X_3056_ clkload8/A _3056_/D vssd1 vssd1 vccd1 vccd1 _3056_/Q sky130_fd_sc_hd__dfxtp_2
X_2007_ _2007_/A _2007_/B vssd1 vssd1 vccd1 vccd1 _2008_/B sky130_fd_sc_hd__nand2_2
XFILLER_70_418 vssd1 vssd1 vccd1 vccd1 sky130_fd_sc_hd__fill_2
XANTENNA__2577__A2 _1622_/C vssd1 vssd1 vccd1 vccd1 sky130_fd_sc_hd__diode_2
XTAP_TAPCELL_ROW_61_693 vssd1 vccd1 sky130_fd_sc_hd__tapvpwrvgnd_1
XFILLER_50_197 vssd1 vssd1 vccd1 vccd1 sky130_fd_sc_hd__fill_1
X_2909_ _2966_/A1 _3157_/Q _3301_/Q _2942_/B2 vssd1 vssd1 vccd1 vccd1 _2909_/X sky130_fd_sc_hd__a22o_2
XTAP_TAPCELL_ROW_69_760 vssd1 vccd1 sky130_fd_sc_hd__tapvpwrvgnd_1
XANTENNA__2782__S _2799_/S vssd1 vssd1 vccd1 vccd1 sky130_fd_sc_hd__diode_2
XFILLER_73_278 vssd1 vssd1 vccd1 vccd1 sky130_fd_sc_hd__fill_2
XTAP_TAPCELL_ROW_16_307 vssd1 vccd1 sky130_fd_sc_hd__tapvpwrvgnd_1
XFILLER_41_164 vssd1 vssd1 vccd1 vccd1 sky130_fd_sc_hd__fill_4
XANTENNA__2568__A2 _2540_/X vssd1 vssd1 vccd1 vccd1 sky130_fd_sc_hd__diode_2
XTAP_TAPCELL_ROW_24_373 vssd1 vccd1 sky130_fd_sc_hd__tapvpwrvgnd_1
XANTENNA__2973__C1 _1585_/A vssd1 vssd1 vccd1 vccd1 sky130_fd_sc_hd__diode_2
XANTENNA__2530__B _2926_/C vssd1 vssd1 vccd1 vccd1 sky130_fd_sc_hd__diode_2
XFILLER_2_33 vssd1 vssd1 vccd1 vccd1 sky130_fd_sc_hd__fill_1
XANTENNA__2692__S _2704_/S vssd1 vssd1 vccd1 vccd1 sky130_fd_sc_hd__diode_2
XFILLER_32_197 vssd1 vssd1 vccd1 vccd1 sky130_fd_sc_hd__fill_2
XANTENNA__1767__A0 _2263_/A vssd1 vssd1 vccd1 vccd1 sky130_fd_sc_hd__diode_2
XANTENNA__2440__B _2533_/B vssd1 vssd1 vccd1 vccd1 sky130_fd_sc_hd__diode_2
X_2625_ hold678/X _2845_/A1 _2645_/S vssd1 vssd1 vccd1 vccd1 _3151_/D sky130_fd_sc_hd__mux2_1
X_2556_ hold535/X _2502_/X _2559_/S vssd1 vssd1 vccd1 vccd1 _3110_/D sky130_fd_sc_hd__mux2_1
X_2487_ _2942_/B2 _2480_/X _2484_/X _2611_/A vssd1 vssd1 vccd1 vccd1 _2487_/X sky130_fd_sc_hd__a22o_2
X_1507_ _2995_/A vssd1 vssd1 vccd1 vccd1 _1507_/Y sky130_fd_sc_hd__inv_2
XANTENNA__2495__B2 _2961_/A1 vssd1 vssd1 vccd1 vccd1 sky130_fd_sc_hd__diode_2
X_3108_ _3204_/CLK _3108_/D fanout204/X vssd1 vssd1 vccd1 vccd1 _3108_/Q sky130_fd_sc_hd__dfrtp_2
XTAP_TAPCELL_ROW_66_730 vssd1 vccd1 sky130_fd_sc_hd__tapvpwrvgnd_1
XANTENNA_fanout162_X _2029_/C vssd1 vssd1 vccd1 vccd1 sky130_fd_sc_hd__diode_2
X_3039_ clkload8/A _3039_/D load_slew210/X vssd1 vssd1 vccd1 vccd1 _3039_/Q sky130_fd_sc_hd__dfrtp_2
XFILLER_55_278 vssd1 vssd1 vccd1 vccd1 sky130_fd_sc_hd__fill_2
XFILLER_15_109 vssd1 vssd1 vccd1 vccd1 sky130_fd_sc_hd__fill_2
XTAP_TAPCELL_ROW_38_498 vssd1 vccd1 sky130_fd_sc_hd__tapvpwrvgnd_1
XFILLER_23_186 vssd1 vssd1 vccd1 vccd1 sky130_fd_sc_hd__fill_1
XANTENNA__1758__A0 _1906_/A vssd1 vssd1 vccd1 vccd1 sky130_fd_sc_hd__diode_2
XTAP_TAPCELL_ROW_21_354 vssd1 vccd1 sky130_fd_sc_hd__tapvpwrvgnd_1
XFILLER_11_75 vssd1 vssd1 vccd1 vccd1 sky130_fd_sc_hd__fill_4
XANTENNA__2777__S _2780_/S vssd1 vssd1 vccd1 vccd1 sky130_fd_sc_hd__diode_2
XANTENNA__2486__B2 _2520_/A vssd1 vssd1 vccd1 vccd1 sky130_fd_sc_hd__diode_2
XTAP_TAPCELL_ROW_29_421 vssd1 vccd1 sky130_fd_sc_hd__tapvpwrvgnd_1
XFILLER_46_201 vssd1 vssd1 vccd1 vccd1 sky130_fd_sc_hd__fill_2
XANTENNA__2228__D _2284_/B vssd1 vssd1 vccd1 vccd1 sky130_fd_sc_hd__diode_2
XFILLER_36_61 vssd1 vssd1 vccd1 vccd1 sky130_fd_sc_hd__fill_4
XANTENNA__1997__B1 _1962_/B vssd1 vssd1 vccd1 vccd1 sky130_fd_sc_hd__diode_2
XTAP_TAPCELL_ROW_72_788 vssd1 vccd1 sky130_fd_sc_hd__tapvpwrvgnd_1
XFILLER_14_153 vssd1 vssd1 vccd1 vccd1 sky130_fd_sc_hd__fill_4
XFILLER_14_197 vssd1 vssd1 vccd1 vccd1 sky130_fd_sc_hd__fill_1
XANTENNA__1749__A0 _2029_/D vssd1 vssd1 vccd1 vccd1 sky130_fd_sc_hd__diode_2
XANTENNA__2946__C1 _1585_/A vssd1 vssd1 vccd1 vccd1 sky130_fd_sc_hd__diode_2
X_2410_ _2406_/X _2410_/B vssd1 vssd1 vccd1 vccd1 _2411_/B sky130_fd_sc_hd__and2b_2
XFILLER_6_363 vssd1 vssd1 vccd1 vccd1 sky130_fd_sc_hd__fill_1
X_3390_ _3393_/CLK _3390_/D load_slew258/X vssd1 vssd1 vccd1 vccd1 _3390_/Q sky130_fd_sc_hd__dfrtp_2
XANTENNA__2687__S _2704_/S vssd1 vssd1 vccd1 vccd1 sky130_fd_sc_hd__diode_2
X_2341_ _2343_/A _2343_/B vssd1 vssd1 vccd1 vccd1 _2372_/A sky130_fd_sc_hd__or2_2
X_2272_ _2272_/A _2272_/B vssd1 vssd1 vccd1 vccd1 _2311_/A sky130_fd_sc_hd__nand2_2
XFILLER_28_3 vssd1 vssd1 vccd1 vccd1 sky130_fd_sc_hd__fill_8
XANTENNA__2229__A1 _2263_/A vssd1 vssd1 vccd1 vccd1 sky130_fd_sc_hd__diode_2
XTAP_TAPCELL_ROW_63_711 vssd1 vccd1 sky130_fd_sc_hd__tapvpwrvgnd_1
XTAP_TAPCELL_ROW_35_468 vssd1 vccd1 sky130_fd_sc_hd__tapvpwrvgnd_1
XANTENNA__2154__C _2347_/A vssd1 vssd1 vccd1 vccd1 sky130_fd_sc_hd__diode_2
XFILLER_20_123 vssd1 vssd1 vccd1 vccd1 sky130_fd_sc_hd__fill_4
XANTENNA__1766__S _1773_/S vssd1 vssd1 vccd1 vccd1 sky130_fd_sc_hd__diode_2
X_1987_ _1989_/A _1989_/B vssd1 vssd1 vccd1 vccd1 _1994_/A sky130_fd_sc_hd__nand2_2
XANTENNA_fanout122_A _3430_/Q vssd1 vssd1 vccd1 vccd1 sky130_fd_sc_hd__diode_2
XANTENNA__2952__A2 _2864_/S vssd1 vssd1 vccd1 vccd1 sky130_fd_sc_hd__diode_2
XFILLER_9_190 vssd1 vssd1 vccd1 vccd1 sky130_fd_sc_hd__fill_8
X_2608_ hold661/X _2607_/Y _2608_/S vssd1 vssd1 vccd1 vccd1 _3144_/D sky130_fd_sc_hd__mux2_1
X_2539_ _3224_/Q _2923_/A2 _2537_/X _2538_/X vssd1 vssd1 vccd1 vccd1 _2540_/B sky130_fd_sc_hd__a211o_2
XFILLER_75_307 vssd1 vccd1 vssd1 vccd1 sky130_ef_sc_hd__decap_40_12
XFILLER_57_38 vssd1 vssd1 vccd1 vccd1 sky130_fd_sc_hd__fill_4
XFILLER_73_15 vssd1 vccd1 vssd1 vccd1 sky130_ef_sc_hd__decap_40_12
XFILLER_43_237 vssd1 vssd1 vccd1 vccd1 sky130_fd_sc_hd__fill_2
XFILLER_24_462 vssd1 vssd1 vccd1 vccd1 sky130_fd_sc_hd__fill_4
XFILLER_51_281 vssd1 vssd1 vccd1 vccd1 sky130_fd_sc_hd__fill_1
XANTENNA__1676__S _1690_/S vssd1 vssd1 vccd1 vccd1 sky130_fd_sc_hd__diode_2
XFILLER_22_41 vssd1 vssd1 vccd1 vccd1 sky130_fd_sc_hd__fill_4
XFILLER_11_167 vssd1 vssd1 vccd1 vccd1 sky130_fd_sc_hd__fill_1
XFILLER_22_85 vssd1 vccd1 vssd1 vccd1 sky130_ef_sc_hd__decap_40_12
XFILLER_22_63 vssd1 vssd1 vccd1 vccd1 sky130_fd_sc_hd__fill_1
XANTENNA__2943__A2 _2967_/A2 vssd1 vssd1 vccd1 vccd1 sky130_fd_sc_hd__diode_2
Xfanout180 _3032_/Q vssd1 vssd1 vccd1 vccd1 _2279_/B sky130_fd_sc_hd__clkdlybuf4s25_1
Xfanout191 _3026_/Q vssd1 vssd1 vccd1 vccd1 _2025_/A sky130_fd_sc_hd__clkdlybuf4s25_1
XTAP_TAPCELL_ROW_77_825 vssd1 vccd1 sky130_fd_sc_hd__tapvpwrvgnd_1
XFILLER_78_189 vssd1 vssd1 vccd1 vccd1 sky130_fd_sc_hd__fill_1
XFILLER_14_9 vssd1 vssd1 vccd1 vccd1 sky130_fd_sc_hd__fill_1
XFILLER_19_256 vssd1 vssd1 vccd1 vccd1 sky130_fd_sc_hd__fill_1
X_2890_ _3263_/Q _2894_/A2 _2894_/B1 _3245_/Q _2889_/X vssd1 vssd1 vccd1 vccd1 _2890_/X
+ sky130_fd_sc_hd__a221o_2
X_1910_ _1911_/A _1912_/B vssd1 vssd1 vccd1 vccd1 _1910_/Y sky130_fd_sc_hd__nand2_2
XFILLER_30_421 vssd1 vssd1 vccd1 vccd1 sky130_fd_sc_hd__fill_2
X_1841_ _1841_/A _1841_/B vssd1 vssd1 vccd1 vccd1 _1842_/B sky130_fd_sc_hd__xnor2_2
X_1772_ _2384_/A hold496/X _1773_/S vssd1 vssd1 vccd1 vccd1 _3052_/D sky130_fd_sc_hd__mux2_1
XANTENNA__2934__A2 _2971_/A2 vssd1 vssd1 vccd1 vccd1 sky130_fd_sc_hd__diode_2
Xhold617 _3391_/Q vssd1 vssd1 vccd1 vccd1 hold617/X sky130_fd_sc_hd__dlygate4sd3_1
Xhold606 _3339_/Q vssd1 vssd1 vccd1 vccd1 hold606/X sky130_fd_sc_hd__dlygate4sd3_1
X_3442_ _3453_/CLK _3442_/D fanout284/X vssd1 vssd1 vccd1 vccd1 _3442_/Q sky130_fd_sc_hd__dfstp_2
Xhold639 _3186_/Q vssd1 vssd1 vccd1 vccd1 hold639/X sky130_fd_sc_hd__dlygate4sd3_1
Xhold628 _3195_/Q vssd1 vssd1 vccd1 vccd1 hold628/X sky130_fd_sc_hd__dlygate4sd3_1
X_3373_ _2996_/Y _3373_/D load_slew283/X vssd1 vssd1 vccd1 vccd1 _3449_/D sky130_fd_sc_hd__dfrtp_2
X_2324_ _2383_/B _2384_/B _2352_/B _2352_/C vssd1 vssd1 vccd1 vccd1 _2327_/A sky130_fd_sc_hd__nand4_2
X_2255_ _2255_/A _2255_/B _2279_/B _2318_/B vssd1 vssd1 vccd1 vccd1 _2258_/A sky130_fd_sc_hd__nand4_2
X_2186_ _2186_/A _2186_/B _2186_/C vssd1 vssd1 vccd1 vccd1 _2188_/B sky130_fd_sc_hd__or3_2
XTAP_TAPCELL_ROW_48_582 vssd1 vccd1 sky130_fd_sc_hd__tapvpwrvgnd_1
XANTENNA__2622__A1 _3404_/Q vssd1 vssd1 vccd1 vccd1 sky130_fd_sc_hd__diode_2
XFILLER_21_487 vssd1 vssd1 vccd1 vccd1 sky130_fd_sc_hd__fill_4
XANTENNA_fanout125_X _2957_/C vssd1 vssd1 vccd1 vccd1 sky130_fd_sc_hd__diode_2
XFILLER_48_307 vssd1 vssd1 vccd1 vccd1 sky130_fd_sc_hd__fill_1
XANTENNA__3034__RESET_B fanout228/X vssd1 vssd1 vccd1 vccd1 sky130_fd_sc_hd__diode_2
XTAP_TAPCELL_ROW_3_196 vssd1 vccd1 sky130_fd_sc_hd__tapvpwrvgnd_1
XFILLER_16_237 vssd1 vssd1 vccd1 vccd1 sky130_fd_sc_hd__fill_1
XFILLER_17_96 vssd1 vssd1 vccd1 vccd1 sky130_fd_sc_hd__fill_4
XANTENNA__2790__S _2799_/S vssd1 vssd1 vccd1 vccd1 sky130_fd_sc_hd__diode_2
XFILLER_24_270 vssd1 vssd1 vccd1 vccd1 sky130_fd_sc_hd__fill_1
XFILLER_8_403 vssd1 vssd1 vccd1 vccd1 sky130_fd_sc_hd__fill_1
XFILLER_12_454 vssd1 vssd1 vccd1 vccd1 sky130_fd_sc_hd__fill_1
XFILLER_79_421 vssd1 vccd1 vssd1 vccd1 sky130_ef_sc_hd__decap_40_12
XFILLER_79_465 vssd1 vssd1 vccd1 vccd1 sky130_fd_sc_hd__fill_8
XFILLER_58_70 vssd1 vssd1 vccd1 vccd1 sky130_fd_sc_hd__fill_2
X_2040_ _2040_/A _2040_/B vssd1 vssd1 vccd1 vccd1 _2063_/B sky130_fd_sc_hd__or2_2
XANTENNA_clkbuf_leaf_11_clk_A clkload2/A vssd1 vssd1 vccd1 vccd1 sky130_fd_sc_hd__diode_2
XANTENNA__2852__A1 _2638_/X vssd1 vssd1 vccd1 vccd1 sky130_fd_sc_hd__diode_2
XTAP_TAPCELL_ROW_45_552 vssd1 vccd1 sky130_fd_sc_hd__tapvpwrvgnd_1
XANTENNA_clkbuf_leaf_26_clk_A clkload3/A vssd1 vssd1 vccd1 vccd1 sky130_fd_sc_hd__diode_2
X_2942_ _2966_/A1 _3160_/Q _3304_/Q _2942_/B2 vssd1 vssd1 vccd1 vccd1 _2942_/X sky130_fd_sc_hd__a22o_2
X_2873_ _3333_/Q _2927_/A2 _2927_/B1 _3315_/Q _2872_/X vssd1 vssd1 vccd1 vccd1 _2873_/X
+ sky130_fd_sc_hd__a221o_2
X_1824_ _1824_/A _1824_/B vssd1 vssd1 vccd1 vccd1 _1824_/Y sky130_fd_sc_hd__xnor2_2
X_1755_ _2383_/B hold517/X _1773_/S vssd1 vssd1 vccd1 vccd1 _3035_/D sky130_fd_sc_hd__mux2_1
Xhold403 _1599_/X vssd1 vssd1 vccd1 vccd1 _3421_/D sky130_fd_sc_hd__dlygate4sd3_1
Xhold414 _3274_/Q vssd1 vssd1 vccd1 vccd1 hold414/X sky130_fd_sc_hd__dlygate4sd3_1
Xhold425 _3359_/Q vssd1 vssd1 vccd1 vccd1 hold425/X sky130_fd_sc_hd__dlygate4sd3_1
Xhold436 _3353_/Q vssd1 vssd1 vccd1 vccd1 hold436/X sky130_fd_sc_hd__dlygate4sd3_1
Xhold447 _3205_/Q vssd1 vssd1 vccd1 vccd1 hold447/X sky130_fd_sc_hd__dlygate4sd3_1
Xhold458 _3383_/Q vssd1 vssd1 vccd1 vccd1 hold458/X sky130_fd_sc_hd__dlygate4sd3_1
Xhold469 _3117_/Q vssd1 vssd1 vccd1 vccd1 hold469/X sky130_fd_sc_hd__dlygate4sd3_1
X_1686_ _1684_/Y _1686_/B vssd1 vssd1 vccd1 vccd1 _1689_/A sky130_fd_sc_hd__nand2b_2
X_3425_ _3429_/CLK _3425_/D load_slew225/X vssd1 vssd1 vccd1 vccd1 _3425_/Q sky130_fd_sc_hd__dfrtp_2
X_3356_ _3404_/CLK _3356_/D load_slew288/X vssd1 vssd1 vccd1 vccd1 _3356_/Q sky130_fd_sc_hd__dfrtp_2
X_3287_ _3287_/CLK _3287_/D load_slew234/X vssd1 vssd1 vccd1 vccd1 _3287_/Q sky130_fd_sc_hd__dfrtp_2
X_2307_ _2306_/A _2306_/C _2306_/B vssd1 vssd1 vccd1 vccd1 _2308_/A sky130_fd_sc_hd__o21a_2
XANTENNA_fanout287_A fanout289/X vssd1 vssd1 vccd1 vccd1 sky130_fd_sc_hd__diode_2
X_2238_ _2237_/B _2237_/C _2237_/A vssd1 vssd1 vccd1 vccd1 _2239_/B sky130_fd_sc_hd__a21o_2
XFILLER_57_159 vssd1 vssd1 vccd1 vccd1 sky130_fd_sc_hd__fill_1
XANTENNA__2843__A1 _2620_/X vssd1 vssd1 vccd1 vccd1 sky130_fd_sc_hd__diode_2
X_2169_ _2150_/A _2150_/B _2168_/X vssd1 vssd1 vccd1 vccd1 _2179_/A sky130_fd_sc_hd__o21a_2
XFILLER_53_332 vssd1 vssd1 vccd1 vccd1 sky130_fd_sc_hd__fill_1
XTAP_TAPCELL_ROW_0_166 vssd1 vccd1 sky130_fd_sc_hd__tapvpwrvgnd_1
XANTENNA_fanout242_X fanout242/X vssd1 vssd1 vccd1 vccd1 sky130_fd_sc_hd__diode_2
XFILLER_70_27 vssd1 vssd1 vccd1 vccd1 sky130_fd_sc_hd__fill_1
XFILLER_79_69 vssd1 vccd1 vssd1 vccd1 sky130_ef_sc_hd__decap_40_12
XFILLER_79_47 vssd1 vssd1 vccd1 vccd1 sky130_fd_sc_hd__fill_1
XTAP_TAPCELL_ROW_8_244 vssd1 vccd1 sky130_fd_sc_hd__tapvpwrvgnd_1
XANTENNA__2531__B1 _2894_/B1 vssd1 vssd1 vccd1 vccd1 sky130_fd_sc_hd__diode_2
XANTENNA__2638__X _2638_/X vssd1 vssd1 vccd1 vccd1 sky130_fd_sc_hd__diode_2
XANTENNA__2785__S _2798_/S vssd1 vssd1 vccd1 vccd1 sky130_fd_sc_hd__diode_2
XTAP_TAPCELL_ROW_59_677 vssd1 vccd1 sky130_fd_sc_hd__tapvpwrvgnd_1
XFILLER_28_62 vssd1 vssd1 vccd1 vccd1 sky130_fd_sc_hd__fill_2
XFILLER_44_365 vssd1 vssd1 vccd1 vccd1 sky130_fd_sc_hd__fill_1
XTAP_TAPCELL_ROW_42_533 vssd1 vccd1 sky130_fd_sc_hd__tapvpwrvgnd_1
XANTENNA__2533__B _2533_/B vssd1 vssd1 vccd1 vccd1 sky130_fd_sc_hd__diode_2
XFILLER_8_255 vssd1 vssd1 vccd1 vccd1 sky130_fd_sc_hd__fill_2
XFILLER_12_295 vssd1 vssd1 vccd1 vccd1 sky130_fd_sc_hd__fill_2
XFILLER_60_60 vssd1 vccd1 vssd1 vccd1 sky130_ef_sc_hd__decap_40_12
X_1540_ _3384_/Q _3456_/Q _1546_/S vssd1 vssd1 vccd1 vccd1 _3457_/D sky130_fd_sc_hd__mux2_1
X_3210_ _3392_/CLK _3210_/D load_slew240/X vssd1 vssd1 vccd1 vccd1 _3210_/Q sky130_fd_sc_hd__dfrtp_2
XFILLER_79_251 vssd1 vssd1 vccd1 vccd1 sky130_fd_sc_hd__fill_1
XANTENNA__2695__S _2700_/S vssd1 vssd1 vccd1 vccd1 sky130_fd_sc_hd__diode_2
X_3141_ _3472_/CLK _3141_/D fanout271/X vssd1 vssd1 vccd1 vccd1 _3141_/Q sky130_fd_sc_hd__dfrtp_2
XFILLER_39_104 vssd1 vssd1 vccd1 vccd1 sky130_fd_sc_hd__fill_8
XFILLER_79_295 vssd1 vssd1 vccd1 vccd1 sky130_fd_sc_hd__fill_1
XFILLER_10_3 vssd1 vssd1 vccd1 vccd1 sky130_fd_sc_hd__fill_4
X_3072_ _3119_/CLK _3072_/D vssd1 vssd1 vccd1 vccd1 _3072_/Q sky130_fd_sc_hd__dfxtp_2
X_2023_ hold473/X _2022_/Y _2412_/S vssd1 vssd1 vccd1 vccd1 _3064_/D sky130_fd_sc_hd__mux2_1
X_2925_ _3338_/Q _2927_/A2 _2927_/B1 _3320_/Q _2924_/X vssd1 vssd1 vccd1 vccd1 _2925_/X
+ sky130_fd_sc_hd__a221o_2
X_2856_ hold598/X _2646_/X _2856_/S vssd1 vssd1 vccd1 vccd1 _3360_/D sky130_fd_sc_hd__mux2_1
X_1807_ _1807_/A _1833_/A _1807_/C vssd1 vssd1 vccd1 vccd1 _1834_/A sky130_fd_sc_hd__nand3_2
X_2787_ hold551/X _2622_/X _2798_/S vssd1 vssd1 vccd1 vccd1 _3294_/D sky130_fd_sc_hd__mux2_1
X_1738_ hold704/X _1737_/Y _1738_/S vssd1 vssd1 vccd1 vccd1 _3020_/D sky130_fd_sc_hd__mux2_1
X_1669_ hold558/X _1668_/Y _1690_/S vssd1 vssd1 vccd1 vccd1 _3009_/D sky130_fd_sc_hd__mux2_1
X_3408_ _3453_/CLK _3408_/D load_slew286/X vssd1 vssd1 vccd1 vccd1 _3408_/Q sky130_fd_sc_hd__dfrtp_2
XTAP_TAPCELL_ROW_5_214 vssd1 vccd1 sky130_fd_sc_hd__tapvpwrvgnd_1
X_3339_ _3395_/CLK _3339_/D fanout243/X vssd1 vssd1 vccd1 vccd1 _3339_/Q sky130_fd_sc_hd__dfrtp_2
XTAP_TAPCELL_ROW_56_647 vssd1 vccd1 sky130_fd_sc_hd__tapvpwrvgnd_1
XFILLER_73_449 vssd1 vssd1 vccd1 vccd1 sky130_fd_sc_hd__fill_1
XFILLER_53_162 vssd1 vssd1 vccd1 vccd1 sky130_fd_sc_hd__fill_1
XFILLER_14_97 vssd1 vssd1 vccd1 vccd1 sky130_fd_sc_hd__fill_4
XFILLER_5_225 vssd1 vssd1 vccd1 vccd1 sky130_fd_sc_hd__fill_2
XFILLER_30_85 vssd1 vssd1 vccd1 vccd1 sky130_fd_sc_hd__fill_4
XFILLER_76_243 vssd1 vssd1 vccd1 vccd1 sky130_fd_sc_hd__fill_8
XFILLER_39_61 vssd1 vssd1 vccd1 vccd1 sky130_fd_sc_hd__fill_1
XFILLER_39_94 vssd1 vssd1 vccd1 vccd1 sky130_fd_sc_hd__fill_2
XFILLER_57_490 vssd1 vssd1 vccd1 vccd1 sky130_fd_sc_hd__fill_4
XFILLER_17_321 vssd1 vssd1 vccd1 vccd1 sky130_fd_sc_hd__fill_4
XFILLER_17_310 vssd1 vssd1 vccd1 vccd1 sky130_fd_sc_hd__fill_8
XFILLER_55_82 vssd1 vssd1 vccd1 vccd1 sky130_fd_sc_hd__fill_4
XFILLER_44_195 vssd1 vssd1 vccd1 vccd1 sky130_fd_sc_hd__fill_1
X_2710_ hold600/X _2805_/A1 _2723_/S vssd1 vssd1 vccd1 vccd1 _3221_/D sky130_fd_sc_hd__mux2_1
X_2641_ hold692/X _2815_/A1 _2645_/S vssd1 vssd1 vccd1 vccd1 _3159_/D sky130_fd_sc_hd__mux2_1
XTAP_TAPCELL_ROW_10_260 vssd1 vccd1 sky130_fd_sc_hd__tapvpwrvgnd_1
X_2572_ hold658/X _1622_/C _2583_/B1 hold691/X vssd1 vssd1 vccd1 vccd1 _3124_/D sky130_fd_sc_hd__a22o_2
XFILLER_58_3 vssd1 vssd1 vccd1 vccd1 sky130_fd_sc_hd__fill_8
X_1523_ _3362_/Q _3447_/D _1525_/S vssd1 vssd1 vccd1 vccd1 _3371_/D sky130_fd_sc_hd__mux2_1
XANTENNA__2438__B _2533_/B vssd1 vssd1 vccd1 vccd1 sky130_fd_sc_hd__diode_2
X_3124_ _3436_/CLK _3124_/D load_slew227/X vssd1 vssd1 vccd1 vccd1 _3124_/Q sky130_fd_sc_hd__dfrtp_2
XFILLER_67_254 vssd1 vssd1 vccd1 vccd1 sky130_fd_sc_hd__fill_2
X_3055_ _3112_/CLK _3055_/D vssd1 vssd1 vccd1 vccd1 _3055_/Q sky130_fd_sc_hd__dfxtp_2
X_2006_ _2005_/A _2005_/C _2029_/C _2029_/A vssd1 vssd1 vccd1 vccd1 _2007_/B sky130_fd_sc_hd__a22o_2
XFILLER_23_313 vssd1 vssd1 vccd1 vccd1 sky130_fd_sc_hd__fill_2
XFILLER_63_493 vssd1 vssd1 vccd1 vccd1 sky130_fd_sc_hd__fill_1
X_2908_ hold719/X _2864_/S _2907_/X vssd1 vssd1 vccd1 vccd1 _3392_/D sky130_fd_sc_hd__o21a_2
XTAP_TAPCELL_ROW_61_694 vssd1 vccd1 sky130_fd_sc_hd__tapvpwrvgnd_1
XANTENNA__2982__A0 _3406_/Q vssd1 vssd1 vccd1 vccd1 sky130_fd_sc_hd__diode_2
X_2839_ hold528/X _2839_/A1 _2852_/S vssd1 vssd1 vccd1 vccd1 _3343_/D sky130_fd_sc_hd__mux2_1
XANTENNA__3435__D _3435_/D vssd1 vssd1 vccd1 vccd1 sky130_fd_sc_hd__diode_2
XANTENNA_fanout65_A _2901_/B1 vssd1 vssd1 vccd1 vccd1 sky130_fd_sc_hd__diode_2
XTAP_TAPCELL_ROW_69_761 vssd1 vccd1 sky130_fd_sc_hd__tapvpwrvgnd_1
XFILLER_58_298 vssd1 vssd1 vccd1 vccd1 sky130_fd_sc_hd__fill_1
XFILLER_46_449 vssd1 vssd1 vccd1 vccd1 sky130_fd_sc_hd__fill_1
Xclkbuf_leaf_38_clk clkbuf_leaf_2_clk/A vssd1 vssd1 vccd1 vccd1 clkload8/A sky130_fd_sc_hd__clkbuf_8
XFILLER_73_246 vssd1 vssd1 vccd1 vccd1 sky130_fd_sc_hd__fill_8
XANTENNA__2265__A2 _2326_/B vssd1 vssd1 vccd1 vccd1 sky130_fd_sc_hd__diode_2
XTAP_TAPCELL_ROW_16_308 vssd1 vccd1 sky130_fd_sc_hd__tapvpwrvgnd_1
XFILLER_54_471 vssd1 vssd1 vccd1 vccd1 sky130_fd_sc_hd__fill_2
XFILLER_54_493 vssd1 vssd1 vccd1 vccd1 sky130_fd_sc_hd__fill_1
XANTENNA_fanout20_X _2776_/S vssd1 vssd1 vccd1 vccd1 sky130_fd_sc_hd__diode_2
XFILLER_25_74 vssd1 vssd1 vccd1 vccd1 sky130_fd_sc_hd__fill_2
XTAP_TAPCELL_ROW_24_374 vssd1 vccd1 sky130_fd_sc_hd__tapvpwrvgnd_1
XFILLER_37_449 vssd1 vssd1 vccd1 vccd1 sky130_fd_sc_hd__fill_1
Xclkbuf_leaf_29_clk clkload3/A vssd1 vssd1 vccd1 vccd1 _3398_/CLK sky130_fd_sc_hd__clkbuf_8
XANTENNA__2256__A2 _2279_/B vssd1 vssd1 vccd1 vccd1 sky130_fd_sc_hd__diode_2
XFILLER_17_151 vssd1 vssd1 vccd1 vccd1 sky130_fd_sc_hd__fill_4
XFILLER_32_165 vssd1 vssd1 vccd1 vccd1 sky130_fd_sc_hd__fill_1
XANTENNA__3389__RESET_B fanout279/X vssd1 vssd1 vccd1 vccd1 sky130_fd_sc_hd__diode_2
X_2624_ _3405_/Q _2610_/A _2644_/B _3128_/Q vssd1 vssd1 vccd1 vccd1 _2624_/X sky130_fd_sc_hd__a22o_2
X_2555_ hold483/X _2489_/X _2559_/S vssd1 vssd1 vccd1 vccd1 _3109_/D sky130_fd_sc_hd__mux2_1
X_2486_ _3220_/Q _2923_/A2 _2485_/X _2520_/A vssd1 vssd1 vccd1 vccd1 _2486_/X sky130_fd_sc_hd__a22o_2
X_1506_ _3443_/Q vssd1 vssd1 vccd1 vccd1 _1506_/Y sky130_fd_sc_hd__inv_2
XANTENNA__2449__A _2533_/A vssd1 vssd1 vccd1 vccd1 sky130_fd_sc_hd__diode_2
XANTENNA__2495__A2 _2967_/A2 vssd1 vssd1 vccd1 vccd1 sky130_fd_sc_hd__diode_2
X_3107_ clkload8/A _3107_/D load_slew210/X vssd1 vssd1 vccd1 vccd1 _3107_/Q sky130_fd_sc_hd__dfrtp_2
XFILLER_46_29 vssd1 vccd1 vssd1 vccd1 sky130_ef_sc_hd__decap_40_12
XTAP_TAPCELL_ROW_66_731 vssd1 vccd1 sky130_fd_sc_hd__tapvpwrvgnd_1
X_3038_ _3112_/CLK _3038_/D wire208/X vssd1 vssd1 vccd1 vccd1 _3038_/Q sky130_fd_sc_hd__dfrtp_2
XANTENNA__2184__A _2263_/A vssd1 vssd1 vccd1 vccd1 sky130_fd_sc_hd__diode_2
XANTENNA_fanout155_X _2154_/B vssd1 vssd1 vccd1 vccd1 sky130_fd_sc_hd__diode_2
XTAP_TAPCELL_ROW_38_499 vssd1 vccd1 sky130_fd_sc_hd__tapvpwrvgnd_1
XFILLER_51_430 vssd1 vssd1 vccd1 vccd1 sky130_fd_sc_hd__fill_4
XFILLER_78_305 vssd1 vssd1 vccd1 vccd1 sky130_fd_sc_hd__fill_2
XANTENNA__2486__A2 _2923_/A2 vssd1 vssd1 vccd1 vccd1 sky130_fd_sc_hd__diode_2
XANTENNA__2793__S _2798_/S vssd1 vssd1 vccd1 vccd1 sky130_fd_sc_hd__diode_2
XTAP_TAPCELL_ROW_29_422 vssd1 vccd1 sky130_fd_sc_hd__tapvpwrvgnd_1
XFILLER_14_121 vssd1 vssd1 vccd1 vccd1 sky130_fd_sc_hd__fill_4
XANTENNA__1997__A1 _2025_/A vssd1 vssd1 vccd1 vccd1 sky130_fd_sc_hd__diode_2
XFILLER_6_375 vssd1 vssd1 vccd1 vccd1 sky130_fd_sc_hd__fill_1
X_2340_ _2340_/A _2340_/B vssd1 vssd1 vccd1 vccd1 _2343_/B sky130_fd_sc_hd__xnor2_2
X_2271_ _2272_/A _2272_/B vssd1 vssd1 vccd1 vccd1 _2273_/A sky130_fd_sc_hd__or2_2
XFILLER_69_327 vssd1 vssd1 vccd1 vccd1 sky130_fd_sc_hd__fill_4
XFILLER_77_91 vssd1 vssd1 vccd1 vccd1 sky130_fd_sc_hd__fill_1
XFILLER_18_493 vssd1 vssd1 vccd1 vccd1 sky130_fd_sc_hd__fill_1
XTAP_TAPCELL_ROW_35_469 vssd1 vccd1 sky130_fd_sc_hd__tapvpwrvgnd_1
XANTENNA__2154__D _2383_/B vssd1 vssd1 vccd1 vccd1 sky130_fd_sc_hd__diode_2
X_1986_ _1986_/A _1986_/B vssd1 vssd1 vccd1 vccd1 _1989_/B sky130_fd_sc_hd__xnor2_2
Xclkbuf_leaf_9_clk clkload2/A vssd1 vssd1 vccd1 vccd1 _3436_/CLK sky130_fd_sc_hd__clkbuf_8
X_2607_ _3444_/Q _3439_/Q vssd1 vssd1 vccd1 vccd1 _2607_/Y sky130_fd_sc_hd__nor2_2
X_2538_ _2781_/B _2532_/X _2536_/X _2445_/S vssd1 vssd1 vccd1 vccd1 _2538_/X sky130_fd_sc_hd__a22o_2
X_2469_ _2611_/A _3147_/Q _3291_/Q _2800_/A vssd1 vssd1 vccd1 vccd1 _2469_/X sky130_fd_sc_hd__a22o_2
XFILLER_75_319 vssd1 vssd1 vccd1 vccd1 sky130_fd_sc_hd__fill_8
XANTENNA__2468__A2 _2667_/B vssd1 vssd1 vccd1 vccd1 sky130_fd_sc_hd__diode_2
XFILLER_73_27 vssd1 vccd1 vssd1 vccd1 sky130_ef_sc_hd__decap_40_12
XFILLER_16_419 vssd1 vssd1 vccd1 vccd1 sky130_fd_sc_hd__fill_1
XANTENNA__1957__S _1993_/S vssd1 vssd1 vccd1 vccd1 sky130_fd_sc_hd__diode_2
XFILLER_11_113 vssd1 vssd1 vccd1 vccd1 sky130_fd_sc_hd__fill_2
XFILLER_51_293 vssd1 vssd1 vccd1 vccd1 sky130_fd_sc_hd__fill_1
XFILLER_22_53 vssd1 vssd1 vccd1 vccd1 sky130_fd_sc_hd__fill_8
XANTENNA__2788__S _2798_/S vssd1 vssd1 vccd1 vccd1 sky130_fd_sc_hd__diode_2
XFILLER_3_334 vssd1 vssd1 vccd1 vccd1 sky130_fd_sc_hd__fill_2
XANTENNA__2459__A2 _2894_/A2 vssd1 vssd1 vccd1 vccd1 sky130_fd_sc_hd__diode_2
Xfanout170 _3038_/Q vssd1 vssd1 vccd1 vccd1 _1906_/A sky130_fd_sc_hd__clkdlybuf4s25_1
Xfanout181 _3032_/Q vssd1 vssd1 vccd1 vccd1 _2146_/B sky130_fd_sc_hd__clkdlybuf4s25_1
Xfanout192 _3026_/Q vssd1 vssd1 vccd1 vccd1 _1865_/B sky130_fd_sc_hd__clkdlybuf4s25_1
XTAP_TAPCELL_ROW_77_826 vssd1 vccd1 sky130_fd_sc_hd__tapvpwrvgnd_1
XFILLER_47_50 vssd1 vssd1 vccd1 vccd1 sky130_fd_sc_hd__fill_4
XANTENNA__2255__C _2279_/B vssd1 vssd1 vccd1 vccd1 sky130_fd_sc_hd__diode_2
Xclkbuf_3_4__f_clk clkbuf_0_clk/X vssd1 vssd1 vccd1 vccd1 clkbuf_3_4__f_clk/X sky130_fd_sc_hd__clkbuf_16
XFILLER_30_411 vssd1 vssd1 vccd1 vccd1 sky130_fd_sc_hd__fill_1
X_1840_ _1884_/A _1839_/X _1856_/A vssd1 vssd1 vccd1 vccd1 _1841_/B sky130_fd_sc_hd__a21bo_2
XFILLER_30_444 vssd1 vssd1 vccd1 vccd1 sky130_fd_sc_hd__fill_4
X_1771_ _2352_/B hold560/X _1771_/S vssd1 vssd1 vccd1 vccd1 _3051_/D sky130_fd_sc_hd__mux2_1
Xhold618 _3226_/Q vssd1 vssd1 vccd1 vccd1 hold618/X sky130_fd_sc_hd__dlygate4sd3_1
Xhold607 _3332_/Q vssd1 vssd1 vccd1 vccd1 hold607/X sky130_fd_sc_hd__dlygate4sd3_1
XFILLER_6_161 vssd1 vccd1 vssd1 vccd1 sky130_ef_sc_hd__decap_40_12
XANTENNA__2698__S _2704_/S vssd1 vssd1 vccd1 vccd1 sky130_fd_sc_hd__diode_2
X_3441_ _3441_/CLK _3441_/D fanout268/X vssd1 vssd1 vccd1 vccd1 _3441_/Q sky130_fd_sc_hd__dfrtp_2
Xhold629 _3304_/Q vssd1 vssd1 vccd1 vccd1 hold629/X sky130_fd_sc_hd__dlygate4sd3_1
X_3372_ _2995_/Y _3372_/D load_slew283/X vssd1 vssd1 vccd1 vccd1 _3448_/D sky130_fd_sc_hd__dfrtp_2
XFILLER_40_3 vssd1 vssd1 vccd1 vccd1 sky130_fd_sc_hd__fill_8
X_2323_ _3037_/Q _2284_/B _2287_/B _2285_/X vssd1 vssd1 vccd1 vccd1 _2330_/A sky130_fd_sc_hd__a31oi_2
XFILLER_69_113 vssd1 vccd1 vssd1 vccd1 sky130_ef_sc_hd__decap_40_12
X_2254_ _2221_/A _2221_/C _2221_/B vssd1 vssd1 vccd1 vccd1 _2261_/A sky130_fd_sc_hd__a21bo_2
X_2185_ _2263_/A _2264_/A _2284_/B _2257_/A vssd1 vssd1 vccd1 vccd1 _2186_/C sky130_fd_sc_hd__a22oi_2
XTAP_TAPCELL_ROW_48_583 vssd1 vccd1 sky130_fd_sc_hd__tapvpwrvgnd_1
XFILLER_25_227 vssd1 vssd1 vccd1 vccd1 sky130_fd_sc_hd__fill_1
XFILLER_40_208 vssd1 vssd1 vccd1 vccd1 sky130_fd_sc_hd__fill_2
XANTENNA__2622__A2 _2610_/A vssd1 vssd1 vccd1 vccd1 sky130_fd_sc_hd__diode_2
XFILLER_33_260 vssd1 vssd1 vccd1 vccd1 sky130_fd_sc_hd__fill_1
XANTENNA__2181__B _2326_/B vssd1 vssd1 vccd1 vccd1 sky130_fd_sc_hd__diode_2
X_1969_ _1967_/X _1969_/B vssd1 vssd1 vccd1 vccd1 _1971_/A sky130_fd_sc_hd__nand2b_2
XANTENNA_fanout118_X _2800_/A vssd1 vssd1 vccd1 vccd1 sky130_fd_sc_hd__diode_2
XFILLER_68_27 vssd1 vssd1 vccd1 vccd1 sky130_fd_sc_hd__fill_1
XFILLER_0_337 vssd1 vssd1 vccd1 vccd1 sky130_fd_sc_hd__fill_4
XFILLER_75_149 vssd1 vssd1 vccd1 vccd1 sky130_fd_sc_hd__fill_2
XFILLER_56_363 vssd1 vssd1 vccd1 vccd1 sky130_fd_sc_hd__fill_1
XTAP_TAPCELL_ROW_3_197 vssd1 vccd1 sky130_fd_sc_hd__tapvpwrvgnd_1
XFILLER_12_433 vssd1 vssd1 vccd1 vccd1 sky130_fd_sc_hd__fill_1
XANTENNA__2091__B _2091_/B vssd1 vssd1 vccd1 vccd1 sky130_fd_sc_hd__diode_2
XFILLER_79_433 vssd1 vccd1 vssd1 vccd1 sky130_ef_sc_hd__decap_40_12
XFILLER_3_197 vssd1 vssd1 vccd1 vccd1 sky130_fd_sc_hd__fill_1
XFILLER_58_93 vssd1 vssd1 vccd1 vccd1 sky130_fd_sc_hd__fill_2
XFILLER_12_7 vssd1 vssd1 vccd1 vccd1 sky130_fd_sc_hd__fill_2
XTAP_TAPCELL_ROW_45_553 vssd1 vccd1 sky130_fd_sc_hd__tapvpwrvgnd_1
XFILLER_62_355 vssd1 vssd1 vccd1 vccd1 sky130_fd_sc_hd__fill_1
X_2941_ hold721/X _2864_/S _2935_/X _2940_/X vssd1 vssd1 vccd1 vccd1 _3395_/D sky130_fd_sc_hd__o22a_2
XFILLER_15_260 vssd1 vccd1 vssd1 vccd1 sky130_ef_sc_hd__decap_40_12
X_2872_ _2924_/B _2924_/C _3351_/Q vssd1 vssd1 vccd1 vccd1 _2872_/X sky130_fd_sc_hd__and3_2
X_1823_ _1821_/Y _1823_/B vssd1 vssd1 vccd1 vccd1 _1824_/B sky130_fd_sc_hd__and2b_2
X_1754_ _2347_/A hold570/X _1771_/S vssd1 vssd1 vccd1 vccd1 _3034_/D sky130_fd_sc_hd__mux2_1
Xhold404 _3357_/Q vssd1 vssd1 vccd1 vccd1 hold404/X sky130_fd_sc_hd__dlygate4sd3_1
Xhold415 _3066_/Q vssd1 vssd1 vccd1 vccd1 hold415/X sky130_fd_sc_hd__dlygate4sd3_1
Xhold426 _3349_/Q vssd1 vssd1 vccd1 vccd1 hold426/X sky130_fd_sc_hd__dlygate4sd3_1
XFILLER_7_492 vssd1 vssd1 vccd1 vccd1 sky130_fd_sc_hd__fill_2
X_3424_ _3429_/CLK _3424_/D load_slew225/X vssd1 vssd1 vccd1 vccd1 _3424_/Q sky130_fd_sc_hd__dfrtp_2
Xhold437 _3398_/Q vssd1 vssd1 vccd1 vccd1 hold437/X sky130_fd_sc_hd__dlygate4sd3_1
Xhold448 _3381_/Q vssd1 vssd1 vccd1 vccd1 hold448/X sky130_fd_sc_hd__dlygate4sd3_1
Xhold459 _3200_/Q vssd1 vssd1 vccd1 vccd1 hold459/X sky130_fd_sc_hd__dlygate4sd3_1
X_1685_ _3079_/Q _3062_/Q vssd1 vssd1 vccd1 vccd1 _1686_/B sky130_fd_sc_hd__nand2_2
X_3355_ _3392_/CLK _3355_/D load_slew253/X vssd1 vssd1 vccd1 vccd1 _3355_/Q sky130_fd_sc_hd__dfrtp_2
X_3286_ _3397_/CLK _3286_/D load_slew248/X vssd1 vssd1 vccd1 vccd1 _3286_/Q sky130_fd_sc_hd__dfrtp_2
X_2306_ _2306_/A _2306_/B _2306_/C vssd1 vssd1 vccd1 vccd1 _2309_/A sky130_fd_sc_hd__or3_2
X_2237_ _2237_/A _2237_/B _2237_/C vssd1 vssd1 vccd1 vccd1 _2237_/X sky130_fd_sc_hd__and3_2
XFILLER_72_108 vssd1 vccd1 vssd1 vccd1 sky130_ef_sc_hd__decap_40_12
XFILLER_38_363 vssd1 vssd1 vccd1 vccd1 sky130_fd_sc_hd__fill_1
X_2168_ _2150_/A _2150_/B _2151_/A vssd1 vssd1 vccd1 vccd1 _2168_/X sky130_fd_sc_hd__a21o_2
X_2099_ _2124_/A _2263_/A _2297_/A _2154_/B vssd1 vssd1 vccd1 vccd1 _2107_/A sky130_fd_sc_hd__and4_2
XTAP_TAPCELL_ROW_0_167 vssd1 vccd1 sky130_fd_sc_hd__tapvpwrvgnd_1
XANTENNA__2904__B _2970_/C vssd1 vssd1 vccd1 vccd1 sky130_fd_sc_hd__diode_2
XANTENNA__2359__A1 _2347_/A vssd1 vssd1 vccd1 vccd1 sky130_fd_sc_hd__diode_2
XPHY_EDGE_ROW_17_Right_17 vssd1 vssd1 vccd1 vccd1 sky130_fd_sc_hd__decap_3
XFILLER_21_285 vssd1 vssd1 vccd1 vccd1 sky130_fd_sc_hd__fill_2
XANTENNA_fanout95_A _2923_/B2 vssd1 vssd1 vccd1 vccd1 sky130_fd_sc_hd__diode_2
XPHY_EDGE_ROW_26_Right_26 vssd1 vssd1 vccd1 vccd1 sky130_fd_sc_hd__decap_3
XFILLER_0_167 vssd1 vssd1 vccd1 vccd1 sky130_fd_sc_hd__fill_1
XFILLER_28_41 vssd1 vssd1 vccd1 vccd1 sky130_fd_sc_hd__fill_1
XFILLER_63_119 vssd1 vssd1 vccd1 vccd1 sky130_fd_sc_hd__fill_1
XFILLER_44_62 vssd1 vssd1 vccd1 vccd1 sky130_fd_sc_hd__fill_1
XPHY_EDGE_ROW_35_Right_35 vssd1 vssd1 vccd1 vccd1 sky130_fd_sc_hd__decap_3
XFILLER_60_72 vssd1 vssd1 vccd1 vccd1 sky130_fd_sc_hd__fill_2
XPHY_EDGE_ROW_44_Right_44 vssd1 vssd1 vccd1 vccd1 sky130_fd_sc_hd__decap_3
X_3140_ _3472_/CLK _3140_/D fanout271/X vssd1 vssd1 vccd1 vccd1 _3140_/Q sky130_fd_sc_hd__dfrtp_2
XFILLER_67_447 vssd1 vssd1 vccd1 vccd1 sky130_fd_sc_hd__fill_1
X_3071_ _3119_/CLK _3071_/D vssd1 vssd1 vccd1 vccd1 _3071_/Q sky130_fd_sc_hd__dfxtp_2
XANTENNA__2286__B1 _2326_/B vssd1 vssd1 vccd1 vccd1 sky130_fd_sc_hd__diode_2
X_2022_ _2022_/A _2022_/B vssd1 vssd1 vccd1 vccd1 _2022_/Y sky130_fd_sc_hd__xnor2_2
XFILLER_62_141 vssd1 vssd1 vccd1 vccd1 sky130_fd_sc_hd__fill_4
XPHY_EDGE_ROW_53_Right_53 vssd1 vssd1 vccd1 vccd1 sky130_fd_sc_hd__decap_3
X_2924_ _3356_/Q _2924_/B _2924_/C vssd1 vssd1 vccd1 vccd1 _2924_/X sky130_fd_sc_hd__and3_2
X_2855_ hold425/X _2644_/X _2856_/S vssd1 vssd1 vccd1 vccd1 _3359_/D sky130_fd_sc_hd__mux2_1
X_1806_ _1805_/A _1862_/A _1862_/B _1805_/B vssd1 vssd1 vccd1 vccd1 _1807_/C sky130_fd_sc_hd__a22o_2
XTAP_TAPCELL_ROW_13_280 vssd1 vccd1 sky130_fd_sc_hd__tapvpwrvgnd_1
X_2786_ hold648/X _2805_/A1 _2798_/S vssd1 vssd1 vccd1 vccd1 _3293_/D sky130_fd_sc_hd__mux2_1
X_1737_ _1737_/A _1737_/B vssd1 vssd1 vccd1 vccd1 _1737_/Y sky130_fd_sc_hd__xnor2_2
X_1668_ _1668_/A _1668_/B vssd1 vssd1 vccd1 vccd1 _1668_/Y sky130_fd_sc_hd__xnor2_2
XPHY_EDGE_ROW_62_Right_62 vssd1 vssd1 vccd1 vccd1 sky130_fd_sc_hd__decap_3
X_3407_ _3441_/CLK _3407_/D fanout268/X vssd1 vssd1 vccd1 vccd1 _3407_/Q sky130_fd_sc_hd__dfrtp_2
XANTENNA__2513__A1 _2961_/A1 vssd1 vssd1 vccd1 vccd1 sky130_fd_sc_hd__diode_2
XANTENNA__2513__B2 _2962_/A1 vssd1 vssd1 vccd1 vccd1 sky130_fd_sc_hd__diode_2
X_3338_ _3404_/CLK _3338_/D load_slew288/X vssd1 vssd1 vccd1 vccd1 _3338_/Q sky130_fd_sc_hd__dfrtp_2
X_1599_ _3421_/Q _1621_/A hold402/X vssd1 vssd1 vccd1 vccd1 _1599_/X sky130_fd_sc_hd__a21o_2
XTAP_TAPCELL_ROW_5_215 vssd1 vccd1 sky130_fd_sc_hd__tapvpwrvgnd_1
X_3269_ _3287_/CLK _3269_/D load_slew234/X vssd1 vssd1 vccd1 vccd1 _3269_/Q sky130_fd_sc_hd__dfrtp_2
XFILLER_73_428 vssd1 vssd1 vccd1 vccd1 sky130_fd_sc_hd__fill_4
XFILLER_26_322 vssd1 vssd1 vccd1 vccd1 sky130_fd_sc_hd__fill_4
XFILLER_26_300 vssd1 vssd1 vccd1 vccd1 sky130_fd_sc_hd__fill_4
XTAP_TAPCELL_ROW_56_648 vssd1 vccd1 sky130_fd_sc_hd__tapvpwrvgnd_1
XPHY_EDGE_ROW_71_Right_71 vssd1 vssd1 vccd1 vccd1 sky130_fd_sc_hd__decap_3
XFILLER_53_174 vssd1 vccd1 vssd1 vccd1 sky130_ef_sc_hd__decap_40_12
XANTENNA__2634__B _2644_/B vssd1 vssd1 vccd1 vccd1 sky130_fd_sc_hd__diode_2
XANTENNA_clkbuf_leaf_10_clk_A clkload1/A vssd1 vssd1 vccd1 vccd1 sky130_fd_sc_hd__diode_2
XFILLER_30_42 vssd1 vssd1 vccd1 vccd1 sky130_fd_sc_hd__fill_2
XANTENNA_fanout98_X _2421_/B vssd1 vssd1 vccd1 vccd1 sky130_fd_sc_hd__diode_2
XANTENNA__2796__S _2798_/S vssd1 vssd1 vccd1 vccd1 sky130_fd_sc_hd__diode_2
XANTENNA_clkbuf_leaf_25_clk_A clkbuf_3_4__f_clk/X vssd1 vssd1 vccd1 vccd1 sky130_fd_sc_hd__diode_2
XFILLER_76_233 vssd1 vssd1 vccd1 vccd1 sky130_fd_sc_hd__fill_2
XFILLER_76_211 vssd1 vssd1 vccd1 vccd1 sky130_fd_sc_hd__fill_1
XFILLER_44_174 vssd1 vssd1 vccd1 vccd1 sky130_fd_sc_hd__fill_1
XFILLER_44_152 vssd1 vccd1 vssd1 vccd1 sky130_ef_sc_hd__decap_40_12
XFILLER_17_366 vssd1 vssd1 vccd1 vccd1 sky130_fd_sc_hd__fill_1
XFILLER_32_369 vssd1 vssd1 vccd1 vccd1 sky130_fd_sc_hd__fill_2
X_2640_ _3136_/Q _2644_/B vssd1 vssd1 vccd1 vccd1 _2640_/X sky130_fd_sc_hd__and2_2
XTAP_TAPCELL_ROW_10_261 vssd1 vccd1 sky130_fd_sc_hd__tapvpwrvgnd_1
X_2571_ hold619/X _1622_/C _2583_/B1 hold672/X vssd1 vssd1 vccd1 vccd1 _3123_/D sky130_fd_sc_hd__a22o_2
X_1522_ _3363_/Q _3448_/D _1525_/S vssd1 vssd1 vccd1 vccd1 _3372_/D sky130_fd_sc_hd__mux2_1
X_3123_ _3343_/CLK _3123_/D wire222/X vssd1 vssd1 vccd1 vccd1 _3123_/Q sky130_fd_sc_hd__dfrtp_2
X_3054_ _3112_/CLK _3054_/D vssd1 vssd1 vccd1 vccd1 _3054_/Q sky130_fd_sc_hd__dfxtp_2
X_2005_ _2005_/A _2029_/A _2005_/C _2029_/C vssd1 vssd1 vccd1 vccd1 _2007_/A sky130_fd_sc_hd__nand4_2
XFILLER_35_163 vssd1 vssd1 vccd1 vccd1 sky130_fd_sc_hd__fill_4
XFILLER_35_185 vssd1 vssd1 vccd1 vccd1 sky130_fd_sc_hd__fill_1
X_2907_ _2942_/B2 _2901_/X _2905_/X _2966_/A1 _2906_/X vssd1 vssd1 vccd1 vccd1 _2907_/X
+ sky130_fd_sc_hd__a221o_2
XANTENNA__2470__A _2472_/A vssd1 vssd1 vccd1 vccd1 sky130_fd_sc_hd__diode_2
X_2838_ _2838_/A _2838_/B _2838_/C vssd1 vssd1 vccd1 vccd1 _2838_/X sky130_fd_sc_hd__and3_2
X_2769_ hold472/X _2624_/X _2780_/S vssd1 vssd1 vccd1 vccd1 _3277_/D sky130_fd_sc_hd__mux2_1
XANTENNA_fanout100_X _1993_/S vssd1 vssd1 vccd1 vccd1 sky130_fd_sc_hd__diode_2
XFILLER_4_9 vssd1 vccd1 vssd1 vccd1 sky130_ef_sc_hd__decap_40_12
XFILLER_58_222 vssd1 vssd1 vccd1 vccd1 sky130_fd_sc_hd__fill_1
XTAP_TAPCELL_ROW_69_762 vssd1 vccd1 sky130_fd_sc_hd__tapvpwrvgnd_1
XTAP_TAPCELL_ROW_16_309 vssd1 vccd1 sky130_fd_sc_hd__tapvpwrvgnd_1
XFILLER_54_461 vssd1 vssd1 vccd1 vccd1 sky130_fd_sc_hd__fill_2
XANTENNA_fanout13_X _2837_/S vssd1 vssd1 vccd1 vccd1 sky130_fd_sc_hd__diode_2
XTAP_TAPCELL_ROW_24_375 vssd1 vccd1 sky130_fd_sc_hd__tapvpwrvgnd_1
XANTENNA__2973__A1 _2973_/A1 vssd1 vssd1 vccd1 vccd1 sky130_fd_sc_hd__diode_2
XFILLER_49_222 vssd1 vssd1 vccd1 vccd1 sky130_fd_sc_hd__fill_2
XFILLER_64_236 vssd1 vccd1 vssd1 vccd1 sky130_ef_sc_hd__decap_40_12
XFILLER_32_155 vssd1 vssd1 vccd1 vccd1 sky130_fd_sc_hd__fill_8
XFILLER_32_199 vssd1 vssd1 vccd1 vccd1 sky130_fd_sc_hd__fill_1
XFILLER_9_362 vssd1 vssd1 vccd1 vccd1 sky130_fd_sc_hd__fill_2
XFILLER_70_3 vssd1 vssd1 vccd1 vccd1 sky130_fd_sc_hd__fill_4
X_2623_ hold663/X _2844_/A1 _2645_/S vssd1 vssd1 vccd1 vccd1 _3150_/D sky130_fd_sc_hd__mux2_1
X_2554_ hold463/X _2477_/X _2559_/S vssd1 vssd1 vccd1 vccd1 _3108_/D sky130_fd_sc_hd__mux2_1
X_1505_ _1738_/S vssd1 vssd1 vccd1 vccd1 _1739_/B sky130_fd_sc_hd__inv_2
X_2485_ _2962_/A1 _3148_/Q _3292_/Q _2961_/A1 vssd1 vssd1 vccd1 vccd1 _2485_/X sky130_fd_sc_hd__a22o_2
XANTENNA__2449__B _2472_/B vssd1 vssd1 vccd1 vccd1 sky130_fd_sc_hd__diode_2
X_3106_ _3112_/CLK _3106_/D wire208/X vssd1 vssd1 vccd1 vccd1 _3106_/Q sky130_fd_sc_hd__dfrtp_2
XTAP_TAPCELL_ROW_66_732 vssd1 vccd1 sky130_fd_sc_hd__tapvpwrvgnd_1
XANTENNA__2465__A _2540_/A vssd1 vssd1 vccd1 vccd1 sky130_fd_sc_hd__diode_2
X_3037_ _3101_/CLK _3037_/D fanout217/X vssd1 vssd1 vccd1 vccd1 _3037_/Q sky130_fd_sc_hd__dfrtp_2
XFILLER_62_29 vssd1 vssd1 vccd1 vccd1 sky130_fd_sc_hd__fill_8
Xwire208 wire208/A vssd1 vssd1 vccd1 vccd1 wire208/X sky130_fd_sc_hd__clkbuf_4
XPHY_EDGE_ROW_21_Left_101 vssd1 vssd1 vccd1 vccd1 sky130_fd_sc_hd__decap_3
XFILLER_46_203 vssd1 vssd1 vccd1 vccd1 sky130_fd_sc_hd__fill_1
XFILLER_46_247 vssd1 vssd1 vccd1 vccd1 sky130_fd_sc_hd__fill_4
XFILLER_36_85 vssd1 vssd1 vccd1 vccd1 sky130_fd_sc_hd__fill_2
XPHY_EDGE_ROW_30_Left_110 vssd1 vssd1 vccd1 vccd1 sky130_fd_sc_hd__decap_3
XFILLER_42_475 vssd1 vssd1 vccd1 vccd1 sky130_fd_sc_hd__fill_1
XANTENNA__2946__A1 _2973_/A1 vssd1 vssd1 vccd1 vccd1 sky130_fd_sc_hd__diode_2
XFILLER_69_306 vssd1 vccd1 vssd1 vccd1 sky130_ef_sc_hd__decap_40_12
X_2270_ _2235_/B _2235_/C _2235_/A vssd1 vssd1 vccd1 vccd1 _2272_/B sky130_fd_sc_hd__a21bo_2
XANTENNA__2285__A _2383_/B vssd1 vssd1 vccd1 vccd1 sky130_fd_sc_hd__diode_2
X_1985_ _1986_/A _1984_/B _1984_/A vssd1 vssd1 vccd1 vccd1 _2019_/A sky130_fd_sc_hd__a21bo_2
XANTENNA__2937__B2 _2520_/A vssd1 vssd1 vccd1 vccd1 sky130_fd_sc_hd__diode_2
X_2606_ _1607_/Y _2601_/C _2594_/X _2605_/Y vssd1 vssd1 vccd1 vccd1 _3143_/D sky130_fd_sc_hd__a31oi_2
X_2537_ _2800_/A _2531_/X _2534_/X _2611_/A vssd1 vssd1 vccd1 vccd1 _2537_/X sky130_fd_sc_hd__a22o_2
X_2468_ _3183_/Q _2667_/B _2648_/B _3165_/Q _2467_/X vssd1 vssd1 vccd1 vccd1 _2468_/X
+ sky130_fd_sc_hd__a221o_2
X_2399_ _2399_/A _2399_/B _2399_/C vssd1 vssd1 vccd1 vccd1 _2419_/A sky130_fd_sc_hd__nand3_2
XFILLER_73_39 vssd1 vssd1 vccd1 vccd1 sky130_fd_sc_hd__fill_4
XANTENNA__2642__B _2644_/B vssd1 vssd1 vccd1 vccd1 sky130_fd_sc_hd__diode_2
XFILLER_11_136 vssd1 vccd1 vssd1 vccd1 sky130_ef_sc_hd__decap_40_12
XANTENNA__2928__A1 _2972_/A1 vssd1 vssd1 vccd1 vccd1 sky130_fd_sc_hd__diode_2
XANTENNA__2928__B2 _2972_/B2 vssd1 vssd1 vccd1 vccd1 sky130_fd_sc_hd__diode_2
XFILLER_11_169 vssd1 vssd1 vccd1 vccd1 sky130_fd_sc_hd__fill_8
XANTENNA__2156__A2 _2352_/B vssd1 vssd1 vccd1 vccd1 sky130_fd_sc_hd__diode_2
XFILLER_0_3 vssd1 vssd1 vccd1 vccd1 sky130_fd_sc_hd__fill_1
XANTENNA_fanout80_X _2901_/A2 vssd1 vssd1 vccd1 vccd1 sky130_fd_sc_hd__diode_2
XFILLER_78_125 vssd1 vccd1 vssd1 vccd1 sky130_ef_sc_hd__decap_40_12
Xfanout160 _2029_/B vssd1 vssd1 vccd1 vccd1 _2005_/C sky130_fd_sc_hd__clkdlybuf4s25_1
Xfanout171 _3037_/Q vssd1 vssd1 vccd1 vccd1 _2399_/B sky130_fd_sc_hd__clkdlybuf4s25_1
Xfanout182 _3031_/Q vssd1 vssd1 vccd1 vccd1 _2297_/A sky130_fd_sc_hd__clkdlybuf4s25_1
XTAP_TAPCELL_ROW_77_827 vssd1 vccd1 sky130_fd_sc_hd__tapvpwrvgnd_1
Xfanout193 _3025_/Q vssd1 vssd1 vccd1 vccd1 _1998_/B sky130_fd_sc_hd__clkdlybuf4s25_1
XANTENNA__2616__B1 _2646_/B vssd1 vssd1 vccd1 vccd1 sky130_fd_sc_hd__diode_2
XFILLER_30_434 vssd1 vssd1 vccd1 vccd1 sky130_fd_sc_hd__fill_2
XFILLER_30_423 vssd1 vssd1 vccd1 vccd1 sky130_fd_sc_hd__fill_1
X_1770_ _2352_/C hold488/X _1771_/S vssd1 vssd1 vccd1 vccd1 _3050_/D sky130_fd_sc_hd__mux2_1
XFILLER_8_78 vssd1 vssd1 vccd1 vccd1 sky130_fd_sc_hd__fill_1
Xhold608 _3265_/Q vssd1 vssd1 vccd1 vccd1 hold608/X sky130_fd_sc_hd__dlygate4sd3_1
X_3440_ _3441_/CLK _3440_/D fanout268/X vssd1 vssd1 vccd1 vccd1 _3440_/Q sky130_fd_sc_hd__dfrtp_2
Xhold619 _3005_/Q vssd1 vssd1 vccd1 vccd1 hold619/X sky130_fd_sc_hd__dlygate4sd3_1
X_3371_ _2994_/Y _3371_/D _3472_/SET_B vssd1 vssd1 vccd1 vccd1 _3447_/D sky130_fd_sc_hd__dfrtp_2
X_2322_ _2347_/A _2384_/A vssd1 vssd1 vccd1 vccd1 _2332_/A sky130_fd_sc_hd__nand2_2
XFILLER_69_125 vssd1 vssd1 vccd1 vccd1 sky130_fd_sc_hd__fill_2
X_2253_ _2305_/A _2306_/A vssd1 vssd1 vccd1 vccd1 _2269_/A sky130_fd_sc_hd__or2_2
X_2184_ _2263_/A _2257_/A _2264_/A _2284_/B vssd1 vssd1 vccd1 vccd1 _2186_/B sky130_fd_sc_hd__and4_2
XTAP_TAPCELL_ROW_48_584 vssd1 vccd1 sky130_fd_sc_hd__tapvpwrvgnd_1
XANTENNA__2181__C _2279_/B vssd1 vssd1 vccd1 vccd1 sky130_fd_sc_hd__diode_2
X_1968_ _2005_/A _2029_/C _2004_/B _2029_/A vssd1 vssd1 vccd1 vccd1 _1969_/B sky130_fd_sc_hd__a22o_2
X_1899_ _2025_/A _2004_/B vssd1 vssd1 vccd1 vccd1 _1900_/C sky130_fd_sc_hd__nand2_2
XANTENNA__2477__X _2477_/X vssd1 vssd1 vccd1 vccd1 sky130_fd_sc_hd__diode_2
XFILLER_48_309 vssd1 vssd1 vccd1 vccd1 sky130_fd_sc_hd__fill_4
XTAP_TAPCELL_ROW_3_198 vssd1 vccd1 sky130_fd_sc_hd__tapvpwrvgnd_1
XPHY_EDGE_ROW_9_Left_89 vssd1 vssd1 vccd1 vccd1 sky130_fd_sc_hd__decap_3
XFILLER_8_416 vssd1 vssd1 vccd1 vccd1 sky130_fd_sc_hd__fill_4
XFILLER_33_53 vssd1 vssd1 vccd1 vccd1 sky130_fd_sc_hd__fill_2
XANTENNA__2799__S _2799_/S vssd1 vssd1 vccd1 vccd1 sky130_fd_sc_hd__diode_2
XFILLER_3_143 vssd1 vssd1 vccd1 vccd1 sky130_fd_sc_hd__fill_2
XFILLER_3_165 vssd1 vssd1 vccd1 vccd1 sky130_fd_sc_hd__fill_2
XFILLER_79_445 vssd1 vssd1 vccd1 vccd1 sky130_fd_sc_hd__fill_1
XFILLER_66_117 vssd1 vccd1 vssd1 vccd1 sky130_ef_sc_hd__decap_40_12
XFILLER_58_72 vssd1 vssd1 vccd1 vccd1 sky130_fd_sc_hd__fill_1
XFILLER_47_364 vssd1 vssd1 vccd1 vccd1 sky130_fd_sc_hd__fill_4
XANTENNA_clkload3_A clkload3/A vssd1 vssd1 vccd1 vccd1 sky130_fd_sc_hd__diode_2
XFILLER_74_183 vssd1 vssd1 vccd1 vccd1 sky130_fd_sc_hd__fill_4
XFILLER_74_172 vssd1 vssd1 vccd1 vccd1 sky130_fd_sc_hd__fill_8
XFILLER_47_397 vssd1 vssd1 vccd1 vccd1 sky130_fd_sc_hd__fill_1
XTAP_TAPCELL_ROW_45_554 vssd1 vccd1 sky130_fd_sc_hd__tapvpwrvgnd_1
XFILLER_74_93 vssd1 vssd1 vccd1 vccd1 sky130_fd_sc_hd__fill_1
XFILLER_74_82 vssd1 vssd1 vccd1 vccd1 sky130_fd_sc_hd__fill_2
XFILLER_62_367 vssd1 vssd1 vccd1 vccd1 sky130_fd_sc_hd__fill_1
X_2940_ _2942_/B2 _2939_/X _2937_/X _1585_/A vssd1 vssd1 vccd1 vccd1 _2940_/X sky130_fd_sc_hd__a211o_2
X_2871_ _3261_/Q _2927_/A2 _2927_/B1 _3243_/Q _2870_/X vssd1 vssd1 vccd1 vccd1 _2871_/X
+ sky130_fd_sc_hd__a221o_2
X_1822_ _1822_/A _1822_/B vssd1 vssd1 vccd1 vccd1 _1823_/B sky130_fd_sc_hd__nand2_2
X_1753_ _2146_/C hold482/X _1773_/S vssd1 vssd1 vccd1 vccd1 _3033_/D sky130_fd_sc_hd__mux2_1
XANTENNA__1907__A _1947_/A vssd1 vssd1 vccd1 vccd1 sky130_fd_sc_hd__diode_2
Xhold405 _3345_/Q vssd1 vssd1 vccd1 vccd1 hold405/X sky130_fd_sc_hd__dlygate4sd3_1
Xhold416 _3207_/Q vssd1 vssd1 vccd1 vccd1 hold416/X sky130_fd_sc_hd__dlygate4sd3_1
Xhold427 _3354_/Q vssd1 vssd1 vccd1 vccd1 hold427/X sky130_fd_sc_hd__dlygate4sd3_1
Xmax_cap102 _1621_/B vssd1 vssd1 vccd1 vccd1 _1623_/B sky130_fd_sc_hd__buf_1
X_1684_ _3079_/Q _3062_/Q vssd1 vssd1 vccd1 vccd1 _1684_/Y sky130_fd_sc_hd__nor2_2
X_3423_ _3423_/CLK _3423_/D fanout226/X vssd1 vssd1 vccd1 vccd1 _3423_/Q sky130_fd_sc_hd__dfrtp_2
Xhold438 _3201_/Q vssd1 vssd1 vccd1 vccd1 hold438/X sky130_fd_sc_hd__dlygate4sd3_1
Xhold449 _3387_/Q vssd1 vssd1 vccd1 vccd1 hold449/X sky130_fd_sc_hd__dlygate4sd3_1
X_3354_ _3387_/CLK _3354_/D load_slew240/X vssd1 vssd1 vccd1 vccd1 _3354_/Q sky130_fd_sc_hd__dfrtp_2
X_3285_ _3397_/CLK _3285_/D load_slew244/X vssd1 vssd1 vccd1 vccd1 _3285_/Q sky130_fd_sc_hd__dfrtp_2
X_2305_ _2305_/A _2305_/B vssd1 vssd1 vccd1 vccd1 _2306_/C sky130_fd_sc_hd__nor2_2
X_2236_ _2235_/A _2235_/B _2235_/C vssd1 vssd1 vccd1 vccd1 _2237_/C sky130_fd_sc_hd__a21o_2
X_2167_ _2152_/Y _2160_/B _2152_/A _2151_/Y vssd1 vssd1 vccd1 vccd1 _2195_/A sky130_fd_sc_hd__a2bb2o_2
XFILLER_65_183 vssd1 vssd1 vccd1 vccd1 sky130_fd_sc_hd__fill_2
X_2098_ _2124_/A _2263_/A _2297_/A _2154_/B vssd1 vssd1 vccd1 vccd1 _2098_/X sky130_fd_sc_hd__a22o_2
XTAP_TAPCELL_ROW_0_168 vssd1 vccd1 sky130_fd_sc_hd__tapvpwrvgnd_1
XANTENNA__1803__A1 _1993_/S vssd1 vssd1 vccd1 vccd1 sky130_fd_sc_hd__diode_2
XFILLER_70_29 vssd1 vssd1 vccd1 vccd1 sky130_fd_sc_hd__fill_1
XFILLER_21_264 vssd1 vssd1 vccd1 vccd1 sky130_fd_sc_hd__fill_1
XANTENNA_fanout130_X _2926_/C vssd1 vssd1 vccd1 vccd1 sky130_fd_sc_hd__diode_2
XANTENNA_fanout228_X fanout228/X vssd1 vssd1 vccd1 vccd1 sky130_fd_sc_hd__diode_2
XFILLER_0_113 vssd1 vssd1 vccd1 vccd1 sky130_fd_sc_hd__fill_8
XANTENNA__2531__A2 _2894_/A2 vssd1 vssd1 vccd1 vccd1 sky130_fd_sc_hd__diode_2
XANTENNA__2648__A _2686_/A vssd1 vssd1 vccd1 vccd1 sky130_fd_sc_hd__diode_2
XFILLER_76_459 vssd1 vssd1 vccd1 vccd1 sky130_fd_sc_hd__fill_2
XFILLER_28_31 vssd1 vssd1 vccd1 vccd1 sky130_fd_sc_hd__fill_8
Xteam_02_298 vssd1 vssd1 vccd1 vccd1 team_02_298/HI gpio_oeb[4] sky130_fd_sc_hd__conb_1
XFILLER_56_183 vssd1 vssd1 vccd1 vccd1 sky130_fd_sc_hd__fill_1
XFILLER_56_150 vssd1 vssd1 vccd1 vccd1 sky130_fd_sc_hd__fill_1
XFILLER_44_356 vssd1 vssd1 vccd1 vccd1 sky130_fd_sc_hd__fill_1
XANTENNA__2383__A _2399_/A vssd1 vssd1 vccd1 vccd1 sky130_fd_sc_hd__diode_2
XFILLER_12_297 vssd1 vssd1 vccd1 vccd1 sky130_fd_sc_hd__fill_1
XFILLER_12_264 vssd1 vssd1 vccd1 vccd1 sky130_fd_sc_hd__fill_1
XFILLER_8_257 vssd1 vssd1 vccd1 vccd1 sky130_fd_sc_hd__fill_1
XFILLER_79_231 vssd1 vccd1 vssd1 vccd1 sky130_ef_sc_hd__decap_40_12
XFILLER_79_253 vssd1 vccd1 vssd1 vccd1 sky130_ef_sc_hd__decap_40_12
X_3070_ _3090_/CLK _3070_/D vssd1 vssd1 vccd1 vccd1 _3070_/Q sky130_fd_sc_hd__dfxtp_2
XFILLER_39_117 vssd1 vssd1 vccd1 vccd1 sky130_fd_sc_hd__fill_2
X_2021_ _1994_/A _1994_/B _2020_/B _2018_/Y vssd1 vssd1 vccd1 vccd1 _2047_/A sky130_fd_sc_hd__a31o_2
XANTENNA__2286__A1 _2383_/B vssd1 vssd1 vccd1 vccd1 sky130_fd_sc_hd__diode_2
XFILLER_35_356 vssd1 vssd1 vccd1 vccd1 sky130_fd_sc_hd__fill_1
XFILLER_35_334 vssd1 vssd1 vccd1 vccd1 sky130_fd_sc_hd__fill_2
XPHY_EDGE_ROW_59_Left_139 vssd1 vssd1 vccd1 vccd1 sky130_fd_sc_hd__decap_3
XFILLER_62_197 vssd1 vssd1 vccd1 vccd1 sky130_fd_sc_hd__fill_1
X_2923_ _3230_/Q _2923_/A2 _2922_/X _2923_/B2 vssd1 vssd1 vccd1 vccd1 _2923_/X sky130_fd_sc_hd__a22o_2
X_2854_ hold400/X _2642_/X _2856_/S vssd1 vssd1 vccd1 vccd1 _3358_/D sky130_fd_sc_hd__mux2_1
X_2785_ hold611/X _2618_/X _2798_/S vssd1 vssd1 vccd1 vccd1 _3292_/D sky130_fd_sc_hd__mux2_1
X_1805_ _1805_/A _1805_/B _1862_/A _1862_/B vssd1 vssd1 vccd1 vccd1 _1833_/A sky130_fd_sc_hd__nand4_2
XTAP_TAPCELL_ROW_13_281 vssd1 vccd1 sky130_fd_sc_hd__tapvpwrvgnd_1
X_1736_ _1727_/Y _1731_/B _1729_/B vssd1 vssd1 vccd1 vccd1 _1737_/B sky130_fd_sc_hd__o21ai_2
XPHY_EDGE_ROW_68_Left_148 vssd1 vssd1 vccd1 vccd1 sky130_fd_sc_hd__decap_3
X_1667_ _1656_/Y _1660_/X _1658_/Y vssd1 vssd1 vccd1 vccd1 _1668_/B sky130_fd_sc_hd__o21ai_2
X_3406_ _3453_/CLK _3406_/D load_slew288/X vssd1 vssd1 vccd1 vccd1 _3406_/Q sky130_fd_sc_hd__dfrtp_2
X_1598_ _3422_/Q _1621_/A hold383/X vssd1 vssd1 vccd1 vccd1 _1598_/X sky130_fd_sc_hd__a21o_2
X_3337_ _3337_/CLK _3337_/D load_slew256/X vssd1 vssd1 vccd1 vccd1 _3337_/Q sky130_fd_sc_hd__dfrtp_2
XTAP_TAPCELL_ROW_5_216 vssd1 vccd1 sky130_fd_sc_hd__tapvpwrvgnd_1
XANTENNA_fanout292_A input2/X vssd1 vssd1 vccd1 vccd1 sky130_fd_sc_hd__diode_2
X_3268_ _3397_/CLK _3268_/D load_slew248/X vssd1 vssd1 vccd1 vccd1 _3268_/Q sky130_fd_sc_hd__dfrtp_2
XFILLER_65_29 vssd1 vssd1 vccd1 vccd1 sky130_fd_sc_hd__fill_8
X_3199_ _3199_/CLK _3199_/D wire222/X vssd1 vssd1 vccd1 vccd1 _3199_/Q sky130_fd_sc_hd__dfrtp_2
X_2219_ _2255_/B _2279_/B _2318_/B _2257_/B vssd1 vssd1 vccd1 vccd1 _2221_/B sky130_fd_sc_hd__a22o_2
XANTENNA__2915__B _2964_/C vssd1 vssd1 vccd1 vccd1 sky130_fd_sc_hd__diode_2
XTAP_TAPCELL_ROW_56_649 vssd1 vccd1 sky130_fd_sc_hd__tapvpwrvgnd_1
XPHY_EDGE_ROW_77_Left_157 vssd1 vssd1 vccd1 vccd1 sky130_fd_sc_hd__decap_3
XFILLER_26_367 vssd1 vssd1 vccd1 vccd1 sky130_fd_sc_hd__fill_1
XFILLER_53_186 vssd1 vssd1 vccd1 vccd1 sky130_fd_sc_hd__fill_2
XANTENNA__1788__B1 _1993_/S vssd1 vssd1 vccd1 vccd1 sky130_fd_sc_hd__diode_2
XFILLER_14_55 vssd1 vccd1 vssd1 vccd1 sky130_ef_sc_hd__decap_40_12
XFILLER_49_404 vssd1 vssd1 vccd1 vccd1 sky130_fd_sc_hd__fill_1
XFILLER_76_267 vssd1 vssd1 vccd1 vccd1 sky130_fd_sc_hd__fill_1
XFILLER_29_183 vssd1 vssd1 vccd1 vccd1 sky130_fd_sc_hd__fill_2
XFILLER_17_345 vssd1 vssd1 vccd1 vccd1 sky130_fd_sc_hd__fill_1
XFILLER_72_473 vssd1 vssd1 vccd1 vccd1 sky130_fd_sc_hd__fill_2
XFILLER_44_164 vssd1 vssd1 vccd1 vccd1 sky130_fd_sc_hd__fill_8
XFILLER_72_484 vssd1 vssd1 vccd1 vccd1 sky130_fd_sc_hd__fill_8
XFILLER_71_61 vssd1 vssd1 vccd1 vccd1 sky130_fd_sc_hd__fill_2
X_2570_ _3004_/Q _1622_/C _2583_/B1 hold713/X vssd1 vssd1 vccd1 vccd1 _2570_/X sky130_fd_sc_hd__a22o_2
X_1521_ _3364_/Q _3449_/D _1525_/S vssd1 vssd1 vccd1 vccd1 _3373_/D sky130_fd_sc_hd__mux2_1
X_3122_ _3343_/CLK _3122_/D wire222/X vssd1 vssd1 vccd1 vccd1 _3122_/Q sky130_fd_sc_hd__dfrtp_2
XFILLER_67_256 vssd1 vssd1 vccd1 vccd1 sky130_fd_sc_hd__fill_1
X_3053_ _3101_/CLK _3053_/D fanout217/X vssd1 vssd1 vccd1 vccd1 _3053_/Q sky130_fd_sc_hd__dfrtp_2
X_2004_ _2029_/D _2004_/B vssd1 vssd1 vccd1 vccd1 _2008_/A sky130_fd_sc_hd__nand2_2
XTAP_TAPCELL_ROW_53_619 vssd1 vccd1 sky130_fd_sc_hd__tapvpwrvgnd_1
XFILLER_35_142 vssd1 vssd1 vccd1 vccd1 sky130_fd_sc_hd__fill_8
X_2906_ _2973_/A1 _2903_/X _2899_/X _1585_/A vssd1 vssd1 vccd1 vccd1 _2906_/X sky130_fd_sc_hd__a211o_2
XANTENNA__2470__B _2472_/B vssd1 vssd1 vccd1 vccd1 sky130_fd_sc_hd__diode_2
XANTENNA_fanout138_A _2472_/A vssd1 vssd1 vccd1 vccd1 sky130_fd_sc_hd__diode_2
X_2837_ hold529/X _2646_/X _2837_/S vssd1 vssd1 vccd1 vccd1 _3342_/D sky130_fd_sc_hd__mux2_1
X_2768_ hold433/X _2622_/X _2780_/S vssd1 vssd1 vccd1 vccd1 _3276_/D sky130_fd_sc_hd__mux2_1
X_2699_ hold410/X _2813_/A1 _2704_/S vssd1 vssd1 vccd1 vccd1 _3211_/D sky130_fd_sc_hd__mux2_1
X_1719_ _1719_/A _1719_/B vssd1 vssd1 vccd1 vccd1 _1719_/Y sky130_fd_sc_hd__xnor2_2
XFILLER_54_473 vssd1 vssd1 vccd1 vccd1 sky130_fd_sc_hd__fill_1
XFILLER_25_76 vssd1 vssd1 vccd1 vccd1 sky130_fd_sc_hd__fill_1
XTAP_TAPCELL_ROW_24_376 vssd1 vccd1 sky130_fd_sc_hd__tapvpwrvgnd_1
XFILLER_41_64 vssd1 vccd1 vssd1 vccd1 sky130_ef_sc_hd__decap_40_12
XANTENNA_clkbuf_3_1__f_clk_X clkload0/A vssd1 vssd1 vccd1 vccd1 sky130_fd_sc_hd__diode_2
XFILLER_60_421 vssd1 vssd1 vccd1 vccd1 sky130_fd_sc_hd__fill_1
XFILLER_60_465 vssd1 vssd1 vccd1 vccd1 sky130_fd_sc_hd__fill_2
X_2622_ _3404_/Q _2610_/A _2644_/B _3127_/Q vssd1 vssd1 vccd1 vccd1 _2622_/X sky130_fd_sc_hd__a22o_2
XFILLER_63_3 vssd1 vccd1 vssd1 vccd1 sky130_ef_sc_hd__decap_40_12
X_2553_ hold634/X _2465_/X _2559_/S vssd1 vssd1 vccd1 vccd1 _3107_/D sky130_fd_sc_hd__mux2_1
X_1504_ _3436_/Q vssd1 vssd1 vccd1 vccd1 _1621_/A sky130_fd_sc_hd__inv_2
X_2484_ _3184_/Q _2667_/B _2648_/B _3166_/Q _2483_/X vssd1 vssd1 vccd1 vccd1 _2484_/X
+ sky130_fd_sc_hd__a221o_2
X_3105_ _3121_/CLK _3105_/D fanout215/X vssd1 vssd1 vccd1 vccd1 _3105_/Q sky130_fd_sc_hd__dfrtp_2
X_3036_ _3101_/CLK _3036_/D fanout217/X vssd1 vssd1 vccd1 vccd1 _3036_/Q sky130_fd_sc_hd__dfrtp_2
XTAP_TAPCELL_ROW_66_733 vssd1 vccd1 sky130_fd_sc_hd__tapvpwrvgnd_1
XANTENNA__2481__A _2533_/A vssd1 vssd1 vccd1 vccd1 sky130_fd_sc_hd__diode_2
XANTENNA_clkbuf_leaf_24_clk_A clkload0/A vssd1 vssd1 vccd1 vccd1 sky130_fd_sc_hd__diode_2
XANTENNA_clkbuf_leaf_39_clk_A clkload0/A vssd1 vssd1 vccd1 vccd1 sky130_fd_sc_hd__diode_2
XFILLER_78_307 vssd1 vssd1 vccd1 vccd1 sky130_fd_sc_hd__fill_1
XANTENNA_fanout70_A _2440_/Y vssd1 vssd1 vccd1 vccd1 sky130_fd_sc_hd__diode_2
XFILLER_42_421 vssd1 vssd1 vccd1 vccd1 sky130_fd_sc_hd__fill_4
XTAP_TAPCELL_ROW_37_490 vssd1 vccd1 sky130_fd_sc_hd__tapvpwrvgnd_1
XFILLER_52_63 vssd1 vssd1 vccd1 vccd1 sky130_fd_sc_hd__fill_2
XFILLER_6_344 vssd1 vssd1 vccd1 vccd1 sky130_fd_sc_hd__fill_1
XFILLER_69_318 vssd1 vssd1 vccd1 vccd1 sky130_fd_sc_hd__fill_4
X_1984_ _1984_/A _1984_/B vssd1 vssd1 vccd1 vccd1 _1986_/B sky130_fd_sc_hd__nand2_2
XANTENNA__2937__A2 _2967_/A2 vssd1 vssd1 vccd1 vccd1 sky130_fd_sc_hd__diode_2
XFILLER_9_160 vssd1 vssd1 vccd1 vccd1 sky130_fd_sc_hd__fill_8
XFILLER_20_159 vssd1 vssd1 vccd1 vccd1 sky130_fd_sc_hd__fill_1
X_2605_ _3143_/Q _2605_/B vssd1 vssd1 vccd1 vccd1 _2605_/Y sky130_fd_sc_hd__xnor2_2
X_2536_ _3260_/Q _2894_/A2 _2894_/B1 _3242_/Q _2535_/X vssd1 vssd1 vccd1 vccd1 _2536_/X
+ sky130_fd_sc_hd__a221o_2
X_2467_ _2472_/A _2472_/B _3201_/Q vssd1 vssd1 vccd1 vccd1 _2467_/X sky130_fd_sc_hd__and3_2
XFILLER_57_19 vssd1 vssd1 vccd1 vccd1 sky130_fd_sc_hd__fill_1
X_2398_ _2399_/A _2399_/B vssd1 vssd1 vccd1 vccd1 _2398_/Y sky130_fd_sc_hd__nand2_2
X_3019_ _3090_/CLK _3019_/D wire208/X vssd1 vssd1 vccd1 vccd1 _3019_/Q sky130_fd_sc_hd__dfrtp_2
XFILLER_24_421 vssd1 vssd1 vccd1 vccd1 sky130_fd_sc_hd__fill_4
XTAP_TAPCELL_ROW_34_460 vssd1 vccd1 sky130_fd_sc_hd__tapvpwrvgnd_1
XFILLER_11_104 vssd1 vssd1 vccd1 vccd1 sky130_fd_sc_hd__fill_8
XFILLER_11_115 vssd1 vssd1 vccd1 vccd1 sky130_fd_sc_hd__fill_1
XFILLER_11_148 vssd1 vssd1 vccd1 vccd1 sky130_fd_sc_hd__fill_4
XFILLER_78_137 vssd1 vssd1 vccd1 vccd1 sky130_fd_sc_hd__fill_2
Xfanout150 _3049_/Q vssd1 vssd1 vccd1 vccd1 _2146_/A sky130_fd_sc_hd__clkdlybuf4s25_1
Xfanout161 _3043_/Q vssd1 vssd1 vccd1 vccd1 _2029_/B sky130_fd_sc_hd__clkdlybuf4s25_1
Xfanout172 _3036_/Q vssd1 vssd1 vccd1 vccd1 _2384_/B sky130_fd_sc_hd__clkdlybuf4s25_1
Xfanout183 _3031_/Q vssd1 vssd1 vccd1 vccd1 _2124_/B sky130_fd_sc_hd__clkdlybuf4s25_1
XTAP_TAPCELL_ROW_77_828 vssd1 vccd1 sky130_fd_sc_hd__tapvpwrvgnd_1
Xfanout194 _3025_/Q vssd1 vssd1 vccd1 vccd1 _1862_/D sky130_fd_sc_hd__clkdlybuf4s25_1
XFILLER_74_365 vssd1 vssd1 vccd1 vccd1 sky130_fd_sc_hd__fill_2
XFILLER_27_281 vssd1 vssd1 vccd1 vccd1 sky130_fd_sc_hd__fill_1
XANTENNA__2919__A2 _2864_/S vssd1 vssd1 vccd1 vccd1 sky130_fd_sc_hd__diode_2
Xhold609 _3241_/Q vssd1 vssd1 vccd1 vccd1 hold609/X sky130_fd_sc_hd__dlygate4sd3_1
XFILLER_6_141 vssd1 vccd1 vssd1 vccd1 sky130_ef_sc_hd__decap_40_12
XFILLER_10_181 vssd1 vssd1 vccd1 vccd1 sky130_fd_sc_hd__fill_2
X_3370_ _2993_/Y _3370_/D load_slew283/X vssd1 vssd1 vccd1 vccd1 _3446_/D sky130_fd_sc_hd__dfrtp_2
X_2321_ _2283_/A _2283_/B _2320_/X vssd1 vssd1 vccd1 vccd1 _2334_/A sky130_fd_sc_hd__a21o_2
X_2252_ _2252_/A _2252_/B _2252_/C _2252_/D vssd1 vssd1 vccd1 vccd1 _2306_/A sky130_fd_sc_hd__and4_2
X_2183_ _3046_/Q _2264_/B vssd1 vssd1 vccd1 vccd1 _2186_/A sky130_fd_sc_hd__and2_2
XFILLER_65_321 vssd1 vssd1 vccd1 vccd1 sky130_fd_sc_hd__fill_1
X_1967_ _2005_/A _2029_/A _2029_/C _2004_/B vssd1 vssd1 vccd1 vccd1 _1967_/X sky130_fd_sc_hd__and4_2
XANTENNA_fanout218_A fanout291/X vssd1 vssd1 vccd1 vccd1 sky130_fd_sc_hd__diode_2
X_1898_ _2005_/C _1962_/B _1998_/B _2029_/C vssd1 vssd1 vccd1 vccd1 _1900_/B sky130_fd_sc_hd__a22o_2
X_2519_ _2962_/A1 _3151_/Q _3295_/Q _2961_/A1 vssd1 vssd1 vccd1 vccd1 _2520_/B sky130_fd_sc_hd__a22o_2
XFILLER_0_317 vssd1 vssd1 vccd1 vccd1 sky130_fd_sc_hd__fill_2
XFILLER_0_306 vssd1 vssd1 vccd1 vccd1 sky130_fd_sc_hd__fill_2
XTAP_TAPCELL_ROW_3_199 vssd1 vccd1 sky130_fd_sc_hd__tapvpwrvgnd_1
XFILLER_17_77 vssd1 vccd1 vssd1 vccd1 sky130_ef_sc_hd__decap_40_12
XANTENNA_fanout33_A _2647_/S vssd1 vssd1 vccd1 vccd1 sky130_fd_sc_hd__diode_2
XFILLER_33_76 vssd1 vssd1 vccd1 vccd1 sky130_fd_sc_hd__fill_2
XFILLER_3_111 vssd1 vssd1 vccd1 vccd1 sky130_fd_sc_hd__fill_1
XANTENNA__2534__B1 _2648_/B vssd1 vssd1 vccd1 vccd1 sky130_fd_sc_hd__diode_2
XFILLER_58_62 vssd1 vssd1 vccd1 vccd1 sky130_fd_sc_hd__fill_8
XFILLER_66_129 vssd1 vssd1 vccd1 vccd1 sky130_fd_sc_hd__fill_2
XTAP_TAPCELL_ROW_45_555 vssd1 vccd1 sky130_fd_sc_hd__tapvpwrvgnd_1
X_2870_ _2924_/B _2924_/C _3279_/Q vssd1 vssd1 vccd1 vccd1 _2870_/X sky130_fd_sc_hd__and3_2
X_1821_ _1822_/A _1822_/B vssd1 vssd1 vccd1 vccd1 _1821_/Y sky130_fd_sc_hd__nor2_2
Xclkbuf_leaf_10_clk clkload1/A vssd1 vssd1 vccd1 vccd1 _3343_/CLK sky130_fd_sc_hd__clkbuf_8
X_1752_ _2279_/B hold632/X _1773_/S vssd1 vssd1 vccd1 vccd1 _3032_/D sky130_fd_sc_hd__mux2_1
XANTENNA__1907__B _2049_/B vssd1 vssd1 vccd1 vccd1 sky130_fd_sc_hd__diode_2
Xhold406 _3085_/Q vssd1 vssd1 vccd1 vccd1 hold406/X sky130_fd_sc_hd__dlygate4sd3_1
Xhold417 _3272_/Q vssd1 vssd1 vccd1 vccd1 hold417/X sky130_fd_sc_hd__dlygate4sd3_1
X_1683_ hold440/X _1682_/Y _1690_/S vssd1 vssd1 vccd1 vccd1 _3011_/D sky130_fd_sc_hd__mux2_1
X_3422_ _3429_/CLK _3422_/D load_slew225/X vssd1 vssd1 vccd1 vccd1 _3422_/Q sky130_fd_sc_hd__dfrtp_2
Xhold428 _3203_/Q vssd1 vssd1 vccd1 vccd1 hold428/X sky130_fd_sc_hd__dlygate4sd3_1
Xhold439 _3352_/Q vssd1 vssd1 vccd1 vccd1 hold439/X sky130_fd_sc_hd__dlygate4sd3_1
XANTENNA__2525__B1 wire66/X vssd1 vssd1 vccd1 vccd1 sky130_fd_sc_hd__diode_2
X_3353_ _3394_/CLK _3353_/D load_slew276/X vssd1 vssd1 vccd1 vccd1 _3353_/Q sky130_fd_sc_hd__dfrtp_2
X_3284_ _3389_/CLK _3284_/D load_slew278/X vssd1 vssd1 vccd1 vccd1 _3284_/Q sky130_fd_sc_hd__dfrtp_2
X_2304_ _2302_/A _2302_/B _2303_/X _2300_/X vssd1 vssd1 vccd1 vccd1 _2306_/B sky130_fd_sc_hd__o31ai_2
X_2235_ _2235_/A _2235_/B _2235_/C vssd1 vssd1 vccd1 vccd1 _2237_/B sky130_fd_sc_hd__nand3_2
XFILLER_57_129 vssd1 vssd1 vccd1 vccd1 sky130_fd_sc_hd__fill_1
X_2166_ hold641/X _2165_/Y _2374_/S vssd1 vssd1 vccd1 vccd1 _3076_/D sky130_fd_sc_hd__mux2_1
XFILLER_38_354 vssd1 vssd1 vccd1 vccd1 sky130_fd_sc_hd__fill_1
X_2097_ hold700/X _2421_/B _2096_/X vssd1 vssd1 vccd1 vccd1 _3071_/D sky130_fd_sc_hd__a21o_2
XTAP_TAPCELL_ROW_0_169 vssd1 vccd1 sky130_fd_sc_hd__tapvpwrvgnd_1
XFILLER_53_335 vssd1 vssd1 vccd1 vccd1 sky130_fd_sc_hd__fill_1
XPHY_EDGE_ROW_3_Right_3 vssd1 vssd1 vccd1 vccd1 sky130_fd_sc_hd__decap_3
X_2999_ _3001_/A vssd1 vssd1 vccd1 vccd1 _2999_/Y sky130_fd_sc_hd__inv_2
XANTENNA__2516__B1 _2515_/X vssd1 vssd1 vccd1 vccd1 sky130_fd_sc_hd__diode_2
XTAP_TAPCELL_ROW_8_236 vssd1 vccd1 sky130_fd_sc_hd__tapvpwrvgnd_1
XANTENNA__2648__B _2648_/B vssd1 vssd1 vccd1 vccd1 sky130_fd_sc_hd__diode_2
XFILLER_0_169 vssd1 vccd1 vssd1 vccd1 sky130_ef_sc_hd__decap_40_12
XFILLER_48_118 vssd1 vssd1 vccd1 vccd1 sky130_fd_sc_hd__fill_2
Xteam_02_299 vssd1 vssd1 vccd1 vccd1 team_02_299/HI gpio_out[0] sky130_fd_sc_hd__conb_1
XANTENNA__2383__B _2383_/B vssd1 vssd1 vccd1 vccd1 sky130_fd_sc_hd__diode_2
XANTENNA_fanout36_X _3437_/D vssd1 vssd1 vccd1 vccd1 sky130_fd_sc_hd__diode_2
XTAP_TAPCELL_ROW_42_525 vssd1 vccd1 sky130_fd_sc_hd__tapvpwrvgnd_1
XFILLER_8_269 vssd1 vssd1 vccd1 vccd1 sky130_fd_sc_hd__fill_1
XFILLER_60_74 vssd1 vssd1 vccd1 vccd1 sky130_fd_sc_hd__fill_1
XFILLER_5_36 vssd1 vssd1 vccd1 vccd1 sky130_fd_sc_hd__fill_8
XFILLER_5_69 vssd1 vssd1 vccd1 vccd1 sky130_fd_sc_hd__fill_1
XFILLER_4_453 vssd1 vssd1 vccd1 vccd1 sky130_fd_sc_hd__fill_2
XFILLER_79_265 vssd1 vccd1 vssd1 vccd1 sky130_ef_sc_hd__decap_40_12
XFILLER_79_243 vssd1 vssd1 vccd1 vccd1 sky130_fd_sc_hd__fill_8
X_2020_ _2018_/Y _2020_/B vssd1 vssd1 vccd1 vccd1 _2022_/B sky130_fd_sc_hd__and2b_2
XANTENNA__2286__A2 _2352_/C vssd1 vssd1 vccd1 vccd1 sky130_fd_sc_hd__diode_2
XFILLER_75_482 vssd1 vssd1 vccd1 vccd1 sky130_fd_sc_hd__fill_4
XANTENNA__3461__CLK _3463_/CLK vssd1 vssd1 vccd1 vccd1 sky130_fd_sc_hd__diode_2
XFILLER_47_195 vssd1 vssd1 vccd1 vccd1 sky130_fd_sc_hd__fill_4
XFILLER_50_305 vssd1 vssd1 vccd1 vccd1 sky130_fd_sc_hd__fill_1
X_2922_ _3158_/Q _2972_/A1 _3302_/Q _2838_/A vssd1 vssd1 vccd1 vccd1 _2922_/X sky130_fd_sc_hd__a22o_2
XFILLER_43_390 vssd1 vssd1 vccd1 vccd1 sky130_fd_sc_hd__fill_2
X_2853_ hold404/X _2640_/X _2856_/S vssd1 vssd1 vccd1 vccd1 _3357_/D sky130_fd_sc_hd__mux2_1
X_2784_ hold602/X _2803_/A1 _2799_/S vssd1 vssd1 vccd1 vccd1 _3291_/D sky130_fd_sc_hd__mux2_1
X_1804_ _1979_/A _1862_/A vssd1 vssd1 vccd1 vccd1 _1841_/A sky130_fd_sc_hd__and2_2
XTAP_TAPCELL_ROW_13_282 vssd1 vccd1 sky130_fd_sc_hd__tapvpwrvgnd_1
X_1735_ _1735_/A _1735_/B vssd1 vssd1 vccd1 vccd1 _1737_/A sky130_fd_sc_hd__nand2_2
X_1666_ _1674_/A _1666_/B vssd1 vssd1 vccd1 vccd1 _1668_/A sky130_fd_sc_hd__nand2b_2
X_3405_ _3453_/CLK _3405_/D load_slew288/X vssd1 vssd1 vccd1 vccd1 _3405_/Q sky130_fd_sc_hd__dfrtp_2
X_1597_ _3423_/Q _1621_/A hold396/X vssd1 vssd1 vccd1 vccd1 _1597_/X sky130_fd_sc_hd__a21o_2
X_3336_ _3387_/CLK _3336_/D load_slew240/X vssd1 vssd1 vccd1 vccd1 _3336_/Q sky130_fd_sc_hd__dfrtp_2
XTAP_TAPCELL_ROW_5_217 vssd1 vccd1 sky130_fd_sc_hd__tapvpwrvgnd_1
XANTENNA_fanout285_A fanout289/X vssd1 vssd1 vccd1 vccd1 sky130_fd_sc_hd__diode_2
X_3267_ _3397_/CLK _3267_/D load_slew244/X vssd1 vssd1 vccd1 vccd1 _3267_/Q sky130_fd_sc_hd__dfrtp_2
X_3198_ _3398_/CLK _3198_/D load_slew250/X vssd1 vssd1 vccd1 vccd1 _3198_/Q sky130_fd_sc_hd__dfrtp_2
X_2218_ _2255_/B _2257_/B _2279_/B _2318_/B vssd1 vssd1 vccd1 vccd1 _2221_/A sky130_fd_sc_hd__nand4_2
X_2149_ _2135_/A _2132_/X _2134_/B vssd1 vssd1 vccd1 vccd1 _2150_/B sky130_fd_sc_hd__o21ai_2
XFILLER_14_23 vssd1 vssd1 vccd1 vccd1 sky130_fd_sc_hd__fill_4
XANTENNA__2931__B _2970_/B vssd1 vssd1 vccd1 vccd1 sky130_fd_sc_hd__diode_2
XANTENNA__3088__Q _3088_/Q vssd1 vssd1 vccd1 vccd1 sky130_fd_sc_hd__diode_2
XFILLER_14_67 vssd1 vccd1 vssd1 vccd1 sky130_ef_sc_hd__decap_40_12
XPHY_EDGE_ROW_12_Left_92 vssd1 vssd1 vccd1 vccd1 sky130_fd_sc_hd__decap_3
XFILLER_5_217 vssd1 vssd1 vccd1 vccd1 sky130_fd_sc_hd__fill_4
XFILLER_30_44 vssd1 vssd1 vccd1 vccd1 sky130_fd_sc_hd__fill_1
XFILLER_30_66 vssd1 vssd1 vccd1 vccd1 sky130_fd_sc_hd__fill_1
XANTENNA__1563__A _2926_/B vssd1 vssd1 vccd1 vccd1 sky130_fd_sc_hd__diode_2
XFILLER_39_42 vssd1 vssd1 vccd1 vccd1 sky130_fd_sc_hd__fill_1
XFILLER_49_416 vssd1 vssd1 vccd1 vccd1 sky130_fd_sc_hd__fill_2
XFILLER_1_478 vssd1 vssd1 vccd1 vccd1 sky130_fd_sc_hd__fill_2
XFILLER_76_235 vssd1 vssd1 vccd1 vccd1 sky130_fd_sc_hd__fill_1
XFILLER_29_173 vssd1 vssd1 vccd1 vccd1 sky130_fd_sc_hd__fill_2
X_1520_ _3365_/Q _3450_/D _1525_/S vssd1 vssd1 vccd1 vccd1 _3374_/D sky130_fd_sc_hd__mux2_1
X_3121_ _3121_/CLK _3121_/D fanout215/X vssd1 vssd1 vccd1 vccd1 _3121_/Q sky130_fd_sc_hd__dfrtp_2
X_3052_ _3121_/CLK _3052_/D load_slew216/X vssd1 vssd1 vccd1 vccd1 _3052_/Q sky130_fd_sc_hd__dfrtp_2
XFILLER_67_279 vssd1 vssd1 vccd1 vccd1 sky130_fd_sc_hd__fill_1
XFILLER_67_268 vssd1 vssd1 vccd1 vccd1 sky130_fd_sc_hd__fill_2
X_2003_ _2029_/D _1970_/B _1969_/B _1967_/X vssd1 vssd1 vccd1 vccd1 _2009_/A sky130_fd_sc_hd__a31o_2
XFILLER_35_132 vssd1 vssd1 vccd1 vccd1 sky130_fd_sc_hd__fill_2
X_2905_ _3192_/Q _2971_/A2 _2971_/B1 _3174_/Q _2904_/X vssd1 vssd1 vccd1 vccd1 _2905_/X
+ sky130_fd_sc_hd__a221o_2
XFILLER_31_360 vssd1 vssd1 vccd1 vccd1 sky130_fd_sc_hd__fill_1
X_2836_ hold694/X _2644_/X _2837_/S vssd1 vssd1 vccd1 vccd1 _3341_/D sky130_fd_sc_hd__mux2_1
X_2767_ hold502/X _2805_/A1 _2780_/S vssd1 vssd1 vccd1 vccd1 _3275_/D sky130_fd_sc_hd__mux2_1
X_2698_ hold409/X _2850_/A1 _2704_/S vssd1 vssd1 vccd1 vccd1 _3210_/D sky130_fd_sc_hd__mux2_1
X_1718_ _1711_/A _1713_/B _1711_/B vssd1 vssd1 vccd1 vccd1 _1719_/B sky130_fd_sc_hd__a21boi_2
XANTENNA__2479__A _2900_/A vssd1 vssd1 vccd1 vccd1 sky130_fd_sc_hd__diode_2
X_1649_ _3074_/Q _3057_/Q vssd1 vssd1 vccd1 vccd1 _1660_/A sky130_fd_sc_hd__nor2_2
XFILLER_76_29 vssd1 vccd1 vssd1 vccd1 sky130_ef_sc_hd__decap_40_12
XANTENNA_input5_A nrst vssd1 vssd1 vccd1 vccd1 sky130_fd_sc_hd__diode_2
XANTENNA_fanout190_X _2049_/B vssd1 vssd1 vccd1 vccd1 sky130_fd_sc_hd__diode_2
X_3319_ _3392_/CLK _3319_/D fanout255/X vssd1 vssd1 vccd1 vccd1 _3319_/Q sky130_fd_sc_hd__dfrtp_2
XANTENNA__2926__B _2926_/B vssd1 vssd1 vccd1 vccd1 sky130_fd_sc_hd__diode_2
XFILLER_41_113 vssd1 vssd1 vccd1 vccd1 sky130_fd_sc_hd__fill_4
XANTENNA__2422__A2 _2838_/B vssd1 vssd1 vccd1 vccd1 sky130_fd_sc_hd__diode_2
XANTENNA__2958__B1 wire66/X vssd1 vssd1 vccd1 vccd1 sky130_fd_sc_hd__diode_2
XTAP_TAPCELL_ROW_24_377 vssd1 vccd1 sky130_fd_sc_hd__tapvpwrvgnd_1
XFILLER_41_43 vssd1 vssd1 vccd1 vccd1 sky130_fd_sc_hd__fill_4
XFILLER_41_76 vssd1 vssd1 vccd1 vccd1 sky130_fd_sc_hd__fill_1
XANTENNA__2431__A_N _2781_/B vssd1 vssd1 vccd1 vccd1 sky130_fd_sc_hd__diode_2
XFILLER_2_15 vssd1 vccd1 vssd1 vccd1 sky130_ef_sc_hd__decap_40_12
XANTENNA__2110__B2 _2154_/B vssd1 vssd1 vccd1 vccd1 sky130_fd_sc_hd__diode_2
XTAP_TAPCELL_ROW_15_300 vssd1 vccd1 sky130_fd_sc_hd__tapvpwrvgnd_1
XFILLER_32_124 vssd1 vssd1 vccd1 vccd1 sky130_fd_sc_hd__fill_1
XFILLER_13_360 vssd1 vssd1 vccd1 vccd1 sky130_fd_sc_hd__fill_2
X_2621_ hold711/X _2805_/A1 _2645_/S vssd1 vssd1 vccd1 vccd1 _3149_/D sky130_fd_sc_hd__mux2_1
X_2552_ hold435/X _2453_/X _2559_/S vssd1 vssd1 vccd1 vccd1 _3106_/D sky130_fd_sc_hd__mux2_1
XFILLER_56_3 vssd1 vssd1 vccd1 vccd1 sky130_fd_sc_hd__fill_8
X_1503_ input4/X vssd1 vssd1 vccd1 vccd1 _1503_/Y sky130_fd_sc_hd__inv_2
X_2483_ _2533_/A _2533_/B _3202_/Q vssd1 vssd1 vccd1 vccd1 _2483_/X sky130_fd_sc_hd__and3_2
X_3104_ _3121_/CLK _3104_/D load_slew216/X vssd1 vssd1 vccd1 vccd1 _3104_/Q sky130_fd_sc_hd__dfrtp_2
X_3035_ _3101_/CLK _3035_/D fanout217/X vssd1 vssd1 vccd1 vccd1 _3035_/Q sky130_fd_sc_hd__dfrtp_2
XTAP_TAPCELL_ROW_66_734 vssd1 vccd1 sky130_fd_sc_hd__tapvpwrvgnd_1
XFILLER_70_208 vssd1 vssd1 vccd1 vccd1 sky130_fd_sc_hd__fill_2
XANTENNA__2184__D _2284_/B vssd1 vssd1 vccd1 vccd1 sky130_fd_sc_hd__diode_2
XANTENNA__2762__A _2838_/B vssd1 vssd1 vccd1 vccd1 sky130_fd_sc_hd__diode_2
XFILLER_63_293 vssd1 vssd1 vccd1 vccd1 sky130_fd_sc_hd__fill_1
XANTENNA__2481__B _2533_/B vssd1 vssd1 vccd1 vccd1 sky130_fd_sc_hd__diode_2
XTAP_TAPCELL_ROW_21_347 vssd1 vccd1 sky130_fd_sc_hd__tapvpwrvgnd_1
X_2819_ _2838_/A _2819_/B _2838_/C vssd1 vssd1 vccd1 vccd1 _2819_/X sky130_fd_sc_hd__and3_2
XFILLER_11_24 vssd1 vssd1 vccd1 vccd1 sky130_fd_sc_hd__fill_4
XANTENNA__2701__S _2704_/S vssd1 vssd1 vccd1 vccd1 sky130_fd_sc_hd__diode_2
XFILLER_11_35 vssd1 vssd1 vccd1 vccd1 sky130_fd_sc_hd__fill_1
XFILLER_11_79 vssd1 vssd1 vccd1 vccd1 sky130_fd_sc_hd__fill_2
XANTENNA__2002__A _2025_/A vssd1 vssd1 vccd1 vccd1 sky130_fd_sc_hd__diode_2
XFILLER_36_21 vssd1 vssd1 vccd1 vccd1 sky130_fd_sc_hd__fill_1
XFILLER_36_87 vssd1 vssd1 vccd1 vccd1 sky130_fd_sc_hd__fill_1
XFILLER_14_179 vssd1 vssd1 vccd1 vccd1 sky130_fd_sc_hd__fill_2
XFILLER_14_157 vssd1 vssd1 vccd1 vccd1 sky130_fd_sc_hd__fill_2
XFILLER_10_330 vssd1 vssd1 vccd1 vccd1 sky130_fd_sc_hd__fill_1
XFILLER_77_330 vssd1 vssd1 vccd1 vccd1 sky130_fd_sc_hd__fill_4
XANTENNA__2285__C _2352_/C vssd1 vssd1 vccd1 vccd1 sky130_fd_sc_hd__diode_2
XTAP_TAPCELL_ROW_63_704 vssd1 vccd1 sky130_fd_sc_hd__tapvpwrvgnd_1
X_1983_ _1982_/A _1982_/C _1982_/B vssd1 vssd1 vccd1 vccd1 _1984_/B sky130_fd_sc_hd__a21o_2
XFILLER_20_127 vssd1 vssd1 vccd1 vccd1 sky130_fd_sc_hd__fill_2
X_2604_ _2594_/B _2590_/Y _2601_/C _2605_/B _2603_/Y vssd1 vssd1 vccd1 vccd1 _3142_/D
+ sky130_fd_sc_hd__a311oi_2
X_2535_ _2926_/B _2926_/C _3278_/Q vssd1 vssd1 vccd1 vccd1 _2535_/X sky130_fd_sc_hd__and3_2
X_2466_ hold702/X wire59/X _2465_/X _1602_/X vssd1 vssd1 vccd1 vccd1 _3091_/D sky130_fd_sc_hd__a22o_2
X_2397_ _2399_/A _2384_/B _2399_/B _2384_/A vssd1 vssd1 vccd1 vccd1 _2400_/A sky130_fd_sc_hd__a22o_2
XFILLER_3_91 vssd1 vssd1 vccd1 vccd1 sky130_fd_sc_hd__fill_8
X_3018_ _3090_/CLK _3018_/D fanout211/X vssd1 vssd1 vccd1 vccd1 _3018_/Q sky130_fd_sc_hd__dfrtp_2
XANTENNA_fanout153_X _2263_/A vssd1 vssd1 vccd1 vccd1 sky130_fd_sc_hd__diode_2
XTAP_TAPCELL_ROW_34_461 vssd1 vccd1 sky130_fd_sc_hd__tapvpwrvgnd_1
XFILLER_24_488 vssd1 vssd1 vccd1 vccd1 sky130_fd_sc_hd__fill_4
XFILLER_24_477 vssd1 vssd1 vccd1 vccd1 sky130_fd_sc_hd__fill_4
XFILLER_24_466 vssd1 vssd1 vccd1 vccd1 sky130_fd_sc_hd__fill_2
XFILLER_24_455 vssd1 vssd1 vccd1 vccd1 sky130_fd_sc_hd__fill_1
XFILLER_7_109 vssd1 vssd1 vccd1 vccd1 sky130_fd_sc_hd__fill_2
XFILLER_22_45 vssd1 vssd1 vccd1 vccd1 sky130_fd_sc_hd__fill_2
XANTENNA_wire66_X wire66/X vssd1 vssd1 vccd1 vccd1 sky130_fd_sc_hd__diode_2
XFILLER_3_337 vssd1 vssd1 vccd1 vccd1 sky130_fd_sc_hd__fill_4
XANTENNA__2561__A1 _1569_/D vssd1 vssd1 vccd1 vccd1 sky130_fd_sc_hd__diode_2
XANTENNA__2667__A _2686_/A vssd1 vssd1 vccd1 vccd1 sky130_fd_sc_hd__diode_2
Xfanout140 _3088_/Q vssd1 vssd1 vccd1 vccd1 _2472_/A sky130_fd_sc_hd__clkdlybuf4s25_1
Xfanout151 _3048_/Q vssd1 vssd1 vccd1 vccd1 _2284_/B sky130_fd_sc_hd__clkdlybuf4s25_1
Xfanout162 _3042_/Q vssd1 vssd1 vccd1 vccd1 _2029_/C sky130_fd_sc_hd__clkdlybuf4s25_1
Xfanout173 _3036_/Q vssd1 vssd1 vccd1 vccd1 _2264_/B sky130_fd_sc_hd__clkdlybuf4s25_1
XTAP_TAPCELL_ROW_77_829 vssd1 vccd1 sky130_fd_sc_hd__tapvpwrvgnd_1
Xfanout184 _2124_/A vssd1 vssd1 vccd1 vccd1 _2205_/A sky130_fd_sc_hd__clkdlybuf4s25_1
Xfanout195 _1962_/B vssd1 vssd1 vccd1 vccd1 _1862_/C sky130_fd_sc_hd__clkdlybuf4s25_1
XFILLER_63_52 vssd1 vssd1 vccd1 vccd1 sky130_fd_sc_hd__fill_4
XANTENNA__2552__A1 _2453_/X vssd1 vssd1 vccd1 vccd1 sky130_fd_sc_hd__diode_2
X_2320_ _2283_/A _2283_/B _2289_/B vssd1 vssd1 vccd1 vccd1 _2320_/X sky130_fd_sc_hd__o21a_2
X_2251_ _2252_/B _2252_/C _2252_/D _2252_/A vssd1 vssd1 vccd1 vccd1 _2305_/A sky130_fd_sc_hd__a22oi_2
XPHY_EDGE_ROW_0_Left_80 vssd1 vssd1 vccd1 vccd1 sky130_fd_sc_hd__decap_3
XFILLER_33_5 vssd1 vssd1 vccd1 vccd1 sky130_fd_sc_hd__fill_4
XANTENNA_clkbuf_leaf_23_clk_A clkload2/A vssd1 vssd1 vccd1 vccd1 sky130_fd_sc_hd__diode_2
X_2182_ _2182_/A _2206_/A vssd1 vssd1 vccd1 vccd1 _2191_/A sky130_fd_sc_hd__or2_2
XFILLER_19_3 vssd1 vssd1 vccd1 vccd1 sky130_fd_sc_hd__fill_8
XANTENNA_clkbuf_leaf_38_clk_A clkbuf_leaf_2_clk/A vssd1 vssd1 vccd1 vccd1 sky130_fd_sc_hd__diode_2
X_1966_ _1966_/A _1966_/B vssd1 vssd1 vccd1 vccd1 _1972_/A sky130_fd_sc_hd__xnor2_2
X_1897_ _2005_/C _2029_/C _1962_/B _1998_/B vssd1 vssd1 vccd1 vccd1 _1900_/A sky130_fd_sc_hd__nand4_2
XANTENNA_fanout113_A _2686_/A vssd1 vssd1 vccd1 vccd1 sky130_fd_sc_hd__diode_2
XANTENNA__2543__A1 _2550_/A1 vssd1 vssd1 vccd1 vccd1 sky130_fd_sc_hd__diode_2
X_2518_ _3259_/Q _2960_/A2 wire66/X _3241_/Q _2517_/X vssd1 vssd1 vccd1 vccd1 _2518_/X
+ sky130_fd_sc_hd__a221o_2
X_2449_ _2533_/A _2472_/B _3343_/Q vssd1 vssd1 vccd1 vccd1 _2449_/X sky130_fd_sc_hd__and3_2
XFILLER_17_89 vssd1 vssd1 vccd1 vccd1 sky130_fd_sc_hd__fill_2
XFILLER_33_55 vssd1 vssd1 vccd1 vccd1 sky130_fd_sc_hd__fill_1
XFILLER_3_167 vssd1 vssd1 vccd1 vccd1 sky130_fd_sc_hd__fill_1
XFILLER_59_171 vssd1 vssd1 vccd1 vccd1 sky130_fd_sc_hd__fill_2
XFILLER_58_85 vssd1 vssd1 vccd1 vccd1 sky130_fd_sc_hd__fill_8
XFILLER_74_141 vssd1 vccd1 vssd1 vccd1 sky130_ef_sc_hd__decap_40_12
XTAP_TAPCELL_ROW_45_556 vssd1 vccd1 sky130_fd_sc_hd__tapvpwrvgnd_1
X_1820_ _1820_/A _1820_/B vssd1 vssd1 vccd1 vccd1 _1822_/B sky130_fd_sc_hd__nor2_2
X_1751_ _2297_/A hold706/X _1771_/S vssd1 vssd1 vccd1 vccd1 _3031_/D sky130_fd_sc_hd__mux2_1
Xhold407 _3347_/Q vssd1 vssd1 vccd1 vccd1 hold407/X sky130_fd_sc_hd__dlygate4sd3_1
Xhold418 _3344_/Q vssd1 vssd1 vccd1 vccd1 hold418/X sky130_fd_sc_hd__dlygate4sd3_1
X_1682_ _1682_/A _1682_/B vssd1 vssd1 vccd1 vccd1 _1682_/Y sky130_fd_sc_hd__xnor2_2
X_3421_ _3429_/CLK _3421_/D fanout224/X vssd1 vssd1 vccd1 vccd1 _3421_/Q sky130_fd_sc_hd__dfrtp_2
Xhold429 _3388_/Q vssd1 vssd1 vccd1 vccd1 hold429/X sky130_fd_sc_hd__dlygate4sd3_1
X_3352_ _3352_/CLK _3352_/D fanout254/X vssd1 vssd1 vccd1 vccd1 _3352_/Q sky130_fd_sc_hd__dfrtp_2
X_2303_ _2303_/A _2303_/B _2303_/C vssd1 vssd1 vccd1 vccd1 _2303_/X sky130_fd_sc_hd__and3_2
X_3283_ _3392_/CLK _3283_/D fanout252/X vssd1 vssd1 vccd1 vccd1 _3283_/Q sky130_fd_sc_hd__dfrtp_2
XANTENNA__2100__A _2421_/B vssd1 vssd1 vccd1 vccd1 sky130_fd_sc_hd__diode_2
X_2234_ _2234_/A _2234_/B vssd1 vssd1 vccd1 vccd1 _2235_/C sky130_fd_sc_hd__xnor2_2
X_2165_ _2165_/A _2165_/B vssd1 vssd1 vccd1 vccd1 _2165_/Y sky130_fd_sc_hd__xnor2_2
XFILLER_65_163 vssd1 vssd1 vccd1 vccd1 sky130_fd_sc_hd__fill_4
X_2096_ _2124_/A _2154_/B _2374_/S vssd1 vssd1 vccd1 vccd1 _2096_/X sky130_fd_sc_hd__and3_2
XFILLER_65_185 vssd1 vssd1 vccd1 vccd1 sky130_fd_sc_hd__fill_1
XANTENNA__2461__B1 _2894_/B1 vssd1 vssd1 vccd1 vccd1 sky130_fd_sc_hd__diode_2
X_2998_ _3001_/A vssd1 vssd1 vccd1 vccd1 _2998_/Y sky130_fd_sc_hd__inv_2
X_1949_ _1949_/A _1949_/B vssd1 vssd1 vccd1 vccd1 _1958_/B sky130_fd_sc_hd__xnor2_2
XANTENNA_fanout116_X _2961_/A1 vssd1 vssd1 vccd1 vccd1 sky130_fd_sc_hd__diode_2
XFILLER_79_29 vssd1 vccd1 vssd1 vccd1 sky130_ef_sc_hd__decap_40_12
XANTENNA__2516__B2 _1602_/X vssd1 vssd1 vccd1 vccd1 sky130_fd_sc_hd__diode_2
XTAP_TAPCELL_ROW_8_237 vssd1 vccd1 sky130_fd_sc_hd__tapvpwrvgnd_1
XFILLER_0_126 vssd1 vssd1 vccd1 vccd1 sky130_fd_sc_hd__fill_4
XFILLER_76_417 vssd1 vssd1 vccd1 vccd1 sky130_fd_sc_hd__fill_2
XFILLER_28_11 vssd1 vssd1 vccd1 vccd1 sky130_fd_sc_hd__fill_2
XFILLER_71_133 vssd1 vssd1 vccd1 vccd1 sky130_fd_sc_hd__fill_4
XFILLER_71_111 vssd1 vssd1 vccd1 vccd1 sky130_fd_sc_hd__fill_1
XFILLER_44_336 vssd1 vssd1 vccd1 vccd1 sky130_fd_sc_hd__fill_1
XFILLER_71_166 vssd1 vssd1 vccd1 vccd1 sky130_fd_sc_hd__fill_2
XFILLER_71_155 vssd1 vssd1 vccd1 vccd1 sky130_fd_sc_hd__fill_4
XTAP_TAPCELL_ROW_42_526 vssd1 vccd1 sky130_fd_sc_hd__tapvpwrvgnd_1
XANTENNA_fanout29_X _2685_/S vssd1 vssd1 vccd1 vccd1 sky130_fd_sc_hd__diode_2
XFILLER_4_421 vssd1 vssd1 vccd1 vccd1 sky130_fd_sc_hd__fill_4
XFILLER_79_277 vssd1 vssd1 vccd1 vccd1 sky130_fd_sc_hd__fill_2
XFILLER_39_119 vssd1 vssd1 vccd1 vccd1 sky130_fd_sc_hd__fill_1
XPHY_EDGE_ROW_13_Right_13 vssd1 vssd1 vccd1 vccd1 sky130_fd_sc_hd__decap_3
X_2921_ _3212_/Q _2838_/B _2920_/X vssd1 vssd1 vccd1 vccd1 _2921_/X sky130_fd_sc_hd__a21o_2
XFILLER_62_188 vssd1 vssd1 vccd1 vccd1 sky130_fd_sc_hd__fill_1
X_2852_ hold395/X _2638_/X _2852_/S vssd1 vssd1 vccd1 vccd1 _3356_/D sky130_fd_sc_hd__mux2_1
X_2783_ hold460/X _2802_/A1 _2799_/S vssd1 vssd1 vccd1 vccd1 _3290_/D sky130_fd_sc_hd__mux2_1
X_1803_ _1993_/S _1800_/X _1824_/A _1802_/X vssd1 vssd1 vccd1 vccd1 _3057_/D sky130_fd_sc_hd__a31o_2
XTAP_TAPCELL_ROW_13_283 vssd1 vccd1 sky130_fd_sc_hd__tapvpwrvgnd_1
XPHY_EDGE_ROW_22_Right_22 vssd1 vssd1 vccd1 vccd1 sky130_fd_sc_hd__decap_3
X_1734_ _3087_/Q _3070_/Q vssd1 vssd1 vccd1 vccd1 _1735_/B sky130_fd_sc_hd__or2_2
X_3404_ _3404_/CLK _3404_/D load_slew281/X vssd1 vssd1 vccd1 vccd1 _3404_/Q sky130_fd_sc_hd__dfrtp_2
X_1665_ _3076_/Q _3059_/Q vssd1 vssd1 vccd1 vccd1 _1666_/B sky130_fd_sc_hd__nand2_2
X_1596_ _3424_/Q _1621_/A hold385/X vssd1 vssd1 vccd1 vccd1 _1596_/X sky130_fd_sc_hd__a21o_2
X_3335_ _3394_/CLK _3335_/D load_slew276/X vssd1 vssd1 vccd1 vccd1 _3335_/Q sky130_fd_sc_hd__dfrtp_2
XTAP_TAPCELL_ROW_5_218 vssd1 vccd1 sky130_fd_sc_hd__tapvpwrvgnd_1
X_3266_ _3394_/CLK _3266_/D load_slew278/X vssd1 vssd1 vccd1 vccd1 _3266_/Q sky130_fd_sc_hd__dfrtp_2
XPHY_EDGE_ROW_31_Right_31 vssd1 vssd1 vccd1 vccd1 sky130_fd_sc_hd__decap_3
X_2217_ _2186_/A _2186_/B _2186_/C vssd1 vssd1 vccd1 vccd1 _2224_/A sky130_fd_sc_hd__o21bai_2
X_3197_ _3359_/CLK _3197_/D load_slew234/X vssd1 vssd1 vccd1 vccd1 _3197_/Q sky130_fd_sc_hd__dfrtp_2
X_2148_ _2213_/A _2148_/B vssd1 vssd1 vccd1 vccd1 _2150_/A sky130_fd_sc_hd__nand2_2
XFILLER_26_336 vssd1 vssd1 vccd1 vccd1 sky130_fd_sc_hd__fill_1
X_2079_ _2081_/A _2081_/B _2081_/C vssd1 vssd1 vccd1 vccd1 _2089_/A sky130_fd_sc_hd__a21o_2
XFILLER_53_188 vssd1 vssd1 vccd1 vccd1 sky130_fd_sc_hd__fill_1
XFILLER_41_328 vssd1 vssd1 vccd1 vccd1 sky130_fd_sc_hd__fill_4
XANTENNA__2704__S _2704_/S vssd1 vssd1 vccd1 vccd1 sky130_fd_sc_hd__diode_2
XANTENNA__2931__C _2970_/C vssd1 vssd1 vccd1 vccd1 sky130_fd_sc_hd__diode_2
XPHY_EDGE_ROW_40_Right_40 vssd1 vssd1 vccd1 vccd1 sky130_fd_sc_hd__decap_3
XFILLER_14_79 vssd1 vssd1 vccd1 vccd1 sky130_fd_sc_hd__fill_4
XFILLER_30_34 vssd1 vssd1 vccd1 vccd1 sky130_fd_sc_hd__fill_8
XANTENNA__1563__B _2926_/C vssd1 vssd1 vccd1 vccd1 sky130_fd_sc_hd__diode_2
XFILLER_76_203 vssd1 vssd1 vccd1 vccd1 sky130_fd_sc_hd__fill_8
XFILLER_29_152 vssd1 vssd1 vccd1 vccd1 sky130_fd_sc_hd__fill_2
XTAP_TAPCELL_ROW_55_640 vssd1 vccd1 sky130_fd_sc_hd__tapvpwrvgnd_1
XFILLER_72_453 vssd1 vccd1 vssd1 vccd1 sky130_ef_sc_hd__decap_40_12
XFILLER_55_86 vssd1 vssd1 vccd1 vccd1 sky130_fd_sc_hd__fill_2
XFILLER_55_75 vssd1 vssd1 vccd1 vccd1 sky130_fd_sc_hd__fill_2
XFILLER_72_475 vssd1 vssd1 vccd1 vccd1 sky130_fd_sc_hd__fill_1
XFILLER_25_391 vssd1 vssd1 vccd1 vccd1 sky130_fd_sc_hd__fill_1
XFILLER_71_85 vssd1 vccd1 vssd1 vccd1 sky130_ef_sc_hd__decap_40_12
XTAP_TAPCELL_ROW_10_253 vssd1 vccd1 sky130_fd_sc_hd__tapvpwrvgnd_1
XFILLER_4_251 vssd1 vssd1 vccd1 vccd1 sky130_fd_sc_hd__fill_1
X_3120_ _3121_/CLK _3120_/D load_slew216/X vssd1 vssd1 vccd1 vccd1 _3120_/Q sky130_fd_sc_hd__dfrtp_2
XFILLER_67_225 vssd1 vssd1 vccd1 vccd1 sky130_fd_sc_hd__fill_1
X_3051_ _3121_/CLK _3051_/D load_slew216/X vssd1 vssd1 vccd1 vccd1 _3051_/Q sky130_fd_sc_hd__dfrtp_2
X_2002_ _2025_/A _2002_/B vssd1 vssd1 vccd1 vccd1 _2010_/A sky130_fd_sc_hd__nand2_2
XFILLER_35_177 vssd1 vssd1 vccd1 vccd1 sky130_fd_sc_hd__fill_2
XANTENNA__2967__B2 _2520_/A vssd1 vssd1 vccd1 vccd1 sky130_fd_sc_hd__diode_2
XANTENNA_clkbuf_0_clk_X clkbuf_0_clk/X vssd1 vssd1 vccd1 vccd1 sky130_fd_sc_hd__diode_2
X_2904_ _2964_/B _2970_/C _3210_/Q vssd1 vssd1 vccd1 vccd1 _2904_/X sky130_fd_sc_hd__and3_2
XTAP_TAPCELL_ROW_61_687 vssd1 vccd1 sky130_fd_sc_hd__tapvpwrvgnd_1
XFILLER_50_158 vssd1 vssd1 vccd1 vccd1 sky130_fd_sc_hd__fill_2
X_2835_ hold563/X _2642_/X _2837_/S vssd1 vssd1 vccd1 vccd1 _3340_/D sky130_fd_sc_hd__mux2_1
X_2766_ hold414/X _2618_/X _2776_/S vssd1 vssd1 vccd1 vccd1 _3274_/D sky130_fd_sc_hd__mux2_1
X_2697_ hold442/X _2811_/A1 _2700_/S vssd1 vssd1 vccd1 vccd1 _3209_/D sky130_fd_sc_hd__mux2_1
X_1717_ _1715_/Y _1717_/B vssd1 vssd1 vccd1 vccd1 _1719_/A sky130_fd_sc_hd__and2b_2
XANTENNA__2479__B _2959_/C vssd1 vssd1 vccd1 vccd1 sky130_fd_sc_hd__diode_2
X_1648_ hold658/X _1647_/Y _1690_/S vssd1 vssd1 vccd1 vccd1 _3006_/D sky130_fd_sc_hd__mux2_1
X_3318_ _3387_/CLK _3318_/D load_slew240/X vssd1 vssd1 vccd1 vccd1 _3318_/Q sky130_fd_sc_hd__dfrtp_2
X_1579_ _1625_/A vssd1 vssd1 vccd1 vccd1 _1580_/C sky130_fd_sc_hd__inv_2
XANTENNA__2926__C _2926_/C vssd1 vssd1 vccd1 vccd1 sky130_fd_sc_hd__diode_2
X_3249_ _3397_/CLK _3249_/D load_slew244/X vssd1 vssd1 vccd1 vccd1 _3249_/Q sky130_fd_sc_hd__dfrtp_2
XTAP_TAPCELL_ROW_52_610 vssd1 vccd1 sky130_fd_sc_hd__tapvpwrvgnd_1
XANTENNA__1839__A _2029_/B vssd1 vssd1 vccd1 vccd1 sky130_fd_sc_hd__diode_2
XFILLER_41_125 vssd1 vssd1 vccd1 vccd1 sky130_fd_sc_hd__fill_1
XTAP_TAPCELL_ROW_24_378 vssd1 vccd1 sky130_fd_sc_hd__tapvpwrvgnd_1
XFILLER_41_169 vssd1 vssd1 vccd1 vccd1 sky130_fd_sc_hd__fill_2
XFILLER_41_11 vssd1 vssd1 vccd1 vccd1 sky130_fd_sc_hd__fill_1
XFILLER_41_55 vssd1 vssd1 vccd1 vccd1 sky130_fd_sc_hd__fill_1
XANTENNA_fanout96_X _2923_/B2 vssd1 vssd1 vccd1 vccd1 sky130_fd_sc_hd__diode_2
Xhold590 _3196_/Q vssd1 vssd1 vccd1 vccd1 hold590/X sky130_fd_sc_hd__dlygate4sd3_1
XFILLER_1_276 vssd1 vssd1 vccd1 vccd1 sky130_fd_sc_hd__fill_4
XFILLER_1_265 vssd1 vssd1 vccd1 vccd1 sky130_fd_sc_hd__fill_2
XANTENNA__2894__B1 _2894_/B1 vssd1 vssd1 vccd1 vccd1 sky130_fd_sc_hd__diode_2
XFILLER_2_27 vssd1 vssd1 vccd1 vccd1 sky130_fd_sc_hd__fill_1
XFILLER_66_85 vssd1 vccd1 vssd1 vccd1 sky130_ef_sc_hd__decap_40_12
XFILLER_17_111 vssd1 vssd1 vccd1 vccd1 sky130_fd_sc_hd__fill_1
XFILLER_17_100 vssd1 vssd1 vccd1 vccd1 sky130_fd_sc_hd__fill_2
XFILLER_57_291 vssd1 vssd1 vccd1 vccd1 sky130_fd_sc_hd__fill_4
XFILLER_17_155 vssd1 vssd1 vccd1 vccd1 sky130_fd_sc_hd__fill_2
XTAP_TAPCELL_ROW_15_301 vssd1 vccd1 sky130_fd_sc_hd__tapvpwrvgnd_1
XFILLER_17_177 vssd1 vssd1 vccd1 vccd1 sky130_fd_sc_hd__fill_4
XFILLER_20_309 vssd1 vssd1 vccd1 vccd1 sky130_fd_sc_hd__fill_1
XFILLER_40_180 vssd1 vssd1 vccd1 vccd1 sky130_fd_sc_hd__fill_2
X_2620_ _3403_/Q _2610_/A _2646_/B _3126_/Q vssd1 vssd1 vccd1 vccd1 _2620_/X sky130_fd_sc_hd__a22o_2
X_2551_ _1580_/C _1629_/B _2588_/C vssd1 vssd1 vccd1 vccd1 _2559_/S sky130_fd_sc_hd__o21a_2
X_2482_ _3256_/Q _2667_/B _2648_/B _3238_/Q _2481_/X vssd1 vssd1 vccd1 vccd1 _2482_/X
+ sky130_fd_sc_hd__a221o_2
X_1502_ _2533_/A vssd1 vssd1 vccd1 vccd1 _2440_/A sky130_fd_sc_hd__inv_2
XFILLER_49_3 vssd1 vccd1 vssd1 vccd1 sky130_ef_sc_hd__decap_40_12
X_3103_ _3121_/CLK _3103_/D fanout217/X vssd1 vssd1 vccd1 vccd1 _3103_/Q sky130_fd_sc_hd__dfrtp_2
X_3034_ _3436_/CLK _3034_/D fanout228/X vssd1 vssd1 vccd1 vccd1 _3034_/Q sky130_fd_sc_hd__dfrtp_2
XTAP_TAPCELL_ROW_66_735 vssd1 vccd1 sky130_fd_sc_hd__tapvpwrvgnd_1
XANTENNA__2101__A2 _2421_/B vssd1 vssd1 vccd1 vccd1 sky130_fd_sc_hd__diode_2
XFILLER_51_434 vssd1 vssd1 vccd1 vccd1 sky130_fd_sc_hd__fill_2
XTAP_TAPCELL_ROW_21_348 vssd1 vccd1 sky130_fd_sc_hd__tapvpwrvgnd_1
X_2818_ hold601/X _2818_/A1 _2818_/S vssd1 vssd1 vccd1 vccd1 _3324_/D sky130_fd_sc_hd__mux2_1
X_2749_ hold584/X _2844_/A1 _2761_/S vssd1 vssd1 vccd1 vccd1 _3258_/D sky130_fd_sc_hd__mux2_1
XANTENNA__2002__B _2002_/B vssd1 vssd1 vccd1 vccd1 sky130_fd_sc_hd__diode_2
XTAP_TAPCELL_ROW_29_415 vssd1 vccd1 sky130_fd_sc_hd__tapvpwrvgnd_1
XFILLER_36_11 vssd1 vssd1 vccd1 vccd1 sky130_fd_sc_hd__fill_1
XFILLER_54_272 vssd1 vssd1 vccd1 vccd1 sky130_fd_sc_hd__fill_1
XANTENNA_fanout11_X _2856_/S vssd1 vssd1 vccd1 vccd1 sky130_fd_sc_hd__diode_2
XFILLER_52_65 vssd1 vssd1 vccd1 vccd1 sky130_fd_sc_hd__fill_1
XFILLER_52_87 vssd1 vssd1 vccd1 vccd1 sky130_fd_sc_hd__fill_4
XANTENNA__2285__D _2326_/B vssd1 vssd1 vccd1 vccd1 sky130_fd_sc_hd__diode_2
XTAP_TAPCELL_ROW_63_705 vssd1 vccd1 sky130_fd_sc_hd__tapvpwrvgnd_1
X_1982_ _1982_/A _1982_/B _1982_/C vssd1 vssd1 vccd1 vccd1 _1984_/A sky130_fd_sc_hd__nand3_2
XFILLER_9_151 vssd1 vssd1 vccd1 vccd1 sky130_fd_sc_hd__fill_2
XANTENNA__2802__S _2814_/S vssd1 vssd1 vccd1 vccd1 sky130_fd_sc_hd__diode_2
XFILLER_9_184 vssd1 vssd1 vccd1 vccd1 sky130_fd_sc_hd__fill_1
X_2603_ _3142_/Q _2603_/B vssd1 vssd1 vccd1 vccd1 _2603_/Y sky130_fd_sc_hd__nor2_2
X_2534_ _3188_/Q _2667_/B _2648_/B _3170_/Q _2533_/X vssd1 vssd1 vccd1 vccd1 _2534_/X
+ sky130_fd_sc_hd__a221o_2
XANTENNA__2570__A2 _1622_/C vssd1 vssd1 vccd1 vccd1 sky130_fd_sc_hd__diode_2
X_2465_ _2540_/A _2465_/B vssd1 vssd1 vccd1 vccd1 _2465_/X sky130_fd_sc_hd__and2_2
X_2396_ _2381_/A _2381_/B _2388_/B vssd1 vssd1 vccd1 vccd1 _2406_/B sky130_fd_sc_hd__o21ai_2
Xwire10 wire10/A vssd1 vssd1 vccd1 vccd1 wire8/A sky130_fd_sc_hd__clkdlybuf4s25_1
X_3017_ _3090_/CLK _3017_/D wire208/A vssd1 vssd1 vccd1 vccd1 _3017_/Q sky130_fd_sc_hd__dfrtp_2
XTAP_TAPCELL_ROW_34_462 vssd1 vccd1 sky130_fd_sc_hd__tapvpwrvgnd_1
XANTENNA__2712__S _2723_/S vssd1 vssd1 vccd1 vccd1 sky130_fd_sc_hd__diode_2
XANTENNA_clkbuf_3_2__f_clk_A clkbuf_0_clk/X vssd1 vssd1 vccd1 vccd1 sky130_fd_sc_hd__diode_2
XANTENNA__2561__A2 _2453_/X vssd1 vssd1 vccd1 vccd1 sky130_fd_sc_hd__diode_2
XANTENNA__2667__B _2667_/B vssd1 vssd1 vccd1 vccd1 sky130_fd_sc_hd__diode_2
Xfanout130 _2472_/B vssd1 vssd1 vccd1 vccd1 _2926_/C sky130_fd_sc_hd__clkdlybuf4s25_1
XFILLER_78_139 vssd1 vssd1 vccd1 vccd1 sky130_fd_sc_hd__fill_1
Xfanout141 _3053_/Q vssd1 vssd1 vccd1 vccd1 _2399_/A sky130_fd_sc_hd__clkdlybuf4s25_1
Xfanout152 _3048_/Q vssd1 vssd1 vccd1 vccd1 _2146_/D sky130_fd_sc_hd__clkdlybuf4s25_1
Xfanout163 _3042_/Q vssd1 vssd1 vccd1 vccd1 _1862_/A sky130_fd_sc_hd__clkdlybuf4s25_1
Xfanout174 _3035_/Q vssd1 vssd1 vccd1 vccd1 _2383_/B sky130_fd_sc_hd__clkdlybuf4s25_1
Xfanout185 _3030_/Q vssd1 vssd1 vccd1 vccd1 _2124_/A sky130_fd_sc_hd__clkdlybuf4s25_1
Xfanout196 _3024_/Q vssd1 vssd1 vccd1 vccd1 _1962_/B sky130_fd_sc_hd__clkdlybuf4s25_1
XFILLER_74_323 vssd1 vssd1 vccd1 vccd1 sky130_fd_sc_hd__fill_2
XFILLER_47_54 vssd1 vssd1 vccd1 vccd1 sky130_fd_sc_hd__fill_2
XFILLER_74_367 vssd1 vssd1 vccd1 vccd1 sky130_fd_sc_hd__fill_1
XFILLER_15_401 vssd1 vssd1 vccd1 vccd1 sky130_fd_sc_hd__fill_1
XFILLER_15_434 vssd1 vssd1 vccd1 vccd1 sky130_fd_sc_hd__fill_1
XPHY_EDGE_ROW_69_Right_69 vssd1 vssd1 vccd1 vccd1 sky130_fd_sc_hd__decap_3
XFILLER_15_467 vssd1 vssd1 vccd1 vccd1 sky130_fd_sc_hd__fill_4
XFILLER_8_15 vssd1 vssd1 vccd1 vccd1 sky130_fd_sc_hd__fill_2
XFILLER_30_426 vssd1 vssd1 vccd1 vccd1 sky130_fd_sc_hd__fill_4
XFILLER_30_448 vssd1 vssd1 vccd1 vccd1 sky130_fd_sc_hd__fill_2
XFILLER_10_183 vssd1 vssd1 vccd1 vccd1 sky130_fd_sc_hd__fill_1
XPHY_EDGE_ROW_78_Right_78 vssd1 vssd1 vccd1 vccd1 sky130_fd_sc_hd__decap_3
XANTENNA__1760__A0 _1970_/B vssd1 vssd1 vccd1 vccd1 sky130_fd_sc_hd__diode_2
X_2250_ _2211_/A _2250_/B vssd1 vssd1 vccd1 vccd1 _2252_/D sky130_fd_sc_hd__nand2b_2
X_2181_ _2257_/B _2326_/B _2279_/B _2318_/B vssd1 vssd1 vccd1 vccd1 _2206_/A sky130_fd_sc_hd__and4_2
XTAP_TAPCELL_ROW_48_576 vssd1 vccd1 sky130_fd_sc_hd__tapvpwrvgnd_1
X_1965_ _1965_/A _1965_/B vssd1 vssd1 vccd1 vccd1 _1966_/B sky130_fd_sc_hd__xor2_2
XTAP_TAPCELL_ROW_31_432 vssd1 vccd1 sky130_fd_sc_hd__tapvpwrvgnd_1
X_1896_ _1867_/A _1867_/B _1867_/C vssd1 vssd1 vccd1 vccd1 _1903_/A sky130_fd_sc_hd__o21bai_2
XANTENNA__1751__A0 _2297_/A vssd1 vssd1 vccd1 vccd1 sky130_fd_sc_hd__diode_2
XANTENNA__2543__A2 _2453_/X vssd1 vssd1 vccd1 vccd1 sky130_fd_sc_hd__diode_2
X_2517_ _2959_/B _2957_/C _3277_/Q vssd1 vssd1 vccd1 vccd1 _2517_/X sky130_fd_sc_hd__and3_2
XFILLER_0_319 vssd1 vssd1 vccd1 vccd1 sky130_fd_sc_hd__fill_1
X_2448_ _3181_/Q _2667_/B _2648_/B _3163_/Q _2447_/X vssd1 vssd1 vccd1 vccd1 _2448_/X
+ sky130_fd_sc_hd__a221o_2
X_2379_ _2381_/A _2381_/B vssd1 vssd1 vccd1 vccd1 _2382_/A sky130_fd_sc_hd__and2_2
XFILLER_68_161 vssd1 vssd1 vccd1 vccd1 sky130_fd_sc_hd__fill_2
XFILLER_56_301 vssd1 vssd1 vccd1 vccd1 sky130_fd_sc_hd__fill_4
XANTENNA__2707__S _2719_/S vssd1 vssd1 vccd1 vccd1 sky130_fd_sc_hd__diode_2
XFILLER_17_35 vssd1 vssd1 vccd1 vccd1 sky130_fd_sc_hd__fill_4
XANTENNA__1806__A1 _1805_/A vssd1 vssd1 vccd1 vccd1 sky130_fd_sc_hd__diode_2
XFILLER_71_337 vssd1 vssd1 vccd1 vccd1 sky130_fd_sc_hd__fill_4
XFILLER_3_124 vssd1 vssd1 vccd1 vccd1 sky130_fd_sc_hd__fill_2
XFILLER_3_113 vssd1 vssd1 vccd1 vccd1 sky130_fd_sc_hd__fill_1
XANTENNA__2534__A2 _2667_/B vssd1 vssd1 vccd1 vccd1 sky130_fd_sc_hd__diode_2
XANTENNA__1742__A0 _1805_/A vssd1 vssd1 vccd1 vccd1 sky130_fd_sc_hd__diode_2
XFILLER_47_334 vssd1 vssd1 vccd1 vccd1 sky130_fd_sc_hd__fill_2
XANTENNA__2617__S _2647_/S vssd1 vssd1 vccd1 vccd1 sky130_fd_sc_hd__diode_2
XFILLER_74_153 vssd1 vssd1 vccd1 vccd1 sky130_fd_sc_hd__fill_4
XFILLER_62_304 vssd1 vssd1 vccd1 vccd1 sky130_fd_sc_hd__fill_4
XANTENNA__3021__RESET_B fanout214/X vssd1 vssd1 vccd1 vccd1 sky130_fd_sc_hd__diode_2
XTAP_TAPCELL_ROW_2_190 vssd1 vccd1 sky130_fd_sc_hd__tapvpwrvgnd_1
XFILLER_74_85 vssd1 vssd1 vccd1 vccd1 sky130_fd_sc_hd__fill_8
XTAP_TAPCELL_ROW_45_557 vssd1 vccd1 sky130_fd_sc_hd__tapvpwrvgnd_1
X_1750_ _2124_/A hold474/X _1773_/S vssd1 vssd1 vccd1 vccd1 _3030_/D sky130_fd_sc_hd__mux2_1
XFILLER_11_470 vssd1 vssd1 vccd1 vccd1 sky130_fd_sc_hd__fill_1
XANTENNA__1907__D _1970_/B vssd1 vssd1 vccd1 vccd1 sky130_fd_sc_hd__diode_2
Xhold408 _3285_/Q vssd1 vssd1 vccd1 vccd1 hold408/X sky130_fd_sc_hd__dlygate4sd3_1
Xmax_cap105 wire106/X vssd1 vssd1 vccd1 vccd1 _1629_/B sky130_fd_sc_hd__clkbuf_2
X_1681_ _1670_/Y _1675_/B _1672_/B vssd1 vssd1 vccd1 vccd1 _1682_/B sky130_fd_sc_hd__o21ai_2
X_3420_ _3472_/CLK _3420_/D fanout268/X vssd1 vssd1 vccd1 vccd1 _3420_/Q sky130_fd_sc_hd__dfrtp_2
Xhold419 _3351_/Q vssd1 vssd1 vccd1 vccd1 hold419/X sky130_fd_sc_hd__dlygate4sd3_1
XANTENNA__2525__A2 _2960_/A2 vssd1 vssd1 vccd1 vccd1 sky130_fd_sc_hd__diode_2
X_3351_ _3404_/CLK _3351_/D load_slew281/X vssd1 vssd1 vccd1 vccd1 _3351_/Q sky130_fd_sc_hd__dfrtp_2
X_2302_ _2302_/A _2302_/B vssd1 vssd1 vccd1 vccd1 _2343_/A sky130_fd_sc_hd__or2_2
XFILLER_31_3 vssd1 vssd1 vccd1 vccd1 sky130_fd_sc_hd__fill_8
X_3282_ _3337_/CLK _3282_/D fanout235/X vssd1 vssd1 vccd1 vccd1 _3282_/Q sky130_fd_sc_hd__dfrtp_2
X_2233_ _2233_/A _2233_/B vssd1 vssd1 vccd1 vccd1 _2234_/B sky130_fd_sc_hd__xnor2_2
XFILLER_78_470 vssd1 vssd1 vccd1 vccd1 sky130_fd_sc_hd__fill_4
X_2164_ _2164_/A _2199_/A vssd1 vssd1 vccd1 vccd1 _2165_/B sky130_fd_sc_hd__nor2_2
X_2095_ _2095_/A _2421_/B vssd1 vssd1 vccd1 vccd1 _3070_/D sky130_fd_sc_hd__and2_2
X_2997_ _2997_/A vssd1 vssd1 vccd1 vccd1 _2997_/Y sky130_fd_sc_hd__inv_2
XANTENNA_fanout223_A fanout291/X vssd1 vssd1 vccd1 vccd1 sky130_fd_sc_hd__diode_2
X_1948_ _1948_/A _1973_/B vssd1 vssd1 vccd1 vccd1 _1949_/B sky130_fd_sc_hd__xor2_2
X_1879_ _1879_/A _1879_/B vssd1 vssd1 vccd1 vccd1 _1880_/B sky130_fd_sc_hd__nand2_2
XTAP_TAPCELL_ROW_8_238 vssd1 vccd1 sky130_fd_sc_hd__tapvpwrvgnd_1
XFILLER_0_105 vssd1 vssd1 vccd1 vccd1 sky130_fd_sc_hd__fill_2
XFILLER_69_470 vssd1 vssd1 vccd1 vccd1 sky130_fd_sc_hd__fill_2
XFILLER_44_348 vssd1 vssd1 vccd1 vccd1 sky130_fd_sc_hd__fill_2
XFILLER_44_359 vssd1 vssd1 vccd1 vccd1 sky130_fd_sc_hd__fill_2
XFILLER_44_33 vssd1 vssd1 vccd1 vccd1 sky130_fd_sc_hd__fill_2
XTAP_TAPCELL_ROW_42_527 vssd1 vccd1 sky130_fd_sc_hd__tapvpwrvgnd_1
XFILLER_12_234 vssd1 vssd1 vccd1 vccd1 sky130_fd_sc_hd__fill_1
XANTENNA_clkbuf_leaf_22_clk_A clkload4/A vssd1 vssd1 vccd1 vccd1 sky130_fd_sc_hd__diode_2
XANTENNA__2204__B2 _2297_/A vssd1 vssd1 vccd1 vccd1 sky130_fd_sc_hd__diode_2
XTAP_TAPCELL_ROW_50_593 vssd1 vccd1 sky130_fd_sc_hd__tapvpwrvgnd_1
XANTENNA_clkbuf_leaf_37_clk_A clkbuf_leaf_2_clk/A vssd1 vssd1 vccd1 vccd1 sky130_fd_sc_hd__diode_2
XFILLER_69_85 vssd1 vccd1 vssd1 vccd1 sky130_ef_sc_hd__decap_40_12
XFILLER_75_440 vssd1 vssd1 vccd1 vccd1 sky130_fd_sc_hd__fill_1
XANTENNA_clkload1_A clkload1/A vssd1 vssd1 vccd1 vccd1 sky130_fd_sc_hd__diode_2
XFILLER_47_186 vssd1 vssd1 vccd1 vccd1 sky130_fd_sc_hd__fill_4
XFILLER_35_337 vssd1 vssd1 vccd1 vccd1 sky130_fd_sc_hd__fill_2
XFILLER_62_145 vssd1 vssd1 vccd1 vccd1 sky130_fd_sc_hd__fill_1
X_2920_ _3194_/Q _2927_/A2 _2927_/B1 _3176_/Q vssd1 vssd1 vccd1 vccd1 _2920_/X sky130_fd_sc_hd__a22o_2
X_2851_ hold420/X _2636_/X _2856_/S vssd1 vssd1 vccd1 vccd1 _3355_/D sky130_fd_sc_hd__mux2_1
XPHY_EDGE_ROW_28_Left_108 vssd1 vssd1 vccd1 vccd1 sky130_fd_sc_hd__decap_3
X_2782_ hold514/X _2612_/X _2799_/S vssd1 vssd1 vccd1 vccd1 _3289_/D sky130_fd_sc_hd__mux2_1
X_1802_ _3057_/Q _2091_/B vssd1 vssd1 vccd1 vccd1 _1802_/X sky130_fd_sc_hd__and2_2
XTAP_TAPCELL_ROW_13_284 vssd1 vccd1 sky130_fd_sc_hd__tapvpwrvgnd_1
X_1733_ _3087_/Q _3070_/Q vssd1 vssd1 vccd1 vccd1 _1735_/A sky130_fd_sc_hd__nand2_2
XANTENNA__2810__S _2814_/S vssd1 vssd1 vccd1 vccd1 sky130_fd_sc_hd__diode_2
X_3403_ _3404_/CLK _3403_/D load_slew281/X vssd1 vssd1 vccd1 vccd1 _3403_/Q sky130_fd_sc_hd__dfrtp_2
X_1664_ _3076_/Q _3059_/Q vssd1 vssd1 vccd1 vccd1 _1674_/A sky130_fd_sc_hd__nor2_2
X_1595_ hold740/X _2590_/A _1632_/A vssd1 vssd1 vccd1 vccd1 _3425_/D sky130_fd_sc_hd__a21o_2
X_3334_ _3352_/CLK _3334_/D fanout257/X vssd1 vssd1 vccd1 vccd1 _3334_/Q sky130_fd_sc_hd__dfrtp_2
XPHY_EDGE_ROW_37_Left_117 vssd1 vssd1 vccd1 vccd1 sky130_fd_sc_hd__decap_3
X_3265_ _3352_/CLK _3265_/D fanout252/X vssd1 vssd1 vccd1 vccd1 _3265_/Q sky130_fd_sc_hd__dfrtp_2
X_2216_ _2216_/A _2216_/B _2216_/C vssd1 vssd1 vccd1 vccd1 _2235_/B sky130_fd_sc_hd__nand3_2
XFILLER_38_120 vssd1 vccd1 vssd1 vccd1 sky130_ef_sc_hd__decap_40_12
X_3196_ _3397_/CLK _3196_/D load_slew248/X vssd1 vssd1 vccd1 vccd1 _3196_/Q sky130_fd_sc_hd__dfrtp_2
XFILLER_26_304 vssd1 vssd1 vccd1 vccd1 sky130_fd_sc_hd__fill_2
X_2147_ _2146_/A _2146_/B _2146_/C _2146_/D vssd1 vssd1 vccd1 vccd1 _2148_/B sky130_fd_sc_hd__a22o_2
XFILLER_26_326 vssd1 vssd1 vccd1 vccd1 sky130_fd_sc_hd__fill_2
X_2078_ _2078_/A _2078_/B vssd1 vssd1 vccd1 vccd1 _2081_/C sky130_fd_sc_hd__xnor2_2
XANTENNA__2781__A _2800_/A vssd1 vssd1 vccd1 vccd1 sky130_fd_sc_hd__diode_2
XPHY_EDGE_ROW_46_Left_126 vssd1 vssd1 vccd1 vccd1 sky130_fd_sc_hd__decap_3
XANTENNA__1945__B1 _1970_/B vssd1 vssd1 vccd1 vccd1 sky130_fd_sc_hd__diode_2
XANTENNA__2720__S _2723_/S vssd1 vssd1 vccd1 vccd1 sky130_fd_sc_hd__diode_2
XPHY_EDGE_ROW_55_Left_135 vssd1 vssd1 vccd1 vccd1 sky130_fd_sc_hd__decap_3
XFILLER_1_414 vssd1 vssd1 vccd1 vccd1 sky130_fd_sc_hd__fill_4
XANTENNA_fanout86_A _1622_/C vssd1 vssd1 vccd1 vccd1 sky130_fd_sc_hd__diode_2
XFILLER_49_418 vssd1 vssd1 vccd1 vccd1 sky130_fd_sc_hd__fill_1
XFILLER_72_421 vssd1 vssd1 vccd1 vccd1 sky130_fd_sc_hd__fill_4
XTAP_TAPCELL_ROW_55_641 vssd1 vccd1 sky130_fd_sc_hd__tapvpwrvgnd_1
XFILLER_72_465 vssd1 vssd1 vccd1 vccd1 sky130_fd_sc_hd__fill_8
XFILLER_44_134 vssd1 vssd1 vccd1 vccd1 sky130_fd_sc_hd__fill_4
XPHY_EDGE_ROW_64_Left_144 vssd1 vssd1 vccd1 vccd1 sky130_fd_sc_hd__decap_3
XFILLER_44_189 vssd1 vssd1 vccd1 vccd1 sky130_fd_sc_hd__fill_4
XFILLER_32_307 vssd1 vssd1 vccd1 vccd1 sky130_fd_sc_hd__fill_1
XTAP_TAPCELL_ROW_27_398 vssd1 vccd1 sky130_fd_sc_hd__tapvpwrvgnd_1
XFILLER_71_97 vssd1 vssd1 vccd1 vccd1 sky130_fd_sc_hd__fill_2
XTAP_TAPCELL_ROW_10_254 vssd1 vccd1 sky130_fd_sc_hd__tapvpwrvgnd_1
XPHY_EDGE_ROW_73_Left_153 vssd1 vssd1 vccd1 vccd1 sky130_fd_sc_hd__decap_3
X_3050_ _3423_/CLK _3050_/D fanout218/X vssd1 vssd1 vccd1 vccd1 _3050_/Q sky130_fd_sc_hd__dfrtp_2
X_2001_ _1966_/A _1966_/B _2000_/X vssd1 vssd1 vccd1 vccd1 _2012_/A sky130_fd_sc_hd__o21a_2
XFILLER_48_462 vssd1 vssd1 vccd1 vccd1 sky130_fd_sc_hd__fill_2
XFILLER_75_281 vssd1 vssd1 vccd1 vccd1 sky130_fd_sc_hd__fill_1
XFILLER_48_473 vssd1 vssd1 vccd1 vccd1 sky130_fd_sc_hd__fill_1
XTAP_TAPCELL_ROW_18_321 vssd1 vccd1 sky130_fd_sc_hd__tapvpwrvgnd_1
XFILLER_75_292 vssd1 vssd1 vccd1 vccd1 sky130_fd_sc_hd__fill_2
XANTENNA__2805__S _2818_/S vssd1 vssd1 vccd1 vccd1 sky130_fd_sc_hd__diode_2
XFILLER_35_167 vssd1 vssd1 vccd1 vccd1 sky130_fd_sc_hd__fill_1
XANTENNA__2967__A2 _2967_/A2 vssd1 vssd1 vccd1 vccd1 sky130_fd_sc_hd__diode_2
X_2903_ _3264_/Q _2971_/A2 _2971_/B1 _3246_/Q _2902_/X vssd1 vssd1 vccd1 vccd1 _2903_/X
+ sky130_fd_sc_hd__a221o_2
X_2834_ hold606/X _2640_/X _2837_/S vssd1 vssd1 vccd1 vccd1 _3339_/D sky130_fd_sc_hd__mux2_1
XTAP_TAPCELL_ROW_61_688 vssd1 vccd1 sky130_fd_sc_hd__tapvpwrvgnd_1
X_2765_ hold445/X _2803_/A1 _2776_/S vssd1 vssd1 vccd1 vccd1 _3273_/D sky130_fd_sc_hd__mux2_1
X_2696_ hold495/X _2848_/A1 _2700_/S vssd1 vssd1 vccd1 vccd1 _3208_/D sky130_fd_sc_hd__mux2_1
X_1716_ _3084_/Q _3067_/Q vssd1 vssd1 vccd1 vccd1 _1717_/B sky130_fd_sc_hd__nand2_2
X_1647_ _1647_/A _1647_/B vssd1 vssd1 vccd1 vccd1 _1647_/Y sky130_fd_sc_hd__xnor2_2
X_3317_ _3394_/CLK _3317_/D load_slew276/X vssd1 vssd1 vccd1 vccd1 _3317_/Q sky130_fd_sc_hd__dfrtp_2
X_1578_ _1583_/A _1578_/B vssd1 vssd1 vccd1 vccd1 _1625_/A sky130_fd_sc_hd__or2_2
XANTENNA_fanout290_A fanout291/X vssd1 vssd1 vccd1 vccd1 sky130_fd_sc_hd__diode_2
X_3248_ _3394_/CLK _3248_/D load_slew278/X vssd1 vssd1 vccd1 vccd1 _3248_/Q sky130_fd_sc_hd__dfrtp_2
XTAP_TAPCELL_ROW_69_755 vssd1 vccd1 sky130_fd_sc_hd__tapvpwrvgnd_1
XANTENNA_fanout176_X _2347_/A vssd1 vssd1 vccd1 vccd1 sky130_fd_sc_hd__diode_2
X_3179_ _3359_/CLK _3179_/D load_slew234/X vssd1 vssd1 vccd1 vccd1 _3179_/Q sky130_fd_sc_hd__dfrtp_2
XFILLER_26_112 vssd1 vssd1 vccd1 vccd1 sky130_fd_sc_hd__fill_2
XANTENNA__2715__S _2719_/S vssd1 vssd1 vccd1 vccd1 sky130_fd_sc_hd__diode_2
XTAP_TAPCELL_ROW_52_611 vssd1 vccd1 sky130_fd_sc_hd__tapvpwrvgnd_1
XFILLER_54_487 vssd1 vssd1 vccd1 vccd1 sky130_fd_sc_hd__fill_4
XFILLER_14_307 vssd1 vssd1 vccd1 vccd1 sky130_fd_sc_hd__fill_1
XFILLER_25_57 vssd1 vssd1 vccd1 vccd1 sky130_fd_sc_hd__fill_2
XANTENNA__2958__A2 _2960_/A2 vssd1 vssd1 vccd1 vccd1 sky130_fd_sc_hd__diode_2
XTAP_TAPCELL_ROW_24_379 vssd1 vccd1 sky130_fd_sc_hd__tapvpwrvgnd_1
XFILLER_41_34 vssd1 vssd1 vccd1 vccd1 sky130_fd_sc_hd__fill_2
Xhold580 _3008_/Q vssd1 vssd1 vccd1 vccd1 hold580/X sky130_fd_sc_hd__dlygate4sd3_1
XFILLER_9_3 vssd1 vssd1 vccd1 vccd1 sky130_fd_sc_hd__fill_8
XFILLER_1_233 vssd1 vssd1 vccd1 vccd1 sky130_fd_sc_hd__fill_2
XFILLER_1_211 vssd1 vccd1 vssd1 vccd1 sky130_ef_sc_hd__decap_40_12
XANTENNA_fanout89_X _3435_/D vssd1 vssd1 vccd1 vccd1 sky130_fd_sc_hd__diode_2
Xhold591 _3336_/Q vssd1 vssd1 vccd1 vccd1 hold591/X sky130_fd_sc_hd__dlygate4sd3_1
XANTENNA__2686__A _2686_/A vssd1 vssd1 vccd1 vccd1 sky130_fd_sc_hd__diode_2
XFILLER_66_97 vssd1 vssd1 vccd1 vccd1 sky130_fd_sc_hd__fill_4
XFILLER_45_421 vssd1 vssd1 vccd1 vccd1 sky130_fd_sc_hd__fill_1
XFILLER_72_251 vssd1 vssd1 vccd1 vccd1 sky130_fd_sc_hd__fill_1
XANTENNA__2625__S _2645_/S vssd1 vssd1 vccd1 vccd1 sky130_fd_sc_hd__diode_2
XTAP_TAPCELL_ROW_15_302 vssd1 vccd1 sky130_fd_sc_hd__tapvpwrvgnd_1
X_2550_ _2550_/A1 _2540_/X _2550_/B1 hold593/X vssd1 vssd1 vccd1 vccd1 _3105_/D sky130_fd_sc_hd__a22o_2
X_2481_ _2533_/A _2533_/B _3274_/Q vssd1 vssd1 vccd1 vccd1 _2481_/X sky130_fd_sc_hd__and3_2
X_1501_ input3/X vssd1 vssd1 vccd1 vccd1 _3442_/D sky130_fd_sc_hd__inv_2
XANTENNA__2885__A1 _2686_/A vssd1 vssd1 vccd1 vccd1 sky130_fd_sc_hd__diode_2
XANTENNA__2885__B2 _2445_/S vssd1 vssd1 vccd1 vccd1 sky130_fd_sc_hd__diode_2
X_3102_ _3436_/CLK _3102_/D fanout228/X vssd1 vssd1 vccd1 vccd1 _3102_/Q sky130_fd_sc_hd__dfrtp_2
X_3033_ _3101_/CLK _3033_/D load_slew216/X vssd1 vssd1 vccd1 vccd1 _3033_/Q sky130_fd_sc_hd__dfrtp_2
XTAP_TAPCELL_ROW_66_736 vssd1 vccd1 sky130_fd_sc_hd__tapvpwrvgnd_1
XFILLER_48_270 vssd1 vssd1 vccd1 vccd1 sky130_fd_sc_hd__fill_4
XFILLER_36_421 vssd1 vssd1 vccd1 vccd1 sky130_fd_sc_hd__fill_1
XFILLER_23_115 vssd1 vssd1 vccd1 vccd1 sky130_fd_sc_hd__fill_1
XANTENNA_fanout136_A _3088_/Q vssd1 vssd1 vccd1 vccd1 sky130_fd_sc_hd__diode_2
XTAP_TAPCELL_ROW_21_349 vssd1 vccd1 sky130_fd_sc_hd__tapvpwrvgnd_1
X_2817_ hold603/X _2817_/A1 _2818_/S vssd1 vssd1 vccd1 vccd1 _3323_/D sky130_fd_sc_hd__mux2_1
X_2748_ hold564/X _2805_/A1 _2761_/S vssd1 vssd1 vccd1 vccd1 _3257_/D sky130_fd_sc_hd__mux2_1
X_2679_ hold589/X _2850_/A1 _2685_/S vssd1 vssd1 vccd1 vccd1 _3192_/D sky130_fd_sc_hd__mux2_1
XANTENNA__2325__B1 _2352_/C vssd1 vssd1 vccd1 vccd1 sky130_fd_sc_hd__diode_2
XANTENNA__2876__A1 _2966_/A1 vssd1 vssd1 vccd1 vccd1 sky130_fd_sc_hd__diode_2
XANTENNA__2876__B2 _2942_/B2 vssd1 vssd1 vccd1 vccd1 sky130_fd_sc_hd__diode_2
XTAP_TAPCELL_ROW_29_416 vssd1 vccd1 sky130_fd_sc_hd__tapvpwrvgnd_1
XFILLER_36_45 vssd1 vssd1 vccd1 vccd1 sky130_fd_sc_hd__fill_2
XFILLER_36_78 vssd1 vssd1 vccd1 vccd1 sky130_fd_sc_hd__fill_4
XANTENNA__2445__S _2445_/S vssd1 vssd1 vccd1 vccd1 sky130_fd_sc_hd__diode_2
XFILLER_52_11 vssd1 vssd1 vccd1 vccd1 sky130_fd_sc_hd__fill_1
XFILLER_52_55 vssd1 vssd1 vccd1 vccd1 sky130_fd_sc_hd__fill_8
XANTENNA__1585__A _1585_/A vssd1 vssd1 vccd1 vccd1 sky130_fd_sc_hd__diode_2
XFILLER_10_365 vssd1 vssd1 vccd1 vccd1 sky130_fd_sc_hd__fill_1
XANTENNA__3046__RESET_B fanout223/X vssd1 vssd1 vccd1 vccd1 sky130_fd_sc_hd__diode_2
XFILLER_6_369 vssd1 vssd1 vccd1 vccd1 sky130_fd_sc_hd__fill_4
XFILLER_37_229 vssd1 vssd1 vccd1 vccd1 sky130_fd_sc_hd__fill_1
XFILLER_37_207 vssd1 vssd1 vccd1 vccd1 sky130_fd_sc_hd__fill_1
XFILLER_18_432 vssd1 vssd1 vccd1 vccd1 sky130_fd_sc_hd__fill_1
XFILLER_18_421 vssd1 vssd1 vccd1 vccd1 sky130_fd_sc_hd__fill_1
XTAP_TAPCELL_ROW_63_706 vssd1 vccd1 sky130_fd_sc_hd__tapvpwrvgnd_1
X_1981_ _1981_/A _1981_/B vssd1 vssd1 vccd1 vccd1 _1982_/C sky130_fd_sc_hd__nand2_2
XTAP_TAPCELL_ROW_71_772 vssd1 vccd1 sky130_fd_sc_hd__tapvpwrvgnd_1
Xclkbuf_leaf_40_clk clkload0/A vssd1 vssd1 vccd1 vccd1 _3349_/CLK sky130_fd_sc_hd__clkbuf_8
XFILLER_13_192 vssd1 vssd1 vccd1 vccd1 sky130_fd_sc_hd__fill_8
X_2602_ _3142_/Q _2603_/B vssd1 vssd1 vccd1 vccd1 _2605_/B sky130_fd_sc_hd__and2_2
XFILLER_61_3 vssd1 vssd1 vccd1 vccd1 sky130_fd_sc_hd__fill_4
X_2533_ _2533_/A _2533_/B _3206_/Q vssd1 vssd1 vccd1 vccd1 _2533_/X sky130_fd_sc_hd__and3_2
X_2464_ _3218_/Q _2923_/A2 _2462_/X _2463_/X vssd1 vssd1 vccd1 vccd1 _2465_/B sky130_fd_sc_hd__a211o_2
X_2395_ hold378/X _2394_/Y _2412_/S vssd1 vssd1 vccd1 vccd1 _3083_/D sky130_fd_sc_hd__mux2_1
XTAP_TAPCELL_ROW_79_850 vssd1 vccd1 sky130_fd_sc_hd__tapvpwrvgnd_1
X_3016_ _3090_/CLK _3016_/D fanout211/X vssd1 vssd1 vccd1 vccd1 _3016_/Q sky130_fd_sc_hd__dfrtp_2
Xwire66 wire66/A vssd1 vssd1 vccd1 vccd1 wire66/X sky130_fd_sc_hd__clkbuf_4
XTAP_TAPCELL_ROW_34_463 vssd1 vccd1 sky130_fd_sc_hd__tapvpwrvgnd_1
Xclkbuf_leaf_31_clk clkbuf_3_4__f_clk/X vssd1 vssd1 vccd1 vccd1 _3395_/CLK sky130_fd_sc_hd__clkbuf_8
XFILLER_22_47 vssd1 vssd1 vccd1 vccd1 sky130_fd_sc_hd__fill_1
Xfanout120 _3431_/Q vssd1 vssd1 vccd1 vccd1 _2972_/B2 sky130_fd_sc_hd__clkdlybuf4s25_1
Xfanout131 _2472_/B vssd1 vssd1 vccd1 vccd1 _2924_/C sky130_fd_sc_hd__clkdlybuf4s25_1
XFILLER_78_118 vssd1 vssd1 vccd1 vccd1 sky130_fd_sc_hd__fill_1
Xfanout142 _3053_/Q vssd1 vssd1 vccd1 vccd1 _2318_/A sky130_fd_sc_hd__clkdlybuf4s25_1
Xfanout153 _3047_/Q vssd1 vssd1 vccd1 vccd1 _2263_/A sky130_fd_sc_hd__clkdlybuf4s25_1
Xfanout164 _3041_/Q vssd1 vssd1 vccd1 vccd1 _2004_/B sky130_fd_sc_hd__clkdlybuf4s25_1
Xfanout175 _3035_/Q vssd1 vssd1 vccd1 vccd1 _2264_/A sky130_fd_sc_hd__clkdlybuf4s25_1
Xfanout186 _3029_/Q vssd1 vssd1 vccd1 vccd1 _2029_/D sky130_fd_sc_hd__clkdlybuf4s25_1
Xfanout197 _1805_/B vssd1 vssd1 vccd1 vccd1 _1979_/A sky130_fd_sc_hd__clkdlybuf4s25_1
XFILLER_63_76 vssd1 vssd1 vccd1 vccd1 sky130_fd_sc_hd__fill_1
Xclkbuf_leaf_22_clk clkload4/A vssd1 vssd1 vccd1 vccd1 _3297_/CLK sky130_fd_sc_hd__clkbuf_8
XFILLER_6_111 vssd1 vssd1 vccd1 vccd1 sky130_fd_sc_hd__fill_4
XFILLER_10_195 vssd1 vssd1 vccd1 vccd1 sky130_fd_sc_hd__fill_1
XFILLER_12_91 vssd1 vssd1 vccd1 vccd1 sky130_fd_sc_hd__fill_1
X_2180_ _2257_/B _2279_/B _2318_/B _2326_/B vssd1 vssd1 vccd1 vccd1 _2182_/A sky130_fd_sc_hd__a22oi_2
XTAP_TAPCELL_ROW_76_820 vssd1 vccd1 sky130_fd_sc_hd__tapvpwrvgnd_1
XTAP_TAPCELL_ROW_48_577 vssd1 vccd1 sky130_fd_sc_hd__tapvpwrvgnd_1
XFILLER_33_210 vssd1 vssd1 vccd1 vccd1 sky130_fd_sc_hd__fill_4
XANTENNA__2813__S _2818_/S vssd1 vssd1 vccd1 vccd1 sky130_fd_sc_hd__diode_2
Xclkbuf_leaf_13_clk clkload4/A vssd1 vssd1 vccd1 vccd1 _3431_/CLK sky130_fd_sc_hd__clkbuf_8
X_1964_ _2025_/A _2005_/C vssd1 vssd1 vccd1 vccd1 _1965_/B sky130_fd_sc_hd__nand2_2
XTAP_TAPCELL_ROW_31_433 vssd1 vccd1 sky130_fd_sc_hd__tapvpwrvgnd_1
X_1895_ _1895_/A _1895_/B _1895_/C vssd1 vssd1 vccd1 vccd1 _1914_/B sky130_fd_sc_hd__and3_2
X_2516_ hold434/X wire59/X _2515_/X _1602_/X vssd1 vssd1 vccd1 vccd1 _3095_/D sky130_fd_sc_hd__a22o_2
X_2447_ _2533_/A _2533_/B _3199_/Q vssd1 vssd1 vccd1 vccd1 _2447_/X sky130_fd_sc_hd__and3_2
X_2378_ _2358_/B _2361_/B _2356_/X vssd1 vssd1 vccd1 vccd1 _2381_/B sky130_fd_sc_hd__a21o_2
XTAP_TAPCELL_ROW_39_500 vssd1 vccd1 sky130_fd_sc_hd__tapvpwrvgnd_1
XFILLER_71_305 vssd1 vssd1 vccd1 vccd1 sky130_fd_sc_hd__fill_4
XANTENNA__2723__S _2723_/S vssd1 vssd1 vccd1 vccd1 sky130_fd_sc_hd__diode_2
XFILLER_33_57 vssd1 vccd1 vssd1 vccd1 sky130_ef_sc_hd__decap_40_12
XFILLER_12_438 vssd1 vccd1 vssd1 vccd1 sky130_ef_sc_hd__decap_40_12
XFILLER_58_21 vssd1 vssd1 vccd1 vccd1 sky130_fd_sc_hd__fill_4
XANTENNA_fanout71_X _2648_/B vssd1 vssd1 vccd1 vccd1 sky130_fd_sc_hd__diode_2
XFILLER_59_173 vssd1 vssd1 vccd1 vccd1 sky130_fd_sc_hd__fill_1
XFILLER_74_31 vssd1 vssd1 vccd1 vccd1 sky130_fd_sc_hd__fill_4
XFILLER_47_368 vssd1 vssd1 vccd1 vccd1 sky130_fd_sc_hd__fill_1
XTAP_TAPCELL_ROW_2_191 vssd1 vccd1 sky130_fd_sc_hd__tapvpwrvgnd_1
XFILLER_74_187 vssd1 vssd1 vccd1 vccd1 sky130_fd_sc_hd__fill_2
XTAP_TAPCELL_ROW_45_558 vssd1 vccd1 sky130_fd_sc_hd__tapvpwrvgnd_1
XANTENNA__2633__S _2647_/S vssd1 vssd1 vccd1 vccd1 sky130_fd_sc_hd__diode_2
Xhold409 _3210_/Q vssd1 vssd1 vccd1 vccd1 hold409/X sky130_fd_sc_hd__dlygate4sd3_1
X_1680_ _1680_/A _1680_/B vssd1 vssd1 vccd1 vccd1 _1682_/A sky130_fd_sc_hd__nand2_2
X_3350_ _3388_/CLK _3350_/D fanout241/X vssd1 vssd1 vccd1 vccd1 _3350_/Q sky130_fd_sc_hd__dfrtp_2
X_2301_ _2303_/B _2303_/C _2303_/A vssd1 vssd1 vccd1 vccd1 _2302_/B sky130_fd_sc_hd__a21oi_2
X_3281_ _3302_/CLK _3281_/D fanout275/X vssd1 vssd1 vccd1 vccd1 _3281_/Q sky130_fd_sc_hd__dfrtp_2
Xclkbuf_leaf_2_clk clkbuf_leaf_2_clk/A vssd1 vssd1 vccd1 vccd1 _3090_/CLK sky130_fd_sc_hd__clkbuf_8
X_2232_ _2232_/A _2233_/B vssd1 vssd1 vccd1 vccd1 _2232_/X sky130_fd_sc_hd__or2_2
XFILLER_24_3 vssd1 vssd1 vccd1 vccd1 sky130_fd_sc_hd__fill_8
XANTENNA__2808__S _2814_/S vssd1 vssd1 vccd1 vccd1 sky130_fd_sc_hd__diode_2
X_2163_ _2163_/A _2163_/B vssd1 vssd1 vccd1 vccd1 _2199_/A sky130_fd_sc_hd__nor2_2
XFILLER_78_493 vssd1 vssd1 vccd1 vccd1 sky130_fd_sc_hd__fill_1
XFILLER_65_110 vssd1 vssd1 vccd1 vccd1 sky130_fd_sc_hd__fill_2
X_2094_ _2089_/Y _2093_/X hold737/X _2412_/S vssd1 vssd1 vccd1 vccd1 _3069_/D sky130_fd_sc_hd__o2bb2a_2
XANTENNA__2461__A2 _2894_/A2 vssd1 vssd1 vccd1 vccd1 sky130_fd_sc_hd__diode_2
X_2996_ _2997_/A vssd1 vssd1 vccd1 vccd1 _2996_/Y sky130_fd_sc_hd__inv_2
XFILLER_9_81 vssd1 vssd1 vccd1 vccd1 sky130_fd_sc_hd__fill_2
X_1947_ _1947_/A _2029_/D vssd1 vssd1 vccd1 vccd1 _1973_/B sky130_fd_sc_hd__nand2_2
X_1878_ _1876_/X _1878_/B vssd1 vssd1 vccd1 vccd1 _1880_/A sky130_fd_sc_hd__nand2b_2
XANTENNA__2498__B _2957_/C vssd1 vssd1 vccd1 vccd1 sky130_fd_sc_hd__diode_2
XTAP_TAPCELL_ROW_8_239 vssd1 vccd1 sky130_fd_sc_hd__tapvpwrvgnd_1
XFILLER_0_139 vssd1 vssd1 vccd1 vccd1 sky130_fd_sc_hd__fill_1
XFILLER_76_419 vssd1 vssd1 vccd1 vccd1 sky130_fd_sc_hd__fill_1
XANTENNA__2718__S _2723_/S vssd1 vssd1 vccd1 vccd1 sky130_fd_sc_hd__diode_2
XFILLER_56_132 vssd1 vssd1 vccd1 vccd1 sky130_fd_sc_hd__fill_1
XFILLER_71_113 vssd1 vssd1 vccd1 vccd1 sky130_fd_sc_hd__fill_8
XFILLER_44_23 vssd1 vssd1 vccd1 vccd1 sky130_fd_sc_hd__fill_4
XTAP_TAPCELL_ROW_42_528 vssd1 vccd1 sky130_fd_sc_hd__tapvpwrvgnd_1
XFILLER_44_56 vssd1 vssd1 vccd1 vccd1 sky130_fd_sc_hd__fill_4
XFILLER_8_217 vssd1 vssd1 vccd1 vccd1 sky130_fd_sc_hd__fill_8
XANTENNA__2204__A2 _2399_/A vssd1 vssd1 vccd1 vccd1 sky130_fd_sc_hd__diode_2
XTAP_TAPCELL_ROW_50_594 vssd1 vccd1 sky130_fd_sc_hd__tapvpwrvgnd_1
XFILLER_69_75 vssd1 vssd1 vccd1 vccd1 sky130_fd_sc_hd__fill_2
XFILLER_69_97 vssd1 vssd1 vccd1 vccd1 sky130_fd_sc_hd__fill_1
XFILLER_79_279 vssd1 vssd1 vccd1 vccd1 sky130_fd_sc_hd__fill_1
XTAP_TAPCELL_ROW_58_661 vssd1 vccd1 sky130_fd_sc_hd__tapvpwrvgnd_1
XANTENNA__2979__A0 _3403_/Q vssd1 vssd1 vccd1 vccd1 sky130_fd_sc_hd__diode_2
XANTENNA_clkbuf_3_4__f_clk_X clkbuf_3_4__f_clk/X vssd1 vssd1 vccd1 vccd1 sky130_fd_sc_hd__diode_2
XFILLER_50_319 vssd1 vssd1 vccd1 vccd1 sky130_fd_sc_hd__fill_4
X_2850_ hold427/X _2850_/A1 _2856_/S vssd1 vssd1 vccd1 vccd1 _3354_/D sky130_fd_sc_hd__mux2_1
X_1801_ _1800_/A _1800_/B _1800_/C vssd1 vssd1 vccd1 vccd1 _1824_/A sky130_fd_sc_hd__o21ai_2
X_2781_ _2800_/A _2781_/B _2800_/C vssd1 vssd1 vccd1 vccd1 _2781_/X sky130_fd_sc_hd__and3_2
X_1732_ hold722/X _1731_/Y _1738_/S vssd1 vssd1 vccd1 vccd1 _3019_/D sky130_fd_sc_hd__mux2_1
XTAP_TAPCELL_ROW_13_285 vssd1 vccd1 sky130_fd_sc_hd__tapvpwrvgnd_1
X_1663_ hold580/X _1690_/S _1661_/Y _1662_/X vssd1 vssd1 vccd1 vccd1 _3008_/D sky130_fd_sc_hd__o22a_2
XFILLER_7_283 vssd1 vssd1 vccd1 vccd1 sky130_fd_sc_hd__fill_4
X_3402_ _3450_/CLK _3402_/D load_slew281/X vssd1 vssd1 vccd1 vccd1 _3402_/Q sky130_fd_sc_hd__dfrtp_2
XANTENNA__2903__B1 _2971_/B1 vssd1 vssd1 vccd1 vccd1 sky130_fd_sc_hd__diode_2
X_1594_ _3440_/Q _3420_/Q _2594_/A vssd1 vssd1 vccd1 vccd1 _1632_/A sky130_fd_sc_hd__and3b_2
XANTENNA__2111__B _2154_/B vssd1 vssd1 vccd1 vccd1 sky130_fd_sc_hd__diode_2
X_3333_ _3404_/CLK _3333_/D fanout287/X vssd1 vssd1 vccd1 vccd1 _3333_/Q sky130_fd_sc_hd__dfrtp_2
X_3264_ _3395_/CLK _3264_/D fanout245/X vssd1 vssd1 vccd1 vccd1 _3264_/Q sky130_fd_sc_hd__dfrtp_2
XPHY_EDGE_ROW_7_Right_7 vssd1 vssd1 vccd1 vccd1 sky130_fd_sc_hd__decap_3
XANTENNA__3032__CLK _3423_/CLK vssd1 vssd1 vccd1 vccd1 sky130_fd_sc_hd__diode_2
X_2215_ _2216_/A _2216_/B _2216_/C vssd1 vssd1 vccd1 vccd1 _2235_/A sky130_fd_sc_hd__a21o_2
X_3195_ _3395_/CLK _3195_/D load_slew244/X vssd1 vssd1 vccd1 vccd1 _3195_/Q sky130_fd_sc_hd__dfrtp_2
XFILLER_66_441 vssd1 vssd1 vccd1 vccd1 sky130_fd_sc_hd__fill_4
XFILLER_38_132 vssd1 vssd1 vccd1 vccd1 sky130_fd_sc_hd__fill_8
X_2146_ _2146_/A _2146_/B _2146_/C _2146_/D vssd1 vssd1 vccd1 vccd1 _2213_/A sky130_fd_sc_hd__nand4_2
XFILLER_38_187 vssd1 vssd1 vccd1 vccd1 sky130_fd_sc_hd__fill_1
X_2077_ _2077_/A _2077_/B vssd1 vssd1 vccd1 vccd1 _2078_/B sky130_fd_sc_hd__or2_2
XANTENNA__2781__B _2781_/B vssd1 vssd1 vccd1 vccd1 sky130_fd_sc_hd__diode_2
X_2979_ _3403_/Q hold376/X _3408_/Q vssd1 vssd1 vccd1 vccd1 _2979_/X sky130_fd_sc_hd__mux2_1
XANTENNA_fanout121_X _2445_/S vssd1 vssd1 vccd1 vccd1 sky130_fd_sc_hd__diode_2
Xhold740 _3425_/Q vssd1 vssd1 vccd1 vccd1 hold740/X sky130_fd_sc_hd__dlygate4sd3_1
XANTENNA_fanout79_A _2901_/A2 vssd1 vssd1 vccd1 vccd1 sky130_fd_sc_hd__diode_2
XTAP_TAPCELL_ROW_55_642 vssd1 vccd1 sky130_fd_sc_hd__tapvpwrvgnd_1
XANTENNA_fanout34_X _2647_/S vssd1 vssd1 vccd1 vccd1 sky130_fd_sc_hd__diode_2
XFILLER_55_88 vssd1 vssd1 vccd1 vccd1 sky130_fd_sc_hd__fill_1
XTAP_TAPCELL_ROW_27_399 vssd1 vccd1 sky130_fd_sc_hd__tapvpwrvgnd_1
XANTENNA__1633__B1 _1690_/S vssd1 vssd1 vccd1 vccd1 sky130_fd_sc_hd__diode_2
XFILLER_40_363 vssd1 vssd1 vccd1 vccd1 sky130_fd_sc_hd__fill_1
XTAP_TAPCELL_ROW_10_255 vssd1 vccd1 sky130_fd_sc_hd__tapvpwrvgnd_1
XFILLER_4_253 vssd1 vssd1 vccd1 vccd1 sky130_fd_sc_hd__fill_1
X_2000_ _1966_/A _1966_/B _1972_/B vssd1 vssd1 vccd1 vccd1 _2000_/X sky130_fd_sc_hd__a21bo_2
XFILLER_0_492 vssd1 vssd1 vccd1 vccd1 sky130_fd_sc_hd__fill_2
XFILLER_63_411 vssd1 vssd1 vccd1 vccd1 sky130_fd_sc_hd__fill_1
XANTENNA__2882__A _2926_/B vssd1 vssd1 vccd1 vccd1 sky130_fd_sc_hd__diode_2
XTAP_TAPCELL_ROW_18_322 vssd1 vccd1 sky130_fd_sc_hd__tapvpwrvgnd_1
XFILLER_63_433 vssd1 vssd1 vccd1 vccd1 sky130_fd_sc_hd__fill_2
X_2902_ _2970_/B _2970_/C _3282_/Q vssd1 vssd1 vccd1 vccd1 _2902_/X sky130_fd_sc_hd__and3_2
X_2833_ hold476/X _2638_/X _2833_/S vssd1 vssd1 vccd1 vccd1 _3338_/D sky130_fd_sc_hd__mux2_1
XTAP_TAPCELL_ROW_61_689 vssd1 vccd1 sky130_fd_sc_hd__tapvpwrvgnd_1
XANTENNA__2821__S _2833_/S vssd1 vssd1 vccd1 vccd1 sky130_fd_sc_hd__diode_2
X_2764_ hold417/X _2802_/A1 _2780_/S vssd1 vssd1 vccd1 vccd1 _3272_/D sky130_fd_sc_hd__mux2_1
X_1715_ _3084_/Q _3067_/Q vssd1 vssd1 vccd1 vccd1 _1715_/Y sky130_fd_sc_hd__nor2_2
X_2695_ hold416/X _2809_/A1 _2700_/S vssd1 vssd1 vccd1 vccd1 _3207_/D sky130_fd_sc_hd__mux2_1
X_1646_ _1646_/A _1646_/B vssd1 vssd1 vccd1 vccd1 _1647_/B sky130_fd_sc_hd__or2_2
X_1577_ _2426_/A _3141_/Q vssd1 vssd1 vccd1 vccd1 _1578_/B sky130_fd_sc_hd__nand2b_2
X_3316_ _3352_/CLK _3316_/D fanout254/X vssd1 vssd1 vccd1 vccd1 _3316_/Q sky130_fd_sc_hd__dfrtp_2
X_3247_ _3352_/CLK _3247_/D fanout252/X vssd1 vssd1 vccd1 vccd1 _3247_/Q sky130_fd_sc_hd__dfrtp_2
XTAP_TAPCELL_ROW_69_756 vssd1 vccd1 sky130_fd_sc_hd__tapvpwrvgnd_1
X_3178_ _3397_/CLK _3178_/D load_slew248/X vssd1 vssd1 vccd1 vccd1 _3178_/Q sky130_fd_sc_hd__dfrtp_2
XPHY_EDGE_ROW_16_Left_96 vssd1 vssd1 vccd1 vccd1 sky130_fd_sc_hd__decap_3
X_2129_ _2129_/A _2152_/A _2129_/C vssd1 vssd1 vccd1 vccd1 _2136_/A sky130_fd_sc_hd__and3_2
XFILLER_26_135 vssd1 vssd1 vccd1 vccd1 sky130_fd_sc_hd__fill_1
XFILLER_54_477 vssd1 vssd1 vccd1 vccd1 sky130_fd_sc_hd__fill_1
XFILLER_25_36 vssd1 vccd1 vssd1 vccd1 sky130_ef_sc_hd__decap_40_12
XFILLER_25_25 vssd1 vssd1 vccd1 vccd1 sky130_fd_sc_hd__fill_4
XANTENNA_clkbuf_leaf_36_clk_A clkload0/A vssd1 vssd1 vccd1 vccd1 sky130_fd_sc_hd__diode_2
XTAP_TAPCELL_ROW_52_612 vssd1 vccd1 sky130_fd_sc_hd__tapvpwrvgnd_1
XANTENNA__2731__S _2742_/S vssd1 vssd1 vccd1 vccd1 sky130_fd_sc_hd__diode_2
Xhold581 _2574_/X vssd1 vssd1 vccd1 vccd1 _3126_/D sky130_fd_sc_hd__dlygate4sd3_1
Xhold570 _3102_/Q vssd1 vssd1 vccd1 vccd1 hold570/X sky130_fd_sc_hd__dlygate4sd3_1
XFILLER_1_223 vssd1 vssd1 vccd1 vccd1 sky130_fd_sc_hd__fill_1
Xhold592 _3314_/Q vssd1 vssd1 vccd1 vccd1 hold592/X sky130_fd_sc_hd__dlygate4sd3_1
XFILLER_49_205 vssd1 vssd1 vccd1 vccd1 sky130_fd_sc_hd__fill_4
XFILLER_1_267 vssd1 vssd1 vccd1 vccd1 sky130_fd_sc_hd__fill_1
XANTENNA__2686__B _2838_/B vssd1 vssd1 vccd1 vccd1 sky130_fd_sc_hd__diode_2
XANTENNA__2894__A2 _2894_/A2 vssd1 vssd1 vccd1 vccd1 sky130_fd_sc_hd__diode_2
XFILLER_2_29 vssd1 vssd1 vccd1 vccd1 sky130_fd_sc_hd__fill_4
XFILLER_66_54 vssd1 vccd1 vssd1 vccd1 sky130_ef_sc_hd__decap_40_12
XFILLER_17_157 vssd1 vssd1 vccd1 vccd1 sky130_fd_sc_hd__fill_1
XTAP_TAPCELL_ROW_15_303 vssd1 vccd1 sky130_fd_sc_hd__tapvpwrvgnd_1
XFILLER_40_160 vssd1 vssd1 vccd1 vccd1 sky130_fd_sc_hd__fill_2
XANTENNA__2641__S _2645_/S vssd1 vssd1 vccd1 vccd1 sky130_fd_sc_hd__diode_2
XFILLER_40_182 vssd1 vssd1 vccd1 vccd1 sky130_fd_sc_hd__fill_1
X_2480_ _3328_/Q _2960_/A2 wire66/X _3310_/Q _2479_/X vssd1 vssd1 vccd1 vccd1 _2480_/X
+ sky130_fd_sc_hd__a221o_2
X_1500_ _1500_/A vssd1 vssd1 vccd1 vccd1 _3439_/D sky130_fd_sc_hd__inv_2
X_3101_ _3101_/CLK _3101_/D fanout217/X vssd1 vssd1 vccd1 vccd1 _3101_/Q sky130_fd_sc_hd__dfrtp_2
XANTENNA__2098__B1 _2297_/A vssd1 vssd1 vccd1 vccd1 sky130_fd_sc_hd__diode_2
X_3032_ _3423_/CLK _3032_/D fanout218/X vssd1 vssd1 vccd1 vccd1 _3032_/Q sky130_fd_sc_hd__dfrtp_2
XTAP_TAPCELL_ROW_66_737 vssd1 vccd1 sky130_fd_sc_hd__tapvpwrvgnd_1
XANTENNA__2816__S _2818_/S vssd1 vssd1 vccd1 vccd1 sky130_fd_sc_hd__diode_2
XFILLER_36_433 vssd1 vssd1 vccd1 vccd1 sky130_fd_sc_hd__fill_4
XFILLER_51_447 vssd1 vssd1 vccd1 vccd1 sky130_fd_sc_hd__fill_1
XFILLER_31_160 vssd1 vssd1 vccd1 vccd1 sky130_fd_sc_hd__fill_8
X_2816_ hold567/X _2816_/A1 _2818_/S vssd1 vssd1 vccd1 vccd1 _3322_/D sky130_fd_sc_hd__mux2_1
XANTENNA_fanout129_A _2472_/B vssd1 vssd1 vccd1 vccd1 sky130_fd_sc_hd__diode_2
X_2747_ hold553/X _2842_/A1 _2757_/S vssd1 vssd1 vccd1 vccd1 _3256_/D sky130_fd_sc_hd__mux2_1
X_2678_ hold681/X _2811_/A1 _2681_/S vssd1 vssd1 vccd1 vccd1 _3191_/D sky130_fd_sc_hd__mux2_1
X_1629_ _1629_/A _1629_/B vssd1 vssd1 vccd1 vccd1 _1630_/C sky130_fd_sc_hd__nor2_2
XANTENNA__2325__A1 _2383_/B vssd1 vssd1 vccd1 vccd1 sky130_fd_sc_hd__diode_2
XANTENNA_input3_A gpio_in[1] vssd1 vssd1 vccd1 vccd1 sky130_fd_sc_hd__diode_2
XTAP_TAPCELL_ROW_29_417 vssd1 vccd1 sky130_fd_sc_hd__tapvpwrvgnd_1
XANTENNA__2726__S _2742_/S vssd1 vssd1 vccd1 vccd1 sky130_fd_sc_hd__diode_2
XTAP_TAPCELL_ROW_37_483 vssd1 vccd1 sky130_fd_sc_hd__tapvpwrvgnd_1
XFILLER_42_425 vssd1 vssd1 vccd1 vccd1 sky130_fd_sc_hd__fill_1
XANTENNA__1569__C _2838_/B vssd1 vssd1 vccd1 vccd1 sky130_fd_sc_hd__diode_2
XFILLER_42_447 vssd1 vssd1 vccd1 vccd1 sky130_fd_sc_hd__fill_1
XFILLER_14_138 vssd1 vssd1 vccd1 vccd1 sky130_fd_sc_hd__fill_2
XFILLER_52_45 vssd1 vssd1 vccd1 vccd1 sky130_fd_sc_hd__fill_4
XFILLER_6_326 vssd1 vssd1 vccd1 vccd1 sky130_fd_sc_hd__fill_4
XANTENNA__2564__A1 _1569_/D vssd1 vssd1 vccd1 vccd1 sky130_fd_sc_hd__diode_2
XFILLER_77_20 vssd1 vssd1 vccd1 vccd1 sky130_fd_sc_hd__fill_1
XANTENNA__1540__S _1546_/S vssd1 vssd1 vccd1 vccd1 sky130_fd_sc_hd__diode_2
XTAP_TAPCELL_ROW_63_707 vssd1 vccd1 sky130_fd_sc_hd__tapvpwrvgnd_1
XFILLER_33_436 vssd1 vssd1 vccd1 vccd1 sky130_fd_sc_hd__fill_4
X_1980_ _1980_/A _1980_/B vssd1 vssd1 vccd1 vccd1 _1982_/B sky130_fd_sc_hd__xnor2_2
XFILLER_33_469 vssd1 vssd1 vccd1 vccd1 sky130_fd_sc_hd__fill_4
XFILLER_33_458 vssd1 vssd1 vccd1 vccd1 sky130_fd_sc_hd__fill_2
XTAP_TAPCELL_ROW_71_773 vssd1 vccd1 sky130_fd_sc_hd__tapvpwrvgnd_1
XANTENNA__1776__A _1906_/A vssd1 vssd1 vccd1 vccd1 sky130_fd_sc_hd__diode_2
X_2601_ _3140_/Q _3141_/Q _2601_/C vssd1 vssd1 vccd1 vccd1 _2603_/B sky130_fd_sc_hd__and3_2
XANTENNA__2555__A1 _2489_/X vssd1 vssd1 vccd1 vccd1 sky130_fd_sc_hd__diode_2
X_2532_ _2611_/A _3152_/Q _3296_/Q _2800_/A vssd1 vssd1 vccd1 vccd1 _2532_/X sky130_fd_sc_hd__a22o_2
XFILLER_54_3 vssd1 vssd1 vccd1 vccd1 sky130_fd_sc_hd__fill_8
XANTENNA__2103__C _2154_/B vssd1 vssd1 vccd1 vccd1 sky130_fd_sc_hd__diode_2
X_2463_ _2781_/B _2457_/X _2461_/X _2445_/S vssd1 vssd1 vccd1 vccd1 _2463_/X sky130_fd_sc_hd__a22o_2
X_2394_ _2394_/A _2394_/B vssd1 vssd1 vccd1 vccd1 _2394_/Y sky130_fd_sc_hd__xnor2_2
XTAP_TAPCELL_ROW_79_851 vssd1 vccd1 sky130_fd_sc_hd__tapvpwrvgnd_1
XTAP_TAPCELL_ROW_79_840 vssd1 vccd1 sky130_fd_sc_hd__tapvpwrvgnd_1
X_3015_ clkload7/A _3015_/D load_slew212/X vssd1 vssd1 vccd1 vccd1 _3015_/Q sky130_fd_sc_hd__dfrtp_2
XTAP_TAPCELL_ROW_34_464 vssd1 vccd1 sky130_fd_sc_hd__tapvpwrvgnd_1
XFILLER_51_277 vssd1 vssd1 vccd1 vccd1 sky130_fd_sc_hd__fill_1
XFILLER_22_26 vssd1 vssd1 vccd1 vccd1 sky130_fd_sc_hd__fill_2
XANTENNA__2546__A1 _2550_/A1 vssd1 vssd1 vccd1 vccd1 sky130_fd_sc_hd__diode_2
XANTENNA__1852__C _2002_/B vssd1 vssd1 vccd1 vccd1 sky130_fd_sc_hd__diode_2
Xfanout110 _3434_/Q vssd1 vssd1 vccd1 vccd1 _1690_/S sky130_fd_sc_hd__clkdlybuf4s25_1
Xfanout121 _2973_/A1 vssd1 vssd1 vccd1 vccd1 _2445_/S sky130_fd_sc_hd__clkdlybuf4s25_1
Xfanout132 _3089_/Q vssd1 vssd1 vccd1 vccd1 _2472_/B sky130_fd_sc_hd__clkdlybuf4s25_1
Xfanout143 _3052_/Q vssd1 vssd1 vccd1 vccd1 _2384_/A sky130_fd_sc_hd__clkdlybuf4s25_1
Xfanout154 _3047_/Q vssd1 vssd1 vccd1 vccd1 _2132_/A sky130_fd_sc_hd__clkdlybuf4s25_1
Xfanout165 _3041_/Q vssd1 vssd1 vccd1 vccd1 _1862_/B sky130_fd_sc_hd__clkdlybuf4s25_1
Xfanout176 _3034_/Q vssd1 vssd1 vccd1 vccd1 _2347_/A sky130_fd_sc_hd__clkdlybuf4s25_1
Xfanout187 _2073_/C vssd1 vssd1 vccd1 vccd1 _2029_/A sky130_fd_sc_hd__clkdlybuf4s25_1
Xfanout198 _3023_/Q vssd1 vssd1 vccd1 vccd1 _1805_/B sky130_fd_sc_hd__clkdlybuf4s25_1
XANTENNA_fanout61_A _2646_/B vssd1 vssd1 vccd1 vccd1 sky130_fd_sc_hd__diode_2
XFILLER_74_325 vssd1 vssd1 vccd1 vccd1 sky130_fd_sc_hd__fill_1
XFILLER_74_358 vssd1 vssd1 vccd1 vccd1 sky130_fd_sc_hd__fill_2
XANTENNA__2482__B1 _2648_/B vssd1 vssd1 vccd1 vccd1 sky130_fd_sc_hd__diode_2
XFILLER_8_17 vssd1 vssd1 vccd1 vccd1 sky130_fd_sc_hd__fill_1
XFILLER_23_480 vssd1 vssd1 vccd1 vccd1 sky130_fd_sc_hd__fill_1
XFILLER_10_141 vssd1 vccd1 vssd1 vccd1 sky130_ef_sc_hd__decap_40_12
XANTENNA__2537__A1 _2800_/A vssd1 vssd1 vccd1 vccd1 sky130_fd_sc_hd__diode_2
XANTENNA__2537__B2 _2611_/A vssd1 vssd1 vccd1 vccd1 sky130_fd_sc_hd__diode_2
XFILLER_77_130 vssd1 vssd1 vccd1 vccd1 sky130_fd_sc_hd__fill_2
XTAP_TAPCELL_ROW_76_821 vssd1 vccd1 sky130_fd_sc_hd__tapvpwrvgnd_1
XTAP_TAPCELL_ROW_48_578 vssd1 vccd1 sky130_fd_sc_hd__tapvpwrvgnd_1
XANTENNA__2473__B1 _2648_/B vssd1 vssd1 vccd1 vccd1 sky130_fd_sc_hd__diode_2
XFILLER_18_296 vssd1 vssd1 vccd1 vccd1 sky130_fd_sc_hd__fill_2
X_1963_ _2073_/B _1962_/X _1961_/X vssd1 vssd1 vccd1 vccd1 _1965_/A sky130_fd_sc_hd__a21bo_2
XTAP_TAPCELL_ROW_31_434 vssd1 vccd1 sky130_fd_sc_hd__tapvpwrvgnd_1
X_1894_ _1895_/A _1895_/B _1895_/C vssd1 vssd1 vccd1 vccd1 _1914_/A sky130_fd_sc_hd__a21oi_2
X_2515_ _2540_/A _2515_/B vssd1 vssd1 vccd1 vccd1 _2515_/X sky130_fd_sc_hd__and2_2
X_2446_ _2445_/S _2441_/X _2967_/A2 _3217_/Q _2443_/X vssd1 vssd1 vccd1 vccd1 _2452_/A
+ sky130_fd_sc_hd__a221o_2
X_2377_ _2377_/A _2377_/B vssd1 vssd1 vccd1 vccd1 _2381_/A sky130_fd_sc_hd__xnor2_2
XTAP_TAPCELL_ROW_39_501 vssd1 vccd1 sky130_fd_sc_hd__tapvpwrvgnd_1
XFILLER_68_163 vssd1 vssd1 vccd1 vccd1 sky130_fd_sc_hd__fill_1
XFILLER_56_369 vssd1 vssd1 vccd1 vccd1 sky130_fd_sc_hd__fill_1
XANTENNA_fanout151_X _2284_/B vssd1 vssd1 vccd1 vccd1 sky130_fd_sc_hd__diode_2
XFILLER_33_69 vssd1 vssd1 vccd1 vccd1 sky130_fd_sc_hd__fill_2
XANTENNA__2519__A1 _2962_/A1 vssd1 vssd1 vccd1 vccd1 sky130_fd_sc_hd__diode_2
XANTENNA__2519__B2 _2961_/A1 vssd1 vssd1 vccd1 vccd1 sky130_fd_sc_hd__diode_2
XFILLER_3_126 vssd1 vssd1 vccd1 vccd1 sky130_fd_sc_hd__fill_1
XFILLER_58_11 vssd1 vssd1 vccd1 vccd1 sky130_fd_sc_hd__fill_2
XFILLER_59_163 vssd1 vssd1 vccd1 vccd1 sky130_fd_sc_hd__fill_4
XANTENNA_fanout64_X _2923_/A2 vssd1 vssd1 vccd1 vccd1 sky130_fd_sc_hd__diode_2
XTAP_TAPCELL_ROW_2_192 vssd1 vccd1 sky130_fd_sc_hd__tapvpwrvgnd_1
XPHY_EDGE_ROW_4_Left_84 vssd1 vssd1 vccd1 vccd1 sky130_fd_sc_hd__decap_3
XFILLER_7_432 vssd1 vssd1 vccd1 vccd1 sky130_fd_sc_hd__fill_1
XFILLER_7_443 vssd1 vssd1 vccd1 vccd1 sky130_fd_sc_hd__fill_4
XANTENNA__2502__X _2502_/X vssd1 vssd1 vccd1 vccd1 sky130_fd_sc_hd__diode_2
X_3280_ _3352_/CLK _3280_/D load_slew258/X vssd1 vssd1 vccd1 vccd1 _3280_/Q sky130_fd_sc_hd__dfrtp_2
X_2300_ _2303_/A _2303_/B _2303_/C vssd1 vssd1 vccd1 vccd1 _2300_/X sky130_fd_sc_hd__or3_2
X_2231_ _2232_/A _2233_/B vssd1 vssd1 vccd1 vccd1 _2231_/Y sky130_fd_sc_hd__nand2_2
X_2162_ _2143_/A _2142_/B _2140_/Y vssd1 vssd1 vccd1 vccd1 _2165_/A sky130_fd_sc_hd__a21o_2
XFILLER_17_3 vssd1 vssd1 vccd1 vccd1 sky130_fd_sc_hd__fill_4
X_2093_ _2412_/S _2093_/B _2093_/C vssd1 vssd1 vccd1 vccd1 _2093_/X sky130_fd_sc_hd__and3_2
XANTENNA__2446__B1 _2967_/A2 vssd1 vssd1 vccd1 vccd1 sky130_fd_sc_hd__diode_2
XFILLER_0_73 vssd1 vssd1 vccd1 vccd1 sky130_fd_sc_hd__fill_1
XANTENNA__2824__S _2837_/S vssd1 vssd1 vccd1 vccd1 sky130_fd_sc_hd__diode_2
X_2995_ _2995_/A vssd1 vssd1 vccd1 vccd1 _2995_/Y sky130_fd_sc_hd__inv_2
X_1946_ _1973_/A _1974_/A vssd1 vssd1 vccd1 vccd1 _1948_/A sky130_fd_sc_hd__nand2_2
XANTENNA__1964__A _2025_/A vssd1 vssd1 vccd1 vccd1 sky130_fd_sc_hd__diode_2
X_1877_ _1876_/A _1876_/B _1876_/C vssd1 vssd1 vccd1 vccd1 _1878_/B sky130_fd_sc_hd__a21o_2
XANTENNA_fanout111_A _2966_/A1 vssd1 vssd1 vccd1 vccd1 sky130_fd_sc_hd__diode_2
XFILLER_0_107 vssd1 vssd1 vccd1 vccd1 sky130_fd_sc_hd__fill_1
X_2429_ _3429_/Q _3427_/Q _1629_/A _1576_/Y _2533_/B vssd1 vssd1 vccd1 vccd1 _2429_/X
+ sky130_fd_sc_hd__o32a_2
XFILLER_69_472 vssd1 vssd1 vccd1 vccd1 sky130_fd_sc_hd__fill_1
XFILLER_28_47 vssd1 vssd1 vccd1 vccd1 sky130_fd_sc_hd__fill_2
XFILLER_28_58 vssd1 vssd1 vccd1 vccd1 sky130_fd_sc_hd__fill_4
XFILLER_44_35 vssd1 vssd1 vccd1 vccd1 sky130_fd_sc_hd__fill_1
XANTENNA__2734__S _2738_/S vssd1 vssd1 vccd1 vccd1 sky130_fd_sc_hd__diode_2
XTAP_TAPCELL_ROW_42_529 vssd1 vccd1 sky130_fd_sc_hd__tapvpwrvgnd_1
XANTENNA__3454__CLK _3463_/CLK vssd1 vssd1 vccd1 vccd1 sky130_fd_sc_hd__diode_2
XTAP_TAPCELL_ROW_50_595 vssd1 vccd1 sky130_fd_sc_hd__tapvpwrvgnd_1
XFILLER_69_32 vssd1 vssd1 vccd1 vccd1 sky130_fd_sc_hd__fill_2
XFILLER_5_29 vssd1 vssd1 vccd1 vccd1 sky130_fd_sc_hd__fill_1
XFILLER_69_65 vssd1 vssd1 vccd1 vccd1 sky130_fd_sc_hd__fill_2
XFILLER_79_225 vssd1 vssd1 vccd1 vccd1 sky130_fd_sc_hd__fill_4
XFILLER_47_111 vssd1 vssd1 vccd1 vccd1 sky130_fd_sc_hd__fill_1
XANTENNA__2428__A0 _2533_/A vssd1 vssd1 vccd1 vccd1 sky130_fd_sc_hd__diode_2
XTAP_TAPCELL_ROW_58_662 vssd1 vccd1 sky130_fd_sc_hd__tapvpwrvgnd_1
XFILLER_75_486 vssd1 vssd1 vccd1 vccd1 sky130_fd_sc_hd__fill_2
XFILLER_47_166 vssd1 vssd1 vccd1 vccd1 sky130_fd_sc_hd__fill_2
XFILLER_62_136 vssd1 vssd1 vccd1 vccd1 sky130_fd_sc_hd__fill_4
XFILLER_35_339 vssd1 vssd1 vccd1 vccd1 sky130_fd_sc_hd__fill_1
X_1800_ _1800_/A _1800_/B _1800_/C vssd1 vssd1 vccd1 vccd1 _1800_/X sky130_fd_sc_hd__or3_2
X_2780_ hold399/X _2818_/A1 _2780_/S vssd1 vssd1 vccd1 vccd1 _3288_/D sky130_fd_sc_hd__mux2_1
X_1731_ _1731_/A _1731_/B vssd1 vssd1 vccd1 vccd1 _1731_/Y sky130_fd_sc_hd__xnor2_2
XTAP_TAPCELL_ROW_13_286 vssd1 vccd1 sky130_fd_sc_hd__tapvpwrvgnd_1
X_1662_ _1657_/X _1658_/Y _1660_/X _1739_/B vssd1 vssd1 vccd1 vccd1 _1662_/X sky130_fd_sc_hd__a31o_2
X_3401_ _3441_/CLK _3401_/D fanout270/X vssd1 vssd1 vccd1 vccd1 _3401_/Q sky130_fd_sc_hd__dfrtp_2
X_3332_ _3352_/CLK _3332_/D fanout254/X vssd1 vssd1 vccd1 vccd1 _3332_/Q sky130_fd_sc_hd__dfrtp_2
X_1593_ _2426_/A _3142_/Q _3141_/Q _3143_/Q vssd1 vssd1 vccd1 vccd1 _1626_/C sky130_fd_sc_hd__or4b_2
X_3263_ _3302_/CLK _3263_/D load_slew276/X vssd1 vssd1 vccd1 vccd1 _3263_/Q sky130_fd_sc_hd__dfrtp_2
X_3194_ _3389_/CLK _3194_/D load_slew278/X vssd1 vssd1 vccd1 vccd1 _3194_/Q sky130_fd_sc_hd__dfrtp_2
X_2214_ _2214_/A _2214_/B vssd1 vssd1 vccd1 vccd1 _2216_/C sky130_fd_sc_hd__nand2_2
X_2145_ _2145_/A _2145_/B vssd1 vssd1 vccd1 vccd1 _2163_/A sky130_fd_sc_hd__or2_2
XFILLER_53_103 vssd1 vssd1 vccd1 vccd1 sky130_fd_sc_hd__fill_1
X_2076_ _2075_/A _2093_/B _2075_/C vssd1 vssd1 vccd1 vccd1 _2077_/B sky130_fd_sc_hd__a21oi_2
XFILLER_53_125 vssd1 vssd1 vccd1 vccd1 sky130_fd_sc_hd__fill_2
XFILLER_19_391 vssd1 vssd1 vccd1 vccd1 sky130_fd_sc_hd__fill_1
XANTENNA__2554__S _2559_/S vssd1 vssd1 vccd1 vccd1 sky130_fd_sc_hd__diode_2
Xclkbuf_3_5__f_clk clkbuf_0_clk/X vssd1 vssd1 vccd1 vccd1 clkload3/A sky130_fd_sc_hd__clkbuf_16
XFILLER_14_27 vssd1 vssd1 vccd1 vccd1 sky130_fd_sc_hd__fill_1
X_2978_ _3402_/Q hold412/X _3408_/Q vssd1 vssd1 vccd1 vccd1 _2978_/X sky130_fd_sc_hd__mux2_1
X_1929_ _1981_/A _1982_/A _1981_/B vssd1 vssd1 vccd1 vccd1 _1933_/B sky130_fd_sc_hd__nand3b_2
XANTENNA__1945__A2 _2004_/B vssd1 vssd1 vccd1 vccd1 sky130_fd_sc_hd__diode_2
XANTENNA__2005__D _2029_/C vssd1 vssd1 vccd1 vccd1 sky130_fd_sc_hd__diode_2
XANTENNA_fanout114_X _2686_/A vssd1 vssd1 vccd1 vccd1 sky130_fd_sc_hd__diode_2
Xhold730 _3072_/Q vssd1 vssd1 vccd1 vccd1 hold730/X sky130_fd_sc_hd__dlygate4sd3_1
Xhold741 _3056_/Q vssd1 vssd1 vccd1 vccd1 hold741/X sky130_fd_sc_hd__dlygate4sd3_1
XANTENNA__2729__S _2742_/S vssd1 vssd1 vccd1 vccd1 sky130_fd_sc_hd__diode_2
XFILLER_39_57 vssd1 vssd1 vccd1 vccd1 sky130_fd_sc_hd__fill_4
XTAP_TAPCELL_ROW_4_210 vssd1 vccd1 sky130_fd_sc_hd__tapvpwrvgnd_1
XFILLER_39_79 vssd1 vssd1 vccd1 vccd1 sky130_fd_sc_hd__fill_2
XANTENNA__2122__A2 _2421_/B vssd1 vssd1 vccd1 vccd1 sky130_fd_sc_hd__diode_2
XFILLER_44_103 vssd1 vssd1 vccd1 vccd1 sky130_fd_sc_hd__fill_1
XTAP_TAPCELL_ROW_55_643 vssd1 vccd1 sky130_fd_sc_hd__tapvpwrvgnd_1
XANTENNA_fanout27_X _2704_/S vssd1 vssd1 vccd1 vccd1 sky130_fd_sc_hd__diode_2
XFILLER_40_386 vssd1 vssd1 vccd1 vccd1 sky130_fd_sc_hd__fill_2
XTAP_TAPCELL_ROW_10_256 vssd1 vccd1 sky130_fd_sc_hd__tapvpwrvgnd_1
XFILLER_4_221 vssd1 vssd1 vccd1 vccd1 sky130_fd_sc_hd__fill_2
XANTENNA__1543__S _1546_/S vssd1 vssd1 vccd1 vccd1 sky130_fd_sc_hd__diode_2
XANTENNA__2639__S _2647_/S vssd1 vssd1 vccd1 vccd1 sky130_fd_sc_hd__diode_2
XFILLER_48_453 vssd1 vssd1 vccd1 vccd1 sky130_fd_sc_hd__fill_1
XFILLER_75_250 vssd1 vssd1 vccd1 vccd1 sky130_fd_sc_hd__fill_1
XFILLER_48_464 vssd1 vssd1 vccd1 vccd1 sky130_fd_sc_hd__fill_1
XANTENNA__2882__B _2926_/C vssd1 vssd1 vccd1 vccd1 sky130_fd_sc_hd__diode_2
XTAP_TAPCELL_ROW_18_323 vssd1 vccd1 sky130_fd_sc_hd__tapvpwrvgnd_1
XFILLER_75_294 vssd1 vssd1 vccd1 vccd1 sky130_fd_sc_hd__fill_1
XFILLER_35_169 vssd1 vssd1 vccd1 vccd1 sky130_fd_sc_hd__fill_8
XFILLER_35_158 vssd1 vssd1 vccd1 vccd1 sky130_fd_sc_hd__fill_2
X_2901_ _3336_/Q _2901_/A2 _2901_/B1 _3318_/Q _2900_/X vssd1 vssd1 vccd1 vccd1 _2901_/X
+ sky130_fd_sc_hd__a221o_2
XFILLER_50_117 vssd1 vssd1 vccd1 vccd1 sky130_fd_sc_hd__fill_2
X_2832_ hold479/X _2636_/X _2837_/S vssd1 vssd1 vccd1 vccd1 _3337_/D sky130_fd_sc_hd__mux2_1
XFILLER_31_386 vssd1 vssd1 vccd1 vccd1 sky130_fd_sc_hd__fill_4
X_2763_ hold455/X _2612_/X _2780_/S vssd1 vssd1 vccd1 vccd1 _3271_/D sky130_fd_sc_hd__mux2_1
X_1714_ hold656/X _1713_/Y _1738_/S vssd1 vssd1 vccd1 vccd1 _3016_/D sky130_fd_sc_hd__mux2_1
X_2694_ hold604/X _2808_/A1 _2700_/S vssd1 vssd1 vccd1 vccd1 _3206_/D sky130_fd_sc_hd__mux2_1
X_1645_ _3072_/Q _3055_/Q _3071_/Q _3054_/Q vssd1 vssd1 vccd1 vccd1 _1646_/B sky130_fd_sc_hd__a22oi_2
Xwire8 wire8/A vssd1 vssd1 vccd1 vccd1 wire8/X sky130_fd_sc_hd__clkdlybuf4s25_1
X_1576_ _2426_/A _1583_/A vssd1 vssd1 vccd1 vccd1 _1576_/Y sky130_fd_sc_hd__nor2_2
XANTENNA_clkload13_A _3423_/CLK vssd1 vssd1 vccd1 vccd1 sky130_fd_sc_hd__diode_2
X_3315_ _3404_/CLK _3315_/D fanout287/X vssd1 vssd1 vccd1 vccd1 _3315_/Q sky130_fd_sc_hd__dfrtp_2
X_3246_ _3395_/CLK _3246_/D fanout245/X vssd1 vssd1 vccd1 vccd1 _3246_/Q sky130_fd_sc_hd__dfrtp_2
XTAP_TAPCELL_ROW_69_757 vssd1 vccd1 sky130_fd_sc_hd__tapvpwrvgnd_1
X_3177_ _3359_/CLK _3177_/D load_slew244/X vssd1 vssd1 vccd1 vccd1 _3177_/Q sky130_fd_sc_hd__dfrtp_2
X_2128_ _2152_/A _2129_/C _2129_/A vssd1 vssd1 vccd1 vccd1 _2145_/A sky130_fd_sc_hd__a21oi_2
X_2059_ _2059_/A _2059_/B vssd1 vssd1 vccd1 vccd1 _2060_/B sky130_fd_sc_hd__nand2_2
XTAP_TAPCELL_ROW_52_613 vssd1 vccd1 sky130_fd_sc_hd__tapvpwrvgnd_1
XFILLER_25_48 vssd1 vssd1 vccd1 vccd1 sky130_fd_sc_hd__fill_1
XFILLER_41_36 vssd1 vssd1 vccd1 vccd1 sky130_fd_sc_hd__fill_1
Xhold571 _3013_/Q vssd1 vssd1 vccd1 vccd1 hold571/X sky130_fd_sc_hd__dlygate4sd3_1
Xhold560 _3119_/Q vssd1 vssd1 vccd1 vccd1 hold560/X sky130_fd_sc_hd__dlygate4sd3_1
Xhold593 _3105_/Q vssd1 vssd1 vccd1 vccd1 hold593/X sky130_fd_sc_hd__dlygate4sd3_1
Xhold582 _3188_/Q vssd1 vssd1 vccd1 vccd1 hold582/X sky130_fd_sc_hd__dlygate4sd3_1
XFILLER_1_235 vssd1 vssd1 vccd1 vccd1 sky130_fd_sc_hd__fill_1
XFILLER_66_66 vssd1 vccd1 vssd1 vccd1 sky130_ef_sc_hd__decap_40_12
XFILLER_57_261 vssd1 vssd1 vccd1 vccd1 sky130_fd_sc_hd__fill_1
XFILLER_72_253 vssd1 vssd1 vccd1 vccd1 sky130_fd_sc_hd__fill_2
XFILLER_9_324 vssd1 vssd1 vccd1 vccd1 sky130_fd_sc_hd__fill_1
XTAP_TAPCELL_ROW_23_370 vssd1 vccd1 sky130_fd_sc_hd__tapvpwrvgnd_1
XANTENNA__1538__S _1546_/S vssd1 vssd1 vccd1 vccd1 sky130_fd_sc_hd__diode_2
XANTENNA__1790__B1 _1998_/B vssd1 vssd1 vccd1 vccd1 sky130_fd_sc_hd__diode_2
X_3100_ _3343_/CLK _3100_/D fanout218/X vssd1 vssd1 vccd1 vccd1 _3100_/Q sky130_fd_sc_hd__dfrtp_2
XFILLER_0_290 vssd1 vssd1 vccd1 vccd1 sky130_fd_sc_hd__fill_1
XANTENNA__2098__B2 _2154_/B vssd1 vssd1 vccd1 vccd1 sky130_fd_sc_hd__diode_2
XANTENNA__2893__A _2926_/B vssd1 vssd1 vccd1 vccd1 sky130_fd_sc_hd__diode_2
X_3031_ _3343_/CLK _3031_/D fanout223/X vssd1 vssd1 vccd1 vccd1 _3031_/Q sky130_fd_sc_hd__dfrtp_2
XFILLER_51_426 vssd1 vssd1 vccd1 vccd1 sky130_fd_sc_hd__fill_2
XANTENNA__2832__S _2837_/S vssd1 vssd1 vccd1 vccd1 sky130_fd_sc_hd__diode_2
X_2815_ hold642/X _2815_/A1 _2818_/S vssd1 vssd1 vccd1 vccd1 _3321_/D sky130_fd_sc_hd__mux2_1
X_2746_ hold638/X _2803_/A1 _2757_/S vssd1 vssd1 vccd1 vccd1 _3255_/D sky130_fd_sc_hd__mux2_1
XFILLER_11_28 vssd1 vssd1 vccd1 vccd1 sky130_fd_sc_hd__fill_2
XANTENNA__2573__A2 _1622_/C vssd1 vssd1 vccd1 vccd1 sky130_fd_sc_hd__diode_2
X_2677_ hold665/X _2848_/A1 _2681_/S vssd1 vssd1 vccd1 vccd1 _3190_/D sky130_fd_sc_hd__mux2_1
X_1628_ _2800_/A _1624_/X _1625_/Y _2540_/A _1627_/X vssd1 vssd1 vccd1 vccd1 _3431_/D
+ sky130_fd_sc_hd__a221o_2
XANTENNA__2325__A2 _2352_/B vssd1 vssd1 vccd1 vccd1 sky130_fd_sc_hd__diode_2
X_1559_ _2426_/A _3141_/Q vssd1 vssd1 vccd1 vccd1 _1603_/A sky130_fd_sc_hd__nor2_2
X_3229_ _3392_/CLK _3229_/D load_slew240/X vssd1 vssd1 vccd1 vccd1 _3229_/Q sky130_fd_sc_hd__dfrtp_2
XTAP_TAPCELL_ROW_29_418 vssd1 vccd1 sky130_fd_sc_hd__tapvpwrvgnd_1
XANTENNA__1836__A1 _1947_/A vssd1 vssd1 vccd1 vccd1 sky130_fd_sc_hd__diode_2
XANTENNA_fanout279_X fanout279/X vssd1 vssd1 vccd1 vccd1 sky130_fd_sc_hd__diode_2
XANTENNA__1836__B2 _1906_/A vssd1 vssd1 vccd1 vccd1 sky130_fd_sc_hd__diode_2
XTAP_TAPCELL_ROW_37_484 vssd1 vccd1 sky130_fd_sc_hd__tapvpwrvgnd_1
XANTENNA__1569__D _1569_/D vssd1 vssd1 vccd1 vccd1 sky130_fd_sc_hd__diode_2
XANTENNA__2742__S _2742_/S vssd1 vssd1 vccd1 vccd1 sky130_fd_sc_hd__diode_2
XTAP_TAPCELL_ROW_20_340 vssd1 vccd1 sky130_fd_sc_hd__tapvpwrvgnd_1
XFILLER_6_338 vssd1 vssd1 vccd1 vccd1 sky130_fd_sc_hd__fill_2
XANTENNA__2564__A2 _2489_/X vssd1 vssd1 vccd1 vccd1 sky130_fd_sc_hd__diode_2
XANTENNA_fanout94_X _2520_/A vssd1 vssd1 vccd1 vccd1 sky130_fd_sc_hd__diode_2
Xhold390 _3451_/Q vssd1 vssd1 vccd1 vccd1 hold390/X sky130_fd_sc_hd__dlygate4sd3_1
XFILLER_77_334 vssd1 vssd1 vccd1 vccd1 sky130_fd_sc_hd__fill_2
XTAP_TAPCELL_ROW_63_708 vssd1 vccd1 sky130_fd_sc_hd__tapvpwrvgnd_1
XANTENNA__2652__S _2662_/S vssd1 vssd1 vccd1 vccd1 sky130_fd_sc_hd__diode_2
XTAP_TAPCELL_ROW_71_774 vssd1 vccd1 sky130_fd_sc_hd__tapvpwrvgnd_1
XANTENNA__1776__B _1805_/A vssd1 vssd1 vccd1 vccd1 sky130_fd_sc_hd__diode_2
XFILLER_9_176 vssd1 vssd1 vccd1 vccd1 sky130_fd_sc_hd__fill_8
X_2600_ _3141_/Q _2599_/Y _2601_/C vssd1 vssd1 vccd1 vccd1 _3141_/D sky130_fd_sc_hd__mux2_1
XFILLER_9_198 vssd1 vssd1 vccd1 vccd1 sky130_fd_sc_hd__fill_2
X_2531_ _3332_/Q _2894_/A2 _2894_/B1 _3314_/Q _2530_/X vssd1 vssd1 vccd1 vccd1 _2531_/X
+ sky130_fd_sc_hd__a221o_2
XANTENNA__1763__A0 _2029_/B vssd1 vssd1 vccd1 vccd1 sky130_fd_sc_hd__diode_2
XANTENNA_clkbuf_leaf_35_clk_A clkbuf_3_4__f_clk/X vssd1 vssd1 vccd1 vccd1 sky130_fd_sc_hd__diode_2
X_2462_ _2838_/A _2456_/X _2459_/X _2686_/A vssd1 vssd1 vccd1 vccd1 _2462_/X sky130_fd_sc_hd__a22o_2
XFILLER_5_393 vssd1 vssd1 vccd1 vccd1 sky130_fd_sc_hd__fill_4
X_2393_ _2390_/X _2393_/B vssd1 vssd1 vccd1 vccd1 _2394_/B sky130_fd_sc_hd__and2b_2
XTAP_TAPCELL_ROW_79_852 vssd1 vccd1 sky130_fd_sc_hd__tapvpwrvgnd_1
XTAP_TAPCELL_ROW_79_841 vssd1 vccd1 sky130_fd_sc_hd__tapvpwrvgnd_1
XANTENNA__2827__S _2833_/S vssd1 vssd1 vccd1 vccd1 sky130_fd_sc_hd__diode_2
XFILLER_68_367 vssd1 vssd1 vccd1 vccd1 sky130_fd_sc_hd__fill_1
X_3014_ _3132_/CLK _3014_/D fanout211/X vssd1 vssd1 vccd1 vccd1 _3014_/Q sky130_fd_sc_hd__dfrtp_2
XTAP_TAPCELL_ROW_34_465 vssd1 vccd1 sky130_fd_sc_hd__tapvpwrvgnd_1
XANTENNA_fanout239_A fanout242/X vssd1 vssd1 vccd1 vccd1 sky130_fd_sc_hd__diode_2
XFILLER_32_470 vssd1 vssd1 vccd1 vccd1 sky130_fd_sc_hd__fill_4
XANTENNA__2546__A2 _2489_/X vssd1 vssd1 vccd1 vccd1 sky130_fd_sc_hd__diode_2
X_2729_ hold578/X _2805_/A1 _2742_/S vssd1 vssd1 vccd1 vccd1 _3239_/D sky130_fd_sc_hd__mux2_1
XFILLER_3_308 vssd1 vssd1 vccd1 vccd1 sky130_fd_sc_hd__fill_4
XANTENNA__1754__A0 _2347_/A vssd1 vssd1 vccd1 vccd1 sky130_fd_sc_hd__diode_2
XANTENNA__1852__D _2029_/B vssd1 vssd1 vccd1 vccd1 sky130_fd_sc_hd__diode_2
Xfanout100 _2313_/S vssd1 vssd1 vccd1 vccd1 _1993_/S sky130_fd_sc_hd__clkdlybuf4s25_1
Xfanout111 _2966_/A1 vssd1 vssd1 vccd1 vccd1 _2962_/A1 sky130_fd_sc_hd__clkdlybuf4s25_1
Xfanout122 _3430_/Q vssd1 vssd1 vccd1 vccd1 _2973_/A1 sky130_fd_sc_hd__clkdlybuf4s25_1
Xfanout133 _2900_/A vssd1 vssd1 vccd1 vccd1 _2959_/B sky130_fd_sc_hd__clkdlybuf4s25_1
Xfanout144 _3052_/Q vssd1 vssd1 vccd1 vccd1 _2255_/A sky130_fd_sc_hd__clkdlybuf4s25_1
Xfanout155 _3046_/Q vssd1 vssd1 vccd1 vccd1 _2154_/B sky130_fd_sc_hd__clkdlybuf4s25_1
XFILLER_59_323 vssd1 vssd1 vccd1 vccd1 sky130_fd_sc_hd__fill_1
XANTENNA__2737__S _2738_/S vssd1 vssd1 vccd1 vccd1 sky130_fd_sc_hd__diode_2
Xfanout166 _3040_/Q vssd1 vssd1 vccd1 vccd1 _1970_/B sky130_fd_sc_hd__clkdlybuf4s25_1
Xfanout177 _3034_/Q vssd1 vssd1 vccd1 vccd1 _2257_/A sky130_fd_sc_hd__clkdlybuf4s25_1
Xfanout188 _3028_/Q vssd1 vssd1 vccd1 vccd1 _2073_/C sky130_fd_sc_hd__clkdlybuf4s25_1
Xfanout199 _1805_/A vssd1 vssd1 vccd1 vccd1 _1884_/A sky130_fd_sc_hd__clkdlybuf4s25_1
XANTENNA__1641__S _1690_/S vssd1 vssd1 vccd1 vccd1 sky130_fd_sc_hd__diode_2
XANTENNA__2964__C _2964_/C vssd1 vssd1 vccd1 vccd1 sky130_fd_sc_hd__diode_2
XPHY_EDGE_ROW_29_Right_29 vssd1 vssd1 vccd1 vccd1 sky130_fd_sc_hd__decap_3
XFILLER_47_57 vssd1 vssd1 vccd1 vccd1 sky130_fd_sc_hd__fill_2
XFILLER_8_29 vssd1 vssd1 vccd1 vccd1 sky130_fd_sc_hd__fill_1
XPHY_EDGE_ROW_38_Right_38 vssd1 vssd1 vccd1 vccd1 sky130_fd_sc_hd__decap_3
XFILLER_10_197 vssd1 vccd1 vssd1 vccd1 sky130_ef_sc_hd__decap_40_12
XANTENNA__1745__A0 _1998_/B vssd1 vssd1 vccd1 vccd1 sky130_fd_sc_hd__diode_2
XANTENNA__2220__B _2326_/B vssd1 vssd1 vccd1 vccd1 sky130_fd_sc_hd__diode_2
XFILLER_2_363 vssd1 vssd1 vccd1 vccd1 sky130_fd_sc_hd__fill_1
XFILLER_2_396 vssd1 vssd1 vccd1 vccd1 sky130_fd_sc_hd__fill_1
XANTENNA__2647__S _2647_/S vssd1 vssd1 vccd1 vccd1 sky130_fd_sc_hd__diode_2
XPHY_EDGE_ROW_47_Right_47 vssd1 vssd1 vccd1 vccd1 sky130_fd_sc_hd__decap_3
XTAP_TAPCELL_ROW_76_822 vssd1 vccd1 sky130_fd_sc_hd__tapvpwrvgnd_1
XFILLER_77_175 vssd1 vccd1 vssd1 vccd1 sky130_ef_sc_hd__decap_40_12
XTAP_TAPCELL_ROW_48_579 vssd1 vccd1 sky130_fd_sc_hd__tapvpwrvgnd_1
XFILLER_18_253 vssd1 vssd1 vccd1 vccd1 sky130_fd_sc_hd__fill_1
X_1962_ _2073_/A _1962_/B _1998_/B vssd1 vssd1 vccd1 vccd1 _1962_/X sky130_fd_sc_hd__and3_2
XPHY_EDGE_ROW_56_Right_56 vssd1 vssd1 vccd1 vccd1 sky130_fd_sc_hd__decap_3
X_1893_ _1893_/A _1893_/B vssd1 vssd1 vccd1 vccd1 _1895_/C sky130_fd_sc_hd__nand2_2
XTAP_TAPCELL_ROW_31_435 vssd1 vccd1 sky130_fd_sc_hd__tapvpwrvgnd_1
X_2514_ _2514_/A _2514_/B vssd1 vssd1 vccd1 vccd1 _2515_/B sky130_fd_sc_hd__or2_2
X_2445_ _2762_/B _2781_/B _2445_/S vssd1 vssd1 vccd1 vccd1 _2445_/X sky130_fd_sc_hd__mux2_1
XPHY_EDGE_ROW_65_Right_65 vssd1 vssd1 vccd1 vccd1 sky130_fd_sc_hd__decap_3
XANTENNA__2557__S _2559_/S vssd1 vssd1 vccd1 vccd1 sky130_fd_sc_hd__diode_2
X_2376_ _2377_/B _2377_/A vssd1 vssd1 vccd1 vccd1 _2405_/A sky130_fd_sc_hd__nand2b_2
XFILLER_68_153 vssd1 vssd1 vccd1 vccd1 sky130_fd_sc_hd__fill_2
XANTENNA_fanout189_A _2049_/B vssd1 vssd1 vccd1 vccd1 sky130_fd_sc_hd__diode_2
XTAP_TAPCELL_ROW_39_502 vssd1 vccd1 sky130_fd_sc_hd__tapvpwrvgnd_1
XFILLER_68_197 vssd1 vssd1 vccd1 vccd1 sky130_fd_sc_hd__fill_4
XPHY_EDGE_ROW_74_Right_74 vssd1 vssd1 vccd1 vccd1 sky130_fd_sc_hd__decap_3
XFILLER_33_37 vssd1 vssd1 vccd1 vccd1 sky130_fd_sc_hd__fill_2
XANTENNA__2959__C _2959_/C vssd1 vssd1 vccd1 vccd1 sky130_fd_sc_hd__diode_2
XFILLER_79_407 vssd1 vccd1 vssd1 vccd1 sky130_ef_sc_hd__decap_40_12
XFILLER_74_44 vssd1 vccd1 vssd1 vccd1 sky130_ef_sc_hd__decap_40_12
XFILLER_74_189 vssd1 vssd1 vccd1 vccd1 sky130_fd_sc_hd__fill_1
XTAP_TAPCELL_ROW_2_193 vssd1 vccd1 sky130_fd_sc_hd__tapvpwrvgnd_1
XFILLER_23_81 vssd1 vssd1 vccd1 vccd1 sky130_fd_sc_hd__fill_1
XANTENNA__1546__S _1546_/S vssd1 vssd1 vccd1 vccd1 sky130_fd_sc_hd__diode_2
XANTENNA__2930__A2 _3437_/D vssd1 vssd1 vccd1 vccd1 sky130_fd_sc_hd__diode_2
X_2230_ _2228_/X _2230_/B vssd1 vssd1 vccd1 vccd1 _2233_/B sky130_fd_sc_hd__nand2b_2
X_2161_ _2163_/A _2163_/B vssd1 vssd1 vccd1 vccd1 _2164_/A sky130_fd_sc_hd__and2_2
X_2092_ _2412_/S _2089_/Y _2090_/X _2091_/X vssd1 vssd1 vccd1 vccd1 _3068_/D sky130_fd_sc_hd__a31o_2
XANTENNA__2446__A1 _2445_/S vssd1 vssd1 vccd1 vccd1 sky130_fd_sc_hd__diode_2
XFILLER_65_167 vssd1 vssd1 vccd1 vccd1 sky130_fd_sc_hd__fill_1
XFILLER_0_52 vssd1 vssd1 vccd1 vccd1 sky130_fd_sc_hd__fill_4
XFILLER_0_85 vssd1 vccd1 vssd1 vccd1 sky130_ef_sc_hd__decap_40_12
X_2994_ _2995_/A vssd1 vssd1 vccd1 vccd1 _2994_/Y sky130_fd_sc_hd__inv_2
X_1945_ _2005_/A _2004_/B _1970_/B _2029_/A vssd1 vssd1 vccd1 vccd1 _1974_/A sky130_fd_sc_hd__a22o_2
XANTENNA__2840__S _2852_/S vssd1 vssd1 vccd1 vccd1 sky130_fd_sc_hd__diode_2
X_1876_ _1876_/A _1876_/B _1876_/C vssd1 vssd1 vccd1 vccd1 _1876_/X sky130_fd_sc_hd__and3_2
XANTENNA__2906__C1 _1585_/A vssd1 vssd1 vccd1 vccd1 sky130_fd_sc_hd__diode_2
XANTENNA__2921__A2 _2838_/B vssd1 vssd1 vccd1 vccd1 sky130_fd_sc_hd__diode_2
X_2428_ _2533_/A _2427_/X wire8/X vssd1 vssd1 vccd1 vccd1 _3088_/D sky130_fd_sc_hd__mux2_1
X_2359_ _2347_/A _2384_/A _2331_/A vssd1 vssd1 vccd1 vccd1 _2360_/B sky130_fd_sc_hd__a21oi_2
XANTENNA__2437__A1 _1602_/X vssd1 vssd1 vccd1 vccd1 sky130_fd_sc_hd__diode_2
XFILLER_44_307 vssd1 vssd1 vccd1 vccd1 sky130_fd_sc_hd__fill_1
XANTENNA__2750__S _2761_/S vssd1 vssd1 vccd1 vccd1 sky130_fd_sc_hd__diode_2
XANTENNA_fanout17_A _2799_/S vssd1 vssd1 vccd1 vccd1 sky130_fd_sc_hd__diode_2
XTAP_TAPCELL_ROW_50_596 vssd1 vccd1 sky130_fd_sc_hd__tapvpwrvgnd_1
XFILLER_4_425 vssd1 vssd1 vccd1 vccd1 sky130_fd_sc_hd__fill_1
XFILLER_69_55 vssd1 vssd1 vccd1 vccd1 sky130_fd_sc_hd__fill_1
XTAP_TAPCELL_ROW_7_230 vssd1 vccd1 sky130_fd_sc_hd__tapvpwrvgnd_1
XFILLER_75_421 vssd1 vssd1 vccd1 vccd1 sky130_fd_sc_hd__fill_2
XTAP_TAPCELL_ROW_58_663 vssd1 vccd1 sky130_fd_sc_hd__tapvpwrvgnd_1
XANTENNA__2226__A _3046_/Q vssd1 vssd1 vccd1 vccd1 sky130_fd_sc_hd__diode_2
XANTENNA__2660__S _2666_/S vssd1 vssd1 vccd1 vccd1 sky130_fd_sc_hd__diode_2
X_1730_ _1723_/A _1725_/B _1723_/B vssd1 vssd1 vccd1 vccd1 _1731_/B sky130_fd_sc_hd__a21boi_2
X_1661_ _1657_/X _1658_/Y _1660_/X vssd1 vssd1 vccd1 vccd1 _1661_/Y sky130_fd_sc_hd__a21oi_2
X_3400_ _3450_/CLK _3400_/D load_slew281/X vssd1 vssd1 vccd1 vccd1 _3400_/Q sky130_fd_sc_hd__dfrtp_2
XANTENNA__2903__A2 _2971_/A2 vssd1 vssd1 vccd1 vccd1 sky130_fd_sc_hd__diode_2
X_3331_ _3331_/CLK _3331_/D load_slew230/X vssd1 vssd1 vccd1 vccd1 _3331_/Q sky130_fd_sc_hd__dfrtp_2
X_1592_ _3142_/Q _3143_/Q _1603_/A vssd1 vssd1 vccd1 vccd1 _2594_/A sky130_fd_sc_hd__and3b_2
X_3262_ _3393_/CLK _3262_/D load_slew258/X vssd1 vssd1 vccd1 vccd1 _3262_/Q sky130_fd_sc_hd__dfrtp_2
X_3193_ _3337_/CLK _3193_/D load_slew256/X vssd1 vssd1 vccd1 vccd1 _3193_/Q sky130_fd_sc_hd__dfrtp_2
X_2213_ _2213_/A _2213_/B vssd1 vssd1 vccd1 vccd1 _2214_/B sky130_fd_sc_hd__nand2_2
XFILLER_38_101 vssd1 vssd1 vccd1 vccd1 sky130_fd_sc_hd__fill_1
X_2144_ hold621/X _2143_/Y _2374_/S vssd1 vssd1 vccd1 vccd1 _3075_/D sky130_fd_sc_hd__mux2_1
XANTENNA__2835__S _2837_/S vssd1 vssd1 vccd1 vccd1 sky130_fd_sc_hd__diode_2
X_2075_ _2075_/A _2093_/B _2075_/C vssd1 vssd1 vccd1 vccd1 _2077_/A sky130_fd_sc_hd__and3_2
X_2977_ _3401_/Q hold387/X _3408_/Q vssd1 vssd1 vccd1 vccd1 _2977_/X sky130_fd_sc_hd__mux2_1
XANTENNA_fanout221_A fanout223/X vssd1 vssd1 vccd1 vccd1 sky130_fd_sc_hd__diode_2
X_1928_ _1904_/B _1910_/Y _1911_/X _1926_/Y _1902_/Y vssd1 vssd1 vccd1 vccd1 _1981_/B
+ sky130_fd_sc_hd__a311o_2
X_1859_ _1859_/A _1859_/B _1859_/C vssd1 vssd1 vccd1 vccd1 _1873_/A sky130_fd_sc_hd__or3_2
Xhold720 _3397_/Q vssd1 vssd1 vccd1 vccd1 hold720/X sky130_fd_sc_hd__dlygate4sd3_1
XANTENNA_fanout107_X _1546_/S vssd1 vssd1 vccd1 vccd1 sky130_fd_sc_hd__diode_2
Xhold731 _3017_/Q vssd1 vssd1 vccd1 vccd1 hold731/X sky130_fd_sc_hd__dlygate4sd3_1
XFILLER_57_421 vssd1 vssd1 vccd1 vccd1 sky130_fd_sc_hd__fill_1
XPHY_EDGE_ROW_24_Left_104 vssd1 vssd1 vccd1 vccd1 sky130_fd_sc_hd__decap_3
XFILLER_57_432 vssd1 vssd1 vccd1 vccd1 sky130_fd_sc_hd__fill_1
XFILLER_17_318 vssd1 vssd1 vccd1 vccd1 sky130_fd_sc_hd__fill_1
XANTENNA__2745__S _2761_/S vssd1 vssd1 vccd1 vccd1 sky130_fd_sc_hd__diode_2
XFILLER_72_435 vssd1 vssd1 vccd1 vccd1 sky130_fd_sc_hd__fill_2
XFILLER_55_57 vssd1 vssd1 vccd1 vccd1 sky130_fd_sc_hd__fill_2
XFILLER_25_395 vssd1 vssd1 vccd1 vccd1 sky130_fd_sc_hd__fill_1
XPHY_EDGE_ROW_33_Left_113 vssd1 vssd1 vccd1 vccd1 sky130_fd_sc_hd__decap_3
XTAP_TAPCELL_ROW_10_257 vssd1 vccd1 sky130_fd_sc_hd__tapvpwrvgnd_1
XPHY_EDGE_ROW_42_Left_122 vssd1 vssd1 vccd1 vccd1 sky130_fd_sc_hd__decap_3
XFILLER_48_443 vssd1 vssd1 vccd1 vccd1 sky130_fd_sc_hd__fill_8
XFILLER_48_421 vssd1 vssd1 vccd1 vccd1 sky130_fd_sc_hd__fill_2
XANTENNA__2655__S _2666_/S vssd1 vssd1 vccd1 vccd1 sky130_fd_sc_hd__diode_2
XTAP_TAPCELL_ROW_18_324 vssd1 vccd1 sky130_fd_sc_hd__tapvpwrvgnd_1
XANTENNA__1779__B _1805_/A vssd1 vssd1 vccd1 vccd1 sky130_fd_sc_hd__diode_2
X_2900_ _2900_/A _2959_/C _3354_/Q vssd1 vssd1 vccd1 vccd1 _2900_/X sky130_fd_sc_hd__and3_2
XTAP_TAPCELL_ROW_26_390 vssd1 vccd1 sky130_fd_sc_hd__tapvpwrvgnd_1
XPHY_EDGE_ROW_51_Left_131 vssd1 vssd1 vccd1 vccd1 sky130_fd_sc_hd__decap_3
XFILLER_31_343 vssd1 vssd1 vccd1 vccd1 sky130_fd_sc_hd__fill_1
XFILLER_31_321 vssd1 vssd1 vccd1 vccd1 sky130_fd_sc_hd__fill_1
X_2831_ hold591/X _2850_/A1 _2837_/S vssd1 vssd1 vccd1 vccd1 _3336_/D sky130_fd_sc_hd__mux2_1
X_2762_ _2838_/B _2762_/B _2800_/C vssd1 vssd1 vccd1 vccd1 _2762_/X sky130_fd_sc_hd__and3_2
X_1713_ _1713_/A _1713_/B vssd1 vssd1 vccd1 vccd1 _1713_/Y sky130_fd_sc_hd__xnor2_2
X_2693_ hold447/X _2845_/A1 _2704_/S vssd1 vssd1 vccd1 vccd1 _3205_/D sky130_fd_sc_hd__mux2_1
X_1644_ _1642_/Y _1644_/B vssd1 vssd1 vccd1 vccd1 _1647_/A sky130_fd_sc_hd__and2b_2
XANTENNA__2888__B2 _2781_/B vssd1 vssd1 vccd1 vccd1 sky130_fd_sc_hd__diode_2
X_1575_ input5/X input1/X vssd1 vssd1 vccd1 vccd1 _1575_/X sky130_fd_sc_hd__and2_2
XPHY_EDGE_ROW_60_Left_140 vssd1 vssd1 vccd1 vccd1 sky130_fd_sc_hd__decap_3
X_3314_ _3352_/CLK _3314_/D fanout254/X vssd1 vssd1 vccd1 vccd1 _3314_/Q sky130_fd_sc_hd__dfrtp_2
X_3245_ _3302_/CLK _3245_/D load_slew276/X vssd1 vssd1 vccd1 vccd1 _3245_/Q sky130_fd_sc_hd__dfrtp_2
XTAP_TAPCELL_ROW_69_758 vssd1 vccd1 sky130_fd_sc_hd__tapvpwrvgnd_1
X_3176_ _3389_/CLK _3176_/D load_slew278/X vssd1 vssd1 vccd1 vccd1 _3176_/Q sky130_fd_sc_hd__dfrtp_2
X_2127_ _2151_/A _2126_/C _2126_/A vssd1 vssd1 vccd1 vccd1 _2129_/C sky130_fd_sc_hd__a21o_2
XFILLER_66_273 vssd1 vssd1 vccd1 vccd1 sky130_fd_sc_hd__fill_1
X_2058_ _2059_/A _2059_/B vssd1 vssd1 vccd1 vccd1 _2081_/A sky130_fd_sc_hd__or2_2
XTAP_TAPCELL_ROW_52_614 vssd1 vccd1 sky130_fd_sc_hd__tapvpwrvgnd_1
XANTENNA__3102__RESET_B fanout228/X vssd1 vssd1 vccd1 vccd1 sky130_fd_sc_hd__diode_2
XTAP_TAPCELL_ROW_60_680 vssd1 vccd1 sky130_fd_sc_hd__tapvpwrvgnd_1
XANTENNA_clkbuf_3_5__f_clk_A clkbuf_0_clk/X vssd1 vssd1 vccd1 vccd1 sky130_fd_sc_hd__diode_2
Xhold572 _3334_/Q vssd1 vssd1 vccd1 vccd1 hold572/X sky130_fd_sc_hd__dlygate4sd3_1
Xhold561 _3114_/Q vssd1 vssd1 vccd1 vccd1 hold561/X sky130_fd_sc_hd__dlygate4sd3_1
Xhold550 _3254_/Q vssd1 vssd1 vccd1 vccd1 hold550/X sky130_fd_sc_hd__dlygate4sd3_1
XFILLER_1_225 vssd1 vssd1 vccd1 vccd1 sky130_fd_sc_hd__fill_8
Xhold594 _3263_/Q vssd1 vssd1 vccd1 vccd1 hold594/X sky130_fd_sc_hd__dlygate4sd3_1
Xhold583 _3235_/Q vssd1 vssd1 vccd1 vccd1 hold583/X sky130_fd_sc_hd__dlygate4sd3_1
XANTENNA_fanout84_A _2438_/X vssd1 vssd1 vccd1 vccd1 sky130_fd_sc_hd__diode_2
XFILLER_66_78 vssd1 vssd1 vccd1 vccd1 sky130_fd_sc_hd__fill_1
XANTENNA__1854__A2 _2029_/B vssd1 vssd1 vccd1 vccd1 sky130_fd_sc_hd__diode_2
XFILLER_72_243 vssd1 vssd1 vccd1 vccd1 sky130_fd_sc_hd__fill_8
XFILLER_25_181 vssd1 vssd1 vccd1 vccd1 sky130_fd_sc_hd__fill_1
XFILLER_15_71 vssd1 vssd1 vccd1 vccd1 sky130_fd_sc_hd__fill_2
XANTENNA__2504__A _2900_/A vssd1 vssd1 vccd1 vccd1 sky130_fd_sc_hd__diode_2
XTAP_TAPCELL_ROW_23_371 vssd1 vccd1 sky130_fd_sc_hd__tapvpwrvgnd_1
XFILLER_9_358 vssd1 vssd1 vccd1 vccd1 sky130_fd_sc_hd__fill_4
XANTENNA__1790__B2 _1906_/A vssd1 vssd1 vccd1 vccd1 sky130_fd_sc_hd__diode_2
XANTENNA__2098__A2 _2263_/A vssd1 vssd1 vccd1 vccd1 sky130_fd_sc_hd__diode_2
XANTENNA__2893__B _2926_/C vssd1 vssd1 vccd1 vccd1 sky130_fd_sc_hd__diode_2
X_3030_ _3119_/CLK _3030_/D load_slew216/X vssd1 vssd1 vccd1 vccd1 _3030_/Q sky130_fd_sc_hd__dfrtp_2
XFILLER_63_221 vssd1 vssd1 vccd1 vccd1 sky130_fd_sc_hd__fill_2
XANTENNA_clkbuf_leaf_9_clk_A clkload2/A vssd1 vssd1 vccd1 vccd1 sky130_fd_sc_hd__diode_2
X_2814_ hold541/X _2814_/A1 _2814_/S vssd1 vssd1 vccd1 vccd1 _3320_/D sky130_fd_sc_hd__mux2_1
X_2745_ hold550/X _2802_/A1 _2761_/S vssd1 vssd1 vccd1 vccd1 _3254_/D sky130_fd_sc_hd__mux2_1
X_2676_ hold637/X _2809_/A1 _2681_/S vssd1 vssd1 vccd1 vccd1 _3189_/D sky130_fd_sc_hd__mux2_1
X_1627_ _2595_/B _2610_/A vssd1 vssd1 vccd1 vccd1 _1627_/X sky130_fd_sc_hd__and2b_2
X_1558_ _3421_/Q _3436_/Q vssd1 vssd1 vccd1 vccd1 _3416_/D sky130_fd_sc_hd__and2_2
X_3228_ _3387_/CLK _3228_/D fanout235/X vssd1 vssd1 vccd1 vccd1 _3228_/Q sky130_fd_sc_hd__dfrtp_2
XFILLER_39_262 vssd1 vssd1 vccd1 vccd1 sky130_fd_sc_hd__fill_2
XANTENNA_fanout174_X _2383_/B vssd1 vssd1 vccd1 vccd1 sky130_fd_sc_hd__diode_2
X_3159_ _3395_/CLK _3159_/D fanout245/X vssd1 vssd1 vccd1 vccd1 _3159_/Q sky130_fd_sc_hd__dfrtp_2
XTAP_TAPCELL_ROW_29_419 vssd1 vccd1 sky130_fd_sc_hd__tapvpwrvgnd_1
XFILLER_36_37 vssd1 vssd1 vccd1 vccd1 sky130_fd_sc_hd__fill_8
XFILLER_54_243 vssd1 vssd1 vccd1 vccd1 sky130_fd_sc_hd__fill_1
XFILLER_42_416 vssd1 vssd1 vccd1 vccd1 sky130_fd_sc_hd__fill_4
Xclkbuf_leaf_34_clk clkbuf_3_4__f_clk/X vssd1 vssd1 vccd1 vccd1 _3331_/CLK sky130_fd_sc_hd__clkbuf_8
XTAP_TAPCELL_ROW_37_485 vssd1 vccd1 sky130_fd_sc_hd__tapvpwrvgnd_1
XANTENNA__2324__A _2383_/B vssd1 vssd1 vccd1 vccd1 sky130_fd_sc_hd__diode_2
XFILLER_50_471 vssd1 vssd1 vccd1 vccd1 sky130_fd_sc_hd__fill_2
XTAP_TAPCELL_ROW_20_341 vssd1 vccd1 sky130_fd_sc_hd__tapvpwrvgnd_1
Xhold380 _2976_/X vssd1 vssd1 vccd1 vccd1 _3400_/D sky130_fd_sc_hd__dlygate4sd3_1
XFILLER_7_3 vssd1 vccd1 vssd1 vccd1 sky130_ef_sc_hd__decap_40_12
XANTENNA_fanout87_X _1622_/C vssd1 vssd1 vccd1 vccd1 sky130_fd_sc_hd__diode_2
Xhold391 _2981_/X vssd1 vssd1 vccd1 vccd1 _3405_/D sky130_fd_sc_hd__dlygate4sd3_1
XTAP_TAPCELL_ROW_63_709 vssd1 vccd1 sky130_fd_sc_hd__tapvpwrvgnd_1
XFILLER_45_265 vssd1 vssd1 vccd1 vccd1 sky130_fd_sc_hd__fill_4
XFILLER_18_479 vssd1 vccd1 vssd1 vccd1 sky130_ef_sc_hd__decap_40_12
Xclkbuf_leaf_25_clk clkbuf_3_4__f_clk/X vssd1 vssd1 vccd1 vccd1 _3392_/CLK sky130_fd_sc_hd__clkbuf_8
XTAP_TAPCELL_ROW_71_775 vssd1 vccd1 sky130_fd_sc_hd__tapvpwrvgnd_1
XANTENNA__1776__C _1993_/S vssd1 vssd1 vccd1 vccd1 sky130_fd_sc_hd__diode_2
XFILLER_9_111 vssd1 vssd1 vccd1 vccd1 sky130_fd_sc_hd__fill_1
XFILLER_13_184 vssd1 vssd1 vccd1 vccd1 sky130_fd_sc_hd__fill_1
X_2530_ _2926_/B _2926_/C _3350_/Q vssd1 vssd1 vccd1 vccd1 _2530_/X sky130_fd_sc_hd__and3_2
XANTENNA__2960__B1 wire66/X vssd1 vssd1 vccd1 vccd1 sky130_fd_sc_hd__diode_2
X_2461_ _3254_/Q _2894_/A2 _2894_/B1 _3236_/Q _2460_/X vssd1 vssd1 vccd1 vccd1 _2461_/X
+ sky130_fd_sc_hd__a221o_2
XFILLER_5_372 vssd1 vssd1 vccd1 vccd1 sky130_fd_sc_hd__fill_1
X_2392_ _2392_/A _2392_/B vssd1 vssd1 vccd1 vccd1 _2393_/B sky130_fd_sc_hd__or2_2
XFILLER_68_313 vssd1 vssd1 vccd1 vccd1 sky130_fd_sc_hd__fill_4
XTAP_TAPCELL_ROW_79_842 vssd1 vccd1 sky130_fd_sc_hd__tapvpwrvgnd_1
XFILLER_68_346 vssd1 vssd1 vccd1 vccd1 sky130_fd_sc_hd__fill_1
XFILLER_68_324 vssd1 vssd1 vccd1 vccd1 sky130_fd_sc_hd__fill_1
XTAP_TAPCELL_ROW_79_853 vssd1 vccd1 sky130_fd_sc_hd__tapvpwrvgnd_1
X_3013_ _3090_/CLK _3013_/D fanout211/X vssd1 vssd1 vccd1 vccd1 _3013_/Q sky130_fd_sc_hd__dfrtp_2
XFILLER_24_416 vssd1 vssd1 vccd1 vccd1 sky130_fd_sc_hd__fill_4
XANTENNA__2843__S _2856_/S vssd1 vssd1 vccd1 vccd1 sky130_fd_sc_hd__diode_2
Xclkbuf_leaf_16_clk clkload4/A vssd1 vssd1 vccd1 vccd1 _3450_/CLK sky130_fd_sc_hd__clkbuf_8
XFILLER_17_490 vssd1 vssd1 vccd1 vccd1 sky130_fd_sc_hd__fill_4
XANTENNA_fanout134_A _2900_/A vssd1 vssd1 vccd1 vccd1 sky130_fd_sc_hd__diode_2
X_2728_ hold547/X _2842_/A1 _2738_/S vssd1 vssd1 vccd1 vccd1 _3238_/D sky130_fd_sc_hd__mux2_1
X_2659_ hold492/X _2811_/A1 _2662_/S vssd1 vssd1 vccd1 vccd1 _3173_/D sky130_fd_sc_hd__mux2_1
Xfanout101 _2313_/S vssd1 vssd1 vccd1 vccd1 _2374_/S sky130_fd_sc_hd__clkdlybuf4s25_1
Xfanout112 _2972_/A1 vssd1 vssd1 vccd1 vccd1 _2966_/A1 sky130_fd_sc_hd__clkdlybuf4s25_1
XANTENNA_fanout291_X fanout291/X vssd1 vssd1 vccd1 vccd1 sky130_fd_sc_hd__diode_2
Xfanout123 _3426_/Q vssd1 vssd1 vccd1 vccd1 _2588_/A sky130_fd_sc_hd__clkdlybuf4s25_1
Xfanout134 _2900_/A vssd1 vssd1 vccd1 vccd1 _2970_/B sky130_fd_sc_hd__clkdlybuf4s25_1
Xfanout145 _3051_/Q vssd1 vssd1 vccd1 vccd1 _2352_/B sky130_fd_sc_hd__clkdlybuf4s25_1
Xfanout156 _1979_/B vssd1 vssd1 vccd1 vccd1 _2073_/A sky130_fd_sc_hd__clkdlybuf4s25_1
Xfanout167 _3040_/Q vssd1 vssd1 vccd1 vccd1 _1828_/D sky130_fd_sc_hd__clkdlybuf4s25_1
Xfanout178 _3033_/Q vssd1 vssd1 vccd1 vccd1 _2318_/B sky130_fd_sc_hd__clkdlybuf4s25_1
Xfanout189 _2049_/B vssd1 vssd1 vccd1 vccd1 _2005_/A sky130_fd_sc_hd__clkdlybuf4s25_1
XANTENNA__2482__A2 _2667_/B vssd1 vssd1 vccd1 vccd1 sky130_fd_sc_hd__diode_2
XANTENNA__2753__S _2757_/S vssd1 vssd1 vccd1 vccd1 sky130_fd_sc_hd__diode_2
XFILLER_63_57 vssd1 vssd1 vccd1 vccd1 sky130_fd_sc_hd__fill_2
XFILLER_63_35 vssd1 vssd1 vccd1 vccd1 sky130_fd_sc_hd__fill_4
XFILLER_42_246 vssd1 vssd1 vccd1 vccd1 sky130_fd_sc_hd__fill_4
XFILLER_23_493 vssd1 vssd1 vccd1 vccd1 sky130_fd_sc_hd__fill_1
XFILLER_10_165 vssd1 vccd1 vssd1 vccd1 sky130_ef_sc_hd__decap_40_12
XFILLER_77_187 vssd1 vssd1 vccd1 vccd1 sky130_fd_sc_hd__fill_2
XANTENNA__2473__A2 _2667_/B vssd1 vssd1 vccd1 vccd1 sky130_fd_sc_hd__diode_2
XANTENNA__2663__S _2666_/S vssd1 vssd1 vccd1 vccd1 sky130_fd_sc_hd__diode_2
XFILLER_73_393 vssd1 vssd1 vccd1 vccd1 sky130_fd_sc_hd__fill_4
XFILLER_18_298 vssd1 vssd1 vccd1 vccd1 sky130_fd_sc_hd__fill_1
X_1961_ _2073_/A _1962_/B _1998_/B _2073_/B vssd1 vssd1 vccd1 vccd1 _1961_/X sky130_fd_sc_hd__a22o_2
XFILLER_14_482 vssd1 vssd1 vccd1 vccd1 sky130_fd_sc_hd__fill_4
X_1892_ _1892_/A _1892_/B vssd1 vssd1 vccd1 vccd1 _1893_/B sky130_fd_sc_hd__nand2_2
XTAP_TAPCELL_ROW_31_436 vssd1 vccd1 sky130_fd_sc_hd__tapvpwrvgnd_1
X_2513_ _2961_/A1 _2510_/X _2512_/X _2962_/A1 vssd1 vssd1 vccd1 vccd1 _2514_/B sky130_fd_sc_hd__a22o_2
Xclkbuf_leaf_5_clk clkload1/A vssd1 vssd1 vccd1 vccd1 _3121_/CLK sky130_fd_sc_hd__clkbuf_8
X_2444_ _2611_/A _2800_/A vssd1 vssd1 vccd1 vccd1 _2762_/B sky130_fd_sc_hd__nor2_2
X_2375_ _2353_/B _2355_/B _2353_/A vssd1 vssd1 vccd1 vccd1 _2377_/B sky130_fd_sc_hd__o21bai_2
XANTENNA__1742__S _3435_/D vssd1 vssd1 vccd1 vccd1 sky130_fd_sc_hd__diode_2
XFILLER_56_305 vssd1 vssd1 vccd1 vccd1 sky130_fd_sc_hd__fill_2
XTAP_TAPCELL_ROW_39_503 vssd1 vccd1 sky130_fd_sc_hd__tapvpwrvgnd_1
XFILLER_68_176 vssd1 vccd1 vssd1 vccd1 sky130_ef_sc_hd__decap_40_12
XANTENNA__2464__A2 _2923_/A2 vssd1 vssd1 vccd1 vccd1 sky130_fd_sc_hd__diode_2
XFILLER_17_39 vssd1 vssd1 vccd1 vccd1 sky130_fd_sc_hd__fill_2
XANTENNA_fanout251_A fanout290/X vssd1 vssd1 vccd1 vccd1 sky130_fd_sc_hd__diode_2
XANTENNA_fanout137_X _2533_/A vssd1 vssd1 vccd1 vccd1 sky130_fd_sc_hd__diode_2
XFILLER_79_419 vssd1 vssd1 vccd1 vccd1 sky130_fd_sc_hd__fill_1
XFILLER_58_13 vssd1 vssd1 vccd1 vccd1 sky130_fd_sc_hd__fill_1
XANTENNA__2748__S _2761_/S vssd1 vssd1 vccd1 vccd1 sky130_fd_sc_hd__diode_2
XFILLER_74_157 vssd1 vssd1 vccd1 vccd1 sky130_fd_sc_hd__fill_1
XFILLER_74_56 vssd1 vccd1 vssd1 vccd1 sky130_ef_sc_hd__decap_40_12
XANTENNA_clkbuf_leaf_34_clk_A clkbuf_3_4__f_clk/X vssd1 vssd1 vccd1 vccd1 sky130_fd_sc_hd__diode_2
XANTENNA__2658__S _2662_/S vssd1 vssd1 vccd1 vccd1 sky130_fd_sc_hd__diode_2
XFILLER_78_430 vssd1 vssd1 vccd1 vccd1 sky130_fd_sc_hd__fill_1
X_2160_ _2160_/A _2160_/B vssd1 vssd1 vccd1 vccd1 _2163_/B sky130_fd_sc_hd__xnor2_2
XFILLER_78_474 vssd1 vssd1 vccd1 vccd1 sky130_fd_sc_hd__fill_2
XFILLER_65_113 vssd1 vssd1 vccd1 vccd1 sky130_fd_sc_hd__fill_1
X_2091_ _3068_/Q _2091_/B vssd1 vssd1 vccd1 vccd1 _2091_/X sky130_fd_sc_hd__and2_2
XFILLER_0_42 vssd1 vssd1 vccd1 vccd1 sky130_fd_sc_hd__fill_2
XTAP_TAPCELL_ROW_44_550 vssd1 vccd1 sky130_fd_sc_hd__tapvpwrvgnd_1
XFILLER_0_97 vssd1 vssd1 vccd1 vccd1 sky130_fd_sc_hd__fill_8
X_2993_ _2995_/A vssd1 vssd1 vccd1 vccd1 _2993_/Y sky130_fd_sc_hd__inv_2
X_1944_ _2005_/A _2029_/A _2004_/B _1970_/B vssd1 vssd1 vccd1 vccd1 _1973_/A sky130_fd_sc_hd__nand4_2
X_1875_ _1834_/Y _1842_/B _1834_/A _1833_/Y vssd1 vssd1 vccd1 vccd1 _1876_/C sky130_fd_sc_hd__a2bb2o_2
X_2427_ _3421_/Q _2427_/B _2427_/C _2426_/X vssd1 vssd1 vccd1 vccd1 _2427_/X sky130_fd_sc_hd__or4b_2
X_2358_ _2356_/X _2358_/B vssd1 vssd1 vccd1 vccd1 _2361_/A sky130_fd_sc_hd__nand2b_2
XFILLER_28_27 vssd1 vssd1 vccd1 vccd1 sky130_fd_sc_hd__fill_1
X_2289_ _2289_/A _2289_/B vssd1 vssd1 vccd1 vccd1 _2303_/A sky130_fd_sc_hd__xnor2_2
XFILLER_52_363 vssd1 vssd1 vccd1 vccd1 sky130_fd_sc_hd__fill_1
XFILLER_12_205 vssd1 vssd1 vccd1 vccd1 sky130_fd_sc_hd__fill_2
XTAP_TAPCELL_ROW_50_597 vssd1 vccd1 sky130_fd_sc_hd__tapvpwrvgnd_1
XTAP_TAPCELL_ROW_7_231 vssd1 vccd1 sky130_fd_sc_hd__tapvpwrvgnd_1
XTAP_TAPCELL_ROW_58_664 vssd1 vccd1 sky130_fd_sc_hd__tapvpwrvgnd_1
XFILLER_35_319 vssd1 vssd1 vccd1 vccd1 sky130_fd_sc_hd__fill_4
XFILLER_18_82 vssd1 vssd1 vccd1 vccd1 sky130_fd_sc_hd__fill_2
XANTENNA__2507__A _2520_/A vssd1 vssd1 vccd1 vccd1 sky130_fd_sc_hd__diode_2
XANTENNA__2226__B _2399_/B vssd1 vssd1 vccd1 vccd1 sky130_fd_sc_hd__diode_2
XTAP_TAPCELL_ROW_41_520 vssd1 vccd1 sky130_fd_sc_hd__tapvpwrvgnd_1
XANTENNA__1784__C _1805_/A vssd1 vssd1 vccd1 vccd1 sky130_fd_sc_hd__diode_2
X_1660_ _1660_/A _1660_/B vssd1 vssd1 vccd1 vccd1 _1660_/X sky130_fd_sc_hd__or2_2
X_1591_ _2588_/A _2431_/C _1590_/Y _1622_/A vssd1 vssd1 vccd1 vccd1 _3426_/D sky130_fd_sc_hd__a211o_2
X_3330_ _3386_/CLK _3330_/D fanout236/X vssd1 vssd1 vccd1 vccd1 _3330_/Q sky130_fd_sc_hd__dfrtp_2
X_3261_ _3389_/CLK _3261_/D load_slew278/X vssd1 vssd1 vccd1 vccd1 _3261_/Q sky130_fd_sc_hd__dfrtp_2
X_3192_ _3392_/CLK _3192_/D fanout252/X vssd1 vssd1 vccd1 vccd1 _3192_/Q sky130_fd_sc_hd__dfrtp_2
X_2212_ _2252_/A _2250_/B _2211_/A vssd1 vssd1 vccd1 vccd1 _2216_/B sky130_fd_sc_hd__a21o_2
XFILLER_22_3 vssd1 vssd1 vccd1 vccd1 sky130_fd_sc_hd__fill_2
X_2143_ _2143_/A _2143_/B vssd1 vssd1 vccd1 vccd1 _2143_/Y sky130_fd_sc_hd__xnor2_2
X_2074_ _2053_/A _2049_/X _2052_/B vssd1 vssd1 vccd1 vccd1 _2075_/C sky130_fd_sc_hd__o21a_2
XFILLER_53_127 vssd1 vssd1 vccd1 vccd1 sky130_fd_sc_hd__fill_1
XFILLER_34_363 vssd1 vssd1 vccd1 vccd1 sky130_fd_sc_hd__fill_1
XANTENNA__2851__S _2856_/S vssd1 vssd1 vccd1 vccd1 sky130_fd_sc_hd__diode_2
XFILLER_14_29 vssd1 vssd1 vccd1 vccd1 sky130_fd_sc_hd__fill_2
X_2976_ _3400_/Q hold379/X _3408_/Q vssd1 vssd1 vccd1 vccd1 _2976_/X sky130_fd_sc_hd__mux2_1
X_1927_ _1902_/Y _1913_/B _1926_/Y _1904_/B vssd1 vssd1 vccd1 vccd1 _1982_/A sky130_fd_sc_hd__o211ai_2
XANTENNA_fanout214_A fanout291/X vssd1 vssd1 vccd1 vccd1 sky130_fd_sc_hd__diode_2
X_1858_ _1893_/A _1892_/B _1892_/A vssd1 vssd1 vccd1 vccd1 _1859_/C sky130_fd_sc_hd__a21oi_2
Xhold721 _3395_/Q vssd1 vssd1 vccd1 vccd1 hold721/X sky130_fd_sc_hd__dlygate4sd3_1
Xhold710 _3007_/Q vssd1 vssd1 vccd1 vccd1 hold710/X sky130_fd_sc_hd__dlygate4sd3_1
Xhold732 _2583_/X vssd1 vssd1 vccd1 vccd1 _3135_/D sky130_fd_sc_hd__dlygate4sd3_1
X_1789_ _1800_/B _1788_/Y hold741/X _2091_/B vssd1 vssd1 vccd1 vccd1 _3056_/D sky130_fd_sc_hd__a2bb2o_2
XFILLER_39_15 vssd1 vssd1 vccd1 vccd1 sky130_fd_sc_hd__fill_2
XFILLER_1_418 vssd1 vssd1 vccd1 vccd1 sky130_fd_sc_hd__fill_2
X_3459_ _3463_/CLK _3459_/D load_slew237/X vssd1 vssd1 vccd1 vccd1 _3459_/Q sky130_fd_sc_hd__dfrtp_2
XANTENNA__1866__B1 _1970_/B vssd1 vssd1 vccd1 vccd1 sky130_fd_sc_hd__diode_2
XFILLER_29_124 vssd1 vssd1 vccd1 vccd1 sky130_fd_sc_hd__fill_1
XFILLER_72_425 vssd1 vssd1 vccd1 vccd1 sky130_fd_sc_hd__fill_1
XFILLER_44_149 vssd1 vssd1 vccd1 vccd1 sky130_fd_sc_hd__fill_1
XFILLER_40_311 vssd1 vccd1 vssd1 vccd1 sky130_ef_sc_hd__decap_40_12
XANTENNA__2761__S _2761_/S vssd1 vssd1 vccd1 vccd1 sky130_fd_sc_hd__diode_2
XFILLER_71_57 vssd1 vssd1 vccd1 vccd1 sky130_fd_sc_hd__fill_4
XTAP_TAPCELL_ROW_10_258 vssd1 vccd1 sky130_fd_sc_hd__tapvpwrvgnd_1
XFILLER_4_223 vssd1 vssd1 vccd1 vccd1 sky130_fd_sc_hd__fill_1
XFILLER_4_201 vssd1 vssd1 vccd1 vccd1 sky130_fd_sc_hd__fill_2
XFILLER_4_256 vssd1 vssd1 vccd1 vccd1 sky130_fd_sc_hd__fill_2
XFILLER_4_245 vssd1 vssd1 vccd1 vccd1 sky130_fd_sc_hd__fill_4
XANTENNA__2897__A2 _3437_/D vssd1 vssd1 vccd1 vccd1 sky130_fd_sc_hd__diode_2
XFILLER_0_473 vssd1 vssd1 vccd1 vccd1 sky130_fd_sc_hd__fill_2
XTAP_TAPCELL_ROW_18_325 vssd1 vccd1 sky130_fd_sc_hd__tapvpwrvgnd_1
XFILLER_75_274 vssd1 vssd1 vccd1 vccd1 sky130_fd_sc_hd__fill_1
XANTENNA__1779__C _1947_/A vssd1 vssd1 vccd1 vccd1 sky130_fd_sc_hd__diode_2
XANTENNA__2671__S _2681_/S vssd1 vssd1 vccd1 vccd1 sky130_fd_sc_hd__diode_2
X_2830_ hold687/X _2632_/X _2833_/S vssd1 vssd1 vccd1 vccd1 _3335_/D sky130_fd_sc_hd__mux2_1
XTAP_TAPCELL_ROW_26_391 vssd1 vccd1 sky130_fd_sc_hd__tapvpwrvgnd_1
X_2761_ hold676/X _2818_/A1 _2761_/S vssd1 vssd1 vccd1 vccd1 _3270_/D sky130_fd_sc_hd__mux2_1
X_2692_ hold484/X _2844_/A1 _2704_/S vssd1 vssd1 vccd1 vccd1 _3204_/D sky130_fd_sc_hd__mux2_1
X_1712_ _1705_/A _1707_/B _1705_/B vssd1 vssd1 vccd1 vccd1 _1713_/B sky130_fd_sc_hd__a21bo_2
XANTENNA_1 _3132_/Q vssd1 vssd1 vccd1 vccd1 sky130_fd_sc_hd__diode_2
X_1643_ _3073_/Q _3056_/Q vssd1 vssd1 vccd1 vccd1 _1644_/B sky130_fd_sc_hd__nand2_2
XFILLER_6_74 vssd1 vssd1 vccd1 vccd1 sky130_fd_sc_hd__fill_2
XANTENNA__2888__A2 _2923_/A2 vssd1 vssd1 vccd1 vccd1 sky130_fd_sc_hd__diode_2
X_1574_ _1573_/Y _3433_/Q vssd1 vssd1 vccd1 vccd1 _1574_/X sky130_fd_sc_hd__and2b_2
X_3313_ _3349_/CLK _3313_/D fanout229/X vssd1 vssd1 vccd1 vccd1 _3313_/Q sky130_fd_sc_hd__dfrtp_2
X_3244_ _3393_/CLK _3244_/D load_slew258/X vssd1 vssd1 vccd1 vccd1 _3244_/Q sky130_fd_sc_hd__dfrtp_2
XANTENNA__2846__S _2852_/S vssd1 vssd1 vccd1 vccd1 sky130_fd_sc_hd__diode_2
XTAP_TAPCELL_ROW_69_759 vssd1 vccd1 sky130_fd_sc_hd__tapvpwrvgnd_1
XANTENNA__1750__S _1773_/S vssd1 vssd1 vccd1 vccd1 sky130_fd_sc_hd__diode_2
X_3175_ _3337_/CLK _3175_/D load_slew256/X vssd1 vssd1 vccd1 vccd1 _3175_/Q sky130_fd_sc_hd__dfrtp_2
X_2126_ _2126_/A _2151_/A _2126_/C vssd1 vssd1 vccd1 vccd1 _2152_/A sky130_fd_sc_hd__nand3_2
X_2057_ _2035_/B _2038_/B _2033_/X vssd1 vssd1 vccd1 vccd1 _2059_/B sky130_fd_sc_hd__a21o_2
XFILLER_26_149 vssd1 vssd1 vccd1 vccd1 sky130_fd_sc_hd__fill_1
XTAP_TAPCELL_ROW_52_615 vssd1 vccd1 sky130_fd_sc_hd__tapvpwrvgnd_1
X_2959_ _3287_/Q _2959_/B _2959_/C vssd1 vssd1 vccd1 vccd1 _2959_/X sky130_fd_sc_hd__and3_2
XTAP_TAPCELL_ROW_60_681 vssd1 vccd1 sky130_fd_sc_hd__tapvpwrvgnd_1
XANTENNA__2610__A _2610_/A vssd1 vssd1 vccd1 vccd1 sky130_fd_sc_hd__diode_2
XANTENNA__2879__A2 _2838_/B vssd1 vssd1 vccd1 vccd1 sky130_fd_sc_hd__diode_2
Xhold562 _3393_/Q vssd1 vssd1 vccd1 vccd1 hold562/X sky130_fd_sc_hd__dlygate4sd3_1
Xhold551 _3294_/Q vssd1 vssd1 vccd1 vccd1 hold551/X sky130_fd_sc_hd__dlygate4sd3_1
Xhold540 _3308_/Q vssd1 vssd1 vccd1 vccd1 hold540/X sky130_fd_sc_hd__dlygate4sd3_1
Xhold595 _3247_/Q vssd1 vssd1 vccd1 vccd1 hold595/X sky130_fd_sc_hd__dlygate4sd3_1
Xhold584 _3258_/Q vssd1 vssd1 vccd1 vccd1 hold584/X sky130_fd_sc_hd__dlygate4sd3_1
Xhold573 _3268_/Q vssd1 vssd1 vccd1 vccd1 hold573/X sky130_fd_sc_hd__dlygate4sd3_1
XANTENNA__2756__S _2757_/S vssd1 vssd1 vccd1 vccd1 sky130_fd_sc_hd__diode_2
XANTENNA_fanout77_A _2901_/A2 vssd1 vssd1 vccd1 vccd1 sky130_fd_sc_hd__diode_2
XANTENNA__2500__A1 _2962_/A1 vssd1 vssd1 vccd1 vccd1 sky130_fd_sc_hd__diode_2
XANTENNA__2500__B2 _2973_/A1 vssd1 vssd1 vccd1 vccd1 sky130_fd_sc_hd__diode_2
XFILLER_45_447 vssd1 vssd1 vccd1 vccd1 sky130_fd_sc_hd__fill_1
XFILLER_13_300 vssd1 vssd1 vccd1 vccd1 sky130_fd_sc_hd__fill_1
XANTENNA_fanout32_X _2662_/S vssd1 vssd1 vccd1 vccd1 sky130_fd_sc_hd__diode_2
XFILLER_53_491 vssd1 vssd1 vccd1 vccd1 sky130_fd_sc_hd__fill_2
XANTENNA__2504__B _2959_/C vssd1 vssd1 vccd1 vccd1 sky130_fd_sc_hd__diode_2
XANTENNA__2567__A1 _1569_/D vssd1 vssd1 vccd1 vccd1 sky130_fd_sc_hd__diode_2
XANTENNA__2520__A _2520_/A vssd1 vssd1 vccd1 vccd1 sky130_fd_sc_hd__diode_2
XANTENNA__2666__S _2666_/S vssd1 vssd1 vccd1 vccd1 sky130_fd_sc_hd__diode_2
XTAP_TAPCELL_ROW_66_729 vssd1 vccd1 sky130_fd_sc_hd__tapvpwrvgnd_1
XFILLER_36_403 vssd1 vssd1 vccd1 vccd1 sky130_fd_sc_hd__fill_2
XFILLER_16_171 vssd1 vssd1 vccd1 vccd1 sky130_fd_sc_hd__fill_1
X_2813_ hold599/X _2813_/A1 _2818_/S vssd1 vssd1 vccd1 vccd1 _3319_/D sky130_fd_sc_hd__mux2_1
XANTENNA__2558__A1 _2528_/X vssd1 vssd1 vccd1 vccd1 sky130_fd_sc_hd__diode_2
X_2744_ hold652/X _2839_/A1 _2761_/S vssd1 vssd1 vccd1 vccd1 _3253_/D sky130_fd_sc_hd__mux2_1
X_2675_ hold582/X _2808_/A1 _2681_/S vssd1 vssd1 vccd1 vccd1 _3188_/D sky130_fd_sc_hd__mux2_1
XANTENNA__1781__A2 _2091_/B vssd1 vssd1 vccd1 vccd1 sky130_fd_sc_hd__diode_2
X_1626_ _3440_/Q _3420_/Q _1626_/C _3438_/Q vssd1 vssd1 vccd1 vccd1 _1626_/X sky130_fd_sc_hd__and4b_2
X_1557_ _3422_/Q _3436_/Q vssd1 vssd1 vccd1 vccd1 _3417_/D sky130_fd_sc_hd__and2_2
XANTENNA__3411__CLK _3423_/CLK vssd1 vssd1 vccd1 vccd1 sky130_fd_sc_hd__diode_2
X_3227_ _3302_/CLK _3227_/D load_slew273/X vssd1 vssd1 vccd1 vccd1 _3227_/Q sky130_fd_sc_hd__dfrtp_2
X_3158_ _3302_/CLK _3158_/D load_slew273/X vssd1 vssd1 vccd1 vccd1 _3158_/Q sky130_fd_sc_hd__dfrtp_2
XFILLER_54_211 vssd1 vssd1 vccd1 vccd1 sky130_fd_sc_hd__fill_2
XFILLER_36_27 vssd1 vssd1 vccd1 vccd1 sky130_fd_sc_hd__fill_1
X_2109_ _2107_/X _2108_/Y hold734/X _2421_/B vssd1 vssd1 vccd1 vccd1 _3073_/D sky130_fd_sc_hd__a2bb2o_2
X_3089_ _3472_/CLK _3089_/D fanout271/X vssd1 vssd1 vccd1 vccd1 _3089_/Q sky130_fd_sc_hd__dfrtp_2
XFILLER_54_255 vssd1 vssd1 vccd1 vccd1 sky130_fd_sc_hd__fill_1
XTAP_TAPCELL_ROW_37_486 vssd1 vccd1 sky130_fd_sc_hd__tapvpwrvgnd_1
XFILLER_52_37 vssd1 vssd1 vccd1 vccd1 sky130_fd_sc_hd__fill_2
XANTENNA__3394__RESET_B fanout279/X vssd1 vssd1 vccd1 vccd1 sky130_fd_sc_hd__diode_2
XANTENNA__2549__A1 _2550_/A1 vssd1 vssd1 vccd1 vccd1 sky130_fd_sc_hd__diode_2
XTAP_TAPCELL_ROW_20_342 vssd1 vccd1 sky130_fd_sc_hd__tapvpwrvgnd_1
Xhold370 _3435_/Q vssd1 vssd1 vccd1 vccd1 _3434_/D sky130_fd_sc_hd__dlygate4sd3_1
Xhold381 _3452_/Q vssd1 vssd1 vccd1 vccd1 hold381/X sky130_fd_sc_hd__dlygate4sd3_1
Xhold392 _3450_/Q vssd1 vssd1 vccd1 vccd1 hold392/X sky130_fd_sc_hd__dlygate4sd3_1
XFILLER_77_23 vssd1 vccd1 vssd1 vccd1 sky130_ef_sc_hd__decap_40_12
XFILLER_45_200 vssd1 vssd1 vccd1 vccd1 sky130_fd_sc_hd__fill_8
XANTENNA__2218__C _2279_/B vssd1 vssd1 vccd1 vccd1 sky130_fd_sc_hd__diode_2
XFILLER_60_236 vssd1 vssd1 vccd1 vccd1 sky130_fd_sc_hd__fill_1
XANTENNA__2515__A _2540_/A vssd1 vssd1 vccd1 vccd1 sky130_fd_sc_hd__diode_2
XANTENNA__2788__A1 _2624_/X vssd1 vssd1 vccd1 vccd1 sky130_fd_sc_hd__diode_2
XTAP_TAPCELL_ROW_71_776 vssd1 vccd1 sky130_fd_sc_hd__tapvpwrvgnd_1
XFILLER_41_472 vssd1 vssd1 vccd1 vccd1 sky130_fd_sc_hd__fill_1
X_2460_ _2924_/B _2924_/C _3272_/Q vssd1 vssd1 vccd1 vccd1 _2460_/X sky130_fd_sc_hd__and3_2
X_2391_ _2372_/A _2368_/A _2372_/B _2370_/B vssd1 vssd1 vccd1 vccd1 _2394_/A sky130_fd_sc_hd__a31o_2
XTAP_TAPCELL_ROW_79_843 vssd1 vccd1 sky130_fd_sc_hd__tapvpwrvgnd_1
XTAP_TAPCELL_ROW_79_854 vssd1 vccd1 sky130_fd_sc_hd__tapvpwrvgnd_1
X_3012_ _3199_/CLK _3012_/D load_slew220/X vssd1 vssd1 vccd1 vccd1 _3012_/Q sky130_fd_sc_hd__dfrtp_2
Xwire59 wire59/A vssd1 vssd1 vccd1 vccd1 wire59/X sky130_fd_sc_hd__buf_2
XFILLER_36_255 vssd1 vssd1 vccd1 vccd1 sky130_fd_sc_hd__fill_1
XFILLER_17_480 vssd1 vssd1 vccd1 vccd1 sky130_fd_sc_hd__fill_1
XANTENNA__1967__C _2029_/C vssd1 vssd1 vccd1 vccd1 sky130_fd_sc_hd__diode_2
XFILLER_22_29 vssd1 vccd1 vssd1 vccd1 sky130_ef_sc_hd__decap_40_12
XANTENNA_fanout127_A _2964_/C vssd1 vssd1 vccd1 vccd1 sky130_fd_sc_hd__diode_2
X_2727_ hold579/X _2803_/A1 _2738_/S vssd1 vssd1 vccd1 vccd1 _3237_/D sky130_fd_sc_hd__mux2_1
XANTENNA__2951__A1 _2972_/B2 vssd1 vssd1 vccd1 vccd1 sky130_fd_sc_hd__diode_2
XANTENNA__2951__B2 _2966_/A1 vssd1 vssd1 vccd1 vccd1 sky130_fd_sc_hd__diode_2
X_2658_ hold585/X _2848_/A1 _2662_/S vssd1 vssd1 vccd1 vccd1 _3172_/D sky130_fd_sc_hd__mux2_1
Xfanout113 _2686_/A vssd1 vssd1 vccd1 vccd1 _2611_/A sky130_fd_sc_hd__clkdlybuf4s25_1
X_2589_ _3144_/Q _1609_/A _1583_/B _3439_/D vssd1 vssd1 vccd1 vccd1 _2589_/X sky130_fd_sc_hd__o22a_2
X_1609_ _1609_/A _1609_/B vssd1 vssd1 vccd1 vccd1 _2595_/B sky130_fd_sc_hd__and2_2
Xfanout124 _3140_/Q vssd1 vssd1 vccd1 vccd1 _2426_/A sky130_fd_sc_hd__clkdlybuf4s25_1
Xfanout135 _2900_/A vssd1 vssd1 vccd1 vccd1 _2964_/B sky130_fd_sc_hd__clkdlybuf4s25_1
Xfanout146 _3051_/Q vssd1 vssd1 vccd1 vccd1 _2255_/B sky130_fd_sc_hd__clkdlybuf4s25_1
XANTENNA_input1_A en vssd1 vssd1 vccd1 vccd1 sky130_fd_sc_hd__diode_2
Xfanout157 _3045_/Q vssd1 vssd1 vccd1 vccd1 _1979_/B sky130_fd_sc_hd__clkdlybuf4s25_1
Xfanout168 _3039_/Q vssd1 vssd1 vccd1 vccd1 _1947_/A sky130_fd_sc_hd__clkdlybuf4s25_1
Xfanout179 _3033_/Q vssd1 vssd1 vccd1 vccd1 _2146_/C sky130_fd_sc_hd__clkdlybuf4s25_1
XFILLER_74_317 vssd1 vssd1 vccd1 vccd1 sky130_fd_sc_hd__fill_1
XFILLER_47_59 vssd1 vssd1 vccd1 vccd1 sky130_fd_sc_hd__fill_1
XANTENNA__3457__CLK _3463_/CLK vssd1 vssd1 vccd1 vccd1 sky130_fd_sc_hd__diode_2
XFILLER_50_280 vssd1 vssd1 vccd1 vccd1 sky130_fd_sc_hd__fill_1
XFILLER_6_115 vssd1 vssd1 vccd1 vccd1 sky130_fd_sc_hd__fill_1
XFILLER_10_177 vssd1 vssd1 vccd1 vccd1 sky130_fd_sc_hd__fill_4
XANTENNA__2942__A1 _2966_/A1 vssd1 vssd1 vccd1 vccd1 sky130_fd_sc_hd__diode_2
XANTENNA__2942__B2 _2942_/B2 vssd1 vssd1 vccd1 vccd1 sky130_fd_sc_hd__diode_2
XANTENNA_clkbuf_leaf_8_clk_A clkload2/A vssd1 vssd1 vccd1 vccd1 sky130_fd_sc_hd__diode_2
XFILLER_65_339 vssd1 vssd1 vccd1 vccd1 sky130_fd_sc_hd__fill_1
XANTENNA__3402__Q _3402_/Q vssd1 vssd1 vccd1 vccd1 sky130_fd_sc_hd__diode_2
XFILLER_33_214 vssd1 vssd1 vccd1 vccd1 sky130_fd_sc_hd__fill_1
X_1960_ _1939_/A _1939_/C _1939_/B vssd1 vssd1 vccd1 vccd1 _1966_/A sky130_fd_sc_hd__a21boi_2
X_1891_ _1933_/A _1931_/B _1890_/A vssd1 vssd1 vccd1 vccd1 _1895_/B sky130_fd_sc_hd__a21o_2
XTAP_TAPCELL_ROW_31_437 vssd1 vccd1 sky130_fd_sc_hd__tapvpwrvgnd_1
X_2512_ _3186_/Q _2901_/A2 _2901_/B1 _3168_/Q _2511_/X vssd1 vssd1 vccd1 vccd1 _2512_/X
+ sky130_fd_sc_hd__a221o_2
XFILLER_52_3 vssd1 vssd1 vccd1 vccd1 sky130_fd_sc_hd__fill_8
XFILLER_5_181 vssd1 vssd1 vccd1 vccd1 sky130_fd_sc_hd__fill_4
X_2443_ _2781_/B _2443_/B vssd1 vssd1 vccd1 vccd1 _2443_/X sky130_fd_sc_hd__and2_2
X_2374_ hold389/X _2373_/X _2374_/S vssd1 vssd1 vccd1 vccd1 _3082_/D sky130_fd_sc_hd__mux2_1
XFILLER_68_155 vssd1 vssd1 vccd1 vccd1 sky130_fd_sc_hd__fill_1
XTAP_TAPCELL_ROW_39_504 vssd1 vccd1 sky130_fd_sc_hd__tapvpwrvgnd_1
XFILLER_68_188 vssd1 vssd1 vccd1 vccd1 sky130_fd_sc_hd__fill_1
XFILLER_49_391 vssd1 vssd1 vccd1 vccd1 sky130_fd_sc_hd__fill_1
XANTENNA__2854__S _2856_/S vssd1 vssd1 vccd1 vccd1 sky130_fd_sc_hd__diode_2
XFILLER_71_309 vssd1 vssd1 vccd1 vccd1 sky130_fd_sc_hd__fill_1
XFILLER_64_361 vssd1 vssd1 vccd1 vccd1 sky130_fd_sc_hd__fill_1
XFILLER_64_350 vssd1 vssd1 vccd1 vccd1 sky130_fd_sc_hd__fill_1
XTAP_TAPCELL_ROW_47_570 vssd1 vccd1 sky130_fd_sc_hd__tapvpwrvgnd_1
XFILLER_20_475 vssd1 vssd1 vccd1 vccd1 sky130_fd_sc_hd__fill_1
XFILLER_58_25 vssd1 vssd1 vccd1 vccd1 sky130_fd_sc_hd__fill_2
XANTENNA__2049__B _2049_/B vssd1 vssd1 vccd1 vccd1 sky130_fd_sc_hd__diode_2
XANTENNA__2764__S _2780_/S vssd1 vssd1 vccd1 vccd1 sky130_fd_sc_hd__diode_2
XFILLER_74_35 vssd1 vssd1 vccd1 vccd1 sky130_fd_sc_hd__fill_2
XANTENNA__2612__B1 _2646_/B vssd1 vssd1 vccd1 vccd1 sky130_fd_sc_hd__diode_2
XFILLER_11_442 vssd1 vssd1 vccd1 vccd1 sky130_fd_sc_hd__fill_4
XFILLER_11_431 vssd1 vssd1 vccd1 vccd1 sky130_fd_sc_hd__fill_2
XFILLER_7_402 vssd1 vccd1 vssd1 vccd1 sky130_ef_sc_hd__decap_40_12
XFILLER_7_468 vssd1 vssd1 vccd1 vccd1 sky130_fd_sc_hd__fill_1
XFILLER_78_486 vssd1 vssd1 vccd1 vccd1 sky130_fd_sc_hd__fill_1
XFILLER_38_317 vssd1 vssd1 vccd1 vccd1 sky130_fd_sc_hd__fill_1
X_2090_ _2089_/A _2089_/B _2089_/C _2093_/C vssd1 vssd1 vccd1 vccd1 _2090_/X sky130_fd_sc_hd__a22o_2
XANTENNA__2674__S _2685_/S vssd1 vssd1 vccd1 vccd1 sky130_fd_sc_hd__diode_2
XFILLER_65_169 vssd1 vssd1 vccd1 vccd1 sky130_fd_sc_hd__fill_1
XFILLER_46_394 vssd1 vssd1 vccd1 vccd1 sky130_fd_sc_hd__fill_4
XFILLER_0_76 vssd1 vssd1 vccd1 vccd1 sky130_fd_sc_hd__fill_8
X_2992_ _2995_/A vssd1 vssd1 vccd1 vccd1 _2992_/Y sky130_fd_sc_hd__inv_2
X_1943_ _1943_/A _1943_/B vssd1 vssd1 vccd1 vccd1 _1949_/A sky130_fd_sc_hd__or2_2
X_1874_ _1873_/A _1873_/B _1873_/C vssd1 vssd1 vccd1 vccd1 _1876_/B sky130_fd_sc_hd__a21o_2
XANTENNA__2906__A1 _2973_/A1 vssd1 vssd1 vccd1 vccd1 sky130_fd_sc_hd__diode_2
XANTENNA__1753__S _1773_/S vssd1 vssd1 vccd1 vccd1 sky130_fd_sc_hd__diode_2
XANTENNA__2849__S _2852_/S vssd1 vssd1 vccd1 vccd1 sky130_fd_sc_hd__diode_2
X_2426_ _2426_/A _2594_/A _2426_/C vssd1 vssd1 vccd1 vccd1 _2426_/X sky130_fd_sc_hd__or3_2
X_2357_ _2357_/A _2357_/B vssd1 vssd1 vccd1 vccd1 _2358_/B sky130_fd_sc_hd__or2_2
XFILLER_28_39 vssd1 vssd1 vccd1 vccd1 sky130_fd_sc_hd__fill_2
X_2288_ _2288_/A _2288_/B vssd1 vssd1 vccd1 vccd1 _2289_/B sky130_fd_sc_hd__xnor2_2
XFILLER_44_309 vssd1 vssd1 vccd1 vccd1 sky130_fd_sc_hd__fill_1
XFILLER_44_27 vssd1 vssd1 vccd1 vccd1 sky130_fd_sc_hd__fill_1
XTAP_TAPCELL_ROW_50_598 vssd1 vccd1 sky130_fd_sc_hd__tapvpwrvgnd_1
XFILLER_4_449 vssd1 vssd1 vccd1 vccd1 sky130_fd_sc_hd__fill_4
XANTENNA__2759__S _2761_/S vssd1 vssd1 vccd1 vccd1 sky130_fd_sc_hd__diode_2
XFILLER_69_57 vssd1 vssd1 vccd1 vccd1 sky130_fd_sc_hd__fill_8
XTAP_TAPCELL_ROW_7_232 vssd1 vccd1 sky130_fd_sc_hd__tapvpwrvgnd_1
XANTENNA__2125__A2 _2352_/C vssd1 vssd1 vccd1 vccd1 sky130_fd_sc_hd__diode_2
XPHY_EDGE_ROW_8_Left_88 vssd1 vssd1 vccd1 vccd1 sky130_fd_sc_hd__decap_3
XANTENNA_fanout62_X _2646_/B vssd1 vssd1 vccd1 vccd1 sky130_fd_sc_hd__diode_2
XFILLER_75_423 vssd1 vssd1 vccd1 vccd1 sky130_fd_sc_hd__fill_1
XANTENNA__1899__A _2025_/A vssd1 vssd1 vccd1 vccd1 sky130_fd_sc_hd__diode_2
XTAP_TAPCELL_ROW_58_665 vssd1 vccd1 sky130_fd_sc_hd__tapvpwrvgnd_1
XFILLER_47_158 vssd1 vssd1 vccd1 vccd1 sky130_fd_sc_hd__fill_8
XTAP_TAPCELL_ROW_41_521 vssd1 vccd1 sky130_fd_sc_hd__tapvpwrvgnd_1
XFILLER_11_283 vssd1 vssd1 vccd1 vccd1 sky130_fd_sc_hd__fill_1
XANTENNA__1784__D _1970_/B vssd1 vssd1 vccd1 vccd1 sky130_fd_sc_hd__diode_2
X_1590_ _3144_/Q _1568_/Y _1584_/A vssd1 vssd1 vccd1 vccd1 _1590_/Y sky130_fd_sc_hd__a21oi_2
XFILLER_7_287 vssd1 vssd1 vccd1 vccd1 sky130_fd_sc_hd__fill_2
XANTENNA__2669__S _2681_/S vssd1 vssd1 vccd1 vccd1 sky130_fd_sc_hd__diode_2
X_3260_ _3383_/CLK _3260_/D fanout272/X vssd1 vssd1 vccd1 vccd1 _3260_/Q sky130_fd_sc_hd__dfrtp_2
X_3191_ _3394_/CLK _3191_/D fanout275/X vssd1 vssd1 vccd1 vccd1 _3191_/Q sky130_fd_sc_hd__dfrtp_2
X_2211_ _2211_/A _2252_/A _2250_/B vssd1 vssd1 vccd1 vccd1 _2216_/A sky130_fd_sc_hd__nand3_2
X_2142_ _2140_/Y _2142_/B vssd1 vssd1 vccd1 vccd1 _2143_/B sky130_fd_sc_hd__and2b_2
XFILLER_66_445 vssd1 vssd1 vccd1 vccd1 sky130_fd_sc_hd__fill_2
XFILLER_15_3 vssd1 vssd1 vccd1 vccd1 sky130_fd_sc_hd__fill_1
X_2073_ _2073_/A _2073_/B _2073_/C _3029_/Q vssd1 vssd1 vccd1 vccd1 _2093_/B sky130_fd_sc_hd__nand4_2
XFILLER_26_309 vssd1 vssd1 vccd1 vccd1 sky130_fd_sc_hd__fill_1
XFILLER_46_191 vssd1 vssd1 vccd1 vccd1 sky130_fd_sc_hd__fill_4
XFILLER_61_150 vssd1 vssd1 vccd1 vccd1 sky130_fd_sc_hd__fill_1
XANTENNA__1748__S _3435_/D vssd1 vssd1 vccd1 vccd1 sky130_fd_sc_hd__diode_2
X_2975_ _3399_/Q hold576/X _3408_/Q vssd1 vssd1 vccd1 vccd1 _2975_/X sky130_fd_sc_hd__mux2_1
X_1926_ _1926_/A _1978_/B vssd1 vssd1 vccd1 vccd1 _1926_/Y sky130_fd_sc_hd__xnor2_2
X_1857_ _1892_/A _1893_/A _1892_/B vssd1 vssd1 vccd1 vccd1 _1859_/B sky130_fd_sc_hd__and3_2
XANTENNA_fanout207_A fanout214/X vssd1 vssd1 vccd1 vccd1 sky130_fd_sc_hd__diode_2
Xhold711 _3149_/Q vssd1 vssd1 vccd1 vccd1 hold711/X sky130_fd_sc_hd__dlygate4sd3_1
Xhold700 _3071_/Q vssd1 vssd1 vccd1 vccd1 hold700/X sky130_fd_sc_hd__dlygate4sd3_1
Xhold733 _3054_/Q vssd1 vssd1 vccd1 vccd1 hold733/X sky130_fd_sc_hd__dlygate4sd3_1
Xhold722 _3019_/Q vssd1 vssd1 vccd1 vccd1 hold722/X sky130_fd_sc_hd__dlygate4sd3_1
X_1788_ _1787_/A _1787_/B _1993_/S vssd1 vssd1 vccd1 vccd1 _1788_/Y sky130_fd_sc_hd__o21ai_2
XANTENNA_clkbuf_leaf_33_clk_A clkbuf_3_4__f_clk/X vssd1 vssd1 vccd1 vccd1 sky130_fd_sc_hd__diode_2
X_3458_ _3463_/CLK _3458_/D load_slew237/X vssd1 vssd1 vccd1 vccd1 _3458_/Q sky130_fd_sc_hd__dfrtp_2
XFILLER_39_38 vssd1 vssd1 vccd1 vccd1 sky130_fd_sc_hd__fill_4
X_3389_ _3389_/CLK _3389_/D fanout279/X vssd1 vssd1 vccd1 vccd1 _3389_/Q sky130_fd_sc_hd__dfrtp_2
X_2409_ _2390_/X _2394_/A _2393_/B _2410_/B vssd1 vssd1 vccd1 vccd1 _2409_/X sky130_fd_sc_hd__o211a_2
XTAP_TAPCELL_ROW_4_202 vssd1 vccd1 sky130_fd_sc_hd__tapvpwrvgnd_1
XANTENNA__1866__A1 _1947_/A vssd1 vssd1 vccd1 vccd1 sky130_fd_sc_hd__diode_2
XFILLER_29_169 vssd1 vssd1 vccd1 vccd1 sky130_fd_sc_hd__fill_4
XFILLER_72_437 vssd1 vssd1 vccd1 vccd1 sky130_fd_sc_hd__fill_1
XFILLER_55_59 vssd1 vssd1 vccd1 vccd1 sky130_fd_sc_hd__fill_1
XFILLER_25_320 vssd1 vssd1 vccd1 vccd1 sky130_fd_sc_hd__fill_2
XFILLER_52_183 vssd1 vssd1 vccd1 vccd1 sky130_fd_sc_hd__fill_8
XFILLER_40_323 vssd1 vssd1 vccd1 vccd1 sky130_fd_sc_hd__fill_4
XTAP_TAPCELL_ROW_10_259 vssd1 vccd1 sky130_fd_sc_hd__tapvpwrvgnd_1
XFILLER_4_213 vssd1 vssd1 vccd1 vccd1 sky130_fd_sc_hd__fill_8
XFILLER_48_401 vssd1 vssd1 vccd1 vccd1 sky130_fd_sc_hd__fill_1
XFILLER_48_434 vssd1 vssd1 vccd1 vccd1 sky130_fd_sc_hd__fill_1
XFILLER_35_128 vssd1 vssd1 vccd1 vccd1 sky130_fd_sc_hd__fill_4
XTAP_TAPCELL_ROW_18_326 vssd1 vccd1 sky130_fd_sc_hd__tapvpwrvgnd_1
XFILLER_16_331 vssd1 vssd1 vccd1 vccd1 sky130_fd_sc_hd__fill_1
XFILLER_16_320 vssd1 vssd1 vccd1 vccd1 sky130_fd_sc_hd__fill_1
XTAP_TAPCELL_ROW_26_392 vssd1 vccd1 sky130_fd_sc_hd__tapvpwrvgnd_1
X_2760_ hold620/X _2817_/A1 _2761_/S vssd1 vssd1 vccd1 vccd1 _3269_/D sky130_fd_sc_hd__mux2_1
X_2691_ hold428/X _2805_/A1 _2704_/S vssd1 vssd1 vccd1 vccd1 _3203_/D sky130_fd_sc_hd__mux2_1
X_1711_ _1711_/A _1711_/B vssd1 vssd1 vccd1 vccd1 _1713_/A sky130_fd_sc_hd__nand2_2
XFILLER_61_91 vssd1 vccd1 vssd1 vccd1 sky130_ef_sc_hd__decap_40_12
XANTENNA__2540__X _2540_/X vssd1 vssd1 vccd1 vccd1 sky130_fd_sc_hd__diode_2
X_1642_ _3073_/Q _3056_/Q vssd1 vssd1 vccd1 vccd1 _1642_/Y sky130_fd_sc_hd__nor2_2
XFILLER_6_42 vssd1 vssd1 vccd1 vccd1 sky130_fd_sc_hd__fill_1
X_1573_ _3410_/Q _3411_/Q _3412_/Q _3414_/Q vssd1 vssd1 vccd1 vccd1 _1573_/Y sky130_fd_sc_hd__nor4_2
X_3312_ clkload8/A _3312_/D fanout213/X vssd1 vssd1 vccd1 vccd1 _3312_/Q sky130_fd_sc_hd__dfrtp_2
X_3243_ _3389_/CLK _3243_/D load_slew278/X vssd1 vssd1 vccd1 vccd1 _3243_/Q sky130_fd_sc_hd__dfrtp_2
XFILLER_39_401 vssd1 vssd1 vccd1 vccd1 sky130_fd_sc_hd__fill_1
X_3174_ _3392_/CLK _3174_/D fanout252/X vssd1 vssd1 vccd1 vccd1 _3174_/Q sky130_fd_sc_hd__dfrtp_2
XFILLER_66_253 vssd1 vssd1 vccd1 vccd1 sky130_fd_sc_hd__fill_4
X_2125_ _2124_/A _2352_/C _2146_/A _2124_/B vssd1 vssd1 vccd1 vccd1 _2126_/C sky130_fd_sc_hd__a22o_2
X_2056_ _2056_/A _2056_/B vssd1 vssd1 vccd1 vccd1 _2059_/A sky130_fd_sc_hd__xnor2_2
XANTENNA__2862__S _2864_/S vssd1 vssd1 vccd1 vccd1 sky130_fd_sc_hd__diode_2
XTAP_TAPCELL_ROW_52_616 vssd1 vccd1 sky130_fd_sc_hd__tapvpwrvgnd_1
XFILLER_25_29 vssd1 vssd1 vccd1 vccd1 sky130_fd_sc_hd__fill_2
X_2958_ _3341_/Q _2960_/A2 wire66/X _3323_/Q _2957_/X vssd1 vssd1 vccd1 vccd1 _2958_/X
+ sky130_fd_sc_hd__a221o_2
XTAP_TAPCELL_ROW_60_682 vssd1 vccd1 sky130_fd_sc_hd__tapvpwrvgnd_1
XFILLER_41_17 vssd1 vssd1 vccd1 vccd1 sky130_fd_sc_hd__fill_4
X_1909_ _1907_/X _1909_/B vssd1 vssd1 vccd1 vccd1 _1912_/B sky130_fd_sc_hd__nand2b_2
XANTENNA_fanout112_X _2966_/A1 vssd1 vssd1 vccd1 vccd1 sky130_fd_sc_hd__diode_2
X_2889_ _2926_/B _2926_/C _3281_/Q vssd1 vssd1 vccd1 vccd1 _2889_/X sky130_fd_sc_hd__and3_2
Xhold530 _3179_/Q vssd1 vssd1 vccd1 vccd1 hold530/X sky130_fd_sc_hd__dlygate4sd3_1
XANTENNA__2610__B _2646_/B vssd1 vssd1 vccd1 vccd1 sky130_fd_sc_hd__diode_2
Xhold563 _3340_/Q vssd1 vssd1 vccd1 vccd1 hold563/X sky130_fd_sc_hd__dlygate4sd3_1
Xhold552 _3331_/Q vssd1 vssd1 vccd1 vccd1 hold552/X sky130_fd_sc_hd__dlygate4sd3_1
Xhold541 _3320_/Q vssd1 vssd1 vccd1 vccd1 hold541/X sky130_fd_sc_hd__dlygate4sd3_1
Xhold596 _3154_/Q vssd1 vssd1 vccd1 vccd1 hold596/X sky130_fd_sc_hd__dlygate4sd3_1
Xhold585 _3172_/Q vssd1 vssd1 vccd1 vccd1 hold585/X sky130_fd_sc_hd__dlygate4sd3_1
Xhold574 _3231_/Q vssd1 vssd1 vccd1 vccd1 hold574/X sky130_fd_sc_hd__dlygate4sd3_1
XFILLER_49_209 vssd1 vssd1 vccd1 vccd1 sky130_fd_sc_hd__fill_2
XANTENNA__2772__S _2776_/S vssd1 vssd1 vccd1 vccd1 sky130_fd_sc_hd__diode_2
XFILLER_13_334 vssd1 vssd1 vccd1 vccd1 sky130_fd_sc_hd__fill_2
XANTENNA_fanout25_X _2723_/S vssd1 vssd1 vccd1 vccd1 sky130_fd_sc_hd__diode_2
XANTENNA__2567__A2 _2528_/X vssd1 vssd1 vccd1 vccd1 sky130_fd_sc_hd__diode_2
XANTENNA__3405__Q _3405_/Q vssd1 vssd1 vccd1 vccd1 sky130_fd_sc_hd__diode_2
XFILLER_0_271 vssd1 vssd1 vccd1 vccd1 sky130_fd_sc_hd__fill_1
XFILLER_48_231 vssd1 vssd1 vccd1 vccd1 sky130_fd_sc_hd__fill_1
XFILLER_63_223 vssd1 vssd1 vccd1 vccd1 sky130_fd_sc_hd__fill_1
XFILLER_48_297 vssd1 vssd1 vccd1 vccd1 sky130_fd_sc_hd__fill_8
XFILLER_36_437 vssd1 vssd1 vccd1 vccd1 sky130_fd_sc_hd__fill_1
XANTENNA__2682__S _2685_/S vssd1 vssd1 vccd1 vccd1 sky130_fd_sc_hd__diode_2
X_2812_ hold498/X _2850_/A1 _2818_/S vssd1 vssd1 vccd1 vccd1 _3318_/D sky130_fd_sc_hd__mux2_1
X_2743_ _2819_/B _2762_/B _2800_/C vssd1 vssd1 vccd1 vccd1 _2743_/X sky130_fd_sc_hd__and3_2
XANTENNA__1766__A0 _2154_/B vssd1 vssd1 vccd1 vccd1 sky130_fd_sc_hd__diode_2
X_2674_ hold566/X _2845_/A1 _2685_/S vssd1 vssd1 vccd1 vccd1 _3187_/D sky130_fd_sc_hd__mux2_1
XANTENNA__2430__B _2957_/C vssd1 vssd1 vccd1 vccd1 sky130_fd_sc_hd__diode_2
X_1625_ _1625_/A _1625_/B vssd1 vssd1 vccd1 vccd1 _1625_/Y sky130_fd_sc_hd__nand2_2
X_1556_ _1556_/A _3436_/Q vssd1 vssd1 vccd1 vccd1 _3418_/D sky130_fd_sc_hd__and2_2
XANTENNA__2857__S _3437_/D vssd1 vssd1 vccd1 vccd1 sky130_fd_sc_hd__diode_2
X_3226_ _3352_/CLK _3226_/D load_slew253/X vssd1 vssd1 vccd1 vccd1 _3226_/Q sky130_fd_sc_hd__dfrtp_2
XANTENNA_fanout274_A fanout279/X vssd1 vssd1 vccd1 vccd1 sky130_fd_sc_hd__diode_2
X_3157_ _3392_/CLK _3157_/D load_slew240/X vssd1 vssd1 vccd1 vccd1 _3157_/Q sky130_fd_sc_hd__dfrtp_2
XFILLER_27_426 vssd1 vssd1 vccd1 vccd1 sky130_fd_sc_hd__fill_1
X_2108_ _2107_/A _2107_/B _2374_/S vssd1 vssd1 vccd1 vccd1 _2108_/Y sky130_fd_sc_hd__o21ai_2
X_3088_ _3436_/CLK _3088_/D load_slew227/X vssd1 vssd1 vccd1 vccd1 _3088_/Q sky130_fd_sc_hd__dfrtp_2
XFILLER_14_109 vssd1 vccd1 vssd1 vccd1 sky130_ef_sc_hd__decap_40_12
X_2039_ _2040_/A _2040_/B vssd1 vssd1 vccd1 vccd1 _2067_/A sky130_fd_sc_hd__nand2_2
XTAP_TAPCELL_ROW_37_487 vssd1 vccd1 sky130_fd_sc_hd__tapvpwrvgnd_1
XFILLER_52_27 vssd1 vssd1 vccd1 vccd1 sky130_fd_sc_hd__fill_1
XFILLER_50_473 vssd1 vssd1 vccd1 vccd1 sky130_fd_sc_hd__fill_1
XANTENNA__2324__C _2352_/B vssd1 vssd1 vccd1 vccd1 sky130_fd_sc_hd__diode_2
XANTENNA__2549__A2 _2528_/X vssd1 vssd1 vccd1 vccd1 sky130_fd_sc_hd__diode_2
XFILLER_22_197 vssd1 vssd1 vccd1 vccd1 sky130_fd_sc_hd__fill_1
XANTENNA__1757__A0 _2399_/B vssd1 vssd1 vccd1 vccd1 sky130_fd_sc_hd__diode_2
XTAP_TAPCELL_ROW_20_343 vssd1 vccd1 sky130_fd_sc_hd__tapvpwrvgnd_1
Xhold371 _3415_/Q vssd1 vssd1 vccd1 vccd1 _3409_/D sky130_fd_sc_hd__dlygate4sd3_1
XANTENNA__2767__S _2780_/S vssd1 vssd1 vccd1 vccd1 sky130_fd_sc_hd__diode_2
Xhold382 _2982_/X vssd1 vssd1 vccd1 vccd1 _3406_/D sky130_fd_sc_hd__dlygate4sd3_1
Xhold393 _2980_/X vssd1 vssd1 vccd1 vccd1 _3404_/D sky130_fd_sc_hd__dlygate4sd3_1
XFILLER_77_35 vssd1 vssd1 vccd1 vccd1 sky130_fd_sc_hd__fill_4
XANTENNA__2485__A1 _2962_/A1 vssd1 vssd1 vccd1 vccd1 sky130_fd_sc_hd__diode_2
XANTENNA__2485__B2 _2961_/A1 vssd1 vssd1 vccd1 vccd1 sky130_fd_sc_hd__diode_2
XTAP_TAPCELL_ROW_28_410 vssd1 vccd1 sky130_fd_sc_hd__tapvpwrvgnd_1
XFILLER_33_418 vssd1 vssd1 vccd1 vccd1 sky130_fd_sc_hd__fill_1
XFILLER_26_72 vssd1 vssd1 vccd1 vccd1 sky130_fd_sc_hd__fill_2
XTAP_TAPCELL_ROW_71_777 vssd1 vccd1 sky130_fd_sc_hd__tapvpwrvgnd_1
XFILLER_9_113 vssd1 vccd1 vssd1 vccd1 sky130_ef_sc_hd__decap_40_12
XFILLER_9_135 vssd1 vccd1 vssd1 vccd1 sky130_ef_sc_hd__decap_40_12
XANTENNA__1748__A0 _2073_/C vssd1 vssd1 vccd1 vccd1 sky130_fd_sc_hd__diode_2
XFILLER_42_93 vssd1 vssd1 vccd1 vccd1 sky130_fd_sc_hd__fill_4
XANTENNA__2960__A2 _2960_/A2 vssd1 vssd1 vccd1 vccd1 sky130_fd_sc_hd__diode_2
XFILLER_5_341 vssd1 vssd1 vccd1 vccd1 sky130_fd_sc_hd__fill_1
XANTENNA__2677__S _2681_/S vssd1 vssd1 vccd1 vccd1 sky130_fd_sc_hd__diode_2
X_2390_ _2392_/A _2392_/B vssd1 vssd1 vccd1 vccd1 _2390_/X sky130_fd_sc_hd__and2_2
XTAP_TAPCELL_ROW_79_855 vssd1 vccd1 sky130_fd_sc_hd__tapvpwrvgnd_1
XTAP_TAPCELL_ROW_79_844 vssd1 vccd1 sky130_fd_sc_hd__tapvpwrvgnd_1
X_3011_ _3132_/CLK _3011_/D load_slew220/X vssd1 vssd1 vccd1 vccd1 _3011_/Q sky130_fd_sc_hd__dfrtp_2
XTAP_TAPCELL_ROW_62_700 vssd1 vccd1 sky130_fd_sc_hd__tapvpwrvgnd_1
XANTENNA__1967__D _2004_/B vssd1 vssd1 vccd1 vccd1 sky130_fd_sc_hd__diode_2
XTAP_TAPCELL_ROW_34_457 vssd1 vccd1 sky130_fd_sc_hd__tapvpwrvgnd_1
XANTENNA__1756__S _1773_/S vssd1 vssd1 vccd1 vccd1 sky130_fd_sc_hd__diode_2
X_2726_ hold504/X _2802_/A1 _2742_/S vssd1 vssd1 vccd1 vccd1 _3236_/D sky130_fd_sc_hd__mux2_1
X_2657_ hold536/X _2809_/A1 _2662_/S vssd1 vssd1 vccd1 vccd1 _3171_/D sky130_fd_sc_hd__mux2_1
X_1608_ _3429_/Q _3427_/Q _3428_/Q _3425_/Q vssd1 vssd1 vccd1 vccd1 _1608_/X sky130_fd_sc_hd__or4_2
Xfanout103 _1608_/X vssd1 vssd1 vccd1 vccd1 _2540_/A sky130_fd_sc_hd__clkdlybuf4s25_1
X_2588_ _2588_/A _3418_/Q _2588_/C vssd1 vssd1 vccd1 vccd1 _2594_/B sky130_fd_sc_hd__or3_2
Xfanout114 _2972_/A1 vssd1 vssd1 vccd1 vccd1 _2686_/A sky130_fd_sc_hd__clkdlybuf4s25_1
Xfanout125 _2959_/C vssd1 vssd1 vccd1 vccd1 _2957_/C sky130_fd_sc_hd__clkdlybuf4s25_1
Xfanout136 _3088_/Q vssd1 vssd1 vccd1 vccd1 _2900_/A sky130_fd_sc_hd__clkdlybuf4s25_1
Xfanout147 _3050_/Q vssd1 vssd1 vccd1 vccd1 _2352_/C sky130_fd_sc_hd__clkdlybuf4s25_1
X_1539_ _3383_/Q _3455_/Q _1546_/S vssd1 vssd1 vccd1 vccd1 _3456_/D sky130_fd_sc_hd__mux2_1
Xfanout158 _2002_/B vssd1 vssd1 vccd1 vccd1 _2073_/B sky130_fd_sc_hd__clkdlybuf4s25_1
Xfanout169 _3039_/Q vssd1 vssd1 vccd1 vccd1 _1813_/A sky130_fd_sc_hd__clkdlybuf4s25_1
X_3209_ _3394_/CLK _3209_/D fanout275/X vssd1 vssd1 vccd1 vccd1 _3209_/Q sky130_fd_sc_hd__dfrtp_2
XFILLER_74_307 vssd1 vssd1 vccd1 vccd1 sky130_fd_sc_hd__fill_1
XFILLER_63_15 vssd1 vssd1 vccd1 vccd1 sky130_fd_sc_hd__fill_1
XANTENNA__2351__A _2352_/B vssd1 vssd1 vccd1 vccd1 sky130_fd_sc_hd__diode_2
XANTENNA__2070__B _2091_/B vssd1 vssd1 vccd1 vccd1 sky130_fd_sc_hd__diode_2
XFILLER_12_85 vssd1 vssd1 vccd1 vccd1 sky130_fd_sc_hd__fill_4
XTAP_TAPCELL_ROW_76_814 vssd1 vccd1 sky130_fd_sc_hd__tapvpwrvgnd_1
XPHY_EDGE_ROW_16_Right_16 vssd1 vssd1 vccd1 vccd1 sky130_fd_sc_hd__decap_3
X_1890_ _1890_/A _1933_/A _1931_/B vssd1 vssd1 vccd1 vccd1 _1895_/A sky130_fd_sc_hd__nand3_2
XTAP_TAPCELL_ROW_31_438 vssd1 vccd1 sky130_fd_sc_hd__tapvpwrvgnd_1
XFILLER_41_281 vssd1 vssd1 vccd1 vccd1 sky130_fd_sc_hd__fill_1
XANTENNA__2918__C1 _1585_/A vssd1 vssd1 vccd1 vccd1 sky130_fd_sc_hd__diode_2
XPHY_EDGE_ROW_25_Right_25 vssd1 vssd1 vccd1 vccd1 sky130_fd_sc_hd__decap_3
X_2511_ _2959_/B _2957_/C _3204_/Q vssd1 vssd1 vccd1 vccd1 _2511_/X sky130_fd_sc_hd__and3_2
X_2442_ _2611_/A _3145_/Q _3289_/Q _2800_/A vssd1 vssd1 vccd1 vccd1 _2443_/B sky130_fd_sc_hd__a22o_2
XFILLER_5_193 vssd1 vssd1 vccd1 vccd1 sky130_fd_sc_hd__fill_4
XFILLER_45_3 vssd1 vssd1 vccd1 vccd1 sky130_fd_sc_hd__fill_8
X_2373_ _2373_/A _2373_/B vssd1 vssd1 vccd1 vccd1 _2373_/X sky130_fd_sc_hd__xor2_2
XTAP_TAPCELL_ROW_39_505 vssd1 vccd1 sky130_fd_sc_hd__tapvpwrvgnd_1
XFILLER_56_307 vssd1 vssd1 vccd1 vccd1 sky130_fd_sc_hd__fill_1
XPHY_EDGE_ROW_34_Right_34 vssd1 vssd1 vccd1 vccd1 sky130_fd_sc_hd__decap_3
XTAP_TAPCELL_ROW_47_571 vssd1 vccd1 sky130_fd_sc_hd__tapvpwrvgnd_1
XPHY_EDGE_ROW_43_Right_43 vssd1 vssd1 vccd1 vccd1 sky130_fd_sc_hd__decap_3
X_2709_ hold478/X _2842_/A1 _2719_/S vssd1 vssd1 vccd1 vccd1 _3220_/D sky130_fd_sc_hd__mux2_1
XPHY_EDGE_ROW_52_Right_52 vssd1 vssd1 vccd1 vccd1 sky130_fd_sc_hd__decap_3
XFILLER_59_167 vssd1 vssd1 vccd1 vccd1 sky130_fd_sc_hd__fill_1
XFILLER_74_137 vssd1 vssd1 vccd1 vccd1 sky130_fd_sc_hd__fill_2
XANTENNA__1663__A2 _1690_/S vssd1 vssd1 vccd1 vccd1 sky130_fd_sc_hd__diode_2
XTAP_TAPCELL_ROW_2_185 vssd1 vccd1 sky130_fd_sc_hd__tapvpwrvgnd_1
XFILLER_70_354 vssd1 vssd1 vccd1 vccd1 sky130_fd_sc_hd__fill_2
XANTENNA__2780__S _2780_/S vssd1 vssd1 vccd1 vccd1 sky130_fd_sc_hd__diode_2
XPHY_EDGE_ROW_61_Right_61 vssd1 vssd1 vccd1 vccd1 sky130_fd_sc_hd__decap_3
XFILLER_7_414 vssd1 vssd1 vccd1 vccd1 sky130_fd_sc_hd__fill_8
XFILLER_23_40 vssd1 vssd1 vccd1 vccd1 sky130_fd_sc_hd__fill_8
XFILLER_7_447 vssd1 vssd1 vccd1 vccd1 sky130_fd_sc_hd__fill_1
XPHY_EDGE_ROW_70_Right_70 vssd1 vssd1 vccd1 vccd1 sky130_fd_sc_hd__decap_3
XFILLER_17_7 vssd1 vssd1 vccd1 vccd1 sky130_fd_sc_hd__fill_2
XFILLER_65_148 vssd1 vssd1 vccd1 vccd1 sky130_fd_sc_hd__fill_2
XFILLER_0_44 vssd1 vssd1 vccd1 vccd1 sky130_fd_sc_hd__fill_1
XFILLER_73_181 vssd1 vssd1 vccd1 vccd1 sky130_fd_sc_hd__fill_2
XFILLER_64_91 vssd1 vssd1 vccd1 vccd1 sky130_fd_sc_hd__fill_1
XANTENNA__2690__S _2700_/S vssd1 vssd1 vccd1 vccd1 sky130_fd_sc_hd__diode_2
X_2991_ _3003_/A vssd1 vssd1 vccd1 vccd1 _2991_/Y sky130_fd_sc_hd__inv_2
XFILLER_9_20 vssd1 vssd1 vccd1 vccd1 sky130_fd_sc_hd__fill_2
X_1942_ _1942_/A _1942_/B _1942_/C vssd1 vssd1 vccd1 vccd1 _1943_/B sky130_fd_sc_hd__and3_2
X_1873_ _1873_/A _1873_/B _1873_/C vssd1 vssd1 vccd1 vccd1 _1876_/A sky130_fd_sc_hd__nand3_2
X_2425_ _2588_/A _2440_/A _1630_/C _3422_/Q vssd1 vssd1 vccd1 vccd1 _2427_/C sky130_fd_sc_hd__a211o_2
X_2356_ _2357_/A _2357_/B vssd1 vssd1 vccd1 vccd1 _2356_/X sky130_fd_sc_hd__and2_2
XANTENNA_fanout187_A _2073_/C vssd1 vssd1 vccd1 vccd1 sky130_fd_sc_hd__diode_2
X_2287_ _2285_/X _2287_/B vssd1 vssd1 vccd1 vccd1 _2288_/B sky130_fd_sc_hd__and2b_2
XFILLER_64_181 vssd1 vssd1 vccd1 vccd1 sky130_fd_sc_hd__fill_2
XFILLER_52_321 vssd1 vssd1 vccd1 vccd1 sky130_fd_sc_hd__fill_1
XANTENNA__2453__X _2453_/X vssd1 vssd1 vccd1 vccd1 sky130_fd_sc_hd__diode_2
XANTENNA_clkbuf_leaf_7_clk_A clkload1/A vssd1 vssd1 vccd1 vccd1 sky130_fd_sc_hd__diode_2
XTAP_TAPCELL_ROW_50_599 vssd1 vccd1 sky130_fd_sc_hd__tapvpwrvgnd_1
Xclkbuf_3_0__f_clk clkbuf_0_clk/X vssd1 vssd1 vccd1 vccd1 clkbuf_leaf_2_clk/A sky130_fd_sc_hd__clkbuf_16
XFILLER_4_417 vssd1 vssd1 vccd1 vccd1 sky130_fd_sc_hd__fill_2
XTAP_TAPCELL_ROW_7_233 vssd1 vccd1 sky130_fd_sc_hd__tapvpwrvgnd_1
XANTENNA__2775__S _2776_/S vssd1 vssd1 vccd1 vccd1 sky130_fd_sc_hd__diode_2
XANTENNA__1899__B _2004_/B vssd1 vssd1 vccd1 vccd1 sky130_fd_sc_hd__diode_2
XTAP_TAPCELL_ROW_58_666 vssd1 vccd1 sky130_fd_sc_hd__tapvpwrvgnd_1
XANTENNA__2833__A1 _2638_/X vssd1 vssd1 vccd1 vccd1 sky130_fd_sc_hd__diode_2
XTAP_TAPCELL_ROW_41_522 vssd1 vccd1 sky130_fd_sc_hd__tapvpwrvgnd_1
XTAP_TAPCELL_ROW_13_279 vssd1 vccd1 sky130_fd_sc_hd__tapvpwrvgnd_1
XFILLER_50_93 vssd1 vssd1 vccd1 vccd1 sky130_fd_sc_hd__fill_1
X_2210_ _2206_/X _2207_/Y _2208_/X _2190_/B vssd1 vssd1 vccd1 vccd1 _2250_/B sky130_fd_sc_hd__o211ai_2
XFILLER_3_483 vssd1 vssd1 vccd1 vccd1 sky130_fd_sc_hd__fill_8
X_3190_ _3393_/CLK _3190_/D load_slew258/X vssd1 vssd1 vccd1 vccd1 _3190_/Q sky130_fd_sc_hd__dfrtp_2
XFILLER_22_5 vssd1 vssd1 vccd1 vccd1 sky130_fd_sc_hd__fill_1
XANTENNA__2685__S _2685_/S vssd1 vssd1 vccd1 vccd1 sky130_fd_sc_hd__diode_2
X_2141_ _2141_/A _2141_/B vssd1 vssd1 vccd1 vccd1 _2142_/B sky130_fd_sc_hd__nand2_2
X_2072_ _2073_/A _2073_/C _3029_/Q _2073_/B vssd1 vssd1 vccd1 vccd1 _2075_/A sky130_fd_sc_hd__a22o_2
XANTENNA__2824__A1 _2620_/X vssd1 vssd1 vccd1 vccd1 sky130_fd_sc_hd__diode_2
X_2974_ hold437/X _2864_/S _2972_/X _2973_/X vssd1 vssd1 vccd1 vccd1 _3398_/D sky130_fd_sc_hd__o22a_2
XFILLER_34_398 vssd1 vssd1 vccd1 vccd1 sky130_fd_sc_hd__fill_1
X_1925_ _1912_/A _1907_/X _1909_/B vssd1 vssd1 vccd1 vccd1 _1978_/B sky130_fd_sc_hd__o21ai_2
X_1856_ _1856_/A _1890_/A _1856_/C _1856_/D vssd1 vssd1 vccd1 vccd1 _1892_/B sky130_fd_sc_hd__nand4_2
XANTENNA__1764__S _3435_/D vssd1 vssd1 vccd1 vccd1 sky130_fd_sc_hd__diode_2
Xhold712 _3125_/Q vssd1 vssd1 vccd1 vccd1 hold712/X sky130_fd_sc_hd__dlygate4sd3_1
Xhold701 _3067_/Q vssd1 vssd1 vccd1 vccd1 hold701/X sky130_fd_sc_hd__dlygate4sd3_1
X_1787_ _1787_/A _1787_/B vssd1 vssd1 vccd1 vccd1 _1800_/B sky130_fd_sc_hd__and2_2
Xhold734 _3073_/Q vssd1 vssd1 vccd1 vccd1 hold734/X sky130_fd_sc_hd__dlygate4sd3_1
Xhold723 _3137_/Q vssd1 vssd1 vccd1 vccd1 hold723/X sky130_fd_sc_hd__dlygate4sd3_1
X_3457_ _3463_/CLK _3457_/D fanout238/X vssd1 vssd1 vccd1 vccd1 _3457_/Q sky130_fd_sc_hd__dfrtp_2
XFILLER_39_17 vssd1 vssd1 vccd1 vccd1 sky130_fd_sc_hd__fill_1
X_3388_ _3388_/CLK _3388_/D fanout241/X vssd1 vssd1 vccd1 vccd1 _3388_/Q sky130_fd_sc_hd__dfrtp_2
X_2408_ _2406_/A _2406_/B _2406_/C vssd1 vssd1 vccd1 vccd1 _2410_/B sky130_fd_sc_hd__a21o_2
XTAP_TAPCELL_ROW_4_203 vssd1 vccd1 sky130_fd_sc_hd__tapvpwrvgnd_1
XFILLER_69_262 vssd1 vccd1 vssd1 vccd1 sky130_ef_sc_hd__decap_40_12
XANTENNA__2512__B1 _2901_/B1 vssd1 vssd1 vccd1 vccd1 sky130_fd_sc_hd__diode_2
X_2339_ _2339_/A _2339_/B vssd1 vssd1 vccd1 vccd1 _2340_/B sky130_fd_sc_hd__xor2_2
XPHY_EDGE_ROW_2_Right_2 vssd1 vssd1 vccd1 vccd1 sky130_fd_sc_hd__decap_3
XFILLER_57_468 vssd1 vssd1 vccd1 vccd1 sky130_fd_sc_hd__fill_1
XFILLER_29_148 vssd1 vssd1 vccd1 vccd1 sky130_fd_sc_hd__fill_4
XTAP_TAPCELL_ROW_55_636 vssd1 vccd1 sky130_fd_sc_hd__tapvpwrvgnd_1
XANTENNA_fanout15_A _2800_/X vssd1 vssd1 vccd1 vccd1 sky130_fd_sc_hd__diode_2
XFILLER_20_85 vssd1 vccd1 vssd1 vccd1 sky130_ef_sc_hd__decap_40_12
XFILLER_0_453 vssd1 vssd1 vccd1 vccd1 sky130_fd_sc_hd__fill_2
XFILLER_0_442 vssd1 vssd1 vccd1 vccd1 sky130_fd_sc_hd__fill_2
XANTENNA__2503__B1 _2502_/X vssd1 vssd1 vccd1 vccd1 sky130_fd_sc_hd__diode_2
XFILLER_48_413 vssd1 vssd1 vccd1 vccd1 sky130_fd_sc_hd__fill_4
XFILLER_0_475 vssd1 vssd1 vccd1 vccd1 sky130_fd_sc_hd__fill_1
XTAP_TAPCELL_ROW_18_327 vssd1 vccd1 sky130_fd_sc_hd__tapvpwrvgnd_1
XFILLER_43_140 vssd1 vssd1 vccd1 vccd1 sky130_fd_sc_hd__fill_1
XFILLER_16_365 vssd1 vssd1 vccd1 vccd1 sky130_fd_sc_hd__fill_2
XTAP_TAPCELL_ROW_26_393 vssd1 vccd1 sky130_fd_sc_hd__tapvpwrvgnd_1
X_2690_ hold503/X _2842_/A1 _2700_/S vssd1 vssd1 vccd1 vccd1 _3202_/D sky130_fd_sc_hd__mux2_1
X_1710_ _3083_/Q _3066_/Q vssd1 vssd1 vccd1 vccd1 _1711_/B sky130_fd_sc_hd__nand2_2
XPHY_EDGE_ROW_20_Left_100 vssd1 vssd1 vccd1 vccd1 sky130_fd_sc_hd__decap_3
XFILLER_77_6 vssd1 vccd1 vssd1 vccd1 sky130_ef_sc_hd__decap_40_12
X_1641_ hold619/X _1640_/Y _1690_/S vssd1 vssd1 vccd1 vccd1 _3005_/D sky130_fd_sc_hd__mux2_1
XFILLER_6_76 vssd1 vssd1 vccd1 vccd1 sky130_fd_sc_hd__fill_1
X_3311_ _3349_/CLK _3311_/D fanout206/X vssd1 vssd1 vccd1 vccd1 _3311_/Q sky130_fd_sc_hd__dfrtp_2
X_1572_ _3429_/Q _1572_/B vssd1 vssd1 vccd1 vccd1 _3410_/D sky130_fd_sc_hd__and2_2
X_3242_ _3383_/CLK _3242_/D fanout263/X vssd1 vssd1 vccd1 vccd1 _3242_/Q sky130_fd_sc_hd__dfrtp_2
X_3173_ _3394_/CLK _3173_/D fanout275/X vssd1 vssd1 vccd1 vccd1 _3173_/Q sky130_fd_sc_hd__dfrtp_2
XFILLER_66_210 vssd1 vssd1 vccd1 vccd1 sky130_fd_sc_hd__fill_2
X_2124_ _2124_/A _2124_/B _2352_/C _2146_/A vssd1 vssd1 vccd1 vccd1 _2151_/A sky130_fd_sc_hd__nand4_2
XANTENNA__3410__RESET_B fanout228/X vssd1 vssd1 vccd1 vccd1 sky130_fd_sc_hd__diode_2
X_2055_ _2056_/B _2056_/A vssd1 vssd1 vccd1 vccd1 _2078_/A sky130_fd_sc_hd__and2b_2
XFILLER_19_181 vssd1 vssd1 vccd1 vccd1 sky130_fd_sc_hd__fill_1
XTAP_TAPCELL_ROW_52_617 vssd1 vccd1 sky130_fd_sc_hd__tapvpwrvgnd_1
XANTENNA__2444__A _2611_/A vssd1 vssd1 vccd1 vccd1 sky130_fd_sc_hd__diode_2
XFILLER_34_184 vssd1 vssd1 vccd1 vccd1 sky130_fd_sc_hd__fill_2
X_2957_ _3359_/Q _2959_/B _2957_/C vssd1 vssd1 vccd1 vccd1 _2957_/X sky130_fd_sc_hd__and3_2
XTAP_TAPCELL_ROW_60_683 vssd1 vccd1 sky130_fd_sc_hd__tapvpwrvgnd_1
X_2888_ _3227_/Q _2923_/A2 _2887_/X _2781_/B vssd1 vssd1 vccd1 vccd1 _2888_/X sky130_fd_sc_hd__a22o_2
X_1908_ _1947_/A _2073_/C _1970_/B _2049_/B vssd1 vssd1 vccd1 vccd1 _1909_/B sky130_fd_sc_hd__a22o_2
XANTENNA__2981__A0 _3405_/Q vssd1 vssd1 vccd1 vccd1 sky130_fd_sc_hd__diode_2
X_1839_ _2029_/B _1839_/B _1869_/A vssd1 vssd1 vccd1 vccd1 _1839_/X sky130_fd_sc_hd__and3_2
Xhold520 _3382_/Q vssd1 vssd1 vccd1 vccd1 hold520/X sky130_fd_sc_hd__dlygate4sd3_1
Xhold553 _3256_/Q vssd1 vssd1 vccd1 vccd1 hold553/X sky130_fd_sc_hd__dlygate4sd3_1
Xhold542 _3267_/Q vssd1 vssd1 vccd1 vccd1 hold542/X sky130_fd_sc_hd__dlygate4sd3_1
Xhold531 _3328_/Q vssd1 vssd1 vccd1 vccd1 hold531/X sky130_fd_sc_hd__dlygate4sd3_1
Xhold597 _3251_/Q vssd1 vssd1 vccd1 vccd1 hold597/X sky130_fd_sc_hd__dlygate4sd3_1
Xhold586 _3222_/Q vssd1 vssd1 vccd1 vccd1 hold586/X sky130_fd_sc_hd__dlygate4sd3_1
Xhold575 _3167_/Q vssd1 vssd1 vccd1 vccd1 hold575/X sky130_fd_sc_hd__dlygate4sd3_1
Xhold564 _3257_/Q vssd1 vssd1 vccd1 vccd1 hold564/X sky130_fd_sc_hd__dlygate4sd3_1
XTAP_TAPCELL_ROW_68_750 vssd1 vccd1 sky130_fd_sc_hd__tapvpwrvgnd_1
XFILLER_17_118 vssd1 vccd1 vssd1 vccd1 sky130_ef_sc_hd__decap_40_12
Xclkbuf_leaf_37_clk clkbuf_leaf_2_clk/A vssd1 vssd1 vccd1 vccd1 clkload7/A sky130_fd_sc_hd__clkbuf_8
XPHY_EDGE_ROW_11_Left_91 vssd1 vssd1 vccd1 vccd1 sky130_fd_sc_hd__decap_3
XFILLER_72_279 vssd1 vssd1 vccd1 vccd1 sky130_fd_sc_hd__fill_2
XANTENNA__1669__S _1690_/S vssd1 vssd1 vccd1 vccd1 sky130_fd_sc_hd__diode_2
XFILLER_53_493 vssd1 vssd1 vccd1 vccd1 sky130_fd_sc_hd__fill_1
XFILLER_40_132 vssd1 vssd1 vccd1 vccd1 sky130_fd_sc_hd__fill_1
XFILLER_15_63 vssd1 vssd1 vccd1 vccd1 sky130_fd_sc_hd__fill_8
XANTENNA_fanout18_X _2799_/S vssd1 vssd1 vccd1 vccd1 sky130_fd_sc_hd__diode_2
Xclkbuf_leaf_28_clk clkload3/A vssd1 vssd1 vccd1 vccd1 _3337_/CLK sky130_fd_sc_hd__clkbuf_8
XFILLER_56_70 vssd1 vssd1 vccd1 vccd1 sky130_fd_sc_hd__fill_1
XTAP_TAPCELL_ROW_74_797 vssd1 vccd1 sky130_fd_sc_hd__tapvpwrvgnd_1
XFILLER_44_493 vssd1 vssd1 vccd1 vccd1 sky130_fd_sc_hd__fill_1
XFILLER_71_290 vssd1 vssd1 vccd1 vccd1 sky130_fd_sc_hd__fill_2
XANTENNA_clkbuf_leaf_32_clk_A clkbuf_3_4__f_clk/X vssd1 vssd1 vccd1 vccd1 sky130_fd_sc_hd__diode_2
X_2811_ hold538/X _2811_/A1 _2814_/S vssd1 vssd1 vccd1 vccd1 _3317_/D sky130_fd_sc_hd__mux2_1
XFILLER_72_91 vssd1 vssd1 vccd1 vccd1 sky130_fd_sc_hd__fill_1
XANTENNA__2551__X _2559_/S vssd1 vssd1 vccd1 vccd1 sky130_fd_sc_hd__diode_2
X_2742_ hold494/X _2818_/A1 _2742_/S vssd1 vssd1 vccd1 vccd1 _3252_/D sky130_fd_sc_hd__mux2_1
XFILLER_75_3 vssd1 vssd1 vccd1 vccd1 sky130_fd_sc_hd__fill_8
X_2673_ hold639/X _2844_/A1 _2685_/S vssd1 vssd1 vccd1 vccd1 _3186_/D sky130_fd_sc_hd__mux2_1
X_1624_ _2588_/A _1629_/A _1610_/Y _1618_/Y _1623_/Y vssd1 vssd1 vccd1 vccd1 _1624_/X
+ sky130_fd_sc_hd__a2111o_2
X_1555_ _3424_/Q _3436_/Q vssd1 vssd1 vccd1 vccd1 _3419_/D sky130_fd_sc_hd__and2_2
X_3225_ _3389_/CLK _3225_/D fanout274/X vssd1 vssd1 vccd1 vccd1 _3225_/Q sky130_fd_sc_hd__dfrtp_2
XANTENNA__2439__A _2533_/A vssd1 vssd1 vccd1 vccd1 sky130_fd_sc_hd__diode_2
X_3156_ _3387_/CLK _3156_/D fanout235/X vssd1 vssd1 vccd1 vccd1 _3156_/Q sky130_fd_sc_hd__dfrtp_2
X_3087_ clkload6/A _3087_/D vssd1 vssd1 vccd1 vccd1 _3087_/Q sky130_fd_sc_hd__dfxtp_2
Xclkbuf_leaf_19_clk clkload5/A vssd1 vssd1 vccd1 vccd1 _3389_/CLK sky130_fd_sc_hd__clkbuf_8
X_2107_ _2107_/A _2107_/B vssd1 vssd1 vccd1 vccd1 _2107_/X sky130_fd_sc_hd__and2_2
XFILLER_54_213 vssd1 vssd1 vccd1 vccd1 sky130_fd_sc_hd__fill_1
XFILLER_27_449 vssd1 vssd1 vccd1 vccd1 sky130_fd_sc_hd__fill_1
X_2038_ _2038_/A _2038_/B vssd1 vssd1 vccd1 vccd1 _2040_/B sky130_fd_sc_hd__xnor2_2
XTAP_TAPCELL_ROW_37_488 vssd1 vccd1 sky130_fd_sc_hd__tapvpwrvgnd_1
XFILLER_50_485 vssd1 vssd1 vccd1 vccd1 sky130_fd_sc_hd__fill_1
XANTENNA__2324__D _2352_/C vssd1 vssd1 vccd1 vccd1 sky130_fd_sc_hd__diode_2
XANTENNA__2902__A _2970_/B vssd1 vssd1 vccd1 vccd1 sky130_fd_sc_hd__diode_2
XTAP_TAPCELL_ROW_20_344 vssd1 vccd1 sky130_fd_sc_hd__tapvpwrvgnd_1
Xhold372 _3419_/Q vssd1 vssd1 vccd1 vccd1 hold372/X sky130_fd_sc_hd__dlygate4sd3_1
Xhold383 _3411_/Q vssd1 vssd1 vccd1 vccd1 hold383/X sky130_fd_sc_hd__dlygate4sd3_1
Xhold394 _3065_/Q vssd1 vssd1 vccd1 vccd1 hold394/X sky130_fd_sc_hd__dlygate4sd3_1
XANTENNA__2783__S _2799_/S vssd1 vssd1 vccd1 vccd1 sky130_fd_sc_hd__diode_2
XTAP_TAPCELL_ROW_28_411 vssd1 vccd1 sky130_fd_sc_hd__tapvpwrvgnd_1
XFILLER_45_235 vssd1 vssd1 vccd1 vccd1 sky130_fd_sc_hd__fill_1
XFILLER_41_441 vssd1 vssd1 vccd1 vccd1 sky130_fd_sc_hd__fill_2
XFILLER_13_110 vssd1 vssd1 vccd1 vccd1 sky130_fd_sc_hd__fill_2
XTAP_TAPCELL_ROW_71_778 vssd1 vccd1 sky130_fd_sc_hd__tapvpwrvgnd_1
XFILLER_9_125 vssd1 vssd1 vccd1 vccd1 sky130_fd_sc_hd__fill_1
XFILLER_13_154 vssd1 vssd1 vccd1 vccd1 sky130_fd_sc_hd__fill_4
XFILLER_9_147 vssd1 vssd1 vccd1 vccd1 sky130_fd_sc_hd__fill_4
XANTENNA__2945__B1 _2971_/B1 vssd1 vssd1 vccd1 vccd1 sky130_fd_sc_hd__diode_2
XFILLER_9_169 vssd1 vssd1 vccd1 vccd1 sky130_fd_sc_hd__fill_2
XFILLER_42_72 vssd1 vssd1 vccd1 vccd1 sky130_fd_sc_hd__fill_2
XTAP_TAPCELL_ROW_79_856 vssd1 vccd1 sky130_fd_sc_hd__tapvpwrvgnd_1
XTAP_TAPCELL_ROW_79_845 vssd1 vccd1 sky130_fd_sc_hd__tapvpwrvgnd_1
XANTENNA__2476__A2 _2923_/A2 vssd1 vssd1 vccd1 vccd1 sky130_fd_sc_hd__diode_2
X_3010_ _3132_/CLK _3010_/D fanout219/X vssd1 vssd1 vccd1 vccd1 _3010_/Q sky130_fd_sc_hd__dfrtp_2
XFILLER_3_99 vssd1 vssd1 vccd1 vccd1 sky130_fd_sc_hd__fill_1
XANTENNA__2693__S _2704_/S vssd1 vssd1 vccd1 vccd1 sky130_fd_sc_hd__diode_2
XTAP_TAPCELL_ROW_62_701 vssd1 vccd1 sky130_fd_sc_hd__tapvpwrvgnd_1
XTAP_TAPCELL_ROW_34_458 vssd1 vccd1 sky130_fd_sc_hd__tapvpwrvgnd_1
X_2725_ hold583/X _2839_/A1 _2742_/S vssd1 vssd1 vccd1 vccd1 _3235_/D sky130_fd_sc_hd__mux2_1
Xclkbuf_leaf_8_clk clkload2/A vssd1 vssd1 vccd1 vccd1 _3429_/CLK sky130_fd_sc_hd__clkbuf_8
X_2656_ hold569/X _2808_/A1 _2662_/S vssd1 vssd1 vccd1 vccd1 _3170_/D sky130_fd_sc_hd__mux2_1
X_1607_ _3429_/Q _3427_/Q _3428_/Q _3425_/Q vssd1 vssd1 vccd1 vccd1 _1607_/Y sky130_fd_sc_hd__nor4_4
XANTENNA__1772__S _1773_/S vssd1 vssd1 vccd1 vccd1 sky130_fd_sc_hd__diode_2
Xfanout104 _1608_/X vssd1 vssd1 vccd1 vccd1 _2590_/B sky130_fd_sc_hd__clkdlybuf4s25_1
X_2587_ hold728/X _2587_/A2 _2587_/B1 _3139_/Q vssd1 vssd1 vccd1 vccd1 _2587_/X sky130_fd_sc_hd__a22o_2
Xfanout115 _3432_/Q vssd1 vssd1 vccd1 vccd1 _2972_/A1 sky130_fd_sc_hd__clkdlybuf4s25_1
Xfanout126 _2964_/C vssd1 vssd1 vccd1 vccd1 _2959_/C sky130_fd_sc_hd__clkdlybuf4s25_1
Xfanout137 _2472_/A vssd1 vssd1 vccd1 vccd1 _2533_/A sky130_fd_sc_hd__clkdlybuf4s25_1
X_1538_ _3382_/Q _3454_/Q _1546_/S vssd1 vssd1 vccd1 vccd1 _3455_/D sky130_fd_sc_hd__mux2_1
XFILLER_59_305 vssd1 vssd1 vccd1 vccd1 sky130_fd_sc_hd__fill_1
Xfanout148 _3050_/Q vssd1 vssd1 vccd1 vccd1 _2257_/B sky130_fd_sc_hd__clkdlybuf4s25_1
Xfanout159 _3044_/Q vssd1 vssd1 vccd1 vccd1 _2002_/B sky130_fd_sc_hd__clkdlybuf4s25_1
X_3208_ _3393_/CLK _3208_/D load_slew258/X vssd1 vssd1 vccd1 vccd1 _3208_/Q sky130_fd_sc_hd__dfrtp_2
X_3139_ clkload7/A _3139_/D load_slew210/X vssd1 vssd1 vccd1 vccd1 _3139_/Q sky130_fd_sc_hd__dfrtp_2
XANTENNA__2219__A2 _2279_/B vssd1 vssd1 vccd1 vccd1 sky130_fd_sc_hd__diode_2
XANTENNA__2351__B _2399_/B vssd1 vssd1 vccd1 vccd1 sky130_fd_sc_hd__diode_2
XANTENNA__2778__S _2780_/S vssd1 vssd1 vccd1 vccd1 sky130_fd_sc_hd__diode_2
XANTENNA__2155__B2 _3046_/Q vssd1 vssd1 vccd1 vccd1 sky130_fd_sc_hd__diode_2
XFILLER_2_345 vssd1 vssd1 vccd1 vccd1 sky130_fd_sc_hd__fill_1
XANTENNA_fanout85_X _2610_/A vssd1 vssd1 vccd1 vccd1 sky130_fd_sc_hd__diode_2
XFILLER_77_113 vssd1 vssd1 vccd1 vccd1 sky130_fd_sc_hd__fill_2
XTAP_TAPCELL_ROW_76_815 vssd1 vccd1 sky130_fd_sc_hd__tapvpwrvgnd_1
XFILLER_73_341 vssd1 vssd1 vccd1 vccd1 sky130_fd_sc_hd__fill_1
XFILLER_37_94 vssd1 vssd1 vccd1 vccd1 sky130_fd_sc_hd__fill_1
XTAP_TAPCELL_ROW_31_439 vssd1 vccd1 sky130_fd_sc_hd__tapvpwrvgnd_1
X_2510_ _3330_/Q _2901_/A2 _2901_/B1 _3312_/Q _2509_/X vssd1 vssd1 vccd1 vccd1 _2510_/X
+ sky130_fd_sc_hd__a221o_2
XANTENNA__2688__S _2700_/S vssd1 vssd1 vccd1 vccd1 sky130_fd_sc_hd__diode_2
X_2441_ _3253_/Q _2667_/B _2648_/B _3235_/Q _2439_/X vssd1 vssd1 vccd1 vccd1 _2441_/X
+ sky130_fd_sc_hd__a221o_2
X_2372_ _2372_/A _2372_/B vssd1 vssd1 vccd1 vccd1 _2373_/B sky130_fd_sc_hd__nand2_2
XFILLER_38_3 vssd1 vssd1 vccd1 vccd1 sky130_fd_sc_hd__fill_2
XTAP_TAPCELL_ROW_39_506 vssd1 vccd1 sky130_fd_sc_hd__tapvpwrvgnd_1
XFILLER_49_393 vssd1 vssd1 vccd1 vccd1 sky130_fd_sc_hd__fill_1
XTAP_TAPCELL_ROW_47_572 vssd1 vccd1 sky130_fd_sc_hd__tapvpwrvgnd_1
XANTENNA__1767__S _1773_/S vssd1 vssd1 vccd1 vccd1 sky130_fd_sc_hd__diode_2
XPHY_EDGE_ROW_49_Left_129 vssd1 vssd1 vccd1 vccd1 sky130_fd_sc_hd__decap_3
XANTENNA_fanout132_A _3089_/Q vssd1 vssd1 vccd1 vccd1 sky130_fd_sc_hd__diode_2
XANTENNA__2171__B _2297_/A vssd1 vssd1 vccd1 vccd1 sky130_fd_sc_hd__diode_2
XANTENNA__2385__A1 _2399_/A vssd1 vssd1 vccd1 vccd1 sky130_fd_sc_hd__diode_2
X_2708_ hold518/X _2803_/A1 _2719_/S vssd1 vssd1 vccd1 vccd1 _3219_/D sky130_fd_sc_hd__mux2_1
XFILLER_3_109 vssd1 vssd1 vccd1 vccd1 sky130_fd_sc_hd__fill_2
X_2639_ hold651/X _2814_/A1 _2647_/S vssd1 vssd1 vccd1 vccd1 _3158_/D sky130_fd_sc_hd__mux2_1
XFILLER_58_27 vssd1 vssd1 vccd1 vccd1 sky130_fd_sc_hd__fill_1
XPHY_EDGE_ROW_58_Left_138 vssd1 vssd1 vccd1 vccd1 sky130_fd_sc_hd__decap_3
XANTENNA__2049__D _2073_/C vssd1 vssd1 vccd1 vccd1 sky130_fd_sc_hd__diode_2
XTAP_TAPCELL_ROW_2_186 vssd1 vccd1 sky130_fd_sc_hd__tapvpwrvgnd_1
XFILLER_70_300 vssd1 vssd1 vccd1 vccd1 sky130_fd_sc_hd__fill_8
XPHY_EDGE_ROW_67_Left_147 vssd1 vssd1 vccd1 vccd1 sky130_fd_sc_hd__decap_3
XANTENNA__2612__A2 _2610_/A vssd1 vssd1 vccd1 vccd1 sky130_fd_sc_hd__diode_2
XFILLER_11_433 vssd1 vssd1 vccd1 vccd1 sky130_fd_sc_hd__fill_1
XFILLER_11_411 vssd1 vssd1 vccd1 vccd1 sky130_fd_sc_hd__fill_1
XPHY_EDGE_ROW_76_Left_156 vssd1 vssd1 vccd1 vccd1 sky130_fd_sc_hd__decap_3
XFILLER_78_411 vssd1 vssd1 vccd1 vccd1 sky130_fd_sc_hd__fill_2
XFILLER_2_197 vssd1 vssd1 vccd1 vccd1 sky130_fd_sc_hd__fill_2
XFILLER_65_127 vssd1 vssd1 vccd1 vccd1 sky130_fd_sc_hd__fill_1
XFILLER_64_70 vssd1 vccd1 vssd1 vccd1 sky130_ef_sc_hd__decap_40_12
X_2990_ _2997_/A vssd1 vssd1 vccd1 vccd1 _2990_/Y sky130_fd_sc_hd__inv_2
XTAP_TAPCELL_ROW_44_542 vssd1 vccd1 sky130_fd_sc_hd__tapvpwrvgnd_1
X_1941_ _1942_/B _1942_/C _1942_/A vssd1 vssd1 vccd1 vccd1 _1943_/A sky130_fd_sc_hd__a21oi_2
X_1872_ _1872_/A _1872_/B vssd1 vssd1 vccd1 vccd1 _1873_/C sky130_fd_sc_hd__xnor2_2
XFILLER_6_492 vssd1 vssd1 vccd1 vccd1 sky130_fd_sc_hd__fill_2
X_2424_ _2533_/A _1625_/Y _2423_/X _2540_/A vssd1 vssd1 vccd1 vccd1 _2427_/B sky130_fd_sc_hd__o211a_2
X_2355_ _2355_/A _2355_/B vssd1 vssd1 vccd1 vccd1 _2357_/B sky130_fd_sc_hd__xnor2_2
X_2286_ _2383_/B _2352_/C _2326_/B _2384_/B vssd1 vssd1 vccd1 vccd1 _2287_/B sky130_fd_sc_hd__a22o_2
XANTENNA__2447__A _2533_/A vssd1 vssd1 vccd1 vccd1 sky130_fd_sc_hd__diode_2
XFILLER_44_29 vssd1 vssd1 vccd1 vccd1 sky130_fd_sc_hd__fill_4
XFILLER_44_18 vssd1 vssd1 vccd1 vccd1 sky130_fd_sc_hd__fill_1
XFILLER_52_388 vssd1 vssd1 vccd1 vccd1 sky130_fd_sc_hd__fill_1
XFILLER_20_296 vssd1 vssd1 vccd1 vccd1 sky130_fd_sc_hd__fill_1
XTAP_TAPCELL_ROW_7_234 vssd1 vccd1 sky130_fd_sc_hd__tapvpwrvgnd_1
XTAP_TAPCELL_ROW_58_667 vssd1 vccd1 sky130_fd_sc_hd__tapvpwrvgnd_1
XFILLER_28_330 vssd1 vssd1 vccd1 vccd1 sky130_fd_sc_hd__fill_1
XFILLER_18_41 vssd1 vccd1 vssd1 vccd1 sky130_ef_sc_hd__decap_40_12
XFILLER_18_85 vssd1 vssd1 vccd1 vccd1 sky130_fd_sc_hd__fill_4
XANTENNA__2791__S _2798_/S vssd1 vssd1 vccd1 vccd1 sky130_fd_sc_hd__diode_2
XFILLER_70_141 vssd1 vssd1 vccd1 vccd1 sky130_fd_sc_hd__fill_4
XTAP_TAPCELL_ROW_41_523 vssd1 vccd1 sky130_fd_sc_hd__tapvpwrvgnd_1
XFILLER_70_174 vssd1 vccd1 vssd1 vccd1 sky130_ef_sc_hd__decap_40_12
XFILLER_34_62 vssd1 vssd1 vccd1 vccd1 sky130_fd_sc_hd__fill_2
XFILLER_7_223 vssd1 vssd1 vccd1 vccd1 sky130_fd_sc_hd__fill_1
XFILLER_7_289 vssd1 vssd1 vccd1 vccd1 sky130_fd_sc_hd__fill_1
XANTENNA__2819__X _2819_/X vssd1 vssd1 vccd1 vccd1 sky130_fd_sc_hd__diode_2
XANTENNA__2521__B2 _2973_/A1 vssd1 vssd1 vccd1 vccd1 sky130_fd_sc_hd__diode_2
X_2140_ _2141_/A _2141_/B vssd1 vssd1 vccd1 vccd1 _2140_/Y sky130_fd_sc_hd__nor2_2
X_2071_ hold415/X _2412_/S _2070_/X vssd1 vssd1 vccd1 vccd1 _3066_/D sky130_fd_sc_hd__o21a_2
Xload_slew73 _2456_/B1 vssd1 vssd1 vccd1 vccd1 _2894_/B1 sky130_fd_sc_hd__clkbuf_4
X_2973_ _2973_/A1 _2971_/X _2967_/X _1585_/A vssd1 vssd1 vccd1 vccd1 _2973_/X sky130_fd_sc_hd__a211o_2
X_1924_ _1979_/A _1979_/B _1978_/A vssd1 vssd1 vccd1 vccd1 _1926_/A sky130_fd_sc_hd__and3_2
X_1855_ _1890_/A _1856_/C _1856_/D _1856_/A vssd1 vssd1 vccd1 vccd1 _1893_/A sky130_fd_sc_hd__a22o_2
Xhold702 _3091_/Q vssd1 vssd1 vccd1 vccd1 hold702/X sky130_fd_sc_hd__dlygate4sd3_1
X_1786_ _1800_/A _1786_/B vssd1 vssd1 vccd1 vccd1 _1787_/B sky130_fd_sc_hd__nor2_2
Xhold735 _3055_/Q vssd1 vssd1 vccd1 vccd1 hold735/X sky130_fd_sc_hd__dlygate4sd3_1
Xhold724 _3418_/Q vssd1 vssd1 vccd1 vccd1 hold724/X sky130_fd_sc_hd__dlygate4sd3_1
Xhold713 _3122_/Q vssd1 vssd1 vccd1 vccd1 hold713/X sky130_fd_sc_hd__dlygate4sd3_1
X_3456_ _3463_/CLK _3456_/D load_slew261/X vssd1 vssd1 vccd1 vccd1 _3456_/Q sky130_fd_sc_hd__dfrtp_2
XANTENNA_fanout297_A input2/X vssd1 vssd1 vccd1 vccd1 sky130_fd_sc_hd__diode_2
X_3387_ _3387_/CLK _3387_/D load_slew240/X vssd1 vssd1 vccd1 vccd1 _3387_/Q sky130_fd_sc_hd__dfrtp_2
X_2407_ _2390_/X _2394_/A _2393_/B vssd1 vssd1 vccd1 vccd1 _2411_/A sky130_fd_sc_hd__o21a_2
XTAP_TAPCELL_ROW_4_204 vssd1 vccd1 sky130_fd_sc_hd__tapvpwrvgnd_1
X_2338_ _2338_/A _2339_/B vssd1 vssd1 vccd1 vccd1 _2369_/A sky130_fd_sc_hd__and2_2
XFILLER_69_274 vssd1 vssd1 vccd1 vccd1 sky130_fd_sc_hd__fill_4
X_2269_ _2269_/A _2305_/B vssd1 vssd1 vccd1 vccd1 _2272_/A sky130_fd_sc_hd__xnor2_2
XFILLER_55_28 vssd1 vssd1 vccd1 vccd1 sky130_fd_sc_hd__fill_1
XTAP_TAPCELL_ROW_55_637 vssd1 vccd1 sky130_fd_sc_hd__tapvpwrvgnd_1
XFILLER_37_171 vssd1 vssd1 vccd1 vccd1 sky130_fd_sc_hd__fill_1
XFILLER_25_322 vssd1 vssd1 vccd1 vccd1 sky130_fd_sc_hd__fill_1
XFILLER_71_16 vssd1 vssd1 vccd1 vccd1 sky130_fd_sc_hd__fill_1
XFILLER_20_97 vssd1 vssd1 vccd1 vccd1 sky130_fd_sc_hd__fill_1
XFILLER_0_421 vssd1 vssd1 vccd1 vccd1 sky130_fd_sc_hd__fill_8
XANTENNA__1690__S _1690_/S vssd1 vssd1 vccd1 vccd1 sky130_fd_sc_hd__diode_2
XANTENNA__2786__S _2798_/S vssd1 vssd1 vccd1 vccd1 sky130_fd_sc_hd__diode_2
XANTENNA__2503__B2 _1602_/X vssd1 vssd1 vccd1 vccd1 sky130_fd_sc_hd__diode_2
XFILLER_75_211 vssd1 vssd1 vccd1 vccd1 sky130_fd_sc_hd__fill_2
XFILLER_29_40 vssd1 vssd1 vccd1 vccd1 sky130_fd_sc_hd__fill_2
XFILLER_48_458 vssd1 vssd1 vccd1 vccd1 sky130_fd_sc_hd__fill_4
XTAP_TAPCELL_ROW_18_328 vssd1 vccd1 sky130_fd_sc_hd__tapvpwrvgnd_1
XTAP_TAPCELL_ROW_26_394 vssd1 vccd1 sky130_fd_sc_hd__tapvpwrvgnd_1
XFILLER_61_71 vssd1 vccd1 vssd1 vccd1 sky130_ef_sc_hd__decap_40_12
X_1640_ _1640_/A _1640_/B vssd1 vssd1 vccd1 vccd1 _1640_/Y sky130_fd_sc_hd__xnor2_2
X_1571_ _3428_/Q _1572_/B vssd1 vssd1 vccd1 vccd1 _3411_/D sky130_fd_sc_hd__and2_2
XFILLER_6_66 vssd1 vssd1 vccd1 vccd1 sky130_fd_sc_hd__fill_8
X_3310_ clkload7/A _3310_/D fanout238/X vssd1 vssd1 vccd1 vccd1 _3310_/Q sky130_fd_sc_hd__dfrtp_2
XFILLER_6_99 vssd1 vccd1 vssd1 vccd1 sky130_ef_sc_hd__decap_40_12
XANTENNA__2696__S _2700_/S vssd1 vssd1 vccd1 vccd1 sky130_fd_sc_hd__diode_2
X_3241_ _3331_/CLK _3241_/D load_slew230/X vssd1 vssd1 vccd1 vccd1 _3241_/Q sky130_fd_sc_hd__dfrtp_2
X_3172_ _3393_/CLK _3172_/D load_slew258/X vssd1 vssd1 vccd1 vccd1 _3172_/Q sky130_fd_sc_hd__dfrtp_2
XFILLER_20_3 vssd1 vssd1 vccd1 vccd1 sky130_fd_sc_hd__fill_4
XANTENNA_clkbuf_leaf_6_clk_A clkload1/A vssd1 vssd1 vccd1 vccd1 sky130_fd_sc_hd__diode_2
X_2123_ _2297_/A _2352_/C vssd1 vssd1 vccd1 vccd1 _2159_/A sky130_fd_sc_hd__and2_2
XFILLER_39_447 vssd1 vssd1 vccd1 vccd1 sky130_fd_sc_hd__fill_1
XFILLER_66_266 vssd1 vssd1 vccd1 vccd1 sky130_fd_sc_hd__fill_1
XFILLER_26_108 vssd1 vssd1 vccd1 vccd1 sky130_fd_sc_hd__fill_4
X_2054_ _2030_/B _2032_/B _2030_/A vssd1 vssd1 vccd1 vccd1 _2056_/B sky130_fd_sc_hd__o21bai_2
XFILLER_19_171 vssd1 vssd1 vccd1 vccd1 sky130_fd_sc_hd__fill_8
XFILLER_34_141 vssd1 vssd1 vccd1 vccd1 sky130_fd_sc_hd__fill_2
XTAP_TAPCELL_ROW_52_618 vssd1 vccd1 sky130_fd_sc_hd__tapvpwrvgnd_1
XANTENNA__2444__B _2800_/A vssd1 vssd1 vccd1 vccd1 sky130_fd_sc_hd__diode_2
X_2956_ _3197_/Q _2960_/A2 wire66/X _3179_/Q _2955_/X vssd1 vssd1 vccd1 vccd1 _2956_/X
+ sky130_fd_sc_hd__a221o_2
XFILLER_22_369 vssd1 vssd1 vccd1 vccd1 sky130_fd_sc_hd__fill_1
X_2887_ _2686_/A _3155_/Q _3299_/Q _2838_/A vssd1 vssd1 vccd1 vccd1 _2887_/X sky130_fd_sc_hd__a22o_2
X_1907_ _1947_/A _2049_/B _2029_/A _1970_/B vssd1 vssd1 vccd1 vccd1 _1907_/X sky130_fd_sc_hd__and4_2
XTAP_TAPCELL_ROW_60_684 vssd1 vccd1 sky130_fd_sc_hd__tapvpwrvgnd_1
X_1838_ _1884_/A _2029_/B _1839_/B _1869_/A vssd1 vssd1 vccd1 vccd1 _1856_/A sky130_fd_sc_hd__a22o_2
Xhold510 _3261_/Q vssd1 vssd1 vccd1 vccd1 hold510/X sky130_fd_sc_hd__dlygate4sd3_1
Xhold554 _3232_/Q vssd1 vssd1 vccd1 vccd1 hold554/X sky130_fd_sc_hd__dlygate4sd3_1
Xhold543 _3300_/Q vssd1 vssd1 vccd1 vccd1 hold543/X sky130_fd_sc_hd__dlygate4sd3_1
Xhold532 _3014_/Q vssd1 vssd1 vccd1 vccd1 hold532/X sky130_fd_sc_hd__dlygate4sd3_1
Xhold521 _3164_/Q vssd1 vssd1 vccd1 vccd1 hold521/X sky130_fd_sc_hd__dlygate4sd3_1
X_1769_ _2326_/B hold469/X _1771_/S vssd1 vssd1 vccd1 vccd1 _3049_/D sky130_fd_sc_hd__mux2_1
Xhold587 _3168_/Q vssd1 vssd1 vccd1 vccd1 hold587/X sky130_fd_sc_hd__dlygate4sd3_1
Xhold576 _3445_/Q vssd1 vssd1 vccd1 vccd1 hold576/X sky130_fd_sc_hd__dlygate4sd3_1
Xhold565 _3224_/Q vssd1 vssd1 vccd1 vccd1 hold565/X sky130_fd_sc_hd__dlygate4sd3_1
X_3439_ _3441_/CLK _3439_/D _2608_/S vssd1 vssd1 vccd1 vccd1 _3439_/Q sky130_fd_sc_hd__dfrtp_2
Xhold598 _3360_/Q vssd1 vssd1 vccd1 vccd1 hold598/X sky130_fd_sc_hd__dlygate4sd3_1
XANTENNA__2497__B1 wire66/X vssd1 vssd1 vccd1 vccd1 sky130_fd_sc_hd__diode_2
XTAP_TAPCELL_ROW_68_751 vssd1 vccd1 sky130_fd_sc_hd__tapvpwrvgnd_1
XFILLER_40_144 vssd1 vssd1 vccd1 vccd1 sky130_fd_sc_hd__fill_4
XFILLER_40_122 vssd1 vssd1 vccd1 vccd1 sky130_fd_sc_hd__fill_2
XANTENNA__2073__C _2073_/C vssd1 vssd1 vccd1 vccd1 sky130_fd_sc_hd__diode_2
XTAP_TAPCELL_ROW_23_364 vssd1 vccd1 sky130_fd_sc_hd__tapvpwrvgnd_1
XFILLER_15_86 vssd1 vssd1 vccd1 vccd1 sky130_fd_sc_hd__fill_8
XFILLER_40_199 vssd1 vssd1 vccd1 vccd1 sky130_fd_sc_hd__fill_1
XFILLER_21_391 vssd1 vssd1 vccd1 vccd1 sky130_fd_sc_hd__fill_1
XANTENNA__2972__A1 _2972_/A1 vssd1 vssd1 vccd1 vccd1 sky130_fd_sc_hd__diode_2
XANTENNA__2972__B2 _2972_/B2 vssd1 vssd1 vccd1 vccd1 sky130_fd_sc_hd__diode_2
Xoutput6 _3540_/X vssd1 vssd1 vccd1 vccd1 gpio_out[3] sky130_fd_sc_hd__clkdlybuf4s25_1
XFILLER_63_225 vssd1 vccd1 vssd1 vccd1 sky130_ef_sc_hd__decap_40_12
XFILLER_56_82 vssd1 vssd1 vccd1 vccd1 sky130_fd_sc_hd__fill_2
XFILLER_16_141 vssd1 vccd1 vssd1 vccd1 sky130_ef_sc_hd__decap_40_12
XTAP_TAPCELL_ROW_74_798 vssd1 vccd1 sky130_fd_sc_hd__tapvpwrvgnd_1
XFILLER_16_174 vssd1 vssd1 vccd1 vccd1 sky130_fd_sc_hd__fill_1
X_2810_ hold533/X _2848_/A1 _2814_/S vssd1 vssd1 vccd1 vccd1 _3316_/D sky130_fd_sc_hd__mux2_1
X_2741_ hold597/X _2817_/A1 _2742_/S vssd1 vssd1 vccd1 vccd1 _3251_/D sky130_fd_sc_hd__mux2_1
XFILLER_8_362 vssd1 vssd1 vccd1 vccd1 sky130_fd_sc_hd__fill_2
X_2672_ hold646/X _2805_/A1 _2685_/S vssd1 vssd1 vccd1 vccd1 _3185_/D sky130_fd_sc_hd__mux2_1
XFILLER_68_3 vssd1 vssd1 vccd1 vccd1 sky130_fd_sc_hd__fill_4
X_1623_ _3436_/Q _1623_/B vssd1 vssd1 vccd1 vccd1 _1623_/Y sky130_fd_sc_hd__nor2_2
X_1554_ _3398_/Q _3471_/Q _1554_/S vssd1 vssd1 vccd1 vccd1 _3540_/A sky130_fd_sc_hd__mux2_1
X_3224_ _3388_/CLK _3224_/D fanout241/X vssd1 vssd1 vccd1 vccd1 _3224_/Q sky130_fd_sc_hd__dfrtp_2
.ends
