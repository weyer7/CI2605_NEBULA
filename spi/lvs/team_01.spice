* NGSPICE file created from team_01.ext - technology: sky130A

* Black-box entry subcircuit for sky130_fd_sc_hd__fill_2 abstract view
.subckt sky130_fd_sc_hd__fill_2 VGND VNB VPB VPWR
.ends

* Black-box entry subcircuit for sky130_fd_sc_hd__fill_4 abstract view
.subckt sky130_fd_sc_hd__fill_4 VGND VNB VPB VPWR
.ends

* Black-box entry subcircuit for sky130_fd_sc_hd__tapvpwrvgnd_1 abstract view
.subckt sky130_fd_sc_hd__tapvpwrvgnd_1 VGND VPWR
.ends

* Black-box entry subcircuit for sky130_fd_sc_hd__dfstp_2 abstract view
.subckt sky130_fd_sc_hd__dfstp_2 CLK D SET_B VGND VNB VPB VPWR Q
.ends

* Black-box entry subcircuit for sky130_fd_sc_hd__or2_2 abstract view
.subckt sky130_fd_sc_hd__or2_2 A B VGND VNB VPB VPWR X
.ends

* Black-box entry subcircuit for sky130_fd_sc_hd__xnor2_2 abstract view
.subckt sky130_fd_sc_hd__xnor2_2 A B VGND VNB VPB VPWR Y
.ends

* Black-box entry subcircuit for sky130_fd_sc_hd__dfrtp_2 abstract view
.subckt sky130_fd_sc_hd__dfrtp_2 CLK D RESET_B VGND VNB VPB VPWR Q
.ends

* Black-box entry subcircuit for sky130_fd_sc_hd__mux2_1 abstract view
.subckt sky130_fd_sc_hd__mux2_1 A0 A1 S VGND VNB VPB VPWR X
.ends

* Black-box entry subcircuit for sky130_fd_sc_hd__fill_1 abstract view
.subckt sky130_fd_sc_hd__fill_1 VGND VNB VPB VPWR
.ends

* Black-box entry subcircuit for sky130_ef_sc_hd__decap_40_12 abstract view
.subckt sky130_ef_sc_hd__decap_40_12 VNB VPB VGND VPWR
.ends

* Black-box entry subcircuit for sky130_fd_sc_hd__and2_2 abstract view
.subckt sky130_fd_sc_hd__and2_2 A B VGND VNB VPB VPWR X
.ends

* Black-box entry subcircuit for sky130_fd_sc_hd__fill_8 abstract view
.subckt sky130_fd_sc_hd__fill_8 VGND VNB VPB VPWR
.ends

* Black-box entry subcircuit for sky130_fd_sc_hd__decap_3 abstract view
.subckt sky130_fd_sc_hd__decap_3 VGND VNB VPB VPWR
.ends

* Black-box entry subcircuit for sky130_fd_sc_hd__diode_2 abstract view
.subckt sky130_fd_sc_hd__diode_2 DIODE VGND VNB VPB VPWR
.ends

* Black-box entry subcircuit for sky130_fd_sc_hd__clkdlybuf4s25_1 abstract view
.subckt sky130_fd_sc_hd__clkdlybuf4s25_1 A VGND VNB VPB VPWR X
.ends

* Black-box entry subcircuit for sky130_fd_sc_hd__clkbuf_16 abstract view
.subckt sky130_fd_sc_hd__clkbuf_16 A VGND VNB VPB VPWR X
.ends

* Black-box entry subcircuit for sky130_fd_sc_hd__and2b_2 abstract view
.subckt sky130_fd_sc_hd__and2b_2 A_N B VGND VNB VPB VPWR X
.ends

* Black-box entry subcircuit for sky130_fd_sc_hd__dlygate4sd3_1 abstract view
.subckt sky130_fd_sc_hd__dlygate4sd3_1 A VGND VNB VPB VPWR X
.ends

* Black-box entry subcircuit for sky130_fd_sc_hd__a21bo_2 abstract view
.subckt sky130_fd_sc_hd__a21bo_2 A1 A2 B1_N VGND VNB VPB VPWR X
.ends

* Black-box entry subcircuit for sky130_fd_sc_hd__a32o_2 abstract view
.subckt sky130_fd_sc_hd__a32o_2 A1 A2 A3 B1 B2 VGND VNB VPB VPWR X
.ends

* Black-box entry subcircuit for sky130_fd_sc_hd__buf_4 abstract view
.subckt sky130_fd_sc_hd__buf_4 A VGND VNB VPB VPWR X
.ends

* Black-box entry subcircuit for sky130_fd_sc_hd__xor2_2 abstract view
.subckt sky130_fd_sc_hd__xor2_2 A B VGND VNB VPB VPWR X
.ends

* Black-box entry subcircuit for sky130_fd_sc_hd__a21oi_2 abstract view
.subckt sky130_fd_sc_hd__a21oi_2 A1 A2 B1 VGND VNB VPB VPWR Y
.ends

* Black-box entry subcircuit for sky130_fd_sc_hd__and4b_2 abstract view
.subckt sky130_fd_sc_hd__and4b_2 A_N B C D VGND VNB VPB VPWR X
.ends

* Black-box entry subcircuit for sky130_fd_sc_hd__o22a_2 abstract view
.subckt sky130_fd_sc_hd__o22a_2 A1 A2 B1 B2 VGND VNB VPB VPWR X
.ends

* Black-box entry subcircuit for sky130_fd_sc_hd__nor2_2 abstract view
.subckt sky130_fd_sc_hd__nor2_2 A B VGND VNB VPB VPWR Y
.ends

* Black-box entry subcircuit for sky130_fd_sc_hd__nand2_2 abstract view
.subckt sky130_fd_sc_hd__nand2_2 A B VGND VNB VPB VPWR Y
.ends

* Black-box entry subcircuit for sky130_fd_sc_hd__or3b_2 abstract view
.subckt sky130_fd_sc_hd__or3b_2 A B C_N VGND VNB VPB VPWR X
.ends

* Black-box entry subcircuit for sky130_fd_sc_hd__a221o_2 abstract view
.subckt sky130_fd_sc_hd__a221o_2 A1 A2 B1 B2 C1 VGND VNB VPB VPWR X
.ends

* Black-box entry subcircuit for sky130_fd_sc_hd__o21a_2 abstract view
.subckt sky130_fd_sc_hd__o21a_2 A1 A2 B1 VGND VNB VPB VPWR X
.ends

* Black-box entry subcircuit for sky130_fd_sc_hd__and3_2 abstract view
.subckt sky130_fd_sc_hd__and3_2 A B C VGND VNB VPB VPWR X
.ends

* Black-box entry subcircuit for sky130_fd_sc_hd__mux4_2 abstract view
.subckt sky130_fd_sc_hd__mux4_2 A0 A1 A2 A3 S0 S1 VGND VNB VPB VPWR X
.ends

* Black-box entry subcircuit for sky130_fd_sc_hd__nor3b_2 abstract view
.subckt sky130_fd_sc_hd__nor3b_2 A B C_N VGND VNB VPB VPWR Y
.ends

* Black-box entry subcircuit for sky130_fd_sc_hd__nand2b_2 abstract view
.subckt sky130_fd_sc_hd__nand2b_2 A_N B VGND VNB VPB VPWR Y
.ends

* Black-box entry subcircuit for sky130_fd_sc_hd__clkbuf_4 abstract view
.subckt sky130_fd_sc_hd__clkbuf_4 A VGND VNB VPB VPWR X
.ends

* Black-box entry subcircuit for sky130_fd_sc_hd__clkbuf_2 abstract view
.subckt sky130_fd_sc_hd__clkbuf_2 A VGND VNB VPB VPWR X
.ends

* Black-box entry subcircuit for sky130_fd_sc_hd__a21o_2 abstract view
.subckt sky130_fd_sc_hd__a21o_2 A1 A2 B1 VGND VNB VPB VPWR X
.ends

* Black-box entry subcircuit for sky130_fd_sc_hd__o21ai_2 abstract view
.subckt sky130_fd_sc_hd__o21ai_2 A1 A2 B1 VGND VNB VPB VPWR Y
.ends

* Black-box entry subcircuit for sky130_fd_sc_hd__and3b_2 abstract view
.subckt sky130_fd_sc_hd__and3b_2 A_N B C VGND VNB VPB VPWR X
.ends

* Black-box entry subcircuit for sky130_fd_sc_hd__o31ai_2 abstract view
.subckt sky130_fd_sc_hd__o31ai_2 A1 A2 A3 B1 VGND VNB VPB VPWR Y
.ends

* Black-box entry subcircuit for sky130_fd_sc_hd__conb_1 abstract view
.subckt sky130_fd_sc_hd__conb_1 VGND VNB VPB VPWR HI LO
.ends

* Black-box entry subcircuit for sky130_fd_sc_hd__buf_1 abstract view
.subckt sky130_fd_sc_hd__buf_1 A VGND VNB VPB VPWR X
.ends

* Black-box entry subcircuit for sky130_fd_sc_hd__a22o_2 abstract view
.subckt sky130_fd_sc_hd__a22o_2 A1 A2 B1 B2 VGND VNB VPB VPWR X
.ends

* Black-box entry subcircuit for sky130_fd_sc_hd__o22ai_2 abstract view
.subckt sky130_fd_sc_hd__o22ai_2 A1 A2 B1 B2 VGND VNB VPB VPWR Y
.ends

* Black-box entry subcircuit for sky130_fd_sc_hd__or3_2 abstract view
.subckt sky130_fd_sc_hd__or3_2 A B C VGND VNB VPB VPWR X
.ends

* Black-box entry subcircuit for sky130_fd_sc_hd__a2bb2o_2 abstract view
.subckt sky130_fd_sc_hd__a2bb2o_2 A1_N A2_N B1 B2 VGND VNB VPB VPWR X
.ends

* Black-box entry subcircuit for sky130_fd_sc_hd__nand3_2 abstract view
.subckt sky130_fd_sc_hd__nand3_2 A B C VGND VNB VPB VPWR Y
.ends

* Black-box entry subcircuit for sky130_fd_sc_hd__o32a_2 abstract view
.subckt sky130_fd_sc_hd__o32a_2 A1 A2 A3 B1 B2 VGND VNB VPB VPWR X
.ends

* Black-box entry subcircuit for sky130_fd_sc_hd__inv_2 abstract view
.subckt sky130_fd_sc_hd__inv_2 A VGND VNB VPB VPWR Y
.ends

* Black-box entry subcircuit for sky130_fd_sc_hd__buf_8 abstract view
.subckt sky130_fd_sc_hd__buf_8 A VGND VNB VPB VPWR X
.ends

* Black-box entry subcircuit for sky130_fd_sc_hd__o2bb2a_2 abstract view
.subckt sky130_fd_sc_hd__o2bb2a_2 A1_N A2_N B1 B2 VGND VNB VPB VPWR X
.ends

* Black-box entry subcircuit for sky130_fd_sc_hd__a31o_2 abstract view
.subckt sky130_fd_sc_hd__a31o_2 A1 A2 A3 B1 VGND VNB VPB VPWR X
.ends

* Black-box entry subcircuit for sky130_fd_sc_hd__a21boi_2 abstract view
.subckt sky130_fd_sc_hd__a21boi_2 A1 A2 B1_N VGND VNB VPB VPWR Y
.ends

* Black-box entry subcircuit for sky130_fd_sc_hd__o21ai_1 abstract view
.subckt sky130_fd_sc_hd__o21ai_1 A1 A2 B1 VGND VNB VPB VPWR Y
.ends

* Black-box entry subcircuit for sky130_fd_sc_hd__and4_2 abstract view
.subckt sky130_fd_sc_hd__and4_2 A B C D VGND VNB VPB VPWR X
.ends

* Black-box entry subcircuit for sky130_fd_sc_hd__nor4_1 abstract view
.subckt sky130_fd_sc_hd__nor4_1 A B C D VGND VNB VPB VPWR Y
.ends

.subckt team_01 clk en gpio_in[0] gpio_in[10] gpio_in[11] gpio_in[12] gpio_in[13]
+ gpio_in[14] gpio_in[15] gpio_in[16] gpio_in[17] gpio_in[18] gpio_in[19] gpio_in[1]
+ gpio_in[20] gpio_in[21] gpio_in[22] gpio_in[23] gpio_in[24] gpio_in[25] gpio_in[26]
+ gpio_in[27] gpio_in[28] gpio_in[29] gpio_in[2] gpio_in[30] gpio_in[31] gpio_in[32]
+ gpio_in[33] gpio_in[3] gpio_in[4] gpio_in[5] gpio_in[6] gpio_in[7] gpio_in[8] gpio_in[9]
+ gpio_oeb[0] gpio_oeb[10] gpio_oeb[11] gpio_oeb[12] gpio_oeb[13] gpio_oeb[14] gpio_oeb[15]
+ gpio_oeb[16] gpio_oeb[17] gpio_oeb[18] gpio_oeb[19] gpio_oeb[1] gpio_oeb[20] gpio_oeb[21]
+ gpio_oeb[22] gpio_oeb[23] gpio_oeb[24] gpio_oeb[25] gpio_oeb[26] gpio_oeb[27] gpio_oeb[28]
+ gpio_oeb[29] gpio_oeb[2] gpio_oeb[30] gpio_oeb[31] gpio_oeb[32] gpio_oeb[33] gpio_oeb[3]
+ gpio_oeb[4] gpio_oeb[5] gpio_oeb[6] gpio_oeb[7] gpio_oeb[8] gpio_oeb[9] gpio_out[0]
+ gpio_out[10] gpio_out[11] gpio_out[12] gpio_out[13] gpio_out[14] gpio_out[15] gpio_out[16]
+ gpio_out[17] gpio_out[18] gpio_out[19] gpio_out[1] gpio_out[20] gpio_out[21] gpio_out[22]
+ gpio_out[23] gpio_out[24] gpio_out[25] gpio_out[26] gpio_out[27] gpio_out[28] gpio_out[29]
+ gpio_out[2] gpio_out[30] gpio_out[31] gpio_out[32] gpio_out[33] gpio_out[3] gpio_out[4]
+ gpio_out[5] gpio_out[6] gpio_out[7] gpio_out[8] gpio_out[9] nrst vccd1 vssd1
XFILLER_13_166 vssd1 vssd1 vccd1 vccd1 sky130_fd_sc_hd__fill_2
XFILLER_26_85 vssd1 vssd1 vccd1 vccd1 sky130_fd_sc_hd__fill_4
XTAP_TAPCELL_ROW_23_150 vssd1 vccd1 sky130_fd_sc_hd__tapvpwrvgnd_1
X_432_ _461_/CLK _432_/D fanout45/X vssd1 vssd1 vccd1 vccd1 _432_/Q sky130_fd_sc_hd__dfstp_2
X_363_ _449_/Q _363_/B vssd1 vssd1 vccd1 vccd1 _363_/X sky130_fd_sc_hd__or2_2
X_294_ _294_/A _294_/B vssd1 vssd1 vccd1 vccd1 _435_/D sky130_fd_sc_hd__xnor2_2
XTAP_TAPCELL_ROW_12_109 vssd1 vccd1 sky130_fd_sc_hd__tapvpwrvgnd_1
X_415_ _468_/CLK _415_/D load_slew49/X vssd1 vssd1 vccd1 vccd1 _415_/Q sky130_fd_sc_hd__dfrtp_2
X_346_ _346_/A0 _345_/Y _346_/S vssd1 vssd1 vccd1 vccd1 _444_/D sky130_fd_sc_hd__mux2_1
X_277_ _482_/Q _484_/Q _311_/A vssd1 vssd1 vccd1 vccd1 _278_/C sky130_fd_sc_hd__mux2_1
XFILLER_23_20 vssd1 vssd1 vccd1 vccd1 sky130_fd_sc_hd__fill_1
XFILLER_23_86 vssd1 vccd1 vssd1 vccd1 sky130_ef_sc_hd__decap_40_12
X_200_ _426_/Q _239_/A vssd1 vssd1 vccd1 vccd1 _213_/A sky130_fd_sc_hd__and2_2
XFILLER_2_121 vssd1 vssd1 vccd1 vccd1 sky130_fd_sc_hd__fill_2
X_329_ _344_/A _464_/Q vssd1 vssd1 vccd1 vccd1 _330_/B sky130_fd_sc_hd__xnor2_2
XFILLER_20_87 vssd1 vssd1 vccd1 vccd1 sky130_fd_sc_hd__fill_8
XFILLER_19_161 vssd1 vssd1 vccd1 vccd1 sky130_fd_sc_hd__fill_4
XPHY_EDGE_ROW_16_Left_48 vssd1 vssd1 vccd1 vccd1 sky130_fd_sc_hd__decap_3
XFILLER_15_87 vssd1 vssd1 vccd1 vccd1 sky130_fd_sc_hd__fill_2
XFILLER_17_109 vssd1 vssd1 vccd1 vccd1 sky130_fd_sc_hd__fill_1
XFILLER_25_197 vssd1 vssd1 vccd1 vccd1 sky130_fd_sc_hd__fill_2
XANTENNA__292__A1 _346_/S vssd1 vssd1 vccd1 vccd1 sky130_fd_sc_hd__diode_2
XFILLER_31_156 vssd1 vssd1 vccd1 vccd1 sky130_fd_sc_hd__fill_1
XFILLER_31_167 vssd1 vssd1 vccd1 vccd1 sky130_fd_sc_hd__fill_1
XFILLER_31_97 vssd1 vccd1 vssd1 vccd1 sky130_ef_sc_hd__decap_40_12
Xoutput7 _263_/X vssd1 vssd1 vccd1 vccd1 gpio_out[10] sky130_fd_sc_hd__clkdlybuf4s25_1
XANTENNA_fanout23_X _406_/A2 vssd1 vssd1 vccd1 vccd1 sky130_fd_sc_hd__diode_2
XFILLER_13_123 vssd1 vssd1 vccd1 vccd1 sky130_fd_sc_hd__fill_2
XFILLER_3_57 vssd1 vssd1 vccd1 vccd1 sky130_fd_sc_hd__fill_4
Xclkbuf_3_6__f_clk clkbuf_0_clk/X vssd1 vssd1 vccd1 vccd1 _468_/CLK sky130_fd_sc_hd__clkbuf_16
X_431_ _468_/CLK _431_/D load_slew49/X vssd1 vssd1 vccd1 vccd1 _431_/Q sky130_fd_sc_hd__dfrtp_2
X_362_ _326_/A _436_/Q _448_/Q vssd1 vssd1 vccd1 vccd1 _363_/B sky130_fd_sc_hd__mux2_1
X_293_ _459_/Q _356_/S vssd1 vssd1 vccd1 vccd1 _294_/B sky130_fd_sc_hd__and2b_2
XFILLER_6_119 vssd1 vssd1 vccd1 vccd1 sky130_fd_sc_hd__fill_4
XPHY_EDGE_ROW_19_Left_51 vssd1 vssd1 vccd1 vccd1 sky130_fd_sc_hd__decap_3
Xhold160 _463_/Q vssd1 vssd1 vccd1 vccd1 _396_/A1 sky130_fd_sc_hd__dlygate4sd3_1
XANTENNA__405__A _405_/A vssd1 vssd1 vccd1 vccd1 sky130_fd_sc_hd__diode_2
X_276_ _326_/A _275_/Y _346_/S vssd1 vssd1 vccd1 vccd1 _432_/D sky130_fd_sc_hd__mux2_1
X_414_ _467_/CLK _414_/D wire44/X vssd1 vssd1 vccd1 vccd1 _414_/Q sky130_fd_sc_hd__dfrtp_2
X_345_ _345_/A _345_/B vssd1 vssd1 vccd1 vccd1 _345_/Y sky130_fd_sc_hd__xnor2_2
XPHY_EDGE_ROW_12_Right_12 vssd1 vssd1 vccd1 vccd1 sky130_fd_sc_hd__decap_3
XPHY_EDGE_ROW_21_Right_21 vssd1 vssd1 vccd1 vccd1 sky130_fd_sc_hd__decap_3
XPHY_EDGE_ROW_4_Left_36 vssd1 vssd1 vccd1 vccd1 sky130_fd_sc_hd__decap_3
XFILLER_23_98 vssd1 vssd1 vccd1 vccd1 sky130_fd_sc_hd__fill_4
XPHY_EDGE_ROW_30_Right_30 vssd1 vssd1 vccd1 vccd1 sky130_fd_sc_hd__decap_3
X_259_ _452_/Q _451_/Q _453_/Q vssd1 vssd1 vccd1 vccd1 _259_/X sky130_fd_sc_hd__a21bo_2
X_328_ _332_/A _273_/Y _350_/B _327_/X _315_/A vssd1 vssd1 vccd1 vccd1 _330_/A sky130_fd_sc_hd__a32o_2
XANTENNA__386__B1 _406_/B1 vssd1 vssd1 vccd1 vccd1 sky130_fd_sc_hd__diode_2
XFILLER_18_98 vssd1 vssd1 vccd1 vccd1 sky130_fd_sc_hd__fill_1
Xload_slew42 fanout41/X vssd1 vssd1 vccd1 vccd1 load_slew42/X sky130_fd_sc_hd__buf_4
XFILLER_20_66 vssd1 vssd1 vccd1 vccd1 sky130_fd_sc_hd__fill_1
XFILLER_19_151 vssd1 vssd1 vccd1 vccd1 sky130_fd_sc_hd__fill_1
XFILLER_28_162 vssd1 vssd1 vccd1 vccd1 sky130_fd_sc_hd__fill_4
XFILLER_28_195 vssd1 vssd1 vccd1 vccd1 sky130_fd_sc_hd__fill_1
XFILLER_6_24 vssd1 vssd1 vccd1 vccd1 sky130_fd_sc_hd__fill_1
XFILLER_15_11 vssd1 vssd1 vccd1 vccd1 sky130_fd_sc_hd__fill_1
XFILLER_25_187 vssd1 vssd1 vccd1 vccd1 sky130_fd_sc_hd__fill_2
XPHY_EDGE_ROW_6_Right_6 vssd1 vssd1 vccd1 vccd1 sky130_fd_sc_hd__decap_3
XFILLER_31_113 vssd1 vssd1 vccd1 vccd1 sky130_fd_sc_hd__fill_8
XTAP_TAPCELL_ROW_26_160 vssd1 vccd1 sky130_fd_sc_hd__tapvpwrvgnd_1
Xoutput10 _269_/Y vssd1 vssd1 vccd1 vccd1 gpio_out[13] sky130_fd_sc_hd__clkdlybuf4s25_1
Xoutput8 _266_/Y vssd1 vssd1 vccd1 vccd1 gpio_out[11] sky130_fd_sc_hd__clkdlybuf4s25_1
XFILLER_30_190 vssd1 vssd1 vccd1 vccd1 sky130_fd_sc_hd__fill_4
XFILLER_13_113 vssd1 vssd1 vccd1 vccd1 sky130_fd_sc_hd__fill_1
XFILLER_26_98 vssd1 vssd1 vccd1 vccd1 sky130_fd_sc_hd__fill_1
X_430_ _463_/CLK _430_/D wire44/X vssd1 vssd1 vccd1 vccd1 _430_/Q sky130_fd_sc_hd__dfrtp_2
X_361_ _361_/A _361_/B vssd1 vssd1 vccd1 vccd1 _450_/D sky130_fd_sc_hd__xor2_2
X_292_ _346_/S _291_/Y _435_/Q vssd1 vssd1 vccd1 vccd1 _294_/A sky130_fd_sc_hd__a21oi_2
XFILLER_10_105 vssd1 vssd1 vccd1 vccd1 sky130_fd_sc_hd__fill_4
Xhold150 _469_/Q vssd1 vssd1 vccd1 vccd1 _410_/B2 sky130_fd_sc_hd__dlygate4sd3_1
Xhold161 _461_/Q vssd1 vssd1 vccd1 vccd1 _394_/B2 sky130_fd_sc_hd__dlygate4sd3_1
XFILLER_5_131 vssd1 vccd1 vssd1 vccd1 sky130_ef_sc_hd__decap_40_12
X_275_ _456_/Q _275_/B vssd1 vssd1 vccd1 vccd1 _275_/Y sky130_fd_sc_hd__xnor2_2
X_413_ _475_/Q _474_/Q _473_/Q _472_/Q vssd1 vssd1 vccd1 vccd1 _476_/D sky130_fd_sc_hd__and4b_2
X_344_ _344_/A _468_/Q vssd1 vssd1 vccd1 vccd1 _345_/B sky130_fd_sc_hd__xnor2_2
XPHY_EDGE_ROW_20_Left_52 vssd1 vssd1 vccd1 vccd1 sky130_fd_sc_hd__decap_3
XFILLER_23_33 vssd1 vssd1 vccd1 vccd1 sky130_fd_sc_hd__fill_2
XFILLER_2_123 vssd1 vssd1 vccd1 vccd1 sky130_fd_sc_hd__fill_1
XFILLER_9_24 vssd1 vssd1 vccd1 vccd1 sky130_fd_sc_hd__fill_4
XFILLER_20_211 vssd1 vssd1 vccd1 vccd1 sky130_fd_sc_hd__fill_1
X_258_ _251_/X _267_/A _257_/X _262_/B vssd1 vssd1 vccd1 vccd1 _258_/X sky130_fd_sc_hd__o22a_2
X_327_ _298_/X _326_/X _332_/A vssd1 vssd1 vccd1 vccd1 _327_/X sky130_fd_sc_hd__mux2_1
XFILLER_11_211 vssd1 vssd1 vccd1 vccd1 sky130_fd_sc_hd__fill_1
XFILLER_18_44 vssd1 vccd1 vssd1 vccd1 sky130_ef_sc_hd__decap_40_12
XFILLER_19_141 vssd1 vssd1 vccd1 vccd1 sky130_fd_sc_hd__fill_1
XTAP_TAPCELL_ROW_6_90 vssd1 vccd1 sky130_fd_sc_hd__tapvpwrvgnd_1
XFILLER_15_67 vssd1 vssd1 vccd1 vccd1 sky130_fd_sc_hd__fill_1
XFILLER_15_78 vssd1 vssd1 vccd1 vccd1 sky130_fd_sc_hd__fill_1
XFILLER_25_155 vssd1 vssd1 vccd1 vccd1 sky130_fd_sc_hd__fill_2
XFILLER_25_166 vssd1 vssd1 vccd1 vccd1 sky130_fd_sc_hd__fill_2
XFILLER_31_33 vssd1 vssd1 vccd1 vccd1 sky130_fd_sc_hd__fill_2
Xoutput11 _271_/X vssd1 vssd1 vccd1 vccd1 gpio_out[14] sky130_fd_sc_hd__clkdlybuf4s25_1
Xoutput9 _267_/Y vssd1 vssd1 vccd1 vccd1 gpio_out[12] sky130_fd_sc_hd__clkdlybuf4s25_1
XFILLER_22_136 vssd1 vssd1 vccd1 vccd1 sky130_fd_sc_hd__fill_4
XTAP_TAPCELL_ROW_26_161 vssd1 vccd1 sky130_fd_sc_hd__tapvpwrvgnd_1
XFILLER_13_125 vssd1 vssd1 vccd1 vccd1 sky130_fd_sc_hd__fill_1
X_360_ _361_/B _360_/B vssd1 vssd1 vccd1 vccd1 _449_/D sky130_fd_sc_hd__nor2_2
X_291_ _332_/A _320_/B vssd1 vssd1 vccd1 vccd1 _291_/Y sky130_fd_sc_hd__nand2_2
XFILLER_3_15 vssd1 vccd1 vssd1 vccd1 sky130_ef_sc_hd__decap_40_12
XFILLER_8_195 vssd1 vssd1 vccd1 vccd1 sky130_fd_sc_hd__fill_1
XANTENNA__329__A _344_/A vssd1 vssd1 vccd1 vccd1 sky130_fd_sc_hd__diode_2
XTAP_TAPCELL_ROW_3_80 vssd1 vccd1 sky130_fd_sc_hd__tapvpwrvgnd_1
Xhold151 _464_/Q vssd1 vssd1 vccd1 vccd1 _400_/B2 sky130_fd_sc_hd__dlygate4sd3_1
Xhold140 _472_/Q vssd1 vssd1 vccd1 vccd1 _241_/B sky130_fd_sc_hd__dlygate4sd3_1
XANTENNA__404__B1 _406_/B1 vssd1 vssd1 vccd1 vccd1 sky130_fd_sc_hd__diode_2
XFILLER_18_206 vssd1 vssd1 vccd1 vccd1 sky130_fd_sc_hd__fill_4
XFILLER_5_143 vssd1 vssd1 vccd1 vccd1 sky130_fd_sc_hd__fill_8
X_274_ _385_/A _435_/Q _273_/Y vssd1 vssd1 vccd1 vccd1 _275_/B sky130_fd_sc_hd__or3b_2
X_412_ _471_/Q _412_/A2 _412_/B1 _412_/B2 _411_/X vssd1 vssd1 vccd1 vccd1 _471_/D
+ sky130_fd_sc_hd__a221o_2
X_343_ _385_/A _315_/A _326_/X _350_/B _300_/B vssd1 vssd1 vccd1 vccd1 _345_/A sky130_fd_sc_hd__a32o_2
XFILLER_4_80 vssd1 vssd1 vccd1 vccd1 sky130_fd_sc_hd__fill_4
XTAP_TAPCELL_ROW_0_70 vssd1 vccd1 sky130_fd_sc_hd__tapvpwrvgnd_1
X_257_ _453_/Q _251_/B _256_/Y vssd1 vssd1 vccd1 vccd1 _257_/X sky130_fd_sc_hd__o21a_2
X_326_ _326_/A _326_/B _486_/Q vssd1 vssd1 vccd1 vccd1 _326_/X sky130_fd_sc_hd__and3_2
XANTENNA__386__A2 _406_/A2 vssd1 vssd1 vccd1 vccd1 sky130_fd_sc_hd__diode_2
XFILLER_18_56 vssd1 vssd1 vccd1 vccd1 sky130_fd_sc_hd__fill_4
X_309_ _309_/A _309_/B vssd1 vssd1 vccd1 vccd1 _309_/Y sky130_fd_sc_hd__xnor2_2
XFILLER_6_37 vssd1 vccd1 vssd1 vccd1 sky130_ef_sc_hd__decap_40_12
XTAP_TAPCELL_ROW_29_170 vssd1 vccd1 sky130_fd_sc_hd__tapvpwrvgnd_1
XTAP_TAPCELL_ROW_6_91 vssd1 vccd1 sky130_fd_sc_hd__tapvpwrvgnd_1
XFILLER_15_57 vssd1 vssd1 vccd1 vccd1 sky130_fd_sc_hd__fill_1
XFILLER_25_189 vssd1 vssd1 vccd1 vccd1 sky130_fd_sc_hd__fill_1
Xoutput12 _485_/Q vssd1 vssd1 vccd1 vccd1 gpio_out[16] sky130_fd_sc_hd__clkdlybuf4s25_1
XFILLER_26_78 vssd1 vssd1 vccd1 vccd1 sky130_fd_sc_hd__fill_4
XFILLER_26_89 vssd1 vssd1 vccd1 vccd1 sky130_fd_sc_hd__fill_1
XFILLER_21_192 vssd1 vssd1 vccd1 vccd1 sky130_fd_sc_hd__fill_1
XFILLER_3_27 vssd1 vssd1 vccd1 vccd1 sky130_fd_sc_hd__fill_2
X_290_ _478_/Q _480_/Q _482_/Q _484_/Q _311_/A _326_/B vssd1 vssd1 vccd1 vccd1 _320_/B
+ sky130_fd_sc_hd__mux4_2
XFILLER_8_141 vssd1 vccd1 vssd1 vccd1 sky130_ef_sc_hd__decap_40_12
XANTENNA_fanout21_X _406_/B1 vssd1 vssd1 vccd1 vccd1 sky130_fd_sc_hd__diode_2
XFILLER_5_111 vssd1 vssd1 vccd1 vccd1 sky130_fd_sc_hd__fill_1
X_273_ _311_/A _326_/B _484_/Q vssd1 vssd1 vccd1 vccd1 _273_/Y sky130_fd_sc_hd__nor3b_2
Xhold152 _400_/X vssd1 vssd1 vccd1 vccd1 _465_/D sky130_fd_sc_hd__dlygate4sd3_1
Xhold141 _241_/Y vssd1 vssd1 vccd1 vccd1 _472_/D sky130_fd_sc_hd__dlygate4sd3_1
Xhold130 _436_/Q vssd1 vssd1 vccd1 vccd1 _302_/A0 sky130_fd_sc_hd__dlygate4sd3_1
X_411_ _411_/A _447_/Q vssd1 vssd1 vccd1 vccd1 _411_/X sky130_fd_sc_hd__and2_2
X_342_ _342_/A0 _341_/Y _346_/S vssd1 vssd1 vccd1 vccd1 _443_/D sky130_fd_sc_hd__mux2_1
XANTENNA__379__A_N _405_/A vssd1 vssd1 vccd1 vccd1 sky130_fd_sc_hd__diode_2
XANTENNA__398__B1 _406_/B1 vssd1 vssd1 vccd1 vccd1 sky130_fd_sc_hd__diode_2
XFILLER_2_158 vssd1 vssd1 vccd1 vccd1 sky130_fd_sc_hd__fill_2
XFILLER_14_210 vssd1 vssd1 vccd1 vccd1 sky130_fd_sc_hd__fill_2
X_256_ _453_/Q _256_/B vssd1 vssd1 vccd1 vccd1 _256_/Y sky130_fd_sc_hd__nand2_2
X_325_ _295_/Y _435_/Q vssd1 vssd1 vccd1 vccd1 _325_/Y sky130_fd_sc_hd__nand2b_2
Xclkload0 _478_/CLK vssd1 vssd1 vccd1 vccd1 clkload0/X sky130_fd_sc_hd__clkbuf_4
X_239_ _239_/A _239_/B vssd1 vssd1 vccd1 vccd1 _239_/X sky130_fd_sc_hd__or2_2
X_308_ _306_/X _307_/Y _315_/A vssd1 vssd1 vccd1 vccd1 _309_/B sky130_fd_sc_hd__a21bo_2
XFILLER_28_121 vssd1 vssd1 vccd1 vccd1 sky130_fd_sc_hd__fill_4
XFILLER_28_187 vssd1 vssd1 vccd1 vccd1 sky130_fd_sc_hd__fill_8
XANTENNA_clkbuf_0_clk_A clk vssd1 vssd1 vccd1 vccd1 sky130_fd_sc_hd__diode_2
XFILLER_19_165 vssd1 vssd1 vccd1 vccd1 sky130_fd_sc_hd__fill_2
XFILLER_6_49 vssd1 vssd1 vccd1 vccd1 sky130_fd_sc_hd__fill_1
XTAP_TAPCELL_ROW_29_171 vssd1 vccd1 sky130_fd_sc_hd__tapvpwrvgnd_1
XFILLER_0_201 vssd1 vssd1 vccd1 vccd1 sky130_fd_sc_hd__fill_2
XFILLER_15_47 vssd1 vssd1 vccd1 vccd1 sky130_fd_sc_hd__fill_1
XFILLER_25_113 vssd1 vssd1 vccd1 vccd1 sky130_fd_sc_hd__fill_2
XFILLER_25_157 vssd1 vssd1 vccd1 vccd1 sky130_fd_sc_hd__fill_1
XFILLER_31_35 vssd1 vssd1 vccd1 vccd1 sky130_fd_sc_hd__fill_1
XFILLER_31_57 vssd1 vssd1 vccd1 vccd1 sky130_fd_sc_hd__fill_4
Xoutput13 _486_/Q vssd1 vssd1 vccd1 vccd1 gpio_out[17] sky130_fd_sc_hd__clkdlybuf4s25_1
XFILLER_31_127 vssd1 vccd1 vssd1 vccd1 sky130_ef_sc_hd__decap_40_12
XPHY_EDGE_ROW_19_Right_19 vssd1 vssd1 vccd1 vccd1 sky130_fd_sc_hd__decap_3
XPHY_EDGE_ROW_28_Right_28 vssd1 vssd1 vccd1 vccd1 sky130_fd_sc_hd__decap_3
Xclkbuf_3_1__f_clk clkbuf_0_clk/X vssd1 vssd1 vccd1 vccd1 _484_/CLK sky130_fd_sc_hd__clkbuf_16
XFILLER_15_190 vssd1 vssd1 vccd1 vccd1 sky130_fd_sc_hd__fill_1
XFILLER_7_81 vssd1 vssd1 vccd1 vccd1 sky130_fd_sc_hd__fill_4
XFILLER_7_92 vssd1 vccd1 vssd1 vccd1 sky130_ef_sc_hd__decap_40_12
XFILLER_8_153 vssd1 vssd1 vccd1 vccd1 sky130_fd_sc_hd__fill_2
XFILLER_8_197 vssd1 vssd1 vccd1 vccd1 sky130_fd_sc_hd__fill_2
XANTENNA__404__A2 _406_/A2 vssd1 vssd1 vccd1 vccd1 sky130_fd_sc_hd__diode_2
X_272_ _311_/A _484_/Q vssd1 vssd1 vccd1 vccd1 _272_/X sky130_fd_sc_hd__and2b_2
Xhold153 _475_/Q vssd1 vssd1 vccd1 vccd1 _242_/B1 sky130_fd_sc_hd__dlygate4sd3_1
Xhold142 _474_/Q vssd1 vssd1 vccd1 vccd1 _244_/B1 sky130_fd_sc_hd__dlygate4sd3_1
Xhold131 _414_/Q vssd1 vssd1 vccd1 vccd1 _223_/A1 sky130_fd_sc_hd__dlygate4sd3_1
Xhold120 _444_/Q vssd1 vssd1 vccd1 vccd1 _346_/A0 sky130_fd_sc_hd__dlygate4sd3_1
X_410_ _412_/B2 _412_/A2 _412_/B1 _410_/B2 _409_/X vssd1 vssd1 vccd1 vccd1 _470_/D
+ sky130_fd_sc_hd__a221o_2
X_341_ _341_/A _341_/B vssd1 vssd1 vccd1 vccd1 _341_/Y sky130_fd_sc_hd__xnor2_2
XFILLER_5_167 vssd1 vssd1 vccd1 vccd1 sky130_fd_sc_hd__fill_1
XFILLER_0_29 vssd1 vssd1 vccd1 vccd1 sky130_fd_sc_hd__fill_1
XPHY_EDGE_ROW_24_Left_56 vssd1 vssd1 vccd1 vccd1 sky130_fd_sc_hd__decap_3
X_255_ _452_/Q _453_/Q vssd1 vssd1 vccd1 vccd1 _264_/B sky130_fd_sc_hd__and2b_2
X_324_ _332_/C _435_/Q vssd1 vssd1 vccd1 vccd1 _350_/B sky130_fd_sc_hd__and2b_2
Xclkload1 _484_/CLK vssd1 vssd1 vccd1 vccd1 clkload1/X sky130_fd_sc_hd__clkbuf_4
XFILLER_1_61 vssd1 vssd1 vccd1 vccd1 sky130_fd_sc_hd__fill_2
X_238_ _422_/Q _238_/A2 _237_/Y vssd1 vssd1 vccd1 vccd1 _238_/Y sky130_fd_sc_hd__a21oi_2
Xload_slew46 fanout45/X vssd1 vssd1 vccd1 vccd1 load_slew46/X sky130_fd_sc_hd__clkbuf_2
X_307_ _332_/A _307_/B vssd1 vssd1 vccd1 vccd1 _307_/Y sky130_fd_sc_hd__nand2_2
XFILLER_20_15 vssd1 vssd1 vccd1 vccd1 sky130_fd_sc_hd__fill_2
XFILLER_28_166 vssd1 vssd1 vccd1 vccd1 sky130_fd_sc_hd__fill_1
XFILLER_29_57 vssd1 vssd1 vccd1 vccd1 sky130_fd_sc_hd__fill_1
XFILLER_19_177 vssd1 vssd1 vccd1 vccd1 sky130_fd_sc_hd__fill_1
XFILLER_25_169 vssd1 vssd1 vccd1 vccd1 sky130_fd_sc_hd__fill_2
XPHY_EDGE_ROW_11_Left_43 vssd1 vssd1 vccd1 vccd1 sky130_fd_sc_hd__decap_3
XFILLER_31_139 vssd1 vssd1 vccd1 vccd1 sky130_fd_sc_hd__fill_1
XFILLER_31_69 vssd1 vccd1 vssd1 vccd1 sky130_ef_sc_hd__decap_40_12
Xoutput14 _448_/Q vssd1 vssd1 vccd1 vccd1 gpio_out[18] sky130_fd_sc_hd__clkdlybuf4s25_1
XFILLER_30_194 vssd1 vssd1 vccd1 vccd1 sky130_fd_sc_hd__fill_2
XFILLER_12_161 vssd1 vssd1 vccd1 vccd1 sky130_fd_sc_hd__fill_4
XFILLER_8_121 vssd1 vccd1 vssd1 vccd1 sky130_ef_sc_hd__decap_40_12
X_486_ _476_/Q _486_/D fanout39/X vssd1 vssd1 vccd1 vccd1 _486_/Q sky130_fd_sc_hd__dfrtp_2
XFILLER_10_109 vssd1 vssd1 vccd1 vccd1 sky130_fd_sc_hd__fill_2
XTAP_TAPCELL_ROW_20_137 vssd1 vccd1 sky130_fd_sc_hd__tapvpwrvgnd_1
Xhold154 _463_/Q vssd1 vssd1 vccd1 vccd1 _398_/B2 sky130_fd_sc_hd__dlygate4sd3_1
Xhold143 _246_/Y vssd1 vssd1 vccd1 vccd1 _474_/D sky130_fd_sc_hd__dlygate4sd3_1
Xhold132 _223_/Y vssd1 vssd1 vccd1 vccd1 _414_/D sky130_fd_sc_hd__dlygate4sd3_1
Xhold121 _438_/Q vssd1 vssd1 vccd1 vccd1 _317_/A0 sky130_fd_sc_hd__dlygate4sd3_1
Xhold110 _479_/Q vssd1 vssd1 vccd1 vccd1 _480_/D sky130_fd_sc_hd__dlygate4sd3_1
X_271_ _454_/Q _256_/Y _270_/Y vssd1 vssd1 vccd1 vccd1 _271_/X sky130_fd_sc_hd__a21o_2
X_340_ _344_/A _467_/Q vssd1 vssd1 vccd1 vccd1 _341_/B sky130_fd_sc_hd__xnor2_2
XANTENNA__398__A2 _406_/A2 vssd1 vssd1 vccd1 vccd1 sky130_fd_sc_hd__diode_2
XFILLER_4_50 vssd1 vssd1 vccd1 vccd1 sky130_fd_sc_hd__fill_1
X_469_ _471_/CLK _469_/D fanout50/X vssd1 vssd1 vccd1 vccd1 _469_/Q sky130_fd_sc_hd__dfrtp_2
XFILLER_9_28 vssd1 vssd1 vccd1 vccd1 sky130_fd_sc_hd__fill_1
X_254_ _452_/Q _451_/Q vssd1 vssd1 vccd1 vccd1 _256_/B sky130_fd_sc_hd__nor2_2
X_323_ _323_/A0 _322_/Y _346_/S vssd1 vssd1 vccd1 vccd1 _439_/D sky130_fd_sc_hd__mux2_1
XFILLER_29_6 vssd1 vssd1 vccd1 vccd1 sky130_fd_sc_hd__fill_8
Xclkload2 _463_/CLK vssd1 vssd1 vccd1 vccd1 clkload2/X sky130_fd_sc_hd__clkbuf_4
X_237_ _422_/Q _238_/A2 _236_/B vssd1 vssd1 vccd1 vccd1 _237_/Y sky130_fd_sc_hd__o21ai_2
X_306_ _433_/Q _332_/A _278_/C vssd1 vssd1 vccd1 vccd1 _306_/X sky130_fd_sc_hd__or3b_2
XFILLER_1_95 vssd1 vssd1 vccd1 vccd1 sky130_fd_sc_hd__fill_4
XFILLER_29_14 vssd1 vssd1 vccd1 vccd1 sky130_fd_sc_hd__fill_1
XFILLER_29_36 vssd1 vccd1 vssd1 vccd1 sky130_ef_sc_hd__decap_40_12
XFILLER_19_167 vssd1 vssd1 vccd1 vccd1 sky130_fd_sc_hd__fill_1
XFILLER_16_159 vssd1 vccd1 vssd1 vccd1 sky130_ef_sc_hd__decap_40_12
XFILLER_31_15 vssd1 vccd1 vssd1 vccd1 sky130_ef_sc_hd__decap_40_12
XFILLER_31_48 vssd1 vssd1 vccd1 vccd1 sky130_fd_sc_hd__fill_8
XPHY_EDGE_ROW_1_Right_1 vssd1 vssd1 vccd1 vccd1 sky130_fd_sc_hd__decap_3
Xoutput15 _449_/Q vssd1 vssd1 vccd1 vccd1 gpio_out[19] sky130_fd_sc_hd__clkdlybuf4s25_1
XFILLER_12_151 vssd1 vssd1 vccd1 vccd1 sky130_fd_sc_hd__fill_1
XFILLER_16_81 vssd1 vssd1 vccd1 vccd1 sky130_fd_sc_hd__fill_2
XFILLER_8_100 vssd1 vssd1 vccd1 vccd1 sky130_fd_sc_hd__fill_1
XFILLER_8_133 vssd1 vssd1 vccd1 vccd1 sky130_fd_sc_hd__fill_4
X_485_ _476_/Q _485_/D load_slew38/X vssd1 vssd1 vccd1 vccd1 _485_/Q sky130_fd_sc_hd__dfrtp_2
XANTENNA_input6_A nrst vssd1 vssd1 vccd1 vccd1 sky130_fd_sc_hd__diode_2
XTAP_TAPCELL_ROW_20_138 vssd1 vccd1 sky130_fd_sc_hd__tapvpwrvgnd_1
Xhold155 _465_/Q vssd1 vssd1 vccd1 vccd1 _402_/B2 sky130_fd_sc_hd__dlygate4sd3_1
Xhold144 _425_/Q vssd1 vssd1 vccd1 vccd1 _192_/A sky130_fd_sc_hd__dlygate4sd3_1
Xhold133 _450_/Q vssd1 vssd1 vccd1 vccd1 _361_/A sky130_fd_sc_hd__dlygate4sd3_1
Xhold122 _445_/Q vssd1 vssd1 vccd1 vccd1 _349_/A0 sky130_fd_sc_hd__dlygate4sd3_1
Xhold111 _483_/Q vssd1 vssd1 vccd1 vccd1 _484_/D sky130_fd_sc_hd__dlygate4sd3_1
XFILLER_5_169 vssd1 vssd1 vccd1 vccd1 sky130_fd_sc_hd__fill_8
X_270_ _262_/B _259_/X _262_/X vssd1 vssd1 vccd1 vccd1 _270_/Y sky130_fd_sc_hd__o21ai_2
X_468_ _468_/CLK _468_/D fanout48/X vssd1 vssd1 vccd1 vccd1 _468_/Q sky130_fd_sc_hd__dfrtp_2
X_399_ _405_/A _441_/Q vssd1 vssd1 vccd1 vccd1 _399_/X sky130_fd_sc_hd__and2_2
XFILLER_2_139 vssd1 vssd1 vccd1 vccd1 sky130_fd_sc_hd__fill_1
X_322_ _463_/Q _322_/B vssd1 vssd1 vccd1 vccd1 _322_/Y sky130_fd_sc_hd__xnor2_2
XFILLER_13_71 vssd1 vssd1 vccd1 vccd1 sky130_fd_sc_hd__fill_2
X_253_ _262_/B _253_/B vssd1 vssd1 vccd1 vccd1 _267_/A sky130_fd_sc_hd__nand2_2
Xfanout50 fanout51/X vssd1 vssd1 vccd1 vccd1 fanout50/X sky130_fd_sc_hd__clkdlybuf4s25_1
Xclkbuf_3_7__f_clk clkbuf_0_clk/X vssd1 vssd1 vccd1 vccd1 _471_/CLK sky130_fd_sc_hd__clkbuf_16
Xclkload3 _467_/CLK vssd1 vssd1 vccd1 vccd1 clkload3/X sky130_fd_sc_hd__clkbuf_4
X_236_ _236_/A _236_/B vssd1 vssd1 vccd1 vccd1 _422_/D sky130_fd_sc_hd__nand2_2
X_305_ _486_/Q _478_/Q _485_/Q _480_/Q _326_/B _326_/A vssd1 vssd1 vccd1 vccd1 _307_/B
+ sky130_fd_sc_hd__mux4_2
XFILLER_10_94 vssd1 vssd1 vccd1 vccd1 sky130_fd_sc_hd__fill_2
XFILLER_19_113 vssd1 vssd1 vccd1 vccd1 sky130_fd_sc_hd__fill_1
XFILLER_29_48 vssd1 vssd1 vccd1 vccd1 sky130_fd_sc_hd__fill_8
X_219_ _455_/Q _219_/B vssd1 vssd1 vccd1 vccd1 _235_/C sky130_fd_sc_hd__and2_2
XFILLER_31_27 vssd1 vssd1 vccd1 vccd1 sky130_fd_sc_hd__fill_1
Xoutput16 _450_/Q vssd1 vssd1 vccd1 vccd1 gpio_out[20] sky130_fd_sc_hd__clkdlybuf4s25_1
Xclkbuf_0_clk clk vssd1 vssd1 vccd1 vccd1 clkbuf_0_clk/X sky130_fd_sc_hd__clkbuf_16
XFILLER_30_141 vssd1 vssd1 vccd1 vccd1 sky130_fd_sc_hd__fill_8
XPHY_EDGE_ROW_15_Right_15 vssd1 vssd1 vccd1 vccd1 sky130_fd_sc_hd__decap_3
XPHY_EDGE_ROW_24_Right_24 vssd1 vssd1 vccd1 vccd1 sky130_fd_sc_hd__decap_3
XFILLER_12_130 vssd1 vssd1 vccd1 vccd1 sky130_fd_sc_hd__fill_1
XFILLER_12_141 vssd1 vssd1 vccd1 vccd1 sky130_fd_sc_hd__fill_2
XTAP_TAPCELL_ROW_31_180 vssd1 vccd1 sky130_fd_sc_hd__tapvpwrvgnd_1
X_484_ _484_/CLK _484_/D load_slew38/X vssd1 vssd1 vccd1 vccd1 _484_/Q sky130_fd_sc_hd__dfrtp_2
XFILLER_12_18 vssd1 vssd1 vccd1 vccd1 sky130_fd_sc_hd__fill_2
XTAP_TAPCELL_ROW_20_139 vssd1 vccd1 sky130_fd_sc_hd__tapvpwrvgnd_1
Xhold156 _468_/Q vssd1 vssd1 vccd1 vccd1 _408_/B2 sky130_fd_sc_hd__dlygate4sd3_1
Xhold145 _426_/Q vssd1 vssd1 vccd1 vccd1 _212_/A1 sky130_fd_sc_hd__dlygate4sd3_1
Xhold134 _431_/Q vssd1 vssd1 vccd1 vccd1 _357_/B sky130_fd_sc_hd__dlygate4sd3_1
Xhold123 _443_/Q vssd1 vssd1 vccd1 vccd1 _342_/A0 sky130_fd_sc_hd__dlygate4sd3_1
Xhold112 _455_/Q vssd1 vssd1 vccd1 vccd1 _375_/A1 sky130_fd_sc_hd__dlygate4sd3_1
XFILLER_26_211 vssd1 vssd1 vccd1 vccd1 sky130_fd_sc_hd__fill_1
XFILLER_5_126 vssd1 vssd1 vccd1 vccd1 sky130_fd_sc_hd__fill_2
XFILLER_5_159 vssd1 vssd1 vccd1 vccd1 sky130_fd_sc_hd__fill_8
XTAP_TAPCELL_ROW_11_106 vssd1 vccd1 sky130_fd_sc_hd__tapvpwrvgnd_1
XFILLER_4_85 vssd1 vccd1 vssd1 vccd1 sky130_ef_sc_hd__decap_40_12
X_467_ _467_/CLK _467_/D load_slew49/X vssd1 vssd1 vccd1 vccd1 _467_/Q sky130_fd_sc_hd__dfrtp_2
X_398_ _400_/B2 _406_/A2 _406_/B1 _398_/B2 _397_/X vssd1 vssd1 vccd1 vccd1 _464_/D
+ sky130_fd_sc_hd__a221o_2
XFILLER_1_151 vssd1 vssd1 vccd1 vccd1 sky130_fd_sc_hd__fill_2
XTAP_TAPCELL_ROW_0_64 vssd1 vccd1 sky130_fd_sc_hd__tapvpwrvgnd_1
X_252_ _452_/Q _451_/Q _453_/Q vssd1 vssd1 vccd1 vccd1 _253_/B sky130_fd_sc_hd__a21o_2
Xfanout51 _229_/X vssd1 vssd1 vccd1 vccd1 fanout51/X sky130_fd_sc_hd__clkdlybuf4s25_1
Xfanout40 fanout51/X vssd1 vssd1 vccd1 vccd1 fanout40/X sky130_fd_sc_hd__clkdlybuf4s25_1
X_321_ _319_/X _320_/Y _315_/A vssd1 vssd1 vccd1 vccd1 _322_/B sky130_fd_sc_hd__a21bo_2
XANTENNA__383__B _405_/A vssd1 vssd1 vccd1 vccd1 sky130_fd_sc_hd__diode_2
XFILLER_1_6 vssd1 vssd1 vccd1 vccd1 sky130_fd_sc_hd__fill_1
XFILLER_6_210 vssd1 vssd1 vccd1 vccd1 sky130_fd_sc_hd__fill_2
X_235_ _225_/X _235_/B _235_/C vssd1 vssd1 vccd1 vccd1 _418_/D sky130_fd_sc_hd__and3b_2
Xload_slew38 fanout37/X vssd1 vssd1 vccd1 vccd1 load_slew38/X sky130_fd_sc_hd__clkbuf_2
Xload_slew49 fanout48/X vssd1 vssd1 vccd1 vccd1 load_slew49/X sky130_fd_sc_hd__buf_4
Xclkload4 _461_/CLK vssd1 vssd1 vccd1 vccd1 clkload4/X sky130_fd_sc_hd__clkbuf_4
X_304_ _486_/Q _485_/Q _311_/A vssd1 vssd1 vccd1 vccd1 _318_/B sky130_fd_sc_hd__mux2_1
XFILLER_1_53 vssd1 vssd1 vccd1 vccd1 sky130_fd_sc_hd__fill_2
XFILLER_20_29 vssd1 vccd1 vssd1 vccd1 sky130_ef_sc_hd__decap_40_12
XFILLER_28_125 vssd1 vssd1 vccd1 vccd1 sky130_fd_sc_hd__fill_1
XFILLER_19_169 vssd1 vssd1 vccd1 vccd1 sky130_fd_sc_hd__fill_8
XFILLER_19_82 vssd1 vccd1 vssd1 vccd1 sky130_ef_sc_hd__decap_40_12
X_218_ _418_/Q _417_/Q _217_/X _419_/Q vssd1 vssd1 vccd1 vccd1 _219_/B sky130_fd_sc_hd__o31ai_2
Xoutput17 _258_/X vssd1 vssd1 vccd1 vccd1 gpio_out[8] sky130_fd_sc_hd__clkdlybuf4s25_1
XFILLER_24_161 vssd1 vssd1 vccd1 vccd1 sky130_fd_sc_hd__fill_1
XFILLER_24_183 vssd1 vccd1 vssd1 vccd1 sky130_ef_sc_hd__decap_40_12
XFILLER_31_109 vssd1 vssd1 vccd1 vccd1 sky130_fd_sc_hd__fill_2
XFILLER_30_120 vssd1 vssd1 vccd1 vccd1 sky130_fd_sc_hd__fill_1
XFILLER_30_197 vssd1 vssd1 vccd1 vccd1 sky130_fd_sc_hd__fill_4
XFILLER_7_85 vssd1 vssd1 vccd1 vccd1 sky130_fd_sc_hd__fill_2
XPHY_EDGE_ROW_15_Left_47 vssd1 vssd1 vccd1 vccd1 sky130_fd_sc_hd__decap_3
XFILLER_16_83 vssd1 vssd1 vccd1 vccd1 sky130_fd_sc_hd__fill_1
XTAP_TAPCELL_ROW_23_148 vssd1 vccd1 sky130_fd_sc_hd__tapvpwrvgnd_1
XTAP_TAPCELL_ROW_31_181 vssd1 vccd1 sky130_fd_sc_hd__tapvpwrvgnd_1
X_483_ _484_/CLK _483_/D load_slew38/X vssd1 vssd1 vccd1 vccd1 _483_/Q sky130_fd_sc_hd__dfrtp_2
XFILLER_12_186 vssd1 vssd1 vccd1 vccd1 sky130_fd_sc_hd__fill_1
XFILLER_12_197 vssd1 vssd1 vccd1 vccd1 sky130_fd_sc_hd__fill_4
XTAP_TAPCELL_ROW_11_107 vssd1 vccd1 sky130_fd_sc_hd__tapvpwrvgnd_1
Xhold157 _456_/Q vssd1 vssd1 vccd1 vccd1 _384_/B2 sky130_fd_sc_hd__dlygate4sd3_1
Xhold146 _467_/Q vssd1 vssd1 vccd1 vccd1 _406_/B2 sky130_fd_sc_hd__dlygate4sd3_1
Xhold135 _441_/Q vssd1 vssd1 vccd1 vccd1 _335_/A0 sky130_fd_sc_hd__dlygate4sd3_1
Xhold124 _446_/Q vssd1 vssd1 vccd1 vccd1 _353_/A0 sky130_fd_sc_hd__dlygate4sd3_1
Xhold113 _430_/Q vssd1 vssd1 vccd1 vccd1 _216_/A1 sky130_fd_sc_hd__dlygate4sd3_1
XFILLER_27_82 vssd1 vssd1 vccd1 vccd1 sky130_fd_sc_hd__fill_8
X_466_ _466_/CLK _466_/D fanout40/X vssd1 vssd1 vccd1 vccd1 _466_/Q sky130_fd_sc_hd__dfrtp_2
X_397_ _405_/A _440_/Q vssd1 vssd1 vccd1 vccd1 _397_/X sky130_fd_sc_hd__and2_2
XFILLER_23_18 vssd1 vssd1 vccd1 vccd1 sky130_fd_sc_hd__fill_2
XFILLER_23_29 vssd1 vssd1 vccd1 vccd1 sky130_fd_sc_hd__fill_4
XFILLER_4_97 vssd1 vssd1 vccd1 vccd1 sky130_fd_sc_hd__fill_4
XPHY_EDGE_ROW_18_Left_50 vssd1 vssd1 vccd1 vccd1 sky130_fd_sc_hd__decap_3
XANTENNA__397__A _405_/A vssd1 vssd1 vccd1 vccd1 sky130_fd_sc_hd__diode_2
XFILLER_13_73 vssd1 vssd1 vccd1 vccd1 sky130_fd_sc_hd__fill_1
XFILLER_13_95 vssd1 vssd1 vccd1 vccd1 sky130_fd_sc_hd__fill_4
XTAP_TAPCELL_ROW_0_65 vssd1 vccd1 sky130_fd_sc_hd__tapvpwrvgnd_1
X_251_ _453_/Q _251_/B vssd1 vssd1 vccd1 vccd1 _251_/X sky130_fd_sc_hd__and2_2
Xfanout41 wire44/A vssd1 vssd1 vccd1 vccd1 fanout41/X sky130_fd_sc_hd__clkdlybuf4s25_1
Xfanout30 _433_/Q vssd1 vssd1 vccd1 vccd1 _326_/B sky130_fd_sc_hd__clkdlybuf4s25_1
X_320_ _385_/A _320_/B vssd1 vssd1 vccd1 vccd1 _320_/Y sky130_fd_sc_hd__nand2_2
XFILLER_18_29 vssd1 vssd1 vccd1 vccd1 sky130_fd_sc_hd__fill_2
X_449_ _468_/CLK _449_/D load_slew49/X vssd1 vssd1 vccd1 vccd1 _449_/Q sky130_fd_sc_hd__dfrtp_2
XPHY_EDGE_ROW_3_Left_35 vssd1 vssd1 vccd1 vccd1 sky130_fd_sc_hd__decap_3
Xclkload5 _468_/CLK vssd1 vssd1 vccd1 vccd1 clkload5/X sky130_fd_sc_hd__clkbuf_4
XFILLER_1_76 vssd1 vssd1 vccd1 vccd1 sky130_fd_sc_hd__fill_1
XFILLER_24_83 vssd1 vssd1 vccd1 vccd1 sky130_fd_sc_hd__fill_1
XFILLER_24_94 vssd1 vssd1 vccd1 vccd1 sky130_fd_sc_hd__fill_4
X_234_ _418_/Q _234_/B vssd1 vssd1 vccd1 vccd1 _235_/B sky130_fd_sc_hd__or2_2
X_303_ _344_/A _461_/Q vssd1 vssd1 vccd1 vccd1 _309_/A sky130_fd_sc_hd__xor2_2
XFILLER_19_94 vssd1 vssd1 vccd1 vccd1 sky130_fd_sc_hd__fill_2
XFILLER_27_181 vssd1 vssd1 vccd1 vccd1 sky130_fd_sc_hd__fill_8
X_217_ _414_/Q _415_/Q _416_/Q vssd1 vssd1 vccd1 vccd1 _217_/X sky130_fd_sc_hd__o21a_2
XFILLER_25_118 vssd1 vccd1 vssd1 vccd1 sky130_ef_sc_hd__decap_40_12
XFILLER_25_3 vssd1 vccd1 vssd1 vccd1 sky130_ef_sc_hd__decap_40_12
XFILLER_31_29 vssd1 vssd1 vccd1 vccd1 sky130_fd_sc_hd__fill_4
Xoutput18 _260_/X vssd1 vssd1 vccd1 vccd1 gpio_out[9] sky130_fd_sc_hd__clkdlybuf4s25_1
XFILLER_16_118 vssd1 vssd1 vccd1 vccd1 sky130_fd_sc_hd__fill_1
XFILLER_21_51 vssd1 vssd1 vccd1 vccd1 sky130_fd_sc_hd__fill_2
XFILLER_24_151 vssd1 vssd1 vccd1 vccd1 sky130_fd_sc_hd__fill_4
XFILLER_24_195 vssd1 vssd1 vccd1 vccd1 sky130_fd_sc_hd__fill_1
XFILLER_30_154 vssd1 vssd1 vccd1 vccd1 sky130_fd_sc_hd__fill_2
XFILLER_26_29 vssd1 vssd1 vccd1 vccd1 sky130_fd_sc_hd__fill_1
XPHY_EDGE_ROW_5_Right_5 vssd1 vssd1 vccd1 vccd1 sky130_fd_sc_hd__decap_3
XTAP_TAPCELL_ROW_23_149 vssd1 vccd1 sky130_fd_sc_hd__tapvpwrvgnd_1
XTAP_TAPCELL_ROW_31_182 vssd1 vccd1 sky130_fd_sc_hd__tapvpwrvgnd_1
XANTENNA_fanout35_X _346_/S vssd1 vssd1 vccd1 vccd1 sky130_fd_sc_hd__diode_2
XFILLER_12_165 vssd1 vssd1 vccd1 vccd1 sky130_fd_sc_hd__fill_2
XTAP_TAPCELL_ROW_14_116 vssd1 vccd1 sky130_fd_sc_hd__tapvpwrvgnd_1
X_482_ _484_/CLK _482_/D load_slew38/X vssd1 vssd1 vccd1 vccd1 _482_/Q sky130_fd_sc_hd__dfrtp_2
XTAP_TAPCELL_ROW_11_108 vssd1 vccd1 sky130_fd_sc_hd__tapvpwrvgnd_1
Xhold158 _461_/Q vssd1 vssd1 vccd1 vccd1 _392_/A1 sky130_fd_sc_hd__dlygate4sd3_1
Xteam_01 vssd1 vssd1 vccd1 vccd1 team_01/HI gpio_oeb[8] sky130_fd_sc_hd__conb_1
Xhold147 _406_/X vssd1 vssd1 vccd1 vccd1 _468_/D sky130_fd_sc_hd__dlygate4sd3_1
Xhold136 _459_/Q vssd1 vssd1 vccd1 vccd1 _390_/B2 sky130_fd_sc_hd__dlygate4sd3_1
Xhold125 _437_/Q vssd1 vssd1 vccd1 vccd1 _310_/A0 sky130_fd_sc_hd__dlygate4sd3_1
Xhold114 _427_/Q vssd1 vssd1 vccd1 vccd1 _211_/A1 sky130_fd_sc_hd__dlygate4sd3_1
XFILLER_27_72 vssd1 vssd1 vccd1 vccd1 sky130_fd_sc_hd__fill_2
XFILLER_5_128 vssd1 vssd1 vccd1 vccd1 sky130_fd_sc_hd__fill_1
X_465_ _478_/CLK _465_/D fanout40/X vssd1 vssd1 vccd1 vccd1 _465_/Q sky130_fd_sc_hd__dfrtp_2
X_396_ _396_/A1 _406_/A2 _406_/B1 _344_/A _395_/X vssd1 vssd1 vccd1 vccd1 _463_/D
+ sky130_fd_sc_hd__a221o_2
XFILLER_4_76 vssd1 vssd1 vccd1 vccd1 sky130_fd_sc_hd__fill_1
XANTENNA_input4_A gpio_in[2] vssd1 vssd1 vccd1 vccd1 sky130_fd_sc_hd__diode_2
X_250_ _452_/Q _451_/Q vssd1 vssd1 vccd1 vccd1 _251_/B sky130_fd_sc_hd__nand2b_2
Xfanout31 _326_/A vssd1 vssd1 vccd1 vccd1 _311_/A sky130_fd_sc_hd__clkdlybuf4s25_1
XFILLER_1_153 vssd1 vssd1 vccd1 vccd1 sky130_fd_sc_hd__fill_1
XTAP_TAPCELL_ROW_0_66 vssd1 vccd1 sky130_fd_sc_hd__tapvpwrvgnd_1
X_448_ _468_/CLK _448_/D load_slew49/X vssd1 vssd1 vccd1 vccd1 _448_/Q sky130_fd_sc_hd__dfrtp_2
X_379_ _405_/A _455_/Q vssd1 vssd1 vccd1 vccd1 _379_/X sky130_fd_sc_hd__and2b_2
Xclkload6 _471_/CLK vssd1 vssd1 vccd1 vccd1 clkload6/X sky130_fd_sc_hd__clkbuf_4
XFILLER_1_55 vssd1 vssd1 vccd1 vccd1 sky130_fd_sc_hd__fill_1
X_233_ _234_/B _233_/B _235_/C vssd1 vssd1 vccd1 vccd1 _417_/D sky130_fd_sc_hd__and3b_2
X_302_ _302_/A0 _301_/Y _356_/S vssd1 vssd1 vccd1 vccd1 _436_/D sky130_fd_sc_hd__mux2_1
XFILLER_18_3 vssd1 vssd1 vccd1 vccd1 sky130_fd_sc_hd__fill_2
XFILLER_25_108 vssd1 vssd1 vccd1 vccd1 sky130_fd_sc_hd__fill_4
X_216_ _216_/A1 _205_/X _204_/Y vssd1 vssd1 vccd1 vccd1 _430_/D sky130_fd_sc_hd__o21a_2
XFILLER_24_141 vssd1 vssd1 vccd1 vccd1 sky130_fd_sc_hd__fill_1
XTAP_TAPCELL_ROW_26_158 vssd1 vccd1 sky130_fd_sc_hd__tapvpwrvgnd_1
XFILLER_21_122 vssd1 vssd1 vccd1 vccd1 sky130_fd_sc_hd__fill_1
XFILLER_12_111 vssd1 vssd1 vccd1 vccd1 sky130_fd_sc_hd__fill_1
XFILLER_12_177 vssd1 vssd1 vccd1 vccd1 sky130_fd_sc_hd__fill_1
XFILLER_16_85 vssd1 vssd1 vccd1 vccd1 sky130_fd_sc_hd__fill_2
XFILLER_8_137 vssd1 vssd1 vccd1 vccd1 sky130_fd_sc_hd__fill_2
XPHY_EDGE_ROW_11_Right_11 vssd1 vssd1 vccd1 vccd1 sky130_fd_sc_hd__decap_3
XPHY_EDGE_ROW_20_Right_20 vssd1 vssd1 vccd1 vccd1 sky130_fd_sc_hd__decap_3
XTAP_TAPCELL_ROW_14_117 vssd1 vccd1 sky130_fd_sc_hd__tapvpwrvgnd_1
X_481_ _484_/CLK _481_/D fanout37/X vssd1 vssd1 vccd1 vccd1 _481_/Q sky130_fd_sc_hd__dfrtp_2
XFILLER_26_203 vssd1 vssd1 vccd1 vccd1 sky130_fd_sc_hd__fill_8
Xhold159 _431_/Q vssd1 vssd1 vccd1 vccd1 _359_/A2 sky130_fd_sc_hd__dlygate4sd3_1
Xhold148 _466_/Q vssd1 vssd1 vccd1 vccd1 _404_/B2 sky130_fd_sc_hd__dlygate4sd3_1
Xhold137 _439_/Q vssd1 vssd1 vccd1 vccd1 _323_/A0 sky130_fd_sc_hd__dlygate4sd3_1
Xhold126 _422_/Q vssd1 vssd1 vccd1 vccd1 _236_/A sky130_fd_sc_hd__dlygate4sd3_1
Xhold115 _211_/Y vssd1 vssd1 vccd1 vccd1 _427_/D sky130_fd_sc_hd__dlygate4sd3_1
XFILLER_5_118 vssd1 vssd1 vccd1 vccd1 sky130_fd_sc_hd__fill_8
X_464_ _467_/CLK _464_/D fanout51/X vssd1 vssd1 vccd1 vccd1 _464_/Q sky130_fd_sc_hd__dfrtp_2
Xclkbuf_3_2__f_clk clkbuf_0_clk/X vssd1 vssd1 vccd1 vccd1 _463_/CLK sky130_fd_sc_hd__clkbuf_16
X_395_ _405_/A _439_/Q vssd1 vssd1 vccd1 vccd1 _395_/X sky130_fd_sc_hd__and2_2
XANTENNA__400__B1 _406_/B1 vssd1 vssd1 vccd1 vccd1 sky130_fd_sc_hd__diode_2
XFILLER_13_53 vssd1 vssd1 vccd1 vccd1 sky130_fd_sc_hd__fill_2
Xfanout43 fanout51/X vssd1 vssd1 vccd1 vccd1 wire44/A sky130_fd_sc_hd__clkdlybuf4s25_1
Xfanout32 _432_/Q vssd1 vssd1 vccd1 vccd1 _326_/A sky130_fd_sc_hd__clkdlybuf4s25_1
Xfanout21 _379_/X vssd1 vssd1 vccd1 vccd1 _406_/B1 sky130_fd_sc_hd__clkdlybuf4s25_1
XFILLER_1_121 vssd1 vssd1 vccd1 vccd1 sky130_fd_sc_hd__fill_8
XFILLER_20_209 vssd1 vssd1 vccd1 vccd1 sky130_fd_sc_hd__fill_2
XTAP_TAPCELL_ROW_0_67 vssd1 vccd1 sky130_fd_sc_hd__tapvpwrvgnd_1
X_447_ _461_/CLK _447_/D load_slew46/X vssd1 vssd1 vccd1 vccd1 _447_/Q sky130_fd_sc_hd__dfrtp_2
X_378_ _378_/A _378_/B vssd1 vssd1 vccd1 vccd1 _378_/Y sky130_fd_sc_hd__nand2_2
X_232_ _417_/Q _232_/B vssd1 vssd1 vccd1 vccd1 _233_/B sky130_fd_sc_hd__or2_2
X_301_ _460_/Q _301_/B vssd1 vssd1 vccd1 vccd1 _301_/Y sky130_fd_sc_hd__xnor2_2
XFILLER_28_139 vssd1 vssd1 vccd1 vccd1 sky130_fd_sc_hd__fill_1
XFILLER_19_30 vssd1 vssd1 vccd1 vccd1 sky130_fd_sc_hd__fill_4
XFILLER_19_96 vssd1 vssd1 vccd1 vccd1 sky130_fd_sc_hd__fill_1
XFILLER_27_150 vssd1 vssd1 vccd1 vccd1 sky130_fd_sc_hd__fill_4
XTAP_TAPCELL_ROW_6_88 vssd1 vccd1 sky130_fd_sc_hd__tapvpwrvgnd_1
X_215_ _215_/A _236_/B _215_/C vssd1 vssd1 vccd1 vccd1 _424_/D sky130_fd_sc_hd__and3_2
XFILLER_24_120 vssd1 vssd1 vccd1 vccd1 sky130_fd_sc_hd__fill_2
XFILLER_24_197 vssd1 vssd1 vccd1 vccd1 sky130_fd_sc_hd__fill_2
XTAP_TAPCELL_ROW_26_159 vssd1 vccd1 sky130_fd_sc_hd__tapvpwrvgnd_1
XFILLER_21_53 vssd1 vssd1 vccd1 vccd1 sky130_fd_sc_hd__fill_1
XFILLER_30_112 vssd1 vssd1 vccd1 vccd1 sky130_fd_sc_hd__fill_8
XFILLER_7_55 vssd1 vssd1 vccd1 vccd1 sky130_fd_sc_hd__fill_1
XFILLER_12_167 vssd1 vssd1 vccd1 vccd1 sky130_fd_sc_hd__fill_1
XTAP_TAPCELL_ROW_14_118 vssd1 vccd1 sky130_fd_sc_hd__tapvpwrvgnd_1
XTAP_TAPCELL_ROW_3_78 vssd1 vccd1 sky130_fd_sc_hd__tapvpwrvgnd_1
X_480_ _484_/CLK _480_/D load_slew38/X vssd1 vssd1 vccd1 vccd1 _480_/Q sky130_fd_sc_hd__dfrtp_2
XFILLER_7_160 vssd1 vssd1 vccd1 vccd1 sky130_fd_sc_hd__fill_4
Xhold149 _470_/Q vssd1 vssd1 vccd1 vccd1 _412_/B2 sky130_fd_sc_hd__dlygate4sd3_1
Xhold138 _429_/Q vssd1 vssd1 vccd1 vccd1 _193_/A sky130_fd_sc_hd__dlygate4sd3_1
Xhold127 _442_/Q vssd1 vssd1 vccd1 vccd1 _338_/A0 sky130_fd_sc_hd__dlygate4sd3_1
Xhold116 _415_/Q vssd1 vssd1 vccd1 vccd1 _231_/A2 sky130_fd_sc_hd__dlygate4sd3_1
XANTENNA__276__S _346_/S vssd1 vssd1 vccd1 vccd1 sky130_fd_sc_hd__diode_2
XFILLER_4_56 vssd1 vccd1 vssd1 vccd1 sky130_ef_sc_hd__decap_40_12
X_463_ _463_/CLK _463_/D load_slew42/X vssd1 vssd1 vccd1 vccd1 _463_/Q sky130_fd_sc_hd__dfrtp_2
X_394_ _344_/A _412_/A2 _412_/B1 _394_/B2 _393_/X vssd1 vssd1 vccd1 vccd1 _462_/D
+ sky130_fd_sc_hd__a221o_2
Xfanout33 _421_/Q vssd1 vssd1 vccd1 vccd1 _405_/A sky130_fd_sc_hd__clkdlybuf4s25_1
Xfanout22 _379_/X vssd1 vssd1 vccd1 vccd1 _412_/B1 sky130_fd_sc_hd__clkdlybuf4s25_1
XFILLER_1_177 vssd1 vccd1 vssd1 vccd1 sky130_ef_sc_hd__decap_40_12
XTAP_TAPCELL_ROW_0_68 vssd1 vccd1 sky130_fd_sc_hd__tapvpwrvgnd_1
XTAP_TAPCELL_ROW_9_99 vssd1 vccd1 sky130_fd_sc_hd__tapvpwrvgnd_1
X_446_ _461_/CLK _446_/D fanout45/X vssd1 vssd1 vccd1 vccd1 _446_/Q sky130_fd_sc_hd__dfrtp_2
X_377_ _457_/Q _458_/Q vssd1 vssd1 vccd1 vccd1 _378_/B sky130_fd_sc_hd__xor2_2
X_231_ _414_/Q _231_/A2 _230_/Y vssd1 vssd1 vccd1 vccd1 _231_/Y sky130_fd_sc_hd__a21oi_2
X_300_ _315_/A _300_/B vssd1 vssd1 vccd1 vccd1 _301_/B sky130_fd_sc_hd__nand2_2
XFILLER_1_57 vssd1 vssd1 vccd1 vccd1 sky130_fd_sc_hd__fill_4
X_429_ _463_/CLK _429_/D wire44/X vssd1 vssd1 vccd1 vccd1 _429_/Q sky130_fd_sc_hd__dfrtp_2
XFILLER_10_66 vssd1 vssd1 vccd1 vccd1 sky130_fd_sc_hd__fill_1
XPHY_EDGE_ROW_7_Left_39 vssd1 vssd1 vccd1 vccd1 sky130_fd_sc_hd__decap_3
Xinput1 en vssd1 vssd1 vccd1 vccd1 _229_/B sky130_fd_sc_hd__clkdlybuf4s25_1
XANTENNA__403__A _405_/A vssd1 vssd1 vccd1 vccd1 sky130_fd_sc_hd__diode_2
XFILLER_18_5 vssd1 vssd1 vccd1 vccd1 sky130_fd_sc_hd__fill_1
XFILLER_27_162 vssd1 vssd1 vccd1 vccd1 sky130_fd_sc_hd__fill_4
XTAP_TAPCELL_ROW_6_89 vssd1 vccd1 sky130_fd_sc_hd__tapvpwrvgnd_1
X_214_ _422_/Q _423_/Q _424_/Q vssd1 vssd1 vccd1 vccd1 _215_/C sky130_fd_sc_hd__a21o_2
XFILLER_18_162 vssd1 vccd1 vssd1 vccd1 sky130_ef_sc_hd__decap_40_12
XFILLER_15_110 vssd1 vssd1 vccd1 vccd1 sky130_fd_sc_hd__fill_2
XFILLER_15_143 vssd1 vssd1 vccd1 vccd1 sky130_fd_sc_hd__fill_4
XTAP_TAPCELL_ROW_17_127 vssd1 vccd1 sky130_fd_sc_hd__tapvpwrvgnd_1
XFILLER_23_3 vssd1 vssd1 vccd1 vccd1 sky130_fd_sc_hd__fill_8
XFILLER_30_179 vssd1 vssd1 vccd1 vccd1 sky130_fd_sc_hd__fill_4
XFILLER_16_87 vssd1 vssd1 vccd1 vccd1 sky130_fd_sc_hd__fill_1
XFILLER_8_106 vssd1 vssd1 vccd1 vccd1 sky130_fd_sc_hd__fill_2
XFILLER_8_139 vssd1 vssd1 vccd1 vccd1 sky130_fd_sc_hd__fill_1
XTAP_TAPCELL_ROW_14_119 vssd1 vccd1 sky130_fd_sc_hd__tapvpwrvgnd_1
XTAP_TAPCELL_ROW_3_79 vssd1 vccd1 sky130_fd_sc_hd__tapvpwrvgnd_1
XPHY_EDGE_ROW_9_Right_9 vssd1 vssd1 vccd1 vccd1 sky130_fd_sc_hd__decap_3
Xhold139 _419_/Q vssd1 vssd1 vccd1 vccd1 _226_/A1 sky130_fd_sc_hd__dlygate4sd3_1
Xhold128 _447_/Q vssd1 vssd1 vccd1 vccd1 _356_/A0 sky130_fd_sc_hd__dlygate4sd3_1
Xhold117 _231_/Y vssd1 vssd1 vccd1 vccd1 _415_/D sky130_fd_sc_hd__dlygate4sd3_1
XFILLER_5_109 vssd1 vssd1 vccd1 vccd1 sky130_fd_sc_hd__fill_2
XANTENNA_fanout33_X _405_/A vssd1 vssd1 vccd1 vccd1 sky130_fd_sc_hd__diode_2
XFILLER_27_42 vssd1 vccd1 vssd1 vccd1 sky130_ef_sc_hd__decap_40_12
XFILLER_4_68 vssd1 vssd1 vccd1 vccd1 sky130_fd_sc_hd__fill_8
X_462_ _466_/CLK _462_/D fanout47/X vssd1 vssd1 vccd1 vccd1 _462_/Q sky130_fd_sc_hd__dfrtp_2
X_393_ _411_/A _438_/Q vssd1 vssd1 vccd1 vccd1 _393_/X sky130_fd_sc_hd__and2_2
XANTENNA__400__A2 _406_/A2 vssd1 vssd1 vccd1 vccd1 sky130_fd_sc_hd__diode_2
XFILLER_13_11 vssd1 vssd1 vccd1 vccd1 sky130_fd_sc_hd__fill_2
XFILLER_13_55 vssd1 vssd1 vccd1 vccd1 sky130_fd_sc_hd__fill_1
XFILLER_1_167 vssd1 vssd1 vccd1 vccd1 sky130_fd_sc_hd__fill_1
XFILLER_1_189 vssd1 vccd1 vssd1 vccd1 sky130_ef_sc_hd__decap_40_12
XTAP_TAPCELL_ROW_0_69 vssd1 vccd1 sky130_fd_sc_hd__tapvpwrvgnd_1
Xfanout45 fanout47/X vssd1 vssd1 vccd1 vccd1 fanout45/X sky130_fd_sc_hd__clkdlybuf4s25_1
Xfanout34 _421_/Q vssd1 vssd1 vccd1 vccd1 _411_/A sky130_fd_sc_hd__clkdlybuf4s25_1
Xfanout23 _374_/Y vssd1 vssd1 vccd1 vccd1 _406_/A2 sky130_fd_sc_hd__clkdlybuf4s25_1
XANTENNA__394__A1 _344_/A vssd1 vssd1 vccd1 vccd1 sky130_fd_sc_hd__diode_2
X_445_ _471_/CLK _445_/D fanout48/X vssd1 vssd1 vccd1 vccd1 _445_/Q sky130_fd_sc_hd__dfrtp_2
X_376_ _460_/Q _471_/Q vssd1 vssd1 vccd1 vccd1 _378_/A sky130_fd_sc_hd__xor2_2
XANTENNA__316__A _344_/A vssd1 vssd1 vccd1 vccd1 sky130_fd_sc_hd__diode_2
XANTENNA_input2_A gpio_in[0] vssd1 vssd1 vccd1 vccd1 sky130_fd_sc_hd__diode_2
XFILLER_10_211 vssd1 vssd1 vccd1 vccd1 sky130_fd_sc_hd__fill_1
XFILLER_24_98 vssd1 vssd1 vccd1 vccd1 sky130_fd_sc_hd__fill_1
X_230_ _414_/Q _231_/A2 _235_/C vssd1 vssd1 vccd1 vccd1 _230_/Y sky130_fd_sc_hd__o21ai_2
XPHY_EDGE_ROW_23_Left_55 vssd1 vssd1 vccd1 vccd1 sky130_fd_sc_hd__decap_3
X_428_ _463_/CLK _428_/D wire44/X vssd1 vssd1 vccd1 vccd1 _428_/Q sky130_fd_sc_hd__dfrtp_2
X_359_ _448_/Q _359_/A2 _449_/Q vssd1 vssd1 vccd1 vccd1 _360_/B sky130_fd_sc_hd__a21oi_2
XFILLER_3_207 vssd1 vssd1 vccd1 vccd1 sky130_fd_sc_hd__fill_2
Xinput2 gpio_in[0] vssd1 vssd1 vccd1 vccd1 _483_/D sky130_fd_sc_hd__clkdlybuf4s25_1
XFILLER_19_21 vssd1 vssd1 vccd1 vccd1 sky130_fd_sc_hd__fill_2
XFILLER_27_196 vssd1 vssd1 vccd1 vccd1 sky130_fd_sc_hd__fill_8
XTAP_TAPCELL_ROW_29_169 vssd1 vccd1 sky130_fd_sc_hd__tapvpwrvgnd_1
X_213_ _213_/A _213_/B vssd1 vssd1 vccd1 vccd1 _426_/D sky130_fd_sc_hd__nor2_2
XFILLER_18_174 vssd1 vccd1 vssd1 vccd1 sky130_ef_sc_hd__decap_40_12
XFILLER_21_99 vssd1 vssd1 vccd1 vccd1 sky130_fd_sc_hd__fill_1
XFILLER_24_155 vssd1 vssd1 vccd1 vccd1 sky130_fd_sc_hd__fill_1
Xmax_cap20 _204_/Y vssd1 vssd1 vccd1 vccd1 _236_/B sky130_fd_sc_hd__buf_1
XFILLER_15_166 vssd1 vssd1 vccd1 vccd1 sky130_fd_sc_hd__fill_2
XFILLER_16_3 vssd1 vssd1 vccd1 vccd1 sky130_fd_sc_hd__fill_2
XFILLER_7_57 vssd1 vccd1 vssd1 vccd1 sky130_ef_sc_hd__decap_40_12
XTAP_TAPCELL_ROW_17_128 vssd1 vccd1 sky130_fd_sc_hd__tapvpwrvgnd_1
XFILLER_12_114 vssd1 vccd1 vssd1 vccd1 sky130_ef_sc_hd__decap_40_12
XFILLER_21_169 vssd1 vssd1 vccd1 vccd1 sky130_fd_sc_hd__fill_2
XFILLER_29_203 vssd1 vssd1 vccd1 vccd1 sky130_fd_sc_hd__fill_1
XPHY_EDGE_ROW_10_Left_42 vssd1 vssd1 vccd1 vccd1 sky130_fd_sc_hd__decap_3
Xhold129 _440_/Q vssd1 vssd1 vccd1 vccd1 _331_/A0 sky130_fd_sc_hd__dlygate4sd3_1
Xhold118 _423_/Q vssd1 vssd1 vccd1 vccd1 _238_/A2 sky130_fd_sc_hd__dlygate4sd3_1
XFILLER_27_32 vssd1 vssd1 vccd1 vccd1 sky130_fd_sc_hd__fill_4
XFILLER_27_54 vssd1 vssd1 vccd1 vccd1 sky130_fd_sc_hd__fill_2
XFILLER_27_98 vssd1 vccd1 vssd1 vccd1 sky130_ef_sc_hd__decap_40_12
XFILLER_4_110 vssd1 vccd1 vssd1 vccd1 sky130_ef_sc_hd__decap_40_12
X_461_ _461_/CLK _461_/D load_slew46/X vssd1 vssd1 vccd1 vccd1 _461_/Q sky130_fd_sc_hd__dfrtp_2
X_392_ _392_/A1 _412_/A2 _412_/B1 _460_/Q _391_/X vssd1 vssd1 vccd1 vccd1 _461_/D
+ sky130_fd_sc_hd__a221o_2
XFILLER_1_113 vssd1 vssd1 vccd1 vccd1 sky130_fd_sc_hd__fill_2
XFILLER_8_5 vssd1 vssd1 vccd1 vccd1 sky130_fd_sc_hd__fill_2
Xfanout35 _420_/Q vssd1 vssd1 vccd1 vccd1 _346_/S sky130_fd_sc_hd__clkdlybuf4s25_1
Xfanout24 _374_/Y vssd1 vssd1 vccd1 vccd1 _412_/A2 sky130_fd_sc_hd__clkdlybuf4s25_1
X_444_ _468_/CLK _444_/D load_slew49/X vssd1 vssd1 vccd1 vccd1 _444_/Q sky130_fd_sc_hd__dfrtp_2
X_375_ _375_/A1 _346_/S _406_/A2 vssd1 vssd1 vccd1 vccd1 _455_/D sky130_fd_sc_hd__a21oi_2
XFILLER_24_33 vssd1 vssd1 vccd1 vccd1 sky130_fd_sc_hd__fill_2
X_427_ _463_/CLK _427_/D load_slew42/X vssd1 vssd1 vccd1 vccd1 _427_/Q sky130_fd_sc_hd__dfrtp_2
X_358_ _449_/Q _448_/Q _431_/Q vssd1 vssd1 vccd1 vccd1 _361_/B sky130_fd_sc_hd__and3_2
XPHY_EDGE_ROW_18_Right_18 vssd1 vssd1 vccd1 vccd1 sky130_fd_sc_hd__decap_3
XPHY_EDGE_ROW_27_Right_27 vssd1 vssd1 vccd1 vccd1 sky130_fd_sc_hd__decap_3
Xinput3 gpio_in[1] vssd1 vssd1 vccd1 vccd1 _481_/D sky130_fd_sc_hd__clkdlybuf4s25_1
X_289_ _385_/A _288_/Y _356_/S vssd1 vssd1 vccd1 vccd1 _434_/D sky130_fd_sc_hd__mux2_1
XFILLER_10_24 vssd1 vssd1 vccd1 vccd1 sky130_fd_sc_hd__fill_4
XFILLER_19_55 vssd1 vssd1 vccd1 vccd1 sky130_fd_sc_hd__fill_1
X_212_ _212_/A1 _239_/A _204_/Y vssd1 vssd1 vccd1 vccd1 _213_/B sky130_fd_sc_hd__o21ai_2
XFILLER_18_120 vssd1 vssd1 vccd1 vccd1 sky130_fd_sc_hd__fill_2
XFILLER_18_186 vssd1 vssd1 vccd1 vccd1 sky130_fd_sc_hd__fill_1
XFILLER_18_197 vssd1 vssd1 vccd1 vccd1 sky130_fd_sc_hd__fill_1
XFILLER_21_34 vssd1 vssd1 vccd1 vccd1 sky130_fd_sc_hd__fill_4
XFILLER_30_137 vssd1 vssd1 vccd1 vccd1 sky130_fd_sc_hd__fill_2
XFILLER_7_47 vssd1 vssd1 vccd1 vccd1 sky130_fd_sc_hd__fill_8
XFILLER_7_69 vssd1 vccd1 vssd1 vccd1 sky130_ef_sc_hd__decap_40_12
XTAP_TAPCELL_ROW_17_129 vssd1 vccd1 sky130_fd_sc_hd__tapvpwrvgnd_1
XANTENNA__340__A _344_/A vssd1 vssd1 vccd1 vccd1 sky130_fd_sc_hd__diode_2
XTAP_TAPCELL_ROW_31_176 vssd1 vccd1 sky130_fd_sc_hd__tapvpwrvgnd_1
XFILLER_12_126 vssd1 vssd1 vccd1 vccd1 sky130_fd_sc_hd__fill_4
XFILLER_16_45 vssd1 vssd1 vccd1 vccd1 sky130_fd_sc_hd__fill_2
XFILLER_8_108 vssd1 vssd1 vccd1 vccd1 sky130_fd_sc_hd__fill_1
XPHY_EDGE_ROW_0_Right_0 vssd1 vssd1 vccd1 vccd1 sky130_fd_sc_hd__decap_3
Xhold119 _238_/Y vssd1 vssd1 vccd1 vccd1 _423_/D sky130_fd_sc_hd__dlygate4sd3_1
Xhold108 _477_/Q vssd1 vssd1 vccd1 vccd1 _478_/D sky130_fd_sc_hd__dlygate4sd3_1
XTAP_TAPCELL_ROW_10_102 vssd1 vccd1 sky130_fd_sc_hd__tapvpwrvgnd_1
X_460_ _461_/CLK _460_/D load_slew46/X vssd1 vssd1 vccd1 vccd1 _460_/Q sky130_fd_sc_hd__dfrtp_2
X_391_ _411_/A _437_/Q vssd1 vssd1 vccd1 vccd1 _391_/X sky130_fd_sc_hd__and2_2
XFILLER_4_122 vssd1 vssd1 vccd1 vccd1 sky130_fd_sc_hd__fill_1
XFILLER_13_57 vssd1 vssd1 vccd1 vccd1 sky130_fd_sc_hd__fill_2
Xfanout47 fanout51/X vssd1 vssd1 vccd1 vccd1 fanout47/X sky130_fd_sc_hd__clkdlybuf4s25_1
Xfanout36 _420_/Q vssd1 vssd1 vccd1 vccd1 _356_/S sky130_fd_sc_hd__clkdlybuf4s25_1
XANTENNA__388__B1 _406_/B1 vssd1 vssd1 vccd1 vccd1 sky130_fd_sc_hd__diode_2
X_443_ _466_/CLK _443_/D fanout48/X vssd1 vssd1 vccd1 vccd1 _443_/Q sky130_fd_sc_hd__dfrtp_2
X_374_ _455_/Q _405_/A vssd1 vssd1 vccd1 vccd1 _374_/Y sky130_fd_sc_hd__nor2_2
XFILLER_5_91 vssd1 vssd1 vccd1 vccd1 sky130_fd_sc_hd__fill_8
XFILLER_1_49 vssd1 vssd1 vccd1 vccd1 sky130_fd_sc_hd__fill_4
Xinput4 gpio_in[2] vssd1 vssd1 vccd1 vccd1 _479_/D sky130_fd_sc_hd__clkdlybuf4s25_1
X_426_ _467_/CLK _426_/D load_slew42/X vssd1 vssd1 vccd1 vccd1 _426_/Q sky130_fd_sc_hd__dfrtp_2
X_357_ _448_/Q _357_/B vssd1 vssd1 vccd1 vccd1 _448_/D sky130_fd_sc_hd__xor2_2
X_288_ _288_/A _288_/B vssd1 vssd1 vccd1 vccd1 _288_/Y sky130_fd_sc_hd__xnor2_2
XFILLER_27_110 vssd1 vssd1 vccd1 vccd1 sky130_fd_sc_hd__fill_2
XFILLER_27_121 vssd1 vssd1 vccd1 vccd1 sky130_fd_sc_hd__fill_2
X_211_ _211_/A1 _213_/A _210_/Y vssd1 vssd1 vccd1 vccd1 _211_/Y sky130_fd_sc_hd__a21oi_2
X_409_ _411_/A _446_/Q vssd1 vssd1 vccd1 vccd1 _409_/X sky130_fd_sc_hd__and2_2
XFILLER_15_113 vssd1 vssd1 vccd1 vccd1 sky130_fd_sc_hd__fill_1
XFILLER_30_149 vssd1 vssd1 vccd1 vccd1 sky130_fd_sc_hd__fill_2
XFILLER_7_15 vssd1 vssd1 vccd1 vccd1 sky130_fd_sc_hd__fill_2
XTAP_TAPCELL_ROW_31_177 vssd1 vccd1 sky130_fd_sc_hd__tapvpwrvgnd_1
XFILLER_20_193 vssd1 vssd1 vccd1 vccd1 sky130_fd_sc_hd__fill_2
XTAP_TAPCELL_ROW_22_144 vssd1 vccd1 sky130_fd_sc_hd__tapvpwrvgnd_1
XFILLER_7_164 vssd1 vssd1 vccd1 vccd1 sky130_fd_sc_hd__fill_2
Xhold109 _481_/Q vssd1 vssd1 vccd1 vccd1 _482_/D sky130_fd_sc_hd__dlygate4sd3_1
X_390_ _460_/Q _412_/A2 _412_/B1 _390_/B2 _389_/X vssd1 vssd1 vccd1 vccd1 _460_/D
+ sky130_fd_sc_hd__a221o_2
XFILLER_4_101 vssd1 vssd1 vccd1 vccd1 sky130_fd_sc_hd__fill_2
XFILLER_4_27 vssd1 vssd1 vccd1 vccd1 sky130_fd_sc_hd__fill_1
XTAP_TAPCELL_ROW_10_103 vssd1 vccd1 sky130_fd_sc_hd__tapvpwrvgnd_1
XTAP_TAPCELL_ROW_4_81 vssd1 vccd1 sky130_fd_sc_hd__tapvpwrvgnd_1
Xfanout48 fanout50/X vssd1 vssd1 vccd1 vccd1 fanout48/X sky130_fd_sc_hd__clkdlybuf4s25_1
Xfanout37 fanout40/X vssd1 vssd1 vccd1 vccd1 fanout37/X sky130_fd_sc_hd__clkdlybuf4s25_1
X_442_ _484_/CLK _442_/D fanout47/X vssd1 vssd1 vccd1 vccd1 _442_/Q sky130_fd_sc_hd__dfrtp_2
X_373_ _262_/B _366_/B _366_/Y _372_/X vssd1 vssd1 vccd1 vccd1 _454_/D sky130_fd_sc_hd__a22o_2
XFILLER_24_57 vssd1 vssd1 vccd1 vccd1 sky130_fd_sc_hd__fill_1
XTAP_TAPCELL_ROW_1_71 vssd1 vccd1 sky130_fd_sc_hd__tapvpwrvgnd_1
Xinput5 gpio_in[3] vssd1 vssd1 vccd1 vccd1 _477_/D sky130_fd_sc_hd__clkdlybuf4s25_1
X_425_ _463_/CLK _425_/D fanout41/X vssd1 vssd1 vccd1 vccd1 _425_/Q sky130_fd_sc_hd__dfrtp_2
X_356_ _356_/A0 _355_/Y _356_/S vssd1 vssd1 vccd1 vccd1 _447_/D sky130_fd_sc_hd__mux2_1
X_287_ _344_/A _458_/Q vssd1 vssd1 vccd1 vccd1 _288_/B sky130_fd_sc_hd__xor2_2
XFILLER_19_57 vssd1 vssd1 vccd1 vccd1 sky130_fd_sc_hd__fill_2
XFILLER_27_166 vssd1 vssd1 vccd1 vccd1 sky130_fd_sc_hd__fill_2
XFILLER_18_122 vssd1 vssd1 vccd1 vccd1 sky130_fd_sc_hd__fill_1
XFILLER_18_133 vssd1 vssd1 vccd1 vccd1 sky130_fd_sc_hd__fill_4
XPHY_EDGE_ROW_27_Left_59 vssd1 vssd1 vccd1 vccd1 sky130_fd_sc_hd__decap_3
X_210_ _427_/Q _213_/A _209_/B vssd1 vssd1 vccd1 vccd1 _210_/Y sky130_fd_sc_hd__o21ai_2
X_408_ _410_/B2 _412_/A2 _412_/B1 _408_/B2 _407_/X vssd1 vssd1 vccd1 vccd1 _469_/D
+ sky130_fd_sc_hd__a221o_2
X_339_ _291_/Y _325_/Y _332_/X _318_/Y vssd1 vssd1 vccd1 vccd1 _341_/A sky130_fd_sc_hd__o22ai_2
XFILLER_15_147 vssd1 vssd1 vccd1 vccd1 sky130_fd_sc_hd__fill_2
XFILLER_15_158 vssd1 vssd1 vccd1 vccd1 sky130_fd_sc_hd__fill_8
XFILLER_30_139 vssd1 vssd1 vccd1 vccd1 sky130_fd_sc_hd__fill_1
XFILLER_14_180 vssd1 vssd1 vccd1 vccd1 sky130_fd_sc_hd__fill_1
XFILLER_21_139 vssd1 vssd1 vccd1 vccd1 sky130_fd_sc_hd__fill_1
XTAP_TAPCELL_ROW_31_178 vssd1 vccd1 sky130_fd_sc_hd__tapvpwrvgnd_1
XTAP_TAPCELL_ROW_7_92 vssd1 vccd1 sky130_fd_sc_hd__tapvpwrvgnd_1
XTAP_TAPCELL_ROW_22_145 vssd1 vccd1 sky130_fd_sc_hd__tapvpwrvgnd_1
XANTENNA__406__B1 _406_/B1 vssd1 vssd1 vccd1 vccd1 sky130_fd_sc_hd__diode_2
XFILLER_7_121 vssd1 vssd1 vccd1 vccd1 sky130_fd_sc_hd__fill_2
XFILLER_27_57 vssd1 vssd1 vccd1 vccd1 sky130_fd_sc_hd__fill_8
XPHY_EDGE_ROW_14_Left_46 vssd1 vssd1 vccd1 vccd1 sky130_fd_sc_hd__decap_3
XTAP_TAPCELL_ROW_10_104 vssd1 vccd1 sky130_fd_sc_hd__tapvpwrvgnd_1
XTAP_TAPCELL_ROW_4_82 vssd1 vccd1 sky130_fd_sc_hd__tapvpwrvgnd_1
XFILLER_13_59 vssd1 vssd1 vccd1 vccd1 sky130_fd_sc_hd__fill_1
X_441_ _484_/CLK _441_/D fanout40/X vssd1 vssd1 vccd1 vccd1 _441_/Q sky130_fd_sc_hd__dfrtp_2
X_372_ _435_/Q _439_/Q _443_/Q _447_/Q _448_/Q _449_/Q vssd1 vssd1 vccd1 vccd1 _372_/X
+ sky130_fd_sc_hd__mux4_2
XFILLER_24_47 vssd1 vssd1 vccd1 vccd1 sky130_fd_sc_hd__fill_2
XFILLER_5_71 vssd1 vccd1 vssd1 vccd1 sky130_ef_sc_hd__decap_40_12
XTAP_TAPCELL_ROW_1_72 vssd1 vccd1 sky130_fd_sc_hd__tapvpwrvgnd_1
X_424_ _467_/CLK _424_/D load_slew42/X vssd1 vssd1 vccd1 vccd1 _424_/Q sky130_fd_sc_hd__dfrtp_2
X_355_ _471_/Q _355_/B vssd1 vssd1 vccd1 vccd1 _355_/Y sky130_fd_sc_hd__xnor2_2
X_286_ _385_/A _435_/Q _286_/C vssd1 vssd1 vccd1 vccd1 _288_/A sky130_fd_sc_hd__or3_2
Xinput6 nrst vssd1 vssd1 vccd1 vccd1 _229_/A sky130_fd_sc_hd__clkdlybuf4s25_1
XPHY_EDGE_ROW_14_Right_14 vssd1 vssd1 vccd1 vccd1 sky130_fd_sc_hd__decap_3
XPHY_EDGE_ROW_23_Right_23 vssd1 vssd1 vccd1 vccd1 sky130_fd_sc_hd__decap_3
XPHY_EDGE_ROW_2_Left_34 vssd1 vssd1 vccd1 vccd1 sky130_fd_sc_hd__decap_3
Xclkbuf_3_3__f_clk clkbuf_0_clk/X vssd1 vssd1 vccd1 vccd1 _467_/CLK sky130_fd_sc_hd__clkbuf_16
X_269_ _262_/B _259_/X _268_/X vssd1 vssd1 vccd1 vccd1 _269_/Y sky130_fd_sc_hd__o21ai_2
X_407_ _411_/A _445_/Q vssd1 vssd1 vccd1 vccd1 _407_/X sky130_fd_sc_hd__and2_2
X_338_ _338_/A0 _337_/Y _346_/S vssd1 vssd1 vccd1 vccd1 _442_/D sky130_fd_sc_hd__mux2_1
XFILLER_30_129 vssd1 vssd1 vccd1 vccd1 sky130_fd_sc_hd__fill_8
XANTENNA__280__A _344_/A vssd1 vssd1 vccd1 vccd1 sky130_fd_sc_hd__diode_2
XFILLER_30_9 vssd1 vccd1 vssd1 vccd1 sky130_ef_sc_hd__decap_40_12
XFILLER_7_17 vssd1 vssd1 vccd1 vccd1 sky130_fd_sc_hd__fill_1
XTAP_TAPCELL_ROW_31_179 vssd1 vccd1 sky130_fd_sc_hd__tapvpwrvgnd_1
XTAP_TAPCELL_ROW_7_93 vssd1 vccd1 sky130_fd_sc_hd__tapvpwrvgnd_1
XFILLER_16_26 vssd1 vssd1 vccd1 vccd1 sky130_fd_sc_hd__fill_2
XFILLER_16_37 vssd1 vssd1 vccd1 vccd1 sky130_fd_sc_hd__fill_8
XFILLER_20_195 vssd1 vssd1 vccd1 vccd1 sky130_fd_sc_hd__fill_1
XTAP_TAPCELL_ROW_22_146 vssd1 vccd1 sky130_fd_sc_hd__tapvpwrvgnd_1
XFILLER_11_151 vssd1 vssd1 vccd1 vccd1 sky130_fd_sc_hd__fill_4
XTAP_TAPCELL_ROW_13_113 vssd1 vccd1 sky130_fd_sc_hd__tapvpwrvgnd_1
XPHY_EDGE_ROW_4_Right_4 vssd1 vssd1 vccd1 vccd1 sky130_fd_sc_hd__decap_3
XFILLER_27_36 vssd1 vssd1 vccd1 vccd1 sky130_fd_sc_hd__fill_1
XFILLER_4_103 vssd1 vssd1 vccd1 vccd1 sky130_fd_sc_hd__fill_1
XPHY_EDGE_ROW_31_Left_63 vssd1 vssd1 vccd1 vccd1 sky130_fd_sc_hd__decap_3
XTAP_TAPCELL_ROW_10_105 vssd1 vccd1 sky130_fd_sc_hd__tapvpwrvgnd_1
XFILLER_16_210 vssd1 vssd1 vccd1 vccd1 sky130_fd_sc_hd__fill_2
XTAP_TAPCELL_ROW_4_83 vssd1 vccd1 sky130_fd_sc_hd__tapvpwrvgnd_1
Xfanout39 fanout40/X vssd1 vssd1 vccd1 vccd1 fanout39/X sky130_fd_sc_hd__clkdlybuf4s25_1
Xfanout28 _454_/Q vssd1 vssd1 vccd1 vccd1 _262_/B sky130_fd_sc_hd__clkdlybuf4s25_1
X_440_ _467_/CLK _440_/D wire44/X vssd1 vssd1 vccd1 vccd1 _440_/Q sky130_fd_sc_hd__dfrtp_2
X_371_ _453_/Q _366_/B _366_/Y _370_/X vssd1 vssd1 vccd1 vccd1 _453_/D sky130_fd_sc_hd__a22o_2
XFILLER_0_194 vssd1 vssd1 vccd1 vccd1 sky130_fd_sc_hd__fill_2
XFILLER_5_61 vssd1 vssd1 vccd1 vccd1 sky130_fd_sc_hd__fill_1
XFILLER_5_83 vssd1 vssd1 vccd1 vccd1 sky130_fd_sc_hd__fill_2
X_423_ _478_/CLK _423_/D load_slew42/X vssd1 vssd1 vccd1 vccd1 _423_/Q sky130_fd_sc_hd__dfrtp_2
X_354_ _319_/X _320_/Y _325_/Y vssd1 vssd1 vccd1 vccd1 _355_/B sky130_fd_sc_hd__a21o_2
X_285_ _319_/A _283_/X _284_/X vssd1 vssd1 vccd1 vccd1 _286_/C sky130_fd_sc_hd__a21oi_2
XTAP_TAPCELL_ROW_1_73 vssd1 vccd1 sky130_fd_sc_hd__tapvpwrvgnd_1
XFILLER_27_113 vssd1 vssd1 vccd1 vccd1 sky130_fd_sc_hd__fill_8
X_199_ _199_/A _215_/A vssd1 vssd1 vccd1 vccd1 _239_/A sky130_fd_sc_hd__nor2_2
X_268_ _262_/B _256_/B _249_/X _453_/Q vssd1 vssd1 vccd1 vccd1 _268_/X sky130_fd_sc_hd__a2bb2o_2
X_406_ _468_/Q _406_/A2 _406_/B1 _406_/B2 _405_/X vssd1 vssd1 vccd1 vccd1 _406_/X
+ sky130_fd_sc_hd__a221o_2
X_337_ _466_/Q _337_/B vssd1 vssd1 vccd1 vccd1 _337_/Y sky130_fd_sc_hd__xnor2_2
XFILLER_17_190 vssd1 vssd1 vccd1 vccd1 sky130_fd_sc_hd__fill_1
Xmax_cap25 _332_/C vssd1 vssd1 vccd1 vccd1 _296_/B sky130_fd_sc_hd__clkdlybuf4s25_1
XFILLER_15_127 vssd1 vssd1 vccd1 vccd1 sky130_fd_sc_hd__fill_8
XFILLER_15_149 vssd1 vssd1 vccd1 vccd1 sky130_fd_sc_hd__fill_1
XFILLER_21_108 vssd1 vssd1 vccd1 vccd1 sky130_fd_sc_hd__fill_2
XTAP_TAPCELL_ROW_25_155 vssd1 vccd1 sky130_fd_sc_hd__tapvpwrvgnd_1
Xteam_01_90 vssd1 vssd1 vccd1 vccd1 gpio_oeb[1] team_01_90/LO sky130_fd_sc_hd__conb_1
XFILLER_14_193 vssd1 vssd1 vccd1 vccd1 sky130_fd_sc_hd__fill_2
XTAP_TAPCELL_ROW_22_147 vssd1 vccd1 sky130_fd_sc_hd__tapvpwrvgnd_1
XTAP_TAPCELL_ROW_7_94 vssd1 vccd1 sky130_fd_sc_hd__tapvpwrvgnd_1
XANTENNA__406__A2 _406_/A2 vssd1 vssd1 vccd1 vccd1 sky130_fd_sc_hd__diode_2
XFILLER_11_163 vssd1 vssd1 vccd1 vccd1 sky130_fd_sc_hd__fill_4
XTAP_TAPCELL_ROW_13_114 vssd1 vccd1 sky130_fd_sc_hd__tapvpwrvgnd_1
XFILLER_8_94 vssd1 vssd1 vccd1 vccd1 sky130_fd_sc_hd__fill_4
XFILLER_17_81 vssd1 vssd1 vccd1 vccd1 sky130_fd_sc_hd__fill_1
XTAP_TAPCELL_ROW_4_84 vssd1 vccd1 sky130_fd_sc_hd__tapvpwrvgnd_1
XFILLER_13_28 vssd1 vssd1 vccd1 vccd1 sky130_fd_sc_hd__fill_4
XFILLER_1_129 vssd1 vssd1 vccd1 vccd1 sky130_fd_sc_hd__fill_1
Xfanout29 _434_/Q vssd1 vssd1 vccd1 vccd1 _385_/A sky130_fd_sc_hd__clkdlybuf4s25_1
X_370_ _434_/Q _438_/Q _442_/Q _446_/Q _448_/Q _449_/Q vssd1 vssd1 vccd1 vccd1 _370_/X
+ sky130_fd_sc_hd__mux4_2
XFILLER_24_27 vssd1 vssd1 vccd1 vccd1 sky130_fd_sc_hd__fill_1
X_422_ _463_/CLK _422_/D fanout41/X vssd1 vssd1 vccd1 vccd1 _422_/Q sky130_fd_sc_hd__dfrtp_2
X_353_ _353_/A0 _352_/Y _356_/S vssd1 vssd1 vccd1 vccd1 _446_/D sky130_fd_sc_hd__mux2_1
X_284_ _311_/A _326_/B _484_/Q vssd1 vssd1 vccd1 vccd1 _284_/X sky130_fd_sc_hd__and3b_2
XFILLER_5_210 vssd1 vssd1 vccd1 vccd1 sky130_fd_sc_hd__fill_2
XANTENNA__323__S _346_/S vssd1 vssd1 vccd1 vccd1 sky130_fd_sc_hd__diode_2
XFILLER_10_29 vssd1 vssd1 vccd1 vccd1 sky130_fd_sc_hd__fill_2
XFILLER_27_169 vssd1 vccd1 vssd1 vccd1 sky130_ef_sc_hd__decap_40_12
X_198_ _424_/Q _422_/Q _423_/Q vssd1 vssd1 vccd1 vccd1 _215_/A sky130_fd_sc_hd__nand3_2
X_267_ _267_/A _267_/B vssd1 vssd1 vccd1 vccd1 _267_/Y sky130_fd_sc_hd__nand2_2
X_405_ _405_/A _444_/Q vssd1 vssd1 vccd1 vccd1 _405_/X sky130_fd_sc_hd__and2_2
X_336_ _385_/A _286_/C _325_/Y _332_/X _313_/Y vssd1 vssd1 vccd1 vccd1 _337_/B sky130_fd_sc_hd__o32a_2
XFILLER_24_139 vssd1 vssd1 vccd1 vccd1 sky130_fd_sc_hd__fill_1
XFILLER_11_50 vssd1 vssd1 vccd1 vccd1 sky130_fd_sc_hd__fill_4
XTAP_TAPCELL_ROW_25_156 vssd1 vccd1 sky130_fd_sc_hd__tapvpwrvgnd_1
Xteam_01_80 vssd1 vssd1 vccd1 vccd1 team_01_80/HI gpio_out[25] sky130_fd_sc_hd__conb_1
Xteam_01_91 vssd1 vssd1 vccd1 vccd1 gpio_oeb[2] team_01_91/LO sky130_fd_sc_hd__conb_1
XTAP_TAPCELL_ROW_16_123 vssd1 vccd1 sky130_fd_sc_hd__tapvpwrvgnd_1
X_319_ _319_/A _385_/A _318_/B vssd1 vssd1 vccd1 vccd1 _319_/X sky130_fd_sc_hd__or3b_2
XFILLER_12_109 vssd1 vssd1 vccd1 vccd1 sky130_fd_sc_hd__fill_2
XFILLER_20_197 vssd1 vccd1 vssd1 vccd1 sky130_ef_sc_hd__decap_40_12
XFILLER_7_113 vssd1 vssd1 vccd1 vccd1 sky130_fd_sc_hd__fill_8
XFILLER_7_157 vssd1 vssd1 vccd1 vccd1 sky130_fd_sc_hd__fill_1
XTAP_TAPCELL_ROW_13_115 vssd1 vccd1 sky130_fd_sc_hd__tapvpwrvgnd_1
XANTENNA__331__S _346_/S vssd1 vssd1 vccd1 vccd1 sky130_fd_sc_hd__diode_2
XFILLER_12_3 vssd1 vssd1 vccd1 vccd1 sky130_fd_sc_hd__fill_1
XFILLER_22_204 vssd1 vssd1 vccd1 vccd1 sky130_fd_sc_hd__fill_8
XFILLER_0_141 vssd1 vccd1 vssd1 vccd1 sky130_ef_sc_hd__decap_40_12
X_421_ _463_/CLK _421_/D load_slew42/X vssd1 vssd1 vccd1 vccd1 _421_/Q sky130_fd_sc_hd__dfrtp_2
X_352_ _352_/A _352_/B vssd1 vssd1 vccd1 vccd1 _352_/Y sky130_fd_sc_hd__xnor2_2
X_283_ _480_/Q _482_/Q _311_/A vssd1 vssd1 vccd1 vccd1 _283_/X sky130_fd_sc_hd__mux2_1
XANTENNA__381__B1 _406_/A2 vssd1 vssd1 vccd1 vccd1 sky130_fd_sc_hd__diode_2
XFILLER_18_137 vssd1 vssd1 vccd1 vccd1 sky130_fd_sc_hd__fill_2
XTAP_TAPCELL_ROW_28_165 vssd1 vccd1 sky130_fd_sc_hd__tapvpwrvgnd_1
X_197_ _431_/Q vssd1 vssd1 vccd1 vccd1 _366_/B sky130_fd_sc_hd__inv_2
X_266_ _267_/B _266_/B vssd1 vssd1 vccd1 vccd1 _266_/Y sky130_fd_sc_hd__xnor2_2
X_404_ _406_/B2 _406_/A2 _406_/B1 _404_/B2 _403_/X vssd1 vssd1 vccd1 vccd1 _467_/D
+ sky130_fd_sc_hd__a221o_2
X_335_ _335_/A0 _334_/X _346_/S vssd1 vssd1 vccd1 vccd1 _441_/D sky130_fd_sc_hd__mux2_1
XPHY_EDGE_ROW_10_Right_10 vssd1 vssd1 vccd1 vccd1 sky130_fd_sc_hd__decap_3
XANTENNA__395__A _405_/A vssd1 vssd1 vccd1 vccd1 sky130_fd_sc_hd__diode_2
XFILLER_11_84 vssd1 vccd1 vssd1 vccd1 sky130_ef_sc_hd__decap_40_12
XPHY_EDGE_ROW_6_Left_38 vssd1 vssd1 vccd1 vccd1 sky130_fd_sc_hd__decap_3
XTAP_TAPCELL_ROW_25_157 vssd1 vccd1 sky130_fd_sc_hd__tapvpwrvgnd_1
Xmax_cap27 _462_/Q vssd1 vssd1 vccd1 vccd1 _344_/A sky130_fd_sc_hd__buf_8
Xteam_01_70 vssd1 vssd1 vccd1 vccd1 team_01_70/HI gpio_out[3] sky130_fd_sc_hd__conb_1
Xteam_01_81 vssd1 vssd1 vccd1 vccd1 team_01_81/HI gpio_out[26] sky130_fd_sc_hd__conb_1
Xteam_01_92 vssd1 vssd1 vccd1 vccd1 gpio_oeb[3] team_01_92/LO sky130_fd_sc_hd__conb_1
XFILLER_14_195 vssd1 vssd1 vccd1 vccd1 sky130_fd_sc_hd__fill_1
XTAP_TAPCELL_ROW_16_124 vssd1 vccd1 sky130_fd_sc_hd__tapvpwrvgnd_1
X_249_ _452_/Q _451_/Q vssd1 vssd1 vccd1 vccd1 _249_/X sky130_fd_sc_hd__and2b_2
X_318_ _326_/B _318_/B vssd1 vssd1 vccd1 vccd1 _318_/Y sky130_fd_sc_hd__nand2_2
Xteam_01_100 vssd1 vssd1 vccd1 vccd1 gpio_oeb[27] team_01_100/LO sky130_fd_sc_hd__conb_1
XFILLER_22_83 vssd1 vssd1 vccd1 vccd1 sky130_fd_sc_hd__fill_1
XFILLER_8_52 vssd1 vccd1 vssd1 vccd1 sky130_ef_sc_hd__decap_40_12
XFILLER_8_85 vssd1 vssd1 vccd1 vccd1 sky130_fd_sc_hd__fill_2
XPHY_EDGE_ROW_9_Left_41 vssd1 vssd1 vccd1 vccd1 sky130_fd_sc_hd__decap_3
XFILLER_3_150 vssd1 vssd1 vccd1 vccd1 sky130_fd_sc_hd__fill_2
XPHY_EDGE_ROW_8_Right_8 vssd1 vssd1 vccd1 vccd1 sky130_fd_sc_hd__decap_3
XANTENNA__342__S _346_/S vssd1 vssd1 vccd1 vccd1 sky130_fd_sc_hd__diode_2
XFILLER_0_153 vssd1 vssd1 vccd1 vccd1 sky130_fd_sc_hd__fill_4
XFILLER_0_197 vssd1 vssd1 vccd1 vccd1 sky130_fd_sc_hd__fill_4
XFILLER_24_29 vssd1 vssd1 vccd1 vccd1 sky130_fd_sc_hd__fill_4
XFILLER_30_61 vssd1 vssd1 vccd1 vccd1 sky130_fd_sc_hd__fill_1
XFILLER_30_83 vssd1 vssd1 vccd1 vccd1 sky130_fd_sc_hd__fill_1
X_420_ _468_/CLK _420_/D load_slew49/X vssd1 vssd1 vccd1 vccd1 _420_/Q sky130_fd_sc_hd__dfrtp_2
X_351_ _462_/Q _470_/Q vssd1 vssd1 vccd1 vccd1 _352_/B sky130_fd_sc_hd__xor2_2
X_282_ _326_/B _281_/Y _346_/S vssd1 vssd1 vccd1 vccd1 _433_/D sky130_fd_sc_hd__mux2_1
XTAP_TAPCELL_ROW_28_166 vssd1 vccd1 sky130_fd_sc_hd__tapvpwrvgnd_1
X_403_ _405_/A _443_/Q vssd1 vssd1 vccd1 vccd1 _403_/X sky130_fd_sc_hd__and2_2
X_334_ _465_/Q _334_/B vssd1 vssd1 vccd1 vccd1 _334_/X sky130_fd_sc_hd__xor2_2
XFILLER_2_65 vssd1 vssd1 vccd1 vccd1 sky130_fd_sc_hd__fill_4
XPHY_EDGE_ROW_22_Left_54 vssd1 vssd1 vccd1 vccd1 sky130_fd_sc_hd__decap_3
X_196_ _449_/Q vssd1 vssd1 vccd1 vccd1 _365_/A sky130_fd_sc_hd__inv_2
X_265_ _451_/Q _262_/B _264_/B _261_/X vssd1 vssd1 vccd1 vccd1 _266_/B sky130_fd_sc_hd__o22a_2
XFILLER_23_185 vssd1 vssd1 vccd1 vccd1 sky130_fd_sc_hd__fill_4
Xteam_01_60 vssd1 vssd1 vccd1 vccd1 team_01_60/HI gpio_oeb[17] sky130_fd_sc_hd__conb_1
Xteam_01_71 vssd1 vssd1 vccd1 vccd1 team_01_71/HI gpio_out[4] sky130_fd_sc_hd__conb_1
Xteam_01_82 vssd1 vssd1 vccd1 vccd1 team_01_82/HI gpio_out[27] sky130_fd_sc_hd__conb_1
Xteam_01_93 vssd1 vssd1 vccd1 vccd1 gpio_oeb[4] team_01_93/LO sky130_fd_sc_hd__conb_1
XFILLER_11_96 vssd1 vccd1 vssd1 vccd1 sky130_ef_sc_hd__decap_40_12
XTAP_TAPCELL_ROW_16_125 vssd1 vccd1 sky130_fd_sc_hd__tapvpwrvgnd_1
X_248_ _239_/B _205_/X _424_/D vssd1 vssd1 vccd1 vccd1 _421_/D sky130_fd_sc_hd__o21a_2
X_317_ _317_/A0 _316_/Y _356_/S vssd1 vssd1 vccd1 vccd1 _438_/D sky130_fd_sc_hd__mux2_1
XTAP_TAPCELL_ROW_30_172 vssd1 vccd1 sky130_fd_sc_hd__tapvpwrvgnd_1
XFILLER_7_104 vssd1 vssd1 vccd1 vccd1 sky130_fd_sc_hd__fill_1
Xteam_01_101 vssd1 vssd1 vccd1 vccd1 gpio_oeb[28] team_01_101/LO sky130_fd_sc_hd__conb_1
XANTENNA_max_cap27_X _344_/A vssd1 vssd1 vccd1 vccd1 sky130_fd_sc_hd__diode_2
XFILLER_6_181 vssd1 vssd1 vccd1 vccd1 sky130_fd_sc_hd__fill_2
XFILLER_6_192 vssd1 vssd1 vccd1 vccd1 sky130_fd_sc_hd__fill_4
XFILLER_8_64 vssd1 vssd1 vccd1 vccd1 sky130_fd_sc_hd__fill_4
XFILLER_8_75 vssd1 vssd1 vccd1 vccd1 sky130_fd_sc_hd__fill_1
XFILLER_28_72 vssd1 vccd1 vssd1 vccd1 sky130_ef_sc_hd__decap_40_12
XFILLER_5_21 vssd1 vssd1 vccd1 vccd1 sky130_fd_sc_hd__fill_1
XFILLER_10_209 vssd1 vssd1 vccd1 vccd1 sky130_fd_sc_hd__fill_2
XFILLER_5_43 vssd1 vssd1 vccd1 vccd1 sky130_fd_sc_hd__fill_4
XFILLER_5_202 vssd1 vssd1 vccd1 vccd1 sky130_fd_sc_hd__fill_8
X_350_ _350_/A _350_/B vssd1 vssd1 vccd1 vccd1 _352_/A sky130_fd_sc_hd__nand2_2
X_281_ _281_/A _281_/B vssd1 vssd1 vccd1 vccd1 _281_/Y sky130_fd_sc_hd__xnor2_2
X_479_ _484_/CLK _479_/D fanout37/X vssd1 vssd1 vccd1 vccd1 _479_/Q sky130_fd_sc_hd__dfrtp_2
XANTENNA__381__A2 _405_/A vssd1 vssd1 vccd1 vccd1 sky130_fd_sc_hd__diode_2
XFILLER_18_139 vssd1 vssd1 vccd1 vccd1 sky130_fd_sc_hd__fill_1
XFILLER_2_205 vssd1 vssd1 vccd1 vccd1 sky130_fd_sc_hd__fill_1
XFILLER_17_150 vssd1 vssd1 vccd1 vccd1 sky130_fd_sc_hd__fill_4
XFILLER_2_33 vssd1 vssd1 vccd1 vccd1 sky130_fd_sc_hd__fill_2
XTAP_TAPCELL_ROW_19_134 vssd1 vccd1 sky130_fd_sc_hd__tapvpwrvgnd_1
XTAP_TAPCELL_ROW_28_167 vssd1 vccd1 sky130_fd_sc_hd__tapvpwrvgnd_1
X_195_ _385_/A vssd1 vssd1 vccd1 vccd1 _332_/A sky130_fd_sc_hd__inv_2
X_264_ _451_/Q _264_/B vssd1 vssd1 vccd1 vccd1 _267_/B sky130_fd_sc_hd__or2_2
X_402_ _404_/B2 _406_/A2 _406_/B1 _402_/B2 _401_/X vssd1 vssd1 vccd1 vccd1 _466_/D
+ sky130_fd_sc_hd__a221o_2
X_333_ _385_/A _315_/A _307_/B _350_/B _279_/B vssd1 vssd1 vccd1 vccd1 _334_/B sky130_fd_sc_hd__a32o_2
Xteam_01_61 vssd1 vssd1 vccd1 vccd1 team_01_61/HI gpio_oeb[18] sky130_fd_sc_hd__conb_1
Xteam_01_72 vssd1 vssd1 vccd1 vccd1 team_01_72/HI gpio_out[5] sky130_fd_sc_hd__conb_1
Xteam_01_83 vssd1 vssd1 vccd1 vccd1 team_01_83/HI gpio_out[28] sky130_fd_sc_hd__conb_1
Xteam_01_94 vssd1 vssd1 vccd1 vccd1 gpio_oeb[5] team_01_94/LO sky130_fd_sc_hd__conb_1
XTAP_TAPCELL_ROW_16_126 vssd1 vccd1 sky130_fd_sc_hd__tapvpwrvgnd_1
X_247_ _417_/Q _419_/D _416_/Q vssd1 vssd1 vccd1 vccd1 _420_/D sky130_fd_sc_hd__and3b_2
X_316_ _344_/A _316_/B vssd1 vssd1 vccd1 vccd1 _316_/Y sky130_fd_sc_hd__xnor2_2
XFILLER_20_112 vssd1 vssd1 vccd1 vccd1 sky130_fd_sc_hd__fill_1
XFILLER_20_189 vssd1 vssd1 vccd1 vccd1 sky130_fd_sc_hd__fill_4
XFILLER_28_3 vssd1 vssd1 vccd1 vccd1 sky130_fd_sc_hd__fill_8
XTAP_TAPCELL_ROW_30_173 vssd1 vccd1 sky130_fd_sc_hd__tapvpwrvgnd_1
XFILLER_11_167 vssd1 vssd1 vccd1 vccd1 sky130_fd_sc_hd__fill_1
Xteam_01_102 vssd1 vssd1 vccd1 vccd1 gpio_oeb[29] team_01_102/LO sky130_fd_sc_hd__conb_1
XFILLER_8_98 vssd1 vssd1 vccd1 vccd1 sky130_fd_sc_hd__fill_2
XFILLER_17_52 vssd1 vssd1 vccd1 vccd1 sky130_fd_sc_hd__fill_2
XFILLER_0_177 vssd1 vssd1 vccd1 vccd1 sky130_fd_sc_hd__fill_2
XFILLER_8_211 vssd1 vssd1 vccd1 vccd1 sky130_fd_sc_hd__fill_1
XFILLER_10_3 vssd1 vssd1 vccd1 vccd1 sky130_fd_sc_hd__fill_4
XFILLER_5_99 vssd1 vssd1 vccd1 vccd1 sky130_fd_sc_hd__fill_1
XANTENNA__384__B1 _406_/B1 vssd1 vssd1 vccd1 vccd1 sky130_fd_sc_hd__diode_2
XFILLER_30_41 vssd1 vccd1 vssd1 vccd1 sky130_ef_sc_hd__decap_40_12
X_280_ _344_/A _457_/Q vssd1 vssd1 vccd1 vccd1 _281_/B sky130_fd_sc_hd__xor2_2
XANTENNA__375__B1 _406_/A2 vssd1 vssd1 vccd1 vccd1 sky130_fd_sc_hd__diode_2
XFILLER_30_85 vssd1 vssd1 vccd1 vccd1 sky130_fd_sc_hd__fill_4
X_478_ _478_/CLK _478_/D load_slew38/X vssd1 vssd1 vccd1 vccd1 _478_/Q sky130_fd_sc_hd__dfrtp_2
XFILLER_25_85 vssd1 vssd1 vccd1 vccd1 sky130_fd_sc_hd__fill_2
XFILLER_26_184 vssd1 vssd1 vccd1 vccd1 sky130_fd_sc_hd__fill_4
XTAP_TAPCELL_ROW_28_168 vssd1 vccd1 sky130_fd_sc_hd__tapvpwrvgnd_1
X_194_ _326_/B vssd1 vssd1 vccd1 vccd1 _319_/A sky130_fd_sc_hd__inv_2
X_263_ _262_/B _251_/X _262_/X _451_/Q vssd1 vssd1 vccd1 vccd1 _263_/X sky130_fd_sc_hd__o2bb2a_2
X_401_ _405_/A _442_/Q vssd1 vssd1 vccd1 vccd1 _401_/X sky130_fd_sc_hd__and2_2
X_332_ _332_/A _435_/Q _332_/C vssd1 vssd1 vccd1 vccd1 _332_/X sky130_fd_sc_hd__or3_2
XANTENNA__303__A _344_/A vssd1 vssd1 vccd1 vccd1 sky130_fd_sc_hd__diode_2
XFILLER_17_162 vssd1 vssd1 vccd1 vccd1 sky130_fd_sc_hd__fill_4
XTAP_TAPCELL_ROW_19_135 vssd1 vccd1 sky130_fd_sc_hd__tapvpwrvgnd_1
Xmax_cap19 _204_/Y vssd1 vssd1 vccd1 vccd1 _209_/B sky130_fd_sc_hd__buf_1
XFILLER_11_54 vssd1 vssd1 vccd1 vccd1 sky130_fd_sc_hd__fill_2
Xteam_01_62 vssd1 vssd1 vccd1 vccd1 team_01_62/HI gpio_oeb[19] sky130_fd_sc_hd__conb_1
Xteam_01_73 vssd1 vssd1 vccd1 vccd1 team_01_73/HI gpio_out[6] sky130_fd_sc_hd__conb_1
Xteam_01_84 vssd1 vssd1 vccd1 vccd1 team_01_84/HI gpio_out[29] sky130_fd_sc_hd__conb_1
Xteam_01_95 vssd1 vssd1 vccd1 vccd1 gpio_oeb[6] team_01_95/LO sky130_fd_sc_hd__conb_1
X_246_ _246_/A _246_/B vssd1 vssd1 vccd1 vccd1 _246_/Y sky130_fd_sc_hd__nor2_2
X_315_ _315_/A _350_/A vssd1 vssd1 vccd1 vccd1 _316_/B sky130_fd_sc_hd__nand2_2
XTAP_TAPCELL_ROW_21_141 vssd1 vccd1 sky130_fd_sc_hd__tapvpwrvgnd_1
XTAP_TAPCELL_ROW_30_174 vssd1 vccd1 sky130_fd_sc_hd__tapvpwrvgnd_1
Xteam_01_103 vssd1 vssd1 vccd1 vccd1 gpio_oeb[30] team_01_103/LO sky130_fd_sc_hd__conb_1
X_229_ _229_/A _229_/B vssd1 vssd1 vccd1 vccd1 _229_/X sky130_fd_sc_hd__and2_2
Xclkbuf_3_4__f_clk clkbuf_0_clk/X vssd1 vssd1 vccd1 vccd1 _466_/CLK sky130_fd_sc_hd__clkbuf_16
X_431__107 vssd1 vssd1 vccd1 vccd1 _431_/D _431__107/LO sky130_fd_sc_hd__conb_1
XANTENNA__401__A _405_/A vssd1 vssd1 vccd1 vccd1 sky130_fd_sc_hd__diode_2
XFILLER_3_142 vssd1 vssd1 vccd1 vccd1 sky130_fd_sc_hd__fill_8
XANTENNA__282__S _346_/S vssd1 vssd1 vccd1 vccd1 sky130_fd_sc_hd__diode_2
XFILLER_0_101 vssd1 vssd1 vccd1 vccd1 sky130_fd_sc_hd__fill_2
XFILLER_28_85 vssd1 vssd1 vccd1 vccd1 sky130_fd_sc_hd__fill_1
XPHY_EDGE_ROW_17_Right_17 vssd1 vssd1 vccd1 vccd1 sky130_fd_sc_hd__decap_3
XPHY_EDGE_ROW_26_Right_26 vssd1 vssd1 vccd1 vccd1 sky130_fd_sc_hd__decap_3
XFILLER_30_53 vssd1 vssd1 vccd1 vccd1 sky130_fd_sc_hd__fill_8
XFILLER_30_75 vssd1 vssd1 vccd1 vccd1 sky130_fd_sc_hd__fill_8
X_477_ _478_/CLK _477_/D fanout37/X vssd1 vssd1 vccd1 vccd1 _477_/Q sky130_fd_sc_hd__dfrtp_2
XFILLER_25_20 vssd1 vssd1 vccd1 vccd1 sky130_fd_sc_hd__fill_2
XFILLER_25_53 vssd1 vssd1 vccd1 vccd1 sky130_fd_sc_hd__fill_2
XFILLER_26_174 vssd1 vssd1 vccd1 vccd1 sky130_fd_sc_hd__fill_2
X_193_ _193_/A vssd1 vssd1 vccd1 vccd1 _193_/Y sky130_fd_sc_hd__inv_2
X_262_ _453_/Q _262_/B _452_/Q vssd1 vssd1 vccd1 vccd1 _262_/X sky130_fd_sc_hd__or3b_2
X_400_ _465_/Q _406_/A2 _406_/B1 _400_/B2 _399_/X vssd1 vssd1 vccd1 vccd1 _400_/X
+ sky130_fd_sc_hd__a221o_2
X_331_ _331_/A0 _330_/Y _346_/S vssd1 vssd1 vccd1 vccd1 _440_/D sky130_fd_sc_hd__mux2_1
XFILLER_2_35 vssd1 vssd1 vccd1 vccd1 sky130_fd_sc_hd__fill_1
XTAP_TAPCELL_ROW_19_136 vssd1 vccd1 sky130_fd_sc_hd__tapvpwrvgnd_1
Xteam_01_52 vssd1 vssd1 vccd1 vccd1 team_01_52/HI gpio_oeb[9] sky130_fd_sc_hd__conb_1
Xteam_01_63 vssd1 vssd1 vccd1 vccd1 team_01_63/HI gpio_oeb[20] sky130_fd_sc_hd__conb_1
Xteam_01_74 vssd1 vssd1 vccd1 vccd1 team_01_74/HI gpio_out[7] sky130_fd_sc_hd__conb_1
Xteam_01_85 vssd1 vssd1 vccd1 vccd1 team_01_85/HI gpio_out[30] sky130_fd_sc_hd__conb_1
Xteam_01_96 vssd1 vssd1 vccd1 vccd1 gpio_oeb[7] team_01_96/LO sky130_fd_sc_hd__conb_1
XPHY_EDGE_ROW_26_Left_58 vssd1 vssd1 vccd1 vccd1 sky130_fd_sc_hd__decap_3
X_245_ _474_/Q _473_/Q _472_/Q _475_/Q vssd1 vssd1 vccd1 vccd1 _246_/B sky130_fd_sc_hd__a31o_2
X_314_ _272_/X _283_/X _297_/X _311_/X _319_/A _332_/A vssd1 vssd1 vccd1 vccd1 _350_/A
+ sky130_fd_sc_hd__mux4_2
XTAP_TAPCELL_ROW_30_175 vssd1 vccd1 sky130_fd_sc_hd__tapvpwrvgnd_1
Xteam_01_104 vssd1 vssd1 vccd1 vccd1 gpio_oeb[31] team_01_104/LO sky130_fd_sc_hd__conb_1
XFILLER_11_169 vssd1 vssd1 vccd1 vccd1 sky130_fd_sc_hd__fill_1
XTAP_TAPCELL_ROW_21_142 vssd1 vccd1 sky130_fd_sc_hd__tapvpwrvgnd_1
X_228_ _485_/Q _486_/Q vssd1 vssd1 vccd1 vccd1 _486_/D sky130_fd_sc_hd__xor2_2
XANTENNA__402__B1 _406_/B1 vssd1 vssd1 vccd1 vccd1 sky130_fd_sc_hd__diode_2
XFILLER_16_206 vssd1 vssd1 vccd1 vccd1 sky130_fd_sc_hd__fill_4
XFILLER_3_165 vssd1 vssd1 vccd1 vccd1 sky130_fd_sc_hd__fill_2
XPHY_EDGE_ROW_13_Left_45 vssd1 vssd1 vccd1 vccd1 sky130_fd_sc_hd__decap_3
XPHY_EDGE_ROW_29_Left_61 vssd1 vssd1 vccd1 vccd1 sky130_fd_sc_hd__decap_3
XFILLER_5_57 vssd1 vssd1 vccd1 vccd1 sky130_fd_sc_hd__fill_4
XANTENNA__375__A2 _346_/S vssd1 vssd1 vccd1 vccd1 sky130_fd_sc_hd__diode_2
XANTENNA__384__A2 _406_/A2 vssd1 vssd1 vccd1 vccd1 sky130_fd_sc_hd__diode_2
XFILLER_14_33 vssd1 vssd1 vccd1 vccd1 sky130_fd_sc_hd__fill_1
XFILLER_30_21 vssd1 vssd1 vccd1 vccd1 sky130_fd_sc_hd__fill_4
X_476_ _478_/CLK _476_/D fanout37/X vssd1 vssd1 vccd1 vccd1 _476_/Q sky130_fd_sc_hd__dfrtp_2
X_192_ _192_/A vssd1 vssd1 vccd1 vccd1 _199_/A sky130_fd_sc_hd__inv_2
X_261_ _453_/Q _452_/Q vssd1 vssd1 vccd1 vccd1 _261_/X sky130_fd_sc_hd__and2b_2
X_330_ _330_/A _330_/B vssd1 vssd1 vccd1 vccd1 _330_/Y sky130_fd_sc_hd__xnor2_2
XFILLER_2_25 vssd1 vssd1 vccd1 vccd1 sky130_fd_sc_hd__fill_2
XFILLER_2_69 vssd1 vssd1 vccd1 vccd1 sky130_fd_sc_hd__fill_1
X_459_ _466_/CLK _459_/D fanout45/X vssd1 vssd1 vccd1 vccd1 _459_/Q sky130_fd_sc_hd__dfrtp_2
XFILLER_23_167 vssd1 vssd1 vccd1 vccd1 sky130_fd_sc_hd__fill_1
XFILLER_23_189 vssd1 vssd1 vccd1 vccd1 sky130_fd_sc_hd__fill_2
Xteam_01_53 vssd1 vssd1 vccd1 vccd1 team_01_53/HI gpio_oeb[10] sky130_fd_sc_hd__conb_1
Xteam_01_64 vssd1 vssd1 vccd1 vccd1 team_01_64/HI gpio_oeb[21] sky130_fd_sc_hd__conb_1
Xteam_01_75 vssd1 vssd1 vccd1 vccd1 team_01_75/HI gpio_out[15] sky130_fd_sc_hd__conb_1
Xteam_01_86 vssd1 vssd1 vccd1 vccd1 team_01_86/HI gpio_out[31] sky130_fd_sc_hd__conb_1
Xteam_01_97 vssd1 vssd1 vccd1 vccd1 gpio_oeb[24] team_01_97/LO sky130_fd_sc_hd__conb_1
XFILLER_14_189 vssd1 vssd1 vccd1 vccd1 sky130_fd_sc_hd__fill_4
XPHY_EDGE_ROW_1_Left_33 vssd1 vssd1 vccd1 vccd1 sky130_fd_sc_hd__decap_3
XTAP_TAPCELL_ROW_24_151 vssd1 vccd1 sky130_fd_sc_hd__tapvpwrvgnd_1
X_244_ _473_/Q _472_/Q _244_/B1 vssd1 vssd1 vccd1 vccd1 _246_/A sky130_fd_sc_hd__a21oi_2
X_313_ _319_/A _297_/X _312_/X vssd1 vssd1 vccd1 vccd1 _313_/Y sky130_fd_sc_hd__o21ai_2
XFILLER_20_159 vssd1 vssd1 vccd1 vccd1 sky130_fd_sc_hd__fill_1
Xteam_01_105 vssd1 vssd1 vccd1 vccd1 gpio_oeb[32] team_01_105/LO sky130_fd_sc_hd__conb_1
XFILLER_22_33 vssd1 vssd1 vccd1 vccd1 sky130_fd_sc_hd__fill_2
XTAP_TAPCELL_ROW_21_143 vssd1 vccd1 sky130_fd_sc_hd__tapvpwrvgnd_1
XFILLER_26_3 vssd1 vssd1 vccd1 vccd1 sky130_fd_sc_hd__fill_4
XFILLER_6_141 vssd1 vccd1 vssd1 vccd1 sky130_ef_sc_hd__decap_40_12
XFILLER_8_68 vssd1 vssd1 vccd1 vccd1 sky130_fd_sc_hd__fill_1
XTAP_TAPCELL_ROW_12_110 vssd1 vccd1 sky130_fd_sc_hd__tapvpwrvgnd_1
X_227_ _475_/Q _474_/Q _473_/Q _472_/Q vssd1 vssd1 vccd1 vccd1 _475_/D sky130_fd_sc_hd__and4b_2
XFILLER_17_44 vssd1 vssd1 vccd1 vccd1 sky130_fd_sc_hd__fill_8
XFILLER_3_100 vssd1 vssd1 vccd1 vccd1 sky130_fd_sc_hd__fill_1
XANTENNA__396__B1 _406_/B1 vssd1 vssd1 vccd1 vccd1 sky130_fd_sc_hd__diode_2
XPHY_EDGE_ROW_3_Right_3 vssd1 vssd1 vccd1 vccd1 sky130_fd_sc_hd__decap_3
XFILLER_0_169 vssd1 vssd1 vccd1 vccd1 sky130_fd_sc_hd__fill_8
XPHY_EDGE_ROW_30_Left_62 vssd1 vssd1 vccd1 vccd1 sky130_fd_sc_hd__decap_3
X_475_ _478_/CLK _475_/D fanout39/X vssd1 vssd1 vccd1 vccd1 _475_/Q sky130_fd_sc_hd__dfrtp_2
XANTENNA_input5_A gpio_in[3] vssd1 vssd1 vccd1 vccd1 sky130_fd_sc_hd__diode_2
XFILLER_25_55 vssd1 vssd1 vccd1 vccd1 sky130_fd_sc_hd__fill_1
XFILLER_26_154 vssd1 vccd1 vssd1 vccd1 sky130_ef_sc_hd__decap_40_12
X_260_ _262_/B _256_/B _259_/X _249_/X _267_/A vssd1 vssd1 vccd1 vccd1 _260_/X sky130_fd_sc_hd__o32a_2
X_191_ _485_/Q vssd1 vssd1 vccd1 vccd1 _485_/D sky130_fd_sc_hd__inv_2
X_458_ _466_/CLK _458_/D fanout47/X vssd1 vssd1 vccd1 vccd1 _458_/Q sky130_fd_sc_hd__dfrtp_2
X_389_ _411_/A _436_/Q vssd1 vssd1 vccd1 vccd1 _389_/X sky130_fd_sc_hd__and2_2
XFILLER_23_102 vssd1 vssd1 vccd1 vccd1 sky130_fd_sc_hd__fill_2
Xteam_01_54 vssd1 vssd1 vccd1 vccd1 team_01_54/HI gpio_oeb[11] sky130_fd_sc_hd__conb_1
Xteam_01_65 vssd1 vssd1 vccd1 vccd1 team_01_65/HI gpio_oeb[22] sky130_fd_sc_hd__conb_1
Xteam_01_76 vssd1 vssd1 vccd1 vccd1 team_01_76/HI gpio_out[21] sky130_fd_sc_hd__conb_1
Xteam_01_87 vssd1 vssd1 vccd1 vccd1 team_01_87/HI gpio_out[32] sky130_fd_sc_hd__conb_1
Xteam_01_98 vssd1 vssd1 vccd1 vccd1 gpio_oeb[25] team_01_98/LO sky130_fd_sc_hd__conb_1
XFILLER_14_135 vssd1 vssd1 vccd1 vccd1 sky130_fd_sc_hd__fill_4
XFILLER_22_190 vssd1 vssd1 vccd1 vccd1 sky130_fd_sc_hd__fill_4
XTAP_TAPCELL_ROW_24_152 vssd1 vccd1 sky130_fd_sc_hd__tapvpwrvgnd_1
X_243_ _473_/Q _472_/Q _242_/Y vssd1 vssd1 vccd1 vccd1 _473_/D sky130_fd_sc_hd__o21a_2
X_312_ _311_/A _486_/Q _326_/B vssd1 vssd1 vccd1 vccd1 _312_/X sky130_fd_sc_hd__a21o_2
Xteam_01_106 vssd1 vssd1 vccd1 vccd1 gpio_oeb[33] team_01_106/LO sky130_fd_sc_hd__conb_1
XFILLER_19_3 vssd1 vssd1 vccd1 vccd1 sky130_fd_sc_hd__fill_4
XFILLER_6_153 vssd1 vssd1 vccd1 vccd1 sky130_fd_sc_hd__fill_1
XTAP_TAPCELL_ROW_12_111 vssd1 vccd1 sky130_fd_sc_hd__tapvpwrvgnd_1
X_226_ _226_/A1 _225_/X _235_/C vssd1 vssd1 vccd1 vccd1 _419_/D sky130_fd_sc_hd__o21a_2
XANTENNA__402__A2 _406_/A2 vssd1 vssd1 vccd1 vccd1 sky130_fd_sc_hd__diode_2
XFILLER_3_167 vssd1 vssd1 vccd1 vccd1 sky130_fd_sc_hd__fill_1
XANTENNA__396__B2 _344_/A vssd1 vssd1 vccd1 vccd1 sky130_fd_sc_hd__diode_2
XFILLER_0_81 vssd1 vssd1 vccd1 vccd1 sky130_fd_sc_hd__fill_2
XFILLER_21_200 vssd1 vccd1 vssd1 vccd1 sky130_ef_sc_hd__decap_40_12
X_209_ _209_/A _209_/B _209_/C vssd1 vssd1 vccd1 vccd1 _428_/D sky130_fd_sc_hd__and3_2
XFILLER_0_115 vssd1 vccd1 vssd1 vccd1 sky130_ef_sc_hd__decap_40_12
XFILLER_28_11 vssd1 vssd1 vccd1 vccd1 sky130_fd_sc_hd__fill_2
XFILLER_28_44 vssd1 vssd1 vccd1 vccd1 sky130_fd_sc_hd__fill_1
XPHY_EDGE_ROW_13_Right_13 vssd1 vssd1 vccd1 vccd1 sky130_fd_sc_hd__decap_3
XPHY_EDGE_ROW_22_Right_22 vssd1 vssd1 vccd1 vccd1 sky130_fd_sc_hd__decap_3
XFILLER_30_89 vssd1 vssd1 vccd1 vccd1 sky130_fd_sc_hd__fill_2
XPHY_EDGE_ROW_31_Right_31 vssd1 vssd1 vccd1 vccd1 sky130_fd_sc_hd__decap_3
X_474_ _484_/CLK _474_/D fanout39/X vssd1 vssd1 vccd1 vccd1 _474_/Q sky130_fd_sc_hd__dfrtp_2
XFILLER_26_111 vssd1 vssd1 vccd1 vccd1 sky130_fd_sc_hd__fill_1
XFILLER_17_166 vssd1 vssd1 vccd1 vccd1 sky130_fd_sc_hd__fill_2
XFILLER_17_188 vssd1 vssd1 vccd1 vccd1 sky130_fd_sc_hd__fill_2
XFILLER_25_45 vssd1 vssd1 vccd1 vccd1 sky130_fd_sc_hd__fill_8
XFILLER_26_166 vssd1 vssd1 vccd1 vccd1 sky130_fd_sc_hd__fill_8
XFILLER_2_27 vssd1 vssd1 vccd1 vccd1 sky130_fd_sc_hd__fill_1
Xteam_01_55 vssd1 vssd1 vccd1 vccd1 team_01_55/HI gpio_oeb[12] sky130_fd_sc_hd__conb_1
Xteam_01_66 vssd1 vssd1 vccd1 vccd1 team_01_66/HI gpio_oeb[23] sky130_fd_sc_hd__conb_1
Xteam_01_77 vssd1 vssd1 vccd1 vccd1 team_01_77/HI gpio_out[22] sky130_fd_sc_hd__conb_1
Xteam_01_88 vssd1 vssd1 vccd1 vccd1 team_01_88/HI gpio_out[33] sky130_fd_sc_hd__conb_1
Xteam_01_99 vssd1 vssd1 vccd1 vccd1 gpio_oeb[26] team_01_99/LO sky130_fd_sc_hd__conb_1
X_457_ _461_/CLK _457_/D fanout45/X vssd1 vssd1 vccd1 vccd1 _457_/Q sky130_fd_sc_hd__dfrtp_2
X_388_ _390_/B2 _412_/A2 _406_/B1 _458_/Q _387_/X vssd1 vssd1 vccd1 vccd1 _459_/D
+ sky130_fd_sc_hd__a221o_2
XANTENNA__344__A _344_/A vssd1 vssd1 vccd1 vccd1 sky130_fd_sc_hd__diode_2
XTAP_TAPCELL_ROW_24_153 vssd1 vccd1 sky130_fd_sc_hd__tapvpwrvgnd_1
X_242_ _473_/Q _472_/Q _242_/B1 vssd1 vssd1 vccd1 vccd1 _242_/Y sky130_fd_sc_hd__a21oi_2
X_311_ _311_/A _486_/Q vssd1 vssd1 vccd1 vccd1 _311_/X sky130_fd_sc_hd__and2_2
XTAP_TAPCELL_ROW_15_120 vssd1 vccd1 sky130_fd_sc_hd__tapvpwrvgnd_1
XFILLER_22_35 vssd1 vssd1 vccd1 vccd1 sky130_fd_sc_hd__fill_1
XFILLER_28_206 vssd1 vssd1 vccd1 vccd1 sky130_fd_sc_hd__fill_2
XTAP_TAPCELL_ROW_12_112 vssd1 vccd1 sky130_fd_sc_hd__tapvpwrvgnd_1
X_225_ _418_/Q _417_/Q _232_/B vssd1 vssd1 vccd1 vccd1 _225_/X sky130_fd_sc_hd__and3_2
XFILLER_17_24 vssd1 vssd1 vccd1 vccd1 sky130_fd_sc_hd__fill_4
XFILLER_17_57 vssd1 vssd1 vccd1 vccd1 sky130_fd_sc_hd__fill_1
XANTENNA__396__A2 _406_/A2 vssd1 vssd1 vccd1 vccd1 sky130_fd_sc_hd__diode_2
XFILLER_30_201 vssd1 vssd1 vccd1 vccd1 sky130_fd_sc_hd__fill_2
X_208_ _427_/Q _426_/Q _239_/A _428_/Q vssd1 vssd1 vccd1 vccd1 _209_/C sky130_fd_sc_hd__a31o_2
XFILLER_0_127 vssd1 vssd1 vccd1 vccd1 sky130_fd_sc_hd__fill_4
XFILLER_12_201 vssd1 vssd1 vccd1 vccd1 sky130_fd_sc_hd__fill_2
XPHY_EDGE_ROW_17_Left_49 vssd1 vssd1 vccd1 vccd1 sky130_fd_sc_hd__decap_3
X_473_ _478_/CLK _473_/D fanout39/X vssd1 vssd1 vccd1 vccd1 _473_/Q sky130_fd_sc_hd__dfrtp_2
XFILLER_6_92 vssd1 vssd1 vccd1 vccd1 sky130_fd_sc_hd__fill_2
XFILLER_25_57 vssd1 vssd1 vccd1 vccd1 sky130_fd_sc_hd__fill_8
XFILLER_2_17 vssd1 vssd1 vccd1 vccd1 sky130_fd_sc_hd__fill_8
XTAP_TAPCELL_ROW_27_162 vssd1 vccd1 sky130_fd_sc_hd__tapvpwrvgnd_1
X_456_ _461_/CLK _456_/D load_slew46/X vssd1 vssd1 vccd1 vccd1 _456_/Q sky130_fd_sc_hd__dfrtp_2
X_387_ _435_/Q _411_/A vssd1 vssd1 vccd1 vccd1 _387_/X sky130_fd_sc_hd__and2_2
XFILLER_14_159 vssd1 vssd1 vccd1 vccd1 sky130_fd_sc_hd__fill_8
XFILLER_23_115 vssd1 vssd1 vccd1 vccd1 sky130_fd_sc_hd__fill_2
Xteam_01_56 vssd1 vssd1 vccd1 vccd1 team_01_56/HI gpio_oeb[13] sky130_fd_sc_hd__conb_1
Xteam_01_67 vssd1 vssd1 vccd1 vccd1 team_01_67/HI gpio_out[0] sky130_fd_sc_hd__conb_1
Xteam_01_78 vssd1 vssd1 vccd1 vccd1 team_01_78/HI gpio_out[23] sky130_fd_sc_hd__conb_1
Xteam_01_89 vssd1 vssd1 vccd1 vccd1 gpio_oeb[0] team_01_89/LO sky130_fd_sc_hd__conb_1
X_310_ _310_/A0 _309_/Y _356_/S vssd1 vssd1 vccd1 vccd1 _437_/D sky130_fd_sc_hd__mux2_1
XTAP_TAPCELL_ROW_15_121 vssd1 vccd1 sky130_fd_sc_hd__tapvpwrvgnd_1
XTAP_TAPCELL_ROW_24_154 vssd1 vccd1 sky130_fd_sc_hd__tapvpwrvgnd_1
X_241_ _475_/Q _241_/B vssd1 vssd1 vccd1 vccd1 _241_/Y sky130_fd_sc_hd__nand2b_2
X_439_ _478_/CLK _439_/D load_slew42/X vssd1 vssd1 vccd1 vccd1 _439_/Q sky130_fd_sc_hd__dfrtp_2
XFILLER_11_118 vssd1 vccd1 vssd1 vccd1 sky130_ef_sc_hd__decap_40_12
XFILLER_9_185 vssd1 vssd1 vccd1 vccd1 sky130_fd_sc_hd__fill_4
Xwire44 wire44/A vssd1 vssd1 vccd1 vccd1 wire44/X sky130_fd_sc_hd__clkbuf_4
XPHY_EDGE_ROW_5_Left_37 vssd1 vssd1 vccd1 vccd1 sky130_fd_sc_hd__decap_3
X_224_ _417_/Q _232_/B vssd1 vssd1 vccd1 vccd1 _234_/B sky130_fd_sc_hd__and2_2
XFILLER_3_169 vssd1 vssd1 vccd1 vccd1 sky130_fd_sc_hd__fill_2
X_207_ _193_/Y _209_/A _206_/X vssd1 vssd1 vccd1 vccd1 _429_/D sky130_fd_sc_hd__a21oi_2
XFILLER_0_83 vssd1 vssd1 vccd1 vccd1 sky130_fd_sc_hd__fill_1
XPHY_EDGE_ROW_8_Left_40 vssd1 vssd1 vccd1 vccd1 sky130_fd_sc_hd__decap_3
XPHY_EDGE_ROW_7_Right_7 vssd1 vssd1 vccd1 vccd1 sky130_fd_sc_hd__decap_3
XFILLER_30_25 vssd1 vssd1 vccd1 vccd1 sky130_fd_sc_hd__fill_2
X_472_ _478_/CLK _472_/D fanout39/X vssd1 vssd1 vccd1 vccd1 _472_/Q sky130_fd_sc_hd__dfrtp_2
XFILLER_1_201 vssd1 vssd1 vccd1 vccd1 sky130_fd_sc_hd__fill_4
XFILLER_2_29 vssd1 vssd1 vccd1 vccd1 sky130_fd_sc_hd__fill_4
XTAP_TAPCELL_ROW_27_163 vssd1 vccd1 sky130_fd_sc_hd__tapvpwrvgnd_1
X_455_ _467_/CLK _455_/D wire44/X vssd1 vssd1 vccd1 vccd1 _455_/Q sky130_fd_sc_hd__dfrtp_2
X_386_ _458_/Q _406_/A2 _406_/B1 _457_/Q _385_/X vssd1 vssd1 vccd1 vccd1 _458_/D sky130_fd_sc_hd__a221o_2
XANTENNA_input3_A gpio_in[1] vssd1 vssd1 vccd1 vccd1 sky130_fd_sc_hd__diode_2
XFILLER_31_193 vssd1 vssd1 vccd1 vccd1 sky130_fd_sc_hd__fill_2
XTAP_TAPCELL_ROW_18_130 vssd1 vccd1 sky130_fd_sc_hd__tapvpwrvgnd_1
Xteam_01_57 vssd1 vssd1 vccd1 vccd1 team_01_57/HI gpio_oeb[14] sky130_fd_sc_hd__conb_1
Xteam_01_68 vssd1 vssd1 vccd1 vccd1 team_01_68/HI gpio_out[1] sky130_fd_sc_hd__conb_1
Xteam_01_79 vssd1 vssd1 vccd1 vccd1 team_01_79/HI gpio_out[24] sky130_fd_sc_hd__conb_1
X_240_ _199_/A _215_/A _239_/X vssd1 vssd1 vccd1 vccd1 _425_/D sky130_fd_sc_hd__a21oi_2
XFILLER_11_108 vssd1 vssd1 vccd1 vccd1 sky130_fd_sc_hd__fill_4
XFILLER_28_208 vssd1 vssd1 vccd1 vccd1 sky130_fd_sc_hd__fill_1
XFILLER_3_61 vssd1 vssd1 vccd1 vccd1 sky130_fd_sc_hd__fill_2
XPHY_EDGE_ROW_21_Left_53 vssd1 vssd1 vccd1 vccd1 sky130_fd_sc_hd__decap_3
XTAP_TAPCELL_ROW_15_122 vssd1 vccd1 sky130_fd_sc_hd__tapvpwrvgnd_1
X_438_ _466_/CLK _438_/D fanout47/X vssd1 vssd1 vccd1 vccd1 _438_/Q sky130_fd_sc_hd__dfrtp_2
X_369_ _452_/Q _366_/B _366_/Y _368_/X vssd1 vssd1 vccd1 vccd1 _452_/D sky130_fd_sc_hd__a22o_2
XFILLER_10_141 vssd1 vssd1 vccd1 vccd1 sky130_fd_sc_hd__fill_1
XFILLER_19_208 vssd1 vssd1 vccd1 vccd1 sky130_fd_sc_hd__fill_4
X_223_ _223_/A1 _219_/B _375_/A1 vssd1 vssd1 vccd1 vccd1 _223_/Y sky130_fd_sc_hd__a21boi_2
XFILLER_12_70 vssd1 vssd1 vccd1 vccd1 sky130_fd_sc_hd__fill_1
XFILLER_6_123 vssd1 vssd1 vccd1 vccd1 sky130_fd_sc_hd__fill_1
XFILLER_3_126 vssd1 vssd1 vccd1 vccd1 sky130_fd_sc_hd__fill_1
XFILLER_2_181 vssd1 vccd1 vssd1 vccd1 sky130_ef_sc_hd__decap_40_12
X_206_ _239_/A _205_/B _209_/B vssd1 vssd1 vccd1 vccd1 _206_/X sky130_fd_sc_hd__a21bo_2
XFILLER_0_51 vssd1 vssd1 vccd1 vccd1 sky130_fd_sc_hd__fill_4
XFILLER_12_203 vssd1 vssd1 vccd1 vccd1 sky130_fd_sc_hd__fill_1
XFILLER_8_207 vssd1 vssd1 vccd1 vccd1 sky130_fd_sc_hd__fill_4
Xclkbuf_3_5__f_clk clkbuf_0_clk/X vssd1 vssd1 vccd1 vccd1 _461_/CLK sky130_fd_sc_hd__clkbuf_16
XFILLER_29_155 vssd1 vssd1 vccd1 vccd1 sky130_fd_sc_hd__fill_4
XFILLER_29_199 vssd1 vssd1 vccd1 vccd1 sky130_fd_sc_hd__fill_4
X_471_ _471_/CLK _471_/D fanout50/X vssd1 vssd1 vccd1 vccd1 _471_/Q sky130_fd_sc_hd__dfrtp_2
XFILLER_25_15 vssd1 vssd1 vccd1 vccd1 sky130_fd_sc_hd__fill_2
XTAP_TAPCELL_ROW_27_164 vssd1 vccd1 sky130_fd_sc_hd__tapvpwrvgnd_1
X_454_ _471_/CLK _454_/D fanout50/X vssd1 vssd1 vccd1 vccd1 _454_/Q sky130_fd_sc_hd__dfrtp_2
X_385_ _385_/A _411_/A vssd1 vssd1 vccd1 vccd1 _385_/X sky130_fd_sc_hd__and2_2
XFILLER_16_180 vssd1 vssd1 vccd1 vccd1 sky130_fd_sc_hd__fill_2
XFILLER_23_117 vssd1 vssd1 vccd1 vccd1 sky130_fd_sc_hd__fill_1
XTAP_TAPCELL_ROW_18_131 vssd1 vccd1 sky130_fd_sc_hd__tapvpwrvgnd_1
Xteam_01_58 vssd1 vssd1 vccd1 vccd1 team_01_58/HI gpio_oeb[15] sky130_fd_sc_hd__conb_1
Xteam_01_69 vssd1 vssd1 vccd1 vccd1 team_01_69/HI gpio_out[2] sky130_fd_sc_hd__conb_1
XFILLER_14_139 vssd1 vssd1 vccd1 vccd1 sky130_fd_sc_hd__fill_1
XFILLER_22_194 vssd1 vssd1 vccd1 vccd1 sky130_fd_sc_hd__fill_2
XFILLER_13_194 vssd1 vssd1 vccd1 vccd1 sky130_fd_sc_hd__fill_2
XFILLER_9_154 vssd1 vssd1 vccd1 vccd1 sky130_fd_sc_hd__fill_1
X_437_ _461_/CLK _437_/D fanout45/X vssd1 vssd1 vccd1 vccd1 _437_/Q sky130_fd_sc_hd__dfrtp_2
X_368_ _433_/Q _437_/Q _441_/Q _445_/Q _448_/Q _449_/Q vssd1 vssd1 vccd1 vccd1 _368_/X
+ sky130_fd_sc_hd__mux4_2
X_299_ _273_/Y _298_/X _332_/A vssd1 vssd1 vccd1 vccd1 _300_/B sky130_fd_sc_hd__mux2_1
XFILLER_22_27 vssd1 vssd1 vccd1 vccd1 sky130_fd_sc_hd__fill_1
XPHY_EDGE_ROW_29_Right_29 vssd1 vssd1 vccd1 vccd1 sky130_fd_sc_hd__decap_3
XFILLER_10_197 vssd1 vccd1 vssd1 vccd1 sky130_ef_sc_hd__decap_40_12
XFILLER_19_7 vssd1 vssd1 vccd1 vccd1 sky130_fd_sc_hd__fill_1
XFILLER_8_29 vssd1 vssd1 vccd1 vccd1 sky130_fd_sc_hd__fill_2
X_222_ _232_/B _222_/B _235_/C vssd1 vssd1 vccd1 vccd1 _416_/D sky130_fd_sc_hd__and3b_2
X_205_ _239_/A _205_/B vssd1 vssd1 vccd1 vccd1 _205_/X sky130_fd_sc_hd__and2_2
XFILLER_0_85 vssd1 vccd1 vssd1 vccd1 sky130_ef_sc_hd__decap_40_12
XFILLER_2_193 vssd1 vssd1 vccd1 vccd1 sky130_fd_sc_hd__fill_2
XANTENNA__287__A _344_/A vssd1 vssd1 vccd1 vccd1 sky130_fd_sc_hd__diode_2
XFILLER_29_101 vssd1 vssd1 vccd1 vccd1 sky130_fd_sc_hd__fill_4
XFILLER_30_27 vssd1 vssd1 vccd1 vccd1 sky130_fd_sc_hd__fill_1
X_470_ _471_/CLK _470_/D fanout50/X vssd1 vssd1 vccd1 vccd1 _470_/Q sky130_fd_sc_hd__dfrtp_2
XANTENNA__374__B _405_/A vssd1 vssd1 vccd1 vccd1 sky130_fd_sc_hd__diode_2
XANTENNA__380__B1 _406_/B1 vssd1 vssd1 vccd1 vccd1 sky130_fd_sc_hd__diode_2
X_453_ _471_/CLK _453_/D fanout50/X vssd1 vssd1 vccd1 vccd1 _453_/Q sky130_fd_sc_hd__dfrtp_2
X_384_ _457_/Q _406_/A2 _406_/B1 _384_/B2 _383_/X vssd1 vssd1 vccd1 vccd1 _457_/D
+ sky130_fd_sc_hd__a221o_2
XFILLER_31_195 vssd1 vssd1 vccd1 vccd1 sky130_fd_sc_hd__fill_1
XFILLER_31_81 vssd1 vssd1 vccd1 vccd1 sky130_fd_sc_hd__fill_2
XTAP_TAPCELL_ROW_18_132 vssd1 vccd1 sky130_fd_sc_hd__tapvpwrvgnd_1
XTAP_TAPCELL_ROW_2_74 vssd1 vccd1 sky130_fd_sc_hd__tapvpwrvgnd_1
Xteam_01_59 vssd1 vssd1 vccd1 vccd1 team_01_59/HI gpio_oeb[16] sky130_fd_sc_hd__conb_1
XTAP_TAPCELL_ROW_9_100 vssd1 vccd1 sky130_fd_sc_hd__tapvpwrvgnd_1
XFILLER_13_162 vssd1 vssd1 vccd1 vccd1 sky130_fd_sc_hd__fill_4
XFILLER_9_122 vssd1 vccd1 vssd1 vccd1 sky130_ef_sc_hd__decap_40_12
X_436_ _461_/CLK _436_/D load_slew46/X vssd1 vssd1 vccd1 vccd1 _436_/Q sky130_fd_sc_hd__dfrtp_2
X_367_ _363_/X _365_/X _366_/Y _366_/B _451_/Q vssd1 vssd1 vccd1 vccd1 _451_/D sky130_fd_sc_hd__a32o_2
X_298_ _485_/Q _478_/Q _480_/Q _482_/Q _326_/A _326_/B vssd1 vssd1 vccd1 vccd1 _298_/X
+ sky130_fd_sc_hd__mux4_2
XFILLER_18_210 vssd1 vssd1 vccd1 vccd1 sky130_fd_sc_hd__fill_2
XFILLER_6_169 vssd1 vccd1 vssd1 vccd1 sky130_ef_sc_hd__decap_40_12
X_221_ _414_/Q _415_/Q _416_/Q vssd1 vssd1 vccd1 vccd1 _222_/B sky130_fd_sc_hd__a21o_2
XTAP_TAPCELL_ROW_8_95 vssd1 vccd1 sky130_fd_sc_hd__tapvpwrvgnd_1
X_419_ _467_/CLK _419_/D wire44/X vssd1 vssd1 vccd1 vccd1 _419_/Q sky130_fd_sc_hd__dfrtp_2
X_204_ _425_/Q _424_/Q _239_/B vssd1 vssd1 vccd1 vccd1 _204_/Y sky130_fd_sc_hd__o21ai_1
XFILLER_0_97 vssd1 vssd1 vccd1 vccd1 sky130_fd_sc_hd__fill_4
XFILLER_18_60 vssd1 vssd1 vccd1 vccd1 sky130_fd_sc_hd__fill_1
XTAP_TAPCELL_ROW_5_85 vssd1 vccd1 sky130_fd_sc_hd__tapvpwrvgnd_1
XFILLER_14_29 vssd1 vssd1 vccd1 vccd1 sky130_fd_sc_hd__fill_4
XFILLER_22_3 vssd1 vssd1 vccd1 vccd1 sky130_fd_sc_hd__fill_4
XFILLER_20_83 vssd1 vssd1 vccd1 vccd1 sky130_fd_sc_hd__fill_1
X_452_ _471_/CLK _452_/D fanout50/X vssd1 vssd1 vccd1 vccd1 _452_/Q sky130_fd_sc_hd__dfrtp_2
X_383_ _433_/Q _405_/A vssd1 vssd1 vccd1 vccd1 _383_/X sky130_fd_sc_hd__and2_2
XTAP_TAPCELL_ROW_18_133 vssd1 vccd1 sky130_fd_sc_hd__tapvpwrvgnd_1
XTAP_TAPCELL_ROW_2_75 vssd1 vccd1 sky130_fd_sc_hd__tapvpwrvgnd_1
XFILLER_11_19 vssd1 vssd1 vccd1 vccd1 sky130_fd_sc_hd__fill_1
XFILLER_22_141 vssd1 vssd1 vccd1 vccd1 sky130_fd_sc_hd__fill_2
XFILLER_26_82 vssd1 vssd1 vccd1 vccd1 sky130_fd_sc_hd__fill_2
XFILLER_9_189 vssd1 vssd1 vccd1 vccd1 sky130_fd_sc_hd__fill_2
XTAP_TAPCELL_ROW_9_101 vssd1 vccd1 sky130_fd_sc_hd__tapvpwrvgnd_1
X_435_ _466_/CLK _435_/D fanout47/X vssd1 vssd1 vccd1 vccd1 _435_/Q sky130_fd_sc_hd__dfstp_2
X_366_ _450_/Q _366_/B vssd1 vssd1 vccd1 vccd1 _366_/Y sky130_fd_sc_hd__nor2_2
X_297_ _485_/Q _478_/Q _311_/A vssd1 vssd1 vccd1 vccd1 _297_/X sky130_fd_sc_hd__mux2_1
XFILLER_22_29 vssd1 vssd1 vccd1 vccd1 sky130_fd_sc_hd__fill_4
Xwire26 _295_/Y vssd1 vssd1 vccd1 vccd1 _332_/C sky130_fd_sc_hd__clkdlybuf4s25_1
XANTENNA__335__S _346_/S vssd1 vssd1 vccd1 vccd1 sky130_fd_sc_hd__diode_2
XANTENNA_input1_A en vssd1 vssd1 vccd1 vccd1 sky130_fd_sc_hd__diode_2
XFILLER_10_111 vssd1 vssd1 vccd1 vccd1 sky130_fd_sc_hd__fill_1
XFILLER_10_122 vssd1 vssd1 vccd1 vccd1 sky130_fd_sc_hd__fill_2
X_220_ _414_/Q _415_/Q _416_/Q vssd1 vssd1 vccd1 vccd1 _232_/B sky130_fd_sc_hd__and3_2
XPHY_EDGE_ROW_25_Left_57 vssd1 vssd1 vccd1 vccd1 sky130_fd_sc_hd__decap_3
XTAP_TAPCELL_ROW_8_96 vssd1 vccd1 sky130_fd_sc_hd__tapvpwrvgnd_1
X_418_ _463_/CLK _418_/D load_slew42/X vssd1 vssd1 vccd1 vccd1 _418_/Q sky130_fd_sc_hd__dfrtp_2
X_349_ _349_/A0 _348_/Y _356_/S vssd1 vssd1 vccd1 vccd1 _445_/D sky130_fd_sc_hd__mux2_1
XFILLER_0_65 vssd1 vccd1 vssd1 vccd1 sky130_ef_sc_hd__decap_40_12
XFILLER_2_195 vssd1 vssd1 vccd1 vccd1 sky130_fd_sc_hd__fill_1
X_203_ _430_/Q _205_/B vssd1 vssd1 vccd1 vccd1 _239_/B sky130_fd_sc_hd__and2_2
XFILLER_9_52 vssd1 vssd1 vccd1 vccd1 sky130_fd_sc_hd__fill_4
XFILLER_9_85 vssd1 vccd1 vssd1 vccd1 sky130_ef_sc_hd__decap_40_12
XTAP_TAPCELL_ROW_5_86 vssd1 vccd1 sky130_fd_sc_hd__tapvpwrvgnd_1
XFILLER_30_29 vssd1 vccd1 vssd1 vccd1 sky130_ef_sc_hd__decap_40_12
XPHY_EDGE_ROW_12_Left_44 vssd1 vssd1 vccd1 vccd1 sky130_fd_sc_hd__decap_3
XPHY_EDGE_ROW_28_Left_60 vssd1 vssd1 vccd1 vccd1 sky130_fd_sc_hd__decap_3
XFILLER_20_95 vssd1 vssd1 vccd1 vccd1 sky130_fd_sc_hd__fill_2
XANTENNA__399__A _405_/A vssd1 vssd1 vccd1 vccd1 sky130_fd_sc_hd__diode_2
XFILLER_1_205 vssd1 vssd1 vccd1 vccd1 sky130_fd_sc_hd__fill_1
XANTENNA__338__S _346_/S vssd1 vssd1 vccd1 vccd1 sky130_fd_sc_hd__diode_2
XFILLER_25_183 vssd1 vssd1 vccd1 vccd1 sky130_fd_sc_hd__fill_4
XFILLER_31_61 vssd1 vssd1 vccd1 vccd1 sky130_fd_sc_hd__fill_2
XFILLER_31_83 vssd1 vssd1 vccd1 vccd1 sky130_fd_sc_hd__fill_1
XTAP_TAPCELL_ROW_2_76 vssd1 vccd1 sky130_fd_sc_hd__tapvpwrvgnd_1
X_451_ _471_/CLK _451_/D fanout50/X vssd1 vssd1 vccd1 vccd1 _451_/Q sky130_fd_sc_hd__dfrtp_2
X_382_ _378_/Y _380_/X _381_/X vssd1 vssd1 vccd1 vccd1 _456_/D sky130_fd_sc_hd__a21o_2
XFILLER_13_142 vssd1 vssd1 vccd1 vccd1 sky130_fd_sc_hd__fill_2
XFILLER_22_153 vssd1 vssd1 vccd1 vccd1 sky130_fd_sc_hd__fill_2
XFILLER_9_113 vssd1 vssd1 vccd1 vccd1 sky130_fd_sc_hd__fill_1
X_434_ _466_/CLK _434_/D fanout47/X vssd1 vssd1 vccd1 vccd1 _434_/Q sky130_fd_sc_hd__dfstp_2
X_365_ _365_/A _365_/B vssd1 vssd1 vccd1 vccd1 _365_/X sky130_fd_sc_hd__or2_2
X_296_ _435_/Q _296_/B vssd1 vssd1 vccd1 vccd1 _315_/A sky130_fd_sc_hd__nor2_2
XFILLER_12_85 vssd1 vccd1 vssd1 vccd1 sky130_ef_sc_hd__decap_40_12
XPHY_EDGE_ROW_0_Left_32 vssd1 vssd1 vccd1 vccd1 sky130_fd_sc_hd__decap_3
XTAP_TAPCELL_ROW_20_140 vssd1 vccd1 sky130_fd_sc_hd__tapvpwrvgnd_1
XPHY_EDGE_ROW_16_Right_16 vssd1 vssd1 vccd1 vccd1 sky130_fd_sc_hd__decap_3
XPHY_EDGE_ROW_25_Right_25 vssd1 vssd1 vccd1 vccd1 sky130_fd_sc_hd__decap_3
XTAP_TAPCELL_ROW_8_97 vssd1 vccd1 sky130_fd_sc_hd__tapvpwrvgnd_1
X_279_ _435_/Q _279_/B vssd1 vssd1 vccd1 vccd1 _281_/A sky130_fd_sc_hd__nand2b_2
X_417_ _467_/CLK _417_/D wire44/X vssd1 vssd1 vccd1 vccd1 _417_/Q sky130_fd_sc_hd__dfrtp_2
X_348_ _469_/Q _348_/B vssd1 vssd1 vccd1 vccd1 _348_/Y sky130_fd_sc_hd__xnor2_2
XANTENNA__346__S _346_/S vssd1 vssd1 vccd1 vccd1 sky130_fd_sc_hd__diode_2
XFILLER_2_141 vssd1 vssd1 vccd1 vccd1 sky130_fd_sc_hd__fill_2
X_202_ _428_/Q _427_/Q _426_/Q _429_/Q vssd1 vssd1 vccd1 vccd1 _205_/B sky130_fd_sc_hd__and4_2
XFILLER_0_55 vssd1 vssd1 vccd1 vccd1 sky130_fd_sc_hd__fill_1
XFILLER_0_77 vssd1 vssd1 vccd1 vccd1 sky130_fd_sc_hd__fill_4
XFILLER_9_75 vssd1 vssd1 vccd1 vccd1 sky130_fd_sc_hd__fill_1
Xclkbuf_3_0__f_clk clkbuf_0_clk/X vssd1 vssd1 vccd1 vccd1 _478_/CLK sky130_fd_sc_hd__clkbuf_16
XFILLER_7_211 vssd1 vssd1 vccd1 vccd1 sky130_fd_sc_hd__fill_1
XTAP_TAPCELL_ROW_5_87 vssd1 vccd1 sky130_fd_sc_hd__tapvpwrvgnd_1
XFILLER_29_159 vssd1 vssd1 vccd1 vccd1 sky130_fd_sc_hd__fill_1
XPHY_EDGE_ROW_2_Right_2 vssd1 vssd1 vccd1 vccd1 sky130_fd_sc_hd__decap_3
XFILLER_20_41 vssd1 vssd1 vccd1 vccd1 sky130_fd_sc_hd__fill_4
XFILLER_28_181 vssd1 vssd1 vccd1 vccd1 sky130_fd_sc_hd__fill_1
XFILLER_26_107 vssd1 vssd1 vccd1 vccd1 sky130_fd_sc_hd__fill_4
XTAP_TAPCELL_ROW_2_77 vssd1 vccd1 sky130_fd_sc_hd__tapvpwrvgnd_1
X_450_ _468_/CLK _450_/D fanout50/X vssd1 vssd1 vccd1 vccd1 _450_/Q sky130_fd_sc_hd__dfrtp_2
X_381_ _326_/A _405_/A _406_/A2 _456_/Q vssd1 vssd1 vccd1 vccd1 _381_/X sky130_fd_sc_hd__a22o_2
XFILLER_31_165 vssd1 vssd1 vccd1 vccd1 sky130_fd_sc_hd__fill_2
XFILLER_22_143 vssd1 vssd1 vccd1 vccd1 sky130_fd_sc_hd__fill_1
X_433_ _466_/CLK _433_/D fanout47/X vssd1 vssd1 vccd1 vccd1 _433_/Q sky130_fd_sc_hd__dfstp_2
XFILLER_3_88 vssd1 vccd1 vssd1 vccd1 sky130_ef_sc_hd__decap_40_12
XFILLER_9_169 vssd1 vssd1 vccd1 vccd1 sky130_fd_sc_hd__fill_1
X_364_ _440_/Q _444_/Q _448_/Q vssd1 vssd1 vccd1 vccd1 _365_/B sky130_fd_sc_hd__mux2_1
X_295_ _484_/Q _482_/Q _478_/Q _480_/Q vssd1 vssd1 vccd1 vccd1 _295_/Y sky130_fd_sc_hd__nor4_1
XFILLER_10_124 vssd1 vssd1 vccd1 vccd1 sky130_fd_sc_hd__fill_1
XFILLER_8_191 vssd1 vssd1 vccd1 vccd1 sky130_fd_sc_hd__fill_4
XFILLER_12_97 vssd1 vccd1 vssd1 vccd1 sky130_ef_sc_hd__decap_40_12
XTAP_TAPCELL_ROW_8_98 vssd1 vccd1 sky130_fd_sc_hd__tapvpwrvgnd_1
X_278_ _319_/A _332_/A _278_/C vssd1 vssd1 vccd1 vccd1 _279_/B sky130_fd_sc_hd__and3_2
X_416_ _468_/CLK _416_/D wire44/X vssd1 vssd1 vccd1 vccd1 _416_/Q sky130_fd_sc_hd__dfrtp_2
X_347_ _306_/X _307_/Y _325_/Y vssd1 vssd1 vccd1 vccd1 _348_/B sky130_fd_sc_hd__a21o_2
XFILLER_2_197 vssd1 vssd1 vccd1 vccd1 sky130_fd_sc_hd__fill_8
X_201_ _428_/Q _427_/Q _213_/A vssd1 vssd1 vccd1 vccd1 _209_/A sky130_fd_sc_hd__nand3_2
XFILLER_20_3 vssd1 vccd1 vssd1 vccd1 sky130_ef_sc_hd__decap_40_12
XFILLER_6_77 vssd1 vssd1 vccd1 vccd1 sky130_fd_sc_hd__fill_2
XFILLER_25_130 vssd1 vssd1 vccd1 vccd1 sky130_fd_sc_hd__fill_4
XFILLER_31_63 vssd1 vssd1 vccd1 vccd1 sky130_fd_sc_hd__fill_1
XFILLER_31_85 vssd1 vccd1 vssd1 vccd1 sky130_ef_sc_hd__decap_40_12
X_380_ _378_/A _378_/B _406_/B1 vssd1 vssd1 vccd1 vccd1 _380_/X sky130_fd_sc_hd__o21a_2
XFILLER_31_111 vssd1 vssd1 vccd1 vccd1 sky130_fd_sc_hd__fill_1
XFILLER_31_177 vssd1 vssd1 vccd1 vccd1 sky130_fd_sc_hd__fill_8
.ends
