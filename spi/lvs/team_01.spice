* NGSPICE file created from team_01.ext - technology: sky130A

* Black-box entry subcircuit for sky130_fd_sc_hd__fill_2 abstract view
.subckt sky130_fd_sc_hd__fill_2 VGND VNB VPB VPWR
.ends

* Black-box entry subcircuit for sky130_fd_sc_hd__dfrtp_1 abstract view
.subckt sky130_fd_sc_hd__dfrtp_1 CLK D RESET_B VGND VNB VPB VPWR Q
.ends

* Black-box entry subcircuit for sky130_fd_sc_hd__tapvpwrvgnd_1 abstract view
.subckt sky130_fd_sc_hd__tapvpwrvgnd_1 VGND VPWR
.ends

* Black-box entry subcircuit for sky130_fd_sc_hd__mux2_1 abstract view
.subckt sky130_fd_sc_hd__mux2_1 A0 A1 S VGND VNB VPB VPWR X
.ends

* Black-box entry subcircuit for sky130_fd_sc_hd__xnor2_1 abstract view
.subckt sky130_fd_sc_hd__xnor2_1 A B VGND VNB VPB VPWR Y
.ends

* Black-box entry subcircuit for sky130_fd_sc_hd__or3_1 abstract view
.subckt sky130_fd_sc_hd__or3_1 A B C VGND VNB VPB VPWR X
.ends

* Black-box entry subcircuit for sky130_fd_sc_hd__mux4_1 abstract view
.subckt sky130_fd_sc_hd__mux4_1 A0 A1 A2 A3 S0 S1 VGND VNB VPB VPWR X
.ends

* Black-box entry subcircuit for sky130_fd_sc_hd__and3_1 abstract view
.subckt sky130_fd_sc_hd__and3_1 A B C VGND VNB VPB VPWR X
.ends

* Black-box entry subcircuit for sky130_fd_sc_hd__diode_2 abstract view
.subckt sky130_fd_sc_hd__diode_2 DIODE VGND VNB VPB VPWR
.ends

* Black-box entry subcircuit for sky130_fd_sc_hd__fill_1 abstract view
.subckt sky130_fd_sc_hd__fill_1 VGND VNB VPB VPWR
.ends

* Black-box entry subcircuit for sky130_fd_sc_hd__fill_4 abstract view
.subckt sky130_fd_sc_hd__fill_4 VGND VNB VPB VPWR
.ends

* Black-box entry subcircuit for sky130_fd_sc_hd__nand2_1 abstract view
.subckt sky130_fd_sc_hd__nand2_1 A B VGND VNB VPB VPWR Y
.ends

* Black-box entry subcircuit for sky130_fd_sc_hd__dlygate4sd3_1 abstract view
.subckt sky130_fd_sc_hd__dlygate4sd3_1 A VGND VNB VPB VPWR X
.ends

* Black-box entry subcircuit for sky130_fd_sc_hd__decap_3 abstract view
.subckt sky130_fd_sc_hd__decap_3 VGND VNB VPB VPWR
.ends

* Black-box entry subcircuit for sky130_fd_sc_hd__buf_2 abstract view
.subckt sky130_fd_sc_hd__buf_2 A VGND VNB VPB VPWR X
.ends

* Black-box entry subcircuit for sky130_fd_sc_hd__fill_8 abstract view
.subckt sky130_fd_sc_hd__fill_8 VGND VNB VPB VPWR
.ends

* Black-box entry subcircuit for sky130_ef_sc_hd__decap_40_12 abstract view
.subckt sky130_ef_sc_hd__decap_40_12 VPWR VGND VPB VNB
.ends

* Black-box entry subcircuit for sky130_fd_sc_hd__clkbuf_16 abstract view
.subckt sky130_fd_sc_hd__clkbuf_16 A VGND VNB VPB VPWR X
.ends

* Black-box entry subcircuit for sky130_fd_sc_hd__xor2_1 abstract view
.subckt sky130_fd_sc_hd__xor2_1 A B VGND VNB VPB VPWR X
.ends

* Black-box entry subcircuit for sky130_fd_sc_hd__a32o_1 abstract view
.subckt sky130_fd_sc_hd__a32o_1 A1 A2 A3 B1 B2 VGND VNB VPB VPWR X
.ends

* Black-box entry subcircuit for sky130_fd_sc_hd__or3b_1 abstract view
.subckt sky130_fd_sc_hd__or3b_1 A B C_N VGND VNB VPB VPWR X
.ends

* Black-box entry subcircuit for sky130_fd_sc_hd__a21o_1 abstract view
.subckt sky130_fd_sc_hd__a21o_1 A1 A2 B1 VGND VNB VPB VPWR X
.ends

* Black-box entry subcircuit for sky130_fd_sc_hd__nand2b_1 abstract view
.subckt sky130_fd_sc_hd__nand2b_1 A_N B VGND VNB VPB VPWR Y
.ends

* Black-box entry subcircuit for sky130_fd_sc_hd__nor2_1 abstract view
.subckt sky130_fd_sc_hd__nor2_1 A B VGND VNB VPB VPWR Y
.ends

* Black-box entry subcircuit for sky130_fd_sc_hd__and4b_1 abstract view
.subckt sky130_fd_sc_hd__and4b_1 A_N B C D VGND VNB VPB VPWR X
.ends

* Black-box entry subcircuit for sky130_fd_sc_hd__and2b_1 abstract view
.subckt sky130_fd_sc_hd__and2b_1 A_N B VGND VNB VPB VPWR X
.ends

* Black-box entry subcircuit for sky130_fd_sc_hd__o21ai_1 abstract view
.subckt sky130_fd_sc_hd__o21ai_1 A1 A2 B1 VGND VNB VPB VPWR Y
.ends

* Black-box entry subcircuit for sky130_fd_sc_hd__or2_1 abstract view
.subckt sky130_fd_sc_hd__or2_1 A B VGND VNB VPB VPWR X
.ends

* Black-box entry subcircuit for sky130_fd_sc_hd__a221o_1 abstract view
.subckt sky130_fd_sc_hd__a221o_1 A1 A2 B1 B2 C1 VGND VNB VPB VPWR X
.ends

* Black-box entry subcircuit for sky130_fd_sc_hd__o32a_1 abstract view
.subckt sky130_fd_sc_hd__o32a_1 A1 A2 A3 B1 B2 VGND VNB VPB VPWR X
.ends

* Black-box entry subcircuit for sky130_fd_sc_hd__or4_1 abstract view
.subckt sky130_fd_sc_hd__or4_1 A B C D VGND VNB VPB VPWR X
.ends

* Black-box entry subcircuit for sky130_fd_sc_hd__and2_1 abstract view
.subckt sky130_fd_sc_hd__and2_1 A B VGND VNB VPB VPWR X
.ends

* Black-box entry subcircuit for sky130_fd_sc_hd__a21bo_1 abstract view
.subckt sky130_fd_sc_hd__a21bo_1 A1 A2 B1_N VGND VNB VPB VPWR X
.ends

* Black-box entry subcircuit for sky130_fd_sc_hd__bufinv_16 abstract view
.subckt sky130_fd_sc_hd__bufinv_16 A VGND VNB VPB VPWR Y
.ends

* Black-box entry subcircuit for sky130_fd_sc_hd__nor4_1 abstract view
.subckt sky130_fd_sc_hd__nor4_1 A B C D VGND VNB VPB VPWR Y
.ends

* Black-box entry subcircuit for sky130_fd_sc_hd__a21oi_1 abstract view
.subckt sky130_fd_sc_hd__a21oi_1 A1 A2 B1 VGND VNB VPB VPWR Y
.ends

* Black-box entry subcircuit for sky130_fd_sc_hd__o22a_1 abstract view
.subckt sky130_fd_sc_hd__o22a_1 A1 A2 B1 B2 VGND VNB VPB VPWR X
.ends

* Black-box entry subcircuit for sky130_fd_sc_hd__clkbuf_4 abstract view
.subckt sky130_fd_sc_hd__clkbuf_4 A VGND VNB VPB VPWR X
.ends

* Black-box entry subcircuit for sky130_fd_sc_hd__dfrtp_2 abstract view
.subckt sky130_fd_sc_hd__dfrtp_2 CLK D RESET_B VGND VNB VPB VPWR Q
.ends

* Black-box entry subcircuit for sky130_fd_sc_hd__o21a_1 abstract view
.subckt sky130_fd_sc_hd__o21a_1 A1 A2 B1 VGND VNB VPB VPWR X
.ends

* Black-box entry subcircuit for sky130_fd_sc_hd__and3b_1 abstract view
.subckt sky130_fd_sc_hd__and3b_1 A_N B C VGND VNB VPB VPWR X
.ends

* Black-box entry subcircuit for sky130_fd_sc_hd__clkinv_4 abstract view
.subckt sky130_fd_sc_hd__clkinv_4 A VGND VNB VPB VPWR Y
.ends

* Black-box entry subcircuit for sky130_fd_sc_hd__a31o_1 abstract view
.subckt sky130_fd_sc_hd__a31o_1 A1 A2 A3 B1 VGND VNB VPB VPWR X
.ends

* Black-box entry subcircuit for sky130_fd_sc_hd__clkinv_2 abstract view
.subckt sky130_fd_sc_hd__clkinv_2 A VGND VNB VPB VPWR Y
.ends

* Black-box entry subcircuit for sky130_fd_sc_hd__clkbuf_2 abstract view
.subckt sky130_fd_sc_hd__clkbuf_2 A VGND VNB VPB VPWR X
.ends

* Black-box entry subcircuit for sky130_fd_sc_hd__o31ai_1 abstract view
.subckt sky130_fd_sc_hd__o31ai_1 A1 A2 A3 B1 VGND VNB VPB VPWR Y
.ends

* Black-box entry subcircuit for sky130_fd_sc_hd__a21boi_1 abstract view
.subckt sky130_fd_sc_hd__a21boi_1 A1 A2 B1_N VGND VNB VPB VPWR Y
.ends

* Black-box entry subcircuit for sky130_fd_sc_hd__conb_1 abstract view
.subckt sky130_fd_sc_hd__conb_1 VGND VNB VPB VPWR HI LO
.ends

* Black-box entry subcircuit for sky130_fd_sc_hd__clkbuf_1 abstract view
.subckt sky130_fd_sc_hd__clkbuf_1 A VGND VNB VPB VPWR X
.ends

* Black-box entry subcircuit for sky130_fd_sc_hd__dfrtp_4 abstract view
.subckt sky130_fd_sc_hd__dfrtp_4 CLK D RESET_B VGND VNB VPB VPWR Q
.ends

* Black-box entry subcircuit for sky130_fd_sc_hd__nor3b_1 abstract view
.subckt sky130_fd_sc_hd__nor3b_1 A B C_N VGND VNB VPB VPWR Y
.ends

* Black-box entry subcircuit for sky130_fd_sc_hd__dfstp_2 abstract view
.subckt sky130_fd_sc_hd__dfstp_2 CLK D SET_B VGND VNB VPB VPWR Q
.ends

* Black-box entry subcircuit for sky130_fd_sc_hd__and4_1 abstract view
.subckt sky130_fd_sc_hd__and4_1 A B C D VGND VNB VPB VPWR X
.ends

* Black-box entry subcircuit for sky130_fd_sc_hd__nand3_1 abstract view
.subckt sky130_fd_sc_hd__nand3_1 A B C VGND VNB VPB VPWR Y
.ends

* Black-box entry subcircuit for sky130_fd_sc_hd__a22o_1 abstract view
.subckt sky130_fd_sc_hd__a22o_1 A1 A2 B1 B2 VGND VNB VPB VPWR X
.ends

* Black-box entry subcircuit for sky130_fd_sc_hd__a2bb2o_1 abstract view
.subckt sky130_fd_sc_hd__a2bb2o_1 A1_N A2_N B1 B2 VGND VNB VPB VPWR X
.ends

* Black-box entry subcircuit for sky130_fd_sc_hd__inv_2 abstract view
.subckt sky130_fd_sc_hd__inv_2 A VGND VNB VPB VPWR Y
.ends

* Black-box entry subcircuit for sky130_fd_sc_hd__o211a_1 abstract view
.subckt sky130_fd_sc_hd__o211a_1 A1 A2 B1 C1 VGND VNB VPB VPWR X
.ends

* Black-box entry subcircuit for sky130_fd_sc_hd__o2bb2a_1 abstract view
.subckt sky130_fd_sc_hd__o2bb2a_1 A1_N A2_N B1 B2 VGND VNB VPB VPWR X
.ends

* Black-box entry subcircuit for sky130_fd_sc_hd__nor2_2 abstract view
.subckt sky130_fd_sc_hd__nor2_2 A B VGND VNB VPB VPWR Y
.ends

* Black-box entry subcircuit for sky130_fd_sc_hd__dfstp_1 abstract view
.subckt sky130_fd_sc_hd__dfstp_1 CLK D SET_B VGND VNB VPB VPWR Q
.ends

* Black-box entry subcircuit for sky130_fd_sc_hd__o211ai_4 abstract view
.subckt sky130_fd_sc_hd__o211ai_4 A1 A2 B1 C1 VGND VNB VPB VPWR Y
.ends

.subckt team_01 clk en gpio_in[0] gpio_in[10] gpio_in[11] gpio_in[12] gpio_in[13]
+ gpio_in[14] gpio_in[15] gpio_in[16] gpio_in[17] gpio_in[18] gpio_in[19] gpio_in[1]
+ gpio_in[20] gpio_in[21] gpio_in[22] gpio_in[23] gpio_in[24] gpio_in[25] gpio_in[26]
+ gpio_in[27] gpio_in[28] gpio_in[29] gpio_in[2] gpio_in[30] gpio_in[31] gpio_in[32]
+ gpio_in[33] gpio_in[3] gpio_in[4] gpio_in[5] gpio_in[6] gpio_in[7] gpio_in[8] gpio_in[9]
+ gpio_oeb[0] gpio_oeb[10] gpio_oeb[11] gpio_oeb[12] gpio_oeb[13] gpio_oeb[14] gpio_oeb[15]
+ gpio_oeb[16] gpio_oeb[17] gpio_oeb[18] gpio_oeb[19] gpio_oeb[1] gpio_oeb[20] gpio_oeb[21]
+ gpio_oeb[22] gpio_oeb[23] gpio_oeb[24] gpio_oeb[25] gpio_oeb[26] gpio_oeb[27] gpio_oeb[28]
+ gpio_oeb[29] gpio_oeb[2] gpio_oeb[30] gpio_oeb[31] gpio_oeb[32] gpio_oeb[33] gpio_oeb[3]
+ gpio_oeb[4] gpio_oeb[5] gpio_oeb[6] gpio_oeb[7] gpio_oeb[8] gpio_oeb[9] gpio_out[0]
+ gpio_out[10] gpio_out[11] gpio_out[12] gpio_out[13] gpio_out[14] gpio_out[15] gpio_out[16]
+ gpio_out[17] gpio_out[18] gpio_out[19] gpio_out[1] gpio_out[20] gpio_out[21] gpio_out[22]
+ gpio_out[23] gpio_out[24] gpio_out[25] gpio_out[26] gpio_out[27] gpio_out[28] gpio_out[29]
+ gpio_out[2] gpio_out[30] gpio_out[31] gpio_out[32] gpio_out[33] gpio_out[3] gpio_out[4]
+ gpio_out[5] gpio_out[6] gpio_out[7] gpio_out[8] gpio_out[9] nrst vccd1 vssd1
XFILLER_26_96 vssd1 vssd1 vccd1 vccd1 sky130_fd_sc_hd__fill_2
XFILLER_26_85 vssd1 vssd1 vccd1 vccd1 sky130_fd_sc_hd__fill_2
X_432_ clknet_3_2__leaf_clk TOP.top_rng_inst.ecstate.next_count\[5\] net35 vssd1 vssd1
+ vccd1 vccd1 TOP.top_rng_inst.ecstate.count_out\[5\] sky130_fd_sc_hd__dfrtp_1
XTAP_TAPCELL_ROW_23_150 vssd1 vccd1 sky130_fd_sc_hd__tapvpwrvgnd_1
X_363_ net105 _162_ net32 vssd1 vssd1 vccd1 vccd1 _018_ sky130_fd_sc_hd__mux2_1
XFILLER_13_166 vssd1 vssd1 vccd1 vccd1 sky130_fd_sc_hd__fill_2
X_294_ _104_ _105_ vssd1 vssd1 vccd1 vccd1 _106_ sky130_fd_sc_hd__xnor2_1
X_415_ clknet_3_6__leaf_clk net123 net37 vssd1 vssd1 vccd1 vccd1 TOP.top_rng_inst.lut1.ecstate.count_out\[1\]
+ sky130_fd_sc_hd__dfrtp_1
X_346_ _042_ TOP.top_rng_inst.display.datas\[3\] _117_ vssd1 vssd1 vccd1 vccd1 _150_
+ sky130_fd_sc_hd__or3_1
XTAP_TAPCELL_ROW_12_109 vssd1 vccd1 sky130_fd_sc_hd__tapvpwrvgnd_1
X_277_ TOP.top_rng_inst.display.datas\[1\] TOP.top_rng_inst.display.datas\[5\] TOP.top_rng_inst.display.datas\[9\]
+ TOP.top_rng_inst.display.datas\[13\] net14 net15 vssd1 vssd1 vccd1 vccd1 _094_ sky130_fd_sc_hd__mux4_1
X_200_ TOP.top_rng_inst.ecstate.count_out\[5\] TOP.top_rng_inst.ecstate.count_out\[4\]
+ _046_ vssd1 vssd1 vccd1 vccd1 _048_ sky130_fd_sc_hd__and3_1
XANTENNA_fanout38_A net42 vssd1 vssd1 vccd1 vccd1 sky130_fd_sc_hd__diode_2
XFILLER_21_209 vssd1 vssd1 vccd1 vccd1 sky130_fd_sc_hd__fill_2
XFILLER_0_79 vssd1 vssd1 vccd1 vccd1 sky130_fd_sc_hd__fill_1
XFILLER_0_57 vssd1 vssd1 vccd1 vccd1 sky130_fd_sc_hd__fill_1
XFILLER_0_24 vssd1 vssd1 vccd1 vccd1 sky130_fd_sc_hd__fill_4
X_329_ _119_ _135_ vssd1 vssd1 vccd1 vccd1 _136_ sky130_fd_sc_hd__nand2_1
XFILLER_9_55 vssd1 vssd1 vccd1 vccd1 sky130_fd_sc_hd__fill_1
XFILLER_9_99 vssd1 vssd1 vccd1 vccd1 sky130_fd_sc_hd__fill_4
XFILLER_15_6 vssd1 vssd1 vccd1 vccd1 sky130_fd_sc_hd__fill_1
XFILLER_29_106 vssd1 vssd1 vccd1 vccd1 sky130_fd_sc_hd__fill_4
XANTENNA__392__A2 net22 vssd1 vssd1 vccd1 vccd1 sky130_fd_sc_hd__diode_2
XFILLER_29_30 vssd1 vssd1 vccd1 vccd1 sky130_fd_sc_hd__fill_4
Xhold30 TOP.top_rng_inst.ecstate.count_out\[6\] vssd1 vssd1 vccd1 vccd1 net129 sky130_fd_sc_hd__dlygate4sd3_1
Xhold41 TOP.top_rng_inst.lut1.internal_state\[7\] vssd1 vssd1 vccd1 vccd1 net140 sky130_fd_sc_hd__dlygate4sd3_1
XPHY_EDGE_ROW_16_Left_48 vssd1 vssd1 vccd1 vccd1 sky130_fd_sc_hd__decap_3
XFILLER_31_53 vssd1 vssd1 vccd1 vccd1 sky130_fd_sc_hd__fill_2
XFILLER_17_109 vssd1 vssd1 vccd1 vccd1 sky130_fd_sc_hd__fill_2
XFILLER_31_189 vssd1 vssd1 vccd1 vccd1 sky130_fd_sc_hd__fill_4
XFILLER_31_167 vssd1 vssd1 vccd1 vccd1 sky130_fd_sc_hd__fill_1
Xoutput7 net7 vssd1 vssd1 vccd1 vccd1 gpio_out[10] sky130_fd_sc_hd__buf_2
XFILLER_16_197 vssd1 vssd1 vccd1 vccd1 sky130_fd_sc_hd__fill_8
XFILLER_7_8 vccd1 vssd1 vccd1 vssd1 sky130_ef_sc_hd__decap_40_12
XFILLER_26_42 vccd1 vssd1 vccd1 vssd1 sky130_ef_sc_hd__decap_40_12
Xclkbuf_3_6__f_clk clknet_0_clk vssd1 vssd1 vccd1 vccd1 clknet_3_6__leaf_clk sky130_fd_sc_hd__clkbuf_16
X_431_ clknet_3_2__leaf_clk TOP.top_rng_inst.ecstate.next_count\[4\] net35 vssd1 vssd1
+ vccd1 vccd1 TOP.top_rng_inst.ecstate.count_out\[4\] sky130_fd_sc_hd__dfrtp_1
X_362_ TOP.top_rng_inst.lut1.internal_state\[13\] _161_ vssd1 vssd1 vccd1 vccd1 _162_
+ sky130_fd_sc_hd__xnor2_1
XFILLER_3_46 vssd1 vssd1 vccd1 vccd1 sky130_fd_sc_hd__fill_8
XFILLER_3_57 vssd1 vssd1 vccd1 vccd1 sky130_fd_sc_hd__fill_4
X_293_ TOP.top_rng_inst.lut1.internal_state\[1\] TOP.top_rng_inst.lut1.internal_state\[6\]
+ vssd1 vssd1 vccd1 vccd1 _105_ sky130_fd_sc_hd__xor2_1
XPHY_EDGE_ROW_19_Left_51 vssd1 vssd1 vccd1 vccd1 sky130_fd_sc_hd__decap_3
XFILLER_6_108 vssd1 vssd1 vccd1 vccd1 sky130_fd_sc_hd__fill_1
X_414_ clknet_3_3__leaf_clk net131 net36 vssd1 vssd1 vccd1 vccd1 TOP.top_rng_inst.lut1.ecstate.count_out\[0\]
+ sky130_fd_sc_hd__dfrtp_1
X_276_ _090_ _092_ _093_ _044_ TOP.top_rng_inst.display.current_data\[0\] vssd1 vssd1
+ vccd1 vccd1 _000_ sky130_fd_sc_hd__a32o_1
X_345_ net113 _149_ net31 vssd1 vssd1 vccd1 vccd1 _013_ sky130_fd_sc_hd__mux2_1
XFILLER_5_174 vssd1 vssd1 vccd1 vccd1 sky130_fd_sc_hd__fill_4
XPHY_EDGE_ROW_21_Right_21 vssd1 vssd1 vccd1 vccd1 sky130_fd_sc_hd__decap_3
XPHY_EDGE_ROW_12_Right_12 vssd1 vssd1 vccd1 vccd1 sky130_fd_sc_hd__decap_3
XPHY_EDGE_ROW_4_Left_36 vssd1 vssd1 vccd1 vccd1 sky130_fd_sc_hd__decap_3
XPHY_EDGE_ROW_30_Right_30 vssd1 vssd1 vccd1 vccd1 sky130_fd_sc_hd__decap_3
X_259_ TOP.top_rng_inst.display.current_data\[2\] net30 TOP.top_rng_inst.display.current_data\[1\]
+ vssd1 vssd1 vccd1 vccd1 _084_ sky130_fd_sc_hd__or3b_1
XFILLER_2_188 vssd1 vssd1 vccd1 vccd1 sky130_fd_sc_hd__fill_8
X_328_ _098_ _107_ _120_ _132_ _041_ _042_ vssd1 vssd1 vccd1 vccd1 _135_ sky130_fd_sc_hd__mux4_1
XFILLER_18_98 vccd1 vssd1 vccd1 vssd1 sky130_ef_sc_hd__decap_40_12
XANTENNA__386__B1 net19 vssd1 vssd1 vccd1 vccd1 sky130_fd_sc_hd__diode_2
XFILLER_29_129 vssd1 vssd1 vccd1 vccd1 sky130_fd_sc_hd__fill_1
XFILLER_29_75 vssd1 vssd1 vccd1 vccd1 sky130_fd_sc_hd__fill_8
Xhold31 TOP.top_rng_inst.lut1.ecstate.count_out\[0\] vssd1 vssd1 vccd1 vccd1 net130
+ sky130_fd_sc_hd__dlygate4sd3_1
Xhold42 TOP.top_rng_inst.lut1.internal_state\[13\] vssd1 vssd1 vccd1 vccd1 net141
+ sky130_fd_sc_hd__dlygate4sd3_1
Xhold20 TOP.top_rng_inst.display.datas\[7\] vssd1 vssd1 vccd1 vccd1 net119 sky130_fd_sc_hd__dlygate4sd3_1
XFILLER_28_162 vssd1 vssd1 vccd1 vccd1 sky130_fd_sc_hd__fill_2
XFILLER_15_33 vssd1 vssd1 vccd1 vccd1 sky130_fd_sc_hd__fill_2
XPHY_EDGE_ROW_6_Right_6 vssd1 vssd1 vccd1 vccd1 sky130_fd_sc_hd__decap_3
Xoutput8 net8 vssd1 vssd1 vccd1 vccd1 gpio_out[11] sky130_fd_sc_hd__buf_2
XFILLER_31_146 vssd1 vssd1 vccd1 vccd1 sky130_fd_sc_hd__fill_4
XFILLER_31_113 vssd1 vssd1 vccd1 vccd1 sky130_fd_sc_hd__fill_2
Xoutput10 net10 vssd1 vssd1 vccd1 vccd1 gpio_out[13] sky130_fd_sc_hd__buf_2
XTAP_TAPCELL_ROW_26_160 vssd1 vccd1 sky130_fd_sc_hd__tapvpwrvgnd_1
XANTENNA__289__S net32 vssd1 vssd1 vccd1 vccd1 sky130_fd_sc_hd__diode_2
XFILLER_26_87 vssd1 vssd1 vccd1 vccd1 sky130_fd_sc_hd__fill_1
XFILLER_26_98 vssd1 vssd1 vccd1 vccd1 sky130_fd_sc_hd__fill_1
XFILLER_26_54 vccd1 vssd1 vccd1 vssd1 sky130_ef_sc_hd__decap_40_12
X_430_ clknet_3_2__leaf_clk TOP.top_rng_inst.ecstate.next_count\[3\] net35 vssd1 vssd1
+ vccd1 vccd1 TOP.top_rng_inst.ecstate.count_out\[3\] sky130_fd_sc_hd__dfrtp_1
XFILLER_13_113 vssd1 vssd1 vccd1 vccd1 sky130_fd_sc_hd__fill_8
X_361_ _127_ _128_ _144_ vssd1 vssd1 vccd1 vccd1 _161_ sky130_fd_sc_hd__a21o_1
X_292_ TOP.top_rng_inst.display.datas\[3\] _103_ vssd1 vssd1 vccd1 vccd1 _104_ sky130_fd_sc_hd__nand2b_1
XFILLER_27_205 vssd1 vssd1 vccd1 vccd1 sky130_fd_sc_hd__fill_2
X_275_ net16 _044_ vssd1 vssd1 vccd1 vccd1 _093_ sky130_fd_sc_hd__nor2_1
X_344_ _147_ _148_ vssd1 vssd1 vccd1 vccd1 _149_ sky130_fd_sc_hd__xnor2_1
XFILLER_18_205 vssd1 vssd1 vccd1 vccd1 sky130_fd_sc_hd__fill_4
X_413_ TOP.top_rng_inst.k1.psc.count_out\[3\] TOP.top_rng_inst.k1.psc.count_out\[1\]
+ TOP.top_rng_inst.k1.psc.count_out\[0\] TOP.top_rng_inst.k1.psc.count_out\[2\] vssd1
+ vssd1 vccd1 vccd1 TOP.top_rng_inst.k1.psc.next_flag sky130_fd_sc_hd__and4b_1
XFILLER_5_131 vssd1 vssd1 vccd1 vccd1 sky130_fd_sc_hd__fill_4
XPHY_EDGE_ROW_20_Left_52 vssd1 vssd1 vccd1 vccd1 sky130_fd_sc_hd__decap_3
XFILLER_23_33 vssd1 vssd1 vccd1 vccd1 sky130_fd_sc_hd__fill_2
XFILLER_2_156 vssd1 vssd1 vccd1 vccd1 sky130_fd_sc_hd__fill_1
XFILLER_3_3 vccd1 vssd1 vccd1 vssd1 sky130_ef_sc_hd__decap_40_12
X_258_ TOP.top_rng_inst.display.current_data\[2\] TOP.top_rng_inst.display.current_data\[1\]
+ vssd1 vssd1 vccd1 vccd1 _083_ sky130_fd_sc_hd__and2b_1
X_327_ _041_ _120_ _133_ vssd1 vssd1 vccd1 vccd1 _134_ sky130_fd_sc_hd__o21ai_1
XFILLER_9_57 vssd1 vssd1 vccd1 vccd1 sky130_fd_sc_hd__fill_4
XFILLER_18_77 vssd1 vssd1 vccd1 vccd1 sky130_fd_sc_hd__fill_4
XFILLER_20_89 vssd1 vssd1 vccd1 vccd1 sky130_fd_sc_hd__fill_2
XFILLER_28_141 vssd1 vssd1 vccd1 vccd1 sky130_fd_sc_hd__fill_2
Xhold32 TOP.top_rng_inst.lut1.ecstate.next_count\[0\] vssd1 vssd1 vccd1 vccd1 net131
+ sky130_fd_sc_hd__dlygate4sd3_1
Xhold10 TOP.top_rng_inst.lut1.started vssd1 vssd1 vccd1 vccd1 net109 sky130_fd_sc_hd__dlygate4sd3_1
Xhold43 TOP.top_rng_inst.lut1.internal_state\[11\] vssd1 vssd1 vccd1 vccd1 net142
+ sky130_fd_sc_hd__dlygate4sd3_1
Xhold21 TOP.top_rng_inst.display.datas\[11\] vssd1 vssd1 vccd1 vccd1 net120 sky130_fd_sc_hd__dlygate4sd3_1
XFILLER_19_174 vssd1 vssd1 vccd1 vccd1 sky130_fd_sc_hd__fill_1
XTAP_TAPCELL_ROW_6_90 vssd1 vccd1 sky130_fd_sc_hd__tapvpwrvgnd_1
Xoutput9 net9 vssd1 vssd1 vccd1 vccd1 gpio_out[12] sky130_fd_sc_hd__buf_2
XFILLER_31_55 vssd1 vssd1 vccd1 vccd1 sky130_fd_sc_hd__fill_1
Xoutput11 net11 vssd1 vssd1 vccd1 vccd1 gpio_out[14] sky130_fd_sc_hd__buf_2
XFILLER_25_111 vssd1 vssd1 vccd1 vccd1 sky130_fd_sc_hd__fill_1
XANTENNA_clkbuf_3_1__f_clk_A clknet_0_clk vssd1 vssd1 vccd1 vccd1 sky130_fd_sc_hd__diode_2
XFILLER_31_169 vssd1 vssd1 vccd1 vccd1 sky130_fd_sc_hd__fill_2
XFILLER_31_125 vssd1 vssd1 vccd1 vccd1 sky130_fd_sc_hd__fill_4
XTAP_TAPCELL_ROW_26_161 vssd1 vccd1 sky130_fd_sc_hd__tapvpwrvgnd_1
XFILLER_22_158 vssd1 vssd1 vccd1 vccd1 sky130_fd_sc_hd__fill_1
XFILLER_26_66 vssd1 vssd1 vccd1 vccd1 sky130_fd_sc_hd__fill_4
X_360_ net110 _160_ net32 vssd1 vssd1 vccd1 vccd1 _017_ sky130_fd_sc_hd__mux2_1
XFILLER_13_169 vssd1 vssd1 vccd1 vccd1 sky130_fd_sc_hd__fill_8
X_291_ _041_ _042_ _102_ vssd1 vssd1 vccd1 vccd1 _103_ sky130_fd_sc_hd__and3_1
XFILLER_12_191 vssd1 vssd1 vccd1 vccd1 sky130_fd_sc_hd__fill_4
XFILLER_3_15 vssd1 vssd1 vccd1 vccd1 sky130_fd_sc_hd__fill_4
XFILLER_10_128 vccd1 vssd1 vccd1 vssd1 sky130_ef_sc_hd__decap_40_12
XTAP_TAPCELL_ROW_3_80 vssd1 vccd1 sky130_fd_sc_hd__tapvpwrvgnd_1
X_274_ _043_ _091_ vssd1 vssd1 vccd1 vccd1 _092_ sky130_fd_sc_hd__or2_1
X_343_ TOP.top_rng_inst.lut1.internal_state\[6\] TOP.top_rng_inst.lut1.internal_state\[8\]
+ vssd1 vssd1 vccd1 vccd1 _148_ sky130_fd_sc_hd__xnor2_1
XANTENNA__404__B1 net19 vssd1 vssd1 vccd1 vccd1 sky130_fd_sc_hd__diode_2
X_412_ TOP.top_rng_inst.lut1.internal_state\[15\] net23 net20 net136 _190_ vssd1 vssd1
+ vccd1 vccd1 _039_ sky130_fd_sc_hd__a221o_1
XFILLER_5_121 vssd1 vssd1 vccd1 vccd1 sky130_fd_sc_hd__fill_2
XFILLER_5_165 vssd1 vssd1 vccd1 vccd1 sky130_fd_sc_hd__fill_2
XFILLER_5_198 vssd1 vssd1 vccd1 vccd1 sky130_fd_sc_hd__fill_8
X_257_ net30 _078_ _082_ _073_ _077_ vssd1 vssd1 vccd1 vccd1 net18 sky130_fd_sc_hd__o32a_1
XTAP_TAPCELL_ROW_0_70 vssd1 vccd1 sky130_fd_sc_hd__tapvpwrvgnd_1
XFILLER_1_190 vccd1 vssd1 vccd1 vssd1 sky130_ef_sc_hd__decap_40_12
X_326_ net27 net13 net25 vssd1 vssd1 vccd1 vccd1 _133_ sky130_fd_sc_hd__a21o_1
XANTENNA__386__A2 net22 vssd1 vssd1 vccd1 vccd1 sky130_fd_sc_hd__diode_2
X_309_ TOP.top_rng_inst.k1.sync_r0.sync TOP.top_rng_inst.k1.sync_r1.sync TOP.top_rng_inst.k1.sync_r3.sync
+ TOP.top_rng_inst.k1.sync_r2.sync vssd1 vssd1 vccd1 vccd1 _118_ sky130_fd_sc_hd__or4_1
Xhold22 TOP.top_rng_inst.display.psc.rollover_flag vssd1 vssd1 vccd1 vccd1 net121
+ sky130_fd_sc_hd__dlygate4sd3_1
Xhold11 TOP.top_rng_inst.display.datas\[12\] vssd1 vssd1 vccd1 vccd1 net110 sky130_fd_sc_hd__dlygate4sd3_1
XFILLER_20_57 vssd1 vssd1 vccd1 vccd1 sky130_fd_sc_hd__fill_2
Xhold33 TOP.top_rng_inst.lut1.internal_state\[9\] vssd1 vssd1 vccd1 vccd1 net132 sky130_fd_sc_hd__dlygate4sd3_1
Xhold44 TOP.top_rng_inst.lut1.internal_state\[5\] vssd1 vssd1 vccd1 vccd1 net143 sky130_fd_sc_hd__dlygate4sd3_1
XFILLER_6_15 vccd1 vssd1 vccd1 vssd1 sky130_ef_sc_hd__decap_40_12
XTAP_TAPCELL_ROW_29_170 vssd1 vccd1 sky130_fd_sc_hd__tapvpwrvgnd_1
XTAP_TAPCELL_ROW_6_91 vssd1 vccd1 sky130_fd_sc_hd__tapvpwrvgnd_1
XFILLER_25_123 vssd1 vssd1 vccd1 vccd1 sky130_fd_sc_hd__fill_1
XFILLER_15_35 vssd1 vssd1 vccd1 vccd1 sky130_fd_sc_hd__fill_1
Xoutput12 net12 vssd1 vssd1 vccd1 vccd1 gpio_out[16] sky130_fd_sc_hd__buf_2
XFILLER_16_145 vssd1 vssd1 vccd1 vccd1 sky130_fd_sc_hd__fill_1
XFILLER_7_80 vssd1 vssd1 vccd1 vccd1 sky130_fd_sc_hd__fill_1
X_290_ TOP.top_rng_inst.k1.sync_r1.sync TOP.top_rng_inst.k1.sync_r0.sync net27 vssd1
+ vssd1 vccd1 vccd1 _102_ sky130_fd_sc_hd__mux2_1
XFILLER_27_207 vssd1 vssd1 vccd1 vccd1 sky130_fd_sc_hd__fill_1
XFILLER_12_181 vssd1 vssd1 vccd1 vccd1 sky130_fd_sc_hd__fill_2
XFILLER_12_25 vssd1 vssd1 vccd1 vccd1 sky130_fd_sc_hd__fill_2
X_273_ TOP.top_rng_inst.display.datas\[8\] TOP.top_rng_inst.display.datas\[12\] net14
+ vssd1 vssd1 vccd1 vccd1 _091_ sky130_fd_sc_hd__mux2_1
X_411_ net28 TOP.top_rng_inst.display.datas\[15\] vssd1 vssd1 vccd1 vccd1 _190_ sky130_fd_sc_hd__and2_1
X_342_ _042_ _099_ _143_ _146_ _119_ vssd1 vssd1 vccd1 vccd1 _147_ sky130_fd_sc_hd__a32o_1
XFILLER_5_111 vssd1 vssd1 vccd1 vccd1 sky130_fd_sc_hd__fill_1
XFILLER_23_57 vssd1 vssd1 vccd1 vccd1 sky130_fd_sc_hd__fill_2
XFILLER_2_136 vssd1 vssd1 vccd1 vccd1 sky130_fd_sc_hd__fill_1
X_256_ TOP.top_rng_inst.display.current_data\[1\] TOP.top_rng_inst.display.current_data\[0\]
+ TOP.top_rng_inst.display.current_data\[2\] vssd1 vssd1 vccd1 vccd1 _082_ sky130_fd_sc_hd__a21bo_1
X_325_ net26 net13 vssd1 vssd1 vccd1 vccd1 _132_ sky130_fd_sc_hd__and2_1
XFILLER_18_35 vccd1 vssd1 vccd1 vssd1 sky130_ef_sc_hd__decap_40_12
Xclkload0 clknet_3_0__leaf_clk vssd1 vssd1 vccd1 vccd1 clkload0/Y sky130_fd_sc_hd__bufinv_16
XFILLER_11_202 vssd1 vssd1 vccd1 vccd1 sky130_fd_sc_hd__fill_4
X_308_ TOP.top_rng_inst.k1.sync_r0.sync TOP.top_rng_inst.k1.sync_r1.sync TOP.top_rng_inst.k1.sync_r3.sync
+ TOP.top_rng_inst.k1.sync_r2.sync vssd1 vssd1 vccd1 vccd1 _117_ sky130_fd_sc_hd__nor4_1
X_239_ TOP.top_rng_inst.k1.psc.count_out\[1\] TOP.top_rng_inst.k1.psc.count_out\[0\]
+ TOP.top_rng_inst.k1.psc.count_out\[3\] vssd1 vssd1 vccd1 vccd1 _070_ sky130_fd_sc_hd__a21oi_1
Xhold23 TOP.top_rng_inst.lut1.ecstate.count_out\[1\] vssd1 vssd1 vccd1 vccd1 net122
+ sky130_fd_sc_hd__dlygate4sd3_1
XFILLER_29_34 vssd1 vssd1 vccd1 vccd1 sky130_fd_sc_hd__fill_2
XFILLER_28_143 vssd1 vssd1 vccd1 vccd1 sky130_fd_sc_hd__fill_1
Xhold34 _034_ vssd1 vssd1 vccd1 vccd1 net133 sky130_fd_sc_hd__dlygate4sd3_1
Xhold12 TOP.top_rng_inst.display.datas\[15\] vssd1 vssd1 vccd1 vccd1 net111 sky130_fd_sc_hd__dlygate4sd3_1
Xhold45 TOP.top_rng_inst.lut1.internal_state\[1\] vssd1 vssd1 vccd1 vccd1 net144 sky130_fd_sc_hd__dlygate4sd3_1
XTAP_TAPCELL_ROW_29_171 vssd1 vccd1 sky130_fd_sc_hd__tapvpwrvgnd_1
XFILLER_19_121 vssd1 vssd1 vccd1 vccd1 sky130_fd_sc_hd__fill_1
XANTENNA_clkbuf_0_clk_A clk vssd1 vssd1 vccd1 vccd1 sky130_fd_sc_hd__diode_2
XFILLER_10_80 vssd1 vssd1 vccd1 vccd1 sky130_fd_sc_hd__fill_4
XFILLER_6_27 vssd1 vssd1 vccd1 vccd1 sky130_fd_sc_hd__fill_1
XFILLER_31_68 vccd1 vssd1 vccd1 vssd1 sky130_ef_sc_hd__decap_40_12
XFILLER_31_57 vssd1 vssd1 vccd1 vccd1 sky130_fd_sc_hd__fill_4
XFILLER_25_113 vssd1 vssd1 vccd1 vccd1 sky130_fd_sc_hd__fill_4
XFILLER_0_201 vssd1 vssd1 vccd1 vccd1 sky130_fd_sc_hd__fill_2
Xoutput13 net13 vssd1 vssd1 vccd1 vccd1 gpio_out[17] sky130_fd_sc_hd__buf_2
XPHY_EDGE_ROW_28_Right_28 vssd1 vssd1 vccd1 vccd1 sky130_fd_sc_hd__decap_3
XPHY_EDGE_ROW_19_Right_19 vssd1 vssd1 vccd1 vccd1 sky130_fd_sc_hd__decap_3
Xclkbuf_3_1__f_clk clknet_0_clk vssd1 vssd1 vccd1 vccd1 clknet_3_1__leaf_clk sky130_fd_sc_hd__clkbuf_16
XFILLER_30_193 vssd1 vssd1 vccd1 vccd1 sky130_fd_sc_hd__fill_2
X_272_ net15 _089_ vssd1 vssd1 vccd1 vccd1 _090_ sky130_fd_sc_hd__or2_1
X_410_ net136 net23 net20 net141 _189_ vssd1 vssd1 vccd1 vccd1 _038_ sky130_fd_sc_hd__a221o_1
XANTENNA__404__A2 net22 vssd1 vssd1 vccd1 vccd1 sky130_fd_sc_hd__diode_2
X_341_ _121_ _145_ _042_ vssd1 vssd1 vccd1 vccd1 _146_ sky130_fd_sc_hd__mux2_1
XFILLER_5_123 vssd1 vssd1 vccd1 vccd1 sky130_fd_sc_hd__fill_1
XFILLER_5_167 vssd1 vssd1 vccd1 vccd1 sky130_fd_sc_hd__fill_1
XFILLER_4_82 vssd1 vssd1 vccd1 vccd1 sky130_fd_sc_hd__fill_2
XFILLER_4_93 vssd1 vssd1 vccd1 vccd1 sky130_fd_sc_hd__fill_2
X_255_ _075_ _077_ _081_ net30 vssd1 vssd1 vccd1 vccd1 net17 sky130_fd_sc_hd__o22a_1
XPHY_EDGE_ROW_24_Left_56 vssd1 vssd1 vccd1 vccd1 sky130_fd_sc_hd__decap_3
XFILLER_13_80 vssd1 vssd1 vccd1 vccd1 sky130_fd_sc_hd__fill_1
X_324_ net114 _131_ net31 vssd1 vssd1 vccd1 vccd1 _010_ sky130_fd_sc_hd__mux2_1
XFILLER_0_29 vccd1 vssd1 vccd1 vssd1 sky130_ef_sc_hd__decap_40_12
XFILLER_9_49 vssd1 vssd1 vccd1 vccd1 sky130_fd_sc_hd__fill_4
XFILLER_18_47 vccd1 vssd1 vccd1 vssd1 sky130_ef_sc_hd__decap_40_12
Xclkload1 clknet_3_1__leaf_clk vssd1 vssd1 vccd1 vccd1 clkload1/X sky130_fd_sc_hd__clkbuf_4
X_238_ TOP.top_rng_inst.k1.psc.count_out\[3\] net107 vssd1 vssd1 vccd1 vccd1 TOP.top_rng_inst.k1.psc.next_count\[0\]
+ sky130_fd_sc_hd__nand2b_1
X_307_ _115_ _116_ vssd1 vssd1 vccd1 vccd1 _008_ sky130_fd_sc_hd__xnor2_1
Xhold24 TOP.top_rng_inst.lut1.ecstate.next_count\[1\] vssd1 vssd1 vccd1 vccd1 net123
+ sky130_fd_sc_hd__dlygate4sd3_1
XFILLER_29_57 vssd1 vssd1 vccd1 vccd1 sky130_fd_sc_hd__fill_1
Xhold46 TOP.top_rng_inst.ecstate.count_out\[4\] vssd1 vssd1 vccd1 vccd1 net145 sky130_fd_sc_hd__dlygate4sd3_1
XANTENNA_fanout41_A net42 vssd1 vssd1 vccd1 vccd1 sky130_fd_sc_hd__diode_2
XFILLER_20_59 vssd1 vssd1 vccd1 vccd1 sky130_fd_sc_hd__fill_1
Xhold13 TOP.top_rng_inst.display.datas\[14\] vssd1 vssd1 vccd1 vccd1 net112 sky130_fd_sc_hd__dlygate4sd3_1
Xhold35 TOP.top_rng_inst.k1.psc.count_out\[2\] vssd1 vssd1 vccd1 vccd1 net134 sky130_fd_sc_hd__dlygate4sd3_1
XFILLER_10_70 vssd1 vssd1 vccd1 vccd1 sky130_fd_sc_hd__fill_4
XFILLER_25_158 vssd1 vssd1 vccd1 vccd1 sky130_fd_sc_hd__fill_2
XPHY_EDGE_ROW_11_Left_43 vssd1 vssd1 vccd1 vccd1 sky130_fd_sc_hd__decap_3
Xoutput14 net14 vssd1 vssd1 vccd1 vccd1 gpio_out[18] sky130_fd_sc_hd__buf_2
XFILLER_31_139 vssd1 vssd1 vccd1 vccd1 sky130_fd_sc_hd__fill_1
XFILLER_16_136 vssd1 vssd1 vccd1 vccd1 sky130_fd_sc_hd__fill_4
XFILLER_12_183 vssd1 vssd1 vccd1 vccd1 sky130_fd_sc_hd__fill_1
X_486_ TOP.top_rng_inst.k1.clk_psc TOP.top_rng_inst.k1.n_keypad_col\[1\] net34 vssd1
+ vssd1 vccd1 vccd1 net13 sky130_fd_sc_hd__dfrtp_2
XTAP_TAPCELL_ROW_20_137 vssd1 vccd1 sky130_fd_sc_hd__tapvpwrvgnd_1
XFILLER_18_209 vssd1 vssd1 vccd1 vccd1 sky130_fd_sc_hd__fill_2
XFILLER_12_49 vssd1 vssd1 vccd1 vccd1 sky130_fd_sc_hd__fill_1
XFILLER_12_27 vssd1 vssd1 vccd1 vccd1 sky130_fd_sc_hd__fill_1
XFILLER_10_109 vccd1 vssd1 vccd1 vssd1 sky130_ef_sc_hd__decap_40_12
XFILLER_27_90 vssd1 vssd1 vccd1 vccd1 sky130_fd_sc_hd__fill_2
X_271_ net27 TOP.top_rng_inst.display.datas\[4\] net14 vssd1 vssd1 vccd1 vccd1 _089_
+ sky130_fd_sc_hd__mux2_1
XFILLER_5_113 vssd1 vssd1 vccd1 vccd1 sky130_fd_sc_hd__fill_8
XFILLER_5_135 vssd1 vssd1 vccd1 vccd1 sky130_fd_sc_hd__fill_1
X_340_ net26 net25 net13 vssd1 vssd1 vccd1 vccd1 _145_ sky130_fd_sc_hd__and3_1
XFILLER_23_59 vssd1 vssd1 vccd1 vccd1 sky130_fd_sc_hd__fill_1
X_469_ clknet_3_7__leaf_clk net139 net41 vssd1 vssd1 vccd1 vccd1 TOP.top_rng_inst.lut1.internal_state\[13\]
+ sky130_fd_sc_hd__dfrtp_1
X_254_ TOP.top_rng_inst.display.current_data\[2\] _074_ _080_ vssd1 vssd1 vccd1 vccd1
+ _081_ sky130_fd_sc_hd__o21a_1
XFILLER_13_92 vssd1 vssd1 vccd1 vccd1 sky130_fd_sc_hd__fill_4
X_323_ _129_ _130_ vssd1 vssd1 vccd1 vccd1 _131_ sky130_fd_sc_hd__xnor2_1
XFILLER_29_6 vccd1 vssd1 vccd1 vssd1 sky130_ef_sc_hd__decap_40_12
Xclkload2 clknet_3_3__leaf_clk vssd1 vssd1 vccd1 vccd1 clkload2/Y sky130_fd_sc_hd__bufinv_16
XFILLER_18_59 vssd1 vssd1 vccd1 vccd1 sky130_fd_sc_hd__fill_2
XFILLER_18_26 vssd1 vssd1 vccd1 vccd1 sky130_fd_sc_hd__fill_2
XFILLER_18_15 vssd1 vssd1 vccd1 vccd1 sky130_fd_sc_hd__fill_1
XFILLER_27_3 vssd1 vssd1 vccd1 vccd1 sky130_fd_sc_hd__fill_1
XFILLER_24_91 vssd1 vssd1 vccd1 vccd1 sky130_fd_sc_hd__fill_1
X_237_ _046_ _052_ _069_ vssd1 vssd1 vccd1 vccd1 TOP.top_rng_inst.ecstate.next_count\[3\]
+ sky130_fd_sc_hd__and3b_1
X_306_ TOP.top_rng_inst.lut1.internal_state\[3\] net32 vssd1 vssd1 vccd1 vccd1 _116_
+ sky130_fd_sc_hd__and2b_1
XANTENNA_clkbuf_3_4__f_clk_A clknet_0_clk vssd1 vssd1 vccd1 vccd1 sky130_fd_sc_hd__diode_2
Xhold14 TOP.top_rng_inst.display.datas\[8\] vssd1 vssd1 vccd1 vccd1 net113 sky130_fd_sc_hd__dlygate4sd3_1
XFILLER_20_49 vssd1 vssd1 vccd1 vccd1 sky130_fd_sc_hd__fill_8
Xhold36 TOP.top_rng_inst.k1.psc.next_count\[2\] vssd1 vssd1 vccd1 vccd1 net135 sky130_fd_sc_hd__dlygate4sd3_1
Xhold47 TOP.top_rng_inst.lut1.internal_state\[0\] vssd1 vssd1 vccd1 vccd1 net146 sky130_fd_sc_hd__dlygate4sd3_1
Xhold25 TOP.top_rng_inst.lut1.internal_state\[3\] vssd1 vssd1 vccd1 vccd1 net124 sky130_fd_sc_hd__dlygate4sd3_1
XFILLER_28_189 vssd1 vssd1 vccd1 vccd1 sky130_fd_sc_hd__fill_1
XFILLER_28_167 vssd1 vssd1 vccd1 vccd1 sky130_fd_sc_hd__fill_2
XFILLER_19_189 vccd1 vssd1 vccd1 vssd1 sky130_ef_sc_hd__decap_40_12
XFILLER_19_167 vssd1 vssd1 vccd1 vccd1 sky130_fd_sc_hd__fill_1
XFILLER_3_211 vssd1 vssd1 vccd1 vccd1 sky130_fd_sc_hd__fill_1
XFILLER_31_118 vssd1 vssd1 vccd1 vccd1 sky130_fd_sc_hd__fill_4
XFILLER_31_15 vccd1 vssd1 vccd1 vssd1 sky130_ef_sc_hd__decap_40_12
Xoutput15 net15 vssd1 vssd1 vccd1 vccd1 gpio_out[19] sky130_fd_sc_hd__buf_2
XPHY_EDGE_ROW_1_Right_1 vssd1 vssd1 vccd1 vccd1 sky130_fd_sc_hd__decap_3
XFILLER_30_195 vssd1 vssd1 vccd1 vccd1 sky130_fd_sc_hd__fill_1
XFILLER_22_129 vssd1 vssd1 vccd1 vccd1 sky130_fd_sc_hd__fill_1
XFILLER_12_195 vssd1 vssd1 vccd1 vccd1 sky130_fd_sc_hd__fill_1
X_485_ TOP.top_rng_inst.k1.clk_psc TOP.top_rng_inst.k1.n_keypad_col\[0\] net34 vssd1
+ vssd1 vccd1 vccd1 net12 sky130_fd_sc_hd__dfrtp_2
XTAP_TAPCELL_ROW_20_138 vssd1 vccd1 sky130_fd_sc_hd__tapvpwrvgnd_1
XANTENNA_input6_A nrst vssd1 vssd1 vccd1 vccd1 sky130_fd_sc_hd__diode_2
XFILLER_17_210 vssd1 vssd1 vccd1 vccd1 sky130_fd_sc_hd__fill_2
X_270_ net6 net1 vssd1 vssd1 vccd1 vccd1 TOP.n_rst sky130_fd_sc_hd__and2_1
XFILLER_5_169 vssd1 vssd1 vccd1 vccd1 sky130_fd_sc_hd__fill_2
X_468_ clknet_3_7__leaf_clk _036_ net40 vssd1 vssd1 vccd1 vccd1 TOP.top_rng_inst.lut1.internal_state\[12\]
+ sky130_fd_sc_hd__dfrtp_1
X_399_ net28 TOP.top_rng_inst.display.datas\[9\] vssd1 vssd1 vccd1 vccd1 _184_ sky130_fd_sc_hd__and2_1
XFILLER_4_95 vssd1 vssd1 vccd1 vccd1 sky130_fd_sc_hd__fill_1
XFILLER_4_191 vssd1 vssd1 vccd1 vccd1 sky130_fd_sc_hd__fill_4
X_322_ TOP.top_rng_inst.lut1.internal_state\[5\] TOP.top_rng_inst.lut1.internal_state\[6\]
+ vssd1 vssd1 vccd1 vccd1 _130_ sky130_fd_sc_hd__xor2_1
XFILLER_2_106 vssd1 vssd1 vccd1 vccd1 sky130_fd_sc_hd__fill_2
XFILLER_2_139 vssd1 vssd1 vccd1 vccd1 sky130_fd_sc_hd__fill_1
X_253_ TOP.top_rng_inst.display.current_data\[2\] _078_ vssd1 vssd1 vccd1 vccd1 _080_
+ sky130_fd_sc_hd__nand2_1
Xclkbuf_3_7__f_clk clknet_0_clk vssd1 vssd1 vccd1 vccd1 clknet_3_7__leaf_clk sky130_fd_sc_hd__clkbuf_16
XFILLER_1_161 vssd1 vssd1 vccd1 vccd1 sky130_fd_sc_hd__fill_2
XANTENNA__383__A net29 vssd1 vssd1 vccd1 vccd1 sky130_fd_sc_hd__diode_2
Xclkload3 clknet_3_4__leaf_clk vssd1 vssd1 vccd1 vccd1 clkload3/Y sky130_fd_sc_hd__clkinv_4
X_236_ TOP.top_rng_inst.ecstate.count_out\[2\] TOP.top_rng_inst.ecstate.count_out\[1\]
+ TOP.top_rng_inst.ecstate.count_out\[0\] TOP.top_rng_inst.ecstate.count_out\[3\]
+ vssd1 vssd1 vccd1 vccd1 _069_ sky130_fd_sc_hd__a31o_1
X_305_ net31 _114_ TOP.top_rng_inst.display.datas\[3\] vssd1 vssd1 vccd1 vccd1 _115_
+ sky130_fd_sc_hd__a21oi_1
XFILLER_19_113 vssd1 vssd1 vccd1 vccd1 sky130_fd_sc_hd__fill_8
Xhold37 TOP.top_rng_inst.lut1.internal_state\[14\] vssd1 vssd1 vccd1 vccd1 net136
+ sky130_fd_sc_hd__dlygate4sd3_1
Xhold15 TOP.top_rng_inst.display.datas\[5\] vssd1 vssd1 vccd1 vccd1 net114 sky130_fd_sc_hd__dlygate4sd3_1
Xhold26 TOP.top_rng_inst.display.datas\[4\] vssd1 vssd1 vccd1 vccd1 net125 sky130_fd_sc_hd__dlygate4sd3_1
X_219_ TOP.top_rng_inst.lut1.ecstate.count_out\[1\] TOP.top_rng_inst.lut1.ecstate.count_out\[0\]
+ TOP.top_rng_inst.lut1.ecstate.count_out\[2\] vssd1 vssd1 vccd1 vccd1 _061_ sky130_fd_sc_hd__and3_1
Xoutput16 net16 vssd1 vssd1 vccd1 vccd1 gpio_out[20] sky130_fd_sc_hd__buf_2
XFILLER_31_27 vssd1 vssd1 vccd1 vccd1 sky130_fd_sc_hd__fill_1
XFILLER_24_171 vccd1 vssd1 vccd1 vssd1 sky130_ef_sc_hd__decap_40_12
Xclkbuf_0_clk clk vssd1 vssd1 vccd1 vccd1 clknet_0_clk sky130_fd_sc_hd__clkbuf_16
XFILLER_30_141 vssd1 vssd1 vccd1 vccd1 sky130_fd_sc_hd__fill_8
XPHY_EDGE_ROW_24_Right_24 vssd1 vssd1 vccd1 vccd1 sky130_fd_sc_hd__decap_3
XPHY_EDGE_ROW_15_Right_15 vssd1 vssd1 vccd1 vccd1 sky130_fd_sc_hd__decap_3
XANTENNA__391__A net29 vssd1 vssd1 vccd1 vccd1 sky130_fd_sc_hd__diode_2
XTAP_TAPCELL_ROW_31_180 vssd1 vccd1 sky130_fd_sc_hd__tapvpwrvgnd_1
XFILLER_12_141 vssd1 vssd1 vccd1 vccd1 sky130_fd_sc_hd__fill_4
X_484_ clknet_3_0__leaf_clk net103 net33 vssd1 vssd1 vccd1 vccd1 TOP.top_rng_inst.k1.sync_r0.sync
+ sky130_fd_sc_hd__dfrtp_2
XTAP_TAPCELL_ROW_20_139 vssd1 vccd1 sky130_fd_sc_hd__tapvpwrvgnd_1
XTAP_TAPCELL_ROW_11_106 vssd1 vccd1 sky130_fd_sc_hd__tapvpwrvgnd_1
XFILLER_27_92 vssd1 vssd1 vccd1 vccd1 sky130_fd_sc_hd__fill_1
X_398_ net137 net23 net20 net140 _183_ vssd1 vssd1 vccd1 vccd1 _032_ sky130_fd_sc_hd__a221o_1
X_467_ clknet_3_6__leaf_clk _035_ net40 vssd1 vssd1 vccd1 vccd1 TOP.top_rng_inst.lut1.internal_state\[11\]
+ sky130_fd_sc_hd__dfrtp_1
XFILLER_4_85 vssd1 vssd1 vccd1 vccd1 sky130_fd_sc_hd__fill_8
X_252_ TOP.top_rng_inst.display.current_data\[1\] TOP.top_rng_inst.display.current_data\[2\]
+ vssd1 vssd1 vccd1 vccd1 _079_ sky130_fd_sc_hd__and2b_1
Xfanout40 net42 vssd1 vssd1 vccd1 vccd1 net40 sky130_fd_sc_hd__clkbuf_4
X_321_ _127_ _128_ _119_ vssd1 vssd1 vccd1 vccd1 _129_ sky130_fd_sc_hd__a21bo_1
XTAP_TAPCELL_ROW_0_64 vssd1 vccd1 sky130_fd_sc_hd__tapvpwrvgnd_1
XFILLER_11_206 vssd1 vssd1 vccd1 vccd1 sky130_fd_sc_hd__fill_2
X_235_ net117 net106 _068_ vssd1 vssd1 vccd1 vccd1 TOP.top_rng_inst.ecstate.next_count\[1\]
+ sky130_fd_sc_hd__a21oi_1
X_304_ _042_ _113_ vssd1 vssd1 vccd1 vccd1 _114_ sky130_fd_sc_hd__nand2_1
Xclkload4 clknet_3_5__leaf_clk vssd1 vssd1 vccd1 vccd1 clkload4/Y sky130_fd_sc_hd__clkinv_2
XFILLER_1_6 vssd1 vssd1 vccd1 vccd1 sky130_fd_sc_hd__fill_8
XFILLER_20_29 vssd1 vssd1 vccd1 vccd1 sky130_fd_sc_hd__fill_2
XFILLER_28_169 vssd1 vssd1 vccd1 vccd1 sky130_fd_sc_hd__fill_1
XFILLER_28_158 vssd1 vssd1 vccd1 vccd1 sky130_fd_sc_hd__fill_4
XFILLER_28_147 vssd1 vssd1 vccd1 vccd1 sky130_fd_sc_hd__fill_8
Xhold27 TOP.top_rng_inst.ecstate.count_out\[5\] vssd1 vssd1 vccd1 vccd1 net126 sky130_fd_sc_hd__dlygate4sd3_1
Xhold38 TOP.top_rng_inst.lut1.internal_state\[8\] vssd1 vssd1 vccd1 vccd1 net137 sky130_fd_sc_hd__dlygate4sd3_1
Xhold16 TOP.top_rng_inst.display.datas\[6\] vssd1 vssd1 vccd1 vccd1 net115 sky130_fd_sc_hd__dlygate4sd3_1
X_218_ TOP.top_rng_inst.lut1.started _059_ vssd1 vssd1 vccd1 vccd1 _060_ sky130_fd_sc_hd__and2_1
XFILLER_19_158 vssd1 vssd1 vccd1 vccd1 sky130_fd_sc_hd__fill_1
Xoutput17 net17 vssd1 vssd1 vccd1 vccd1 gpio_out[8] sky130_fd_sc_hd__buf_2
XANTENNA__389__A net29 vssd1 vssd1 vccd1 vccd1 sky130_fd_sc_hd__diode_2
XFILLER_24_183 vssd1 vssd1 vccd1 vccd1 sky130_fd_sc_hd__fill_1
XFILLER_30_197 vssd1 vssd1 vccd1 vccd1 sky130_fd_sc_hd__fill_8
XFILLER_26_17 vssd1 vssd1 vccd1 vccd1 sky130_fd_sc_hd__fill_2
XPHY_EDGE_ROW_15_Left_47 vssd1 vssd1 vccd1 vccd1 sky130_fd_sc_hd__decap_3
XTAP_TAPCELL_ROW_31_181 vssd1 vccd1 sky130_fd_sc_hd__tapvpwrvgnd_1
XTAP_TAPCELL_ROW_23_148 vssd1 vccd1 sky130_fd_sc_hd__tapvpwrvgnd_1
XANTENNA_fanout42_X net42 vssd1 vssd1 vccd1 vccd1 sky130_fd_sc_hd__diode_2
X_483_ clknet_3_1__leaf_clk net2 net33 vssd1 vssd1 vccd1 vccd1 TOP.top_rng_inst.k1.sync_r0.n_sr\[1\]
+ sky130_fd_sc_hd__dfrtp_1
XFILLER_12_197 vccd1 vssd1 vccd1 vssd1 sky130_ef_sc_hd__decap_40_12
XFILLER_8_124 vssd1 vssd1 vccd1 vccd1 sky130_fd_sc_hd__fill_2
XFILLER_8_157 vssd1 vssd1 vccd1 vccd1 sky130_fd_sc_hd__fill_2
XTAP_TAPCELL_ROW_11_107 vssd1 vccd1 sky130_fd_sc_hd__tapvpwrvgnd_1
X_397_ net28 TOP.top_rng_inst.display.datas\[8\] vssd1 vssd1 vccd1 vccd1 _183_ sky130_fd_sc_hd__and2_1
X_466_ clknet_3_1__leaf_clk net133 net36 vssd1 vssd1 vccd1 vccd1 TOP.top_rng_inst.lut1.internal_state\[10\]
+ sky130_fd_sc_hd__dfrtp_1
XPHY_EDGE_ROW_18_Left_50 vssd1 vssd1 vccd1 vccd1 sky130_fd_sc_hd__decap_3
XFILLER_4_53 vssd1 vssd1 vccd1 vccd1 sky130_fd_sc_hd__fill_1
X_251_ TOP.top_rng_inst.display.current_data\[1\] TOP.top_rng_inst.display.current_data\[0\]
+ vssd1 vssd1 vccd1 vccd1 _078_ sky130_fd_sc_hd__nor2_1
Xfanout30 TOP.top_rng_inst.display.current_data\[3\] vssd1 vssd1 vccd1 vccd1 net30
+ sky130_fd_sc_hd__clkbuf_2
Xfanout41 net42 vssd1 vssd1 vccd1 vccd1 net41 sky130_fd_sc_hd__buf_2
XFILLER_13_84 vssd1 vssd1 vccd1 vccd1 sky130_fd_sc_hd__fill_4
XFILLER_13_51 vssd1 vssd1 vccd1 vccd1 sky130_fd_sc_hd__fill_4
X_320_ _042_ _126_ vssd1 vssd1 vccd1 vccd1 _128_ sky130_fd_sc_hd__nand2_1
XFILLER_1_163 vssd1 vssd1 vccd1 vccd1 sky130_fd_sc_hd__fill_1
XTAP_TAPCELL_ROW_0_65 vssd1 vccd1 sky130_fd_sc_hd__tapvpwrvgnd_1
X_449_ clknet_3_6__leaf_clk _017_ net40 vssd1 vssd1 vccd1 vccd1 TOP.top_rng_inst.display.datas\[12\]
+ sky130_fd_sc_hd__dfrtp_1
Xclkload5 clknet_3_6__leaf_clk vssd1 vssd1 vccd1 vccd1 clkload5/Y sky130_fd_sc_hd__bufinv_16
XPHY_EDGE_ROW_3_Left_35 vssd1 vssd1 vccd1 vccd1 sky130_fd_sc_hd__decap_3
XFILLER_24_83 vssd1 vssd1 vccd1 vccd1 sky130_fd_sc_hd__fill_1
X_234_ TOP.top_rng_inst.ecstate.count_out\[1\] TOP.top_rng_inst.ecstate.count_out\[0\]
+ _052_ vssd1 vssd1 vccd1 vccd1 _068_ sky130_fd_sc_hd__o21ai_1
X_303_ TOP.top_rng_inst.k1.sync_r3.sync TOP.top_rng_inst.k1.sync_r2.sync TOP.top_rng_inst.k1.sync_r1.sync
+ TOP.top_rng_inst.k1.sync_r0.sync net27 TOP.top_rng_inst.display.datas\[1\] vssd1
+ vssd1 vccd1 vccd1 _113_ sky130_fd_sc_hd__mux4_1
Xhold17 TOP.top_rng_inst.lut1.ecstate.count_out\[5\] vssd1 vssd1 vccd1 vccd1 net116
+ sky130_fd_sc_hd__dlygate4sd3_1
Xhold39 TOP.top_rng_inst.lut1.internal_state\[12\] vssd1 vssd1 vccd1 vccd1 net138
+ sky130_fd_sc_hd__dlygate4sd3_1
Xhold28 TOP.top_rng_inst.display.datas\[10\] vssd1 vssd1 vccd1 vccd1 net127 sky130_fd_sc_hd__dlygate4sd3_1
X_217_ TOP.top_rng_inst.lut1.ecstate.count_out\[4\] TOP.top_rng_inst.lut1.ecstate.count_out\[3\]
+ _058_ TOP.top_rng_inst.lut1.ecstate.count_out\[5\] vssd1 vssd1 vccd1 vccd1 _059_
+ sky130_fd_sc_hd__o31ai_1
XFILLER_10_85 vccd1 vssd1 vccd1 vssd1 sky130_ef_sc_hd__decap_40_12
XFILLER_10_74 vssd1 vssd1 vccd1 vccd1 sky130_fd_sc_hd__fill_1
XFILLER_10_41 vssd1 vssd1 vccd1 vccd1 sky130_fd_sc_hd__fill_1
XFILLER_3_203 vssd1 vssd1 vccd1 vccd1 sky130_fd_sc_hd__fill_8
XFILLER_31_29 vccd1 vssd1 vccd1 vssd1 sky130_ef_sc_hd__decap_40_12
Xoutput18 net18 vssd1 vssd1 vccd1 vccd1 gpio_out[9] sky130_fd_sc_hd__buf_2
XFILLER_18_170 vssd1 vssd1 vccd1 vccd1 sky130_fd_sc_hd__fill_1
XFILLER_7_20 vccd1 vssd1 vccd1 vssd1 sky130_ef_sc_hd__decap_40_12
XTAP_TAPCELL_ROW_31_182 vssd1 vccd1 sky130_fd_sc_hd__tapvpwrvgnd_1
XTAP_TAPCELL_ROW_23_149 vssd1 vccd1 sky130_fd_sc_hd__tapvpwrvgnd_1
XFILLER_21_121 vssd1 vssd1 vccd1 vccd1 sky130_fd_sc_hd__fill_2
XPHY_EDGE_ROW_5_Right_5 vssd1 vssd1 vccd1 vccd1 sky130_fd_sc_hd__decap_3
XTAP_TAPCELL_ROW_14_116 vssd1 vccd1 sky130_fd_sc_hd__tapvpwrvgnd_1
XFILLER_12_110 vssd1 vssd1 vccd1 vccd1 sky130_fd_sc_hd__fill_2
X_482_ clknet_3_0__leaf_clk net100 net34 vssd1 vssd1 vccd1 vccd1 TOP.top_rng_inst.k1.sync_r1.sync
+ sky130_fd_sc_hd__dfrtp_1
XTAP_TAPCELL_ROW_11_108 vssd1 vccd1 sky130_fd_sc_hd__tapvpwrvgnd_1
XANTENNA_clkbuf_3_7__f_clk_A clknet_0_clk vssd1 vssd1 vccd1 vccd1 sky130_fd_sc_hd__diode_2
X_396_ net140 net23 net20 TOP.top_rng_inst.lut1.internal_state\[6\] _182_ vssd1 vssd1
+ vccd1 vccd1 _031_ sky130_fd_sc_hd__a221o_1
X_465_ clknet_3_3__leaf_clk _033_ net36 vssd1 vssd1 vccd1 vccd1 TOP.top_rng_inst.lut1.internal_state\[9\]
+ sky130_fd_sc_hd__dfrtp_1
XFILLER_23_205 vssd1 vssd1 vccd1 vccd1 sky130_fd_sc_hd__fill_4
X_250_ net30 _076_ vssd1 vssd1 vccd1 vccd1 _077_ sky130_fd_sc_hd__nand2_1
Xfanout31 TOP.top_rng_inst.lut1.ecstate.rollover_flag vssd1 vssd1 vccd1 vccd1 net31
+ sky130_fd_sc_hd__clkbuf_4
Xfanout20 _173_ vssd1 vssd1 vccd1 vccd1 net20 sky130_fd_sc_hd__clkbuf_2
XANTENNA__352__S net31 vssd1 vssd1 vccd1 vccd1 sky130_fd_sc_hd__diode_2
Xfanout42 TOP.n_rst vssd1 vssd1 vccd1 vccd1 net42 sky130_fd_sc_hd__clkbuf_2
XANTENNA_input4_A gpio_in[2] vssd1 vssd1 vccd1 vccd1 sky130_fd_sc_hd__diode_2
X_379_ net28 TOP.top_rng_inst.lut1.started vssd1 vssd1 vccd1 vccd1 _173_ sky130_fd_sc_hd__and2b_1
X_448_ clknet_3_5__leaf_clk _016_ net38 vssd1 vssd1 vccd1 vccd1 TOP.top_rng_inst.display.datas\[11\]
+ sky130_fd_sc_hd__dfrtp_1
XFILLER_1_153 vssd1 vssd1 vccd1 vccd1 sky130_fd_sc_hd__fill_8
XTAP_TAPCELL_ROW_0_66 vssd1 vccd1 sky130_fd_sc_hd__tapvpwrvgnd_1
Xclkload6 clknet_3_7__leaf_clk vssd1 vssd1 vccd1 vccd1 clkload6/Y sky130_fd_sc_hd__clkinv_2
XFILLER_11_208 vssd1 vssd1 vccd1 vccd1 sky130_fd_sc_hd__fill_1
X_233_ net106 _052_ vssd1 vssd1 vccd1 vccd1 TOP.top_rng_inst.ecstate.next_count\[0\]
+ sky130_fd_sc_hd__nand2_1
XFILLER_1_55 vssd1 vssd1 vccd1 vccd1 sky130_fd_sc_hd__fill_1
X_302_ net24 _112_ net31 vssd1 vssd1 vccd1 vccd1 _007_ sky130_fd_sc_hd__mux2_1
XFILLER_29_18 vccd1 vssd1 vccd1 vssd1 sky130_ef_sc_hd__decap_40_12
XFILLER_28_138 vssd1 vssd1 vccd1 vccd1 sky130_fd_sc_hd__fill_2
Xhold29 TOP.top_rng_inst.display.datas\[9\] vssd1 vssd1 vccd1 vccd1 net128 sky130_fd_sc_hd__dlygate4sd3_1
Xhold18 TOP.top_rng_inst.ecstate.count_out\[1\] vssd1 vssd1 vccd1 vccd1 net117 sky130_fd_sc_hd__dlygate4sd3_1
XFILLER_27_182 vccd1 vssd1 vccd1 vssd1 sky130_ef_sc_hd__decap_40_12
XFILLER_10_97 vccd1 vssd1 vccd1 vssd1 sky130_ef_sc_hd__decap_40_12
X_216_ TOP.top_rng_inst.lut1.ecstate.count_out\[1\] TOP.top_rng_inst.lut1.ecstate.count_out\[0\]
+ TOP.top_rng_inst.lut1.ecstate.count_out\[2\] vssd1 vssd1 vccd1 vccd1 _058_ sky130_fd_sc_hd__o21a_1
XFILLER_25_119 vssd1 vssd1 vccd1 vccd1 sky130_fd_sc_hd__fill_4
XFILLER_18_3 vccd1 vssd1 vccd1 vssd1 sky130_ef_sc_hd__decap_40_12
XTAP_TAPCELL_ROW_26_158 vssd1 vccd1 sky130_fd_sc_hd__tapvpwrvgnd_1
XFILLER_24_141 vssd1 vssd1 vccd1 vccd1 sky130_fd_sc_hd__fill_2
XANTENNA__360__S net32 vssd1 vssd1 vccd1 vccd1 sky130_fd_sc_hd__diode_2
XPHY_EDGE_ROW_20_Right_20 vssd1 vssd1 vccd1 vccd1 sky130_fd_sc_hd__decap_3
XFILLER_16_41 vssd1 vssd1 vccd1 vccd1 sky130_fd_sc_hd__fill_2
XTAP_TAPCELL_ROW_14_117 vssd1 vccd1 sky130_fd_sc_hd__tapvpwrvgnd_1
X_481_ clknet_3_0__leaf_clk net3 net33 vssd1 vssd1 vccd1 vccd1 TOP.top_rng_inst.k1.sync_r1.n_sr\[1\]
+ sky130_fd_sc_hd__dfrtp_1
XPHY_EDGE_ROW_11_Right_11 vssd1 vssd1 vccd1 vccd1 sky130_fd_sc_hd__decap_3
XFILLER_8_126 vssd1 vssd1 vccd1 vccd1 sky130_fd_sc_hd__fill_1
XFILLER_8_137 vssd1 vssd1 vccd1 vccd1 sky130_fd_sc_hd__fill_1
XFILLER_8_159 vssd1 vssd1 vccd1 vccd1 sky130_fd_sc_hd__fill_1
XFILLER_7_181 vssd1 vssd1 vccd1 vccd1 sky130_fd_sc_hd__fill_8
XFILLER_27_84 vssd1 vssd1 vccd1 vccd1 sky130_fd_sc_hd__fill_1
XFILLER_27_51 vssd1 vssd1 vccd1 vccd1 sky130_fd_sc_hd__fill_4
X_464_ clknet_3_3__leaf_clk _032_ net36 vssd1 vssd1 vccd1 vccd1 TOP.top_rng_inst.lut1.internal_state\[8\]
+ sky130_fd_sc_hd__dfrtp_1
Xclkbuf_3_2__f_clk clknet_0_clk vssd1 vssd1 vccd1 vccd1 clknet_3_2__leaf_clk sky130_fd_sc_hd__clkbuf_16
X_395_ net28 TOP.top_rng_inst.display.datas\[7\] vssd1 vssd1 vccd1 vccd1 _182_ sky130_fd_sc_hd__and2_1
XFILLER_4_22 vssd1 vssd1 vccd1 vccd1 sky130_fd_sc_hd__fill_4
XFILLER_4_195 vssd1 vssd1 vccd1 vccd1 sky130_fd_sc_hd__fill_1
Xfanout32 TOP.top_rng_inst.lut1.ecstate.rollover_flag vssd1 vssd1 vccd1 vccd1 net32
+ sky130_fd_sc_hd__buf_2
X_447_ clknet_3_0__leaf_clk _015_ net34 vssd1 vssd1 vccd1 vccd1 TOP.top_rng_inst.display.datas\[10\]
+ sky130_fd_sc_hd__dfrtp_1
XTAP_TAPCELL_ROW_0_67 vssd1 vccd1 sky130_fd_sc_hd__tapvpwrvgnd_1
XFILLER_1_121 vssd1 vssd1 vccd1 vccd1 sky130_fd_sc_hd__fill_2
X_378_ _170_ _171_ vssd1 vssd1 vccd1 vccd1 _172_ sky130_fd_sc_hd__nand2_1
X_232_ _064_ _067_ _060_ vssd1 vssd1 vccd1 vccd1 TOP.top_rng_inst.lut1.ecstate.next_count\[4\]
+ sky130_fd_sc_hd__and3b_1
XANTENNA__363__S net32 vssd1 vssd1 vccd1 vccd1 sky130_fd_sc_hd__diode_2
X_301_ _110_ _111_ vssd1 vssd1 vccd1 vccd1 _112_ sky130_fd_sc_hd__xnor2_1
Xhold19 TOP.top_rng_inst.ecstate.next_count\[1\] vssd1 vssd1 vccd1 vccd1 net118 sky130_fd_sc_hd__dlygate4sd3_1
XFILLER_25_109 vssd1 vssd1 vccd1 vccd1 sky130_fd_sc_hd__fill_2
X_215_ _040_ _053_ _052_ vssd1 vssd1 vccd1 vccd1 TOP.top_rng_inst.ecstate.next_count\[8\]
+ sky130_fd_sc_hd__a21boi_1
XTAP_TAPCELL_ROW_6_88 vssd1 vccd1 sky130_fd_sc_hd__tapvpwrvgnd_1
XTAP_TAPCELL_ROW_26_159 vssd1 vccd1 sky130_fd_sc_hd__tapvpwrvgnd_1
XFILLER_30_189 vssd1 vssd1 vccd1 vccd1 sky130_fd_sc_hd__fill_4
XFILLER_21_42 vccd1 vssd1 vccd1 vssd1 sky130_ef_sc_hd__decap_40_12
XFILLER_15_186 vccd1 vssd1 vccd1 vssd1 sky130_ef_sc_hd__decap_40_12
XFILLER_21_123 vssd1 vssd1 vccd1 vccd1 sky130_fd_sc_hd__fill_1
XTAP_TAPCELL_ROW_14_118 vssd1 vccd1 sky130_fd_sc_hd__tapvpwrvgnd_1
XFILLER_12_145 vssd1 vssd1 vccd1 vccd1 sky130_fd_sc_hd__fill_1
X_480_ clknet_3_0__leaf_clk net101 net34 vssd1 vssd1 vccd1 vccd1 TOP.top_rng_inst.k1.sync_r2.sync
+ sky130_fd_sc_hd__dfrtp_1
XTAP_TAPCELL_ROW_3_78 vssd1 vccd1 sky130_fd_sc_hd__tapvpwrvgnd_1
X_463_ clknet_3_3__leaf_clk _031_ net36 vssd1 vssd1 vccd1 vccd1 TOP.top_rng_inst.lut1.internal_state\[7\]
+ sky130_fd_sc_hd__dfrtp_1
X_394_ TOP.top_rng_inst.lut1.internal_state\[6\] net22 net19 net143 _181_ vssd1 vssd1
+ vccd1 vccd1 _030_ sky130_fd_sc_hd__a221o_1
XFILLER_4_130 vssd1 vssd1 vccd1 vccd1 sky130_fd_sc_hd__fill_1
XFILLER_4_141 vccd1 vssd1 vccd1 vssd1 sky130_ef_sc_hd__decap_40_12
Xfanout22 _097_ vssd1 vssd1 vccd1 vccd1 net22 sky130_fd_sc_hd__clkbuf_4
Xfanout33 net34 vssd1 vssd1 vccd1 vccd1 net33 sky130_fd_sc_hd__clkbuf_4
X_446_ clknet_3_0__leaf_clk _014_ net35 vssd1 vssd1 vccd1 vccd1 TOP.top_rng_inst.display.datas\[9\]
+ sky130_fd_sc_hd__dfrtp_1
XFILLER_1_166 vssd1 vssd1 vccd1 vccd1 sky130_fd_sc_hd__fill_2
XTAP_TAPCELL_ROW_0_68 vssd1 vccd1 sky130_fd_sc_hd__tapvpwrvgnd_1
X_377_ TOP.top_rng_inst.lut1.internal_state\[2\] TOP.top_rng_inst.lut1.internal_state\[1\]
+ vssd1 vssd1 vccd1 vccd1 _171_ sky130_fd_sc_hd__xnor2_1
XTAP_TAPCELL_ROW_9_99 vssd1 vccd1 sky130_fd_sc_hd__tapvpwrvgnd_1
XANTENNA__394__B1 net19 vssd1 vssd1 vccd1 vccd1 sky130_fd_sc_hd__diode_2
X_231_ TOP.top_rng_inst.lut1.ecstate.count_out\[4\] _063_ vssd1 vssd1 vccd1 vccd1
+ _067_ sky130_fd_sc_hd__or2_1
X_436__99 vssd1 vssd1 vccd1 vccd1 net99 _436__99/LO sky130_fd_sc_hd__conb_1
XFILLER_24_97 vccd1 vssd1 vccd1 vssd1 sky130_ef_sc_hd__decap_40_12
XFILLER_24_42 vssd1 vssd1 vccd1 vccd1 sky130_fd_sc_hd__fill_2
X_300_ TOP.top_rng_inst.lut1.internal_state\[2\] TOP.top_rng_inst.lut1.internal_state\[6\]
+ vssd1 vssd1 vccd1 vccd1 _111_ sky130_fd_sc_hd__xor2_1
X_429_ clknet_3_2__leaf_clk TOP.top_rng_inst.ecstate.next_count\[2\] net35 vssd1 vssd1
+ vccd1 vccd1 TOP.top_rng_inst.ecstate.count_out\[2\] sky130_fd_sc_hd__dfrtp_2
XFILLER_1_57 vssd1 vssd1 vccd1 vccd1 sky130_fd_sc_hd__fill_2
XFILLER_1_35 vccd1 vssd1 vccd1 vssd1 sky130_ef_sc_hd__decap_40_12
XFILLER_19_53 vssd1 vssd1 vccd1 vccd1 sky130_fd_sc_hd__fill_2
Xinput1 en vssd1 vssd1 vccd1 vccd1 net1 sky130_fd_sc_hd__clkbuf_1
XPHY_EDGE_ROW_7_Left_39 vssd1 vssd1 vccd1 vccd1 sky130_fd_sc_hd__decap_3
XFILLER_27_173 vssd1 vssd1 vccd1 vccd1 sky130_fd_sc_hd__fill_2
XFILLER_25_6 vssd1 vssd1 vccd1 vccd1 sky130_fd_sc_hd__fill_8
X_214_ _045_ _052_ _057_ vssd1 vssd1 vccd1 vccd1 TOP.top_rng_inst.ecstate.next_count\[2\]
+ sky130_fd_sc_hd__and3_1
XANTENNA__403__A net29 vssd1 vssd1 vccd1 vccd1 sky130_fd_sc_hd__diode_2
XTAP_TAPCELL_ROW_6_89 vssd1 vccd1 sky130_fd_sc_hd__tapvpwrvgnd_1
XFILLER_21_54 vssd1 vssd1 vccd1 vccd1 sky130_fd_sc_hd__fill_2
XTAP_TAPCELL_ROW_17_127 vssd1 vccd1 sky130_fd_sc_hd__tapvpwrvgnd_1
XFILLER_15_198 vssd1 vssd1 vccd1 vccd1 sky130_fd_sc_hd__fill_4
XFILLER_23_3 vssd1 vssd1 vccd1 vccd1 sky130_fd_sc_hd__fill_2
XFILLER_21_113 vssd1 vssd1 vccd1 vccd1 sky130_fd_sc_hd__fill_8
XFILLER_7_78 vssd1 vssd1 vccd1 vccd1 sky130_fd_sc_hd__fill_2
XFILLER_16_43 vssd1 vssd1 vccd1 vccd1 sky130_fd_sc_hd__fill_1
XTAP_TAPCELL_ROW_14_119 vssd1 vccd1 sky130_fd_sc_hd__tapvpwrvgnd_1
XTAP_TAPCELL_ROW_3_79 vssd1 vccd1 sky130_fd_sc_hd__tapvpwrvgnd_1
XFILLER_8_106 vssd1 vssd1 vccd1 vccd1 sky130_fd_sc_hd__fill_1
XPHY_EDGE_ROW_9_Right_9 vssd1 vssd1 vccd1 vccd1 sky130_fd_sc_hd__decap_3
XFILLER_4_197 vccd1 vssd1 vccd1 vssd1 sky130_ef_sc_hd__decap_40_12
X_393_ net29 TOP.top_rng_inst.display.datas\[6\] vssd1 vssd1 vccd1 vccd1 _181_ sky130_fd_sc_hd__and2_1
X_462_ clknet_3_4__leaf_clk _030_ net39 vssd1 vssd1 vccd1 vccd1 TOP.top_rng_inst.lut1.internal_state\[6\]
+ sky130_fd_sc_hd__dfrtp_4
Xfanout23 _097_ vssd1 vssd1 vccd1 vccd1 net23 sky130_fd_sc_hd__clkbuf_2
XFILLER_13_88 vssd1 vssd1 vccd1 vccd1 sky130_fd_sc_hd__fill_1
XFILLER_13_55 vssd1 vssd1 vccd1 vccd1 sky130_fd_sc_hd__fill_1
Xfanout34 net37 vssd1 vssd1 vccd1 vccd1 net34 sky130_fd_sc_hd__buf_2
XTAP_TAPCELL_ROW_0_69 vssd1 vccd1 sky130_fd_sc_hd__tapvpwrvgnd_1
XFILLER_1_123 vssd1 vssd1 vccd1 vccd1 sky130_fd_sc_hd__fill_1
X_445_ clknet_3_6__leaf_clk _013_ net40 vssd1 vssd1 vccd1 vccd1 TOP.top_rng_inst.display.datas\[8\]
+ sky130_fd_sc_hd__dfrtp_1
X_376_ TOP.top_rng_inst.lut1.internal_state\[4\] TOP.top_rng_inst.lut1.internal_state\[15\]
+ vssd1 vssd1 vccd1 vccd1 _170_ sky130_fd_sc_hd__xnor2_1
X_230_ _063_ _066_ _060_ vssd1 vssd1 vccd1 vccd1 TOP.top_rng_inst.lut1.ecstate.next_count\[3\]
+ sky130_fd_sc_hd__and3b_1
XANTENNA_input2_A gpio_in[0] vssd1 vssd1 vccd1 vccd1 sky130_fd_sc_hd__diode_2
XPHY_EDGE_ROW_23_Left_55 vssd1 vssd1 vccd1 vccd1 sky130_fd_sc_hd__decap_3
X_359_ _158_ _159_ vssd1 vssd1 vccd1 vccd1 _160_ sky130_fd_sc_hd__xnor2_1
X_428_ clknet_3_2__leaf_clk net118 net35 vssd1 vssd1 vccd1 vccd1 TOP.top_rng_inst.ecstate.count_out\[1\]
+ sky130_fd_sc_hd__dfrtp_1
XFILLER_1_69 vssd1 vssd1 vccd1 vccd1 sky130_fd_sc_hd__fill_1
XFILLER_1_47 vssd1 vssd1 vccd1 vccd1 sky130_fd_sc_hd__fill_8
XFILLER_1_14 vssd1 vssd1 vccd1 vccd1 sky130_fd_sc_hd__fill_1
XANTENNA_clkbuf_3_0__f_clk_A clknet_0_clk vssd1 vssd1 vccd1 vccd1 sky130_fd_sc_hd__diode_2
XFILLER_10_23 vssd1 vssd1 vccd1 vccd1 sky130_fd_sc_hd__fill_4
Xinput2 gpio_in[0] vssd1 vssd1 vccd1 vccd1 net2 sky130_fd_sc_hd__clkbuf_1
XTAP_TAPCELL_ROW_29_169 vssd1 vccd1 sky130_fd_sc_hd__tapvpwrvgnd_1
XFILLER_19_108 vssd1 vssd1 vccd1 vccd1 sky130_fd_sc_hd__fill_4
XFILLER_19_65 vssd1 vssd1 vccd1 vccd1 sky130_fd_sc_hd__fill_2
X_213_ TOP.top_rng_inst.ecstate.count_out\[1\] TOP.top_rng_inst.ecstate.count_out\[0\]
+ TOP.top_rng_inst.ecstate.count_out\[2\] vssd1 vssd1 vccd1 vccd1 _057_ sky130_fd_sc_hd__a21o_1
XFILLER_18_141 vssd1 vssd1 vccd1 vccd1 sky130_fd_sc_hd__fill_4
XFILLER_21_33 vssd1 vssd1 vccd1 vccd1 sky130_fd_sc_hd__fill_1
XTAP_TAPCELL_ROW_17_128 vssd1 vccd1 sky130_fd_sc_hd__tapvpwrvgnd_1
XANTENNA__295__S net31 vssd1 vssd1 vccd1 vccd1 sky130_fd_sc_hd__diode_2
XFILLER_29_203 vssd1 vssd1 vccd1 vccd1 sky130_fd_sc_hd__fill_4
XPHY_EDGE_ROW_10_Left_42 vssd1 vssd1 vccd1 vccd1 sky130_fd_sc_hd__decap_3
X_392_ net143 net22 net19 TOP.top_rng_inst.lut1.internal_state\[4\] _180_ vssd1 vssd1
+ vccd1 vccd1 _029_ sky130_fd_sc_hd__a221o_1
X_461_ clknet_3_5__leaf_clk _029_ net39 vssd1 vssd1 vccd1 vccd1 TOP.top_rng_inst.lut1.internal_state\[5\]
+ sky130_fd_sc_hd__dfrtp_1
XFILLER_4_110 vccd1 vssd1 vccd1 vssd1 sky130_ef_sc_hd__decap_40_12
Xfanout35 net36 vssd1 vssd1 vccd1 vccd1 net35 sky130_fd_sc_hd__clkbuf_4
XFILLER_1_113 vssd1 vssd1 vccd1 vccd1 sky130_fd_sc_hd__fill_8
Xfanout24 TOP.top_rng_inst.display.datas\[2\] vssd1 vssd1 vccd1 vccd1 net24 sky130_fd_sc_hd__buf_2
X_375_ net104 _169_ vssd1 vssd1 vccd1 vccd1 _023_ sky130_fd_sc_hd__xor2_1
X_444_ clknet_3_3__leaf_clk _012_ net36 vssd1 vssd1 vccd1 vccd1 TOP.top_rng_inst.display.datas\[7\]
+ sky130_fd_sc_hd__dfrtp_1
XFILLER_24_33 vssd1 vssd1 vccd1 vccd1 sky130_fd_sc_hd__fill_1
XFILLER_24_22 vssd1 vssd1 vccd1 vccd1 sky130_fd_sc_hd__fill_4
XANTENNA__394__A2 net22 vssd1 vssd1 vccd1 vccd1 sky130_fd_sc_hd__diode_2
XFILLER_24_44 vssd1 vssd1 vccd1 vccd1 sky130_fd_sc_hd__fill_1
X_358_ TOP.top_rng_inst.lut1.internal_state\[6\] TOP.top_rng_inst.lut1.internal_state\[12\]
+ vssd1 vssd1 vccd1 vccd1 _159_ sky130_fd_sc_hd__xnor2_1
X_427_ clknet_3_0__leaf_clk TOP.top_rng_inst.ecstate.next_count\[0\] net35 vssd1 vssd1
+ vccd1 vccd1 TOP.top_rng_inst.ecstate.count_out\[0\] sky130_fd_sc_hd__dfrtp_2
XPHY_EDGE_ROW_27_Right_27 vssd1 vssd1 vccd1 vccd1 sky130_fd_sc_hd__decap_3
XPHY_EDGE_ROW_18_Right_18 vssd1 vssd1 vccd1 vccd1 sky130_fd_sc_hd__decap_3
Xinput3 gpio_in[1] vssd1 vssd1 vccd1 vccd1 net3 sky130_fd_sc_hd__clkbuf_1
X_289_ net27 _101_ net32 vssd1 vssd1 vccd1 vccd1 _005_ sky130_fd_sc_hd__mux2_1
XFILLER_27_175 vssd1 vssd1 vccd1 vccd1 sky130_fd_sc_hd__fill_1
X_212_ _047_ _056_ vssd1 vssd1 vccd1 vccd1 TOP.top_rng_inst.ecstate.next_count\[4\]
+ sky130_fd_sc_hd__nor2_1
XFILLER_19_55 vssd1 vssd1 vccd1 vccd1 sky130_fd_sc_hd__fill_1
XFILLER_19_11 vssd1 vssd1 vccd1 vccd1 sky130_fd_sc_hd__fill_2
XTAP_TAPCELL_ROW_17_129 vssd1 vccd1 sky130_fd_sc_hd__tapvpwrvgnd_1
Xmax_cap21 _117_ vssd1 vssd1 vccd1 vccd1 net21 sky130_fd_sc_hd__clkbuf_1
XTAP_TAPCELL_ROW_31_176 vssd1 vccd1 sky130_fd_sc_hd__tapvpwrvgnd_1
XFILLER_12_126 vccd1 vssd1 vccd1 vssd1 sky130_ef_sc_hd__decap_40_12
XPHY_EDGE_ROW_0_Right_0 vssd1 vssd1 vccd1 vccd1 sky130_fd_sc_hd__decap_3
XFILLER_26_207 vssd1 vssd1 vccd1 vccd1 sky130_fd_sc_hd__fill_1
XFILLER_11_181 vssd1 vssd1 vccd1 vccd1 sky130_fd_sc_hd__fill_1
XFILLER_27_77 vssd1 vssd1 vccd1 vccd1 sky130_fd_sc_hd__fill_1
XFILLER_27_55 vssd1 vssd1 vccd1 vccd1 sky130_fd_sc_hd__fill_1
XANTENNA_fanout19_X net19 vssd1 vssd1 vccd1 vccd1 sky130_fd_sc_hd__diode_2
X_391_ net29 TOP.top_rng_inst.display.datas\[5\] vssd1 vssd1 vccd1 vccd1 _180_ sky130_fd_sc_hd__and2_1
XTAP_TAPCELL_ROW_10_102 vssd1 vccd1 sky130_fd_sc_hd__tapvpwrvgnd_1
X_460_ clknet_3_5__leaf_clk _028_ net39 vssd1 vssd1 vccd1 vccd1 TOP.top_rng_inst.lut1.internal_state\[4\]
+ sky130_fd_sc_hd__dfrtp_1
XFILLER_4_26 vssd1 vssd1 vccd1 vccd1 sky130_fd_sc_hd__fill_2
XFILLER_4_37 vccd1 vssd1 vccd1 vssd1 sky130_ef_sc_hd__decap_40_12
XFILLER_4_122 vssd1 vssd1 vccd1 vccd1 sky130_fd_sc_hd__fill_8
XFILLER_4_155 vssd1 vssd1 vccd1 vccd1 sky130_fd_sc_hd__fill_1
Xfanout36 net37 vssd1 vssd1 vccd1 vccd1 net36 sky130_fd_sc_hd__clkbuf_4
XFILLER_13_57 vccd1 vssd1 vccd1 vssd1 sky130_ef_sc_hd__decap_40_12
Xfanout25 TOP.top_rng_inst.display.datas\[1\] vssd1 vssd1 vccd1 vccd1 net25 sky130_fd_sc_hd__buf_2
X_374_ _168_ _169_ vssd1 vssd1 vccd1 vccd1 _022_ sky130_fd_sc_hd__nor2_1
XFILLER_9_203 vssd1 vssd1 vccd1 vccd1 sky130_fd_sc_hd__fill_1
X_443_ clknet_3_4__leaf_clk _011_ net38 vssd1 vssd1 vccd1 vccd1 TOP.top_rng_inst.display.datas\[6\]
+ sky130_fd_sc_hd__dfrtp_1
XFILLER_1_169 vssd1 vssd1 vccd1 vccd1 sky130_fd_sc_hd__fill_1
XANTENNA__388__B1 net19 vssd1 vssd1 vccd1 vccd1 sky130_fd_sc_hd__diode_2
XFILLER_0_191 vssd1 vssd1 vccd1 vccd1 sky130_fd_sc_hd__fill_1
XFILLER_6_3 vccd1 vssd1 vccd1 vssd1 sky130_ef_sc_hd__decap_40_12
X_426_ clknet_3_2__leaf_clk TOP.top_rng_inst.ecstate.next_flag net35 vssd1 vssd1 vccd1
+ vccd1 TOP.top_rng_inst.ecstate.rollover_flag sky130_fd_sc_hd__dfrtp_1
Xinput4 gpio_in[2] vssd1 vssd1 vccd1 vccd1 net4 sky130_fd_sc_hd__clkbuf_1
X_357_ net24 _119_ _145_ _143_ _122_ vssd1 vssd1 vccd1 vccd1 _158_ sky130_fd_sc_hd__a32o_1
X_288_ TOP.top_rng_inst.lut1.internal_state\[0\] _100_ vssd1 vssd1 vccd1 vccd1 _101_
+ sky130_fd_sc_hd__xnor2_1
X_211_ net145 _046_ _052_ vssd1 vssd1 vccd1 vccd1 _056_ sky130_fd_sc_hd__o21ai_1
X_409_ net28 TOP.top_rng_inst.display.datas\[14\] vssd1 vssd1 vccd1 vccd1 _189_ sky130_fd_sc_hd__and2_1
XFILLER_18_132 vssd1 vssd1 vccd1 vccd1 sky130_fd_sc_hd__fill_8
XFILLER_18_110 vccd1 vssd1 vccd1 vssd1 sky130_ef_sc_hd__decap_40_12
XFILLER_21_57 vccd1 vssd1 vccd1 vssd1 sky130_ef_sc_hd__decap_40_12
XFILLER_2_81 vssd1 vssd1 vccd1 vccd1 sky130_fd_sc_hd__fill_2
XFILLER_30_149 vssd1 vssd1 vccd1 vccd1 sky130_fd_sc_hd__fill_2
XFILLER_15_146 vccd1 vssd1 vccd1 vssd1 sky130_ef_sc_hd__decap_40_12
XFILLER_15_135 vssd1 vssd1 vccd1 vccd1 sky130_fd_sc_hd__fill_2
XFILLER_7_48 vssd1 vssd1 vccd1 vccd1 sky130_fd_sc_hd__fill_8
XTAP_TAPCELL_ROW_31_177 vssd1 vccd1 sky130_fd_sc_hd__tapvpwrvgnd_1
XTAP_TAPCELL_ROW_22_144 vssd1 vccd1 sky130_fd_sc_hd__tapvpwrvgnd_1
XFILLER_20_193 vssd1 vssd1 vccd1 vccd1 sky130_fd_sc_hd__fill_2
XFILLER_12_138 vssd1 vssd1 vccd1 vccd1 sky130_fd_sc_hd__fill_2
XFILLER_21_3 vssd1 vssd1 vccd1 vccd1 sky130_fd_sc_hd__fill_4
XFILLER_7_164 vssd1 vssd1 vccd1 vccd1 sky130_fd_sc_hd__fill_4
X_390_ TOP.top_rng_inst.lut1.internal_state\[4\] net22 net19 net124 _179_ vssd1 vssd1
+ vccd1 vccd1 _028_ sky130_fd_sc_hd__a221o_1
XTAP_TAPCELL_ROW_10_103 vssd1 vccd1 sky130_fd_sc_hd__tapvpwrvgnd_1
XFILLER_4_49 vssd1 vssd1 vccd1 vccd1 sky130_fd_sc_hd__fill_4
XFILLER_13_69 vssd1 vssd1 vccd1 vccd1 sky130_fd_sc_hd__fill_8
Xfanout37 net42 vssd1 vssd1 vccd1 vccd1 net37 sky130_fd_sc_hd__clkbuf_2
XTAP_TAPCELL_ROW_4_81 vssd1 vccd1 sky130_fd_sc_hd__tapvpwrvgnd_1
Xfanout26 net27 vssd1 vssd1 vccd1 vccd1 net26 sky130_fd_sc_hd__buf_2
X_373_ net14 net15 TOP.top_rng_inst.display.psc.rollover_flag vssd1 vssd1 vccd1 vccd1
+ _169_ sky130_fd_sc_hd__and3_1
XANTENNA_fanout31_X net31 vssd1 vssd1 vccd1 vccd1 sky130_fd_sc_hd__diode_2
XFILLER_13_211 vssd1 vssd1 vccd1 vccd1 sky130_fd_sc_hd__fill_1
X_442_ clknet_3_5__leaf_clk _010_ net38 vssd1 vssd1 vccd1 vccd1 TOP.top_rng_inst.display.datas\[5\]
+ sky130_fd_sc_hd__dfrtp_1
XFILLER_0_181 vssd1 vssd1 vccd1 vccd1 sky130_fd_sc_hd__fill_8
XFILLER_5_81 vccd1 vssd1 vccd1 vssd1 sky130_ef_sc_hd__decap_40_12
X_425_ clknet_3_3__leaf_clk _004_ net37 vssd1 vssd1 vccd1 vccd1 TOP.top_rng_inst.lut1.started
+ sky130_fd_sc_hd__dfrtp_1
X_356_ net120 _157_ net32 vssd1 vssd1 vccd1 vccd1 _016_ sky130_fd_sc_hd__mux2_1
XTAP_TAPCELL_ROW_1_71 vssd1 vccd1 sky130_fd_sc_hd__tapvpwrvgnd_1
X_287_ net24 TOP.top_rng_inst.display.datas\[3\] _099_ vssd1 vssd1 vccd1 vccd1 _100_
+ sky130_fd_sc_hd__or3b_1
Xinput5 gpio_in[3] vssd1 vssd1 vccd1 vccd1 net5 sky130_fd_sc_hd__clkbuf_1
XFILLER_27_100 vccd1 vssd1 vccd1 vssd1 sky130_ef_sc_hd__decap_40_12
XFILLER_19_57 vssd1 vssd1 vccd1 vccd1 sky130_fd_sc_hd__fill_8
XFILLER_19_13 vssd1 vssd1 vccd1 vccd1 sky130_fd_sc_hd__fill_1
XFILLER_10_37 vssd1 vssd1 vccd1 vccd1 sky130_fd_sc_hd__fill_4
X_210_ _048_ _055_ vssd1 vssd1 vccd1 vccd1 TOP.top_rng_inst.ecstate.next_count\[5\]
+ sky130_fd_sc_hd__nor2_1
XPHY_EDGE_ROW_27_Left_59 vssd1 vssd1 vccd1 vccd1 sky130_fd_sc_hd__decap_3
X_408_ TOP.top_rng_inst.lut1.internal_state\[13\] net22 net20 net138 _188_ vssd1 vssd1
+ vccd1 vccd1 _037_ sky130_fd_sc_hd__a221o_1
XFILLER_18_122 vssd1 vssd1 vccd1 vccd1 sky130_fd_sc_hd__fill_2
XANTENNA_fanout39_A net42 vssd1 vssd1 vccd1 vccd1 sky130_fd_sc_hd__diode_2
X_339_ TOP.top_rng_inst.display.datas\[3\] _118_ vssd1 vssd1 vccd1 vccd1 _144_ sky130_fd_sc_hd__nand2_1
XFILLER_2_60 vssd1 vssd1 vccd1 vccd1 sky130_fd_sc_hd__fill_8
XFILLER_21_69 vssd1 vssd1 vccd1 vccd1 sky130_fd_sc_hd__fill_8
XFILLER_15_169 vssd1 vssd1 vccd1 vccd1 sky130_fd_sc_hd__fill_2
XFILLER_15_158 vssd1 vssd1 vccd1 vccd1 sky130_fd_sc_hd__fill_1
XTAP_TAPCELL_ROW_31_178 vssd1 vccd1 sky130_fd_sc_hd__tapvpwrvgnd_1
XTAP_TAPCELL_ROW_7_92 vssd1 vccd1 sky130_fd_sc_hd__tapvpwrvgnd_1
XTAP_TAPCELL_ROW_22_145 vssd1 vccd1 sky130_fd_sc_hd__tapvpwrvgnd_1
XFILLER_12_106 vssd1 vssd1 vccd1 vccd1 sky130_fd_sc_hd__fill_4
XANTENNA__406__B1 net19 vssd1 vssd1 vccd1 vccd1 sky130_fd_sc_hd__diode_2
XFILLER_27_24 vssd1 vssd1 vccd1 vccd1 sky130_fd_sc_hd__fill_4
XPHY_EDGE_ROW_14_Left_46 vssd1 vssd1 vccd1 vccd1 sky130_fd_sc_hd__decap_3
XTAP_TAPCELL_ROW_10_104 vssd1 vccd1 sky130_fd_sc_hd__tapvpwrvgnd_1
XFILLER_4_17 vssd1 vssd1 vccd1 vccd1 sky130_fd_sc_hd__fill_1
XANTENNA_clkbuf_3_3__f_clk_A clknet_0_clk vssd1 vssd1 vccd1 vccd1 sky130_fd_sc_hd__diode_2
Xfanout38 net42 vssd1 vssd1 vccd1 vccd1 net38 sky130_fd_sc_hd__clkbuf_4
Xfanout27 TOP.top_rng_inst.display.datas\[0\] vssd1 vssd1 vccd1 vccd1 net27 sky130_fd_sc_hd__buf_2
XTAP_TAPCELL_ROW_4_82 vssd1 vccd1 sky130_fd_sc_hd__tapvpwrvgnd_1
X_372_ net14 TOP.top_rng_inst.display.psc.rollover_flag net15 vssd1 vssd1 vccd1 vccd1
+ _168_ sky130_fd_sc_hd__a21oi_1
XANTENNA__388__A2 net22 vssd1 vssd1 vccd1 vccd1 sky130_fd_sc_hd__diode_2
X_441_ clknet_3_5__leaf_clk _009_ net38 vssd1 vssd1 vccd1 vccd1 TOP.top_rng_inst.display.datas\[4\]
+ sky130_fd_sc_hd__dfrtp_1
XFILLER_5_71 vssd1 vssd1 vccd1 vccd1 sky130_fd_sc_hd__fill_4
XFILLER_5_93 vssd1 vssd1 vccd1 vccd1 sky130_fd_sc_hd__fill_1
X_424_ clknet_3_7__leaf_clk _003_ net41 vssd1 vssd1 vccd1 vccd1 TOP.top_rng_inst.display.current_data\[3\]
+ sky130_fd_sc_hd__dfrtp_1
X_355_ _155_ _156_ vssd1 vssd1 vccd1 vccd1 _157_ sky130_fd_sc_hd__xnor2_1
XTAP_TAPCELL_ROW_1_72 vssd1 vccd1 sky130_fd_sc_hd__tapvpwrvgnd_1
X_286_ net26 net25 TOP.top_rng_inst.k1.sync_r0.sync vssd1 vssd1 vccd1 vccd1 _099_
+ sky130_fd_sc_hd__nor3b_1
Xinput6 nrst vssd1 vssd1 vccd1 vccd1 net6 sky130_fd_sc_hd__clkbuf_1
XFILLER_10_27 vssd1 vssd1 vccd1 vccd1 sky130_fd_sc_hd__fill_1
XFILLER_27_167 vssd1 vssd1 vccd1 vccd1 sky130_fd_sc_hd__fill_1
XPHY_EDGE_ROW_23_Right_23 vssd1 vssd1 vccd1 vccd1 sky130_fd_sc_hd__decap_3
Xclkbuf_3_3__f_clk clknet_0_clk vssd1 vssd1 vccd1 vccd1 clknet_3_3__leaf_clk sky130_fd_sc_hd__clkbuf_16
XPHY_EDGE_ROW_14_Right_14 vssd1 vssd1 vccd1 vccd1 sky130_fd_sc_hd__decap_3
XPHY_EDGE_ROW_2_Left_34 vssd1 vssd1 vccd1 vccd1 sky130_fd_sc_hd__decap_3
X_407_ net28 TOP.top_rng_inst.display.datas\[13\] vssd1 vssd1 vccd1 vccd1 _188_ sky130_fd_sc_hd__and2_1
X_338_ TOP.top_rng_inst.display.datas\[3\] _118_ vssd1 vssd1 vccd1 vccd1 _143_ sky130_fd_sc_hd__and2_1
XFILLER_2_83 vssd1 vssd1 vccd1 vccd1 sky130_fd_sc_hd__fill_1
X_269_ net12 net13 vssd1 vssd1 vccd1 vccd1 TOP.top_rng_inst.k1.n_keypad_col\[1\] sky130_fd_sc_hd__xor2_1
XFILLER_23_181 vccd1 vssd1 vccd1 vssd1 sky130_ef_sc_hd__decap_40_12
XFILLER_15_137 vssd1 vssd1 vccd1 vccd1 sky130_fd_sc_hd__fill_1
XFILLER_15_126 vssd1 vssd1 vccd1 vccd1 sky130_fd_sc_hd__fill_1
XTAP_TAPCELL_ROW_31_179 vssd1 vccd1 sky130_fd_sc_hd__tapvpwrvgnd_1
XFILLER_30_9 vccd1 vssd1 vccd1 vssd1 sky130_ef_sc_hd__decap_40_12
XFILLER_14_170 vssd1 vssd1 vccd1 vccd1 sky130_fd_sc_hd__fill_2
XTAP_TAPCELL_ROW_7_93 vssd1 vccd1 sky130_fd_sc_hd__tapvpwrvgnd_1
XFILLER_29_207 vssd1 vssd1 vccd1 vccd1 sky130_fd_sc_hd__fill_1
XTAP_TAPCELL_ROW_22_146 vssd1 vccd1 sky130_fd_sc_hd__tapvpwrvgnd_1
XFILLER_20_195 vssd1 vssd1 vccd1 vccd1 sky130_fd_sc_hd__fill_1
XFILLER_22_80 vssd1 vssd1 vccd1 vccd1 sky130_fd_sc_hd__fill_4
XTAP_TAPCELL_ROW_13_113 vssd1 vccd1 sky130_fd_sc_hd__tapvpwrvgnd_1
XFILLER_7_133 vssd1 vssd1 vccd1 vccd1 sky130_fd_sc_hd__fill_2
XPHY_EDGE_ROW_4_Right_4 vssd1 vssd1 vccd1 vccd1 sky130_fd_sc_hd__decap_3
XPHY_EDGE_ROW_31_Left_63 vssd1 vssd1 vccd1 vccd1 sky130_fd_sc_hd__decap_3
XTAP_TAPCELL_ROW_10_105 vssd1 vccd1 sky130_fd_sc_hd__tapvpwrvgnd_1
XFILLER_3_191 vccd1 vssd1 vccd1 vssd1 sky130_ef_sc_hd__decap_40_12
XTAP_TAPCELL_ROW_4_83 vssd1 vccd1 sky130_fd_sc_hd__tapvpwrvgnd_1
X_371_ net14 net121 vssd1 vssd1 vccd1 vccd1 _021_ sky130_fd_sc_hd__xor2_1
Xfanout28 net29 vssd1 vssd1 vccd1 vccd1 net28 sky130_fd_sc_hd__clkbuf_2
Xfanout39 net42 vssd1 vssd1 vccd1 vccd1 net39 sky130_fd_sc_hd__clkbuf_2
X_440_ clknet_3_4__leaf_clk _008_ net38 vssd1 vssd1 vccd1 vccd1 TOP.top_rng_inst.display.datas\[3\]
+ sky130_fd_sc_hd__dfstp_2
XFILLER_24_26 vssd1 vssd1 vccd1 vccd1 sky130_fd_sc_hd__fill_2
XFILLER_10_205 vssd1 vssd1 vccd1 vccd1 sky130_fd_sc_hd__fill_4
X_423_ clknet_3_7__leaf_clk _002_ net41 vssd1 vssd1 vccd1 vccd1 TOP.top_rng_inst.display.current_data\[2\]
+ sky130_fd_sc_hd__dfrtp_4
X_354_ TOP.top_rng_inst.lut1.internal_state\[6\] TOP.top_rng_inst.lut1.internal_state\[11\]
+ vssd1 vssd1 vccd1 vccd1 _156_ sky130_fd_sc_hd__xor2_1
X_285_ net26 TOP.top_rng_inst.k1.sync_r0.sync vssd1 vssd1 vccd1 vccd1 _098_ sky130_fd_sc_hd__and2b_1
XTAP_TAPCELL_ROW_1_73 vssd1 vccd1 sky130_fd_sc_hd__tapvpwrvgnd_1
XFILLER_27_124 vccd1 vssd1 vccd1 vssd1 sky130_ef_sc_hd__decap_40_12
XFILLER_27_113 vssd1 vssd1 vccd1 vccd1 sky130_fd_sc_hd__fill_8
X_268_ TOP.top_rng_inst.display.current_data\[3\] _080_ _088_ vssd1 vssd1 vccd1 vccd1
+ net11 sky130_fd_sc_hd__a21o_1
X_199_ TOP.top_rng_inst.ecstate.count_out\[4\] _046_ vssd1 vssd1 vccd1 vccd1 _047_
+ sky130_fd_sc_hd__and2_1
X_406_ net138 net23 net19 net142 _187_ vssd1 vssd1 vccd1 vccd1 _036_ sky130_fd_sc_hd__a221o_1
XFILLER_18_168 vssd1 vssd1 vccd1 vccd1 sky130_fd_sc_hd__fill_2
XFILLER_18_124 vssd1 vssd1 vccd1 vccd1 sky130_fd_sc_hd__fill_1
X_337_ net119 _142_ net31 vssd1 vssd1 vccd1 vccd1 _012_ sky130_fd_sc_hd__mux2_1
XFILLER_24_138 vssd1 vssd1 vccd1 vccd1 sky130_fd_sc_hd__fill_2
XTAP_TAPCELL_ROW_25_155 vssd1 vccd1 sky130_fd_sc_hd__tapvpwrvgnd_1
XFILLER_23_193 vssd1 vssd1 vccd1 vccd1 sky130_fd_sc_hd__fill_2
Xteam_01_90 vssd1 vssd1 vccd1 vccd1 gpio_oeb[25] team_01_90/LO sky130_fd_sc_hd__conb_1
XTAP_TAPCELL_ROW_22_147 vssd1 vccd1 sky130_fd_sc_hd__tapvpwrvgnd_1
XFILLER_16_27 vssd1 vssd1 vccd1 vccd1 sky130_fd_sc_hd__fill_1
XFILLER_14_193 vssd1 vssd1 vccd1 vccd1 sky130_fd_sc_hd__fill_1
XTAP_TAPCELL_ROW_7_94 vssd1 vccd1 sky130_fd_sc_hd__tapvpwrvgnd_1
XTAP_TAPCELL_ROW_13_114 vssd1 vccd1 sky130_fd_sc_hd__tapvpwrvgnd_1
XFILLER_8_50 vssd1 vssd1 vccd1 vccd1 sky130_fd_sc_hd__fill_4
XTAP_TAPCELL_ROW_4_84 vssd1 vccd1 sky130_fd_sc_hd__tapvpwrvgnd_1
Xfanout29 TOP.top_rng_inst.ecstate.rollover_flag vssd1 vssd1 vccd1 vccd1 net29 sky130_fd_sc_hd__buf_2
XFILLER_28_80 vssd1 vssd1 vccd1 vccd1 sky130_fd_sc_hd__fill_4
X_370_ net111 _167_ net31 vssd1 vssd1 vccd1 vccd1 _020_ sky130_fd_sc_hd__mux2_1
XFILLER_0_195 vssd1 vssd1 vccd1 vccd1 sky130_fd_sc_hd__fill_1
X_422_ clknet_3_7__leaf_clk _001_ net41 vssd1 vssd1 vccd1 vccd1 TOP.top_rng_inst.display.current_data\[1\]
+ sky130_fd_sc_hd__dfrtp_2
X_284_ net109 net31 net23 vssd1 vssd1 vccd1 vccd1 _004_ sky130_fd_sc_hd__a21oi_1
X_353_ _114_ _144_ _150_ _138_ vssd1 vssd1 vccd1 vccd1 _155_ sky130_fd_sc_hd__o22a_1
XFILLER_27_169 vssd1 vssd1 vccd1 vccd1 sky130_fd_sc_hd__fill_4
XFILLER_19_49 vssd1 vssd1 vccd1 vccd1 sky130_fd_sc_hd__fill_4
X_267_ net30 _082_ _084_ vssd1 vssd1 vccd1 vccd1 _088_ sky130_fd_sc_hd__o21ai_1
X_405_ net28 TOP.top_rng_inst.display.datas\[12\] vssd1 vssd1 vccd1 vccd1 _187_ sky130_fd_sc_hd__and2_1
X_198_ TOP.top_rng_inst.ecstate.count_out\[2\] TOP.top_rng_inst.ecstate.count_out\[3\]
+ TOP.top_rng_inst.ecstate.count_out\[1\] TOP.top_rng_inst.ecstate.count_out\[0\]
+ vssd1 vssd1 vccd1 vccd1 _046_ sky130_fd_sc_hd__and4_1
X_336_ TOP.top_rng_inst.lut1.internal_state\[7\] _141_ vssd1 vssd1 vccd1 vccd1 _142_
+ sky130_fd_sc_hd__xnor2_1
XFILLER_24_117 vssd1 vssd1 vccd1 vccd1 sky130_fd_sc_hd__fill_1
XFILLER_21_17 vccd1 vssd1 vccd1 vssd1 sky130_ef_sc_hd__decap_40_12
XFILLER_2_85 vssd1 vssd1 vccd1 vccd1 sky130_fd_sc_hd__fill_2
Xteam_01_80 vssd1 vssd1 vccd1 vccd1 team_01_80/HI gpio_out[33] sky130_fd_sc_hd__conb_1
XFILLER_30_109 vssd1 vssd1 vccd1 vccd1 sky130_fd_sc_hd__fill_8
XTAP_TAPCELL_ROW_25_156 vssd1 vccd1 sky130_fd_sc_hd__tapvpwrvgnd_1
Xteam_01_91 vssd1 vssd1 vccd1 vccd1 gpio_oeb[26] team_01_91/LO sky130_fd_sc_hd__conb_1
XANTENNA_fanout37_A net42 vssd1 vssd1 vccd1 vccd1 sky130_fd_sc_hd__diode_2
XTAP_TAPCELL_ROW_16_123 vssd1 vccd1 sky130_fd_sc_hd__tapvpwrvgnd_1
X_319_ net25 _042_ _102_ vssd1 vssd1 vccd1 vccd1 _127_ sky130_fd_sc_hd__or3b_1
XFILLER_20_197 vssd1 vssd1 vccd1 vccd1 sky130_fd_sc_hd__fill_8
XFILLER_21_7 vssd1 vssd1 vccd1 vccd1 sky130_fd_sc_hd__fill_2
XTAP_TAPCELL_ROW_13_115 vssd1 vccd1 sky130_fd_sc_hd__tapvpwrvgnd_1
XFILLER_11_120 vccd1 vssd1 vccd1 vssd1 sky130_ef_sc_hd__decap_40_12
XANTENNA__331__S net32 vssd1 vssd1 vccd1 vccd1 sky130_fd_sc_hd__diode_2
Xfanout19 _173_ vssd1 vssd1 vccd1 vccd1 net19 sky130_fd_sc_hd__clkbuf_4
XFILLER_0_141 vssd1 vssd1 vccd1 vccd1 sky130_fd_sc_hd__fill_2
XANTENNA__387__A net29 vssd1 vssd1 vccd1 vccd1 sky130_fd_sc_hd__diode_2
X_421_ clknet_3_7__leaf_clk _000_ net41 vssd1 vssd1 vccd1 vccd1 TOP.top_rng_inst.display.current_data\[0\]
+ sky130_fd_sc_hd__dfrtp_4
X_283_ TOP.top_rng_inst.lut1.started net28 vssd1 vssd1 vccd1 vccd1 _097_ sky130_fd_sc_hd__nor2_1
XANTENNA_fanout22_X net22 vssd1 vssd1 vccd1 vccd1 sky130_fd_sc_hd__diode_2
X_352_ net127 _154_ net31 vssd1 vssd1 vccd1 vccd1 _015_ sky130_fd_sc_hd__mux2_1
XFILLER_27_159 vssd1 vssd1 vccd1 vccd1 sky130_fd_sc_hd__fill_8
XANTENNA__390__B1 net19 vssd1 vssd1 vccd1 vccd1 sky130_fd_sc_hd__diode_2
X_266_ net30 _082_ _087_ vssd1 vssd1 vccd1 vccd1 net10 sky130_fd_sc_hd__o21ai_1
XTAP_TAPCELL_ROW_28_165 vssd1 vccd1 sky130_fd_sc_hd__tapvpwrvgnd_1
X_197_ TOP.top_rng_inst.ecstate.count_out\[2\] TOP.top_rng_inst.ecstate.count_out\[1\]
+ TOP.top_rng_inst.ecstate.count_out\[0\] vssd1 vssd1 vccd1 vccd1 _045_ sky130_fd_sc_hd__nand3_1
X_404_ net142 net22 net19 TOP.top_rng_inst.lut1.internal_state\[10\] _186_ vssd1 vssd1
+ vccd1 vccd1 _035_ sky130_fd_sc_hd__a221o_1
X_335_ _139_ _140_ _119_ vssd1 vssd1 vccd1 vccd1 _141_ sky130_fd_sc_hd__a21bo_1
XFILLER_21_29 vssd1 vssd1 vccd1 vccd1 sky130_fd_sc_hd__fill_4
XPHY_EDGE_ROW_10_Right_10 vssd1 vssd1 vccd1 vccd1 sky130_fd_sc_hd__decap_3
Xteam_01_70 vssd1 vssd1 vccd1 vccd1 team_01_70/HI gpio_out[23] sky130_fd_sc_hd__conb_1
Xteam_01_92 vssd1 vssd1 vccd1 vccd1 gpio_oeb[27] team_01_92/LO sky130_fd_sc_hd__conb_1
XTAP_TAPCELL_ROW_25_157 vssd1 vccd1 sky130_fd_sc_hd__tapvpwrvgnd_1
Xteam_01_81 vssd1 vssd1 vccd1 vccd1 gpio_oeb[0] team_01_81/LO sky130_fd_sc_hd__conb_1
XFILLER_11_95 vccd1 vssd1 vccd1 vssd1 sky130_ef_sc_hd__decap_40_12
XPHY_EDGE_ROW_6_Left_38 vssd1 vssd1 vccd1 vccd1 sky130_fd_sc_hd__decap_3
X_249_ TOP.top_rng_inst.display.current_data\[1\] TOP.top_rng_inst.display.current_data\[0\]
+ TOP.top_rng_inst.display.current_data\[2\] vssd1 vssd1 vccd1 vccd1 _076_ sky130_fd_sc_hd__a21o_1
XANTENNA_clkbuf_3_6__f_clk_A clknet_0_clk vssd1 vssd1 vccd1 vccd1 sky130_fd_sc_hd__diode_2
XTAP_TAPCELL_ROW_16_124 vssd1 vccd1 sky130_fd_sc_hd__tapvpwrvgnd_1
X_318_ net13 TOP.top_rng_inst.k1.sync_r3.sync net12 TOP.top_rng_inst.k1.sync_r2.sync
+ net25 net26 vssd1 vssd1 vccd1 vccd1 _126_ sky130_fd_sc_hd__mux4_1
XFILLER_11_132 vccd1 vssd1 vccd1 vssd1 sky130_ef_sc_hd__decap_40_12
XFILLER_7_169 vccd1 vssd1 vccd1 vssd1 sky130_ef_sc_hd__decap_40_12
XFILLER_27_39 vccd1 vssd1 vccd1 vssd1 sky130_ef_sc_hd__decap_40_12
XFILLER_4_139 vssd1 vssd1 vccd1 vccd1 sky130_fd_sc_hd__fill_1
XPHY_EDGE_ROW_9_Left_41 vssd1 vssd1 vccd1 vccd1 sky130_fd_sc_hd__decap_3
Xhold1 TOP.top_rng_inst.k1.sync_r1.n_sr\[1\] vssd1 vssd1 vccd1 vccd1 net100 sky130_fd_sc_hd__dlygate4sd3_1
XPHY_EDGE_ROW_8_Right_8 vssd1 vssd1 vccd1 vccd1 sky130_fd_sc_hd__decap_3
XFILLER_0_197 vssd1 vssd1 vccd1 vccd1 sky130_fd_sc_hd__fill_4
XFILLER_5_75 vssd1 vssd1 vccd1 vccd1 sky130_fd_sc_hd__fill_1
XFILLER_24_29 vssd1 vssd1 vccd1 vccd1 sky130_fd_sc_hd__fill_4
XFILLER_30_83 vssd1 vssd1 vccd1 vccd1 sky130_fd_sc_hd__fill_1
X_420_ clknet_3_3__leaf_clk TOP.top_rng_inst.lut1.ecstate.next_flag net40 vssd1 vssd1
+ vccd1 vccd1 TOP.top_rng_inst.lut1.ecstate.rollover_flag sky130_fd_sc_hd__dfrtp_1
X_282_ net30 _044_ _093_ _096_ vssd1 vssd1 vccd1 vccd1 _003_ sky130_fd_sc_hd__a22o_1
XANTENNA__337__S net31 vssd1 vssd1 vccd1 vccd1 sky130_fd_sc_hd__diode_2
X_351_ TOP.top_rng_inst.lut1.internal_state\[10\] _153_ vssd1 vssd1 vccd1 vccd1 _154_
+ sky130_fd_sc_hd__xnor2_1
XTAP_TAPCELL_ROW_28_166 vssd1 vccd1 sky130_fd_sc_hd__tapvpwrvgnd_1
X_403_ net29 TOP.top_rng_inst.display.datas\[11\] vssd1 vssd1 vccd1 vccd1 _186_ sky130_fd_sc_hd__and2_1
X_334_ _041_ net24 _125_ vssd1 vssd1 vccd1 vccd1 _140_ sky130_fd_sc_hd__or3b_1
XANTENNA__381__B2 net22 vssd1 vssd1 vccd1 vccd1 sky130_fd_sc_hd__diode_2
XANTENNA__381__A1 net29 vssd1 vssd1 vccd1 vccd1 sky130_fd_sc_hd__diode_2
X_265_ net30 _078_ _073_ TOP.top_rng_inst.display.current_data\[2\] vssd1 vssd1 vccd1
+ vccd1 _087_ sky130_fd_sc_hd__a2bb2o_1
X_196_ TOP.top_rng_inst.display.psc.rollover_flag vssd1 vssd1 vccd1 vccd1 _044_ sky130_fd_sc_hd__inv_2
XPHY_EDGE_ROW_22_Left_54 vssd1 vssd1 vccd1 vccd1 sky130_fd_sc_hd__decap_3
XFILLER_2_32 vssd1 vssd1 vccd1 vccd1 sky130_fd_sc_hd__fill_8
Xteam_01_60 vssd1 vssd1 vccd1 vccd1 team_01_60/HI gpio_out[1] sky130_fd_sc_hd__conb_1
Xteam_01_82 vssd1 vssd1 vccd1 vccd1 gpio_oeb[1] team_01_82/LO sky130_fd_sc_hd__conb_1
Xteam_01_71 vssd1 vssd1 vccd1 vccd1 team_01_71/HI gpio_out[24] sky130_fd_sc_hd__conb_1
Xteam_01_93 vssd1 vssd1 vccd1 vccd1 gpio_oeb[28] team_01_93/LO sky130_fd_sc_hd__conb_1
X_248_ TOP.top_rng_inst.display.current_data\[2\] _074_ vssd1 vssd1 vccd1 vccd1 _075_
+ sky130_fd_sc_hd__and2_1
XTAP_TAPCELL_ROW_16_125 vssd1 vccd1 sky130_fd_sc_hd__tapvpwrvgnd_1
XFILLER_11_85 vssd1 vssd1 vccd1 vccd1 sky130_fd_sc_hd__fill_2
X_317_ net13 net12 net26 vssd1 vssd1 vccd1 vccd1 _125_ sky130_fd_sc_hd__mux2_1
XTAP_TAPCELL_ROW_30_172 vssd1 vccd1 sky130_fd_sc_hd__tapvpwrvgnd_1
XFILLER_28_211 vssd1 vssd1 vccd1 vccd1 sky130_fd_sc_hd__fill_1
XANTENNA__345__S net31 vssd1 vssd1 vccd1 vccd1 sky130_fd_sc_hd__diode_2
XFILLER_21_9 vssd1 vssd1 vccd1 vccd1 sky130_fd_sc_hd__fill_1
XFILLER_11_144 vssd1 vssd1 vccd1 vccd1 sky130_fd_sc_hd__fill_4
XFILLER_7_104 vssd1 vssd1 vccd1 vccd1 sky130_fd_sc_hd__fill_8
XFILLER_25_203 vssd1 vssd1 vccd1 vccd1 sky130_fd_sc_hd__fill_4
Xhold2 TOP.top_rng_inst.k1.sync_r2.n_sr\[1\] vssd1 vssd1 vccd1 vccd1 net101 sky130_fd_sc_hd__dlygate4sd3_1
XFILLER_3_151 vssd1 vssd1 vccd1 vccd1 sky130_fd_sc_hd__fill_4
XFILLER_0_165 vssd1 vssd1 vccd1 vccd1 sky130_fd_sc_hd__fill_2
XFILLER_0_143 vssd1 vssd1 vccd1 vccd1 sky130_fd_sc_hd__fill_1
XFILLER_5_54 vssd1 vssd1 vccd1 vccd1 sky130_fd_sc_hd__fill_2
XFILLER_5_65 vssd1 vssd1 vccd1 vccd1 sky130_fd_sc_hd__fill_2
X_281_ TOP.top_rng_inst.display.datas\[3\] TOP.top_rng_inst.display.datas\[7\] TOP.top_rng_inst.display.datas\[11\]
+ TOP.top_rng_inst.display.datas\[15\] net14 net15 vssd1 vssd1 vccd1 vccd1 _096_ sky130_fd_sc_hd__mux4_1
XFILLER_14_85 vccd1 vssd1 vccd1 vssd1 sky130_ef_sc_hd__decap_40_12
X_350_ net24 _109_ _144_ _150_ _134_ vssd1 vssd1 vccd1 vccd1 _153_ sky130_fd_sc_hd__o32a_1
X_479_ clknet_3_0__leaf_clk net4 net33 vssd1 vssd1 vccd1 vccd1 TOP.top_rng_inst.k1.sync_r2.n_sr\[1\]
+ sky130_fd_sc_hd__dfrtp_1
XANTENNA__390__A2 net22 vssd1 vssd1 vccd1 vccd1 sky130_fd_sc_hd__diode_2
X_264_ _077_ _085_ vssd1 vssd1 vccd1 vccd1 net9 sky130_fd_sc_hd__nand2_1
XTAP_TAPCELL_ROW_28_167 vssd1 vccd1 sky130_fd_sc_hd__tapvpwrvgnd_1
XTAP_TAPCELL_ROW_19_134 vssd1 vccd1 sky130_fd_sc_hd__tapvpwrvgnd_1
X_402_ TOP.top_rng_inst.lut1.internal_state\[10\] net22 net19 net132 _185_ vssd1 vssd1
+ vccd1 vccd1 _034_ sky130_fd_sc_hd__a221o_1
X_333_ net24 _113_ vssd1 vssd1 vccd1 vccd1 _139_ sky130_fd_sc_hd__nand2_1
XFILLER_2_77 vssd1 vssd1 vccd1 vccd1 sky130_fd_sc_hd__fill_4
X_195_ net12 vssd1 vssd1 vccd1 vccd1 TOP.top_rng_inst.k1.n_keypad_col\[0\] sky130_fd_sc_hd__inv_2
Xteam_01_61 vssd1 vssd1 vccd1 vccd1 team_01_61/HI gpio_out[2] sky130_fd_sc_hd__conb_1
Xteam_01_94 vssd1 vssd1 vccd1 vccd1 gpio_oeb[29] team_01_94/LO sky130_fd_sc_hd__conb_1
Xteam_01_72 vssd1 vssd1 vccd1 vccd1 team_01_72/HI gpio_out[25] sky130_fd_sc_hd__conb_1
Xteam_01_50 vssd1 vssd1 vccd1 vccd1 team_01_50/HI gpio_oeb[15] sky130_fd_sc_hd__conb_1
Xteam_01_83 vssd1 vssd1 vccd1 vccd1 gpio_oeb[2] team_01_83/LO sky130_fd_sc_hd__conb_1
X_247_ TOP.top_rng_inst.display.current_data\[1\] TOP.top_rng_inst.display.current_data\[0\]
+ vssd1 vssd1 vccd1 vccd1 _074_ sky130_fd_sc_hd__nand2b_1
XTAP_TAPCELL_ROW_16_126 vssd1 vccd1 sky130_fd_sc_hd__tapvpwrvgnd_1
XFILLER_11_20 vssd1 vssd1 vccd1 vccd1 sky130_fd_sc_hd__fill_1
X_316_ net125 _124_ net32 vssd1 vssd1 vccd1 vccd1 _009_ sky130_fd_sc_hd__mux2_1
XTAP_TAPCELL_ROW_30_173 vssd1 vccd1 sky130_fd_sc_hd__tapvpwrvgnd_1
XFILLER_19_201 vssd1 vssd1 vccd1 vccd1 sky130_fd_sc_hd__fill_4
XFILLER_6_182 vccd1 vssd1 vccd1 vssd1 sky130_ef_sc_hd__decap_40_12
XFILLER_8_54 vssd1 vssd1 vccd1 vccd1 sky130_fd_sc_hd__fill_2
XANTENNA__356__S net32 vssd1 vssd1 vccd1 vccd1 sky130_fd_sc_hd__diode_2
Xhold3 TOP.top_rng_inst.k1.sync_r3.n_sr\[1\] vssd1 vssd1 vccd1 vccd1 net102 sky130_fd_sc_hd__dlygate4sd3_1
XFILLER_0_100 vccd1 vssd1 vccd1 vssd1 sky130_ef_sc_hd__decap_40_12
XFILLER_5_99 vccd1 vssd1 vccd1 vssd1 sky130_ef_sc_hd__decap_40_12
X_280_ TOP.top_rng_inst.display.current_data\[2\] _044_ _093_ _095_ vssd1 vssd1 vccd1
+ vccd1 _002_ sky130_fd_sc_hd__a22o_1
XFILLER_14_53 vssd1 vssd1 vccd1 vccd1 sky130_fd_sc_hd__fill_4
XANTENNA__384__B1 net19 vssd1 vssd1 vccd1 vccd1 sky130_fd_sc_hd__diode_2
X_478_ clknet_3_1__leaf_clk net102 net33 vssd1 vssd1 vccd1 vccd1 TOP.top_rng_inst.k1.sync_r3.sync
+ sky130_fd_sc_hd__dfrtp_1
X_263_ _085_ _086_ vssd1 vssd1 vccd1 vccd1 net8 sky130_fd_sc_hd__xnor2_1
XTAP_TAPCELL_ROW_28_168 vssd1 vccd1 sky130_fd_sc_hd__tapvpwrvgnd_1
X_194_ net15 vssd1 vssd1 vccd1 vccd1 _043_ sky130_fd_sc_hd__inv_2
X_401_ net28 TOP.top_rng_inst.display.datas\[10\] vssd1 vssd1 vccd1 vccd1 _185_ sky130_fd_sc_hd__and2_1
X_332_ TOP.top_rng_inst.display.datas\[1\] _125_ vssd1 vssd1 vccd1 vccd1 _138_ sky130_fd_sc_hd__nand2_1
XTAP_TAPCELL_ROW_19_135 vssd1 vccd1 sky130_fd_sc_hd__tapvpwrvgnd_1
Xteam_01_51 vssd1 vssd1 vccd1 vccd1 team_01_51/HI gpio_oeb[16] sky130_fd_sc_hd__conb_1
Xteam_01_62 vssd1 vssd1 vccd1 vccd1 team_01_62/HI gpio_out[3] sky130_fd_sc_hd__conb_1
XFILLER_23_165 vssd1 vssd1 vccd1 vccd1 sky130_fd_sc_hd__fill_2
Xteam_01_95 vssd1 vssd1 vccd1 vccd1 gpio_oeb[30] team_01_95/LO sky130_fd_sc_hd__conb_1
XFILLER_11_87 vssd1 vssd1 vccd1 vccd1 sky130_fd_sc_hd__fill_1
XFILLER_11_10 vssd1 vssd1 vccd1 vccd1 sky130_fd_sc_hd__fill_8
Xteam_01_73 vssd1 vssd1 vccd1 vccd1 team_01_73/HI gpio_out[26] sky130_fd_sc_hd__conb_1
Xteam_01_84 vssd1 vssd1 vccd1 vccd1 gpio_oeb[3] team_01_84/LO sky130_fd_sc_hd__conb_1
X_246_ TOP.top_rng_inst.display.current_data\[1\] TOP.top_rng_inst.display.current_data\[0\]
+ vssd1 vssd1 vccd1 vccd1 _073_ sky130_fd_sc_hd__and2b_1
XFILLER_20_135 vssd1 vssd1 vccd1 vccd1 sky130_fd_sc_hd__fill_2
X_315_ TOP.top_rng_inst.lut1.internal_state\[4\] _123_ vssd1 vssd1 vccd1 vccd1 _124_
+ sky130_fd_sc_hd__xnor2_1
XTAP_TAPCELL_ROW_30_174 vssd1 vccd1 sky130_fd_sc_hd__tapvpwrvgnd_1
XANTENNA_fanout28_A net29 vssd1 vssd1 vccd1 vccd1 sky130_fd_sc_hd__diode_2
XTAP_TAPCELL_ROW_21_141 vssd1 vccd1 sky130_fd_sc_hd__tapvpwrvgnd_1
XFILLER_7_117 vccd1 vssd1 vccd1 vssd1 sky130_ef_sc_hd__decap_40_12
X_229_ TOP.top_rng_inst.lut1.ecstate.count_out\[3\] _061_ vssd1 vssd1 vccd1 vccd1
+ _066_ sky130_fd_sc_hd__or2_1
Xclkbuf_3_4__f_clk clknet_0_clk vssd1 vssd1 vccd1 vccd1 clknet_3_4__leaf_clk sky130_fd_sc_hd__clkbuf_16
XFILLER_6_194 vssd1 vssd1 vccd1 vccd1 sky130_fd_sc_hd__fill_2
XFILLER_8_77 vssd1 vssd1 vccd1 vccd1 sky130_fd_sc_hd__fill_2
XFILLER_16_205 vssd1 vssd1 vccd1 vccd1 sky130_fd_sc_hd__fill_1
XFILLER_3_164 vssd1 vssd1 vccd1 vccd1 sky130_fd_sc_hd__fill_4
Xhold4 TOP.top_rng_inst.k1.sync_r0.n_sr\[1\] vssd1 vssd1 vccd1 vccd1 net103 sky130_fd_sc_hd__dlygate4sd3_1
XFILLER_28_96 vssd1 vssd1 vccd1 vccd1 sky130_fd_sc_hd__fill_2
XFILLER_28_85 vssd1 vssd1 vccd1 vccd1 sky130_fd_sc_hd__fill_4
XPHY_EDGE_ROW_26_Right_26 vssd1 vssd1 vccd1 vccd1 sky130_fd_sc_hd__decap_3
XPHY_EDGE_ROW_17_Right_17 vssd1 vssd1 vccd1 vccd1 sky130_fd_sc_hd__decap_3
XANTENNA__367__S net32 vssd1 vssd1 vccd1 vccd1 sky130_fd_sc_hd__diode_2
XFILLER_0_189 vssd1 vssd1 vccd1 vccd1 sky130_fd_sc_hd__fill_2
XFILLER_0_167 vssd1 vssd1 vccd1 vccd1 sky130_fd_sc_hd__fill_1
XFILLER_14_76 vssd1 vssd1 vccd1 vccd1 sky130_fd_sc_hd__fill_8
XFILLER_30_75 vssd1 vssd1 vccd1 vccd1 sky130_fd_sc_hd__fill_8
X_477_ clknet_3_1__leaf_clk net5 net34 vssd1 vssd1 vccd1 vccd1 TOP.top_rng_inst.k1.sync_r3.n_sr\[1\]
+ sky130_fd_sc_hd__dfrtp_1
X_262_ TOP.top_rng_inst.display.current_data\[0\] net30 _079_ _083_ vssd1 vssd1 vccd1
+ vccd1 _086_ sky130_fd_sc_hd__o22a_1
XFILLER_26_141 vssd1 vssd1 vccd1 vccd1 sky130_fd_sc_hd__fill_2
XFILLER_25_97 vccd1 vssd1 vccd1 vssd1 sky130_ef_sc_hd__decap_40_12
X_400_ net132 net23 net20 net137 _184_ vssd1 vssd1 vccd1 vccd1 _033_ sky130_fd_sc_hd__a221o_1
XFILLER_4_9 vssd1 vssd1 vccd1 vccd1 sky130_fd_sc_hd__fill_8
X_193_ net24 vssd1 vssd1 vccd1 vccd1 _042_ sky130_fd_sc_hd__inv_2
X_331_ net115 _137_ net32 vssd1 vssd1 vccd1 vccd1 _011_ sky130_fd_sc_hd__mux2_1
XTAP_TAPCELL_ROW_19_136 vssd1 vccd1 sky130_fd_sc_hd__tapvpwrvgnd_1
XFILLER_2_68 vssd1 vssd1 vccd1 vccd1 sky130_fd_sc_hd__fill_2
Xteam_01_74 vssd1 vssd1 vccd1 vccd1 team_01_74/HI gpio_out[27] sky130_fd_sc_hd__conb_1
Xteam_01_52 vssd1 vssd1 vccd1 vccd1 team_01_52/HI gpio_oeb[17] sky130_fd_sc_hd__conb_1
Xteam_01_85 vssd1 vssd1 vccd1 vccd1 gpio_oeb[4] team_01_85/LO sky130_fd_sc_hd__conb_1
XFILLER_2_6 vccd1 vssd1 vccd1 vssd1 sky130_ef_sc_hd__decap_40_12
Xteam_01_63 vssd1 vssd1 vccd1 vccd1 team_01_63/HI gpio_out[4] sky130_fd_sc_hd__conb_1
Xteam_01_96 vssd1 vssd1 vccd1 vccd1 gpio_oeb[31] team_01_96/LO sky130_fd_sc_hd__conb_1
XPHY_EDGE_ROW_26_Left_58 vssd1 vssd1 vccd1 vccd1 sky130_fd_sc_hd__decap_3
X_245_ TOP.top_rng_inst.ecstate.count_out\[8\] _046_ _051_ TOP.top_rng_inst.ecstate.next_count\[2\]
+ vssd1 vssd1 vccd1 vccd1 TOP.top_rng_inst.ecstate.next_flag sky130_fd_sc_hd__o211a_1
XFILLER_14_177 vccd1 vssd1 vccd1 vssd1 sky130_ef_sc_hd__decap_40_12
X_314_ _119_ _122_ vssd1 vssd1 vccd1 vccd1 _123_ sky130_fd_sc_hd__nand2_1
XTAP_TAPCELL_ROW_30_175 vssd1 vccd1 sky130_fd_sc_hd__tapvpwrvgnd_1
XFILLER_20_114 vssd1 vssd1 vccd1 vccd1 sky130_fd_sc_hd__fill_2
XTAP_TAPCELL_ROW_21_142 vssd1 vccd1 sky130_fd_sc_hd__tapvpwrvgnd_1
XFILLER_11_169 vssd1 vssd1 vccd1 vccd1 sky130_fd_sc_hd__fill_1
XFILLER_7_129 vssd1 vssd1 vccd1 vccd1 sky130_fd_sc_hd__fill_4
XFILLER_8_23 vssd1 vssd1 vccd1 vccd1 sky130_fd_sc_hd__fill_4
X_228_ net122 TOP.top_rng_inst.lut1.ecstate.count_out\[0\] _065_ vssd1 vssd1 vccd1
+ vccd1 TOP.top_rng_inst.lut1.ecstate.next_count\[1\] sky130_fd_sc_hd__a21oi_1
XANTENNA__402__B1 net19 vssd1 vssd1 vccd1 vccd1 sky130_fd_sc_hd__diode_2
XANTENNA_fanout40_A net42 vssd1 vssd1 vccd1 vccd1 sky130_fd_sc_hd__diode_2
Xhold5 net16 vssd1 vssd1 vccd1 vccd1 net104 sky130_fd_sc_hd__dlygate4sd3_1
XPHY_EDGE_ROW_29_Left_61 vssd1 vssd1 vccd1 vccd1 sky130_fd_sc_hd__decap_3
XPHY_EDGE_ROW_13_Left_45 vssd1 vssd1 vccd1 vccd1 sky130_fd_sc_hd__decap_3
XFILLER_13_209 vssd1 vssd1 vccd1 vccd1 sky130_fd_sc_hd__fill_2
XFILLER_0_113 vccd1 vssd1 vccd1 vssd1 sky130_ef_sc_hd__decap_40_12
XFILLER_5_57 vssd1 vssd1 vccd1 vccd1 sky130_fd_sc_hd__fill_8
XANTENNA__306__B net32 vssd1 vssd1 vccd1 vccd1 sky130_fd_sc_hd__diode_2
XFILLER_30_21 vssd1 vssd1 vccd1 vccd1 sky130_fd_sc_hd__fill_4
XFILLER_29_183 vccd1 vssd1 vccd1 vssd1 sky130_ef_sc_hd__decap_40_12
X_476_ clknet_3_1__leaf_clk TOP.top_rng_inst.k1.psc.next_flag net33 vssd1 vssd1 vccd1
+ vccd1 TOP.top_rng_inst.k1.clk_psc sky130_fd_sc_hd__dfrtp_1
XANTENNA__384__A2 net22 vssd1 vssd1 vccd1 vccd1 sky130_fd_sc_hd__diode_2
X_261_ TOP.top_rng_inst.display.current_data\[0\] _079_ vssd1 vssd1 vccd1 vccd1 _085_
+ sky130_fd_sc_hd__or2_1
XFILLER_26_153 vccd1 vssd1 vccd1 vssd1 sky130_ef_sc_hd__decap_40_12
X_330_ TOP.top_rng_inst.lut1.internal_state\[6\] _136_ vssd1 vssd1 vccd1 vccd1 _137_
+ sky130_fd_sc_hd__xnor2_1
X_192_ net25 vssd1 vssd1 vccd1 vccd1 _041_ sky130_fd_sc_hd__inv_2
X_459_ clknet_3_5__leaf_clk _027_ net39 vssd1 vssd1 vccd1 vccd1 TOP.top_rng_inst.lut1.internal_state\[3\]
+ sky130_fd_sc_hd__dfrtp_1
Xteam_01_64 vssd1 vssd1 vccd1 vccd1 team_01_64/HI gpio_out[5] sky130_fd_sc_hd__conb_1
XFILLER_23_167 vssd1 vssd1 vccd1 vccd1 sky130_fd_sc_hd__fill_1
Xteam_01_53 vssd1 vssd1 vccd1 vccd1 team_01_53/HI gpio_oeb[18] sky130_fd_sc_hd__conb_1
Xteam_01_86 vssd1 vssd1 vccd1 vccd1 gpio_oeb[5] team_01_86/LO sky130_fd_sc_hd__conb_1
Xteam_01_97 vssd1 vssd1 vccd1 vccd1 gpio_oeb[32] team_01_97/LO sky130_fd_sc_hd__conb_1
Xteam_01_75 vssd1 vssd1 vccd1 vccd1 team_01_75/HI gpio_out[28] sky130_fd_sc_hd__conb_1
XFILLER_28_6 vccd1 vssd1 vccd1 vssd1 sky130_ef_sc_hd__decap_40_12
X_244_ TOP.top_rng_inst.lut1.ecstate.count_out\[1\] net116 TOP.top_rng_inst.lut1.ecstate.next_count\[2\]
+ vssd1 vssd1 vccd1 vccd1 TOP.top_rng_inst.lut1.ecstate.next_flag sky130_fd_sc_hd__and3b_1
XTAP_TAPCELL_ROW_24_151 vssd1 vccd1 sky130_fd_sc_hd__tapvpwrvgnd_1
XFILLER_14_189 vssd1 vssd1 vccd1 vccd1 sky130_fd_sc_hd__fill_4
X_313_ _099_ _121_ _042_ vssd1 vssd1 vccd1 vccd1 _122_ sky130_fd_sc_hd__mux2_1
XPHY_EDGE_ROW_1_Left_33 vssd1 vssd1 vccd1 vccd1 sky130_fd_sc_hd__decap_3
XFILLER_20_137 vssd1 vssd1 vccd1 vccd1 sky130_fd_sc_hd__fill_1
XFILLER_22_44 vssd1 vssd1 vccd1 vccd1 sky130_fd_sc_hd__fill_4
XFILLER_22_11 vssd1 vssd1 vccd1 vccd1 sky130_fd_sc_hd__fill_2
XTAP_TAPCELL_ROW_21_143 vssd1 vccd1 sky130_fd_sc_hd__tapvpwrvgnd_1
XFILLER_11_148 vssd1 vssd1 vccd1 vccd1 sky130_fd_sc_hd__fill_2
X_227_ TOP.top_rng_inst.lut1.ecstate.count_out\[1\] TOP.top_rng_inst.lut1.ecstate.count_out\[0\]
+ _060_ vssd1 vssd1 vccd1 vccd1 _065_ sky130_fd_sc_hd__o21ai_1
XFILLER_25_207 vssd1 vssd1 vccd1 vccd1 sky130_fd_sc_hd__fill_1
XTAP_TAPCELL_ROW_12_110 vssd1 vccd1 sky130_fd_sc_hd__tapvpwrvgnd_1
XFILLER_6_141 vssd1 vssd1 vccd1 vccd1 sky130_fd_sc_hd__fill_8
XFILLER_6_163 vssd1 vssd1 vccd1 vccd1 sky130_fd_sc_hd__fill_2
XFILLER_8_79 vssd1 vssd1 vccd1 vccd1 sky130_fd_sc_hd__fill_1
XFILLER_17_55 vssd1 vssd1 vccd1 vccd1 sky130_fd_sc_hd__fill_1
Xhold6 TOP.top_rng_inst.display.datas\[13\] vssd1 vssd1 vccd1 vccd1 net105 sky130_fd_sc_hd__dlygate4sd3_1
XFILLER_3_155 vssd1 vssd1 vccd1 vccd1 sky130_fd_sc_hd__fill_1
XPHY_EDGE_ROW_3_Right_3 vssd1 vssd1 vccd1 vccd1 sky130_fd_sc_hd__decap_3
XPHY_EDGE_ROW_30_Left_62 vssd1 vssd1 vccd1 vccd1 sky130_fd_sc_hd__decap_3
XFILLER_0_169 vccd1 vssd1 vccd1 vssd1 sky130_ef_sc_hd__decap_40_12
XFILLER_0_125 vccd1 vssd1 vccd1 vssd1 sky130_ef_sc_hd__decap_40_12
XFILLER_29_173 vssd1 vssd1 vccd1 vccd1 sky130_fd_sc_hd__fill_2
XFILLER_5_206 vssd1 vssd1 vccd1 vccd1 sky130_fd_sc_hd__fill_2
X_475_ clknet_3_1__leaf_clk TOP.top_rng_inst.k1.psc.next_count\[3\] net33 vssd1 vssd1
+ vccd1 vccd1 TOP.top_rng_inst.k1.psc.count_out\[3\] sky130_fd_sc_hd__dfrtp_1
XFILLER_26_165 vccd1 vssd1 vccd1 vssd1 sky130_ef_sc_hd__decap_40_12
XFILLER_26_132 vssd1 vssd1 vccd1 vccd1 sky130_fd_sc_hd__fill_8
X_260_ net30 _075_ _084_ TOP.top_rng_inst.display.current_data\[0\] vssd1 vssd1 vccd1
+ vccd1 net7 sky130_fd_sc_hd__o2bb2a_1
XFILLER_6_90 vccd1 vssd1 vccd1 vssd1 sky130_ef_sc_hd__decap_40_12
XANTENNA_input5_A gpio_in[3] vssd1 vssd1 vccd1 vccd1 sky130_fd_sc_hd__diode_2
X_191_ TOP.top_rng_inst.ecstate.count_out\[8\] vssd1 vssd1 vccd1 vccd1 _040_ sky130_fd_sc_hd__inv_2
XFILLER_17_165 vssd1 vssd1 vccd1 vccd1 sky130_fd_sc_hd__fill_2
XFILLER_17_121 vccd1 vssd1 vccd1 vssd1 sky130_ef_sc_hd__decap_40_12
X_458_ clknet_3_1__leaf_clk _026_ net38 vssd1 vssd1 vccd1 vccd1 TOP.top_rng_inst.lut1.internal_state\[2\]
+ sky130_fd_sc_hd__dfrtp_2
X_389_ net29 TOP.top_rng_inst.display.datas\[4\] vssd1 vssd1 vccd1 vccd1 _179_ sky130_fd_sc_hd__and2_1
Xteam_01_98 vssd1 vssd1 vccd1 vccd1 gpio_oeb[33] team_01_98/LO sky130_fd_sc_hd__conb_1
XANTENNA__284__A2 net31 vssd1 vssd1 vccd1 vccd1 sky130_fd_sc_hd__diode_2
XFILLER_23_102 vssd1 vssd1 vccd1 vccd1 sky130_fd_sc_hd__fill_1
Xteam_01_87 vssd1 vssd1 vccd1 vccd1 gpio_oeb[6] team_01_87/LO sky130_fd_sc_hd__conb_1
Xteam_01_65 vssd1 vssd1 vccd1 vccd1 team_01_65/HI gpio_out[6] sky130_fd_sc_hd__conb_1
Xteam_01_43 vssd1 vssd1 vccd1 vccd1 team_01_43/HI gpio_oeb[8] sky130_fd_sc_hd__conb_1
Xteam_01_76 vssd1 vssd1 vccd1 vccd1 team_01_76/HI gpio_out[29] sky130_fd_sc_hd__conb_1
Xteam_01_54 vssd1 vssd1 vccd1 vccd1 team_01_54/HI gpio_oeb[19] sky130_fd_sc_hd__conb_1
XTAP_TAPCELL_ROW_24_152 vssd1 vccd1 sky130_fd_sc_hd__tapvpwrvgnd_1
X_243_ _071_ _072_ vssd1 vssd1 vccd1 vccd1 TOP.top_rng_inst.k1.psc.next_count\[2\]
+ sky130_fd_sc_hd__nor2_1
X_312_ net12 TOP.top_rng_inst.k1.sync_r3.sync TOP.top_rng_inst.k1.sync_r2.sync TOP.top_rng_inst.k1.sync_r1.sync
+ net26 net25 vssd1 vssd1 vccd1 vccd1 _121_ sky130_fd_sc_hd__mux4_1
XFILLER_19_205 vssd1 vssd1 vccd1 vccd1 sky130_fd_sc_hd__fill_2
XFILLER_19_3 vssd1 vssd1 vccd1 vccd1 sky130_fd_sc_hd__fill_8
XTAP_TAPCELL_ROW_12_111 vssd1 vccd1 sky130_fd_sc_hd__tapvpwrvgnd_1
X_226_ TOP.top_rng_inst.k1.psc.count_out\[3\] TOP.top_rng_inst.k1.psc.count_out\[1\]
+ TOP.top_rng_inst.k1.psc.count_out\[0\] TOP.top_rng_inst.k1.psc.count_out\[2\] vssd1
+ vssd1 vccd1 vccd1 TOP.top_rng_inst.k1.psc.next_count\[3\] sky130_fd_sc_hd__and4b_1
XFILLER_6_197 vccd1 vssd1 vccd1 vssd1 sky130_ef_sc_hd__decap_40_12
XFILLER_17_89 vccd1 vssd1 vccd1 vssd1 sky130_ef_sc_hd__decap_40_12
XANTENNA__402__A2 net22 vssd1 vssd1 vccd1 vccd1 sky130_fd_sc_hd__diode_2
Xhold7 TOP.top_rng_inst.ecstate.count_out\[0\] vssd1 vssd1 vccd1 vccd1 net106 sky130_fd_sc_hd__dlygate4sd3_1
X_209_ net126 _047_ _052_ vssd1 vssd1 vccd1 vccd1 _055_ sky130_fd_sc_hd__o21ai_1
XFILLER_21_211 vssd1 vssd1 vccd1 vccd1 sky130_fd_sc_hd__fill_1
XANTENNA_fanout29_X net29 vssd1 vssd1 vccd1 vccd1 sky130_fd_sc_hd__diode_2
XFILLER_0_137 vssd1 vssd1 vccd1 vccd1 sky130_fd_sc_hd__fill_2
XPHY_EDGE_ROW_22_Right_22 vssd1 vssd1 vccd1 vccd1 sky130_fd_sc_hd__decap_3
XPHY_EDGE_ROW_13_Right_13 vssd1 vssd1 vccd1 vccd1 sky130_fd_sc_hd__decap_3
XPHY_EDGE_ROW_31_Right_31 vssd1 vssd1 vccd1 vccd1 sky130_fd_sc_hd__decap_3
XFILLER_14_57 vssd1 vssd1 vccd1 vccd1 sky130_fd_sc_hd__fill_2
X_474_ clknet_3_1__leaf_clk net135 net33 vssd1 vssd1 vccd1 vccd1 TOP.top_rng_inst.k1.psc.count_out\[2\]
+ sky130_fd_sc_hd__dfrtp_1
XANTENNA_clkbuf_0_clk_X clknet_0_clk vssd1 vssd1 vccd1 vccd1 sky130_fd_sc_hd__diode_2
XFILLER_26_177 vccd1 vssd1 vccd1 vssd1 sky130_ef_sc_hd__decap_40_12
XFILLER_25_34 vssd1 vssd1 vccd1 vccd1 sky130_fd_sc_hd__fill_2
XFILLER_17_177 vssd1 vssd1 vccd1 vccd1 sky130_fd_sc_hd__fill_2
XFILLER_17_133 vccd1 vssd1 vccd1 vssd1 sky130_ef_sc_hd__decap_40_12
XFILLER_17_111 vssd1 vssd1 vccd1 vccd1 sky130_fd_sc_hd__fill_1
Xteam_01_77 vssd1 vssd1 vccd1 vccd1 team_01_77/HI gpio_out[30] sky130_fd_sc_hd__conb_1
Xteam_01_55 vssd1 vssd1 vccd1 vccd1 team_01_55/HI gpio_oeb[20] sky130_fd_sc_hd__conb_1
Xteam_01_66 vssd1 vssd1 vccd1 vccd1 team_01_66/HI gpio_out[7] sky130_fd_sc_hd__conb_1
Xteam_01_44 vssd1 vssd1 vccd1 vccd1 team_01_44/HI gpio_oeb[9] sky130_fd_sc_hd__conb_1
Xteam_01_88 vssd1 vssd1 vccd1 vccd1 gpio_oeb[7] team_01_88/LO sky130_fd_sc_hd__conb_1
XFILLER_23_169 vccd1 vssd1 vccd1 vssd1 sky130_ef_sc_hd__decap_40_12
X_457_ clknet_3_4__leaf_clk _025_ net39 vssd1 vssd1 vccd1 vccd1 TOP.top_rng_inst.lut1.internal_state\[1\]
+ sky130_fd_sc_hd__dfrtp_2
X_388_ net124 net22 net19 TOP.top_rng_inst.lut1.internal_state\[2\] _178_ vssd1 vssd1
+ vccd1 vccd1 _027_ sky130_fd_sc_hd__a221o_1
XTAP_TAPCELL_ROW_24_153 vssd1 vccd1 sky130_fd_sc_hd__tapvpwrvgnd_1
XFILLER_14_158 vccd1 vssd1 vccd1 vssd1 sky130_ef_sc_hd__decap_40_12
XFILLER_14_136 vssd1 vssd1 vccd1 vccd1 sky130_fd_sc_hd__fill_2
X_242_ TOP.top_rng_inst.k1.psc.count_out\[1\] TOP.top_rng_inst.k1.psc.count_out\[0\]
+ TOP.top_rng_inst.k1.psc.count_out\[2\] TOP.top_rng_inst.k1.psc.count_out\[3\] vssd1
+ vssd1 vccd1 vccd1 _072_ sky130_fd_sc_hd__a31o_1
X_311_ net12 TOP.top_rng_inst.k1.sync_r3.sync net26 vssd1 vssd1 vccd1 vccd1 _120_
+ sky130_fd_sc_hd__mux2_1
XTAP_TAPCELL_ROW_15_120 vssd1 vccd1 sky130_fd_sc_hd__tapvpwrvgnd_1
XANTENNA_clkbuf_3_2__f_clk_A clknet_0_clk vssd1 vssd1 vccd1 vccd1 sky130_fd_sc_hd__diode_2
XFILLER_22_35 vssd1 vssd1 vccd1 vccd1 sky130_fd_sc_hd__fill_4
X_225_ net116 _064_ _060_ vssd1 vssd1 vccd1 vccd1 TOP.top_rng_inst.lut1.ecstate.next_count\[5\]
+ sky130_fd_sc_hd__o21a_1
XTAP_TAPCELL_ROW_12_112 vssd1 vccd1 sky130_fd_sc_hd__tapvpwrvgnd_1
XFILLER_3_179 vccd1 vssd1 vccd1 vssd1 sky130_ef_sc_hd__decap_40_12
Xhold8 TOP.top_rng_inst.k1.psc.count_out\[0\] vssd1 vssd1 vccd1 vccd1 net107 sky130_fd_sc_hd__dlygate4sd3_1
X_208_ _049_ _054_ vssd1 vssd1 vccd1 vccd1 TOP.top_rng_inst.ecstate.next_count\[6\]
+ sky130_fd_sc_hd__nor2_1
XPHY_EDGE_ROW_17_Left_49 vssd1 vssd1 vccd1 vccd1 sky130_fd_sc_hd__decap_3
XFILLER_5_208 vssd1 vssd1 vccd1 vccd1 sky130_fd_sc_hd__fill_1
X_473_ clknet_3_1__leaf_clk TOP.top_rng_inst.k1.psc.next_count\[1\] net33 vssd1 vssd1
+ vccd1 vccd1 TOP.top_rng_inst.k1.psc.count_out\[1\] sky130_fd_sc_hd__dfrtp_1
XFILLER_26_189 vssd1 vssd1 vccd1 vccd1 sky130_fd_sc_hd__fill_4
XFILLER_25_57 vccd1 vssd1 vccd1 vssd1 sky130_ef_sc_hd__decap_40_12
XFILLER_17_101 vssd1 vssd1 vccd1 vccd1 sky130_fd_sc_hd__fill_8
XTAP_TAPCELL_ROW_27_162 vssd1 vccd1 sky130_fd_sc_hd__tapvpwrvgnd_1
XFILLER_17_167 vssd1 vssd1 vccd1 vccd1 sky130_fd_sc_hd__fill_1
XFILLER_17_145 vccd1 vssd1 vccd1 vssd1 sky130_ef_sc_hd__decap_40_12
X_456_ clknet_3_5__leaf_clk _024_ net39 vssd1 vssd1 vccd1 vccd1 TOP.top_rng_inst.lut1.internal_state\[0\]
+ sky130_fd_sc_hd__dfrtp_1
X_387_ net29 TOP.top_rng_inst.display.datas\[3\] vssd1 vssd1 vccd1 vccd1 _178_ sky130_fd_sc_hd__and2_1
Xteam_01_56 vssd1 vssd1 vccd1 vccd1 team_01_56/HI gpio_oeb[21] sky130_fd_sc_hd__conb_1
Xteam_01_89 vssd1 vssd1 vccd1 vccd1 gpio_oeb[24] team_01_89/LO sky130_fd_sc_hd__conb_1
Xteam_01_45 vssd1 vssd1 vccd1 vccd1 team_01_45/HI gpio_oeb[10] sky130_fd_sc_hd__conb_1
X_310_ TOP.top_rng_inst.display.datas\[3\] net21 vssd1 vssd1 vccd1 vccd1 _119_ sky130_fd_sc_hd__nor2_2
Xteam_01_67 vssd1 vssd1 vccd1 vccd1 team_01_67/HI gpio_out[15] sky130_fd_sc_hd__conb_1
Xteam_01_78 vssd1 vssd1 vccd1 vccd1 team_01_78/HI gpio_out[31] sky130_fd_sc_hd__conb_1
XTAP_TAPCELL_ROW_24_154 vssd1 vccd1 sky130_fd_sc_hd__tapvpwrvgnd_1
XTAP_TAPCELL_ROW_15_121 vssd1 vccd1 sky130_fd_sc_hd__tapvpwrvgnd_1
X_439_ clknet_3_4__leaf_clk _007_ net38 vssd1 vssd1 vccd1 vccd1 TOP.top_rng_inst.display.datas\[2\]
+ sky130_fd_sc_hd__dfstp_1
X_241_ TOP.top_rng_inst.k1.psc.count_out\[1\] TOP.top_rng_inst.k1.psc.count_out\[0\]
+ net134 vssd1 vssd1 vccd1 vccd1 _071_ sky130_fd_sc_hd__a21oi_1
XFILLER_22_25 vssd1 vssd1 vccd1 vccd1 sky130_fd_sc_hd__fill_2
XFILLER_11_107 vssd1 vssd1 vccd1 vccd1 sky130_fd_sc_hd__fill_2
X_224_ TOP.top_rng_inst.lut1.ecstate.count_out\[4\] TOP.top_rng_inst.lut1.ecstate.count_out\[3\]
+ _061_ vssd1 vssd1 vccd1 vccd1 _064_ sky130_fd_sc_hd__and3_1
XFILLER_19_207 vssd1 vssd1 vccd1 vccd1 sky130_fd_sc_hd__fill_1
XFILLER_10_195 vssd1 vssd1 vccd1 vccd1 sky130_fd_sc_hd__fill_1
XPHY_EDGE_ROW_5_Left_37 vssd1 vssd1 vccd1 vccd1 sky130_fd_sc_hd__decap_3
XFILLER_8_27 vssd1 vssd1 vccd1 vccd1 sky130_fd_sc_hd__fill_1
XFILLER_26_6 vssd1 vssd1 vccd1 vccd1 sky130_fd_sc_hd__fill_8
XFILLER_24_210 vssd1 vssd1 vccd1 vccd1 sky130_fd_sc_hd__fill_2
XFILLER_17_47 vssd1 vssd1 vccd1 vccd1 sky130_fd_sc_hd__fill_8
XFILLER_3_169 vssd1 vssd1 vccd1 vccd1 sky130_fd_sc_hd__fill_8
Xhold9 TOP.top_rng_inst.k1.psc.next_count\[0\] vssd1 vssd1 vccd1 vccd1 net108 sky130_fd_sc_hd__dlygate4sd3_1
X_207_ net129 _048_ _052_ vssd1 vssd1 vccd1 vccd1 _054_ sky130_fd_sc_hd__o21ai_1
XFILLER_28_57 vssd1 vssd1 vccd1 vccd1 sky130_fd_sc_hd__fill_2
XFILLER_0_139 vssd1 vssd1 vccd1 vccd1 sky130_fd_sc_hd__fill_1
XFILLER_9_70 vssd1 vssd1 vccd1 vccd1 sky130_fd_sc_hd__fill_4
XPHY_EDGE_ROW_8_Left_40 vssd1 vssd1 vccd1 vccd1 sky130_fd_sc_hd__decap_3
XFILLER_8_206 vssd1 vssd1 vccd1 vccd1 sky130_fd_sc_hd__fill_2
XPHY_EDGE_ROW_7_Right_7 vssd1 vssd1 vccd1 vccd1 sky130_fd_sc_hd__decap_3
XFILLER_30_25 vssd1 vssd1 vccd1 vccd1 sky130_fd_sc_hd__fill_2
XFILLER_29_110 vssd1 vssd1 vccd1 vccd1 sky130_fd_sc_hd__fill_2
XANTENNA__302__S net31 vssd1 vssd1 vccd1 vccd1 sky130_fd_sc_hd__diode_2
X_472_ clknet_3_1__leaf_clk net108 net33 vssd1 vssd1 vccd1 vccd1 TOP.top_rng_inst.k1.psc.count_out\[0\]
+ sky130_fd_sc_hd__dfrtp_2
XFILLER_6_82 vssd1 vssd1 vccd1 vccd1 sky130_fd_sc_hd__fill_2
XFILLER_25_69 vssd1 vssd1 vccd1 vccd1 sky130_fd_sc_hd__fill_2
XFILLER_25_14 vssd1 vssd1 vccd1 vccd1 sky130_fd_sc_hd__fill_1
X_455_ clknet_3_7__leaf_clk _023_ net41 vssd1 vssd1 vccd1 vccd1 net16 sky130_fd_sc_hd__dfrtp_1
XTAP_TAPCELL_ROW_27_163 vssd1 vccd1 sky130_fd_sc_hd__tapvpwrvgnd_1
XFILLER_25_190 vssd1 vssd1 vccd1 vccd1 sky130_fd_sc_hd__fill_4
XFILLER_17_157 vssd1 vssd1 vccd1 vccd1 sky130_fd_sc_hd__fill_8
XFILLER_15_91 vssd1 vssd1 vccd1 vccd1 sky130_fd_sc_hd__fill_4
XFILLER_2_18 vssd1 vssd1 vccd1 vccd1 sky130_fd_sc_hd__fill_2
X_386_ TOP.top_rng_inst.lut1.internal_state\[2\] net22 net19 net144 _177_ vssd1 vssd1
+ vccd1 vccd1 _026_ sky130_fd_sc_hd__a221o_1
XFILLER_31_193 vssd1 vssd1 vccd1 vccd1 sky130_fd_sc_hd__fill_2
XFILLER_31_182 vssd1 vssd1 vccd1 vccd1 sky130_fd_sc_hd__fill_2
Xteam_01_46 vssd1 vssd1 vccd1 vccd1 team_01_46/HI gpio_oeb[11] sky130_fd_sc_hd__conb_1
XTAP_TAPCELL_ROW_18_130 vssd1 vccd1 sky130_fd_sc_hd__tapvpwrvgnd_1
Xteam_01_68 vssd1 vssd1 vccd1 vccd1 team_01_68/HI gpio_out[21] sky130_fd_sc_hd__conb_1
XFILLER_11_49 vssd1 vssd1 vccd1 vccd1 sky130_fd_sc_hd__fill_2
XANTENNA_input3_A gpio_in[1] vssd1 vssd1 vccd1 vccd1 sky130_fd_sc_hd__diode_2
Xteam_01_79 vssd1 vssd1 vccd1 vccd1 team_01_79/HI gpio_out[32] sky130_fd_sc_hd__conb_1
Xteam_01_57 vssd1 vssd1 vccd1 vccd1 team_01_57/HI gpio_oeb[22] sky130_fd_sc_hd__conb_1
X_240_ TOP.top_rng_inst.k1.psc.count_out\[1\] net107 _070_ vssd1 vssd1 vccd1 vccd1
+ TOP.top_rng_inst.k1.psc.next_count\[1\] sky130_fd_sc_hd__o21a_1
XPHY_EDGE_ROW_21_Left_53 vssd1 vssd1 vccd1 vccd1 sky130_fd_sc_hd__decap_3
XTAP_TAPCELL_ROW_15_122 vssd1 vccd1 sky130_fd_sc_hd__tapvpwrvgnd_1
X_369_ TOP.top_rng_inst.lut1.internal_state\[15\] _166_ vssd1 vssd1 vccd1 vccd1 _167_
+ sky130_fd_sc_hd__xnor2_1
XFILLER_3_61 vssd1 vssd1 vccd1 vccd1 sky130_fd_sc_hd__fill_1
X_438_ clknet_3_1__leaf_clk _006_ net34 vssd1 vssd1 vccd1 vccd1 TOP.top_rng_inst.display.datas\[1\]
+ sky130_fd_sc_hd__dfstp_1
X_223_ TOP.top_rng_inst.lut1.ecstate.count_out\[3\] _061_ vssd1 vssd1 vccd1 vccd1
+ _063_ sky130_fd_sc_hd__and2_1
XFILLER_22_48 vssd1 vssd1 vccd1 vccd1 sky130_fd_sc_hd__fill_1
XFILLER_10_141 vccd1 vssd1 vccd1 vssd1 sky130_ef_sc_hd__decap_40_12
XFILLER_3_126 vssd1 vssd1 vccd1 vccd1 sky130_fd_sc_hd__fill_4
X_206_ _050_ _052_ _053_ vssd1 vssd1 vccd1 vccd1 TOP.top_rng_inst.ecstate.next_count\[7\]
+ sky130_fd_sc_hd__and3_1
XANTENNA__305__A1 net31 vssd1 vssd1 vccd1 vccd1 sky130_fd_sc_hd__diode_2
Xclkbuf_3_5__f_clk clknet_0_clk vssd1 vssd1 vccd1 vccd1 clknet_3_5__leaf_clk sky130_fd_sc_hd__clkbuf_16
XFILLER_30_59 vssd1 vssd1 vccd1 vccd1 sky130_fd_sc_hd__fill_4
XFILLER_30_37 vssd1 vssd1 vccd1 vccd1 sky130_fd_sc_hd__fill_2
XFILLER_29_166 vssd1 vssd1 vccd1 vccd1 sky130_fd_sc_hd__fill_2
X_471_ clknet_3_5__leaf_clk _039_ net38 vssd1 vssd1 vccd1 vccd1 TOP.top_rng_inst.lut1.internal_state\[15\]
+ sky130_fd_sc_hd__dfrtp_1
XFILLER_26_147 vssd1 vssd1 vccd1 vccd1 sky130_fd_sc_hd__fill_1
XFILLER_25_26 vssd1 vssd1 vccd1 vccd1 sky130_fd_sc_hd__fill_1
XFILLER_6_50 vssd1 vssd1 vccd1 vccd1 sky130_fd_sc_hd__fill_2
XFILLER_31_80 vssd1 vssd1 vccd1 vccd1 sky130_fd_sc_hd__fill_4
XTAP_TAPCELL_ROW_27_164 vssd1 vccd1 sky130_fd_sc_hd__tapvpwrvgnd_1
X_454_ clknet_3_6__leaf_clk _022_ net40 vssd1 vssd1 vccd1 vccd1 net15 sky130_fd_sc_hd__dfrtp_4
XFILLER_17_169 vssd1 vssd1 vccd1 vccd1 sky130_fd_sc_hd__fill_8
XFILLER_1_202 vssd1 vssd1 vccd1 vccd1 sky130_fd_sc_hd__fill_4
X_385_ net29 net24 vssd1 vssd1 vccd1 vccd1 _177_ sky130_fd_sc_hd__and2_1
XFILLER_31_161 vssd1 vssd1 vccd1 vccd1 sky130_fd_sc_hd__fill_4
Xteam_01_58 vssd1 vssd1 vccd1 vccd1 team_01_58/HI gpio_oeb[23] sky130_fd_sc_hd__conb_1
XTAP_TAPCELL_ROW_18_131 vssd1 vccd1 sky130_fd_sc_hd__tapvpwrvgnd_1
Xteam_01_69 vssd1 vssd1 vccd1 vccd1 team_01_69/HI gpio_out[22] sky130_fd_sc_hd__conb_1
Xteam_01_47 vssd1 vssd1 vccd1 vccd1 team_01_47/HI gpio_oeb[12] sky130_fd_sc_hd__conb_1
XFILLER_22_150 vssd1 vssd1 vccd1 vccd1 sky130_fd_sc_hd__fill_8
XFILLER_14_128 vssd1 vssd1 vccd1 vccd1 sky130_fd_sc_hd__fill_8
XFILLER_28_209 vssd1 vssd1 vccd1 vccd1 sky130_fd_sc_hd__fill_2
XFILLER_13_150 vccd1 vssd1 vccd1 vssd1 sky130_ef_sc_hd__decap_40_12
X_368_ _139_ _140_ _144_ vssd1 vssd1 vccd1 vccd1 _166_ sky130_fd_sc_hd__a21o_1
X_437_ clknet_3_4__leaf_clk _005_ net38 vssd1 vssd1 vccd1 vccd1 TOP.top_rng_inst.display.datas\[0\]
+ sky130_fd_sc_hd__dfstp_1
XFILLER_3_73 vccd1 vssd1 vccd1 vssd1 sky130_ef_sc_hd__decap_40_12
XFILLER_3_95 vccd1 vssd1 vccd1 vssd1 sky130_ef_sc_hd__decap_40_12
X_299_ net24 TOP.top_rng_inst.display.datas\[3\] _109_ vssd1 vssd1 vccd1 vccd1 _110_
+ sky130_fd_sc_hd__or3_1
XPHY_EDGE_ROW_29_Right_29 vssd1 vssd1 vccd1 vccd1 sky130_fd_sc_hd__decap_3
XFILLER_22_27 vssd1 vssd1 vccd1 vccd1 sky130_fd_sc_hd__fill_1
X_222_ net130 _059_ net109 vssd1 vssd1 vccd1 vccd1 TOP.top_rng_inst.lut1.ecstate.next_count\[0\]
+ sky130_fd_sc_hd__a21boi_1
XFILLER_12_71 vssd1 vssd1 vccd1 vccd1 sky130_fd_sc_hd__fill_2
XFILLER_6_102 vssd1 vssd1 vccd1 vccd1 sky130_fd_sc_hd__fill_4
XFILLER_6_135 vssd1 vssd1 vccd1 vccd1 sky130_fd_sc_hd__fill_4
X_205_ _046_ _051_ vssd1 vssd1 vccd1 vccd1 _053_ sky130_fd_sc_hd__nand2_1
XFILLER_0_41 vccd1 vssd1 vccd1 vssd1 sky130_ef_sc_hd__decap_40_12
XFILLER_9_83 vssd1 vssd1 vccd1 vccd1 sky130_fd_sc_hd__fill_1
XFILLER_28_59 vssd1 vssd1 vccd1 vccd1 sky130_fd_sc_hd__fill_1
XFILLER_28_26 vssd1 vssd1 vccd1 vccd1 sky130_fd_sc_hd__fill_2
XANTENNA__316__S net32 vssd1 vssd1 vccd1 vccd1 sky130_fd_sc_hd__diode_2
XFILLER_8_208 vssd1 vssd1 vccd1 vccd1 sky130_fd_sc_hd__fill_1
XFILLER_18_81 vssd1 vssd1 vccd1 vccd1 sky130_fd_sc_hd__fill_2
XFILLER_30_27 vssd1 vssd1 vccd1 vccd1 sky130_fd_sc_hd__fill_1
XFILLER_29_145 vssd1 vssd1 vccd1 vccd1 sky130_fd_sc_hd__fill_4
X_470_ clknet_3_7__leaf_clk _038_ net41 vssd1 vssd1 vccd1 vccd1 TOP.top_rng_inst.lut1.internal_state\[14\]
+ sky130_fd_sc_hd__dfrtp_1
XFILLER_6_62 vccd1 vssd1 vccd1 vssd1 sky130_ef_sc_hd__decap_40_12
X_453_ clknet_3_6__leaf_clk _021_ net40 vssd1 vssd1 vccd1 vccd1 net14 sky130_fd_sc_hd__dfrtp_4
XANTENNA_clkbuf_3_5__f_clk_A clknet_0_clk vssd1 vssd1 vccd1 vccd1 sky130_fd_sc_hd__diode_2
X_384_ TOP.top_rng_inst.lut1.internal_state\[1\] net22 net19 net146 _176_ vssd1 vssd1
+ vccd1 vccd1 _025_ sky130_fd_sc_hd__a221o_1
XANTENNA__380__B1 net19 vssd1 vssd1 vccd1 vccd1 sky130_fd_sc_hd__diode_2
XFILLER_31_195 vssd1 vssd1 vccd1 vccd1 sky130_fd_sc_hd__fill_1
XFILLER_31_184 vssd1 vssd1 vccd1 vccd1 sky130_fd_sc_hd__fill_1
Xteam_01_48 vssd1 vssd1 vccd1 vccd1 team_01_48/HI gpio_oeb[13] sky130_fd_sc_hd__conb_1
XTAP_TAPCELL_ROW_18_132 vssd1 vccd1 sky130_fd_sc_hd__tapvpwrvgnd_1
XFILLER_11_18 vssd1 vssd1 vccd1 vccd1 sky130_fd_sc_hd__fill_2
XTAP_TAPCELL_ROW_2_74 vssd1 vccd1 sky130_fd_sc_hd__tapvpwrvgnd_1
Xteam_01_59 vssd1 vssd1 vccd1 vccd1 team_01_59/HI gpio_out[0] sky130_fd_sc_hd__conb_1
XANTENNA__324__S net31 vssd1 vssd1 vccd1 vccd1 sky130_fd_sc_hd__diode_2
XTAP_TAPCELL_ROW_9_100 vssd1 vccd1 sky130_fd_sc_hd__tapvpwrvgnd_1
XANTENNA__385__A net29 vssd1 vssd1 vccd1 vccd1 sky130_fd_sc_hd__diode_2
X_436_ clknet_3_6__leaf_clk net99 net40 vssd1 vssd1 vccd1 vccd1 TOP.top_rng_inst.display.psc.rollover_flag
+ sky130_fd_sc_hd__dfrtp_1
X_367_ net112 _165_ net32 vssd1 vssd1 vccd1 vccd1 _019_ sky130_fd_sc_hd__mux2_1
XFILLER_13_162 vssd1 vssd1 vccd1 vccd1 sky130_fd_sc_hd__fill_4
X_298_ _041_ _107_ _108_ net26 vssd1 vssd1 vccd1 vccd1 _109_ sky130_fd_sc_hd__o2bb2a_1
XFILLER_22_39 vssd1 vssd1 vccd1 vccd1 sky130_fd_sc_hd__fill_2
XFILLER_22_17 vssd1 vssd1 vccd1 vccd1 sky130_fd_sc_hd__fill_8
XFILLER_3_85 vssd1 vssd1 vccd1 vccd1 sky130_fd_sc_hd__fill_2
X_221_ _061_ _062_ _060_ vssd1 vssd1 vccd1 vccd1 TOP.top_rng_inst.lut1.ecstate.next_count\[2\]
+ sky130_fd_sc_hd__and3b_1
XFILLER_10_187 vssd1 vssd1 vccd1 vccd1 sky130_fd_sc_hd__fill_8
XFILLER_10_121 vssd1 vssd1 vccd1 vccd1 sky130_fd_sc_hd__fill_4
XFILLER_6_125 vssd1 vssd1 vccd1 vccd1 sky130_fd_sc_hd__fill_2
X_419_ clknet_3_2__leaf_clk TOP.top_rng_inst.lut1.ecstate.next_count\[5\] net37 vssd1
+ vssd1 vccd1 vccd1 TOP.top_rng_inst.lut1.ecstate.count_out\[5\] sky130_fd_sc_hd__dfrtp_1
XTAP_TAPCELL_ROW_8_95 vssd1 vccd1 sky130_fd_sc_hd__tapvpwrvgnd_1
XFILLER_30_205 vssd1 vssd1 vccd1 vccd1 sky130_fd_sc_hd__fill_1
X_204_ TOP.top_rng_inst.ecstate.count_out\[2\] TOP.top_rng_inst.ecstate.count_out\[3\]
+ TOP.top_rng_inst.ecstate.count_out\[8\] _051_ vssd1 vssd1 vccd1 vccd1 _052_ sky130_fd_sc_hd__o211ai_4
XFILLER_15_202 vssd1 vssd1 vccd1 vccd1 sky130_fd_sc_hd__fill_2
XFILLER_24_6 vssd1 vssd1 vccd1 vccd1 sky130_fd_sc_hd__fill_8
XFILLER_0_53 vssd1 vssd1 vccd1 vccd1 sky130_fd_sc_hd__fill_2
XFILLER_28_49 vssd1 vssd1 vccd1 vccd1 sky130_fd_sc_hd__fill_8
XANTENNA__393__A net29 vssd1 vssd1 vccd1 vccd1 sky130_fd_sc_hd__diode_2
XTAP_TAPCELL_ROW_5_85 vssd1 vccd1 sky130_fd_sc_hd__tapvpwrvgnd_1
XFILLER_22_3 vssd1 vssd1 vccd1 vccd1 sky130_fd_sc_hd__fill_8
XFILLER_29_113 vccd1 vssd1 vccd1 vssd1 sky130_ef_sc_hd__decap_40_12
XFILLER_26_127 vssd1 vssd1 vccd1 vccd1 sky130_fd_sc_hd__fill_2
XFILLER_6_52 vssd1 vssd1 vccd1 vccd1 sky130_fd_sc_hd__fill_1
XFILLER_6_74 vssd1 vssd1 vccd1 vccd1 sky130_fd_sc_hd__fill_8
XANTENNA_fanout32_X net32 vssd1 vssd1 vccd1 vccd1 sky130_fd_sc_hd__diode_2
XFILLER_25_160 vssd1 vssd1 vccd1 vccd1 sky130_fd_sc_hd__fill_1
X_452_ clknet_3_5__leaf_clk _020_ net38 vssd1 vssd1 vccd1 vccd1 TOP.top_rng_inst.display.datas\[15\]
+ sky130_fd_sc_hd__dfrtp_1
X_383_ net29 net25 vssd1 vssd1 vccd1 vccd1 _176_ sky130_fd_sc_hd__and2_1
XFILLER_31_141 vssd1 vssd1 vccd1 vccd1 sky130_fd_sc_hd__fill_2
XTAP_TAPCELL_ROW_18_133 vssd1 vccd1 sky130_fd_sc_hd__tapvpwrvgnd_1
XTAP_TAPCELL_ROW_2_75 vssd1 vccd1 sky130_fd_sc_hd__tapvpwrvgnd_1
Xteam_01_49 vssd1 vssd1 vccd1 vccd1 team_01_49/HI gpio_oeb[14] sky130_fd_sc_hd__conb_1
X_435_ clknet_3_2__leaf_clk TOP.top_rng_inst.ecstate.next_count\[8\] net35 vssd1 vssd1
+ vccd1 vccd1 TOP.top_rng_inst.ecstate.count_out\[8\] sky130_fd_sc_hd__dfrtp_2
XANTENNA__408__A2 net22 vssd1 vssd1 vccd1 vccd1 sky130_fd_sc_hd__diode_2
X_366_ _163_ _164_ vssd1 vssd1 vccd1 vccd1 _165_ sky130_fd_sc_hd__xnor2_1
XFILLER_13_185 vssd1 vssd1 vccd1 vccd1 sky130_fd_sc_hd__fill_4
XTAP_TAPCELL_ROW_9_101 vssd1 vccd1 sky130_fd_sc_hd__tapvpwrvgnd_1
XFILLER_9_167 vssd1 vssd1 vccd1 vccd1 sky130_fd_sc_hd__fill_1
XFILLER_9_134 vssd1 vssd1 vccd1 vccd1 sky130_fd_sc_hd__fill_1
X_297_ net25 TOP.top_rng_inst.k1.sync_r0.sync vssd1 vssd1 vccd1 vccd1 _108_ sky130_fd_sc_hd__nand2_1
X_220_ TOP.top_rng_inst.lut1.ecstate.count_out\[1\] TOP.top_rng_inst.lut1.ecstate.count_out\[0\]
+ TOP.top_rng_inst.lut1.ecstate.count_out\[2\] vssd1 vssd1 vccd1 vccd1 _062_ sky130_fd_sc_hd__a21o_1
XANTENNA_input1_A en vssd1 vssd1 vccd1 vccd1 sky130_fd_sc_hd__diode_2
XFILLER_12_73 vssd1 vssd1 vccd1 vccd1 sky130_fd_sc_hd__fill_1
XFILLER_6_115 vssd1 vssd1 vccd1 vccd1 sky130_fd_sc_hd__fill_4
XFILLER_6_159 vssd1 vssd1 vccd1 vccd1 sky130_fd_sc_hd__fill_4
X_418_ clknet_3_2__leaf_clk TOP.top_rng_inst.lut1.ecstate.next_count\[4\] net36 vssd1
+ vssd1 vccd1 vccd1 TOP.top_rng_inst.lut1.ecstate.count_out\[4\] sky130_fd_sc_hd__dfrtp_1
XPHY_EDGE_ROW_25_Left_57 vssd1 vssd1 vccd1 vccd1 sky130_fd_sc_hd__decap_3
XFILLER_18_211 vssd1 vssd1 vccd1 vccd1 sky130_fd_sc_hd__fill_1
X_349_ net128 _152_ net31 vssd1 vssd1 vccd1 vccd1 _014_ sky130_fd_sc_hd__mux2_1
XTAP_TAPCELL_ROW_8_96 vssd1 vccd1 sky130_fd_sc_hd__tapvpwrvgnd_1
XFILLER_3_107 vssd1 vssd1 vccd1 vccd1 sky130_fd_sc_hd__fill_2
X_203_ TOP.top_rng_inst.ecstate.count_out\[6\] TOP.top_rng_inst.ecstate.count_out\[5\]
+ TOP.top_rng_inst.ecstate.count_out\[4\] TOP.top_rng_inst.ecstate.count_out\[7\]
+ vssd1 vssd1 vccd1 vccd1 _051_ sky130_fd_sc_hd__and4_1
XFILLER_18_83 vssd1 vssd1 vccd1 vccd1 sky130_fd_sc_hd__fill_1
XTAP_TAPCELL_ROW_5_86 vssd1 vccd1 sky130_fd_sc_hd__tapvpwrvgnd_1
XFILLER_30_29 vssd1 vssd1 vccd1 vccd1 sky130_fd_sc_hd__fill_8
XPHY_EDGE_ROW_28_Left_60 vssd1 vssd1 vccd1 vccd1 sky130_fd_sc_hd__decap_3
XPHY_EDGE_ROW_12_Left_44 vssd1 vssd1 vccd1 vccd1 sky130_fd_sc_hd__decap_3
XFILLER_29_169 vssd1 vssd1 vccd1 vccd1 sky130_fd_sc_hd__fill_4
XFILLER_29_158 vssd1 vssd1 vccd1 vccd1 sky130_fd_sc_hd__fill_8
XFILLER_29_125 vssd1 vssd1 vccd1 vccd1 sky130_fd_sc_hd__fill_4
XFILLER_9_8 vccd1 vssd1 vccd1 vssd1 sky130_ef_sc_hd__decap_40_12
XFILLER_31_61 vssd1 vssd1 vccd1 vccd1 sky130_fd_sc_hd__fill_2
XFILLER_25_194 vssd1 vssd1 vccd1 vccd1 sky130_fd_sc_hd__fill_2
XFILLER_25_150 vssd1 vssd1 vccd1 vccd1 sky130_fd_sc_hd__fill_8
X_451_ clknet_3_7__leaf_clk _019_ net41 vssd1 vssd1 vccd1 vccd1 TOP.top_rng_inst.display.datas\[14\]
+ sky130_fd_sc_hd__dfrtp_1
XFILLER_15_95 vssd1 vssd1 vccd1 vccd1 sky130_fd_sc_hd__fill_2
XTAP_TAPCELL_ROW_2_76 vssd1 vccd1 sky130_fd_sc_hd__tapvpwrvgnd_1
X_382_ _172_ _174_ _175_ vssd1 vssd1 vccd1 vccd1 _024_ sky130_fd_sc_hd__a21o_1
XFILLER_31_197 vssd1 vssd1 vccd1 vccd1 sky130_fd_sc_hd__fill_2
XFILLER_31_175 vssd1 vssd1 vccd1 vccd1 sky130_fd_sc_hd__fill_2
XFILLER_31_153 vssd1 vssd1 vccd1 vccd1 sky130_fd_sc_hd__fill_4
X_434_ clknet_3_2__leaf_clk TOP.top_rng_inst.ecstate.next_count\[7\] net35 vssd1 vssd1
+ vccd1 vccd1 TOP.top_rng_inst.ecstate.count_out\[7\] sky130_fd_sc_hd__dfrtp_1
XFILLER_22_197 vccd1 vssd1 vccd1 vssd1 sky130_ef_sc_hd__decap_40_12
XFILLER_22_164 vssd1 vssd1 vccd1 vccd1 sky130_fd_sc_hd__fill_2
X_365_ _135_ _143_ vssd1 vssd1 vccd1 vccd1 _164_ sky130_fd_sc_hd__nand2_1
XFILLER_9_113 vssd1 vssd1 vccd1 vccd1 sky130_fd_sc_hd__fill_1
X_296_ TOP.top_rng_inst.k1.sync_r2.sync TOP.top_rng_inst.k1.sync_r1.sync net26 vssd1
+ vssd1 vccd1 vccd1 _107_ sky130_fd_sc_hd__mux2_1
XFILLER_3_54 vssd1 vssd1 vccd1 vccd1 sky130_fd_sc_hd__fill_2
XFILLER_3_87 vssd1 vssd1 vccd1 vccd1 sky130_fd_sc_hd__fill_1
XFILLER_8_190 vssd1 vssd1 vccd1 vccd1 sky130_fd_sc_hd__fill_4
XTAP_TAPCELL_ROW_20_140 vssd1 vccd1 sky130_fd_sc_hd__tapvpwrvgnd_1
XPHY_EDGE_ROW_0_Left_32 vssd1 vssd1 vccd1 vccd1 sky130_fd_sc_hd__decap_3
XFILLER_6_127 vssd1 vssd1 vccd1 vccd1 sky130_fd_sc_hd__fill_1
XFILLER_6_149 vssd1 vssd1 vccd1 vccd1 sky130_fd_sc_hd__fill_1
X_417_ clknet_3_2__leaf_clk TOP.top_rng_inst.lut1.ecstate.next_count\[3\] net36 vssd1
+ vssd1 vccd1 vccd1 TOP.top_rng_inst.lut1.ecstate.count_out\[3\] sky130_fd_sc_hd__dfrtp_1
XPHY_EDGE_ROW_25_Right_25 vssd1 vssd1 vccd1 vccd1 sky130_fd_sc_hd__decap_3
X_348_ TOP.top_rng_inst.lut1.internal_state\[9\] _151_ vssd1 vssd1 vccd1 vccd1 _152_
+ sky130_fd_sc_hd__xor2_1
XPHY_EDGE_ROW_16_Right_16 vssd1 vssd1 vccd1 vccd1 sky130_fd_sc_hd__decap_3
X_279_ TOP.top_rng_inst.display.datas\[2\] TOP.top_rng_inst.display.datas\[6\] TOP.top_rng_inst.display.datas\[10\]
+ TOP.top_rng_inst.display.datas\[14\] net14 net15 vssd1 vssd1 vccd1 vccd1 _095_ sky130_fd_sc_hd__mux4_1
XFILLER_5_171 vssd1 vssd1 vccd1 vccd1 sky130_fd_sc_hd__fill_1
XTAP_TAPCELL_ROW_8_97 vssd1 vccd1 sky130_fd_sc_hd__tapvpwrvgnd_1
X_202_ TOP.top_rng_inst.ecstate.count_out\[7\] _049_ vssd1 vssd1 vccd1 vccd1 _050_
+ sky130_fd_sc_hd__or2_1
XFILLER_17_7 vccd1 vssd1 vccd1 vssd1 sky130_ef_sc_hd__decap_40_12
XFILLER_2_152 vssd1 vssd1 vccd1 vccd1 sky130_fd_sc_hd__fill_4
XFILLER_28_18 vssd1 vssd1 vccd1 vccd1 sky130_fd_sc_hd__fill_8
XFILLER_0_88 vccd1 vssd1 vccd1 vssd1 sky130_ef_sc_hd__decap_40_12
XFILLER_0_55 vssd1 vssd1 vccd1 vccd1 sky130_fd_sc_hd__fill_1
XFILLER_9_20 vssd1 vssd1 vccd1 vccd1 sky130_fd_sc_hd__fill_1
XFILLER_9_53 vssd1 vssd1 vccd1 vccd1 sky130_fd_sc_hd__fill_2
Xclkbuf_3_0__f_clk clknet_0_clk vssd1 vssd1 vccd1 vccd1 clknet_3_0__leaf_clk sky130_fd_sc_hd__clkbuf_16
XANTENNA__392__B1 net19 vssd1 vssd1 vccd1 vccd1 sky130_fd_sc_hd__diode_2
XTAP_TAPCELL_ROW_5_87 vssd1 vccd1 sky130_fd_sc_hd__tapvpwrvgnd_1
XPHY_EDGE_ROW_2_Right_2 vssd1 vssd1 vccd1 vccd1 sky130_fd_sc_hd__decap_3
XFILLER_20_85 vssd1 vssd1 vccd1 vccd1 sky130_fd_sc_hd__fill_4
XFILLER_26_129 vssd1 vssd1 vccd1 vccd1 sky130_fd_sc_hd__fill_1
XFILLER_25_19 vssd1 vssd1 vccd1 vccd1 sky130_fd_sc_hd__fill_2
X_450_ clknet_3_6__leaf_clk _018_ net40 vssd1 vssd1 vccd1 vccd1 TOP.top_rng_inst.display.datas\[13\]
+ sky130_fd_sc_hd__dfrtp_1
X_381_ net29 net27 TOP.top_rng_inst.lut1.internal_state\[0\] net22 vssd1 vssd1 vccd1
+ vccd1 _175_ sky130_fd_sc_hd__a22o_1
XTAP_TAPCELL_ROW_2_77 vssd1 vccd1 sky130_fd_sc_hd__tapvpwrvgnd_1
XFILLER_31_165 vssd1 vssd1 vccd1 vccd1 sky130_fd_sc_hd__fill_2
XFILLER_31_132 vssd1 vssd1 vccd1 vccd1 sky130_fd_sc_hd__fill_4
XFILLER_16_195 vssd1 vssd1 vccd1 vccd1 sky130_fd_sc_hd__fill_1
X_433_ clknet_3_2__leaf_clk TOP.top_rng_inst.ecstate.next_count\[6\] net36 vssd1 vssd1
+ vccd1 vccd1 TOP.top_rng_inst.ecstate.count_out\[6\] sky130_fd_sc_hd__dfrtp_1
XANTENNA__349__S net31 vssd1 vssd1 vccd1 vccd1 sky130_fd_sc_hd__diode_2
X_364_ TOP.top_rng_inst.lut1.internal_state\[6\] TOP.top_rng_inst.lut1.internal_state\[14\]
+ vssd1 vssd1 vccd1 vccd1 _163_ sky130_fd_sc_hd__xor2_1
XFILLER_13_121 vssd1 vssd1 vccd1 vccd1 sky130_fd_sc_hd__fill_2
XFILLER_13_110 vssd1 vssd1 vccd1 vccd1 sky130_fd_sc_hd__fill_2
XFILLER_9_103 vssd1 vssd1 vccd1 vccd1 sky130_fd_sc_hd__fill_1
X_295_ net25 _106_ net31 vssd1 vssd1 vccd1 vccd1 _006_ sky130_fd_sc_hd__mux2_1
XFILLER_6_106 vssd1 vssd1 vccd1 vccd1 sky130_fd_sc_hd__fill_2
X_416_ clknet_3_3__leaf_clk TOP.top_rng_inst.lut1.ecstate.next_count\[2\] net40 vssd1
+ vssd1 vccd1 vccd1 TOP.top_rng_inst.lut1.ecstate.count_out\[2\] sky130_fd_sc_hd__dfrtp_1
X_278_ TOP.top_rng_inst.display.current_data\[1\] _044_ _093_ _094_ vssd1 vssd1 vccd1
+ vccd1 _001_ sky130_fd_sc_hd__a22o_1
X_347_ net24 _119_ _126_ _143_ _103_ vssd1 vssd1 vccd1 vccd1 _151_ sky130_fd_sc_hd__a32o_1
XFILLER_6_139 vssd1 vssd1 vccd1 vccd1 sky130_fd_sc_hd__fill_1
XTAP_TAPCELL_ROW_8_98 vssd1 vccd1 sky130_fd_sc_hd__tapvpwrvgnd_1
XFILLER_3_109 vssd1 vssd1 vccd1 vccd1 sky130_fd_sc_hd__fill_1
X_201_ TOP.top_rng_inst.ecstate.count_out\[6\] _048_ vssd1 vssd1 vccd1 vccd1 _049_
+ sky130_fd_sc_hd__and2_1
XFILLER_2_197 vccd1 vssd1 vccd1 vssd1 sky130_ef_sc_hd__decap_40_12
XFILLER_0_12 vccd1 vssd1 vccd1 vssd1 sky130_ef_sc_hd__decap_40_12
XFILLER_9_87 vccd1 vssd1 vccd1 vssd1 sky130_ef_sc_hd__decap_40_12
XFILLER_18_85 vssd1 vssd1 vccd1 vccd1 sky130_fd_sc_hd__fill_8
XFILLER_29_149 vssd1 vssd1 vccd1 vccd1 sky130_fd_sc_hd__fill_2
Xhold40 _037_ vssd1 vssd1 vccd1 vccd1 net139 sky130_fd_sc_hd__dlygate4sd3_1
XFILLER_20_31 vssd1 vssd1 vccd1 vccd1 sky130_fd_sc_hd__fill_1
XFILLER_26_119 vssd1 vssd1 vccd1 vccd1 sky130_fd_sc_hd__fill_8
XFILLER_31_85 vccd1 vssd1 vccd1 vssd1 sky130_ef_sc_hd__decap_40_12
XFILLER_31_41 vccd1 vssd1 vccd1 vssd1 sky130_ef_sc_hd__decap_40_12
XANTENNA__370__S net31 vssd1 vssd1 vccd1 vccd1 sky130_fd_sc_hd__diode_2
X_380_ _170_ _171_ net19 vssd1 vssd1 vccd1 vccd1 _174_ sky130_fd_sc_hd__o21a_1
XFILLER_31_199 vssd1 vssd1 vccd1 vccd1 sky130_fd_sc_hd__fill_1
XFILLER_31_177 vssd1 vssd1 vccd1 vccd1 sky130_fd_sc_hd__fill_1
XFILLER_31_111 vssd1 vssd1 vccd1 vccd1 sky130_fd_sc_hd__fill_1
XFILLER_16_141 vssd1 vssd1 vccd1 vccd1 sky130_fd_sc_hd__fill_4
.ends
