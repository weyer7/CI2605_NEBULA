* NGSPICE file created from team_04.ext - technology: sky130A

* Black-box entry subcircuit for sky130_fd_sc_hd__fill_2 abstract view
.subckt sky130_fd_sc_hd__fill_2 VGND VNB VPB VPWR
.ends

* Black-box entry subcircuit for sky130_fd_sc_hd__tapvpwrvgnd_1 abstract view
.subckt sky130_fd_sc_hd__tapvpwrvgnd_1 VGND VPWR
.ends

* Black-box entry subcircuit for sky130_ef_sc_hd__decap_40_12 abstract view
.subckt sky130_ef_sc_hd__decap_40_12 VPWR VGND VPB VNB
.ends

* Black-box entry subcircuit for sky130_fd_sc_hd__fill_1 abstract view
.subckt sky130_fd_sc_hd__fill_1 VGND VNB VPB VPWR
.ends

* Black-box entry subcircuit for sky130_fd_sc_hd__fill_8 abstract view
.subckt sky130_fd_sc_hd__fill_8 VGND VNB VPB VPWR
.ends

* Black-box entry subcircuit for sky130_fd_sc_hd__xnor2_2 abstract view
.subckt sky130_fd_sc_hd__xnor2_2 A B VGND VNB VPB VPWR Y
.ends

* Black-box entry subcircuit for sky130_fd_sc_hd__dfxtp_1 abstract view
.subckt sky130_fd_sc_hd__dfxtp_1 CLK D VGND VNB VPB VPWR Q
.ends

* Black-box entry subcircuit for sky130_fd_sc_hd__or3b_1 abstract view
.subckt sky130_fd_sc_hd__or3b_1 A B C_N VGND VNB VPB VPWR X
.ends

* Black-box entry subcircuit for sky130_fd_sc_hd__a21o_1 abstract view
.subckt sky130_fd_sc_hd__a21o_1 A1 A2 B1 VGND VNB VPB VPWR X
.ends

* Black-box entry subcircuit for sky130_fd_sc_hd__a22o_1 abstract view
.subckt sky130_fd_sc_hd__a22o_1 A1 A2 B1 B2 VGND VNB VPB VPWR X
.ends

* Black-box entry subcircuit for sky130_fd_sc_hd__o2bb2a_1 abstract view
.subckt sky130_fd_sc_hd__o2bb2a_1 A1_N A2_N B1 B2 VGND VNB VPB VPWR X
.ends

* Black-box entry subcircuit for sky130_fd_sc_hd__nand2b_1 abstract view
.subckt sky130_fd_sc_hd__nand2b_1 A_N B VGND VNB VPB VPWR Y
.ends

* Black-box entry subcircuit for sky130_fd_sc_hd__xor2_1 abstract view
.subckt sky130_fd_sc_hd__xor2_1 A B VGND VNB VPB VPWR X
.ends

* Black-box entry subcircuit for sky130_fd_sc_hd__o211a_1 abstract view
.subckt sky130_fd_sc_hd__o211a_1 A1 A2 B1 C1 VGND VNB VPB VPWR X
.ends

* Black-box entry subcircuit for sky130_fd_sc_hd__nand2_1 abstract view
.subckt sky130_fd_sc_hd__nand2_1 A B VGND VNB VPB VPWR Y
.ends

* Black-box entry subcircuit for sky130_fd_sc_hd__and2b_1 abstract view
.subckt sky130_fd_sc_hd__and2b_1 A_N B VGND VNB VPB VPWR X
.ends

* Black-box entry subcircuit for sky130_fd_sc_hd__and4_1 abstract view
.subckt sky130_fd_sc_hd__and4_1 A B C D VGND VNB VPB VPWR X
.ends

* Black-box entry subcircuit for sky130_fd_sc_hd__and3_1 abstract view
.subckt sky130_fd_sc_hd__and3_1 A B C VGND VNB VPB VPWR X
.ends

* Black-box entry subcircuit for sky130_fd_sc_hd__xor2_2 abstract view
.subckt sky130_fd_sc_hd__xor2_2 A B VGND VNB VPB VPWR X
.ends

* Black-box entry subcircuit for sky130_fd_sc_hd__or3_1 abstract view
.subckt sky130_fd_sc_hd__or3_1 A B C VGND VNB VPB VPWR X
.ends

* Black-box entry subcircuit for sky130_fd_sc_hd__dlygate4sd3_1 abstract view
.subckt sky130_fd_sc_hd__dlygate4sd3_1 A VGND VNB VPB VPWR X
.ends

* Black-box entry subcircuit for sky130_fd_sc_hd__fill_4 abstract view
.subckt sky130_fd_sc_hd__fill_4 VGND VNB VPB VPWR
.ends

* Black-box entry subcircuit for sky130_fd_sc_hd__a32o_1 abstract view
.subckt sky130_fd_sc_hd__a32o_1 A1 A2 A3 B1 B2 VGND VNB VPB VPWR X
.ends

* Black-box entry subcircuit for sky130_fd_sc_hd__and3_4 abstract view
.subckt sky130_fd_sc_hd__and3_4 A B C VGND VNB VPB VPWR X
.ends

* Black-box entry subcircuit for sky130_fd_sc_hd__buf_2 abstract view
.subckt sky130_fd_sc_hd__buf_2 A VGND VNB VPB VPWR X
.ends

* Black-box entry subcircuit for sky130_fd_sc_hd__dfrtp_1 abstract view
.subckt sky130_fd_sc_hd__dfrtp_1 CLK D RESET_B VGND VNB VPB VPWR Q
.ends

* Black-box entry subcircuit for sky130_fd_sc_hd__clkbuf_16 abstract view
.subckt sky130_fd_sc_hd__clkbuf_16 A VGND VNB VPB VPWR X
.ends

* Black-box entry subcircuit for sky130_fd_sc_hd__dlygate4sd1_1 abstract view
.subckt sky130_fd_sc_hd__dlygate4sd1_1 A VGND VNB VPB VPWR X
.ends

* Black-box entry subcircuit for sky130_fd_sc_hd__a31o_1 abstract view
.subckt sky130_fd_sc_hd__a31o_1 A1 A2 A3 B1 VGND VNB VPB VPWR X
.ends

* Black-box entry subcircuit for sky130_fd_sc_hd__o21a_1 abstract view
.subckt sky130_fd_sc_hd__o21a_1 A1 A2 B1 VGND VNB VPB VPWR X
.ends

* Black-box entry subcircuit for sky130_fd_sc_hd__inv_2 abstract view
.subckt sky130_fd_sc_hd__inv_2 A VGND VNB VPB VPWR Y
.ends

* Black-box entry subcircuit for sky130_fd_sc_hd__a41o_1 abstract view
.subckt sky130_fd_sc_hd__a41o_1 A1 A2 A3 A4 B1 VGND VNB VPB VPWR X
.ends

* Black-box entry subcircuit for sky130_fd_sc_hd__o21ai_2 abstract view
.subckt sky130_fd_sc_hd__o21ai_2 A1 A2 B1 VGND VNB VPB VPWR Y
.ends

* Black-box entry subcircuit for sky130_fd_sc_hd__decap_3 abstract view
.subckt sky130_fd_sc_hd__decap_3 VGND VNB VPB VPWR
.ends

* Black-box entry subcircuit for sky130_fd_sc_hd__nor2_1 abstract view
.subckt sky130_fd_sc_hd__nor2_1 A B VGND VNB VPB VPWR Y
.ends

* Black-box entry subcircuit for sky130_fd_sc_hd__a221o_1 abstract view
.subckt sky130_fd_sc_hd__a221o_1 A1 A2 B1 B2 C1 VGND VNB VPB VPWR X
.ends

* Black-box entry subcircuit for sky130_fd_sc_hd__and4bb_1 abstract view
.subckt sky130_fd_sc_hd__and4bb_1 A_N B_N C D VGND VNB VPB VPWR X
.ends

* Black-box entry subcircuit for sky130_fd_sc_hd__xnor2_1 abstract view
.subckt sky130_fd_sc_hd__xnor2_1 A B VGND VNB VPB VPWR Y
.ends

* Black-box entry subcircuit for sky130_fd_sc_hd__a21oi_1 abstract view
.subckt sky130_fd_sc_hd__a21oi_1 A1 A2 B1 VGND VNB VPB VPWR Y
.ends

* Black-box entry subcircuit for sky130_fd_sc_hd__o21ai_1 abstract view
.subckt sky130_fd_sc_hd__o21ai_1 A1 A2 B1 VGND VNB VPB VPWR Y
.ends

* Black-box entry subcircuit for sky130_fd_sc_hd__and2_1 abstract view
.subckt sky130_fd_sc_hd__and2_1 A B VGND VNB VPB VPWR X
.ends

* Black-box entry subcircuit for sky130_fd_sc_hd__or2_1 abstract view
.subckt sky130_fd_sc_hd__or2_1 A B VGND VNB VPB VPWR X
.ends

* Black-box entry subcircuit for sky130_fd_sc_hd__xor2_4 abstract view
.subckt sky130_fd_sc_hd__xor2_4 A B VGND VNB VPB VPWR X
.ends

* Black-box entry subcircuit for sky130_fd_sc_hd__o21a_2 abstract view
.subckt sky130_fd_sc_hd__o21a_2 A1 A2 B1 VGND VNB VPB VPWR X
.ends

* Black-box entry subcircuit for sky130_fd_sc_hd__or3b_4 abstract view
.subckt sky130_fd_sc_hd__or3b_4 A B C_N VGND VNB VPB VPWR X
.ends

* Black-box entry subcircuit for sky130_fd_sc_hd__a31o_4 abstract view
.subckt sky130_fd_sc_hd__a31o_4 A1 A2 A3 B1 VGND VNB VPB VPWR X
.ends

* Black-box entry subcircuit for sky130_fd_sc_hd__dlymetal6s4s_1 abstract view
.subckt sky130_fd_sc_hd__dlymetal6s4s_1 A VGND VNB VPB VPWR X
.ends

* Black-box entry subcircuit for sky130_fd_sc_hd__diode_2 abstract view
.subckt sky130_fd_sc_hd__diode_2 DIODE VGND VNB VPB VPWR
.ends

* Black-box entry subcircuit for sky130_fd_sc_hd__or2_2 abstract view
.subckt sky130_fd_sc_hd__or2_2 A B VGND VNB VPB VPWR X
.ends

* Black-box entry subcircuit for sky130_fd_sc_hd__o311a_1 abstract view
.subckt sky130_fd_sc_hd__o311a_1 A1 A2 A3 B1 C1 VGND VNB VPB VPWR X
.ends

* Black-box entry subcircuit for sky130_fd_sc_hd__a211o_1 abstract view
.subckt sky130_fd_sc_hd__a211o_1 A1 A2 B1 C1 VGND VNB VPB VPWR X
.ends

* Black-box entry subcircuit for sky130_fd_sc_hd__a21bo_4 abstract view
.subckt sky130_fd_sc_hd__a21bo_4 A1 A2 B1_N VGND VNB VPB VPWR X
.ends

* Black-box entry subcircuit for sky130_fd_sc_hd__or2_4 abstract view
.subckt sky130_fd_sc_hd__or2_4 A B VGND VNB VPB VPWR X
.ends

* Black-box entry subcircuit for sky130_fd_sc_hd__o31a_1 abstract view
.subckt sky130_fd_sc_hd__o31a_1 A1 A2 A3 B1 VGND VNB VPB VPWR X
.ends

* Black-box entry subcircuit for sky130_fd_sc_hd__or3_4 abstract view
.subckt sky130_fd_sc_hd__or3_4 A B C VGND VNB VPB VPWR X
.ends

* Black-box entry subcircuit for sky130_fd_sc_hd__nand2_2 abstract view
.subckt sky130_fd_sc_hd__nand2_2 A B VGND VNB VPB VPWR Y
.ends

* Black-box entry subcircuit for sky130_fd_sc_hd__o22a_1 abstract view
.subckt sky130_fd_sc_hd__o22a_1 A1 A2 B1 B2 VGND VNB VPB VPWR X
.ends

* Black-box entry subcircuit for sky130_fd_sc_hd__a2bb2o_1 abstract view
.subckt sky130_fd_sc_hd__a2bb2o_1 A1_N A2_N B1 B2 VGND VNB VPB VPWR X
.ends

* Black-box entry subcircuit for sky130_fd_sc_hd__and3b_1 abstract view
.subckt sky130_fd_sc_hd__and3b_1 A_N B C VGND VNB VPB VPWR X
.ends

* Black-box entry subcircuit for sky130_fd_sc_hd__clkbuf_8 abstract view
.subckt sky130_fd_sc_hd__clkbuf_8 A VGND VNB VPB VPWR X
.ends

* Black-box entry subcircuit for sky130_fd_sc_hd__or4_4 abstract view
.subckt sky130_fd_sc_hd__or4_4 A B C D VGND VNB VPB VPWR X
.ends

* Black-box entry subcircuit for sky130_fd_sc_hd__o31ai_1 abstract view
.subckt sky130_fd_sc_hd__o31ai_1 A1 A2 A3 B1 VGND VNB VPB VPWR Y
.ends

* Black-box entry subcircuit for sky130_fd_sc_hd__o221a_1 abstract view
.subckt sky130_fd_sc_hd__o221a_1 A1 A2 B1 B2 C1 VGND VNB VPB VPWR X
.ends

* Black-box entry subcircuit for sky130_fd_sc_hd__clkinv_2 abstract view
.subckt sky130_fd_sc_hd__clkinv_2 A VGND VNB VPB VPWR Y
.ends

* Black-box entry subcircuit for sky130_fd_sc_hd__nor2_2 abstract view
.subckt sky130_fd_sc_hd__nor2_2 A B VGND VNB VPB VPWR Y
.ends

* Black-box entry subcircuit for sky130_fd_sc_hd__or4b_1 abstract view
.subckt sky130_fd_sc_hd__or4b_1 A B C D_N VGND VNB VPB VPWR X
.ends

* Black-box entry subcircuit for sky130_fd_sc_hd__nor3b_1 abstract view
.subckt sky130_fd_sc_hd__nor3b_1 A B C_N VGND VNB VPB VPWR Y
.ends

* Black-box entry subcircuit for sky130_fd_sc_hd__bufinv_16 abstract view
.subckt sky130_fd_sc_hd__bufinv_16 A VGND VNB VPB VPWR Y
.ends

* Black-box entry subcircuit for sky130_fd_sc_hd__a21oi_2 abstract view
.subckt sky130_fd_sc_hd__a21oi_2 A1 A2 B1 VGND VNB VPB VPWR Y
.ends

* Black-box entry subcircuit for sky130_fd_sc_hd__or4bb_1 abstract view
.subckt sky130_fd_sc_hd__or4bb_1 A B C_N D_N VGND VNB VPB VPWR X
.ends

* Black-box entry subcircuit for sky130_fd_sc_hd__a21bo_1 abstract view
.subckt sky130_fd_sc_hd__a21bo_1 A1 A2 B1_N VGND VNB VPB VPWR X
.ends

* Black-box entry subcircuit for sky130_fd_sc_hd__nand3_1 abstract view
.subckt sky130_fd_sc_hd__nand3_1 A B C VGND VNB VPB VPWR Y
.ends

* Black-box entry subcircuit for sky130_fd_sc_hd__o21ba_1 abstract view
.subckt sky130_fd_sc_hd__o21ba_1 A1 A2 B1_N VGND VNB VPB VPWR X
.ends

* Black-box entry subcircuit for sky130_fd_sc_hd__a2111oi_2 abstract view
.subckt sky130_fd_sc_hd__a2111oi_2 A1 A2 B1 C1 D1 VGND VNB VPB VPWR Y
.ends

* Black-box entry subcircuit for sky130_fd_sc_hd__and4b_1 abstract view
.subckt sky130_fd_sc_hd__and4b_1 A_N B C D VGND VNB VPB VPWR X
.ends

* Black-box entry subcircuit for sky130_fd_sc_hd__o21bai_2 abstract view
.subckt sky130_fd_sc_hd__o21bai_2 A1 A2 B1_N VGND VNB VPB VPWR Y
.ends

* Black-box entry subcircuit for sky130_fd_sc_hd__a31oi_1 abstract view
.subckt sky130_fd_sc_hd__a31oi_1 A1 A2 A3 B1 VGND VNB VPB VPWR Y
.ends

* Black-box entry subcircuit for sky130_fd_sc_hd__o221ai_2 abstract view
.subckt sky130_fd_sc_hd__o221ai_2 A1 A2 B1 B2 C1 VGND VNB VPB VPWR Y
.ends

* Black-box entry subcircuit for sky130_fd_sc_hd__clkbuf_2 abstract view
.subckt sky130_fd_sc_hd__clkbuf_2 A VGND VNB VPB VPWR X
.ends

* Black-box entry subcircuit for sky130_fd_sc_hd__or4_1 abstract view
.subckt sky130_fd_sc_hd__or4_1 A B C D VGND VNB VPB VPWR X
.ends

* Black-box entry subcircuit for sky130_fd_sc_hd__clkinvlp_4 abstract view
.subckt sky130_fd_sc_hd__clkinvlp_4 A VGND VNB VPB VPWR Y
.ends

* Black-box entry subcircuit for sky130_fd_sc_hd__clkbuf_1 abstract view
.subckt sky130_fd_sc_hd__clkbuf_1 A VGND VNB VPB VPWR X
.ends

* Black-box entry subcircuit for sky130_fd_sc_hd__buf_6 abstract view
.subckt sky130_fd_sc_hd__buf_6 A VGND VNB VPB VPWR X
.ends

* Black-box entry subcircuit for sky130_fd_sc_hd__inv_6 abstract view
.subckt sky130_fd_sc_hd__inv_6 A VGND VNB VPB VPWR Y
.ends

* Black-box entry subcircuit for sky130_fd_sc_hd__a21boi_2 abstract view
.subckt sky130_fd_sc_hd__a21boi_2 A1 A2 B1_N VGND VNB VPB VPWR Y
.ends

* Black-box entry subcircuit for sky130_fd_sc_hd__o22ai_4 abstract view
.subckt sky130_fd_sc_hd__o22ai_4 A1 A2 B1 B2 VGND VNB VPB VPWR Y
.ends

* Black-box entry subcircuit for sky130_fd_sc_hd__a2bb2o_2 abstract view
.subckt sky130_fd_sc_hd__a2bb2o_2 A1_N A2_N B1 B2 VGND VNB VPB VPWR X
.ends

* Black-box entry subcircuit for sky130_fd_sc_hd__dfrtp_4 abstract view
.subckt sky130_fd_sc_hd__dfrtp_4 CLK D RESET_B VGND VNB VPB VPWR Q
.ends

* Black-box entry subcircuit for sky130_fd_sc_hd__clkbuf_4 abstract view
.subckt sky130_fd_sc_hd__clkbuf_4 A VGND VNB VPB VPWR X
.ends

* Black-box entry subcircuit for sky130_fd_sc_hd__a311o_1 abstract view
.subckt sky130_fd_sc_hd__a311o_1 A1 A2 A3 B1 C1 VGND VNB VPB VPWR X
.ends

* Black-box entry subcircuit for sky130_fd_sc_hd__a22oi_1 abstract view
.subckt sky130_fd_sc_hd__a22oi_1 A1 A2 B1 B2 VGND VNB VPB VPWR Y
.ends

* Black-box entry subcircuit for sky130_fd_sc_hd__nor3_1 abstract view
.subckt sky130_fd_sc_hd__nor3_1 A B C VGND VNB VPB VPWR Y
.ends

* Black-box entry subcircuit for sky130_fd_sc_hd__a31oi_4 abstract view
.subckt sky130_fd_sc_hd__a31oi_4 A1 A2 A3 B1 VGND VNB VPB VPWR Y
.ends

* Black-box entry subcircuit for sky130_fd_sc_hd__nor4_4 abstract view
.subckt sky130_fd_sc_hd__nor4_4 A B C D VGND VNB VPB VPWR Y
.ends

* Black-box entry subcircuit for sky130_fd_sc_hd__buf_8 abstract view
.subckt sky130_fd_sc_hd__buf_8 A VGND VNB VPB VPWR X
.ends

* Black-box entry subcircuit for sky130_fd_sc_hd__nor4_1 abstract view
.subckt sky130_fd_sc_hd__nor4_1 A B C D VGND VNB VPB VPWR Y
.ends

* Black-box entry subcircuit for sky130_fd_sc_hd__a2111o_1 abstract view
.subckt sky130_fd_sc_hd__a2111o_1 A1 A2 B1 C1 D1 VGND VNB VPB VPWR X
.ends

* Black-box entry subcircuit for sky130_fd_sc_hd__buf_1 abstract view
.subckt sky130_fd_sc_hd__buf_1 A VGND VNB VPB VPWR X
.ends

* Black-box entry subcircuit for sky130_fd_sc_hd__a22oi_2 abstract view
.subckt sky130_fd_sc_hd__a22oi_2 A1 A2 B1 B2 VGND VNB VPB VPWR Y
.ends

* Black-box entry subcircuit for sky130_fd_sc_hd__xnor2_4 abstract view
.subckt sky130_fd_sc_hd__xnor2_4 A B VGND VNB VPB VPWR Y
.ends

* Black-box entry subcircuit for sky130_fd_sc_hd__a21boi_1 abstract view
.subckt sky130_fd_sc_hd__a21boi_1 A1 A2 B1_N VGND VNB VPB VPWR Y
.ends

* Black-box entry subcircuit for sky130_fd_sc_hd__buf_4 abstract view
.subckt sky130_fd_sc_hd__buf_4 A VGND VNB VPB VPWR X
.ends

* Black-box entry subcircuit for sky130_fd_sc_hd__conb_1 abstract view
.subckt sky130_fd_sc_hd__conb_1 VGND VNB VPB VPWR HI LO
.ends

* Black-box entry subcircuit for sky130_fd_sc_hd__a21o_4 abstract view
.subckt sky130_fd_sc_hd__a21o_4 A1 A2 B1 VGND VNB VPB VPWR X
.ends

* Black-box entry subcircuit for sky130_fd_sc_hd__o31ai_4 abstract view
.subckt sky130_fd_sc_hd__o31ai_4 A1 A2 A3 B1 VGND VNB VPB VPWR Y
.ends

* Black-box entry subcircuit for sky130_fd_sc_hd__a21oi_4 abstract view
.subckt sky130_fd_sc_hd__a21oi_4 A1 A2 B1 VGND VNB VPB VPWR Y
.ends

* Black-box entry subcircuit for sky130_fd_sc_hd__or4b_4 abstract view
.subckt sky130_fd_sc_hd__or4b_4 A B C D_N VGND VNB VPB VPWR X
.ends

* Black-box entry subcircuit for sky130_fd_sc_hd__nand4_1 abstract view
.subckt sky130_fd_sc_hd__nand4_1 A B C D VGND VNB VPB VPWR Y
.ends

* Black-box entry subcircuit for sky130_fd_sc_hd__mux2_1 abstract view
.subckt sky130_fd_sc_hd__mux2_1 A0 A1 S VGND VNB VPB VPWR X
.ends

* Black-box entry subcircuit for sky130_fd_sc_hd__mux2_2 abstract view
.subckt sky130_fd_sc_hd__mux2_2 A0 A1 S VGND VNB VPB VPWR X
.ends

* Black-box entry subcircuit for sky130_fd_sc_hd__dfrtp_2 abstract view
.subckt sky130_fd_sc_hd__dfrtp_2 CLK D RESET_B VGND VNB VPB VPWR Q
.ends

* Black-box entry subcircuit for sky130_fd_sc_hd__and2_4 abstract view
.subckt sky130_fd_sc_hd__and2_4 A B VGND VNB VPB VPWR X
.ends

* Black-box entry subcircuit for sky130_fd_sc_hd__nand3b_1 abstract view
.subckt sky130_fd_sc_hd__nand3b_1 A_N B C VGND VNB VPB VPWR Y
.ends

* Black-box entry subcircuit for sky130_fd_sc_hd__a22o_4 abstract view
.subckt sky130_fd_sc_hd__a22o_4 A1 A2 B1 B2 VGND VNB VPB VPWR X
.ends

* Black-box entry subcircuit for sky130_fd_sc_hd__o211ai_2 abstract view
.subckt sky130_fd_sc_hd__o211ai_2 A1 A2 B1 C1 VGND VNB VPB VPWR Y
.ends

* Black-box entry subcircuit for sky130_fd_sc_hd__o21bai_4 abstract view
.subckt sky130_fd_sc_hd__o21bai_4 A1 A2 B1_N VGND VNB VPB VPWR Y
.ends

* Black-box entry subcircuit for sky130_fd_sc_hd__nand3_4 abstract view
.subckt sky130_fd_sc_hd__nand3_4 A B C VGND VNB VPB VPWR Y
.ends

* Black-box entry subcircuit for sky130_fd_sc_hd__dlymetal6s2s_1 abstract view
.subckt sky130_fd_sc_hd__dlymetal6s2s_1 A VGND VNB VPB VPWR X
.ends

* Black-box entry subcircuit for sky130_fd_sc_hd__and2b_2 abstract view
.subckt sky130_fd_sc_hd__and2b_2 A_N B VGND VNB VPB VPWR X
.ends

* Black-box entry subcircuit for sky130_fd_sc_hd__o21bai_1 abstract view
.subckt sky130_fd_sc_hd__o21bai_1 A1 A2 B1_N VGND VNB VPB VPWR Y
.ends

* Black-box entry subcircuit for sky130_fd_sc_hd__o32a_1 abstract view
.subckt sky130_fd_sc_hd__o32a_1 A1 A2 A3 B1 B2 VGND VNB VPB VPWR X
.ends

* Black-box entry subcircuit for sky130_fd_sc_hd__or4bb_4 abstract view
.subckt sky130_fd_sc_hd__or4bb_4 A B C_N D_N VGND VNB VPB VPWR X
.ends

* Black-box entry subcircuit for sky130_fd_sc_hd__nor3_2 abstract view
.subckt sky130_fd_sc_hd__nor3_2 A B C VGND VNB VPB VPWR Y
.ends

* Black-box entry subcircuit for sky130_fd_sc_hd__a211oi_1 abstract view
.subckt sky130_fd_sc_hd__a211oi_1 A1 A2 B1 C1 VGND VNB VPB VPWR Y
.ends

* Black-box entry subcircuit for sky130_fd_sc_hd__or4_2 abstract view
.subckt sky130_fd_sc_hd__or4_2 A B C D VGND VNB VPB VPWR X
.ends

* Black-box entry subcircuit for sky130_fd_sc_hd__a2bb2o_4 abstract view
.subckt sky130_fd_sc_hd__a2bb2o_4 A1_N A2_N B1 B2 VGND VNB VPB VPWR X
.ends

* Black-box entry subcircuit for sky130_fd_sc_hd__dfxtp_2 abstract view
.subckt sky130_fd_sc_hd__dfxtp_2 CLK D VGND VNB VPB VPWR Q
.ends

* Black-box entry subcircuit for sky130_fd_sc_hd__o32ai_4 abstract view
.subckt sky130_fd_sc_hd__o32ai_4 A1 A2 A3 B1 B2 VGND VNB VPB VPWR Y
.ends

* Black-box entry subcircuit for sky130_fd_sc_hd__a211oi_2 abstract view
.subckt sky130_fd_sc_hd__a211oi_2 A1 A2 B1 C1 VGND VNB VPB VPWR Y
.ends

* Black-box entry subcircuit for sky130_fd_sc_hd__a211o_4 abstract view
.subckt sky130_fd_sc_hd__a211o_4 A1 A2 B1 C1 VGND VNB VPB VPWR X
.ends

.subckt team_04 clk en gpio_in[0] gpio_in[10] gpio_in[11] gpio_in[12] gpio_in[13]
+ gpio_in[14] gpio_in[15] gpio_in[16] gpio_in[17] gpio_in[18] gpio_in[19] gpio_in[1]
+ gpio_in[20] gpio_in[21] gpio_in[22] gpio_in[23] gpio_in[24] gpio_in[25] gpio_in[26]
+ gpio_in[27] gpio_in[28] gpio_in[29] gpio_in[2] gpio_in[30] gpio_in[31] gpio_in[32]
+ gpio_in[33] gpio_in[3] gpio_in[4] gpio_in[5] gpio_in[6] gpio_in[7] gpio_in[8] gpio_in[9]
+ gpio_oeb[0] gpio_oeb[10] gpio_oeb[11] gpio_oeb[12] gpio_oeb[13] gpio_oeb[14] gpio_oeb[15]
+ gpio_oeb[16] gpio_oeb[17] gpio_oeb[18] gpio_oeb[19] gpio_oeb[1] gpio_oeb[20] gpio_oeb[21]
+ gpio_oeb[22] gpio_oeb[23] gpio_oeb[24] gpio_oeb[25] gpio_oeb[26] gpio_oeb[27] gpio_oeb[28]
+ gpio_oeb[29] gpio_oeb[2] gpio_oeb[30] gpio_oeb[31] gpio_oeb[32] gpio_oeb[33] gpio_oeb[3]
+ gpio_oeb[4] gpio_oeb[5] gpio_oeb[6] gpio_oeb[7] gpio_oeb[8] gpio_oeb[9] gpio_out[0]
+ gpio_out[10] gpio_out[11] gpio_out[12] gpio_out[13] gpio_out[14] gpio_out[15] gpio_out[16]
+ gpio_out[17] gpio_out[18] gpio_out[19] gpio_out[1] gpio_out[20] gpio_out[21] gpio_out[22]
+ gpio_out[23] gpio_out[24] gpio_out[25] gpio_out[26] gpio_out[27] gpio_out[28] gpio_out[29]
+ gpio_out[2] gpio_out[30] gpio_out[31] gpio_out[32] gpio_out[33] gpio_out[3] gpio_out[4]
+ gpio_out[5] gpio_out[6] gpio_out[7] gpio_out[8] gpio_out[9] nrst vccd1 vssd1
XFILLER_7_7 vssd1 vssd1 vccd1 vccd1 sky130_fd_sc_hd__fill_2
XTAP_TAPCELL_ROW_9_148 vssd1 vccd1 sky130_fd_sc_hd__tapvpwrvgnd_1
XFILLER_45_225 vccd1 vssd1 vccd1 vssd1 sky130_ef_sc_hd__decap_40_12
XFILLER_13_155 vssd1 vssd1 vccd1 vccd1 sky130_fd_sc_hd__fill_1
XFILLER_3_45 vssd1 vssd1 vccd1 vccd1 sky130_fd_sc_hd__fill_2
XFILLER_36_258 vssd1 vssd1 vccd1 vccd1 sky130_fd_sc_hd__fill_1
XFILLER_36_203 vssd1 vssd1 vccd1 vccd1 sky130_fd_sc_hd__fill_8
X_1270_ _0464_ _0501_ vssd1 vssd1 vccd1 vccd1 _0502_ sky130_fd_sc_hd__xnor2_2
XFILLER_3_89 vssd1 vssd1 vccd1 vccd1 sky130_fd_sc_hd__fill_2
XTAP_TAPCELL_ROW_14_172 vssd1 vccd1 sky130_fd_sc_hd__tapvpwrvgnd_1
X_1606_ clknet_3_1__leaf_clk _0015_ vssd1 vssd1 vccd1 vccd1 STOPWATCH_INST.digit_scanner.period_counter\[6\]
+ sky130_fd_sc_hd__dfxtp_1
X_0985_ _0198_ _0206_ net47 vssd1 vssd1 vccd1 vccd1 _0217_ sky130_fd_sc_hd__or3b_1
X_1399_ _0539_ _0592_ _0548_ vssd1 vssd1 vccd1 vccd1 _0631_ sky130_fd_sc_hd__a21o_1
XTAP_TAPCELL_ROW_6_129 vssd1 vccd1 sky130_fd_sc_hd__tapvpwrvgnd_1
X_1537_ net44 net40 _0751_ _0754_ vssd1 vssd1 vccd1 vccd1 _0046_ sky130_fd_sc_hd__a22o_1
X_1468_ STOPWATCH_INST.clock_div.cycles\[11\] net41 net37 _0695_ vssd1 vssd1 vccd1
+ vccd1 _0036_ sky130_fd_sc_hd__a22o_1
XTAP_TAPCELL_ROW_37_286 vssd1 vccd1 sky130_fd_sc_hd__tapvpwrvgnd_1
XFILLER_27_225 vssd1 vssd1 vccd1 vccd1 sky130_fd_sc_hd__fill_1
XFILLER_33_217 vssd1 vssd1 vccd1 vccd1 sky130_fd_sc_hd__fill_1
XTAP_TAPCELL_ROW_28_242 vssd1 vccd1 sky130_fd_sc_hd__tapvpwrvgnd_1
X_1253_ _0475_ _0482_ _0484_ _0481_ vssd1 vssd1 vccd1 vccd1 _0485_ sky130_fd_sc_hd__o2bb2a_1
X_1322_ _0549_ net140 vssd1 vssd1 vccd1 vccd1 _0554_ sky130_fd_sc_hd__nand2b_1
X_1184_ _0268_ _0415_ vssd1 vssd1 vccd1 vccd1 _0416_ sky130_fd_sc_hd__xor2_1
XFILLER_24_228 vssd1 vssd1 vccd1 vccd1 sky130_fd_sc_hd__fill_1
XFILLER_32_283 vssd1 vssd1 vccd1 vccd1 sky130_fd_sc_hd__fill_1
XFILLER_32_250 vssd1 vssd1 vccd1 vccd1 sky130_fd_sc_hd__fill_2
X_0968_ net47 net46 STOPWATCH_INST.clock_div.cycles\[17\] STOPWATCH_INST.clock_div.cycles\[18\]
+ vssd1 vssd1 vccd1 vccd1 _0200_ sky130_fd_sc_hd__o211a_1
X_0899_ STOPWATCH_INST.digit_scanner.period_counter\[4\] _0118_ vssd1 vssd1 vccd1
+ vccd1 _0150_ sky130_fd_sc_hd__nand2_1
XTAP_TAPCELL_ROW_2_110 vssd1 vccd1 sky130_fd_sc_hd__tapvpwrvgnd_1
XFILLER_15_239 vssd1 vssd1 vccd1 vccd1 sky130_fd_sc_hd__fill_1
XFILLER_23_64 vssd1 vssd1 vccd1 vccd1 sky130_fd_sc_hd__fill_1
X_0822_ _0086_ _0092_ vssd1 vssd1 vccd1 vccd1 net14 sky130_fd_sc_hd__and2b_1
XFILLER_9_22 vssd1 vssd1 vccd1 vccd1 sky130_fd_sc_hd__fill_1
XFILLER_21_209 vssd1 vssd1 vccd1 vccd1 sky130_fd_sc_hd__fill_1
X_1236_ _0467_ _0454_ _0465_ _0426_ vssd1 vssd1 vccd1 vccd1 _0468_ sky130_fd_sc_hd__and4_1
X_1305_ _0489_ _0503_ net24 vssd1 vssd1 vccd1 vccd1 _0537_ sky130_fd_sc_hd__and3_1
X_1167_ _0339_ _0377_ vssd1 vssd1 vccd1 vccd1 _0399_ sky130_fd_sc_hd__xnor2_2
X_1098_ net127 _0329_ vssd1 vssd1 vccd1 vccd1 _0330_ sky130_fd_sc_hd__xor2_2
XFILLER_20_297 vssd1 vssd1 vccd1 vccd1 sky130_fd_sc_hd__fill_2
XFILLER_18_20 vssd1 vssd1 vccd1 vccd1 sky130_fd_sc_hd__fill_2
XFILLER_18_53 vccd1 vssd1 vccd1 vssd1 sky130_ef_sc_hd__decap_40_12
XFILLER_34_41 vccd1 vssd1 vccd1 vssd1 sky130_ef_sc_hd__decap_40_12
XFILLER_11_242 vssd1 vssd1 vccd1 vccd1 sky130_fd_sc_hd__fill_1
XFILLER_7_257 vccd1 vssd1 vccd1 vssd1 sky130_ef_sc_hd__decap_40_12
XFILLER_7_279 vssd1 vssd1 vccd1 vccd1 sky130_fd_sc_hd__fill_1
XFILLER_38_128 vccd1 vssd1 vccd1 vssd1 sky130_ef_sc_hd__decap_40_12
XFILLER_38_106 vssd1 vssd1 vccd1 vccd1 sky130_fd_sc_hd__fill_1
X_1021_ _0244_ _0247_ _0250_ vssd1 vssd1 vccd1 vccd1 _0253_ sky130_fd_sc_hd__or3b_1
X_0805_ _0068_ STOPWATCH_INST.sync_clear.q _0077_ vssd1 vssd1 vccd1 vccd1 _0078_ sky130_fd_sc_hd__or3_1
XFILLER_44_109 vccd1 vssd1 vccd1 vssd1 sky130_ef_sc_hd__decap_40_12
X_1219_ _0447_ _0450_ _0439_ vssd1 vssd1 vccd1 vccd1 _0451_ sky130_fd_sc_hd__a21o_1
XFILLER_4_227 vccd1 vssd1 vccd1 vssd1 sky130_ef_sc_hd__decap_40_12
Xhold63 STOPWATCH_INST.clock_div.cycles\[5\] vssd1 vssd1 vccd1 vccd1 net181 sky130_fd_sc_hd__dlygate4sd3_1
Xhold41 STOPWATCH_INST.sync_one.sync_2 vssd1 vssd1 vccd1 vccd1 net159 sky130_fd_sc_hd__dlygate4sd3_1
Xhold52 STOPWATCH_INST.digit_scanner.period_counter\[1\] vssd1 vssd1 vccd1 vccd1 net170
+ sky130_fd_sc_hd__dlygate4sd3_1
XFILLER_35_109 vssd1 vssd1 vccd1 vccd1 sky130_fd_sc_hd__fill_2
XFILLER_3_293 vssd1 vssd1 vccd1 vccd1 sky130_fd_sc_hd__fill_4
X_1570_ net36 _0778_ _0779_ net39 STOPWATCH_INST.clock_div.cycles\[29\] vssd1 vssd1
+ vccd1 vccd1 _0054_ sky130_fd_sc_hd__a32o_1
XFILLER_34_197 vssd1 vssd1 vccd1 vccd1 sky130_fd_sc_hd__fill_4
X_1004_ _0168_ _0179_ _0201_ vssd1 vssd1 vccd1 vccd1 _0236_ sky130_fd_sc_hd__and3_4
XFILLER_15_32 vssd1 vssd1 vccd1 vccd1 sky130_fd_sc_hd__fill_4
XFILLER_40_178 vssd1 vssd1 vccd1 vccd1 sky130_fd_sc_hd__fill_1
XFILLER_40_145 vssd1 vssd1 vccd1 vccd1 sky130_fd_sc_hd__fill_1
XFILLER_31_64 vssd1 vssd1 vccd1 vccd1 sky130_fd_sc_hd__fill_4
Xoutput7 net7 vssd1 vssd1 vccd1 vccd1 gpio_out[10] sky130_fd_sc_hd__buf_2
XFILLER_31_167 vssd1 vssd1 vccd1 vccd1 sky130_fd_sc_hd__fill_1
XFILLER_16_131 vssd1 vssd1 vccd1 vccd1 sky130_fd_sc_hd__fill_8
X_1622_ clknet_3_5__leaf_clk _0031_ net57 vssd1 vssd1 vccd1 vccd1 STOPWATCH_INST.clock_div.cycles\[6\]
+ sky130_fd_sc_hd__dfrtp_1
XFILLER_39_201 vccd1 vssd1 vccd1 vssd1 sky130_ef_sc_hd__decap_40_12
X_1484_ _0615_ net16 _0701_ vssd1 vssd1 vccd1 vccd1 _0709_ sky130_fd_sc_hd__and3_1
X_1553_ STOPWATCH_INST.clock_div.cycles\[23\] net136 _0759_ vssd1 vssd1 vccd1 vccd1
+ _0768_ sky130_fd_sc_hd__and3_1
XFILLER_39_278 vssd1 vssd1 vccd1 vccd1 sky130_fd_sc_hd__fill_2
XFILLER_45_237 vccd1 vssd1 vccd1 vssd1 sky130_ef_sc_hd__decap_40_12
XFILLER_9_105 vssd1 vssd1 vccd1 vccd1 sky130_fd_sc_hd__fill_4
XFILLER_13_167 vssd1 vssd1 vccd1 vccd1 sky130_fd_sc_hd__fill_1
Xclkbuf_3_6__f_clk clknet_0_clk vssd1 vssd1 vccd1 vccd1 clknet_3_6__leaf_clk sky130_fd_sc_hd__clkbuf_16
XFILLER_42_85 vccd1 vssd1 vccd1 vssd1 sky130_ef_sc_hd__decap_40_12
XFILLER_42_41 vccd1 vssd1 vccd1 vssd1 sky130_ef_sc_hd__decap_40_12
Xrebuffer8 _0244_ vssd1 vssd1 vccd1 vccd1 net126 sky130_fd_sc_hd__dlygate4sd1_1
X_0984_ net46 _0215_ vssd1 vssd1 vccd1 vccd1 _0216_ sky130_fd_sc_hd__xor2_2
XTAP_TAPCELL_ROW_14_173 vssd1 vccd1 sky130_fd_sc_hd__tapvpwrvgnd_1
X_1605_ clknet_3_0__leaf_clk net176 vssd1 vssd1 vccd1 vccd1 STOPWATCH_INST.digit_scanner.period_counter\[5\]
+ sky130_fd_sc_hd__dfxtp_1
X_1536_ net38 _0752_ _0753_ _0667_ vssd1 vssd1 vccd1 vccd1 _0754_ sky130_fd_sc_hd__a31o_1
X_1467_ _0691_ _0690_ _0694_ vssd1 vssd1 vccd1 vccd1 _0695_ sky130_fd_sc_hd__o21a_1
X_1398_ _0629_ vssd1 vssd1 vccd1 vccd1 _0630_ sky130_fd_sc_hd__inv_2
XTAP_TAPCELL_ROW_37_287 vssd1 vccd1 sky130_fd_sc_hd__tapvpwrvgnd_1
XFILLER_27_237 vssd1 vssd1 vccd1 vccd1 sky130_fd_sc_hd__fill_2
XFILLER_6_108 vssd1 vssd1 vccd1 vccd1 sky130_fd_sc_hd__fill_1
XFILLER_6_119 vssd1 vssd1 vccd1 vccd1 sky130_fd_sc_hd__fill_4
XFILLER_10_137 vssd1 vssd1 vccd1 vccd1 sky130_fd_sc_hd__fill_2
XFILLER_37_30 vccd1 vssd1 vccd1 vssd1 sky130_ef_sc_hd__decap_40_12
XTAP_TAPCELL_ROW_28_243 vssd1 vccd1 sky130_fd_sc_hd__tapvpwrvgnd_1
XFILLER_5_130 vssd1 vssd1 vccd1 vccd1 sky130_fd_sc_hd__fill_4
XTAP_TAPCELL_ROW_11_154 vssd1 vccd1 sky130_fd_sc_hd__tapvpwrvgnd_1
X_1252_ _0483_ vssd1 vssd1 vccd1 vccd1 _0484_ sky130_fd_sc_hd__inv_2
X_1321_ _0520_ _0522_ net24 _0544_ _0518_ vssd1 vssd1 vccd1 vccd1 _0553_ sky130_fd_sc_hd__a41o_1
X_1183_ _0270_ _0332_ _0414_ vssd1 vssd1 vccd1 vccd1 _0415_ sky130_fd_sc_hd__a21o_1
X_0967_ _0181_ _0197_ STOPWATCH_INST.clock_div.cycles\[31\] vssd1 vssd1 vccd1 vccd1
+ _0199_ sky130_fd_sc_hd__o21ai_2
XPHY_EDGE_ROW_12_Right_12 vssd1 vssd1 vccd1 vccd1 sky130_fd_sc_hd__decap_3
X_0898_ _0118_ _0149_ vssd1 vssd1 vccd1 vccd1 _0012_ sky130_fd_sc_hd__nor2_1
X_1519_ _0667_ _0738_ _0737_ vssd1 vssd1 vccd1 vccd1 _0739_ sky130_fd_sc_hd__and3_1
XTAP_TAPCELL_ROW_2_111 vssd1 vccd1 sky130_fd_sc_hd__tapvpwrvgnd_1
XPHY_EDGE_ROW_21_Right_21 vssd1 vssd1 vccd1 vccd1 sky130_fd_sc_hd__decap_3
XTAP_TAPCELL_ROW_25_224 vssd1 vccd1 sky130_fd_sc_hd__tapvpwrvgnd_1
XPHY_EDGE_ROW_30_Right_30 vssd1 vssd1 vccd1 vccd1 sky130_fd_sc_hd__decap_3
XFILLER_2_188 vssd1 vssd1 vccd1 vccd1 sky130_fd_sc_hd__fill_8
XFILLER_2_155 vssd1 vssd1 vccd1 vccd1 sky130_fd_sc_hd__fill_2
XFILLER_0_36 vssd1 vssd1 vccd1 vccd1 sky130_fd_sc_hd__fill_1
X_0821_ _0087_ _0089_ _0090_ _0091_ STOPWATCH_INST.digit_scanner.ctrl vssd1 vssd1
+ vccd1 vccd1 _0092_ sky130_fd_sc_hd__a221o_1
XFILLER_14_251 vssd1 vssd1 vccd1 vccd1 sky130_fd_sc_hd__fill_1
XFILLER_43_3 vccd1 vssd1 vccd1 vssd1 sky130_ef_sc_hd__decap_40_12
X_1304_ _0481_ _0535_ vssd1 vssd1 vccd1 vccd1 _0536_ sky130_fd_sc_hd__xnor2_2
X_1235_ _0447_ _0439_ _0450_ _0433_ vssd1 vssd1 vccd1 vccd1 _0467_ sky130_fd_sc_hd__and4bb_1
X_1166_ _0322_ _0393_ vssd1 vssd1 vccd1 vccd1 _0398_ sky130_fd_sc_hd__xor2_1
X_1097_ _0289_ _0315_ vssd1 vssd1 vccd1 vccd1 _0329_ sky130_fd_sc_hd__nor2_1
XFILLER_34_53 vssd1 vssd1 vccd1 vccd1 sky130_fd_sc_hd__fill_4
XFILLER_7_269 vssd1 vssd1 vccd1 vccd1 sky130_fd_sc_hd__fill_8
X_1020_ _0211_ _0234_ _0251_ vssd1 vssd1 vccd1 vccd1 _0252_ sky130_fd_sc_hd__a21o_1
XFILLER_46_195 vssd1 vssd1 vccd1 vccd1 sky130_fd_sc_hd__fill_1
XPHY_EDGE_ROW_28_Left_75 vssd1 vssd1 vccd1 vccd1 sky130_fd_sc_hd__decap_3
XPHY_EDGE_ROW_12_Left_59 vssd1 vssd1 vccd1 vccd1 sky130_fd_sc_hd__decap_3
X_0804_ STOPWATCH_INST.sync_pause.q STOPWATCH_INST.sync_pause.sync_2 vssd1 vssd1 vccd1
+ vccd1 _0077_ sky130_fd_sc_hd__and2b_1
XFILLER_37_173 vssd1 vssd1 vccd1 vccd1 sky130_fd_sc_hd__fill_2
X_1218_ _0399_ _0440_ vssd1 vssd1 vccd1 vccd1 _0450_ sky130_fd_sc_hd__xor2_1
X_1149_ net49 _0364_ vssd1 vssd1 vccd1 vccd1 _0381_ sky130_fd_sc_hd__xnor2_1
XFILLER_4_239 vccd1 vssd1 vccd1 vssd1 sky130_ef_sc_hd__decap_40_12
Xhold64 STOPWATCH_INST.digit_scanner.period_counter\[6\] vssd1 vssd1 vccd1 vccd1 net182
+ sky130_fd_sc_hd__dlygate4sd3_1
Xhold53 STOPWATCH_INST.clock_div.cycles\[6\] vssd1 vssd1 vccd1 vccd1 net171 sky130_fd_sc_hd__dlygate4sd3_1
Xhold42 STOPWATCH_INST.sync_clear.sync_2 vssd1 vssd1 vccd1 vccd1 net160 sky130_fd_sc_hd__dlygate4sd3_1
XFILLER_43_176 vssd1 vssd1 vccd1 vccd1 sky130_fd_sc_hd__fill_2
XFILLER_3_261 vccd1 vssd1 vccd1 vssd1 sky130_ef_sc_hd__decap_40_12
X_1003_ _0231_ _0233_ vssd1 vssd1 vccd1 vccd1 _0235_ sky130_fd_sc_hd__nor2_1
XPHY_EDGE_ROW_6_Right_6 vssd1 vssd1 vccd1 vccd1 sky130_fd_sc_hd__decap_3
XFILLER_40_124 vssd1 vssd1 vccd1 vccd1 sky130_fd_sc_hd__fill_2
XFILLER_0_253 vssd1 vssd1 vccd1 vccd1 sky130_fd_sc_hd__fill_2
Xoutput8 net8 vssd1 vssd1 vccd1 vccd1 gpio_out[11] sky130_fd_sc_hd__buf_2
Xoutput10 net10 vssd1 vssd1 vccd1 vccd1 gpio_out[13] sky130_fd_sc_hd__buf_2
XFILLER_31_113 vssd1 vssd1 vccd1 vccd1 sky130_fd_sc_hd__fill_2
X_1621_ clknet_3_5__leaf_clk _0030_ net57 vssd1 vssd1 vccd1 vccd1 STOPWATCH_INST.clock_div.cycles\[5\]
+ sky130_fd_sc_hd__dfrtp_1
X_1552_ STOPWATCH_INST.clock_div.cycles\[23\] _0758_ net136 vssd1 vssd1 vccd1 vccd1
+ _0767_ sky130_fd_sc_hd__a21oi_1
XFILLER_39_257 vssd1 vssd1 vccd1 vccd1 sky130_fd_sc_hd__fill_2
XFILLER_39_235 vssd1 vssd1 vccd1 vccd1 sky130_fd_sc_hd__fill_2
XFILLER_39_213 vssd1 vssd1 vccd1 vccd1 sky130_fd_sc_hd__fill_4
X_1483_ _0615_ _0701_ vssd1 vssd1 vccd1 vccd1 _0708_ sky130_fd_sc_hd__nand2_1
XPHY_EDGE_ROW_15_Left_62 vssd1 vssd1 vccd1 vccd1 sky130_fd_sc_hd__decap_3
XFILLER_45_249 vccd1 vssd1 vccd1 vssd1 sky130_ef_sc_hd__decap_40_12
XFILLER_45_205 vccd1 vssd1 vccd1 vssd1 sky130_ef_sc_hd__decap_40_12
XFILLER_42_53 vccd1 vssd1 vccd1 vssd1 sky130_ef_sc_hd__decap_40_12
XFILLER_42_97 vccd1 vssd1 vccd1 vssd1 sky130_ef_sc_hd__decap_40_12
Xrebuffer9 _0288_ vssd1 vssd1 vccd1 vccd1 net127 sky130_fd_sc_hd__dlygate4sd1_1
XFILLER_3_47 vssd1 vssd1 vccd1 vccd1 sky130_fd_sc_hd__fill_1
XFILLER_36_216 vssd1 vssd1 vccd1 vccd1 sky130_fd_sc_hd__fill_4
X_0983_ _0199_ _0207_ net47 vssd1 vssd1 vccd1 vccd1 _0215_ sky130_fd_sc_hd__a21o_1
X_1604_ clknet_3_0__leaf_clk _0013_ vssd1 vssd1 vccd1 vccd1 STOPWATCH_INST.digit_scanner.period_counter\[4\]
+ sky130_fd_sc_hd__dfxtp_1
X_1535_ net44 _0747_ vssd1 vssd1 vccd1 vccd1 _0753_ sky130_fd_sc_hd__nand2_1
X_1466_ _0692_ _0693_ net34 vssd1 vssd1 vccd1 vccd1 _0694_ sky130_fd_sc_hd__o21ai_1
X_1397_ _0621_ _0628_ vssd1 vssd1 vccd1 vccd1 _0629_ sky130_fd_sc_hd__and2_1
XTAP_TAPCELL_ROW_37_288 vssd1 vccd1 sky130_fd_sc_hd__tapvpwrvgnd_1
XFILLER_10_105 vssd1 vssd1 vccd1 vccd1 sky130_fd_sc_hd__fill_2
XFILLER_10_149 vssd1 vssd1 vccd1 vccd1 sky130_fd_sc_hd__fill_2
XTAP_TAPCELL_ROW_20_199 vssd1 vccd1 sky130_fd_sc_hd__tapvpwrvgnd_1
XPHY_EDGE_ROW_0_Left_47 vssd1 vssd1 vccd1 vccd1 sky130_fd_sc_hd__decap_3
XFILLER_37_97 vssd1 vssd1 vccd1 vccd1 sky130_fd_sc_hd__fill_2
XFILLER_37_42 vccd1 vssd1 vccd1 vssd1 sky130_ef_sc_hd__decap_40_12
XFILLER_26_282 vssd1 vssd1 vccd1 vccd1 sky130_fd_sc_hd__fill_1
XTAP_TAPCELL_ROW_11_155 vssd1 vccd1 sky130_fd_sc_hd__tapvpwrvgnd_1
X_1320_ _0550_ _0551_ vssd1 vssd1 vccd1 vccd1 _0552_ sky130_fd_sc_hd__or2_1
XFILLER_5_120 vssd1 vssd1 vccd1 vccd1 sky130_fd_sc_hd__fill_2
X_1251_ _0424_ _0479_ vssd1 vssd1 vccd1 vccd1 _0483_ sky130_fd_sc_hd__xor2_4
X_1182_ _0333_ _0335_ net125 _0405_ vssd1 vssd1 vccd1 vccd1 _0414_ sky130_fd_sc_hd__and4_1
XTAP_TAPCELL_ROW_34_269 vssd1 vccd1 sky130_fd_sc_hd__tapvpwrvgnd_1
XPHY_EDGE_ROW_42_Left_89 vssd1 vssd1 vccd1 vccd1 sky130_fd_sc_hd__decap_3
XFILLER_32_296 vssd1 vssd1 vccd1 vccd1 sky130_fd_sc_hd__fill_2
X_0897_ net165 _0117_ vssd1 vssd1 vccd1 vccd1 _0149_ sky130_fd_sc_hd__nor2_1
X_0966_ _0181_ _0197_ STOPWATCH_INST.clock_div.cycles\[31\] vssd1 vssd1 vccd1 vccd1
+ _0198_ sky130_fd_sc_hd__o21a_2
X_1449_ STOPWATCH_INST.clock_div.cycles\[9\] _0673_ vssd1 vssd1 vccd1 vccd1 _0679_
+ sky130_fd_sc_hd__and2_1
X_1518_ _0629_ _0637_ net18 vssd1 vssd1 vccd1 vccd1 _0738_ sky130_fd_sc_hd__or3b_4
XTAP_TAPCELL_ROW_2_112 vssd1 vccd1 sky130_fd_sc_hd__tapvpwrvgnd_1
XFILLER_23_88 vssd1 vssd1 vccd1 vccd1 sky130_fd_sc_hd__fill_2
XTAP_TAPCELL_ROW_25_225 vssd1 vccd1 sky130_fd_sc_hd__tapvpwrvgnd_1
XFILLER_2_145 vssd1 vssd1 vccd1 vccd1 sky130_fd_sc_hd__fill_2
XFILLER_2_134 vssd1 vssd1 vccd1 vccd1 sky130_fd_sc_hd__fill_4
X_0820_ STOPWATCH_INST.bcd_num\[3\] STOPWATCH_INST.bcd_num\[2\] vssd1 vssd1 vccd1
+ vccd1 _0091_ sky130_fd_sc_hd__and2b_1
XFILLER_9_57 vccd1 vssd1 vccd1 vssd1 sky130_ef_sc_hd__decap_40_12
X_1303_ _0483_ _0532_ net129 vssd1 vssd1 vccd1 vccd1 _0535_ sky130_fd_sc_hd__o21a_1
X_1165_ _0322_ _0393_ vssd1 vssd1 vccd1 vccd1 _0397_ sky130_fd_sc_hd__xnor2_1
X_1234_ _0454_ _0465_ vssd1 vssd1 vccd1 vccd1 _0466_ sky130_fd_sc_hd__and2_1
X_1096_ net30 net31 STOPWATCH_INST.clock_div.cycles\[13\] _0286_ vssd1 vssd1 vccd1
+ vccd1 _0328_ sky130_fd_sc_hd__o2bb2a_1
XTAP_TAPCELL_ROW_30_250 vssd1 vccd1 sky130_fd_sc_hd__tapvpwrvgnd_1
X_0949_ _0186_ _0187_ vssd1 vssd1 vccd1 vccd1 _0025_ sky130_fd_sc_hd__nor2_1
XFILLER_11_222 vssd1 vssd1 vccd1 vccd1 sky130_fd_sc_hd__fill_2
XFILLER_46_141 vccd1 vssd1 vccd1 vssd1 sky130_ef_sc_hd__decap_40_12
XPHY_EDGE_ROW_3_Left_50 vssd1 vssd1 vccd1 vccd1 sky130_fd_sc_hd__decap_3
XTAP_TAPCELL_ROW_44_320 vssd1 vccd1 sky130_fd_sc_hd__tapvpwrvgnd_1
X_0803_ _0072_ _0075_ _0069_ vssd1 vssd1 vccd1 vccd1 _0076_ sky130_fd_sc_hd__a21oi_1
XFILLER_37_185 vssd1 vssd1 vccd1 vccd1 sky130_fd_sc_hd__fill_4
X_1217_ _0399_ _0440_ vssd1 vssd1 vccd1 vccd1 _0449_ sky130_fd_sc_hd__xnor2_1
X_1148_ _0362_ _0360_ _0351_ net49 vssd1 vssd1 vccd1 vccd1 _0380_ sky130_fd_sc_hd__a31o_4
X_1079_ _0241_ _0306_ vssd1 vssd1 vccd1 vccd1 _0311_ sky130_fd_sc_hd__xor2_1
XPHY_EDGE_ROW_45_Left_92 vssd1 vssd1 vccd1 vccd1 sky130_fd_sc_hd__decap_3
Xhold65 STOPWATCH_INST.digit_scanner.period_counter\[8\] vssd1 vssd1 vccd1 vccd1 net183
+ sky130_fd_sc_hd__dlygate4sd3_1
Xhold54 STOPWATCH_INST.digit_scanner.period_counter\[13\] vssd1 vssd1 vccd1 vccd1
+ net172 sky130_fd_sc_hd__dlygate4sd3_1
Xhold43 STOPWATCH_INST.digit_scanner.period_counter\[0\] vssd1 vssd1 vccd1 vccd1 net161
+ sky130_fd_sc_hd__dlygate4sd3_1
XFILLER_45_53 vssd1 vssd1 vccd1 vccd1 sky130_fd_sc_hd__fill_2
XFILLER_43_111 vssd1 vssd1 vccd1 vccd1 sky130_fd_sc_hd__fill_1
XFILLER_3_273 vssd1 vssd1 vccd1 vccd1 sky130_fd_sc_hd__fill_4
Xrebuffer19 _0327_ vssd1 vssd1 vccd1 vccd1 net137 sky130_fd_sc_hd__dlymetal6s4s_1
X_1002_ _0224_ _0226_ _0228_ _0230_ _0233_ vssd1 vssd1 vccd1 vccd1 _0234_ sky130_fd_sc_hd__a41o_1
XFILLER_25_133 vssd1 vssd1 vccd1 vccd1 sky130_fd_sc_hd__fill_4
XFILLER_25_177 vssd1 vssd1 vccd1 vccd1 sky130_fd_sc_hd__fill_2
XFILLER_25_188 vssd1 vssd1 vccd1 vccd1 sky130_fd_sc_hd__fill_4
XFILLER_31_55 vssd1 vssd1 vccd1 vccd1 sky130_fd_sc_hd__fill_1
Xoutput9 net9 vssd1 vssd1 vccd1 vccd1 gpio_out[12] sky130_fd_sc_hd__buf_2
Xoutput11 net11 vssd1 vssd1 vccd1 vccd1 gpio_out[14] sky130_fd_sc_hd__buf_2
XANTENNA_clkbuf_3_1__f_clk_A clknet_0_clk vssd1 vssd1 vccd1 vccd1 sky130_fd_sc_hd__diode_2
XFILLER_16_122 vssd1 vssd1 vccd1 vccd1 sky130_fd_sc_hd__fill_1
XFILLER_31_103 vssd1 vssd1 vccd1 vccd1 sky130_fd_sc_hd__fill_2
X_1620_ clknet_3_5__leaf_clk _0029_ net57 vssd1 vssd1 vccd1 vccd1 STOPWATCH_INST.clock_div.cycles\[4\]
+ sky130_fd_sc_hd__dfrtp_1
X_1551_ net38 _0763_ _0766_ net39 STOPWATCH_INST.clock_div.cycles\[23\] vssd1 vssd1
+ vccd1 vccd1 _0048_ sky130_fd_sc_hd__a32o_1
X_1482_ _0614_ net16 _0701_ _0612_ vssd1 vssd1 vccd1 vccd1 _0707_ sky130_fd_sc_hd__a31o_1
XFILLER_22_158 vssd1 vssd1 vccd1 vccd1 sky130_fd_sc_hd__fill_4
XFILLER_30_180 vssd1 vssd1 vccd1 vccd1 sky130_fd_sc_hd__fill_4
XFILLER_45_217 vssd1 vssd1 vccd1 vccd1 sky130_fd_sc_hd__fill_4
XFILLER_38_280 vccd1 vssd1 vccd1 vssd1 sky130_ef_sc_hd__decap_40_12
XFILLER_26_66 vssd1 vssd1 vccd1 vccd1 sky130_fd_sc_hd__fill_2
XFILLER_42_65 vccd1 vssd1 vccd1 vssd1 sky130_ef_sc_hd__decap_40_12
XTAP_TAPCELL_ROW_8_140 vssd1 vccd1 sky130_fd_sc_hd__tapvpwrvgnd_1
XFILLER_44_250 vssd1 vssd1 vccd1 vccd1 sky130_fd_sc_hd__fill_2
XFILLER_36_228 vssd1 vssd1 vccd1 vccd1 sky130_fd_sc_hd__fill_4
X_0982_ net45 _0213_ vssd1 vssd1 vccd1 vccd1 _0214_ sky130_fd_sc_hd__xnor2_2
XFILLER_8_195 vssd1 vssd1 vccd1 vccd1 sky130_fd_sc_hd__fill_1
X_1603_ clknet_3_2__leaf_clk _0012_ vssd1 vssd1 vccd1 vccd1 STOPWATCH_INST.digit_scanner.period_counter\[3\]
+ sky130_fd_sc_hd__dfxtp_1
X_1465_ _0061_ _0686_ vssd1 vssd1 vccd1 vccd1 _0693_ sky130_fd_sc_hd__and2_1
X_1534_ net44 _0747_ vssd1 vssd1 vccd1 vccd1 _0752_ sky130_fd_sc_hd__or2_1
XFILLER_27_239 vssd1 vssd1 vccd1 vccd1 sky130_fd_sc_hd__fill_1
X_1396_ _0547_ _0624_ _0627_ vssd1 vssd1 vccd1 vccd1 _0628_ sky130_fd_sc_hd__and3_1
XFILLER_35_272 vssd1 vssd1 vccd1 vccd1 sky130_fd_sc_hd__fill_2
XFILLER_10_139 vssd1 vssd1 vccd1 vccd1 sky130_fd_sc_hd__fill_1
XFILLER_37_87 vssd1 vssd1 vccd1 vccd1 sky130_fd_sc_hd__fill_4
XFILLER_37_54 vssd1 vssd1 vccd1 vccd1 sky130_fd_sc_hd__fill_2
XFILLER_26_294 vssd1 vssd1 vccd1 vccd1 sky130_fd_sc_hd__fill_2
XFILLER_26_250 vssd1 vssd1 vccd1 vccd1 sky130_fd_sc_hd__fill_2
XFILLER_18_228 vssd1 vssd1 vccd1 vccd1 sky130_fd_sc_hd__fill_8
XFILLER_41_297 vssd1 vssd1 vccd1 vccd1 sky130_fd_sc_hd__fill_2
XTAP_TAPCELL_ROW_11_156 vssd1 vccd1 sky130_fd_sc_hd__tapvpwrvgnd_1
X_1250_ _0472_ _0478_ _0474_ vssd1 vssd1 vccd1 vccd1 _0482_ sky130_fd_sc_hd__a21o_1
X_1181_ _0366_ _0412_ vssd1 vssd1 vccd1 vccd1 _0413_ sky130_fd_sc_hd__or2_2
XFILLER_32_264 vccd1 vssd1 vccd1 vssd1 sky130_ef_sc_hd__decap_40_12
XFILLER_32_253 vssd1 vssd1 vccd1 vccd1 sky130_fd_sc_hd__fill_4
XFILLER_32_220 vssd1 vssd1 vccd1 vccd1 sky130_fd_sc_hd__fill_4
XFILLER_17_250 vssd1 vssd1 vccd1 vccd1 sky130_fd_sc_hd__fill_8
X_0896_ _0117_ net163 vssd1 vssd1 vccd1 vccd1 _0011_ sky130_fd_sc_hd__nor2_1
X_0965_ net43 net42 STOPWATCH_INST.clock_div.cycles\[26\] STOPWATCH_INST.clock_div.cycles\[27\]
+ STOPWATCH_INST.clock_div.cycles\[28\] vssd1 vssd1 vccd1 vccd1 _0197_ sky130_fd_sc_hd__o311a_1
XFILLER_4_91 vssd1 vssd1 vccd1 vccd1 sky130_fd_sc_hd__fill_4
XTAP_TAPCELL_ROW_2_113 vssd1 vccd1 sky130_fd_sc_hd__tapvpwrvgnd_1
X_1448_ _0676_ _0677_ vssd1 vssd1 vccd1 vccd1 _0678_ sky130_fd_sc_hd__nor2_1
X_1517_ _0630_ net135 _0638_ vssd1 vssd1 vccd1 vccd1 _0737_ sky130_fd_sc_hd__a21o_1
X_1379_ _0585_ _0596_ _0589_ _0569_ vssd1 vssd1 vccd1 vccd1 _0611_ sky130_fd_sc_hd__a211o_1
XTAP_TAPCELL_ROW_25_226 vssd1 vccd1 sky130_fd_sc_hd__tapvpwrvgnd_1
XFILLER_23_275 vssd1 vssd1 vccd1 vccd1 sky130_fd_sc_hd__fill_2
XFILLER_23_297 vssd1 vssd1 vccd1 vccd1 sky130_fd_sc_hd__fill_2
XFILLER_2_168 vccd1 vssd1 vccd1 vssd1 sky130_ef_sc_hd__decap_40_12
XFILLER_2_157 vssd1 vssd1 vccd1 vccd1 sky130_fd_sc_hd__fill_1
XFILLER_0_27 vssd1 vssd1 vccd1 vccd1 sky130_fd_sc_hd__fill_1
XFILLER_14_253 vccd1 vssd1 vccd1 vssd1 sky130_ef_sc_hd__decap_40_12
X_1302_ _0533_ _0532_ _0485_ vssd1 vssd1 vccd1 vccd1 _0534_ sky130_fd_sc_hd__a21bo_4
X_1233_ _0460_ _0463_ _0464_ vssd1 vssd1 vccd1 vccd1 _0465_ sky130_fd_sc_hd__a21o_1
XFILLER_29_3 vccd1 vssd1 vccd1 vssd1 sky130_ef_sc_hd__decap_40_12
X_1095_ _0326_ _0322_ vssd1 vssd1 vccd1 vccd1 _0327_ sky130_fd_sc_hd__or2_4
X_1164_ _0391_ _0389_ _0388_ _0395_ vssd1 vssd1 vccd1 vccd1 _0396_ sky130_fd_sc_hd__a31o_4
XTAP_TAPCELL_ROW_30_251 vssd1 vccd1 sky130_fd_sc_hd__tapvpwrvgnd_1
X_0948_ _0071_ net35 net180 vssd1 vssd1 vccd1 vccd1 _0187_ sky130_fd_sc_hd__a21oi_1
X_0879_ net52 _0136_ vssd1 vssd1 vccd1 vccd1 _0137_ sky130_fd_sc_hd__or2_1
XFILLER_34_66 vssd1 vssd1 vccd1 vccd1 sky130_fd_sc_hd__fill_8
XFILLER_11_234 vssd1 vssd1 vccd1 vccd1 sky130_fd_sc_hd__fill_8
XFILLER_11_278 vssd1 vssd1 vccd1 vccd1 sky130_fd_sc_hd__fill_2
XFILLER_46_197 vccd1 vssd1 vccd1 vssd1 sky130_ef_sc_hd__decap_40_12
XFILLER_46_153 vccd1 vssd1 vccd1 vssd1 sky130_ef_sc_hd__decap_40_12
XTAP_TAPCELL_ROW_44_321 vssd1 vccd1 sky130_fd_sc_hd__tapvpwrvgnd_1
X_0802_ STOPWATCH_INST.fsm_inst1.currentState\[1\] STOPWATCH_INST.fsm_inst1.currentState\[0\]
+ _0073_ vssd1 vssd1 vccd1 vccd1 _0075_ sky130_fd_sc_hd__or3_1
XFILLER_6_293 vssd1 vssd1 vccd1 vccd1 sky130_fd_sc_hd__fill_2
X_1216_ _0447_ vssd1 vssd1 vccd1 vccd1 _0448_ sky130_fd_sc_hd__inv_2
X_1147_ _0341_ _0377_ _0378_ vssd1 vssd1 vccd1 vccd1 _0379_ sky130_fd_sc_hd__o21a_1
X_1078_ _0303_ _0309_ vssd1 vssd1 vccd1 vccd1 _0310_ sky130_fd_sc_hd__nand2_1
XFILLER_45_21 vccd1 vssd1 vccd1 vssd1 sky130_ef_sc_hd__decap_40_12
XFILLER_29_55 vssd1 vssd1 vccd1 vccd1 sky130_fd_sc_hd__fill_1
XFILLER_28_197 vssd1 vssd1 vccd1 vccd1 sky130_fd_sc_hd__fill_4
Xhold55 STOPWATCH_INST.digit_scanner.period_counter\[7\] vssd1 vssd1 vccd1 vccd1 net173
+ sky130_fd_sc_hd__dlygate4sd3_1
Xhold66 STOPWATCH_INST.digit_scanner.period_counter\[10\] vssd1 vssd1 vccd1 vccd1
+ net184 sky130_fd_sc_hd__dlygate4sd3_1
Xhold44 STOPWATCH_INST.digit_scanner.period_counter\[2\] vssd1 vssd1 vccd1 vccd1 net162
+ sky130_fd_sc_hd__dlygate4sd3_1
XFILLER_43_189 vssd1 vssd1 vccd1 vccd1 sky130_fd_sc_hd__fill_1
XFILLER_43_156 vccd1 vssd1 vccd1 vssd1 sky130_ef_sc_hd__decap_40_12
X_1001_ _0166_ _0208_ _0209_ _0232_ vssd1 vssd1 vccd1 vccd1 _0233_ sky130_fd_sc_hd__o31a_1
XFILLER_15_13 vccd1 vssd1 vccd1 vssd1 sky130_ef_sc_hd__decap_40_12
XFILLER_15_57 vssd1 vssd1 vccd1 vccd1 sky130_fd_sc_hd__fill_1
XFILLER_15_68 vssd1 vssd1 vccd1 vccd1 sky130_fd_sc_hd__fill_2
XFILLER_25_167 vssd1 vssd1 vccd1 vccd1 sky130_fd_sc_hd__fill_1
Xoutput12 net12 vssd1 vssd1 vccd1 vccd1 gpio_out[4] sky130_fd_sc_hd__buf_2
XFILLER_0_233 vssd1 vssd1 vccd1 vccd1 sky130_fd_sc_hd__fill_1
XFILLER_16_145 vssd1 vssd1 vccd1 vccd1 sky130_fd_sc_hd__fill_2
X_1481_ net37 _0703_ _0706_ net41 net48 vssd1 vssd1 vccd1 vccd1 _0038_ sky130_fd_sc_hd__a32o_1
X_1550_ _0764_ _0765_ _0185_ vssd1 vssd1 vccd1 vccd1 _0766_ sky130_fd_sc_hd__a21o_1
XFILLER_39_237 vssd1 vssd1 vccd1 vccd1 sky130_fd_sc_hd__fill_1
XTAP_TAPCELL_ROW_17_184 vssd1 vccd1 sky130_fd_sc_hd__tapvpwrvgnd_1
XFILLER_38_292 vssd1 vssd1 vccd1 vccd1 sky130_fd_sc_hd__fill_4
XFILLER_13_104 vssd1 vssd1 vccd1 vccd1 sky130_fd_sc_hd__fill_8
XFILLER_42_77 vssd1 vssd1 vccd1 vccd1 sky130_fd_sc_hd__fill_4
XTAP_TAPCELL_ROW_8_141 vssd1 vccd1 sky130_fd_sc_hd__tapvpwrvgnd_1
XFILLER_29_281 vssd1 vssd1 vccd1 vccd1 sky130_fd_sc_hd__fill_1
X_0981_ _0199_ _0207_ _0200_ vssd1 vssd1 vccd1 vccd1 _0213_ sky130_fd_sc_hd__a21oi_1
XFILLER_8_141 vssd1 vssd1 vccd1 vccd1 sky130_fd_sc_hd__fill_2
X_1602_ clknet_3_2__leaf_clk _0011_ vssd1 vssd1 vccd1 vccd1 STOPWATCH_INST.digit_scanner.period_counter\[2\]
+ sky130_fd_sc_hd__dfxtp_1
X_1395_ _0625_ _0626_ vssd1 vssd1 vccd1 vccd1 _0627_ sky130_fd_sc_hd__nor2_1
X_1464_ _0061_ _0686_ vssd1 vssd1 vccd1 vccd1 _0692_ sky130_fd_sc_hd__nor2_1
X_1533_ net34 _0750_ _0749_ vssd1 vssd1 vccd1 vccd1 _0751_ sky130_fd_sc_hd__or3_4
XFILLER_10_107 vssd1 vssd1 vccd1 vccd1 sky130_fd_sc_hd__fill_1
XTAP_TAPCELL_ROW_11_157 vssd1 vccd1 sky130_fd_sc_hd__tapvpwrvgnd_1
XFILLER_45_9 vccd1 vssd1 vccd1 vssd1 sky130_ef_sc_hd__decap_40_12
X_1180_ _0320_ _0365_ vssd1 vssd1 vccd1 vccd1 _0412_ sky130_fd_sc_hd__and2_1
XFILLER_32_298 vssd1 vssd1 vccd1 vccd1 sky130_fd_sc_hd__fill_1
X_0964_ STOPWATCH_INST.clock_div.cycles\[27\] STOPWATCH_INST.clock_div.cycles\[28\]
+ vssd1 vssd1 vccd1 vccd1 _0196_ sky130_fd_sc_hd__nand2_2
X_0895_ STOPWATCH_INST.digit_scanner.period_counter\[1\] STOPWATCH_INST.digit_scanner.period_counter\[0\]
+ net162 vssd1 vssd1 vccd1 vccd1 _0148_ sky130_fd_sc_hd__a21oi_1
X_1516_ _0733_ net38 _0736_ net40 STOPWATCH_INST.clock_div.cycles\[18\] vssd1 vssd1
+ vccd1 vccd1 _0043_ sky130_fd_sc_hd__a32o_1
X_1447_ _0601_ _0606_ net17 vssd1 vssd1 vccd1 vccd1 _0677_ sky130_fd_sc_hd__and3_1
X_1378_ net119 _0596_ _0589_ vssd1 vssd1 vccd1 vccd1 _0610_ sky130_fd_sc_hd__a21oi_1
XFILLER_23_210 vssd1 vssd1 vccd1 vccd1 sky130_fd_sc_hd__fill_1
XFILLER_23_243 vssd1 vssd1 vccd1 vccd1 sky130_fd_sc_hd__fill_1
XTAP_TAPCELL_ROW_25_227 vssd1 vccd1 sky130_fd_sc_hd__tapvpwrvgnd_1
XFILLER_14_265 vccd1 vssd1 vccd1 vssd1 sky130_ef_sc_hd__decap_40_12
X_1301_ _0419_ _0483_ vssd1 vssd1 vccd1 vccd1 _0533_ sky130_fd_sc_hd__nor2_1
X_1232_ _0387_ _0458_ _0459_ _0385_ vssd1 vssd1 vccd1 vccd1 _0464_ sky130_fd_sc_hd__o22a_1
X_1094_ _0325_ _0280_ vssd1 vssd1 vccd1 vccd1 _0326_ sky130_fd_sc_hd__xnor2_2
X_1163_ _0393_ _0394_ _0330_ _0363_ vssd1 vssd1 vccd1 vccd1 _0395_ sky130_fd_sc_hd__a2bb2o_1
XTAP_TAPCELL_ROW_30_252 vssd1 vccd1 sky130_fd_sc_hd__tapvpwrvgnd_1
X_0947_ STOPWATCH_INST.clock_div.cycles\[0\] _0071_ net35 vssd1 vssd1 vccd1 vccd1
+ _0186_ sky130_fd_sc_hd__and3_1
XFILLER_20_224 vssd1 vssd1 vccd1 vccd1 sky130_fd_sc_hd__fill_1
X_0878_ _0136_ _0124_ _0133_ vssd1 vssd1 vccd1 vccd1 _0004_ sky130_fd_sc_hd__and3b_1
XFILLER_18_13 vssd1 vssd1 vccd1 vccd1 sky130_fd_sc_hd__fill_1
XFILLER_11_202 vssd1 vssd1 vccd1 vccd1 sky130_fd_sc_hd__fill_4
XFILLER_11_213 vssd1 vssd1 vccd1 vccd1 sky130_fd_sc_hd__fill_2
XFILLER_11_246 vssd1 vssd1 vccd1 vccd1 sky130_fd_sc_hd__fill_1
Xclkload0 clknet_3_0__leaf_clk vssd1 vssd1 vccd1 vccd1 clkload0/X sky130_fd_sc_hd__clkbuf_8
XFILLER_46_165 vssd1 vssd1 vccd1 vccd1 sky130_fd_sc_hd__fill_2
XTAP_TAPCELL_ROW_44_322 vssd1 vccd1 sky130_fd_sc_hd__tapvpwrvgnd_1
X_0801_ STOPWATCH_INST.fsm_inst1.currentState\[1\] STOPWATCH_INST.fsm_inst1.currentState\[0\]
+ vssd1 vssd1 vccd1 vccd1 _0074_ sky130_fd_sc_hd__nor2_1
XFILLER_37_165 vssd1 vssd1 vccd1 vccd1 sky130_fd_sc_hd__fill_2
XFILLER_37_143 vssd1 vssd1 vccd1 vccd1 sky130_fd_sc_hd__fill_2
XFILLER_37_110 vssd1 vssd1 vccd1 vccd1 sky130_fd_sc_hd__fill_2
X_1146_ _0339_ _0377_ _0337_ vssd1 vssd1 vccd1 vccd1 _0378_ sky130_fd_sc_hd__o21ai_1
X_1215_ _0440_ _0444_ _0441_ _0445_ vssd1 vssd1 vccd1 vccd1 _0447_ sky130_fd_sc_hd__or4_4
X_1077_ _0307_ _0308_ vssd1 vssd1 vccd1 vccd1 _0309_ sky130_fd_sc_hd__and2b_1
Xhold56 STOPWATCH_INST.digit_scanner.period_counter\[11\] vssd1 vssd1 vccd1 vccd1
+ net174 sky130_fd_sc_hd__dlygate4sd3_1
Xhold45 _0148_ vssd1 vssd1 vccd1 vccd1 net163 sky130_fd_sc_hd__dlygate4sd3_1
XFILLER_45_55 vssd1 vssd1 vccd1 vccd1 sky130_fd_sc_hd__fill_1
XFILLER_45_33 vccd1 vssd1 vccd1 vssd1 sky130_ef_sc_hd__decap_40_12
XFILLER_43_113 vccd1 vssd1 vccd1 vssd1 sky130_ef_sc_hd__decap_40_12
XFILLER_28_176 vssd1 vssd1 vccd1 vccd1 sky130_fd_sc_hd__fill_4
XFILLER_3_297 vssd1 vssd1 vccd1 vccd1 sky130_fd_sc_hd__fill_2
XFILLER_19_110 vssd1 vssd1 vccd1 vccd1 sky130_fd_sc_hd__fill_2
X_1000_ net44 _0208_ _0209_ STOPWATCH_INST.clock_div.cycles\[22\] vssd1 vssd1 vccd1
+ vccd1 _0232_ sky130_fd_sc_hd__o31ai_1
XFILLER_34_102 vccd1 vssd1 vccd1 vssd1 sky130_ef_sc_hd__decap_40_12
XANTENNA_clkbuf_0_clk_A clk vssd1 vssd1 vccd1 vccd1 sky130_fd_sc_hd__diode_2
X_1129_ _0354_ _0357_ _0358_ vssd1 vssd1 vccd1 vccd1 _0361_ sky130_fd_sc_hd__or3b_1
XFILLER_25_113 vssd1 vssd1 vccd1 vccd1 sky130_fd_sc_hd__fill_4
XFILLER_40_149 vssd1 vssd1 vccd1 vccd1 sky130_fd_sc_hd__fill_8
XFILLER_15_25 vssd1 vssd1 vccd1 vccd1 sky130_fd_sc_hd__fill_4
XFILLER_25_179 vssd1 vssd1 vccd1 vccd1 sky130_fd_sc_hd__fill_1
XFILLER_31_57 vssd1 vssd1 vccd1 vccd1 sky130_fd_sc_hd__fill_1
Xoutput13 net13 vssd1 vssd1 vccd1 vccd1 gpio_out[5] sky130_fd_sc_hd__buf_2
XFILLER_0_289 vssd1 vssd1 vccd1 vccd1 sky130_fd_sc_hd__fill_1
XFILLER_0_278 vssd1 vssd1 vccd1 vccd1 sky130_fd_sc_hd__fill_2
XFILLER_0_245 vssd1 vssd1 vccd1 vccd1 sky130_fd_sc_hd__fill_2
XFILLER_0_223 vssd1 vssd1 vccd1 vccd1 sky130_fd_sc_hd__fill_1
XPHY_EDGE_ROW_19_Right_19 vssd1 vssd1 vccd1 vccd1 sky130_fd_sc_hd__decap_3
XFILLER_24_190 vssd1 vssd1 vccd1 vccd1 sky130_fd_sc_hd__fill_4
Xclkbuf_3_1__f_clk clknet_0_clk vssd1 vssd1 vccd1 vccd1 clknet_3_1__leaf_clk sky130_fd_sc_hd__clkbuf_16
XPHY_EDGE_ROW_28_Right_28 vssd1 vssd1 vccd1 vccd1 sky130_fd_sc_hd__decap_3
X_1480_ _0704_ _0705_ _0185_ vssd1 vssd1 vccd1 vccd1 _0706_ sky130_fd_sc_hd__a21o_1
XPHY_EDGE_ROW_37_Right_37 vssd1 vssd1 vccd1 vccd1 sky130_fd_sc_hd__decap_3
XTAP_TAPCELL_ROW_17_185 vssd1 vccd1 sky130_fd_sc_hd__tapvpwrvgnd_1
XFILLER_22_138 vssd1 vssd1 vccd1 vccd1 sky130_fd_sc_hd__fill_2
XPHY_EDGE_ROW_46_Right_46 vssd1 vssd1 vccd1 vccd1 sky130_fd_sc_hd__decap_3
XFILLER_26_68 vssd1 vssd1 vccd1 vccd1 sky130_fd_sc_hd__fill_1
XTAP_TAPCELL_ROW_8_142 vssd1 vccd1 sky130_fd_sc_hd__tapvpwrvgnd_1
XFILLER_44_230 vccd1 vssd1 vccd1 vssd1 sky130_ef_sc_hd__decap_40_12
X_0980_ _0211_ vssd1 vssd1 vccd1 vccd1 _0212_ sky130_fd_sc_hd__inv_2
XFILLER_12_171 vssd1 vssd1 vccd1 vccd1 sky130_fd_sc_hd__fill_1
XFILLER_8_131 vssd1 vssd1 vccd1 vccd1 sky130_fd_sc_hd__fill_2
XFILLER_8_197 vssd1 vssd1 vccd1 vccd1 sky130_fd_sc_hd__fill_1
X_1532_ _0639_ net18 _0644_ vssd1 vssd1 vccd1 vccd1 _0750_ sky130_fd_sc_hd__and3_1
X_1601_ clknet_3_2__leaf_clk _0010_ vssd1 vssd1 vccd1 vccd1 STOPWATCH_INST.digit_scanner.period_counter\[1\]
+ sky130_fd_sc_hd__dfxtp_1
X_1394_ _0597_ _0622_ _0543_ vssd1 vssd1 vccd1 vccd1 _0626_ sky130_fd_sc_hd__a21oi_1
X_1463_ _0607_ _0608_ net19 net36 vssd1 vssd1 vccd1 vccd1 _0691_ sky130_fd_sc_hd__a31o_1
XFILLER_35_296 vssd1 vssd1 vccd1 vccd1 sky130_fd_sc_hd__fill_2
XPHY_EDGE_ROW_19_Left_66 vssd1 vssd1 vccd1 vccd1 sky130_fd_sc_hd__decap_3
XFILLER_12_15 vssd1 vssd1 vccd1 vccd1 sky130_fd_sc_hd__fill_4
XFILLER_41_222 vssd1 vssd1 vccd1 vccd1 sky130_fd_sc_hd__fill_2
XTAP_TAPCELL_ROW_36_280 vssd1 vccd1 sky130_fd_sc_hd__tapvpwrvgnd_1
XFILLER_5_167 vssd1 vssd1 vccd1 vccd1 sky130_fd_sc_hd__fill_1
XFILLER_5_145 vssd1 vssd1 vccd1 vccd1 sky130_fd_sc_hd__fill_2
XFILLER_5_134 vssd1 vssd1 vccd1 vccd1 sky130_fd_sc_hd__fill_1
XTAP_TAPCELL_ROW_11_158 vssd1 vccd1 sky130_fd_sc_hd__tapvpwrvgnd_1
XFILLER_32_288 vssd1 vssd1 vccd1 vccd1 sky130_fd_sc_hd__fill_8
X_0963_ net171 _0194_ vssd1 vssd1 vccd1 vccd1 _0031_ sky130_fd_sc_hd__xor2_1
X_0894_ net170 net161 vssd1 vssd1 vccd1 vccd1 _0010_ sky130_fd_sc_hd__xor2_1
X_1515_ _0734_ _0735_ net35 vssd1 vssd1 vccd1 vccd1 _0736_ sky130_fd_sc_hd__o21ai_1
XFILLER_4_82 vssd1 vssd1 vccd1 vccd1 sky130_fd_sc_hd__fill_2
X_1446_ _0601_ net17 _0606_ vssd1 vssd1 vccd1 vccd1 _0676_ sky130_fd_sc_hd__a21oi_1
X_1377_ _0605_ _0604_ _0600_ _0608_ vssd1 vssd1 vccd1 vccd1 _0609_ sky130_fd_sc_hd__o31a_1
XFILLER_23_200 vssd1 vssd1 vccd1 vccd1 sky130_fd_sc_hd__fill_8
XFILLER_23_222 vssd1 vssd1 vccd1 vccd1 sky130_fd_sc_hd__fill_2
XTAP_TAPCELL_ROW_25_228 vssd1 vccd1 sky130_fd_sc_hd__tapvpwrvgnd_1
XFILLER_3_6 vssd1 vssd1 vccd1 vccd1 sky130_fd_sc_hd__fill_4
X_1300_ _0504_ _0516_ _0524_ _0527_ _0531_ vssd1 vssd1 vccd1 vccd1 _0532_ sky130_fd_sc_hd__a41o_1
XFILLER_36_6 vccd1 vssd1 vccd1 vssd1 sky130_ef_sc_hd__decap_40_12
X_1162_ _0330_ _0348_ vssd1 vssd1 vccd1 vccd1 _0394_ sky130_fd_sc_hd__nor2_1
X_1231_ STOPWATCH_INST.clock_div.cycles\[11\] _0455_ _0461_ STOPWATCH_INST.clock_div.cycles\[10\]
+ _0456_ vssd1 vssd1 vccd1 vccd1 _0463_ sky130_fd_sc_hd__o221a_1
XTAP_TAPCELL_ROW_0_94 vssd1 vccd1 sky130_fd_sc_hd__tapvpwrvgnd_1
X_1093_ net31 net30 _0323_ _0276_ _0278_ vssd1 vssd1 vccd1 vccd1 _0325_ sky130_fd_sc_hd__a221o_1
XTAP_TAPCELL_ROW_22_209 vssd1 vccd1 sky130_fd_sc_hd__tapvpwrvgnd_1
XTAP_TAPCELL_ROW_30_253 vssd1 vccd1 sky130_fd_sc_hd__tapvpwrvgnd_1
X_0877_ _0134_ _0135_ STOPWATCH_INST.clock_div.second_tick vssd1 vssd1 vccd1 vccd1
+ _0136_ sky130_fd_sc_hd__o21a_1
XFILLER_9_281 vccd1 vssd1 vccd1 vssd1 sky130_ef_sc_hd__decap_40_12
X_0946_ net36 vssd1 vssd1 vccd1 vccd1 _0185_ sky130_fd_sc_hd__inv_2
X_1429_ _0182_ _0660_ vssd1 vssd1 vccd1 vccd1 _0661_ sky130_fd_sc_hd__or2_1
XFILLER_34_57 vssd1 vssd1 vccd1 vccd1 sky130_fd_sc_hd__fill_2
Xclkload1 clknet_3_1__leaf_clk vssd1 vssd1 vccd1 vccd1 clkload1/Y sky130_fd_sc_hd__clkinv_2
XFILLER_11_225 vssd1 vssd1 vccd1 vccd1 sky130_fd_sc_hd__fill_4
XTAP_TAPCELL_ROW_44_323 vssd1 vccd1 sky130_fd_sc_hd__tapvpwrvgnd_1
X_0800_ STOPWATCH_INST.sync_one.q STOPWATCH_INST.sync_one.sync_2 vssd1 vssd1 vccd1
+ vccd1 _0073_ sky130_fd_sc_hd__nand2b_1
XFILLER_6_295 vssd1 vssd1 vccd1 vccd1 sky130_fd_sc_hd__fill_1
X_1145_ _0364_ _0376_ vssd1 vssd1 vccd1 vccd1 _0377_ sky130_fd_sc_hd__nand2_1
X_1214_ _0444_ _0445_ vssd1 vssd1 vccd1 vccd1 _0446_ sky130_fd_sc_hd__nor2_2
X_1076_ _0256_ _0304_ _0299_ _0244_ vssd1 vssd1 vccd1 vccd1 _0308_ sky130_fd_sc_hd__a2bb2o_1
X_0929_ STOPWATCH_INST.clock_div.cycles\[23\] _0167_ vssd1 vssd1 vccd1 vccd1 _0168_
+ sky130_fd_sc_hd__nand2_1
XFILLER_29_79 vssd1 vssd1 vccd1 vccd1 sky130_fd_sc_hd__fill_2
XFILLER_29_57 vssd1 vssd1 vccd1 vccd1 sky130_fd_sc_hd__fill_2
Xhold46 STOPWATCH_INST.digit_scanner.period_counter\[15\] vssd1 vssd1 vccd1 vccd1
+ net164 sky130_fd_sc_hd__dlygate4sd3_1
Xhold57 STOPWATCH_INST.digit_scanner.period_counter\[5\] vssd1 vssd1 vccd1 vccd1 net175
+ sky130_fd_sc_hd__dlygate4sd3_1
Xhold35 STOPWATCH_INST.sync_clear.sync_1 vssd1 vssd1 vccd1 vccd1 net153 sky130_fd_sc_hd__dlygate4sd3_1
XFILLER_45_45 vssd1 vssd1 vccd1 vccd1 sky130_fd_sc_hd__fill_8
XFILLER_43_125 vccd1 vssd1 vccd1 vssd1 sky130_ef_sc_hd__decap_40_12
XTAP_TAPCELL_ROW_41_304 vssd1 vccd1 sky130_fd_sc_hd__tapvpwrvgnd_1
XFILLER_28_166 vssd1 vssd1 vccd1 vccd1 sky130_fd_sc_hd__fill_2
XPHY_EDGE_ROW_7_Left_54 vssd1 vssd1 vccd1 vccd1 sky130_fd_sc_hd__decap_3
XFILLER_3_221 vssd1 vssd1 vccd1 vccd1 sky130_fd_sc_hd__fill_2
XFILLER_34_114 vccd1 vssd1 vccd1 vssd1 sky130_ef_sc_hd__decap_40_12
XFILLER_19_100 vssd1 vssd1 vccd1 vccd1 sky130_fd_sc_hd__fill_1
X_1128_ _0354_ _0357_ vssd1 vssd1 vccd1 vccd1 _0360_ sky130_fd_sc_hd__nand2b_1
X_1059_ _0278_ _0288_ _0276_ net132 vssd1 vssd1 vccd1 vccd1 _0291_ sky130_fd_sc_hd__and4bb_1
XFILLER_25_169 vssd1 vssd1 vccd1 vccd1 sky130_fd_sc_hd__fill_8
Xoutput14 net14 vssd1 vssd1 vccd1 vccd1 gpio_out[8] sky130_fd_sc_hd__buf_2
XFILLER_0_202 vssd1 vssd1 vccd1 vccd1 sky130_fd_sc_hd__fill_4
XANTENNA__1550__B1 _0185_ vssd1 vssd1 vccd1 vccd1 sky130_fd_sc_hd__diode_2
XFILLER_31_128 vssd1 vssd1 vccd1 vccd1 sky130_fd_sc_hd__fill_2
XFILLER_16_147 vssd1 vssd1 vccd1 vccd1 sky130_fd_sc_hd__fill_1
XFILLER_21_80 vssd1 vssd1 vccd1 vccd1 sky130_fd_sc_hd__fill_4
XFILLER_30_161 vssd1 vssd1 vccd1 vccd1 sky130_fd_sc_hd__fill_2
XTAP_TAPCELL_ROW_17_186 vssd1 vccd1 sky130_fd_sc_hd__tapvpwrvgnd_1
XFILLER_21_161 vssd1 vssd1 vccd1 vccd1 sky130_fd_sc_hd__fill_2
XTAP_TAPCELL_ROW_8_143 vssd1 vccd1 sky130_fd_sc_hd__tapvpwrvgnd_1
XFILLER_44_253 vccd1 vssd1 vccd1 vssd1 sky130_ef_sc_hd__decap_40_12
XFILLER_44_242 vssd1 vssd1 vccd1 vccd1 sky130_fd_sc_hd__fill_8
XFILLER_29_294 vssd1 vssd1 vccd1 vccd1 sky130_fd_sc_hd__fill_4
XFILLER_44_297 vssd1 vssd1 vccd1 vccd1 sky130_fd_sc_hd__fill_2
X_1462_ _0607_ net19 _0608_ vssd1 vssd1 vccd1 vccd1 _0690_ sky130_fd_sc_hd__a21oi_1
X_1600_ clknet_3_2__leaf_clk _0009_ vssd1 vssd1 vccd1 vccd1 STOPWATCH_INST.digit_scanner.period_counter\[0\]
+ sky130_fd_sc_hd__dfxtp_1
X_1531_ _0639_ net18 _0644_ vssd1 vssd1 vccd1 vccd1 _0749_ sky130_fd_sc_hd__a21oi_1
X_1393_ _0543_ _0597_ _0622_ vssd1 vssd1 vccd1 vccd1 _0625_ sky130_fd_sc_hd__and3_1
XTAP_TAPCELL_ROW_5_124 vssd1 vccd1 sky130_fd_sc_hd__tapvpwrvgnd_1
XFILLER_37_57 vccd1 vssd1 vccd1 vssd1 sky130_ef_sc_hd__decap_40_12
XFILLER_26_253 vssd1 vssd1 vccd1 vccd1 sky130_fd_sc_hd__fill_8
XFILLER_41_278 vssd1 vssd1 vccd1 vccd1 sky130_fd_sc_hd__fill_2
XTAP_TAPCELL_ROW_36_281 vssd1 vccd1 sky130_fd_sc_hd__tapvpwrvgnd_1
XPHY_EDGE_ROW_36_Left_83 vssd1 vssd1 vccd1 vccd1 sky130_fd_sc_hd__decap_3
XANTENNA__0946__A net36 vssd1 vssd1 vccd1 vccd1 sky130_fd_sc_hd__diode_2
XPHY_EDGE_ROW_20_Left_67 vssd1 vssd1 vccd1 vccd1 sky130_fd_sc_hd__decap_3
X_0893_ _0129_ _0146_ _0147_ _0125_ STOPWATCH_INST.bcd_num\[7\] vssd1 vssd1 vccd1
+ vccd1 _0008_ sky130_fd_sc_hd__a32o_1
X_0962_ STOPWATCH_INST.clock_div.cycles\[5\] STOPWATCH_INST.clock_div.cycles\[4\]
+ STOPWATCH_INST.clock_div.cycles\[6\] _0190_ vssd1 vssd1 vccd1 vccd1 _0195_ sky130_fd_sc_hd__and4_1
XFILLER_4_61 vssd1 vssd1 vccd1 vccd1 sky130_fd_sc_hd__fill_1
X_1445_ net37 _0672_ _0675_ net41 STOPWATCH_INST.clock_div.cycles\[8\] vssd1 vssd1
+ vccd1 vccd1 _0033_ sky130_fd_sc_hd__a32o_1
X_1514_ STOPWATCH_INST.clock_div.cycles\[17\] STOPWATCH_INST.clock_div.cycles\[18\]
+ _0723_ vssd1 vssd1 vccd1 vccd1 _0735_ sky130_fd_sc_hd__and3_1
X_1376_ _0582_ _0587_ _0597_ _0603_ _0578_ vssd1 vssd1 vccd1 vccd1 _0608_ sky130_fd_sc_hd__a32o_1
XFILLER_23_256 vccd1 vssd1 vccd1 vssd1 sky130_ef_sc_hd__decap_40_12
XFILLER_2_138 vssd1 vssd1 vccd1 vccd1 sky130_fd_sc_hd__fill_2
XFILLER_2_116 vssd1 vssd1 vccd1 vccd1 sky130_fd_sc_hd__fill_8
XFILLER_0_19 vssd1 vssd1 vccd1 vccd1 sky130_fd_sc_hd__fill_4
XFILLER_14_223 vssd1 vssd1 vccd1 vccd1 sky130_fd_sc_hd__fill_4
X_1092_ net30 _0314_ _0323_ _0276_ vssd1 vssd1 vccd1 vccd1 _0324_ sky130_fd_sc_hd__a22o_1
X_1161_ _0330_ _0348_ _0363_ vssd1 vssd1 vccd1 vccd1 _0393_ sky130_fd_sc_hd__a21o_1
X_1230_ STOPWATCH_INST.clock_div.cycles\[10\] _0461_ vssd1 vssd1 vccd1 vccd1 _0462_
+ sky130_fd_sc_hd__nor2_1
XTAP_TAPCELL_ROW_0_95 vssd1 vccd1 sky130_fd_sc_hd__tapvpwrvgnd_1
X_0876_ STOPWATCH_INST.bcd_num\[3\] STOPWATCH_INST.bcd_num\[2\] _0112_ vssd1 vssd1
+ vccd1 vccd1 _0135_ sky130_fd_sc_hd__and3_1
XFILLER_9_260 vccd1 vssd1 vccd1 vssd1 sky130_ef_sc_hd__decap_40_12
XFILLER_9_293 vssd1 vssd1 vccd1 vccd1 sky130_fd_sc_hd__fill_2
X_0945_ _0179_ _0183_ _0080_ vssd1 vssd1 vccd1 vccd1 _0184_ sky130_fd_sc_hd__a21o_1
X_1428_ STOPWATCH_INST.clock_div.cycles\[8\] STOPWATCH_INST.clock_div.cycles\[11\]
+ STOPWATCH_INST.clock_div.cycles\[17\] _0659_ vssd1 vssd1 vccd1 vccd1 _0660_ sky130_fd_sc_hd__or4b_1
XFILLER_18_37 vssd1 vssd1 vccd1 vccd1 sky130_fd_sc_hd__fill_2
X_1359_ _0567_ _0569_ _0571_ vssd1 vssd1 vccd1 vccd1 _0591_ sky130_fd_sc_hd__nor3b_1
Xclkload2 clknet_3_3__leaf_clk vssd1 vssd1 vccd1 vccd1 clkload2/Y sky130_fd_sc_hd__bufinv_16
XFILLER_46_167 vssd1 vssd1 vccd1 vccd1 sky130_fd_sc_hd__fill_1
XANTENNA_clkbuf_3_4__f_clk_A clknet_0_clk vssd1 vssd1 vccd1 vccd1 sky130_fd_sc_hd__diode_2
XFILLER_10_270 vccd1 vssd1 vccd1 vssd1 sky130_ef_sc_hd__decap_40_12
X_1213_ _0392_ net28 _0395_ vssd1 vssd1 vccd1 vccd1 _0445_ sky130_fd_sc_hd__a21oi_2
XFILLER_27_3 vccd1 vssd1 vccd1 vssd1 sky130_ef_sc_hd__decap_40_12
XFILLER_37_189 vssd1 vssd1 vccd1 vccd1 sky130_fd_sc_hd__fill_1
X_1144_ _0330_ _0348_ _0322_ vssd1 vssd1 vccd1 vccd1 _0376_ sky130_fd_sc_hd__a21o_1
XFILLER_37_167 vssd1 vssd1 vccd1 vccd1 sky130_fd_sc_hd__fill_1
X_1075_ _0239_ _0305_ vssd1 vssd1 vccd1 vccd1 _0307_ sky130_fd_sc_hd__xor2_1
XPHY_EDGE_ROW_23_Left_70 vssd1 vssd1 vccd1 vccd1 sky130_fd_sc_hd__decap_3
X_0859_ STOPWATCH_INST.digit_scanner.period_counter\[5\] STOPWATCH_INST.digit_scanner.period_counter\[4\]
+ STOPWATCH_INST.digit_scanner.period_counter\[9\] STOPWATCH_INST.digit_scanner.period_counter\[8\]
+ vssd1 vssd1 vccd1 vccd1 _0122_ sky130_fd_sc_hd__or4bb_1
X_0928_ net45 STOPWATCH_INST.clock_div.cycles\[20\] net44 STOPWATCH_INST.clock_div.cycles\[22\]
+ vssd1 vssd1 vccd1 vccd1 _0167_ sky130_fd_sc_hd__a211o_1
Xhold58 _0014_ vssd1 vssd1 vccd1 vccd1 net176 sky130_fd_sc_hd__dlygate4sd3_1
Xhold36 STOPWATCH_INST.sync_ten.sync_1 vssd1 vssd1 vccd1 vccd1 net154 sky130_fd_sc_hd__dlygate4sd3_1
Xhold47 STOPWATCH_INST.digit_scanner.period_counter\[3\] vssd1 vssd1 vccd1 vccd1 net165
+ sky130_fd_sc_hd__dlygate4sd3_1
XFILLER_45_57 vccd1 vssd1 vccd1 vssd1 sky130_ef_sc_hd__decap_40_12
XFILLER_43_137 vssd1 vssd1 vccd1 vccd1 sky130_fd_sc_hd__fill_4
XTAP_TAPCELL_ROW_41_305 vssd1 vccd1 sky130_fd_sc_hd__tapvpwrvgnd_1
XFILLER_3_277 vssd1 vssd1 vccd1 vccd1 sky130_fd_sc_hd__fill_2
XFILLER_10_71 vccd1 vssd1 vccd1 vssd1 sky130_ef_sc_hd__decap_40_12
XFILLER_34_148 vccd1 vssd1 vccd1 vssd1 sky130_ef_sc_hd__decap_40_12
XFILLER_34_137 vssd1 vssd1 vccd1 vccd1 sky130_fd_sc_hd__fill_2
XFILLER_34_126 vssd1 vssd1 vccd1 vccd1 sky130_fd_sc_hd__fill_4
XFILLER_19_123 vccd1 vssd1 vccd1 vssd1 sky130_ef_sc_hd__decap_40_12
X_1127_ _0350_ _0358_ _0357_ vssd1 vssd1 vccd1 vccd1 _0359_ sky130_fd_sc_hd__a21o_1
XFILLER_40_107 vssd1 vssd1 vccd1 vccd1 sky130_fd_sc_hd__fill_4
X_1058_ _0288_ _0289_ vssd1 vssd1 vccd1 vccd1 _0290_ sky130_fd_sc_hd__or2_1
XFILLER_25_137 vssd1 vssd1 vccd1 vccd1 sky130_fd_sc_hd__fill_2
XFILLER_25_159 vssd1 vssd1 vccd1 vccd1 sky130_fd_sc_hd__fill_8
XFILLER_31_15 vccd1 vssd1 vccd1 vssd1 sky130_ef_sc_hd__decap_40_12
Xoutput15 net15 vssd1 vssd1 vccd1 vccd1 gpio_out[9] sky130_fd_sc_hd__buf_2
XPHY_EDGE_ROW_1_Right_1 vssd1 vssd1 vccd1 vccd1 sky130_fd_sc_hd__decap_3
XFILLER_0_258 vccd1 vssd1 vccd1 vssd1 sky130_ef_sc_hd__decap_40_12
XFILLER_0_247 vssd1 vssd1 vccd1 vccd1 sky130_fd_sc_hd__fill_1
XFILLER_0_225 vssd1 vssd1 vccd1 vccd1 sky130_fd_sc_hd__fill_8
XFILLER_16_115 vssd1 vssd1 vccd1 vccd1 sky130_fd_sc_hd__fill_4
XTAP_TAPCELL_ROW_17_187 vssd1 vccd1 sky130_fd_sc_hd__tapvpwrvgnd_1
XFILLER_30_195 vssd1 vssd1 vccd1 vccd1 sky130_fd_sc_hd__fill_1
XFILLER_30_184 vssd1 vssd1 vccd1 vccd1 sky130_fd_sc_hd__fill_2
XFILLER_38_251 vssd1 vssd1 vccd1 vccd1 sky130_fd_sc_hd__fill_1
XFILLER_26_15 vccd1 vssd1 vccd1 vssd1 sky130_ef_sc_hd__decap_40_12
XFILLER_21_151 vssd1 vssd1 vccd1 vccd1 sky130_fd_sc_hd__fill_1
XFILLER_44_265 vccd1 vssd1 vccd1 vssd1 sky130_ef_sc_hd__decap_40_12
X_1461_ STOPWATCH_INST.clock_div.cycles\[10\] net41 net37 _0689_ vssd1 vssd1 vccd1
+ vccd1 _0035_ sky130_fd_sc_hd__a22o_1
X_1392_ _0538_ _0623_ vssd1 vssd1 vccd1 vccd1 _0624_ sky130_fd_sc_hd__xnor2_2
X_1530_ STOPWATCH_INST.clock_div.cycles\[20\] net40 _0748_ vssd1 vssd1 vccd1 vccd1
+ _0045_ sky130_fd_sc_hd__a21bo_1
XFILLER_35_298 vssd1 vssd1 vccd1 vccd1 sky130_fd_sc_hd__fill_1
XANTENNA_input6_A nrst vssd1 vssd1 vccd1 vccd1 sky130_fd_sc_hd__diode_2
XTAP_TAPCELL_ROW_5_125 vssd1 vccd1 sky130_fd_sc_hd__tapvpwrvgnd_1
XFILLER_37_69 vccd1 vssd1 vccd1 vssd1 sky130_ef_sc_hd__decap_40_12
XTAP_TAPCELL_ROW_36_282 vssd1 vccd1 sky130_fd_sc_hd__tapvpwrvgnd_1
XFILLER_5_147 vssd1 vssd1 vccd1 vccd1 sky130_fd_sc_hd__fill_1
XFILLER_32_279 vssd1 vssd1 vccd1 vccd1 sky130_fd_sc_hd__fill_4
XFILLER_32_257 vssd1 vssd1 vccd1 vccd1 sky130_fd_sc_hd__fill_2
X_0961_ _0193_ _0194_ vssd1 vssd1 vccd1 vccd1 _0030_ sky130_fd_sc_hd__nor2_1
XFILLER_17_298 vssd1 vssd1 vccd1 vccd1 sky130_fd_sc_hd__fill_1
X_0892_ STOPWATCH_INST.bcd_num\[6\] _0140_ _0145_ vssd1 vssd1 vccd1 vccd1 _0147_ sky130_fd_sc_hd__a21o_1
XFILLER_4_180 vssd1 vssd1 vccd1 vccd1 sky130_fd_sc_hd__fill_1
XFILLER_4_95 vssd1 vssd1 vccd1 vccd1 sky130_fd_sc_hd__fill_1
X_1444_ _0673_ _0674_ net34 vssd1 vssd1 vccd1 vccd1 _0675_ sky130_fd_sc_hd__o21ai_1
X_1375_ _0600_ _0604_ _0605_ vssd1 vssd1 vccd1 vccd1 _0607_ sky130_fd_sc_hd__or3_1
X_1513_ STOPWATCH_INST.clock_div.cycles\[18\] _0730_ vssd1 vssd1 vccd1 vccd1 _0734_
+ sky130_fd_sc_hd__nor2_1
XFILLER_23_268 vssd1 vssd1 vccd1 vccd1 sky130_fd_sc_hd__fill_2
Xfanout50 STOPWATCH_INST.bcd_num\[6\] vssd1 vssd1 vccd1 vccd1 net50 sky130_fd_sc_hd__buf_2
XFILLER_13_71 vssd1 vssd1 vccd1 vccd1 sky130_fd_sc_hd__fill_2
XTAP_TAPCELL_ROW_0_96 vssd1 vccd1 sky130_fd_sc_hd__tapvpwrvgnd_1
X_1091_ _0274_ _0290_ vssd1 vssd1 vccd1 vccd1 _0323_ sky130_fd_sc_hd__nand2b_1
X_1160_ _0388_ _0389_ _0391_ vssd1 vssd1 vccd1 vccd1 _0392_ sky130_fd_sc_hd__nand3_1
Xclkbuf_3_7__f_clk clknet_0_clk vssd1 vssd1 vccd1 vccd1 clknet_3_7__leaf_clk sky130_fd_sc_hd__clkbuf_16
X_0944_ _0168_ _0178_ _0182_ vssd1 vssd1 vccd1 vccd1 _0183_ sky130_fd_sc_hd__o21ba_1
XFILLER_20_216 vssd1 vssd1 vccd1 vccd1 sky130_fd_sc_hd__fill_8
X_0875_ STOPWATCH_INST.bcd_num\[2\] _0089_ STOPWATCH_INST.bcd_num\[3\] vssd1 vssd1
+ vccd1 vccd1 _0134_ sky130_fd_sc_hd__and3b_1
XFILLER_9_272 vssd1 vssd1 vccd1 vccd1 sky130_fd_sc_hd__fill_8
X_1358_ net23 _0587_ _0567_ _0569_ _0576_ vssd1 vssd1 vccd1 vccd1 _0590_ sky130_fd_sc_hd__a2111oi_2
XFILLER_18_27 vssd1 vssd1 vccd1 vccd1 sky130_fd_sc_hd__fill_1
X_1427_ net141 STOPWATCH_INST.clock_div.cycles\[23\] STOPWATCH_INST.clock_div.cycles\[20\]
+ STOPWATCH_INST.clock_div.cycles\[15\] vssd1 vssd1 vccd1 vccd1 _0659_ sky130_fd_sc_hd__and4b_1
X_1289_ _0438_ _0507_ vssd1 vssd1 vccd1 vccd1 _0521_ sky130_fd_sc_hd__xnor2_2
XFILLER_34_26 vssd1 vssd1 vccd1 vccd1 sky130_fd_sc_hd__fill_2
Xclkload3 clknet_3_4__leaf_clk vssd1 vssd1 vccd1 vccd1 clkload3/Y sky130_fd_sc_hd__bufinv_16
XFILLER_46_113 vccd1 vssd1 vccd1 vssd1 sky130_ef_sc_hd__decap_40_12
XFILLER_24_70 vssd1 vssd1 vccd1 vccd1 sky130_fd_sc_hd__fill_2
XFILLER_41_6 vccd1 vssd1 vccd1 vssd1 sky130_ef_sc_hd__decap_40_12
XFILLER_6_253 vccd1 vssd1 vccd1 vssd1 sky130_ef_sc_hd__decap_40_12
XFILLER_10_282 vccd1 vssd1 vccd1 vssd1 sky130_ef_sc_hd__decap_40_12
X_1212_ _0392_ _0395_ net121 vssd1 vssd1 vccd1 vccd1 _0444_ sky130_fd_sc_hd__and3_1
X_1143_ _0372_ _0374_ _0369_ vssd1 vssd1 vccd1 vccd1 _0375_ sky130_fd_sc_hd__o21ai_1
XFILLER_37_157 vssd1 vssd1 vccd1 vccd1 sky130_fd_sc_hd__fill_2
X_1074_ _0239_ _0257_ _0304_ vssd1 vssd1 vccd1 vccd1 _0306_ sky130_fd_sc_hd__and3_1
XFILLER_1_85 vssd1 vssd1 vccd1 vccd1 sky130_fd_sc_hd__fill_2
X_0927_ net44 STOPWATCH_INST.clock_div.cycles\[22\] vssd1 vssd1 vccd1 vccd1 _0166_
+ sky130_fd_sc_hd__or2_1
XFILLER_29_15 vccd1 vssd1 vccd1 vssd1 sky130_ef_sc_hd__decap_40_12
X_0858_ STOPWATCH_INST.digit_scanner.period_counter\[7\] STOPWATCH_INST.digit_scanner.period_counter\[6\]
+ STOPWATCH_INST.digit_scanner.period_counter\[11\] STOPWATCH_INST.digit_scanner.period_counter\[10\]
+ vssd1 vssd1 vccd1 vccd1 _0121_ sky130_fd_sc_hd__or4b_1
X_0789_ STOPWATCH_INST.clock_div.cycles\[17\] vssd1 vssd1 vccd1 vccd1 _0063_ sky130_fd_sc_hd__inv_2
XFILLER_43_105 vssd1 vssd1 vccd1 vccd1 sky130_fd_sc_hd__fill_4
XFILLER_28_168 vssd1 vssd1 vccd1 vccd1 sky130_fd_sc_hd__fill_1
Xhold48 STOPWATCH_INST.digit_scanner.period_counter\[12\] vssd1 vssd1 vccd1 vccd1
+ net166 sky130_fd_sc_hd__dlygate4sd3_1
Xhold59 STOPWATCH_INST.clock_div.cycles\[2\] vssd1 vssd1 vccd1 vccd1 net177 sky130_fd_sc_hd__dlygate4sd3_1
Xhold37 STOPWATCH_INST.sync_one.sync_1 vssd1 vssd1 vccd1 vccd1 net155 sky130_fd_sc_hd__dlygate4sd3_1
XFILLER_45_69 vccd1 vssd1 vccd1 vssd1 sky130_ef_sc_hd__decap_40_12
XTAP_TAPCELL_ROW_41_306 vssd1 vccd1 sky130_fd_sc_hd__tapvpwrvgnd_1
XFILLER_6_19 vssd1 vssd1 vccd1 vccd1 sky130_fd_sc_hd__fill_1
XFILLER_3_223 vssd1 vssd1 vccd1 vccd1 sky130_fd_sc_hd__fill_1
XFILLER_10_83 vssd1 vssd1 vccd1 vccd1 sky130_fd_sc_hd__fill_1
XFILLER_19_113 vssd1 vssd1 vccd1 vccd1 sky130_fd_sc_hd__fill_1
XFILLER_19_135 vssd1 vssd1 vccd1 vccd1 sky130_fd_sc_hd__fill_1
X_1126_ _0318_ _0320_ vssd1 vssd1 vccd1 vccd1 _0358_ sky130_fd_sc_hd__nor2_1
X_1057_ STOPWATCH_INST.clock_div.cycles\[13\] _0286_ _0287_ vssd1 vssd1 vccd1 vccd1
+ _0289_ sky130_fd_sc_hd__o21bai_2
XFILLER_31_27 vccd1 vssd1 vccd1 vssd1 sky130_ef_sc_hd__decap_40_12
XFILLER_0_237 vssd1 vssd1 vccd1 vccd1 sky130_fd_sc_hd__fill_8
XFILLER_46_90 vssd1 vssd1 vccd1 vccd1 sky130_fd_sc_hd__fill_4
Xclkbuf_0_clk clk vssd1 vssd1 vccd1 vccd1 clknet_0_clk sky130_fd_sc_hd__clkbuf_16
XTAP_TAPCELL_ROW_17_188 vssd1 vccd1 sky130_fd_sc_hd__tapvpwrvgnd_1
XFILLER_30_174 vssd1 vssd1 vccd1 vccd1 sky130_fd_sc_hd__fill_2
XFILLER_30_163 vssd1 vssd1 vccd1 vccd1 sky130_fd_sc_hd__fill_1
XFILLER_30_141 vssd1 vssd1 vccd1 vccd1 sky130_fd_sc_hd__fill_4
XPHY_EDGE_ROW_15_Right_15 vssd1 vssd1 vccd1 vccd1 sky130_fd_sc_hd__decap_3
XFILLER_38_296 vssd1 vssd1 vccd1 vccd1 sky130_fd_sc_hd__fill_2
XFILLER_38_263 vssd1 vssd1 vccd1 vccd1 sky130_fd_sc_hd__fill_4
X_1109_ _0337_ _0339_ vssd1 vssd1 vccd1 vccd1 _0341_ sky130_fd_sc_hd__or2_1
XPHY_EDGE_ROW_24_Right_24 vssd1 vssd1 vccd1 vccd1 sky130_fd_sc_hd__decap_3
XFILLER_26_27 vssd1 vssd1 vccd1 vccd1 sky130_fd_sc_hd__fill_1
XFILLER_42_26 vssd1 vssd1 vccd1 vccd1 sky130_fd_sc_hd__fill_2
XPHY_EDGE_ROW_33_Right_33 vssd1 vssd1 vccd1 vccd1 sky130_fd_sc_hd__decap_3
XFILLER_44_277 vccd1 vssd1 vccd1 vssd1 sky130_ef_sc_hd__decap_40_12
XPHY_EDGE_ROW_42_Right_42 vssd1 vssd1 vccd1 vccd1 sky130_fd_sc_hd__decap_3
XFILLER_32_81 vssd1 vssd1 vccd1 vccd1 sky130_fd_sc_hd__fill_2
XFILLER_8_112 vssd1 vssd1 vccd1 vccd1 sky130_fd_sc_hd__fill_2
XFILLER_8_178 vccd1 vssd1 vccd1 vssd1 sky130_ef_sc_hd__decap_40_12
XFILLER_12_141 vssd1 vssd1 vccd1 vccd1 sky130_fd_sc_hd__fill_4
XTAP_TAPCELL_ROW_14_169 vssd1 vccd1 sky130_fd_sc_hd__tapvpwrvgnd_1
X_1460_ _0185_ _0684_ _0685_ _0688_ vssd1 vssd1 vccd1 vccd1 _0689_ sky130_fd_sc_hd__a31oi_1
X_1391_ _0592_ _0597_ vssd1 vssd1 vccd1 vccd1 _0623_ sky130_fd_sc_hd__nand2_1
XFILLER_35_255 vssd1 vssd1 vccd1 vccd1 sky130_fd_sc_hd__fill_8
XFILLER_35_233 vssd1 vssd1 vccd1 vccd1 sky130_fd_sc_hd__fill_2
XFILLER_35_288 vssd1 vssd1 vccd1 vccd1 sky130_fd_sc_hd__fill_8
XFILLER_12_29 vssd1 vssd1 vccd1 vccd1 sky130_fd_sc_hd__fill_2
XTAP_TAPCELL_ROW_5_126 vssd1 vccd1 sky130_fd_sc_hd__tapvpwrvgnd_1
X_1589_ clknet_3_1__leaf_clk net159 net53 vssd1 vssd1 vccd1 vccd1 STOPWATCH_INST.sync_one.q
+ sky130_fd_sc_hd__dfrtp_1
XFILLER_41_225 vssd1 vssd1 vccd1 vccd1 sky130_fd_sc_hd__fill_2
XTAP_TAPCELL_ROW_36_283 vssd1 vccd1 sky130_fd_sc_hd__tapvpwrvgnd_1
XTAP_TAPCELL_ROW_28_239 vssd1 vccd1 sky130_fd_sc_hd__tapvpwrvgnd_1
XFILLER_26_266 vccd1 vssd1 vccd1 vssd1 sky130_ef_sc_hd__decap_40_12
XFILLER_5_159 vssd1 vssd1 vccd1 vccd1 sky130_fd_sc_hd__fill_8
X_0960_ STOPWATCH_INST.clock_div.cycles\[5\] STOPWATCH_INST.clock_div.cycles\[4\]
+ _0191_ vssd1 vssd1 vccd1 vccd1 _0194_ sky130_fd_sc_hd__and3_1
X_0891_ net50 _0140_ _0145_ vssd1 vssd1 vccd1 vccd1 _0146_ sky130_fd_sc_hd__nand3_1
XTAP_TAPCELL_ROW_10_150 vssd1 vccd1 sky130_fd_sc_hd__tapvpwrvgnd_1
X_1512_ _0630_ _0649_ _0732_ _0727_ _0185_ vssd1 vssd1 vccd1 vccd1 _0733_ sky130_fd_sc_hd__o221ai_2
X_1443_ STOPWATCH_INST.clock_div.cycles\[7\] _0195_ STOPWATCH_INST.clock_div.cycles\[8\]
+ vssd1 vssd1 vccd1 vccd1 _0674_ sky130_fd_sc_hd__a21oi_1
X_1374_ _0605_ vssd1 vssd1 vccd1 vccd1 _0606_ sky130_fd_sc_hd__inv_2
XTAP_TAPCELL_ROW_33_264 vssd1 vccd1 sky130_fd_sc_hd__tapvpwrvgnd_1
XFILLER_2_107 vssd1 vssd1 vccd1 vccd1 sky130_fd_sc_hd__fill_2
XANTENNA_fanout57_A net59 vssd1 vssd1 vccd1 vccd1 sky130_fd_sc_hd__diode_2
Xfanout51 STOPWATCH_INST.bcd_num\[5\] vssd1 vssd1 vccd1 vccd1 net51 sky130_fd_sc_hd__clkbuf_2
Xfanout40 _0070_ vssd1 vssd1 vccd1 vccd1 net40 sky130_fd_sc_hd__buf_2
XFILLER_14_236 vssd1 vssd1 vccd1 vccd1 sky130_fd_sc_hd__fill_2
XTAP_TAPCELL_ROW_24_220 vssd1 vccd1 sky130_fd_sc_hd__tapvpwrvgnd_1
XTAP_TAPCELL_ROW_0_97 vssd1 vccd1 sky130_fd_sc_hd__tapvpwrvgnd_1
X_1090_ _0274_ _0321_ vssd1 vssd1 vccd1 vccd1 _0322_ sky130_fd_sc_hd__xnor2_2
X_0874_ STOPWATCH_INST.bcd_num\[2\] _0112_ _0126_ STOPWATCH_INST.bcd_num\[3\] vssd1
+ vssd1 vccd1 vccd1 _0133_ sky130_fd_sc_hd__a31o_1
XFILLER_9_295 vssd1 vssd1 vccd1 vccd1 sky130_fd_sc_hd__fill_1
X_0943_ STOPWATCH_INST.clock_div.cycles\[27\] STOPWATCH_INST.clock_div.cycles\[28\]
+ STOPWATCH_INST.clock_div.cycles\[31\] _0181_ vssd1 vssd1 vccd1 vccd1 _0182_ sky130_fd_sc_hd__or4_1
X_1288_ _0508_ _0519_ vssd1 vssd1 vccd1 vccd1 _0520_ sky130_fd_sc_hd__and2_1
X_1357_ _0571_ _0588_ vssd1 vssd1 vccd1 vccd1 _0589_ sky130_fd_sc_hd__nor2_1
X_1426_ STOPWATCH_INST.clock_div.cycles\[14\] net46 _0657_ _0655_ vssd1 vssd1 vccd1
+ vccd1 _0658_ sky130_fd_sc_hd__o31a_1
Xclkload4 clknet_3_5__leaf_clk vssd1 vssd1 vccd1 vccd1 clkload4/Y sky130_fd_sc_hd__clkinvlp_4
XFILLER_1_6 vssd1 vssd1 vccd1 vccd1 sky130_fd_sc_hd__fill_2
XFILLER_46_169 vccd1 vssd1 vccd1 vssd1 sky130_ef_sc_hd__decap_40_12
XFILLER_46_125 vccd1 vssd1 vccd1 vssd1 sky130_ef_sc_hd__decap_40_12
XFILLER_6_210 vssd1 vssd1 vccd1 vccd1 sky130_fd_sc_hd__fill_2
XFILLER_40_92 vssd1 vssd1 vccd1 vccd1 sky130_fd_sc_hd__fill_2
XFILLER_40_81 vssd1 vssd1 vccd1 vccd1 sky130_fd_sc_hd__fill_2
XFILLER_6_232 vccd1 vssd1 vccd1 vssd1 sky130_ef_sc_hd__decap_40_12
XFILLER_6_265 vccd1 vssd1 vccd1 vssd1 sky130_ef_sc_hd__decap_40_12
XFILLER_10_294 vssd1 vssd1 vccd1 vccd1 sky130_fd_sc_hd__fill_2
X_1142_ _0351_ _0359_ _0373_ vssd1 vssd1 vccd1 vccd1 _0374_ sky130_fd_sc_hd__o21a_1
X_1211_ _0442_ vssd1 vssd1 vccd1 vccd1 _0443_ sky130_fd_sc_hd__inv_2
XFILLER_34_6 vccd1 vssd1 vccd1 vssd1 sky130_ef_sc_hd__decap_40_12
XFILLER_37_169 vssd1 vssd1 vccd1 vccd1 sky130_fd_sc_hd__fill_4
X_1073_ _0257_ _0304_ vssd1 vssd1 vccd1 vccd1 _0305_ sky130_fd_sc_hd__nand2_1
X_0926_ net164 _0164_ vssd1 vssd1 vccd1 vccd1 _0024_ sky130_fd_sc_hd__xor2_1
X_0857_ STOPWATCH_INST.digit_scanner.period_counter\[12\] STOPWATCH_INST.digit_scanner.period_counter\[15\]
+ STOPWATCH_INST.digit_scanner.period_counter\[14\] STOPWATCH_INST.digit_scanner.period_counter\[13\]
+ vssd1 vssd1 vccd1 vccd1 _0120_ sky130_fd_sc_hd__or4b_1
XFILLER_29_27 vccd1 vssd1 vccd1 vssd1 sky130_ef_sc_hd__decap_40_12
X_0788_ STOPWATCH_INST.clock_div.cycles\[14\] vssd1 vssd1 vccd1 vccd1 _0062_ sky130_fd_sc_hd__inv_2
Xhold38 STOPWATCH_INST.sync_pause.sync_1 vssd1 vssd1 vccd1 vccd1 net156 sky130_fd_sc_hd__dlygate4sd3_1
X_1409_ _0563_ _0640_ vssd1 vssd1 vccd1 vccd1 _0641_ sky130_fd_sc_hd__nand2_1
Xhold49 _0162_ vssd1 vssd1 vccd1 vccd1 net167 sky130_fd_sc_hd__dlygate4sd3_1
XTAP_TAPCELL_ROW_41_307 vssd1 vccd1 sky130_fd_sc_hd__tapvpwrvgnd_1
XFILLER_3_279 vssd1 vssd1 vccd1 vccd1 sky130_fd_sc_hd__fill_1
XFILLER_34_139 vssd1 vssd1 vccd1 vccd1 sky130_fd_sc_hd__fill_1
XFILLER_42_194 vssd1 vssd1 vccd1 vccd1 sky130_fd_sc_hd__fill_2
X_1125_ _0355_ _0356_ vssd1 vssd1 vccd1 vccd1 _0357_ sky130_fd_sc_hd__or2_1
XFILLER_25_117 vssd1 vssd1 vccd1 vccd1 sky130_fd_sc_hd__fill_2
X_1056_ _0272_ _0216_ vssd1 vssd1 vccd1 vccd1 _0288_ sky130_fd_sc_hd__xnor2_2
XFILLER_31_39 vccd1 vssd1 vccd1 vssd1 sky130_ef_sc_hd__decap_40_12
X_0909_ _0155_ vssd1 vssd1 vccd1 vccd1 _0156_ sky130_fd_sc_hd__inv_2
XFILLER_0_216 vssd1 vssd1 vccd1 vccd1 sky130_fd_sc_hd__fill_2
XFILLER_16_139 vssd1 vssd1 vccd1 vccd1 sky130_fd_sc_hd__fill_1
XFILLER_24_194 vssd1 vssd1 vccd1 vccd1 sky130_fd_sc_hd__fill_2
XFILLER_11_8 vssd1 vssd1 vccd1 vccd1 sky130_fd_sc_hd__fill_1
XFILLER_38_253 vssd1 vssd1 vccd1 vccd1 sky130_fd_sc_hd__fill_2
XFILLER_38_231 vccd1 vssd1 vccd1 vssd1 sky130_ef_sc_hd__decap_40_12
X_1108_ _0337_ _0339_ vssd1 vssd1 vccd1 vccd1 _0340_ sky130_fd_sc_hd__nor2_1
X_1039_ _0268_ _0270_ vssd1 vssd1 vccd1 vccd1 _0271_ sky130_fd_sc_hd__nand2_1
XFILLER_44_289 vssd1 vssd1 vccd1 vccd1 sky130_fd_sc_hd__fill_8
XFILLER_16_83 vssd1 vssd1 vccd1 vccd1 sky130_fd_sc_hd__fill_1
XFILLER_32_71 vssd1 vssd1 vccd1 vccd1 sky130_fd_sc_hd__fill_1
XFILLER_8_124 vssd1 vssd1 vccd1 vccd1 sky130_fd_sc_hd__fill_2
XFILLER_8_146 vssd1 vssd1 vccd1 vccd1 sky130_fd_sc_hd__fill_8
X_1390_ _0539_ _0592_ vssd1 vssd1 vccd1 vccd1 _0622_ sky130_fd_sc_hd__nand2_1
XFILLER_35_223 vssd1 vssd1 vccd1 vccd1 sky130_fd_sc_hd__fill_1
XFILLER_12_19 vssd1 vssd1 vccd1 vccd1 sky130_fd_sc_hd__fill_1
X_1588_ clknet_3_0__leaf_clk net155 net53 vssd1 vssd1 vccd1 vccd1 STOPWATCH_INST.sync_one.sync_2
+ sky130_fd_sc_hd__dfrtp_1
XTAP_TAPCELL_ROW_5_127 vssd1 vccd1 sky130_fd_sc_hd__tapvpwrvgnd_1
XFILLER_41_204 vssd1 vssd1 vccd1 vccd1 sky130_fd_sc_hd__fill_4
XFILLER_26_278 vssd1 vssd1 vccd1 vccd1 sky130_fd_sc_hd__fill_4
XFILLER_5_116 vssd1 vssd1 vccd1 vccd1 sky130_fd_sc_hd__fill_4
XFILLER_17_223 vssd1 vssd1 vccd1 vccd1 sky130_fd_sc_hd__fill_1
XFILLER_43_81 vccd1 vssd1 vccd1 vssd1 sky130_ef_sc_hd__decap_40_12
XFILLER_32_259 vssd1 vssd1 vccd1 vccd1 sky130_fd_sc_hd__fill_1
X_0890_ STOPWATCH_INST.bcd_num\[7\] _0144_ vssd1 vssd1 vccd1 vccd1 _0145_ sky130_fd_sc_hd__xnor2_1
XTAP_TAPCELL_ROW_10_151 vssd1 vccd1 sky130_fd_sc_hd__tapvpwrvgnd_1
X_1442_ STOPWATCH_INST.clock_div.cycles\[7\] STOPWATCH_INST.clock_div.cycles\[8\]
+ _0195_ vssd1 vssd1 vccd1 vccd1 _0673_ sky130_fd_sc_hd__and3_1
X_1511_ _0547_ _0625_ vssd1 vssd1 vccd1 vccd1 _0732_ sky130_fd_sc_hd__xor2_1
X_1373_ _0572_ _0598_ vssd1 vssd1 vccd1 vccd1 _0605_ sky130_fd_sc_hd__xor2_2
XTAP_TAPCELL_ROW_33_265 vssd1 vccd1 sky130_fd_sc_hd__tapvpwrvgnd_1
X_1709_ STOPWATCH_INST.digit_scanner.ctrl vssd1 vssd1 vccd1 vccd1 net13 sky130_fd_sc_hd__clkbuf_1
Xfanout30 _0312_ vssd1 vssd1 vccd1 vccd1 net30 sky130_fd_sc_hd__buf_6
Xfanout52 STOPWATCH_INST.bcd_num\[4\] vssd1 vssd1 vccd1 vccd1 net52 sky130_fd_sc_hd__clkbuf_2
Xfanout41 _0070_ vssd1 vssd1 vccd1 vccd1 net41 sky130_fd_sc_hd__clkbuf_2
XFILLER_22_281 vssd1 vssd1 vccd1 vccd1 sky130_fd_sc_hd__fill_2
XTAP_TAPCELL_ROW_24_221 vssd1 vccd1 sky130_fd_sc_hd__tapvpwrvgnd_1
XFILLER_13_73 vssd1 vssd1 vccd1 vccd1 sky130_fd_sc_hd__fill_1
XFILLER_1_130 vssd1 vssd1 vccd1 vccd1 sky130_fd_sc_hd__fill_1
XTAP_TAPCELL_ROW_0_98 vssd1 vccd1 sky130_fd_sc_hd__tapvpwrvgnd_1
X_0873_ _0124_ _0131_ _0132_ vssd1 vssd1 vccd1 vccd1 _0003_ sky130_fd_sc_hd__and3_1
XFILLER_13_281 vccd1 vssd1 vccd1 vssd1 sky130_ef_sc_hd__decap_40_12
X_0942_ STOPWATCH_INST.clock_div.cycles\[29\] STOPWATCH_INST.clock_div.cycles\[30\]
+ vssd1 vssd1 vccd1 vccd1 _0181_ sky130_fd_sc_hd__or2_1
X_1425_ STOPWATCH_INST.clock_div.cycles\[7\] _0080_ _0656_ vssd1 vssd1 vccd1 vccd1
+ _0657_ sky130_fd_sc_hd__or3_1
X_1287_ _0438_ _0507_ vssd1 vssd1 vccd1 vccd1 _0519_ sky130_fd_sc_hd__nand2_1
X_1356_ net23 _0587_ _0576_ vssd1 vssd1 vccd1 vccd1 _0588_ sky130_fd_sc_hd__a21oi_1
XFILLER_11_229 vssd1 vssd1 vccd1 vccd1 sky130_fd_sc_hd__fill_1
Xclkload5 clknet_3_6__leaf_clk vssd1 vssd1 vccd1 vccd1 clkload5/Y sky130_fd_sc_hd__inv_6
XFILLER_46_104 vssd1 vssd1 vccd1 vccd1 sky130_fd_sc_hd__fill_8
XFILLER_46_137 vssd1 vssd1 vccd1 vccd1 sky130_fd_sc_hd__fill_2
XFILLER_6_244 vssd1 vssd1 vccd1 vccd1 sky130_fd_sc_hd__fill_8
XFILLER_6_277 vccd1 vssd1 vccd1 vssd1 sky130_ef_sc_hd__decap_40_12
X_1141_ _0355_ _0370_ _0356_ vssd1 vssd1 vccd1 vccd1 _0373_ sky130_fd_sc_hd__o21ai_1
X_1210_ _0440_ _0441_ vssd1 vssd1 vccd1 vccd1 _0442_ sky130_fd_sc_hd__nor2_1
X_1072_ _0248_ _0298_ vssd1 vssd1 vccd1 vccd1 _0304_ sky130_fd_sc_hd__or2_1
XFILLER_1_87 vssd1 vssd1 vccd1 vccd1 sky130_fd_sc_hd__fill_1
XFILLER_45_181 vccd1 vssd1 vccd1 vssd1 sky130_ef_sc_hd__decap_40_12
X_0856_ _0118_ vssd1 vssd1 vccd1 vccd1 _0119_ sky130_fd_sc_hd__inv_2
X_0925_ _0164_ net169 vssd1 vssd1 vccd1 vccd1 _0023_ sky130_fd_sc_hd__nor2_1
XFILLER_20_19 vssd1 vssd1 vccd1 vccd1 sky130_fd_sc_hd__fill_1
X_0787_ STOPWATCH_INST.clock_div.cycles\[11\] vssd1 vssd1 vccd1 vccd1 _0061_ sky130_fd_sc_hd__inv_2
XFILLER_29_39 vccd1 vssd1 vccd1 vssd1 sky130_ef_sc_hd__decap_40_12
X_1408_ _0556_ _0631_ _0597_ vssd1 vssd1 vccd1 vccd1 _0640_ sky130_fd_sc_hd__a21boi_2
Xhold39 STOPWATCH_INST.sync_ten.sync_2 vssd1 vssd1 vccd1 vccd1 net157 sky130_fd_sc_hd__dlygate4sd3_1
XFILLER_36_181 vccd1 vssd1 vccd1 vssd1 sky130_ef_sc_hd__decap_40_12
X_1339_ _0499_ net129 _0568_ _0570_ vssd1 vssd1 vccd1 vccd1 _0571_ sky130_fd_sc_hd__o22ai_4
XTAP_TAPCELL_ROW_41_308 vssd1 vccd1 sky130_fd_sc_hd__tapvpwrvgnd_1
XFILLER_3_225 vccd1 vssd1 vccd1 vssd1 sky130_ef_sc_hd__decap_40_12
XFILLER_3_203 vccd1 vssd1 vccd1 vssd1 sky130_ef_sc_hd__decap_40_12
XFILLER_10_85 vssd1 vssd1 vccd1 vccd1 sky130_fd_sc_hd__fill_4
XFILLER_35_93 vssd1 vssd1 vccd1 vccd1 sky130_fd_sc_hd__fill_4
XFILLER_27_181 vccd1 vssd1 vccd1 vssd1 sky130_ef_sc_hd__decap_40_12
XFILLER_25_3 vccd1 vssd1 vccd1 vssd1 sky130_ef_sc_hd__decap_40_12
XPHY_EDGE_ROW_27_Left_74 vssd1 vssd1 vccd1 vccd1 sky130_fd_sc_hd__decap_3
X_1124_ _0308_ _0352_ vssd1 vssd1 vccd1 vccd1 _0356_ sky130_fd_sc_hd__xnor2_1
X_1055_ _0218_ _0284_ vssd1 vssd1 vccd1 vccd1 _0287_ sky130_fd_sc_hd__xnor2_2
XPHY_EDGE_ROW_11_Left_58 vssd1 vssd1 vccd1 vccd1 sky130_fd_sc_hd__decap_3
XFILLER_25_107 vssd1 vssd1 vccd1 vccd1 sky130_fd_sc_hd__fill_1
XANTENNA__1480__B1 _0185_ vssd1 vssd1 vccd1 vccd1 sky130_fd_sc_hd__diode_2
X_0908_ STOPWATCH_INST.digit_scanner.period_counter\[7\] STOPWATCH_INST.digit_scanner.period_counter\[8\]
+ _0152_ vssd1 vssd1 vccd1 vccd1 _0155_ sky130_fd_sc_hd__and3_1
X_0839_ _0096_ _0101_ _0106_ _0105_ vssd1 vssd1 vccd1 vccd1 net8 sky130_fd_sc_hd__a31o_1
XFILLER_21_84 vssd1 vssd1 vccd1 vccd1 sky130_fd_sc_hd__fill_2
XFILLER_30_176 vssd1 vssd1 vccd1 vccd1 sky130_fd_sc_hd__fill_1
XFILLER_15_184 vssd1 vssd1 vccd1 vccd1 sky130_fd_sc_hd__fill_2
XFILLER_7_53 vssd1 vssd1 vccd1 vccd1 sky130_fd_sc_hd__fill_2
XFILLER_7_64 vssd1 vssd1 vccd1 vccd1 sky130_fd_sc_hd__fill_2
XFILLER_38_243 vssd1 vssd1 vccd1 vccd1 sky130_fd_sc_hd__fill_8
XFILLER_38_298 vssd1 vssd1 vccd1 vccd1 sky130_fd_sc_hd__fill_1
X_1107_ _0324_ _0338_ _0276_ _0315_ vssd1 vssd1 vccd1 vccd1 _0339_ sky130_fd_sc_hd__a2bb2o_2
X_1038_ _0233_ _0269_ vssd1 vssd1 vccd1 vccd1 _0270_ sky130_fd_sc_hd__xnor2_2
XPHY_EDGE_ROW_5_Right_5 vssd1 vssd1 vccd1 vccd1 sky130_fd_sc_hd__decap_3
XFILLER_21_198 vssd1 vssd1 vccd1 vccd1 sky130_fd_sc_hd__fill_4
XFILLER_29_298 vssd1 vssd1 vccd1 vccd1 sky130_fd_sc_hd__fill_1
XFILLER_29_287 vssd1 vssd1 vccd1 vccd1 sky130_fd_sc_hd__fill_1
XFILLER_29_265 vssd1 vssd1 vccd1 vccd1 sky130_fd_sc_hd__fill_1
XFILLER_8_114 vssd1 vssd1 vccd1 vccd1 sky130_fd_sc_hd__fill_1
XFILLER_12_165 vssd1 vssd1 vccd1 vccd1 sky130_fd_sc_hd__fill_4
XFILLER_32_83 vssd1 vssd1 vccd1 vccd1 sky130_fd_sc_hd__fill_1
XFILLER_35_268 vssd1 vssd1 vccd1 vccd1 sky130_fd_sc_hd__fill_4
XFILLER_35_202 vssd1 vssd1 vccd1 vccd1 sky130_fd_sc_hd__fill_2
XTAP_TAPCELL_ROW_5_128 vssd1 vccd1 sky130_fd_sc_hd__tapvpwrvgnd_1
X_1587_ clknet_3_2__leaf_clk net3 net53 vssd1 vssd1 vccd1 vccd1 STOPWATCH_INST.sync_ten.sync_1
+ sky130_fd_sc_hd__dfrtp_1
XFILLER_41_227 vssd1 vssd1 vccd1 vccd1 sky130_fd_sc_hd__fill_1
XPHY_EDGE_ROW_14_Left_61 vssd1 vssd1 vccd1 vccd1 sky130_fd_sc_hd__decap_3
XFILLER_43_93 vccd1 vssd1 vccd1 vssd1 sky130_ef_sc_hd__decap_40_12
XFILLER_40_260 vssd1 vssd1 vccd1 vccd1 sky130_fd_sc_hd__fill_2
XANTENNA_clkbuf_3_7__f_clk_A clknet_0_clk vssd1 vssd1 vccd1 vccd1 sky130_fd_sc_hd__diode_2
XTAP_TAPCELL_ROW_10_152 vssd1 vccd1 sky130_fd_sc_hd__tapvpwrvgnd_1
X_1441_ _0600_ net17 _0671_ net34 vssd1 vssd1 vccd1 vccd1 _0672_ sky130_fd_sc_hd__a211o_1
X_1510_ net37 _0731_ _0728_ net40 STOPWATCH_INST.clock_div.cycles\[17\] vssd1 vssd1
+ vccd1 vccd1 _0042_ sky130_fd_sc_hd__a32o_1
XTAP_TAPCELL_ROW_2_109 vssd1 vccd1 sky130_fd_sc_hd__tapvpwrvgnd_1
X_1372_ _0581_ _0602_ vssd1 vssd1 vccd1 vccd1 _0604_ sky130_fd_sc_hd__xnor2_1
XTAP_TAPCELL_ROW_33_266 vssd1 vccd1 sky130_fd_sc_hd__tapvpwrvgnd_1
XFILLER_31_271 vssd1 vssd1 vccd1 vccd1 sky130_fd_sc_hd__fill_4
X_1708_ STOPWATCH_INST.D0_AN_0 vssd1 vssd1 vccd1 vccd1 net12 sky130_fd_sc_hd__clkbuf_1
X_1639_ clknet_3_3__leaf_clk _0048_ net58 vssd1 vssd1 vccd1 vccd1 STOPWATCH_INST.clock_div.cycles\[23\]
+ sky130_fd_sc_hd__dfrtp_4
XANTENNA_input4_A gpio_in[2] vssd1 vssd1 vccd1 vccd1 sky130_fd_sc_hd__diode_2
XFILLER_14_205 vssd1 vssd1 vccd1 vccd1 sky130_fd_sc_hd__fill_4
XFILLER_14_227 vssd1 vssd1 vccd1 vccd1 sky130_fd_sc_hd__fill_1
XFILLER_14_238 vssd1 vssd1 vccd1 vccd1 sky130_fd_sc_hd__fill_1
Xfanout31 _0314_ vssd1 vssd1 vccd1 vccd1 net31 sky130_fd_sc_hd__buf_2
Xfanout53 net59 vssd1 vssd1 vccd1 vccd1 net53 sky130_fd_sc_hd__clkbuf_4
XFILLER_14_249 vssd1 vssd1 vccd1 vccd1 sky130_fd_sc_hd__fill_2
Xfanout42 STOPWATCH_INST.clock_div.cycles\[25\] vssd1 vssd1 vccd1 vccd1 net42 sky130_fd_sc_hd__buf_6
XTAP_TAPCELL_ROW_24_222 vssd1 vccd1 sky130_fd_sc_hd__tapvpwrvgnd_1
XFILLER_1_120 vssd1 vssd1 vccd1 vccd1 sky130_fd_sc_hd__fill_2
XFILLER_38_71 vccd1 vssd1 vccd1 vssd1 sky130_ef_sc_hd__decap_40_12
XTAP_TAPCELL_ROW_0_99 vssd1 vccd1 sky130_fd_sc_hd__tapvpwrvgnd_1
X_0941_ net42 net43 STOPWATCH_INST.clock_div.cycles\[26\] vssd1 vssd1 vccd1 vccd1
+ _0180_ sky130_fd_sc_hd__or3_4
X_0872_ STOPWATCH_INST.bcd_num\[2\] STOPWATCH_INST.clock_div.second_tick _0112_ vssd1
+ vssd1 vccd1 vccd1 _0132_ sky130_fd_sc_hd__nand3_1
XFILLER_13_293 vssd1 vssd1 vccd1 vccd1 sky130_fd_sc_hd__fill_4
X_1355_ STOPWATCH_INST.clock_div.cycles\[8\] _0572_ vssd1 vssd1 vccd1 vccd1 _0587_
+ sky130_fd_sc_hd__or2_1
X_1424_ net43 STOPWATCH_INST.clock_div.cycles\[26\] _0166_ _0176_ vssd1 vssd1 vccd1
+ vccd1 _0656_ sky130_fd_sc_hd__or4_1
XANTENNA__1574__C1 net36 vssd1 vssd1 vccd1 vccd1 sky130_fd_sc_hd__diode_2
X_1286_ _0517_ vssd1 vssd1 vccd1 vccd1 _0518_ sky130_fd_sc_hd__inv_2
XFILLER_34_18 vssd1 vssd1 vccd1 vccd1 sky130_fd_sc_hd__fill_8
XPHY_EDGE_ROW_41_Left_88 vssd1 vssd1 vccd1 vccd1 sky130_fd_sc_hd__decap_3
XFILLER_34_29 vccd1 vssd1 vccd1 vssd1 sky130_ef_sc_hd__decap_40_12
Xclkload6 clknet_3_7__leaf_clk vssd1 vssd1 vccd1 vccd1 clkload6/Y sky130_fd_sc_hd__inv_6
XFILLER_24_40 vssd1 vssd1 vccd1 vccd1 sky130_fd_sc_hd__fill_2
XFILLER_40_83 vssd1 vssd1 vccd1 vccd1 sky130_fd_sc_hd__fill_1
XFILLER_6_289 vssd1 vssd1 vccd1 vccd1 sky130_fd_sc_hd__fill_4
X_1140_ _0367_ _0371_ vssd1 vssd1 vccd1 vccd1 _0372_ sky130_fd_sc_hd__nor2_1
XFILLER_37_127 vssd1 vssd1 vccd1 vccd1 sky130_fd_sc_hd__fill_2
X_1071_ _0283_ _0296_ _0293_ _0302_ _0245_ vssd1 vssd1 vccd1 vccd1 _0303_ sky130_fd_sc_hd__a311o_1
XFILLER_1_77 vssd1 vssd1 vccd1 vccd1 sky130_fd_sc_hd__fill_8
XFILLER_45_193 vccd1 vssd1 vccd1 vssd1 sky130_ef_sc_hd__decap_40_12
X_0924_ STOPWATCH_INST.digit_scanner.period_counter\[13\] _0161_ net168 vssd1 vssd1
+ vccd1 vccd1 _0165_ sky130_fd_sc_hd__a21oi_1
X_0855_ STOPWATCH_INST.digit_scanner.period_counter\[3\] _0117_ vssd1 vssd1 vccd1
+ vccd1 _0118_ sky130_fd_sc_hd__and2_1
X_0786_ STOPWATCH_INST.clock_div.cycles\[9\] vssd1 vssd1 vccd1 vccd1 _0060_ sky130_fd_sc_hd__inv_2
X_1338_ _0494_ _0498_ _0499_ vssd1 vssd1 vccd1 vccd1 _0570_ sky130_fd_sc_hd__and3_1
X_1407_ _0628_ _0621_ _0635_ _0637_ vssd1 vssd1 vccd1 vccd1 _0639_ sky130_fd_sc_hd__a211o_1
X_1269_ _0460_ _0463_ net130 net27 vssd1 vssd1 vccd1 vccd1 _0501_ sky130_fd_sc_hd__a22o_1
XFILLER_3_237 vccd1 vssd1 vccd1 vssd1 sky130_ef_sc_hd__decap_40_12
XFILLER_42_141 vssd1 vssd1 vccd1 vccd1 sky130_fd_sc_hd__fill_4
XFILLER_27_193 vssd1 vssd1 vccd1 vccd1 sky130_fd_sc_hd__fill_8
X_1123_ _0301_ _0317_ vssd1 vssd1 vccd1 vccd1 _0355_ sky130_fd_sc_hd__xnor2_2
X_1054_ _0284_ _0285_ vssd1 vssd1 vccd1 vccd1 _0286_ sky130_fd_sc_hd__or2_1
XFILLER_25_119 vssd1 vssd1 vccd1 vccd1 sky130_fd_sc_hd__fill_1
XFILLER_33_196 vssd1 vssd1 vccd1 vccd1 sky130_fd_sc_hd__fill_2
X_0907_ STOPWATCH_INST.digit_scanner.period_counter\[7\] _0152_ net183 vssd1 vssd1
+ vccd1 vccd1 _0154_ sky130_fd_sc_hd__a21o_1
X_0838_ net51 net52 net50 vssd1 vssd1 vccd1 vccd1 _0106_ sky130_fd_sc_hd__or3_1
XFILLER_16_119 vssd1 vssd1 vccd1 vccd1 sky130_fd_sc_hd__fill_1
XPHY_EDGE_ROW_44_Left_91 vssd1 vssd1 vccd1 vccd1 sky130_fd_sc_hd__decap_3
XFILLER_24_141 vssd1 vssd1 vccd1 vccd1 sky130_fd_sc_hd__fill_4
XFILLER_21_30 vssd1 vssd1 vccd1 vccd1 sky130_fd_sc_hd__fill_1
XFILLER_15_152 vssd1 vssd1 vccd1 vccd1 sky130_fd_sc_hd__fill_2
XFILLER_30_111 vssd1 vssd1 vccd1 vccd1 sky130_fd_sc_hd__fill_2
XFILLER_38_255 vssd1 vssd1 vccd1 vccd1 sky130_fd_sc_hd__fill_1
X_1106_ _0276_ _0323_ vssd1 vssd1 vccd1 vccd1 _0338_ sky130_fd_sc_hd__nor2_1
XFILLER_42_29 vccd1 vssd1 vccd1 vssd1 sky130_ef_sc_hd__decap_40_12
XFILLER_42_18 vssd1 vssd1 vccd1 vccd1 sky130_fd_sc_hd__fill_8
X_1037_ net133 net32 _0231_ vssd1 vssd1 vccd1 vccd1 _0269_ sky130_fd_sc_hd__a21o_1
XTAP_TAPCELL_ROW_16_180 vssd1 vccd1 sky130_fd_sc_hd__tapvpwrvgnd_1
XFILLER_21_111 vssd1 vssd1 vccd1 vccd1 sky130_fd_sc_hd__fill_1
XFILLER_21_177 vssd1 vssd1 vccd1 vccd1 sky130_fd_sc_hd__fill_2
XTAP_TAPCELL_ROW_39_294 vssd1 vccd1 sky130_fd_sc_hd__tapvpwrvgnd_1
XFILLER_29_277 vssd1 vssd1 vccd1 vccd1 sky130_fd_sc_hd__fill_2
XFILLER_29_222 vssd1 vssd1 vccd1 vccd1 sky130_fd_sc_hd__fill_2
XPHY_EDGE_ROW_11_Right_11 vssd1 vssd1 vccd1 vccd1 sky130_fd_sc_hd__decap_3
XFILLER_12_155 vssd1 vssd1 vccd1 vccd1 sky130_fd_sc_hd__fill_1
XFILLER_12_177 vssd1 vssd1 vccd1 vccd1 sky130_fd_sc_hd__fill_8
XFILLER_16_74 vssd1 vssd1 vccd1 vccd1 sky130_fd_sc_hd__fill_1
XPHY_EDGE_ROW_20_Right_20 vssd1 vssd1 vccd1 vccd1 sky130_fd_sc_hd__decap_3
X_1586_ clknet_3_2__leaf_clk net157 net53 vssd1 vssd1 vccd1 vccd1 STOPWATCH_INST.sync_ten.q
+ sky130_fd_sc_hd__dfrtp_1
XFILLER_37_18 vccd1 vssd1 vccd1 vssd1 sky130_ef_sc_hd__decap_40_12
XFILLER_27_84 vccd1 vssd1 vccd1 vssd1 sky130_ef_sc_hd__decap_40_12
XFILLER_40_250 vssd1 vssd1 vccd1 vccd1 sky130_fd_sc_hd__fill_2
XTAP_TAPCELL_ROW_10_153 vssd1 vccd1 sky130_fd_sc_hd__tapvpwrvgnd_1
XFILLER_4_184 vccd1 vssd1 vccd1 vssd1 sky130_ef_sc_hd__decap_40_12
X_1440_ _0598_ _0599_ net16 _0059_ vssd1 vssd1 vccd1 vccd1 _0671_ sky130_fd_sc_hd__a22oi_1
X_1371_ _0585_ _0596_ _0586_ _0581_ vssd1 vssd1 vccd1 vccd1 _0603_ sky130_fd_sc_hd__a211o_1
XTAP_TAPCELL_ROW_33_267 vssd1 vccd1 sky130_fd_sc_hd__tapvpwrvgnd_1
XFILLER_16_280 vccd1 vssd1 vccd1 vssd1 sky130_ef_sc_hd__decap_40_12
Xclkbuf_3_2__f_clk clknet_0_clk vssd1 vssd1 vccd1 vccd1 clknet_3_2__leaf_clk sky130_fd_sc_hd__clkbuf_16
X_1638_ clknet_3_6__leaf_clk _0047_ net58 vssd1 vssd1 vccd1 vccd1 STOPWATCH_INST.clock_div.cycles\[22\]
+ sky130_fd_sc_hd__dfrtp_4
X_1569_ STOPWATCH_INST.clock_div.cycles\[29\] _0776_ vssd1 vssd1 vccd1 vccd1 _0779_
+ sky130_fd_sc_hd__nand2_1
XTAP_TAPCELL_ROW_24_223 vssd1 vccd1 sky130_fd_sc_hd__tapvpwrvgnd_1
Xfanout32 _0255_ vssd1 vssd1 vccd1 vccd1 net32 sky130_fd_sc_hd__buf_2
Xfanout54 net55 vssd1 vssd1 vccd1 vccd1 net54 sky130_fd_sc_hd__clkbuf_4
Xfanout43 STOPWATCH_INST.clock_div.cycles\[24\] vssd1 vssd1 vccd1 vccd1 net43 sky130_fd_sc_hd__buf_6
XFILLER_38_83 vssd1 vssd1 vccd1 vccd1 sky130_fd_sc_hd__fill_1
XFILLER_13_272 vssd1 vssd1 vccd1 vccd1 sky130_fd_sc_hd__fill_8
XFILLER_13_261 vssd1 vssd1 vccd1 vccd1 sky130_fd_sc_hd__fill_1
X_0940_ net43 net42 STOPWATCH_INST.clock_div.cycles\[26\] vssd1 vssd1 vccd1 vccd1
+ _0179_ sky130_fd_sc_hd__nor3_1
X_0871_ STOPWATCH_INST.bcd_num\[1\] STOPWATCH_INST.bcd_num\[0\] STOPWATCH_INST.clock_div.second_tick
+ STOPWATCH_INST.bcd_num\[2\] vssd1 vssd1 vccd1 vccd1 _0131_ sky130_fd_sc_hd__a31o_1
X_1285_ _0435_ _0508_ vssd1 vssd1 vccd1 vccd1 _0517_ sky130_fd_sc_hd__xnor2_1
X_1354_ STOPWATCH_INST.clock_div.cycles\[8\] _0572_ vssd1 vssd1 vccd1 vccd1 _0586_
+ sky130_fd_sc_hd__nor2_1
X_1423_ _0080_ _0653_ _0654_ vssd1 vssd1 vccd1 vccd1 _0655_ sky130_fd_sc_hd__nand3_1
XFILLER_11_209 vssd1 vssd1 vccd1 vccd1 sky130_fd_sc_hd__fill_4
XTAP_TAPCELL_ROW_21_204 vssd1 vccd1 sky130_fd_sc_hd__tapvpwrvgnd_1
XFILLER_46_139 vssd1 vssd1 vccd1 vccd1 sky130_fd_sc_hd__fill_1
XANTENNA_fanout55_A net59 vssd1 vssd1 vccd1 vccd1 sky130_fd_sc_hd__diode_2
XFILLER_37_106 vssd1 vssd1 vccd1 vccd1 sky130_fd_sc_hd__fill_4
XFILLER_45_161 vssd1 vssd1 vccd1 vccd1 sky130_fd_sc_hd__fill_4
X_1070_ _0263_ _0301_ vssd1 vssd1 vccd1 vccd1 _0302_ sky130_fd_sc_hd__nand2_1
X_0923_ STOPWATCH_INST.digit_scanner.period_counter\[13\] STOPWATCH_INST.digit_scanner.period_counter\[14\]
+ _0161_ vssd1 vssd1 vccd1 vccd1 _0164_ sky130_fd_sc_hd__and3_1
X_0854_ STOPWATCH_INST.digit_scanner.period_counter\[1\] STOPWATCH_INST.digit_scanner.period_counter\[0\]
+ STOPWATCH_INST.digit_scanner.period_counter\[2\] vssd1 vssd1 vccd1 vccd1 _0117_
+ sky130_fd_sc_hd__and3_1
X_0785_ STOPWATCH_INST.clock_div.cycles\[7\] vssd1 vssd1 vccd1 vccd1 _0059_ sky130_fd_sc_hd__inv_2
X_1337_ _0502_ _0568_ vssd1 vssd1 vccd1 vccd1 _0569_ sky130_fd_sc_hd__xnor2_2
X_1406_ _0637_ vssd1 vssd1 vccd1 vccd1 _0638_ sky130_fd_sc_hd__inv_2
X_1268_ _0491_ _0494_ _0497_ _0499_ vssd1 vssd1 vccd1 vccd1 _0500_ sky130_fd_sc_hd__a31o_1
XFILLER_43_109 vssd1 vssd1 vccd1 vccd1 sky130_fd_sc_hd__fill_2
X_1199_ _0402_ _0407_ net29 vssd1 vssd1 vccd1 vccd1 _0431_ sky130_fd_sc_hd__and3_1
XFILLER_36_161 vssd1 vssd1 vccd1 vccd1 sky130_fd_sc_hd__fill_2
XFILLER_3_249 vccd1 vssd1 vccd1 vssd1 sky130_ef_sc_hd__decap_40_12
XFILLER_10_65 vssd1 vssd1 vccd1 vccd1 sky130_fd_sc_hd__fill_1
XFILLER_19_74 vssd1 vssd1 vccd1 vccd1 sky130_fd_sc_hd__fill_1
XFILLER_35_73 vssd1 vssd1 vccd1 vccd1 sky130_fd_sc_hd__fill_2
X_1122_ _0307_ _0353_ vssd1 vssd1 vccd1 vccd1 _0354_ sky130_fd_sc_hd__xor2_1
XFILLER_32_6 vccd1 vssd1 vccd1 vssd1 sky130_ef_sc_hd__decap_40_12
XFILLER_2_293 vssd1 vssd1 vccd1 vccd1 sky130_fd_sc_hd__fill_2
X_1053_ STOPWATCH_INST.clock_div.cycles\[14\] net128 _0255_ vssd1 vssd1 vccd1 vccd1
+ _0285_ sky130_fd_sc_hd__and3_1
XFILLER_18_194 vssd1 vssd1 vccd1 vccd1 sky130_fd_sc_hd__fill_2
X_0906_ net173 _0152_ vssd1 vssd1 vccd1 vccd1 _0016_ sky130_fd_sc_hd__xor2_1
X_0837_ _0088_ _0089_ _0099_ _0104_ vssd1 vssd1 vccd1 vccd1 _0105_ sky130_fd_sc_hd__o211a_1
XFILLER_24_120 vssd1 vssd1 vccd1 vccd1 sky130_fd_sc_hd__fill_1
XFILLER_24_153 vssd1 vssd1 vccd1 vccd1 sky130_fd_sc_hd__fill_2
XFILLER_21_86 vssd1 vssd1 vccd1 vccd1 sky130_fd_sc_hd__fill_1
XFILLER_46_83 vssd1 vssd1 vccd1 vccd1 sky130_fd_sc_hd__fill_1
XFILLER_46_50 vssd1 vssd1 vccd1 vccd1 sky130_fd_sc_hd__fill_2
XFILLER_15_164 vssd1 vssd1 vccd1 vccd1 sky130_fd_sc_hd__fill_4
XFILLER_30_145 vssd1 vssd1 vccd1 vccd1 sky130_fd_sc_hd__fill_1
XFILLER_7_55 vssd1 vssd1 vccd1 vccd1 sky130_fd_sc_hd__fill_1
XFILLER_30_3 vccd1 vssd1 vccd1 vssd1 sky130_ef_sc_hd__decap_40_12
XFILLER_38_212 vccd1 vssd1 vccd1 vssd1 sky130_ef_sc_hd__decap_40_12
XFILLER_38_201 vssd1 vssd1 vccd1 vccd1 sky130_fd_sc_hd__fill_2
X_1105_ _0278_ _0324_ vssd1 vssd1 vccd1 vccd1 _0337_ sky130_fd_sc_hd__xnor2_1
X_1036_ _0211_ _0260_ vssd1 vssd1 vccd1 vccd1 _0268_ sky130_fd_sc_hd__xnor2_2
XTAP_TAPCELL_ROW_16_181 vssd1 vccd1 sky130_fd_sc_hd__tapvpwrvgnd_1
XTAP_TAPCELL_ROW_39_295 vssd1 vccd1 sky130_fd_sc_hd__tapvpwrvgnd_1
XFILLER_32_41 vccd1 vssd1 vccd1 vssd1 sky130_ef_sc_hd__decap_40_12
XFILLER_12_145 vssd1 vssd1 vccd1 vccd1 sky130_fd_sc_hd__fill_2
XFILLER_35_204 vssd1 vssd1 vccd1 vccd1 sky130_fd_sc_hd__fill_1
XFILLER_43_281 vccd1 vssd1 vccd1 vssd1 sky130_ef_sc_hd__decap_40_12
X_1585_ clknet_3_0__leaf_clk net154 net53 vssd1 vssd1 vccd1 vccd1 STOPWATCH_INST.sync_ten.sync_2
+ sky130_fd_sc_hd__dfrtp_1
X_1019_ _0243_ _0248_ _0249_ _0250_ vssd1 vssd1 vccd1 vccd1 _0251_ sky130_fd_sc_hd__or4_4
XFILLER_26_215 vssd1 vssd1 vccd1 vccd1 sky130_fd_sc_hd__fill_2
XFILLER_26_204 vssd1 vssd1 vccd1 vccd1 sky130_fd_sc_hd__fill_2
XFILLER_43_51 vssd1 vssd1 vccd1 vccd1 sky130_fd_sc_hd__fill_4
XFILLER_40_262 vssd1 vssd1 vccd1 vccd1 sky130_fd_sc_hd__fill_1
XFILLER_40_240 vssd1 vssd1 vccd1 vccd1 sky130_fd_sc_hd__fill_1
XFILLER_27_96 vccd1 vssd1 vccd1 vssd1 sky130_ef_sc_hd__decap_40_12
XFILLER_4_141 vssd1 vssd1 vccd1 vccd1 sky130_fd_sc_hd__fill_4
XFILLER_4_174 vssd1 vssd1 vccd1 vccd1 sky130_fd_sc_hd__fill_4
XFILLER_4_78 vssd1 vssd1 vccd1 vccd1 sky130_fd_sc_hd__fill_4
X_1370_ _0585_ _0596_ _0586_ vssd1 vssd1 vccd1 vccd1 _0602_ sky130_fd_sc_hd__a21o_1
XTAP_TAPCELL_ROW_33_268 vssd1 vccd1 sky130_fd_sc_hd__tapvpwrvgnd_1
XFILLER_31_284 vssd1 vssd1 vccd1 vccd1 sky130_fd_sc_hd__fill_1
XFILLER_16_292 vssd1 vssd1 vccd1 vccd1 sky130_fd_sc_hd__fill_4
X_1637_ clknet_3_6__leaf_clk _0046_ net58 vssd1 vssd1 vccd1 vccd1 STOPWATCH_INST.clock_div.cycles\[21\]
+ sky130_fd_sc_hd__dfrtp_1
X_1499_ STOPWATCH_INST.clock_div.cycles\[16\] _0718_ vssd1 vssd1 vccd1 vccd1 _0722_
+ sky130_fd_sc_hd__nor2_1
X_1568_ STOPWATCH_INST.clock_div.cycles\[29\] _0776_ vssd1 vssd1 vccd1 vccd1 _0778_
+ sky130_fd_sc_hd__or2_1
Xfanout33 _0252_ vssd1 vssd1 vccd1 vccd1 net33 sky130_fd_sc_hd__buf_6
Xfanout55 net59 vssd1 vssd1 vccd1 vccd1 net55 sky130_fd_sc_hd__clkbuf_2
Xfanout44 STOPWATCH_INST.clock_div.cycles\[21\] vssd1 vssd1 vccd1 vccd1 net44 sky130_fd_sc_hd__buf_2
XFILLER_22_251 vssd1 vssd1 vccd1 vccd1 sky130_fd_sc_hd__fill_1
XFILLER_1_122 vssd1 vssd1 vccd1 vccd1 sky130_fd_sc_hd__fill_1
XFILLER_8_3 vssd1 vssd1 vccd1 vccd1 sky130_fd_sc_hd__fill_4
XTAP_TAPCELL_ROW_30_249 vssd1 vccd1 sky130_fd_sc_hd__tapvpwrvgnd_1
X_0870_ STOPWATCH_INST.bcd_num\[1\] _0125_ _0129_ _0130_ vssd1 vssd1 vccd1 vccd1 _0002_
+ sky130_fd_sc_hd__a22o_1
X_1422_ net45 STOPWATCH_INST.clock_div.cycles\[18\] net46 STOPWATCH_INST.clock_div.cycles\[7\]
+ vssd1 vssd1 vccd1 vccd1 _0654_ sky130_fd_sc_hd__and4b_1
X_1284_ _0427_ _0510_ _0514_ vssd1 vssd1 vccd1 vccd1 _0516_ sky130_fd_sc_hd__and3_1
X_1353_ _0584_ _0583_ net22 _0536_ vssd1 vssd1 vccd1 vccd1 _0585_ sky130_fd_sc_hd__a31oi_4
X_0999_ net138 _0226_ _0228_ _0230_ vssd1 vssd1 vccd1 vccd1 _0231_ sky130_fd_sc_hd__and4_1
XTAP_TAPCELL_ROW_21_205 vssd1 vccd1 sky130_fd_sc_hd__tapvpwrvgnd_1
XTAP_TAPCELL_ROW_44_319 vssd1 vccd1 sky130_fd_sc_hd__tapvpwrvgnd_1
XFILLER_39_192 vssd1 vssd1 vccd1 vccd1 sky130_fd_sc_hd__fill_1
XFILLER_24_53 vssd1 vssd1 vccd1 vccd1 sky130_fd_sc_hd__fill_4
XFILLER_40_41 vccd1 vssd1 vccd1 vssd1 sky130_ef_sc_hd__decap_40_12
XFILLER_37_129 vssd1 vssd1 vccd1 vccd1 sky130_fd_sc_hd__fill_1
X_0853_ net6 net1 vssd1 vssd1 vccd1 vccd1 STOPWATCH_INST.clock_div.n_rst sky130_fd_sc_hd__and2_1
X_0922_ net172 _0161_ _0163_ vssd1 vssd1 vccd1 vccd1 _0022_ sky130_fd_sc_hd__a21oi_1
X_1405_ _0521_ _0636_ vssd1 vssd1 vccd1 vccd1 _0637_ sky130_fd_sc_hd__xnor2_2
X_0784_ net161 vssd1 vssd1 vccd1 vccd1 _0009_ sky130_fd_sc_hd__inv_2
X_1198_ _0429_ vssd1 vssd1 vccd1 vccd1 _0430_ sky130_fd_sc_hd__inv_2
XFILLER_36_151 vssd1 vssd1 vccd1 vccd1 sky130_fd_sc_hd__fill_1
XFILLER_28_107 vssd1 vssd1 vccd1 vccd1 sky130_fd_sc_hd__fill_2
X_1336_ _0500_ net129 vssd1 vssd1 vccd1 vccd1 _0568_ sky130_fd_sc_hd__nand2_2
X_1267_ _0460_ _0493_ vssd1 vssd1 vccd1 vccd1 _0499_ sky130_fd_sc_hd__xnor2_2
Xinput1 en vssd1 vssd1 vccd1 vccd1 net1 sky130_fd_sc_hd__clkbuf_1
XFILLER_42_121 vccd1 vssd1 vccd1 vssd1 sky130_ef_sc_hd__decap_40_12
XFILLER_35_30 vccd1 vssd1 vccd1 vssd1 sky130_ef_sc_hd__decap_40_12
XFILLER_27_140 vssd1 vssd1 vccd1 vccd1 sky130_fd_sc_hd__fill_1
XTAP_TAPCELL_ROW_40_300 vssd1 vccd1 sky130_fd_sc_hd__tapvpwrvgnd_1
XANTENNA__1529__A1 _0185_ vssd1 vssd1 vccd1 vccd1 sky130_fd_sc_hd__diode_2
X_1121_ _0308_ _0352_ vssd1 vssd1 vccd1 vccd1 _0353_ sky130_fd_sc_hd__nand2_1
X_1052_ net33 net32 STOPWATCH_INST.clock_div.cycles\[14\] vssd1 vssd1 vccd1 vccd1
+ _0284_ sky130_fd_sc_hd__a21oi_2
XFILLER_18_5 vssd1 vssd1 vccd1 vccd1 sky130_fd_sc_hd__fill_8
XFILLER_33_198 vssd1 vssd1 vccd1 vccd1 sky130_fd_sc_hd__fill_1
XFILLER_33_165 vssd1 vssd1 vccd1 vccd1 sky130_fd_sc_hd__fill_2
X_0905_ _0152_ _0153_ vssd1 vssd1 vccd1 vccd1 _0015_ sky130_fd_sc_hd__and2b_1
X_0836_ STOPWATCH_INST.bcd_num\[1\] STOPWATCH_INST.bcd_num\[0\] _0103_ _0098_ vssd1
+ vssd1 vccd1 vccd1 _0104_ sky130_fd_sc_hd__o31a_1
XFILLER_0_209 vssd1 vssd1 vccd1 vccd1 sky130_fd_sc_hd__fill_4
X_1319_ net140 _0549_ _0510_ vssd1 vssd1 vccd1 vccd1 _0551_ sky130_fd_sc_hd__a21oi_1
XFILLER_21_54 vssd1 vssd1 vccd1 vccd1 sky130_fd_sc_hd__fill_2
XFILLER_46_62 vssd1 vssd1 vccd1 vccd1 sky130_fd_sc_hd__fill_4
XFILLER_23_3 vssd1 vssd1 vccd1 vccd1 sky130_fd_sc_hd__fill_4
X_1104_ _0268_ _0333_ _0335_ vssd1 vssd1 vccd1 vccd1 _0336_ sky130_fd_sc_hd__and3_1
X_1035_ _0266_ vssd1 vssd1 vccd1 vccd1 _0267_ sky130_fd_sc_hd__inv_2
XFILLER_38_224 vssd1 vssd1 vccd1 vccd1 sky130_fd_sc_hd__fill_1
XANTENNA__1438__B1 _0185_ vssd1 vssd1 vccd1 vccd1 sky130_fd_sc_hd__diode_2
XTAP_TAPCELL_ROW_16_182 vssd1 vccd1 sky130_fd_sc_hd__tapvpwrvgnd_1
XFILLER_21_113 vssd1 vssd1 vccd1 vccd1 sky130_fd_sc_hd__fill_4
XFILLER_21_179 vssd1 vssd1 vccd1 vccd1 sky130_fd_sc_hd__fill_1
X_0819_ STOPWATCH_INST.bcd_num\[1\] STOPWATCH_INST.bcd_num\[0\] vssd1 vssd1 vccd1
+ vccd1 _0090_ sky130_fd_sc_hd__nor2_1
XTAP_TAPCELL_ROW_8_139 vssd1 vccd1 sky130_fd_sc_hd__tapvpwrvgnd_1
XFILLER_29_279 vssd1 vssd1 vccd1 vccd1 sky130_fd_sc_hd__fill_1
XTAP_TAPCELL_ROW_39_296 vssd1 vccd1 sky130_fd_sc_hd__tapvpwrvgnd_1
XFILLER_32_53 vssd1 vssd1 vccd1 vccd1 sky130_fd_sc_hd__fill_4
XFILLER_35_238 vssd1 vssd1 vccd1 vccd1 sky130_fd_sc_hd__fill_4
XFILLER_43_293 vssd1 vssd1 vccd1 vccd1 sky130_fd_sc_hd__fill_4
XPHY_EDGE_ROW_9_Right_9 vssd1 vssd1 vccd1 vccd1 sky130_fd_sc_hd__decap_3
X_1584_ clknet_3_2__leaf_clk net4 net54 vssd1 vssd1 vccd1 vccd1 STOPWATCH_INST.sync_pause.sync_1
+ sky130_fd_sc_hd__dfrtp_1
XFILLER_41_208 vssd1 vssd1 vccd1 vccd1 sky130_fd_sc_hd__fill_1
X_1018_ net42 _0204_ vssd1 vssd1 vccd1 vccd1 _0250_ sky130_fd_sc_hd__or2_1
XTAP_TAPCELL_ROW_4_120 vssd1 vccd1 sky130_fd_sc_hd__tapvpwrvgnd_1
XFILLER_40_296 vssd1 vssd1 vccd1 vccd1 sky130_fd_sc_hd__fill_2
XFILLER_4_197 vssd1 vssd1 vccd1 vccd1 sky130_fd_sc_hd__fill_4
XFILLER_4_57 vssd1 vssd1 vccd1 vccd1 sky130_fd_sc_hd__fill_4
XFILLER_23_208 vssd1 vssd1 vccd1 vccd1 sky130_fd_sc_hd__fill_2
X_1636_ clknet_3_7__leaf_clk _0045_ net58 vssd1 vssd1 vccd1 vccd1 STOPWATCH_INST.clock_div.cycles\[20\]
+ sky130_fd_sc_hd__dfrtp_4
XPHY_EDGE_ROW_18_Left_65 vssd1 vssd1 vccd1 vccd1 sky130_fd_sc_hd__decap_3
X_1567_ net36 _0775_ _0777_ net39 STOPWATCH_INST.clock_div.cycles\[28\] vssd1 vssd1
+ vccd1 vccd1 _0053_ sky130_fd_sc_hd__a32o_1
X_1498_ _0621_ _0624_ net135 net34 vssd1 vssd1 vccd1 vccd1 _0721_ sky130_fd_sc_hd__a31o_1
Xfanout56 net59 vssd1 vssd1 vccd1 vccd1 net56 sky130_fd_sc_hd__clkbuf_4
Xfanout34 net35 vssd1 vssd1 vccd1 vccd1 net34 sky130_fd_sc_hd__buf_2
Xfanout45 STOPWATCH_INST.clock_div.cycles\[19\] vssd1 vssd1 vccd1 vccd1 net45 sky130_fd_sc_hd__clkbuf_4
XFILLER_13_44 vssd1 vssd1 vccd1 vccd1 sky130_fd_sc_hd__fill_1
XFILLER_38_41 vccd1 vssd1 vccd1 vssd1 sky130_ef_sc_hd__decap_40_12
XFILLER_1_167 vssd1 vssd1 vccd1 vccd1 sky130_fd_sc_hd__fill_1
XFILLER_9_223 vssd1 vssd1 vccd1 vccd1 sky130_fd_sc_hd__fill_1
X_1421_ net44 STOPWATCH_INST.clock_div.cycles\[22\] net136 STOPWATCH_INST.clock_div.cycles\[26\]
+ vssd1 vssd1 vccd1 vccd1 _0653_ sky130_fd_sc_hd__and4_1
X_1283_ _0510_ _0514_ vssd1 vssd1 vccd1 vccd1 _0515_ sky130_fd_sc_hd__and2_1
X_1352_ _0567_ _0565_ _0569_ _0576_ vssd1 vssd1 vccd1 vccd1 _0584_ sky130_fd_sc_hd__nor4_4
XTAP_TAPCELL_ROW_21_206 vssd1 vccd1 sky130_fd_sc_hd__tapvpwrvgnd_1
X_0998_ _0214_ _0229_ vssd1 vssd1 vccd1 vccd1 _0230_ sky130_fd_sc_hd__or2_1
X_1619_ clknet_3_4__leaf_clk _0028_ net57 vssd1 vssd1 vccd1 vccd1 STOPWATCH_INST.clock_div.cycles\[3\]
+ sky130_fd_sc_hd__dfrtp_1
XANTENNA_input2_A gpio_in[0] vssd1 vssd1 vccd1 vccd1 sky130_fd_sc_hd__diode_2
XFILLER_10_233 vssd1 vssd1 vccd1 vccd1 sky130_fd_sc_hd__fill_4
XFILLER_40_53 vccd1 vssd1 vccd1 vssd1 sky130_ef_sc_hd__decap_40_12
XANTENNA__1592__RESET_B net59 vssd1 vssd1 vccd1 vccd1 sky130_fd_sc_hd__diode_2
X_0921_ net172 _0161_ _0123_ vssd1 vssd1 vccd1 vccd1 _0163_ sky130_fd_sc_hd__o21ai_1
X_0852_ _0110_ _0115_ _0116_ STOPWATCH_INST.D0_AN_0 vssd1 vssd1 vccd1 vccd1 net11
+ sky130_fd_sc_hd__a22o_1
X_0783_ STOPWATCH_INST.fsm_inst1.currentState\[1\] vssd1 vssd1 vccd1 vccd1 _0058_
+ sky130_fd_sc_hd__inv_2
X_1335_ _0537_ _0566_ vssd1 vssd1 vccd1 vccd1 _0567_ sky130_fd_sc_hd__or2_2
X_1404_ _0547_ _0625_ _0545_ vssd1 vssd1 vccd1 vccd1 _0636_ sky130_fd_sc_hd__a21o_1
XANTENNA_clkbuf_3_0__f_clk_A clknet_0_clk vssd1 vssd1 vccd1 vccd1 sky130_fd_sc_hd__diode_2
XFILLER_5_281 vccd1 vssd1 vccd1 vssd1 sky130_ef_sc_hd__decap_40_12
X_1197_ _0414_ _0428_ vssd1 vssd1 vccd1 vccd1 _0429_ sky130_fd_sc_hd__nand2b_1
XFILLER_36_163 vssd1 vssd1 vccd1 vccd1 sky130_fd_sc_hd__fill_1
XFILLER_36_141 vssd1 vssd1 vccd1 vccd1 sky130_fd_sc_hd__fill_8
Xinput2 gpio_in[0] vssd1 vssd1 vccd1 vccd1 net2 sky130_fd_sc_hd__clkbuf_1
X_1266_ _0491_ _0497_ vssd1 vssd1 vccd1 vccd1 _0498_ sky130_fd_sc_hd__and2_1
XFILLER_10_23 vssd1 vssd1 vccd1 vccd1 sky130_fd_sc_hd__fill_4
XFILLER_10_89 vssd1 vssd1 vccd1 vccd1 sky130_fd_sc_hd__fill_2
XFILLER_42_133 vssd1 vssd1 vccd1 vccd1 sky130_fd_sc_hd__fill_4
XTAP_TAPCELL_ROW_40_301 vssd1 vccd1 sky130_fd_sc_hd__tapvpwrvgnd_1
XFILLER_35_97 vssd1 vssd1 vccd1 vccd1 sky130_fd_sc_hd__fill_1
XFILLER_35_75 vssd1 vssd1 vccd1 vccd1 sky130_fd_sc_hd__fill_1
XFILLER_35_42 vccd1 vssd1 vccd1 vssd1 sky130_ef_sc_hd__decap_40_12
XFILLER_27_163 vssd1 vssd1 vccd1 vccd1 sky130_fd_sc_hd__fill_4
XFILLER_2_295 vssd1 vssd1 vccd1 vccd1 sky130_fd_sc_hd__fill_1
XFILLER_2_251 vssd1 vssd1 vccd1 vccd1 sky130_fd_sc_hd__fill_1
X_1120_ net134 net31 _0297_ _0302_ vssd1 vssd1 vccd1 vccd1 _0352_ sky130_fd_sc_hd__o2bb2a_1
X_1051_ _0266_ _0282_ _0271_ vssd1 vssd1 vccd1 vccd1 _0283_ sky130_fd_sc_hd__a21oi_1
XFILLER_33_188 vssd1 vssd1 vccd1 vccd1 sky130_fd_sc_hd__fill_8
X_0904_ STOPWATCH_INST.digit_scanner.period_counter\[5\] STOPWATCH_INST.digit_scanner.period_counter\[4\]
+ _0118_ net182 vssd1 vssd1 vccd1 vccd1 _0153_ sky130_fd_sc_hd__a31o_1
X_0835_ STOPWATCH_INST.bcd_num\[2\] STOPWATCH_INST.bcd_num\[3\] vssd1 vssd1 vccd1
+ vccd1 _0103_ sky130_fd_sc_hd__nand2b_1
X_1318_ _0510_ net24 _0549_ vssd1 vssd1 vccd1 vccd1 _0550_ sky130_fd_sc_hd__and3_1
X_1249_ _0472_ _0477_ _0480_ vssd1 vssd1 vccd1 vccd1 _0481_ sky130_fd_sc_hd__o21a_1
XFILLER_46_85 vssd1 vssd1 vccd1 vccd1 sky130_fd_sc_hd__fill_2
XPHY_EDGE_ROW_6_Left_53 vssd1 vssd1 vccd1 vccd1 sky130_fd_sc_hd__decap_3
Xmax_cap20 _0593_ vssd1 vssd1 vccd1 vccd1 net20 sky130_fd_sc_hd__clkbuf_2
X_1103_ _0266_ _0334_ vssd1 vssd1 vccd1 vccd1 _0335_ sky130_fd_sc_hd__xnor2_2
X_1034_ _0226_ _0265_ _0257_ _0231_ vssd1 vssd1 vccd1 vccd1 _0266_ sky130_fd_sc_hd__a2bb2o_2
XTAP_TAPCELL_ROW_16_183 vssd1 vccd1 sky130_fd_sc_hd__tapvpwrvgnd_1
XFILLER_21_125 vssd1 vssd1 vccd1 vccd1 sky130_fd_sc_hd__fill_4
XFILLER_21_169 vssd1 vssd1 vccd1 vccd1 sky130_fd_sc_hd__fill_8
X_0818_ STOPWATCH_INST.bcd_num\[1\] STOPWATCH_INST.bcd_num\[0\] vssd1 vssd1 vccd1
+ vccd1 _0089_ sky130_fd_sc_hd__and2b_1
XFILLER_44_206 vccd1 vssd1 vccd1 vssd1 sky130_ef_sc_hd__decap_40_12
XFILLER_29_269 vssd1 vssd1 vccd1 vccd1 sky130_fd_sc_hd__fill_8
XFILLER_29_225 vssd1 vssd1 vccd1 vccd1 sky130_fd_sc_hd__fill_2
XTAP_TAPCELL_ROW_39_297 vssd1 vccd1 sky130_fd_sc_hd__tapvpwrvgnd_1
XPHY_EDGE_ROW_32_Left_79 vssd1 vssd1 vccd1 vccd1 sky130_fd_sc_hd__decap_3
XFILLER_12_147 vssd1 vssd1 vccd1 vccd1 sky130_fd_sc_hd__fill_1
XFILLER_12_169 vssd1 vssd1 vccd1 vccd1 sky130_fd_sc_hd__fill_2
XFILLER_16_66 vssd1 vssd1 vccd1 vccd1 sky130_fd_sc_hd__fill_8
XFILLER_32_65 vssd1 vssd1 vccd1 vccd1 sky130_fd_sc_hd__fill_4
XFILLER_20_180 vssd1 vssd1 vccd1 vccd1 sky130_fd_sc_hd__fill_4
XTAP_TAPCELL_ROW_13_164 vssd1 vccd1 sky130_fd_sc_hd__tapvpwrvgnd_1
X_1583_ clknet_3_3__leaf_clk net158 net54 vssd1 vssd1 vccd1 vccd1 STOPWATCH_INST.sync_pause.q
+ sky130_fd_sc_hd__dfrtp_1
XFILLER_34_294 vssd1 vssd1 vccd1 vccd1 sky130_fd_sc_hd__fill_4
XFILLER_34_250 vssd1 vssd1 vccd1 vccd1 sky130_fd_sc_hd__fill_2
X_1017_ _0065_ _0240_ _0067_ vssd1 vssd1 vccd1 vccd1 _0249_ sky130_fd_sc_hd__a21o_1
XTAP_TAPCELL_ROW_4_121 vssd1 vccd1 sky130_fd_sc_hd__tapvpwrvgnd_1
XFILLER_27_65 vccd1 vssd1 vccd1 vssd1 sky130_ef_sc_hd__decap_40_12
XFILLER_27_54 vssd1 vssd1 vccd1 vccd1 sky130_fd_sc_hd__fill_2
XTAP_TAPCELL_ROW_27_234 vssd1 vccd1 sky130_fd_sc_hd__tapvpwrvgnd_1
XFILLER_27_43 vssd1 vssd1 vccd1 vccd1 sky130_fd_sc_hd__fill_2
XFILLER_16_272 vssd1 vssd1 vccd1 vccd1 sky130_fd_sc_hd__fill_1
XFILLER_31_275 vssd1 vssd1 vccd1 vccd1 sky130_fd_sc_hd__fill_1
X_1635_ clknet_3_7__leaf_clk _0044_ net59 vssd1 vssd1 vccd1 vccd1 STOPWATCH_INST.clock_div.cycles\[19\]
+ sky130_fd_sc_hd__dfrtp_1
X_1566_ _0776_ vssd1 vssd1 vccd1 vccd1 _0777_ sky130_fd_sc_hd__inv_2
X_1497_ _0621_ net18 _0624_ vssd1 vssd1 vccd1 vccd1 _0720_ sky130_fd_sc_hd__a21oi_1
XFILLER_14_209 vssd1 vssd1 vccd1 vccd1 sky130_fd_sc_hd__fill_2
Xfanout24 net25 vssd1 vssd1 vccd1 vccd1 net24 sky130_fd_sc_hd__buf_8
Xfanout57 net59 vssd1 vssd1 vccd1 vccd1 net57 sky130_fd_sc_hd__buf_2
XFILLER_13_23 vssd1 vssd1 vccd1 vccd1 sky130_fd_sc_hd__fill_1
Xfanout35 net36 vssd1 vssd1 vccd1 vccd1 net35 sky130_fd_sc_hd__buf_2
XFILLER_22_253 vssd1 vssd1 vccd1 vccd1 sky130_fd_sc_hd__fill_2
Xfanout46 STOPWATCH_INST.clock_div.cycles\[16\] vssd1 vssd1 vccd1 vccd1 net46 sky130_fd_sc_hd__buf_2
XFILLER_38_53 vccd1 vssd1 vccd1 vssd1 sky130_ef_sc_hd__decap_40_12
XPHY_EDGE_ROW_35_Left_82 vssd1 vssd1 vccd1 vccd1 sky130_fd_sc_hd__decap_3
XFILLER_9_213 vssd1 vssd1 vccd1 vccd1 sky130_fd_sc_hd__fill_2
XFILLER_13_253 vssd1 vssd1 vccd1 vccd1 sky130_fd_sc_hd__fill_8
XFILLER_13_297 vssd1 vssd1 vccd1 vccd1 sky130_fd_sc_hd__fill_2
X_1420_ _0059_ net16 _0651_ net34 vssd1 vssd1 vccd1 vccd1 _0652_ sky130_fd_sc_hd__a211o_1
X_1351_ _0571_ _0572_ _0573_ _0574_ vssd1 vssd1 vccd1 vccd1 _0583_ sky130_fd_sc_hd__nor4_1
X_1282_ _0433_ _0512_ vssd1 vssd1 vccd1 vccd1 _0514_ sky130_fd_sc_hd__xnor2_1
XTAP_TAPCELL_ROW_21_207 vssd1 vccd1 sky130_fd_sc_hd__tapvpwrvgnd_1
X_1618_ clknet_3_5__leaf_clk _0027_ net57 vssd1 vssd1 vccd1 vccd1 STOPWATCH_INST.clock_div.cycles\[2\]
+ sky130_fd_sc_hd__dfrtp_1
X_0997_ STOPWATCH_INST.clock_div.cycles\[18\] _0220_ vssd1 vssd1 vccd1 vccd1 _0229_
+ sky130_fd_sc_hd__xnor2_2
X_1549_ STOPWATCH_INST.clock_div.cycles\[23\] _0758_ vssd1 vssd1 vccd1 vccd1 _0765_
+ sky130_fd_sc_hd__nand2_1
XFILLER_10_223 vssd1 vssd1 vccd1 vccd1 sky130_fd_sc_hd__fill_2
XFILLER_40_65 vccd1 vssd1 vccd1 vssd1 sky130_ef_sc_hd__decap_40_12
X_0920_ _0161_ net167 vssd1 vssd1 vccd1 vccd1 _0021_ sky130_fd_sc_hd__nor2_1
X_0851_ STOPWATCH_INST.bcd_num\[1\] _0088_ _0091_ _0112_ vssd1 vssd1 vccd1 vccd1 _0116_
+ sky130_fd_sc_hd__a2bb2o_1
X_1334_ _0503_ net140 _0489_ vssd1 vssd1 vccd1 vccd1 _0566_ sky130_fd_sc_hd__a21oi_1
XFILLER_28_109 vssd1 vssd1 vccd1 vccd1 sky130_fd_sc_hd__fill_1
X_1403_ _0633_ _0634_ vssd1 vssd1 vccd1 vccd1 _0635_ sky130_fd_sc_hd__nand2_1
XFILLER_5_293 vssd1 vssd1 vccd1 vccd1 sky130_fd_sc_hd__fill_1
XPHY_EDGE_ROW_18_Right_18 vssd1 vssd1 vccd1 vccd1 sky130_fd_sc_hd__decap_3
X_1265_ STOPWATCH_INST.clock_div.cycles\[9\] _0490_ _0495_ vssd1 vssd1 vccd1 vccd1
+ _0497_ sky130_fd_sc_hd__or3_1
X_1196_ _0335_ net125 _0405_ _0333_ vssd1 vssd1 vccd1 vccd1 _0428_ sky130_fd_sc_hd__a31o_1
XPHY_EDGE_ROW_27_Right_27 vssd1 vssd1 vccd1 vccd1 sky130_fd_sc_hd__decap_3
Xinput3 gpio_in[1] vssd1 vssd1 vccd1 vccd1 net3 sky130_fd_sc_hd__clkbuf_1
XPHY_EDGE_ROW_36_Right_36 vssd1 vssd1 vccd1 vccd1 sky130_fd_sc_hd__decap_3
XANTENNA_fanout53_A net59 vssd1 vssd1 vccd1 vccd1 sky130_fd_sc_hd__diode_2
XPHY_EDGE_ROW_45_Right_45 vssd1 vssd1 vccd1 vccd1 sky130_fd_sc_hd__decap_3
XTAP_TAPCELL_ROW_40_302 vssd1 vccd1 sky130_fd_sc_hd__tapvpwrvgnd_1
XFILLER_35_54 vssd1 vssd1 vccd1 vccd1 sky130_fd_sc_hd__fill_2
XFILLER_2_241 vssd1 vssd1 vccd1 vccd1 sky130_fd_sc_hd__fill_8
X_1050_ _0274_ _0276_ _0278_ _0279_ _0265_ vssd1 vssd1 vccd1 vccd1 _0282_ sky130_fd_sc_hd__a2111o_1
XFILLER_18_131 vssd1 vssd1 vccd1 vccd1 sky130_fd_sc_hd__fill_2
XFILLER_18_197 vssd1 vssd1 vccd1 vccd1 sky130_fd_sc_hd__fill_4
XFILLER_33_167 vssd1 vssd1 vccd1 vccd1 sky130_fd_sc_hd__fill_1
X_0834_ STOPWATCH_INST.digit_scanner.ctrl _0100_ _0102_ vssd1 vssd1 vccd1 vccd1 net7
+ sky130_fd_sc_hd__o21ai_1
X_0903_ STOPWATCH_INST.digit_scanner.period_counter\[5\] STOPWATCH_INST.digit_scanner.period_counter\[4\]
+ STOPWATCH_INST.digit_scanner.period_counter\[6\] _0118_ vssd1 vssd1 vccd1 vccd1
+ _0152_ sky130_fd_sc_hd__and4_1
X_1248_ _0424_ _0470_ _0478_ _0419_ vssd1 vssd1 vccd1 vccd1 _0480_ sky130_fd_sc_hd__a31o_1
X_1317_ _0524_ _0544_ vssd1 vssd1 vccd1 vccd1 _0549_ sky130_fd_sc_hd__nand2_1
X_1179_ _0402_ _0410_ vssd1 vssd1 vccd1 vccd1 _0411_ sky130_fd_sc_hd__and2_1
XFILLER_24_178 vccd1 vssd1 vccd1 vssd1 sky130_ef_sc_hd__decap_40_12
XFILLER_46_97 vssd1 vssd1 vccd1 vccd1 sky130_fd_sc_hd__fill_4
Xmax_cap21 _0590_ vssd1 vssd1 vccd1 vccd1 net21 sky130_fd_sc_hd__clkbuf_1
X_1102_ _0312_ _0314_ _0331_ vssd1 vssd1 vccd1 vccd1 _0334_ sky130_fd_sc_hd__a21oi_1
XFILLER_46_281 vssd1 vssd1 vccd1 vccd1 sky130_fd_sc_hd__fill_2
X_1033_ _0228_ _0259_ vssd1 vssd1 vccd1 vccd1 _0265_ sky130_fd_sc_hd__and2_1
X_0817_ STOPWATCH_INST.bcd_num\[3\] STOPWATCH_INST.bcd_num\[2\] vssd1 vssd1 vccd1
+ vccd1 _0088_ sky130_fd_sc_hd__or2_1
XFILLER_44_218 vccd1 vssd1 vccd1 vssd1 sky130_ef_sc_hd__decap_40_12
XTAP_TAPCELL_ROW_39_298 vssd1 vccd1 sky130_fd_sc_hd__tapvpwrvgnd_1
XFILLER_37_281 vssd1 vssd1 vccd1 vccd1 sky130_fd_sc_hd__fill_4
XPHY_EDGE_ROW_0_Right_0 vssd1 vssd1 vccd1 vccd1 sky130_fd_sc_hd__decap_3
XFILLER_8_108 vssd1 vssd1 vccd1 vccd1 sky130_fd_sc_hd__fill_4
XFILLER_20_192 vssd1 vssd1 vccd1 vccd1 sky130_fd_sc_hd__fill_4
XFILLER_35_229 vssd1 vssd1 vccd1 vccd1 sky130_fd_sc_hd__fill_4
XTAP_TAPCELL_ROW_13_165 vssd1 vccd1 sky130_fd_sc_hd__tapvpwrvgnd_1
X_1582_ clknet_3_3__leaf_clk net156 net54 vssd1 vssd1 vccd1 vccd1 STOPWATCH_INST.sync_pause.sync_2
+ sky130_fd_sc_hd__dfrtp_1
XTAP_TAPCELL_ROW_36_279 vssd1 vccd1 sky130_fd_sc_hd__tapvpwrvgnd_1
X_1016_ _0244_ _0247_ vssd1 vssd1 vccd1 vccd1 _0248_ sky130_fd_sc_hd__or2_1
XTAP_TAPCELL_ROW_4_122 vssd1 vccd1 sky130_fd_sc_hd__tapvpwrvgnd_1
XTAP_TAPCELL_ROW_27_235 vssd1 vccd1 sky130_fd_sc_hd__tapvpwrvgnd_1
XFILLER_27_77 vssd1 vssd1 vccd1 vccd1 sky130_fd_sc_hd__fill_2
XFILLER_25_240 vssd1 vssd1 vccd1 vccd1 sky130_fd_sc_hd__fill_2
XFILLER_40_276 vccd1 vssd1 vccd1 vssd1 sky130_ef_sc_hd__decap_40_12
XFILLER_40_298 vssd1 vssd1 vccd1 vccd1 sky130_fd_sc_hd__fill_1
XFILLER_40_221 vssd1 vssd1 vccd1 vccd1 sky130_fd_sc_hd__fill_4
XFILLER_25_295 vssd1 vssd1 vccd1 vccd1 sky130_fd_sc_hd__fill_4
XFILLER_16_251 vssd1 vssd1 vccd1 vccd1 sky130_fd_sc_hd__fill_1
XFILLER_31_298 vssd1 vssd1 vccd1 vccd1 sky130_fd_sc_hd__fill_1
X_1634_ clknet_3_7__leaf_clk _0043_ net58 vssd1 vssd1 vccd1 vccd1 STOPWATCH_INST.clock_div.cycles\[18\]
+ sky130_fd_sc_hd__dfrtp_4
X_1496_ net38 _0716_ _0719_ net40 net47 vssd1 vssd1 vccd1 vccd1 _0040_ sky130_fd_sc_hd__a32o_1
X_1565_ _0196_ _0772_ vssd1 vssd1 vccd1 vccd1 _0776_ sky130_fd_sc_hd__nor2_1
Xfanout25 _0534_ vssd1 vssd1 vccd1 vccd1 net25 sky130_fd_sc_hd__buf_8
XTAP_TAPCELL_ROW_32_260 vssd1 vccd1 sky130_fd_sc_hd__tapvpwrvgnd_1
XFILLER_13_57 vssd1 vssd1 vccd1 vccd1 sky130_fd_sc_hd__fill_2
Xfanout47 STOPWATCH_INST.clock_div.cycles\[15\] vssd1 vssd1 vccd1 vccd1 net47 sky130_fd_sc_hd__clkbuf_2
Xfanout58 net59 vssd1 vssd1 vccd1 vccd1 net58 sky130_fd_sc_hd__clkbuf_4
Xfanout36 _0184_ vssd1 vssd1 vccd1 vccd1 net36 sky130_fd_sc_hd__clkbuf_4
XFILLER_38_65 vssd1 vssd1 vccd1 vccd1 sky130_fd_sc_hd__fill_2
XFILLER_1_169 vssd1 vssd1 vccd1 vccd1 sky130_fd_sc_hd__fill_8
XFILLER_13_221 vssd1 vssd1 vccd1 vccd1 sky130_fd_sc_hd__fill_2
X_1281_ _0439_ _0506_ _0478_ _0433_ vssd1 vssd1 vccd1 vccd1 _0513_ sky130_fd_sc_hd__o211a_1
X_1350_ _0575_ _0577_ _0579_ _0580_ vssd1 vssd1 vccd1 vccd1 _0582_ sky130_fd_sc_hd__nor4_1
XTAP_TAPCELL_ROW_46_330 vssd1 vccd1 sky130_fd_sc_hd__tapvpwrvgnd_1
XFILLER_0_191 vssd1 vssd1 vccd1 vccd1 sky130_fd_sc_hd__fill_1
X_0996_ STOPWATCH_INST.clock_div.cycles\[20\] _0227_ vssd1 vssd1 vccd1 vccd1 _0228_
+ sky130_fd_sc_hd__xnor2_2
XTAP_TAPCELL_ROW_21_208 vssd1 vccd1 sky130_fd_sc_hd__tapvpwrvgnd_1
X_1617_ clknet_3_5__leaf_clk _0026_ net57 vssd1 vssd1 vccd1 vccd1 STOPWATCH_INST.clock_div.cycles\[1\]
+ sky130_fd_sc_hd__dfrtp_1
XFILLER_39_162 vssd1 vssd1 vccd1 vccd1 sky130_fd_sc_hd__fill_1
X_1479_ net48 _0698_ vssd1 vssd1 vccd1 vccd1 _0705_ sky130_fd_sc_hd__nand2_1
X_1548_ STOPWATCH_INST.clock_div.cycles\[23\] _0758_ vssd1 vssd1 vccd1 vccd1 _0764_
+ sky130_fd_sc_hd__or2_1
XFILLER_40_77 vssd1 vssd1 vccd1 vccd1 sky130_fd_sc_hd__fill_4
XFILLER_45_165 vssd1 vssd1 vccd1 vccd1 sky130_fd_sc_hd__fill_2
X_0850_ _0084_ _0109_ STOPWATCH_INST.bcd_num\[5\] vssd1 vssd1 vccd1 vccd1 _0115_ sky130_fd_sc_hd__o21ai_1
X_1402_ _0597_ _0631_ _0555_ vssd1 vssd1 vccd1 vccd1 _0634_ sky130_fd_sc_hd__a21o_1
X_1333_ _0538_ _0557_ _0548_ _0564_ vssd1 vssd1 vccd1 vccd1 _0565_ sky130_fd_sc_hd__or4_4
Xinput4 gpio_in[2] vssd1 vssd1 vccd1 vccd1 net4 sky130_fd_sc_hd__clkbuf_1
X_1264_ _0490_ _0495_ vssd1 vssd1 vccd1 vccd1 _0496_ sky130_fd_sc_hd__or2_1
X_1195_ _0426_ vssd1 vssd1 vccd1 vccd1 _0427_ sky130_fd_sc_hd__inv_2
X_0979_ STOPWATCH_INST.clock_div.cycles\[23\] _0210_ vssd1 vssd1 vccd1 vccd1 _0211_
+ sky130_fd_sc_hd__xnor2_2
XANTENNA__1459__B1 _0185_ vssd1 vssd1 vccd1 vccd1 sky130_fd_sc_hd__diode_2
XTAP_TAPCELL_ROW_40_303 vssd1 vccd1 sky130_fd_sc_hd__tapvpwrvgnd_1
XFILLER_2_253 vccd1 vssd1 vccd1 vssd1 sky130_ef_sc_hd__decap_40_12
X_0833_ STOPWATCH_INST.bcd_num\[4\] STOPWATCH_INST.D0_AN_0 _0101_ vssd1 vssd1 vccd1
+ vccd1 _0102_ sky130_fd_sc_hd__or3_1
X_0902_ net175 _0150_ vssd1 vssd1 vccd1 vccd1 _0014_ sky130_fd_sc_hd__xnor2_1
X_1247_ _0470_ _0478_ vssd1 vssd1 vccd1 vccd1 _0479_ sky130_fd_sc_hd__nand2_2
X_1178_ _0406_ _0409_ _0333_ vssd1 vssd1 vccd1 vccd1 _0410_ sky130_fd_sc_hd__nor3b_1
X_1316_ _0541_ _0542_ _0546_ _0545_ _0521_ vssd1 vssd1 vccd1 vccd1 _0548_ sky130_fd_sc_hd__a2111o_1
XFILLER_21_57 vssd1 vssd1 vccd1 vccd1 sky130_fd_sc_hd__fill_2
XFILLER_46_76 vssd1 vssd1 vccd1 vccd1 sky130_fd_sc_hd__fill_4
XFILLER_15_113 vssd1 vssd1 vccd1 vccd1 sky130_fd_sc_hd__fill_1
Xmax_cap22 net23 vssd1 vssd1 vccd1 vccd1 net22 sky130_fd_sc_hd__buf_1
XFILLER_30_127 vssd1 vssd1 vccd1 vccd1 sky130_fd_sc_hd__fill_4
XFILLER_30_116 vssd1 vssd1 vccd1 vccd1 sky130_fd_sc_hd__fill_1
XFILLER_11_90 vssd1 vssd1 vccd1 vccd1 sky130_fd_sc_hd__fill_4
X_1101_ _0270_ _0332_ vssd1 vssd1 vccd1 vccd1 _0333_ sky130_fd_sc_hd__xor2_1
X_1032_ _0263_ vssd1 vssd1 vccd1 vccd1 _0264_ sky130_fd_sc_hd__inv_2
XFILLER_21_105 vssd1 vssd1 vccd1 vccd1 sky130_fd_sc_hd__fill_4
X_0816_ STOPWATCH_INST.bcd_num\[3\] STOPWATCH_INST.bcd_num\[2\] vssd1 vssd1 vccd1
+ vccd1 _0087_ sky130_fd_sc_hd__nor2_1
XFILLER_35_219 vssd1 vssd1 vccd1 vccd1 sky130_fd_sc_hd__fill_4
XFILLER_7_164 vssd1 vssd1 vccd1 vccd1 sky130_fd_sc_hd__fill_4
XFILLER_11_160 vssd1 vssd1 vccd1 vccd1 sky130_fd_sc_hd__fill_2
X_1581_ clknet_3_2__leaf_clk net5 net54 vssd1 vssd1 vccd1 vccd1 STOPWATCH_INST.sync_clear.sync_1
+ sky130_fd_sc_hd__dfrtp_1
XTAP_TAPCELL_ROW_13_166 vssd1 vccd1 sky130_fd_sc_hd__tapvpwrvgnd_1
XFILLER_21_3 vssd1 vssd1 vccd1 vccd1 sky130_fd_sc_hd__fill_4
X_1015_ _0179_ _0202_ _0246_ STOPWATCH_INST.clock_div.cycles\[26\] vssd1 vssd1 vccd1
+ vccd1 _0247_ sky130_fd_sc_hd__a22oi_2
XTAP_TAPCELL_ROW_4_123 vssd1 vccd1 sky130_fd_sc_hd__tapvpwrvgnd_1
XFILLER_43_55 vssd1 vssd1 vccd1 vccd1 sky130_fd_sc_hd__fill_1
XTAP_TAPCELL_ROW_27_236 vssd1 vccd1 sky130_fd_sc_hd__tapvpwrvgnd_1
XFILLER_40_288 vssd1 vssd1 vccd1 vccd1 sky130_fd_sc_hd__fill_8
XFILLER_4_178 vssd1 vssd1 vccd1 vccd1 sky130_fd_sc_hd__fill_2
XFILLER_4_145 vssd1 vssd1 vccd1 vccd1 sky130_fd_sc_hd__fill_2
XFILLER_4_27 vssd1 vssd1 vccd1 vccd1 sky130_fd_sc_hd__fill_1
X_1564_ STOPWATCH_INST.clock_div.cycles\[26\] STOPWATCH_INST.clock_div.cycles\[27\]
+ _0770_ STOPWATCH_INST.clock_div.cycles\[28\] vssd1 vssd1 vccd1 vccd1 _0775_ sky130_fd_sc_hd__a31o_1
X_1633_ clknet_3_6__leaf_clk _0042_ net58 vssd1 vssd1 vccd1 vccd1 STOPWATCH_INST.clock_div.cycles\[17\]
+ sky130_fd_sc_hd__dfrtp_4
XTAP_TAPCELL_ROW_1_104 vssd1 vccd1 sky130_fd_sc_hd__tapvpwrvgnd_1
X_1495_ _0717_ _0718_ net35 vssd1 vssd1 vccd1 vccd1 _0719_ sky130_fd_sc_hd__o21ai_1
Xfanout26 _0475_ vssd1 vssd1 vccd1 vccd1 net26 sky130_fd_sc_hd__buf_6
Xfanout37 net38 vssd1 vssd1 vccd1 vccd1 net37 sky130_fd_sc_hd__buf_2
XTAP_TAPCELL_ROW_32_261 vssd1 vccd1 sky130_fd_sc_hd__tapvpwrvgnd_1
Xfanout59 STOPWATCH_INST.clock_div.n_rst vssd1 vssd1 vccd1 vccd1 net59 sky130_fd_sc_hd__buf_2
Xfanout48 STOPWATCH_INST.clock_div.cycles\[13\] vssd1 vssd1 vccd1 vccd1 net48 sky130_fd_sc_hd__clkbuf_2
XFILLER_22_255 vssd1 vssd1 vccd1 vccd1 sky130_fd_sc_hd__fill_1
XFILLER_22_277 vssd1 vssd1 vccd1 vccd1 sky130_fd_sc_hd__fill_4
XFILLER_1_137 vssd1 vssd1 vccd1 vccd1 sky130_fd_sc_hd__fill_2
XFILLER_8_7 vssd1 vssd1 vccd1 vccd1 sky130_fd_sc_hd__fill_1
XFILLER_9_215 vssd1 vssd1 vccd1 vccd1 sky130_fd_sc_hd__fill_1
XFILLER_9_248 vccd1 vssd1 vccd1 vssd1 sky130_ef_sc_hd__decap_40_12
X_1280_ _0439_ _0506_ _0478_ vssd1 vssd1 vccd1 vccd1 _0512_ sky130_fd_sc_hd__o21ai_1
XFILLER_0_181 vssd1 vssd1 vccd1 vccd1 sky130_fd_sc_hd__fill_8
XTAP_TAPCELL_ROW_46_331 vssd1 vccd1 sky130_fd_sc_hd__tapvpwrvgnd_1
X_0995_ net45 _0200_ _0206_ _0198_ vssd1 vssd1 vccd1 vccd1 _0227_ sky130_fd_sc_hd__o22a_1
XFILLER_5_70 vssd1 vssd1 vccd1 vccd1 sky130_fd_sc_hd__fill_4
X_1616_ clknet_3_4__leaf_clk _0025_ net57 vssd1 vssd1 vccd1 vccd1 STOPWATCH_INST.clock_div.cycles\[0\]
+ sky130_fd_sc_hd__dfrtp_1
X_1547_ _0761_ _0762_ vssd1 vssd1 vccd1 vccd1 _0763_ sky130_fd_sc_hd__or2_4
X_1478_ net48 _0698_ vssd1 vssd1 vccd1 vccd1 _0704_ sky130_fd_sc_hd__or2_1
XFILLER_24_57 vssd1 vssd1 vccd1 vccd1 sky130_fd_sc_hd__fill_2
XFILLER_10_258 vccd1 vssd1 vccd1 vssd1 sky130_ef_sc_hd__decap_40_12
XFILLER_45_111 vssd1 vssd1 vccd1 vccd1 sky130_fd_sc_hd__fill_1
X_1401_ _0555_ _0597_ _0631_ vssd1 vssd1 vccd1 vccd1 _0633_ sky130_fd_sc_hd__nand3_1
X_1194_ _0423_ _0425_ vssd1 vssd1 vccd1 vccd1 _0426_ sky130_fd_sc_hd__and2_1
X_1332_ _0530_ _0559_ _0561_ _0562_ _0558_ vssd1 vssd1 vccd1 vccd1 _0564_ sky130_fd_sc_hd__a221o_1
Xinput5 gpio_in[3] vssd1 vssd1 vccd1 vccd1 net5 sky130_fd_sc_hd__clkbuf_1
X_1263_ STOPWATCH_INST.clock_div.cycles\[10\] net26 net27 vssd1 vssd1 vccd1 vccd1
+ _0495_ sky130_fd_sc_hd__and3_1
X_0978_ _0198_ _0206_ _0209_ _0166_ vssd1 vssd1 vccd1 vccd1 _0210_ sky130_fd_sc_hd__o22a_1
XFILLER_42_158 vssd1 vssd1 vccd1 vccd1 sky130_fd_sc_hd__fill_4
XFILLER_2_265 vccd1 vssd1 vccd1 vssd1 sky130_ef_sc_hd__decap_40_12
XFILLER_33_169 vssd1 vssd1 vccd1 vccd1 sky130_fd_sc_hd__fill_1
XFILLER_33_136 vssd1 vssd1 vccd1 vccd1 sky130_fd_sc_hd__fill_2
X_0832_ STOPWATCH_INST.bcd_num\[7\] net50 net51 vssd1 vssd1 vccd1 vccd1 _0101_ sky130_fd_sc_hd__or3b_1
X_0901_ _0123_ _0150_ _0151_ vssd1 vssd1 vccd1 vccd1 _0013_ sky130_fd_sc_hd__and3_1
X_1315_ _0545_ _0546_ vssd1 vssd1 vccd1 vccd1 _0547_ sky130_fd_sc_hd__nor2_1
X_1246_ net130 net27 vssd1 vssd1 vccd1 vccd1 _0478_ sky130_fd_sc_hd__nand2_1
X_1177_ _0335_ _0408_ vssd1 vssd1 vccd1 vccd1 _0409_ sky130_fd_sc_hd__xor2_2
XFILLER_2_60 vssd1 vssd1 vccd1 vccd1 sky130_fd_sc_hd__fill_8
XTAP_TAPCELL_ROW_19_194 vssd1 vccd1 sky130_fd_sc_hd__tapvpwrvgnd_1
XFILLER_46_55 vssd1 vssd1 vccd1 vccd1 sky130_fd_sc_hd__fill_1
Xmax_cap23 _0582_ vssd1 vssd1 vccd1 vccd1 net23 sky130_fd_sc_hd__buf_1
XFILLER_23_7 vssd1 vssd1 vccd1 vccd1 sky130_fd_sc_hd__fill_2
XFILLER_46_294 vssd1 vssd1 vccd1 vccd1 sky130_fd_sc_hd__fill_2
XFILLER_46_272 vssd1 vssd1 vccd1 vccd1 sky130_fd_sc_hd__fill_4
X_1100_ net134 net31 _0331_ _0267_ vssd1 vssd1 vccd1 vccd1 _0332_ sky130_fd_sc_hd__o2bb2a_1
X_1031_ net124 _0262_ vssd1 vssd1 vccd1 vccd1 _0263_ sky130_fd_sc_hd__xnor2_2
X_0815_ net51 net52 _0084_ _0085_ STOPWATCH_INST.digit_scanner.ctrl vssd1 vssd1 vccd1
+ vccd1 _0086_ sky130_fd_sc_hd__o311a_1
X_1229_ _0061_ net28 vssd1 vssd1 vccd1 vccd1 _0461_ sky130_fd_sc_hd__xnor2_1
XFILLER_32_57 vssd1 vssd1 vccd1 vccd1 sky130_fd_sc_hd__fill_2
XFILLER_43_297 vssd1 vssd1 vccd1 vccd1 sky130_fd_sc_hd__fill_2
XFILLER_43_253 vccd1 vssd1 vccd1 vssd1 sky130_ef_sc_hd__decap_40_12
XFILLER_28_294 vssd1 vssd1 vccd1 vccd1 sky130_fd_sc_hd__fill_4
X_1580_ clknet_3_3__leaf_clk net160 net54 vssd1 vssd1 vccd1 vccd1 STOPWATCH_INST.sync_clear.q
+ sky130_fd_sc_hd__dfrtp_1
XTAP_TAPCELL_ROW_13_167 vssd1 vccd1 sky130_fd_sc_hd__tapvpwrvgnd_1
XFILLER_22_90 vssd1 vssd1 vccd1 vccd1 sky130_fd_sc_hd__fill_2
XFILLER_14_3 vssd1 vssd1 vccd1 vccd1 sky130_fd_sc_hd__fill_1
XFILLER_34_253 vssd1 vssd1 vccd1 vccd1 sky130_fd_sc_hd__fill_4
X_1014_ net123 net42 _0202_ vssd1 vssd1 vccd1 vccd1 _0246_ sky130_fd_sc_hd__or3b_1
XFILLER_27_57 vssd1 vssd1 vccd1 vccd1 sky130_fd_sc_hd__fill_4
XFILLER_40_256 vssd1 vssd1 vccd1 vccd1 sky130_fd_sc_hd__fill_1
XFILLER_40_234 vssd1 vssd1 vccd1 vccd1 sky130_fd_sc_hd__fill_4
XTAP_TAPCELL_ROW_27_237 vssd1 vccd1 sky130_fd_sc_hd__tapvpwrvgnd_1
XFILLER_25_253 vssd1 vssd1 vccd1 vccd1 sky130_fd_sc_hd__fill_4
Xclone22 net25 vssd1 vssd1 vccd1 vccd1 net140 sky130_fd_sc_hd__clkbuf_1
Xclone11 _0534_ vssd1 vssd1 vccd1 vccd1 net129 sky130_fd_sc_hd__clkbuf_1
XFILLER_16_253 vssd1 vssd1 vccd1 vccd1 sky130_fd_sc_hd__fill_2
X_1494_ net47 _0711_ vssd1 vssd1 vccd1 vccd1 _0718_ sky130_fd_sc_hd__and2_1
X_1563_ STOPWATCH_INST.clock_div.cycles\[27\] net39 net36 _0774_ vssd1 vssd1 vccd1
+ vccd1 _0052_ sky130_fd_sc_hd__a22o_1
X_1632_ clknet_3_6__leaf_clk _0041_ net58 vssd1 vssd1 vccd1 vccd1 STOPWATCH_INST.clock_div.cycles\[16\]
+ sky130_fd_sc_hd__dfrtp_1
XTAP_TAPCELL_ROW_1_105 vssd1 vccd1 sky130_fd_sc_hd__tapvpwrvgnd_1
XANTENNA_clkbuf_3_3__f_clk_A clknet_0_clk vssd1 vssd1 vccd1 vccd1 sky130_fd_sc_hd__diode_2
Xfanout27 _0477_ vssd1 vssd1 vccd1 vccd1 net27 sky130_fd_sc_hd__clkbuf_4
Xfanout38 _0666_ vssd1 vssd1 vccd1 vccd1 net38 sky130_fd_sc_hd__clkbuf_2
Xfanout16 net19 vssd1 vssd1 vccd1 vccd1 net16 sky130_fd_sc_hd__buf_6
Xfanout49 STOPWATCH_INST.clock_div.cycles\[12\] vssd1 vssd1 vccd1 vccd1 net49 sky130_fd_sc_hd__buf_2
XFILLER_22_201 vssd1 vssd1 vccd1 vccd1 sky130_fd_sc_hd__fill_2
XTAP_TAPCELL_ROW_32_262 vssd1 vccd1 sky130_fd_sc_hd__tapvpwrvgnd_1
XFILLER_13_59 vssd1 vssd1 vccd1 vccd1 sky130_fd_sc_hd__fill_1
XFILLER_38_67 vssd1 vssd1 vccd1 vccd1 sky130_fd_sc_hd__fill_1
XFILLER_13_223 vssd1 vssd1 vccd1 vccd1 sky130_fd_sc_hd__fill_1
XFILLER_13_234 vccd1 vssd1 vccd1 vssd1 sky130_ef_sc_hd__decap_40_12
XTAP_TAPCELL_ROW_46_332 vssd1 vccd1 sky130_fd_sc_hd__tapvpwrvgnd_1
X_0994_ net44 _0225_ vssd1 vssd1 vccd1 vccd1 _0226_ sky130_fd_sc_hd__xnor2_1
X_1615_ clknet_3_1__leaf_clk _0024_ vssd1 vssd1 vccd1 vccd1 STOPWATCH_INST.digit_scanner.period_counter\[15\]
+ sky130_fd_sc_hd__dfxtp_1
X_1477_ _0614_ net16 _0701_ _0702_ net34 vssd1 vssd1 vccd1 vccd1 _0703_ sky130_fd_sc_hd__a311o_1
X_1546_ _0646_ net135 _0755_ _0184_ vssd1 vssd1 vccd1 vccd1 _0762_ sky130_fd_sc_hd__a31o_1
XFILLER_39_186 vssd1 vssd1 vccd1 vccd1 sky130_fd_sc_hd__fill_2
XFILLER_39_131 vssd1 vssd1 vccd1 vccd1 sky130_fd_sc_hd__fill_4
XFILLER_10_237 vssd1 vssd1 vccd1 vccd1 sky130_fd_sc_hd__fill_2
XFILLER_24_36 vssd1 vssd1 vccd1 vccd1 sky130_fd_sc_hd__fill_4
XPHY_EDGE_ROW_39_Left_86 vssd1 vssd1 vccd1 vccd1 sky130_fd_sc_hd__decap_3
XFILLER_45_167 vssd1 vssd1 vccd1 vccd1 sky130_fd_sc_hd__fill_1
X_1331_ _0561_ _0562_ vssd1 vssd1 vccd1 vccd1 _0563_ sky130_fd_sc_hd__nand2_1
X_1400_ _0597_ _0631_ vssd1 vssd1 vccd1 vccd1 _0632_ sky130_fd_sc_hd__nand2_1
X_1193_ _0416_ _0422_ vssd1 vssd1 vccd1 vccd1 _0425_ sky130_fd_sc_hd__nand2_1
X_1262_ _0457_ _0492_ vssd1 vssd1 vccd1 vccd1 _0494_ sky130_fd_sc_hd__xnor2_2
Xinput6 nrst vssd1 vssd1 vccd1 vccd1 net6 sky130_fd_sc_hd__clkbuf_1
XFILLER_10_27 vssd1 vssd1 vccd1 vccd1 sky130_fd_sc_hd__fill_1
X_0977_ net45 _0200_ STOPWATCH_INST.clock_div.cycles\[20\] vssd1 vssd1 vccd1 vccd1
+ _0209_ sky130_fd_sc_hd__o21a_1
X_1529_ _0185_ _0741_ _0742_ _0746_ vssd1 vssd1 vccd1 vccd1 _0748_ sky130_fd_sc_hd__a31o_1
XFILLER_42_137 vssd1 vssd1 vccd1 vccd1 sky130_fd_sc_hd__fill_2
XFILLER_35_57 vccd1 vssd1 vccd1 vssd1 sky130_ef_sc_hd__decap_40_12
XFILLER_27_167 vssd1 vssd1 vccd1 vccd1 sky130_fd_sc_hd__fill_1
XFILLER_27_134 vssd1 vssd1 vccd1 vccd1 sky130_fd_sc_hd__fill_1
XPHY_EDGE_ROW_14_Right_14 vssd1 vssd1 vccd1 vccd1 sky130_fd_sc_hd__decap_3
Xclkbuf_3_3__f_clk clknet_0_clk vssd1 vssd1 vccd1 vccd1 clknet_3_3__leaf_clk sky130_fd_sc_hd__clkbuf_16
XFILLER_2_277 vccd1 vssd1 vccd1 vssd1 sky130_ef_sc_hd__decap_40_12
XPHY_EDGE_ROW_23_Right_23 vssd1 vssd1 vccd1 vccd1 sky130_fd_sc_hd__decap_3
XFILLER_18_156 vssd1 vssd1 vccd1 vccd1 sky130_fd_sc_hd__fill_2
XPHY_EDGE_ROW_32_Right_32 vssd1 vssd1 vccd1 vccd1 sky130_fd_sc_hd__decap_3
X_0900_ STOPWATCH_INST.digit_scanner.period_counter\[4\] _0118_ vssd1 vssd1 vccd1
+ vccd1 _0151_ sky130_fd_sc_hd__or2_1
X_0831_ _0087_ _0097_ vssd1 vssd1 vccd1 vccd1 _0100_ sky130_fd_sc_hd__nand2_1
XPHY_EDGE_ROW_41_Right_41 vssd1 vssd1 vccd1 vccd1 sky130_fd_sc_hd__decap_3
X_1314_ net140 _0544_ _0522_ vssd1 vssd1 vccd1 vccd1 _0546_ sky130_fd_sc_hd__a21oi_1
X_1245_ _0374_ _0476_ vssd1 vssd1 vccd1 vccd1 _0477_ sky130_fd_sc_hd__xnor2_2
X_1176_ net125 _0405_ vssd1 vssd1 vccd1 vccd1 _0408_ sky130_fd_sc_hd__nand2_1
XTAP_TAPCELL_ROW_19_195 vssd1 vccd1 sky130_fd_sc_hd__tapvpwrvgnd_1
XFILLER_21_59 vssd1 vssd1 vccd1 vccd1 sky130_fd_sc_hd__fill_1
XFILLER_46_34 vccd1 vssd1 vccd1 vssd1 sky130_ef_sc_hd__decap_40_12
XFILLER_46_12 vccd1 vssd1 vccd1 vssd1 sky130_ef_sc_hd__decap_40_12
XFILLER_46_251 vssd1 vssd1 vccd1 vccd1 sky130_fd_sc_hd__fill_1
X_1030_ _0204_ _0212_ _0260_ _0203_ vssd1 vssd1 vccd1 vccd1 _0262_ sky130_fd_sc_hd__o31a_1
X_0814_ net51 STOPWATCH_INST.bcd_num\[7\] net50 net52 vssd1 vssd1 vccd1 vccd1 _0085_
+ sky130_fd_sc_hd__or4b_1
XFILLER_14_192 vssd1 vssd1 vccd1 vccd1 sky130_fd_sc_hd__fill_4
XFILLER_21_129 vssd1 vssd1 vccd1 vccd1 sky130_fd_sc_hd__fill_2
XPHY_EDGE_ROW_26_Left_73 vssd1 vssd1 vccd1 vccd1 sky130_fd_sc_hd__decap_3
XPHY_EDGE_ROW_10_Left_57 vssd1 vssd1 vccd1 vccd1 sky130_fd_sc_hd__decap_3
X_1228_ net122 _0458_ vssd1 vssd1 vccd1 vccd1 _0460_ sky130_fd_sc_hd__xnor2_2
XFILLER_29_207 vssd1 vssd1 vccd1 vccd1 sky130_fd_sc_hd__fill_2
XFILLER_37_262 vssd1 vssd1 vccd1 vccd1 sky130_fd_sc_hd__fill_2
X_1159_ _0345_ _0390_ _0384_ _0382_ vssd1 vssd1 vccd1 vccd1 _0391_ sky130_fd_sc_hd__or4_4
XFILLER_32_69 vssd1 vssd1 vccd1 vccd1 sky130_fd_sc_hd__fill_2
XFILLER_20_184 vssd1 vssd1 vccd1 vccd1 sky130_fd_sc_hd__fill_1
XTAP_TAPCELL_ROW_38_290 vssd1 vccd1 sky130_fd_sc_hd__tapvpwrvgnd_1
XFILLER_43_265 vccd1 vssd1 vccd1 vssd1 sky130_ef_sc_hd__decap_40_12
XTAP_TAPCELL_ROW_13_168 vssd1 vccd1 sky130_fd_sc_hd__tapvpwrvgnd_1
XFILLER_7_133 vssd1 vssd1 vccd1 vccd1 sky130_fd_sc_hd__fill_2
XFILLER_34_298 vssd1 vssd1 vccd1 vccd1 sky130_fd_sc_hd__fill_1
XFILLER_34_210 vccd1 vssd1 vccd1 vssd1 sky130_ef_sc_hd__decap_40_12
X_1013_ net126 vssd1 vssd1 vccd1 vccd1 _0245_ sky130_fd_sc_hd__inv_2
XFILLER_19_262 vssd1 vssd1 vccd1 vccd1 sky130_fd_sc_hd__fill_1
XFILLER_8_71 vccd1 vssd1 vccd1 vssd1 sky130_ef_sc_hd__decap_40_12
XPHY_EDGE_ROW_4_Right_4 vssd1 vssd1 vccd1 vccd1 sky130_fd_sc_hd__decap_3
XTAP_TAPCELL_ROW_27_238 vssd1 vccd1 sky130_fd_sc_hd__tapvpwrvgnd_1
XFILLER_25_221 vssd1 vssd1 vccd1 vccd1 sky130_fd_sc_hd__fill_2
XFILLER_25_232 vssd1 vssd1 vccd1 vccd1 sky130_fd_sc_hd__fill_8
XFILLER_43_57 vccd1 vssd1 vccd1 vssd1 sky130_ef_sc_hd__decap_40_12
Xclone12 _0475_ vssd1 vssd1 vccd1 vccd1 net130 sky130_fd_sc_hd__clkbuf_1
Xclone23 net142 vssd1 vssd1 vccd1 vccd1 net141 sky130_fd_sc_hd__clkbuf_1
XTAP_TAPCELL_ROW_10_149 vssd1 vccd1 sky130_fd_sc_hd__tapvpwrvgnd_1
XFILLER_17_80 vssd1 vssd1 vccd1 vccd1 sky130_fd_sc_hd__fill_1
X_1631_ clknet_3_6__leaf_clk _0040_ net56 vssd1 vssd1 vccd1 vccd1 STOPWATCH_INST.clock_div.cycles\[15\]
+ sky130_fd_sc_hd__dfrtp_1
X_1493_ net47 _0711_ vssd1 vssd1 vccd1 vccd1 _0717_ sky130_fd_sc_hd__nor2_1
X_1562_ STOPWATCH_INST.clock_div.cycles\[27\] _0772_ vssd1 vssd1 vccd1 vccd1 _0774_
+ sky130_fd_sc_hd__xnor2_1
XTAP_TAPCELL_ROW_1_106 vssd1 vccd1 sky130_fd_sc_hd__tapvpwrvgnd_1
Xfanout28 _0421_ vssd1 vssd1 vccd1 vccd1 net28 sky130_fd_sc_hd__buf_6
XTAP_TAPCELL_ROW_32_263 vssd1 vccd1 sky130_fd_sc_hd__tapvpwrvgnd_1
Xfanout39 _0070_ vssd1 vssd1 vccd1 vccd1 net39 sky130_fd_sc_hd__buf_2
Xfanout17 net19 vssd1 vssd1 vccd1 vccd1 net17 sky130_fd_sc_hd__buf_1
XTAP_TAPCELL_ROW_24_219 vssd1 vccd1 sky130_fd_sc_hd__tapvpwrvgnd_1
XFILLER_1_106 vssd1 vssd1 vccd1 vccd1 sky130_fd_sc_hd__fill_1
XPHY_EDGE_ROW_13_Left_60 vssd1 vssd1 vccd1 vccd1 sky130_fd_sc_hd__decap_3
XFILLER_13_202 vssd1 vssd1 vccd1 vccd1 sky130_fd_sc_hd__fill_1
XTAP_TAPCELL_ROW_46_333 vssd1 vccd1 sky130_fd_sc_hd__tapvpwrvgnd_1
XFILLER_0_150 vccd1 vssd1 vccd1 vssd1 sky130_ef_sc_hd__decap_40_12
X_0993_ _0208_ _0209_ vssd1 vssd1 vccd1 vccd1 _0225_ sky130_fd_sc_hd__nor2_1
X_1614_ clknet_3_1__leaf_clk _0023_ vssd1 vssd1 vccd1 vccd1 STOPWATCH_INST.digit_scanner.period_counter\[14\]
+ sky130_fd_sc_hd__dfxtp_1
XFILLER_5_61 vssd1 vssd1 vccd1 vccd1 sky130_fd_sc_hd__fill_1
X_1476_ net16 _0701_ _0614_ vssd1 vssd1 vccd1 vccd1 _0702_ sky130_fd_sc_hd__a21oi_1
X_1545_ net18 _0755_ _0646_ vssd1 vssd1 vccd1 vccd1 _0761_ sky130_fd_sc_hd__a21oi_1
XFILLER_24_15 vccd1 vssd1 vccd1 vssd1 sky130_ef_sc_hd__decap_40_12
XTAP_TAPCELL_ROW_20_200 vssd1 vccd1 sky130_fd_sc_hd__tapvpwrvgnd_1
XFILLER_24_59 vssd1 vssd1 vccd1 vccd1 sky130_fd_sc_hd__fill_1
XFILLER_45_113 vccd1 vssd1 vccd1 vssd1 sky130_ef_sc_hd__decap_40_12
XTAP_TAPCELL_ROW_43_314 vssd1 vccd1 sky130_fd_sc_hd__tapvpwrvgnd_1
XFILLER_5_231 vccd1 vssd1 vccd1 vssd1 sky130_ef_sc_hd__decap_40_12
XFILLER_39_6 vccd1 vssd1 vccd1 vssd1 sky130_ef_sc_hd__decap_40_12
X_1330_ _0515_ _0534_ _0549_ vssd1 vssd1 vccd1 vccd1 _0562_ sky130_fd_sc_hd__nand3_1
XFILLER_30_80 vssd1 vssd1 vccd1 vccd1 sky130_fd_sc_hd__fill_4
X_1261_ net26 net27 _0457_ _0462_ vssd1 vssd1 vccd1 vccd1 _0493_ sky130_fd_sc_hd__a211o_1
X_1192_ _0413_ _0423_ vssd1 vssd1 vccd1 vccd1 _0424_ sky130_fd_sc_hd__xnor2_4
XFILLER_36_135 vssd1 vssd1 vccd1 vccd1 sky130_fd_sc_hd__fill_4
XFILLER_36_102 vssd1 vssd1 vccd1 vccd1 sky130_fd_sc_hd__fill_2
X_0976_ _0198_ _0206_ vssd1 vssd1 vccd1 vccd1 _0208_ sky130_fd_sc_hd__nor2_2
XPHY_EDGE_ROW_40_Left_87 vssd1 vssd1 vccd1 vccd1 sky130_fd_sc_hd__decap_3
XFILLER_27_113 vssd1 vssd1 vccd1 vccd1 sky130_fd_sc_hd__fill_4
X_1459_ _0686_ _0687_ _0185_ vssd1 vssd1 vccd1 vccd1 _0688_ sky130_fd_sc_hd__a21oi_1
X_1528_ STOPWATCH_INST.clock_div.cycles\[18\] STOPWATCH_INST.clock_div.cycles\[19\]
+ STOPWATCH_INST.clock_div.cycles\[20\] _0730_ vssd1 vssd1 vccd1 vccd1 _0747_ sky130_fd_sc_hd__and4_1
XFILLER_35_190 vssd1 vssd1 vccd1 vccd1 sky130_fd_sc_hd__fill_1
XFILLER_35_69 vssd1 vssd1 vccd1 vccd1 sky130_fd_sc_hd__fill_4
XFILLER_2_289 vssd1 vssd1 vccd1 vccd1 sky130_fd_sc_hd__fill_4
XFILLER_33_138 vssd1 vssd1 vccd1 vccd1 sky130_fd_sc_hd__fill_1
X_0830_ _0098_ _0099_ _0096_ vssd1 vssd1 vccd1 vccd1 net15 sky130_fd_sc_hd__a21oi_1
X_1244_ _0372_ _0417_ net29 vssd1 vssd1 vccd1 vccd1 _0476_ sky130_fd_sc_hd__a21bo_1
X_1313_ _0522_ net24 _0544_ vssd1 vssd1 vccd1 vccd1 _0545_ sky130_fd_sc_hd__and3_1
X_1175_ _0406_ vssd1 vssd1 vccd1 vccd1 _0407_ sky130_fd_sc_hd__inv_2
XFILLER_17_190 vssd1 vssd1 vccd1 vccd1 sky130_fd_sc_hd__fill_8
XTAP_TAPCELL_ROW_19_196 vssd1 vccd1 sky130_fd_sc_hd__tapvpwrvgnd_1
XFILLER_24_127 vccd1 vssd1 vccd1 vssd1 sky130_ef_sc_hd__decap_40_12
X_0959_ STOPWATCH_INST.clock_div.cycles\[4\] _0191_ net181 vssd1 vssd1 vccd1 vccd1
+ _0193_ sky130_fd_sc_hd__a21oi_1
XFILLER_46_57 vssd1 vssd1 vccd1 vccd1 sky130_fd_sc_hd__fill_2
XFILLER_46_46 vssd1 vssd1 vccd1 vccd1 sky130_fd_sc_hd__fill_4
XFILLER_46_24 vssd1 vssd1 vccd1 vccd1 sky130_fd_sc_hd__fill_4
XFILLER_11_82 vssd1 vssd1 vccd1 vccd1 sky130_fd_sc_hd__fill_2
X_0813_ STOPWATCH_INST.bcd_num\[7\] net50 vssd1 vssd1 vccd1 vccd1 _0084_ sky130_fd_sc_hd__nand2b_1
X_1158_ STOPWATCH_INST.clock_div.cycles\[11\] _0346_ vssd1 vssd1 vccd1 vccd1 _0390_
+ sky130_fd_sc_hd__nand2_1
X_1227_ STOPWATCH_INST.clock_div.cycles\[11\] _0382_ net122 net121 vssd1 vssd1 vccd1
+ vccd1 _0459_ sky130_fd_sc_hd__o211a_1
X_1089_ net134 net31 _0290_ vssd1 vssd1 vccd1 vccd1 _0321_ sky130_fd_sc_hd__a21boi_1
XFILLER_32_26 vssd1 vssd1 vccd1 vccd1 sky130_fd_sc_hd__fill_2
XFILLER_12_108 vssd1 vssd1 vccd1 vccd1 sky130_fd_sc_hd__fill_4
XFILLER_20_141 vssd1 vssd1 vccd1 vccd1 sky130_fd_sc_hd__fill_2
XFILLER_32_59 vssd1 vssd1 vccd1 vccd1 sky130_fd_sc_hd__fill_1
XTAP_TAPCELL_ROW_7_134 vssd1 vccd1 sky130_fd_sc_hd__tapvpwrvgnd_1
XFILLER_43_277 vssd1 vssd1 vccd1 vccd1 sky130_fd_sc_hd__fill_2
XFILLER_43_222 vssd1 vssd1 vccd1 vccd1 sky130_fd_sc_hd__fill_2
XPHY_EDGE_ROW_43_Left_90 vssd1 vssd1 vccd1 vccd1 sky130_fd_sc_hd__decap_3
XTAP_TAPCELL_ROW_38_291 vssd1 vccd1 sky130_fd_sc_hd__tapvpwrvgnd_1
X_1012_ _0237_ STOPWATCH_INST.clock_div.cycles\[27\] vssd1 vssd1 vccd1 vccd1 _0244_
+ sky130_fd_sc_hd__xnor2_2
XFILLER_34_222 vssd1 vssd1 vccd1 vccd1 sky130_fd_sc_hd__fill_8
XFILLER_8_83 vssd1 vssd1 vccd1 vccd1 sky130_fd_sc_hd__fill_1
XFILLER_27_15 vccd1 vssd1 vccd1 vssd1 sky130_ef_sc_hd__decap_40_12
XFILLER_43_69 vccd1 vssd1 vccd1 vssd1 sky130_ef_sc_hd__decap_40_12
XFILLER_40_225 vssd1 vssd1 vccd1 vccd1 sky130_fd_sc_hd__fill_1
XFILLER_4_115 vssd1 vssd1 vccd1 vccd1 sky130_fd_sc_hd__fill_4
XFILLER_4_104 vssd1 vssd1 vccd1 vccd1 sky130_fd_sc_hd__fill_2
XFILLER_16_222 vssd1 vssd1 vccd1 vccd1 sky130_fd_sc_hd__fill_1
XFILLER_16_255 vssd1 vssd1 vccd1 vccd1 sky130_fd_sc_hd__fill_1
XFILLER_33_91 vssd1 vssd1 vccd1 vccd1 sky130_fd_sc_hd__fill_8
X_1630_ clknet_3_6__leaf_clk _0039_ net58 vssd1 vssd1 vccd1 vccd1 STOPWATCH_INST.clock_div.cycles\[14\]
+ sky130_fd_sc_hd__dfrtp_4
X_1492_ _0619_ net16 _0708_ net34 _0715_ vssd1 vssd1 vccd1 vccd1 _0716_ sky130_fd_sc_hd__a311o_1
X_1561_ STOPWATCH_INST.clock_div.cycles\[26\] net39 net38 _0773_ vssd1 vssd1 vccd1
+ vccd1 _0051_ sky130_fd_sc_hd__a22o_1
XTAP_TAPCELL_ROW_1_107 vssd1 vccd1 sky130_fd_sc_hd__tapvpwrvgnd_1
Xfanout29 _0421_ vssd1 vssd1 vccd1 vccd1 net29 sky130_fd_sc_hd__buf_4
Xfanout18 net19 vssd1 vssd1 vccd1 vccd1 net18 sky130_fd_sc_hd__buf_8
XFILLER_22_269 vssd1 vssd1 vccd1 vccd1 sky130_fd_sc_hd__fill_1
XFILLER_13_225 vssd1 vssd1 vccd1 vccd1 sky130_fd_sc_hd__fill_4
XFILLER_21_291 vssd1 vssd1 vccd1 vccd1 sky130_fd_sc_hd__fill_2
XFILLER_0_162 vssd1 vssd1 vccd1 vccd1 sky130_fd_sc_hd__fill_4
XTAP_TAPCELL_ROW_46_334 vssd1 vccd1 sky130_fd_sc_hd__tapvpwrvgnd_1
XFILLER_0_195 vssd1 vssd1 vccd1 vccd1 sky130_fd_sc_hd__fill_1
X_0992_ _0214_ _0222_ _0219_ _0216_ vssd1 vssd1 vccd1 vccd1 _0224_ sky130_fd_sc_hd__or4_4
X_1613_ clknet_3_0__leaf_clk _0022_ vssd1 vssd1 vccd1 vccd1 STOPWATCH_INST.digit_scanner.period_counter\[13\]
+ sky130_fd_sc_hd__dfxtp_1
XFILLER_8_251 vssd1 vssd1 vccd1 vccd1 sky130_fd_sc_hd__fill_1
X_1544_ _0756_ net38 _0760_ net40 STOPWATCH_INST.clock_div.cycles\[22\] vssd1 vssd1
+ vccd1 vccd1 _0047_ sky130_fd_sc_hd__a32o_1
XFILLER_39_111 vssd1 vssd1 vccd1 vccd1 sky130_fd_sc_hd__fill_1
X_1475_ _0609_ _0618_ vssd1 vssd1 vccd1 vccd1 _0701_ sky130_fd_sc_hd__or2_1
XFILLER_39_188 vssd1 vssd1 vccd1 vccd1 sky130_fd_sc_hd__fill_1
XFILLER_24_27 vssd1 vssd1 vccd1 vccd1 sky130_fd_sc_hd__fill_1
XFILLER_40_26 vssd1 vssd1 vccd1 vccd1 sky130_fd_sc_hd__fill_2
XTAP_TAPCELL_ROW_20_201 vssd1 vccd1 sky130_fd_sc_hd__tapvpwrvgnd_1
XFILLER_45_169 vccd1 vssd1 vccd1 vssd1 sky130_ef_sc_hd__decap_40_12
XFILLER_45_125 vccd1 vssd1 vccd1 vssd1 sky130_ef_sc_hd__decap_40_12
Xteam_04_90 vssd1 vssd1 vccd1 vccd1 team_04_90/HI gpio_out[30] sky130_fd_sc_hd__conb_1
XTAP_TAPCELL_ROW_43_315 vssd1 vccd1 sky130_fd_sc_hd__tapvpwrvgnd_1
XFILLER_5_243 vccd1 vssd1 vccd1 vssd1 sky130_ef_sc_hd__decap_40_12
X_1191_ _0416_ _0422_ vssd1 vssd1 vccd1 vccd1 _0423_ sky130_fd_sc_hd__or2_2
X_1260_ net130 net27 _0462_ vssd1 vssd1 vccd1 vccd1 _0492_ sky130_fd_sc_hd__a21oi_1
X_0975_ _0168_ _0201_ _0205_ vssd1 vssd1 vccd1 vccd1 _0207_ sky130_fd_sc_hd__a21o_4
X_1527_ net37 _0743_ _0745_ _0667_ vssd1 vssd1 vccd1 vccd1 _0746_ sky130_fd_sc_hd__a31oi_1
X_1458_ STOPWATCH_INST.clock_div.cycles\[10\] _0679_ vssd1 vssd1 vccd1 vccd1 _0687_
+ sky130_fd_sc_hd__or2_1
X_1389_ _0567_ _0609_ _0615_ _0617_ _0620_ vssd1 vssd1 vccd1 vccd1 _0621_ sky130_fd_sc_hd__a41o_1
XFILLER_42_139 vssd1 vssd1 vccd1 vccd1 sky130_fd_sc_hd__fill_1
XFILLER_27_169 vccd1 vssd1 vccd1 vssd1 sky130_ef_sc_hd__decap_40_12
XFILLER_18_158 vssd1 vssd1 vccd1 vccd1 sky130_fd_sc_hd__fill_1
XFILLER_41_183 vssd1 vssd1 vccd1 vccd1 sky130_fd_sc_hd__fill_4
XFILLER_41_172 vssd1 vssd1 vccd1 vccd1 sky130_fd_sc_hd__fill_8
XFILLER_25_92 vssd1 vssd1 vccd1 vccd1 sky130_fd_sc_hd__fill_8
XANTENNA__1543__B1 net36 vssd1 vssd1 vccd1 vccd1 sky130_fd_sc_hd__diode_2
X_1243_ _0471_ _0469_ _0468_ _0474_ vssd1 vssd1 vccd1 vccd1 _0475_ sky130_fd_sc_hd__o31ai_4
X_1174_ _0326_ _0404_ vssd1 vssd1 vccd1 vccd1 _0406_ sky130_fd_sc_hd__xnor2_1
X_1312_ _0504_ _0527_ _0528_ _0526_ vssd1 vssd1 vccd1 vccd1 _0544_ sky130_fd_sc_hd__a22oi_2
XFILLER_2_85 vssd1 vssd1 vccd1 vccd1 sky130_fd_sc_hd__fill_1
XTAP_TAPCELL_ROW_19_197 vssd1 vccd1 sky130_fd_sc_hd__tapvpwrvgnd_1
XFILLER_24_139 vssd1 vssd1 vccd1 vccd1 sky130_fd_sc_hd__fill_1
X_0958_ net179 _0191_ vssd1 vssd1 vccd1 vccd1 _0029_ sky130_fd_sc_hd__xor2_1
X_0889_ net50 _0141_ vssd1 vssd1 vccd1 vccd1 _0144_ sky130_fd_sc_hd__nand2_1
XFILLER_46_69 vssd1 vssd1 vccd1 vccd1 sky130_fd_sc_hd__fill_4
XFILLER_15_128 vssd1 vssd1 vccd1 vccd1 sky130_fd_sc_hd__fill_1
XFILLER_11_94 vssd1 vssd1 vccd1 vccd1 sky130_fd_sc_hd__fill_1
XFILLER_46_286 vssd1 vssd1 vccd1 vccd1 sky130_fd_sc_hd__fill_8
XFILLER_46_253 vccd1 vssd1 vccd1 vssd1 sky130_ef_sc_hd__decap_40_12
XFILLER_36_91 vssd1 vssd1 vccd1 vccd1 sky130_fd_sc_hd__fill_1
XFILLER_21_109 vssd1 vssd1 vccd1 vccd1 sky130_fd_sc_hd__fill_2
X_0812_ _0077_ _0079_ _0080_ _0078_ _0083_ vssd1 vssd1 vccd1 vccd1 STOPWATCH_INST.fsm_inst1.nextState\[1\]
+ sky130_fd_sc_hd__a221o_1
XFILLER_37_297 vssd1 vssd1 vccd1 vccd1 sky130_fd_sc_hd__fill_2
XFILLER_37_242 vssd1 vssd1 vccd1 vccd1 sky130_fd_sc_hd__fill_1
X_1157_ _0345_ _0383_ vssd1 vssd1 vccd1 vccd1 _0389_ sky130_fd_sc_hd__xnor2_2
X_1226_ STOPWATCH_INST.clock_div.cycles\[11\] _0382_ net121 vssd1 vssd1 vccd1 vccd1
+ _0458_ sky130_fd_sc_hd__o21ai_2
X_1088_ _0296_ _0315_ _0316_ _0319_ vssd1 vssd1 vccd1 vccd1 _0320_ sky130_fd_sc_hd__a22o_1
XFILLER_28_231 vccd1 vssd1 vccd1 vssd1 sky130_ef_sc_hd__decap_40_12
XTAP_TAPCELL_ROW_7_135 vssd1 vccd1 sky130_fd_sc_hd__tapvpwrvgnd_1
XTAP_TAPCELL_ROW_38_292 vssd1 vccd1 sky130_fd_sc_hd__tapvpwrvgnd_1
XFILLER_28_264 vssd1 vssd1 vccd1 vccd1 sky130_fd_sc_hd__fill_1
XFILLER_7_102 vssd1 vssd1 vccd1 vccd1 sky130_fd_sc_hd__fill_4
XFILLER_7_113 vssd1 vssd1 vccd1 vccd1 sky130_fd_sc_hd__fill_1
XFILLER_7_135 vssd1 vssd1 vccd1 vccd1 sky130_fd_sc_hd__fill_1
XFILLER_11_175 vssd1 vssd1 vccd1 vccd1 sky130_fd_sc_hd__fill_1
XFILLER_11_197 vssd1 vssd1 vccd1 vccd1 sky130_fd_sc_hd__fill_2
XFILLER_34_234 vssd1 vssd1 vccd1 vccd1 sky130_fd_sc_hd__fill_4
X_1011_ _0239_ _0241_ vssd1 vssd1 vccd1 vccd1 _0243_ sky130_fd_sc_hd__nand2_1
XFILLER_19_220 vssd1 vssd1 vccd1 vccd1 sky130_fd_sc_hd__fill_2
XFILLER_27_27 vccd1 vssd1 vccd1 vssd1 sky130_ef_sc_hd__decap_40_12
XFILLER_43_15 vccd1 vssd1 vccd1 vssd1 sky130_ef_sc_hd__decap_40_12
X_1209_ net28 _0396_ _0397_ vssd1 vssd1 vccd1 vccd1 _0441_ sky130_fd_sc_hd__a21oi_4
XFILLER_25_223 vssd1 vssd1 vccd1 vccd1 sky130_fd_sc_hd__fill_1
X_1560_ STOPWATCH_INST.clock_div.cycles\[26\] _0770_ _0772_ net36 vssd1 vssd1 vccd1
+ vccd1 _0773_ sky130_fd_sc_hd__o211a_1
XFILLER_12_3 vccd1 vssd1 vccd1 vssd1 sky130_ef_sc_hd__decap_40_12
X_1491_ net16 _0708_ _0619_ vssd1 vssd1 vccd1 vccd1 _0715_ sky130_fd_sc_hd__a21oi_1
XTAP_TAPCELL_ROW_1_108 vssd1 vccd1 sky130_fd_sc_hd__tapvpwrvgnd_1
Xfanout19 _0650_ vssd1 vssd1 vccd1 vccd1 net19 sky130_fd_sc_hd__buf_6
XFILLER_38_15 vccd1 vssd1 vccd1 vssd1 sky130_ef_sc_hd__decap_40_12
XFILLER_9_219 vssd1 vssd1 vccd1 vccd1 sky130_fd_sc_hd__fill_4
XFILLER_21_281 vssd1 vssd1 vccd1 vccd1 sky130_fd_sc_hd__fill_1
XFILLER_0_141 vssd1 vssd1 vccd1 vccd1 sky130_fd_sc_hd__fill_4
XTAP_TAPCELL_ROW_46_335 vssd1 vccd1 sky130_fd_sc_hd__tapvpwrvgnd_1
XFILLER_28_92 vssd1 vssd1 vccd1 vccd1 sky130_fd_sc_hd__fill_1
X_0991_ _0216_ _0219_ _0222_ vssd1 vssd1 vccd1 vccd1 _0223_ sky130_fd_sc_hd__or3_1
X_1612_ clknet_3_0__leaf_clk _0021_ vssd1 vssd1 vccd1 vccd1 STOPWATCH_INST.digit_scanner.period_counter\[12\]
+ sky130_fd_sc_hd__dfxtp_1
X_1474_ net49 net41 _0667_ _0697_ _0700_ vssd1 vssd1 vccd1 vccd1 _0037_ sky130_fd_sc_hd__a221o_1
X_1543_ _0757_ _0759_ net36 vssd1 vssd1 vccd1 vccd1 _0760_ sky130_fd_sc_hd__o21ai_1
XFILLER_39_123 vssd1 vssd1 vccd1 vccd1 sky130_fd_sc_hd__fill_2
XTAP_TAPCELL_ROW_20_202 vssd1 vccd1 sky130_fd_sc_hd__tapvpwrvgnd_1
Xteam_04_80 vssd1 vssd1 vccd1 vccd1 team_04_80/HI gpio_out[20] sky130_fd_sc_hd__conb_1
XFILLER_45_137 vccd1 vssd1 vccd1 vssd1 sky130_ef_sc_hd__decap_40_12
XTAP_TAPCELL_ROW_43_316 vssd1 vccd1 sky130_fd_sc_hd__tapvpwrvgnd_1
Xteam_04_91 vssd1 vssd1 vccd1 vccd1 team_04_91/HI gpio_out[31] sky130_fd_sc_hd__conb_1
XFILLER_5_255 vccd1 vssd1 vccd1 vssd1 sky130_ef_sc_hd__decap_40_12
XFILLER_5_222 vssd1 vssd1 vccd1 vccd1 sky130_fd_sc_hd__fill_2
X_1190_ _0411_ net29 vssd1 vssd1 vccd1 vccd1 _0422_ sky130_fd_sc_hd__nand2b_1
XANTENNA__1570__A1 net36 vssd1 vssd1 vccd1 vccd1 sky130_fd_sc_hd__diode_2
X_0974_ _0168_ _0201_ _0205_ vssd1 vssd1 vccd1 vccd1 _0206_ sky130_fd_sc_hd__a21oi_4
X_1457_ STOPWATCH_INST.clock_div.cycles\[10\] _0679_ vssd1 vssd1 vccd1 vccd1 _0686_
+ sky130_fd_sc_hd__nand2_1
X_1526_ _0744_ vssd1 vssd1 vccd1 vccd1 _0745_ sky130_fd_sc_hd__inv_2
X_1388_ _0612_ _0614_ _0618_ _0619_ vssd1 vssd1 vccd1 vccd1 _0620_ sky130_fd_sc_hd__a31o_1
XFILLER_18_115 vssd1 vssd1 vccd1 vccd1 sky130_fd_sc_hd__fill_1
XFILLER_41_151 vccd1 vssd1 vccd1 vssd1 sky130_ef_sc_hd__decap_40_12
XFILLER_41_81 vccd1 vssd1 vccd1 vssd1 sky130_ef_sc_hd__decap_40_12
XFILLER_44_6 vccd1 vssd1 vccd1 vssd1 sky130_ef_sc_hd__decap_40_12
X_1311_ _0541_ _0542_ vssd1 vssd1 vccd1 vccd1 _0543_ sky130_fd_sc_hd__nand2_1
X_1242_ _0372_ _0375_ _0417_ _0473_ vssd1 vssd1 vccd1 vccd1 _0474_ sky130_fd_sc_hd__a31o_1
X_1173_ _0326_ _0403_ vssd1 vssd1 vccd1 vccd1 _0405_ sky130_fd_sc_hd__or2_1
XPHY_EDGE_ROW_10_Right_10 vssd1 vssd1 vccd1 vccd1 sky130_fd_sc_hd__decap_3
XFILLER_32_151 vssd1 vssd1 vccd1 vccd1 sky130_fd_sc_hd__fill_1
XFILLER_17_181 vssd1 vssd1 vccd1 vccd1 sky130_fd_sc_hd__fill_4
XTAP_TAPCELL_ROW_19_198 vssd1 vccd1 sky130_fd_sc_hd__tapvpwrvgnd_1
X_0888_ net50 _0125_ _0129_ _0143_ vssd1 vssd1 vccd1 vccd1 _0007_ sky130_fd_sc_hd__a22o_1
X_0957_ _0191_ _0192_ vssd1 vssd1 vccd1 vccd1 _0028_ sky130_fd_sc_hd__and2b_1
X_1509_ _0729_ _0730_ net35 vssd1 vssd1 vccd1 vccd1 _0731_ sky130_fd_sc_hd__o21ai_1
XFILLER_11_73 vssd1 vssd1 vccd1 vccd1 sky130_fd_sc_hd__fill_4
XFILLER_11_84 vssd1 vssd1 vccd1 vccd1 sky130_fd_sc_hd__fill_1
XFILLER_46_265 vssd1 vssd1 vccd1 vccd1 sky130_fd_sc_hd__fill_4
XFILLER_46_221 vssd1 vssd1 vccd1 vccd1 sky130_fd_sc_hd__fill_2
XTAP_TAPCELL_ROW_16_179 vssd1 vccd1 sky130_fd_sc_hd__tapvpwrvgnd_1
X_0811_ _0068_ STOPWATCH_INST.sync_clear.q _0069_ _0082_ vssd1 vssd1 vccd1 vccd1 _0083_
+ sky130_fd_sc_hd__o31a_1
XANTENNA_clkbuf_3_6__f_clk_A clknet_0_clk vssd1 vssd1 vccd1 vccd1 sky130_fd_sc_hd__diode_2
XFILLER_37_276 vssd1 vssd1 vccd1 vccd1 sky130_fd_sc_hd__fill_4
X_1087_ _0294_ _0295_ vssd1 vssd1 vccd1 vccd1 _0319_ sky130_fd_sc_hd__nand2_1
X_1156_ _0381_ _0383_ _0384_ _0386_ vssd1 vssd1 vccd1 vccd1 _0388_ sky130_fd_sc_hd__or4b_4
X_1225_ STOPWATCH_INST.clock_div.cycles\[11\] _0455_ _0456_ vssd1 vssd1 vccd1 vccd1
+ _0457_ sky130_fd_sc_hd__o21ai_2
XFILLER_20_143 vssd1 vssd1 vccd1 vccd1 sky130_fd_sc_hd__fill_1
XTAP_TAPCELL_ROW_7_136 vssd1 vccd1 sky130_fd_sc_hd__tapvpwrvgnd_1
XFILLER_28_243 vssd1 vssd1 vccd1 vccd1 sky130_fd_sc_hd__fill_2
XFILLER_28_221 vssd1 vssd1 vccd1 vccd1 sky130_fd_sc_hd__fill_2
XFILLER_43_279 vssd1 vssd1 vccd1 vccd1 sky130_fd_sc_hd__fill_1
XTAP_TAPCELL_ROW_38_293 vssd1 vccd1 sky130_fd_sc_hd__tapvpwrvgnd_1
XFILLER_28_298 vssd1 vssd1 vccd1 vccd1 sky130_fd_sc_hd__fill_1
XFILLER_7_125 vssd1 vssd1 vccd1 vccd1 sky130_fd_sc_hd__fill_8
XFILLER_7_169 vssd1 vssd1 vccd1 vccd1 sky130_fd_sc_hd__fill_1
XFILLER_34_257 vssd1 vssd1 vccd1 vccd1 sky130_fd_sc_hd__fill_1
XFILLER_34_246 vssd1 vssd1 vccd1 vccd1 sky130_fd_sc_hd__fill_4
X_1010_ _0239_ _0241_ vssd1 vssd1 vccd1 vccd1 _0242_ sky130_fd_sc_hd__and2_1
XFILLER_19_298 vssd1 vssd1 vccd1 vccd1 sky130_fd_sc_hd__fill_1
XFILLER_8_85 vssd1 vssd1 vccd1 vccd1 sky130_fd_sc_hd__fill_2
XTAP_TAPCELL_ROW_12_160 vssd1 vccd1 sky130_fd_sc_hd__tapvpwrvgnd_1
X_1208_ _0396_ _0397_ net28 vssd1 vssd1 vccd1 vccd1 _0440_ sky130_fd_sc_hd__and3_1
XFILLER_27_39 vssd1 vssd1 vccd1 vccd1 sky130_fd_sc_hd__fill_4
X_1139_ _0355_ _0370_ vssd1 vssd1 vccd1 vccd1 _0371_ sky130_fd_sc_hd__xnor2_1
XFILLER_43_27 vccd1 vssd1 vccd1 vssd1 sky130_ef_sc_hd__decap_40_12
XFILLER_40_238 vssd1 vssd1 vccd1 vccd1 sky130_fd_sc_hd__fill_2
XTAP_TAPCELL_ROW_35_274 vssd1 vccd1 sky130_fd_sc_hd__tapvpwrvgnd_1
XFILLER_25_213 vssd1 vssd1 vccd1 vccd1 sky130_fd_sc_hd__fill_8
Xclone15 _0252_ vssd1 vssd1 vccd1 vccd1 net133 sky130_fd_sc_hd__clkbuf_1
XFILLER_4_106 vssd1 vssd1 vccd1 vccd1 sky130_fd_sc_hd__fill_1
XTAP_TAPCELL_ROW_26_230 vssd1 vccd1 sky130_fd_sc_hd__tapvpwrvgnd_1
XFILLER_17_94 vssd1 vssd1 vccd1 vccd1 sky130_fd_sc_hd__fill_1
XFILLER_3_161 vssd1 vssd1 vccd1 vccd1 sky130_fd_sc_hd__fill_4
X_1490_ net37 _0710_ _0714_ net40 STOPWATCH_INST.clock_div.cycles\[14\] vssd1 vssd1
+ vccd1 vccd1 _0039_ sky130_fd_sc_hd__a32o_1
XPHY_EDGE_ROW_8_Right_8 vssd1 vssd1 vccd1 vccd1 sky130_fd_sc_hd__decap_3
XFILLER_30_293 vssd1 vssd1 vccd1 vccd1 sky130_fd_sc_hd__fill_4
XPHY_EDGE_ROW_39_Right_39 vssd1 vssd1 vccd1 vccd1 sky130_fd_sc_hd__decap_3
XFILLER_38_27 vssd1 vssd1 vccd1 vccd1 sky130_fd_sc_hd__fill_1
XFILLER_0_197 vssd1 vssd1 vccd1 vccd1 sky130_fd_sc_hd__fill_2
XTAP_TAPCELL_ROW_46_336 vssd1 vccd1 sky130_fd_sc_hd__tapvpwrvgnd_1
XFILLER_44_81 vssd1 vssd1 vccd1 vccd1 sky130_fd_sc_hd__fill_2
X_1611_ clknet_3_0__leaf_clk _0020_ vssd1 vssd1 vccd1 vccd1 STOPWATCH_INST.digit_scanner.period_counter\[11\]
+ sky130_fd_sc_hd__dfxtp_1
XFILLER_8_253 vccd1 vssd1 vccd1 vssd1 sky130_ef_sc_hd__decap_40_12
XFILLER_8_297 vssd1 vssd1 vccd1 vccd1 sky130_fd_sc_hd__fill_2
XFILLER_12_260 vssd1 vssd1 vccd1 vccd1 sky130_fd_sc_hd__fill_2
X_0990_ _0221_ _0063_ _0220_ vssd1 vssd1 vccd1 vccd1 _0222_ sky130_fd_sc_hd__a21o_1
X_1473_ _0698_ _0699_ _0682_ vssd1 vssd1 vccd1 vccd1 _0700_ sky130_fd_sc_hd__and3b_1
X_1542_ STOPWATCH_INST.clock_div.cycles\[21\] STOPWATCH_INST.clock_div.cycles\[22\]
+ _0747_ vssd1 vssd1 vccd1 vccd1 _0759_ sky130_fd_sc_hd__and3_1
XFILLER_39_135 vssd1 vssd1 vccd1 vccd1 sky130_fd_sc_hd__fill_2
XFILLER_39_113 vssd1 vssd1 vccd1 vccd1 sky130_fd_sc_hd__fill_2
XFILLER_10_219 vssd1 vssd1 vccd1 vccd1 sky130_fd_sc_hd__fill_4
XPHY_EDGE_ROW_17_Left_64 vssd1 vssd1 vccd1 vccd1 sky130_fd_sc_hd__decap_3
XTAP_TAPCELL_ROW_20_203 vssd1 vccd1 sky130_fd_sc_hd__tapvpwrvgnd_1
XFILLER_45_149 vccd1 vssd1 vccd1 vssd1 sky130_ef_sc_hd__decap_40_12
XFILLER_45_105 vssd1 vssd1 vccd1 vccd1 sky130_fd_sc_hd__fill_4
XTAP_TAPCELL_ROW_43_317 vssd1 vccd1 sky130_fd_sc_hd__tapvpwrvgnd_1
Xteam_04_92 vssd1 vssd1 vccd1 vccd1 team_04_92/HI gpio_out[32] sky130_fd_sc_hd__conb_1
Xteam_04_81 vssd1 vssd1 vccd1 vccd1 team_04_81/HI gpio_out[21] sky130_fd_sc_hd__conb_1
Xteam_04_70 vssd1 vssd1 vccd1 vccd1 team_04_70/HI gpio_oeb[14] sky130_fd_sc_hd__conb_1
XFILLER_5_267 vccd1 vssd1 vccd1 vssd1 sky130_ef_sc_hd__decap_40_12
XFILLER_39_81 vssd1 vssd1 vccd1 vccd1 sky130_fd_sc_hd__fill_1
XFILLER_36_149 vssd1 vssd1 vccd1 vccd1 sky130_fd_sc_hd__fill_2
XFILLER_44_193 vssd1 vssd1 vccd1 vccd1 sky130_fd_sc_hd__fill_2
X_0973_ _0180_ _0066_ _0181_ _0196_ vssd1 vssd1 vccd1 vccd1 _0205_ sky130_fd_sc_hd__or4_4
X_1456_ _0601_ _0604_ _0606_ net16 vssd1 vssd1 vccd1 vccd1 _0685_ sky130_fd_sc_hd__nand4_1
X_1387_ _0567_ _0611_ vssd1 vssd1 vccd1 vccd1 _0619_ sky130_fd_sc_hd__xor2_1
X_1525_ net45 STOPWATCH_INST.clock_div.cycles\[20\] _0735_ vssd1 vssd1 vccd1 vccd1
+ _0744_ sky130_fd_sc_hd__and3_1
XPHY_EDGE_ROW_2_Left_49 vssd1 vssd1 vccd1 vccd1 sky130_fd_sc_hd__decap_3
XFILLER_41_163 vssd1 vssd1 vccd1 vccd1 sky130_fd_sc_hd__fill_1
XFILLER_33_108 vssd1 vssd1 vccd1 vccd1 sky130_fd_sc_hd__fill_1
XFILLER_41_93 vccd1 vssd1 vccd1 vssd1 sky130_ef_sc_hd__decap_40_12
X_1241_ _0367_ _0418_ _0371_ vssd1 vssd1 vccd1 vccd1 _0473_ sky130_fd_sc_hd__o21a_1
XFILLER_37_6 vccd1 vssd1 vccd1 vssd1 sky130_ef_sc_hd__decap_40_12
X_1310_ _0540_ net24 _0528_ vssd1 vssd1 vccd1 vccd1 _0542_ sky130_fd_sc_hd__a21o_1
XFILLER_2_32 vssd1 vssd1 vccd1 vccd1 sky130_fd_sc_hd__fill_2
XFILLER_2_10 vssd1 vssd1 vccd1 vccd1 sky130_fd_sc_hd__fill_1
XFILLER_1_281 vccd1 vssd1 vccd1 vssd1 sky130_ef_sc_hd__decap_40_12
X_1172_ _0363_ _0403_ vssd1 vssd1 vccd1 vccd1 _0404_ sky130_fd_sc_hd__nor2_1
XFILLER_2_76 vssd1 vssd1 vccd1 vccd1 sky130_fd_sc_hd__fill_8
XFILLER_24_108 vccd1 vssd1 vccd1 vssd1 sky130_ef_sc_hd__decap_40_12
X_0956_ STOPWATCH_INST.clock_div.cycles\[1\] STOPWATCH_INST.clock_div.cycles\[2\]
+ _0186_ STOPWATCH_INST.clock_div.cycles\[3\] vssd1 vssd1 vccd1 vccd1 _0192_ sky130_fd_sc_hd__a31o_1
X_0887_ _0141_ _0142_ vssd1 vssd1 vccd1 vccd1 _0143_ sky130_fd_sc_hd__xnor2_1
X_1439_ _0652_ net37 _0670_ net40 STOPWATCH_INST.clock_div.cycles\[7\] vssd1 vssd1
+ vccd1 vccd1 _0032_ sky130_fd_sc_hd__a32o_1
X_1508_ net46 STOPWATCH_INST.clock_div.cycles\[17\] _0718_ vssd1 vssd1 vccd1 vccd1
+ _0730_ sky130_fd_sc_hd__and3_1
XFILLER_11_52 vssd1 vssd1 vccd1 vccd1 sky130_fd_sc_hd__fill_4
X_0810_ net39 _0073_ _0074_ _0069_ vssd1 vssd1 vccd1 vccd1 _0082_ sky130_fd_sc_hd__a22o_1
X_1224_ _0061_ net121 _0382_ vssd1 vssd1 vccd1 vccd1 _0456_ sky130_fd_sc_hd__a21o_1
X_1086_ _0263_ _0316_ vssd1 vssd1 vccd1 vccd1 _0318_ sky130_fd_sc_hd__xnor2_2
X_1155_ _0385_ net122 vssd1 vssd1 vccd1 vccd1 _0387_ sky130_fd_sc_hd__nand2_1
XFILLER_32_29 vccd1 vssd1 vccd1 vssd1 sky130_ef_sc_hd__decap_40_12
XFILLER_32_18 vssd1 vssd1 vccd1 vccd1 sky130_fd_sc_hd__fill_8
X_0939_ net47 _0174_ _0177_ vssd1 vssd1 vccd1 vccd1 _0178_ sky130_fd_sc_hd__a21oi_1
XTAP_TAPCELL_ROW_7_137 vssd1 vccd1 sky130_fd_sc_hd__tapvpwrvgnd_1
XFILLER_43_225 vccd1 vssd1 vccd1 vssd1 sky130_ef_sc_hd__decap_40_12
XFILLER_43_214 vssd1 vssd1 vccd1 vccd1 sky130_fd_sc_hd__fill_8
XFILLER_43_247 vssd1 vssd1 vccd1 vccd1 sky130_fd_sc_hd__fill_1
XPHY_EDGE_ROW_5_Left_52 vssd1 vssd1 vccd1 vccd1 sky130_fd_sc_hd__decap_3
XFILLER_19_244 vssd1 vssd1 vccd1 vccd1 sky130_fd_sc_hd__fill_2
XTAP_TAPCELL_ROW_12_161 vssd1 vccd1 sky130_fd_sc_hd__tapvpwrvgnd_1
X_1207_ _0436_ _0437_ _0409_ _0431_ _0434_ vssd1 vssd1 vccd1 vccd1 _0439_ sky130_fd_sc_hd__a2111o_1
XFILLER_43_39 vccd1 vssd1 vccd1 vssd1 sky130_ef_sc_hd__decap_40_12
X_1138_ _0350_ _0358_ _0363_ vssd1 vssd1 vccd1 vccd1 _0370_ sky130_fd_sc_hd__a21o_1
Xclone16 _0312_ vssd1 vssd1 vccd1 vccd1 net134 sky130_fd_sc_hd__clkbuf_1
XTAP_TAPCELL_ROW_35_275 vssd1 vccd1 sky130_fd_sc_hd__tapvpwrvgnd_1
X_1069_ _0299_ _0300_ vssd1 vssd1 vccd1 vccd1 _0301_ sky130_fd_sc_hd__and2_1
XFILLER_25_247 vssd1 vssd1 vccd1 vccd1 sky130_fd_sc_hd__fill_1
XPHY_EDGE_ROW_31_Left_78 vssd1 vssd1 vccd1 vccd1 sky130_fd_sc_hd__decap_3
XTAP_TAPCELL_ROW_26_231 vssd1 vccd1 sky130_fd_sc_hd__tapvpwrvgnd_1
XFILLER_16_225 vssd1 vssd1 vccd1 vccd1 sky130_fd_sc_hd__fill_4
XFILLER_16_247 vssd1 vssd1 vccd1 vccd1 sky130_fd_sc_hd__fill_4
XFILLER_13_217 vssd1 vssd1 vccd1 vccd1 sky130_fd_sc_hd__fill_4
XFILLER_21_250 vssd1 vssd1 vccd1 vccd1 sky130_fd_sc_hd__fill_8
XTAP_TAPCELL_ROW_46_337 vssd1 vccd1 sky130_fd_sc_hd__tapvpwrvgnd_1
X_1610_ clknet_3_0__leaf_clk _0019_ vssd1 vssd1 vccd1 vccd1 STOPWATCH_INST.digit_scanner.period_counter\[10\]
+ sky130_fd_sc_hd__dfxtp_1
XFILLER_8_243 vssd1 vssd1 vccd1 vccd1 sky130_fd_sc_hd__fill_8
XFILLER_8_265 vccd1 vssd1 vccd1 vssd1 sky130_ef_sc_hd__decap_40_12
XFILLER_12_250 vssd1 vssd1 vccd1 vccd1 sky130_fd_sc_hd__fill_2
XFILLER_39_125 vssd1 vssd1 vccd1 vccd1 sky130_fd_sc_hd__fill_1
XFILLER_5_54 vssd1 vssd1 vccd1 vccd1 sky130_fd_sc_hd__fill_2
X_1472_ net49 _0692_ vssd1 vssd1 vccd1 vccd1 _0699_ sky130_fd_sc_hd__or2_1
X_1541_ STOPWATCH_INST.clock_div.cycles\[21\] STOPWATCH_INST.clock_div.cycles\[22\]
+ _0744_ vssd1 vssd1 vccd1 vccd1 _0758_ sky130_fd_sc_hd__and3_1
XFILLER_39_158 vssd1 vssd1 vccd1 vccd1 sky130_fd_sc_hd__fill_4
XFILLER_40_18 vssd1 vssd1 vccd1 vccd1 sky130_fd_sc_hd__fill_8
XFILLER_10_209 vssd1 vssd1 vccd1 vccd1 sky130_fd_sc_hd__fill_2
XFILLER_40_29 vccd1 vssd1 vccd1 vssd1 sky130_ef_sc_hd__decap_40_12
Xteam_04_71 vssd1 vssd1 vccd1 vccd1 team_04_71/HI gpio_oeb[15] sky130_fd_sc_hd__conb_1
XTAP_TAPCELL_ROW_43_318 vssd1 vccd1 sky130_fd_sc_hd__tapvpwrvgnd_1
Xteam_04_60 vssd1 vssd1 vccd1 vccd1 team_04_60/HI gpio_oeb[4] sky130_fd_sc_hd__conb_1
Xteam_04_93 vssd1 vssd1 vccd1 vccd1 team_04_93/HI gpio_out[33] sky130_fd_sc_hd__conb_1
Xteam_04_82 vssd1 vssd1 vccd1 vccd1 team_04_82/HI gpio_out[22] sky130_fd_sc_hd__conb_1
XFILLER_14_41 vssd1 vssd1 vccd1 vccd1 sky130_fd_sc_hd__fill_2
XFILLER_14_85 vssd1 vssd1 vccd1 vccd1 sky130_fd_sc_hd__fill_2
XFILLER_30_51 vssd1 vssd1 vccd1 vccd1 sky130_fd_sc_hd__fill_1
XFILLER_5_279 vssd1 vssd1 vccd1 vccd1 sky130_fd_sc_hd__fill_1
XFILLER_36_139 vssd1 vssd1 vccd1 vccd1 sky130_fd_sc_hd__fill_1
XPHY_EDGE_ROW_34_Left_81 vssd1 vssd1 vccd1 vccd1 sky130_fd_sc_hd__decap_3
XFILLER_29_180 vssd1 vssd1 vccd1 vccd1 sky130_fd_sc_hd__fill_2
X_0972_ net123 _0202_ vssd1 vssd1 vccd1 vccd1 _0204_ sky130_fd_sc_hd__xor2_1
X_1524_ STOPWATCH_INST.clock_div.cycles\[19\] _0735_ STOPWATCH_INST.clock_div.cycles\[20\]
+ vssd1 vssd1 vccd1 vccd1 _0743_ sky130_fd_sc_hd__a21o_1
XFILLER_27_117 vssd1 vssd1 vccd1 vccd1 sky130_fd_sc_hd__fill_2
X_1455_ _0601_ _0606_ net17 _0604_ vssd1 vssd1 vccd1 vccd1 _0684_ sky130_fd_sc_hd__a31o_1
X_1386_ _0576_ _0597_ _0613_ _0616_ vssd1 vssd1 vccd1 vccd1 _0618_ sky130_fd_sc_hd__a2bb2o_1
XFILLER_42_109 vccd1 vssd1 vccd1 vssd1 sky130_ef_sc_hd__decap_40_12
XFILLER_35_194 vssd1 vssd1 vccd1 vccd1 sky130_fd_sc_hd__fill_8
XFILLER_35_18 vccd1 vssd1 vccd1 vssd1 sky130_ef_sc_hd__decap_40_12
XFILLER_2_249 vssd1 vssd1 vccd1 vccd1 sky130_fd_sc_hd__fill_2
XFILLER_2_205 vccd1 vssd1 vccd1 vssd1 sky130_ef_sc_hd__decap_40_12
XFILLER_41_120 vssd1 vssd1 vccd1 vccd1 sky130_fd_sc_hd__fill_8
XFILLER_26_194 vssd1 vssd1 vccd1 vccd1 sky130_fd_sc_hd__fill_2
X_1240_ _0468_ _0469_ _0471_ vssd1 vssd1 vccd1 vccd1 _0472_ sky130_fd_sc_hd__or3_1
X_1171_ _0340_ _0376_ vssd1 vssd1 vccd1 vccd1 _0403_ sky130_fd_sc_hd__and2_1
XFILLER_2_99 vssd1 vssd1 vccd1 vccd1 sky130_fd_sc_hd__fill_8
X_0886_ net50 _0140_ vssd1 vssd1 vccd1 vccd1 _0142_ sky130_fd_sc_hd__xnor2_1
X_0955_ _0071_ net35 _0190_ vssd1 vssd1 vccd1 vccd1 _0191_ sky130_fd_sc_hd__and3_1
X_1507_ STOPWATCH_INST.clock_div.cycles\[17\] _0723_ vssd1 vssd1 vccd1 vccd1 _0729_
+ sky130_fd_sc_hd__nor2_1
X_1438_ _0668_ _0669_ _0185_ vssd1 vssd1 vccd1 vccd1 _0670_ sky130_fd_sc_hd__a21o_1
X_1369_ _0600_ vssd1 vssd1 vccd1 vccd1 _0601_ sky130_fd_sc_hd__inv_2
XFILLER_23_142 vssd1 vssd1 vccd1 vccd1 sky130_fd_sc_hd__fill_4
Xteam_04_110 vssd1 vssd1 vccd1 vccd1 gpio_oeb[28] team_04_110/LO sky130_fd_sc_hd__conb_1
XFILLER_46_223 vssd1 vssd1 vccd1 vccd1 sky130_fd_sc_hd__fill_1
XFILLER_14_153 vccd1 vssd1 vccd1 vssd1 sky130_ef_sc_hd__decap_40_12
X_1154_ _0346_ _0380_ vssd1 vssd1 vccd1 vccd1 _0386_ sky130_fd_sc_hd__xnor2_4
XFILLER_28_3 vccd1 vssd1 vccd1 vssd1 sky130_ef_sc_hd__decap_40_12
X_1223_ _0382_ net28 vssd1 vssd1 vccd1 vccd1 _0455_ sky130_fd_sc_hd__nand2_1
X_1085_ net30 net31 _0264_ _0297_ vssd1 vssd1 vccd1 vccd1 _0317_ sky130_fd_sc_hd__a211o_1
XFILLER_37_289 vssd1 vssd1 vccd1 vccd1 sky130_fd_sc_hd__fill_8
XFILLER_20_123 vssd1 vssd1 vccd1 vccd1 sky130_fd_sc_hd__fill_2
X_0869_ _0089_ _0103_ _0097_ vssd1 vssd1 vccd1 vccd1 _0130_ sky130_fd_sc_hd__a21o_1
X_0938_ net46 STOPWATCH_INST.clock_div.cycles\[17\] _0175_ _0176_ vssd1 vssd1 vccd1
+ vccd1 _0177_ sky130_fd_sc_hd__or4_1
XTAP_TAPCELL_ROW_7_138 vssd1 vccd1 sky130_fd_sc_hd__tapvpwrvgnd_1
XFILLER_43_237 vssd1 vssd1 vccd1 vccd1 sky130_fd_sc_hd__fill_4
XFILLER_28_278 vssd1 vssd1 vccd1 vccd1 sky130_fd_sc_hd__fill_4
XFILLER_28_256 vssd1 vssd1 vccd1 vccd1 sky130_fd_sc_hd__fill_8
XFILLER_28_245 vssd1 vssd1 vccd1 vccd1 sky130_fd_sc_hd__fill_1
XFILLER_28_223 vssd1 vssd1 vccd1 vccd1 sky130_fd_sc_hd__fill_1
XFILLER_28_201 vssd1 vssd1 vccd1 vccd1 sky130_fd_sc_hd__fill_2
XFILLER_11_101 vssd1 vssd1 vccd1 vccd1 sky130_fd_sc_hd__fill_2
XANTENNA_fanout35_A net36 vssd1 vssd1 vccd1 vccd1 sky130_fd_sc_hd__diode_2
XFILLER_22_74 vssd1 vssd1 vccd1 vccd1 sky130_fd_sc_hd__fill_1
XFILLER_19_212 vssd1 vssd1 vccd1 vccd1 sky130_fd_sc_hd__fill_8
XFILLER_8_87 vssd1 vssd1 vccd1 vccd1 sky130_fd_sc_hd__fill_1
XTAP_TAPCELL_ROW_12_162 vssd1 vccd1 sky130_fd_sc_hd__tapvpwrvgnd_1
XTAP_TAPCELL_ROW_4_119 vssd1 vccd1 sky130_fd_sc_hd__tapvpwrvgnd_1
XFILLER_6_182 vssd1 vssd1 vccd1 vccd1 sky130_fd_sc_hd__fill_4
X_1137_ _0359_ _0368_ _0354_ vssd1 vssd1 vccd1 vccd1 _0369_ sky130_fd_sc_hd__mux2_1
X_1206_ _0436_ _0437_ vssd1 vssd1 vccd1 vccd1 _0438_ sky130_fd_sc_hd__and2_1
XFILLER_25_204 vssd1 vssd1 vccd1 vccd1 sky130_fd_sc_hd__fill_2
XTAP_TAPCELL_ROW_35_276 vssd1 vccd1 sky130_fd_sc_hd__tapvpwrvgnd_1
XFILLER_33_281 vssd1 vssd1 vccd1 vccd1 sky130_fd_sc_hd__fill_1
X_1068_ _0256_ _0298_ _0247_ vssd1 vssd1 vccd1 vccd1 _0300_ sky130_fd_sc_hd__o21ai_1
Xclone17 net19 vssd1 vssd1 vccd1 vccd1 net135 sky130_fd_sc_hd__clkbuf_1
XTAP_TAPCELL_ROW_26_232 vssd1 vccd1 sky130_fd_sc_hd__tapvpwrvgnd_1
XFILLER_33_51 vssd1 vssd1 vccd1 vccd1 sky130_fd_sc_hd__fill_4
XANTENNA__1435__A _0185_ vssd1 vssd1 vccd1 vccd1 sky130_fd_sc_hd__diode_2
XFILLER_30_262 vssd1 vssd1 vccd1 vccd1 sky130_fd_sc_hd__fill_4
XFILLER_30_251 vssd1 vssd1 vccd1 vccd1 sky130_fd_sc_hd__fill_1
XFILLER_30_284 vssd1 vssd1 vccd1 vccd1 sky130_fd_sc_hd__fill_2
XFILLER_38_29 vccd1 vssd1 vccd1 vssd1 sky130_ef_sc_hd__decap_40_12
XTAP_TAPCELL_ROW_0_100 vssd1 vccd1 sky130_fd_sc_hd__tapvpwrvgnd_1
XFILLER_13_229 vssd1 vssd1 vccd1 vccd1 sky130_fd_sc_hd__fill_1
XTAP_TAPCELL_ROW_46_338 vssd1 vccd1 sky130_fd_sc_hd__tapvpwrvgnd_1
XFILLER_0_166 vssd1 vssd1 vccd1 vccd1 sky130_fd_sc_hd__fill_2
XFILLER_44_83 vssd1 vssd1 vccd1 vccd1 sky130_fd_sc_hd__fill_1
XFILLER_12_262 vssd1 vssd1 vccd1 vccd1 sky130_fd_sc_hd__fill_1
XFILLER_8_277 vccd1 vssd1 vccd1 vssd1 sky130_ef_sc_hd__decap_40_12
X_1540_ net44 _0747_ STOPWATCH_INST.clock_div.cycles\[22\] vssd1 vssd1 vccd1 vccd1
+ _0757_ sky130_fd_sc_hd__a21oi_1
XFILLER_39_137 vssd1 vssd1 vccd1 vccd1 sky130_fd_sc_hd__fill_1
XFILLER_39_115 vssd1 vssd1 vccd1 vccd1 sky130_fd_sc_hd__fill_1
X_1471_ net49 _0692_ vssd1 vssd1 vccd1 vccd1 _0698_ sky130_fd_sc_hd__and2_1
Xteam_04_72 vssd1 vssd1 vccd1 vccd1 team_04_72/HI gpio_out[0] sky130_fd_sc_hd__conb_1
Xteam_04_61 vssd1 vssd1 vccd1 vccd1 team_04_61/HI gpio_oeb[5] sky130_fd_sc_hd__conb_1
Xteam_04_94 vssd1 vssd1 vccd1 vccd1 gpio_oeb[0] team_04_94/LO sky130_fd_sc_hd__conb_1
Xteam_04_83 vssd1 vssd1 vccd1 vccd1 team_04_83/HI gpio_out[23] sky130_fd_sc_hd__conb_1
XFILLER_30_74 vssd1 vssd1 vccd1 vccd1 sky130_fd_sc_hd__fill_2
XFILLER_30_41 vssd1 vssd1 vccd1 vccd1 sky130_fd_sc_hd__fill_8
XFILLER_30_85 vssd1 vssd1 vccd1 vccd1 sky130_fd_sc_hd__fill_1
XFILLER_44_195 vssd1 vssd1 vccd1 vccd1 sky130_fd_sc_hd__fill_1
X_0971_ net43 _0202_ vssd1 vssd1 vccd1 vccd1 _0203_ sky130_fd_sc_hd__nand2b_1
X_1454_ _0667_ _0678_ _0683_ vssd1 vssd1 vccd1 vccd1 _0034_ sky130_fd_sc_hd__a21o_1
X_1523_ _0630_ _0635_ _0638_ net135 vssd1 vssd1 vccd1 vccd1 _0742_ sky130_fd_sc_hd__nand4_1
X_1385_ _0613_ _0616_ _0576_ _0597_ vssd1 vssd1 vccd1 vccd1 _0617_ sky130_fd_sc_hd__o2bb2a_1
XFILLER_2_217 vccd1 vssd1 vccd1 vssd1 sky130_ef_sc_hd__decap_40_12
XFILLER_41_187 vssd1 vssd1 vccd1 vccd1 sky130_fd_sc_hd__fill_2
X_1170_ _0400_ _0396_ _0379_ vssd1 vssd1 vccd1 vccd1 _0402_ sky130_fd_sc_hd__a21o_1
XFILLER_2_45 vssd1 vssd1 vccd1 vccd1 sky130_fd_sc_hd__fill_2
XFILLER_1_261 vccd1 vssd1 vccd1 vssd1 sky130_ef_sc_hd__decap_40_12
X_0885_ net51 _0138_ _0139_ vssd1 vssd1 vccd1 vccd1 _0006_ sky130_fd_sc_hd__a21oi_1
X_0954_ STOPWATCH_INST.clock_div.cycles\[0\] STOPWATCH_INST.clock_div.cycles\[1\]
+ STOPWATCH_INST.clock_div.cycles\[3\] STOPWATCH_INST.clock_div.cycles\[2\] vssd1
+ vssd1 vccd1 vccd1 _0190_ sky130_fd_sc_hd__and4_1
X_1437_ STOPWATCH_INST.clock_div.cycles\[7\] _0195_ vssd1 vssd1 vccd1 vccd1 _0669_
+ sky130_fd_sc_hd__or2_1
X_1506_ _0727_ net34 _0726_ vssd1 vssd1 vccd1 vccd1 _0728_ sky130_fd_sc_hd__or3b_4
XFILLER_46_29 vssd1 vssd1 vccd1 vccd1 sky130_fd_sc_hd__fill_2
X_1299_ _0529_ _0510_ _0514_ _0427_ _0530_ vssd1 vssd1 vccd1 vccd1 _0531_ sky130_fd_sc_hd__a41o_1
X_1368_ _0598_ _0059_ _0599_ vssd1 vssd1 vccd1 vccd1 _0600_ sky130_fd_sc_hd__and3_1
XTAP_TAPCELL_ROW_18_190 vssd1 vccd1 sky130_fd_sc_hd__tapvpwrvgnd_1
XFILLER_23_110 vssd1 vssd1 vccd1 vccd1 sky130_fd_sc_hd__fill_2
XFILLER_11_65 vssd1 vssd1 vccd1 vccd1 sky130_fd_sc_hd__fill_1
Xteam_04_111 vssd1 vssd1 vccd1 vccd1 gpio_oeb[29] team_04_111/LO sky130_fd_sc_hd__conb_1
Xteam_04_100 vssd1 vssd1 vccd1 vccd1 gpio_oeb[18] team_04_100/LO sky130_fd_sc_hd__conb_1
XFILLER_46_279 vssd1 vssd1 vccd1 vccd1 sky130_fd_sc_hd__fill_1
XFILLER_36_73 vssd1 vssd1 vccd1 vccd1 sky130_fd_sc_hd__fill_8
XFILLER_14_165 vssd1 vssd1 vccd1 vccd1 sky130_fd_sc_hd__fill_2
XFILLER_42_6 vccd1 vssd1 vccd1 vssd1 sky130_ef_sc_hd__decap_40_12
X_1084_ net134 net31 _0297_ vssd1 vssd1 vccd1 vccd1 _0316_ sky130_fd_sc_hd__a21oi_2
XFILLER_37_246 vccd1 vssd1 vccd1 vssd1 sky130_ef_sc_hd__decap_40_12
X_1222_ _0389_ _0453_ vssd1 vssd1 vccd1 vccd1 _0454_ sky130_fd_sc_hd__xnor2_2
X_1153_ _0383_ _0384_ vssd1 vssd1 vccd1 vccd1 _0385_ sky130_fd_sc_hd__nor2_1
X_0868_ STOPWATCH_INST.clock_div.second_tick _0124_ vssd1 vssd1 vccd1 vccd1 _0129_
+ sky130_fd_sc_hd__and2_1
X_0799_ _0068_ STOPWATCH_INST.sync_clear.q net39 vssd1 vssd1 vccd1 vccd1 _0072_ sky130_fd_sc_hd__o21ai_1
X_0937_ STOPWATCH_INST.clock_div.cycles\[18\] net45 vssd1 vssd1 vccd1 vccd1 _0176_
+ sky130_fd_sc_hd__nand2b_1
XFILLER_28_213 vssd1 vssd1 vccd1 vccd1 sky130_fd_sc_hd__fill_8
XFILLER_19_268 vssd1 vssd1 vccd1 vccd1 sky130_fd_sc_hd__fill_8
XFILLER_34_238 vssd1 vssd1 vccd1 vccd1 sky130_fd_sc_hd__fill_1
Xclkbuf_3_4__f_clk clknet_0_clk vssd1 vssd1 vccd1 vccd1 clknet_3_4__leaf_clk sky130_fd_sc_hd__clkbuf_16
XTAP_TAPCELL_ROW_12_163 vssd1 vccd1 sky130_fd_sc_hd__tapvpwrvgnd_1
X_1136_ _0359_ net125 vssd1 vssd1 vccd1 vccd1 _0368_ sky130_fd_sc_hd__nand2_1
X_1205_ _0401_ net29 _0379_ vssd1 vssd1 vccd1 vccd1 _0437_ sky130_fd_sc_hd__a21bo_1
X_1067_ _0247_ _0256_ _0298_ vssd1 vssd1 vccd1 vccd1 _0299_ sky130_fd_sc_hd__or3_1
XTAP_TAPCELL_ROW_35_277 vssd1 vccd1 sky130_fd_sc_hd__tapvpwrvgnd_1
Xclone18 STOPWATCH_INST.clock_div.cycles\[24\] vssd1 vssd1 vccd1 vccd1 net136 sky130_fd_sc_hd__clkbuf_1
XTAP_TAPCELL_ROW_26_233 vssd1 vccd1 sky130_fd_sc_hd__tapvpwrvgnd_1
XFILLER_16_238 vssd1 vssd1 vccd1 vccd1 sky130_fd_sc_hd__fill_1
XFILLER_3_120 vccd1 vssd1 vccd1 vssd1 sky130_ef_sc_hd__decap_40_12
XTAP_TAPCELL_ROW_0_101 vssd1 vccd1 sky130_fd_sc_hd__tapvpwrvgnd_1
X_1119_ _0311_ net31 _0310_ vssd1 vssd1 vccd1 vccd1 _0351_ sky130_fd_sc_hd__mux2_2
XTAP_TAPCELL_ROW_23_214 vssd1 vccd1 sky130_fd_sc_hd__tapvpwrvgnd_1
XPHY_EDGE_ROW_17_Right_17 vssd1 vssd1 vccd1 vccd1 sky130_fd_sc_hd__decap_3
XPHY_EDGE_ROW_26_Right_26 vssd1 vssd1 vccd1 vccd1 sky130_fd_sc_hd__decap_3
XFILLER_0_145 vssd1 vssd1 vccd1 vccd1 sky130_fd_sc_hd__fill_2
XFILLER_28_41 vssd1 vssd1 vccd1 vccd1 sky130_fd_sc_hd__fill_4
XFILLER_0_189 vssd1 vssd1 vccd1 vccd1 sky130_fd_sc_hd__fill_2
XPHY_EDGE_ROW_35_Right_35 vssd1 vssd1 vccd1 vccd1 sky130_fd_sc_hd__decap_3
XFILLER_8_289 vssd1 vssd1 vccd1 vccd1 sky130_fd_sc_hd__fill_8
X_1470_ _0617_ _0696_ vssd1 vssd1 vccd1 vccd1 _0697_ sky130_fd_sc_hd__xnor2_1
XPHY_EDGE_ROW_44_Right_44 vssd1 vssd1 vccd1 vccd1 sky130_fd_sc_hd__decap_3
XFILLER_39_105 vssd1 vssd1 vccd1 vccd1 sky130_fd_sc_hd__fill_4
X_1599_ clknet_3_4__leaf_clk _0008_ net56 vssd1 vssd1 vccd1 vccd1 STOPWATCH_INST.bcd_num\[7\]
+ sky130_fd_sc_hd__dfrtp_2
Xteam_04_84 vssd1 vssd1 vccd1 vccd1 team_04_84/HI gpio_out[24] sky130_fd_sc_hd__conb_1
Xteam_04_62 vssd1 vssd1 vccd1 vccd1 team_04_62/HI gpio_oeb[6] sky130_fd_sc_hd__conb_1
XFILLER_38_193 vssd1 vssd1 vccd1 vccd1 sky130_fd_sc_hd__fill_2
Xteam_04_95 vssd1 vssd1 vccd1 vccd1 gpio_oeb[1] team_04_95/LO sky130_fd_sc_hd__conb_1
Xteam_04_73 vssd1 vssd1 vccd1 vccd1 team_04_73/HI gpio_out[1] sky130_fd_sc_hd__conb_1
XFILLER_14_43 vssd1 vssd1 vccd1 vccd1 sky130_fd_sc_hd__fill_1
XFILLER_14_87 vssd1 vssd1 vccd1 vccd1 sky130_fd_sc_hd__fill_1
XFILLER_30_64 vssd1 vssd1 vccd1 vccd1 sky130_fd_sc_hd__fill_4
XFILLER_44_141 vccd1 vssd1 vccd1 vssd1 sky130_ef_sc_hd__decap_40_12
XFILLER_29_160 vssd1 vssd1 vccd1 vccd1 sky130_fd_sc_hd__fill_1
X_0970_ _0168_ _0201_ _0198_ vssd1 vssd1 vccd1 vccd1 _0202_ sky130_fd_sc_hd__and3_1
X_1453_ _0680_ _0681_ _0682_ net41 STOPWATCH_INST.clock_div.cycles\[9\] vssd1 vssd1
+ vccd1 vccd1 _0683_ sky130_fd_sc_hd__a32o_1
X_1522_ _0630_ _0638_ net135 _0635_ vssd1 vssd1 vccd1 vccd1 _0741_ sky130_fd_sc_hd__a31o_1
XFILLER_27_108 vssd1 vssd1 vccd1 vccd1 sky130_fd_sc_hd__fill_4
X_1384_ _0576_ _0582_ _0587_ vssd1 vssd1 vccd1 vccd1 _0616_ sky130_fd_sc_hd__nand3_1
XFILLER_35_163 vssd1 vssd1 vccd1 vccd1 sky130_fd_sc_hd__fill_4
XFILLER_2_229 vccd1 vssd1 vccd1 vssd1 sky130_ef_sc_hd__decap_40_12
XFILLER_41_111 vssd1 vssd1 vccd1 vccd1 sky130_fd_sc_hd__fill_1
XFILLER_26_141 vccd1 vssd1 vccd1 vssd1 sky130_ef_sc_hd__decap_40_12
XANTENNA_fanout58_A net59 vssd1 vssd1 vccd1 vccd1 sky130_fd_sc_hd__diode_2
XFILLER_41_30 vccd1 vssd1 vccd1 vssd1 sky130_ef_sc_hd__decap_40_12
XFILLER_1_273 vssd1 vssd1 vccd1 vccd1 sky130_fd_sc_hd__fill_4
XFILLER_32_155 vccd1 vssd1 vccd1 vssd1 sky130_ef_sc_hd__decap_40_12
XFILLER_32_133 vssd1 vssd1 vccd1 vccd1 sky130_fd_sc_hd__fill_2
XFILLER_17_141 vccd1 vssd1 vccd1 vssd1 sky130_ef_sc_hd__decap_40_12
XFILLER_17_163 vssd1 vssd1 vccd1 vccd1 sky130_fd_sc_hd__fill_4
X_0884_ STOPWATCH_INST.bcd_num\[5\] net52 _0135_ vssd1 vssd1 vccd1 vccd1 _0141_ sky130_fd_sc_hd__and3_1
X_0953_ net177 _0188_ vssd1 vssd1 vccd1 vccd1 _0027_ sky130_fd_sc_hd__xnor2_1
X_1436_ STOPWATCH_INST.clock_div.cycles\[7\] _0195_ vssd1 vssd1 vccd1 vccd1 _0668_
+ sky130_fd_sc_hd__nand2_1
X_1367_ STOPWATCH_INST.clock_div.cycles\[8\] net119 _0596_ vssd1 vssd1 vccd1 vccd1
+ _0599_ sky130_fd_sc_hd__nand3_1
X_1505_ _0621_ _0624_ _0627_ net19 vssd1 vssd1 vccd1 vccd1 _0727_ sky130_fd_sc_hd__and4_1
X_1298_ _0427_ _0513_ vssd1 vssd1 vccd1 vccd1 _0530_ sky130_fd_sc_hd__xnor2_1
XTAP_TAPCELL_ROW_18_191 vssd1 vccd1 sky130_fd_sc_hd__tapvpwrvgnd_1
Xteam_04_112 vssd1 vssd1 vccd1 vccd1 gpio_oeb[30] team_04_112/LO sky130_fd_sc_hd__conb_1
XFILLER_11_77 vssd1 vssd1 vccd1 vccd1 sky130_fd_sc_hd__fill_1
Xteam_04_101 vssd1 vssd1 vccd1 vccd1 gpio_oeb[19] team_04_101/LO sky130_fd_sc_hd__conb_1
XFILLER_46_225 vccd1 vssd1 vccd1 vssd1 sky130_ef_sc_hd__decap_40_12
XFILLER_36_85 vssd1 vssd1 vccd1 vccd1 sky130_fd_sc_hd__fill_4
XFILLER_36_41 vccd1 vssd1 vccd1 vssd1 sky130_ef_sc_hd__decap_40_12
XFILLER_14_133 vssd1 vssd1 vccd1 vccd1 sky130_fd_sc_hd__fill_2
XFILLER_35_6 vccd1 vssd1 vccd1 vssd1 sky130_ef_sc_hd__decap_40_12
X_1221_ _0387_ _0452_ net121 vssd1 vssd1 vccd1 vccd1 _0453_ sky130_fd_sc_hd__o21a_1
XFILLER_37_258 vssd1 vssd1 vccd1 vccd1 sky130_fd_sc_hd__fill_4
X_1083_ net30 net31 vssd1 vssd1 vccd1 vccd1 _0315_ sky130_fd_sc_hd__and2_4
X_1152_ _0347_ _0364_ _0344_ vssd1 vssd1 vccd1 vccd1 _0384_ sky130_fd_sc_hd__a21oi_2
X_0936_ net44 STOPWATCH_INST.clock_div.cycles\[22\] STOPWATCH_INST.clock_div.cycles\[23\]
+ STOPWATCH_INST.clock_div.cycles\[20\] vssd1 vssd1 vccd1 vccd1 _0175_ sky130_fd_sc_hd__or4bb_1
XFILLER_20_158 vssd1 vssd1 vccd1 vccd1 sky130_fd_sc_hd__fill_1
X_0798_ STOPWATCH_INST.fsm_inst1.currentState\[1\] STOPWATCH_INST.fsm_inst1.currentState\[0\]
+ vssd1 vssd1 vccd1 vccd1 _0071_ sky130_fd_sc_hd__nand2_2
X_0867_ _0127_ _0128_ _0074_ vssd1 vssd1 vccd1 vccd1 _0001_ sky130_fd_sc_hd__a21oi_1
X_1419_ _0059_ net16 vssd1 vssd1 vccd1 vccd1 _0651_ sky130_fd_sc_hd__nor2_1
XFILLER_43_206 vssd1 vssd1 vccd1 vccd1 sky130_fd_sc_hd__fill_1
XFILLER_11_136 vccd1 vssd1 vccd1 vssd1 sky130_ef_sc_hd__decap_40_12
XFILLER_10_180 vccd1 vssd1 vccd1 vssd1 sky130_ef_sc_hd__decap_40_12
X_1204_ _0379_ _0401_ net29 vssd1 vssd1 vccd1 vccd1 _0436_ sky130_fd_sc_hd__nand3b_1
XFILLER_33_3 vccd1 vssd1 vccd1 vssd1 sky130_ef_sc_hd__decap_40_12
X_1135_ _0318_ _0366_ vssd1 vssd1 vccd1 vccd1 _0367_ sky130_fd_sc_hd__xnor2_2
XTAP_TAPCELL_ROW_35_278 vssd1 vccd1 sky130_fd_sc_hd__tapvpwrvgnd_1
XFILLER_33_250 vssd1 vssd1 vccd1 vccd1 sky130_fd_sc_hd__fill_1
X_1066_ _0212_ _0235_ _0250_ vssd1 vssd1 vccd1 vccd1 _0298_ sky130_fd_sc_hd__nor3_1
XFILLER_18_280 vssd1 vssd1 vccd1 vccd1 sky130_fd_sc_hd__fill_1
X_0919_ STOPWATCH_INST.digit_scanner.period_counter\[11\] _0159_ net166 vssd1 vssd1
+ vccd1 vccd1 _0162_ sky130_fd_sc_hd__a21oi_1
XPHY_EDGE_ROW_9_Left_56 vssd1 vssd1 vccd1 vccd1 sky130_fd_sc_hd__decap_3
XFILLER_16_206 vssd1 vssd1 vccd1 vccd1 sky130_fd_sc_hd__fill_2
XFILLER_17_54 vssd1 vssd1 vccd1 vccd1 sky130_fd_sc_hd__fill_2
Xclone1 _0584_ _0583_ net22 _0536_ vssd1 vssd1 vccd1 vccd1 net119 sky130_fd_sc_hd__a31oi_1
XFILLER_24_283 vssd1 vssd1 vccd1 vccd1 sky130_fd_sc_hd__fill_1
XFILLER_3_132 vssd1 vssd1 vccd1 vccd1 sky130_fd_sc_hd__fill_2
XFILLER_3_165 vssd1 vssd1 vccd1 vccd1 sky130_fd_sc_hd__fill_2
XTAP_TAPCELL_ROW_32_259 vssd1 vccd1 sky130_fd_sc_hd__tapvpwrvgnd_1
XFILLER_30_297 vssd1 vssd1 vccd1 vccd1 sky130_fd_sc_hd__fill_2
XTAP_TAPCELL_ROW_0_102 vssd1 vccd1 sky130_fd_sc_hd__tapvpwrvgnd_1
X_1118_ _0342_ _0349_ vssd1 vssd1 vccd1 vccd1 _0350_ sky130_fd_sc_hd__nand2_1
X_1049_ _0268_ _0270_ _0280_ vssd1 vssd1 vccd1 vccd1 _0281_ sky130_fd_sc_hd__nand3_1
XTAP_TAPCELL_ROW_23_215 vssd1 vccd1 sky130_fd_sc_hd__tapvpwrvgnd_1
XFILLER_21_297 vssd1 vssd1 vccd1 vccd1 sky130_fd_sc_hd__fill_2
XTAP_TAPCELL_ROW_46_329 vssd1 vccd1 sky130_fd_sc_hd__tapvpwrvgnd_1
XFILLER_44_41 vccd1 vssd1 vccd1 vssd1 sky130_ef_sc_hd__decap_40_12
XFILLER_44_85 vccd1 vssd1 vccd1 vssd1 sky130_ef_sc_hd__decap_40_12
XFILLER_5_57 vssd1 vssd1 vccd1 vccd1 sky130_fd_sc_hd__fill_4
X_1598_ clknet_3_4__leaf_clk _0007_ net56 vssd1 vssd1 vccd1 vccd1 STOPWATCH_INST.bcd_num\[6\]
+ sky130_fd_sc_hd__dfrtp_1
XFILLER_45_109 vssd1 vssd1 vccd1 vccd1 sky130_fd_sc_hd__fill_2
Xteam_04_96 vssd1 vssd1 vccd1 vccd1 gpio_oeb[2] team_04_96/LO sky130_fd_sc_hd__conb_1
Xteam_04_63 vssd1 vssd1 vccd1 vccd1 team_04_63/HI gpio_oeb[7] sky130_fd_sc_hd__conb_1
Xteam_04_85 vssd1 vssd1 vccd1 vccd1 team_04_85/HI gpio_out[25] sky130_fd_sc_hd__conb_1
Xteam_04_74 vssd1 vssd1 vccd1 vccd1 team_04_74/HI gpio_out[2] sky130_fd_sc_hd__conb_1
XFILLER_39_30 vccd1 vssd1 vccd1 vssd1 sky130_ef_sc_hd__decap_40_12
XFILLER_44_197 vssd1 vssd1 vccd1 vccd1 sky130_fd_sc_hd__fill_2
XFILLER_44_153 vccd1 vssd1 vccd1 vssd1 sky130_ef_sc_hd__decap_40_12
XTAP_TAPCELL_ROW_42_310 vssd1 vccd1 sky130_fd_sc_hd__tapvpwrvgnd_1
XFILLER_4_293 vssd1 vssd1 vccd1 vccd1 sky130_fd_sc_hd__fill_2
X_1452_ _0071_ net35 _0665_ vssd1 vssd1 vccd1 vccd1 _0682_ sky130_fd_sc_hd__and3_1
X_1383_ _0612_ _0614_ vssd1 vssd1 vccd1 vccd1 _0615_ sky130_fd_sc_hd__and2_1
X_1521_ net45 net40 _0682_ _0740_ _0739_ vssd1 vssd1 vccd1 vccd1 _0044_ sky130_fd_sc_hd__a221o_1
XFILLER_26_153 vccd1 vssd1 vccd1 vssd1 sky130_ef_sc_hd__decap_40_12
XFILLER_26_120 vssd1 vssd1 vccd1 vccd1 sky130_fd_sc_hd__fill_2
XFILLER_41_42 vccd1 vssd1 vccd1 vssd1 sky130_ef_sc_hd__decap_40_12
XPHY_EDGE_ROW_38_Left_85 vssd1 vssd1 vccd1 vccd1 sky130_fd_sc_hd__decap_3
XFILLER_2_14 vssd1 vssd1 vccd1 vccd1 sky130_fd_sc_hd__fill_1
XPHY_EDGE_ROW_22_Left_69 vssd1 vssd1 vccd1 vccd1 sky130_fd_sc_hd__decap_3
XFILLER_2_47 vssd1 vssd1 vccd1 vccd1 sky130_fd_sc_hd__fill_1
XFILLER_32_167 vssd1 vssd1 vccd1 vccd1 sky130_fd_sc_hd__fill_4
XFILLER_32_101 vssd1 vssd1 vccd1 vccd1 sky130_fd_sc_hd__fill_4
X_0952_ _0188_ _0189_ vssd1 vssd1 vccd1 vccd1 _0026_ sky130_fd_sc_hd__and2_1
X_0883_ net51 STOPWATCH_INST.bcd_num\[4\] _0134_ vssd1 vssd1 vccd1 vccd1 _0140_ sky130_fd_sc_hd__and3_1
X_1504_ net19 _0624_ _0621_ _0627_ vssd1 vssd1 vccd1 vccd1 _0726_ sky130_fd_sc_hd__a31o_1
X_1366_ _0596_ _0585_ STOPWATCH_INST.clock_div.cycles\[8\] vssd1 vssd1 vccd1 vccd1
+ _0598_ sky130_fd_sc_hd__a21o_1
X_1435_ _0185_ net37 vssd1 vssd1 vccd1 vccd1 _0667_ sky130_fd_sc_hd__and2_1
X_1297_ _0528_ _0526_ _0517_ _0521_ _0523_ vssd1 vssd1 vccd1 vccd1 _0529_ sky130_fd_sc_hd__a2111o_1
XTAP_TAPCELL_ROW_18_192 vssd1 vccd1 sky130_fd_sc_hd__tapvpwrvgnd_1
XFILLER_23_167 vssd1 vssd1 vccd1 vccd1 sky130_fd_sc_hd__fill_1
Xteam_04_102 vssd1 vssd1 vccd1 vccd1 gpio_oeb[20] team_04_102/LO sky130_fd_sc_hd__conb_1
Xteam_04_113 vssd1 vssd1 vccd1 vccd1 gpio_oeb[31] team_04_113/LO sky130_fd_sc_hd__conb_1
XFILLER_46_237 vccd1 vssd1 vccd1 vssd1 sky130_ef_sc_hd__decap_40_12
XFILLER_36_53 vccd1 vssd1 vccd1 vssd1 sky130_ef_sc_hd__decap_40_12
X_1220_ STOPWATCH_INST.clock_div.cycles\[11\] _0382_ vssd1 vssd1 vccd1 vccd1 _0452_
+ sky130_fd_sc_hd__nor2_1
X_1151_ _0344_ _0347_ _0364_ vssd1 vssd1 vccd1 vccd1 _0383_ sky130_fd_sc_hd__and3_1
XFILLER_45_281 vccd1 vssd1 vccd1 vssd1 sky130_ef_sc_hd__decap_40_12
X_1082_ _0249_ _0313_ vssd1 vssd1 vccd1 vccd1 _0314_ sky130_fd_sc_hd__xnor2_1
X_0866_ STOPWATCH_INST.bcd_num\[0\] _0125_ vssd1 vssd1 vccd1 vccd1 _0128_ sky130_fd_sc_hd__or2_1
XFILLER_20_115 vssd1 vssd1 vccd1 vccd1 sky130_fd_sc_hd__fill_2
X_0935_ net49 _0173_ STOPWATCH_INST.clock_div.cycles\[14\] net48 vssd1 vssd1 vccd1
+ vccd1 _0174_ sky130_fd_sc_hd__a211o_1
X_0797_ STOPWATCH_INST.fsm_inst1.currentState\[1\] STOPWATCH_INST.fsm_inst1.currentState\[0\]
+ vssd1 vssd1 vccd1 vccd1 _0070_ sky130_fd_sc_hd__and2_1
X_1349_ _0579_ _0580_ vssd1 vssd1 vccd1 vccd1 _0581_ sky130_fd_sc_hd__or2_1
X_1418_ _0643_ _0639_ _0649_ vssd1 vssd1 vccd1 vccd1 _0650_ sky130_fd_sc_hd__o21ai_2
XFILLER_11_148 vccd1 vssd1 vccd1 vssd1 sky130_ef_sc_hd__decap_40_12
XTAP_TAPCELL_ROW_6_130 vssd1 vccd1 sky130_fd_sc_hd__tapvpwrvgnd_1
XFILLER_19_237 vssd1 vssd1 vccd1 vccd1 sky130_fd_sc_hd__fill_2
XFILLER_42_295 vssd1 vssd1 vccd1 vccd1 sky130_fd_sc_hd__fill_1
XFILLER_42_251 vssd1 vssd1 vccd1 vccd1 sky130_fd_sc_hd__fill_1
XFILLER_6_130 vssd1 vssd1 vccd1 vccd1 sky130_fd_sc_hd__fill_2
XFILLER_6_141 vssd1 vssd1 vccd1 vccd1 sky130_fd_sc_hd__fill_1
X_1134_ _0320_ _0365_ vssd1 vssd1 vccd1 vccd1 _0366_ sky130_fd_sc_hd__nor2_1
X_1203_ _0431_ _0434_ vssd1 vssd1 vccd1 vccd1 _0435_ sky130_fd_sc_hd__or2_1
XPHY_EDGE_ROW_25_Left_72 vssd1 vssd1 vccd1 vccd1 sky130_fd_sc_hd__decap_3
XFILLER_26_3 vccd1 vssd1 vccd1 vssd1 sky130_ef_sc_hd__decap_40_12
X_1065_ _0294_ _0295_ vssd1 vssd1 vccd1 vccd1 _0297_ sky130_fd_sc_hd__nor2_1
XFILLER_33_273 vssd1 vssd1 vccd1 vccd1 sky130_fd_sc_hd__fill_4
X_0918_ STOPWATCH_INST.digit_scanner.period_counter\[11\] STOPWATCH_INST.digit_scanner.period_counter\[12\]
+ _0159_ vssd1 vssd1 vccd1 vccd1 _0161_ sky130_fd_sc_hd__and3_1
X_0849_ _0110_ _0111_ _0114_ _0107_ vssd1 vssd1 vccd1 vccd1 net10 sky130_fd_sc_hd__a22o_1
XFILLER_16_218 vssd1 vssd1 vccd1 vccd1 sky130_fd_sc_hd__fill_4
XFILLER_16_229 vssd1 vssd1 vccd1 vccd1 sky130_fd_sc_hd__fill_1
XFILLER_33_76 vssd1 vssd1 vccd1 vccd1 sky130_fd_sc_hd__fill_1
XFILLER_24_251 vssd1 vssd1 vccd1 vccd1 sky130_fd_sc_hd__fill_1
XFILLER_3_177 vssd1 vssd1 vccd1 vccd1 sky130_fd_sc_hd__fill_1
XFILLER_15_295 vssd1 vssd1 vccd1 vccd1 sky130_fd_sc_hd__fill_4
XFILLER_30_276 vssd1 vssd1 vccd1 vccd1 sky130_fd_sc_hd__fill_2
X_1117_ _0341_ _0327_ _0348_ _0330_ vssd1 vssd1 vccd1 vccd1 _0349_ sky130_fd_sc_hd__or4b_4
XTAP_TAPCELL_ROW_0_103 vssd1 vccd1 sky130_fd_sc_hd__tapvpwrvgnd_1
X_1048_ _0228_ _0259_ vssd1 vssd1 vccd1 vccd1 _0280_ sky130_fd_sc_hd__xor2_2
XPHY_EDGE_ROW_3_Right_3 vssd1 vssd1 vccd1 vccd1 sky130_fd_sc_hd__decap_3
XFILLER_21_232 vssd1 vssd1 vccd1 vccd1 sky130_fd_sc_hd__fill_2
XFILLER_21_265 vccd1 vssd1 vccd1 vssd1 sky130_ef_sc_hd__decap_40_12
XTAP_TAPCELL_ROW_23_216 vssd1 vccd1 sky130_fd_sc_hd__tapvpwrvgnd_1
XANTENNA__1567__A1 net36 vssd1 vssd1 vccd1 vccd1 sky130_fd_sc_hd__diode_2
XFILLER_0_169 vccd1 vssd1 vccd1 vssd1 sky130_ef_sc_hd__decap_40_12
XFILLER_44_53 vccd1 vssd1 vccd1 vssd1 sky130_ef_sc_hd__decap_40_12
XANTENNA_fanout36_X net36 vssd1 vssd1 vccd1 vccd1 sky130_fd_sc_hd__diode_2
XFILLER_44_97 vccd1 vssd1 vccd1 vssd1 sky130_ef_sc_hd__decap_40_12
XFILLER_12_276 vccd1 vssd1 vccd1 vssd1 sky130_ef_sc_hd__decap_40_12
X_1597_ clknet_3_1__leaf_clk _0006_ net53 vssd1 vssd1 vccd1 vccd1 STOPWATCH_INST.bcd_num\[5\]
+ sky130_fd_sc_hd__dfrtp_1
Xteam_04_86 vssd1 vssd1 vccd1 vccd1 team_04_86/HI gpio_out[26] sky130_fd_sc_hd__conb_1
Xteam_04_64 vssd1 vssd1 vccd1 vccd1 team_04_64/HI gpio_oeb[8] sky130_fd_sc_hd__conb_1
XFILLER_38_195 vssd1 vssd1 vccd1 vccd1 sky130_fd_sc_hd__fill_1
Xteam_04_75 vssd1 vssd1 vccd1 vccd1 team_04_75/HI gpio_out[3] sky130_fd_sc_hd__conb_1
Xteam_04_97 vssd1 vssd1 vccd1 vccd1 gpio_oeb[3] team_04_97/LO sky130_fd_sc_hd__conb_1
XFILLER_39_42 vccd1 vssd1 vccd1 vssd1 sky130_ef_sc_hd__decap_40_12
XFILLER_44_121 vccd1 vssd1 vccd1 vssd1 sky130_ef_sc_hd__decap_40_12
XFILLER_39_75 vssd1 vssd1 vccd1 vccd1 sky130_fd_sc_hd__fill_4
XFILLER_29_195 vssd1 vssd1 vccd1 vccd1 sky130_fd_sc_hd__fill_1
XFILLER_44_165 vccd1 vssd1 vccd1 vssd1 sky130_ef_sc_hd__decap_40_12
XTAP_TAPCELL_ROW_42_311 vssd1 vccd1 sky130_fd_sc_hd__tapvpwrvgnd_1
X_1520_ net45 _0735_ vssd1 vssd1 vccd1 vccd1 _0740_ sky130_fd_sc_hd__xor2_1
X_1451_ STOPWATCH_INST.clock_div.cycles\[9\] _0673_ vssd1 vssd1 vccd1 vccd1 _0681_
+ sky130_fd_sc_hd__or2_1
X_1382_ _0571_ _0613_ vssd1 vssd1 vccd1 vccd1 _0614_ sky130_fd_sc_hd__xor2_2
XANTENNA_input5_A gpio_in[3] vssd1 vssd1 vccd1 vccd1 sky130_fd_sc_hd__diode_2
XFILLER_41_135 vccd1 vssd1 vccd1 vssd1 sky130_ef_sc_hd__decap_40_12
XFILLER_26_165 vssd1 vssd1 vccd1 vccd1 sky130_fd_sc_hd__fill_2
XFILLER_41_54 vssd1 vssd1 vccd1 vccd1 sky130_fd_sc_hd__fill_2
XFILLER_2_37 vssd1 vssd1 vccd1 vccd1 sky130_fd_sc_hd__fill_8
XFILLER_2_26 vssd1 vssd1 vccd1 vccd1 sky130_fd_sc_hd__fill_2
XFILLER_17_132 vssd1 vssd1 vccd1 vccd1 sky130_fd_sc_hd__fill_1
X_0951_ STOPWATCH_INST.clock_div.cycles\[1\] _0186_ vssd1 vssd1 vccd1 vccd1 _0189_
+ sky130_fd_sc_hd__or2_1
X_0882_ net51 _0138_ _0124_ vssd1 vssd1 vccd1 vccd1 _0139_ sky130_fd_sc_hd__o21ai_1
X_1503_ _0724_ _0725_ net46 net40 vssd1 vssd1 vccd1 vccd1 _0041_ sky130_fd_sc_hd__a2bb2o_1
X_1296_ _0448_ _0486_ _0443_ _0525_ vssd1 vssd1 vccd1 vccd1 _0528_ sky130_fd_sc_hd__a22o_4
X_1434_ _0071_ _0665_ vssd1 vssd1 vccd1 vccd1 _0666_ sky130_fd_sc_hd__and2_1
X_1365_ _0585_ _0596_ vssd1 vssd1 vccd1 vccd1 _0597_ sky130_fd_sc_hd__nand2_2
XTAP_TAPCELL_ROW_18_193 vssd1 vccd1 sky130_fd_sc_hd__tapvpwrvgnd_1
XFILLER_23_113 vssd1 vssd1 vccd1 vccd1 sky130_fd_sc_hd__fill_4
XFILLER_23_146 vssd1 vssd1 vccd1 vccd1 sky130_fd_sc_hd__fill_2
XFILLER_11_57 vssd1 vssd1 vccd1 vccd1 sky130_fd_sc_hd__fill_8
Xteam_04_114 vssd1 vssd1 vccd1 vccd1 gpio_oeb[32] team_04_114/LO sky130_fd_sc_hd__conb_1
Xteam_04_103 vssd1 vssd1 vccd1 vccd1 gpio_oeb[21] team_04_103/LO sky130_fd_sc_hd__conb_1
XFILLER_46_249 vssd1 vssd1 vccd1 vccd1 sky130_fd_sc_hd__fill_2
XFILLER_36_65 vssd1 vssd1 vccd1 vccd1 sky130_fd_sc_hd__fill_2
XFILLER_36_98 vssd1 vssd1 vccd1 vccd1 sky130_fd_sc_hd__fill_4
XFILLER_37_238 vssd1 vssd1 vccd1 vccd1 sky130_fd_sc_hd__fill_4
X_1150_ STOPWATCH_INST.clock_div.cycles\[12\] _0363_ vssd1 vssd1 vccd1 vccd1 _0382_
+ sky130_fd_sc_hd__xnor2_4
XFILLER_45_293 vssd1 vssd1 vccd1 vccd1 sky130_fd_sc_hd__fill_2
X_1081_ _0242_ _0304_ _0256_ vssd1 vssd1 vccd1 vccd1 _0313_ sky130_fd_sc_hd__a21o_1
X_0865_ STOPWATCH_INST.bcd_num\[0\] _0125_ vssd1 vssd1 vccd1 vccd1 _0127_ sky130_fd_sc_hd__nand2_1
XFILLER_13_190 vccd1 vssd1 vccd1 vssd1 sky130_ef_sc_hd__decap_40_12
XTAP_TAPCELL_ROW_15_174 vssd1 vccd1 sky130_fd_sc_hd__tapvpwrvgnd_1
X_0934_ _0171_ _0172_ _0061_ vssd1 vssd1 vccd1 vccd1 _0173_ sky130_fd_sc_hd__o21ai_1
XFILLER_20_138 vssd1 vssd1 vccd1 vccd1 sky130_fd_sc_hd__fill_2
X_0796_ STOPWATCH_INST.sync_ten.q STOPWATCH_INST.sync_ten.sync_2 vssd1 vssd1 vccd1
+ vccd1 _0069_ sky130_fd_sc_hd__and2b_1
X_1417_ _0645_ _0646_ _0648_ vssd1 vssd1 vccd1 vccd1 _0649_ sky130_fd_sc_hd__o21a_1
X_1279_ net26 net27 _0505_ vssd1 vssd1 vccd1 vccd1 _0511_ sky130_fd_sc_hd__a21oi_1
XFILLER_3_91 vssd1 vssd1 vccd1 vccd1 sky130_fd_sc_hd__fill_1
X_1348_ _0060_ net129 _0496_ vssd1 vssd1 vccd1 vccd1 _0580_ sky130_fd_sc_hd__a21oi_1
XTAP_TAPCELL_ROW_6_131 vssd1 vccd1 sky130_fd_sc_hd__tapvpwrvgnd_1
XTAP_TAPCELL_ROW_29_244 vssd1 vccd1 sky130_fd_sc_hd__tapvpwrvgnd_1
XFILLER_27_271 vssd1 vssd1 vccd1 vccd1 sky130_fd_sc_hd__fill_8
XFILLER_40_6 vccd1 vssd1 vccd1 vssd1 sky130_ef_sc_hd__decap_40_12
X_1133_ _0350_ _0364_ vssd1 vssd1 vccd1 vccd1 _0365_ sky130_fd_sc_hd__nand2_1
X_1202_ _0402_ net29 _0407_ vssd1 vssd1 vccd1 vccd1 _0434_ sky130_fd_sc_hd__a21oi_1
X_1064_ _0295_ vssd1 vssd1 vccd1 vccd1 _0296_ sky130_fd_sc_hd__inv_2
XFILLER_19_3 vssd1 vssd1 vccd1 vccd1 sky130_fd_sc_hd__fill_2
XANTENNA__1512__C1 _0185_ vssd1 vssd1 vccd1 vccd1 sky130_fd_sc_hd__diode_2
X_0917_ net174 _0159_ vssd1 vssd1 vccd1 vccd1 _0020_ sky130_fd_sc_hd__xor2_1
X_0848_ STOPWATCH_INST.bcd_num\[2\] _0113_ STOPWATCH_INST.bcd_num\[3\] vssd1 vssd1
+ vccd1 vccd1 _0114_ sky130_fd_sc_hd__a21oi_1
Xclone3 _0421_ vssd1 vssd1 vccd1 vccd1 net121 sky130_fd_sc_hd__clkbuf_1
XFILLER_16_208 vssd1 vssd1 vccd1 vccd1 sky130_fd_sc_hd__fill_1
XFILLER_17_23 vssd1 vssd1 vccd1 vccd1 sky130_fd_sc_hd__fill_1
XFILLER_33_55 vssd1 vssd1 vccd1 vccd1 sky130_fd_sc_hd__fill_1
XFILLER_3_167 vssd1 vssd1 vccd1 vccd1 sky130_fd_sc_hd__fill_1
XFILLER_3_134 vssd1 vssd1 vccd1 vccd1 sky130_fd_sc_hd__fill_1
XFILLER_15_274 vssd1 vssd1 vccd1 vccd1 sky130_fd_sc_hd__fill_4
XFILLER_30_266 vssd1 vssd1 vccd1 vccd1 sky130_fd_sc_hd__fill_1
X_1047_ _0228_ _0259_ vssd1 vssd1 vccd1 vccd1 _0279_ sky130_fd_sc_hd__nor2_1
X_1116_ net49 _0346_ _0345_ _0344_ vssd1 vssd1 vccd1 vccd1 _0348_ sky130_fd_sc_hd__o211ai_2
XTAP_TAPCELL_ROW_23_217 vssd1 vccd1 sky130_fd_sc_hd__tapvpwrvgnd_1
XFILLER_44_65 vccd1 vssd1 vccd1 vssd1 sky130_ef_sc_hd__decap_40_12
XFILLER_12_288 vssd1 vssd1 vccd1 vccd1 sky130_fd_sc_hd__fill_8
XFILLER_39_119 vssd1 vssd1 vccd1 vccd1 sky130_fd_sc_hd__fill_4
XPHY_EDGE_ROW_13_Right_13 vssd1 vssd1 vccd1 vccd1 sky130_fd_sc_hd__decap_3
XPHY_EDGE_ROW_22_Right_22 vssd1 vssd1 vccd1 vccd1 sky130_fd_sc_hd__decap_3
XFILLER_7_281 vccd1 vssd1 vccd1 vssd1 sky130_ef_sc_hd__decap_40_12
X_1596_ clknet_3_1__leaf_clk _0005_ net53 vssd1 vssd1 vccd1 vccd1 STOPWATCH_INST.bcd_num\[4\]
+ sky130_fd_sc_hd__dfrtp_1
XFILLER_38_163 vssd1 vssd1 vccd1 vccd1 sky130_fd_sc_hd__fill_2
XFILLER_38_152 vssd1 vssd1 vccd1 vccd1 sky130_fd_sc_hd__fill_2
XFILLER_38_141 vssd1 vssd1 vccd1 vccd1 sky130_fd_sc_hd__fill_2
XPHY_EDGE_ROW_31_Right_31 vssd1 vssd1 vccd1 vccd1 sky130_fd_sc_hd__decap_3
Xteam_04_87 vssd1 vssd1 vccd1 vccd1 team_04_87/HI gpio_out[27] sky130_fd_sc_hd__conb_1
XFILLER_38_185 vssd1 vssd1 vccd1 vccd1 sky130_fd_sc_hd__fill_8
Xteam_04_76 vssd1 vssd1 vccd1 vccd1 team_04_76/HI gpio_out[16] sky130_fd_sc_hd__conb_1
Xteam_04_65 vssd1 vssd1 vccd1 vccd1 team_04_65/HI gpio_oeb[9] sky130_fd_sc_hd__conb_1
Xteam_04_98 vssd1 vssd1 vccd1 vccd1 gpio_oeb[16] team_04_98/LO sky130_fd_sc_hd__conb_1
XFILLER_14_24 vssd1 vssd1 vccd1 vccd1 sky130_fd_sc_hd__fill_4
XPHY_EDGE_ROW_40_Right_40 vssd1 vssd1 vccd1 vccd1 sky130_fd_sc_hd__decap_3
XFILLER_39_54 vssd1 vssd1 vccd1 vccd1 sky130_fd_sc_hd__fill_2
XFILLER_44_133 vssd1 vssd1 vccd1 vccd1 sky130_fd_sc_hd__fill_4
XFILLER_44_199 vssd1 vssd1 vccd1 vccd1 sky130_fd_sc_hd__fill_1
XFILLER_44_177 vccd1 vssd1 vccd1 vssd1 sky130_ef_sc_hd__decap_40_12
XTAP_TAPCELL_ROW_42_312 vssd1 vccd1 sky130_fd_sc_hd__tapvpwrvgnd_1
XFILLER_4_251 vssd1 vssd1 vccd1 vccd1 sky130_fd_sc_hd__fill_1
X_1450_ _0679_ vssd1 vssd1 vccd1 vccd1 _0680_ sky130_fd_sc_hd__inv_2
XFILLER_4_295 vssd1 vssd1 vccd1 vccd1 sky130_fd_sc_hd__fill_1
X_1381_ net119 _0596_ _0588_ vssd1 vssd1 vccd1 vccd1 _0613_ sky130_fd_sc_hd__a21oi_2
XFILLER_35_111 vssd1 vssd1 vccd1 vccd1 sky130_fd_sc_hd__fill_1
XANTENNA_clkbuf_0_clk_X clknet_0_clk vssd1 vssd1 vccd1 vccd1 sky130_fd_sc_hd__diode_2
X_1648_ clknet_3_4__leaf_clk _0057_ net56 vssd1 vssd1 vccd1 vccd1 STOPWATCH_INST.clock_div.second_tick
+ sky130_fd_sc_hd__dfrtp_1
X_1579_ clknet_3_2__leaf_clk net153 net54 vssd1 vssd1 vccd1 vccd1 STOPWATCH_INST.sync_clear.sync_2
+ sky130_fd_sc_hd__dfrtp_1
XFILLER_41_147 vssd1 vssd1 vccd1 vccd1 sky130_fd_sc_hd__fill_1
XFILLER_25_45 vssd1 vssd1 vccd1 vccd1 sky130_fd_sc_hd__fill_8
XFILLER_32_147 vssd1 vssd1 vccd1 vccd1 sky130_fd_sc_hd__fill_4
XFILLER_32_114 vssd1 vssd1 vccd1 vccd1 sky130_fd_sc_hd__fill_2
XFILLER_17_111 vssd1 vssd1 vccd1 vccd1 sky130_fd_sc_hd__fill_1
X_0950_ STOPWATCH_INST.clock_div.cycles\[1\] _0186_ vssd1 vssd1 vccd1 vccd1 _0188_
+ sky130_fd_sc_hd__nand2_1
X_0881_ _0138_ _0124_ _0137_ vssd1 vssd1 vccd1 vccd1 _0005_ sky130_fd_sc_hd__and3b_1
X_1433_ _0658_ _0661_ _0664_ _0195_ vssd1 vssd1 vccd1 vccd1 _0665_ sky130_fd_sc_hd__or4b_1
X_1502_ _0720_ _0721_ net37 vssd1 vssd1 vccd1 vccd1 _0725_ sky130_fd_sc_hd__o21ai_1
X_1295_ _0442_ _0526_ vssd1 vssd1 vccd1 vccd1 _0527_ sky130_fd_sc_hd__nor2_1
X_1364_ net20 _0594_ _0573_ vssd1 vssd1 vccd1 vccd1 _0596_ sky130_fd_sc_hd__o21bai_4
XFILLER_23_103 vssd1 vssd1 vccd1 vccd1 sky130_fd_sc_hd__fill_1
XFILLER_23_158 vssd1 vssd1 vccd1 vccd1 sky130_fd_sc_hd__fill_1
XFILLER_23_169 vssd1 vssd1 vccd1 vccd1 sky130_fd_sc_hd__fill_1
Xteam_04_115 vssd1 vssd1 vccd1 vccd1 gpio_oeb[33] team_04_115/LO sky130_fd_sc_hd__conb_1
Xteam_04_104 vssd1 vssd1 vccd1 vccd1 gpio_oeb[22] team_04_104/LO sky130_fd_sc_hd__conb_1
XANTENNA_fanout56_A net59 vssd1 vssd1 vccd1 vccd1 sky130_fd_sc_hd__diode_2
X_1080_ _0309_ _0303_ _0311_ vssd1 vssd1 vccd1 vccd1 _0312_ sky130_fd_sc_hd__a21o_1
XFILLER_45_261 vccd1 vssd1 vccd1 vssd1 sky130_ef_sc_hd__decap_40_12
XTAP_TAPCELL_ROW_15_175 vssd1 vccd1 sky130_fd_sc_hd__tapvpwrvgnd_1
X_0795_ STOPWATCH_INST.digit_scanner.ctrl vssd1 vssd1 vccd1 vccd1 STOPWATCH_INST.D0_AN_0
+ sky130_fd_sc_hd__inv_2
X_0864_ _0125_ vssd1 vssd1 vccd1 vccd1 _0126_ sky130_fd_sc_hd__inv_2
XFILLER_9_151 vssd1 vssd1 vccd1 vccd1 sky130_fd_sc_hd__fill_4
X_0933_ STOPWATCH_INST.clock_div.cycles\[7\] _0170_ STOPWATCH_INST.clock_div.cycles\[8\]
+ vssd1 vssd1 vccd1 vccd1 _0172_ sky130_fd_sc_hd__a21oi_1
X_1416_ _0596_ _0647_ vssd1 vssd1 vccd1 vccd1 _0648_ sky130_fd_sc_hd__nand2_1
X_1347_ _0060_ _0496_ net25 vssd1 vssd1 vccd1 vccd1 _0579_ sky130_fd_sc_hd__and3_1
XTAP_TAPCELL_ROW_38_289 vssd1 vccd1 sky130_fd_sc_hd__tapvpwrvgnd_1
X_1278_ _0409_ _0509_ vssd1 vssd1 vccd1 vccd1 _0510_ sky130_fd_sc_hd__xor2_2
XANTENNA_clkbuf_3_2__f_clk_A clknet_0_clk vssd1 vssd1 vccd1 vccd1 sky130_fd_sc_hd__diode_2
XTAP_TAPCELL_ROW_29_245 vssd1 vccd1 sky130_fd_sc_hd__tapvpwrvgnd_1
XANTENNA_fanout59_X net59 vssd1 vssd1 vccd1 vccd1 sky130_fd_sc_hd__diode_2
XTAP_TAPCELL_ROW_6_132 vssd1 vccd1 sky130_fd_sc_hd__tapvpwrvgnd_1
XFILLER_19_206 vssd1 vssd1 vccd1 vccd1 sky130_fd_sc_hd__fill_2
XFILLER_42_275 vccd1 vssd1 vccd1 vssd1 sky130_ef_sc_hd__decap_40_12
XFILLER_6_132 vssd1 vssd1 vccd1 vccd1 sky130_fd_sc_hd__fill_1
X_1201_ _0430_ _0432_ _0411_ net29 vssd1 vssd1 vccd1 vccd1 _0433_ sky130_fd_sc_hd__a2bb2o_1
X_1132_ net120 _0360_ _0351_ vssd1 vssd1 vccd1 vccd1 _0364_ sky130_fd_sc_hd__nand3_4
X_1063_ _0204_ _0261_ vssd1 vssd1 vccd1 vccd1 _0295_ sky130_fd_sc_hd__xnor2_1
X_0916_ _0123_ _0158_ _0160_ vssd1 vssd1 vccd1 vccd1 _0019_ sky130_fd_sc_hd__and3_1
X_0847_ STOPWATCH_INST.bcd_num\[1\] STOPWATCH_INST.bcd_num\[0\] vssd1 vssd1 vccd1
+ vccd1 _0113_ sky130_fd_sc_hd__nand2_1
XFILLER_24_220 vssd1 vssd1 vccd1 vccd1 sky130_fd_sc_hd__fill_8
XTAP_TAPCELL_ROW_34_270 vssd1 vccd1 sky130_fd_sc_hd__tapvpwrvgnd_1
XFILLER_33_67 vssd1 vssd1 vccd1 vccd1 sky130_fd_sc_hd__fill_1
XFILLER_30_278 vssd1 vssd1 vccd1 vccd1 sky130_fd_sc_hd__fill_1
XFILLER_30_245 vssd1 vssd1 vccd1 vccd1 sky130_fd_sc_hd__fill_4
XFILLER_31_3 vccd1 vssd1 vccd1 vssd1 sky130_ef_sc_hd__decap_40_12
X_1046_ _0214_ _0277_ vssd1 vssd1 vccd1 vccd1 _0278_ sky130_fd_sc_hd__xnor2_2
X_1115_ net49 _0346_ vssd1 vssd1 vccd1 vccd1 _0347_ sky130_fd_sc_hd__or2_1
XFILLER_0_60 vssd1 vssd1 vccd1 vccd1 sky130_fd_sc_hd__fill_1
XTAP_TAPCELL_ROW_23_218 vssd1 vccd1 sky130_fd_sc_hd__tapvpwrvgnd_1
XFILLER_21_223 vssd1 vssd1 vccd1 vccd1 sky130_fd_sc_hd__fill_1
XFILLER_44_77 vssd1 vssd1 vccd1 vccd1 sky130_fd_sc_hd__fill_4
XFILLER_12_256 vssd1 vssd1 vccd1 vccd1 sky130_fd_sc_hd__fill_4
XFILLER_39_109 vssd1 vssd1 vccd1 vccd1 sky130_fd_sc_hd__fill_2
X_1595_ clknet_3_4__leaf_clk _0004_ net56 vssd1 vssd1 vccd1 vccd1 STOPWATCH_INST.bcd_num\[3\]
+ sky130_fd_sc_hd__dfrtp_2
XFILLER_7_293 vssd1 vssd1 vccd1 vccd1 sky130_fd_sc_hd__fill_2
Xteam_04_88 vssd1 vssd1 vccd1 vccd1 team_04_88/HI gpio_out[28] sky130_fd_sc_hd__conb_1
XFILLER_38_197 vssd1 vssd1 vccd1 vccd1 sky130_fd_sc_hd__fill_4
Xteam_04_66 vssd1 vssd1 vccd1 vccd1 team_04_66/HI gpio_oeb[10] sky130_fd_sc_hd__conb_1
Xteam_04_77 vssd1 vssd1 vccd1 vccd1 team_04_77/HI gpio_out[17] sky130_fd_sc_hd__conb_1
X_1029_ _0212_ _0260_ vssd1 vssd1 vccd1 vccd1 _0261_ sky130_fd_sc_hd__or2_1
Xteam_04_99 vssd1 vssd1 vccd1 vccd1 gpio_oeb[17] team_04_99/LO sky130_fd_sc_hd__conb_1
XFILLER_30_68 vssd1 vssd1 vccd1 vccd1 sky130_fd_sc_hd__fill_1
XFILLER_44_189 vssd1 vssd1 vccd1 vccd1 sky130_fd_sc_hd__fill_4
XTAP_TAPCELL_ROW_42_313 vssd1 vccd1 sky130_fd_sc_hd__tapvpwrvgnd_1
X_1380_ _0569_ _0610_ vssd1 vssd1 vccd1 vccd1 _0612_ sky130_fd_sc_hd__xnor2_1
XFILLER_35_167 vssd1 vssd1 vccd1 vccd1 sky130_fd_sc_hd__fill_1
X_1578_ clknet_3_3__leaf_clk STOPWATCH_INST.fsm_inst1.nextState\[1\] net53 vssd1 vssd1
+ vccd1 vccd1 STOPWATCH_INST.fsm_inst1.currentState\[1\] sky130_fd_sc_hd__dfrtp_2
X_1647_ clknet_3_2__leaf_clk _0056_ net55 vssd1 vssd1 vccd1 vccd1 STOPWATCH_INST.clock_div.cycles\[31\]
+ sky130_fd_sc_hd__dfrtp_4
Xrebuffer20 _0224_ vssd1 vssd1 vccd1 vccd1 net138 sky130_fd_sc_hd__dlymetal6s2s_1
XFILLER_26_167 vssd1 vssd1 vccd1 vccd1 sky130_fd_sc_hd__fill_1
XFILLER_25_79 vssd1 vssd1 vccd1 vccd1 sky130_fd_sc_hd__fill_1
XFILLER_1_277 vssd1 vssd1 vccd1 vccd1 sky130_fd_sc_hd__fill_2
XFILLER_17_167 vssd1 vssd1 vccd1 vccd1 sky130_fd_sc_hd__fill_1
X_0880_ net52 _0136_ vssd1 vssd1 vccd1 vccd1 _0138_ sky130_fd_sc_hd__and2_1
X_1363_ _0593_ _0594_ vssd1 vssd1 vccd1 vccd1 _0595_ sky130_fd_sc_hd__nor2_1
X_1432_ _0062_ _0662_ _0663_ _0171_ vssd1 vssd1 vccd1 vccd1 _0664_ sky130_fd_sc_hd__o22a_1
X_1501_ _0722_ _0723_ net35 vssd1 vssd1 vccd1 vccd1 _0724_ sky130_fd_sc_hd__o21a_1
X_1294_ _0446_ _0486_ vssd1 vssd1 vccd1 vccd1 _0526_ sky130_fd_sc_hd__xnor2_4
Xteam_04_105 vssd1 vssd1 vccd1 vccd1 gpio_oeb[23] team_04_105/LO sky130_fd_sc_hd__conb_1
Xteam_04_116 vssd1 vssd1 vccd1 vccd1 gpio_out[6] team_04_116/LO sky130_fd_sc_hd__conb_1
XFILLER_36_89 vssd1 vssd1 vccd1 vccd1 sky130_fd_sc_hd__fill_2
XFILLER_14_137 vssd1 vssd1 vccd1 vccd1 sky130_fd_sc_hd__fill_2
XFILLER_45_295 vssd1 vssd1 vccd1 vccd1 sky130_fd_sc_hd__fill_1
XFILLER_45_273 vssd1 vssd1 vccd1 vccd1 sky130_fd_sc_hd__fill_4
XTAP_TAPCELL_ROW_15_176 vssd1 vccd1 sky130_fd_sc_hd__tapvpwrvgnd_1
X_0932_ STOPWATCH_INST.clock_div.cycles\[9\] STOPWATCH_INST.clock_div.cycles\[10\]
+ vssd1 vssd1 vccd1 vccd1 _0171_ sky130_fd_sc_hd__nand2_1
X_0863_ STOPWATCH_INST.clock_div.second_tick _0124_ vssd1 vssd1 vccd1 vccd1 _0125_
+ sky130_fd_sc_hd__and2b_2
X_0794_ STOPWATCH_INST.sync_clear.sync_2 vssd1 vssd1 vccd1 vccd1 _0068_ sky130_fd_sc_hd__inv_2
X_1346_ _0575_ _0577_ vssd1 vssd1 vccd1 vccd1 _0578_ sky130_fd_sc_hd__or2_1
X_1415_ net119 _0595_ _0573_ vssd1 vssd1 vccd1 vccd1 _0647_ sky130_fd_sc_hd__o21ai_1
X_1277_ _0435_ _0508_ _0431_ vssd1 vssd1 vccd1 vccd1 _0509_ sky130_fd_sc_hd__o21bai_1
XFILLER_22_47 vssd1 vssd1 vccd1 vccd1 sky130_fd_sc_hd__fill_2
XTAP_TAPCELL_ROW_6_133 vssd1 vccd1 sky130_fd_sc_hd__tapvpwrvgnd_1
XTAP_TAPCELL_ROW_29_246 vssd1 vccd1 sky130_fd_sc_hd__tapvpwrvgnd_1
XFILLER_42_287 vssd1 vssd1 vccd1 vccd1 sky130_fd_sc_hd__fill_8
X_1200_ _0409_ net29 _0402_ _0407_ vssd1 vssd1 vccd1 vccd1 _0432_ sky130_fd_sc_hd__and4b_1
XFILLER_19_5 vssd1 vssd1 vccd1 vccd1 sky130_fd_sc_hd__fill_1
X_1062_ _0283_ _0293_ vssd1 vssd1 vccd1 vccd1 _0294_ sky130_fd_sc_hd__nand2_1
XFILLER_33_221 vssd1 vssd1 vccd1 vccd1 sky130_fd_sc_hd__fill_2
X_1131_ _0351_ _0360_ _0362_ vssd1 vssd1 vccd1 vccd1 _0363_ sky130_fd_sc_hd__and3_4
XFILLER_18_240 vccd1 vssd1 vccd1 vssd1 sky130_ef_sc_hd__decap_40_12
XFILLER_18_273 vssd1 vssd1 vccd1 vccd1 sky130_fd_sc_hd__fill_2
X_0915_ _0159_ vssd1 vssd1 vccd1 vccd1 _0160_ sky130_fd_sc_hd__inv_2
X_0846_ STOPWATCH_INST.bcd_num\[1\] STOPWATCH_INST.bcd_num\[0\] vssd1 vssd1 vccd1
+ vccd1 _0112_ sky130_fd_sc_hd__and2_1
X_1329_ _0510_ net25 _0549_ _0514_ vssd1 vssd1 vccd1 vccd1 _0561_ sky130_fd_sc_hd__a31o_1
XTAP_TAPCELL_ROW_3_114 vssd1 vccd1 sky130_fd_sc_hd__tapvpwrvgnd_1
XTAP_TAPCELL_ROW_34_271 vssd1 vccd1 sky130_fd_sc_hd__tapvpwrvgnd_1
XFILLER_24_243 vssd1 vssd1 vccd1 vccd1 sky130_fd_sc_hd__fill_8
XFILLER_24_287 vccd1 vssd1 vccd1 vssd1 sky130_ef_sc_hd__decap_40_12
XFILLER_3_169 vssd1 vssd1 vccd1 vccd1 sky130_fd_sc_hd__fill_8
XFILLER_15_221 vssd1 vssd1 vccd1 vccd1 sky130_fd_sc_hd__fill_2
XPHY_EDGE_ROW_29_Left_76 vssd1 vssd1 vccd1 vccd1 sky130_fd_sc_hd__decap_3
X_1114_ STOPWATCH_INST.clock_div.cycles\[13\] _0315_ vssd1 vssd1 vccd1 vccd1 _0346_
+ sky130_fd_sc_hd__xnor2_2
XFILLER_2_180 vssd1 vssd1 vccd1 vccd1 sky130_fd_sc_hd__fill_2
XFILLER_24_3 vccd1 vssd1 vccd1 vssd1 sky130_ef_sc_hd__decap_40_12
X_1045_ _0223_ _0229_ net133 net32 vssd1 vssd1 vccd1 vccd1 _0277_ sky130_fd_sc_hd__a22oi_2
XFILLER_0_72 vccd1 vssd1 vccd1 vssd1 sky130_ef_sc_hd__decap_40_12
XFILLER_21_202 vssd1 vssd1 vccd1 vccd1 sky130_fd_sc_hd__fill_1
X_0829_ _0089_ _0091_ STOPWATCH_INST.digit_scanner.ctrl vssd1 vssd1 vccd1 vccd1 _0099_
+ sky130_fd_sc_hd__a21oi_1
XFILLER_0_117 vssd1 vssd1 vccd1 vccd1 sky130_fd_sc_hd__fill_1
XPHY_EDGE_ROW_7_Right_7 vssd1 vssd1 vccd1 vccd1 sky130_fd_sc_hd__decap_3
X_1594_ clknet_3_4__leaf_clk _0003_ net56 vssd1 vssd1 vccd1 vccd1 STOPWATCH_INST.bcd_num\[2\]
+ sky130_fd_sc_hd__dfrtp_4
Xteam_04_89 vssd1 vssd1 vccd1 vccd1 team_04_89/HI gpio_out[29] sky130_fd_sc_hd__conb_1
Xteam_04_67 vssd1 vssd1 vccd1 vccd1 team_04_67/HI gpio_oeb[11] sky130_fd_sc_hd__conb_1
XFILLER_38_165 vssd1 vssd1 vccd1 vccd1 sky130_fd_sc_hd__fill_1
Xteam_04_78 vssd1 vssd1 vccd1 vccd1 team_04_78/HI gpio_out[18] sky130_fd_sc_hd__conb_1
X_1028_ net33 net32 _0235_ vssd1 vssd1 vccd1 vccd1 _0260_ sky130_fd_sc_hd__a21o_1
XFILLER_14_37 vssd1 vssd1 vccd1 vccd1 sky130_fd_sc_hd__fill_4
XFILLER_29_154 vssd1 vssd1 vccd1 vccd1 sky130_fd_sc_hd__fill_4
XFILLER_4_253 vccd1 vssd1 vccd1 vssd1 sky130_ef_sc_hd__decap_40_12
XFILLER_35_146 vssd1 vssd1 vccd1 vccd1 sky130_fd_sc_hd__fill_4
XFILLER_35_124 vssd1 vssd1 vccd1 vccd1 sky130_fd_sc_hd__fill_2
XFILLER_35_113 vssd1 vssd1 vccd1 vccd1 sky130_fd_sc_hd__fill_2
XFILLER_6_82 vssd1 vssd1 vccd1 vccd1 sky130_fd_sc_hd__fill_2
X_1646_ clknet_3_2__leaf_clk _0055_ net54 vssd1 vssd1 vccd1 vccd1 STOPWATCH_INST.clock_div.cycles\[30\]
+ sky130_fd_sc_hd__dfrtp_2
X_1577_ clknet_3_1__leaf_clk STOPWATCH_INST.fsm_inst1.nextState\[0\] net53 vssd1 vssd1
+ vccd1 vccd1 STOPWATCH_INST.fsm_inst1.currentState\[0\] sky130_fd_sc_hd__dfrtp_2
XPHY_EDGE_ROW_16_Left_63 vssd1 vssd1 vccd1 vccd1 sky130_fd_sc_hd__decap_3
XANTENNA__1560__C1 net36 vssd1 vssd1 vccd1 vccd1 sky130_fd_sc_hd__diode_2
XFILLER_41_105 vssd1 vssd1 vccd1 vccd1 sky130_fd_sc_hd__fill_4
Xrebuffer10 _0252_ vssd1 vssd1 vccd1 vccd1 net128 sky130_fd_sc_hd__dlygate4sd1_1
Xrebuffer21 net138 vssd1 vssd1 vccd1 vccd1 net139 sky130_fd_sc_hd__dlymetal6s2s_1
XFILLER_41_57 vccd1 vssd1 vccd1 vssd1 sky130_ef_sc_hd__decap_40_12
XFILLER_17_113 vssd1 vssd1 vccd1 vccd1 sky130_fd_sc_hd__fill_2
XFILLER_17_124 vssd1 vssd1 vccd1 vccd1 sky130_fd_sc_hd__fill_8
XFILLER_32_105 vssd1 vssd1 vccd1 vccd1 sky130_fd_sc_hd__fill_1
X_1500_ net47 net46 _0713_ vssd1 vssd1 vccd1 vccd1 _0723_ sky130_fd_sc_hd__and3_1
X_1293_ net27 net26 _0444_ _0445_ _0466_ vssd1 vssd1 vccd1 vccd1 _0525_ sky130_fd_sc_hd__a2111o_1
X_1362_ _0548_ _0556_ _0564_ vssd1 vssd1 vccd1 vccd1 _0594_ sky130_fd_sc_hd__a21o_1
X_1431_ net48 STOPWATCH_INST.clock_div.cycles\[14\] STOPWATCH_INST.clock_div.cycles\[22\]
+ net49 vssd1 vssd1 vccd1 vccd1 _0663_ sky130_fd_sc_hd__or4b_1
Xteam_04_117 vssd1 vssd1 vccd1 vccd1 gpio_out[7] team_04_117/LO sky130_fd_sc_hd__conb_1
Xteam_04_106 vssd1 vssd1 vccd1 vccd1 gpio_oeb[24] team_04_106/LO sky130_fd_sc_hd__conb_1
X_1629_ clknet_3_7__leaf_clk _0038_ net56 vssd1 vssd1 vccd1 vccd1 STOPWATCH_INST.clock_div.cycles\[13\]
+ sky130_fd_sc_hd__dfrtp_2
XANTENNA_input3_A gpio_in[1] vssd1 vssd1 vccd1 vccd1 sky130_fd_sc_hd__diode_2
XPHY_EDGE_ROW_1_Left_48 vssd1 vssd1 vccd1 vccd1 sky130_fd_sc_hd__decap_3
X_0931_ STOPWATCH_INST.clock_div.cycles\[5\] STOPWATCH_INST.clock_div.cycles\[4\]
+ STOPWATCH_INST.clock_div.cycles\[6\] _0169_ vssd1 vssd1 vccd1 vccd1 _0170_ sky130_fd_sc_hd__or4_1
X_0862_ _0088_ _0094_ _0113_ STOPWATCH_INST.fsm_inst1.currentState\[0\] STOPWATCH_INST.fsm_inst1.currentState\[1\]
+ vssd1 vssd1 vccd1 vccd1 _0124_ sky130_fd_sc_hd__o32a_1
XTAP_TAPCELL_ROW_15_177 vssd1 vccd1 sky130_fd_sc_hd__tapvpwrvgnd_1
X_0793_ STOPWATCH_INST.clock_div.cycles\[30\] vssd1 vssd1 vccd1 vccd1 _0067_ sky130_fd_sc_hd__inv_2
X_1276_ net131 _0477_ _0506_ _0438_ vssd1 vssd1 vccd1 vccd1 _0508_ sky130_fd_sc_hd__a211o_1
X_1414_ _0560_ _0641_ vssd1 vssd1 vccd1 vccd1 _0646_ sky130_fd_sc_hd__xor2_1
X_1345_ _0497_ net129 _0491_ vssd1 vssd1 vccd1 vccd1 _0577_ sky130_fd_sc_hd__a21oi_1
XFILLER_22_15 vssd1 vssd1 vccd1 vccd1 sky130_fd_sc_hd__fill_4
XTAP_TAPCELL_ROW_29_247 vssd1 vccd1 sky130_fd_sc_hd__tapvpwrvgnd_1
XFILLER_27_252 vssd1 vssd1 vccd1 vccd1 sky130_fd_sc_hd__fill_2
XFILLER_10_141 vssd1 vssd1 vccd1 vccd1 sky130_fd_sc_hd__fill_1
XFILLER_6_123 vssd1 vssd1 vccd1 vccd1 sky130_fd_sc_hd__fill_1
X_1130_ _0349_ _0342_ _0361_ vssd1 vssd1 vccd1 vccd1 _0362_ sky130_fd_sc_hd__a21o_1
XANTENNA__0946__Y _0185_ vssd1 vssd1 vccd1 vccd1 sky130_fd_sc_hd__diode_2
X_1061_ _0281_ _0289_ _0266_ _0291_ vssd1 vssd1 vccd1 vccd1 _0293_ sky130_fd_sc_hd__or4bb_4
X_0914_ STOPWATCH_INST.digit_scanner.period_counter\[9\] STOPWATCH_INST.digit_scanner.period_counter\[10\]
+ _0155_ vssd1 vssd1 vccd1 vccd1 _0159_ sky130_fd_sc_hd__and3_1
X_0845_ net51 net52 STOPWATCH_INST.bcd_num\[7\] net50 vssd1 vssd1 vccd1 vccd1 _0111_
+ sky130_fd_sc_hd__or4_1
X_1328_ _0530_ _0559_ _0558_ vssd1 vssd1 vccd1 vccd1 _0560_ sky130_fd_sc_hd__a21o_1
X_1259_ _0461_ _0490_ vssd1 vssd1 vccd1 vccd1 _0491_ sky130_fd_sc_hd__xor2_1
XTAP_TAPCELL_ROW_3_115 vssd1 vccd1 sky130_fd_sc_hd__tapvpwrvgnd_1
XTAP_TAPCELL_ROW_34_272 vssd1 vccd1 sky130_fd_sc_hd__tapvpwrvgnd_1
XFILLER_3_104 vssd1 vssd1 vccd1 vccd1 sky130_fd_sc_hd__fill_8
XPHY_EDGE_ROW_4_Left_51 vssd1 vssd1 vccd1 vccd1 sky130_fd_sc_hd__decap_3
X_1044_ _0229_ _0275_ vssd1 vssd1 vccd1 vccd1 _0276_ sky130_fd_sc_hd__xnor2_2
X_1113_ _0287_ _0328_ vssd1 vssd1 vccd1 vccd1 _0345_ sky130_fd_sc_hd__xnor2_2
XFILLER_21_258 vssd1 vssd1 vccd1 vccd1 sky130_fd_sc_hd__fill_2
X_0828_ _0091_ _0097_ vssd1 vssd1 vccd1 vccd1 _0098_ sky130_fd_sc_hd__nand2_1
XPHY_EDGE_ROW_46_Left_93 vssd1 vssd1 vccd1 vccd1 sky130_fd_sc_hd__decap_3
XFILLER_28_58 vssd1 vssd1 vccd1 vccd1 sky130_fd_sc_hd__fill_2
XPHY_EDGE_ROW_30_Left_77 vssd1 vssd1 vccd1 vccd1 sky130_fd_sc_hd__decap_3
XANTENNA__1635__RESET_B net59 vssd1 vssd1 vccd1 vccd1 sky130_fd_sc_hd__diode_2
XFILLER_7_295 vssd1 vssd1 vccd1 vccd1 sky130_fd_sc_hd__fill_1
X_1593_ clknet_3_4__leaf_clk _0002_ net56 vssd1 vssd1 vccd1 vccd1 STOPWATCH_INST.bcd_num\[1\]
+ sky130_fd_sc_hd__dfrtp_2
Xteam_04_68 vssd1 vssd1 vccd1 vccd1 team_04_68/HI gpio_oeb[12] sky130_fd_sc_hd__conb_1
Xteam_04_79 vssd1 vssd1 vccd1 vccd1 team_04_79/HI gpio_out[19] sky130_fd_sc_hd__conb_1
X_1027_ net33 net32 _0258_ vssd1 vssd1 vccd1 vccd1 _0259_ sky130_fd_sc_hd__a21oi_2
Xclkbuf_3_5__f_clk clknet_0_clk vssd1 vssd1 vccd1 vccd1 clknet_3_5__leaf_clk sky130_fd_sc_hd__clkbuf_16
XFILLER_30_15 vccd1 vssd1 vccd1 vssd1 sky130_ef_sc_hd__decap_40_12
XFILLER_39_79 vssd1 vssd1 vccd1 vccd1 sky130_fd_sc_hd__fill_2
XFILLER_39_57 vssd1 vssd1 vccd1 vccd1 sky130_fd_sc_hd__fill_4
XFILLER_4_265 vccd1 vssd1 vccd1 vssd1 sky130_ef_sc_hd__decap_40_12
XFILLER_29_90 vssd1 vssd1 vccd1 vccd1 sky130_fd_sc_hd__fill_1
X_1576_ STOPWATCH_INST.clock_div.second_tick _0071_ net38 vssd1 vssd1 vccd1 vccd1
+ _0057_ sky130_fd_sc_hd__o21ba_1
X_1645_ clknet_3_2__leaf_clk _0054_ net54 vssd1 vssd1 vccd1 vccd1 STOPWATCH_INST.clock_div.cycles\[29\]
+ sky130_fd_sc_hd__dfrtp_2
XFILLER_41_128 vssd1 vssd1 vccd1 vccd1 sky130_fd_sc_hd__fill_2
XFILLER_25_15 vccd1 vssd1 vccd1 vssd1 sky130_ef_sc_hd__decap_40_12
XFILLER_41_69 vccd1 vssd1 vccd1 vssd1 sky130_ef_sc_hd__decap_40_12
XFILLER_1_279 vssd1 vssd1 vccd1 vccd1 sky130_fd_sc_hd__fill_1
XFILLER_17_169 vccd1 vssd1 vccd1 vssd1 sky130_ef_sc_hd__decap_40_12
XFILLER_15_70 vssd1 vssd1 vccd1 vccd1 sky130_fd_sc_hd__fill_1
XPHY_EDGE_ROW_33_Left_80 vssd1 vssd1 vccd1 vccd1 sky130_fd_sc_hd__decap_3
X_1430_ STOPWATCH_INST.clock_div.cycles\[9\] STOPWATCH_INST.clock_div.cycles\[10\]
+ net49 net48 vssd1 vssd1 vccd1 vccd1 _0662_ sky130_fd_sc_hd__or4b_1
X_1292_ _0518_ _0520_ _0522_ vssd1 vssd1 vccd1 vccd1 _0524_ sky130_fd_sc_hd__and3_1
X_1361_ _0565_ _0590_ _0591_ vssd1 vssd1 vccd1 vccd1 _0593_ sky130_fd_sc_hd__nor3_2
Xteam_04_118 vssd1 vssd1 vccd1 vccd1 gpio_out[15] team_04_118/LO sky130_fd_sc_hd__conb_1
Xteam_04_107 vssd1 vssd1 vccd1 vccd1 gpio_oeb[25] team_04_107/LO sky130_fd_sc_hd__conb_1
X_1628_ clknet_3_7__leaf_clk _0037_ net58 vssd1 vssd1 vccd1 vccd1 STOPWATCH_INST.clock_div.cycles\[12\]
+ sky130_fd_sc_hd__dfrtp_1
X_1559_ net141 STOPWATCH_INST.clock_div.cycles\[26\] _0768_ vssd1 vssd1 vccd1 vccd1
+ _0772_ sky130_fd_sc_hd__nand3_1
XFILLER_46_209 vccd1 vssd1 vccd1 vssd1 sky130_ef_sc_hd__decap_40_12
XFILLER_14_139 vssd1 vssd1 vccd1 vccd1 sky130_fd_sc_hd__fill_1
XFILLER_22_172 vssd1 vssd1 vccd1 vccd1 sky130_fd_sc_hd__fill_1
Xrebuffer2 _0362_ vssd1 vssd1 vccd1 vccd1 net120 sky130_fd_sc_hd__clkbuf_2
X_0930_ STOPWATCH_INST.clock_div.cycles\[0\] STOPWATCH_INST.clock_div.cycles\[1\]
+ STOPWATCH_INST.clock_div.cycles\[3\] STOPWATCH_INST.clock_div.cycles\[2\] vssd1
+ vssd1 vccd1 vccd1 _0169_ sky130_fd_sc_hd__or4_1
X_0861_ STOPWATCH_INST.digit_scanner.ctrl _0123_ vssd1 vssd1 vccd1 vccd1 _0000_ sky130_fd_sc_hd__xnor2_1
XFILLER_9_121 vssd1 vssd1 vccd1 vccd1 sky130_fd_sc_hd__fill_2
XTAP_TAPCELL_ROW_15_178 vssd1 vccd1 sky130_fd_sc_hd__tapvpwrvgnd_1
X_0792_ STOPWATCH_INST.clock_div.cycles\[31\] vssd1 vssd1 vccd1 vccd1 _0066_ sky130_fd_sc_hd__inv_2
X_1413_ _0642_ _0644_ vssd1 vssd1 vccd1 vccd1 _0645_ sky130_fd_sc_hd__and2_1
XFILLER_36_220 vssd1 vssd1 vccd1 vccd1 sky130_fd_sc_hd__fill_1
X_1275_ _0475_ _0477_ _0506_ vssd1 vssd1 vccd1 vccd1 _0507_ sky130_fd_sc_hd__a21o_1
X_1344_ _0494_ _0575_ vssd1 vssd1 vccd1 vccd1 _0576_ sky130_fd_sc_hd__xor2_2
XFILLER_22_27 vssd1 vssd1 vccd1 vccd1 sky130_fd_sc_hd__fill_1
XPHY_EDGE_ROW_29_Right_29 vssd1 vssd1 vccd1 vccd1 sky130_fd_sc_hd__decap_3
XTAP_TAPCELL_ROW_29_248 vssd1 vccd1 sky130_fd_sc_hd__tapvpwrvgnd_1
XPHY_EDGE_ROW_38_Right_38 vssd1 vssd1 vccd1 vccd1 sky130_fd_sc_hd__decap_3
XFILLER_6_102 vssd1 vssd1 vccd1 vccd1 sky130_fd_sc_hd__fill_4
XFILLER_8_29 vssd1 vssd1 vccd1 vccd1 sky130_fd_sc_hd__fill_2
XTAP_TAPCELL_ROW_12_159 vssd1 vccd1 sky130_fd_sc_hd__tapvpwrvgnd_1
XFILLER_6_168 vssd1 vssd1 vccd1 vccd1 sky130_fd_sc_hd__fill_4
X_1060_ _0289_ _0291_ vssd1 vssd1 vccd1 vccd1 _0292_ sky130_fd_sc_hd__and2b_1
XFILLER_33_223 vssd1 vssd1 vccd1 vccd1 sky130_fd_sc_hd__fill_1
XFILLER_18_253 vccd1 vssd1 vccd1 vssd1 sky130_ef_sc_hd__decap_40_12
XFILLER_18_275 vssd1 vssd1 vccd1 vccd1 sky130_fd_sc_hd__fill_1
X_0913_ STOPWATCH_INST.digit_scanner.period_counter\[9\] _0155_ net184 vssd1 vssd1
+ vccd1 vccd1 _0158_ sky130_fd_sc_hd__a21o_1
X_0844_ net50 _0109_ STOPWATCH_INST.D0_AN_0 STOPWATCH_INST.bcd_num\[7\] vssd1 vssd1
+ vccd1 vccd1 _0110_ sky130_fd_sc_hd__a211oi_1
XTAP_TAPCELL_ROW_3_116 vssd1 vccd1 sky130_fd_sc_hd__tapvpwrvgnd_1
X_1189_ _0420_ _0417_ _0375_ vssd1 vssd1 vccd1 vccd1 _0421_ sky130_fd_sc_hd__o21bai_4
Xclone7 net120 _0360_ _0351_ vssd1 vssd1 vccd1 vccd1 net125 sky130_fd_sc_hd__nand3_1
X_1327_ _0515_ _0549_ _0534_ vssd1 vssd1 vccd1 vccd1 _0559_ sky130_fd_sc_hd__a21bo_1
X_1258_ net130 net27 STOPWATCH_INST.clock_div.cycles\[10\] vssd1 vssd1 vccd1 vccd1
+ _0490_ sky130_fd_sc_hd__a21oi_1
XTAP_TAPCELL_ROW_26_229 vssd1 vccd1 sky130_fd_sc_hd__tapvpwrvgnd_1
XTAP_TAPCELL_ROW_34_273 vssd1 vccd1 sky130_fd_sc_hd__tapvpwrvgnd_1
XFILLER_33_15 vccd1 vssd1 vccd1 vssd1 sky130_ef_sc_hd__decap_40_12
XFILLER_24_267 vccd1 vssd1 vccd1 vssd1 sky130_ef_sc_hd__decap_40_12
XFILLER_3_149 vccd1 vssd1 vccd1 vssd1 sky130_ef_sc_hd__decap_40_12
XFILLER_15_223 vssd1 vssd1 vccd1 vccd1 sky130_fd_sc_hd__fill_1
XFILLER_15_278 vssd1 vssd1 vccd1 vccd1 sky130_fd_sc_hd__fill_2
XFILLER_2_182 vssd1 vssd1 vccd1 vccd1 sky130_fd_sc_hd__fill_1
X_1112_ _0286_ _0343_ vssd1 vssd1 vccd1 vccd1 _0344_ sky130_fd_sc_hd__xnor2_1
X_1043_ net33 net32 _0223_ vssd1 vssd1 vccd1 vccd1 _0275_ sky130_fd_sc_hd__a21boi_2
XFILLER_0_85 vssd1 vssd1 vccd1 vccd1 sky130_fd_sc_hd__fill_4
XTAP_TAPCELL_ROW_31_254 vssd1 vccd1 sky130_fd_sc_hd__tapvpwrvgnd_1
XFILLER_9_50 vssd1 vssd1 vccd1 vccd1 sky130_fd_sc_hd__fill_4
XFILLER_9_94 vssd1 vssd1 vccd1 vccd1 sky130_fd_sc_hd__fill_2
X_0827_ STOPWATCH_INST.bcd_num\[0\] STOPWATCH_INST.bcd_num\[1\] vssd1 vssd1 vccd1
+ vccd1 _0097_ sky130_fd_sc_hd__and2b_1
XFILLER_28_15 vccd1 vssd1 vccd1 vssd1 sky130_ef_sc_hd__decap_40_12
XTAP_TAPCELL_ROW_22_210 vssd1 vccd1 sky130_fd_sc_hd__tapvpwrvgnd_1
XTAP_TAPCELL_ROW_45_324 vssd1 vccd1 sky130_fd_sc_hd__tapvpwrvgnd_1
X_1592_ clknet_3_1__leaf_clk _0001_ net59 vssd1 vssd1 vccd1 vccd1 STOPWATCH_INST.bcd_num\[0\]
+ sky130_fd_sc_hd__dfrtp_2
XFILLER_11_270 vssd1 vssd1 vccd1 vccd1 sky130_fd_sc_hd__fill_8
XFILLER_11_281 vccd1 vssd1 vccd1 vssd1 sky130_ef_sc_hd__decap_40_12
Xteam_04_69 vssd1 vssd1 vccd1 vccd1 team_04_69/HI gpio_oeb[13] sky130_fd_sc_hd__conb_1
X_1026_ net139 _0230_ vssd1 vssd1 vccd1 vccd1 _0258_ sky130_fd_sc_hd__nand2_1
XFILLER_30_27 vssd1 vssd1 vccd1 vccd1 sky130_fd_sc_hd__fill_1
XFILLER_30_49 vssd1 vssd1 vccd1 vccd1 sky130_fd_sc_hd__fill_2
XFILLER_44_137 vssd1 vssd1 vccd1 vccd1 sky130_fd_sc_hd__fill_2
XFILLER_4_277 vccd1 vssd1 vccd1 vssd1 sky130_ef_sc_hd__decap_40_12
XFILLER_35_126 vssd1 vssd1 vccd1 vccd1 sky130_fd_sc_hd__fill_1
XFILLER_43_181 vssd1 vssd1 vccd1 vccd1 sky130_fd_sc_hd__fill_8
X_1644_ clknet_3_2__leaf_clk _0053_ net54 vssd1 vssd1 vccd1 vccd1 STOPWATCH_INST.clock_div.cycles\[28\]
+ sky130_fd_sc_hd__dfrtp_4
X_1575_ _0185_ _0782_ STOPWATCH_INST.clock_div.cycles\[31\] net39 vssd1 vssd1 vccd1
+ vccd1 _0056_ sky130_fd_sc_hd__a2bb2o_1
XFILLER_34_192 vssd1 vssd1 vccd1 vccd1 sky130_fd_sc_hd__fill_4
X_1009_ STOPWATCH_INST.clock_div.cycles\[29\] _0240_ vssd1 vssd1 vccd1 vccd1 _0241_
+ sky130_fd_sc_hd__xnor2_2
XFILLER_25_27 vssd1 vssd1 vccd1 vccd1 sky130_fd_sc_hd__fill_8
XANTENNA_clkbuf_3_5__f_clk_A clknet_0_clk vssd1 vssd1 vccd1 vccd1 sky130_fd_sc_hd__diode_2
XFILLER_1_225 vccd1 vssd1 vccd1 vssd1 sky130_ef_sc_hd__decap_40_12
XFILLER_25_192 vssd1 vssd1 vccd1 vccd1 sky130_fd_sc_hd__fill_1
X_1360_ net21 _0591_ vssd1 vssd1 vccd1 vccd1 _0592_ sky130_fd_sc_hd__nor2_1
X_1291_ _0449_ _0511_ vssd1 vssd1 vccd1 vccd1 _0523_ sky130_fd_sc_hd__xnor2_1
XFILLER_31_195 vssd1 vssd1 vccd1 vccd1 sky130_fd_sc_hd__fill_1
Xteam_04_108 vssd1 vssd1 vccd1 vccd1 gpio_oeb[26] team_04_108/LO sky130_fd_sc_hd__conb_1
X_1558_ _0770_ _0771_ net141 net39 vssd1 vssd1 vccd1 vccd1 _0050_ sky130_fd_sc_hd__a2bb2o_1
X_1489_ _0711_ _0712_ net35 vssd1 vssd1 vccd1 vccd1 _0714_ sky130_fd_sc_hd__o21ai_1
X_1627_ clknet_3_7__leaf_clk _0036_ net58 vssd1 vssd1 vccd1 vccd1 STOPWATCH_INST.clock_div.cycles\[11\]
+ sky130_fd_sc_hd__dfrtp_4
XFILLER_39_284 vccd1 vssd1 vccd1 vssd1 sky130_ef_sc_hd__decap_40_12
XFILLER_36_26 vssd1 vssd1 vccd1 vccd1 sky130_fd_sc_hd__fill_2
XFILLER_7_3 vssd1 vssd1 vccd1 vccd1 sky130_fd_sc_hd__fill_4
XTAP_TAPCELL_ROW_9_144 vssd1 vccd1 sky130_fd_sc_hd__tapvpwrvgnd_1
XFILLER_45_221 vssd1 vssd1 vccd1 vccd1 sky130_fd_sc_hd__fill_2
XFILLER_26_92 vssd1 vssd1 vccd1 vccd1 sky130_fd_sc_hd__fill_2
X_0791_ STOPWATCH_INST.clock_div.cycles\[29\] vssd1 vssd1 vccd1 vccd1 _0065_ sky130_fd_sc_hd__inv_2
X_0860_ _0119_ _0120_ _0121_ _0122_ vssd1 vssd1 vccd1 vccd1 _0123_ sky130_fd_sc_hd__or4_2
XFILLER_9_155 vssd1 vssd1 vccd1 vccd1 sky130_fd_sc_hd__fill_2
X_1343_ _0498_ net25 vssd1 vssd1 vccd1 vccd1 _0575_ sky130_fd_sc_hd__and2_1
X_1412_ _0557_ _0632_ _0633_ _0552_ vssd1 vssd1 vccd1 vccd1 _0644_ sky130_fd_sc_hd__a2bb2o_1
X_1274_ _0449_ _0505_ vssd1 vssd1 vccd1 vccd1 _0506_ sky130_fd_sc_hd__nor2_1
X_0989_ net47 net46 _0199_ _0207_ vssd1 vssd1 vccd1 vccd1 _0221_ sky130_fd_sc_hd__a2bb2o_4
XFILLER_27_210 vccd1 vssd1 vccd1 vssd1 sky130_ef_sc_hd__decap_40_12
XFILLER_12_83 vssd1 vssd1 vccd1 vccd1 sky130_fd_sc_hd__fill_1
XFILLER_18_265 vssd1 vssd1 vccd1 vccd1 sky130_fd_sc_hd__fill_2
XFILLER_33_246 vssd1 vssd1 vccd1 vccd1 sky130_fd_sc_hd__fill_4
X_0912_ net178 _0155_ _0157_ vssd1 vssd1 vccd1 vccd1 _0018_ sky130_fd_sc_hd__o21a_1
X_0843_ STOPWATCH_INST.bcd_num\[5\] net52 vssd1 vssd1 vccd1 vccd1 _0109_ sky130_fd_sc_hd__nand2_1
X_1326_ _0485_ _0532_ vssd1 vssd1 vccd1 vccd1 _0558_ sky130_fd_sc_hd__nor2_1
XTAP_TAPCELL_ROW_3_117 vssd1 vccd1 sky130_fd_sc_hd__tapvpwrvgnd_1
X_1188_ _0356_ _0372_ vssd1 vssd1 vccd1 vccd1 _0420_ sky130_fd_sc_hd__nand2_1
X_1257_ _0488_ vssd1 vssd1 vccd1 vccd1 _0489_ sky130_fd_sc_hd__inv_2
XFILLER_33_27 vccd1 vssd1 vccd1 vssd1 sky130_ef_sc_hd__decap_40_12
XFILLER_24_279 vssd1 vssd1 vccd1 vccd1 sky130_fd_sc_hd__fill_4
XFILLER_30_249 vssd1 vssd1 vccd1 vccd1 sky130_fd_sc_hd__fill_2
XFILLER_15_257 vssd1 vssd1 vccd1 vccd1 sky130_fd_sc_hd__fill_4
XTAP_TAPCELL_ROW_40_299 vssd1 vccd1 sky130_fd_sc_hd__tapvpwrvgnd_1
XFILLER_23_60 vssd1 vssd1 vccd1 vccd1 sky130_fd_sc_hd__fill_4
X_1042_ net132 _0273_ _0256_ _0223_ vssd1 vssd1 vccd1 vccd1 _0274_ sky130_fd_sc_hd__o2bb2a_1
X_1111_ net134 net31 net48 vssd1 vssd1 vccd1 vccd1 _0343_ sky130_fd_sc_hd__a21o_1
XTAP_TAPCELL_ROW_31_255 vssd1 vccd1 sky130_fd_sc_hd__tapvpwrvgnd_1
X_0826_ STOPWATCH_INST.digit_scanner.ctrl _0094_ _0095_ vssd1 vssd1 vccd1 vccd1 _0096_
+ sky130_fd_sc_hd__and3_1
X_1309_ _0528_ net140 _0540_ vssd1 vssd1 vccd1 vccd1 _0541_ sky130_fd_sc_hd__nand3_1
XFILLER_28_27 vssd1 vssd1 vccd1 vccd1 sky130_fd_sc_hd__fill_1
XFILLER_44_26 vssd1 vssd1 vccd1 vccd1 sky130_fd_sc_hd__fill_2
XTAP_TAPCELL_ROW_22_211 vssd1 vccd1 sky130_fd_sc_hd__tapvpwrvgnd_1
XFILLER_20_271 vssd1 vssd1 vccd1 vccd1 sky130_fd_sc_hd__fill_1
XTAP_TAPCELL_ROW_45_325 vssd1 vccd1 sky130_fd_sc_hd__tapvpwrvgnd_1
XFILLER_34_81 vssd1 vssd1 vccd1 vccd1 sky130_fd_sc_hd__fill_2
XFILLER_11_293 vssd1 vssd1 vccd1 vccd1 sky130_fd_sc_hd__fill_2
X_1591_ clknet_3_1__leaf_clk _0000_ vssd1 vssd1 vccd1 vccd1 STOPWATCH_INST.digit_scanner.ctrl
+ sky130_fd_sc_hd__dfxtp_2
XFILLER_38_102 vssd1 vssd1 vccd1 vccd1 sky130_fd_sc_hd__fill_4
XFILLER_22_3 vccd1 vssd1 vccd1 vssd1 sky130_ef_sc_hd__decap_40_12
X_1025_ net133 net32 vssd1 vssd1 vccd1 vccd1 _0257_ sky130_fd_sc_hd__nand2_1
X_0809_ _0077_ _0080_ _0081_ _0076_ vssd1 vssd1 vccd1 vccd1 STOPWATCH_INST.fsm_inst1.nextState\[0\]
+ sky130_fd_sc_hd__a211o_1
XFILLER_29_113 vssd1 vssd1 vccd1 vccd1 sky130_fd_sc_hd__fill_2
XFILLER_4_289 vssd1 vssd1 vccd1 vccd1 sky130_fd_sc_hd__fill_4
XFILLER_4_201 vssd1 vssd1 vccd1 vccd1 sky130_fd_sc_hd__fill_1
XFILLER_20_83 vssd1 vssd1 vccd1 vccd1 sky130_fd_sc_hd__fill_1
XFILLER_29_81 vssd1 vssd1 vccd1 vccd1 sky130_fd_sc_hd__fill_1
XFILLER_35_105 vssd1 vssd1 vccd1 vccd1 sky130_fd_sc_hd__fill_4
X_1643_ clknet_3_3__leaf_clk _0052_ net54 vssd1 vssd1 vccd1 vccd1 STOPWATCH_INST.clock_div.cycles\[27\]
+ sky130_fd_sc_hd__dfrtp_4
XFILLER_6_96 vssd1 vssd1 vccd1 vccd1 sky130_fd_sc_hd__fill_4
X_1574_ STOPWATCH_INST.clock_div.cycles\[31\] _0067_ _0779_ _0781_ net36 vssd1 vssd1
+ vccd1 vccd1 _0782_ sky130_fd_sc_hd__o311a_1
Xrebuffer13 _0475_ vssd1 vssd1 vccd1 vccd1 net131 sky130_fd_sc_hd__dlygate4sd1_1
Xrebuffer24 STOPWATCH_INST.clock_div.cycles\[25\] vssd1 vssd1 vccd1 vccd1 net142 sky130_fd_sc_hd__dlygate4sd1_1
XFILLER_34_160 vssd1 vssd1 vccd1 vccd1 sky130_fd_sc_hd__fill_2
X_1008_ _0198_ _0206_ _0236_ _0196_ vssd1 vssd1 vccd1 vccd1 _0240_ sky130_fd_sc_hd__o22a_1
XFILLER_1_204 vccd1 vssd1 vccd1 vssd1 sky130_ef_sc_hd__decap_40_12
XFILLER_1_237 vccd1 vssd1 vccd1 vssd1 sky130_ef_sc_hd__decap_40_12
XFILLER_40_174 vssd1 vssd1 vccd1 vccd1 sky130_fd_sc_hd__fill_4
XFILLER_40_141 vssd1 vssd1 vccd1 vccd1 sky130_fd_sc_hd__fill_4
XFILLER_31_93 vssd1 vssd1 vccd1 vccd1 sky130_fd_sc_hd__fill_1
X_1290_ _0450_ _0511_ vssd1 vssd1 vccd1 vccd1 _0522_ sky130_fd_sc_hd__xnor2_1
XFILLER_0_281 vssd1 vssd1 vccd1 vccd1 sky130_fd_sc_hd__fill_8
XFILLER_0_270 vssd1 vssd1 vccd1 vccd1 sky130_fd_sc_hd__fill_8
XFILLER_31_130 vssd1 vssd1 vccd1 vccd1 sky130_fd_sc_hd__fill_1
X_1626_ clknet_3_5__leaf_clk _0035_ net57 vssd1 vssd1 vccd1 vccd1 STOPWATCH_INST.clock_div.cycles\[10\]
+ sky130_fd_sc_hd__dfrtp_4
Xteam_04_109 vssd1 vssd1 vccd1 vccd1 gpio_oeb[27] team_04_109/LO sky130_fd_sc_hd__conb_1
X_1557_ net141 _0768_ _0682_ vssd1 vssd1 vccd1 vccd1 _0771_ sky130_fd_sc_hd__o21ai_1
X_1488_ net48 STOPWATCH_INST.clock_div.cycles\[14\] _0698_ vssd1 vssd1 vccd1 vccd1
+ _0713_ sky130_fd_sc_hd__and3_1
XFILLER_39_296 vssd1 vssd1 vccd1 vccd1 sky130_fd_sc_hd__fill_2
XFILLER_22_130 vssd1 vssd1 vccd1 vccd1 sky130_fd_sc_hd__fill_8
XFILLER_22_141 vssd1 vssd1 vccd1 vccd1 sky130_fd_sc_hd__fill_8
XFILLER_22_185 vssd1 vssd1 vccd1 vccd1 sky130_fd_sc_hd__fill_2
XTAP_TAPCELL_ROW_9_145 vssd1 vccd1 sky130_fd_sc_hd__tapvpwrvgnd_1
XFILLER_45_277 vssd1 vssd1 vccd1 vccd1 sky130_fd_sc_hd__fill_2
XFILLER_26_82 vssd1 vssd1 vccd1 vccd1 sky130_fd_sc_hd__fill_2
XFILLER_9_123 vssd1 vssd1 vccd1 vccd1 sky130_fd_sc_hd__fill_1
XANTENNA__1460__A1 _0185_ vssd1 vssd1 vccd1 vccd1 sky130_fd_sc_hd__diode_2
XFILLER_42_81 vssd1 vssd1 vccd1 vccd1 sky130_fd_sc_hd__fill_2
Xrebuffer4 _0386_ vssd1 vssd1 vccd1 vccd1 net122 sky130_fd_sc_hd__dlygate4sd1_1
XFILLER_9_189 vssd1 vssd1 vccd1 vccd1 sky130_fd_sc_hd__fill_8
X_0790_ STOPWATCH_INST.clock_div.cycles\[27\] vssd1 vssd1 vccd1 vccd1 _0064_ sky130_fd_sc_hd__inv_2
X_1273_ _0454_ _0465_ _0447_ vssd1 vssd1 vccd1 vccd1 _0505_ sky130_fd_sc_hd__a21oi_1
XFILLER_3_31 vssd1 vssd1 vccd1 vccd1 sky130_fd_sc_hd__fill_2
X_1342_ _0170_ STOPWATCH_INST.clock_div.cycles\[7\] STOPWATCH_INST.clock_div.cycles\[8\]
+ vssd1 vssd1 vccd1 vccd1 _0574_ sky130_fd_sc_hd__or3b_1
X_1411_ _0552_ _0560_ _0642_ vssd1 vssd1 vccd1 vccd1 _0643_ sky130_fd_sc_hd__nand3_1
XFILLER_22_29 vssd1 vssd1 vccd1 vccd1 sky130_fd_sc_hd__fill_8
X_0988_ net47 net46 _0198_ _0206_ STOPWATCH_INST.clock_div.cycles\[17\] vssd1 vssd1
+ vccd1 vccd1 _0220_ sky130_fd_sc_hd__o221a_1
X_1609_ clknet_3_0__leaf_clk _0018_ vssd1 vssd1 vccd1 vccd1 STOPWATCH_INST.digit_scanner.period_counter\[9\]
+ sky130_fd_sc_hd__dfxtp_1
XFILLER_27_244 vssd1 vssd1 vccd1 vccd1 sky130_fd_sc_hd__fill_8
XFILLER_27_233 vssd1 vssd1 vccd1 vccd1 sky130_fd_sc_hd__fill_4
XFILLER_27_222 vssd1 vssd1 vccd1 vccd1 sky130_fd_sc_hd__fill_2
XANTENNA_input1_A en vssd1 vssd1 vccd1 vccd1 sky130_fd_sc_hd__diode_2
XFILLER_10_111 vccd1 vssd1 vccd1 vssd1 sky130_ef_sc_hd__decap_40_12
XFILLER_37_81 vssd1 vssd1 vccd1 vccd1 sky130_fd_sc_hd__fill_2
XFILLER_33_225 vssd1 vssd1 vccd1 vccd1 sky130_fd_sc_hd__fill_1
X_0911_ STOPWATCH_INST.digit_scanner.period_counter\[9\] _0155_ _0123_ vssd1 vssd1
+ vccd1 vccd1 _0157_ sky130_fd_sc_hd__a21boi_1
X_0842_ _0100_ _0104_ _0107_ _0108_ vssd1 vssd1 vccd1 vccd1 net9 sky130_fd_sc_hd__a31o_1
X_1325_ _0553_ _0554_ _0550_ _0551_ vssd1 vssd1 vccd1 vccd1 _0557_ sky130_fd_sc_hd__a211o_1
X_1256_ _0454_ net130 net27 _0486_ _0487_ vssd1 vssd1 vccd1 vccd1 _0488_ sky130_fd_sc_hd__a32o_1
XTAP_TAPCELL_ROW_3_118 vssd1 vccd1 sky130_fd_sc_hd__tapvpwrvgnd_1
X_1187_ _0367_ _0418_ vssd1 vssd1 vccd1 vccd1 _0419_ sky130_fd_sc_hd__xor2_1
XFILLER_33_39 vccd1 vssd1 vccd1 vssd1 sky130_ef_sc_hd__decap_40_12
XFILLER_30_228 vssd1 vssd1 vccd1 vccd1 sky130_fd_sc_hd__fill_4
X_1110_ _0330_ net137 _0340_ _0326_ _0336_ vssd1 vssd1 vccd1 vccd1 _0342_ sky130_fd_sc_hd__o221a_1
XFILLER_17_6 vssd1 vssd1 vccd1 vccd1 sky130_fd_sc_hd__fill_1
X_1041_ net133 net32 _0216_ _0219_ vssd1 vssd1 vccd1 vccd1 _0273_ sky130_fd_sc_hd__a211o_1
XFILLER_0_54 vssd1 vssd1 vccd1 vccd1 sky130_fd_sc_hd__fill_2
XTAP_TAPCELL_ROW_31_256 vssd1 vccd1 sky130_fd_sc_hd__tapvpwrvgnd_1
X_0825_ _0084_ net51 net52 vssd1 vssd1 vccd1 vccd1 _0095_ sky130_fd_sc_hd__or3b_1
XFILLER_9_96 vssd1 vssd1 vccd1 vccd1 sky130_fd_sc_hd__fill_1
XFILLER_14_291 vssd1 vssd1 vccd1 vccd1 sky130_fd_sc_hd__fill_8
X_1239_ _0419_ _0424_ vssd1 vssd1 vccd1 vccd1 _0471_ sky130_fd_sc_hd__nand2_1
X_1308_ _0504_ _0526_ vssd1 vssd1 vccd1 vccd1 _0540_ sky130_fd_sc_hd__or2_1
XFILLER_12_217 vssd1 vssd1 vccd1 vccd1 sky130_fd_sc_hd__fill_8
XTAP_TAPCELL_ROW_22_212 vssd1 vccd1 sky130_fd_sc_hd__tapvpwrvgnd_1
XPHY_EDGE_ROW_8_Left_55 vssd1 vssd1 vccd1 vccd1 sky130_fd_sc_hd__decap_3
XTAP_TAPCELL_ROW_45_326 vssd1 vccd1 sky130_fd_sc_hd__tapvpwrvgnd_1
X_1590_ clknet_3_0__leaf_clk net2 net53 vssd1 vssd1 vccd1 vccd1 STOPWATCH_INST.sync_one.sync_1
+ sky130_fd_sc_hd__dfrtp_1
XANTENNA__1572__B1 net36 vssd1 vssd1 vccd1 vccd1 sky130_fd_sc_hd__diode_2
X_1024_ net133 net32 vssd1 vssd1 vccd1 vccd1 _0256_ sky130_fd_sc_hd__and2_1
XFILLER_30_29 vccd1 vssd1 vccd1 vssd1 sky130_ef_sc_hd__decap_40_12
X_0808_ _0071_ _0073_ _0078_ _0079_ vssd1 vssd1 vccd1 vccd1 _0081_ sky130_fd_sc_hd__a2bb2o_1
XFILLER_29_125 vssd1 vssd1 vccd1 vccd1 sky130_fd_sc_hd__fill_2
XANTENNA__1563__B1 net36 vssd1 vssd1 vccd1 vccd1 sky130_fd_sc_hd__diode_2
XFILLER_44_139 vssd1 vssd1 vccd1 vccd1 sky130_fd_sc_hd__fill_1
XFILLER_29_169 vssd1 vssd1 vccd1 vccd1 sky130_fd_sc_hd__fill_1
XFILLER_29_158 vssd1 vssd1 vccd1 vccd1 sky130_fd_sc_hd__fill_2
XFILLER_29_71 vssd1 vssd1 vccd1 vccd1 sky130_fd_sc_hd__fill_8
Xhold60 STOPWATCH_INST.digit_scanner.period_counter\[9\] vssd1 vssd1 vccd1 vccd1 net178
+ sky130_fd_sc_hd__dlygate4sd3_1
XFILLER_45_81 vccd1 vssd1 vccd1 vssd1 sky130_ef_sc_hd__decap_40_12
XFILLER_28_180 vssd1 vssd1 vccd1 vccd1 sky130_fd_sc_hd__fill_2
X_1642_ clknet_3_3__leaf_clk _0051_ net55 vssd1 vssd1 vccd1 vccd1 STOPWATCH_INST.clock_div.cycles\[26\]
+ sky130_fd_sc_hd__dfrtp_4
XANTENNA__1575__A1_N _0185_ vssd1 vssd1 vccd1 vccd1 sky130_fd_sc_hd__diode_2
X_1573_ STOPWATCH_INST.clock_div.cycles\[29\] STOPWATCH_INST.clock_div.cycles\[30\]
+ _0776_ _0066_ vssd1 vssd1 vccd1 vccd1 _0781_ sky130_fd_sc_hd__a31o_1
XFILLER_41_109 vssd1 vssd1 vccd1 vccd1 sky130_fd_sc_hd__fill_2
Xrebuffer14 _0222_ vssd1 vssd1 vccd1 vccd1 net132 sky130_fd_sc_hd__dlygate4sd1_1
X_1007_ _0196_ _0208_ _0236_ _0238_ STOPWATCH_INST.clock_div.cycles\[28\] vssd1 vssd1
+ vccd1 vccd1 _0239_ sky130_fd_sc_hd__o32ai_4
XFILLER_1_249 vccd1 vssd1 vccd1 vssd1 sky130_ef_sc_hd__decap_40_12
XFILLER_1_216 vssd1 vssd1 vccd1 vccd1 sky130_fd_sc_hd__fill_8
XFILLER_16_194 vssd1 vssd1 vccd1 vccd1 sky130_fd_sc_hd__fill_2
XTAP_TAPCELL_ROW_18_189 vssd1 vccd1 sky130_fd_sc_hd__tapvpwrvgnd_1
X_1625_ clknet_3_5__leaf_clk _0034_ net57 vssd1 vssd1 vccd1 vccd1 STOPWATCH_INST.clock_div.cycles\[9\]
+ sky130_fd_sc_hd__dfrtp_2
X_1556_ STOPWATCH_INST.clock_div.cycles\[23\] net136 net141 _0758_ vssd1 vssd1 vccd1
+ vccd1 _0770_ sky130_fd_sc_hd__and4_1
X_1487_ net48 _0698_ STOPWATCH_INST.clock_div.cycles\[14\] vssd1 vssd1 vccd1 vccd1
+ _0712_ sky130_fd_sc_hd__a21oi_1
XFILLER_22_197 vssd1 vssd1 vccd1 vccd1 sky130_fd_sc_hd__fill_4
XTAP_TAPCELL_ROW_9_146 vssd1 vccd1 sky130_fd_sc_hd__tapvpwrvgnd_1
XFILLER_45_223 vssd1 vssd1 vccd1 vccd1 sky130_fd_sc_hd__fill_1
XPHY_EDGE_ROW_37_Left_84 vssd1 vssd1 vccd1 vccd1 sky130_fd_sc_hd__decap_3
XFILLER_26_50 vssd1 vssd1 vccd1 vccd1 sky130_fd_sc_hd__fill_4
XFILLER_9_113 vssd1 vssd1 vccd1 vccd1 sky130_fd_sc_hd__fill_8
XFILLER_9_157 vssd1 vssd1 vccd1 vccd1 sky130_fd_sc_hd__fill_1
Xrebuffer5 STOPWATCH_INST.clock_div.cycles\[24\] vssd1 vssd1 vccd1 vccd1 net123 sky130_fd_sc_hd__dlygate4sd1_1
XPHY_EDGE_ROW_21_Left_68 vssd1 vssd1 vccd1 vccd1 sky130_fd_sc_hd__decap_3
X_1410_ _0563_ _0640_ vssd1 vssd1 vccd1 vccd1 _0642_ sky130_fd_sc_hd__xor2_2
X_1341_ _0483_ _0558_ vssd1 vssd1 vccd1 vccd1 _0573_ sky130_fd_sc_hd__xnor2_2
X_1272_ _0500_ _0502_ _0488_ vssd1 vssd1 vccd1 vccd1 _0504_ sky130_fd_sc_hd__a21o_1
XFILLER_3_10 vssd1 vssd1 vccd1 vccd1 sky130_fd_sc_hd__fill_1
X_0987_ _0215_ _0062_ _0217_ vssd1 vssd1 vccd1 vccd1 _0219_ sky130_fd_sc_hd__and3_1
XTAP_TAPCELL_ROW_14_170 vssd1 vccd1 sky130_fd_sc_hd__tapvpwrvgnd_1
X_1608_ clknet_3_0__leaf_clk _0017_ vssd1 vssd1 vccd1 vccd1 STOPWATCH_INST.digit_scanner.period_counter\[8\]
+ sky130_fd_sc_hd__dfxtp_1
X_1539_ _0642_ _0750_ _0755_ _0648_ _0185_ vssd1 vssd1 vccd1 vccd1 _0756_ sky130_fd_sc_hd__o221ai_2
XTAP_TAPCELL_ROW_37_284 vssd1 vccd1 sky130_fd_sc_hd__tapvpwrvgnd_1
XFILLER_10_101 vssd1 vssd1 vccd1 vccd1 sky130_fd_sc_hd__fill_4
XFILLER_10_123 vssd1 vssd1 vccd1 vccd1 sky130_fd_sc_hd__fill_2
XFILLER_18_201 vssd1 vssd1 vccd1 vccd1 sky130_fd_sc_hd__fill_1
XFILLER_33_237 vssd1 vssd1 vccd1 vccd1 sky130_fd_sc_hd__fill_2
XTAP_TAPCELL_ROW_28_240 vssd1 vccd1 sky130_fd_sc_hd__tapvpwrvgnd_1
XPHY_EDGE_ROW_16_Right_16 vssd1 vssd1 vccd1 vccd1 sky130_fd_sc_hd__decap_3
XFILLER_18_267 vssd1 vssd1 vccd1 vccd1 sky130_fd_sc_hd__fill_1
XFILLER_41_281 vccd1 vssd1 vccd1 vssd1 sky130_ef_sc_hd__decap_40_12
XFILLER_41_270 vssd1 vssd1 vccd1 vccd1 sky130_fd_sc_hd__fill_8
X_0910_ _0123_ _0154_ _0156_ vssd1 vssd1 vccd1 vccd1 _0017_ sky130_fd_sc_hd__and3_1
X_0841_ STOPWATCH_INST.bcd_num\[7\] _0093_ _0106_ STOPWATCH_INST.digit_scanner.ctrl
+ vssd1 vssd1 vccd1 vccd1 _0108_ sky130_fd_sc_hd__o211a_1
XPHY_EDGE_ROW_25_Right_25 vssd1 vssd1 vccd1 vccd1 sky130_fd_sc_hd__decap_3
X_1186_ _0375_ _0417_ vssd1 vssd1 vccd1 vccd1 _0418_ sky130_fd_sc_hd__nand2_1
XPHY_EDGE_ROW_34_Right_34 vssd1 vssd1 vccd1 vccd1 sky130_fd_sc_hd__decap_3
X_1255_ _0454_ _0465_ vssd1 vssd1 vccd1 vccd1 _0487_ sky130_fd_sc_hd__or2_1
X_1324_ _0552_ _0555_ vssd1 vssd1 vccd1 vccd1 _0556_ sky130_fd_sc_hd__and2b_1
XPHY_EDGE_ROW_43_Right_43 vssd1 vssd1 vccd1 vccd1 sky130_fd_sc_hd__decap_3
XFILLER_23_270 vssd1 vssd1 vccd1 vccd1 sky130_fd_sc_hd__fill_1
XFILLER_2_141 vssd1 vssd1 vccd1 vccd1 sky130_fd_sc_hd__fill_4
X_1040_ net33 net32 _0219_ vssd1 vssd1 vccd1 vccd1 _0272_ sky130_fd_sc_hd__a21o_1
XTAP_TAPCELL_ROW_31_257 vssd1 vccd1 sky130_fd_sc_hd__tapvpwrvgnd_1
X_0824_ _0084_ _0093_ vssd1 vssd1 vccd1 vccd1 _0094_ sky130_fd_sc_hd__or2_1
XPHY_EDGE_ROW_24_Left_71 vssd1 vssd1 vccd1 vccd1 sky130_fd_sc_hd__decap_3
XFILLER_28_29 vccd1 vssd1 vccd1 vssd1 sky130_ef_sc_hd__decap_40_12
X_1238_ _0468_ _0469_ vssd1 vssd1 vccd1 vccd1 _0470_ sky130_fd_sc_hd__nor2_1
X_1169_ _0396_ _0400_ vssd1 vssd1 vccd1 vccd1 _0401_ sky130_fd_sc_hd__nand2_1
X_1307_ _0526_ _0537_ vssd1 vssd1 vccd1 vccd1 _0539_ sky130_fd_sc_hd__xor2_1
XTAP_TAPCELL_ROW_22_213 vssd1 vccd1 sky130_fd_sc_hd__tapvpwrvgnd_1
Xclkbuf_3_0__f_clk clknet_0_clk vssd1 vssd1 vccd1 vccd1 clknet_3_0__leaf_clk sky130_fd_sc_hd__clkbuf_16
XTAP_TAPCELL_ROW_45_327 vssd1 vccd1 sky130_fd_sc_hd__tapvpwrvgnd_1
XFILLER_34_83 vssd1 vssd1 vccd1 vccd1 sky130_fd_sc_hd__fill_1
XFILLER_7_277 vssd1 vssd1 vccd1 vccd1 sky130_fd_sc_hd__fill_2
XFILLER_11_295 vssd1 vssd1 vccd1 vccd1 sky130_fd_sc_hd__fill_1
XFILLER_46_181 vccd1 vssd1 vccd1 vssd1 sky130_ef_sc_hd__decap_40_12
XFILLER_38_159 vssd1 vssd1 vccd1 vccd1 sky130_fd_sc_hd__fill_4
XFILLER_38_148 vssd1 vssd1 vccd1 vccd1 sky130_fd_sc_hd__fill_4
X_1023_ STOPWATCH_INST.clock_div.cycles\[31\] _0208_ _0254_ vssd1 vssd1 vccd1 vccd1
+ _0255_ sky130_fd_sc_hd__a21oi_1
X_0807_ _0058_ STOPWATCH_INST.fsm_inst1.currentState\[0\] vssd1 vssd1 vccd1 vccd1
+ _0080_ sky130_fd_sc_hd__nor2_1
XFILLER_29_104 vssd1 vssd1 vccd1 vccd1 sky130_fd_sc_hd__fill_1
XPHY_EDGE_ROW_2_Right_2 vssd1 vssd1 vccd1 vccd1 sky130_fd_sc_hd__decap_3
XFILLER_20_41 vccd1 vssd1 vccd1 vssd1 sky130_ef_sc_hd__decap_40_12
XFILLER_20_96 vssd1 vssd1 vccd1 vccd1 sky130_fd_sc_hd__fill_1
Xhold61 STOPWATCH_INST.clock_div.cycles\[4\] vssd1 vssd1 vccd1 vccd1 net179 sky130_fd_sc_hd__dlygate4sd3_1
Xhold50 STOPWATCH_INST.digit_scanner.period_counter\[14\] vssd1 vssd1 vccd1 vccd1
+ net168 sky130_fd_sc_hd__dlygate4sd3_1
XFILLER_45_93 vccd1 vssd1 vccd1 vssd1 sky130_ef_sc_hd__decap_40_12
X_1641_ clknet_3_3__leaf_clk _0050_ net55 vssd1 vssd1 vccd1 vccd1 STOPWATCH_INST.clock_div.cycles\[25\]
+ sky130_fd_sc_hd__dfrtp_1
X_1572_ STOPWATCH_INST.clock_div.cycles\[30\] net39 net36 _0780_ vssd1 vssd1 vccd1
+ vccd1 _0055_ sky130_fd_sc_hd__a22o_1
X_1006_ _0199_ _0207_ _0236_ _0064_ vssd1 vssd1 vccd1 vccd1 _0238_ sky130_fd_sc_hd__a211oi_2
XFILLER_41_18 vccd1 vssd1 vccd1 vssd1 sky130_ef_sc_hd__decap_40_12
XFILLER_31_73 vccd1 vssd1 vccd1 vssd1 sky130_ef_sc_hd__decap_40_12
XFILLER_31_51 vssd1 vssd1 vccd1 vccd1 sky130_fd_sc_hd__fill_4
XFILLER_31_165 vssd1 vssd1 vccd1 vccd1 sky130_fd_sc_hd__fill_2
XANTENNA__1463__B1 net36 vssd1 vssd1 vccd1 vccd1 sky130_fd_sc_hd__diode_2
X_1624_ clknet_3_5__leaf_clk _0033_ net56 vssd1 vssd1 vccd1 vccd1 STOPWATCH_INST.clock_div.cycles\[8\]
+ sky130_fd_sc_hd__dfrtp_4
X_1555_ net136 _0070_ _0769_ vssd1 vssd1 vccd1 vccd1 _0049_ sky130_fd_sc_hd__a21bo_1
XFILLER_39_298 vssd1 vssd1 vccd1 vccd1 sky130_fd_sc_hd__fill_1
XFILLER_36_29 vccd1 vssd1 vccd1 vssd1 sky130_ef_sc_hd__decap_40_12
XFILLER_36_18 vssd1 vssd1 vccd1 vccd1 sky130_fd_sc_hd__fill_8
X_1486_ net48 STOPWATCH_INST.clock_div.cycles\[14\] _0698_ vssd1 vssd1 vccd1 vccd1
+ _0711_ sky130_fd_sc_hd__and3_1
XTAP_TAPCELL_ROW_9_147 vssd1 vccd1 sky130_fd_sc_hd__tapvpwrvgnd_1
XFILLER_45_279 vssd1 vssd1 vccd1 vccd1 sky130_fd_sc_hd__fill_1
XFILLER_42_83 vssd1 vssd1 vccd1 vccd1 sky130_fd_sc_hd__fill_1
XFILLER_13_165 vssd1 vssd1 vccd1 vccd1 sky130_fd_sc_hd__fill_2
Xrebuffer6 STOPWATCH_INST.clock_div.cycles\[25\] vssd1 vssd1 vccd1 vccd1 net124 sky130_fd_sc_hd__dlygate4sd1_1
X_1340_ _0060_ net25 vssd1 vssd1 vccd1 vccd1 _0572_ sky130_fd_sc_hd__xnor2_2
X_1271_ _0500_ _0502_ vssd1 vssd1 vccd1 vccd1 _0503_ sky130_fd_sc_hd__nand2_1
XFILLER_3_77 vssd1 vssd1 vccd1 vccd1 sky130_fd_sc_hd__fill_4
X_0986_ _0215_ _0217_ vssd1 vssd1 vccd1 vccd1 _0218_ sky130_fd_sc_hd__nand2_1
XTAP_TAPCELL_ROW_14_171 vssd1 vccd1 sky130_fd_sc_hd__tapvpwrvgnd_1
X_1607_ clknet_3_1__leaf_clk _0016_ vssd1 vssd1 vccd1 vccd1 STOPWATCH_INST.digit_scanner.period_counter\[7\]
+ sky130_fd_sc_hd__dfxtp_1
X_1469_ _0609_ net17 vssd1 vssd1 vccd1 vccd1 _0696_ sky130_fd_sc_hd__nand2b_1
X_1538_ _0639_ _0645_ vssd1 vssd1 vccd1 vccd1 _0755_ sky130_fd_sc_hd__nand2_1
XFILLER_42_205 vssd1 vssd1 vccd1 vccd1 sky130_fd_sc_hd__fill_8
XFILLER_27_279 vssd1 vssd1 vccd1 vccd1 sky130_fd_sc_hd__fill_1
XTAP_TAPCELL_ROW_37_285 vssd1 vccd1 sky130_fd_sc_hd__tapvpwrvgnd_1
XFILLER_6_106 vssd1 vssd1 vccd1 vccd1 sky130_fd_sc_hd__fill_2
XFILLER_6_139 vssd1 vssd1 vccd1 vccd1 sky130_fd_sc_hd__fill_1
XFILLER_37_83 vssd1 vssd1 vccd1 vccd1 sky130_fd_sc_hd__fill_1
XTAP_TAPCELL_ROW_28_241 vssd1 vccd1 sky130_fd_sc_hd__tapvpwrvgnd_1
XFILLER_26_290 vssd1 vssd1 vccd1 vccd1 sky130_fd_sc_hd__fill_4
XFILLER_41_293 vssd1 vssd1 vccd1 vccd1 sky130_fd_sc_hd__fill_4
X_0840_ _0087_ _0090_ STOPWATCH_INST.digit_scanner.ctrl vssd1 vssd1 vccd1 vccd1 _0107_
+ sky130_fd_sc_hd__a21oi_1
XFILLER_38_3 vccd1 vssd1 vccd1 vssd1 sky130_ef_sc_hd__decap_40_12
X_1323_ _0553_ _0554_ vssd1 vssd1 vccd1 vccd1 _0555_ sky130_fd_sc_hd__nand2_1
X_1185_ _0410_ _0402_ _0413_ _0416_ vssd1 vssd1 vccd1 vccd1 _0417_ sky130_fd_sc_hd__a211o_4
X_1254_ net26 net27 _0466_ vssd1 vssd1 vccd1 vccd1 _0486_ sky130_fd_sc_hd__a21oi_4
X_0969_ net45 _0200_ _0175_ vssd1 vssd1 vccd1 vccd1 _0201_ sky130_fd_sc_hd__o21bai_4
XFILLER_23_30 vssd1 vssd1 vccd1 vccd1 sky130_fd_sc_hd__fill_2
XFILLER_0_23 vssd1 vssd1 vccd1 vccd1 sky130_fd_sc_hd__fill_1
XFILLER_0_45 vssd1 vssd1 vccd1 vccd1 sky130_fd_sc_hd__fill_2
XTAP_TAPCELL_ROW_31_258 vssd1 vccd1 sky130_fd_sc_hd__tapvpwrvgnd_1
XFILLER_9_54 vssd1 vssd1 vccd1 vccd1 sky130_fd_sc_hd__fill_2
XFILLER_21_219 vssd1 vssd1 vccd1 vccd1 sky130_fd_sc_hd__fill_1
X_0823_ net52 net51 vssd1 vssd1 vccd1 vccd1 _0093_ sky130_fd_sc_hd__nand2b_1
X_1306_ _0526_ _0537_ vssd1 vssd1 vccd1 vccd1 _0538_ sky130_fd_sc_hd__xnor2_2
XFILLER_44_29 vccd1 vssd1 vccd1 vssd1 sky130_ef_sc_hd__decap_40_12
XFILLER_44_18 vssd1 vssd1 vccd1 vccd1 sky130_fd_sc_hd__fill_8
X_1237_ _0426_ _0433_ _0451_ vssd1 vssd1 vccd1 vccd1 _0469_ sky130_fd_sc_hd__and3_1
X_1099_ _0282_ _0292_ vssd1 vssd1 vccd1 vccd1 _0331_ sky130_fd_sc_hd__nor2_1
X_1168_ _0398_ _0399_ vssd1 vssd1 vccd1 vccd1 _0400_ sky130_fd_sc_hd__nor2_1
XTAP_TAPCELL_ROW_45_328 vssd1 vccd1 sky130_fd_sc_hd__tapvpwrvgnd_1
XFILLER_7_245 vccd1 vssd1 vccd1 vssd1 sky130_ef_sc_hd__decap_40_12
XFILLER_46_193 vssd1 vssd1 vccd1 vccd1 sky130_fd_sc_hd__fill_2
X_1022_ _0242_ _0253_ _0249_ vssd1 vssd1 vccd1 vccd1 _0254_ sky130_fd_sc_hd__a21oi_1
XFILLER_39_18 vccd1 vssd1 vccd1 vssd1 sky130_ef_sc_hd__decap_40_12
X_0806_ _0058_ STOPWATCH_INST.fsm_inst1.currentState\[0\] vssd1 vssd1 vccd1 vccd1
+ _0079_ sky130_fd_sc_hd__and2_1
XFILLER_29_127 vssd1 vssd1 vccd1 vccd1 sky130_fd_sc_hd__fill_1
XTAP_TAPCELL_ROW_42_309 vssd1 vccd1 sky130_fd_sc_hd__tapvpwrvgnd_1
XANTENNA__1539__C1 _0185_ vssd1 vssd1 vccd1 vccd1 sky130_fd_sc_hd__diode_2
XFILLER_29_51 vssd1 vssd1 vccd1 vccd1 sky130_fd_sc_hd__fill_4
Xhold40 STOPWATCH_INST.sync_pause.sync_2 vssd1 vssd1 vccd1 vccd1 net158 sky130_fd_sc_hd__dlygate4sd3_1
XFILLER_20_64 vssd1 vssd1 vccd1 vccd1 sky130_fd_sc_hd__fill_1
XFILLER_43_141 vssd1 vssd1 vccd1 vccd1 sky130_fd_sc_hd__fill_2
Xhold51 _0165_ vssd1 vssd1 vccd1 vccd1 net169 sky130_fd_sc_hd__dlygate4sd3_1
Xhold62 STOPWATCH_INST.clock_div.cycles\[0\] vssd1 vssd1 vccd1 vccd1 net180 sky130_fd_sc_hd__dlygate4sd3_1
XFILLER_3_281 vccd1 vssd1 vccd1 vssd1 sky130_ef_sc_hd__decap_40_12
X_1640_ clknet_3_3__leaf_clk _0049_ net55 vssd1 vssd1 vccd1 vccd1 STOPWATCH_INST.clock_div.cycles\[24\]
+ sky130_fd_sc_hd__dfrtp_1
X_1571_ STOPWATCH_INST.clock_div.cycles\[30\] _0779_ vssd1 vssd1 vccd1 vccd1 _0780_
+ sky130_fd_sc_hd__xnor2_1
XFILLER_34_130 vssd1 vssd1 vccd1 vccd1 sky130_fd_sc_hd__fill_2
X_1005_ _0207_ _0199_ _0236_ vssd1 vssd1 vccd1 vccd1 _0237_ sky130_fd_sc_hd__a21oi_4
XFILLER_15_64 vssd1 vssd1 vccd1 vccd1 sky130_fd_sc_hd__fill_4
XFILLER_15_75 vssd1 vssd1 vccd1 vccd1 sky130_fd_sc_hd__fill_2
XFILLER_25_196 vssd1 vssd1 vccd1 vccd1 sky130_fd_sc_hd__fill_8
XFILLER_31_85 vssd1 vssd1 vccd1 vccd1 sky130_fd_sc_hd__fill_8
XFILLER_0_251 vssd1 vssd1 vccd1 vccd1 sky130_fd_sc_hd__fill_1
XFILLER_16_141 vssd1 vssd1 vccd1 vccd1 sky130_fd_sc_hd__fill_4
XFILLER_16_163 vssd1 vssd1 vccd1 vccd1 sky130_fd_sc_hd__fill_1
XFILLER_31_144 vssd1 vssd1 vccd1 vccd1 sky130_fd_sc_hd__fill_8
X_1623_ clknet_3_4__leaf_clk _0032_ net56 vssd1 vssd1 vccd1 vccd1 STOPWATCH_INST.clock_div.cycles\[7\]
+ sky130_fd_sc_hd__dfrtp_4
X_1554_ _0767_ _0768_ _0682_ vssd1 vssd1 vccd1 vccd1 _0769_ sky130_fd_sc_hd__or3b_1
X_1485_ _0709_ net34 _0707_ vssd1 vssd1 vccd1 vccd1 _0710_ sky130_fd_sc_hd__or3b_4
.ends
