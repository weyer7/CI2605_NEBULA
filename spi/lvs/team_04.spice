* NGSPICE file created from team_04.ext - technology: sky130A

* Black-box entry subcircuit for sky130_ef_sc_hd__decap_40_12 abstract view
.subckt sky130_ef_sc_hd__decap_40_12 VPWR VGND VPB VNB
.ends

* Black-box entry subcircuit for sky130_fd_sc_hd__fill_4 abstract view
.subckt sky130_fd_sc_hd__fill_4 VGND VNB VPB VPWR
.ends

* Black-box entry subcircuit for sky130_fd_sc_hd__tapvpwrvgnd_1 abstract view
.subckt sky130_fd_sc_hd__tapvpwrvgnd_1 VGND VPWR
.ends

* Black-box entry subcircuit for sky130_fd_sc_hd__fill_1 abstract view
.subckt sky130_fd_sc_hd__fill_1 VGND VNB VPB VPWR
.ends

* Black-box entry subcircuit for sky130_fd_sc_hd__dlymetal6s4s_1 abstract view
.subckt sky130_fd_sc_hd__dlymetal6s4s_1 A VGND VNB VPB VPWR X
.ends

* Black-box entry subcircuit for sky130_fd_sc_hd__fill_2 abstract view
.subckt sky130_fd_sc_hd__fill_2 VGND VNB VPB VPWR
.ends

* Black-box entry subcircuit for sky130_fd_sc_hd__o21ai_2 abstract view
.subckt sky130_fd_sc_hd__o21ai_2 A1 A2 B1 VGND VNB VPB VPWR Y
.ends

* Black-box entry subcircuit for sky130_fd_sc_hd__nor2_1 abstract view
.subckt sky130_fd_sc_hd__nor2_1 A B VGND VNB VPB VPWR Y
.ends

* Black-box entry subcircuit for sky130_fd_sc_hd__dfxtp_1 abstract view
.subckt sky130_fd_sc_hd__dfxtp_1 CLK D VGND VNB VPB VPWR Q
.ends

* Black-box entry subcircuit for sky130_fd_sc_hd__o21ai_1 abstract view
.subckt sky130_fd_sc_hd__o21ai_1 A1 A2 B1 VGND VNB VPB VPWR Y
.ends

* Black-box entry subcircuit for sky130_fd_sc_hd__a31o_1 abstract view
.subckt sky130_fd_sc_hd__a31o_1 A1 A2 A3 B1 VGND VNB VPB VPWR X
.ends

* Black-box entry subcircuit for sky130_fd_sc_hd__a21oi_2 abstract view
.subckt sky130_fd_sc_hd__a21oi_2 A1 A2 B1 VGND VNB VPB VPWR Y
.ends

* Black-box entry subcircuit for sky130_fd_sc_hd__a32o_2 abstract view
.subckt sky130_fd_sc_hd__a32o_2 A1 A2 A3 B1 B2 VGND VNB VPB VPWR X
.ends

* Black-box entry subcircuit for sky130_fd_sc_hd__or2_1 abstract view
.subckt sky130_fd_sc_hd__or2_1 A B VGND VNB VPB VPWR X
.ends

* Black-box entry subcircuit for sky130_fd_sc_hd__a21bo_1 abstract view
.subckt sky130_fd_sc_hd__a21bo_1 A1 A2 B1_N VGND VNB VPB VPWR X
.ends

* Black-box entry subcircuit for sky130_fd_sc_hd__o31a_1 abstract view
.subckt sky130_fd_sc_hd__o31a_1 A1 A2 A3 B1 VGND VNB VPB VPWR X
.ends

* Black-box entry subcircuit for sky130_fd_sc_hd__a21o_1 abstract view
.subckt sky130_fd_sc_hd__a21o_1 A1 A2 B1 VGND VNB VPB VPWR X
.ends

* Black-box entry subcircuit for sky130_fd_sc_hd__diode_2 abstract view
.subckt sky130_fd_sc_hd__diode_2 DIODE VGND VNB VPB VPWR
.ends

* Black-box entry subcircuit for sky130_fd_sc_hd__a21oi_1 abstract view
.subckt sky130_fd_sc_hd__a21oi_1 A1 A2 B1 VGND VNB VPB VPWR Y
.ends

* Black-box entry subcircuit for sky130_fd_sc_hd__nand2_1 abstract view
.subckt sky130_fd_sc_hd__nand2_1 A B VGND VNB VPB VPWR Y
.ends

* Black-box entry subcircuit for sky130_fd_sc_hd__or3_1 abstract view
.subckt sky130_fd_sc_hd__or3_1 A B C VGND VNB VPB VPWR X
.ends

* Black-box entry subcircuit for sky130_fd_sc_hd__inv_2 abstract view
.subckt sky130_fd_sc_hd__inv_2 A VGND VNB VPB VPWR Y
.ends

* Black-box entry subcircuit for sky130_fd_sc_hd__xnor2_4 abstract view
.subckt sky130_fd_sc_hd__xnor2_4 A B VGND VNB VPB VPWR Y
.ends

* Black-box entry subcircuit for sky130_fd_sc_hd__and3b_1 abstract view
.subckt sky130_fd_sc_hd__and3b_1 A_N B C VGND VNB VPB VPWR X
.ends

* Black-box entry subcircuit for sky130_fd_sc_hd__dlygate4sd3_1 abstract view
.subckt sky130_fd_sc_hd__dlygate4sd3_1 A VGND VNB VPB VPWR X
.ends

* Black-box entry subcircuit for sky130_fd_sc_hd__dfrtp_1 abstract view
.subckt sky130_fd_sc_hd__dfrtp_1 CLK D RESET_B VGND VNB VPB VPWR Q
.ends

* Black-box entry subcircuit for sky130_fd_sc_hd__dlygate4sd1_1 abstract view
.subckt sky130_fd_sc_hd__dlygate4sd1_1 A VGND VNB VPB VPWR X
.ends

* Black-box entry subcircuit for sky130_fd_sc_hd__clkbuf_2 abstract view
.subckt sky130_fd_sc_hd__clkbuf_2 A VGND VNB VPB VPWR X
.ends

* Black-box entry subcircuit for sky130_fd_sc_hd__fill_8 abstract view
.subckt sky130_fd_sc_hd__fill_8 VGND VNB VPB VPWR
.ends

* Black-box entry subcircuit for sky130_fd_sc_hd__buf_6 abstract view
.subckt sky130_fd_sc_hd__buf_6 A VGND VNB VPB VPWR X
.ends

* Black-box entry subcircuit for sky130_fd_sc_hd__clkbuf_1 abstract view
.subckt sky130_fd_sc_hd__clkbuf_1 A VGND VNB VPB VPWR X
.ends

* Black-box entry subcircuit for sky130_fd_sc_hd__buf_2 abstract view
.subckt sky130_fd_sc_hd__buf_2 A VGND VNB VPB VPWR X
.ends

* Black-box entry subcircuit for sky130_fd_sc_hd__dfrtp_4 abstract view
.subckt sky130_fd_sc_hd__dfrtp_4 CLK D RESET_B VGND VNB VPB VPWR Q
.ends

* Black-box entry subcircuit for sky130_fd_sc_hd__a22o_1 abstract view
.subckt sky130_fd_sc_hd__a22o_1 A1 A2 B1 B2 VGND VNB VPB VPWR X
.ends

* Black-box entry subcircuit for sky130_fd_sc_hd__clkbuf_16 abstract view
.subckt sky130_fd_sc_hd__clkbuf_16 A VGND VNB VPB VPWR X
.ends

* Black-box entry subcircuit for sky130_fd_sc_hd__o21a_1 abstract view
.subckt sky130_fd_sc_hd__o21a_1 A1 A2 B1 VGND VNB VPB VPWR X
.ends

* Black-box entry subcircuit for sky130_fd_sc_hd__xnor2_1 abstract view
.subckt sky130_fd_sc_hd__xnor2_1 A B VGND VNB VPB VPWR Y
.ends

* Black-box entry subcircuit for sky130_fd_sc_hd__a211oi_2 abstract view
.subckt sky130_fd_sc_hd__a211oi_2 A1 A2 B1 C1 VGND VNB VPB VPWR Y
.ends

* Black-box entry subcircuit for sky130_fd_sc_hd__and3_2 abstract view
.subckt sky130_fd_sc_hd__and3_2 A B C VGND VNB VPB VPWR X
.ends

* Black-box entry subcircuit for sky130_fd_sc_hd__decap_3 abstract view
.subckt sky130_fd_sc_hd__decap_3 VGND VNB VPB VPWR
.ends

* Black-box entry subcircuit for sky130_fd_sc_hd__o311a_1 abstract view
.subckt sky130_fd_sc_hd__o311a_1 A1 A2 A3 B1 C1 VGND VNB VPB VPWR X
.ends

* Black-box entry subcircuit for sky130_fd_sc_hd__xor2_2 abstract view
.subckt sky130_fd_sc_hd__xor2_2 A B VGND VNB VPB VPWR X
.ends

* Black-box entry subcircuit for sky130_fd_sc_hd__xor2_4 abstract view
.subckt sky130_fd_sc_hd__xor2_4 A B VGND VNB VPB VPWR X
.ends

* Black-box entry subcircuit for sky130_fd_sc_hd__and3_1 abstract view
.subckt sky130_fd_sc_hd__and3_1 A B C VGND VNB VPB VPWR X
.ends

* Black-box entry subcircuit for sky130_fd_sc_hd__xor2_1 abstract view
.subckt sky130_fd_sc_hd__xor2_1 A B VGND VNB VPB VPWR X
.ends

* Black-box entry subcircuit for sky130_fd_sc_hd__a311o_1 abstract view
.subckt sky130_fd_sc_hd__a311o_1 A1 A2 A3 B1 C1 VGND VNB VPB VPWR X
.ends

* Black-box entry subcircuit for sky130_fd_sc_hd__xnor2_2 abstract view
.subckt sky130_fd_sc_hd__xnor2_2 A B VGND VNB VPB VPWR Y
.ends

* Black-box entry subcircuit for sky130_fd_sc_hd__a32o_1 abstract view
.subckt sky130_fd_sc_hd__a32o_1 A1 A2 A3 B1 B2 VGND VNB VPB VPWR X
.ends

* Black-box entry subcircuit for sky130_fd_sc_hd__and2_1 abstract view
.subckt sky130_fd_sc_hd__and2_1 A B VGND VNB VPB VPWR X
.ends

* Black-box entry subcircuit for sky130_fd_sc_hd__a2111o_1 abstract view
.subckt sky130_fd_sc_hd__a2111o_1 A1 A2 B1 C1 D1 VGND VNB VPB VPWR X
.ends

* Black-box entry subcircuit for sky130_fd_sc_hd__a21boi_1 abstract view
.subckt sky130_fd_sc_hd__a21boi_1 A1 A2 B1_N VGND VNB VPB VPWR Y
.ends

* Black-box entry subcircuit for sky130_fd_sc_hd__nand3b_1 abstract view
.subckt sky130_fd_sc_hd__nand3b_1 A_N B C VGND VNB VPB VPWR Y
.ends

* Black-box entry subcircuit for sky130_fd_sc_hd__a211o_1 abstract view
.subckt sky130_fd_sc_hd__a211o_1 A1 A2 B1 C1 VGND VNB VPB VPWR X
.ends

* Black-box entry subcircuit for sky130_fd_sc_hd__or4b_4 abstract view
.subckt sky130_fd_sc_hd__or4b_4 A B C D_N VGND VNB VPB VPWR X
.ends

* Black-box entry subcircuit for sky130_fd_sc_hd__or2_4 abstract view
.subckt sky130_fd_sc_hd__or2_4 A B VGND VNB VPB VPWR X
.ends

* Black-box entry subcircuit for sky130_fd_sc_hd__and2b_1 abstract view
.subckt sky130_fd_sc_hd__and2b_1 A_N B VGND VNB VPB VPWR X
.ends

* Black-box entry subcircuit for sky130_fd_sc_hd__or3_4 abstract view
.subckt sky130_fd_sc_hd__or3_4 A B C VGND VNB VPB VPWR X
.ends

* Black-box entry subcircuit for sky130_fd_sc_hd__or3b_1 abstract view
.subckt sky130_fd_sc_hd__or3b_1 A B C_N VGND VNB VPB VPWR X
.ends

* Black-box entry subcircuit for sky130_fd_sc_hd__clkinv_2 abstract view
.subckt sky130_fd_sc_hd__clkinv_2 A VGND VNB VPB VPWR Y
.ends

* Black-box entry subcircuit for sky130_fd_sc_hd__o221a_1 abstract view
.subckt sky130_fd_sc_hd__o221a_1 A1 A2 B1 B2 C1 VGND VNB VPB VPWR X
.ends

* Black-box entry subcircuit for sky130_fd_sc_hd__nand2_2 abstract view
.subckt sky130_fd_sc_hd__nand2_2 A B VGND VNB VPB VPWR Y
.ends

* Black-box entry subcircuit for sky130_fd_sc_hd__o31ai_2 abstract view
.subckt sky130_fd_sc_hd__o31ai_2 A1 A2 A3 B1 VGND VNB VPB VPWR Y
.ends

* Black-box entry subcircuit for sky130_fd_sc_hd__o2bb2a_2 abstract view
.subckt sky130_fd_sc_hd__o2bb2a_2 A1_N A2_N B1 B2 VGND VNB VPB VPWR X
.ends

* Black-box entry subcircuit for sky130_fd_sc_hd__or3b_4 abstract view
.subckt sky130_fd_sc_hd__or3b_4 A B C_N VGND VNB VPB VPWR X
.ends

* Black-box entry subcircuit for sky130_fd_sc_hd__or4_1 abstract view
.subckt sky130_fd_sc_hd__or4_1 A B C D VGND VNB VPB VPWR X
.ends

* Black-box entry subcircuit for sky130_fd_sc_hd__clkbuf_4 abstract view
.subckt sky130_fd_sc_hd__clkbuf_4 A VGND VNB VPB VPWR X
.ends

* Black-box entry subcircuit for sky130_fd_sc_hd__a221o_1 abstract view
.subckt sky130_fd_sc_hd__a221o_1 A1 A2 B1 B2 C1 VGND VNB VPB VPWR X
.ends

* Black-box entry subcircuit for sky130_fd_sc_hd__and3_4 abstract view
.subckt sky130_fd_sc_hd__and3_4 A B C VGND VNB VPB VPWR X
.ends

* Black-box entry subcircuit for sky130_fd_sc_hd__a2bb2o_1 abstract view
.subckt sky130_fd_sc_hd__a2bb2o_1 A1_N A2_N B1 B2 VGND VNB VPB VPWR X
.ends

* Black-box entry subcircuit for sky130_fd_sc_hd__or4b_1 abstract view
.subckt sky130_fd_sc_hd__or4b_1 A B C D_N VGND VNB VPB VPWR X
.ends

* Black-box entry subcircuit for sky130_fd_sc_hd__bufinv_16 abstract view
.subckt sky130_fd_sc_hd__bufinv_16 A VGND VNB VPB VPWR Y
.ends

* Black-box entry subcircuit for sky130_fd_sc_hd__a221oi_4 abstract view
.subckt sky130_fd_sc_hd__a221oi_4 A1 A2 B1 B2 C1 VGND VNB VPB VPWR Y
.ends

* Black-box entry subcircuit for sky130_fd_sc_hd__a41o_1 abstract view
.subckt sky130_fd_sc_hd__a41o_1 A1 A2 A3 A4 B1 VGND VNB VPB VPWR X
.ends

* Black-box entry subcircuit for sky130_fd_sc_hd__clkinv_1 abstract view
.subckt sky130_fd_sc_hd__clkinv_1 A VGND VNB VPB VPWR Y
.ends

* Black-box entry subcircuit for sky130_fd_sc_hd__nand3_1 abstract view
.subckt sky130_fd_sc_hd__nand3_1 A B C VGND VNB VPB VPWR Y
.ends

* Black-box entry subcircuit for sky130_fd_sc_hd__dfrtp_2 abstract view
.subckt sky130_fd_sc_hd__dfrtp_2 CLK D RESET_B VGND VNB VPB VPWR Q
.ends

* Black-box entry subcircuit for sky130_fd_sc_hd__and4b_1 abstract view
.subckt sky130_fd_sc_hd__and4b_1 A_N B C D VGND VNB VPB VPWR X
.ends

* Black-box entry subcircuit for sky130_fd_sc_hd__inv_6 abstract view
.subckt sky130_fd_sc_hd__inv_6 A VGND VNB VPB VPWR Y
.ends

* Black-box entry subcircuit for sky130_fd_sc_hd__o32a_2 abstract view
.subckt sky130_fd_sc_hd__o32a_2 A1 A2 A3 B1 B2 VGND VNB VPB VPWR X
.ends

* Black-box entry subcircuit for sky130_fd_sc_hd__o2bb2a_4 abstract view
.subckt sky130_fd_sc_hd__o2bb2a_4 A1_N A2_N B1 B2 VGND VNB VPB VPWR X
.ends

* Black-box entry subcircuit for sky130_fd_sc_hd__buf_1 abstract view
.subckt sky130_fd_sc_hd__buf_1 A VGND VNB VPB VPWR X
.ends

* Black-box entry subcircuit for sky130_fd_sc_hd__and4_1 abstract view
.subckt sky130_fd_sc_hd__and4_1 A B C D VGND VNB VPB VPWR X
.ends

* Black-box entry subcircuit for sky130_fd_sc_hd__and2_4 abstract view
.subckt sky130_fd_sc_hd__and2_4 A B VGND VNB VPB VPWR X
.ends

* Black-box entry subcircuit for sky130_fd_sc_hd__clkinv_4 abstract view
.subckt sky130_fd_sc_hd__clkinv_4 A VGND VNB VPB VPWR Y
.ends

* Black-box entry subcircuit for sky130_fd_sc_hd__nand2b_1 abstract view
.subckt sky130_fd_sc_hd__nand2b_1 A_N B VGND VNB VPB VPWR Y
.ends

* Black-box entry subcircuit for sky130_fd_sc_hd__a211oi_1 abstract view
.subckt sky130_fd_sc_hd__a211oi_1 A1 A2 B1 C1 VGND VNB VPB VPWR Y
.ends

* Black-box entry subcircuit for sky130_fd_sc_hd__or4_4 abstract view
.subckt sky130_fd_sc_hd__or4_4 A B C D VGND VNB VPB VPWR X
.ends

* Black-box entry subcircuit for sky130_fd_sc_hd__o21ai_4 abstract view
.subckt sky130_fd_sc_hd__o21ai_4 A1 A2 B1 VGND VNB VPB VPWR Y
.ends

* Black-box entry subcircuit for sky130_fd_sc_hd__nor2_2 abstract view
.subckt sky130_fd_sc_hd__nor2_2 A B VGND VNB VPB VPWR Y
.ends

* Black-box entry subcircuit for sky130_fd_sc_hd__a31o_4 abstract view
.subckt sky130_fd_sc_hd__a31o_4 A1 A2 A3 B1 VGND VNB VPB VPWR X
.ends

* Black-box entry subcircuit for sky130_fd_sc_hd__buf_8 abstract view
.subckt sky130_fd_sc_hd__buf_8 A VGND VNB VPB VPWR X
.ends

* Black-box entry subcircuit for sky130_fd_sc_hd__o211a_1 abstract view
.subckt sky130_fd_sc_hd__o211a_1 A1 A2 B1 C1 VGND VNB VPB VPWR X
.ends

* Black-box entry subcircuit for sky130_fd_sc_hd__or4bb_4 abstract view
.subckt sky130_fd_sc_hd__or4bb_4 A B C_N D_N VGND VNB VPB VPWR X
.ends

* Black-box entry subcircuit for sky130_fd_sc_hd__or4bb_1 abstract view
.subckt sky130_fd_sc_hd__or4bb_1 A B C_N D_N VGND VNB VPB VPWR X
.ends

* Black-box entry subcircuit for sky130_fd_sc_hd__o2bb2a_1 abstract view
.subckt sky130_fd_sc_hd__o2bb2a_1 A1_N A2_N B1 B2 VGND VNB VPB VPWR X
.ends

* Black-box entry subcircuit for sky130_fd_sc_hd__and2_2 abstract view
.subckt sky130_fd_sc_hd__and2_2 A B VGND VNB VPB VPWR X
.ends

* Black-box entry subcircuit for sky130_fd_sc_hd__a211o_4 abstract view
.subckt sky130_fd_sc_hd__a211o_4 A1 A2 B1 C1 VGND VNB VPB VPWR X
.ends

* Black-box entry subcircuit for sky130_fd_sc_hd__a31o_2 abstract view
.subckt sky130_fd_sc_hd__a31o_2 A1 A2 A3 B1 VGND VNB VPB VPWR X
.ends

* Black-box entry subcircuit for sky130_fd_sc_hd__nor2_4 abstract view
.subckt sky130_fd_sc_hd__nor2_4 A B VGND VNB VPB VPWR Y
.ends

* Black-box entry subcircuit for sky130_fd_sc_hd__dfxtp_2 abstract view
.subckt sky130_fd_sc_hd__dfxtp_2 CLK D VGND VNB VPB VPWR Q
.ends

* Black-box entry subcircuit for sky130_fd_sc_hd__o32ai_4 abstract view
.subckt sky130_fd_sc_hd__o32ai_4 A1 A2 A3 B1 B2 VGND VNB VPB VPWR Y
.ends

* Black-box entry subcircuit for sky130_fd_sc_hd__buf_4 abstract view
.subckt sky130_fd_sc_hd__buf_4 A VGND VNB VPB VPWR X
.ends

* Black-box entry subcircuit for sky130_fd_sc_hd__a22oi_4 abstract view
.subckt sky130_fd_sc_hd__a22oi_4 A1 A2 B1 B2 VGND VNB VPB VPWR Y
.ends

* Black-box entry subcircuit for sky130_fd_sc_hd__a21oi_4 abstract view
.subckt sky130_fd_sc_hd__a21oi_4 A1 A2 B1 VGND VNB VPB VPWR Y
.ends

* Black-box entry subcircuit for sky130_fd_sc_hd__dlymetal6s2s_1 abstract view
.subckt sky130_fd_sc_hd__dlymetal6s2s_1 A VGND VNB VPB VPWR X
.ends

* Black-box entry subcircuit for sky130_fd_sc_hd__a2bb2o_4 abstract view
.subckt sky130_fd_sc_hd__a2bb2o_4 A1_N A2_N B1 B2 VGND VNB VPB VPWR X
.ends

* Black-box entry subcircuit for sky130_fd_sc_hd__o211ai_1 abstract view
.subckt sky130_fd_sc_hd__o211ai_1 A1 A2 B1 C1 VGND VNB VPB VPWR Y
.ends

* Black-box entry subcircuit for sky130_fd_sc_hd__a31oi_2 abstract view
.subckt sky130_fd_sc_hd__a31oi_2 A1 A2 A3 B1 VGND VNB VPB VPWR Y
.ends

* Black-box entry subcircuit for sky130_fd_sc_hd__conb_1 abstract view
.subckt sky130_fd_sc_hd__conb_1 VGND VNB VPB VPWR HI LO
.ends

* Black-box entry subcircuit for sky130_fd_sc_hd__o41a_1 abstract view
.subckt sky130_fd_sc_hd__o41a_1 A1 A2 A3 A4 B1 VGND VNB VPB VPWR X
.ends

* Black-box entry subcircuit for sky130_fd_sc_hd__a21o_4 abstract view
.subckt sky130_fd_sc_hd__a21o_4 A1 A2 B1 VGND VNB VPB VPWR X
.ends

* Black-box entry subcircuit for sky130_fd_sc_hd__o311a_4 abstract view
.subckt sky130_fd_sc_hd__o311a_4 A1 A2 A3 B1 C1 VGND VNB VPB VPWR X
.ends

* Black-box entry subcircuit for sky130_fd_sc_hd__nor3_1 abstract view
.subckt sky130_fd_sc_hd__nor3_1 A B C VGND VNB VPB VPWR Y
.ends

* Black-box entry subcircuit for sky130_fd_sc_hd__o21bai_4 abstract view
.subckt sky130_fd_sc_hd__o21bai_4 A1 A2 B1_N VGND VNB VPB VPWR Y
.ends

* Black-box entry subcircuit for sky130_fd_sc_hd__o21ba_1 abstract view
.subckt sky130_fd_sc_hd__o21ba_1 A1 A2 B1_N VGND VNB VPB VPWR X
.ends

* Black-box entry subcircuit for sky130_fd_sc_hd__o211ai_2 abstract view
.subckt sky130_fd_sc_hd__o211ai_2 A1 A2 B1 C1 VGND VNB VPB VPWR Y
.ends

* Black-box entry subcircuit for sky130_fd_sc_hd__o21ba_4 abstract view
.subckt sky130_fd_sc_hd__o21ba_4 A1 A2 B1_N VGND VNB VPB VPWR X
.ends

* Black-box entry subcircuit for sky130_fd_sc_hd__o22a_1 abstract view
.subckt sky130_fd_sc_hd__o22a_1 A1 A2 B1 B2 VGND VNB VPB VPWR X
.ends

* Black-box entry subcircuit for sky130_fd_sc_hd__or2_2 abstract view
.subckt sky130_fd_sc_hd__or2_2 A B VGND VNB VPB VPWR X
.ends

* Black-box entry subcircuit for sky130_fd_sc_hd__nor4_2 abstract view
.subckt sky130_fd_sc_hd__nor4_2 A B C D VGND VNB VPB VPWR Y
.ends

* Black-box entry subcircuit for sky130_fd_sc_hd__o211a_4 abstract view
.subckt sky130_fd_sc_hd__o211a_4 A1 A2 B1 C1 VGND VNB VPB VPWR X
.ends

* Black-box entry subcircuit for sky130_fd_sc_hd__o31ai_4 abstract view
.subckt sky130_fd_sc_hd__o31ai_4 A1 A2 A3 B1 VGND VNB VPB VPWR Y
.ends

* Black-box entry subcircuit for sky130_fd_sc_hd__a31oi_1 abstract view
.subckt sky130_fd_sc_hd__a31oi_1 A1 A2 A3 B1 VGND VNB VPB VPWR Y
.ends

* Black-box entry subcircuit for sky130_fd_sc_hd__mux2_4 abstract view
.subckt sky130_fd_sc_hd__mux2_4 A0 A1 S VGND VNB VPB VPWR X
.ends

* Black-box entry subcircuit for sky130_fd_sc_hd__o31a_4 abstract view
.subckt sky130_fd_sc_hd__o31a_4 A1 A2 A3 B1 VGND VNB VPB VPWR X
.ends

* Black-box entry subcircuit for sky130_fd_sc_hd__nand4_4 abstract view
.subckt sky130_fd_sc_hd__nand4_4 A B C D VGND VNB VPB VPWR Y
.ends

* Black-box entry subcircuit for sky130_fd_sc_hd__o211ai_4 abstract view
.subckt sky130_fd_sc_hd__o211ai_4 A1 A2 B1 C1 VGND VNB VPB VPWR Y
.ends

* Black-box entry subcircuit for sky130_fd_sc_hd__nor3_4 abstract view
.subckt sky130_fd_sc_hd__nor3_4 A B C VGND VNB VPB VPWR Y
.ends

* Black-box entry subcircuit for sky130_fd_sc_hd__o221ai_2 abstract view
.subckt sky130_fd_sc_hd__o221ai_2 A1 A2 B1 B2 C1 VGND VNB VPB VPWR Y
.ends

* Black-box entry subcircuit for sky130_fd_sc_hd__o31ai_1 abstract view
.subckt sky130_fd_sc_hd__o31ai_1 A1 A2 A3 B1 VGND VNB VPB VPWR Y
.ends

* Black-box entry subcircuit for sky130_fd_sc_hd__nand4b_4 abstract view
.subckt sky130_fd_sc_hd__nand4b_4 A_N B C D VGND VNB VPB VPWR Y
.ends

* Black-box entry subcircuit for sky130_fd_sc_hd__o32a_1 abstract view
.subckt sky130_fd_sc_hd__o32a_1 A1 A2 A3 B1 B2 VGND VNB VPB VPWR X
.ends

* Black-box entry subcircuit for sky130_fd_sc_hd__o2111a_1 abstract view
.subckt sky130_fd_sc_hd__o2111a_1 A1 A2 B1 C1 D1 VGND VNB VPB VPWR X
.ends

.subckt team_04 clk en gpio_in[0] gpio_in[10] gpio_in[11] gpio_in[12] gpio_in[13]
+ gpio_in[14] gpio_in[15] gpio_in[16] gpio_in[17] gpio_in[18] gpio_in[19] gpio_in[1]
+ gpio_in[20] gpio_in[21] gpio_in[22] gpio_in[23] gpio_in[24] gpio_in[25] gpio_in[26]
+ gpio_in[27] gpio_in[28] gpio_in[29] gpio_in[2] gpio_in[30] gpio_in[31] gpio_in[32]
+ gpio_in[33] gpio_in[3] gpio_in[4] gpio_in[5] gpio_in[6] gpio_in[7] gpio_in[8] gpio_in[9]
+ gpio_oeb[0] gpio_oeb[10] gpio_oeb[11] gpio_oeb[12] gpio_oeb[13] gpio_oeb[14] gpio_oeb[15]
+ gpio_oeb[16] gpio_oeb[17] gpio_oeb[18] gpio_oeb[19] gpio_oeb[1] gpio_oeb[20] gpio_oeb[21]
+ gpio_oeb[22] gpio_oeb[23] gpio_oeb[24] gpio_oeb[25] gpio_oeb[26] gpio_oeb[27] gpio_oeb[28]
+ gpio_oeb[29] gpio_oeb[2] gpio_oeb[30] gpio_oeb[31] gpio_oeb[32] gpio_oeb[33] gpio_oeb[3]
+ gpio_oeb[4] gpio_oeb[5] gpio_oeb[6] gpio_oeb[7] gpio_oeb[8] gpio_oeb[9] gpio_out[0]
+ gpio_out[10] gpio_out[11] gpio_out[12] gpio_out[13] gpio_out[14] gpio_out[15] gpio_out[16]
+ gpio_out[17] gpio_out[18] gpio_out[19] gpio_out[1] gpio_out[20] gpio_out[21] gpio_out[22]
+ gpio_out[23] gpio_out[24] gpio_out[25] gpio_out[26] gpio_out[27] gpio_out[28] gpio_out[29]
+ gpio_out[2] gpio_out[30] gpio_out[31] gpio_out[32] gpio_out[33] gpio_out[3] gpio_out[4]
+ gpio_out[5] gpio_out[6] gpio_out[7] gpio_out[8] gpio_out[9] nrst vccd1 vssd1
XFILLER_39_244 vccd1 vssd1 vccd1 vssd1 sky130_ef_sc_hd__decap_40_12
XFILLER_22_122 vssd1 vssd1 vccd1 vccd1 sky130_fd_sc_hd__fill_4
XTAP_TAPCELL_ROW_9_148 vssd1 vccd1 sky130_fd_sc_hd__tapvpwrvgnd_1
XFILLER_45_225 vccd1 vssd1 vccd1 vssd1 sky130_ef_sc_hd__decap_40_12
XFILLER_26_85 vssd1 vssd1 vccd1 vccd1 sky130_fd_sc_hd__fill_1
Xrebuffer7 net122 vssd1 vssd1 vccd1 vccd1 net115 sky130_fd_sc_hd__dlymetal6s4s_1
XFILLER_42_95 vssd1 vssd1 vccd1 vccd1 sky130_fd_sc_hd__fill_4
XFILLER_3_23 vssd1 vssd1 vccd1 vccd1 sky130_fd_sc_hd__fill_2
X_1270_ _0498_ _0500_ _0506_ vssd1 vssd1 vccd1 vccd1 _0507_ sky130_fd_sc_hd__o21ai_2
XTAP_TAPCELL_ROW_14_172 vssd1 vccd1 sky130_fd_sc_hd__tapvpwrvgnd_1
X_0985_ _0217_ _0221_ vssd1 vssd1 vccd1 vccd1 _0222_ sky130_fd_sc_hd__nor2_1
X_1606_ clknet_3_4__leaf_clk _0024_ vssd1 vssd1 vccd1 vccd1 STOPWATCH_INST.digit_scanner.period_counter\[15\]
+ sky130_fd_sc_hd__dfxtp_1
X_1468_ _0698_ _0699_ net32 vssd1 vssd1 vccd1 vccd1 _0700_ sky130_fd_sc_hd__o21ai_1
XTAP_TAPCELL_ROW_6_129 vssd1 vccd1 sky130_fd_sc_hd__tapvpwrvgnd_1
X_1537_ _0650_ net117 _0752_ net28 vssd1 vssd1 vccd1 vccd1 _0758_ sky130_fd_sc_hd__a31o_1
X_1399_ net109 _0591_ _0635_ vssd1 vssd1 vccd1 vccd1 _0636_ sky130_fd_sc_hd__a21oi_2
XTAP_TAPCELL_ROW_37_286 vssd1 vccd1 sky130_fd_sc_hd__tapvpwrvgnd_1
XFILLER_6_107 vssd1 vssd1 vccd1 vccd1 sky130_fd_sc_hd__fill_1
XFILLER_12_54 vssd1 vssd1 vccd1 vccd1 sky130_fd_sc_hd__fill_2
XTAP_TAPCELL_ROW_28_242 vssd1 vccd1 sky130_fd_sc_hd__tapvpwrvgnd_1
X_1253_ _0435_ _0479_ _0486_ _0489_ _0488_ vssd1 vssd1 vccd1 vccd1 _0490_ sky130_fd_sc_hd__a32o_2
X_1322_ _0546_ _0558_ vssd1 vssd1 vccd1 vccd1 _0559_ sky130_fd_sc_hd__or2_1
X_1184_ _0386_ _0415_ net151 vssd1 vssd1 vccd1 vccd1 _0421_ sky130_fd_sc_hd__a21bo_1
X_0968_ net137 _0195_ _0201_ STOPWATCH_INST.clock_div.cycles\[22\] vssd1 vssd1 vccd1
+ vccd1 _0205_ sky130_fd_sc_hd__o31a_1
X_0899_ STOPWATCH_INST.digit_scanner.period_counter\[9\] _0146_ net220 vssd1 vssd1
+ vccd1 vccd1 _0149_ sky130_fd_sc_hd__a21o_1
XTAP_TAPCELL_ROW_2_110 vssd1 vccd1 sky130_fd_sc_hd__tapvpwrvgnd_1
XFILLER_15_206 vssd1 vssd1 vccd1 vccd1 sky130_fd_sc_hd__fill_2
XFILLER_15_239 vssd1 vssd1 vccd1 vccd1 sky130_fd_sc_hd__fill_2
XANTENNA_fanout38_A _0067_ vssd1 vssd1 vccd1 vccd1 sky130_fd_sc_hd__diode_2
XANTENNA__1213__C_N net42 vssd1 vssd1 vccd1 vccd1 sky130_fd_sc_hd__diode_2
XFILLER_0_35 vccd1 vssd1 vccd1 vssd1 sky130_ef_sc_hd__decap_40_12
XFILLER_0_57 vssd1 vssd1 vccd1 vccd1 sky130_fd_sc_hd__fill_2
X_0822_ _0094_ _0095_ _0093_ vssd1 vssd1 vccd1 vccd1 net14 sky130_fd_sc_hd__a21oi_1
X_1236_ _0385_ _0460_ vssd1 vssd1 vccd1 vccd1 _0473_ sky130_fd_sc_hd__nand2_1
X_1305_ net18 _0536_ _0540_ _0541_ vssd1 vssd1 vccd1 vccd1 _0542_ sky130_fd_sc_hd__a31o_1
XFILLER_44_19 vssd1 vssd1 vccd1 vccd1 sky130_fd_sc_hd__fill_1
X_1167_ _0327_ _0348_ _0364_ vssd1 vssd1 vccd1 vccd1 _0404_ sky130_fd_sc_hd__or3_1
X_1098_ _0334_ vssd1 vssd1 vccd1 vccd1 _0335_ sky130_fd_sc_hd__inv_2
XANTENNA__1566__B1 net32 vssd1 vssd1 vccd1 vccd1 sky130_fd_sc_hd__diode_2
XFILLER_34_96 vssd1 vssd1 vccd1 vccd1 sky130_fd_sc_hd__fill_2
XFILLER_34_85 vssd1 vssd1 vccd1 vccd1 sky130_fd_sc_hd__fill_4
XFILLER_11_275 vssd1 vssd1 vccd1 vccd1 sky130_fd_sc_hd__fill_4
XANTENNA__1557__B1 net38 vssd1 vssd1 vccd1 vccd1 sky130_fd_sc_hd__diode_2
X_1021_ _0203_ _0255_ vssd1 vssd1 vccd1 vccd1 _0258_ sky130_fd_sc_hd__xnor2_4
X_0805_ STOPWATCH_INST.fsm_inst1.currentState\[1\] STOPWATCH_INST.fsm_inst1.currentState\[0\]
+ _0073_ vssd1 vssd1 vccd1 vccd1 _0081_ sky130_fd_sc_hd__and3b_1
X_1219_ _0061_ net127 _0371_ vssd1 vssd1 vccd1 vccd1 _0456_ sky130_fd_sc_hd__a21oi_1
XFILLER_45_40 vccd1 vssd1 vccd1 vssd1 sky130_ef_sc_hd__decap_40_12
XFILLER_35_109 vssd1 vssd1 vccd1 vccd1 sky130_fd_sc_hd__fill_2
Xhold85 STOPWATCH_INST.digit_scanner.period_counter\[15\] vssd1 vssd1 vccd1 vccd1
+ net193 sky130_fd_sc_hd__dlygate4sd3_1
Xhold96 STOPWATCH_INST.digit_scanner.period_counter\[7\] vssd1 vssd1 vccd1 vccd1 net204
+ sky130_fd_sc_hd__dlygate4sd3_1
XFILLER_6_78 vssd1 vssd1 vccd1 vccd1 sky130_fd_sc_hd__fill_4
XFILLER_6_45 vccd1 vssd1 vccd1 vssd1 sky130_ef_sc_hd__decap_40_12
X_1570_ clknet_3_3__leaf_clk net187 net44 vssd1 vssd1 vccd1 vccd1 STOPWATCH_INST.sync_clear.sync_2
+ sky130_fd_sc_hd__dfrtp_1
Xrebuffer39 net146 vssd1 vssd1 vccd1 vccd1 net147 sky130_fd_sc_hd__dlygate4sd1_1
Xrebuffer28 _0226_ vssd1 vssd1 vccd1 vccd1 net136 sky130_fd_sc_hd__clkbuf_2
XFILLER_13_3 vssd1 vssd1 vccd1 vccd1 sky130_fd_sc_hd__fill_8
Xrebuffer17 _0641_ vssd1 vssd1 vccd1 vccd1 net125 sky130_fd_sc_hd__buf_6
XFILLER_34_186 vssd1 vssd1 vccd1 vccd1 sky130_fd_sc_hd__fill_8
X_1004_ STOPWATCH_INST.clock_div.cycles\[25\] _0233_ STOPWATCH_INST.clock_div.cycles\[26\]
+ vssd1 vssd1 vccd1 vccd1 _0241_ sky130_fd_sc_hd__o21ai_1
X_1699_ STOPWATCH_INST.D0_AN_0 vssd1 vssd1 vccd1 vccd1 net11 sky130_fd_sc_hd__clkbuf_1
XFILLER_40_167 vssd1 vssd1 vccd1 vccd1 sky130_fd_sc_hd__fill_8
Xoutput7 net7 vssd1 vssd1 vccd1 vccd1 gpio_out[11] sky130_fd_sc_hd__buf_2
XFILLER_31_167 vssd1 vssd1 vccd1 vccd1 sky130_fd_sc_hd__fill_1
XFILLER_16_186 vssd1 vssd1 vccd1 vccd1 sky130_fd_sc_hd__fill_1
X_1622_ clknet_3_7__leaf_clk _0040_ net49 vssd1 vssd1 vccd1 vccd1 STOPWATCH_INST.clock_div.cycles\[15\]
+ sky130_fd_sc_hd__dfrtp_4
XFILLER_39_223 vssd1 vssd1 vccd1 vccd1 sky130_fd_sc_hd__fill_1
X_1553_ STOPWATCH_INST.clock_div.cycles\[27\] net38 net32 _0769_ vssd1 vssd1 vccd1
+ vccd1 _0052_ sky130_fd_sc_hd__a22o_1
X_1484_ STOPWATCH_INST.clock_div.cycles\[15\] _0708_ vssd1 vssd1 vccd1 vccd1 _0713_
+ sky130_fd_sc_hd__nor2_1
XFILLER_22_145 vssd1 vssd1 vccd1 vccd1 sky130_fd_sc_hd__fill_8
XFILLER_45_237 vccd1 vssd1 vccd1 vssd1 sky130_ef_sc_hd__decap_40_12
XFILLER_13_167 vssd1 vssd1 vccd1 vccd1 sky130_fd_sc_hd__fill_1
Xclkbuf_3_6__f_clk clknet_0_clk vssd1 vssd1 vccd1 vccd1 clknet_3_6__leaf_clk sky130_fd_sc_hd__clkbuf_16
Xrebuffer8 _0275_ vssd1 vssd1 vccd1 vccd1 net116 sky130_fd_sc_hd__dlygate4sd1_1
XFILLER_3_57 vssd1 vssd1 vccd1 vccd1 sky130_fd_sc_hd__fill_1
X_0984_ _0219_ _0220_ vssd1 vssd1 vccd1 vccd1 _0221_ sky130_fd_sc_hd__nand2_1
XTAP_TAPCELL_ROW_14_173 vssd1 vccd1 sky130_fd_sc_hd__tapvpwrvgnd_1
X_1605_ clknet_3_4__leaf_clk _0023_ vssd1 vssd1 vccd1 vccd1 STOPWATCH_INST.digit_scanner.period_counter\[14\]
+ sky130_fd_sc_hd__dfxtp_1
X_1536_ net16 _0752_ _0650_ vssd1 vssd1 vccd1 vccd1 _0757_ sky130_fd_sc_hd__a21oi_1
X_1467_ STOPWATCH_INST.clock_div.cycles\[12\] _0693_ vssd1 vssd1 vccd1 vccd1 _0699_
+ sky130_fd_sc_hd__nor2_1
X_1398_ _0559_ _0570_ _0584_ vssd1 vssd1 vccd1 vccd1 _0635_ sky130_fd_sc_hd__o21a_1
XTAP_TAPCELL_ROW_37_287 vssd1 vccd1 sky130_fd_sc_hd__tapvpwrvgnd_1
XFILLER_35_281 vccd1 vssd1 vccd1 vssd1 sky130_ef_sc_hd__decap_40_12
XFILLER_27_248 vccd1 vssd1 vccd1 vssd1 sky130_ef_sc_hd__decap_40_12
XFILLER_6_119 vccd1 vssd1 vccd1 vssd1 sky130_ef_sc_hd__decap_40_12
XTAP_TAPCELL_ROW_28_243 vssd1 vccd1 sky130_fd_sc_hd__tapvpwrvgnd_1
XFILLER_41_295 vssd1 vssd1 vccd1 vccd1 sky130_fd_sc_hd__fill_1
XFILLER_41_251 vccd1 vssd1 vccd1 vssd1 sky130_ef_sc_hd__decap_40_12
XFILLER_5_185 vssd1 vssd1 vccd1 vccd1 sky130_fd_sc_hd__fill_2
XANTENNA__1455__A net42 vssd1 vssd1 vccd1 vccd1 sky130_fd_sc_hd__diode_2
XTAP_TAPCELL_ROW_11_154 vssd1 vccd1 sky130_fd_sc_hd__tapvpwrvgnd_1
X_1252_ _0406_ _0425_ vssd1 vssd1 vccd1 vccd1 _0489_ sky130_fd_sc_hd__xnor2_1
X_1321_ _0549_ _0554_ _0557_ _0543_ vssd1 vssd1 vccd1 vccd1 _0558_ sky130_fd_sc_hd__a211oi_2
X_1183_ _0410_ _0413_ net22 vssd1 vssd1 vccd1 vccd1 _0420_ sky130_fd_sc_hd__and3_2
X_0967_ _0195_ _0201_ vssd1 vssd1 vccd1 vccd1 _0204_ sky130_fd_sc_hd__nor2_1
X_0898_ net212 _0146_ _0148_ vssd1 vssd1 vccd1 vccd1 _0018_ sky130_fd_sc_hd__o21a_1
XPHY_EDGE_ROW_12_Right_12 vssd1 vssd1 vccd1 vccd1 sky130_fd_sc_hd__decap_3
X_1519_ _0741_ _0742_ net31 vssd1 vssd1 vccd1 vccd1 _0743_ sky130_fd_sc_hd__o21a_1
XTAP_TAPCELL_ROW_2_111 vssd1 vccd1 sky130_fd_sc_hd__tapvpwrvgnd_1
XPHY_EDGE_ROW_21_Right_21 vssd1 vssd1 vccd1 vccd1 sky130_fd_sc_hd__decap_3
XFILLER_15_229 vssd1 vssd1 vccd1 vccd1 sky130_fd_sc_hd__fill_2
XFILLER_23_54 vssd1 vssd1 vccd1 vccd1 sky130_fd_sc_hd__fill_2
XFILLER_23_251 vssd1 vssd1 vccd1 vccd1 sky130_fd_sc_hd__fill_1
XTAP_TAPCELL_ROW_25_224 vssd1 vccd1 sky130_fd_sc_hd__tapvpwrvgnd_1
XPHY_EDGE_ROW_30_Right_30 vssd1 vssd1 vccd1 vccd1 sky130_fd_sc_hd__decap_3
XFILLER_23_65 vssd1 vssd1 vccd1 vccd1 sky130_fd_sc_hd__fill_2
XFILLER_0_14 vssd1 vssd1 vccd1 vccd1 sky130_fd_sc_hd__fill_1
XFILLER_0_47 vssd1 vssd1 vccd1 vccd1 sky130_fd_sc_hd__fill_8
X_0821_ _0088_ _0090_ STOPWATCH_INST.digit_scanner.ctrl vssd1 vssd1 vccd1 vccd1 _0095_
+ sky130_fd_sc_hd__a21oi_1
XFILLER_14_273 vssd1 vssd1 vccd1 vccd1 sky130_fd_sc_hd__fill_1
XFILLER_43_3 vssd1 vssd1 vccd1 vccd1 sky130_fd_sc_hd__fill_4
X_1166_ _0348_ _0364_ vssd1 vssd1 vccd1 vccd1 _0403_ sky130_fd_sc_hd__nor2_1
X_1235_ _0465_ _0471_ vssd1 vssd1 vccd1 vccd1 _0472_ sky130_fd_sc_hd__nand2_1
X_1304_ _0474_ _0525_ _0529_ _0533_ _0516_ vssd1 vssd1 vccd1 vccd1 _0541_ sky130_fd_sc_hd__o311a_1
X_1097_ _0272_ _0333_ vssd1 vssd1 vccd1 vccd1 _0334_ sky130_fd_sc_hd__xor2_2
XFILLER_20_276 vssd1 vssd1 vccd1 vccd1 sky130_fd_sc_hd__fill_1
XFILLER_18_21 vssd1 vssd1 vccd1 vccd1 sky130_fd_sc_hd__fill_4
XFILLER_34_64 vssd1 vssd1 vccd1 vccd1 sky130_fd_sc_hd__fill_2
XANTENNA__0902__A _0122_ vssd1 vssd1 vccd1 vccd1 sky130_fd_sc_hd__diode_2
XFILLER_7_225 vssd1 vssd1 vccd1 vccd1 sky130_fd_sc_hd__fill_2
XFILLER_11_232 vssd1 vssd1 vccd1 vccd1 sky130_fd_sc_hd__fill_8
XANTENNA__1557__A1 net32 vssd1 vssd1 vccd1 vccd1 sky130_fd_sc_hd__diode_2
X_1020_ _0235_ _0256_ vssd1 vssd1 vccd1 vccd1 _0257_ sky130_fd_sc_hd__xor2_4
XFILLER_15_7 vssd1 vssd1 vccd1 vccd1 sky130_fd_sc_hd__fill_2
XFILLER_46_195 vssd1 vssd1 vccd1 vccd1 sky130_fd_sc_hd__fill_1
XPHY_EDGE_ROW_28_Left_75 vssd1 vssd1 vccd1 vccd1 sky130_fd_sc_hd__decap_3
XPHY_EDGE_ROW_12_Left_59 vssd1 vssd1 vccd1 vccd1 sky130_fd_sc_hd__decap_3
X_0804_ _0065_ STOPWATCH_INST.sync_clear.q _0066_ _0079_ vssd1 vssd1 vccd1 vccd1 _0080_
+ sky130_fd_sc_hd__o31a_1
X_1149_ _0382_ _0385_ vssd1 vssd1 vccd1 vccd1 _0386_ sky130_fd_sc_hd__nor2_1
X_1218_ _0061_ _0371_ net23 vssd1 vssd1 vccd1 vccd1 _0455_ sky130_fd_sc_hd__and3_1
XFILLER_1_90 vssd1 vssd1 vccd1 vccd1 sky130_fd_sc_hd__fill_1
XFILLER_20_66 vssd1 vssd1 vccd1 vccd1 sky130_fd_sc_hd__fill_8
Xhold97 STOPWATCH_INST.digit_scanner.period_counter\[11\] vssd1 vssd1 vccd1 vccd1
+ net205 sky130_fd_sc_hd__dlygate4sd3_1
Xhold86 STOPWATCH_INST.digit_scanner.period_counter\[3\] vssd1 vssd1 vccd1 vccd1 net194
+ sky130_fd_sc_hd__dlygate4sd3_1
XFILLER_45_52 vssd1 vssd1 vccd1 vccd1 sky130_fd_sc_hd__fill_1
XFILLER_43_198 vssd1 vssd1 vccd1 vccd1 sky130_fd_sc_hd__fill_2
XFILLER_43_187 vssd1 vssd1 vccd1 vccd1 sky130_fd_sc_hd__fill_2
XFILLER_28_195 vssd1 vssd1 vccd1 vccd1 sky130_fd_sc_hd__fill_1
X_1003_ net132 vssd1 vssd1 vccd1 vccd1 _0240_ sky130_fd_sc_hd__inv_2
Xrebuffer29 net39 vssd1 vssd1 vccd1 vccd1 net137 sky130_fd_sc_hd__dlygate4sd1_1
Xrebuffer18 _0655_ vssd1 vssd1 vccd1 vccd1 net126 sky130_fd_sc_hd__dlygate4sd1_1
XFILLER_34_176 vssd1 vssd1 vccd1 vccd1 sky130_fd_sc_hd__fill_4
XPHY_EDGE_ROW_6_Right_6 vssd1 vssd1 vccd1 vccd1 sky130_fd_sc_hd__decap_3
XFILLER_40_135 vssd1 vssd1 vccd1 vccd1 sky130_fd_sc_hd__fill_4
XFILLER_0_253 vccd1 vssd1 vccd1 vssd1 sky130_ef_sc_hd__decap_40_12
Xoutput8 net8 vssd1 vssd1 vccd1 vccd1 gpio_out[12] sky130_fd_sc_hd__buf_2
Xoutput10 net10 vssd1 vssd1 vccd1 vccd1 gpio_out[14] sky130_fd_sc_hd__buf_2
XFILLER_31_113 vssd1 vssd1 vccd1 vccd1 sky130_fd_sc_hd__fill_1
X_1552_ STOPWATCH_INST.clock_div.cycles\[27\] _0767_ vssd1 vssd1 vccd1 vccd1 _0769_
+ sky130_fd_sc_hd__xor2_1
X_1621_ clknet_3_7__leaf_clk _0039_ net49 vssd1 vssd1 vccd1 vccd1 STOPWATCH_INST.clock_div.cycles\[14\]
+ sky130_fd_sc_hd__dfrtp_4
XFILLER_39_268 vssd1 vssd1 vccd1 vccd1 sky130_fd_sc_hd__fill_4
X_1483_ _0618_ _0620_ net15 _0711_ net30 vssd1 vssd1 vccd1 vccd1 _0712_ sky130_fd_sc_hd__a311o_1
XFILLER_39_279 vssd1 vssd1 vccd1 vccd1 sky130_fd_sc_hd__fill_1
XPHY_EDGE_ROW_15_Left_62 vssd1 vssd1 vccd1 vccd1 sky130_fd_sc_hd__decap_3
XFILLER_42_31 vccd1 vssd1 vccd1 vssd1 sky130_ef_sc_hd__decap_40_12
XFILLER_3_36 vssd1 vssd1 vccd1 vccd1 sky130_fd_sc_hd__fill_8
XFILLER_36_205 vccd1 vssd1 vccd1 vssd1 sky130_ef_sc_hd__decap_40_12
X_0983_ net137 _0204_ vssd1 vssd1 vccd1 vccd1 _0220_ sky130_fd_sc_hd__xnor2_2
X_1604_ clknet_3_4__leaf_clk _0022_ vssd1 vssd1 vccd1 vccd1 STOPWATCH_INST.digit_scanner.period_counter\[13\]
+ sky130_fd_sc_hd__dfxtp_1
XFILLER_8_194 vssd1 vssd1 vccd1 vccd1 sky130_fd_sc_hd__fill_2
X_1535_ _0753_ net33 _0756_ net37 net135 vssd1 vssd1 vccd1 vccd1 _0047_ sky130_fd_sc_hd__a32o_1
X_1466_ STOPWATCH_INST.clock_div.cycles\[12\] _0693_ vssd1 vssd1 vccd1 vccd1 _0698_
+ sky130_fd_sc_hd__and2_1
X_1397_ _0633_ vssd1 vssd1 vccd1 vccd1 _0634_ sky130_fd_sc_hd__inv_2
XTAP_TAPCELL_ROW_37_288 vssd1 vccd1 sky130_fd_sc_hd__tapvpwrvgnd_1
XFILLER_35_293 vssd1 vssd1 vccd1 vccd1 sky130_fd_sc_hd__fill_4
XFILLER_10_127 vccd1 vssd1 vccd1 vssd1 sky130_ef_sc_hd__decap_40_12
XFILLER_12_56 vssd1 vssd1 vccd1 vccd1 sky130_fd_sc_hd__fill_1
XTAP_TAPCELL_ROW_20_199 vssd1 vccd1 sky130_fd_sc_hd__tapvpwrvgnd_1
XFILLER_5_6 vssd1 vssd1 vccd1 vccd1 sky130_fd_sc_hd__fill_8
XPHY_EDGE_ROW_0_Left_47 vssd1 vssd1 vccd1 vccd1 sky130_fd_sc_hd__decap_3
XFILLER_18_238 vssd1 vssd1 vccd1 vccd1 sky130_fd_sc_hd__fill_1
XFILLER_41_263 vssd1 vssd1 vccd1 vccd1 sky130_fd_sc_hd__fill_4
XFILLER_41_230 vssd1 vssd1 vccd1 vccd1 sky130_fd_sc_hd__fill_4
XTAP_TAPCELL_ROW_11_155 vssd1 vccd1 sky130_fd_sc_hd__tapvpwrvgnd_1
XFILLER_5_164 vssd1 vssd1 vccd1 vccd1 sky130_fd_sc_hd__fill_4
X_1320_ _0513_ _0548_ vssd1 vssd1 vccd1 vccd1 _0557_ sky130_fd_sc_hd__xor2_2
X_1182_ _0368_ _0418_ vssd1 vssd1 vccd1 vccd1 _0419_ sky130_fd_sc_hd__xor2_2
X_1251_ net19 net20 _0485_ _0433_ _0430_ vssd1 vssd1 vccd1 vccd1 _0488_ sky130_fd_sc_hd__a2111o_1
XTAP_TAPCELL_ROW_34_269 vssd1 vccd1 sky130_fd_sc_hd__tapvpwrvgnd_1
XPHY_EDGE_ROW_42_Left_89 vssd1 vssd1 vccd1 vccd1 sky130_fd_sc_hd__decap_3
X_0966_ STOPWATCH_INST.clock_div.cycles\[23\] _0202_ vssd1 vssd1 vccd1 vccd1 _0203_
+ sky130_fd_sc_hd__xnor2_2
X_0897_ STOPWATCH_INST.digit_scanner.period_counter\[9\] _0146_ _0122_ vssd1 vssd1
+ vccd1 vccd1 _0148_ sky130_fd_sc_hd__a21boi_1
X_1449_ _0682_ _0683_ net29 vssd1 vssd1 vccd1 vccd1 _0684_ sky130_fd_sc_hd__o21ai_1
X_1518_ net130 STOPWATCH_INST.clock_div.cycles\[20\] _0730_ vssd1 vssd1 vccd1 vccd1
+ _0742_ sky130_fd_sc_hd__and3_1
XTAP_TAPCELL_ROW_2_112 vssd1 vccd1 sky130_fd_sc_hd__tapvpwrvgnd_1
XFILLER_15_208 vssd1 vssd1 vccd1 vccd1 sky130_fd_sc_hd__fill_1
XFILLER_23_88 vccd1 vssd1 vccd1 vssd1 sky130_ef_sc_hd__decap_40_12
XFILLER_23_296 vssd1 vssd1 vccd1 vccd1 sky130_fd_sc_hd__fill_2
XTAP_TAPCELL_ROW_25_225 vssd1 vccd1 sky130_fd_sc_hd__tapvpwrvgnd_1
XFILLER_3_3 vccd1 vssd1 vccd1 vssd1 sky130_ef_sc_hd__decap_40_12
XFILLER_2_145 vssd1 vssd1 vccd1 vccd1 sky130_fd_sc_hd__fill_1
XFILLER_2_178 vssd1 vssd1 vccd1 vccd1 sky130_fd_sc_hd__fill_2
XFILLER_9_57 vssd1 vssd1 vccd1 vccd1 sky130_fd_sc_hd__fill_2
X_0820_ net43 _0090_ STOPWATCH_INST.bcd_num\[1\] vssd1 vssd1 vccd1 vccd1 _0094_ sky130_fd_sc_hd__nand3b_1
XFILLER_36_3 vssd1 vssd1 vccd1 vccd1 sky130_fd_sc_hd__fill_1
X_1303_ _0516_ _0535_ vssd1 vssd1 vccd1 vccd1 _0540_ sky130_fd_sc_hd__or2_1
X_1165_ _0401_ vssd1 vssd1 vccd1 vccd1 _0402_ sky130_fd_sc_hd__inv_2
X_1096_ net26 net25 _0331_ net147 vssd1 vssd1 vccd1 vccd1 _0333_ sky130_fd_sc_hd__a211o_1
X_1234_ _0445_ _0468_ _0428_ _0419_ vssd1 vssd1 vccd1 vccd1 _0471_ sky130_fd_sc_hd__or4b_4
XANTENNA__1566__A2 _0067_ vssd1 vssd1 vccd1 vccd1 sky130_fd_sc_hd__diode_2
X_0949_ _0185_ vssd1 vssd1 vccd1 vccd1 _0186_ sky130_fd_sc_hd__inv_2
XTAP_TAPCELL_ROW_30_250 vssd1 vccd1 sky130_fd_sc_hd__tapvpwrvgnd_1
XFILLER_18_66 vccd1 vssd1 vccd1 vssd1 sky130_ef_sc_hd__decap_40_12
XFILLER_46_141 vccd1 vssd1 vccd1 vssd1 sky130_ef_sc_hd__decap_40_12
XPHY_EDGE_ROW_3_Left_50 vssd1 vssd1 vccd1 vccd1 sky130_fd_sc_hd__decap_3
XTAP_TAPCELL_ROW_44_320 vssd1 vccd1 sky130_fd_sc_hd__tapvpwrvgnd_1
X_0803_ net37 _0070_ _0071_ _0066_ vssd1 vssd1 vccd1 vccd1 _0079_ sky130_fd_sc_hd__a22o_1
X_1148_ _0354_ _0384_ vssd1 vssd1 vccd1 vccd1 _0385_ sky130_fd_sc_hd__xor2_1
X_1079_ _0302_ _0315_ net24 vssd1 vssd1 vccd1 vccd1 _0316_ sky130_fd_sc_hd__o21ai_2
X_1217_ _0447_ _0453_ vssd1 vssd1 vccd1 vccd1 _0454_ sky130_fd_sc_hd__or2_1
XPHY_EDGE_ROW_45_Left_92 vssd1 vssd1 vccd1 vccd1 sky130_fd_sc_hd__decap_3
XFILLER_20_89 vccd1 vssd1 vccd1 vssd1 sky130_ef_sc_hd__decap_40_12
XFILLER_29_32 vccd1 vssd1 vccd1 vssd1 sky130_ef_sc_hd__decap_40_12
XFILLER_28_130 vssd1 vssd1 vccd1 vccd1 sky130_fd_sc_hd__fill_1
Xhold87 STOPWATCH_INST.digit_scanner.period_counter\[2\] vssd1 vssd1 vccd1 vccd1 net195
+ sky130_fd_sc_hd__dlygate4sd3_1
Xhold98 STOPWATCH_INST.digit_scanner.period_counter\[5\] vssd1 vssd1 vccd1 vccd1 net206
+ sky130_fd_sc_hd__dlygate4sd3_1
Xhold76 STOPWATCH_INST.sync_pause.sync_1 vssd1 vssd1 vccd1 vccd1 net184 sky130_fd_sc_hd__dlygate4sd3_1
XFILLER_43_111 vssd1 vssd1 vccd1 vccd1 sky130_fd_sc_hd__fill_1
XFILLER_6_14 vssd1 vssd1 vccd1 vccd1 sky130_fd_sc_hd__fill_2
X_1002_ _0238_ _0230_ vssd1 vssd1 vccd1 vccd1 _0239_ sky130_fd_sc_hd__or2_4
XFILLER_25_111 vssd1 vssd1 vccd1 vccd1 sky130_fd_sc_hd__fill_1
XFILLER_31_55 vssd1 vssd1 vccd1 vccd1 sky130_fd_sc_hd__fill_1
XFILLER_0_265 vccd1 vssd1 vccd1 vssd1 sky130_ef_sc_hd__decap_40_12
XFILLER_0_221 vssd1 vssd1 vccd1 vccd1 sky130_fd_sc_hd__fill_2
Xoutput11 net11 vssd1 vssd1 vccd1 vccd1 gpio_out[4] sky130_fd_sc_hd__buf_2
Xoutput9 net9 vssd1 vssd1 vccd1 vccd1 gpio_out[13] sky130_fd_sc_hd__buf_2
XANTENNA_clkbuf_3_1__f_clk_A clknet_0_clk vssd1 vssd1 vccd1 vccd1 sky130_fd_sc_hd__diode_2
XFILLER_16_155 vssd1 vssd1 vccd1 vccd1 sky130_fd_sc_hd__fill_1
XFILLER_31_169 vssd1 vssd1 vccd1 vccd1 sky130_fd_sc_hd__fill_2
X_1551_ net32 net33 _0768_ net38 net216 vssd1 vssd1 vccd1 vccd1 _0051_ sky130_fd_sc_hd__a32o_1
X_1482_ _0620_ net15 _0618_ vssd1 vssd1 vccd1 vccd1 _0711_ sky130_fd_sc_hd__a21oi_1
X_1620_ clknet_3_7__leaf_clk _0038_ net47 vssd1 vssd1 vccd1 vccd1 STOPWATCH_INST.clock_div.cycles\[13\]
+ sky130_fd_sc_hd__dfrtp_1
XFILLER_39_225 vssd1 vssd1 vccd1 vccd1 sky130_fd_sc_hd__fill_2
XFILLER_42_43 vssd1 vssd1 vccd1 vccd1 sky130_fd_sc_hd__fill_2
XFILLER_13_169 vssd1 vssd1 vccd1 vccd1 sky130_fd_sc_hd__fill_4
XFILLER_36_217 vccd1 vssd1 vccd1 vssd1 sky130_ef_sc_hd__decap_40_12
XFILLER_3_15 vssd1 vssd1 vccd1 vccd1 sky130_fd_sc_hd__fill_8
XTAP_TAPCELL_ROW_8_140 vssd1 vccd1 sky130_fd_sc_hd__tapvpwrvgnd_1
XFILLER_44_294 vssd1 vssd1 vccd1 vccd1 sky130_fd_sc_hd__fill_2
X_0982_ _0196_ _0201_ _0218_ vssd1 vssd1 vccd1 vccd1 _0219_ sky130_fd_sc_hd__a21o_1
X_1603_ clknet_3_5__leaf_clk _0021_ vssd1 vssd1 vccd1 vccd1 STOPWATCH_INST.digit_scanner.period_counter\[12\]
+ sky130_fd_sc_hd__dfxtp_1
XANTENNA__1357__B1 STOPWATCH_INST.clock_div.cycles\[8\] vssd1 vssd1 vccd1 vccd1 sky130_fd_sc_hd__diode_2
X_1465_ _0607_ _0610_ net126 _0696_ net30 vssd1 vssd1 vccd1 vccd1 _0697_ sky130_fd_sc_hd__a311o_1
X_1534_ _0754_ _0755_ net31 vssd1 vssd1 vccd1 vccd1 _0756_ sky130_fd_sc_hd__o21ai_1
X_1396_ _0621_ _0632_ vssd1 vssd1 vccd1 vccd1 _0633_ sky130_fd_sc_hd__and2_1
XFILLER_10_139 vssd1 vssd1 vccd1 vccd1 sky130_fd_sc_hd__fill_1
XFILLER_37_21 vccd1 vssd1 vccd1 vssd1 sky130_ef_sc_hd__decap_40_12
XANTENNA__1615__Q STOPWATCH_INST.clock_div.cycles\[8\] vssd1 vssd1 vccd1 vccd1 sky130_fd_sc_hd__diode_2
XFILLER_18_206 vssd1 vssd1 vccd1 vccd1 sky130_fd_sc_hd__fill_4
XFILLER_37_54 vssd1 vssd1 vccd1 vccd1 sky130_fd_sc_hd__fill_2
XFILLER_26_250 vssd1 vssd1 vccd1 vccd1 sky130_fd_sc_hd__fill_2
XTAP_TAPCELL_ROW_11_156 vssd1 vccd1 sky130_fd_sc_hd__tapvpwrvgnd_1
XFILLER_5_187 vssd1 vssd1 vccd1 vccd1 sky130_fd_sc_hd__fill_1
XANTENNA__1625__RESET_B net47 vssd1 vssd1 vccd1 vccd1 sky130_fd_sc_hd__diode_2
X_1181_ _0375_ net127 vssd1 vssd1 vccd1 vccd1 _0418_ sky130_fd_sc_hd__and2b_1
X_1250_ _0430_ _0478_ _0485_ vssd1 vssd1 vccd1 vccd1 _0487_ sky130_fd_sc_hd__or3_4
XFILLER_32_253 vssd1 vssd1 vccd1 vccd1 sky130_fd_sc_hd__fill_4
XFILLER_32_220 vccd1 vssd1 vccd1 vssd1 sky130_ef_sc_hd__decap_40_12
X_0965_ _0157_ _0200_ _0195_ vssd1 vssd1 vccd1 vccd1 _0202_ sky130_fd_sc_hd__a21oi_1
X_0896_ _0122_ _0145_ _0147_ vssd1 vssd1 vccd1 vccd1 _0017_ sky130_fd_sc_hd__and3_1
XTAP_TAPCELL_ROW_2_113 vssd1 vccd1 sky130_fd_sc_hd__tapvpwrvgnd_1
X_1448_ STOPWATCH_INST.clock_div.cycles\[9\] _0676_ vssd1 vssd1 vccd1 vccd1 _0683_
+ sky130_fd_sc_hd__nor2_1
X_1517_ STOPWATCH_INST.clock_div.cycles\[20\] _0735_ vssd1 vssd1 vccd1 vccd1 _0741_
+ sky130_fd_sc_hd__nor2_1
X_1379_ _0545_ _0609_ vssd1 vssd1 vccd1 vccd1 _0616_ sky130_fd_sc_hd__xnor2_4
XTAP_TAPCELL_ROW_25_226 vssd1 vccd1 sky130_fd_sc_hd__tapvpwrvgnd_1
XFILLER_23_67 vssd1 vssd1 vccd1 vccd1 sky130_fd_sc_hd__fill_1
XFILLER_23_264 vssd1 vssd1 vccd1 vccd1 sky130_fd_sc_hd__fill_1
XANTENNA__0897__B1_N _0122_ vssd1 vssd1 vccd1 vccd1 sky130_fd_sc_hd__diode_2
XFILLER_14_253 vccd1 vssd1 vccd1 vssd1 sky130_ef_sc_hd__decap_40_12
XFILLER_14_297 vssd1 vssd1 vccd1 vccd1 sky130_fd_sc_hd__fill_2
X_1233_ _0419_ _0469_ vssd1 vssd1 vccd1 vccd1 _0470_ sky130_fd_sc_hd__and2_1
X_1302_ _0537_ _0538_ vssd1 vssd1 vccd1 vccd1 _0539_ sky130_fd_sc_hd__or2_1
X_1095_ net25 net26 _0331_ vssd1 vssd1 vccd1 vccd1 _0332_ sky130_fd_sc_hd__a21o_1
X_1164_ _0348_ _0365_ _0400_ vssd1 vssd1 vccd1 vccd1 _0401_ sky130_fd_sc_hd__a21oi_1
X_0948_ STOPWATCH_INST.clock_div.cycles\[31\] _0184_ vssd1 vssd1 vccd1 vccd1 _0185_
+ sky130_fd_sc_hd__nand2_1
XTAP_TAPCELL_ROW_30_251 vssd1 vccd1 sky130_fd_sc_hd__tapvpwrvgnd_1
XFILLER_20_201 vssd1 vssd1 vccd1 vccd1 sky130_fd_sc_hd__fill_2
XFILLER_20_234 vssd1 vssd1 vccd1 vccd1 sky130_fd_sc_hd__fill_2
X_0879_ net213 _0137_ _0138_ vssd1 vssd1 vccd1 vccd1 _0008_ sky130_fd_sc_hd__a21oi_1
XFILLER_18_78 vssd1 vssd1 vccd1 vccd1 sky130_fd_sc_hd__fill_4
XFILLER_7_249 vssd1 vssd1 vccd1 vccd1 sky130_fd_sc_hd__fill_1
XFILLER_46_197 vccd1 vssd1 vccd1 vssd1 sky130_ef_sc_hd__decap_40_12
XFILLER_46_153 vccd1 vssd1 vccd1 vssd1 sky130_ef_sc_hd__decap_40_12
XTAP_TAPCELL_ROW_44_321 vssd1 vccd1 sky130_fd_sc_hd__tapvpwrvgnd_1
X_0802_ _0077_ _0078_ vssd1 vssd1 vccd1 vccd1 STOPWATCH_INST.fsm_inst1.nextState\[0\]
+ sky130_fd_sc_hd__nand2_1
X_1216_ _0372_ net127 _0374_ vssd1 vssd1 vccd1 vccd1 _0453_ sky130_fd_sc_hd__a21oi_1
X_1147_ _0356_ _0364_ _0353_ vssd1 vssd1 vccd1 vccd1 _0384_ sky130_fd_sc_hd__or3b_1
X_1078_ net111 _0300_ net26 vssd1 vssd1 vccd1 vccd1 _0315_ sky130_fd_sc_hd__a21oi_1
XFILLER_20_13 vccd1 vssd1 vccd1 vssd1 sky130_ef_sc_hd__decap_40_12
XFILLER_29_44 vssd1 vssd1 vccd1 vccd1 sky130_fd_sc_hd__fill_4
XFILLER_29_22 vssd1 vssd1 vccd1 vccd1 sky130_fd_sc_hd__fill_2
XFILLER_28_197 vccd1 vssd1 vccd1 vssd1 sky130_ef_sc_hd__decap_40_12
Xhold99 _0014_ vssd1 vssd1 vccd1 vccd1 net207 sky130_fd_sc_hd__dlygate4sd3_1
Xhold88 _0139_ vssd1 vssd1 vccd1 vccd1 net196 sky130_fd_sc_hd__dlygate4sd3_1
Xhold77 STOPWATCH_INST.sync_one.sync_1 vssd1 vssd1 vccd1 vccd1 net185 sky130_fd_sc_hd__dlygate4sd3_1
XFILLER_45_87 vssd1 vssd1 vccd1 vccd1 sky130_fd_sc_hd__fill_1
XFILLER_34_156 vssd1 vssd1 vccd1 vccd1 sky130_fd_sc_hd__fill_8
XFILLER_34_134 vssd1 vssd1 vccd1 vccd1 sky130_fd_sc_hd__fill_4
X_1001_ net136 _0186_ STOPWATCH_INST.clock_div.cycles\[27\] vssd1 vssd1 vccd1 vccd1
+ _0238_ sky130_fd_sc_hd__a21oi_1
XFILLER_25_101 vssd1 vssd1 vccd1 vccd1 sky130_fd_sc_hd__fill_8
XFILLER_40_148 vssd1 vssd1 vccd1 vccd1 sky130_fd_sc_hd__fill_2
XFILLER_25_167 vssd1 vssd1 vccd1 vccd1 sky130_fd_sc_hd__fill_1
XFILLER_25_189 vssd1 vssd1 vccd1 vccd1 sky130_fd_sc_hd__fill_1
Xoutput12 net12 vssd1 vssd1 vccd1 vccd1 gpio_out[5] sky130_fd_sc_hd__buf_2
X_1550_ _0766_ _0767_ vssd1 vssd1 vccd1 vccd1 _0768_ sky130_fd_sc_hd__nor2_1
X_1481_ net34 _0707_ _0710_ net38 STOPWATCH_INST.clock_div.cycles\[14\] vssd1 vssd1
+ vccd1 vccd1 _0039_ sky130_fd_sc_hd__a32o_1
XTAP_TAPCELL_ROW_17_184 vssd1 vccd1 sky130_fd_sc_hd__tapvpwrvgnd_1
XFILLER_22_126 vssd1 vssd1 vccd1 vccd1 sky130_fd_sc_hd__fill_1
XFILLER_7_80 vssd1 vssd1 vccd1 vccd1 sky130_fd_sc_hd__fill_2
XFILLER_26_23 vssd1 vssd1 vccd1 vccd1 sky130_fd_sc_hd__fill_4
XFILLER_9_108 vssd1 vssd1 vccd1 vccd1 sky130_fd_sc_hd__fill_4
XFILLER_13_148 vssd1 vssd1 vccd1 vccd1 sky130_fd_sc_hd__fill_2
XFILLER_21_181 vccd1 vssd1 vccd1 vssd1 sky130_ef_sc_hd__decap_40_12
XTAP_TAPCELL_ROW_8_141 vssd1 vccd1 sky130_fd_sc_hd__tapvpwrvgnd_1
XFILLER_36_229 vssd1 vssd1 vccd1 vccd1 sky130_fd_sc_hd__fill_2
XFILLER_29_281 vccd1 vssd1 vccd1 vssd1 sky130_ef_sc_hd__decap_40_12
XFILLER_44_273 vssd1 vssd1 vccd1 vccd1 sky130_fd_sc_hd__fill_1
X_0981_ _0190_ _0196_ STOPWATCH_INST.clock_div.cycles\[20\] vssd1 vssd1 vccd1 vccd1
+ _0218_ sky130_fd_sc_hd__a21oi_1
X_1602_ clknet_3_5__leaf_clk _0020_ vssd1 vssd1 vccd1 vccd1 STOPWATCH_INST.digit_scanner.period_counter\[11\]
+ sky130_fd_sc_hd__dfxtp_1
XFILLER_8_130 vssd1 vssd1 vccd1 vccd1 sky130_fd_sc_hd__fill_4
XFILLER_8_174 vssd1 vssd1 vccd1 vccd1 sky130_fd_sc_hd__fill_4
X_1464_ _0607_ _0655_ _0610_ vssd1 vssd1 vccd1 vccd1 _0696_ sky130_fd_sc_hd__a21oi_1
X_1395_ _0627_ _0629_ _0631_ vssd1 vssd1 vccd1 vccd1 _0632_ sky130_fd_sc_hd__and3_1
X_1533_ net39 net135 _0742_ vssd1 vssd1 vccd1 vccd1 _0755_ sky130_fd_sc_hd__and3_1
XFILLER_37_33 vssd1 vssd1 vccd1 vccd1 sky130_fd_sc_hd__fill_4
XFILLER_18_218 vccd1 vssd1 vccd1 vssd1 sky130_ef_sc_hd__decap_40_12
XFILLER_41_276 vssd1 vssd1 vccd1 vccd1 sky130_fd_sc_hd__fill_4
XTAP_TAPCELL_ROW_11_157 vssd1 vccd1 sky130_fd_sc_hd__tapvpwrvgnd_1
XFILLER_45_9 vssd1 vssd1 vccd1 vccd1 sky130_fd_sc_hd__fill_4
X_1180_ _0410_ _0381_ _0414_ _0416_ _0377_ vssd1 vssd1 vccd1 vccd1 _0417_ sky130_fd_sc_hd__a311o_1
X_0964_ _0200_ vssd1 vssd1 vccd1 vccd1 _0201_ sky130_fd_sc_hd__inv_2
XFILLER_32_276 vssd1 vssd1 vccd1 vccd1 sky130_fd_sc_hd__fill_1
XFILLER_32_232 vccd1 vssd1 vccd1 vssd1 sky130_ef_sc_hd__decap_40_12
X_0895_ _0146_ vssd1 vssd1 vccd1 vccd1 _0147_ sky130_fd_sc_hd__inv_2
X_1516_ _0633_ _0639_ _0654_ _0637_ vssd1 vssd1 vccd1 vccd1 _0740_ sky130_fd_sc_hd__or4b_4
X_1447_ STOPWATCH_INST.clock_div.cycles\[9\] _0676_ vssd1 vssd1 vccd1 vccd1 _0682_
+ sky130_fd_sc_hd__and2_1
X_1378_ _0542_ _0613_ vssd1 vssd1 vccd1 vccd1 _0615_ sky130_fd_sc_hd__xnor2_1
XTAP_TAPCELL_ROW_25_227 vssd1 vccd1 sky130_fd_sc_hd__tapvpwrvgnd_1
XFILLER_23_298 vssd1 vssd1 vccd1 vccd1 sky130_fd_sc_hd__fill_1
XFILLER_9_15 vssd1 vssd1 vccd1 vccd1 sky130_fd_sc_hd__fill_1
XFILLER_14_265 vssd1 vssd1 vccd1 vccd1 sky130_fd_sc_hd__fill_8
X_1232_ net21 _0467_ _0448_ vssd1 vssd1 vccd1 vccd1 _0469_ sky130_fd_sc_hd__a21o_1
X_1301_ _0520_ net18 vssd1 vssd1 vccd1 vccd1 _0538_ sky130_fd_sc_hd__and2_1
X_1094_ _0271_ _0278_ _0267_ vssd1 vssd1 vccd1 vccd1 _0331_ sky130_fd_sc_hd__a21boi_1
X_1163_ _0347_ _0364_ _0334_ vssd1 vssd1 vccd1 vccd1 _0400_ sky130_fd_sc_hd__o21a_1
X_0947_ STOPWATCH_INST.clock_div.cycles\[27\] STOPWATCH_INST.clock_div.cycles\[28\]
+ STOPWATCH_INST.clock_div.cycles\[30\] STOPWATCH_INST.clock_div.cycles\[29\] vssd1
+ vssd1 vccd1 vccd1 _0184_ sky130_fd_sc_hd__a211o_1
XTAP_TAPCELL_ROW_30_252 vssd1 vccd1 sky130_fd_sc_hd__tapvpwrvgnd_1
X_0878_ STOPWATCH_INST.bcd_num\[7\] _0137_ _0123_ vssd1 vssd1 vccd1 vccd1 _0138_ sky130_fd_sc_hd__o21ai_1
XANTENNA__1487__B1 net38 vssd1 vssd1 vccd1 vccd1 sky130_fd_sc_hd__diode_2
XFILLER_34_89 vssd1 vssd1 vccd1 vccd1 sky130_fd_sc_hd__fill_2
XFILLER_11_279 vssd1 vssd1 vccd1 vccd1 sky130_fd_sc_hd__fill_1
Xclkload0 clknet_3_0__leaf_clk vssd1 vssd1 vccd1 vccd1 clkload0/Y sky130_fd_sc_hd__clkinv_2
XFILLER_46_165 vssd1 vssd1 vccd1 vccd1 sky130_fd_sc_hd__fill_2
XFILLER_46_110 vssd1 vssd1 vccd1 vccd1 sky130_fd_sc_hd__fill_2
XTAP_TAPCELL_ROW_44_322 vssd1 vccd1 sky130_fd_sc_hd__tapvpwrvgnd_1
X_0801_ _0068_ _0070_ _0072_ _0066_ _0075_ vssd1 vssd1 vccd1 vccd1 _0078_ sky130_fd_sc_hd__o221a_1
XFILLER_6_261 vssd1 vssd1 vccd1 vccd1 sky130_fd_sc_hd__fill_4
X_1146_ _0353_ _0365_ vssd1 vssd1 vccd1 vccd1 _0383_ sky130_fd_sc_hd__nand2_2
XFILLER_37_165 vssd1 vssd1 vccd1 vccd1 sky130_fd_sc_hd__fill_2
XFILLER_37_110 vssd1 vssd1 vccd1 vccd1 sky130_fd_sc_hd__fill_2
X_1215_ _0448_ _0451_ _0419_ vssd1 vssd1 vccd1 vccd1 _0452_ sky130_fd_sc_hd__or3b_1
XANTENNA__1469__B1 net38 vssd1 vssd1 vccd1 vccd1 sky130_fd_sc_hd__diode_2
X_1077_ STOPWATCH_INST.clock_div.cycles\[12\] _0310_ _0312_ vssd1 vssd1 vccd1 vccd1
+ _0314_ sky130_fd_sc_hd__or3_1
XFILLER_20_25 vssd1 vssd1 vccd1 vccd1 sky130_fd_sc_hd__fill_2
Xhold78 STOPWATCH_INST.sync_ten.sync_1 vssd1 vssd1 vccd1 vccd1 net186 sky130_fd_sc_hd__dlygate4sd3_1
Xhold89 STOPWATCH_INST.digit_scanner.period_counter\[12\] vssd1 vssd1 vccd1 vccd1
+ net197 sky130_fd_sc_hd__dlygate4sd3_1
XFILLER_43_179 vssd1 vssd1 vccd1 vccd1 sky130_fd_sc_hd__fill_8
XFILLER_6_27 vssd1 vssd1 vccd1 vccd1 sky130_fd_sc_hd__fill_1
X_1000_ STOPWATCH_INST.clock_div.cycles\[29\] _0195_ _0227_ STOPWATCH_INST.clock_div.cycles\[30\]
+ vssd1 vssd1 vccd1 vccd1 _0237_ sky130_fd_sc_hd__o31ai_2
XFILLER_3_297 vssd1 vssd1 vccd1 vccd1 sky130_fd_sc_hd__fill_2
XFILLER_19_121 vssd1 vssd1 vccd1 vccd1 sky130_fd_sc_hd__fill_8
XANTENNA_clkbuf_0_clk_A clk vssd1 vssd1 vccd1 vccd1 sky130_fd_sc_hd__diode_2
X_1129_ _0317_ _0360_ _0362_ _0314_ vssd1 vssd1 vccd1 vccd1 _0366_ sky130_fd_sc_hd__o31a_1
XANTENNA__0854__X _0122_ vssd1 vssd1 vccd1 vccd1 sky130_fd_sc_hd__diode_2
XFILLER_25_113 vccd1 vssd1 vccd1 vssd1 sky130_ef_sc_hd__decap_40_12
XFILLER_31_57 vssd1 vssd1 vccd1 vccd1 sky130_fd_sc_hd__fill_2
XFILLER_31_46 vssd1 vssd1 vccd1 vccd1 sky130_fd_sc_hd__fill_2
Xoutput13 net13 vssd1 vssd1 vccd1 vccd1 gpio_out[8] sky130_fd_sc_hd__buf_2
XFILLER_0_223 vssd1 vssd1 vccd1 vccd1 sky130_fd_sc_hd__fill_1
XANTENNA__1619__RESET_B net49 vssd1 vssd1 vccd1 vccd1 sky130_fd_sc_hd__diode_2
XPHY_EDGE_ROW_19_Right_19 vssd1 vssd1 vccd1 vccd1 sky130_fd_sc_hd__decap_3
Xclkbuf_3_1__f_clk clknet_0_clk vssd1 vssd1 vccd1 vccd1 clknet_3_1__leaf_clk sky130_fd_sc_hd__clkbuf_16
XPHY_EDGE_ROW_28_Right_28 vssd1 vssd1 vccd1 vccd1 sky130_fd_sc_hd__decap_3
X_1480_ _0708_ _0709_ net32 vssd1 vssd1 vccd1 vccd1 _0710_ sky130_fd_sc_hd__o21ai_1
XPHY_EDGE_ROW_37_Right_37 vssd1 vssd1 vccd1 vccd1 sky130_fd_sc_hd__decap_3
XFILLER_15_190 vssd1 vssd1 vccd1 vccd1 sky130_fd_sc_hd__fill_2
XTAP_TAPCELL_ROW_17_185 vssd1 vccd1 sky130_fd_sc_hd__tapvpwrvgnd_1
XPHY_EDGE_ROW_46_Right_46 vssd1 vssd1 vccd1 vccd1 sky130_fd_sc_hd__decap_3
XFILLER_42_45 vssd1 vssd1 vccd1 vccd1 sky130_fd_sc_hd__fill_1
XFILLER_21_193 vssd1 vssd1 vccd1 vccd1 sky130_fd_sc_hd__fill_4
XTAP_TAPCELL_ROW_8_142 vssd1 vccd1 sky130_fd_sc_hd__tapvpwrvgnd_1
XFILLER_29_293 vssd1 vssd1 vccd1 vccd1 sky130_fd_sc_hd__fill_4
X_0980_ _0214_ _0216_ vssd1 vssd1 vccd1 vccd1 _0217_ sky130_fd_sc_hd__nor2_1
XFILLER_12_171 vssd1 vssd1 vccd1 vccd1 sky130_fd_sc_hd__fill_4
X_1601_ clknet_3_5__leaf_clk _0019_ vssd1 vssd1 vccd1 vccd1 STOPWATCH_INST.digit_scanner.period_counter\[10\]
+ sky130_fd_sc_hd__dfxtp_1
XFILLER_8_197 vssd1 vssd1 vccd1 vccd1 sky130_fd_sc_hd__fill_2
X_1532_ net135 _0750_ vssd1 vssd1 vccd1 vccd1 _0754_ sky130_fd_sc_hd__nor2_1
X_1394_ _0624_ _0630_ _0570_ _0593_ vssd1 vssd1 vccd1 vccd1 _0631_ sky130_fd_sc_hd__o2bb2a_2
X_1463_ net34 _0692_ _0695_ net36 STOPWATCH_INST.clock_div.cycles\[11\] vssd1 vssd1
+ vccd1 vccd1 _0036_ sky130_fd_sc_hd__a32o_1
XPHY_EDGE_ROW_19_Left_66 vssd1 vssd1 vccd1 vccd1 sky130_fd_sc_hd__decap_3
XFILLER_41_222 vssd1 vssd1 vccd1 vccd1 sky130_fd_sc_hd__fill_2
XTAP_TAPCELL_ROW_36_280 vssd1 vccd1 sky130_fd_sc_hd__tapvpwrvgnd_1
XFILLER_26_263 vssd1 vssd1 vccd1 vccd1 sky130_fd_sc_hd__fill_2
XFILLER_5_156 vssd1 vssd1 vccd1 vccd1 sky130_fd_sc_hd__fill_2
XTAP_TAPCELL_ROW_11_158 vssd1 vccd1 sky130_fd_sc_hd__tapvpwrvgnd_1
XFILLER_32_244 vssd1 vssd1 vccd1 vccd1 sky130_fd_sc_hd__fill_8
X_0963_ STOPWATCH_INST.clock_div.cycles\[20\] _0190_ vssd1 vssd1 vccd1 vccd1 _0200_
+ sky130_fd_sc_hd__nand2_1
X_0894_ STOPWATCH_INST.digit_scanner.period_counter\[7\] STOPWATCH_INST.digit_scanner.period_counter\[8\]
+ _0143_ vssd1 vssd1 vccd1 vccd1 _0146_ sky130_fd_sc_hd__and3_1
X_1515_ _0634_ _0640_ net16 _0637_ vssd1 vssd1 vccd1 vccd1 _0739_ sky130_fd_sc_hd__a31o_1
XFILLER_4_82 vssd1 vssd1 vccd1 vccd1 sky130_fd_sc_hd__fill_2
X_1446_ _0679_ _0680_ vssd1 vssd1 vccd1 vccd1 _0681_ sky130_fd_sc_hd__or2_1
X_1377_ net109 _0591_ _0612_ _0542_ vssd1 vssd1 vccd1 vccd1 _0614_ sky130_fd_sc_hd__a211o_1
XTAP_TAPCELL_ROW_25_228 vssd1 vccd1 sky130_fd_sc_hd__tapvpwrvgnd_1
XFILLER_0_29 vssd1 vssd1 vccd1 vccd1 sky130_fd_sc_hd__fill_2
XFILLER_14_233 vssd1 vssd1 vccd1 vccd1 sky130_fd_sc_hd__fill_1
XFILLER_43_7 vssd1 vssd1 vccd1 vccd1 sky130_fd_sc_hd__fill_2
XFILLER_13_80 vssd1 vssd1 vccd1 vccd1 sky130_fd_sc_hd__fill_8
X_1162_ _0397_ _0398_ vssd1 vssd1 vccd1 vccd1 _0399_ sky130_fd_sc_hd__nand2_1
X_1231_ net21 _0467_ _0448_ vssd1 vssd1 vccd1 vccd1 _0468_ sky130_fd_sc_hd__a21oi_1
XTAP_TAPCELL_ROW_0_94 vssd1 vccd1 sky130_fd_sc_hd__tapvpwrvgnd_1
X_1300_ net128 _0536_ _0482_ vssd1 vssd1 vccd1 vccd1 _0537_ sky130_fd_sc_hd__a21oi_1
X_1093_ _0258_ _0327_ _0329_ vssd1 vssd1 vccd1 vccd1 _0330_ sky130_fd_sc_hd__or3b_4
XTAP_TAPCELL_ROW_22_209 vssd1 vccd1 sky130_fd_sc_hd__tapvpwrvgnd_1
XTAP_TAPCELL_ROW_30_253 vssd1 vccd1 sky130_fd_sc_hd__tapvpwrvgnd_1
X_0946_ net202 _0183_ vssd1 vssd1 vccd1 vccd1 _0031_ sky130_fd_sc_hd__xor2_1
X_0877_ _0137_ _0123_ _0136_ vssd1 vssd1 vccd1 vccd1 _0007_ sky130_fd_sc_hd__and3b_1
XFILLER_9_281 vssd1 vssd1 vccd1 vccd1 sky130_fd_sc_hd__fill_1
XFILLER_20_236 vssd1 vssd1 vccd1 vccd1 sky130_fd_sc_hd__fill_1
XFILLER_20_258 vccd1 vssd1 vccd1 vssd1 sky130_ef_sc_hd__decap_40_12
X_1429_ net135 STOPWATCH_INST.clock_div.cycles\[24\] STOPWATCH_INST.clock_div.cycles\[26\]
+ _0665_ vssd1 vssd1 vccd1 vccd1 _0666_ sky130_fd_sc_hd__or4_1
XFILLER_18_25 vssd1 vssd1 vccd1 vccd1 sky130_fd_sc_hd__fill_2
XFILLER_11_214 vssd1 vssd1 vccd1 vccd1 sky130_fd_sc_hd__fill_1
XFILLER_11_258 vssd1 vssd1 vccd1 vccd1 sky130_fd_sc_hd__fill_4
Xclkload1 clknet_3_2__leaf_clk vssd1 vssd1 vccd1 vccd1 clkload1/X sky130_fd_sc_hd__clkbuf_4
XTAP_TAPCELL_ROW_44_323 vssd1 vccd1 sky130_fd_sc_hd__tapvpwrvgnd_1
XFILLER_6_240 vssd1 vssd1 vccd1 vccd1 sky130_fd_sc_hd__fill_1
XFILLER_6_251 vssd1 vssd1 vccd1 vccd1 sky130_fd_sc_hd__fill_1
X_0800_ net209 _0076_ STOPWATCH_INST.sync_pause.sync_2 vssd1 vssd1 vccd1 vccd1 _0077_
+ sky130_fd_sc_hd__or3b_1
X_1145_ _0324_ _0378_ vssd1 vssd1 vccd1 vccd1 _0382_ sky130_fd_sc_hd__xnor2_2
X_1214_ STOPWATCH_INST.clock_div.cycles\[7\] _0162_ _0449_ _0450_ vssd1 vssd1 vccd1
+ vccd1 _0451_ sky130_fd_sc_hd__or4_1
X_1076_ _0310_ _0312_ vssd1 vssd1 vccd1 vccd1 _0313_ sky130_fd_sc_hd__or2_1
X_0929_ _0169_ _0170_ _0172_ _0076_ vssd1 vssd1 vccd1 vccd1 _0173_ sky130_fd_sc_hd__o31ai_2
XFILLER_29_57 vssd1 vssd1 vccd1 vccd1 sky130_fd_sc_hd__fill_2
Xhold79 STOPWATCH_INST.sync_clear.sync_1 vssd1 vssd1 vccd1 vccd1 net187 sky130_fd_sc_hd__dlygate4sd3_1
XFILLER_43_169 vssd1 vssd1 vccd1 vccd1 sky130_fd_sc_hd__fill_4
XTAP_TAPCELL_ROW_41_304 vssd1 vccd1 sky130_fd_sc_hd__tapvpwrvgnd_1
XPHY_EDGE_ROW_7_Left_54 vssd1 vssd1 vccd1 vccd1 sky130_fd_sc_hd__decap_3
XFILLER_19_111 vssd1 vssd1 vccd1 vccd1 sky130_fd_sc_hd__fill_1
X_1059_ _0231_ _0295_ vssd1 vssd1 vccd1 vccd1 _0296_ sky130_fd_sc_hd__and2_1
X_1128_ _0364_ vssd1 vssd1 vccd1 vccd1 _0365_ sky130_fd_sc_hd__inv_2
XFILLER_25_125 vccd1 vssd1 vccd1 vssd1 sky130_ef_sc_hd__decap_40_12
XFILLER_25_169 vccd1 vssd1 vccd1 vssd1 sky130_ef_sc_hd__decap_40_12
XFILLER_40_139 vssd1 vssd1 vccd1 vccd1 sky130_fd_sc_hd__fill_1
XFILLER_40_128 vssd1 vssd1 vccd1 vccd1 sky130_fd_sc_hd__fill_1
XFILLER_31_14 vssd1 vssd1 vccd1 vccd1 sky130_fd_sc_hd__fill_1
Xoutput14 net14 vssd1 vssd1 vccd1 vccd1 gpio_out[9] sky130_fd_sc_hd__buf_2
XFILLER_31_139 vccd1 vssd1 vccd1 vssd1 sky130_ef_sc_hd__decap_40_12
XTAP_TAPCELL_ROW_17_186 vssd1 vccd1 sky130_fd_sc_hd__tapvpwrvgnd_1
XFILLER_7_82 vssd1 vssd1 vccd1 vccd1 sky130_fd_sc_hd__fill_1
XFILLER_38_250 vssd1 vssd1 vccd1 vccd1 sky130_fd_sc_hd__fill_2
XFILLER_26_69 vssd1 vssd1 vccd1 vccd1 sky130_fd_sc_hd__fill_4
XTAP_TAPCELL_ROW_8_143 vssd1 vccd1 sky130_fd_sc_hd__tapvpwrvgnd_1
X_1600_ clknet_3_4__leaf_clk _0018_ vssd1 vssd1 vccd1 vccd1 STOPWATCH_INST.digit_scanner.period_counter\[9\]
+ sky130_fd_sc_hd__dfxtp_1
X_1531_ _0649_ _0745_ _0645_ _0747_ net28 vssd1 vssd1 vccd1 vccd1 _0753_ sky130_fd_sc_hd__a221o_1
X_1462_ _0693_ _0694_ net30 vssd1 vssd1 vccd1 vccd1 _0695_ sky130_fd_sc_hd__o21ai_1
X_1393_ _0559_ _0570_ vssd1 vssd1 vccd1 vccd1 _0630_ sky130_fd_sc_hd__nand2_1
XFILLER_35_297 vssd1 vssd1 vccd1 vccd1 sky130_fd_sc_hd__fill_2
Xhold110 STOPWATCH_INST.clock_div.cycles\[24\] vssd1 vssd1 vccd1 vccd1 net218 sky130_fd_sc_hd__dlygate4sd3_1
XTAP_TAPCELL_ROW_5_124 vssd1 vccd1 sky130_fd_sc_hd__tapvpwrvgnd_1
XFILLER_41_234 vssd1 vssd1 vccd1 vccd1 sky130_fd_sc_hd__fill_2
XTAP_TAPCELL_ROW_36_281 vssd1 vccd1 sky130_fd_sc_hd__tapvpwrvgnd_1
XFILLER_26_275 vssd1 vssd1 vccd1 vccd1 sky130_fd_sc_hd__fill_2
XFILLER_5_124 vccd1 vssd1 vccd1 vssd1 sky130_ef_sc_hd__decap_40_12
XFILLER_5_102 vssd1 vssd1 vccd1 vccd1 sky130_fd_sc_hd__fill_4
XPHY_EDGE_ROW_36_Left_83 vssd1 vssd1 vccd1 vccd1 sky130_fd_sc_hd__decap_3
XPHY_EDGE_ROW_20_Left_67 vssd1 vssd1 vccd1 vccd1 sky130_fd_sc_hd__decap_3
XFILLER_27_90 vssd1 vssd1 vccd1 vccd1 sky130_fd_sc_hd__fill_1
X_0962_ _0197_ _0198_ vssd1 vssd1 vccd1 vccd1 _0199_ sky130_fd_sc_hd__or2_1
X_0893_ STOPWATCH_INST.digit_scanner.period_counter\[7\] _0143_ net217 vssd1 vssd1
+ vccd1 vccd1 _0145_ sky130_fd_sc_hd__a21o_1
X_1445_ _0598_ _0600_ net15 net29 vssd1 vssd1 vccd1 vccd1 _0680_ sky130_fd_sc_hd__a31o_1
X_1514_ _0174_ net33 _0734_ _0738_ vssd1 vssd1 vccd1 vccd1 _0044_ sky130_fd_sc_hd__a31o_1
X_1376_ net109 _0591_ _0612_ vssd1 vssd1 vccd1 vccd1 _0613_ sky130_fd_sc_hd__a21oi_1
XFILLER_23_15 vssd1 vssd1 vccd1 vccd1 sky130_fd_sc_hd__fill_1
XFILLER_23_223 vssd1 vssd1 vccd1 vccd1 sky130_fd_sc_hd__fill_1
XFILLER_2_138 vssd1 vssd1 vccd1 vccd1 sky130_fd_sc_hd__fill_2
XFILLER_14_289 vssd1 vssd1 vccd1 vccd1 sky130_fd_sc_hd__fill_8
X_1092_ _0260_ _0328_ vssd1 vssd1 vccd1 vccd1 _0329_ sky130_fd_sc_hd__xor2_2
X_1161_ _0336_ _0393_ vssd1 vssd1 vccd1 vccd1 _0398_ sky130_fd_sc_hd__xnor2_2
X_1230_ net42 _0449_ vssd1 vssd1 vccd1 vccd1 _0467_ sky130_fd_sc_hd__or2_1
XFILLER_29_6 vssd1 vssd1 vccd1 vccd1 sky130_fd_sc_hd__fill_4
XTAP_TAPCELL_ROW_0_95 vssd1 vccd1 sky130_fd_sc_hd__tapvpwrvgnd_1
X_0876_ STOPWATCH_INST.bcd_num\[6\] _0134_ vssd1 vssd1 vccd1 vccd1 _0137_ sky130_fd_sc_hd__and2_1
X_0945_ _0182_ _0183_ vssd1 vssd1 vccd1 vccd1 _0030_ sky130_fd_sc_hd__nor2_1
X_1428_ STOPWATCH_INST.clock_div.cycles\[7\] _0062_ _0157_ vssd1 vssd1 vccd1 vccd1
+ _0665_ sky130_fd_sc_hd__or3b_1
XFILLER_34_36 vssd1 vssd1 vccd1 vccd1 sky130_fd_sc_hd__fill_1
XFILLER_34_14 vssd1 vssd1 vccd1 vccd1 sky130_fd_sc_hd__fill_2
X_1359_ _0594_ _0595_ vssd1 vssd1 vccd1 vccd1 _0596_ sky130_fd_sc_hd__or2_1
Xclkload2 clknet_3_3__leaf_clk vssd1 vssd1 vccd1 vccd1 clkload2/X sky130_fd_sc_hd__clkbuf_4
XFILLER_46_167 vssd1 vssd1 vccd1 vccd1 sky130_fd_sc_hd__fill_1
XANTENNA_clkbuf_3_4__f_clk_A clknet_0_clk vssd1 vssd1 vccd1 vccd1 sky130_fd_sc_hd__diode_2
XFILLER_24_80 vssd1 vssd1 vccd1 vccd1 sky130_fd_sc_hd__fill_4
X_1213_ STOPWATCH_INST.clock_div.cycles\[9\] STOPWATCH_INST.clock_div.cycles\[8\]
+ net42 vssd1 vssd1 vccd1 vccd1 _0450_ sky130_fd_sc_hd__or3b_1
X_1144_ _0380_ vssd1 vssd1 vccd1 vccd1 _0381_ sky130_fd_sc_hd__inv_2
XFILLER_37_167 vssd1 vssd1 vccd1 vccd1 sky130_fd_sc_hd__fill_1
XFILLER_37_156 vssd1 vssd1 vccd1 vccd1 sky130_fd_sc_hd__fill_2
X_1075_ STOPWATCH_INST.clock_div.cycles\[13\] net24 net27 vssd1 vssd1 vccd1 vccd1
+ _0312_ sky130_fd_sc_hd__and3_1
XPHY_EDGE_ROW_23_Left_70 vssd1 vssd1 vccd1 vccd1 sky130_fd_sc_hd__decap_3
X_0928_ STOPWATCH_INST.clock_div.cycles\[27\] STOPWATCH_INST.clock_div.cycles\[28\]
+ STOPWATCH_INST.clock_div.cycles\[31\] _0171_ vssd1 vssd1 vccd1 vccd1 _0172_ sky130_fd_sc_hd__or4_1
X_0859_ _0071_ _0125_ vssd1 vssd1 vccd1 vccd1 _0001_ sky130_fd_sc_hd__nor2_1
XFILLER_20_27 vssd1 vssd1 vccd1 vccd1 sky130_fd_sc_hd__fill_1
XFILLER_45_13 vssd1 vssd1 vccd1 vccd1 sky130_fd_sc_hd__fill_2
XFILLER_29_69 vssd1 vssd1 vccd1 vccd1 sky130_fd_sc_hd__fill_1
XFILLER_45_57 vssd1 vssd1 vccd1 vccd1 sky130_fd_sc_hd__fill_1
XTAP_TAPCELL_ROW_41_305 vssd1 vccd1 sky130_fd_sc_hd__tapvpwrvgnd_1
XFILLER_34_104 vccd1 vssd1 vccd1 vssd1 sky130_ef_sc_hd__decap_40_12
X_1058_ net119 _0294_ vssd1 vssd1 vccd1 vccd1 _0295_ sky130_fd_sc_hd__nor2_1
X_1127_ _0316_ _0359_ _0363_ vssd1 vssd1 vccd1 vccd1 _0364_ sky130_fd_sc_hd__and3_4
XFILLER_25_137 vccd1 vssd1 vccd1 vssd1 sky130_ef_sc_hd__decap_40_12
XFILLER_31_48 vssd1 vssd1 vccd1 vccd1 sky130_fd_sc_hd__fill_1
XFILLER_31_26 vccd1 vssd1 vccd1 vssd1 sky130_ef_sc_hd__decap_40_12
XPHY_EDGE_ROW_1_Right_1 vssd1 vssd1 vccd1 vccd1 sky130_fd_sc_hd__decap_3
XFILLER_0_225 vccd1 vssd1 vccd1 vssd1 sky130_ef_sc_hd__decap_40_12
XFILLER_39_207 vccd1 vssd1 vccd1 vssd1 sky130_ef_sc_hd__decap_40_12
XTAP_TAPCELL_ROW_17_187 vssd1 vccd1 sky130_fd_sc_hd__tapvpwrvgnd_1
XFILLER_7_72 vssd1 vssd1 vccd1 vccd1 sky130_fd_sc_hd__fill_8
XFILLER_15_192 vssd1 vssd1 vccd1 vccd1 sky130_fd_sc_hd__fill_1
XFILLER_42_14 vssd1 vssd1 vccd1 vccd1 sky130_fd_sc_hd__fill_2
XFILLER_8_188 vssd1 vssd1 vccd1 vccd1 sky130_fd_sc_hd__fill_1
XFILLER_8_199 vssd1 vssd1 vccd1 vccd1 sky130_fd_sc_hd__fill_1
X_1530_ net144 _0649_ vssd1 vssd1 vccd1 vccd1 _0752_ sky130_fd_sc_hd__nand2_1
X_1392_ _0625_ _0628_ vssd1 vssd1 vccd1 vccd1 _0629_ sky130_fd_sc_hd__nor2_1
X_1461_ STOPWATCH_INST.clock_div.cycles\[10\] _0682_ STOPWATCH_INST.clock_div.cycles\[11\]
+ vssd1 vssd1 vccd1 vccd1 _0694_ sky130_fd_sc_hd__a21oi_1
XFILLER_35_254 vccd1 vssd1 vccd1 vssd1 sky130_ef_sc_hd__decap_40_12
Xhold111 STOPWATCH_INST.digit_scanner.period_counter\[6\] vssd1 vssd1 vccd1 vccd1
+ net219 sky130_fd_sc_hd__dlygate4sd3_1
Xhold100 STOPWATCH_INST.clock_div.cycles\[2\] vssd1 vssd1 vccd1 vccd1 net208 sky130_fd_sc_hd__dlygate4sd3_1
XTAP_TAPCELL_ROW_5_125 vssd1 vccd1 sky130_fd_sc_hd__tapvpwrvgnd_1
XFILLER_37_69 vssd1 vssd1 vccd1 vccd1 sky130_fd_sc_hd__fill_2
XFILLER_26_298 vssd1 vssd1 vccd1 vccd1 sky130_fd_sc_hd__fill_1
XFILLER_26_265 vssd1 vssd1 vccd1 vccd1 sky130_fd_sc_hd__fill_1
XTAP_TAPCELL_ROW_36_282 vssd1 vccd1 sky130_fd_sc_hd__tapvpwrvgnd_1
XANTENNA__1441__B1 STOPWATCH_INST.clock_div.cycles\[8\] vssd1 vssd1 vccd1 vccd1 sky130_fd_sc_hd__diode_2
XFILLER_5_169 vccd1 vssd1 vccd1 vssd1 sky130_ef_sc_hd__decap_40_12
XFILLER_5_136 vccd1 vssd1 vccd1 vssd1 sky130_ef_sc_hd__decap_40_12
XFILLER_17_221 vssd1 vssd1 vccd1 vccd1 sky130_fd_sc_hd__fill_2
XFILLER_32_257 vssd1 vssd1 vccd1 vccd1 sky130_fd_sc_hd__fill_2
X_0961_ STOPWATCH_INST.clock_div.cycles\[15\] _0187_ _0194_ vssd1 vssd1 vccd1 vccd1
+ _0198_ sky130_fd_sc_hd__and3_1
XFILLER_17_298 vssd1 vssd1 vccd1 vccd1 sky130_fd_sc_hd__fill_1
X_0892_ net204 _0143_ vssd1 vssd1 vccd1 vccd1 _0016_ sky130_fd_sc_hd__xor2_1
XFILLER_4_62 vccd1 vssd1 vccd1 vssd1 sky130_ef_sc_hd__decap_40_12
X_1444_ _0598_ net15 _0600_ vssd1 vssd1 vccd1 vccd1 _0679_ sky130_fd_sc_hd__a21oi_1
X_1375_ _0556_ _0557_ _0545_ vssd1 vssd1 vccd1 vccd1 _0612_ sky130_fd_sc_hd__o21a_1
X_1513_ _0735_ _0737_ net130 net37 vssd1 vssd1 vccd1 vccd1 _0738_ sky130_fd_sc_hd__a2bb2o_1
XFILLER_23_202 vssd1 vssd1 vccd1 vccd1 sky130_fd_sc_hd__fill_4
XFILLER_14_213 vccd1 vssd1 vccd1 vssd1 sky130_ef_sc_hd__decap_40_12
XFILLER_14_279 vssd1 vssd1 vccd1 vccd1 sky130_fd_sc_hd__fill_2
XTAP_TAPCELL_ROW_0_96 vssd1 vccd1 sky130_fd_sc_hd__tapvpwrvgnd_1
XFILLER_1_161 vssd1 vssd1 vccd1 vccd1 sky130_fd_sc_hd__fill_4
X_1091_ net27 net25 _0281_ vssd1 vssd1 vccd1 vccd1 _0328_ sky130_fd_sc_hd__a21o_1
X_1160_ _0390_ _0387_ _0396_ vssd1 vssd1 vccd1 vccd1 _0397_ sky130_fd_sc_hd__a21o_1
Xclkbuf_3_7__f_clk clknet_0_clk vssd1 vssd1 vccd1 vccd1 clknet_3_7__leaf_clk sky130_fd_sc_hd__clkbuf_16
X_0944_ STOPWATCH_INST.clock_div.cycles\[4\] STOPWATCH_INST.clock_div.cycles\[5\]
+ _0180_ vssd1 vssd1 vccd1 vccd1 _0183_ sky130_fd_sc_hd__and3_1
XFILLER_9_250 vccd1 vssd1 vccd1 vssd1 sky130_ef_sc_hd__decap_40_12
XFILLER_20_216 vccd1 vssd1 vccd1 vssd1 sky130_ef_sc_hd__decap_40_12
X_0875_ STOPWATCH_INST.bcd_num\[6\] _0134_ vssd1 vssd1 vccd1 vccd1 _0136_ sky130_fd_sc_hd__or2_1
X_1427_ _0060_ net41 STOPWATCH_INST.clock_div.cycles\[14\] STOPWATCH_INST.clock_div.cycles\[10\]
+ vssd1 vssd1 vccd1 vccd1 _0664_ sky130_fd_sc_hd__or4b_1
X_1358_ _0590_ STOPWATCH_INST.clock_div.cycles\[8\] _0591_ vssd1 vssd1 vccd1 vccd1
+ _0595_ sky130_fd_sc_hd__and3_1
XFILLER_18_27 vssd1 vssd1 vccd1 vccd1 sky130_fd_sc_hd__fill_1
X_1289_ _0525_ vssd1 vssd1 vccd1 vccd1 _0526_ sky130_fd_sc_hd__inv_2
Xclkload3 clknet_3_4__leaf_clk vssd1 vssd1 vccd1 vccd1 clkload3/Y sky130_fd_sc_hd__bufinv_16
XFILLER_46_113 vccd1 vssd1 vccd1 vssd1 sky130_ef_sc_hd__decap_40_12
XFILLER_41_6 vccd1 vssd1 vccd1 vssd1 sky130_ef_sc_hd__decap_40_12
XFILLER_6_253 vssd1 vssd1 vccd1 vccd1 sky130_fd_sc_hd__fill_4
XFILLER_10_293 vssd1 vssd1 vccd1 vccd1 sky130_fd_sc_hd__fill_2
XFILLER_37_113 vssd1 vssd1 vccd1 vccd1 sky130_fd_sc_hd__fill_8
X_1212_ _0061_ net23 vssd1 vssd1 vccd1 vccd1 _0449_ sky130_fd_sc_hd__xnor2_2
X_1143_ _0321_ _0379_ vssd1 vssd1 vccd1 vccd1 _0380_ sky130_fd_sc_hd__xnor2_2
XFILLER_37_179 vssd1 vssd1 vccd1 vccd1 sky130_fd_sc_hd__fill_8
X_1074_ net143 _0310_ vssd1 vssd1 vccd1 vccd1 _0311_ sky130_fd_sc_hd__xor2_2
XFILLER_1_52 vssd1 vssd1 vccd1 vccd1 sky130_fd_sc_hd__fill_4
X_0927_ STOPWATCH_INST.clock_div.cycles\[29\] STOPWATCH_INST.clock_div.cycles\[30\]
+ vssd1 vssd1 vccd1 vccd1 _0171_ sky130_fd_sc_hd__or2_1
X_0858_ net43 _0124_ vssd1 vssd1 vccd1 vccd1 _0125_ sky130_fd_sc_hd__xnor2_1
X_0789_ STOPWATCH_INST.sync_ten.q STOPWATCH_INST.sync_ten.sync_2 vssd1 vssd1 vccd1
+ vccd1 _0066_ sky130_fd_sc_hd__and2b_1
XFILLER_29_59 vssd1 vssd1 vccd1 vccd1 sky130_fd_sc_hd__fill_1
XFILLER_28_179 vccd1 vssd1 vccd1 vssd1 sky130_ef_sc_hd__decap_40_12
XTAP_TAPCELL_ROW_41_306 vssd1 vccd1 sky130_fd_sc_hd__tapvpwrvgnd_1
XFILLER_10_83 vssd1 vssd1 vccd1 vccd1 sky130_fd_sc_hd__fill_1
XFILLER_34_138 vssd1 vssd1 vccd1 vccd1 sky130_fd_sc_hd__fill_2
XFILLER_34_116 vccd1 vssd1 vccd1 vssd1 sky130_ef_sc_hd__decap_40_12
X_1126_ _0349_ _0352_ _0361_ vssd1 vssd1 vccd1 vccd1 _0363_ sky130_fd_sc_hd__a21o_1
X_1057_ _0225_ _0236_ _0243_ vssd1 vssd1 vccd1 vccd1 _0294_ sky130_fd_sc_hd__o21a_1
XFILLER_25_149 vccd1 vssd1 vccd1 vssd1 sky130_ef_sc_hd__decap_40_12
XFILLER_31_38 vssd1 vssd1 vccd1 vccd1 sky130_fd_sc_hd__fill_8
XFILLER_0_237 vccd1 vssd1 vccd1 vssd1 sky130_ef_sc_hd__decap_40_12
XFILLER_31_108 vssd1 vssd1 vccd1 vccd1 sky130_fd_sc_hd__fill_4
XFILLER_39_219 vssd1 vssd1 vccd1 vccd1 sky130_fd_sc_hd__fill_4
XFILLER_11_7 vssd1 vssd1 vccd1 vccd1 sky130_fd_sc_hd__fill_1
XTAP_TAPCELL_ROW_17_188 vssd1 vccd1 sky130_fd_sc_hd__tapvpwrvgnd_1
Xclkbuf_0_clk clk vssd1 vssd1 vccd1 vccd1 clknet_0_clk sky130_fd_sc_hd__clkbuf_16
XFILLER_30_141 vssd1 vssd1 vccd1 vccd1 sky130_fd_sc_hd__fill_8
XPHY_EDGE_ROW_15_Right_15 vssd1 vssd1 vccd1 vccd1 sky130_fd_sc_hd__decap_3
XFILLER_38_274 vssd1 vssd1 vccd1 vccd1 sky130_fd_sc_hd__fill_2
X_1109_ _0343_ _0344_ vssd1 vssd1 vccd1 vccd1 _0346_ sky130_fd_sc_hd__or2_1
XPHY_EDGE_ROW_24_Right_24 vssd1 vssd1 vccd1 vccd1 sky130_fd_sc_hd__decap_3
XFILLER_26_27 vssd1 vssd1 vccd1 vccd1 sky130_fd_sc_hd__fill_1
XPHY_EDGE_ROW_33_Right_33 vssd1 vssd1 vccd1 vccd1 sky130_fd_sc_hd__decap_3
XFILLER_29_263 vccd1 vssd1 vccd1 vssd1 sky130_ef_sc_hd__decap_40_12
XFILLER_29_252 vssd1 vssd1 vccd1 vccd1 sky130_fd_sc_hd__fill_2
XPHY_EDGE_ROW_42_Right_42 vssd1 vssd1 vccd1 vccd1 sky130_fd_sc_hd__decap_3
XFILLER_12_141 vssd1 vssd1 vccd1 vccd1 sky130_fd_sc_hd__fill_1
XTAP_TAPCELL_ROW_14_169 vssd1 vccd1 sky130_fd_sc_hd__tapvpwrvgnd_1
X_1391_ _0593_ _0623_ _0580_ vssd1 vssd1 vccd1 vccd1 _0628_ sky130_fd_sc_hd__a21oi_1
X_1460_ STOPWATCH_INST.clock_div.cycles\[10\] STOPWATCH_INST.clock_div.cycles\[11\]
+ _0682_ vssd1 vssd1 vccd1 vccd1 _0693_ sky130_fd_sc_hd__and3_1
XFILLER_35_222 vssd1 vssd1 vccd1 vccd1 sky130_fd_sc_hd__fill_2
XFILLER_35_266 vccd1 vssd1 vccd1 vssd1 sky130_ef_sc_hd__decap_40_12
Xhold112 STOPWATCH_INST.digit_scanner.period_counter\[10\] vssd1 vssd1 vccd1 vccd1
+ net220 sky130_fd_sc_hd__dlygate4sd3_1
XFILLER_12_29 vssd1 vssd1 vccd1 vccd1 sky130_fd_sc_hd__fill_4
Xhold101 STOPWATCH_INST.sync_pause.q vssd1 vssd1 vccd1 vccd1 net209 sky130_fd_sc_hd__dlygate4sd3_1
XFILLER_37_37 vssd1 vssd1 vccd1 vccd1 sky130_fd_sc_hd__fill_1
XTAP_TAPCELL_ROW_5_126 vssd1 vccd1 sky130_fd_sc_hd__tapvpwrvgnd_1
X_1589_ clknet_3_0__leaf_clk _0007_ net45 vssd1 vssd1 vccd1 vccd1 STOPWATCH_INST.bcd_num\[6\]
+ sky130_fd_sc_hd__dfrtp_1
XFILLER_41_225 vssd1 vssd1 vccd1 vccd1 sky130_fd_sc_hd__fill_1
XTAP_TAPCELL_ROW_36_283 vssd1 vccd1 sky130_fd_sc_hd__tapvpwrvgnd_1
XTAP_TAPCELL_ROW_28_239 vssd1 vccd1 sky130_fd_sc_hd__tapvpwrvgnd_1
XANTENNA__1213__B STOPWATCH_INST.clock_div.cycles\[8\] vssd1 vssd1 vccd1 vccd1 sky130_fd_sc_hd__diode_2
XANTENNA__1441__A1 STOPWATCH_INST.clock_div.cycles\[7\] vssd1 vssd1 vccd1 vccd1 sky130_fd_sc_hd__diode_2
XFILLER_5_148 vssd1 vssd1 vccd1 vccd1 sky130_fd_sc_hd__fill_8
X_0960_ _0187_ _0194_ STOPWATCH_INST.clock_div.cycles\[15\] vssd1 vssd1 vccd1 vccd1
+ _0197_ sky130_fd_sc_hd__a21oi_2
X_0891_ _0143_ _0144_ vssd1 vssd1 vccd1 vccd1 _0015_ sky130_fd_sc_hd__and2b_1
XTAP_TAPCELL_ROW_10_150 vssd1 vccd1 sky130_fd_sc_hd__tapvpwrvgnd_1
X_1512_ net130 _0730_ _0736_ vssd1 vssd1 vccd1 vccd1 _0737_ sky130_fd_sc_hd__o21ai_1
XFILLER_4_74 vssd1 vssd1 vccd1 vccd1 sky130_fd_sc_hd__fill_8
X_1443_ _0675_ net34 _0678_ net36 STOPWATCH_INST.clock_div.cycles\[8\] vssd1 vssd1
+ vccd1 vccd1 _0033_ sky130_fd_sc_hd__a32o_1
X_1374_ _0608_ _0610_ vssd1 vssd1 vccd1 vccd1 _0611_ sky130_fd_sc_hd__or2_1
XANTENNA__1314__A _0060_ vssd1 vssd1 vccd1 vccd1 sky130_fd_sc_hd__diode_2
XFILLER_23_225 vccd1 vssd1 vccd1 vssd1 sky130_ef_sc_hd__decap_40_12
XTAP_TAPCELL_ROW_33_264 vssd1 vccd1 sky130_fd_sc_hd__tapvpwrvgnd_1
XFILLER_14_225 vssd1 vssd1 vccd1 vccd1 sky130_fd_sc_hd__fill_8
Xfanout40 STOPWATCH_INST.clock_div.cycles\[19\] vssd1 vssd1 vccd1 vccd1 net40 sky130_fd_sc_hd__buf_6
XTAP_TAPCELL_ROW_24_220 vssd1 vccd1 sky130_fd_sc_hd__tapvpwrvgnd_1
XTAP_TAPCELL_ROW_0_97 vssd1 vccd1 sky130_fd_sc_hd__tapvpwrvgnd_1
XFILLER_1_195 vccd1 vssd1 vccd1 vssd1 sky130_ef_sc_hd__decap_40_12
X_1090_ _0264_ _0326_ vssd1 vssd1 vccd1 vccd1 _0327_ sky130_fd_sc_hd__xnor2_2
X_0943_ STOPWATCH_INST.clock_div.cycles\[4\] _0180_ net214 vssd1 vssd1 vccd1 vccd1
+ _0182_ sky130_fd_sc_hd__a21oi_1
X_0874_ _0134_ _0135_ vssd1 vssd1 vccd1 vccd1 _0006_ sky130_fd_sc_hd__nor2_1
XFILLER_9_262 vccd1 vssd1 vccd1 vssd1 sky130_ef_sc_hd__decap_40_12
XFILLER_9_295 vssd1 vssd1 vccd1 vccd1 sky130_fd_sc_hd__fill_1
XFILLER_20_228 vssd1 vssd1 vccd1 vccd1 sky130_fd_sc_hd__fill_2
X_1357_ _0590_ _0591_ STOPWATCH_INST.clock_div.cycles\[8\] vssd1 vssd1 vccd1 vccd1
+ _0594_ sky130_fd_sc_hd__a21oi_2
X_1288_ _0497_ _0507_ _0523_ _0519_ _0524_ vssd1 vssd1 vccd1 vccd1 _0525_ sky130_fd_sc_hd__a221oi_4
X_1426_ STOPWATCH_INST.clock_div.cycles\[7\] _0060_ _0661_ _0662_ _0076_ vssd1 vssd1
+ vccd1 vccd1 _0663_ sky130_fd_sc_hd__a41o_1
XFILLER_34_27 vssd1 vssd1 vccd1 vccd1 sky130_fd_sc_hd__fill_1
Xclkload4 clknet_3_5__leaf_clk vssd1 vssd1 vccd1 vccd1 clkload4/Y sky130_fd_sc_hd__clkinv_1
XANTENNA__0907__B1 _0122_ vssd1 vssd1 vccd1 vccd1 sky130_fd_sc_hd__diode_2
XFILLER_46_169 vccd1 vssd1 vccd1 vssd1 sky130_ef_sc_hd__decap_40_12
XFILLER_46_125 vccd1 vssd1 vccd1 vssd1 sky130_ef_sc_hd__decap_40_12
XFILLER_10_250 vssd1 vssd1 vccd1 vccd1 sky130_fd_sc_hd__fill_2
XFILLER_6_221 vssd1 vssd1 vccd1 vccd1 sky130_fd_sc_hd__fill_2
XFILLER_6_265 vssd1 vssd1 vccd1 vccd1 sky130_fd_sc_hd__fill_1
XFILLER_6_298 vssd1 vssd1 vccd1 vccd1 sky130_fd_sc_hd__fill_1
X_1142_ _0324_ _0378_ vssd1 vssd1 vccd1 vccd1 _0379_ sky130_fd_sc_hd__nor2_1
XFILLER_34_6 vssd1 vssd1 vccd1 vccd1 sky130_fd_sc_hd__fill_8
X_1211_ _0373_ _0447_ vssd1 vssd1 vccd1 vccd1 _0448_ sky130_fd_sc_hd__xor2_2
X_1073_ net24 net27 STOPWATCH_INST.clock_div.cycles\[13\] vssd1 vssd1 vccd1 vccd1
+ _0310_ sky130_fd_sc_hd__a21oi_2
X_0926_ STOPWATCH_INST.clock_div.cycles\[24\] STOPWATCH_INST.clock_div.cycles\[26\]
+ STOPWATCH_INST.clock_div.cycles\[25\] vssd1 vssd1 vccd1 vccd1 _0170_ sky130_fd_sc_hd__or3_4
X_0857_ _0059_ _0123_ vssd1 vssd1 vccd1 vccd1 _0124_ sky130_fd_sc_hd__nand2_1
XANTENNA__1562__B1 net32 vssd1 vssd1 vccd1 vccd1 sky130_fd_sc_hd__diode_2
X_0788_ STOPWATCH_INST.digit_scanner.ctrl vssd1 vssd1 vccd1 vccd1 STOPWATCH_INST.D0_AN_0
+ sky130_fd_sc_hd__inv_2
X_1409_ _0567_ _0572_ vssd1 vssd1 vccd1 vccd1 _0646_ sky130_fd_sc_hd__nand2_2
XFILLER_28_114 vccd1 vssd1 vccd1 vssd1 sky130_ef_sc_hd__decap_40_12
XFILLER_28_103 vssd1 vssd1 vccd1 vccd1 sky130_fd_sc_hd__fill_2
XTAP_TAPCELL_ROW_41_307 vssd1 vccd1 sky130_fd_sc_hd__tapvpwrvgnd_1
XFILLER_3_246 vssd1 vssd1 vccd1 vccd1 sky130_fd_sc_hd__fill_1
XANTENNA__1553__B1 net32 vssd1 vssd1 vccd1 vccd1 sky130_fd_sc_hd__diode_2
XFILLER_3_279 vssd1 vssd1 vccd1 vccd1 sky130_fd_sc_hd__fill_1
XFILLER_35_81 vccd1 vssd1 vccd1 vssd1 sky130_ef_sc_hd__decap_40_12
XFILLER_34_128 vssd1 vssd1 vccd1 vccd1 sky130_fd_sc_hd__fill_2
XFILLER_32_3 vssd1 vssd1 vccd1 vccd1 sky130_fd_sc_hd__fill_2
X_1125_ _0349_ _0352_ _0361_ vssd1 vssd1 vccd1 vccd1 _0362_ sky130_fd_sc_hd__a21oi_2
X_1056_ _0257_ _0284_ _0282_ _0292_ _0240_ vssd1 vssd1 vccd1 vccd1 _0293_ sky130_fd_sc_hd__a311o_1
XFILLER_15_29 vssd1 vssd1 vccd1 vccd1 sky130_fd_sc_hd__fill_4
X_0909_ STOPWATCH_INST.digit_scanner.period_counter\[13\] STOPWATCH_INST.digit_scanner.period_counter\[14\]
+ _0152_ vssd1 vssd1 vccd1 vccd1 _0155_ sky130_fd_sc_hd__and3_1
XFILLER_0_249 vssd1 vssd1 vccd1 vccd1 sky130_fd_sc_hd__fill_2
XFILLER_16_117 vssd1 vssd1 vccd1 vccd1 sky130_fd_sc_hd__fill_4
XFILLER_16_128 vssd1 vssd1 vccd1 vccd1 sky130_fd_sc_hd__fill_1
XFILLER_24_183 vccd1 vssd1 vccd1 vssd1 sky130_ef_sc_hd__decap_40_12
XANTENNA__1637__RESET_B net49 vssd1 vssd1 vccd1 vccd1 sky130_fd_sc_hd__diode_2
XFILLER_38_264 vssd1 vssd1 vccd1 vccd1 sky130_fd_sc_hd__fill_2
XFILLER_38_253 vssd1 vssd1 vccd1 vccd1 sky130_fd_sc_hd__fill_4
X_1108_ _0309_ _0311_ _0314_ vssd1 vssd1 vccd1 vccd1 _0345_ sky130_fd_sc_hd__nand3_1
X_1039_ _0268_ _0212_ vssd1 vssd1 vccd1 vccd1 _0276_ sky130_fd_sc_hd__xnor2_2
XFILLER_21_153 vssd1 vssd1 vccd1 vccd1 sky130_fd_sc_hd__fill_4
XFILLER_21_197 vssd1 vssd1 vccd1 vccd1 sky130_fd_sc_hd__fill_2
XFILLER_29_297 vssd1 vssd1 vccd1 vccd1 sky130_fd_sc_hd__fill_2
XANTENNA_fanout42_X net42 vssd1 vssd1 vccd1 vccd1 sky130_fd_sc_hd__diode_2
XFILLER_16_61 vccd1 vssd1 vccd1 vssd1 sky130_ef_sc_hd__decap_40_12
XFILLER_12_175 vssd1 vssd1 vccd1 vccd1 sky130_fd_sc_hd__fill_1
X_1390_ _0583_ _0625_ vssd1 vssd1 vccd1 vccd1 _0627_ sky130_fd_sc_hd__xnor2_1
XFILLER_35_278 vssd1 vssd1 vccd1 vccd1 sky130_fd_sc_hd__fill_2
Xhold102 STOPWATCH_INST.clock_div.cycles\[0\] vssd1 vssd1 vccd1 vccd1 net210 sky130_fd_sc_hd__dlygate4sd3_1
X_1588_ clknet_3_1__leaf_clk _0006_ net45 vssd1 vssd1 vccd1 vccd1 STOPWATCH_INST.bcd_num\[5\]
+ sky130_fd_sc_hd__dfrtp_2
XTAP_TAPCELL_ROW_5_127 vssd1 vccd1 sky130_fd_sc_hd__tapvpwrvgnd_1
XFILLER_26_223 vccd1 vssd1 vccd1 vssd1 sky130_ef_sc_hd__decap_40_12
XFILLER_17_223 vssd1 vssd1 vccd1 vccd1 sky130_fd_sc_hd__fill_1
XFILLER_32_259 vssd1 vssd1 vccd1 vccd1 sky130_fd_sc_hd__fill_1
X_0890_ STOPWATCH_INST.digit_scanner.period_counter\[5\] STOPWATCH_INST.digit_scanner.period_counter\[4\]
+ _0117_ net219 vssd1 vssd1 vccd1 vccd1 _0144_ sky130_fd_sc_hd__a31o_1
XFILLER_4_171 vssd1 vssd1 vccd1 vccd1 sky130_fd_sc_hd__fill_4
XFILLER_4_42 vccd1 vssd1 vccd1 vssd1 sky130_ef_sc_hd__decap_40_12
X_1442_ _0676_ _0677_ net29 vssd1 vssd1 vccd1 vccd1 _0678_ sky130_fd_sc_hd__o21ai_1
XTAP_TAPCELL_ROW_10_151 vssd1 vccd1 sky130_fd_sc_hd__tapvpwrvgnd_1
X_1511_ _0068_ net30 _0671_ vssd1 vssd1 vccd1 vccd1 _0736_ sky130_fd_sc_hd__and3_1
X_1373_ _0557_ _0604_ vssd1 vssd1 vccd1 vccd1 _0610_ sky130_fd_sc_hd__xor2_2
XFILLER_23_237 vccd1 vssd1 vccd1 vssd1 sky130_ef_sc_hd__decap_40_12
XTAP_TAPCELL_ROW_33_265 vssd1 vccd1 sky130_fd_sc_hd__tapvpwrvgnd_1
XFILLER_14_237 vssd1 vssd1 vccd1 vccd1 sky130_fd_sc_hd__fill_2
Xfanout41 STOPWATCH_INST.clock_div.cycles\[13\] vssd1 vssd1 vccd1 vccd1 net41 sky130_fd_sc_hd__clkbuf_2
Xfanout30 net31 vssd1 vssd1 vccd1 vccd1 net30 sky130_fd_sc_hd__buf_2
XTAP_TAPCELL_ROW_24_221 vssd1 vccd1 sky130_fd_sc_hd__tapvpwrvgnd_1
XTAP_TAPCELL_ROW_0_98 vssd1 vccd1 sky130_fd_sc_hd__tapvpwrvgnd_1
X_0942_ net211 _0180_ vssd1 vssd1 vccd1 vccd1 _0029_ sky130_fd_sc_hd__xor2_1
X_0873_ STOPWATCH_INST.bcd_num\[5\] _0133_ _0123_ vssd1 vssd1 vccd1 vccd1 _0135_ sky130_fd_sc_hd__o21ai_1
XFILLER_9_274 vssd1 vssd1 vccd1 vccd1 sky130_fd_sc_hd__fill_4
X_1425_ net42 _0062_ net41 STOPWATCH_INST.clock_div.cycles\[14\] vssd1 vssd1 vccd1
+ vccd1 _0662_ sky130_fd_sc_hd__and4b_1
X_1287_ _0424_ _0494_ vssd1 vssd1 vccd1 vccd1 _0524_ sky130_fd_sc_hd__xor2_2
X_1356_ _0590_ _0591_ vssd1 vssd1 vccd1 vccd1 _0593_ sky130_fd_sc_hd__nand2_2
XFILLER_18_29 vssd1 vssd1 vccd1 vccd1 sky130_fd_sc_hd__fill_1
Xclkload5 clknet_3_6__leaf_clk vssd1 vssd1 vccd1 vccd1 clkload5/Y sky130_fd_sc_hd__inv_6
XFILLER_46_137 vssd1 vssd1 vccd1 vccd1 sky130_fd_sc_hd__fill_2
XFILLER_10_295 vssd1 vssd1 vccd1 vccd1 sky130_fd_sc_hd__fill_1
X_1141_ _0353_ _0357_ _0364_ vssd1 vssd1 vccd1 vccd1 _0378_ sky130_fd_sc_hd__a21o_1
X_1072_ _0251_ _0307_ vssd1 vssd1 vccd1 vccd1 _0309_ sky130_fd_sc_hd__xnor2_2
X_1210_ _0372_ _0374_ net23 vssd1 vssd1 vccd1 vccd1 _0447_ sky130_fd_sc_hd__and3_1
XFILLER_1_21 vssd1 vssd1 vccd1 vccd1 sky130_fd_sc_hd__fill_2
XFILLER_45_181 vccd1 vssd1 vccd1 vssd1 sky130_ef_sc_hd__decap_40_12
X_0925_ _0167_ _0168_ _0160_ vssd1 vssd1 vccd1 vccd1 _0169_ sky130_fd_sc_hd__o21a_1
X_0856_ _0087_ _0092_ _0110_ STOPWATCH_INST.fsm_inst1.currentState\[0\] STOPWATCH_INST.fsm_inst1.currentState\[1\]
+ vssd1 vssd1 vccd1 vccd1 _0123_ sky130_fd_sc_hd__o32a_2
X_0787_ STOPWATCH_INST.sync_clear.sync_2 vssd1 vssd1 vccd1 vccd1 _0065_ sky130_fd_sc_hd__inv_2
X_1408_ _0563_ _0643_ vssd1 vssd1 vccd1 vccd1 _0645_ sky130_fd_sc_hd__xnor2_4
XFILLER_28_126 vssd1 vssd1 vccd1 vccd1 sky130_fd_sc_hd__fill_4
X_1339_ _0574_ _0575_ vssd1 vssd1 vccd1 vccd1 _0576_ sky130_fd_sc_hd__nand2_1
XTAP_TAPCELL_ROW_41_308 vssd1 vccd1 sky130_fd_sc_hd__tapvpwrvgnd_1
XFILLER_3_225 vssd1 vssd1 vccd1 vccd1 sky130_fd_sc_hd__fill_2
XFILLER_10_85 vssd1 vssd1 vccd1 vccd1 sky130_fd_sc_hd__fill_8
XFILLER_35_93 vccd1 vssd1 vccd1 vssd1 sky130_ef_sc_hd__decap_40_12
XPHY_EDGE_ROW_27_Left_74 vssd1 vssd1 vccd1 vccd1 sky130_fd_sc_hd__decap_3
X_1055_ _0288_ _0290_ vssd1 vssd1 vccd1 vccd1 _0292_ sky130_fd_sc_hd__nand2_2
X_1124_ _0325_ _0320_ _0357_ vssd1 vssd1 vccd1 vccd1 _0361_ sky130_fd_sc_hd__or3b_4
XPHY_EDGE_ROW_11_Left_58 vssd1 vssd1 vccd1 vccd1 sky130_fd_sc_hd__decap_3
XANTENNA__1480__B1 net32 vssd1 vssd1 vccd1 vccd1 sky130_fd_sc_hd__diode_2
X_0839_ STOPWATCH_INST.bcd_num\[5\] STOPWATCH_INST.bcd_num\[4\] STOPWATCH_INST.bcd_num\[7\]
+ STOPWATCH_INST.bcd_num\[6\] vssd1 vssd1 vccd1 vccd1 _0109_ sky130_fd_sc_hd__or4_1
X_0908_ net203 _0152_ _0154_ vssd1 vssd1 vccd1 vccd1 _0022_ sky130_fd_sc_hd__a21oi_1
XFILLER_24_195 vssd1 vssd1 vccd1 vccd1 sky130_fd_sc_hd__fill_1
XFILLER_30_176 vccd1 vssd1 vccd1 vssd1 sky130_ef_sc_hd__decap_40_12
XFILLER_30_121 vssd1 vssd1 vccd1 vccd1 sky130_fd_sc_hd__fill_8
XFILLER_7_31 vssd1 vssd1 vccd1 vccd1 sky130_fd_sc_hd__fill_1
XFILLER_38_210 vssd1 vssd1 vccd1 vccd1 sky130_fd_sc_hd__fill_2
X_1038_ _0270_ _0269_ _0267_ _0272_ net146 vssd1 vssd1 vccd1 vccd1 _0275_ sky130_fd_sc_hd__a311o_1
XFILLER_38_276 vssd1 vssd1 vccd1 vccd1 sky130_fd_sc_hd__fill_1
X_1107_ _0309_ _0311_ _0314_ vssd1 vssd1 vccd1 vccd1 _0344_ sky130_fd_sc_hd__and3_1
XPHY_EDGE_ROW_5_Right_5 vssd1 vssd1 vccd1 vccd1 sky130_fd_sc_hd__decap_3
XFILLER_29_210 vssd1 vssd1 vccd1 vccd1 sky130_fd_sc_hd__fill_4
XFILLER_12_121 vccd1 vssd1 vccd1 vssd1 sky130_ef_sc_hd__decap_40_12
XFILLER_16_40 vssd1 vssd1 vccd1 vccd1 sky130_fd_sc_hd__fill_2
XFILLER_16_73 vssd1 vssd1 vccd1 vccd1 sky130_fd_sc_hd__fill_2
XTAP_TAPCELL_ROW_5_128 vssd1 vccd1 sky130_fd_sc_hd__tapvpwrvgnd_1
Xhold103 STOPWATCH_INST.clock_div.cycles\[4\] vssd1 vssd1 vccd1 vccd1 net211 sky130_fd_sc_hd__dlygate4sd3_1
X_1587_ clknet_3_1__leaf_clk _0005_ net45 vssd1 vssd1 vccd1 vccd1 STOPWATCH_INST.bcd_num\[4\]
+ sky130_fd_sc_hd__dfrtp_2
XFILLER_26_235 vssd1 vssd1 vccd1 vccd1 sky130_fd_sc_hd__fill_2
XPHY_EDGE_ROW_14_Left_61 vssd1 vssd1 vccd1 vccd1 sky130_fd_sc_hd__decap_3
XFILLER_17_257 vccd1 vssd1 vccd1 vssd1 sky130_ef_sc_hd__decap_40_12
XFILLER_40_293 vssd1 vssd1 vccd1 vccd1 sky130_fd_sc_hd__fill_2
XANTENNA_clkbuf_3_7__f_clk_A clknet_0_clk vssd1 vssd1 vccd1 vccd1 sky130_fd_sc_hd__diode_2
XFILLER_4_54 vssd1 vssd1 vccd1 vccd1 sky130_fd_sc_hd__fill_2
X_1441_ STOPWATCH_INST.clock_div.cycles\[7\] _0656_ STOPWATCH_INST.clock_div.cycles\[8\]
+ vssd1 vssd1 vccd1 vccd1 _0677_ sky130_fd_sc_hd__a21oi_1
XTAP_TAPCELL_ROW_10_152 vssd1 vccd1 sky130_fd_sc_hd__tapvpwrvgnd_1
X_1510_ STOPWATCH_INST.clock_div.cycles\[18\] net130 _0724_ vssd1 vssd1 vccd1 vccd1
+ _0735_ sky130_fd_sc_hd__and3_1
XTAP_TAPCELL_ROW_2_109 vssd1 vccd1 sky130_fd_sc_hd__tapvpwrvgnd_1
X_1372_ _0590_ _0591_ _0556_ _0557_ vssd1 vssd1 vccd1 vccd1 _0609_ sky130_fd_sc_hd__o2bb2a_4
XTAP_TAPCELL_ROW_33_266 vssd1 vccd1 sky130_fd_sc_hd__tapvpwrvgnd_1
XANTENNA__1621__RESET_B net49 vssd1 vssd1 vccd1 vccd1 sky130_fd_sc_hd__diode_2
XFILLER_23_249 vssd1 vssd1 vccd1 vccd1 sky130_fd_sc_hd__fill_2
X_1639_ clknet_3_1__leaf_clk _0057_ net45 vssd1 vssd1 vccd1 vccd1 STOPWATCH_INST.clock_div.second_tick
+ sky130_fd_sc_hd__dfrtp_1
XANTENNA_input4_A gpio_in[3] vssd1 vssd1 vccd1 vccd1 sky130_fd_sc_hd__diode_2
XFILLER_14_205 vssd1 vssd1 vccd1 vccd1 sky130_fd_sc_hd__fill_2
Xfanout20 _0463_ vssd1 vssd1 vccd1 vccd1 net20 sky130_fd_sc_hd__clkbuf_4
Xfanout42 STOPWATCH_INST.clock_div.cycles\[10\] vssd1 vssd1 vccd1 vccd1 net42 sky130_fd_sc_hd__clkbuf_4
XFILLER_13_41 vccd1 vssd1 vccd1 vssd1 sky130_ef_sc_hd__decap_40_12
Xfanout31 net32 vssd1 vssd1 vccd1 vccd1 net31 sky130_fd_sc_hd__buf_1
XTAP_TAPCELL_ROW_24_222 vssd1 vccd1 sky130_fd_sc_hd__tapvpwrvgnd_1
XTAP_TAPCELL_ROW_0_99 vssd1 vccd1 sky130_fd_sc_hd__tapvpwrvgnd_1
XANTENNA__1431__A STOPWATCH_INST.clock_div.cycles\[8\] vssd1 vssd1 vccd1 vccd1 sky130_fd_sc_hd__diode_2
X_0941_ _0180_ _0181_ vssd1 vssd1 vccd1 vccd1 _0028_ sky130_fd_sc_hd__and2b_1
X_0872_ STOPWATCH_INST.bcd_num\[5\] STOPWATCH_INST.bcd_num\[4\] _0131_ vssd1 vssd1
+ vccd1 vccd1 _0134_ sky130_fd_sc_hd__and3_1
X_1424_ net135 STOPWATCH_INST.clock_div.cycles\[24\] STOPWATCH_INST.clock_div.cycles\[26\]
+ _0660_ vssd1 vssd1 vccd1 vccd1 _0661_ sky130_fd_sc_hd__and4_1
X_1355_ _0590_ _0591_ vssd1 vssd1 vccd1 vccd1 _0592_ sky130_fd_sc_hd__and2_4
X_1286_ _0506_ _0497_ _0521_ vssd1 vssd1 vccd1 vccd1 _0523_ sky130_fd_sc_hd__and3_1
XPHY_EDGE_ROW_41_Left_88 vssd1 vssd1 vccd1 vccd1 sky130_fd_sc_hd__decap_3
Xclkload6 clknet_3_7__leaf_clk vssd1 vssd1 vccd1 vccd1 clkload6/Y sky130_fd_sc_hd__clkinv_4
XFILLER_6_223 vssd1 vssd1 vccd1 vccd1 sky130_fd_sc_hd__fill_1
XFILLER_40_83 vssd1 vssd1 vccd1 vccd1 sky130_fd_sc_hd__fill_1
X_1140_ _0359_ _0363_ _0376_ vssd1 vssd1 vccd1 vccd1 _0377_ sky130_fd_sc_hd__and3_1
X_1071_ net24 net27 _0251_ _0254_ vssd1 vssd1 vccd1 vccd1 _0308_ sky130_fd_sc_hd__a211o_1
XFILLER_45_193 vssd1 vssd1 vccd1 vccd1 sky130_fd_sc_hd__fill_8
X_0924_ STOPWATCH_INST.clock_div.cycles\[15\] _0165_ _0166_ STOPWATCH_INST.clock_div.cycles\[17\]
+ vssd1 vssd1 vccd1 vccd1 _0168_ sky130_fd_sc_hd__a211o_1
X_0786_ STOPWATCH_INST.clock_div.cycles\[18\] vssd1 vssd1 vccd1 vccd1 _0064_ sky130_fd_sc_hd__inv_2
X_0855_ net215 _0122_ vssd1 vssd1 vccd1 vccd1 _0000_ sky130_fd_sc_hd__xnor2_1
XANTENNA__1562__A2 net38 vssd1 vssd1 vccd1 vccd1 sky130_fd_sc_hd__diode_2
XFILLER_29_18 vssd1 vssd1 vccd1 vccd1 sky130_fd_sc_hd__fill_4
X_1407_ _0563_ _0643_ vssd1 vssd1 vccd1 vccd1 _0644_ sky130_fd_sc_hd__nor2_1
X_1338_ _0522_ net150 vssd1 vssd1 vccd1 vccd1 _0575_ sky130_fd_sc_hd__nand2b_1
X_1269_ _0432_ _0487_ _0501_ _0503_ vssd1 vssd1 vccd1 vccd1 _0506_ sky130_fd_sc_hd__and4_1
XANTENNA__1553__A2 net38 vssd1 vssd1 vccd1 vccd1 sky130_fd_sc_hd__diode_2
XFILLER_10_53 vssd1 vssd1 vccd1 vccd1 sky130_fd_sc_hd__fill_2
XFILLER_10_75 vssd1 vssd1 vccd1 vccd1 sky130_fd_sc_hd__fill_8
XFILLER_19_62 vssd1 vssd1 vccd1 vccd1 sky130_fd_sc_hd__fill_2
XFILLER_19_95 vssd1 vssd1 vccd1 vccd1 sky130_fd_sc_hd__fill_2
X_1054_ _0290_ vssd1 vssd1 vccd1 vccd1 _0291_ sky130_fd_sc_hd__inv_2
X_1123_ _0359_ vssd1 vssd1 vccd1 vccd1 _0360_ sky130_fd_sc_hd__inv_2
XFILLER_33_185 vssd1 vssd1 vccd1 vccd1 sky130_fd_sc_hd__fill_2
X_0907_ net203 _0152_ _0122_ vssd1 vssd1 vccd1 vccd1 _0154_ sky130_fd_sc_hd__o21ai_1
X_0838_ STOPWATCH_INST.bcd_num\[6\] _0107_ STOPWATCH_INST.D0_AN_0 STOPWATCH_INST.bcd_num\[7\]
+ vssd1 vssd1 vccd1 vccd1 _0108_ sky130_fd_sc_hd__a211oi_1
XPHY_EDGE_ROW_44_Left_91 vssd1 vssd1 vccd1 vccd1 sky130_fd_sc_hd__decap_3
XFILLER_30_188 vssd1 vssd1 vccd1 vccd1 sky130_fd_sc_hd__fill_8
XFILLER_30_133 vssd1 vssd1 vccd1 vccd1 sky130_fd_sc_hd__fill_4
XFILLER_38_266 vssd1 vssd1 vccd1 vccd1 sky130_fd_sc_hd__fill_1
X_1106_ net139 _0308_ vssd1 vssd1 vccd1 vccd1 _0343_ sky130_fd_sc_hd__xnor2_2
X_1037_ _0273_ _0216_ vssd1 vssd1 vccd1 vccd1 _0274_ sky130_fd_sc_hd__xnor2_2
XTAP_TAPCELL_ROW_16_180 vssd1 vccd1 sky130_fd_sc_hd__tapvpwrvgnd_1
XFILLER_21_199 vssd1 vssd1 vccd1 vccd1 sky130_fd_sc_hd__fill_1
XTAP_TAPCELL_ROW_39_294 vssd1 vccd1 sky130_fd_sc_hd__tapvpwrvgnd_1
XPHY_EDGE_ROW_11_Right_11 vssd1 vssd1 vccd1 vccd1 sky130_fd_sc_hd__decap_3
XFILLER_12_111 vssd1 vssd1 vccd1 vccd1 sky130_fd_sc_hd__fill_1
XFILLER_12_133 vssd1 vssd1 vccd1 vccd1 sky130_fd_sc_hd__fill_4
XFILLER_16_85 vssd1 vssd1 vccd1 vccd1 sky130_fd_sc_hd__fill_1
XPHY_EDGE_ROW_20_Right_20 vssd1 vssd1 vccd1 vccd1 sky130_fd_sc_hd__decap_3
XFILLER_35_225 vssd1 vssd1 vccd1 vccd1 sky130_fd_sc_hd__fill_1
XFILLER_7_181 vccd1 vssd1 vccd1 vssd1 sky130_ef_sc_hd__decap_40_12
Xhold104 STOPWATCH_INST.digit_scanner.period_counter\[9\] vssd1 vssd1 vccd1 vccd1
+ net212 sky130_fd_sc_hd__dlygate4sd3_1
X_1586_ clknet_3_0__leaf_clk _0004_ net45 vssd1 vssd1 vccd1 vccd1 STOPWATCH_INST.bcd_num\[3\]
+ sky130_fd_sc_hd__dfrtp_2
XFILLER_41_239 vccd1 vssd1 vccd1 vssd1 sky130_ef_sc_hd__decap_40_12
XFILLER_34_280 vssd1 vssd1 vccd1 vccd1 sky130_fd_sc_hd__fill_4
XANTENNA__1426__A1 STOPWATCH_INST.clock_div.cycles\[7\] vssd1 vssd1 vccd1 vccd1 sky130_fd_sc_hd__diode_2
XFILLER_17_225 vccd1 vssd1 vccd1 vssd1 sky130_ef_sc_hd__decap_40_12
XFILLER_17_269 vssd1 vssd1 vccd1 vccd1 sky130_fd_sc_hd__fill_2
XFILLER_40_261 vssd1 vssd1 vccd1 vccd1 sky130_fd_sc_hd__fill_1
XTAP_TAPCELL_ROW_10_153 vssd1 vccd1 sky130_fd_sc_hd__tapvpwrvgnd_1
X_1440_ STOPWATCH_INST.clock_div.cycles\[7\] STOPWATCH_INST.clock_div.cycles\[8\]
+ _0656_ vssd1 vssd1 vccd1 vccd1 _0676_ sky130_fd_sc_hd__and3_1
X_1371_ _0607_ vssd1 vssd1 vccd1 vccd1 _0608_ sky130_fd_sc_hd__inv_2
XTAP_TAPCELL_ROW_33_267 vssd1 vccd1 sky130_fd_sc_hd__tapvpwrvgnd_1
Xclkbuf_3_2__f_clk clknet_0_clk vssd1 vssd1 vccd1 vccd1 clknet_3_2__leaf_clk sky130_fd_sc_hd__clkbuf_16
X_1638_ clknet_3_2__leaf_clk _0056_ net49 vssd1 vssd1 vccd1 vccd1 STOPWATCH_INST.clock_div.cycles\[31\]
+ sky130_fd_sc_hd__dfrtp_4
XANTENNA__0919__B1 STOPWATCH_INST.clock_div.cycles\[8\] vssd1 vssd1 vccd1 vccd1 sky130_fd_sc_hd__diode_2
X_1569_ clknet_3_0__leaf_clk STOPWATCH_INST.fsm_inst1.nextState\[1\] net44 vssd1 vssd1
+ vccd1 vccd1 STOPWATCH_INST.fsm_inst1.currentState\[1\] sky130_fd_sc_hd__dfrtp_4
XTAP_TAPCELL_ROW_24_223 vssd1 vccd1 sky130_fd_sc_hd__tapvpwrvgnd_1
XFILLER_13_53 vssd1 vssd1 vccd1 vccd1 sky130_fd_sc_hd__fill_2
Xfanout43 STOPWATCH_INST.bcd_num\[0\] vssd1 vssd1 vccd1 vccd1 net43 sky130_fd_sc_hd__clkbuf_2
Xfanout32 _0173_ vssd1 vssd1 vccd1 vccd1 net32 sky130_fd_sc_hd__clkbuf_4
XFILLER_1_121 vccd1 vssd1 vccd1 vssd1 sky130_ef_sc_hd__decap_40_12
XFILLER_1_165 vssd1 vssd1 vccd1 vccd1 sky130_fd_sc_hd__fill_2
X_0940_ STOPWATCH_INST.clock_div.cycles\[1\] STOPWATCH_INST.clock_div.cycles\[2\]
+ _0175_ STOPWATCH_INST.clock_div.cycles\[3\] vssd1 vssd1 vccd1 vccd1 _0181_ sky130_fd_sc_hd__a31o_1
XFILLER_13_272 vssd1 vssd1 vccd1 vccd1 sky130_fd_sc_hd__fill_2
XFILLER_13_294 vssd1 vssd1 vccd1 vccd1 sky130_fd_sc_hd__fill_4
X_0871_ _0133_ _0123_ _0132_ vssd1 vssd1 vccd1 vccd1 _0005_ sky130_fd_sc_hd__and3b_1
X_1354_ _0531_ _0588_ vssd1 vssd1 vccd1 vccd1 _0591_ sky130_fd_sc_hd__xnor2_4
X_1285_ _0519_ _0521_ _0507_ vssd1 vssd1 vccd1 vccd1 _0522_ sky130_fd_sc_hd__a21o_1
X_1423_ STOPWATCH_INST.clock_div.cycles\[19\] STOPWATCH_INST.clock_div.cycles\[21\]
+ STOPWATCH_INST.clock_div.cycles\[16\] STOPWATCH_INST.clock_div.cycles\[18\] vssd1
+ vssd1 vccd1 vccd1 _0660_ sky130_fd_sc_hd__and4b_1
XTAP_TAPCELL_ROW_21_204 vssd1 vccd1 sky130_fd_sc_hd__tapvpwrvgnd_1
XFILLER_1_9 vccd1 vssd1 vccd1 vssd1 sky130_ef_sc_hd__decap_40_12
XFILLER_46_139 vssd1 vssd1 vccd1 vccd1 sky130_fd_sc_hd__fill_1
XFILLER_24_85 vccd1 vssd1 vccd1 vssd1 sky130_ef_sc_hd__decap_40_12
XFILLER_6_257 vssd1 vssd1 vccd1 vccd1 sky130_fd_sc_hd__fill_1
XFILLER_10_253 vccd1 vssd1 vccd1 vssd1 sky130_ef_sc_hd__decap_40_12
XFILLER_27_8 vssd1 vssd1 vccd1 vccd1 sky130_fd_sc_hd__fill_1
XFILLER_45_161 vssd1 vssd1 vccd1 vccd1 sky130_fd_sc_hd__fill_4
X_1070_ net24 net27 _0254_ vssd1 vssd1 vccd1 vccd1 _0307_ sky130_fd_sc_hd__a21oi_1
XFILLER_1_78 vccd1 vssd1 vccd1 vssd1 sky130_ef_sc_hd__decap_40_12
X_0854_ _0118_ _0119_ _0120_ _0121_ vssd1 vssd1 vccd1 vccd1 _0122_ sky130_fd_sc_hd__or4_4
X_0923_ STOPWATCH_INST.clock_div.cycles\[16\] STOPWATCH_INST.clock_div.cycles\[18\]
+ net130 vssd1 vssd1 vccd1 vccd1 _0167_ sky130_fd_sc_hd__or3b_1
X_0785_ STOPWATCH_INST.clock_div.cycles\[17\] vssd1 vssd1 vccd1 vccd1 _0063_ sky130_fd_sc_hd__inv_2
XANTENNA__1547__B1 net38 vssd1 vssd1 vccd1 vccd1 sky130_fd_sc_hd__diode_2
X_1406_ _0577_ _0635_ _0593_ vssd1 vssd1 vccd1 vccd1 _0643_ sky130_fd_sc_hd__o21ai_4
X_1337_ _0504_ net17 _0573_ _0505_ _0488_ vssd1 vssd1 vccd1 vccd1 _0574_ sky130_fd_sc_hd__a32o_2
X_1268_ _0433_ _0487_ vssd1 vssd1 vccd1 vccd1 _0505_ sky130_fd_sc_hd__nand2_1
XFILLER_43_109 vssd1 vssd1 vccd1 vccd1 sky130_fd_sc_hd__fill_2
X_1199_ _0391_ net151 vssd1 vssd1 vccd1 vccd1 _0436_ sky130_fd_sc_hd__nand2_1
XFILLER_35_40 vssd1 vssd1 vccd1 vccd1 sky130_fd_sc_hd__fill_1
XANTENNA__1437__A STOPWATCH_INST.clock_div.cycles\[7\] vssd1 vssd1 vccd1 vccd1 sky130_fd_sc_hd__diode_2
X_1122_ _0320_ _0325_ vssd1 vssd1 vccd1 vccd1 _0359_ sky130_fd_sc_hd__nand2b_1
X_1053_ STOPWATCH_INST.clock_div.cycles\[25\] _0289_ vssd1 vssd1 vccd1 vccd1 _0290_
+ sky130_fd_sc_hd__xnor2_2
XFILLER_33_153 vccd1 vssd1 vccd1 vssd1 sky130_ef_sc_hd__decap_40_12
XFILLER_25_109 vssd1 vssd1 vccd1 vccd1 sky130_fd_sc_hd__fill_2
X_0837_ STOPWATCH_INST.bcd_num\[5\] STOPWATCH_INST.bcd_num\[4\] vssd1 vssd1 vccd1
+ vccd1 _0107_ sky130_fd_sc_hd__nand2_1
X_0906_ _0152_ net198 vssd1 vssd1 vccd1 vccd1 _0021_ sky130_fd_sc_hd__nor2_1
XFILLER_24_197 vccd1 vssd1 vccd1 vssd1 sky130_ef_sc_hd__decap_40_12
XFILLER_46_61 vssd1 vssd1 vccd1 vccd1 sky130_fd_sc_hd__fill_2
XFILLER_15_186 vssd1 vssd1 vccd1 vccd1 sky130_fd_sc_hd__fill_4
XFILLER_7_55 vssd1 vssd1 vccd1 vccd1 sky130_fd_sc_hd__fill_1
X_1105_ _0271_ _0341_ vssd1 vssd1 vccd1 vccd1 _0342_ sky130_fd_sc_hd__xnor2_2
X_1036_ _0245_ _0247_ _0214_ vssd1 vssd1 vccd1 vccd1 _0273_ sky130_fd_sc_hd__a21oi_2
XTAP_TAPCELL_ROW_16_181 vssd1 vccd1 sky130_fd_sc_hd__tapvpwrvgnd_1
XFILLER_44_215 vssd1 vssd1 vccd1 vccd1 sky130_fd_sc_hd__fill_2
XTAP_TAPCELL_ROW_39_295 vssd1 vccd1 sky130_fd_sc_hd__tapvpwrvgnd_1
XFILLER_29_278 vssd1 vssd1 vccd1 vccd1 sky130_fd_sc_hd__fill_2
XFILLER_16_75 vssd1 vssd1 vccd1 vccd1 sky130_fd_sc_hd__fill_1
XFILLER_12_145 vssd1 vssd1 vccd1 vccd1 sky130_fd_sc_hd__fill_4
Xhold105 STOPWATCH_INST.bcd_num\[7\] vssd1 vssd1 vccd1 vccd1 net213 sky130_fd_sc_hd__dlygate4sd3_1
XFILLER_7_193 vssd1 vssd1 vccd1 vccd1 sky130_fd_sc_hd__fill_4
X_1585_ clknet_3_1__leaf_clk _0003_ net45 vssd1 vssd1 vccd1 vccd1 STOPWATCH_INST.bcd_num\[2\]
+ sky130_fd_sc_hd__dfrtp_2
X_1019_ _0225_ _0247_ vssd1 vssd1 vccd1 vccd1 _0256_ sky130_fd_sc_hd__nor2_2
XFILLER_26_259 vssd1 vssd1 vccd1 vccd1 sky130_fd_sc_hd__fill_4
XFILLER_26_237 vssd1 vssd1 vccd1 vccd1 sky130_fd_sc_hd__fill_1
XANTENNA__1360__A STOPWATCH_INST.clock_div.cycles\[7\] vssd1 vssd1 vccd1 vccd1 sky130_fd_sc_hd__diode_2
XANTENNA__1426__A2 _0060_ vssd1 vssd1 vccd1 vccd1 sky130_fd_sc_hd__diode_2
XFILLER_17_215 vssd1 vssd1 vccd1 vccd1 sky130_fd_sc_hd__fill_2
XFILLER_17_237 vssd1 vssd1 vccd1 vccd1 sky130_fd_sc_hd__fill_8
XFILLER_40_251 vssd1 vssd1 vccd1 vccd1 sky130_fd_sc_hd__fill_1
XFILLER_40_295 vssd1 vssd1 vccd1 vccd1 sky130_fd_sc_hd__fill_1
XFILLER_4_56 vssd1 vssd1 vccd1 vccd1 sky130_fd_sc_hd__fill_1
X_1370_ _0599_ _0598_ _0602_ _0606_ vssd1 vssd1 vccd1 vccd1 _0607_ sky130_fd_sc_hd__a31o_4
XTAP_TAPCELL_ROW_33_268 vssd1 vccd1 sky130_fd_sc_hd__tapvpwrvgnd_1
XFILLER_31_262 vssd1 vssd1 vccd1 vccd1 sky130_fd_sc_hd__fill_2
X_1637_ clknet_3_2__leaf_clk _0055_ net49 vssd1 vssd1 vccd1 vccd1 STOPWATCH_INST.clock_div.cycles\[30\]
+ sky130_fd_sc_hd__dfrtp_4
XANTENNA__0919__A1 STOPWATCH_INST.clock_div.cycles\[7\] vssd1 vssd1 vccd1 vccd1 sky130_fd_sc_hd__diode_2
XANTENNA__1630__RESET_B net47 vssd1 vssd1 vccd1 vccd1 sky130_fd_sc_hd__diode_2
X_1568_ clknet_3_3__leaf_clk STOPWATCH_INST.fsm_inst1.nextState\[0\] net44 vssd1 vssd1
+ vccd1 vccd1 STOPWATCH_INST.fsm_inst1.currentState\[0\] sky130_fd_sc_hd__dfrtp_4
X_1499_ _0724_ _0725_ net31 vssd1 vssd1 vccd1 vccd1 _0726_ sky130_fd_sc_hd__o21ai_1
Xfanout22 net23 vssd1 vssd1 vccd1 vccd1 net22 sky130_fd_sc_hd__buf_8
Xfanout33 _0673_ vssd1 vssd1 vccd1 vccd1 net33 sky130_fd_sc_hd__clkbuf_4
Xfanout44 net45 vssd1 vssd1 vccd1 vccd1 net44 sky130_fd_sc_hd__clkbuf_4
XFILLER_22_273 vssd1 vssd1 vccd1 vccd1 sky130_fd_sc_hd__fill_2
XFILLER_1_111 vssd1 vssd1 vccd1 vccd1 sky130_fd_sc_hd__fill_1
XFILLER_1_133 vssd1 vssd1 vccd1 vccd1 sky130_fd_sc_hd__fill_8
XFILLER_1_177 vssd1 vssd1 vccd1 vccd1 sky130_fd_sc_hd__fill_2
XFILLER_8_3 vssd1 vssd1 vccd1 vccd1 sky130_fd_sc_hd__fill_8
XTAP_TAPCELL_ROW_30_249 vssd1 vccd1 sky130_fd_sc_hd__tapvpwrvgnd_1
X_0870_ STOPWATCH_INST.bcd_num\[4\] _0131_ vssd1 vssd1 vccd1 vccd1 _0133_ sky130_fd_sc_hd__and2_1
XANTENNA__1271__B1 net42 vssd1 vssd1 vccd1 vccd1 sky130_fd_sc_hd__diode_2
X_1422_ net28 net117 _0658_ _0068_ vssd1 vssd1 vccd1 vccd1 _0659_ sky130_fd_sc_hd__o211a_1
X_1284_ _0439_ _0498_ vssd1 vssd1 vccd1 vccd1 _0521_ sky130_fd_sc_hd__and2b_1
X_1353_ _0587_ _0568_ _0589_ vssd1 vssd1 vccd1 vccd1 _0590_ sky130_fd_sc_hd__o21ai_4
X_0999_ STOPWATCH_INST.clock_div.cycles\[25\] _0235_ vssd1 vssd1 vccd1 vccd1 _0236_
+ sky130_fd_sc_hd__nand2b_1
XTAP_TAPCELL_ROW_21_205 vssd1 vccd1 sky130_fd_sc_hd__tapvpwrvgnd_1
XANTENNA__1317__A1 STOPWATCH_INST.clock_div.cycles\[8\] vssd1 vssd1 vccd1 vccd1 sky130_fd_sc_hd__diode_2
XTAP_TAPCELL_ROW_44_319 vssd1 vccd1 sky130_fd_sc_hd__tapvpwrvgnd_1
XFILLER_39_181 vccd1 vssd1 vccd1 vssd1 sky130_ef_sc_hd__decap_40_12
XANTENNA_fanout48_A net49 vssd1 vssd1 vccd1 vccd1 sky130_fd_sc_hd__diode_2
XFILLER_24_97 vccd1 vssd1 vccd1 vssd1 sky130_ef_sc_hd__decap_40_12
XFILLER_40_85 vssd1 vssd1 vccd1 vccd1 sky130_fd_sc_hd__fill_4
XFILLER_10_265 vccd1 vssd1 vccd1 vssd1 sky130_ef_sc_hd__decap_40_12
XFILLER_45_140 vssd1 vssd1 vccd1 vccd1 sky130_fd_sc_hd__fill_4
X_0922_ STOPWATCH_INST.clock_div.cycles\[22\] net39 STOPWATCH_INST.clock_div.cycles\[23\]
+ STOPWATCH_INST.clock_div.cycles\[20\] vssd1 vssd1 vccd1 vccd1 _0166_ sky130_fd_sc_hd__or4bb_4
X_0853_ STOPWATCH_INST.digit_scanner.period_counter\[5\] STOPWATCH_INST.digit_scanner.period_counter\[4\]
+ STOPWATCH_INST.digit_scanner.period_counter\[9\] STOPWATCH_INST.digit_scanner.period_counter\[8\]
+ vssd1 vssd1 vccd1 vccd1 _0121_ sky130_fd_sc_hd__or4bb_1
X_0784_ STOPWATCH_INST.clock_div.cycles\[12\] vssd1 vssd1 vccd1 vccd1 _0062_ sky130_fd_sc_hd__inv_2
X_1405_ _0641_ vssd1 vssd1 vccd1 vccd1 _0642_ sky130_fd_sc_hd__inv_2
XANTENNA__1547__A1 net32 vssd1 vssd1 vccd1 vccd1 sky130_fd_sc_hd__diode_2
X_1198_ _0430_ _0434_ vssd1 vssd1 vccd1 vccd1 _0435_ sky130_fd_sc_hd__nor2_1
Xinput1 gpio_in[0] vssd1 vssd1 vccd1 vccd1 net1 sky130_fd_sc_hd__clkbuf_1
X_1267_ _0487_ _0501_ _0503_ vssd1 vssd1 vccd1 vccd1 _0504_ sky130_fd_sc_hd__and3_1
X_1336_ _0519_ _0521_ _0498_ _0500_ vssd1 vssd1 vccd1 vccd1 _0573_ sky130_fd_sc_hd__o2bb2a_1
XFILLER_42_121 vssd1 vssd1 vccd1 vccd1 sky130_fd_sc_hd__fill_1
XFILLER_35_30 vssd1 vssd1 vccd1 vccd1 sky130_fd_sc_hd__fill_1
XFILLER_27_195 vssd1 vssd1 vccd1 vccd1 sky130_fd_sc_hd__fill_4
XFILLER_27_184 vssd1 vssd1 vccd1 vccd1 sky130_fd_sc_hd__fill_2
XTAP_TAPCELL_ROW_40_300 vssd1 vccd1 sky130_fd_sc_hd__tapvpwrvgnd_1
XFILLER_2_250 vssd1 vssd1 vccd1 vccd1 sky130_fd_sc_hd__fill_2
X_1121_ _0353_ _0357_ _0325_ vssd1 vssd1 vccd1 vccd1 _0358_ sky130_fd_sc_hd__a21oi_1
X_1052_ _0235_ _0256_ _0233_ vssd1 vssd1 vccd1 vccd1 _0289_ sky130_fd_sc_hd__a21boi_1
XFILLER_33_187 vssd1 vssd1 vccd1 vccd1 sky130_fd_sc_hd__fill_1
XFILLER_33_165 vssd1 vssd1 vccd1 vccd1 sky130_fd_sc_hd__fill_2
XFILLER_18_195 vssd1 vssd1 vccd1 vccd1 sky130_fd_sc_hd__fill_1
X_0905_ STOPWATCH_INST.digit_scanner.period_counter\[11\] _0150_ net197 vssd1 vssd1
+ vccd1 vccd1 _0153_ sky130_fd_sc_hd__a21oi_1
X_0836_ _0104_ _0106_ vssd1 vssd1 vccd1 vccd1 net8 sky130_fd_sc_hd__or2_1
XFILLER_0_209 vccd1 vssd1 vccd1 vssd1 sky130_ef_sc_hd__decap_40_12
X_1319_ _0549_ _0554_ vssd1 vssd1 vccd1 vccd1 _0556_ sky130_fd_sc_hd__and2_1
XFILLER_24_121 vssd1 vssd1 vccd1 vccd1 sky130_fd_sc_hd__fill_4
XANTENNA__1273__A net42 vssd1 vssd1 vccd1 vccd1 sky130_fd_sc_hd__diode_2
XFILLER_7_23 vssd1 vssd1 vccd1 vccd1 sky130_fd_sc_hd__fill_8
XFILLER_23_3 vssd1 vssd1 vccd1 vccd1 sky130_fd_sc_hd__fill_2
X_1104_ net25 net26 _0277_ vssd1 vssd1 vccd1 vccd1 _0341_ sky130_fd_sc_hd__a21oi_1
X_1035_ _0219_ _0262_ vssd1 vssd1 vccd1 vccd1 _0272_ sky130_fd_sc_hd__xnor2_2
XTAP_TAPCELL_ROW_16_182 vssd1 vccd1 sky130_fd_sc_hd__tapvpwrvgnd_1
XFILLER_21_157 vssd1 vssd1 vccd1 vccd1 sky130_fd_sc_hd__fill_2
X_0819_ _0082_ _0083_ _0092_ STOPWATCH_INST.digit_scanner.ctrl vssd1 vssd1 vccd1 vccd1
+ _0093_ sky130_fd_sc_hd__o211a_1
XTAP_TAPCELL_ROW_8_139 vssd1 vccd1 sky130_fd_sc_hd__tapvpwrvgnd_1
XFILLER_29_235 vccd1 vssd1 vccd1 vssd1 sky130_ef_sc_hd__decap_40_12
XFILLER_29_202 vssd1 vssd1 vccd1 vccd1 sky130_fd_sc_hd__fill_2
XTAP_TAPCELL_ROW_39_296 vssd1 vccd1 sky130_fd_sc_hd__tapvpwrvgnd_1
XFILLER_8_106 vccd1 vssd1 vccd1 vssd1 sky130_ef_sc_hd__decap_40_12
XFILLER_12_179 vccd1 vssd1 vccd1 vssd1 sky130_ef_sc_hd__decap_40_12
Xhold106 STOPWATCH_INST.clock_div.cycles\[5\] vssd1 vssd1 vccd1 vccd1 net214 sky130_fd_sc_hd__dlygate4sd3_1
XPHY_EDGE_ROW_9_Right_9 vssd1 vssd1 vccd1 vccd1 sky130_fd_sc_hd__decap_3
X_1584_ clknet_3_0__leaf_clk _0002_ net45 vssd1 vssd1 vccd1 vccd1 STOPWATCH_INST.bcd_num\[1\]
+ sky130_fd_sc_hd__dfrtp_4
X_1018_ _0245_ _0247_ _0206_ _0222_ vssd1 vssd1 vccd1 vccd1 _0255_ sky130_fd_sc_hd__o2bb2a_2
XTAP_TAPCELL_ROW_4_120 vssd1 vccd1 sky130_fd_sc_hd__tapvpwrvgnd_1
XFILLER_43_52 vssd1 vssd1 vccd1 vccd1 sky130_fd_sc_hd__fill_1
XFILLER_43_41 vssd1 vssd1 vccd1 vccd1 sky130_fd_sc_hd__fill_4
XFILLER_25_293 vssd1 vssd1 vccd1 vccd1 sky130_fd_sc_hd__fill_4
XFILLER_4_175 vssd1 vssd1 vccd1 vccd1 sky130_fd_sc_hd__fill_2
X_1636_ clknet_3_2__leaf_clk _0054_ net49 vssd1 vssd1 vccd1 vccd1 STOPWATCH_INST.clock_div.cycles\[29\]
+ sky130_fd_sc_hd__dfrtp_4
X_1567_ _0059_ net37 net33 vssd1 vssd1 vccd1 vccd1 _0057_ sky130_fd_sc_hd__a21oi_1
XPHY_EDGE_ROW_18_Left_65 vssd1 vssd1 vccd1 vccd1 sky130_fd_sc_hd__decap_3
X_1498_ _0063_ _0719_ vssd1 vssd1 vccd1 vccd1 _0725_ sky130_fd_sc_hd__and2_1
Xfanout23 _0417_ vssd1 vssd1 vccd1 vccd1 net23 sky130_fd_sc_hd__buf_6
Xfanout45 net5 vssd1 vssd1 vccd1 vccd1 net45 sky130_fd_sc_hd__clkbuf_4
Xfanout34 _0673_ vssd1 vssd1 vccd1 vccd1 net34 sky130_fd_sc_hd__buf_2
XFILLER_13_55 vssd1 vssd1 vccd1 vccd1 sky130_fd_sc_hd__fill_1
XFILLER_13_88 vssd1 vssd1 vccd1 vccd1 sky130_fd_sc_hd__fill_1
XFILLER_22_296 vssd1 vssd1 vccd1 vccd1 sky130_fd_sc_hd__fill_2
XFILLER_1_167 vssd1 vssd1 vccd1 vccd1 sky130_fd_sc_hd__fill_1
XFILLER_38_85 vssd1 vssd1 vccd1 vccd1 sky130_fd_sc_hd__fill_1
XFILLER_9_278 vssd1 vssd1 vccd1 vccd1 sky130_fd_sc_hd__fill_2
XFILLER_13_274 vssd1 vssd1 vccd1 vccd1 sky130_fd_sc_hd__fill_1
X_1421_ net28 _0657_ vssd1 vssd1 vccd1 vccd1 _0658_ sky130_fd_sc_hd__nand2_1
XANTENNA__1456__A net42 vssd1 vssd1 vccd1 vccd1 sky130_fd_sc_hd__diode_2
X_1352_ _0529_ _0565_ vssd1 vssd1 vccd1 vccd1 _0589_ sky130_fd_sc_hd__xor2_2
X_1283_ _0519_ vssd1 vssd1 vccd1 vccd1 _0520_ sky130_fd_sc_hd__inv_2
XTAP_TAPCELL_ROW_21_206 vssd1 vccd1 sky130_fd_sc_hd__tapvpwrvgnd_1
X_0998_ _0233_ _0234_ vssd1 vssd1 vccd1 vccd1 _0235_ sky130_fd_sc_hd__and2_2
X_1619_ clknet_3_7__leaf_clk _0037_ net49 vssd1 vssd1 vccd1 vccd1 STOPWATCH_INST.clock_div.cycles\[12\]
+ sky130_fd_sc_hd__dfrtp_2
XANTENNA_input2_A gpio_in[1] vssd1 vssd1 vccd1 vccd1 sky130_fd_sc_hd__diode_2
XFILLER_39_193 vssd1 vssd1 vccd1 vccd1 sky130_fd_sc_hd__fill_4
XFILLER_10_277 vccd1 vssd1 vccd1 vssd1 sky130_ef_sc_hd__decap_40_12
XFILLER_24_43 vccd1 vssd1 vccd1 vssd1 sky130_ef_sc_hd__decap_40_12
XFILLER_40_75 vssd1 vssd1 vccd1 vccd1 sky130_fd_sc_hd__fill_1
XFILLER_40_31 vccd1 vssd1 vccd1 vssd1 sky130_ef_sc_hd__decap_40_12
X_0921_ STOPWATCH_INST.clock_div.cycles\[12\] _0164_ STOPWATCH_INST.clock_div.cycles\[14\]
+ net41 vssd1 vssd1 vccd1 vccd1 _0165_ sky130_fd_sc_hd__a211o_1
X_0783_ STOPWATCH_INST.clock_div.cycles\[11\] vssd1 vssd1 vccd1 vccd1 _0061_ sky130_fd_sc_hd__inv_2
X_0852_ STOPWATCH_INST.digit_scanner.period_counter\[7\] STOPWATCH_INST.digit_scanner.period_counter\[6\]
+ STOPWATCH_INST.digit_scanner.period_counter\[11\] STOPWATCH_INST.digit_scanner.period_counter\[10\]
+ vssd1 vssd1 vccd1 vccd1 _0120_ sky130_fd_sc_hd__or4b_1
XFILLER_5_281 vssd1 vssd1 vccd1 vccd1 sky130_fd_sc_hd__fill_4
XANTENNA_clkbuf_3_0__f_clk_A clknet_0_clk vssd1 vssd1 vccd1 vccd1 sky130_fd_sc_hd__diode_2
X_1335_ _0560_ _0571_ vssd1 vssd1 vccd1 vccd1 _0572_ sky130_fd_sc_hd__or2_1
X_1404_ _0632_ _0621_ _0637_ _0639_ vssd1 vssd1 vccd1 vccd1 _0641_ sky130_fd_sc_hd__a211o_4
X_1197_ _0425_ _0407_ _0431_ vssd1 vssd1 vccd1 vccd1 _0434_ sky130_fd_sc_hd__or3b_4
X_1266_ _0444_ _0492_ vssd1 vssd1 vccd1 vccd1 _0503_ sky130_fd_sc_hd__xnor2_1
Xinput2 gpio_in[1] vssd1 vssd1 vccd1 vccd1 net2 sky130_fd_sc_hd__clkbuf_1
XFILLER_10_23 vssd1 vssd1 vccd1 vccd1 sky130_fd_sc_hd__fill_1
XANTENNA_input5_X net5 vssd1 vssd1 vccd1 vccd1 sky130_fd_sc_hd__diode_2
XFILLER_19_87 vssd1 vssd1 vccd1 vccd1 sky130_fd_sc_hd__fill_8
XTAP_TAPCELL_ROW_40_301 vssd1 vccd1 sky130_fd_sc_hd__tapvpwrvgnd_1
X_1120_ _0354_ _0356_ vssd1 vssd1 vccd1 vccd1 _0357_ sky130_fd_sc_hd__nor2_1
X_1051_ _0287_ _0242_ vssd1 vssd1 vccd1 vccd1 _0288_ sky130_fd_sc_hd__xnor2_4
XFILLER_33_111 vssd1 vssd1 vccd1 vccd1 sky130_fd_sc_hd__fill_1
XFILLER_18_185 vssd1 vssd1 vccd1 vccd1 sky130_fd_sc_hd__fill_2
XFILLER_33_177 vssd1 vssd1 vccd1 vccd1 sky130_fd_sc_hd__fill_1
X_0904_ STOPWATCH_INST.digit_scanner.period_counter\[11\] STOPWATCH_INST.digit_scanner.period_counter\[12\]
+ _0150_ vssd1 vssd1 vccd1 vccd1 _0152_ sky130_fd_sc_hd__and3_1
X_0835_ net43 _0087_ _0101_ STOPWATCH_INST.D0_AN_0 vssd1 vssd1 vccd1 vccd1 _0106_
+ sky130_fd_sc_hd__o211a_1
X_1318_ _0554_ vssd1 vssd1 vccd1 vccd1 _0555_ sky130_fd_sc_hd__inv_2
X_1249_ _0485_ vssd1 vssd1 vccd1 vccd1 _0486_ sky130_fd_sc_hd__inv_2
XFILLER_21_55 vssd1 vssd1 vccd1 vccd1 sky130_fd_sc_hd__fill_1
XFILLER_21_77 vssd1 vssd1 vccd1 vccd1 sky130_fd_sc_hd__fill_1
XFILLER_46_41 vccd1 vssd1 vccd1 vssd1 sky130_ef_sc_hd__decap_40_12
XPHY_EDGE_ROW_6_Left_53 vssd1 vssd1 vccd1 vccd1 sky130_fd_sc_hd__decap_3
XFILLER_15_111 vssd1 vssd1 vccd1 vccd1 sky130_fd_sc_hd__fill_1
XFILLER_15_166 vssd1 vssd1 vccd1 vccd1 sky130_fd_sc_hd__fill_2
XFILLER_7_57 vccd1 vssd1 vccd1 vssd1 sky130_ef_sc_hd__decap_40_12
XFILLER_7_35 vccd1 vssd1 vccd1 vssd1 sky130_ef_sc_hd__decap_40_12
XFILLER_16_3 vssd1 vssd1 vccd1 vccd1 sky130_fd_sc_hd__fill_2
X_1103_ _0336_ _0338_ vssd1 vssd1 vccd1 vccd1 _0340_ sky130_fd_sc_hd__nand2_1
X_1034_ _0269_ _0270_ vssd1 vssd1 vccd1 vccd1 _0271_ sky130_fd_sc_hd__nand2_1
XANTENNA__1624__RESET_B net47 vssd1 vssd1 vccd1 vccd1 sky130_fd_sc_hd__diode_2
XANTENNA__1358__B STOPWATCH_INST.clock_div.cycles\[8\] vssd1 vssd1 vccd1 vccd1 sky130_fd_sc_hd__diode_2
XTAP_TAPCELL_ROW_16_183 vssd1 vccd1 sky130_fd_sc_hd__tapvpwrvgnd_1
XFILLER_21_169 vccd1 vssd1 vccd1 vssd1 sky130_ef_sc_hd__decap_40_12
X_0818_ STOPWATCH_INST.bcd_num\[4\] _0082_ STOPWATCH_INST.bcd_num\[5\] vssd1 vssd1
+ vccd1 vccd1 _0092_ sky130_fd_sc_hd__or3b_1
XFILLER_29_225 vssd1 vssd1 vccd1 vccd1 sky130_fd_sc_hd__fill_2
XFILLER_29_214 vssd1 vssd1 vccd1 vccd1 sky130_fd_sc_hd__fill_2
XTAP_TAPCELL_ROW_39_297 vssd1 vccd1 sky130_fd_sc_hd__tapvpwrvgnd_1
XPHY_EDGE_ROW_32_Left_79 vssd1 vssd1 vccd1 vccd1 sky130_fd_sc_hd__decap_3
XFILLER_8_118 vccd1 vssd1 vccd1 vssd1 sky130_ef_sc_hd__decap_40_12
XFILLER_32_76 vssd1 vssd1 vccd1 vccd1 sky130_fd_sc_hd__fill_8
XFILLER_35_206 vccd1 vssd1 vccd1 vssd1 sky130_ef_sc_hd__decap_40_12
XTAP_TAPCELL_ROW_13_164 vssd1 vccd1 sky130_fd_sc_hd__tapvpwrvgnd_1
Xhold107 STOPWATCH_INST.digit_scanner.ctrl vssd1 vssd1 vccd1 vccd1 net215 sky130_fd_sc_hd__dlygate4sd3_1
X_1583_ clknet_3_0__leaf_clk _0001_ net44 vssd1 vssd1 vccd1 vccd1 STOPWATCH_INST.bcd_num\[0\]
+ sky130_fd_sc_hd__dfrtp_1
X_1017_ net41 net142 vssd1 vssd1 vccd1 vccd1 _0254_ sky130_fd_sc_hd__nor2_1
XFILLER_34_250 vssd1 vssd1 vccd1 vccd1 sky130_fd_sc_hd__fill_2
XTAP_TAPCELL_ROW_4_121 vssd1 vccd1 sky130_fd_sc_hd__tapvpwrvgnd_1
XFILLER_17_217 vssd1 vssd1 vccd1 vccd1 sky130_fd_sc_hd__fill_1
XTAP_TAPCELL_ROW_27_234 vssd1 vccd1 sky130_fd_sc_hd__tapvpwrvgnd_1
XFILLER_40_253 vssd1 vssd1 vccd1 vccd1 sky130_fd_sc_hd__fill_8
XFILLER_4_14 vssd1 vssd1 vccd1 vccd1 sky130_fd_sc_hd__fill_1
XFILLER_31_297 vssd1 vssd1 vccd1 vccd1 sky130_fd_sc_hd__fill_2
X_1566_ STOPWATCH_INST.clock_div.cycles\[31\] _0067_ net32 _0778_ vssd1 vssd1 vccd1
+ vccd1 _0056_ sky130_fd_sc_hd__a22o_1
X_1635_ clknet_3_2__leaf_clk _0053_ net49 vssd1 vssd1 vccd1 vccd1 STOPWATCH_INST.clock_div.cycles\[28\]
+ sky130_fd_sc_hd__dfrtp_2
X_1497_ _0063_ _0719_ vssd1 vssd1 vccd1 vccd1 _0724_ sky130_fd_sc_hd__nor2_1
Xfanout24 _0303_ vssd1 vssd1 vccd1 vccd1 net24 sky130_fd_sc_hd__buf_6
Xfanout46 net47 vssd1 vssd1 vccd1 vccd1 net46 sky130_fd_sc_hd__clkbuf_4
XPHY_EDGE_ROW_35_Left_82 vssd1 vssd1 vccd1 vccd1 sky130_fd_sc_hd__decap_3
X_1420_ _0656_ vssd1 vssd1 vccd1 vccd1 _0657_ sky130_fd_sc_hd__inv_2
X_1351_ _0526_ _0529_ net150 vssd1 vssd1 vccd1 vccd1 _0588_ sky130_fd_sc_hd__o21a_1
X_1282_ _0454_ _0514_ _0516_ _0518_ vssd1 vssd1 vccd1 vccd1 _0519_ sky130_fd_sc_hd__a31o_2
XTAP_TAPCELL_ROW_21_207 vssd1 vccd1 sky130_fd_sc_hd__tapvpwrvgnd_1
X_0997_ _0187_ _0193_ STOPWATCH_INST.clock_div.cycles\[24\] vssd1 vssd1 vccd1 vccd1
+ _0234_ sky130_fd_sc_hd__o21ai_1
X_1618_ clknet_3_7__leaf_clk _0036_ net49 vssd1 vssd1 vccd1 vccd1 STOPWATCH_INST.clock_div.cycles\[11\]
+ sky130_fd_sc_hd__dfrtp_2
X_1549_ STOPWATCH_INST.clock_div.cycles\[25\] STOPWATCH_INST.clock_div.cycles\[26\]
+ _0762_ vssd1 vssd1 vccd1 vccd1 _0767_ sky130_fd_sc_hd__and3_1
XFILLER_5_90 vccd1 vssd1 vccd1 vssd1 sky130_ef_sc_hd__decap_40_12
XFILLER_24_33 vssd1 vssd1 vccd1 vccd1 sky130_fd_sc_hd__fill_2
XFILLER_40_43 vssd1 vssd1 vccd1 vccd1 sky130_fd_sc_hd__fill_4
XFILLER_40_10 vssd1 vssd1 vccd1 vccd1 sky130_fd_sc_hd__fill_2
XFILLER_6_249 vssd1 vssd1 vccd1 vccd1 sky130_fd_sc_hd__fill_2
XFILLER_10_289 vssd1 vssd1 vccd1 vccd1 sky130_fd_sc_hd__fill_4
XFILLER_24_55 vssd1 vssd1 vccd1 vccd1 sky130_fd_sc_hd__fill_4
XFILLER_45_131 vssd1 vssd1 vccd1 vccd1 sky130_fd_sc_hd__fill_1
X_0920_ STOPWATCH_INST.clock_div.cycles\[9\] net42 _0163_ STOPWATCH_INST.clock_div.cycles\[11\]
+ vssd1 vssd1 vccd1 vccd1 _0164_ sky130_fd_sc_hd__a31o_1
X_0851_ STOPWATCH_INST.digit_scanner.period_counter\[12\] STOPWATCH_INST.digit_scanner.period_counter\[15\]
+ STOPWATCH_INST.digit_scanner.period_counter\[14\] STOPWATCH_INST.digit_scanner.period_counter\[13\]
+ vssd1 vssd1 vccd1 vccd1 _0119_ sky130_fd_sc_hd__or4b_1
X_0782_ STOPWATCH_INST.clock_div.cycles\[9\] vssd1 vssd1 vccd1 vccd1 _0060_ sky130_fd_sc_hd__inv_2
X_1403_ _0639_ vssd1 vssd1 vccd1 vccd1 _0640_ sky130_fd_sc_hd__inv_2
X_1334_ _0522_ net150 _0490_ vssd1 vssd1 vccd1 vccd1 _0571_ sky130_fd_sc_hd__a21oi_1
XPHY_EDGE_ROW_18_Right_18 vssd1 vssd1 vccd1 vccd1 sky130_fd_sc_hd__decap_3
X_1265_ _0487_ _0501_ vssd1 vssd1 vccd1 vccd1 _0502_ sky130_fd_sc_hd__nand2_1
XPHY_EDGE_ROW_27_Right_27 vssd1 vssd1 vccd1 vccd1 sky130_fd_sc_hd__decap_3
Xinput3 gpio_in[2] vssd1 vssd1 vccd1 vccd1 net3 sky130_fd_sc_hd__clkbuf_1
X_1196_ _0432_ vssd1 vssd1 vccd1 vccd1 _0433_ sky130_fd_sc_hd__inv_2
XPHY_EDGE_ROW_36_Right_36 vssd1 vssd1 vccd1 vccd1 sky130_fd_sc_hd__decap_3
XPHY_EDGE_ROW_45_Right_45 vssd1 vssd1 vccd1 vccd1 sky130_fd_sc_hd__decap_3
XTAP_TAPCELL_ROW_40_302 vssd1 vccd1 sky130_fd_sc_hd__tapvpwrvgnd_1
XFILLER_35_54 vssd1 vssd1 vccd1 vccd1 sky130_fd_sc_hd__fill_2
XFILLER_35_10 vssd1 vssd1 vccd1 vccd1 sky130_fd_sc_hd__fill_2
XFILLER_27_186 vssd1 vssd1 vccd1 vccd1 sky130_fd_sc_hd__fill_1
X_1050_ _0286_ net118 vssd1 vssd1 vccd1 vccd1 _0287_ sky130_fd_sc_hd__nor2_4
XFILLER_33_134 vssd1 vssd1 vccd1 vccd1 sky130_fd_sc_hd__fill_1
XFILLER_18_153 vccd1 vssd1 vccd1 vssd1 sky130_ef_sc_hd__decap_40_12
XFILLER_18_197 vssd1 vssd1 vccd1 vccd1 sky130_fd_sc_hd__fill_2
XFILLER_33_167 vssd1 vssd1 vccd1 vccd1 sky130_fd_sc_hd__fill_1
X_0834_ _0086_ _0089_ vssd1 vssd1 vccd1 vccd1 _0105_ sky130_fd_sc_hd__nand2_1
X_0903_ net205 _0150_ vssd1 vssd1 vccd1 vccd1 _0020_ sky130_fd_sc_hd__xor2_1
X_1248_ _0444_ _0484_ vssd1 vssd1 vccd1 vccd1 _0485_ sky130_fd_sc_hd__and2_1
X_1317_ STOPWATCH_INST.clock_div.cycles\[8\] _0550_ _0551_ _0552_ vssd1 vssd1 vccd1
+ vccd1 _0554_ sky130_fd_sc_hd__o211a_1
X_1179_ _0380_ _0386_ vssd1 vssd1 vccd1 vccd1 _0416_ sky130_fd_sc_hd__nor2_1
XFILLER_46_53 vssd1 vssd1 vccd1 vccd1 sky130_fd_sc_hd__fill_2
XFILLER_46_20 vssd1 vssd1 vccd1 vccd1 sky130_fd_sc_hd__fill_8
Xmax_cap21 _0458_ vssd1 vssd1 vccd1 vccd1 net21 sky130_fd_sc_hd__buf_1
XFILLER_15_101 vssd1 vssd1 vccd1 vccd1 sky130_fd_sc_hd__fill_8
XFILLER_30_137 vssd1 vssd1 vccd1 vccd1 sky130_fd_sc_hd__fill_2
XFILLER_7_47 vssd1 vssd1 vccd1 vccd1 sky130_fd_sc_hd__fill_8
X_1102_ _0338_ vssd1 vssd1 vccd1 vccd1 _0339_ sky130_fd_sc_hd__inv_2
XFILLER_38_204 vssd1 vssd1 vccd1 vccd1 sky130_fd_sc_hd__fill_1
XFILLER_30_6 vccd1 vssd1 vccd1 vssd1 sky130_ef_sc_hd__decap_40_12
XFILLER_46_281 vssd1 vssd1 vccd1 vccd1 sky130_fd_sc_hd__fill_8
X_1033_ net35 _0213_ _0248_ vssd1 vssd1 vccd1 vccd1 _0270_ sky130_fd_sc_hd__or3_4
XFILLER_21_126 vssd1 vssd1 vccd1 vccd1 sky130_fd_sc_hd__fill_2
X_0817_ _0085_ _0091_ vssd1 vssd1 vccd1 vccd1 net13 sky130_fd_sc_hd__and2b_1
XFILLER_21_159 vssd1 vssd1 vccd1 vccd1 sky130_fd_sc_hd__fill_1
XTAP_TAPCELL_ROW_39_298 vssd1 vccd1 sky130_fd_sc_hd__tapvpwrvgnd_1
XFILLER_29_204 vssd1 vssd1 vccd1 vccd1 sky130_fd_sc_hd__fill_1
XPHY_EDGE_ROW_0_Right_0 vssd1 vssd1 vccd1 vccd1 sky130_fd_sc_hd__decap_3
XFILLER_43_273 vssd1 vssd1 vccd1 vccd1 sky130_fd_sc_hd__fill_4
XFILLER_35_218 vssd1 vssd1 vccd1 vccd1 sky130_fd_sc_hd__fill_4
XFILLER_28_281 vccd1 vssd1 vccd1 vssd1 sky130_ef_sc_hd__decap_40_12
Xhold108 STOPWATCH_INST.clock_div.cycles\[26\] vssd1 vssd1 vccd1 vccd1 net216 sky130_fd_sc_hd__dlygate4sd3_1
XTAP_TAPCELL_ROW_13_165 vssd1 vccd1 sky130_fd_sc_hd__tapvpwrvgnd_1
X_1582_ clknet_3_1__leaf_clk _0000_ vssd1 vssd1 vccd1 vccd1 STOPWATCH_INST.digit_scanner.ctrl
+ sky130_fd_sc_hd__dfxtp_2
XFILLER_19_270 vssd1 vssd1 vccd1 vccd1 sky130_fd_sc_hd__fill_1
X_1016_ net141 STOPWATCH_INST.clock_div.cycles\[14\] vssd1 vssd1 vccd1 vccd1 _0253_
+ sky130_fd_sc_hd__xnor2_4
XTAP_TAPCELL_ROW_36_279 vssd1 vccd1 sky130_fd_sc_hd__tapvpwrvgnd_1
XFILLER_34_284 vssd1 vssd1 vccd1 vccd1 sky130_fd_sc_hd__fill_1
XTAP_TAPCELL_ROW_4_122 vssd1 vccd1 sky130_fd_sc_hd__tapvpwrvgnd_1
XFILLER_27_55 vssd1 vssd1 vccd1 vccd1 sky130_fd_sc_hd__fill_1
XTAP_TAPCELL_ROW_27_235 vssd1 vccd1 sky130_fd_sc_hd__tapvpwrvgnd_1
XFILLER_40_221 vccd1 vssd1 vccd1 vssd1 sky130_ef_sc_hd__decap_40_12
Xclone20 _0534_ vssd1 vssd1 vccd1 vccd1 net128 sky130_fd_sc_hd__clkbuf_1
Xclone42 net18 vssd1 vssd1 vccd1 vccd1 net150 sky130_fd_sc_hd__clkbuf_1
XFILLER_4_177 vssd1 vssd1 vccd1 vccd1 sky130_fd_sc_hd__fill_1
XFILLER_4_26 vssd1 vssd1 vccd1 vccd1 sky130_fd_sc_hd__fill_2
XFILLER_31_254 vssd1 vssd1 vccd1 vccd1 sky130_fd_sc_hd__fill_8
XFILLER_16_295 vssd1 vssd1 vccd1 vccd1 sky130_fd_sc_hd__fill_4
X_1634_ clknet_3_2__leaf_clk _0052_ net48 vssd1 vssd1 vccd1 vccd1 STOPWATCH_INST.clock_div.cycles\[27\]
+ sky130_fd_sc_hd__dfrtp_4
X_1565_ STOPWATCH_INST.clock_div.cycles\[31\] _0776_ _0777_ STOPWATCH_INST.clock_div.cycles\[30\]
+ vssd1 vssd1 vccd1 vccd1 _0778_ sky130_fd_sc_hd__a22o_1
X_1496_ _0722_ net30 _0721_ vssd1 vssd1 vccd1 vccd1 _0723_ sky130_fd_sc_hd__or3b_4
Xfanout25 _0303_ vssd1 vssd1 vccd1 vccd1 net25 sky130_fd_sc_hd__buf_6
XTAP_TAPCELL_ROW_32_260 vssd1 vccd1 sky130_fd_sc_hd__tapvpwrvgnd_1
Xfanout47 net5 vssd1 vssd1 vccd1 vccd1 net47 sky130_fd_sc_hd__buf_2
Xfanout36 net37 vssd1 vssd1 vccd1 vccd1 net36 sky130_fd_sc_hd__buf_2
XFILLER_13_57 vssd1 vssd1 vccd1 vccd1 sky130_fd_sc_hd__fill_4
XFILLER_13_68 vccd1 vssd1 vccd1 vssd1 sky130_ef_sc_hd__decap_40_12
XFILLER_22_243 vssd1 vssd1 vccd1 vccd1 sky130_fd_sc_hd__fill_2
XFILLER_22_298 vssd1 vssd1 vccd1 vccd1 sky130_fd_sc_hd__fill_1
XFILLER_38_54 vssd1 vssd1 vccd1 vccd1 sky130_fd_sc_hd__fill_1
XFILLER_1_169 vssd1 vssd1 vccd1 vccd1 sky130_fd_sc_hd__fill_8
XFILLER_13_221 vssd1 vssd1 vccd1 vccd1 sky130_fd_sc_hd__fill_2
XFILLER_13_298 vssd1 vssd1 vccd1 vccd1 sky130_fd_sc_hd__fill_1
X_1350_ _0586_ _0558_ _0546_ _0584_ _0577_ vssd1 vssd1 vccd1 vccd1 _0587_ sky130_fd_sc_hd__o32ai_4
X_1281_ _0516_ _0517_ _0482_ vssd1 vssd1 vccd1 vccd1 _0518_ sky130_fd_sc_hd__a21bo_1
XTAP_TAPCELL_ROW_46_330 vssd1 vccd1 sky130_fd_sc_hd__tapvpwrvgnd_1
X_0996_ STOPWATCH_INST.clock_div.cycles\[24\] _0160_ _0187_ _0191_ vssd1 vssd1 vccd1
+ vccd1 _0233_ sky130_fd_sc_hd__or4_1
XTAP_TAPCELL_ROW_21_208 vssd1 vccd1 sky130_fd_sc_hd__tapvpwrvgnd_1
X_1617_ clknet_3_6__leaf_clk _0035_ net47 vssd1 vssd1 vccd1 vccd1 STOPWATCH_INST.clock_div.cycles\[10\]
+ sky130_fd_sc_hd__dfrtp_1
XFILLER_39_162 vssd1 vssd1 vccd1 vccd1 sky130_fd_sc_hd__fill_4
X_1479_ net41 _0698_ STOPWATCH_INST.clock_div.cycles\[14\] vssd1 vssd1 vccd1 vccd1
+ _0709_ sky130_fd_sc_hd__a21oi_1
XANTENNA__1486__B1 net32 vssd1 vssd1 vccd1 vccd1 sky130_fd_sc_hd__diode_2
X_1548_ STOPWATCH_INST.clock_div.cycles\[25\] _0762_ STOPWATCH_INST.clock_div.cycles\[26\]
+ vssd1 vssd1 vccd1 vccd1 _0766_ sky130_fd_sc_hd__a21oi_1
XFILLER_40_55 vccd1 vssd1 vccd1 vssd1 sky130_ef_sc_hd__decap_40_12
XFILLER_45_165 vssd1 vssd1 vccd1 vccd1 sky130_fd_sc_hd__fill_2
X_0850_ _0117_ vssd1 vssd1 vccd1 vccd1 _0118_ sky130_fd_sc_hd__inv_2
X_0781_ STOPWATCH_INST.clock_div.second_tick vssd1 vssd1 vccd1 vccd1 _0059_ sky130_fd_sc_hd__inv_2
X_1402_ _0502_ _0638_ vssd1 vssd1 vccd1 vccd1 _0639_ sky130_fd_sc_hd__xor2_2
XANTENNA__1468__B1 net32 vssd1 vssd1 vccd1 vccd1 sky130_fd_sc_hd__diode_2
X_1333_ _0498_ _0538_ vssd1 vssd1 vccd1 vccd1 _0570_ sky130_fd_sc_hd__xor2_2
Xinput4 gpio_in[3] vssd1 vssd1 vccd1 vccd1 net4 sky130_fd_sc_hd__clkbuf_1
XANTENNA__1618__RESET_B net49 vssd1 vssd1 vccd1 vccd1 sky130_fd_sc_hd__diode_2
X_1264_ _0478_ _0485_ _0430_ vssd1 vssd1 vccd1 vccd1 _0501_ sky130_fd_sc_hd__o21ai_1
X_1195_ _0425_ _0431_ vssd1 vssd1 vccd1 vccd1 _0432_ sky130_fd_sc_hd__and2b_1
X_0979_ net40 _0215_ vssd1 vssd1 vccd1 vccd1 _0216_ sky130_fd_sc_hd__xnor2_2
XANTENNA_fanout46_A net47 vssd1 vssd1 vccd1 vccd1 sky130_fd_sc_hd__diode_2
XFILLER_27_121 vssd1 vssd1 vccd1 vccd1 sky130_fd_sc_hd__fill_1
XTAP_TAPCELL_ROW_40_303 vssd1 vccd1 sky130_fd_sc_hd__tapvpwrvgnd_1
XFILLER_2_253 vssd1 vssd1 vccd1 vccd1 sky130_fd_sc_hd__fill_2
XFILLER_33_113 vccd1 vssd1 vccd1 vssd1 sky130_ef_sc_hd__decap_40_12
XFILLER_18_165 vssd1 vssd1 vccd1 vccd1 sky130_fd_sc_hd__fill_1
XFILLER_18_187 vssd1 vssd1 vccd1 vccd1 sky130_fd_sc_hd__fill_1
X_0902_ _0122_ _0149_ _0151_ vssd1 vssd1 vccd1 vccd1 _0019_ sky130_fd_sc_hd__and3_1
X_0833_ STOPWATCH_INST.digit_scanner.ctrl _0092_ _0097_ _0103_ vssd1 vssd1 vccd1 vccd1
+ _0104_ sky130_fd_sc_hd__and4_1
X_1178_ net114 _0414_ vssd1 vssd1 vccd1 vccd1 _0415_ sky130_fd_sc_hd__nand2_1
X_1247_ _0419_ _0469_ _0443_ vssd1 vssd1 vccd1 vccd1 _0484_ sky130_fd_sc_hd__a21o_1
X_1316_ _0551_ _0552_ vssd1 vssd1 vccd1 vccd1 _0553_ sky130_fd_sc_hd__and2_1
XFILLER_21_35 vssd1 vssd1 vccd1 vccd1 sky130_fd_sc_hd__fill_1
XFILLER_21_57 vccd1 vssd1 vccd1 vssd1 sky130_ef_sc_hd__decap_40_12
XANTENNA_fanout49_X net49 vssd1 vssd1 vccd1 vccd1 sky130_fd_sc_hd__diode_2
XFILLER_30_149 vssd1 vssd1 vccd1 vccd1 sky130_fd_sc_hd__fill_2
XFILLER_23_190 vccd1 vssd1 vccd1 vssd1 sky130_ef_sc_hd__decap_40_12
X_1101_ _0267_ _0306_ _0332_ _0337_ vssd1 vssd1 vccd1 vccd1 _0338_ sky130_fd_sc_hd__o2bb2a_2
X_1032_ net35 _0212_ _0248_ _0211_ vssd1 vssd1 vccd1 vccd1 _0269_ sky130_fd_sc_hd__o31ai_2
XFILLER_38_238 vccd1 vssd1 vccd1 vssd1 sky130_ef_sc_hd__decap_40_12
X_0816_ _0086_ _0088_ _0089_ _0090_ STOPWATCH_INST.digit_scanner.ctrl vssd1 vssd1
+ vccd1 vccd1 _0091_ sky130_fd_sc_hd__a221o_1
XFILLER_29_227 vssd1 vssd1 vccd1 vccd1 sky130_fd_sc_hd__fill_1
XFILLER_29_216 vssd1 vssd1 vccd1 vccd1 sky130_fd_sc_hd__fill_1
XFILLER_12_149 vssd1 vssd1 vccd1 vccd1 sky130_fd_sc_hd__fill_1
XFILLER_20_193 vssd1 vssd1 vccd1 vccd1 sky130_fd_sc_hd__fill_2
XFILLER_43_296 vssd1 vssd1 vccd1 vccd1 sky130_fd_sc_hd__fill_2
XFILLER_28_293 vssd1 vssd1 vccd1 vccd1 sky130_fd_sc_hd__fill_4
XFILLER_28_260 vssd1 vssd1 vccd1 vccd1 sky130_fd_sc_hd__fill_2
Xhold109 STOPWATCH_INST.digit_scanner.period_counter\[8\] vssd1 vssd1 vccd1 vccd1
+ net217 sky130_fd_sc_hd__dlygate4sd3_1
XFILLER_7_197 vssd1 vssd1 vccd1 vccd1 sky130_fd_sc_hd__fill_1
XTAP_TAPCELL_ROW_13_166 vssd1 vccd1 sky130_fd_sc_hd__tapvpwrvgnd_1
X_1581_ clknet_3_3__leaf_clk net1 net44 vssd1 vssd1 vccd1 vccd1 STOPWATCH_INST.sync_one.sync_1
+ sky130_fd_sc_hd__dfrtp_1
X_1015_ _0199_ _0250_ vssd1 vssd1 vccd1 vccd1 _0252_ sky130_fd_sc_hd__xnor2_2
XFILLER_19_293 vssd1 vssd1 vccd1 vccd1 sky130_fd_sc_hd__fill_4
XTAP_TAPCELL_ROW_4_123 vssd1 vccd1 sky130_fd_sc_hd__tapvpwrvgnd_1
XFILLER_40_233 vccd1 vssd1 vccd1 vssd1 sky130_ef_sc_hd__decap_40_12
XTAP_TAPCELL_ROW_27_236 vssd1 vccd1 sky130_fd_sc_hd__tapvpwrvgnd_1
Xclone43 net23 vssd1 vssd1 vccd1 vccd1 net151 sky130_fd_sc_hd__clkbuf_1
XFILLER_4_134 vssd1 vssd1 vccd1 vccd1 sky130_fd_sc_hd__fill_4
XFILLER_16_241 vssd1 vssd1 vccd1 vccd1 sky130_fd_sc_hd__fill_2
X_1564_ STOPWATCH_INST.clock_div.cycles\[31\] _0774_ vssd1 vssd1 vccd1 vccd1 _0777_
+ sky130_fd_sc_hd__nor2_1
X_1633_ clknet_3_2__leaf_clk _0051_ net48 vssd1 vssd1 vccd1 vccd1 STOPWATCH_INST.clock_div.cycles\[26\]
+ sky130_fd_sc_hd__dfrtp_2
XTAP_TAPCELL_ROW_1_104 vssd1 vccd1 sky130_fd_sc_hd__tapvpwrvgnd_1
X_1495_ _0621_ _0629_ _0631_ net16 vssd1 vssd1 vccd1 vccd1 _0722_ sky130_fd_sc_hd__and4_1
Xfanout26 _0305_ vssd1 vssd1 vccd1 vccd1 net26 sky130_fd_sc_hd__buf_2
Xfanout15 _0655_ vssd1 vssd1 vccd1 vccd1 net15 sky130_fd_sc_hd__buf_4
Xfanout37 net38 vssd1 vssd1 vccd1 vccd1 net37 sky130_fd_sc_hd__buf_2
XFILLER_22_233 vssd1 vssd1 vccd1 vccd1 sky130_fd_sc_hd__fill_4
XTAP_TAPCELL_ROW_32_261 vssd1 vccd1 sky130_fd_sc_hd__tapvpwrvgnd_1
Xfanout48 net49 vssd1 vssd1 vccd1 vccd1 net48 sky130_fd_sc_hd__clkbuf_4
XFILLER_13_233 vssd1 vssd1 vccd1 vccd1 sky130_fd_sc_hd__fill_1
X_1280_ _0458_ _0511_ _0512_ _0454_ vssd1 vssd1 vccd1 vccd1 _0517_ sky130_fd_sc_hd__a22oi_4
XFILLER_0_181 vccd1 vssd1 vccd1 vssd1 sky130_ef_sc_hd__decap_40_12
XTAP_TAPCELL_ROW_46_331 vssd1 vccd1 sky130_fd_sc_hd__tapvpwrvgnd_1
X_0995_ _0231_ _0229_ vssd1 vssd1 vccd1 vccd1 _0232_ sky130_fd_sc_hd__nand2_2
X_1616_ clknet_3_4__leaf_clk _0034_ net46 vssd1 vssd1 vccd1 vccd1 STOPWATCH_INST.clock_div.cycles\[9\]
+ sky130_fd_sc_hd__dfrtp_4
X_1547_ net32 _0764_ _0765_ net38 STOPWATCH_INST.clock_div.cycles\[25\] vssd1 vssd1
+ vccd1 vccd1 _0050_ sky130_fd_sc_hd__a32o_1
X_1478_ net41 STOPWATCH_INST.clock_div.cycles\[14\] _0698_ vssd1 vssd1 vccd1 vccd1
+ _0708_ sky130_fd_sc_hd__and3_1
XFILLER_40_89 vssd1 vssd1 vccd1 vccd1 sky130_fd_sc_hd__fill_1
XFILLER_40_67 vssd1 vssd1 vccd1 vccd1 sky130_fd_sc_hd__fill_8
XFILLER_40_12 vssd1 vssd1 vccd1 vccd1 sky130_fd_sc_hd__fill_1
XFILLER_45_144 vssd1 vssd1 vccd1 vccd1 sky130_fd_sc_hd__fill_2
XFILLER_1_39 vssd1 vssd1 vccd1 vccd1 sky130_fd_sc_hd__fill_1
X_0780_ net192 vssd1 vssd1 vccd1 vccd1 _0009_ sky130_fd_sc_hd__inv_2
XFILLER_5_295 vssd1 vssd1 vccd1 vccd1 sky130_fd_sc_hd__fill_1
XFILLER_5_273 vssd1 vssd1 vccd1 vccd1 sky130_fd_sc_hd__fill_1
X_1401_ _0581_ _0626_ vssd1 vssd1 vccd1 vccd1 _0638_ sky130_fd_sc_hd__nor2_1
X_1194_ _0399_ _0417_ _0402_ vssd1 vssd1 vccd1 vccd1 _0431_ sky130_fd_sc_hd__a21o_1
XFILLER_36_144 vssd1 vssd1 vccd1 vccd1 sky130_fd_sc_hd__fill_4
XFILLER_36_100 vccd1 vssd1 vccd1 vssd1 sky130_ef_sc_hd__decap_40_12
X_1263_ _0479_ _0483_ _0499_ vssd1 vssd1 vccd1 vccd1 _0500_ sky130_fd_sc_hd__a21oi_2
Xinput5 nrst vssd1 vssd1 vccd1 vccd1 net5 sky130_fd_sc_hd__buf_1
X_1332_ _0498_ _0520_ vssd1 vssd1 vccd1 vccd1 _0569_ sky130_fd_sc_hd__nand2_1
XFILLER_36_188 vssd1 vssd1 vccd1 vccd1 sky130_fd_sc_hd__fill_1
X_0978_ _0189_ _0195_ vssd1 vssd1 vccd1 vccd1 _0215_ sky130_fd_sc_hd__nor2_1
XFILLER_10_15 vssd1 vssd1 vccd1 vccd1 sky130_fd_sc_hd__fill_1
XFILLER_27_199 vssd1 vssd1 vccd1 vccd1 sky130_fd_sc_hd__fill_2
XFILLER_27_111 vssd1 vssd1 vccd1 vccd1 sky130_fd_sc_hd__fill_1
XFILLER_18_9 vccd1 vssd1 vccd1 vssd1 sky130_ef_sc_hd__decap_40_12
XFILLER_33_169 vssd1 vssd1 vccd1 vccd1 sky130_fd_sc_hd__fill_8
XFILLER_33_125 vssd1 vssd1 vccd1 vccd1 sky130_fd_sc_hd__fill_2
X_0901_ _0150_ vssd1 vssd1 vccd1 vccd1 _0151_ sky130_fd_sc_hd__inv_2
X_0832_ _0093_ _0096_ _0103_ _0102_ vssd1 vssd1 vccd1 vccd1 net7 sky130_fd_sc_hd__a31o_1
X_1315_ _0060_ net18 _0510_ vssd1 vssd1 vccd1 vccd1 _0552_ sky130_fd_sc_hd__a21o_1
X_1177_ _0411_ _0413_ vssd1 vssd1 vccd1 vccd1 _0414_ sky130_fd_sc_hd__and2_1
X_1246_ _0443_ _0470_ vssd1 vssd1 vccd1 vccd1 _0483_ sky130_fd_sc_hd__nor2_1
XFILLER_24_125 vssd1 vssd1 vccd1 vccd1 sky130_fd_sc_hd__fill_2
XTAP_TAPCELL_ROW_19_194 vssd1 vccd1 sky130_fd_sc_hd__tapvpwrvgnd_1
XFILLER_21_69 vssd1 vssd1 vccd1 vccd1 sky130_fd_sc_hd__fill_8
XFILLER_46_55 vssd1 vssd1 vccd1 vccd1 sky130_fd_sc_hd__fill_1
XFILLER_15_169 vssd1 vssd1 vccd1 vccd1 sky130_fd_sc_hd__fill_4
XFILLER_30_139 vssd1 vssd1 vccd1 vccd1 sky130_fd_sc_hd__fill_1
XFILLER_23_7 vssd1 vssd1 vccd1 vccd1 sky130_fd_sc_hd__fill_8
X_1100_ _0267_ _0271_ _0278_ vssd1 vssd1 vccd1 vccd1 _0337_ sky130_fd_sc_hd__and3b_1
X_1031_ net123 _0247_ _0210_ vssd1 vssd1 vccd1 vccd1 _0268_ sky130_fd_sc_hd__a21oi_4
XFILLER_14_191 vssd1 vssd1 vccd1 vccd1 sky130_fd_sc_hd__fill_4
X_0815_ STOPWATCH_INST.bcd_num\[3\] STOPWATCH_INST.bcd_num\[2\] vssd1 vssd1 vccd1
+ vccd1 _0090_ sky130_fd_sc_hd__and2b_1
XFILLER_37_294 vssd1 vssd1 vccd1 vccd1 sky130_fd_sc_hd__fill_2
X_1229_ net42 _0449_ vssd1 vssd1 vccd1 vccd1 _0466_ sky130_fd_sc_hd__nor2_1
XFILLER_16_25 vssd1 vssd1 vccd1 vccd1 sky130_fd_sc_hd__fill_2
XFILLER_20_161 vccd1 vssd1 vccd1 vssd1 sky130_ef_sc_hd__decap_40_12
XFILLER_43_220 vssd1 vssd1 vccd1 vccd1 sky130_fd_sc_hd__fill_4
XTAP_TAPCELL_ROW_13_167 vssd1 vccd1 sky130_fd_sc_hd__tapvpwrvgnd_1
X_1580_ clknet_3_0__leaf_clk net189 net44 vssd1 vssd1 vccd1 vccd1 STOPWATCH_INST.sync_one.q
+ sky130_fd_sc_hd__dfrtp_1
X_1014_ _0199_ _0250_ vssd1 vssd1 vccd1 vccd1 _0251_ sky130_fd_sc_hd__xor2_2
XFILLER_34_297 vssd1 vssd1 vccd1 vccd1 sky130_fd_sc_hd__fill_2
XFILLER_27_35 vssd1 vssd1 vccd1 vccd1 sky130_fd_sc_hd__fill_8
XFILLER_40_245 vssd1 vssd1 vccd1 vccd1 sky130_fd_sc_hd__fill_4
XTAP_TAPCELL_ROW_27_237 vssd1 vccd1 sky130_fd_sc_hd__tapvpwrvgnd_1
XFILLER_25_297 vssd1 vssd1 vccd1 vccd1 sky130_fd_sc_hd__fill_2
XFILLER_40_289 vssd1 vssd1 vccd1 vccd1 sky130_fd_sc_hd__fill_4
XFILLER_4_102 vssd1 vssd1 vccd1 vccd1 sky130_fd_sc_hd__fill_1
Xclone22 STOPWATCH_INST.clock_div.cycles\[19\] vssd1 vssd1 vccd1 vccd1 net130 sky130_fd_sc_hd__clkbuf_1
XFILLER_16_286 vssd1 vssd1 vccd1 vccd1 sky130_fd_sc_hd__fill_2
X_1563_ STOPWATCH_INST.clock_div.cycles\[29\] STOPWATCH_INST.clock_div.cycles\[30\]
+ _0771_ vssd1 vssd1 vccd1 vccd1 _0776_ sky130_fd_sc_hd__nand3_1
X_1494_ _0621_ net16 _0631_ _0629_ vssd1 vssd1 vccd1 vccd1 _0721_ sky130_fd_sc_hd__a31o_1
X_1632_ clknet_3_2__leaf_clk _0050_ net48 vssd1 vssd1 vccd1 vccd1 STOPWATCH_INST.clock_div.cycles\[25\]
+ sky130_fd_sc_hd__dfrtp_4
XTAP_TAPCELL_ROW_1_105 vssd1 vccd1 sky130_fd_sc_hd__tapvpwrvgnd_1
XANTENNA_clkbuf_3_3__f_clk_A clknet_0_clk vssd1 vssd1 vccd1 vccd1 sky130_fd_sc_hd__diode_2
Xfanout27 _0305_ vssd1 vssd1 vccd1 vccd1 net27 sky130_fd_sc_hd__dlymetal6s2s_1
Xfanout16 _0655_ vssd1 vssd1 vccd1 vccd1 net16 sky130_fd_sc_hd__buf_6
Xfanout38 _0067_ vssd1 vssd1 vccd1 vccd1 net38 sky130_fd_sc_hd__clkbuf_4
XFILLER_22_245 vssd1 vssd1 vccd1 vccd1 sky130_fd_sc_hd__fill_1
Xfanout49 net5 vssd1 vssd1 vccd1 vccd1 net49 sky130_fd_sc_hd__clkbuf_4
XTAP_TAPCELL_ROW_32_262 vssd1 vccd1 sky130_fd_sc_hd__tapvpwrvgnd_1
XFILLER_38_23 vssd1 vssd1 vccd1 vccd1 sky130_fd_sc_hd__fill_4
XFILLER_9_238 vccd1 vssd1 vccd1 vssd1 sky130_ef_sc_hd__decap_40_12
XFILLER_13_223 vssd1 vssd1 vccd1 vccd1 sky130_fd_sc_hd__fill_1
XFILLER_13_256 vccd1 vssd1 vccd1 vssd1 sky130_ef_sc_hd__decap_40_12
XFILLER_0_193 vssd1 vssd1 vccd1 vccd1 sky130_fd_sc_hd__fill_2
XTAP_TAPCELL_ROW_46_332 vssd1 vccd1 sky130_fd_sc_hd__tapvpwrvgnd_1
X_0994_ STOPWATCH_INST.clock_div.cycles\[28\] _0230_ _0227_ _0196_ vssd1 vssd1 vccd1
+ vccd1 _0231_ sky130_fd_sc_hd__a2bb2o_4
X_1615_ clknet_3_6__leaf_clk _0033_ net46 vssd1 vssd1 vccd1 vccd1 STOPWATCH_INST.clock_div.cycles\[8\]
+ sky130_fd_sc_hd__dfrtp_4
X_1477_ _0620_ _0654_ _0706_ _0174_ vssd1 vssd1 vccd1 vccd1 _0707_ sky130_fd_sc_hd__o211ai_1
X_1546_ STOPWATCH_INST.clock_div.cycles\[25\] _0762_ vssd1 vssd1 vccd1 vccd1 _0765_
+ sky130_fd_sc_hd__nand2_1
XFILLER_39_197 vssd1 vssd1 vccd1 vccd1 sky130_fd_sc_hd__fill_2
XFILLER_24_25 vssd1 vssd1 vccd1 vccd1 sky130_fd_sc_hd__fill_2
XFILLER_40_79 vssd1 vssd1 vccd1 vccd1 sky130_fd_sc_hd__fill_4
XPHY_EDGE_ROW_39_Left_86 vssd1 vssd1 vccd1 vccd1 sky130_fd_sc_hd__decap_3
XFILLER_45_167 vssd1 vssd1 vccd1 vccd1 sky130_fd_sc_hd__fill_1
XFILLER_5_285 vssd1 vssd1 vccd1 vccd1 sky130_fd_sc_hd__fill_2
X_1400_ _0576_ _0636_ vssd1 vssd1 vccd1 vccd1 _0637_ sky130_fd_sc_hd__xnor2_2
X_1331_ _0562_ _0561_ _0565_ _0566_ vssd1 vssd1 vccd1 vccd1 _0568_ sky130_fd_sc_hd__a211o_4
X_1193_ _0397_ _0398_ net127 _0429_ vssd1 vssd1 vccd1 vccd1 _0430_ sky130_fd_sc_hd__a31oi_2
XFILLER_36_112 vssd1 vssd1 vccd1 vccd1 sky130_fd_sc_hd__fill_1
X_1262_ _0442_ _0480_ _0439_ vssd1 vssd1 vccd1 vccd1 _0499_ sky130_fd_sc_hd__a21oi_1
XANTENNA__1627__RESET_B net47 vssd1 vssd1 vccd1 vccd1 sky130_fd_sc_hd__diode_2
X_0977_ _0210_ _0211_ _0212_ _0209_ vssd1 vssd1 vccd1 vccd1 _0214_ sky130_fd_sc_hd__o31a_1
XFILLER_10_49 vssd1 vssd1 vccd1 vccd1 sky130_fd_sc_hd__fill_4
XFILLER_19_14 vssd1 vssd1 vccd1 vccd1 sky130_fd_sc_hd__fill_2
X_1529_ _0748_ net33 _0751_ net37 net39 vssd1 vssd1 vccd1 vccd1 _0046_ sky130_fd_sc_hd__a32o_1
XFILLER_42_137 vssd1 vssd1 vccd1 vccd1 sky130_fd_sc_hd__fill_2
XFILLER_35_57 vccd1 vssd1 vccd1 vssd1 sky130_ef_sc_hd__decap_40_12
XFILLER_35_24 vssd1 vssd1 vccd1 vccd1 sky130_fd_sc_hd__fill_4
XFILLER_27_167 vssd1 vssd1 vccd1 vccd1 sky130_fd_sc_hd__fill_1
XPHY_EDGE_ROW_14_Right_14 vssd1 vssd1 vccd1 vccd1 sky130_fd_sc_hd__decap_3
Xclkbuf_3_3__f_clk clknet_0_clk vssd1 vssd1 vccd1 vccd1 clknet_3_3__leaf_clk sky130_fd_sc_hd__clkbuf_16
XPHY_EDGE_ROW_23_Right_23 vssd1 vssd1 vccd1 vccd1 sky130_fd_sc_hd__decap_3
XPHY_EDGE_ROW_32_Right_32 vssd1 vssd1 vccd1 vccd1 sky130_fd_sc_hd__decap_3
X_0900_ STOPWATCH_INST.digit_scanner.period_counter\[9\] STOPWATCH_INST.digit_scanner.period_counter\[10\]
+ _0146_ vssd1 vssd1 vccd1 vccd1 _0150_ sky130_fd_sc_hd__and3_1
X_0831_ STOPWATCH_INST.bcd_num\[5\] STOPWATCH_INST.bcd_num\[4\] STOPWATCH_INST.bcd_num\[6\]
+ vssd1 vssd1 vccd1 vccd1 _0103_ sky130_fd_sc_hd__or3_1
XPHY_EDGE_ROW_41_Right_41 vssd1 vssd1 vccd1 vccd1 sky130_fd_sc_hd__decap_3
X_1314_ _0060_ _0510_ net128 vssd1 vssd1 vccd1 vccd1 _0551_ sky130_fd_sc_hd__nand3_1
X_1176_ _0258_ _0412_ vssd1 vssd1 vccd1 vccd1 _0413_ sky130_fd_sc_hd__xnor2_1
X_1245_ _0419_ _0481_ vssd1 vssd1 vccd1 vccd1 _0482_ sky130_fd_sc_hd__xnor2_1
XTAP_TAPCELL_ROW_19_195 vssd1 vccd1 sky130_fd_sc_hd__tapvpwrvgnd_1
XFILLER_32_181 vssd1 vssd1 vccd1 vccd1 sky130_fd_sc_hd__fill_8
XFILLER_46_12 vssd1 vssd1 vccd1 vccd1 sky130_fd_sc_hd__fill_4
Xmax_cap35 _0210_ vssd1 vssd1 vccd1 vccd1 net35 sky130_fd_sc_hd__clkbuf_1
XFILLER_30_129 vssd1 vssd1 vccd1 vccd1 sky130_fd_sc_hd__fill_1
XFILLER_46_251 vssd1 vssd1 vccd1 vccd1 sky130_fd_sc_hd__fill_1
X_1030_ _0209_ _0266_ vssd1 vssd1 vccd1 vccd1 _0267_ sky130_fd_sc_hd__xnor2_2
X_0814_ STOPWATCH_INST.bcd_num\[1\] net43 vssd1 vssd1 vccd1 vccd1 _0089_ sky130_fd_sc_hd__nor2_1
XFILLER_21_118 vssd1 vssd1 vccd1 vccd1 sky130_fd_sc_hd__fill_8
XPHY_EDGE_ROW_26_Left_73 vssd1 vssd1 vccd1 vccd1 sky130_fd_sc_hd__decap_3
XPHY_EDGE_ROW_10_Left_57 vssd1 vssd1 vccd1 vccd1 sky130_fd_sc_hd__decap_3
X_1228_ _0435_ _0464_ _0428_ vssd1 vssd1 vccd1 vccd1 _0465_ sky130_fd_sc_hd__a21o_1
X_1159_ _0394_ _0395_ vssd1 vssd1 vccd1 vccd1 _0396_ sky130_fd_sc_hd__nand2b_1
XFILLER_20_173 vccd1 vssd1 vccd1 vssd1 sky130_ef_sc_hd__decap_40_12
XFILLER_20_195 vssd1 vssd1 vccd1 vccd1 sky130_fd_sc_hd__fill_1
XTAP_TAPCELL_ROW_38_290 vssd1 vccd1 sky130_fd_sc_hd__tapvpwrvgnd_1
XFILLER_28_262 vssd1 vssd1 vccd1 vccd1 sky130_fd_sc_hd__fill_1
XFILLER_28_251 vssd1 vssd1 vccd1 vccd1 sky130_fd_sc_hd__fill_1
XFILLER_43_298 vssd1 vssd1 vccd1 vccd1 sky130_fd_sc_hd__fill_1
XFILLER_7_111 vssd1 vssd1 vccd1 vccd1 sky130_fd_sc_hd__fill_1
XTAP_TAPCELL_ROW_13_168 vssd1 vccd1 sky130_fd_sc_hd__tapvpwrvgnd_1
X_1013_ net112 _0247_ STOPWATCH_INST.clock_div.cycles\[14\] vssd1 vssd1 vccd1 vccd1
+ _0250_ sky130_fd_sc_hd__a21o_1
XPHY_EDGE_ROW_4_Right_4 vssd1 vssd1 vccd1 vccd1 sky130_fd_sc_hd__decap_3
XTAP_TAPCELL_ROW_27_238 vssd1 vccd1 sky130_fd_sc_hd__tapvpwrvgnd_1
XTAP_TAPCELL_ROW_10_149 vssd1 vccd1 sky130_fd_sc_hd__tapvpwrvgnd_1
XFILLER_16_243 vssd1 vssd1 vccd1 vccd1 sky130_fd_sc_hd__fill_1
X_1700_ STOPWATCH_INST.digit_scanner.ctrl vssd1 vssd1 vccd1 vccd1 net12 sky130_fd_sc_hd__clkbuf_1
X_1631_ clknet_3_3__leaf_clk _0049_ net48 vssd1 vssd1 vccd1 vccd1 STOPWATCH_INST.clock_div.cycles\[24\]
+ sky130_fd_sc_hd__dfrtp_2
X_1562_ STOPWATCH_INST.clock_div.cycles\[30\] net38 net32 _0775_ vssd1 vssd1 vccd1
+ vccd1 _0055_ sky130_fd_sc_hd__a22o_1
X_1493_ net33 _0717_ _0720_ net36 STOPWATCH_INST.clock_div.cycles\[16\] vssd1 vssd1
+ vccd1 vccd1 _0041_ sky130_fd_sc_hd__a32o_1
XTAP_TAPCELL_ROW_1_106 vssd1 vccd1 sky130_fd_sc_hd__tapvpwrvgnd_1
XTAP_TAPCELL_ROW_32_263 vssd1 vccd1 sky130_fd_sc_hd__tapvpwrvgnd_1
Xfanout28 net30 vssd1 vssd1 vccd1 vccd1 net28 sky130_fd_sc_hd__buf_2
Xfanout17 net18 vssd1 vssd1 vccd1 vccd1 net17 sky130_fd_sc_hd__buf_8
Xfanout39 STOPWATCH_INST.clock_div.cycles\[21\] vssd1 vssd1 vccd1 vccd1 net39 sky130_fd_sc_hd__buf_6
XFILLER_22_257 vssd1 vssd1 vccd1 vccd1 sky130_fd_sc_hd__fill_2
XTAP_TAPCELL_ROW_24_219 vssd1 vccd1 sky130_fd_sc_hd__tapvpwrvgnd_1
XPHY_EDGE_ROW_13_Left_60 vssd1 vssd1 vccd1 vccd1 sky130_fd_sc_hd__decap_3
XFILLER_9_206 vssd1 vssd1 vccd1 vccd1 sky130_fd_sc_hd__fill_1
XFILLER_13_268 vssd1 vssd1 vccd1 vccd1 sky130_fd_sc_hd__fill_4
XTAP_TAPCELL_ROW_46_333 vssd1 vccd1 sky130_fd_sc_hd__tapvpwrvgnd_1
X_0993_ STOPWATCH_INST.clock_div.cycles\[27\] _0226_ _0186_ vssd1 vssd1 vccd1 vccd1
+ _0230_ sky130_fd_sc_hd__and3_1
XFILLER_8_261 vssd1 vssd1 vccd1 vccd1 sky130_fd_sc_hd__fill_2
X_1614_ clknet_3_1__leaf_clk _0032_ net46 vssd1 vssd1 vccd1 vccd1 STOPWATCH_INST.clock_div.cycles\[7\]
+ sky130_fd_sc_hd__dfrtp_4
X_1476_ _0611_ _0616_ net15 _0615_ vssd1 vssd1 vccd1 vccd1 _0706_ sky130_fd_sc_hd__a31o_1
X_1545_ STOPWATCH_INST.clock_div.cycles\[25\] _0762_ vssd1 vssd1 vccd1 vccd1 _0764_
+ sky130_fd_sc_hd__or2_1
XFILLER_6_209 vccd1 vssd1 vccd1 vssd1 sky130_ef_sc_hd__decap_40_12
XTAP_TAPCELL_ROW_20_200 vssd1 vccd1 sky130_fd_sc_hd__tapvpwrvgnd_1
XFILLER_40_47 vssd1 vssd1 vccd1 vccd1 sky130_fd_sc_hd__fill_1
XFILLER_6_6 vssd1 vssd1 vccd1 vccd1 sky130_fd_sc_hd__fill_8
XTAP_TAPCELL_ROW_43_314 vssd1 vccd1 sky130_fd_sc_hd__tapvpwrvgnd_1
XFILLER_14_92 vssd1 vssd1 vccd1 vccd1 sky130_fd_sc_hd__fill_8
X_1261_ _0442_ _0480_ vssd1 vssd1 vccd1 vccd1 _0498_ sky130_fd_sc_hd__xor2_4
X_1330_ _0565_ _0566_ vssd1 vssd1 vccd1 vccd1 _0567_ sky130_fd_sc_hd__or2_1
X_1192_ _0397_ net23 _0398_ vssd1 vssd1 vccd1 vccd1 _0429_ sky130_fd_sc_hd__a21oi_1
X_0976_ _0211_ _0212_ vssd1 vssd1 vccd1 vccd1 _0213_ sky130_fd_sc_hd__or2_1
XPHY_EDGE_ROW_40_Left_87 vssd1 vssd1 vccd1 vccd1 sky130_fd_sc_hd__decap_3
X_1459_ _0608_ net15 _0686_ _0606_ net29 vssd1 vssd1 vccd1 vccd1 _0692_ sky130_fd_sc_hd__a221o_1
XFILLER_19_37 vssd1 vssd1 vccd1 vccd1 sky130_fd_sc_hd__fill_2
X_1528_ _0749_ _0750_ net31 vssd1 vssd1 vccd1 vccd1 _0751_ sky130_fd_sc_hd__o21ai_1
XFILLER_35_69 vccd1 vssd1 vccd1 vssd1 sky130_ef_sc_hd__decap_40_12
XFILLER_35_36 vssd1 vssd1 vccd1 vccd1 sky130_fd_sc_hd__fill_4
XFILLER_18_124 vccd1 vssd1 vccd1 vssd1 sky130_ef_sc_hd__decap_40_12
XFILLER_41_182 vssd1 vssd1 vccd1 vccd1 sky130_fd_sc_hd__fill_4
X_0830_ _0087_ _0088_ _0095_ _0101_ vssd1 vssd1 vccd1 vccd1 _0102_ sky130_fd_sc_hd__o211a_1
X_1244_ net20 net19 _0468_ vssd1 vssd1 vccd1 vccd1 _0481_ sky130_fd_sc_hd__a21oi_1
X_1313_ _0060_ net18 vssd1 vssd1 vccd1 vccd1 _0550_ sky130_fd_sc_hd__xnor2_2
X_1175_ _0260_ _0328_ _0408_ vssd1 vssd1 vccd1 vccd1 _0412_ sky130_fd_sc_hd__o21a_1
XTAP_TAPCELL_ROW_19_196 vssd1 vccd1 sky130_fd_sc_hd__tapvpwrvgnd_1
X_0959_ _0187_ _0194_ vssd1 vssd1 vccd1 vccd1 _0196_ sky130_fd_sc_hd__nand2_2
XFILLER_21_27 vssd1 vssd1 vccd1 vccd1 sky130_fd_sc_hd__fill_8
XFILLER_46_68 vssd1 vssd1 vccd1 vccd1 sky130_fd_sc_hd__fill_2
XFILLER_46_57 vssd1 vssd1 vccd1 vccd1 sky130_fd_sc_hd__fill_4
X_0813_ STOPWATCH_INST.bcd_num\[1\] net43 vssd1 vssd1 vccd1 vccd1 _0088_ sky130_fd_sc_hd__and2b_1
X_1158_ _0342_ _0388_ vssd1 vssd1 vccd1 vccd1 _0395_ sky130_fd_sc_hd__xor2_1
X_1227_ _0443_ _0444_ vssd1 vssd1 vccd1 vccd1 _0464_ sky130_fd_sc_hd__nand2_1
X_1089_ net24 net26 _0280_ vssd1 vssd1 vccd1 vccd1 _0326_ sky130_fd_sc_hd__a21oi_2
XFILLER_32_37 vssd1 vssd1 vccd1 vccd1 sky130_fd_sc_hd__fill_2
XFILLER_16_27 vssd1 vssd1 vccd1 vccd1 sky130_fd_sc_hd__fill_1
XFILLER_16_49 vccd1 vssd1 vccd1 vssd1 sky130_ef_sc_hd__decap_40_12
XFILLER_20_185 vssd1 vssd1 vccd1 vccd1 sky130_fd_sc_hd__fill_8
XTAP_TAPCELL_ROW_7_134 vssd1 vccd1 sky130_fd_sc_hd__tapvpwrvgnd_1
XFILLER_43_277 vssd1 vssd1 vccd1 vccd1 sky130_fd_sc_hd__fill_2
XPHY_EDGE_ROW_43_Left_90 vssd1 vssd1 vccd1 vccd1 sky130_fd_sc_hd__decap_3
XTAP_TAPCELL_ROW_38_291 vssd1 vccd1 sky130_fd_sc_hd__tapvpwrvgnd_1
XANTENNA_fanout47_X net47 vssd1 vssd1 vccd1 vccd1 sky130_fd_sc_hd__diode_2
XFILLER_7_156 vccd1 vssd1 vccd1 vssd1 sky130_ef_sc_hd__decap_40_12
X_1012_ net112 _0247_ vssd1 vssd1 vccd1 vccd1 _0249_ sky130_fd_sc_hd__nand2_1
XFILLER_21_6 vssd1 vssd1 vccd1 vccd1 sky130_fd_sc_hd__fill_1
XFILLER_34_266 vssd1 vssd1 vccd1 vccd1 sky130_fd_sc_hd__fill_2
XFILLER_34_233 vssd1 vssd1 vccd1 vccd1 sky130_fd_sc_hd__fill_2
XFILLER_8_83 vssd1 vssd1 vccd1 vccd1 sky130_fd_sc_hd__fill_1
XFILLER_25_222 vssd1 vssd1 vccd1 vccd1 sky130_fd_sc_hd__fill_2
XFILLER_31_225 vccd1 vssd1 vccd1 vssd1 sky130_ef_sc_hd__decap_40_12
X_1630_ clknet_3_1__leaf_clk _0048_ net47 vssd1 vssd1 vccd1 vccd1 STOPWATCH_INST.clock_div.cycles\[23\]
+ sky130_fd_sc_hd__dfrtp_4
X_1561_ STOPWATCH_INST.clock_div.cycles\[30\] _0774_ vssd1 vssd1 vccd1 vccd1 _0775_
+ sky130_fd_sc_hd__xnor2_1
X_1492_ _0718_ _0719_ _0174_ vssd1 vssd1 vccd1 vccd1 _0720_ sky130_fd_sc_hd__a21o_1
XTAP_TAPCELL_ROW_1_107 vssd1 vccd1 sky130_fd_sc_hd__tapvpwrvgnd_1
XFILLER_13_17 vccd1 vssd1 vccd1 vssd1 sky130_ef_sc_hd__decap_40_12
Xfanout29 net30 vssd1 vssd1 vccd1 vccd1 net29 sky130_fd_sc_hd__buf_1
Xfanout18 _0534_ vssd1 vssd1 vccd1 vccd1 net18 sky130_fd_sc_hd__buf_6
XANTENNA__1214__A STOPWATCH_INST.clock_div.cycles\[7\] vssd1 vssd1 vccd1 vccd1 sky130_fd_sc_hd__diode_2
XFILLER_13_203 vssd1 vssd1 vccd1 vccd1 sky130_fd_sc_hd__fill_2
XFILLER_13_225 vssd1 vssd1 vccd1 vccd1 sky130_fd_sc_hd__fill_8
XTAP_TAPCELL_ROW_46_334 vssd1 vccd1 sky130_fd_sc_hd__tapvpwrvgnd_1
XFILLER_28_80 vssd1 vssd1 vccd1 vccd1 sky130_fd_sc_hd__fill_4
XFILLER_0_195 vssd1 vssd1 vccd1 vccd1 sky130_fd_sc_hd__fill_1
X_0992_ _0228_ STOPWATCH_INST.clock_div.cycles\[29\] vssd1 vssd1 vccd1 vccd1 _0229_
+ sky130_fd_sc_hd__xnor2_2
XFILLER_5_51 vssd1 vssd1 vccd1 vccd1 sky130_fd_sc_hd__fill_4
X_1613_ clknet_3_4__leaf_clk _0031_ net46 vssd1 vssd1 vccd1 vccd1 STOPWATCH_INST.clock_div.cycles\[6\]
+ sky130_fd_sc_hd__dfrtp_1
XFILLER_8_251 vssd1 vssd1 vccd1 vccd1 sky130_fd_sc_hd__fill_1
X_1544_ net218 net37 _0763_ vssd1 vssd1 vccd1 vccd1 _0049_ sky130_fd_sc_hd__a21o_1
XFILLER_39_166 vssd1 vssd1 vccd1 vccd1 sky130_fd_sc_hd__fill_2
XFILLER_39_122 vssd1 vssd1 vccd1 vccd1 sky130_fd_sc_hd__fill_1
XFILLER_39_111 vssd1 vssd1 vccd1 vccd1 sky130_fd_sc_hd__fill_1
X_1475_ net34 _0702_ _0705_ net36 net41 vssd1 vssd1 vccd1 vccd1 _0038_ sky130_fd_sc_hd__a32o_1
XFILLER_24_27 vssd1 vssd1 vccd1 vccd1 sky130_fd_sc_hd__fill_1
XTAP_TAPCELL_ROW_20_201 vssd1 vccd1 sky130_fd_sc_hd__tapvpwrvgnd_1
XFILLER_45_169 vccd1 vssd1 vccd1 vssd1 sky130_ef_sc_hd__decap_40_12
Xteam_04_90 vssd1 vssd1 vccd1 vccd1 team_04_90/HI gpio_out[30] sky130_fd_sc_hd__conb_1
XTAP_TAPCELL_ROW_43_315 vssd1 vccd1 sky130_fd_sc_hd__tapvpwrvgnd_1
XFILLER_30_70 vssd1 vssd1 vccd1 vccd1 sky130_fd_sc_hd__fill_2
X_1191_ _0424_ _0427_ vssd1 vssd1 vccd1 vccd1 _0428_ sky130_fd_sc_hd__or2_1
X_1260_ _0490_ _0424_ _0495_ vssd1 vssd1 vccd1 vccd1 _0497_ sky130_fd_sc_hd__and3_1
X_0975_ STOPWATCH_INST.clock_div.cycles\[16\] _0197_ vssd1 vssd1 vccd1 vccd1 _0212_
+ sky130_fd_sc_hd__xnor2_2
XANTENNA__1636__RESET_B net49 vssd1 vssd1 vccd1 vccd1 sky130_fd_sc_hd__diode_2
X_1527_ net39 _0158_ _0729_ vssd1 vssd1 vccd1 vccd1 _0750_ sky130_fd_sc_hd__and3_1
X_1458_ net33 _0688_ _0691_ net36 net42 vssd1 vssd1 vccd1 vccd1 _0035_ sky130_fd_sc_hd__a32o_1
X_1389_ _0583_ _0593_ _0623_ _0580_ vssd1 vssd1 vccd1 vccd1 _0626_ sky130_fd_sc_hd__and4b_1
XFILLER_19_16 vssd1 vssd1 vccd1 vccd1 sky130_fd_sc_hd__fill_1
XFILLER_42_139 vssd1 vssd1 vccd1 vccd1 sky130_fd_sc_hd__fill_1
XFILLER_18_136 vssd1 vssd1 vccd1 vccd1 sky130_fd_sc_hd__fill_4
X_1174_ _0356_ _0383_ vssd1 vssd1 vccd1 vccd1 _0411_ sky130_fd_sc_hd__xor2_4
X_1243_ net20 net19 _0470_ vssd1 vssd1 vccd1 vccd1 _0480_ sky130_fd_sc_hd__a21oi_2
XFILLER_2_85 vssd1 vssd1 vccd1 vccd1 sky130_fd_sc_hd__fill_1
X_1312_ _0509_ _0547_ vssd1 vssd1 vccd1 vccd1 _0549_ sky130_fd_sc_hd__xnor2_2
XTAP_TAPCELL_ROW_19_197 vssd1 vccd1 sky130_fd_sc_hd__tapvpwrvgnd_1
XFILLER_24_117 vssd1 vssd1 vccd1 vccd1 sky130_fd_sc_hd__fill_2
XFILLER_24_139 vssd1 vssd1 vccd1 vccd1 sky130_fd_sc_hd__fill_1
X_0958_ _0187_ _0194_ vssd1 vssd1 vccd1 vccd1 _0195_ sky130_fd_sc_hd__and2_2
X_0889_ STOPWATCH_INST.digit_scanner.period_counter\[5\] STOPWATCH_INST.digit_scanner.period_counter\[4\]
+ STOPWATCH_INST.digit_scanner.period_counter\[6\] _0117_ vssd1 vssd1 vccd1 vccd1
+ _0143_ sky130_fd_sc_hd__and4_1
XANTENNA_fanout37_A net38 vssd1 vssd1 vccd1 vccd1 sky130_fd_sc_hd__diode_2
XFILLER_46_253 vccd1 vssd1 vccd1 vssd1 sky130_ef_sc_hd__decap_40_12
X_0812_ STOPWATCH_INST.bcd_num\[3\] STOPWATCH_INST.bcd_num\[2\] vssd1 vssd1 vccd1
+ vccd1 _0087_ sky130_fd_sc_hd__or2_1
X_1157_ _0339_ _0392_ vssd1 vssd1 vccd1 vccd1 _0394_ sky130_fd_sc_hd__xnor2_1
XFILLER_37_286 vssd1 vssd1 vccd1 vccd1 sky130_fd_sc_hd__fill_8
XFILLER_37_253 vssd1 vssd1 vccd1 vccd1 sky130_fd_sc_hd__fill_2
XFILLER_37_220 vssd1 vssd1 vccd1 vccd1 sky130_fd_sc_hd__fill_4
X_1226_ _0459_ _0452_ _0446_ _0462_ _0422_ vssd1 vssd1 vccd1 vccd1 _0463_ sky130_fd_sc_hd__o41a_1
X_1088_ _0321_ _0324_ vssd1 vssd1 vccd1 vccd1 _0325_ sky130_fd_sc_hd__or2_4
XFILLER_12_109 vssd1 vssd1 vccd1 vccd1 sky130_fd_sc_hd__fill_2
XFILLER_20_197 vssd1 vssd1 vccd1 vccd1 sky130_fd_sc_hd__fill_4
XTAP_TAPCELL_ROW_7_135 vssd1 vccd1 sky130_fd_sc_hd__tapvpwrvgnd_1
XFILLER_43_245 vssd1 vssd1 vccd1 vccd1 sky130_fd_sc_hd__fill_4
XTAP_TAPCELL_ROW_38_292 vssd1 vccd1 sky130_fd_sc_hd__tapvpwrvgnd_1
XFILLER_28_297 vssd1 vssd1 vccd1 vccd1 sky130_fd_sc_hd__fill_2
XFILLER_7_113 vccd1 vssd1 vccd1 vssd1 sky130_ef_sc_hd__decap_40_12
XFILLER_22_82 vssd1 vssd1 vccd1 vccd1 sky130_fd_sc_hd__fill_2
X_1011_ _0245_ _0247_ vssd1 vssd1 vccd1 vccd1 _0248_ sky130_fd_sc_hd__and2_4
XFILLER_19_297 vssd1 vssd1 vccd1 vccd1 sky130_fd_sc_hd__fill_2
XFILLER_34_289 vssd1 vssd1 vccd1 vccd1 sky130_fd_sc_hd__fill_8
X_1209_ _0428_ _0445_ vssd1 vssd1 vccd1 vccd1 _0446_ sky130_fd_sc_hd__or2_1
Xclone25 _0477_ vssd1 vssd1 vccd1 vccd1 net133 sky130_fd_sc_hd__clkbuf_1
XFILLER_4_138 vssd1 vssd1 vccd1 vccd1 sky130_fd_sc_hd__fill_2
XFILLER_31_237 vssd1 vssd1 vccd1 vccd1 sky130_fd_sc_hd__fill_8
X_1560_ _0173_ _0773_ _0774_ net38 STOPWATCH_INST.clock_div.cycles\[29\] vssd1 vssd1
+ vccd1 vccd1 _0054_ sky130_fd_sc_hd__a32o_1
XFILLER_33_81 vssd1 vssd1 vccd1 vccd1 sky130_fd_sc_hd__fill_4
X_1491_ STOPWATCH_INST.clock_div.cycles\[16\] _0714_ vssd1 vssd1 vccd1 vccd1 _0719_
+ sky130_fd_sc_hd__nand2_1
Xfanout19 _0477_ vssd1 vssd1 vccd1 vccd1 net19 sky130_fd_sc_hd__buf_8
XTAP_TAPCELL_ROW_1_108 vssd1 vccd1 sky130_fd_sc_hd__tapvpwrvgnd_1
XFILLER_13_29 vccd1 vssd1 vccd1 vssd1 sky130_ef_sc_hd__decap_40_12
XFILLER_22_237 vssd1 vssd1 vccd1 vccd1 sky130_fd_sc_hd__fill_2
XFILLER_38_15 vssd1 vssd1 vccd1 vccd1 sky130_fd_sc_hd__fill_2
XANTENNA__1230__A net42 vssd1 vssd1 vccd1 vccd1 sky130_fd_sc_hd__diode_2
XFILLER_0_141 vssd1 vssd1 vccd1 vccd1 sky130_fd_sc_hd__fill_8
XTAP_TAPCELL_ROW_46_335 vssd1 vccd1 sky130_fd_sc_hd__tapvpwrvgnd_1
X_0991_ _0194_ _0187_ _0227_ vssd1 vssd1 vccd1 vccd1 _0228_ sky130_fd_sc_hd__a21oi_4
XFILLER_8_263 vssd1 vssd1 vccd1 vccd1 sky130_fd_sc_hd__fill_1
X_1612_ clknet_3_6__leaf_clk _0030_ net46 vssd1 vssd1 vccd1 vccd1 STOPWATCH_INST.clock_div.cycles\[5\]
+ sky130_fd_sc_hd__dfrtp_1
X_1543_ _0762_ _0736_ _0761_ vssd1 vssd1 vccd1 vccd1 _0763_ sky130_fd_sc_hd__and3b_1
X_1474_ _0703_ _0704_ _0174_ vssd1 vssd1 vccd1 vccd1 _0705_ sky130_fd_sc_hd__a21o_1
XTAP_TAPCELL_ROW_20_202 vssd1 vccd1 sky130_fd_sc_hd__tapvpwrvgnd_1
XTAP_TAPCELL_ROW_43_316 vssd1 vccd1 sky130_fd_sc_hd__tapvpwrvgnd_1
Xteam_04_91 vssd1 vssd1 vccd1 vccd1 team_04_91/HI gpio_out[31] sky130_fd_sc_hd__conb_1
Xteam_04_80 vssd1 vssd1 vccd1 vccd1 team_04_80/HI gpio_out[20] sky130_fd_sc_hd__conb_1
XFILLER_14_83 vssd1 vssd1 vccd1 vccd1 sky130_fd_sc_hd__fill_1
XFILLER_5_277 vssd1 vssd1 vccd1 vccd1 sky130_fd_sc_hd__fill_2
X_1190_ _0409_ _0426_ vssd1 vssd1 vccd1 vccd1 _0427_ sky130_fd_sc_hd__xnor2_1
XFILLER_44_170 vssd1 vssd1 vccd1 vccd1 sky130_fd_sc_hd__fill_2
X_0974_ STOPWATCH_INST.clock_div.cycles\[17\] _0207_ vssd1 vssd1 vccd1 vccd1 _0211_
+ sky130_fd_sc_hd__xnor2_1
X_1457_ _0689_ _0690_ _0174_ vssd1 vssd1 vccd1 vccd1 _0691_ sky130_fd_sc_hd__a21o_1
X_1526_ net39 _0742_ vssd1 vssd1 vccd1 vccd1 _0749_ sky130_fd_sc_hd__nor2_1
XFILLER_27_159 vssd1 vssd1 vccd1 vccd1 sky130_fd_sc_hd__fill_1
X_1388_ _0580_ _0593_ _0623_ vssd1 vssd1 vccd1 vccd1 _0625_ sky130_fd_sc_hd__and3_1
XFILLER_44_6 vssd1 vssd1 vccd1 vccd1 sky130_fd_sc_hd__fill_4
X_1311_ STOPWATCH_INST.clock_div.cycles\[9\] _0510_ net128 _0509_ vssd1 vssd1 vccd1
+ vccd1 _0548_ sky130_fd_sc_hd__o211a_1
X_1173_ _0398_ _0397_ _0401_ _0407_ _0409_ vssd1 vssd1 vccd1 vccd1 _0410_ sky130_fd_sc_hd__a2111o_1
X_1242_ net20 _0477_ vssd1 vssd1 vccd1 vccd1 _0479_ sky130_fd_sc_hd__nand2_1
XPHY_EDGE_ROW_10_Right_10 vssd1 vssd1 vccd1 vccd1 sky130_fd_sc_hd__decap_3
XTAP_TAPCELL_ROW_19_198 vssd1 vccd1 sky130_fd_sc_hd__tapvpwrvgnd_1
X_0957_ _0159_ _0192_ _0185_ vssd1 vssd1 vccd1 vccd1 _0194_ sky130_fd_sc_hd__a21o_4
X_0888_ net206 _0141_ vssd1 vssd1 vccd1 vccd1 _0014_ sky130_fd_sc_hd__xnor2_1
X_1509_ _0732_ _0733_ vssd1 vssd1 vccd1 vccd1 _0734_ sky130_fd_sc_hd__nor2_1
XFILLER_11_84 vccd1 vssd1 vccd1 vssd1 sky130_ef_sc_hd__decap_40_12
XFILLER_46_265 vccd1 vssd1 vccd1 vssd1 sky130_ef_sc_hd__decap_40_12
XFILLER_46_221 vssd1 vssd1 vccd1 vccd1 sky130_fd_sc_hd__fill_2
XFILLER_14_195 vssd1 vssd1 vccd1 vccd1 sky130_fd_sc_hd__fill_1
XTAP_TAPCELL_ROW_16_179 vssd1 vccd1 sky130_fd_sc_hd__tapvpwrvgnd_1
X_0811_ STOPWATCH_INST.bcd_num\[3\] STOPWATCH_INST.bcd_num\[2\] vssd1 vssd1 vccd1
+ vccd1 _0086_ sky130_fd_sc_hd__nor2_1
XANTENNA_clkbuf_3_6__f_clk_A clknet_0_clk vssd1 vssd1 vccd1 vccd1 sky130_fd_sc_hd__diode_2
X_1225_ _0382_ _0461_ vssd1 vssd1 vccd1 vccd1 _0462_ sky130_fd_sc_hd__xnor2_2
X_1087_ net149 _0323_ vssd1 vssd1 vccd1 vccd1 _0324_ sky130_fd_sc_hd__xnor2_4
X_1156_ _0339_ _0392_ vssd1 vssd1 vccd1 vccd1 _0393_ sky130_fd_sc_hd__nor2_1
XFILLER_37_265 vssd1 vssd1 vccd1 vccd1 sky130_fd_sc_hd__fill_2
XFILLER_32_39 vssd1 vssd1 vccd1 vccd1 sky130_fd_sc_hd__fill_1
XTAP_TAPCELL_ROW_7_136 vssd1 vccd1 sky130_fd_sc_hd__tapvpwrvgnd_1
XANTENNA__1620__RESET_B net47 vssd1 vssd1 vccd1 vccd1 sky130_fd_sc_hd__diode_2
XFILLER_28_243 vssd1 vssd1 vccd1 vccd1 sky130_fd_sc_hd__fill_8
XFILLER_43_279 vssd1 vssd1 vccd1 vccd1 sky130_fd_sc_hd__fill_1
XTAP_TAPCELL_ROW_38_293 vssd1 vccd1 sky130_fd_sc_hd__tapvpwrvgnd_1
XFILLER_11_121 vssd1 vssd1 vccd1 vccd1 sky130_fd_sc_hd__fill_4
XFILLER_7_103 vssd1 vssd1 vccd1 vccd1 sky130_fd_sc_hd__fill_8
XFILLER_7_125 vssd1 vssd1 vccd1 vccd1 sky130_fd_sc_hd__fill_4
XFILLER_7_169 vccd1 vssd1 vccd1 vssd1 sky130_ef_sc_hd__decap_40_12
XFILLER_11_165 vssd1 vssd1 vccd1 vccd1 sky130_fd_sc_hd__fill_2
X_1010_ STOPWATCH_INST.clock_div.cycles\[31\] _0195_ _0237_ _0246_ vssd1 vssd1 vccd1
+ vccd1 _0247_ sky130_fd_sc_hd__o2bb2a_4
XFILLER_34_202 vssd1 vssd1 vccd1 vccd1 sky130_fd_sc_hd__fill_1
XFILLER_14_7 vssd1 vssd1 vccd1 vccd1 sky130_fd_sc_hd__fill_2
XFILLER_19_254 vccd1 vssd1 vccd1 vssd1 sky130_ef_sc_hd__decap_40_12
XTAP_TAPCELL_ROW_12_160 vssd1 vccd1 sky130_fd_sc_hd__tapvpwrvgnd_1
X_1208_ _0430_ _0443_ _0434_ _0444_ vssd1 vssd1 vccd1 vccd1 _0445_ sky130_fd_sc_hd__or4b_4
X_1139_ _0358_ _0364_ _0320_ vssd1 vssd1 vccd1 vccd1 _0376_ sky130_fd_sc_hd__o21ai_1
XFILLER_40_249 vssd1 vssd1 vccd1 vccd1 sky130_fd_sc_hd__fill_2
XTAP_TAPCELL_ROW_35_274 vssd1 vccd1 sky130_fd_sc_hd__tapvpwrvgnd_1
XFILLER_25_257 vssd1 vssd1 vccd1 vccd1 sky130_fd_sc_hd__fill_1
XFILLER_25_279 vssd1 vssd1 vccd1 vccd1 sky130_fd_sc_hd__fill_1
XFILLER_17_83 vccd1 vssd1 vccd1 vssd1 sky130_ef_sc_hd__decap_40_12
XTAP_TAPCELL_ROW_26_230 vssd1 vccd1 sky130_fd_sc_hd__tapvpwrvgnd_1
XFILLER_31_216 vssd1 vssd1 vccd1 vccd1 sky130_fd_sc_hd__fill_8
XFILLER_16_279 vssd1 vssd1 vccd1 vccd1 sky130_fd_sc_hd__fill_1
X_1490_ STOPWATCH_INST.clock_div.cycles\[16\] _0714_ vssd1 vssd1 vccd1 vccd1 _0718_
+ sky130_fd_sc_hd__or2_1
XPHY_EDGE_ROW_8_Right_8 vssd1 vssd1 vccd1 vccd1 sky130_fd_sc_hd__decap_3
XPHY_EDGE_ROW_39_Right_39 vssd1 vssd1 vccd1 vccd1 sky130_fd_sc_hd__decap_3
XFILLER_38_27 vssd1 vssd1 vccd1 vccd1 sky130_fd_sc_hd__fill_1
XANTENNA__0887__A _0122_ vssd1 vssd1 vccd1 vccd1 sky130_fd_sc_hd__diode_2
XFILLER_13_205 vssd1 vssd1 vccd1 vccd1 sky130_fd_sc_hd__fill_1
XFILLER_0_153 vccd1 vssd1 vccd1 vssd1 sky130_ef_sc_hd__decap_40_12
XFILLER_0_197 vccd1 vssd1 vccd1 vssd1 sky130_ef_sc_hd__decap_40_12
XTAP_TAPCELL_ROW_46_336 vssd1 vccd1 sky130_fd_sc_hd__tapvpwrvgnd_1
XFILLER_28_93 vssd1 vssd1 vccd1 vccd1 sky130_fd_sc_hd__fill_2
X_0990_ _0160_ _0170_ _0191_ STOPWATCH_INST.clock_div.cycles\[28\] STOPWATCH_INST.clock_div.cycles\[27\]
+ vssd1 vssd1 vccd1 vccd1 _0227_ sky130_fd_sc_hd__o311a_4
X_1611_ clknet_3_6__leaf_clk _0029_ net46 vssd1 vssd1 vccd1 vccd1 STOPWATCH_INST.clock_div.cycles\[4\]
+ sky130_fd_sc_hd__dfrtp_1
XFILLER_8_253 vssd1 vssd1 vccd1 vccd1 sky130_fd_sc_hd__fill_8
X_1473_ net41 _0698_ vssd1 vssd1 vccd1 vccd1 _0704_ sky130_fd_sc_hd__nand2_1
X_1542_ STOPWATCH_INST.clock_div.cycles\[23\] STOPWATCH_INST.clock_div.cycles\[24\]
+ _0755_ vssd1 vssd1 vccd1 vccd1 _0762_ sky130_fd_sc_hd__and3_1
XFILLER_10_208 vssd1 vssd1 vccd1 vccd1 sky130_fd_sc_hd__fill_1
XPHY_EDGE_ROW_17_Left_64 vssd1 vssd1 vccd1 vccd1 sky130_fd_sc_hd__decap_3
XTAP_TAPCELL_ROW_20_203 vssd1 vccd1 sky130_fd_sc_hd__tapvpwrvgnd_1
XFILLER_24_29 vssd1 vssd1 vccd1 vccd1 sky130_fd_sc_hd__fill_4
XTAP_TAPCELL_ROW_43_317 vssd1 vccd1 sky130_fd_sc_hd__tapvpwrvgnd_1
Xteam_04_92 vssd1 vssd1 vccd1 vccd1 team_04_92/HI gpio_out[32] sky130_fd_sc_hd__conb_1
Xteam_04_70 vssd1 vssd1 vccd1 vccd1 team_04_70/HI gpio_oeb[32] sky130_fd_sc_hd__conb_1
Xteam_04_81 vssd1 vssd1 vccd1 vccd1 team_04_81/HI gpio_out[21] sky130_fd_sc_hd__conb_1
XFILLER_5_212 vssd1 vssd1 vccd1 vccd1 sky130_fd_sc_hd__fill_4
XFILLER_30_72 vssd1 vssd1 vccd1 vccd1 sky130_fd_sc_hd__fill_1
XFILLER_39_70 vssd1 vssd1 vccd1 vccd1 sky130_fd_sc_hd__fill_1
XFILLER_29_190 vccd1 vssd1 vccd1 vssd1 sky130_ef_sc_hd__decap_40_12
XFILLER_44_193 vssd1 vssd1 vccd1 vccd1 sky130_fd_sc_hd__fill_2
X_0973_ STOPWATCH_INST.clock_div.cycles\[14\] _0197_ _0198_ vssd1 vssd1 vccd1 vccd1
+ _0210_ sky130_fd_sc_hd__nor3_1
X_1456_ net42 _0682_ vssd1 vssd1 vccd1 vccd1 _0690_ sky130_fd_sc_hd__or2_1
X_1387_ _0592_ _0622_ vssd1 vssd1 vccd1 vccd1 _0624_ sky130_fd_sc_hd__nor2_1
X_1525_ net28 _0746_ _0747_ vssd1 vssd1 vccd1 vccd1 _0748_ sky130_fd_sc_hd__or3b_4
XFILLER_35_28 vssd1 vssd1 vccd1 vccd1 sky130_fd_sc_hd__fill_2
XPHY_EDGE_ROW_2_Left_49 vssd1 vssd1 vccd1 vccd1 sky130_fd_sc_hd__decap_3
XFILLER_4_6 vssd1 vssd1 vccd1 vccd1 sky130_fd_sc_hd__fill_8
XFILLER_2_226 vssd1 vssd1 vccd1 vccd1 sky130_fd_sc_hd__fill_2
XFILLER_26_193 vssd1 vssd1 vccd1 vccd1 sky130_fd_sc_hd__fill_2
XFILLER_25_72 vssd1 vssd1 vccd1 vccd1 sky130_fd_sc_hd__fill_2
X_1241_ net20 net19 vssd1 vssd1 vccd1 vccd1 _0478_ sky130_fd_sc_hd__and2_1
X_1310_ STOPWATCH_INST.clock_div.cycles\[9\] _0510_ net128 vssd1 vssd1 vccd1 vccd1
+ _0547_ sky130_fd_sc_hd__o21ai_1
X_1172_ _0329_ _0404_ vssd1 vssd1 vccd1 vccd1 _0409_ sky130_fd_sc_hd__xor2_1
X_0956_ _0159_ _0192_ vssd1 vssd1 vccd1 vccd1 _0193_ sky130_fd_sc_hd__nand2_1
X_0887_ _0122_ _0141_ _0142_ vssd1 vssd1 vccd1 vccd1 _0013_ sky130_fd_sc_hd__and3_1
XFILLER_46_16 vssd1 vssd1 vccd1 vccd1 sky130_fd_sc_hd__fill_1
X_1439_ _0597_ net15 _0596_ _0674_ net29 vssd1 vssd1 vccd1 vccd1 _0675_ sky130_fd_sc_hd__a221o_1
X_1508_ _0634_ _0640_ net117 vssd1 vssd1 vccd1 vccd1 _0733_ sky130_fd_sc_hd__and3_1
XFILLER_11_96 vssd1 vssd1 vccd1 vccd1 sky130_fd_sc_hd__fill_8
XFILLER_46_277 vssd1 vssd1 vccd1 vccd1 sky130_fd_sc_hd__fill_2
XFILLER_36_60 vssd1 vssd1 vccd1 vccd1 sky130_fd_sc_hd__fill_4
X_0810_ STOPWATCH_INST.bcd_num\[5\] STOPWATCH_INST.bcd_num\[4\] _0082_ _0084_ STOPWATCH_INST.digit_scanner.ctrl
+ vssd1 vssd1 vccd1 vccd1 _0085_ sky130_fd_sc_hd__o311a_1
X_1224_ _0385_ _0460_ vssd1 vssd1 vccd1 vccd1 _0461_ sky130_fd_sc_hd__nor2_1
X_1086_ net24 net26 _0285_ _0291_ vssd1 vssd1 vccd1 vccd1 _0323_ sky130_fd_sc_hd__a211o_4
X_1155_ _0316_ _0359_ _0363_ _0342_ _0346_ vssd1 vssd1 vccd1 vccd1 _0392_ sky130_fd_sc_hd__a32o_1
XFILLER_32_29 vssd1 vssd1 vccd1 vccd1 sky130_fd_sc_hd__fill_8
X_0939_ _0068_ net28 _0179_ vssd1 vssd1 vccd1 vccd1 _0180_ sky130_fd_sc_hd__and3_1
XFILLER_20_111 vssd1 vssd1 vccd1 vccd1 sky130_fd_sc_hd__fill_2
XFILLER_20_122 vssd1 vssd1 vccd1 vccd1 sky130_fd_sc_hd__fill_4
XTAP_TAPCELL_ROW_7_137 vssd1 vccd1 sky130_fd_sc_hd__tapvpwrvgnd_1
XFILLER_43_225 vssd1 vssd1 vccd1 vccd1 sky130_fd_sc_hd__fill_1
XANTENNA__1443__B2 STOPWATCH_INST.clock_div.cycles\[8\] vssd1 vssd1 vccd1 vccd1 sky130_fd_sc_hd__diode_2
XFILLER_11_111 vssd1 vssd1 vccd1 vccd1 sky130_fd_sc_hd__fill_1
XPHY_EDGE_ROW_5_Left_52 vssd1 vssd1 vccd1 vccd1 sky130_fd_sc_hd__decap_3
XFILLER_11_177 vssd1 vssd1 vccd1 vccd1 sky130_fd_sc_hd__fill_2
XFILLER_34_258 vssd1 vssd1 vccd1 vccd1 sky130_fd_sc_hd__fill_8
XFILLER_19_266 vssd1 vssd1 vccd1 vccd1 sky130_fd_sc_hd__fill_4
XFILLER_42_291 vssd1 vssd1 vccd1 vccd1 sky130_fd_sc_hd__fill_4
XFILLER_8_42 vccd1 vssd1 vccd1 vssd1 sky130_ef_sc_hd__decap_40_12
XTAP_TAPCELL_ROW_12_161 vssd1 vccd1 sky130_fd_sc_hd__tapvpwrvgnd_1
X_1207_ _0396_ _0436_ _0437_ _0394_ vssd1 vssd1 vccd1 vccd1 _0444_ sky130_fd_sc_hd__a2bb2o_1
XFILLER_25_203 vssd1 vssd1 vccd1 vccd1 sky130_fd_sc_hd__fill_2
XFILLER_25_214 vssd1 vssd1 vccd1 vccd1 sky130_fd_sc_hd__fill_8
X_1069_ net24 net26 vssd1 vssd1 vccd1 vccd1 _0306_ sky130_fd_sc_hd__and2_1
XFILLER_40_217 vssd1 vssd1 vccd1 vccd1 sky130_fd_sc_hd__fill_1
XTAP_TAPCELL_ROW_35_275 vssd1 vccd1 sky130_fd_sc_hd__tapvpwrvgnd_1
X_1138_ _0372_ _0373_ _0374_ vssd1 vssd1 vccd1 vccd1 _0375_ sky130_fd_sc_hd__and3_1
XFILLER_25_225 vccd1 vssd1 vccd1 vssd1 sky130_ef_sc_hd__decap_40_12
XPHY_EDGE_ROW_31_Left_78 vssd1 vssd1 vccd1 vccd1 sky130_fd_sc_hd__decap_3
XTAP_TAPCELL_ROW_26_231 vssd1 vccd1 sky130_fd_sc_hd__tapvpwrvgnd_1
XFILLER_17_95 vccd1 vssd1 vccd1 vssd1 sky130_ef_sc_hd__decap_40_12
XFILLER_3_173 vssd1 vssd1 vccd1 vccd1 sky130_fd_sc_hd__fill_2
XFILLER_15_291 vssd1 vssd1 vccd1 vccd1 sky130_fd_sc_hd__fill_8
XFILLER_22_239 vssd1 vssd1 vccd1 vccd1 sky130_fd_sc_hd__fill_1
XFILLER_30_294 vssd1 vssd1 vccd1 vccd1 sky130_fd_sc_hd__fill_4
XFILLER_38_17 vssd1 vssd1 vccd1 vccd1 sky130_fd_sc_hd__fill_1
XFILLER_13_217 vssd1 vssd1 vccd1 vccd1 sky130_fd_sc_hd__fill_4
XFILLER_0_165 vssd1 vssd1 vccd1 vccd1 sky130_fd_sc_hd__fill_2
XTAP_TAPCELL_ROW_46_337 vssd1 vccd1 sky130_fd_sc_hd__tapvpwrvgnd_1
X_1610_ clknet_3_1__leaf_clk _0028_ net46 vssd1 vssd1 vccd1 vccd1 STOPWATCH_INST.clock_div.cycles\[3\]
+ sky130_fd_sc_hd__dfrtp_1
XFILLER_12_250 vssd1 vssd1 vccd1 vccd1 sky130_fd_sc_hd__fill_2
X_1541_ STOPWATCH_INST.clock_div.cycles\[23\] _0755_ STOPWATCH_INST.clock_div.cycles\[24\]
+ vssd1 vssd1 vccd1 vccd1 _0761_ sky130_fd_sc_hd__a21o_1
X_1472_ net41 _0698_ vssd1 vssd1 vccd1 vccd1 _0703_ sky130_fd_sc_hd__or2_1
XFILLER_39_169 vccd1 vssd1 vccd1 vssd1 sky130_ef_sc_hd__decap_40_12
XFILLER_45_117 vccd1 vssd1 vccd1 vssd1 sky130_ef_sc_hd__decap_40_12
Xteam_04_71 vssd1 vssd1 vccd1 vccd1 team_04_71/HI gpio_oeb[33] sky130_fd_sc_hd__conb_1
XTAP_TAPCELL_ROW_43_318 vssd1 vccd1 sky130_fd_sc_hd__tapvpwrvgnd_1
Xteam_04_93 vssd1 vssd1 vccd1 vccd1 team_04_93/HI gpio_out[33] sky130_fd_sc_hd__conb_1
Xteam_04_60 vssd1 vssd1 vccd1 vccd1 team_04_60/HI gpio_oeb[22] sky130_fd_sc_hd__conb_1
Xteam_04_82 vssd1 vssd1 vccd1 vccd1 team_04_82/HI gpio_out[22] sky130_fd_sc_hd__conb_1
XFILLER_14_41 vssd1 vssd1 vccd1 vccd1 sky130_fd_sc_hd__fill_4
XFILLER_5_279 vssd1 vssd1 vccd1 vccd1 sky130_fd_sc_hd__fill_1
XFILLER_5_257 vccd1 vssd1 vccd1 vssd1 sky130_ef_sc_hd__decap_40_12
XFILLER_36_139 vssd1 vssd1 vccd1 vccd1 sky130_fd_sc_hd__fill_1
XPHY_EDGE_ROW_34_Left_81 vssd1 vssd1 vccd1 vccd1 sky130_fd_sc_hd__decap_3
XFILLER_44_172 vssd1 vssd1 vccd1 vccd1 sky130_fd_sc_hd__fill_1
X_0972_ _0189_ _0196_ _0208_ _0064_ vssd1 vssd1 vccd1 vccd1 _0209_ sky130_fd_sc_hd__a22o_1
X_1524_ _0642_ _0648_ _0654_ vssd1 vssd1 vccd1 vccd1 _0747_ sky130_fd_sc_hd__or3_4
XFILLER_4_290 vssd1 vssd1 vccd1 vccd1 sky130_fd_sc_hd__fill_2
X_1455_ net42 _0682_ vssd1 vssd1 vccd1 vccd1 _0689_ sky130_fd_sc_hd__nand2_1
X_1386_ _0622_ vssd1 vssd1 vccd1 vccd1 _0623_ sky130_fd_sc_hd__inv_2
XFILLER_41_186 vssd1 vssd1 vccd1 vccd1 sky130_fd_sc_hd__fill_1
XFILLER_41_120 vssd1 vssd1 vccd1 vccd1 sky130_fd_sc_hd__fill_1
XANTENNA__1427__A _0060_ vssd1 vssd1 vccd1 vccd1 sky130_fd_sc_hd__diode_2
X_1171_ _0327_ _0348_ _0364_ _0329_ vssd1 vssd1 vccd1 vccd1 _0408_ sky130_fd_sc_hd__or4b_1
X_1240_ _0471_ _0465_ _0476_ _0462_ _0422_ vssd1 vssd1 vccd1 vccd1 _0477_ sky130_fd_sc_hd__a32o_2
XFILLER_1_260 vssd1 vssd1 vccd1 vccd1 sky130_fd_sc_hd__fill_2
XFILLER_24_109 vssd1 vssd1 vccd1 vccd1 sky130_fd_sc_hd__fill_8
X_0955_ net40 _0189_ _0166_ vssd1 vssd1 vccd1 vccd1 _0192_ sky130_fd_sc_hd__o21bai_4
X_0886_ STOPWATCH_INST.digit_scanner.period_counter\[4\] _0117_ vssd1 vssd1 vccd1
+ vccd1 _0142_ sky130_fd_sc_hd__or2_1
X_1507_ _0634_ net117 _0640_ vssd1 vssd1 vccd1 vccd1 _0732_ sky130_fd_sc_hd__a21oi_1
X_1438_ net36 _0671_ _0672_ vssd1 vssd1 vccd1 vccd1 _0032_ sky130_fd_sc_hd__o21ba_1
X_1369_ _0604_ _0605_ _0549_ _0592_ vssd1 vssd1 vccd1 vccd1 _0606_ sky130_fd_sc_hd__a2bb2o_1
XFILLER_15_109 vssd1 vssd1 vccd1 vccd1 sky130_fd_sc_hd__fill_2
XFILLER_23_120 vssd1 vssd1 vccd1 vccd1 sky130_fd_sc_hd__fill_1
XFILLER_23_153 vssd1 vssd1 vccd1 vccd1 sky130_fd_sc_hd__fill_1
XFILLER_11_42 vccd1 vssd1 vccd1 vssd1 sky130_ef_sc_hd__decap_40_12
XFILLER_46_289 vssd1 vssd1 vccd1 vccd1 sky130_fd_sc_hd__fill_1
XFILLER_46_223 vssd1 vssd1 vccd1 vccd1 sky130_fd_sc_hd__fill_1
XFILLER_14_120 vssd1 vssd1 vccd1 vccd1 sky130_fd_sc_hd__fill_1
XFILLER_14_197 vssd1 vssd1 vccd1 vccd1 sky130_fd_sc_hd__fill_8
X_1223_ _0415_ net151 vssd1 vssd1 vccd1 vccd1 _0460_ sky130_fd_sc_hd__nand2_1
X_1154_ _0387_ _0390_ vssd1 vssd1 vccd1 vccd1 _0391_ sky130_fd_sc_hd__nand2_1
XFILLER_28_3 vssd1 vssd1 vccd1 vccd1 sky130_fd_sc_hd__fill_4
X_1085_ net24 net26 _0285_ vssd1 vssd1 vccd1 vccd1 _0322_ sky130_fd_sc_hd__a21oi_1
XFILLER_20_101 vssd1 vssd1 vccd1 vccd1 sky130_fd_sc_hd__fill_1
X_0938_ STOPWATCH_INST.clock_div.cycles\[0\] STOPWATCH_INST.clock_div.cycles\[1\]
+ STOPWATCH_INST.clock_div.cycles\[3\] STOPWATCH_INST.clock_div.cycles\[2\] vssd1
+ vssd1 vccd1 vccd1 _0179_ sky130_fd_sc_hd__and4_1
X_0869_ STOPWATCH_INST.bcd_num\[4\] _0131_ vssd1 vssd1 vccd1 vccd1 _0132_ sky130_fd_sc_hd__or2_1
XTAP_TAPCELL_ROW_7_138 vssd1 vccd1 sky130_fd_sc_hd__tapvpwrvgnd_1
XFILLER_11_167 vssd1 vssd1 vccd1 vccd1 sky130_fd_sc_hd__fill_1
XFILLER_22_85 vssd1 vssd1 vccd1 vccd1 sky130_fd_sc_hd__fill_4
XANTENNA__1440__A STOPWATCH_INST.clock_div.cycles\[7\] vssd1 vssd1 vccd1 vccd1 sky130_fd_sc_hd__diode_2
XFILLER_8_54 vssd1 vssd1 vccd1 vccd1 sky130_fd_sc_hd__fill_4
XTAP_TAPCELL_ROW_12_162 vssd1 vccd1 sky130_fd_sc_hd__tapvpwrvgnd_1
XTAP_TAPCELL_ROW_4_119 vssd1 vccd1 sky130_fd_sc_hd__tapvpwrvgnd_1
XFILLER_6_182 vccd1 vssd1 vccd1 vssd1 sky130_ef_sc_hd__decap_40_12
X_1206_ _0440_ _0441_ _0437_ _0438_ vssd1 vssd1 vccd1 vccd1 _0443_ sky130_fd_sc_hd__o211ai_2
X_1137_ _0313_ _0369_ vssd1 vssd1 vccd1 vccd1 _0374_ sky130_fd_sc_hd__xor2_1
XFILLER_25_237 vccd1 vssd1 vccd1 vssd1 sky130_ef_sc_hd__decap_40_12
X_1068_ _0237_ _0304_ vssd1 vssd1 vccd1 vccd1 _0305_ sky130_fd_sc_hd__xor2_1
XTAP_TAPCELL_ROW_35_276 vssd1 vccd1 sky130_fd_sc_hd__tapvpwrvgnd_1
XTAP_TAPCELL_ROW_26_232 vssd1 vccd1 sky130_fd_sc_hd__tapvpwrvgnd_1
XFILLER_16_226 vssd1 vssd1 vccd1 vccd1 sky130_fd_sc_hd__fill_2
XANTENNA_fanout38_X net38 vssd1 vssd1 vccd1 vccd1 sky130_fd_sc_hd__diode_2
XFILLER_24_270 vccd1 vssd1 vccd1 vssd1 sky130_ef_sc_hd__decap_40_12
XANTENNA__1435__A STOPWATCH_INST.clock_div.cycles\[7\] vssd1 vssd1 vccd1 vccd1 sky130_fd_sc_hd__diode_2
XFILLER_38_29 vssd1 vssd1 vccd1 vccd1 sky130_fd_sc_hd__fill_8
XTAP_TAPCELL_ROW_0_100 vssd1 vccd1 sky130_fd_sc_hd__tapvpwrvgnd_1
XFILLER_0_111 vssd1 vssd1 vccd1 vccd1 sky130_fd_sc_hd__fill_1
XTAP_TAPCELL_ROW_46_338 vssd1 vccd1 sky130_fd_sc_hd__tapvpwrvgnd_1
XFILLER_28_95 vssd1 vssd1 vccd1 vccd1 sky130_fd_sc_hd__fill_1
XFILLER_5_55 vssd1 vssd1 vccd1 vccd1 sky130_fd_sc_hd__fill_1
X_1540_ STOPWATCH_INST.clock_div.cycles\[23\] net36 net33 _0760_ vssd1 vssd1 vccd1
+ vccd1 _0048_ sky130_fd_sc_hd__a22o_1
XFILLER_5_66 vccd1 vssd1 vccd1 vssd1 sky130_ef_sc_hd__decap_40_12
X_1471_ _0611_ _0616_ net126 _0701_ net30 vssd1 vssd1 vccd1 vccd1 _0702_ sky130_fd_sc_hd__a311o_1
Xteam_04_72 vssd1 vssd1 vccd1 vccd1 team_04_72/HI gpio_out[0] sky130_fd_sc_hd__conb_1
XFILLER_45_129 vssd1 vssd1 vccd1 vccd1 sky130_fd_sc_hd__fill_2
Xteam_04_61 vssd1 vssd1 vccd1 vccd1 team_04_61/HI gpio_oeb[23] sky130_fd_sc_hd__conb_1
Xteam_04_50 vssd1 vssd1 vccd1 vccd1 team_04_50/HI gpio_oeb[0] sky130_fd_sc_hd__conb_1
Xteam_04_94 vssd1 vssd1 vccd1 vccd1 gpio_oeb[4] team_04_94/LO sky130_fd_sc_hd__conb_1
Xteam_04_83 vssd1 vssd1 vccd1 vccd1 team_04_83/HI gpio_out[23] sky130_fd_sc_hd__conb_1
XFILLER_30_41 vccd1 vssd1 vccd1 vssd1 sky130_ef_sc_hd__decap_40_12
XFILLER_5_269 vssd1 vssd1 vccd1 vccd1 sky130_fd_sc_hd__fill_4
XFILLER_39_94 vssd1 vssd1 vccd1 vccd1 sky130_fd_sc_hd__fill_2
XFILLER_44_195 vssd1 vssd1 vccd1 vccd1 sky130_fd_sc_hd__fill_1
X_0971_ _0187_ _0194_ _0188_ _0063_ vssd1 vssd1 vccd1 vccd1 _0208_ sky130_fd_sc_hd__a211o_1
X_1454_ _0602_ _0654_ _0687_ net28 vssd1 vssd1 vccd1 vccd1 _0688_ sky130_fd_sc_hd__a211o_1
X_1523_ _0642_ _0654_ _0648_ vssd1 vssd1 vccd1 vccd1 _0746_ sky130_fd_sc_hd__o21a_1
X_1385_ _0559_ _0570_ vssd1 vssd1 vccd1 vccd1 _0622_ sky130_fd_sc_hd__nor2_1
XFILLER_35_184 vssd1 vssd1 vccd1 vccd1 sky130_fd_sc_hd__fill_2
XFILLER_2_228 vssd1 vssd1 vccd1 vccd1 sky130_fd_sc_hd__fill_1
XFILLER_26_195 vssd1 vssd1 vccd1 vccd1 sky130_fd_sc_hd__fill_1
XFILLER_25_63 vssd1 vssd1 vccd1 vccd1 sky130_fd_sc_hd__fill_2
X_1170_ _0404_ _0405_ vssd1 vssd1 vccd1 vccd1 _0407_ sky130_fd_sc_hd__nand2_1
X_0954_ net40 _0189_ _0166_ vssd1 vssd1 vccd1 vccd1 _0191_ sky130_fd_sc_hd__o21ba_4
X_0885_ STOPWATCH_INST.digit_scanner.period_counter\[4\] _0117_ vssd1 vssd1 vccd1
+ vccd1 _0141_ sky130_fd_sc_hd__nand2_1
X_1437_ STOPWATCH_INST.clock_div.cycles\[7\] _0654_ vssd1 vssd1 vccd1 vccd1 _0674_
+ sky130_fd_sc_hd__or2_4
X_1506_ _0727_ net33 _0731_ net37 STOPWATCH_INST.clock_div.cycles\[18\] vssd1 vssd1
+ vccd1 vccd1 _0043_ sky130_fd_sc_hd__a32o_1
XFILLER_46_29 vccd1 vssd1 vccd1 vssd1 sky130_ef_sc_hd__decap_40_12
X_1368_ _0549_ _0554_ vssd1 vssd1 vccd1 vccd1 _0605_ sky130_fd_sc_hd__nor2_1
X_1299_ _0516_ _0535_ vssd1 vssd1 vccd1 vccd1 _0536_ sky130_fd_sc_hd__nand2_1
XTAP_TAPCELL_ROW_18_190 vssd1 vccd1 sky130_fd_sc_hd__tapvpwrvgnd_1
XFILLER_11_54 vssd1 vssd1 vccd1 vccd1 sky130_fd_sc_hd__fill_2
Xteam_04_100 vssd1 vssd1 vccd1 vccd1 gpio_oeb[10] team_04_100/LO sky130_fd_sc_hd__conb_1
XFILLER_46_279 vssd1 vssd1 vccd1 vccd1 sky130_fd_sc_hd__fill_1
XFILLER_42_6 vssd1 vssd1 vccd1 vccd1 sky130_fd_sc_hd__fill_8
X_1084_ _0299_ _0318_ vssd1 vssd1 vccd1 vccd1 _0321_ sky130_fd_sc_hd__xnor2_4
X_1153_ _0343_ _0365_ _0388_ _0389_ vssd1 vssd1 vccd1 vccd1 _0390_ sky130_fd_sc_hd__o22a_1
X_1222_ net21 vssd1 vssd1 vccd1 vccd1 _0459_ sky130_fd_sc_hd__inv_2
X_0868_ _0131_ _0123_ _0129_ vssd1 vssd1 vccd1 vccd1 _0004_ sky130_fd_sc_hd__and3b_1
X_0937_ net208 _0177_ vssd1 vssd1 vccd1 vccd1 _0027_ sky130_fd_sc_hd__xnor2_1
X_0799_ STOPWATCH_INST.fsm_inst1.currentState\[1\] _0058_ vssd1 vssd1 vccd1 vccd1
+ _0076_ sky130_fd_sc_hd__nand2_1
XFILLER_43_249 vssd1 vssd1 vccd1 vccd1 sky130_fd_sc_hd__fill_2
XFILLER_28_224 vssd1 vssd1 vccd1 vccd1 sky130_fd_sc_hd__fill_4
XANTENNA__1440__B STOPWATCH_INST.clock_div.cycles\[8\] vssd1 vssd1 vccd1 vccd1 sky130_fd_sc_hd__diode_2
Xclkbuf_3_4__f_clk clknet_0_clk vssd1 vssd1 vccd1 vccd1 clknet_3_4__leaf_clk sky130_fd_sc_hd__clkbuf_16
XFILLER_6_194 vssd1 vssd1 vccd1 vccd1 sky130_fd_sc_hd__fill_2
XTAP_TAPCELL_ROW_12_163 vssd1 vccd1 sky130_fd_sc_hd__tapvpwrvgnd_1
X_1067_ _0232_ _0294_ _0249_ vssd1 vssd1 vccd1 vccd1 _0304_ sky130_fd_sc_hd__o21a_1
X_1136_ _0311_ _0366_ vssd1 vssd1 vccd1 vccd1 _0373_ sky130_fd_sc_hd__xor2_2
X_1205_ _0440_ _0441_ vssd1 vssd1 vccd1 vccd1 _0442_ sky130_fd_sc_hd__or2_2
XFILLER_25_205 vssd1 vssd1 vccd1 vccd1 sky130_fd_sc_hd__fill_1
XFILLER_25_249 vssd1 vssd1 vccd1 vccd1 sky130_fd_sc_hd__fill_8
XTAP_TAPCELL_ROW_35_277 vssd1 vccd1 sky130_fd_sc_hd__tapvpwrvgnd_1
XFILLER_17_31 vssd1 vssd1 vccd1 vccd1 sky130_fd_sc_hd__fill_8
XTAP_TAPCELL_ROW_26_233 vssd1 vccd1 sky130_fd_sc_hd__tapvpwrvgnd_1
XFILLER_24_282 vccd1 vssd1 vccd1 vssd1 sky130_ef_sc_hd__decap_40_12
XFILLER_12_7 vssd1 vssd1 vccd1 vccd1 sky130_fd_sc_hd__fill_8
XTAP_TAPCELL_ROW_0_101 vssd1 vccd1 sky130_fd_sc_hd__tapvpwrvgnd_1
XANTENNA__1361__A STOPWATCH_INST.clock_div.cycles\[7\] vssd1 vssd1 vccd1 vccd1 sky130_fd_sc_hd__diode_2
X_1119_ _0257_ _0355_ vssd1 vssd1 vccd1 vccd1 _0356_ sky130_fd_sc_hd__xor2_4
XTAP_TAPCELL_ROW_23_214 vssd1 vccd1 sky130_fd_sc_hd__tapvpwrvgnd_1
XPHY_EDGE_ROW_17_Right_17 vssd1 vssd1 vccd1 vccd1 sky130_fd_sc_hd__decap_3
XPHY_EDGE_ROW_26_Right_26 vssd1 vssd1 vccd1 vccd1 sky130_fd_sc_hd__decap_3
XFILLER_0_167 vssd1 vssd1 vccd1 vccd1 sky130_fd_sc_hd__fill_1
XFILLER_28_85 vssd1 vssd1 vccd1 vccd1 sky130_fd_sc_hd__fill_8
XPHY_EDGE_ROW_35_Right_35 vssd1 vssd1 vccd1 vccd1 sky130_fd_sc_hd__decap_3
XFILLER_12_274 vssd1 vssd1 vccd1 vccd1 sky130_fd_sc_hd__fill_2
XFILLER_5_78 vccd1 vssd1 vccd1 vssd1 sky130_ef_sc_hd__decap_40_12
X_1470_ _0611_ net15 _0616_ vssd1 vssd1 vccd1 vccd1 _0701_ sky130_fd_sc_hd__a21oi_1
XPHY_EDGE_ROW_44_Right_44 vssd1 vssd1 vccd1 vccd1 sky130_fd_sc_hd__decap_3
X_1599_ clknet_3_5__leaf_clk _0017_ vssd1 vssd1 vccd1 vccd1 STOPWATCH_INST.digit_scanner.period_counter\[8\]
+ sky130_fd_sc_hd__dfxtp_1
Xteam_04_73 vssd1 vssd1 vccd1 vccd1 team_04_73/HI gpio_out[1] sky130_fd_sc_hd__conb_1
Xteam_04_95 vssd1 vssd1 vccd1 vccd1 gpio_oeb[5] team_04_95/LO sky130_fd_sc_hd__conb_1
Xteam_04_84 vssd1 vssd1 vccd1 vccd1 team_04_84/HI gpio_out[24] sky130_fd_sc_hd__conb_1
Xteam_04_51 vssd1 vssd1 vccd1 vccd1 team_04_51/HI gpio_oeb[1] sky130_fd_sc_hd__conb_1
Xteam_04_62 vssd1 vssd1 vccd1 vccd1 team_04_62/HI gpio_oeb[24] sky130_fd_sc_hd__conb_1
XFILLER_30_53 vssd1 vssd1 vccd1 vccd1 sky130_fd_sc_hd__fill_2
XFILLER_44_163 vssd1 vssd1 vccd1 vccd1 sky130_fd_sc_hd__fill_1
X_0970_ _0187_ _0194_ _0188_ vssd1 vssd1 vccd1 vccd1 _0207_ sky130_fd_sc_hd__a21oi_1
XFILLER_4_292 vssd1 vssd1 vccd1 vccd1 sky130_fd_sc_hd__fill_1
X_1453_ _0603_ net15 _0685_ vssd1 vssd1 vccd1 vccd1 _0687_ sky130_fd_sc_hd__and3_1
X_1522_ _0642_ _0654_ vssd1 vssd1 vccd1 vccd1 _0745_ sky130_fd_sc_hd__nor2_1
X_1384_ _0617_ _0607_ _0619_ vssd1 vssd1 vccd1 vccd1 _0621_ sky130_fd_sc_hd__a21oi_4
XANTENNA__1623__RESET_B net49 vssd1 vssd1 vccd1 vccd1 sky130_fd_sc_hd__diode_2
XFILLER_41_111 vssd1 vssd1 vccd1 vccd1 sky130_fd_sc_hd__fill_1
XFILLER_25_42 vssd1 vssd1 vccd1 vccd1 sky130_fd_sc_hd__fill_2
XFILLER_41_30 vccd1 vssd1 vccd1 vssd1 sky130_ef_sc_hd__decap_40_12
XFILLER_37_9 vccd1 vssd1 vccd1 vssd1 sky130_ef_sc_hd__decap_40_12
X_0953_ net40 _0189_ vssd1 vssd1 vccd1 vccd1 _0190_ sky130_fd_sc_hd__or2_1
X_0884_ _0117_ _0140_ vssd1 vssd1 vccd1 vccd1 _0012_ sky130_fd_sc_hd__nor2_1
X_1436_ _0068_ _0671_ vssd1 vssd1 vccd1 vccd1 _0673_ sky130_fd_sc_hd__and2_1
X_1367_ net109 _0591_ _0556_ vssd1 vssd1 vccd1 vccd1 _0604_ sky130_fd_sc_hd__a21o_1
X_1505_ _0728_ _0729_ net30 vssd1 vssd1 vccd1 vccd1 _0731_ sky130_fd_sc_hd__o21ai_1
XFILLER_23_100 vssd1 vssd1 vccd1 vccd1 sky130_fd_sc_hd__fill_2
XFILLER_23_111 vssd1 vssd1 vccd1 vccd1 sky130_fd_sc_hd__fill_1
X_1298_ _0514_ _0517_ vssd1 vssd1 vccd1 vccd1 _0535_ sky130_fd_sc_hd__or2_1
XTAP_TAPCELL_ROW_18_191 vssd1 vccd1 sky130_fd_sc_hd__tapvpwrvgnd_1
Xteam_04_101 vssd1 vssd1 vccd1 vccd1 gpio_oeb[11] team_04_101/LO sky130_fd_sc_hd__conb_1
XFILLER_2_6 vssd1 vssd1 vccd1 vccd1 sky130_fd_sc_hd__fill_1
XFILLER_46_225 vccd1 vssd1 vccd1 vssd1 sky130_ef_sc_hd__decap_40_12
XFILLER_35_6 vssd1 vssd1 vccd1 vccd1 sky130_fd_sc_hd__fill_4
X_1221_ _0447_ _0453_ _0455_ _0456_ vssd1 vssd1 vccd1 vccd1 _0458_ sky130_fd_sc_hd__nor4_2
X_1083_ _0297_ _0319_ _0301_ _0306_ vssd1 vssd1 vccd1 vccd1 _0320_ sky130_fd_sc_hd__o2bb2a_4
X_1152_ _0343_ _0344_ vssd1 vssd1 vccd1 vccd1 _0389_ sky130_fd_sc_hd__and2_1
XFILLER_37_225 vccd1 vssd1 vccd1 vssd1 sky130_ef_sc_hd__decap_40_12
X_0936_ _0177_ _0178_ vssd1 vssd1 vccd1 vccd1 _0026_ sky130_fd_sc_hd__and2_1
XFILLER_20_136 vssd1 vssd1 vccd1 vccd1 sky130_fd_sc_hd__fill_4
X_0867_ _0111_ _0130_ STOPWATCH_INST.bcd_num\[3\] STOPWATCH_INST.clock_div.second_tick
+ vssd1 vssd1 vccd1 vccd1 _0131_ sky130_fd_sc_hd__o211a_1
X_0798_ STOPWATCH_INST.fsm_inst1.currentState\[1\] _0058_ _0074_ vssd1 vssd1 vccd1
+ vccd1 _0075_ sky130_fd_sc_hd__or3b_1
X_1419_ STOPWATCH_INST.clock_div.cycles\[4\] STOPWATCH_INST.clock_div.cycles\[5\]
+ STOPWATCH_INST.clock_div.cycles\[6\] _0179_ vssd1 vssd1 vccd1 vccd1 _0656_ sky130_fd_sc_hd__and4_1
XFILLER_36_291 vssd1 vssd1 vccd1 vccd1 sky130_fd_sc_hd__fill_4
XFILLER_11_147 vssd1 vssd1 vccd1 vccd1 sky130_fd_sc_hd__fill_4
XFILLER_11_169 vssd1 vssd1 vccd1 vccd1 sky130_fd_sc_hd__fill_8
XFILLER_34_217 vccd1 vssd1 vccd1 vssd1 sky130_ef_sc_hd__decap_40_12
XFILLER_19_225 vccd1 vssd1 vccd1 vssd1 sky130_ef_sc_hd__decap_40_12
XFILLER_42_261 vssd1 vssd1 vccd1 vccd1 sky130_fd_sc_hd__fill_2
XFILLER_42_250 vssd1 vssd1 vccd1 vccd1 sky130_fd_sc_hd__fill_2
XFILLER_8_78 vssd1 vssd1 vccd1 vccd1 sky130_fd_sc_hd__fill_2
X_1204_ _0387_ _0390_ net22 vssd1 vssd1 vccd1 vccd1 _0441_ sky130_fd_sc_hd__and3_1
X_1066_ _0300_ _0293_ _0302_ vssd1 vssd1 vccd1 vccd1 _0303_ sky130_fd_sc_hd__a21bo_1
XFILLER_40_209 vssd1 vssd1 vccd1 vccd1 sky130_fd_sc_hd__fill_8
XTAP_TAPCELL_ROW_35_278 vssd1 vccd1 sky130_fd_sc_hd__tapvpwrvgnd_1
X_1135_ STOPWATCH_INST.clock_div.cycles\[11\] _0370_ _0369_ vssd1 vssd1 vccd1 vccd1
+ _0372_ sky130_fd_sc_hd__or3_4
Xclone19 _0417_ vssd1 vssd1 vccd1 vccd1 net127 sky130_fd_sc_hd__clkbuf_1
X_0919_ STOPWATCH_INST.clock_div.cycles\[7\] _0162_ STOPWATCH_INST.clock_div.cycles\[8\]
+ vssd1 vssd1 vccd1 vccd1 _0163_ sky130_fd_sc_hd__a21o_1
XPHY_EDGE_ROW_9_Left_56 vssd1 vssd1 vccd1 vccd1 sky130_fd_sc_hd__decap_3
Xclone1 _0568_ _0587_ _0589_ vssd1 vssd1 vccd1 vccd1 net109 sky130_fd_sc_hd__o21ai_4
XFILLER_17_54 vssd1 vssd1 vccd1 vccd1 sky130_fd_sc_hd__fill_2
XFILLER_33_31 vssd1 vssd1 vccd1 vccd1 sky130_fd_sc_hd__fill_1
XFILLER_24_261 vssd1 vssd1 vccd1 vccd1 sky130_fd_sc_hd__fill_2
XFILLER_24_294 vssd1 vssd1 vccd1 vccd1 sky130_fd_sc_hd__fill_4
XFILLER_3_121 vssd1 vssd1 vccd1 vccd1 sky130_fd_sc_hd__fill_1
XTAP_TAPCELL_ROW_32_259 vssd1 vccd1 sky130_fd_sc_hd__tapvpwrvgnd_1
XTAP_TAPCELL_ROW_0_102 vssd1 vccd1 sky130_fd_sc_hd__tapvpwrvgnd_1
X_1118_ net25 net26 _0261_ _0281_ vssd1 vssd1 vccd1 vccd1 _0355_ sky130_fd_sc_hd__a211oi_2
X_1049_ _0225_ _0236_ vssd1 vssd1 vccd1 vccd1 _0286_ sky130_fd_sc_hd__nor2_1
XFILLER_21_264 vssd1 vssd1 vccd1 vccd1 sky130_fd_sc_hd__fill_1
XTAP_TAPCELL_ROW_23_215 vssd1 vccd1 sky130_fd_sc_hd__tapvpwrvgnd_1
XFILLER_28_31 vssd1 vssd1 vccd1 vccd1 sky130_fd_sc_hd__fill_1
XFILLER_0_113 vccd1 vssd1 vccd1 vssd1 sky130_ef_sc_hd__decap_40_12
XTAP_TAPCELL_ROW_46_329 vssd1 vccd1 sky130_fd_sc_hd__tapvpwrvgnd_1
XFILLER_44_41 vssd1 vssd1 vccd1 vccd1 sky130_fd_sc_hd__fill_2
XFILLER_28_53 vssd1 vssd1 vccd1 vccd1 sky130_fd_sc_hd__fill_1
XFILLER_5_57 vssd1 vssd1 vccd1 vccd1 sky130_fd_sc_hd__fill_2
X_1598_ clknet_3_5__leaf_clk _0016_ vssd1 vssd1 vccd1 vccd1 STOPWATCH_INST.digit_scanner.period_counter\[7\]
+ sky130_fd_sc_hd__dfxtp_1
Xteam_04_85 vssd1 vssd1 vccd1 vccd1 team_04_85/HI gpio_out[25] sky130_fd_sc_hd__conb_1
Xteam_04_63 vssd1 vssd1 vccd1 vccd1 team_04_63/HI gpio_oeb[25] sky130_fd_sc_hd__conb_1
XFILLER_38_172 vccd1 vssd1 vccd1 vssd1 sky130_ef_sc_hd__decap_40_12
Xteam_04_74 vssd1 vssd1 vccd1 vccd1 team_04_74/HI gpio_out[2] sky130_fd_sc_hd__conb_1
Xteam_04_52 vssd1 vssd1 vccd1 vccd1 team_04_52/HI gpio_oeb[2] sky130_fd_sc_hd__conb_1
Xteam_04_96 vssd1 vssd1 vccd1 vccd1 gpio_oeb[6] team_04_96/LO sky130_fd_sc_hd__conb_1
XFILLER_30_76 vssd1 vssd1 vccd1 vccd1 sky130_fd_sc_hd__fill_8
XFILLER_5_216 vssd1 vssd1 vccd1 vccd1 sky130_fd_sc_hd__fill_2
XFILLER_44_197 vssd1 vssd1 vccd1 vccd1 sky130_fd_sc_hd__fill_1
XTAP_TAPCELL_ROW_42_310 vssd1 vccd1 sky130_fd_sc_hd__tapvpwrvgnd_1
X_1452_ _0603_ net15 vssd1 vssd1 vccd1 vccd1 _0686_ sky130_fd_sc_hd__nand2_1
X_1521_ STOPWATCH_INST.clock_div.cycles\[20\] net36 _0744_ net33 vssd1 vssd1 vccd1
+ vccd1 _0045_ sky130_fd_sc_hd__a22o_1
X_1383_ _0611_ _0615_ _0616_ vssd1 vssd1 vccd1 vccd1 _0620_ sky130_fd_sc_hd__nand3_1
XFILLER_26_164 vssd1 vssd1 vccd1 vccd1 sky130_fd_sc_hd__fill_1
XFILLER_25_65 vssd1 vssd1 vccd1 vccd1 sky130_fd_sc_hd__fill_1
XFILLER_26_120 vssd1 vssd1 vccd1 vccd1 sky130_fd_sc_hd__fill_1
XFILLER_41_64 vssd1 vssd1 vccd1 vccd1 sky130_fd_sc_hd__fill_4
XFILLER_41_42 vssd1 vssd1 vccd1 vccd1 sky130_fd_sc_hd__fill_4
XPHY_EDGE_ROW_38_Left_85 vssd1 vssd1 vccd1 vccd1 sky130_fd_sc_hd__decap_3
XPHY_EDGE_ROW_22_Left_69 vssd1 vssd1 vccd1 vccd1 sky130_fd_sc_hd__decap_3
XFILLER_32_189 vssd1 vssd1 vccd1 vccd1 sky130_fd_sc_hd__fill_2
XFILLER_32_145 vccd1 vssd1 vccd1 vssd1 sky130_ef_sc_hd__decap_40_12
X_0952_ STOPWATCH_INST.clock_div.cycles\[15\] STOPWATCH_INST.clock_div.cycles\[16\]
+ STOPWATCH_INST.clock_div.cycles\[17\] STOPWATCH_INST.clock_div.cycles\[18\] vssd1
+ vssd1 vccd1 vccd1 _0189_ sky130_fd_sc_hd__o211a_4
X_0883_ net194 _0116_ vssd1 vssd1 vccd1 vccd1 _0140_ sky130_fd_sc_hd__nor2_1
X_1504_ STOPWATCH_INST.clock_div.cycles\[16\] STOPWATCH_INST.clock_div.cycles\[17\]
+ STOPWATCH_INST.clock_div.cycles\[18\] _0714_ vssd1 vssd1 vccd1 vccd1 _0730_ sky130_fd_sc_hd__and4_1
X_1435_ STOPWATCH_INST.clock_div.cycles\[7\] _0659_ vssd1 vssd1 vccd1 vccd1 _0672_
+ sky130_fd_sc_hd__xnor2_1
X_1366_ _0597_ _0600_ _0602_ vssd1 vssd1 vccd1 vccd1 _0603_ sky130_fd_sc_hd__or3b_1
XTAP_TAPCELL_ROW_18_192 vssd1 vccd1 sky130_fd_sc_hd__tapvpwrvgnd_1
X_1297_ _0474_ _0529_ _0525_ _0533_ vssd1 vssd1 vccd1 vccd1 _0534_ sky130_fd_sc_hd__o31ai_4
Xteam_04_102 vssd1 vssd1 vccd1 vccd1 gpio_oeb[12] team_04_102/LO sky130_fd_sc_hd__conb_1
XFILLER_46_237 vccd1 vssd1 vccd1 vssd1 sky130_ef_sc_hd__decap_40_12
XFILLER_36_64 vssd1 vssd1 vccd1 vccd1 sky130_fd_sc_hd__fill_1
XFILLER_36_31 vssd1 vssd1 vccd1 vccd1 sky130_fd_sc_hd__fill_4
X_1151_ _0317_ _0360_ _0362_ _0346_ vssd1 vssd1 vccd1 vccd1 _0388_ sky130_fd_sc_hd__o31ai_2
X_1220_ _0455_ _0456_ vssd1 vssd1 vccd1 vccd1 _0457_ sky130_fd_sc_hd__or2_1
X_1082_ _0299_ _0318_ vssd1 vssd1 vccd1 vccd1 _0319_ sky130_fd_sc_hd__or2_1
XFILLER_45_281 vccd1 vssd1 vccd1 vssd1 sky130_ef_sc_hd__decap_40_12
XFILLER_37_237 vccd1 vssd1 vccd1 vssd1 sky130_ef_sc_hd__decap_40_12
X_0935_ STOPWATCH_INST.clock_div.cycles\[1\] _0175_ vssd1 vssd1 vccd1 vccd1 _0178_
+ sky130_fd_sc_hd__or2_1
X_0866_ STOPWATCH_INST.bcd_num\[2\] _0088_ vssd1 vssd1 vccd1 vccd1 _0130_ sky130_fd_sc_hd__and2b_1
XFILLER_20_126 vssd1 vssd1 vccd1 vccd1 sky130_fd_sc_hd__fill_2
X_0797_ _0065_ STOPWATCH_INST.sync_clear.q _0073_ vssd1 vssd1 vccd1 vccd1 _0074_ sky130_fd_sc_hd__or3_1
X_1418_ _0646_ _0645_ net125 _0653_ vssd1 vssd1 vccd1 vccd1 _0655_ sky130_fd_sc_hd__o31ai_4
X_1349_ _0568_ _0570_ _0585_ _0577_ vssd1 vssd1 vccd1 vccd1 _0586_ sky130_fd_sc_hd__or4_4
XFILLER_11_104 vssd1 vssd1 vccd1 vccd1 sky130_fd_sc_hd__fill_2
XFILLER_22_66 vccd1 vssd1 vccd1 vssd1 sky130_ef_sc_hd__decap_40_12
XTAP_TAPCELL_ROW_6_130 vssd1 vccd1 sky130_fd_sc_hd__tapvpwrvgnd_1
XANTENNA__1364__A1 STOPWATCH_INST.clock_div.cycles\[8\] vssd1 vssd1 vccd1 vccd1 sky130_fd_sc_hd__diode_2
XFILLER_34_229 vssd1 vssd1 vccd1 vccd1 sky130_fd_sc_hd__fill_4
XFILLER_27_270 vssd1 vssd1 vccd1 vccd1 sky130_fd_sc_hd__fill_4
XFILLER_19_237 vssd1 vssd1 vccd1 vccd1 sky130_fd_sc_hd__fill_1
XFILLER_42_295 vssd1 vssd1 vccd1 vccd1 sky130_fd_sc_hd__fill_1
XFILLER_8_24 vssd1 vssd1 vccd1 vccd1 sky130_fd_sc_hd__fill_4
XFILLER_6_141 vccd1 vssd1 vccd1 vssd1 sky130_ef_sc_hd__decap_40_12
X_1203_ _0387_ net22 _0390_ vssd1 vssd1 vccd1 vccd1 _0440_ sky130_fd_sc_hd__a21oi_1
X_1134_ _0369_ _0370_ vssd1 vssd1 vccd1 vccd1 _0371_ sky130_fd_sc_hd__or2_1
XPHY_EDGE_ROW_25_Left_72 vssd1 vssd1 vccd1 vccd1 sky130_fd_sc_hd__decap_3
X_1065_ net134 _0296_ vssd1 vssd1 vccd1 vccd1 _0302_ sky130_fd_sc_hd__xnor2_1
XFILLER_33_295 vssd1 vssd1 vccd1 vccd1 sky130_fd_sc_hd__fill_4
XFILLER_18_292 vssd1 vssd1 vccd1 vccd1 sky130_fd_sc_hd__fill_4
X_0918_ STOPWATCH_INST.clock_div.cycles\[4\] STOPWATCH_INST.clock_div.cycles\[5\]
+ STOPWATCH_INST.clock_div.cycles\[6\] _0161_ vssd1 vssd1 vccd1 vccd1 _0162_ sky130_fd_sc_hd__or4_1
X_0849_ STOPWATCH_INST.digit_scanner.period_counter\[3\] _0116_ vssd1 vssd1 vccd1
+ vccd1 _0117_ sky130_fd_sc_hd__and2_1
XFILLER_17_77 vssd1 vssd1 vccd1 vccd1 sky130_fd_sc_hd__fill_2
XFILLER_24_251 vssd1 vssd1 vccd1 vccd1 sky130_fd_sc_hd__fill_1
XFILLER_30_298 vssd1 vssd1 vccd1 vccd1 sky130_fd_sc_hd__fill_1
X_1117_ _0290_ _0322_ vssd1 vssd1 vccd1 vccd1 _0354_ sky130_fd_sc_hd__xnor2_2
XTAP_TAPCELL_ROW_0_103 vssd1 vccd1 sky130_fd_sc_hd__tapvpwrvgnd_1
X_1048_ _0257_ _0282_ _0284_ vssd1 vssd1 vccd1 vccd1 _0285_ sky130_fd_sc_hd__and3_1
XPHY_EDGE_ROW_3_Right_3 vssd1 vssd1 vccd1 vccd1 sky130_fd_sc_hd__decap_3
XTAP_TAPCELL_ROW_23_216 vssd1 vccd1 sky130_fd_sc_hd__tapvpwrvgnd_1
XANTENNA__1617__RESET_B net47 vssd1 vssd1 vccd1 vccd1 sky130_fd_sc_hd__diode_2
XFILLER_21_298 vssd1 vssd1 vccd1 vccd1 sky130_fd_sc_hd__fill_1
XFILLER_0_125 vccd1 vssd1 vccd1 vssd1 sky130_ef_sc_hd__decap_40_12
XFILLER_0_169 vccd1 vssd1 vccd1 vssd1 sky130_ef_sc_hd__decap_40_12
XFILLER_8_247 vssd1 vssd1 vccd1 vccd1 sky130_fd_sc_hd__fill_4
XFILLER_12_232 vssd1 vssd1 vccd1 vccd1 sky130_fd_sc_hd__fill_2
XFILLER_12_276 vssd1 vssd1 vccd1 vccd1 sky130_fd_sc_hd__fill_1
X_1597_ clknet_3_5__leaf_clk _0015_ vssd1 vssd1 vccd1 vccd1 STOPWATCH_INST.digit_scanner.period_counter\[6\]
+ sky130_fd_sc_hd__dfxtp_1
Xteam_04_64 vssd1 vssd1 vccd1 vccd1 team_04_64/HI gpio_oeb[26] sky130_fd_sc_hd__conb_1
Xteam_04_97 vssd1 vssd1 vccd1 vccd1 gpio_oeb[7] team_04_97/LO sky130_fd_sc_hd__conb_1
Xteam_04_53 vssd1 vssd1 vccd1 vccd1 team_04_53/HI gpio_oeb[3] sky130_fd_sc_hd__conb_1
XFILLER_38_184 vssd1 vssd1 vccd1 vccd1 sky130_fd_sc_hd__fill_4
Xteam_04_86 vssd1 vssd1 vccd1 vccd1 team_04_86/HI gpio_out[26] sky130_fd_sc_hd__conb_1
Xteam_04_75 vssd1 vssd1 vccd1 vccd1 team_04_75/HI gpio_out[3] sky130_fd_sc_hd__conb_1
XFILLER_39_31 vssd1 vssd1 vccd1 vccd1 sky130_fd_sc_hd__fill_4
XFILLER_29_151 vssd1 vssd1 vccd1 vccd1 sky130_fd_sc_hd__fill_8
XTAP_TAPCELL_ROW_42_311 vssd1 vccd1 sky130_fd_sc_hd__tapvpwrvgnd_1
XFILLER_4_250 vssd1 vssd1 vccd1 vccd1 sky130_fd_sc_hd__fill_2
X_1520_ _0174_ _0740_ _0739_ _0743_ vssd1 vssd1 vccd1 vccd1 _0744_ sky130_fd_sc_hd__a31oi_1
X_1451_ _0598_ _0599_ _0602_ vssd1 vssd1 vccd1 vccd1 _0685_ sky130_fd_sc_hd__a21o_1
X_1382_ _0615_ _0616_ _0618_ vssd1 vssd1 vccd1 vccd1 _0619_ sky130_fd_sc_hd__a21oi_1
XFILLER_35_154 vssd1 vssd1 vccd1 vccd1 sky130_fd_sc_hd__fill_4
XANTENNA_input5_A nrst vssd1 vssd1 vccd1 vccd1 sky130_fd_sc_hd__diode_2
Xrebuffer40 net147 vssd1 vssd1 vccd1 vccd1 net148 sky130_fd_sc_hd__dlymetal6s2s_1
XFILLER_25_55 vssd1 vssd1 vccd1 vccd1 sky130_fd_sc_hd__fill_1
XFILLER_2_37 vssd1 vssd1 vccd1 vccd1 sky130_fd_sc_hd__fill_2
XFILLER_1_297 vssd1 vssd1 vccd1 vccd1 sky130_fd_sc_hd__fill_2
XFILLER_17_121 vssd1 vssd1 vccd1 vccd1 sky130_fd_sc_hd__fill_4
XFILLER_17_132 vssd1 vssd1 vccd1 vccd1 sky130_fd_sc_hd__fill_1
XFILLER_17_187 vssd1 vssd1 vccd1 vccd1 sky130_fd_sc_hd__fill_2
XFILLER_32_157 vccd1 vssd1 vccd1 vssd1 sky130_ef_sc_hd__decap_40_12
X_0951_ STOPWATCH_INST.clock_div.cycles\[15\] STOPWATCH_INST.clock_div.cycles\[16\]
+ vssd1 vssd1 vccd1 vccd1 _0188_ sky130_fd_sc_hd__nor2_1
X_0882_ _0116_ net196 vssd1 vssd1 vccd1 vccd1 _0011_ sky130_fd_sc_hd__nor2_1
X_1503_ STOPWATCH_INST.clock_div.cycles\[18\] _0724_ vssd1 vssd1 vccd1 vccd1 _0729_
+ sky130_fd_sc_hd__and2_1
X_1296_ _0529_ _0531_ _0532_ vssd1 vssd1 vccd1 vccd1 _0533_ sky130_fd_sc_hd__a21oi_2
X_1365_ _0553_ _0601_ _0593_ vssd1 vssd1 vccd1 vccd1 _0602_ sky130_fd_sc_hd__mux2_4
X_1434_ _0172_ _0670_ _0667_ _0663_ vssd1 vssd1 vccd1 vccd1 _0671_ sky130_fd_sc_hd__or4b_1
XTAP_TAPCELL_ROW_18_193 vssd1 vccd1 sky130_fd_sc_hd__tapvpwrvgnd_1
Xteam_04_103 vssd1 vssd1 vccd1 vccd1 gpio_oeb[13] team_04_103/LO sky130_fd_sc_hd__conb_1
XANTENNA__1614__Q STOPWATCH_INST.clock_div.cycles\[7\] vssd1 vssd1 vccd1 vccd1 sky130_fd_sc_hd__diode_2
XFILLER_46_249 vssd1 vssd1 vccd1 vccd1 sky130_fd_sc_hd__fill_2
X_1150_ _0372_ _0373_ _0374_ _0368_ vssd1 vssd1 vccd1 vccd1 _0387_ sky130_fd_sc_hd__a31o_4
XFILLER_28_7 vssd1 vssd1 vccd1 vccd1 sky130_fd_sc_hd__fill_1
X_1081_ _0285_ _0292_ net24 net26 vssd1 vssd1 vccd1 vccd1 _0318_ sky130_fd_sc_hd__a2bb2o_4
XFILLER_37_249 vssd1 vssd1 vccd1 vccd1 sky130_fd_sc_hd__fill_4
X_0934_ STOPWATCH_INST.clock_div.cycles\[1\] _0175_ vssd1 vssd1 vccd1 vccd1 _0177_
+ sky130_fd_sc_hd__nand2_1
X_0865_ _0111_ _0124_ STOPWATCH_INST.bcd_num\[3\] vssd1 vssd1 vccd1 vccd1 _0129_ sky130_fd_sc_hd__a21o_1
XTAP_TAPCELL_ROW_15_174 vssd1 vccd1 sky130_fd_sc_hd__tapvpwrvgnd_1
XFILLER_20_149 vccd1 vssd1 vccd1 vssd1 sky130_ef_sc_hd__decap_40_12
X_1417_ _0646_ _0645_ _0641_ _0653_ vssd1 vssd1 vccd1 vccd1 _0654_ sky130_fd_sc_hd__o31a_4
X_0796_ STOPWATCH_INST.sync_pause.q STOPWATCH_INST.sync_pause.sync_2 vssd1 vssd1 vccd1
+ vccd1 _0073_ sky130_fd_sc_hd__and2b_1
X_1279_ _0481_ _0515_ _0448_ _0479_ vssd1 vssd1 vccd1 vccd1 _0516_ sky130_fd_sc_hd__o2bb2a_1
X_1348_ _0578_ _0579_ _0502_ _0582_ _0581_ vssd1 vssd1 vccd1 vccd1 _0585_ sky130_fd_sc_hd__a2111o_1
XFILLER_22_78 vssd1 vssd1 vccd1 vccd1 sky130_fd_sc_hd__fill_4
XFILLER_22_89 vssd1 vssd1 vccd1 vccd1 sky130_fd_sc_hd__fill_2
XTAP_TAPCELL_ROW_6_131 vssd1 vccd1 sky130_fd_sc_hd__tapvpwrvgnd_1
XFILLER_19_205 vssd1 vssd1 vccd1 vccd1 sky130_fd_sc_hd__fill_4
XFILLER_19_216 vssd1 vssd1 vccd1 vccd1 sky130_fd_sc_hd__fill_8
XTAP_TAPCELL_ROW_29_244 vssd1 vccd1 sky130_fd_sc_hd__tapvpwrvgnd_1
XFILLER_27_260 vssd1 vssd1 vccd1 vccd1 sky130_fd_sc_hd__fill_4
XFILLER_6_131 vssd1 vssd1 vccd1 vccd1 sky130_fd_sc_hd__fill_8
XFILLER_6_153 vssd1 vssd1 vccd1 vccd1 sky130_fd_sc_hd__fill_4
XFILLER_8_14 vssd1 vssd1 vccd1 vccd1 sky130_fd_sc_hd__fill_2
XFILLER_40_6 vssd1 vssd1 vccd1 vccd1 sky130_fd_sc_hd__fill_4
XFILLER_6_197 vccd1 vssd1 vccd1 vssd1 sky130_ef_sc_hd__decap_40_12
X_1064_ net110 _0300_ vssd1 vssd1 vccd1 vccd1 _0301_ sky130_fd_sc_hd__nand2_2
X_1133_ _0363_ _0316_ _0359_ STOPWATCH_INST.clock_div.cycles\[12\] vssd1 vssd1 vccd1
+ vccd1 _0370_ sky130_fd_sc_hd__and4_1
X_1202_ _0437_ _0438_ vssd1 vssd1 vccd1 vccd1 _0439_ sky130_fd_sc_hd__and2_1
XFILLER_33_241 vssd1 vssd1 vccd1 vccd1 sky130_fd_sc_hd__fill_2
X_0917_ STOPWATCH_INST.clock_div.cycles\[0\] STOPWATCH_INST.clock_div.cycles\[1\]
+ STOPWATCH_INST.clock_div.cycles\[3\] STOPWATCH_INST.clock_div.cycles\[2\] vssd1
+ vssd1 vccd1 vccd1 _0161_ sky130_fd_sc_hd__or4_1
X_0848_ STOPWATCH_INST.digit_scanner.period_counter\[1\] STOPWATCH_INST.digit_scanner.period_counter\[0\]
+ STOPWATCH_INST.digit_scanner.period_counter\[2\] vssd1 vssd1 vccd1 vccd1 _0116_
+ sky130_fd_sc_hd__and3_1
X_0779_ STOPWATCH_INST.fsm_inst1.currentState\[0\] vssd1 vssd1 vccd1 vccd1 _0058_
+ sky130_fd_sc_hd__inv_2
XFILLER_30_222 vssd1 vssd1 vccd1 vccd1 sky130_fd_sc_hd__fill_2
XFILLER_15_241 vssd1 vssd1 vccd1 vccd1 sky130_fd_sc_hd__fill_1
X_1047_ _0265_ _0277_ _0279_ _0283_ vssd1 vssd1 vccd1 vccd1 _0284_ sky130_fd_sc_hd__nand4_4
X_1116_ _0349_ _0352_ vssd1 vssd1 vccd1 vccd1 _0353_ sky130_fd_sc_hd__nand2_1
XFILLER_9_90 vssd1 vssd1 vccd1 vccd1 sky130_fd_sc_hd__fill_8
XFILLER_21_222 vssd1 vssd1 vccd1 vccd1 sky130_fd_sc_hd__fill_2
XTAP_TAPCELL_ROW_23_217 vssd1 vccd1 sky130_fd_sc_hd__tapvpwrvgnd_1
XFILLER_0_137 vssd1 vssd1 vccd1 vccd1 sky130_fd_sc_hd__fill_2
XFILLER_44_43 vssd1 vssd1 vccd1 vccd1 sky130_fd_sc_hd__fill_1
XFILLER_44_10 vssd1 vssd1 vccd1 vccd1 sky130_fd_sc_hd__fill_2
XFILLER_8_226 vccd1 vssd1 vccd1 vssd1 sky130_ef_sc_hd__decap_40_12
XFILLER_10_7 vssd1 vssd1 vccd1 vccd1 sky130_fd_sc_hd__fill_8
XPHY_EDGE_ROW_13_Right_13 vssd1 vssd1 vccd1 vccd1 sky130_fd_sc_hd__decap_3
XPHY_EDGE_ROW_22_Right_22 vssd1 vssd1 vccd1 vccd1 sky130_fd_sc_hd__decap_3
X_1596_ clknet_3_5__leaf_clk net207 vssd1 vssd1 vccd1 vccd1 STOPWATCH_INST.digit_scanner.period_counter\[5\]
+ sky130_fd_sc_hd__dfxtp_1
Xteam_04_54 vssd1 vssd1 vccd1 vccd1 team_04_54/HI gpio_oeb[16] sky130_fd_sc_hd__conb_1
XPHY_EDGE_ROW_31_Right_31 vssd1 vssd1 vccd1 vccd1 sky130_fd_sc_hd__decap_3
Xteam_04_76 vssd1 vssd1 vccd1 vccd1 team_04_76/HI gpio_out[16] sky130_fd_sc_hd__conb_1
Xteam_04_65 vssd1 vssd1 vccd1 vccd1 team_04_65/HI gpio_oeb[27] sky130_fd_sc_hd__conb_1
Xteam_04_98 vssd1 vssd1 vccd1 vccd1 gpio_oeb[8] team_04_98/LO sky130_fd_sc_hd__conb_1
Xteam_04_87 vssd1 vssd1 vccd1 vccd1 team_04_87/HI gpio_out[27] sky130_fd_sc_hd__conb_1
XPHY_EDGE_ROW_40_Right_40 vssd1 vssd1 vccd1 vccd1 sky130_fd_sc_hd__decap_3
XFILLER_5_218 vssd1 vssd1 vccd1 vccd1 sky130_fd_sc_hd__fill_1
XFILLER_14_57 vssd1 vssd1 vccd1 vccd1 sky130_fd_sc_hd__fill_2
XFILLER_14_79 vssd1 vssd1 vccd1 vccd1 sky130_fd_sc_hd__fill_4
XFILLER_44_122 vssd1 vssd1 vccd1 vccd1 sky130_fd_sc_hd__fill_1
XFILLER_39_76 vssd1 vssd1 vccd1 vccd1 sky130_fd_sc_hd__fill_2
XTAP_TAPCELL_ROW_42_312 vssd1 vccd1 sky130_fd_sc_hd__tapvpwrvgnd_1
X_1450_ net34 _0681_ _0684_ net36 STOPWATCH_INST.clock_div.cycles\[9\] vssd1 vssd1
+ vccd1 vccd1 _0034_ sky130_fd_sc_hd__a32o_1
X_1381_ _0539_ _0614_ vssd1 vssd1 vccd1 vccd1 _0618_ sky130_fd_sc_hd__xor2_1
XFILLER_35_111 vssd1 vssd1 vccd1 vccd1 sky130_fd_sc_hd__fill_1
XANTENNA_clkbuf_0_clk_X clknet_0_clk vssd1 vssd1 vccd1 vccd1 sky130_fd_sc_hd__diode_2
X_1579_ clknet_3_0__leaf_clk net185 net44 vssd1 vssd1 vccd1 vccd1 STOPWATCH_INST.sync_one.sync_2
+ sky130_fd_sc_hd__dfrtp_1
Xrebuffer41 _0288_ vssd1 vssd1 vccd1 vccd1 net149 sky130_fd_sc_hd__dlygate4sd1_1
Xrebuffer30 net140 vssd1 vssd1 vccd1 vccd1 net138 sky130_fd_sc_hd__buf_1
XANTENNA__1458__B2 net42 vssd1 vssd1 vccd1 vccd1 sky130_fd_sc_hd__diode_2
XFILLER_25_89 vccd1 vssd1 vccd1 vssd1 sky130_ef_sc_hd__decap_40_12
XFILLER_2_27 vssd1 vssd1 vccd1 vccd1 sky130_fd_sc_hd__fill_1
XFILLER_32_103 vssd1 vssd1 vccd1 vccd1 sky130_fd_sc_hd__fill_1
XFILLER_17_111 vssd1 vssd1 vccd1 vccd1 sky130_fd_sc_hd__fill_1
XFILLER_17_177 vssd1 vssd1 vccd1 vccd1 sky130_fd_sc_hd__fill_2
X_0950_ _0170_ _0171_ _0184_ STOPWATCH_INST.clock_div.cycles\[31\] vssd1 vssd1 vccd1
+ vccd1 _0187_ sky130_fd_sc_hd__o211ai_4
XFILLER_32_169 vccd1 vssd1 vccd1 vssd1 sky130_ef_sc_hd__decap_40_12
X_0881_ STOPWATCH_INST.digit_scanner.period_counter\[1\] STOPWATCH_INST.digit_scanner.period_counter\[0\]
+ net195 vssd1 vssd1 vccd1 vccd1 _0139_ sky130_fd_sc_hd__a21oi_1
X_1502_ STOPWATCH_INST.clock_div.cycles\[18\] _0724_ vssd1 vssd1 vccd1 vccd1 _0728_
+ sky130_fd_sc_hd__nor2_1
X_1433_ _0657_ _0668_ _0669_ vssd1 vssd1 vccd1 vccd1 _0670_ sky130_fd_sc_hd__or3b_1
X_1295_ _0462_ net133 vssd1 vssd1 vccd1 vccd1 _0532_ sky130_fd_sc_hd__xor2_1
X_1364_ STOPWATCH_INST.clock_div.cycles\[8\] _0510_ _0550_ _0555_ vssd1 vssd1 vccd1
+ vccd1 _0601_ sky130_fd_sc_hd__o31a_1
Xteam_04_104 vssd1 vssd1 vccd1 vccd1 gpio_oeb[14] team_04_104/LO sky130_fd_sc_hd__conb_1
XFILLER_36_88 vccd1 vssd1 vccd1 vssd1 sky130_ef_sc_hd__decap_40_12
X_1080_ _0316_ vssd1 vssd1 vccd1 vccd1 _0317_ sky130_fd_sc_hd__inv_2
XTAP_TAPCELL_ROW_15_175 vssd1 vccd1 sky130_fd_sc_hd__tapvpwrvgnd_1
XFILLER_20_128 vssd1 vssd1 vccd1 vccd1 sky130_fd_sc_hd__fill_1
X_0933_ _0175_ _0176_ vssd1 vssd1 vccd1 vccd1 _0025_ sky130_fd_sc_hd__nor2_1
X_0864_ _0059_ _0112_ _0123_ _0128_ vssd1 vssd1 vccd1 vccd1 _0003_ sky130_fd_sc_hd__o211a_1
X_0795_ STOPWATCH_INST.fsm_inst1.currentState\[1\] STOPWATCH_INST.fsm_inst1.currentState\[0\]
+ _0070_ _0069_ vssd1 vssd1 vccd1 vccd1 _0072_ sky130_fd_sc_hd__o31a_1
X_1416_ _0649_ _0650_ _0652_ vssd1 vssd1 vccd1 vccd1 _0653_ sky130_fd_sc_hd__o21ba_1
X_1347_ _0583_ _0580_ _0501_ _0487_ vssd1 vssd1 vccd1 vccd1 _0584_ sky130_fd_sc_hd__and4b_1
XFILLER_43_209 vssd1 vssd1 vccd1 vccd1 sky130_fd_sc_hd__fill_8
XTAP_TAPCELL_ROW_38_289 vssd1 vccd1 sky130_fd_sc_hd__tapvpwrvgnd_1
XFILLER_36_261 vssd1 vssd1 vccd1 vccd1 sky130_fd_sc_hd__fill_2
XFILLER_36_250 vssd1 vssd1 vccd1 vccd1 sky130_fd_sc_hd__fill_2
X_1278_ _0466_ _0459_ _0448_ vssd1 vssd1 vccd1 vccd1 _0515_ sky130_fd_sc_hd__or3b_1
XANTENNA_clkbuf_3_2__f_clk_A clknet_0_clk vssd1 vssd1 vccd1 vccd1 sky130_fd_sc_hd__diode_2
XTAP_TAPCELL_ROW_29_245 vssd1 vccd1 sky130_fd_sc_hd__tapvpwrvgnd_1
XTAP_TAPCELL_ROW_6_132 vssd1 vccd1 sky130_fd_sc_hd__tapvpwrvgnd_1
XFILLER_42_253 vssd1 vssd1 vccd1 vccd1 sky130_fd_sc_hd__fill_8
XFILLER_8_37 vssd1 vssd1 vccd1 vccd1 sky130_fd_sc_hd__fill_2
X_1201_ _0391_ net151 _0395_ vssd1 vssd1 vccd1 vccd1 _0438_ sky130_fd_sc_hd__a21o_1
XFILLER_33_6 vssd1 vssd1 vccd1 vccd1 sky130_fd_sc_hd__fill_4
X_1063_ _0297_ _0299_ vssd1 vssd1 vccd1 vccd1 _0300_ sky130_fd_sc_hd__nor2_1
X_1132_ _0317_ _0360_ _0362_ _0062_ vssd1 vssd1 vccd1 vccd1 _0369_ sky130_fd_sc_hd__o31a_1
X_0916_ net39 _0158_ STOPWATCH_INST.clock_div.cycles\[22\] STOPWATCH_INST.clock_div.cycles\[23\]
+ vssd1 vssd1 vccd1 vccd1 _0160_ sky130_fd_sc_hd__o31a_1
X_0847_ STOPWATCH_INST.D0_AN_0 _0113_ _0115_ _0114_ _0108_ vssd1 vssd1 vccd1 vccd1
+ net10 sky130_fd_sc_hd__a32o_1
Xclone4 _0244_ _0224_ _0223_ vssd1 vssd1 vccd1 vccd1 net112 sky130_fd_sc_hd__or3_4
XFILLER_17_57 vccd1 vssd1 vccd1 vssd1 sky130_ef_sc_hd__decap_40_12
XFILLER_24_253 vssd1 vssd1 vccd1 vccd1 sky130_fd_sc_hd__fill_8
XTAP_TAPCELL_ROW_34_270 vssd1 vccd1 sky130_fd_sc_hd__tapvpwrvgnd_1
XFILLER_3_135 vssd1 vssd1 vccd1 vccd1 sky130_fd_sc_hd__fill_1
XFILLER_15_231 vssd1 vssd1 vccd1 vccd1 sky130_fd_sc_hd__fill_1
X_1046_ _0272_ _0260_ _0258_ vssd1 vssd1 vccd1 vccd1 _0283_ sky130_fd_sc_hd__nor3_4
X_1115_ _0351_ _0343_ _0345_ _0330_ _0350_ vssd1 vssd1 vccd1 vccd1 _0352_ sky130_fd_sc_hd__o41a_1
XFILLER_0_82 vssd1 vssd1 vccd1 vccd1 sky130_fd_sc_hd__fill_2
XTAP_TAPCELL_ROW_23_218 vssd1 vccd1 sky130_fd_sc_hd__tapvpwrvgnd_1
XFILLER_0_149 vssd1 vssd1 vccd1 vccd1 sky130_fd_sc_hd__fill_1
XANTENNA__1626__RESET_B net47 vssd1 vssd1 vccd1 vccd1 sky130_fd_sc_hd__diode_2
XFILLER_44_33 vssd1 vssd1 vccd1 vccd1 sky130_fd_sc_hd__fill_8
XFILLER_12_212 vccd1 vssd1 vccd1 vssd1 sky130_ef_sc_hd__decap_40_12
XFILLER_12_234 vssd1 vssd1 vccd1 vccd1 sky130_fd_sc_hd__fill_1
XFILLER_8_238 vssd1 vssd1 vccd1 vccd1 sky130_fd_sc_hd__fill_1
XFILLER_39_109 vssd1 vssd1 vccd1 vccd1 sky130_fd_sc_hd__fill_2
X_1595_ clknet_3_5__leaf_clk _0013_ vssd1 vssd1 vccd1 vccd1 STOPWATCH_INST.digit_scanner.period_counter\[4\]
+ sky130_fd_sc_hd__dfxtp_1
Xteam_04_55 vssd1 vssd1 vccd1 vccd1 team_04_55/HI gpio_oeb[17] sky130_fd_sc_hd__conb_1
Xteam_04_77 vssd1 vssd1 vccd1 vccd1 team_04_77/HI gpio_out[17] sky130_fd_sc_hd__conb_1
Xteam_04_88 vssd1 vssd1 vccd1 vccd1 team_04_88/HI gpio_out[28] sky130_fd_sc_hd__conb_1
Xteam_04_66 vssd1 vssd1 vccd1 vccd1 team_04_66/HI gpio_oeb[28] sky130_fd_sc_hd__conb_1
X_1029_ _0247_ _0245_ _0213_ net35 vssd1 vssd1 vccd1 vccd1 _0266_ sky130_fd_sc_hd__o2bb2a_4
Xteam_04_99 vssd1 vssd1 vccd1 vccd1 gpio_oeb[9] team_04_99/LO sky130_fd_sc_hd__conb_1
XFILLER_14_25 vssd1 vssd1 vccd1 vccd1 sky130_fd_sc_hd__fill_2
XFILLER_39_66 vssd1 vssd1 vccd1 vccd1 sky130_fd_sc_hd__fill_4
XTAP_TAPCELL_ROW_42_313 vssd1 vccd1 sky130_fd_sc_hd__tapvpwrvgnd_1
XFILLER_4_274 vccd1 vssd1 vccd1 vssd1 sky130_ef_sc_hd__decap_40_12
XFILLER_4_263 vssd1 vssd1 vccd1 vccd1 sky130_fd_sc_hd__fill_1
X_1380_ _0610_ _0615_ _0539_ _0616_ vssd1 vssd1 vccd1 vccd1 _0617_ sky130_fd_sc_hd__and4b_1
X_1578_ clknet_3_2__leaf_clk net2 net48 vssd1 vssd1 vccd1 vccd1 STOPWATCH_INST.sync_ten.sync_1
+ sky130_fd_sc_hd__dfrtp_1
Xrebuffer31 _0276_ vssd1 vssd1 vccd1 vccd1 net139 sky130_fd_sc_hd__dlygate4sd1_1
XFILLER_26_178 vssd1 vssd1 vccd1 vccd1 sky130_fd_sc_hd__fill_4
XFILLER_26_123 vccd1 vssd1 vccd1 vssd1 sky130_ef_sc_hd__decap_40_12
XFILLER_41_148 vssd1 vssd1 vccd1 vccd1 sky130_fd_sc_hd__fill_1
XFILLER_41_89 vssd1 vssd1 vccd1 vccd1 sky130_fd_sc_hd__fill_4
XFILLER_17_167 vssd1 vssd1 vccd1 vccd1 sky130_fd_sc_hd__fill_1
X_0880_ net201 net192 vssd1 vssd1 vccd1 vccd1 _0010_ sky130_fd_sc_hd__xor2_1
XANTENNA__1425__A_N net42 vssd1 vssd1 vccd1 vccd1 sky130_fd_sc_hd__diode_2
X_1363_ _0550_ _0594_ vssd1 vssd1 vccd1 vccd1 _0600_ sky130_fd_sc_hd__xnor2_1
X_1501_ _0634_ _0654_ _0722_ _0627_ _0174_ vssd1 vssd1 vccd1 vccd1 _0727_ sky130_fd_sc_hd__o221ai_2
X_1432_ STOPWATCH_INST.clock_div.cycles\[25\] STOPWATCH_INST.clock_div.cycles\[23\]
+ STOPWATCH_INST.clock_div.cycles\[20\] STOPWATCH_INST.clock_div.cycles\[15\] vssd1
+ vssd1 vccd1 vccd1 _0669_ sky130_fd_sc_hd__and4b_1
X_1294_ _0530_ vssd1 vssd1 vccd1 vccd1 _0531_ sky130_fd_sc_hd__inv_2
Xteam_04_105 vssd1 vssd1 vccd1 vccd1 gpio_oeb[15] team_04_105/LO sky130_fd_sc_hd__conb_1
XANTENNA_fanout49_A net5 vssd1 vssd1 vccd1 vccd1 sky130_fd_sc_hd__diode_2
XFILLER_22_181 vccd1 vssd1 vccd1 vssd1 sky130_ef_sc_hd__decap_40_12
X_0932_ _0068_ net28 net210 vssd1 vssd1 vccd1 vccd1 _0176_ sky130_fd_sc_hd__a21oi_1
XFILLER_9_141 vssd1 vssd1 vccd1 vccd1 sky130_fd_sc_hd__fill_1
XTAP_TAPCELL_ROW_15_176 vssd1 vccd1 sky130_fd_sc_hd__tapvpwrvgnd_1
X_0863_ STOPWATCH_INST.bcd_num\[1\] STOPWATCH_INST.bcd_num\[0\] STOPWATCH_INST.clock_div.second_tick
+ STOPWATCH_INST.bcd_num\[2\] vssd1 vssd1 vccd1 vccd1 _0128_ sky130_fd_sc_hd__a31o_1
X_0794_ STOPWATCH_INST.fsm_inst1.currentState\[1\] STOPWATCH_INST.fsm_inst1.currentState\[0\]
+ vssd1 vssd1 vccd1 vccd1 _0071_ sky130_fd_sc_hd__nor2_1
X_1415_ _0589_ _0651_ net109 vssd1 vssd1 vccd1 vccd1 _0652_ sky130_fd_sc_hd__o21a_1
X_1346_ _0581_ _0582_ vssd1 vssd1 vccd1 vccd1 _0583_ sky130_fd_sc_hd__or2_1
XFILLER_36_295 vssd1 vssd1 vccd1 vccd1 sky130_fd_sc_hd__fill_1
X_1277_ STOPWATCH_INST.clock_div.cycles\[9\] _0510_ _0513_ _0509_ vssd1 vssd1 vccd1
+ vccd1 _0514_ sky130_fd_sc_hd__o211a_1
XFILLER_22_25 vssd1 vssd1 vccd1 vccd1 sky130_fd_sc_hd__fill_2
XTAP_TAPCELL_ROW_6_133 vssd1 vccd1 sky130_fd_sc_hd__tapvpwrvgnd_1
XTAP_TAPCELL_ROW_29_246 vssd1 vccd1 sky130_fd_sc_hd__tapvpwrvgnd_1
XFILLER_42_221 vssd1 vssd1 vccd1 vccd1 sky130_fd_sc_hd__fill_4
XFILLER_27_284 vccd1 vssd1 vccd1 vssd1 sky130_ef_sc_hd__decap_40_12
XFILLER_10_151 vssd1 vssd1 vccd1 vccd1 sky130_fd_sc_hd__fill_4
X_1200_ _0391_ _0395_ net22 vssd1 vssd1 vccd1 vccd1 _0437_ sky130_fd_sc_hd__nand3_1
X_1062_ _0249_ _0294_ _0298_ vssd1 vssd1 vccd1 vccd1 _0299_ sky130_fd_sc_hd__a21oi_2
XFILLER_33_243 vssd1 vssd1 vccd1 vccd1 sky130_fd_sc_hd__fill_1
XFILLER_33_210 vssd1 vssd1 vccd1 vccd1 sky130_fd_sc_hd__fill_1
X_1131_ _0309_ _0367_ vssd1 vssd1 vccd1 vccd1 _0368_ sky130_fd_sc_hd__xor2_2
X_0915_ net39 STOPWATCH_INST.clock_div.cycles\[22\] _0158_ STOPWATCH_INST.clock_div.cycles\[23\]
+ vssd1 vssd1 vccd1 vccd1 _0159_ sky130_fd_sc_hd__o31ai_1
X_0846_ STOPWATCH_INST.bcd_num\[3\] _0112_ STOPWATCH_INST.bcd_num\[1\] vssd1 vssd1
+ vccd1 vccd1 _0115_ sky130_fd_sc_hd__o21ai_1
XTAP_TAPCELL_ROW_3_114 vssd1 vccd1 sky130_fd_sc_hd__tapvpwrvgnd_1
X_1329_ _0534_ _0564_ _0524_ vssd1 vssd1 vccd1 vccd1 _0566_ sky130_fd_sc_hd__a21boi_1
XTAP_TAPCELL_ROW_34_271 vssd1 vccd1 sky130_fd_sc_hd__tapvpwrvgnd_1
XFILLER_17_69 vssd1 vssd1 vccd1 vccd1 sky130_fd_sc_hd__fill_8
XFILLER_24_243 vssd1 vssd1 vccd1 vccd1 sky130_fd_sc_hd__fill_8
XFILLER_24_298 vssd1 vssd1 vccd1 vccd1 sky130_fd_sc_hd__fill_1
XFILLER_3_169 vssd1 vssd1 vccd1 vccd1 sky130_fd_sc_hd__fill_4
XPHY_EDGE_ROW_29_Left_76 vssd1 vssd1 vccd1 vccd1 sky130_fd_sc_hd__decap_3
X_1114_ _0334_ _0336_ _0338_ _0342_ vssd1 vssd1 vccd1 vccd1 _0351_ sky130_fd_sc_hd__nand4b_4
X_1045_ _0275_ _0265_ _0261_ vssd1 vssd1 vccd1 vccd1 _0282_ sky130_fd_sc_hd__a21oi_2
X_0829_ STOPWATCH_INST.bcd_num\[1\] net43 _0100_ _0094_ vssd1 vssd1 vccd1 vccd1 _0101_
+ sky130_fd_sc_hd__o31a_1
XFILLER_0_139 vssd1 vssd1 vccd1 vccd1 sky130_fd_sc_hd__fill_1
XFILLER_44_56 vssd1 vssd1 vccd1 vccd1 sky130_fd_sc_hd__fill_2
XFILLER_12_224 vssd1 vssd1 vccd1 vccd1 sky130_fd_sc_hd__fill_8
XANTENNA_fanout31_A net32 vssd1 vssd1 vccd1 vccd1 sky130_fd_sc_hd__diode_2
XFILLER_5_39 vccd1 vssd1 vccd1 vssd1 sky130_ef_sc_hd__decap_40_12
X_1594_ clknet_3_4__leaf_clk _0012_ vssd1 vssd1 vccd1 vccd1 STOPWATCH_INST.digit_scanner.period_counter\[3\]
+ sky130_fd_sc_hd__dfxtp_1
XPHY_EDGE_ROW_7_Right_7 vssd1 vssd1 vccd1 vccd1 sky130_fd_sc_hd__decap_3
Xteam_04_67 vssd1 vssd1 vccd1 vccd1 team_04_67/HI gpio_oeb[29] sky130_fd_sc_hd__conb_1
Xteam_04_89 vssd1 vssd1 vccd1 vccd1 team_04_89/HI gpio_out[29] sky130_fd_sc_hd__conb_1
Xteam_04_78 vssd1 vssd1 vccd1 vccd1 team_04_78/HI gpio_out[18] sky130_fd_sc_hd__conb_1
Xteam_04_56 vssd1 vssd1 vccd1 vccd1 team_04_56/HI gpio_oeb[18] sky130_fd_sc_hd__conb_1
X_1028_ _0217_ _0221_ net120 _0263_ _0220_ vssd1 vssd1 vccd1 vccd1 _0265_ sky130_fd_sc_hd__o32ai_4
XANTENNA__0920__A2 net42 vssd1 vssd1 vccd1 vccd1 sky130_fd_sc_hd__diode_2
XFILLER_4_286 vssd1 vssd1 vccd1 vccd1 sky130_fd_sc_hd__fill_4
XFILLER_4_253 vssd1 vssd1 vccd1 vccd1 sky130_fd_sc_hd__fill_2
XFILLER_35_113 vccd1 vssd1 vccd1 vssd1 sky130_ef_sc_hd__decap_40_12
XFILLER_6_82 vssd1 vssd1 vccd1 vccd1 sky130_fd_sc_hd__fill_2
XPHY_EDGE_ROW_16_Left_63 vssd1 vssd1 vccd1 vccd1 sky130_fd_sc_hd__decap_3
X_1577_ clknet_3_2__leaf_clk net188 net48 vssd1 vssd1 vccd1 vccd1 STOPWATCH_INST.sync_ten.q
+ sky130_fd_sc_hd__dfrtp_1
Xrebuffer32 _0293_ vssd1 vssd1 vccd1 vccd1 net140 sky130_fd_sc_hd__clkbuf_1
Xrebuffer21 _0277_ vssd1 vssd1 vccd1 vccd1 net129 sky130_fd_sc_hd__dlygate4sd1_1
Xrebuffer10 _0248_ vssd1 vssd1 vccd1 vccd1 net118 sky130_fd_sc_hd__dlymetal6s2s_1
XFILLER_26_102 vssd1 vssd1 vccd1 vccd1 sky130_fd_sc_hd__fill_2
XFILLER_41_68 vssd1 vssd1 vccd1 vccd1 sky130_fd_sc_hd__fill_1
XFILLER_41_46 vssd1 vssd1 vccd1 vccd1 sky130_fd_sc_hd__fill_2
XFILLER_1_223 vssd1 vssd1 vccd1 vccd1 sky130_fd_sc_hd__fill_1
XFILLER_17_113 vssd1 vssd1 vccd1 vccd1 sky130_fd_sc_hd__fill_4
XFILLER_15_91 vssd1 vssd1 vccd1 vccd1 sky130_fd_sc_hd__fill_2
X_1500_ _0723_ net34 _0726_ net36 STOPWATCH_INST.clock_div.cycles\[17\] vssd1 vssd1
+ vccd1 vccd1 _0042_ sky130_fd_sc_hd__a32o_1
X_1293_ _0476_ _0527_ _0528_ vssd1 vssd1 vccd1 vccd1 _0530_ sky130_fd_sc_hd__a21oi_1
X_1431_ STOPWATCH_INST.clock_div.cycles\[8\] STOPWATCH_INST.clock_div.cycles\[11\]
+ STOPWATCH_INST.clock_div.cycles\[17\] vssd1 vssd1 vccd1 vccd1 _0668_ sky130_fd_sc_hd__or3_1
X_1362_ _0550_ _0594_ vssd1 vssd1 vccd1 vccd1 _0599_ sky130_fd_sc_hd__xor2_2
XFILLER_31_171 vssd1 vssd1 vccd1 vccd1 sky130_fd_sc_hd__fill_1
XFILLER_23_149 vssd1 vssd1 vccd1 vccd1 sky130_fd_sc_hd__fill_4
Xteam_04_106 vssd1 vssd1 vccd1 vccd1 gpio_out[6] team_04_106/LO sky130_fd_sc_hd__conb_1
X_1629_ clknet_3_0__leaf_clk _0047_ net45 vssd1 vssd1 vccd1 vccd1 STOPWATCH_INST.clock_div.cycles\[22\]
+ sky130_fd_sc_hd__dfrtp_4
XFILLER_36_35 vssd1 vssd1 vccd1 vccd1 sky130_fd_sc_hd__fill_2
XANTENNA_input3_A gpio_in[2] vssd1 vssd1 vccd1 vccd1 sky130_fd_sc_hd__diode_2
XPHY_EDGE_ROW_1_Left_48 vssd1 vssd1 vccd1 vccd1 sky130_fd_sc_hd__decap_3
XFILLER_22_193 vssd1 vssd1 vccd1 vccd1 sky130_fd_sc_hd__fill_2
XFILLER_45_274 vssd1 vssd1 vccd1 vccd1 sky130_fd_sc_hd__fill_4
XFILLER_45_252 vccd1 vssd1 vccd1 vssd1 sky130_ef_sc_hd__decap_40_12
XFILLER_37_208 vccd1 vssd1 vccd1 vssd1 sky130_ef_sc_hd__decap_40_12
X_0931_ STOPWATCH_INST.clock_div.cycles\[0\] _0068_ net28 vssd1 vssd1 vccd1 vccd1
+ _0175_ sky130_fd_sc_hd__and3_1
X_0862_ _0123_ _0127_ vssd1 vssd1 vccd1 vccd1 _0002_ sky130_fd_sc_hd__and2_1
XTAP_TAPCELL_ROW_15_177 vssd1 vccd1 sky130_fd_sc_hd__tapvpwrvgnd_1
X_0793_ STOPWATCH_INST.sync_one.q STOPWATCH_INST.sync_one.sync_2 vssd1 vssd1 vccd1
+ vccd1 _0070_ sky130_fd_sc_hd__nand2b_1
X_1276_ _0457_ _0511_ vssd1 vssd1 vccd1 vccd1 _0513_ sky130_fd_sc_hd__xnor2_2
XFILLER_3_50 vssd1 vssd1 vccd1 vccd1 sky130_fd_sc_hd__fill_4
X_1414_ _0568_ _0587_ _0591_ vssd1 vssd1 vccd1 vccd1 _0651_ sky130_fd_sc_hd__o21ba_1
X_1345_ net150 _0573_ _0503_ vssd1 vssd1 vccd1 vccd1 _0582_ sky130_fd_sc_hd__a21oi_1
XFILLER_36_263 vssd1 vssd1 vccd1 vccd1 sky130_fd_sc_hd__fill_1
XFILLER_22_37 vssd1 vssd1 vccd1 vccd1 sky130_fd_sc_hd__fill_1
XTAP_TAPCELL_ROW_29_247 vssd1 vccd1 sky130_fd_sc_hd__tapvpwrvgnd_1
XFILLER_27_296 vssd1 vssd1 vccd1 vccd1 sky130_fd_sc_hd__fill_2
XFILLER_27_274 vssd1 vssd1 vccd1 vccd1 sky130_fd_sc_hd__fill_2
XFILLER_42_233 vssd1 vssd1 vccd1 vccd1 sky130_fd_sc_hd__fill_1
X_1130_ _0317_ _0360_ _0362_ _0314_ _0311_ vssd1 vssd1 vccd1 vccd1 _0367_ sky130_fd_sc_hd__o311a_1
XFILLER_19_6 vssd1 vssd1 vccd1 vccd1 sky130_fd_sc_hd__fill_8
X_1061_ _0242_ net118 _0286_ _0239_ vssd1 vssd1 vccd1 vccd1 _0298_ sky130_fd_sc_hd__o31a_1
XFILLER_18_230 vssd1 vssd1 vccd1 vccd1 sky130_fd_sc_hd__fill_8
XFILLER_18_296 vssd1 vssd1 vccd1 vccd1 sky130_fd_sc_hd__fill_2
X_0845_ _0082_ _0107_ STOPWATCH_INST.bcd_num\[5\] vssd1 vssd1 vccd1 vccd1 _0114_ sky130_fd_sc_hd__o21ai_1
X_0914_ net40 STOPWATCH_INST.clock_div.cycles\[20\] vssd1 vssd1 vccd1 vccd1 _0158_
+ sky130_fd_sc_hd__and2_4
XTAP_TAPCELL_ROW_3_115 vssd1 vccd1 sky130_fd_sc_hd__tapvpwrvgnd_1
X_1259_ _0490_ _0495_ vssd1 vssd1 vccd1 vccd1 _0496_ sky130_fd_sc_hd__and2_1
X_1328_ _0526_ _0533_ vssd1 vssd1 vccd1 vccd1 _0565_ sky130_fd_sc_hd__nor2_1
XTAP_TAPCELL_ROW_34_272 vssd1 vccd1 sky130_fd_sc_hd__tapvpwrvgnd_1
XFILLER_33_69 vccd1 vssd1 vccd1 vssd1 sky130_ef_sc_hd__decap_40_12
XPHY_EDGE_ROW_4_Left_51 vssd1 vssd1 vccd1 vccd1 sky130_fd_sc_hd__decap_3
X_1044_ _0264_ _0280_ vssd1 vssd1 vccd1 vccd1 _0281_ sky130_fd_sc_hd__nor2_1
X_1113_ _0334_ _0342_ _0343_ vssd1 vssd1 vccd1 vccd1 _0350_ sky130_fd_sc_hd__nand3b_1
XFILLER_0_62 vccd1 vssd1 vccd1 vssd1 sky130_ef_sc_hd__decap_40_12
XFILLER_21_225 vccd1 vssd1 vccd1 vssd1 sky130_ef_sc_hd__decap_40_12
X_0828_ STOPWATCH_INST.bcd_num\[2\] STOPWATCH_INST.bcd_num\[3\] vssd1 vssd1 vccd1
+ vccd1 _0100_ sky130_fd_sc_hd__nand2b_1
XPHY_EDGE_ROW_46_Left_93 vssd1 vssd1 vccd1 vccd1 sky130_fd_sc_hd__decap_3
XANTENNA__1635__RESET_B net49 vssd1 vssd1 vccd1 vccd1 sky130_fd_sc_hd__diode_2
XPHY_EDGE_ROW_30_Left_77 vssd1 vssd1 vccd1 vccd1 sky130_fd_sc_hd__decap_3
X_1593_ clknet_3_5__leaf_clk _0011_ vssd1 vssd1 vccd1 vccd1 STOPWATCH_INST.digit_scanner.period_counter\[2\]
+ sky130_fd_sc_hd__dfxtp_1
Xteam_04_57 vssd1 vssd1 vccd1 vccd1 team_04_57/HI gpio_oeb[19] sky130_fd_sc_hd__conb_1
X_1027_ _0217_ _0221_ net121 _0263_ _0220_ vssd1 vssd1 vccd1 vccd1 _0264_ sky130_fd_sc_hd__o32a_1
XFILLER_38_188 vssd1 vssd1 vccd1 vccd1 sky130_fd_sc_hd__fill_2
XFILLER_38_122 vssd1 vssd1 vccd1 vccd1 sky130_fd_sc_hd__fill_2
Xteam_04_68 vssd1 vssd1 vccd1 vccd1 team_04_68/HI gpio_oeb[30] sky130_fd_sc_hd__conb_1
Xclkbuf_3_5__f_clk clknet_0_clk vssd1 vssd1 vccd1 vccd1 clknet_3_5__leaf_clk sky130_fd_sc_hd__clkbuf_16
Xteam_04_79 vssd1 vssd1 vccd1 vccd1 team_04_79/HI gpio_out[19] sky130_fd_sc_hd__conb_1
XFILLER_14_27 vssd1 vssd1 vccd1 vccd1 sky130_fd_sc_hd__fill_1
XFILLER_30_26 vssd1 vssd1 vccd1 vccd1 sky130_fd_sc_hd__fill_2
XFILLER_39_35 vssd1 vssd1 vccd1 vccd1 sky130_fd_sc_hd__fill_2
XFILLER_35_125 vccd1 vssd1 vccd1 vssd1 sky130_ef_sc_hd__decap_40_12
Xhold90 _0153_ vssd1 vssd1 vccd1 vccd1 net198 sky130_fd_sc_hd__dlygate4sd3_1
X_1576_ clknet_3_2__leaf_clk net186 net48 vssd1 vssd1 vccd1 vccd1 STOPWATCH_INST.sync_ten.sync_2
+ sky130_fd_sc_hd__dfrtp_1
Xrebuffer11 net118 vssd1 vssd1 vccd1 vccd1 net119 sky130_fd_sc_hd__dlymetal6s2s_1
XANTENNA__1560__B1 net38 vssd1 vssd1 vccd1 vccd1 sky130_fd_sc_hd__diode_2
Xrebuffer33 _0248_ vssd1 vssd1 vccd1 vccd1 net141 sky130_fd_sc_hd__buf_6
XFILLER_34_180 vssd1 vssd1 vccd1 vccd1 sky130_fd_sc_hd__fill_1
XFILLER_26_169 vssd1 vssd1 vccd1 vccd1 sky130_fd_sc_hd__fill_1
XFILLER_26_158 vssd1 vssd1 vccd1 vccd1 sky130_fd_sc_hd__fill_1
XANTENNA__1551__B1 net38 vssd1 vssd1 vccd1 vccd1 sky130_fd_sc_hd__diode_2
XFILLER_17_125 vssd1 vssd1 vccd1 vccd1 sky130_fd_sc_hd__fill_2
XFILLER_17_169 vssd1 vssd1 vccd1 vccd1 sky130_fd_sc_hd__fill_4
XFILLER_32_117 vssd1 vssd1 vccd1 vccd1 sky130_fd_sc_hd__fill_2
XANTENNA__0790__X _0067_ vssd1 vssd1 vccd1 vccd1 sky130_fd_sc_hd__diode_2
XPHY_EDGE_ROW_33_Left_80 vssd1 vssd1 vccd1 vccd1 sky130_fd_sc_hd__decap_3
X_1430_ _0167_ _0664_ _0666_ _0076_ vssd1 vssd1 vccd1 vccd1 _0667_ sky130_fd_sc_hd__o31a_1
X_1292_ _0475_ _0527_ vssd1 vssd1 vccd1 vccd1 _0529_ sky130_fd_sc_hd__xnor2_4
X_1361_ STOPWATCH_INST.clock_div.cycles\[7\] _0594_ _0595_ vssd1 vssd1 vccd1 vccd1
+ _0598_ sky130_fd_sc_hd__or3_4
XFILLER_16_191 vssd1 vssd1 vccd1 vccd1 sky130_fd_sc_hd__fill_4
Xteam_04_107 vssd1 vssd1 vccd1 vccd1 gpio_out[7] team_04_107/LO sky130_fd_sc_hd__conb_1
X_1559_ STOPWATCH_INST.clock_div.cycles\[29\] _0771_ vssd1 vssd1 vccd1 vccd1 _0774_
+ sky130_fd_sc_hd__nand2_1
X_1628_ clknet_3_3__leaf_clk _0046_ net44 vssd1 vssd1 vccd1 vccd1 STOPWATCH_INST.clock_div.cycles\[21\]
+ sky130_fd_sc_hd__dfrtp_1
XFILLER_46_209 vccd1 vssd1 vccd1 vssd1 sky130_ef_sc_hd__decap_40_12
XFILLER_39_294 vssd1 vssd1 vccd1 vccd1 sky130_fd_sc_hd__fill_2
XFILLER_14_106 vccd1 vssd1 vccd1 vssd1 sky130_ef_sc_hd__decap_40_12
XFILLER_45_264 vssd1 vssd1 vccd1 vccd1 sky130_fd_sc_hd__fill_4
XFILLER_26_80 vssd1 vssd1 vccd1 vccd1 sky130_fd_sc_hd__fill_4
Xrebuffer2 net115 vssd1 vssd1 vccd1 vccd1 net110 sky130_fd_sc_hd__clkbuf_2
X_0861_ STOPWATCH_INST.clock_div.second_tick _0088_ _0100_ _0126_ STOPWATCH_INST.bcd_num\[1\]
+ vssd1 vssd1 vccd1 vccd1 _0127_ sky130_fd_sc_hd__a32o_1
X_0930_ net28 vssd1 vssd1 vccd1 vccd1 _0174_ sky130_fd_sc_hd__inv_2
XFILLER_13_183 vccd1 vssd1 vccd1 vssd1 sky130_ef_sc_hd__decap_40_12
XTAP_TAPCELL_ROW_15_178 vssd1 vccd1 sky130_fd_sc_hd__tapvpwrvgnd_1
X_0792_ _0065_ STOPWATCH_INST.sync_clear.q net37 vssd1 vssd1 vccd1 vccd1 _0069_ sky130_fd_sc_hd__o21ai_1
X_1413_ _0567_ _0644_ vssd1 vssd1 vccd1 vccd1 _0650_ sky130_fd_sc_hd__xnor2_2
XFILLER_36_253 vssd1 vssd1 vccd1 vccd1 sky130_fd_sc_hd__fill_8
X_1275_ net20 net133 _0466_ _0457_ vssd1 vssd1 vccd1 vccd1 _0512_ sky130_fd_sc_hd__a211o_1
XFILLER_28_209 vssd1 vssd1 vccd1 vccd1 sky130_fd_sc_hd__fill_1
XANTENNA__0855__B _0122_ vssd1 vssd1 vccd1 vccd1 sky130_fd_sc_hd__diode_2
X_1344_ _0503_ net17 _0573_ vssd1 vssd1 vccd1 vccd1 _0581_ sky130_fd_sc_hd__and3_1
XFILLER_22_27 vssd1 vssd1 vccd1 vccd1 sky130_fd_sc_hd__fill_1
XFILLER_19_209 vssd1 vssd1 vccd1 vccd1 sky130_fd_sc_hd__fill_2
XPHY_EDGE_ROW_29_Right_29 vssd1 vssd1 vccd1 vccd1 sky130_fd_sc_hd__decap_3
XTAP_TAPCELL_ROW_29_248 vssd1 vccd1 sky130_fd_sc_hd__tapvpwrvgnd_1
XFILLER_27_264 vssd1 vssd1 vccd1 vccd1 sky130_fd_sc_hd__fill_1
XPHY_EDGE_ROW_38_Right_38 vssd1 vssd1 vccd1 vccd1 sky130_fd_sc_hd__decap_3
XTAP_TAPCELL_ROW_12_159 vssd1 vccd1 sky130_fd_sc_hd__tapvpwrvgnd_1
XFILLER_6_157 vssd1 vssd1 vccd1 vccd1 sky130_fd_sc_hd__fill_2
X_1060_ _0231_ _0295_ vssd1 vssd1 vccd1 vccd1 _0297_ sky130_fd_sc_hd__xnor2_1
XFILLER_18_253 vccd1 vssd1 vccd1 vssd1 sky130_ef_sc_hd__decap_40_12
X_0913_ net39 STOPWATCH_INST.clock_div.cycles\[22\] vssd1 vssd1 vccd1 vccd1 _0157_
+ sky130_fd_sc_hd__nor2_1
X_0844_ STOPWATCH_INST.D0_AN_0 _0105_ _0113_ _0109_ _0108_ vssd1 vssd1 vccd1 vccd1
+ net9 sky130_fd_sc_hd__a32o_1
XTAP_TAPCELL_ROW_3_116 vssd1 vccd1 sky130_fd_sc_hd__tapvpwrvgnd_1
X_1189_ _0399_ _0402_ _0406_ net127 vssd1 vssd1 vccd1 vccd1 _0426_ sky130_fd_sc_hd__and4_1
X_1327_ _0496_ _0522_ vssd1 vssd1 vccd1 vccd1 _0564_ sky130_fd_sc_hd__nand2_1
X_1258_ _0427_ _0493_ vssd1 vssd1 vccd1 vccd1 _0495_ sky130_fd_sc_hd__xnor2_1
XTAP_TAPCELL_ROW_26_229 vssd1 vccd1 sky130_fd_sc_hd__tapvpwrvgnd_1
XTAP_TAPCELL_ROW_34_273 vssd1 vccd1 sky130_fd_sc_hd__tapvpwrvgnd_1
XFILLER_30_215 vssd1 vssd1 vccd1 vccd1 sky130_fd_sc_hd__fill_4
XANTENNA__0782__Y _0060_ vssd1 vssd1 vccd1 vccd1 sky130_fd_sc_hd__diode_2
XFILLER_23_81 vssd1 vssd1 vccd1 vccd1 sky130_fd_sc_hd__fill_2
XFILLER_31_6 vssd1 vssd1 vccd1 vccd1 sky130_fd_sc_hd__fill_8
X_1112_ _0335_ _0340_ _0330_ vssd1 vssd1 vccd1 vccd1 _0349_ sky130_fd_sc_hd__a21oi_1
X_1043_ _0277_ net145 net116 vssd1 vssd1 vccd1 vccd1 _0280_ sky130_fd_sc_hd__a21oi_2
XFILLER_0_74 vssd1 vssd1 vccd1 vccd1 sky130_fd_sc_hd__fill_8
XFILLER_0_85 vccd1 vssd1 vccd1 vssd1 sky130_ef_sc_hd__decap_40_12
XTAP_TAPCELL_ROW_31_254 vssd1 vccd1 sky130_fd_sc_hd__tapvpwrvgnd_1
XFILLER_9_50 vssd1 vssd1 vccd1 vccd1 sky130_fd_sc_hd__fill_2
X_0827_ _0099_ vssd1 vssd1 vccd1 vccd1 net6 sky130_fd_sc_hd__inv_2
XFILLER_12_204 vssd1 vssd1 vccd1 vccd1 sky130_fd_sc_hd__fill_4
Xsplit27 STOPWATCH_INST.clock_div.cycles\[22\] vssd1 vssd1 vccd1 vccd1 net135 sky130_fd_sc_hd__buf_1
XFILLER_20_270 vssd1 vssd1 vccd1 vccd1 sky130_fd_sc_hd__fill_1
XTAP_TAPCELL_ROW_22_210 vssd1 vccd1 sky130_fd_sc_hd__tapvpwrvgnd_1
XTAP_TAPCELL_ROW_45_324 vssd1 vccd1 sky130_fd_sc_hd__tapvpwrvgnd_1
XFILLER_34_91 vssd1 vssd1 vccd1 vccd1 sky130_fd_sc_hd__fill_1
X_1592_ clknet_3_4__leaf_clk _0010_ vssd1 vssd1 vccd1 vccd1 STOPWATCH_INST.digit_scanner.period_counter\[1\]
+ sky130_fd_sc_hd__dfxtp_1
XFILLER_11_281 vccd1 vssd1 vccd1 vssd1 sky130_ef_sc_hd__decap_40_12
X_1026_ _0219_ _0262_ vssd1 vssd1 vccd1 vccd1 _0263_ sky130_fd_sc_hd__and2_1
Xteam_04_69 vssd1 vssd1 vccd1 vccd1 team_04_69/HI gpio_oeb[31] sky130_fd_sc_hd__conb_1
Xteam_04_58 vssd1 vssd1 vccd1 vccd1 team_04_58/HI gpio_oeb[20] sky130_fd_sc_hd__conb_1
XFILLER_14_17 vssd1 vssd1 vccd1 vccd1 sky130_fd_sc_hd__fill_8
XFILLER_29_167 vssd1 vssd1 vccd1 vccd1 sky130_fd_sc_hd__fill_1
XFILLER_4_255 vssd1 vssd1 vccd1 vccd1 sky130_fd_sc_hd__fill_1
XFILLER_29_80 vssd1 vssd1 vccd1 vccd1 sky130_fd_sc_hd__fill_2
XFILLER_20_82 vssd1 vssd1 vccd1 vccd1 sky130_fd_sc_hd__fill_2
XFILLER_35_137 vssd1 vssd1 vccd1 vccd1 sky130_fd_sc_hd__fill_4
Xhold80 STOPWATCH_INST.sync_ten.sync_2 vssd1 vssd1 vccd1 vccd1 net188 sky130_fd_sc_hd__dlygate4sd3_1
Xhold91 STOPWATCH_INST.digit_scanner.period_counter\[14\] vssd1 vssd1 vccd1 vccd1
+ net199 sky130_fd_sc_hd__dlygate4sd3_1
X_1575_ clknet_3_3__leaf_clk net3 net48 vssd1 vssd1 vccd1 vccd1 STOPWATCH_INST.sync_pause.sync_1
+ sky130_fd_sc_hd__dfrtp_1
Xrebuffer23 net138 vssd1 vssd1 vccd1 vccd1 net131 sky130_fd_sc_hd__buf_1
Xrebuffer12 _0248_ vssd1 vssd1 vccd1 vccd1 net120 sky130_fd_sc_hd__dlymetal6s2s_1
Xrebuffer34 _0253_ vssd1 vssd1 vccd1 vccd1 net142 sky130_fd_sc_hd__dlygate4sd1_1
XFILLER_26_104 vssd1 vssd1 vccd1 vccd1 sky130_fd_sc_hd__fill_1
XFILLER_41_118 vssd1 vssd1 vccd1 vccd1 sky130_fd_sc_hd__fill_2
X_1009_ _0236_ _0243_ net124 vssd1 vssd1 vccd1 vccd1 _0246_ sky130_fd_sc_hd__a21oi_1
XFILLER_25_38 vssd1 vssd1 vccd1 vccd1 sky130_fd_sc_hd__fill_4
XFILLER_41_48 vssd1 vssd1 vccd1 vccd1 sky130_fd_sc_hd__fill_1
XANTENNA_clkbuf_3_5__f_clk_A clknet_0_clk vssd1 vssd1 vccd1 vccd1 sky130_fd_sc_hd__diode_2
XANTENNA__1551__A1 net32 vssd1 vssd1 vccd1 vccd1 sky130_fd_sc_hd__diode_2
XFILLER_1_269 vssd1 vssd1 vccd1 vccd1 sky130_fd_sc_hd__fill_4
XFILLER_1_225 vssd1 vssd1 vccd1 vccd1 sky130_fd_sc_hd__fill_4
XFILLER_17_148 vssd1 vssd1 vccd1 vccd1 sky130_fd_sc_hd__fill_2
XFILLER_17_159 vssd1 vssd1 vccd1 vccd1 sky130_fd_sc_hd__fill_8
XFILLER_15_93 vssd1 vssd1 vccd1 vccd1 sky130_fd_sc_hd__fill_1
XFILLER_25_181 vssd1 vssd1 vccd1 vccd1 sky130_fd_sc_hd__fill_8
X_1360_ STOPWATCH_INST.clock_div.cycles\[7\] _0596_ vssd1 vssd1 vccd1 vccd1 _0597_
+ sky130_fd_sc_hd__nor2_1
X_1291_ _0475_ _0527_ _0474_ vssd1 vssd1 vccd1 vccd1 _0528_ sky130_fd_sc_hd__a21oi_1
XFILLER_31_151 vccd1 vssd1 vccd1 vssd1 sky130_ef_sc_hd__decap_40_12
X_1558_ STOPWATCH_INST.clock_div.cycles\[29\] _0771_ vssd1 vssd1 vccd1 vccd1 _0773_
+ sky130_fd_sc_hd__or2_1
Xteam_04_108 vssd1 vssd1 vccd1 vccd1 gpio_out[15] team_04_108/LO sky130_fd_sc_hd__conb_1
X_1627_ clknet_3_1__leaf_clk _0045_ net47 vssd1 vssd1 vccd1 vccd1 STOPWATCH_INST.clock_div.cycles\[20\]
+ sky130_fd_sc_hd__dfrtp_2
X_1489_ _0621_ _0631_ net117 net30 _0716_ vssd1 vssd1 vccd1 vccd1 _0717_ sky130_fd_sc_hd__a311o_1
XFILLER_36_48 vccd1 vssd1 vccd1 vssd1 sky130_ef_sc_hd__decap_40_12
XFILLER_36_37 vssd1 vssd1 vccd1 vccd1 sky130_fd_sc_hd__fill_1
XFILLER_14_118 vssd1 vssd1 vccd1 vccd1 sky130_fd_sc_hd__fill_2
XFILLER_22_195 vssd1 vssd1 vccd1 vccd1 sky130_fd_sc_hd__fill_1
XTAP_TAPCELL_ROW_9_144 vssd1 vccd1 sky130_fd_sc_hd__tapvpwrvgnd_1
Xrebuffer3 net110 vssd1 vssd1 vccd1 vccd1 net111 sky130_fd_sc_hd__dlygate4sd1_1
X_0860_ net43 STOPWATCH_INST.clock_div.second_tick vssd1 vssd1 vccd1 vccd1 _0126_
+ sky130_fd_sc_hd__nand2_1
X_0791_ STOPWATCH_INST.fsm_inst1.currentState\[1\] STOPWATCH_INST.fsm_inst1.currentState\[0\]
+ vssd1 vssd1 vccd1 vccd1 _0068_ sky130_fd_sc_hd__nand2_2
XFILLER_13_173 vssd1 vssd1 vccd1 vccd1 sky130_fd_sc_hd__fill_2
XFILLER_13_195 vssd1 vssd1 vccd1 vccd1 sky130_fd_sc_hd__fill_8
X_1412_ _0645_ _0648_ vssd1 vssd1 vccd1 vccd1 _0649_ sky130_fd_sc_hd__nor2_1
X_1343_ _0578_ _0579_ vssd1 vssd1 vccd1 vccd1 _0580_ sky130_fd_sc_hd__nand2_1
X_1274_ net20 net19 _0466_ vssd1 vssd1 vccd1 vccd1 _0511_ sky130_fd_sc_hd__a21oi_2
XANTENNA__1313__A _0060_ vssd1 vssd1 vccd1 vccd1 sky130_fd_sc_hd__diode_2
X_0989_ _0170_ _0160_ _0191_ vssd1 vssd1 vccd1 vccd1 _0226_ sky130_fd_sc_hd__or3_4
XFILLER_27_298 vssd1 vssd1 vccd1 vccd1 sky130_fd_sc_hd__fill_1
XFILLER_27_232 vccd1 vssd1 vccd1 vssd1 sky130_ef_sc_hd__decap_40_12
XANTENNA_fanout47_A net5 vssd1 vssd1 vccd1 vccd1 sky130_fd_sc_hd__diode_2
XFILLER_18_210 vssd1 vssd1 vccd1 vccd1 sky130_fd_sc_hd__fill_2
XFILLER_18_265 vssd1 vssd1 vccd1 vccd1 sky130_fd_sc_hd__fill_8
XFILLER_33_257 vssd1 vssd1 vccd1 vccd1 sky130_fd_sc_hd__fill_2
X_0912_ net193 _0155_ vssd1 vssd1 vccd1 vccd1 _0024_ sky130_fd_sc_hd__xor2_1
XFILLER_18_298 vssd1 vssd1 vccd1 vccd1 sky130_fd_sc_hd__fill_1
X_0843_ STOPWATCH_INST.bcd_num\[2\] _0110_ STOPWATCH_INST.bcd_num\[3\] vssd1 vssd1
+ vccd1 vccd1 _0113_ sky130_fd_sc_hd__a21oi_1
XTAP_TAPCELL_ROW_3_117 vssd1 vccd1 sky130_fd_sc_hd__tapvpwrvgnd_1
X_1326_ _0561_ _0562_ vssd1 vssd1 vccd1 vccd1 _0563_ sky130_fd_sc_hd__and2_2
X_1188_ _0399_ net22 _0402_ vssd1 vssd1 vccd1 vccd1 _0425_ sky130_fd_sc_hd__and3_1
XFILLER_24_224 vssd1 vssd1 vccd1 vccd1 sky130_fd_sc_hd__fill_4
X_1257_ _0427_ _0478_ _0491_ vssd1 vssd1 vccd1 vccd1 _0494_ sky130_fd_sc_hd__or3_1
XFILLER_15_279 vssd1 vssd1 vccd1 vccd1 sky130_fd_sc_hd__fill_1
XTAP_TAPCELL_ROW_40_299 vssd1 vccd1 sky130_fd_sc_hd__tapvpwrvgnd_1
X_1111_ _0334_ _0347_ vssd1 vssd1 vccd1 vccd1 _0348_ sky130_fd_sc_hd__nor2_1
X_1042_ _0274_ _0267_ _0211_ vssd1 vssd1 vccd1 vccd1 _0279_ sky130_fd_sc_hd__and3b_1
XFILLER_0_97 vccd1 vssd1 vccd1 vssd1 sky130_ef_sc_hd__decap_40_12
XTAP_TAPCELL_ROW_31_255 vssd1 vccd1 sky130_fd_sc_hd__tapvpwrvgnd_1
XFILLER_0_109 vssd1 vssd1 vccd1 vccd1 sky130_fd_sc_hd__fill_2
X_0826_ STOPWATCH_INST.D0_AN_0 _0097_ _0098_ vssd1 vssd1 vccd1 vccd1 _0099_ sky130_fd_sc_hd__o21a_1
X_1309_ _0543_ _0545_ vssd1 vssd1 vccd1 vccd1 _0546_ sky130_fd_sc_hd__nor2_1
XTAP_TAPCELL_ROW_22_211 vssd1 vccd1 sky130_fd_sc_hd__tapvpwrvgnd_1
XTAP_TAPCELL_ROW_45_325 vssd1 vccd1 sky130_fd_sc_hd__tapvpwrvgnd_1
XFILLER_18_82 vssd1 vssd1 vccd1 vccd1 sky130_fd_sc_hd__fill_2
XFILLER_18_93 vssd1 vssd1 vccd1 vccd1 sky130_fd_sc_hd__fill_2
XFILLER_7_220 vssd1 vssd1 vccd1 vccd1 sky130_fd_sc_hd__fill_4
XFILLER_7_297 vssd1 vssd1 vccd1 vccd1 sky130_fd_sc_hd__fill_2
X_1591_ clknet_3_5__leaf_clk _0009_ vssd1 vssd1 vccd1 vccd1 STOPWATCH_INST.digit_scanner.period_counter\[0\]
+ sky130_fd_sc_hd__dfxtp_1
Xteam_04_59 vssd1 vssd1 vccd1 vccd1 team_04_59/HI gpio_oeb[21] sky130_fd_sc_hd__conb_1
X_1025_ net112 _0247_ _0217_ vssd1 vssd1 vccd1 vccd1 _0262_ sky130_fd_sc_hd__a21oi_2
XFILLER_14_29 vccd1 vssd1 vccd1 vssd1 sky130_ef_sc_hd__decap_40_12
X_0809_ STOPWATCH_INST.bcd_num\[7\] STOPWATCH_INST.bcd_num\[6\] _0083_ vssd1 vssd1
+ vccd1 vccd1 _0084_ sky130_fd_sc_hd__or3_1
XFILLER_29_113 vccd1 vssd1 vccd1 vssd1 sky130_ef_sc_hd__decap_40_12
Xhold92 _0156_ vssd1 vssd1 vccd1 vccd1 net200 sky130_fd_sc_hd__dlygate4sd3_1
Xhold81 STOPWATCH_INST.sync_one.sync_2 vssd1 vssd1 vccd1 vccd1 net189 sky130_fd_sc_hd__dlygate4sd3_1
XFILLER_35_105 vssd1 vssd1 vccd1 vccd1 sky130_fd_sc_hd__fill_4
XFILLER_6_85 vccd1 vssd1 vccd1 vssd1 sky130_ef_sc_hd__decap_40_12
X_1574_ clknet_3_3__leaf_clk net190 net48 vssd1 vssd1 vccd1 vccd1 STOPWATCH_INST.sync_pause.q
+ sky130_fd_sc_hd__dfrtp_1
Xrebuffer24 _0239_ vssd1 vssd1 vccd1 vccd1 net132 sky130_fd_sc_hd__dlymetal6s4s_1
Xrebuffer13 net120 vssd1 vssd1 vccd1 vccd1 net121 sky130_fd_sc_hd__dlygate4sd1_1
Xrebuffer35 net142 vssd1 vssd1 vccd1 vccd1 net143 sky130_fd_sc_hd__dlymetal6s2s_1
X_1008_ _0244_ _0224_ _0223_ vssd1 vssd1 vccd1 vccd1 _0245_ sky130_fd_sc_hd__or3_4
XFILLER_9_7 vssd1 vssd1 vccd1 vccd1 sky130_fd_sc_hd__fill_8
XFILLER_1_237 vssd1 vssd1 vccd1 vccd1 sky130_fd_sc_hd__fill_2
XFILLER_1_248 vccd1 vssd1 vccd1 vssd1 sky130_ef_sc_hd__decap_40_12
XFILLER_32_119 vssd1 vssd1 vccd1 vccd1 sky130_fd_sc_hd__fill_1
XFILLER_17_127 vssd1 vssd1 vccd1 vccd1 sky130_fd_sc_hd__fill_1
XANTENNA_fanout32_X net32 vssd1 vssd1 vccd1 vccd1 sky130_fd_sc_hd__diode_2
X_1290_ _0463_ _0477_ _0472_ vssd1 vssd1 vccd1 vccd1 _0527_ sky130_fd_sc_hd__a21oi_4
XFILLER_0_281 vssd1 vssd1 vccd1 vccd1 sky130_fd_sc_hd__fill_1
XFILLER_31_163 vssd1 vssd1 vccd1 vccd1 sky130_fd_sc_hd__fill_4
X_1626_ clknet_3_6__leaf_clk _0044_ net47 vssd1 vssd1 vccd1 vccd1 STOPWATCH_INST.clock_div.cycles\[19\]
+ sky130_fd_sc_hd__dfrtp_1
XFILLER_39_230 vssd1 vssd1 vccd1 vccd1 sky130_fd_sc_hd__fill_1
X_1557_ net32 _0770_ _0772_ net38 STOPWATCH_INST.clock_div.cycles\[28\] vssd1 vssd1
+ vccd1 vccd1 _0053_ sky130_fd_sc_hd__a32o_1
X_1488_ _0621_ net16 _0631_ vssd1 vssd1 vccd1 vccd1 _0716_ sky130_fd_sc_hd__a21oi_1
XTAP_TAPCELL_ROW_9_145 vssd1 vccd1 sky130_fd_sc_hd__tapvpwrvgnd_1
XFILLER_9_156 vccd1 vssd1 vccd1 vssd1 sky130_ef_sc_hd__decap_40_12
XFILLER_9_178 vssd1 vssd1 vccd1 vccd1 sky130_fd_sc_hd__fill_2
X_0790_ STOPWATCH_INST.fsm_inst1.currentState\[1\] STOPWATCH_INST.fsm_inst1.currentState\[0\]
+ vssd1 vssd1 vccd1 vccd1 _0067_ sky130_fd_sc_hd__and2_1
XFILLER_3_97 vssd1 vssd1 vccd1 vccd1 sky130_fd_sc_hd__fill_1
XFILLER_3_75 vssd1 vssd1 vccd1 vccd1 sky130_fd_sc_hd__fill_4
X_1411_ _0577_ _0592_ _0635_ _0647_ vssd1 vssd1 vccd1 vccd1 _0648_ sky130_fd_sc_hd__o31a_1
X_1342_ net17 _0569_ _0500_ vssd1 vssd1 vccd1 vccd1 _0579_ sky130_fd_sc_hd__a21bo_1
X_1273_ net42 _0478_ vssd1 vssd1 vccd1 vccd1 _0510_ sky130_fd_sc_hd__xnor2_2
X_0988_ _0223_ _0224_ vssd1 vssd1 vccd1 vccd1 _0225_ sky130_fd_sc_hd__nor2_1
XFILLER_22_29 vssd1 vssd1 vccd1 vccd1 sky130_fd_sc_hd__fill_8
X_1609_ clknet_3_1__leaf_clk _0027_ net46 vssd1 vssd1 vccd1 vccd1 STOPWATCH_INST.clock_div.cycles\[2\]
+ sky130_fd_sc_hd__dfrtp_1
XANTENNA_input1_A gpio_in[0] vssd1 vssd1 vccd1 vccd1 sky130_fd_sc_hd__diode_2
XFILLER_33_225 vccd1 vssd1 vccd1 vssd1 sky130_ef_sc_hd__decap_40_12
X_0842_ _0111_ vssd1 vssd1 vccd1 vccd1 _0112_ sky130_fd_sc_hd__inv_2
X_0911_ _0155_ net200 vssd1 vssd1 vccd1 vccd1 _0023_ sky130_fd_sc_hd__nor2_1
XFILLER_5_181 vssd1 vssd1 vccd1 vccd1 sky130_fd_sc_hd__fill_4
X_1256_ net20 net133 _0491_ vssd1 vssd1 vccd1 vccd1 _0493_ sky130_fd_sc_hd__a21oi_1
XTAP_TAPCELL_ROW_3_118 vssd1 vccd1 sky130_fd_sc_hd__tapvpwrvgnd_1
X_1325_ _0496_ _0522_ _0534_ vssd1 vssd1 vccd1 vccd1 _0562_ sky130_fd_sc_hd__nand3_1
X_1187_ _0420_ _0423_ vssd1 vssd1 vccd1 vccd1 _0424_ sky130_fd_sc_hd__or2_2
XFILLER_33_17 vccd1 vssd1 vccd1 vssd1 sky130_ef_sc_hd__decap_40_12
Xclone9 _0655_ vssd1 vssd1 vccd1 vccd1 net117 sky130_fd_sc_hd__clkbuf_1
XFILLER_15_225 vssd1 vssd1 vccd1 vccd1 sky130_fd_sc_hd__fill_4
XFILLER_23_50 vssd1 vssd1 vccd1 vccd1 sky130_fd_sc_hd__fill_4
X_1110_ _0342_ _0346_ _0340_ vssd1 vssd1 vccd1 vccd1 _0347_ sky130_fd_sc_hd__a21oi_1
X_1041_ net129 vssd1 vssd1 vccd1 vccd1 _0278_ sky130_fd_sc_hd__inv_2
XTAP_TAPCELL_ROW_31_256 vssd1 vccd1 sky130_fd_sc_hd__tapvpwrvgnd_1
X_0825_ net43 STOPWATCH_INST.digit_scanner.ctrl _0087_ STOPWATCH_INST.bcd_num\[1\]
+ vssd1 vssd1 vccd1 vccd1 _0098_ sky130_fd_sc_hd__or4b_1
X_1239_ _0474_ _0475_ vssd1 vssd1 vccd1 vccd1 _0476_ sky130_fd_sc_hd__and2_1
X_1308_ _0517_ _0544_ vssd1 vssd1 vccd1 vccd1 _0545_ sky130_fd_sc_hd__xnor2_2
XFILLER_44_27 vssd1 vssd1 vccd1 vccd1 sky130_fd_sc_hd__fill_1
XTAP_TAPCELL_ROW_22_212 vssd1 vccd1 sky130_fd_sc_hd__tapvpwrvgnd_1
XANTENNA__1229__A net42 vssd1 vssd1 vccd1 vccd1 sky130_fd_sc_hd__diode_2
XPHY_EDGE_ROW_8_Left_55 vssd1 vssd1 vccd1 vccd1 sky130_fd_sc_hd__decap_3
XTAP_TAPCELL_ROW_45_326 vssd1 vccd1 sky130_fd_sc_hd__tapvpwrvgnd_1
XFILLER_34_60 vssd1 vssd1 vccd1 vccd1 sky130_fd_sc_hd__fill_4
X_1590_ clknet_3_0__leaf_clk _0008_ net45 vssd1 vssd1 vccd1 vccd1 STOPWATCH_INST.bcd_num\[7\]
+ sky130_fd_sc_hd__dfrtp_1
X_1024_ _0258_ _0260_ vssd1 vssd1 vccd1 vccd1 _0261_ sky130_fd_sc_hd__or2_1
XFILLER_30_29 vccd1 vssd1 vccd1 vssd1 sky130_ef_sc_hd__decap_40_12
XFILLER_30_18 vssd1 vssd1 vccd1 vccd1 sky130_fd_sc_hd__fill_8
X_0808_ STOPWATCH_INST.bcd_num\[5\] STOPWATCH_INST.bcd_num\[4\] vssd1 vssd1 vccd1
+ vccd1 _0083_ sky130_fd_sc_hd__nand2b_1
XFILLER_29_125 vccd1 vssd1 vccd1 vssd1 sky130_ef_sc_hd__decap_40_12
XFILLER_37_191 vssd1 vssd1 vccd1 vccd1 sky130_fd_sc_hd__fill_2
XFILLER_20_40 vssd1 vssd1 vccd1 vccd1 sky130_fd_sc_hd__fill_2
Xhold93 STOPWATCH_INST.digit_scanner.period_counter\[1\] vssd1 vssd1 vccd1 vccd1 net201
+ sky130_fd_sc_hd__dlygate4sd3_1
Xhold82 STOPWATCH_INST.sync_pause.sync_2 vssd1 vssd1 vccd1 vccd1 net190 sky130_fd_sc_hd__dlygate4sd3_1
XFILLER_28_191 vssd1 vssd1 vccd1 vccd1 sky130_fd_sc_hd__fill_4
XFILLER_6_97 vssd1 vssd1 vccd1 vccd1 sky130_fd_sc_hd__fill_8
X_1573_ clknet_3_2__leaf_clk net184 net48 vssd1 vssd1 vccd1 vccd1 STOPWATCH_INST.sync_pause.sync_2
+ sky130_fd_sc_hd__dfrtp_1
Xrebuffer14 net131 vssd1 vssd1 vccd1 vccd1 net122 sky130_fd_sc_hd__buf_1
X_1007_ _0232_ _0236_ _0237_ _0243_ vssd1 vssd1 vccd1 vccd1 _0244_ sky130_fd_sc_hd__or4b_4
Xrebuffer36 _0641_ vssd1 vssd1 vccd1 vccd1 net144 sky130_fd_sc_hd__dlygate4sd1_1
XFILLER_34_194 vssd1 vssd1 vccd1 vccd1 sky130_fd_sc_hd__fill_2
XFILLER_17_117 vssd1 vssd1 vccd1 vccd1 sky130_fd_sc_hd__fill_1
XFILLER_40_120 vssd1 vssd1 vccd1 vccd1 sky130_fd_sc_hd__fill_8
XFILLER_25_161 vssd1 vssd1 vccd1 vccd1 sky130_fd_sc_hd__fill_1
XFILLER_40_197 vccd1 vssd1 vccd1 vssd1 sky130_ef_sc_hd__decap_40_12
XFILLER_40_175 vssd1 vssd1 vccd1 vccd1 sky130_fd_sc_hd__fill_2
XFILLER_31_175 vccd1 vssd1 vccd1 vssd1 sky130_ef_sc_hd__decap_40_12
XFILLER_16_161 vccd1 vssd1 vccd1 vssd1 sky130_ef_sc_hd__decap_40_12
XTAP_TAPCELL_ROW_18_189 vssd1 vccd1 sky130_fd_sc_hd__tapvpwrvgnd_1
X_1556_ _0771_ vssd1 vssd1 vccd1 vccd1 _0772_ sky130_fd_sc_hd__inv_2
X_1625_ clknet_3_3__leaf_clk _0043_ net47 vssd1 vssd1 vccd1 vccd1 STOPWATCH_INST.clock_div.cycles\[18\]
+ sky130_fd_sc_hd__dfrtp_4
XFILLER_39_286 vssd1 vssd1 vccd1 vccd1 sky130_fd_sc_hd__fill_8
X_1487_ net34 _0712_ _0715_ net38 STOPWATCH_INST.clock_div.cycles\[15\] vssd1 vssd1
+ vccd1 vccd1 _0040_ sky130_fd_sc_hd__a32o_1
XFILLER_22_153 vssd1 vssd1 vccd1 vccd1 sky130_fd_sc_hd__fill_2
XTAP_TAPCELL_ROW_9_146 vssd1 vccd1 sky130_fd_sc_hd__tapvpwrvgnd_1
XFILLER_45_278 vssd1 vssd1 vccd1 vccd1 sky130_fd_sc_hd__fill_2
XFILLER_45_212 vccd1 vssd1 vccd1 vssd1 sky130_ef_sc_hd__decap_40_12
XPHY_EDGE_ROW_37_Left_84 vssd1 vssd1 vccd1 vccd1 sky130_fd_sc_hd__decap_3
XFILLER_13_131 vssd1 vssd1 vccd1 vccd1 sky130_fd_sc_hd__fill_2
Xrebuffer5 _0410_ vssd1 vssd1 vccd1 vccd1 net113 sky130_fd_sc_hd__dlygate4sd1_1
X_1410_ _0576_ _0636_ _0572_ vssd1 vssd1 vccd1 vccd1 _0647_ sky130_fd_sc_hd__a21bo_1
XPHY_EDGE_ROW_21_Left_68 vssd1 vssd1 vccd1 vccd1 sky130_fd_sc_hd__decap_3
X_1272_ _0449_ _0508_ vssd1 vssd1 vccd1 vccd1 _0509_ sky130_fd_sc_hd__xnor2_2
XFILLER_3_54 vssd1 vssd1 vccd1 vccd1 sky130_fd_sc_hd__fill_2
X_1341_ _0500_ net150 _0569_ vssd1 vssd1 vccd1 vccd1 _0578_ sky130_fd_sc_hd__nand3b_1
XFILLER_36_234 vssd1 vssd1 vccd1 vccd1 sky130_fd_sc_hd__fill_1
X_0987_ _0214_ _0216_ _0219_ _0220_ _0203_ vssd1 vssd1 vccd1 vccd1 _0224_ sky130_fd_sc_hd__o2111a_1
XTAP_TAPCELL_ROW_14_170 vssd1 vccd1 sky130_fd_sc_hd__tapvpwrvgnd_1
XANTENNA__0896__A _0122_ vssd1 vssd1 vccd1 vccd1 sky130_fd_sc_hd__diode_2
X_1608_ clknet_3_1__leaf_clk _0026_ net46 vssd1 vssd1 vccd1 vccd1 STOPWATCH_INST.clock_div.cycles\[1\]
+ sky130_fd_sc_hd__dfrtp_1
X_1539_ _0757_ _0758_ _0759_ _0174_ vssd1 vssd1 vccd1 vccd1 _0760_ sky130_fd_sc_hd__o22a_1
XFILLER_27_201 vssd1 vssd1 vccd1 vccd1 sky130_fd_sc_hd__fill_1
XTAP_TAPCELL_ROW_37_284 vssd1 vccd1 sky130_fd_sc_hd__tapvpwrvgnd_1
XANTENNA__1638__RESET_B net49 vssd1 vssd1 vccd1 vccd1 sky130_fd_sc_hd__diode_2
XFILLER_6_105 vssd1 vssd1 vccd1 vccd1 sky130_fd_sc_hd__fill_2
XFILLER_12_85 vccd1 vssd1 vccd1 vssd1 sky130_ef_sc_hd__decap_40_12
XFILLER_33_259 vssd1 vssd1 vccd1 vccd1 sky130_fd_sc_hd__fill_1
XFILLER_33_237 vssd1 vssd1 vccd1 vccd1 sky130_fd_sc_hd__fill_4
XTAP_TAPCELL_ROW_28_240 vssd1 vccd1 sky130_fd_sc_hd__tapvpwrvgnd_1
XPHY_EDGE_ROW_16_Right_16 vssd1 vssd1 vccd1 vccd1 sky130_fd_sc_hd__decap_3
XFILLER_18_212 vssd1 vssd1 vccd1 vccd1 sky130_fd_sc_hd__fill_1
XFILLER_41_281 vccd1 vssd1 vccd1 vssd1 sky130_ef_sc_hd__decap_40_12
XFILLER_41_270 vssd1 vssd1 vccd1 vccd1 sky130_fd_sc_hd__fill_1
X_0910_ STOPWATCH_INST.digit_scanner.period_counter\[13\] _0152_ net199 vssd1 vssd1
+ vccd1 vccd1 _0156_ sky130_fd_sc_hd__a21oi_1
X_0841_ STOPWATCH_INST.bcd_num\[1\] net43 STOPWATCH_INST.bcd_num\[2\] vssd1 vssd1
+ vccd1 vccd1 _0111_ sky130_fd_sc_hd__and3_1
XPHY_EDGE_ROW_25_Right_25 vssd1 vssd1 vccd1 vccd1 sky130_fd_sc_hd__decap_3
X_1186_ net113 net151 _0413_ vssd1 vssd1 vccd1 vccd1 _0423_ sky130_fd_sc_hd__a21oi_1
XPHY_EDGE_ROW_34_Right_34 vssd1 vssd1 vccd1 vccd1 sky130_fd_sc_hd__decap_3
X_1255_ net20 net133 _0483_ vssd1 vssd1 vccd1 vccd1 _0492_ sky130_fd_sc_hd__a21oi_1
X_1324_ net17 _0522_ _0490_ _0495_ vssd1 vssd1 vccd1 vccd1 _0561_ sky130_fd_sc_hd__a31o_1
XFILLER_33_29 vssd1 vssd1 vccd1 vccd1 sky130_fd_sc_hd__fill_2
XPHY_EDGE_ROW_43_Right_43 vssd1 vssd1 vccd1 vccd1 sky130_fd_sc_hd__decap_3
XFILLER_15_248 vssd1 vssd1 vccd1 vccd1 sky130_fd_sc_hd__fill_1
XFILLER_23_292 vssd1 vssd1 vccd1 vccd1 sky130_fd_sc_hd__fill_4
XFILLER_2_174 vssd1 vssd1 vccd1 vccd1 sky130_fd_sc_hd__fill_4
X_1040_ net41 _0253_ _0252_ _0276_ vssd1 vssd1 vccd1 vccd1 _0277_ sky130_fd_sc_hd__o211a_4
XFILLER_0_22 vssd1 vssd1 vccd1 vccd1 sky130_fd_sc_hd__fill_2
XFILLER_0_55 vssd1 vssd1 vccd1 vccd1 sky130_fd_sc_hd__fill_1
XFILLER_9_31 vssd1 vssd1 vccd1 vccd1 sky130_fd_sc_hd__fill_2
XTAP_TAPCELL_ROW_31_257 vssd1 vccd1 sky130_fd_sc_hd__tapvpwrvgnd_1
X_0824_ STOPWATCH_INST.bcd_num\[4\] _0096_ vssd1 vssd1 vccd1 vccd1 _0097_ sky130_fd_sc_hd__or2_1
XFILLER_9_64 vssd1 vssd1 vccd1 vccd1 sky130_fd_sc_hd__fill_2
XPHY_EDGE_ROW_24_Left_71 vssd1 vssd1 vccd1 vccd1 sky130_fd_sc_hd__decap_3
XFILLER_28_29 vssd1 vssd1 vccd1 vccd1 sky130_fd_sc_hd__fill_2
X_1169_ _0327_ _0403_ vssd1 vssd1 vccd1 vccd1 _0406_ sky130_fd_sc_hd__xnor2_1
X_1238_ _0411_ _0420_ vssd1 vssd1 vccd1 vccd1 _0475_ sky130_fd_sc_hd__xnor2_4
X_1307_ _0514_ net128 vssd1 vssd1 vccd1 vccd1 _0544_ sky130_fd_sc_hd__nand2b_1
XFILLER_20_251 vssd1 vssd1 vccd1 vccd1 sky130_fd_sc_hd__fill_1
XTAP_TAPCELL_ROW_22_213 vssd1 vccd1 sky130_fd_sc_hd__tapvpwrvgnd_1
Xclkbuf_3_0__f_clk clknet_0_clk vssd1 vssd1 vccd1 vccd1 clknet_3_0__leaf_clk sky130_fd_sc_hd__clkbuf_16
XTAP_TAPCELL_ROW_45_327 vssd1 vccd1 sky130_fd_sc_hd__tapvpwrvgnd_1
XFILLER_34_72 vccd1 vssd1 vccd1 vssd1 sky130_ef_sc_hd__decap_40_12
XFILLER_46_181 vccd1 vssd1 vccd1 vssd1 sky130_ef_sc_hd__decap_40_12
X_1023_ _0206_ _0259_ vssd1 vssd1 vccd1 vccd1 _0260_ sky130_fd_sc_hd__xnor2_2
X_0807_ STOPWATCH_INST.bcd_num\[7\] STOPWATCH_INST.bcd_num\[6\] vssd1 vssd1 vccd1
+ vccd1 _0082_ sky130_fd_sc_hd__nand2b_1
XFILLER_29_137 vccd1 vssd1 vccd1 vssd1 sky130_ef_sc_hd__decap_40_12
XFILLER_29_104 vssd1 vssd1 vccd1 vccd1 sky130_fd_sc_hd__fill_8
XPHY_EDGE_ROW_2_Right_2 vssd1 vssd1 vccd1 vccd1 sky130_fd_sc_hd__decap_3
XANTENNA__1315__A1 _0060_ vssd1 vssd1 vccd1 vccd1 sky130_fd_sc_hd__diode_2
Xhold94 STOPWATCH_INST.clock_div.cycles\[6\] vssd1 vssd1 vccd1 vccd1 net202 sky130_fd_sc_hd__dlygate4sd3_1
Xhold83 STOPWATCH_INST.sync_clear.sync_2 vssd1 vssd1 vccd1 vccd1 net191 sky130_fd_sc_hd__dlygate4sd3_1
X_1572_ clknet_3_3__leaf_clk net4 net44 vssd1 vssd1 vccd1 vccd1 STOPWATCH_INST.sync_clear.sync_1
+ sky130_fd_sc_hd__dfrtp_1
Xrebuffer37 _0279_ vssd1 vssd1 vccd1 vccd1 net145 sky130_fd_sc_hd__dlygate4sd3_1
Xrebuffer15 _0245_ vssd1 vssd1 vccd1 vccd1 net123 sky130_fd_sc_hd__buf_4
Xrebuffer26 _0229_ vssd1 vssd1 vccd1 vccd1 net134 sky130_fd_sc_hd__dlygate4sd1_1
X_1006_ _0242_ _0239_ vssd1 vssd1 vccd1 vccd1 _0243_ sky130_fd_sc_hd__nor2_4
XANTENNA__1481__B1 net38 vssd1 vssd1 vccd1 vccd1 sky130_fd_sc_hd__diode_2
XFILLER_19_181 vccd1 vssd1 vccd1 vssd1 sky130_ef_sc_hd__decap_40_12
XFILLER_41_18 vccd1 vssd1 vccd1 vssd1 sky130_ef_sc_hd__decap_40_12
XFILLER_1_239 vssd1 vssd1 vccd1 vccd1 sky130_fd_sc_hd__fill_1
XFILLER_17_107 vssd1 vssd1 vccd1 vccd1 sky130_fd_sc_hd__fill_4
XFILLER_15_63 vssd1 vssd1 vccd1 vccd1 sky130_fd_sc_hd__fill_1
XFILLER_25_195 vssd1 vssd1 vccd1 vccd1 sky130_fd_sc_hd__fill_8
XFILLER_31_187 vssd1 vssd1 vccd1 vccd1 sky130_fd_sc_hd__fill_2
XFILLER_16_195 vssd1 vssd1 vccd1 vccd1 sky130_fd_sc_hd__fill_1
X_1555_ STOPWATCH_INST.clock_div.cycles\[27\] STOPWATCH_INST.clock_div.cycles\[28\]
+ _0767_ vssd1 vssd1 vccd1 vccd1 _0771_ sky130_fd_sc_hd__and3_1
X_1624_ clknet_3_7__leaf_clk _0042_ net47 vssd1 vssd1 vccd1 vccd1 STOPWATCH_INST.clock_div.cycles\[17\]
+ sky130_fd_sc_hd__dfrtp_4
X_1486_ _0713_ _0714_ net32 vssd1 vssd1 vccd1 vccd1 _0715_ sky130_fd_sc_hd__o21ai_1
XFILLER_7_6 vccd1 vssd1 vccd1 vssd1 sky130_ef_sc_hd__decap_40_12
XTAP_TAPCELL_ROW_9_147 vssd1 vccd1 sky130_fd_sc_hd__tapvpwrvgnd_1
XFILLER_42_83 vssd1 vssd1 vccd1 vccd1 sky130_fd_sc_hd__fill_1
Xrebuffer6 net113 vssd1 vssd1 vccd1 vccd1 net114 sky130_fd_sc_hd__dlygate4sd1_1
XANTENNA__1428__A STOPWATCH_INST.clock_div.cycles\[7\] vssd1 vssd1 vccd1 vccd1 sky130_fd_sc_hd__diode_2
X_1340_ _0575_ _0574_ _0560_ _0571_ vssd1 vssd1 vccd1 vccd1 _0577_ sky130_fd_sc_hd__a211o_4
XFILLER_3_44 vssd1 vssd1 vccd1 vccd1 sky130_fd_sc_hd__fill_1
X_1271_ net20 net133 net42 vssd1 vssd1 vccd1 vccd1 _0508_ sky130_fd_sc_hd__a21o_1
XFILLER_44_290 vssd1 vssd1 vccd1 vccd1 sky130_fd_sc_hd__fill_4
XFILLER_36_279 vccd1 vssd1 vccd1 vssd1 sky130_ef_sc_hd__decap_40_12
XFILLER_36_246 vssd1 vssd1 vccd1 vccd1 sky130_fd_sc_hd__fill_4
X_0986_ _0203_ _0206_ vssd1 vssd1 vccd1 vccd1 _0223_ sky130_fd_sc_hd__and2_1
XTAP_TAPCELL_ROW_14_171 vssd1 vccd1 sky130_fd_sc_hd__tapvpwrvgnd_1
X_1469_ net34 _0697_ _0700_ net38 STOPWATCH_INST.clock_div.cycles\[12\] vssd1 vssd1
+ vccd1 vccd1 _0037_ sky130_fd_sc_hd__a32o_1
X_1607_ clknet_3_1__leaf_clk _0025_ net46 vssd1 vssd1 vccd1 vccd1 STOPWATCH_INST.clock_div.cycles\[0\]
+ sky130_fd_sc_hd__dfrtp_1
X_1538_ STOPWATCH_INST.clock_div.cycles\[23\] _0755_ vssd1 vssd1 vccd1 vccd1 _0759_
+ sky130_fd_sc_hd__xor2_1
XFILLER_42_238 vssd1 vssd1 vccd1 vccd1 sky130_fd_sc_hd__fill_2
XTAP_TAPCELL_ROW_37_285 vssd1 vccd1 sky130_fd_sc_hd__tapvpwrvgnd_1
XFILLER_10_113 vssd1 vssd1 vccd1 vccd1 sky130_fd_sc_hd__fill_1
XFILLER_12_20 vssd1 vssd1 vccd1 vccd1 sky130_fd_sc_hd__fill_8
XFILLER_6_139 vssd1 vssd1 vccd1 vccd1 sky130_fd_sc_hd__fill_1
XFILLER_12_42 vccd1 vssd1 vccd1 vssd1 sky130_ef_sc_hd__decap_40_12
XFILLER_12_97 vssd1 vssd1 vccd1 vccd1 sky130_fd_sc_hd__fill_1
XFILLER_33_249 vssd1 vssd1 vccd1 vccd1 sky130_fd_sc_hd__fill_8
XTAP_TAPCELL_ROW_28_241 vssd1 vccd1 sky130_fd_sc_hd__tapvpwrvgnd_1
XFILLER_26_290 vssd1 vssd1 vccd1 vccd1 sky130_fd_sc_hd__fill_8
XFILLER_41_293 vssd1 vssd1 vccd1 vccd1 sky130_fd_sc_hd__fill_2
X_0840_ STOPWATCH_INST.bcd_num\[1\] net43 vssd1 vssd1 vccd1 vccd1 _0110_ sky130_fd_sc_hd__nand2_1
XFILLER_38_3 vccd1 vssd1 vccd1 vssd1 sky130_ef_sc_hd__decap_40_12
X_1323_ _0490_ _0522_ net17 vssd1 vssd1 vccd1 vccd1 _0560_ sky130_fd_sc_hd__and3_1
X_1185_ _0380_ _0421_ vssd1 vssd1 vccd1 vccd1 _0422_ sky130_fd_sc_hd__xnor2_1
X_1254_ _0444_ _0484_ _0435_ vssd1 vssd1 vccd1 vccd1 _0491_ sky130_fd_sc_hd__a21boi_1
X_0969_ _0157_ _0204_ _0205_ vssd1 vssd1 vccd1 vccd1 _0206_ sky130_fd_sc_hd__a21oi_2
XANTENNA_fanout45_A net5 vssd1 vssd1 vccd1 vccd1 sky130_fd_sc_hd__diode_2
XFILLER_23_260 vssd1 vssd1 vccd1 vccd1 sky130_fd_sc_hd__fill_4
XFILLER_0_12 vssd1 vssd1 vccd1 vccd1 sky130_fd_sc_hd__fill_2
XTAP_TAPCELL_ROW_31_258 vssd1 vccd1 sky130_fd_sc_hd__tapvpwrvgnd_1
X_0823_ STOPWATCH_INST.bcd_num\[7\] STOPWATCH_INST.bcd_num\[6\] STOPWATCH_INST.bcd_num\[5\]
+ vssd1 vssd1 vccd1 vccd1 _0096_ sky130_fd_sc_hd__or3b_1
XFILLER_9_98 vssd1 vssd1 vccd1 vccd1 sky130_fd_sc_hd__fill_1
X_1306_ _0537_ _0538_ _0542_ vssd1 vssd1 vccd1 vccd1 _0543_ sky130_fd_sc_hd__or3_1
X_1237_ _0461_ _0473_ vssd1 vssd1 vccd1 vccd1 _0474_ sky130_fd_sc_hd__and2b_1
X_1168_ _0348_ _0364_ _0327_ vssd1 vssd1 vccd1 vccd1 _0405_ sky130_fd_sc_hd__o21ai_1
X_1099_ net148 _0332_ vssd1 vssd1 vccd1 vccd1 _0336_ sky130_fd_sc_hd__xor2_2
XFILLER_12_208 vssd1 vssd1 vccd1 vccd1 sky130_fd_sc_hd__fill_1
XFILLER_20_230 vssd1 vssd1 vccd1 vccd1 sky130_fd_sc_hd__fill_1
XFILLER_20_274 vssd1 vssd1 vccd1 vccd1 sky130_fd_sc_hd__fill_2
XFILLER_18_85 vssd1 vssd1 vccd1 vccd1 sky130_fd_sc_hd__fill_8
XTAP_TAPCELL_ROW_45_328 vssd1 vccd1 sky130_fd_sc_hd__tapvpwrvgnd_1
XANTENNA__1622__RESET_B net49 vssd1 vssd1 vccd1 vccd1 sky130_fd_sc_hd__diode_2
XFILLER_46_193 vssd1 vssd1 vccd1 vccd1 sky130_fd_sc_hd__fill_2
X_1022_ net112 _0247_ _0222_ vssd1 vssd1 vccd1 vccd1 _0259_ sky130_fd_sc_hd__a21oi_2
X_0806_ STOPWATCH_INST.fsm_inst1.currentState\[1\] _0058_ _0074_ _0080_ _0081_ vssd1
+ vssd1 vccd1 vccd1 STOPWATCH_INST.fsm_inst1.nextState\[1\] sky130_fd_sc_hd__a311o_1
XFILLER_44_108 vssd1 vssd1 vccd1 vccd1 sky130_fd_sc_hd__fill_1
XTAP_TAPCELL_ROW_42_309 vssd1 vccd1 sky130_fd_sc_hd__tapvpwrvgnd_1
XFILLER_20_42 vssd1 vssd1 vccd1 vccd1 sky130_fd_sc_hd__fill_1
XFILLER_4_259 vssd1 vssd1 vccd1 vccd1 sky130_fd_sc_hd__fill_4
Xhold95 STOPWATCH_INST.digit_scanner.period_counter\[13\] vssd1 vssd1 vccd1 vccd1
+ net203 sky130_fd_sc_hd__dlygate4sd3_1
Xhold84 STOPWATCH_INST.digit_scanner.period_counter\[0\] vssd1 vssd1 vccd1 vccd1 net192
+ sky130_fd_sc_hd__dlygate4sd3_1
XFILLER_6_33 vccd1 vssd1 vccd1 vssd1 sky130_ef_sc_hd__decap_40_12
X_1571_ clknet_3_3__leaf_clk net191 net44 vssd1 vssd1 vccd1 vccd1 STOPWATCH_INST.sync_clear.q
+ sky130_fd_sc_hd__dfrtp_1
Xrebuffer16 _0232_ vssd1 vssd1 vccd1 vccd1 net124 sky130_fd_sc_hd__dlygate4sd3_1
Xrebuffer38 _0274_ vssd1 vssd1 vccd1 vccd1 net146 sky130_fd_sc_hd__dlymetal6s2s_1
XFILLER_34_141 vssd1 vssd1 vccd1 vccd1 sky130_fd_sc_hd__fill_2
X_1005_ _0170_ _0187_ _0193_ _0241_ vssd1 vssd1 vccd1 vccd1 _0242_ sky130_fd_sc_hd__o31a_1
XFILLER_19_160 vssd1 vssd1 vccd1 vccd1 sky130_fd_sc_hd__fill_2
XFILLER_19_193 vccd1 vssd1 vccd1 vssd1 sky130_ef_sc_hd__decap_40_12
XFILLER_1_207 vssd1 vssd1 vccd1 vccd1 sky130_fd_sc_hd__fill_8
XFILLER_1_229 vssd1 vssd1 vccd1 vccd1 sky130_fd_sc_hd__fill_1
Xoutput6 net6 vssd1 vssd1 vccd1 vccd1 gpio_out[10] sky130_fd_sc_hd__buf_2
XFILLER_0_251 vssd1 vssd1 vccd1 vccd1 sky130_fd_sc_hd__fill_1
X_1554_ STOPWATCH_INST.clock_div.cycles\[27\] _0767_ STOPWATCH_INST.clock_div.cycles\[28\]
+ vssd1 vssd1 vccd1 vccd1 _0770_ sky130_fd_sc_hd__a21o_1
X_1485_ STOPWATCH_INST.clock_div.cycles\[15\] _0708_ vssd1 vssd1 vccd1 vccd1 _0714_
+ sky130_fd_sc_hd__and2_1
X_1623_ clknet_3_3__leaf_clk _0041_ net49 vssd1 vssd1 vccd1 vccd1 STOPWATCH_INST.clock_div.cycles\[16\]
+ sky130_fd_sc_hd__dfrtp_4
.ends
