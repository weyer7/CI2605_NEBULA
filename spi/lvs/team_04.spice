* NGSPICE file created from team_04.ext - technology: sky130A

* Black-box entry subcircuit for sky130_fd_sc_hd__fill_2 abstract view
.subckt sky130_fd_sc_hd__fill_2 VGND VNB VPB VPWR
.ends

* Black-box entry subcircuit for sky130_fd_sc_hd__tapvpwrvgnd_1 abstract view
.subckt sky130_fd_sc_hd__tapvpwrvgnd_1 VGND VPWR
.ends

* Black-box entry subcircuit for sky130_fd_sc_hd__fill_8 abstract view
.subckt sky130_fd_sc_hd__fill_8 VGND VNB VPB VPWR
.ends

* Black-box entry subcircuit for sky130_fd_sc_hd__xor2_2 abstract view
.subckt sky130_fd_sc_hd__xor2_2 A B VGND VNB VPB VPWR X
.ends

* Black-box entry subcircuit for sky130_fd_sc_hd__dfrtp_2 abstract view
.subckt sky130_fd_sc_hd__dfrtp_2 CLK D RESET_B VGND VNB VPB VPWR Q
.ends

* Black-box entry subcircuit for sky130_fd_sc_hd__a21oi_4 abstract view
.subckt sky130_fd_sc_hd__a21oi_4 A1 A2 B1 VGND VNB VPB VPWR Y
.ends

* Black-box entry subcircuit for sky130_fd_sc_hd__or2_2 abstract view
.subckt sky130_fd_sc_hd__or2_2 A B VGND VNB VPB VPWR X
.ends

* Black-box entry subcircuit for sky130_fd_sc_hd__nor2_2 abstract view
.subckt sky130_fd_sc_hd__nor2_2 A B VGND VNB VPB VPWR Y
.ends

* Black-box entry subcircuit for sky130_fd_sc_hd__and2_2 abstract view
.subckt sky130_fd_sc_hd__and2_2 A B VGND VNB VPB VPWR X
.ends

* Black-box entry subcircuit for sky130_fd_sc_hd__fill_1 abstract view
.subckt sky130_fd_sc_hd__fill_1 VGND VNB VPB VPWR
.ends

* Black-box entry subcircuit for sky130_fd_sc_hd__xnor2_2 abstract view
.subckt sky130_fd_sc_hd__xnor2_2 A B VGND VNB VPB VPWR Y
.ends

* Black-box entry subcircuit for sky130_fd_sc_hd__a21bo_2 abstract view
.subckt sky130_fd_sc_hd__a21bo_2 A1 A2 B1_N VGND VNB VPB VPWR X
.ends

* Black-box entry subcircuit for sky130_fd_sc_hd__clkbuf_8 abstract view
.subckt sky130_fd_sc_hd__clkbuf_8 A VGND VNB VPB VPWR X
.ends

* Black-box entry subcircuit for sky130_fd_sc_hd__a21o_2 abstract view
.subckt sky130_fd_sc_hd__a21o_2 A1 A2 B1 VGND VNB VPB VPWR X
.ends

* Black-box entry subcircuit for sky130_ef_sc_hd__decap_40_12 abstract view
.subckt sky130_ef_sc_hd__decap_40_12 VNB VPB VGND VPWR
.ends

* Black-box entry subcircuit for sky130_fd_sc_hd__fill_4 abstract view
.subckt sky130_fd_sc_hd__fill_4 VGND VNB VPB VPWR
.ends

* Black-box entry subcircuit for sky130_fd_sc_hd__o21ai_2 abstract view
.subckt sky130_fd_sc_hd__o21ai_2 A1 A2 B1 VGND VNB VPB VPWR Y
.ends

* Black-box entry subcircuit for sky130_fd_sc_hd__and3_2 abstract view
.subckt sky130_fd_sc_hd__and3_2 A B C VGND VNB VPB VPWR X
.ends

* Black-box entry subcircuit for sky130_fd_sc_hd__a311o_2 abstract view
.subckt sky130_fd_sc_hd__a311o_2 A1 A2 A3 B1 C1 VGND VNB VPB VPWR X
.ends

* Black-box entry subcircuit for sky130_fd_sc_hd__inv_2 abstract view
.subckt sky130_fd_sc_hd__inv_2 A VGND VNB VPB VPWR Y
.ends

* Black-box entry subcircuit for sky130_fd_sc_hd__and3b_2 abstract view
.subckt sky130_fd_sc_hd__and3b_2 A_N B C VGND VNB VPB VPWR X
.ends

* Black-box entry subcircuit for sky130_fd_sc_hd__buf_2 abstract view
.subckt sky130_fd_sc_hd__buf_2 A VGND VNB VPB VPWR X
.ends

* Black-box entry subcircuit for sky130_fd_sc_hd__clkdlybuf4s25_1 abstract view
.subckt sky130_fd_sc_hd__clkdlybuf4s25_1 A VGND VNB VPB VPWR X
.ends

* Black-box entry subcircuit for sky130_fd_sc_hd__or4_2 abstract view
.subckt sky130_fd_sc_hd__or4_2 A B C D VGND VNB VPB VPWR X
.ends

* Black-box entry subcircuit for sky130_fd_sc_hd__a32o_2 abstract view
.subckt sky130_fd_sc_hd__a32o_2 A1 A2 A3 B1 B2 VGND VNB VPB VPWR X
.ends

* Black-box entry subcircuit for sky130_fd_sc_hd__diode_2 abstract view
.subckt sky130_fd_sc_hd__diode_2 DIODE VGND VNB VPB VPWR
.ends

* Black-box entry subcircuit for sky130_fd_sc_hd__nand3_2 abstract view
.subckt sky130_fd_sc_hd__nand3_2 A B C VGND VNB VPB VPWR Y
.ends

* Black-box entry subcircuit for sky130_fd_sc_hd__or3b_4 abstract view
.subckt sky130_fd_sc_hd__or3b_4 A B C_N VGND VNB VPB VPWR X
.ends

* Black-box entry subcircuit for sky130_fd_sc_hd__a31o_2 abstract view
.subckt sky130_fd_sc_hd__a31o_2 A1 A2 A3 B1 VGND VNB VPB VPWR X
.ends

* Black-box entry subcircuit for sky130_fd_sc_hd__nand2_2 abstract view
.subckt sky130_fd_sc_hd__nand2_2 A B VGND VNB VPB VPWR Y
.ends

* Black-box entry subcircuit for sky130_fd_sc_hd__a21o_4 abstract view
.subckt sky130_fd_sc_hd__a21o_4 A1 A2 B1 VGND VNB VPB VPWR X
.ends

* Black-box entry subcircuit for sky130_fd_sc_hd__a22oi_2 abstract view
.subckt sky130_fd_sc_hd__a22oi_2 A1 A2 B1 B2 VGND VNB VPB VPWR Y
.ends

* Black-box entry subcircuit for sky130_fd_sc_hd__decap_3 abstract view
.subckt sky130_fd_sc_hd__decap_3 VGND VNB VPB VPWR
.ends

* Black-box entry subcircuit for sky130_fd_sc_hd__o21a_2 abstract view
.subckt sky130_fd_sc_hd__o21a_2 A1 A2 B1 VGND VNB VPB VPWR X
.ends

* Black-box entry subcircuit for sky130_fd_sc_hd__nand2b_2 abstract view
.subckt sky130_fd_sc_hd__nand2b_2 A_N B VGND VNB VPB VPWR Y
.ends

* Black-box entry subcircuit for sky130_fd_sc_hd__or3b_2 abstract view
.subckt sky130_fd_sc_hd__or3b_2 A B C_N VGND VNB VPB VPWR X
.ends

* Black-box entry subcircuit for sky130_fd_sc_hd__or4bb_2 abstract view
.subckt sky130_fd_sc_hd__or4bb_2 A B C_N D_N VGND VNB VPB VPWR X
.ends

* Black-box entry subcircuit for sky130_fd_sc_hd__nand3_4 abstract view
.subckt sky130_fd_sc_hd__nand3_4 A B C VGND VNB VPB VPWR Y
.ends

* Black-box entry subcircuit for sky130_fd_sc_hd__a21oi_2 abstract view
.subckt sky130_fd_sc_hd__a21oi_2 A1 A2 B1 VGND VNB VPB VPWR Y
.ends

* Black-box entry subcircuit for sky130_fd_sc_hd__or4bb_4 abstract view
.subckt sky130_fd_sc_hd__or4bb_4 A B C_N D_N VGND VNB VPB VPWR X
.ends

* Black-box entry subcircuit for sky130_fd_sc_hd__nand2_4 abstract view
.subckt sky130_fd_sc_hd__nand2_4 A B VGND VNB VPB VPWR Y
.ends

* Black-box entry subcircuit for sky130_fd_sc_hd__o41a_2 abstract view
.subckt sky130_fd_sc_hd__o41a_2 A1 A2 A3 A4 B1 VGND VNB VPB VPWR X
.ends

* Black-box entry subcircuit for sky130_fd_sc_hd__or4b_2 abstract view
.subckt sky130_fd_sc_hd__or4b_2 A B C D_N VGND VNB VPB VPWR X
.ends

* Black-box entry subcircuit for sky130_fd_sc_hd__o41a_4 abstract view
.subckt sky130_fd_sc_hd__o41a_4 A1 A2 A3 A4 B1 VGND VNB VPB VPWR X
.ends

* Black-box entry subcircuit for sky130_fd_sc_hd__and4b_2 abstract view
.subckt sky130_fd_sc_hd__and4b_2 A_N B C D VGND VNB VPB VPWR X
.ends

* Black-box entry subcircuit for sky130_fd_sc_hd__and4_2 abstract view
.subckt sky130_fd_sc_hd__and4_2 A B C D VGND VNB VPB VPWR X
.ends

* Black-box entry subcircuit for sky130_fd_sc_hd__a21boi_2 abstract view
.subckt sky130_fd_sc_hd__a21boi_2 A1 A2 B1_N VGND VNB VPB VPWR Y
.ends

* Black-box entry subcircuit for sky130_fd_sc_hd__nand4b_4 abstract view
.subckt sky130_fd_sc_hd__nand4b_4 A_N B C D VGND VNB VPB VPWR Y
.ends

* Black-box entry subcircuit for sky130_fd_sc_hd__a22o_2 abstract view
.subckt sky130_fd_sc_hd__a22o_2 A1 A2 B1 B2 VGND VNB VPB VPWR X
.ends

* Black-box entry subcircuit for sky130_fd_sc_hd__o31a_2 abstract view
.subckt sky130_fd_sc_hd__o31a_2 A1 A2 A3 B1 VGND VNB VPB VPWR X
.ends

* Black-box entry subcircuit for sky130_fd_sc_hd__and2b_2 abstract view
.subckt sky130_fd_sc_hd__and2b_2 A_N B VGND VNB VPB VPWR X
.ends

* Black-box entry subcircuit for sky130_fd_sc_hd__and3_4 abstract view
.subckt sky130_fd_sc_hd__and3_4 A B C VGND VNB VPB VPWR X
.ends

* Black-box entry subcircuit for sky130_fd_sc_hd__clkbuf_2 abstract view
.subckt sky130_fd_sc_hd__clkbuf_2 A VGND VNB VPB VPWR X
.ends

* Black-box entry subcircuit for sky130_fd_sc_hd__a211o_4 abstract view
.subckt sky130_fd_sc_hd__a211o_4 A1 A2 B1 C1 VGND VNB VPB VPWR X
.ends

* Black-box entry subcircuit for sky130_fd_sc_hd__or2_4 abstract view
.subckt sky130_fd_sc_hd__or2_4 A B VGND VNB VPB VPWR X
.ends

* Black-box entry subcircuit for sky130_fd_sc_hd__o31ai_4 abstract view
.subckt sky130_fd_sc_hd__o31ai_4 A1 A2 A3 B1 VGND VNB VPB VPWR Y
.ends

* Black-box entry subcircuit for sky130_fd_sc_hd__xor2_4 abstract view
.subckt sky130_fd_sc_hd__xor2_4 A B VGND VNB VPB VPWR X
.ends

* Black-box entry subcircuit for sky130_fd_sc_hd__a221o_2 abstract view
.subckt sky130_fd_sc_hd__a221o_2 A1 A2 B1 B2 C1 VGND VNB VPB VPWR X
.ends

* Black-box entry subcircuit for sky130_fd_sc_hd__clkbuf_4 abstract view
.subckt sky130_fd_sc_hd__clkbuf_4 A VGND VNB VPB VPWR X
.ends

* Black-box entry subcircuit for sky130_fd_sc_hd__o21ba_2 abstract view
.subckt sky130_fd_sc_hd__o21ba_2 A1 A2 B1_N VGND VNB VPB VPWR X
.ends

* Black-box entry subcircuit for sky130_fd_sc_hd__o32ai_2 abstract view
.subckt sky130_fd_sc_hd__o32ai_2 A1 A2 A3 B1 B2 VGND VNB VPB VPWR Y
.ends

* Black-box entry subcircuit for sky130_fd_sc_hd__a211oi_2 abstract view
.subckt sky130_fd_sc_hd__a211oi_2 A1 A2 B1 C1 VGND VNB VPB VPWR Y
.ends

* Black-box entry subcircuit for sky130_fd_sc_hd__a2bb2o_4 abstract view
.subckt sky130_fd_sc_hd__a2bb2o_4 A1_N A2_N B1 B2 VGND VNB VPB VPWR X
.ends

* Black-box entry subcircuit for sky130_fd_sc_hd__o22a_2 abstract view
.subckt sky130_fd_sc_hd__o22a_2 A1 A2 B1 B2 VGND VNB VPB VPWR X
.ends

* Black-box entry subcircuit for sky130_fd_sc_hd__o211a_2 abstract view
.subckt sky130_fd_sc_hd__o211a_2 A1 A2 B1 C1 VGND VNB VPB VPWR X
.ends

* Black-box entry subcircuit for sky130_fd_sc_hd__or3_4 abstract view
.subckt sky130_fd_sc_hd__or3_4 A B C VGND VNB VPB VPWR X
.ends

* Black-box entry subcircuit for sky130_fd_sc_hd__o21ba_4 abstract view
.subckt sky130_fd_sc_hd__o21ba_4 A1 A2 B1_N VGND VNB VPB VPWR X
.ends

* Black-box entry subcircuit for sky130_fd_sc_hd__buf_4 abstract view
.subckt sky130_fd_sc_hd__buf_4 A VGND VNB VPB VPWR X
.ends

* Black-box entry subcircuit for sky130_fd_sc_hd__o211a_4 abstract view
.subckt sky130_fd_sc_hd__o211a_4 A1 A2 B1 C1 VGND VNB VPB VPWR X
.ends

* Black-box entry subcircuit for sky130_fd_sc_hd__nor3_4 abstract view
.subckt sky130_fd_sc_hd__nor3_4 A B C VGND VNB VPB VPWR Y
.ends

* Black-box entry subcircuit for sky130_fd_sc_hd__buf_8 abstract view
.subckt sky130_fd_sc_hd__buf_8 A VGND VNB VPB VPWR X
.ends

* Black-box entry subcircuit for sky130_fd_sc_hd__xnor2_4 abstract view
.subckt sky130_fd_sc_hd__xnor2_4 A B VGND VNB VPB VPWR Y
.ends

* Black-box entry subcircuit for sky130_fd_sc_hd__clkbuf_16 abstract view
.subckt sky130_fd_sc_hd__clkbuf_16 A VGND VNB VPB VPWR X
.ends

* Black-box entry subcircuit for sky130_fd_sc_hd__or4_4 abstract view
.subckt sky130_fd_sc_hd__or4_4 A B C D VGND VNB VPB VPWR X
.ends

* Black-box entry subcircuit for sky130_fd_sc_hd__o311a_2 abstract view
.subckt sky130_fd_sc_hd__o311a_2 A1 A2 A3 B1 C1 VGND VNB VPB VPWR X
.ends

* Black-box entry subcircuit for sky130_fd_sc_hd__nand3b_2 abstract view
.subckt sky130_fd_sc_hd__nand3b_2 A_N B C VGND VNB VPB VPWR Y
.ends

* Black-box entry subcircuit for sky130_fd_sc_hd__a211o_2 abstract view
.subckt sky130_fd_sc_hd__a211o_2 A1 A2 B1 C1 VGND VNB VPB VPWR X
.ends

* Black-box entry subcircuit for sky130_fd_sc_hd__a2bb2o_2 abstract view
.subckt sky130_fd_sc_hd__a2bb2o_2 A1_N A2_N B1 B2 VGND VNB VPB VPWR X
.ends

* Black-box entry subcircuit for sky130_fd_sc_hd__mux2_1 abstract view
.subckt sky130_fd_sc_hd__mux2_1 A0 A1 S VGND VNB VPB VPWR X
.ends

* Black-box entry subcircuit for sky130_fd_sc_hd__buf_6 abstract view
.subckt sky130_fd_sc_hd__buf_6 A VGND VNB VPB VPWR X
.ends

* Black-box entry subcircuit for sky130_fd_sc_hd__or4b_4 abstract view
.subckt sky130_fd_sc_hd__or4b_4 A B C D_N VGND VNB VPB VPWR X
.ends

* Black-box entry subcircuit for sky130_fd_sc_hd__o31a_4 abstract view
.subckt sky130_fd_sc_hd__o31a_4 A1 A2 A3 B1 VGND VNB VPB VPWR X
.ends

* Black-box entry subcircuit for sky130_fd_sc_hd__or3_2 abstract view
.subckt sky130_fd_sc_hd__or3_2 A B C VGND VNB VPB VPWR X
.ends

* Black-box entry subcircuit for sky130_fd_sc_hd__dfxtp_2 abstract view
.subckt sky130_fd_sc_hd__dfxtp_2 CLK D VGND VNB VPB VPWR Q
.ends

* Black-box entry subcircuit for sky130_fd_sc_hd__dlymetal6s4s_1 abstract view
.subckt sky130_fd_sc_hd__dlymetal6s4s_1 A VGND VNB VPB VPWR X
.ends

* Black-box entry subcircuit for sky130_fd_sc_hd__o31ai_2 abstract view
.subckt sky130_fd_sc_hd__o31ai_2 A1 A2 A3 B1 VGND VNB VPB VPWR Y
.ends

* Black-box entry subcircuit for sky130_fd_sc_hd__o22ai_2 abstract view
.subckt sky130_fd_sc_hd__o22ai_2 A1 A2 B1 B2 VGND VNB VPB VPWR Y
.ends

* Black-box entry subcircuit for sky130_fd_sc_hd__o2111a_2 abstract view
.subckt sky130_fd_sc_hd__o2111a_2 A1 A2 B1 C1 D1 VGND VNB VPB VPWR X
.ends

* Black-box entry subcircuit for sky130_fd_sc_hd__a2111oi_2 abstract view
.subckt sky130_fd_sc_hd__a2111oi_2 A1 A2 B1 C1 D1 VGND VNB VPB VPWR Y
.ends

* Black-box entry subcircuit for sky130_fd_sc_hd__o21ai_4 abstract view
.subckt sky130_fd_sc_hd__o21ai_4 A1 A2 B1 VGND VNB VPB VPWR Y
.ends

* Black-box entry subcircuit for sky130_fd_sc_hd__nor2_4 abstract view
.subckt sky130_fd_sc_hd__nor2_4 A B VGND VNB VPB VPWR Y
.ends

* Black-box entry subcircuit for sky130_fd_sc_hd__nor3b_2 abstract view
.subckt sky130_fd_sc_hd__nor3b_2 A B C_N VGND VNB VPB VPWR Y
.ends

* Black-box entry subcircuit for sky130_fd_sc_hd__dfstp_2 abstract view
.subckt sky130_fd_sc_hd__dfstp_2 CLK D SET_B VGND VNB VPB VPWR Q
.ends

* Black-box entry subcircuit for sky130_fd_sc_hd__conb_1 abstract view
.subckt sky130_fd_sc_hd__conb_1 VGND VNB VPB VPWR HI LO
.ends

* Black-box entry subcircuit for sky130_fd_sc_hd__o2bb2a_2 abstract view
.subckt sky130_fd_sc_hd__o2bb2a_2 A1_N A2_N B1 B2 VGND VNB VPB VPWR X
.ends

* Black-box entry subcircuit for sky130_fd_sc_hd__o211ai_2 abstract view
.subckt sky130_fd_sc_hd__o211ai_2 A1 A2 B1 C1 VGND VNB VPB VPWR Y
.ends

* Black-box entry subcircuit for sky130_fd_sc_hd__a31o_4 abstract view
.subckt sky130_fd_sc_hd__a31o_4 A1 A2 A3 B1 VGND VNB VPB VPWR X
.ends

* Black-box entry subcircuit for sky130_fd_sc_hd__dlymetal6s2s_1 abstract view
.subckt sky130_fd_sc_hd__dlymetal6s2s_1 A VGND VNB VPB VPWR X
.ends

* Black-box entry subcircuit for sky130_fd_sc_hd__dlygate4sd3_1 abstract view
.subckt sky130_fd_sc_hd__dlygate4sd3_1 A VGND VNB VPB VPWR X
.ends

* Black-box entry subcircuit for sky130_fd_sc_hd__a31oi_2 abstract view
.subckt sky130_fd_sc_hd__a31oi_2 A1 A2 A3 B1 VGND VNB VPB VPWR Y
.ends

* Black-box entry subcircuit for sky130_fd_sc_hd__a41o_4 abstract view
.subckt sky130_fd_sc_hd__a41o_4 A1 A2 A3 A4 B1 VGND VNB VPB VPWR X
.ends

* Black-box entry subcircuit for sky130_fd_sc_hd__nor3_2 abstract view
.subckt sky130_fd_sc_hd__nor3_2 A B C VGND VNB VPB VPWR Y
.ends

* Black-box entry subcircuit for sky130_fd_sc_hd__a41o_2 abstract view
.subckt sky130_fd_sc_hd__a41o_2 A1 A2 A3 A4 B1 VGND VNB VPB VPWR X
.ends

* Black-box entry subcircuit for sky130_fd_sc_hd__dlygate4sd1_1 abstract view
.subckt sky130_fd_sc_hd__dlygate4sd1_1 A VGND VNB VPB VPWR X
.ends

* Black-box entry subcircuit for sky130_fd_sc_hd__o21bai_2 abstract view
.subckt sky130_fd_sc_hd__o21bai_2 A1 A2 B1_N VGND VNB VPB VPWR Y
.ends

* Black-box entry subcircuit for sky130_fd_sc_hd__a31oi_4 abstract view
.subckt sky130_fd_sc_hd__a31oi_4 A1 A2 A3 B1 VGND VNB VPB VPWR Y
.ends

* Black-box entry subcircuit for sky130_fd_sc_hd__o22ai_4 abstract view
.subckt sky130_fd_sc_hd__o22ai_4 A1 A2 B1 B2 VGND VNB VPB VPWR Y
.ends

* Black-box entry subcircuit for sky130_fd_sc_hd__nand2_8 abstract view
.subckt sky130_fd_sc_hd__nand2_8 A B VGND VNB VPB VPWR Y
.ends

* Black-box entry subcircuit for sky130_fd_sc_hd__nand4_2 abstract view
.subckt sky130_fd_sc_hd__nand4_2 A B C D VGND VNB VPB VPWR Y
.ends

* Black-box entry subcircuit for sky130_fd_sc_hd__mux2_4 abstract view
.subckt sky130_fd_sc_hd__mux2_4 A0 A1 S VGND VNB VPB VPWR X
.ends

* Black-box entry subcircuit for sky130_fd_sc_hd__o21bai_4 abstract view
.subckt sky130_fd_sc_hd__o21bai_4 A1 A2 B1_N VGND VNB VPB VPWR Y
.ends

* Black-box entry subcircuit for sky130_fd_sc_hd__o2bb2a_4 abstract view
.subckt sky130_fd_sc_hd__o2bb2a_4 A1_N A2_N B1 B2 VGND VNB VPB VPWR X
.ends

* Black-box entry subcircuit for sky130_fd_sc_hd__nor3b_4 abstract view
.subckt sky130_fd_sc_hd__nor3b_4 A B C_N VGND VNB VPB VPWR Y
.ends

* Black-box entry subcircuit for sky130_fd_sc_hd__nor4_2 abstract view
.subckt sky130_fd_sc_hd__nor4_2 A B C D VGND VNB VPB VPWR Y
.ends

.subckt team_04 clk en gpio_in[0] gpio_in[10] gpio_in[11] gpio_in[12] gpio_in[13]
+ gpio_in[14] gpio_in[15] gpio_in[16] gpio_in[17] gpio_in[18] gpio_in[19] gpio_in[1]
+ gpio_in[20] gpio_in[21] gpio_in[22] gpio_in[23] gpio_in[24] gpio_in[25] gpio_in[26]
+ gpio_in[27] gpio_in[28] gpio_in[29] gpio_in[2] gpio_in[30] gpio_in[31] gpio_in[32]
+ gpio_in[33] gpio_in[3] gpio_in[4] gpio_in[5] gpio_in[6] gpio_in[7] gpio_in[8] gpio_in[9]
+ gpio_oeb[0] gpio_oeb[10] gpio_oeb[11] gpio_oeb[12] gpio_oeb[13] gpio_oeb[14] gpio_oeb[15]
+ gpio_oeb[16] gpio_oeb[17] gpio_oeb[18] gpio_oeb[19] gpio_oeb[1] gpio_oeb[20] gpio_oeb[21]
+ gpio_oeb[22] gpio_oeb[23] gpio_oeb[24] gpio_oeb[25] gpio_oeb[26] gpio_oeb[27] gpio_oeb[28]
+ gpio_oeb[29] gpio_oeb[2] gpio_oeb[30] gpio_oeb[31] gpio_oeb[32] gpio_oeb[33] gpio_oeb[3]
+ gpio_oeb[4] gpio_oeb[5] gpio_oeb[6] gpio_oeb[7] gpio_oeb[8] gpio_oeb[9] gpio_out[0]
+ gpio_out[10] gpio_out[11] gpio_out[12] gpio_out[13] gpio_out[14] gpio_out[15] gpio_out[16]
+ gpio_out[17] gpio_out[18] gpio_out[19] gpio_out[1] gpio_out[20] gpio_out[21] gpio_out[22]
+ gpio_out[23] gpio_out[24] gpio_out[25] gpio_out[26] gpio_out[27] gpio_out[28] gpio_out[29]
+ gpio_out[2] gpio_out[30] gpio_out[31] gpio_out[32] gpio_out[33] gpio_out[3] gpio_out[4]
+ gpio_out[5] gpio_out[6] gpio_out[7] gpio_out[8] gpio_out[9] nrst vccd1 vssd1
XFILLER_39_277 vssd1 vssd1 vccd1 vccd1 sky130_fd_sc_hd__fill_2
XFILLER_22_111 vssd1 vssd1 vccd1 vccd1 sky130_fd_sc_hd__fill_2
XTAP_TAPCELL_ROW_9_148 vssd1 vccd1 sky130_fd_sc_hd__tapvpwrvgnd_1
XFILLER_26_74 vssd1 vssd1 vccd1 vccd1 sky130_fd_sc_hd__fill_8
XFILLER_45_225 vssd1 vssd1 vccd1 vccd1 sky130_fd_sc_hd__fill_2
XFILLER_13_177 vssd1 vssd1 vccd1 vccd1 sky130_fd_sc_hd__fill_2
XFILLER_9_137 vssd1 vssd1 vccd1 vccd1 sky130_fd_sc_hd__fill_2
X_1270_ _1337_/A _1270_/B vssd1 vssd1 vccd1 vccd1 _1270_/X sky130_fd_sc_hd__xor2_2
XFILLER_44_291 vssd1 vssd1 vccd1 vccd1 sky130_fd_sc_hd__fill_2
XTAP_TAPCELL_ROW_14_172 vssd1 vccd1 sky130_fd_sc_hd__tapvpwrvgnd_1
X_1606_ clkload8/A _1606_/D load_slew58/X vssd1 vssd1 vccd1 vccd1 _1606_/Q sky130_fd_sc_hd__dfrtp_2
X_0985_ _1001_/A1 _1002_/C _0977_/Y vssd1 vssd1 vccd1 vccd1 _0991_/A sky130_fd_sc_hd__a21oi_4
X_1537_ _1634_/Q _1538_/B vssd1 vssd1 vccd1 vccd1 _1539_/B sky130_fd_sc_hd__or2_2
X_1468_ _1613_/Q _1482_/D vssd1 vssd1 vccd1 vccd1 _1468_/Y sky130_fd_sc_hd__nor2_2
X_1399_ _1408_/A _1408_/C vssd1 vssd1 vccd1 vccd1 _1409_/B sky130_fd_sc_hd__and2_2
XTAP_TAPCELL_ROW_6_129 vssd1 vccd1 sky130_fd_sc_hd__tapvpwrvgnd_1
XFILLER_42_228 vssd1 vssd1 vccd1 vccd1 sky130_fd_sc_hd__fill_1
XTAP_TAPCELL_ROW_37_286 vssd1 vccd1 sky130_fd_sc_hd__tapvpwrvgnd_1
XFILLER_12_43 vssd1 vssd1 vccd1 vccd1 sky130_fd_sc_hd__fill_1
XTAP_TAPCELL_ROW_28_242 vssd1 vccd1 sky130_fd_sc_hd__tapvpwrvgnd_1
XFILLER_5_173 vssd1 vssd1 vccd1 vccd1 sky130_fd_sc_hd__fill_1
X_1322_ _1322_/A _1322_/B vssd1 vssd1 vccd1 vccd1 _1456_/B sky130_fd_sc_hd__xnor2_2
X_1253_ _1219_/X _1233_/B _1236_/Y vssd1 vssd1 vccd1 vccd1 _1285_/C sky130_fd_sc_hd__a21bo_2
X_1184_ _1185_/A _1185_/B vssd1 vssd1 vccd1 vccd1 _1186_/A sky130_fd_sc_hd__or2_2
Xclkbuf_4_12_0_clk clkbuf_0_clk/X vssd1 vssd1 vccd1 vccd1 clkload9/A sky130_fd_sc_hd__clkbuf_8
X_0968_ _0968_/A _0968_/B vssd1 vssd1 vccd1 vccd1 _1028_/A sky130_fd_sc_hd__xnor2_2
X_0899_ _1489_/A1 _0897_/B _1597_/Q vssd1 vssd1 vccd1 vccd1 _0900_/B sky130_fd_sc_hd__a21o_2
XTAP_TAPCELL_ROW_2_110 vssd1 vccd1 sky130_fd_sc_hd__tapvpwrvgnd_1
XFILLER_23_250 vssd1 vccd1 vssd1 vccd1 sky130_ef_sc_hd__decap_40_12
XFILLER_0_24 vssd1 vssd1 vccd1 vccd1 sky130_fd_sc_hd__fill_4
XFILLER_14_250 vssd1 vssd1 vccd1 vccd1 sky130_fd_sc_hd__fill_2
X_0822_ _1631_/Q _1630_/Q vssd1 vssd1 vccd1 vccd1 _0841_/C sky130_fd_sc_hd__or2_2
XFILLER_9_55 vssd1 vssd1 vccd1 vccd1 sky130_fd_sc_hd__fill_1
XFILLER_9_11 vssd1 vssd1 vccd1 vccd1 sky130_fd_sc_hd__fill_1
X_1305_ _1305_/A _1305_/B vssd1 vssd1 vccd1 vccd1 _1332_/S sky130_fd_sc_hd__xnor2_2
X_1236_ _1235_/A _1235_/B _1282_/B vssd1 vssd1 vccd1 vccd1 _1236_/Y sky130_fd_sc_hd__o21ai_2
X_1167_ _1603_/Q _1177_/A vssd1 vssd1 vccd1 vccd1 _1174_/A sky130_fd_sc_hd__nor2_2
X_1098_ _1098_/A _1098_/B vssd1 vssd1 vccd1 vccd1 _1154_/A sky130_fd_sc_hd__xnor2_2
XFILLER_18_42 vssd1 vssd1 vccd1 vccd1 sky130_fd_sc_hd__fill_2
XFILLER_34_52 vssd1 vssd1 vccd1 vccd1 sky130_fd_sc_hd__fill_1
XFILLER_34_85 vssd1 vssd1 vccd1 vccd1 sky130_fd_sc_hd__fill_2
XFILLER_7_213 vssd1 vssd1 vccd1 vccd1 sky130_fd_sc_hd__fill_2
XFILLER_7_246 vssd1 vssd1 vccd1 vccd1 sky130_fd_sc_hd__fill_4
XFILLER_38_106 vssd1 vssd1 vccd1 vccd1 sky130_fd_sc_hd__fill_2
X_1021_ _1021_/A _1021_/B vssd1 vssd1 vccd1 vccd1 _1021_/Y sky130_fd_sc_hd__xnor2_2
X_0805_ _0805_/A _0805_/B _0805_/C vssd1 vssd1 vccd1 vccd1 _0805_/X sky130_fd_sc_hd__and3_2
XFILLER_29_106 vssd1 vssd1 vccd1 vccd1 sky130_fd_sc_hd__fill_4
XFILLER_29_117 vssd1 vssd1 vccd1 vccd1 sky130_fd_sc_hd__fill_1
X_1219_ _1272_/A _1218_/A _1178_/A _1277_/A _1218_/X vssd1 vssd1 vccd1 vccd1 _1219_/X
+ sky130_fd_sc_hd__a311o_2
XFILLER_45_95 vssd1 vssd1 vccd1 vccd1 sky130_fd_sc_hd__fill_1
XFILLER_6_23 vssd1 vssd1 vccd1 vccd1 sky130_fd_sc_hd__fill_4
XFILLER_6_45 vssd1 vccd1 vssd1 vccd1 sky130_ef_sc_hd__decap_40_12
X_1570_ _1573_/C vssd1 vssd1 vccd1 vccd1 _1571_/C sky130_fd_sc_hd__inv_2
XFILLER_13_3 vssd1 vssd1 vccd1 vccd1 sky130_fd_sc_hd__fill_2
X_1004_ _1605_/Q _1005_/B _1004_/C vssd1 vssd1 vccd1 vccd1 _1007_/B sky130_fd_sc_hd__and3b_2
Xrebuffer129 _0992_/B vssd1 vssd1 vccd1 vccd1 _1131_/A sky130_fd_sc_hd__buf_2
XFILLER_25_175 vssd1 vccd1 vssd1 vccd1 sky130_ef_sc_hd__decap_40_12
XFILLER_15_87 vssd1 vssd1 vccd1 vccd1 sky130_fd_sc_hd__fill_1
XFILLER_40_112 vssd1 vssd1 vccd1 vccd1 sky130_fd_sc_hd__fill_8
Xoutput7 _0835_/X vssd1 vssd1 vccd1 vccd1 gpio_out[10] sky130_fd_sc_hd__clkdlybuf4s25_1
XFILLER_16_197 vssd1 vssd1 vccd1 vccd1 sky130_fd_sc_hd__fill_4
XFILLER_31_167 vssd1 vssd1 vccd1 vccd1 sky130_fd_sc_hd__fill_1
X_1622_ clkload0/A _1622_/D fanout59/X vssd1 vssd1 vccd1 vccd1 _1622_/Q sky130_fd_sc_hd__dfrtp_2
X_1553_ _1553_/A _1553_/B _1553_/C _1553_/D vssd1 vssd1 vccd1 vccd1 _1582_/B sky130_fd_sc_hd__or4_2
X_1484_ _1489_/A1 _1483_/Y _1480_/X _1515_/A1 _1615_/Q vssd1 vssd1 vccd1 vccd1 _1615_/D
+ sky130_fd_sc_hd__a32o_2
XFILLER_39_245 vssd1 vssd1 vccd1 vccd1 sky130_fd_sc_hd__fill_1
XFILLER_39_256 vssd1 vssd1 vccd1 vccd1 sky130_fd_sc_hd__fill_1
XANTENNA__1454__A2 _1378_/B vssd1 vssd1 vccd1 vccd1 sky130_fd_sc_hd__diode_2
XFILLER_22_189 vssd1 vssd1 vccd1 vccd1 sky130_fd_sc_hd__fill_1
XFILLER_13_123 vssd1 vssd1 vccd1 vccd1 sky130_fd_sc_hd__fill_1
XFILLER_13_134 vssd1 vssd1 vccd1 vccd1 sky130_fd_sc_hd__fill_4
XFILLER_13_167 vssd1 vssd1 vccd1 vccd1 sky130_fd_sc_hd__fill_1
XFILLER_42_85 vssd1 vssd1 vccd1 vccd1 sky130_fd_sc_hd__fill_4
XANTENNA__1381__B2 _1376_/A vssd1 vssd1 vccd1 vccd1 sky130_fd_sc_hd__diode_2
XFILLER_3_35 vssd1 vssd1 vccd1 vccd1 sky130_fd_sc_hd__fill_2
X_0984_ _0984_/A _0984_/B _1072_/A vssd1 vssd1 vccd1 vccd1 _0984_/Y sky130_fd_sc_hd__nand3_2
XTAP_TAPCELL_ROW_14_173 vssd1 vccd1 sky130_fd_sc_hd__tapvpwrvgnd_1
X_1605_ _1605_/CLK _1605_/D load_slew58/X vssd1 vssd1 vccd1 vccd1 _1605_/Q sky130_fd_sc_hd__dfrtp_2
X_1536_ _1538_/B _1536_/B vssd1 vssd1 vccd1 vccd1 _1633_/D sky130_fd_sc_hd__nor2_2
XFILLER_27_204 vssd1 vssd1 vccd1 vccd1 sky130_fd_sc_hd__fill_2
X_1467_ _1480_/B _1467_/B _1466_/Y vssd1 vssd1 vccd1 vccd1 _1467_/X sky130_fd_sc_hd__or3b_4
X_1398_ _1404_/A _1420_/A2 _1396_/Y _1480_/B vssd1 vssd1 vccd1 vccd1 _1398_/X sky130_fd_sc_hd__a31o_2
XTAP_TAPCELL_ROW_37_287 vssd1 vccd1 sky130_fd_sc_hd__tapvpwrvgnd_1
XFILLER_12_11 vssd1 vssd1 vccd1 vccd1 sky130_fd_sc_hd__fill_4
XFILLER_6_119 vssd1 vssd1 vccd1 vccd1 sky130_fd_sc_hd__fill_4
XANTENNA__1264__B _1265_/B vssd1 vssd1 vccd1 vccd1 sky130_fd_sc_hd__diode_2
XTAP_TAPCELL_ROW_28_243 vssd1 vccd1 sky130_fd_sc_hd__tapvpwrvgnd_1
XFILLER_41_251 vssd1 vccd1 vssd1 vccd1 sky130_ef_sc_hd__decap_40_12
XTAP_TAPCELL_ROW_11_154 vssd1 vccd1 sky130_fd_sc_hd__tapvpwrvgnd_1
XFILLER_38_5 vssd1 vssd1 vccd1 vccd1 sky130_fd_sc_hd__fill_2
X_1321_ _1327_/B _1336_/B vssd1 vssd1 vccd1 vccd1 _1322_/B sky130_fd_sc_hd__nand2_2
X_1252_ _1246_/Y _1242_/X _1290_/B vssd1 vssd1 vccd1 vccd1 _1252_/X sky130_fd_sc_hd__a21o_4
XFILLER_17_281 vssd1 vssd1 vccd1 vccd1 sky130_fd_sc_hd__fill_1
X_1183_ _1183_/A _1183_/B vssd1 vssd1 vccd1 vccd1 _1185_/B sky130_fd_sc_hd__nand2_2
X_0967_ _0996_/A _0996_/B _1002_/B _1002_/C vssd1 vssd1 vccd1 vccd1 _0968_/B sky130_fd_sc_hd__a22oi_2
X_1519_ _1519_/A _1539_/A vssd1 vssd1 vccd1 vccd1 _1521_/S sky130_fd_sc_hd__nand2_2
X_0898_ _1378_/A _0901_/C vssd1 vssd1 vccd1 vccd1 _0900_/A sky130_fd_sc_hd__or2_2
XPHY_EDGE_ROW_12_Right_12 vssd1 vssd1 vccd1 vccd1 sky130_fd_sc_hd__decap_3
XTAP_TAPCELL_ROW_2_111 vssd1 vccd1 sky130_fd_sc_hd__tapvpwrvgnd_1
XPHY_EDGE_ROW_21_Right_21 vssd1 vssd1 vccd1 vccd1 sky130_fd_sc_hd__decap_3
XFILLER_23_295 vssd1 vssd1 vccd1 vccd1 sky130_fd_sc_hd__fill_4
XTAP_TAPCELL_ROW_25_224 vssd1 vccd1 sky130_fd_sc_hd__tapvpwrvgnd_1
XPHY_EDGE_ROW_30_Right_30 vssd1 vssd1 vccd1 vccd1 sky130_fd_sc_hd__decap_3
XFILLER_14_273 vssd1 vssd1 vccd1 vccd1 sky130_fd_sc_hd__fill_1
X_0821_ _1631_/Q _1630_/Q vssd1 vssd1 vccd1 vccd1 _0821_/Y sky130_fd_sc_hd__nor2_2
X_1304_ _1299_/Y _1281_/X _1303_/X _1302_/X _1293_/Y vssd1 vssd1 vccd1 vccd1 _1304_/X
+ sky130_fd_sc_hd__a311o_2
X_1235_ _1235_/A _1235_/B vssd1 vssd1 vccd1 vccd1 _1260_/A sky130_fd_sc_hd__nor2_2
X_1166_ _1166_/A1 _1158_/X _1182_/A vssd1 vssd1 vccd1 vccd1 _1243_/A sky130_fd_sc_hd__a21o_2
X_1097_ _1036_/Y _1043_/Y _1086_/B vssd1 vssd1 vccd1 vccd1 _1098_/B sky130_fd_sc_hd__o21a_2
XFILLER_20_243 vssd1 vssd1 vccd1 vccd1 sky130_fd_sc_hd__fill_2
XFILLER_20_298 vssd1 vssd1 vccd1 vccd1 sky130_fd_sc_hd__fill_1
XANTENNA__1261__C _1265_/B vssd1 vssd1 vccd1 vccd1 sky130_fd_sc_hd__diode_2
XFILLER_11_298 vssd1 vssd1 vccd1 vccd1 sky130_fd_sc_hd__fill_1
Xclkbuf_4_11_0_clk clkbuf_0_clk/X vssd1 vssd1 vccd1 vccd1 clkload8/A sky130_fd_sc_hd__clkbuf_8
X_1020_ _1020_/A _1020_/B vssd1 vssd1 vccd1 vccd1 _1020_/X sky130_fd_sc_hd__and2_2
XFILLER_46_195 vssd1 vssd1 vccd1 vccd1 sky130_fd_sc_hd__fill_1
XPHY_EDGE_ROW_28_Left_75 vssd1 vssd1 vccd1 vccd1 sky130_fd_sc_hd__decap_3
X_0804_ _1592_/Q _1593_/Q vssd1 vssd1 vccd1 vccd1 _0805_/C sky130_fd_sc_hd__nand2b_2
XPHY_EDGE_ROW_12_Left_59 vssd1 vssd1 vccd1 vccd1 sky130_fd_sc_hd__decap_3
XFILLER_6_291 vssd1 vssd1 vccd1 vccd1 sky130_fd_sc_hd__fill_4
X_1218_ _1218_/A _1218_/B vssd1 vssd1 vccd1 vccd1 _1218_/X sky130_fd_sc_hd__and2_2
X_1149_ _1225_/A _1149_/B _1224_/A vssd1 vssd1 vccd1 vccd1 _1149_/X sky130_fd_sc_hd__or3b_2
XFILLER_20_11 vssd1 vssd1 vccd1 vccd1 sky130_fd_sc_hd__fill_4
XFILLER_20_66 vssd1 vssd1 vccd1 vccd1 sky130_fd_sc_hd__fill_2
XANTENNA_fanout53_X _1376_/A vssd1 vssd1 vccd1 vccd1 sky130_fd_sc_hd__diode_2
XFILLER_28_195 vssd1 vssd1 vccd1 vccd1 sky130_fd_sc_hd__fill_1
XFILLER_6_57 vssd1 vccd1 vssd1 vccd1 sky130_ef_sc_hd__decap_40_12
XFILLER_34_110 vssd1 vccd1 vssd1 vccd1 sky130_ef_sc_hd__decap_40_12
X_1003_ _1005_/B _1004_/C vssd1 vssd1 vccd1 vccd1 _1042_/A sky130_fd_sc_hd__and2_2
XFILLER_34_165 vssd1 vccd1 vssd1 vccd1 sky130_ef_sc_hd__decap_40_12
XPHY_EDGE_ROW_6_Right_6 vssd1 vssd1 vccd1 vccd1 sky130_fd_sc_hd__decap_3
XFILLER_15_33 vssd1 vssd1 vccd1 vccd1 sky130_fd_sc_hd__fill_2
XFILLER_15_55 vssd1 vssd1 vccd1 vccd1 sky130_fd_sc_hd__fill_1
XFILLER_25_187 vssd1 vccd1 vssd1 vccd1 sky130_ef_sc_hd__decap_40_12
XFILLER_40_102 vssd1 vssd1 vccd1 vccd1 sky130_fd_sc_hd__fill_1
XFILLER_31_54 vssd1 vssd1 vccd1 vccd1 sky130_fd_sc_hd__fill_2
XFILLER_0_253 vssd1 vssd1 vccd1 vccd1 sky130_fd_sc_hd__fill_2
Xoutput10 _0852_/X vssd1 vssd1 vccd1 vccd1 gpio_out[13] sky130_fd_sc_hd__clkdlybuf4s25_1
Xoutput8 _0840_/X vssd1 vssd1 vccd1 vccd1 gpio_out[11] sky130_fd_sc_hd__clkdlybuf4s25_1
XFILLER_31_113 vssd1 vssd1 vccd1 vccd1 sky130_fd_sc_hd__fill_1
X_1552_ _1640_/Q _1641_/Q _1644_/Q _1645_/Q vssd1 vssd1 vccd1 vccd1 _1553_/D sky130_fd_sc_hd__or4bb_2
X_1621_ clkload0/A _1621_/D fanout59/X vssd1 vssd1 vccd1 vccd1 _1621_/Q sky130_fd_sc_hd__dfrtp_2
X_1483_ _1481_/Y _1490_/D _0893_/C vssd1 vssd1 vccd1 vccd1 _1483_/Y sky130_fd_sc_hd__o21ai_2
XFILLER_39_279 vssd1 vssd1 vccd1 vccd1 sky130_fd_sc_hd__fill_1
XPHY_EDGE_ROW_15_Left_62 vssd1 vssd1 vccd1 vccd1 sky130_fd_sc_hd__decap_3
XFILLER_45_238 vssd1 vssd1 vccd1 vccd1 sky130_fd_sc_hd__fill_1
XFILLER_13_102 vssd1 vssd1 vccd1 vccd1 sky130_fd_sc_hd__fill_8
XFILLER_13_113 vssd1 vssd1 vccd1 vccd1 sky130_fd_sc_hd__fill_8
XFILLER_13_179 vssd1 vssd1 vccd1 vccd1 sky130_fd_sc_hd__fill_1
XFILLER_9_139 vssd1 vssd1 vccd1 vccd1 sky130_fd_sc_hd__fill_1
X_0983_ _0984_/B _1072_/A vssd1 vssd1 vccd1 vccd1 _0983_/Y sky130_fd_sc_hd__nand2_2
X_1604_ _1605_/CLK _1604_/D load_slew58/X vssd1 vssd1 vccd1 vccd1 _1604_/Q sky130_fd_sc_hd__dfrtp_2
X_1535_ hold260/X _1533_/A _1539_/A vssd1 vssd1 vccd1 vccd1 _1536_/B sky130_fd_sc_hd__o21ai_2
X_1466_ _1466_/A _1466_/B _1466_/C vssd1 vssd1 vccd1 vccd1 _1466_/Y sky130_fd_sc_hd__nand3_4
X_1397_ _1397_/A1 _1396_/Y _1404_/A vssd1 vssd1 vccd1 vccd1 _1397_/Y sky130_fd_sc_hd__a21oi_2
XTAP_TAPCELL_ROW_37_288 vssd1 vccd1 sky130_fd_sc_hd__tapvpwrvgnd_1
XFILLER_6_109 vssd1 vssd1 vccd1 vccd1 sky130_fd_sc_hd__fill_2
XTAP_TAPCELL_ROW_20_199 vssd1 vccd1 sky130_fd_sc_hd__tapvpwrvgnd_1
XPHY_EDGE_ROW_0_Left_47 vssd1 vssd1 vccd1 vccd1 sky130_fd_sc_hd__decap_3
XFILLER_41_263 vssd1 vssd1 vccd1 vccd1 sky130_fd_sc_hd__fill_4
XTAP_TAPCELL_ROW_11_155 vssd1 vccd1 sky130_fd_sc_hd__tapvpwrvgnd_1
X_1320_ _1293_/B _1325_/A _1319_/Y vssd1 vssd1 vccd1 vccd1 _1479_/A sky130_fd_sc_hd__o21ai_2
X_1251_ _1305_/A _1307_/A _1249_/Y vssd1 vssd1 vccd1 vccd1 _1290_/B sky130_fd_sc_hd__o21ai_2
X_1182_ _1182_/A _1182_/B _1170_/Y _1180_/Y vssd1 vssd1 vccd1 vccd1 _1182_/X sky130_fd_sc_hd__or4bb_4
XTAP_TAPCELL_ROW_34_269 vssd1 vccd1 sky130_fd_sc_hd__tapvpwrvgnd_1
X_0966_ _1002_/B _1002_/C vssd1 vssd1 vccd1 vccd1 _0972_/A sky130_fd_sc_hd__nand2_4
X_0897_ _1597_/Q _0897_/B vssd1 vssd1 vccd1 vccd1 _0901_/C sky130_fd_sc_hd__nand2_2
XPHY_EDGE_ROW_42_Left_89 vssd1 vssd1 vccd1 vccd1 sky130_fd_sc_hd__decap_3
X_1518_ _0827_/C _0841_/C _0826_/Y _0848_/Y _0797_/Y vssd1 vssd1 vccd1 vccd1 _1539_/A
+ sky130_fd_sc_hd__o41a_2
X_1449_ _1449_/A _1449_/B vssd1 vssd1 vccd1 vccd1 _1449_/Y sky130_fd_sc_hd__nor2_2
XTAP_TAPCELL_ROW_2_112 vssd1 vccd1 sky130_fd_sc_hd__tapvpwrvgnd_1
XFILLER_23_77 vssd1 vssd1 vccd1 vccd1 sky130_fd_sc_hd__fill_8
XTAP_TAPCELL_ROW_25_225 vssd1 vccd1 sky130_fd_sc_hd__tapvpwrvgnd_1
XFILLER_14_296 vssd1 vssd1 vccd1 vccd1 sky130_fd_sc_hd__fill_2
X_0820_ _1629_/Q _1520_/A _1631_/Q _1630_/Q vssd1 vssd1 vccd1 vccd1 _0820_/X sky130_fd_sc_hd__or4b_2
X_1303_ _1316_/A _1303_/B _1322_/A vssd1 vssd1 vccd1 vccd1 _1303_/X sky130_fd_sc_hd__and3_2
X_1234_ _1234_/A _1234_/B vssd1 vssd1 vccd1 vccd1 _1235_/B sky130_fd_sc_hd__nor2_2
X_1165_ _1164_/B _1164_/A _1240_/A vssd1 vssd1 vccd1 vccd1 _1182_/A sky130_fd_sc_hd__a21o_2
X_1096_ _1094_/A _1095_/Y _1089_/Y _1086_/X _1094_/X vssd1 vssd1 vccd1 vccd1 _1096_/X
+ sky130_fd_sc_hd__o41a_4
XANTENNA__1376__A _1376_/A vssd1 vssd1 vccd1 vccd1 sky130_fd_sc_hd__diode_2
X_0949_ _1016_/A _1021_/A vssd1 vssd1 vccd1 vccd1 _0949_/Y sky130_fd_sc_hd__nand2b_2
XTAP_TAPCELL_ROW_30_250 vssd1 vccd1 sky130_fd_sc_hd__tapvpwrvgnd_1
XFILLER_18_33 vssd1 vssd1 vccd1 vccd1 sky130_fd_sc_hd__fill_2
XFILLER_18_99 vssd1 vssd1 vccd1 vccd1 sky130_fd_sc_hd__fill_2
XPHY_EDGE_ROW_3_Left_50 vssd1 vssd1 vccd1 vccd1 sky130_fd_sc_hd__decap_3
XTAP_TAPCELL_ROW_44_320 vssd1 vccd1 sky130_fd_sc_hd__tapvpwrvgnd_1
X_0803_ _1589_/Q _1590_/Q vssd1 vssd1 vccd1 vccd1 _0805_/B sky130_fd_sc_hd__nand2b_2
XFILLER_37_185 vssd1 vssd1 vccd1 vccd1 sky130_fd_sc_hd__fill_1
X_1217_ _1212_/B _1178_/Y _1211_/X _1178_/A vssd1 vssd1 vccd1 vccd1 _1218_/B sky130_fd_sc_hd__a22oi_2
X_1148_ _1225_/A _1223_/B _1225_/B _1148_/D vssd1 vssd1 vccd1 vccd1 _1181_/C sky130_fd_sc_hd__and4b_2
X_1079_ _1108_/S _1056_/Y _1105_/B vssd1 vssd1 vccd1 vccd1 _1080_/B sky130_fd_sc_hd__a21oi_2
XPHY_EDGE_ROW_45_Left_92 vssd1 vssd1 vccd1 vccd1 sky130_fd_sc_hd__decap_3
XFILLER_29_32 vssd1 vssd1 vccd1 vccd1 sky130_fd_sc_hd__fill_1
XFILLER_29_54 vssd1 vssd1 vccd1 vccd1 sky130_fd_sc_hd__fill_2
XFILLER_29_76 vssd1 vssd1 vccd1 vccd1 sky130_fd_sc_hd__fill_4
XFILLER_6_69 vssd1 vccd1 vssd1 vccd1 sky130_ef_sc_hd__decap_40_12
XFILLER_34_122 vssd1 vssd1 vccd1 vccd1 sky130_fd_sc_hd__fill_2
X_1002_ _1416_/A _1002_/B _1002_/C vssd1 vssd1 vccd1 vccd1 _1004_/C sky130_fd_sc_hd__nand3_2
XFILLER_34_177 vssd1 vssd1 vccd1 vccd1 sky130_fd_sc_hd__fill_2
XFILLER_34_188 vssd1 vssd1 vccd1 vccd1 sky130_fd_sc_hd__fill_2
XFILLER_25_144 vssd1 vssd1 vccd1 vccd1 sky130_fd_sc_hd__fill_1
XFILLER_25_199 vssd1 vssd1 vccd1 vccd1 sky130_fd_sc_hd__fill_2
XFILLER_31_66 vssd1 vssd1 vccd1 vccd1 sky130_fd_sc_hd__fill_4
Xclkbuf_4_10_0_clk clkbuf_0_clk/X vssd1 vssd1 vccd1 vccd1 _1641_/CLK sky130_fd_sc_hd__clkbuf_8
XFILLER_0_210 vssd1 vssd1 vccd1 vccd1 sky130_fd_sc_hd__fill_2
Xoutput11 _0855_/X vssd1 vssd1 vccd1 vccd1 gpio_out[14] sky130_fd_sc_hd__clkdlybuf4s25_1
Xoutput9 _0844_/X vssd1 vssd1 vccd1 vccd1 gpio_out[12] sky130_fd_sc_hd__clkdlybuf4s25_1
XFILLER_31_125 vssd1 vccd1 vssd1 vccd1 sky130_ef_sc_hd__decap_40_12
XFILLER_31_169 vssd1 vssd1 vccd1 vccd1 sky130_fd_sc_hd__fill_4
X_1551_ _1642_/Q _1643_/Q _1647_/Q _1646_/Q vssd1 vssd1 vccd1 vccd1 _1553_/C sky130_fd_sc_hd__or4b_2
X_1620_ clkload5/A _1620_/D fanout63/X vssd1 vssd1 vccd1 vccd1 _1620_/Q sky130_fd_sc_hd__dfrtp_2
X_1482_ _1613_/Q _1615_/Q _1614_/Q _1482_/D vssd1 vssd1 vccd1 vccd1 _1490_/D sky130_fd_sc_hd__and4_2
XFILLER_39_214 vssd1 vssd1 vccd1 vccd1 sky130_fd_sc_hd__fill_1
XFILLER_39_225 vssd1 vssd1 vccd1 vccd1 sky130_fd_sc_hd__fill_4
XFILLER_39_236 vssd1 vssd1 vccd1 vccd1 sky130_fd_sc_hd__fill_2
XFILLER_39_269 vssd1 vssd1 vccd1 vccd1 sky130_fd_sc_hd__fill_1
XFILLER_30_191 vssd1 vssd1 vccd1 vccd1 sky130_fd_sc_hd__fill_4
XFILLER_13_169 vssd1 vssd1 vccd1 vccd1 sky130_fd_sc_hd__fill_8
XANTENNA__0877__C1 _1376_/A vssd1 vssd1 vccd1 vccd1 sky130_fd_sc_hd__diode_2
XTAP_TAPCELL_ROW_8_140 vssd1 vccd1 sky130_fd_sc_hd__tapvpwrvgnd_1
X_0982_ _1617_/Q _0982_/B vssd1 vssd1 vccd1 vccd1 _1072_/A sky130_fd_sc_hd__xnor2_2
X_1603_ _1605_/CLK _1603_/D load_slew58/X vssd1 vssd1 vccd1 vccd1 _1603_/Q sky130_fd_sc_hd__dfrtp_2
X_1534_ _1534_/A _1632_/Q _1534_/C vssd1 vssd1 vccd1 vccd1 _1538_/B sky130_fd_sc_hd__and3_2
X_1465_ _1466_/B _1466_/C _1466_/A vssd1 vssd1 vccd1 vccd1 _1467_/B sky130_fd_sc_hd__a21oi_2
X_1396_ _1404_/B vssd1 vssd1 vccd1 vccd1 _1396_/Y sky130_fd_sc_hd__inv_2
XFILLER_26_250 vssd1 vssd1 vccd1 vccd1 sky130_fd_sc_hd__fill_2
XFILLER_5_121 vssd1 vssd1 vccd1 vccd1 sky130_fd_sc_hd__fill_1
XTAP_TAPCELL_ROW_11_156 vssd1 vccd1 sky130_fd_sc_hd__tapvpwrvgnd_1
XFILLER_5_187 vssd1 vccd1 vssd1 vccd1 sky130_ef_sc_hd__decap_40_12
X_1250_ _1144_/Y _1248_/B _1247_/X vssd1 vssd1 vccd1 vccd1 _1307_/A sky130_fd_sc_hd__a21boi_2
X_1181_ _1157_/Y _1181_/B _1181_/C _1181_/D vssd1 vssd1 vccd1 vccd1 _1182_/B sky130_fd_sc_hd__nand4b_4
XFILLER_17_261 vssd1 vssd1 vccd1 vccd1 sky130_fd_sc_hd__fill_1
XFILLER_17_294 vssd1 vssd1 vccd1 vccd1 sky130_fd_sc_hd__fill_4
XFILLER_32_253 vssd1 vssd1 vccd1 vccd1 sky130_fd_sc_hd__fill_2
XFILLER_32_297 vssd1 vssd1 vccd1 vccd1 sky130_fd_sc_hd__fill_2
X_0965_ _1002_/B _1002_/C vssd1 vssd1 vccd1 vccd1 _1016_/B sky130_fd_sc_hd__and2_2
X_0896_ hold265/X _1378_/A _1489_/A1 _0895_/Y vssd1 vssd1 vccd1 vccd1 _1596_/D sky130_fd_sc_hd__a22o_2
X_1517_ _0910_/C _0805_/A _1513_/Y _1516_/X vssd1 vssd1 vccd1 vccd1 _1627_/D sky130_fd_sc_hd__o31a_2
X_1448_ _1456_/A _1448_/B _1448_/C vssd1 vssd1 vccd1 vccd1 _1449_/B sky130_fd_sc_hd__and3_2
XTAP_TAPCELL_ROW_2_113 vssd1 vccd1 sky130_fd_sc_hd__tapvpwrvgnd_1
X_1379_ _0875_/B _1502_/C vssd1 vssd1 vccd1 vccd1 _1380_/A sky130_fd_sc_hd__and2b_2
XTAP_TAPCELL_ROW_25_226 vssd1 vccd1 sky130_fd_sc_hd__tapvpwrvgnd_1
XFILLER_23_45 vssd1 vssd1 vccd1 vccd1 sky130_fd_sc_hd__fill_4
XFILLER_14_253 vssd1 vssd1 vccd1 vccd1 sky130_fd_sc_hd__fill_2
XFILLER_9_25 vssd1 vssd1 vccd1 vccd1 sky130_fd_sc_hd__fill_4
X_1302_ _1303_/B _1322_/A _1302_/C vssd1 vssd1 vccd1 vccd1 _1302_/X sky130_fd_sc_hd__and3_2
X_1233_ _1233_/A _1233_/B _1233_/C vssd1 vssd1 vccd1 vccd1 _1233_/X sky130_fd_sc_hd__and3_4
X_1164_ _1164_/A _1164_/B vssd1 vssd1 vccd1 vccd1 _1230_/A sky130_fd_sc_hd__nand2_2
X_1095_ _1603_/Q _1095_/B vssd1 vssd1 vccd1 vccd1 _1095_/Y sky130_fd_sc_hd__nand2_2
X_0948_ _0913_/Y _0943_/X _0947_/X _1499_/A vssd1 vssd1 vccd1 vccd1 _1016_/A sky130_fd_sc_hd__a22oi_2
XTAP_TAPCELL_ROW_30_251 vssd1 vccd1 sky130_fd_sc_hd__tapvpwrvgnd_1
X_0879_ _1605_/Q _1416_/A _0878_/X _1422_/A vssd1 vssd1 vccd1 vccd1 _0880_/D sky130_fd_sc_hd__o31a_2
XFILLER_7_227 vssd1 vssd1 vccd1 vccd1 sky130_fd_sc_hd__fill_4
XFILLER_46_197 vssd1 vccd1 vssd1 vccd1 sky130_ef_sc_hd__decap_40_12
Xload_slew55 fanout54/X vssd1 vssd1 vccd1 vccd1 load_slew55/X sky130_fd_sc_hd__clkbuf_2
XTAP_TAPCELL_ROW_44_321 vssd1 vccd1 sky130_fd_sc_hd__tapvpwrvgnd_1
X_0802_ _0810_/A vssd1 vssd1 vccd1 vccd1 _0802_/Y sky130_fd_sc_hd__inv_2
X_1216_ _1192_/A _1170_/Y _1216_/A3 _1215_/X vssd1 vssd1 vccd1 vccd1 _1277_/A sky130_fd_sc_hd__a31o_2
XFILLER_1_92 vssd1 vccd1 vssd1 vccd1 sky130_ef_sc_hd__decap_40_12
XFILLER_37_153 vssd1 vssd1 vccd1 vccd1 sky130_fd_sc_hd__fill_2
X_1147_ _1225_/B _1148_/D vssd1 vssd1 vccd1 vccd1 _1224_/A sky130_fd_sc_hd__and2_2
X_1078_ _1078_/A1 _1071_/A _1077_/Y _1056_/Y vssd1 vssd1 vccd1 vccd1 _1080_/A sky130_fd_sc_hd__a211o_4
XFILLER_20_24 vssd1 vssd1 vccd1 vccd1 sky130_fd_sc_hd__fill_4
XFILLER_45_21 vssd1 vssd1 vccd1 vccd1 sky130_fd_sc_hd__fill_1
XFILLER_45_43 vssd1 vccd1 vssd1 vccd1 sky130_ef_sc_hd__decap_40_12
XFILLER_6_37 vssd1 vssd1 vccd1 vccd1 sky130_fd_sc_hd__fill_2
XFILLER_19_142 vssd1 vccd1 vssd1 vccd1 sky130_ef_sc_hd__decap_40_12
X_1001_ _1001_/A1 _1002_/C _1416_/A vssd1 vssd1 vccd1 vccd1 _1005_/B sky130_fd_sc_hd__a21o_2
XFILLER_15_35 vssd1 vssd1 vccd1 vccd1 sky130_fd_sc_hd__fill_1
XFILLER_15_57 vssd1 vssd1 vccd1 vccd1 sky130_fd_sc_hd__fill_2
XFILLER_25_167 vssd1 vssd1 vccd1 vccd1 sky130_fd_sc_hd__fill_1
XFILLER_31_45 vssd1 vssd1 vccd1 vccd1 sky130_fd_sc_hd__fill_1
Xoutput12 _1716_/X vssd1 vssd1 vccd1 vccd1 gpio_out[4] sky130_fd_sc_hd__clkdlybuf4s25_1
XFILLER_31_137 vssd1 vccd1 vssd1 vccd1 sky130_ef_sc_hd__decap_40_12
X_1550_ _1648_/Q _1650_/Q _1651_/Q _1649_/Q vssd1 vssd1 vccd1 vccd1 _1553_/B sky130_fd_sc_hd__or4b_2
X_1481_ _1615_/Q _1485_/C vssd1 vssd1 vccd1 vccd1 _1481_/Y sky130_fd_sc_hd__nor2_2
XFILLER_11_3 vssd1 vssd1 vccd1 vccd1 sky130_fd_sc_hd__fill_1
XTAP_TAPCELL_ROW_17_184 vssd1 vccd1 sky130_fd_sc_hd__tapvpwrvgnd_1
XFILLER_38_270 vssd1 vssd1 vccd1 vccd1 sky130_fd_sc_hd__fill_2
XFILLER_42_77 vssd1 vssd1 vccd1 vccd1 sky130_fd_sc_hd__fill_4
XFILLER_3_27 vssd1 vssd1 vccd1 vccd1 sky130_fd_sc_hd__fill_8
XTAP_TAPCELL_ROW_8_141 vssd1 vccd1 sky130_fd_sc_hd__tapvpwrvgnd_1
XFILLER_44_262 vssd1 vssd1 vccd1 vccd1 sky130_fd_sc_hd__fill_1
X_0981_ _1011_/A _1011_/B _0952_/Y vssd1 vssd1 vccd1 vccd1 _0982_/B sky130_fd_sc_hd__a21oi_2
X_1602_ _1605_/CLK _1602_/D load_slew58/X vssd1 vssd1 vccd1 vccd1 _1602_/Q sky130_fd_sc_hd__dfrtp_2
XFILLER_8_174 vssd1 vssd1 vccd1 vccd1 sky130_fd_sc_hd__fill_2
XFILLER_8_141 vssd1 vssd1 vccd1 vccd1 sky130_fd_sc_hd__fill_4
X_1533_ _1533_/A _1533_/B vssd1 vssd1 vccd1 vccd1 _1632_/D sky130_fd_sc_hd__nor2_2
X_1464_ _1464_/A _1464_/B vssd1 vssd1 vccd1 vccd1 _1466_/C sky130_fd_sc_hd__or2_4
X_1395_ _1395_/A _1395_/B _1395_/C vssd1 vssd1 vccd1 vccd1 _1404_/B sky130_fd_sc_hd__and3_2
XANTENNA_fanout21_X _1265_/B vssd1 vssd1 vccd1 vccd1 sky130_fd_sc_hd__diode_2
XFILLER_5_111 vssd1 vssd1 vccd1 vccd1 sky130_fd_sc_hd__fill_1
XTAP_TAPCELL_ROW_11_157 vssd1 vccd1 sky130_fd_sc_hd__tapvpwrvgnd_1
XFILLER_5_199 vssd1 vccd1 vssd1 vccd1 sky130_ef_sc_hd__decap_40_12
X_1180_ _1173_/A _1212_/A _1176_/X _1205_/B vssd1 vssd1 vccd1 vccd1 _1180_/Y sky130_fd_sc_hd__o31ai_4
XFILLER_32_265 vssd1 vccd1 vssd1 vccd1 sky130_ef_sc_hd__decap_40_12
X_0964_ _0960_/D _0963_/Y _0962_/Y vssd1 vssd1 vccd1 vccd1 _0964_/X sky130_fd_sc_hd__o21a_2
X_1516_ _1626_/Q _1514_/Y _1627_/Q vssd1 vssd1 vccd1 vccd1 _1516_/X sky130_fd_sc_hd__a21o_2
X_0895_ _0897_/B _0895_/B vssd1 vssd1 vccd1 vccd1 _0895_/Y sky130_fd_sc_hd__nor2_2
X_1447_ _1448_/B _1448_/C _1456_/A vssd1 vssd1 vccd1 vccd1 _1449_/A sky130_fd_sc_hd__a21oi_2
X_1378_ _1378_/A _1378_/B vssd1 vssd1 vccd1 vccd1 _1502_/C sky130_fd_sc_hd__nor2_2
XTAP_TAPCELL_ROW_25_227 vssd1 vccd1 sky130_fd_sc_hd__tapvpwrvgnd_1
XFILLER_14_221 vssd1 vccd1 vssd1 vccd1 sky130_ef_sc_hd__decap_40_12
XFILLER_14_298 vssd1 vssd1 vccd1 vccd1 sky130_fd_sc_hd__fill_1
XFILLER_13_90 vssd1 vccd1 vssd1 vccd1 sky130_ef_sc_hd__decap_40_12
X_1301_ _1327_/A _1327_/B vssd1 vssd1 vccd1 vccd1 _1318_/B sky130_fd_sc_hd__nand2_2
X_1232_ _1224_/X _1232_/B _1239_/C _1240_/A vssd1 vssd1 vccd1 vccd1 _1233_/C sky130_fd_sc_hd__and4b_2
X_1163_ _1163_/A _1163_/B vssd1 vssd1 vccd1 vccd1 _1164_/B sky130_fd_sc_hd__or2_4
X_1094_ _1094_/A _1094_/B vssd1 vssd1 vccd1 vccd1 _1094_/X sky130_fd_sc_hd__xor2_4
X_0947_ _0890_/A _0909_/Y _0947_/B1 _0951_/B _0950_/A vssd1 vssd1 vccd1 vccd1 _0947_/X
+ sky130_fd_sc_hd__a221o_2
XTAP_TAPCELL_ROW_30_252 vssd1 vccd1 sky130_fd_sc_hd__tapvpwrvgnd_1
X_0878_ _1603_/Q _0877_/X _1408_/A vssd1 vssd1 vccd1 vccd1 _0878_/X sky130_fd_sc_hd__o21a_2
XFILLER_18_24 vssd1 vssd1 vccd1 vccd1 sky130_fd_sc_hd__fill_4
XFILLER_11_257 vssd1 vccd1 vssd1 vccd1 sky130_ef_sc_hd__decap_40_12
XFILLER_11_279 vssd1 vssd1 vccd1 vccd1 sky130_fd_sc_hd__fill_1
Xclkload0 clkload0/A vssd1 vssd1 vccd1 vccd1 clkload0/X sky130_fd_sc_hd__clkbuf_4
XFILLER_46_165 vssd1 vssd1 vccd1 vccd1 sky130_fd_sc_hd__fill_2
XTAP_TAPCELL_ROW_44_322 vssd1 vccd1 sky130_fd_sc_hd__tapvpwrvgnd_1
X_0801_ _1583_/Q _1584_/Q vssd1 vssd1 vccd1 vccd1 _0810_/A sky130_fd_sc_hd__and2b_2
XFILLER_37_110 vssd1 vssd1 vccd1 vccd1 sky130_fd_sc_hd__fill_2
XFILLER_37_132 vssd1 vssd1 vccd1 vccd1 sky130_fd_sc_hd__fill_4
X_1215_ _1170_/Y _1215_/A2 _1234_/B vssd1 vssd1 vccd1 vccd1 _1215_/X sky130_fd_sc_hd__o21ba_2
X_1146_ _1145_/A _1163_/B _1145_/B vssd1 vssd1 vccd1 vccd1 _1148_/D sky130_fd_sc_hd__o21ai_2
X_1077_ _1108_/S _1077_/B vssd1 vssd1 vccd1 vccd1 _1077_/Y sky130_fd_sc_hd__nand2_2
XFILLER_45_55 vssd1 vssd1 vccd1 vccd1 sky130_fd_sc_hd__fill_1
XFILLER_6_27 vssd1 vssd1 vccd1 vccd1 sky130_fd_sc_hd__fill_1
XFILLER_19_154 vssd1 vssd1 vccd1 vccd1 sky130_fd_sc_hd__fill_4
X_1000_ _1009_/D _1131_/A _1068_/A _0992_/X _0999_/X vssd1 vssd1 vccd1 vccd1 _1010_/A
+ sky130_fd_sc_hd__o32ai_2
XFILLER_34_124 vssd1 vssd1 vccd1 vccd1 sky130_fd_sc_hd__fill_1
XANTENNA_clkbuf_0_clk_A clk vssd1 vssd1 vccd1 vccd1 sky130_fd_sc_hd__diode_2
XANTENNA_clkbuf_4_9_0_clk_A clkbuf_0_clk/X vssd1 vssd1 vccd1 vccd1 sky130_fd_sc_hd__diode_2
XFILLER_25_113 vssd1 vssd1 vccd1 vccd1 sky130_fd_sc_hd__fill_4
X_1129_ _1129_/A _1129_/B vssd1 vssd1 vccd1 vccd1 _1187_/A sky130_fd_sc_hd__xor2_2
XFILLER_40_127 vssd1 vccd1 vssd1 vccd1 sky130_ef_sc_hd__decap_40_12
XFILLER_0_201 vssd1 vssd1 vccd1 vccd1 sky130_fd_sc_hd__fill_2
XFILLER_31_57 vssd1 vssd1 vccd1 vccd1 sky130_fd_sc_hd__fill_2
Xoutput13 _1717_/X vssd1 vssd1 vccd1 vccd1 gpio_out[5] sky130_fd_sc_hd__clkdlybuf4s25_1
XFILLER_0_223 vssd1 vssd1 vccd1 vccd1 sky130_fd_sc_hd__fill_1
XFILLER_0_289 vssd1 vssd1 vccd1 vccd1 sky130_fd_sc_hd__fill_1
XFILLER_31_105 vssd1 vssd1 vccd1 vccd1 sky130_fd_sc_hd__fill_4
XFILLER_31_149 vssd1 vccd1 vssd1 vccd1 sky130_ef_sc_hd__decap_40_12
XPHY_EDGE_ROW_19_Right_19 vssd1 vssd1 vccd1 vccd1 sky130_fd_sc_hd__decap_3
X_1480_ _1480_/A _1480_/B _1479_/X vssd1 vssd1 vccd1 vccd1 _1480_/X sky130_fd_sc_hd__or3b_4
XPHY_EDGE_ROW_28_Right_28 vssd1 vssd1 vccd1 vccd1 sky130_fd_sc_hd__decap_3
XPHY_EDGE_ROW_37_Right_37 vssd1 vssd1 vccd1 vccd1 sky130_fd_sc_hd__decap_3
XTAP_TAPCELL_ROW_17_185 vssd1 vccd1 sky130_fd_sc_hd__tapvpwrvgnd_1
XPHY_EDGE_ROW_46_Right_46 vssd1 vssd1 vccd1 vccd1 sky130_fd_sc_hd__decap_3
XFILLER_13_138 vssd1 vssd1 vccd1 vccd1 sky130_fd_sc_hd__fill_2
XFILLER_45_219 vssd1 vssd1 vccd1 vccd1 sky130_fd_sc_hd__fill_4
XFILLER_42_89 vssd1 vssd1 vccd1 vccd1 sky130_fd_sc_hd__fill_2
XTAP_TAPCELL_ROW_8_142 vssd1 vccd1 sky130_fd_sc_hd__tapvpwrvgnd_1
XFILLER_12_171 vssd1 vssd1 vccd1 vccd1 sky130_fd_sc_hd__fill_1
X_0980_ _1001_/A1 _1002_/C _0978_/X _0918_/Y vssd1 vssd1 vccd1 vccd1 _1011_/B sky130_fd_sc_hd__a211oi_2
X_1601_ _1605_/CLK _1601_/D fanout56/X vssd1 vssd1 vccd1 vccd1 _1601_/Q sky130_fd_sc_hd__dfrtp_2
X_1532_ _1632_/Q _1534_/C _1539_/A vssd1 vssd1 vccd1 vccd1 _1533_/B sky130_fd_sc_hd__o21ai_2
X_1463_ _1462_/Y _1458_/Y _1612_/Q _1463_/B2 vssd1 vssd1 vccd1 vccd1 _1612_/D sky130_fd_sc_hd__a2bb2o_4
X_1394_ _1462_/B1 _1393_/Y _1390_/X _1463_/B2 _1603_/Q vssd1 vssd1 vccd1 vccd1 _1603_/D
+ sky130_fd_sc_hd__a32o_2
XFILLER_35_252 vssd1 vssd1 vccd1 vccd1 sky130_fd_sc_hd__fill_4
XPHY_EDGE_ROW_19_Left_66 vssd1 vssd1 vccd1 vccd1 sky130_fd_sc_hd__decap_3
XFILLER_5_9 vssd1 vssd1 vccd1 vccd1 sky130_fd_sc_hd__fill_4
XFILLER_41_200 vssd1 vccd1 vssd1 vccd1 sky130_ef_sc_hd__decap_40_12
XTAP_TAPCELL_ROW_36_280 vssd1 vccd1 sky130_fd_sc_hd__tapvpwrvgnd_1
XFILLER_5_101 vssd1 vssd1 vccd1 vccd1 sky130_fd_sc_hd__fill_8
XFILLER_5_145 vssd1 vssd1 vccd1 vccd1 sky130_fd_sc_hd__fill_2
XTAP_TAPCELL_ROW_11_158 vssd1 vccd1 sky130_fd_sc_hd__tapvpwrvgnd_1
XFILLER_32_255 vssd1 vssd1 vccd1 vccd1 sky130_fd_sc_hd__fill_1
XFILLER_32_277 vssd1 vssd1 vccd1 vccd1 sky130_fd_sc_hd__fill_2
X_0963_ _0970_/A _0960_/C _0949_/Y vssd1 vssd1 vccd1 vccd1 _0963_/Y sky130_fd_sc_hd__a21oi_2
X_0894_ _0893_/B _0893_/C _1596_/Q vssd1 vssd1 vccd1 vccd1 _0895_/B sky130_fd_sc_hd__a21oi_2
X_1515_ _1515_/A1 _1513_/Y _1514_/Y hold263/X vssd1 vssd1 vccd1 vccd1 _1626_/D sky130_fd_sc_hd__o22a_2
XFILLER_4_71 vssd1 vssd1 vccd1 vccd1 sky130_fd_sc_hd__fill_1
XFILLER_4_93 vssd1 vccd1 vssd1 vccd1 sky130_ef_sc_hd__decap_40_12
X_1446_ _1462_/B1 _1442_/X _1445_/Y _1463_/B2 _1610_/Q vssd1 vssd1 vccd1 vccd1 _1610_/D
+ sky130_fd_sc_hd__a32o_2
X_1377_ _1392_/C vssd1 vssd1 vccd1 vccd1 _1377_/Y sky130_fd_sc_hd__inv_2
XTAP_TAPCELL_ROW_25_228 vssd1 vccd1 sky130_fd_sc_hd__tapvpwrvgnd_1
XFILLER_0_29 vssd1 vccd1 vssd1 vccd1 sky130_ef_sc_hd__decap_40_12
XFILLER_14_233 vssd1 vssd1 vccd1 vccd1 sky130_fd_sc_hd__fill_4
X_1300_ _1315_/A _1316_/A _1302_/C vssd1 vssd1 vccd1 vccd1 _1327_/B sky130_fd_sc_hd__a21o_2
X_1231_ _1231_/A _1240_/B vssd1 vssd1 vccd1 vccd1 _1288_/A sky130_fd_sc_hd__or2_2
X_1162_ _1225_/A _1225_/B _1126_/Y vssd1 vssd1 vccd1 vccd1 _1164_/A sky130_fd_sc_hd__o21ai_2
XTAP_TAPCELL_ROW_0_94 vssd1 vccd1 sky130_fd_sc_hd__tapvpwrvgnd_1
X_1093_ _1177_/A _1093_/B _1093_/C vssd1 vssd1 vccd1 vccd1 _1093_/Y sky130_fd_sc_hd__nand3_2
XTAP_TAPCELL_ROW_22_209 vssd1 vccd1 sky130_fd_sc_hd__tapvpwrvgnd_1
X_0946_ _0890_/A _0909_/Y _0947_/B1 _0951_/B vssd1 vssd1 vccd1 vccd1 _0950_/B sky130_fd_sc_hd__a22o_2
X_0877_ _1599_/Q _1600_/Q _1602_/Q _1376_/A vssd1 vssd1 vccd1 vccd1 _0877_/X sky130_fd_sc_hd__o211a_2
XTAP_TAPCELL_ROW_30_253 vssd1 vccd1 sky130_fd_sc_hd__tapvpwrvgnd_1
X_1429_ _1429_/A _1436_/C vssd1 vssd1 vccd1 vccd1 _1429_/Y sky130_fd_sc_hd__nor2_2
XFILLER_11_225 vssd1 vssd1 vccd1 vccd1 sky130_fd_sc_hd__fill_2
XFILLER_11_269 vssd1 vssd1 vccd1 vccd1 sky130_fd_sc_hd__fill_2
XFILLER_34_24 vssd1 vssd1 vccd1 vccd1 sky130_fd_sc_hd__fill_4
Xclkload1 clkload1/A vssd1 vssd1 vccd1 vccd1 clkload1/X sky130_fd_sc_hd__clkbuf_4
XFILLER_46_111 vssd1 vssd1 vccd1 vccd1 sky130_fd_sc_hd__fill_1
XFILLER_46_177 vssd1 vccd1 vssd1 vccd1 sky130_ef_sc_hd__decap_40_12
XTAP_TAPCELL_ROW_44_323 vssd1 vccd1 sky130_fd_sc_hd__tapvpwrvgnd_1
XANTENNA__1402__B2 _1378_/B vssd1 vssd1 vccd1 vccd1 sky130_fd_sc_hd__diode_2
X_0800_ input6/X input1/X vssd1 vssd1 vccd1 vccd1 _0800_/X sky130_fd_sc_hd__and2_2
XFILLER_6_295 vssd1 vssd1 vccd1 vccd1 sky130_fd_sc_hd__fill_1
XFILLER_1_61 vssd1 vssd1 vccd1 vccd1 sky130_fd_sc_hd__fill_2
XFILLER_1_83 vssd1 vssd1 vccd1 vccd1 sky130_fd_sc_hd__fill_1
XFILLER_37_155 vssd1 vssd1 vccd1 vccd1 sky130_fd_sc_hd__fill_1
X_1214_ _1170_/Y _1215_/A2 _1216_/A3 _1192_/A vssd1 vssd1 vccd1 vccd1 _1234_/B sky130_fd_sc_hd__a22o_2
X_1145_ _1145_/A _1145_/B _1163_/B vssd1 vssd1 vccd1 vccd1 _1225_/B sky130_fd_sc_hd__or3_4
XANTENNA_clkbuf_4_5_0_clk_A clkbuf_0_clk/X vssd1 vssd1 vccd1 vccd1 sky130_fd_sc_hd__diode_2
X_1076_ _1106_/A _1077_/B _1056_/Y vssd1 vssd1 vccd1 vccd1 _1076_/Y sky130_fd_sc_hd__a21oi_2
XFILLER_20_15 vssd1 vssd1 vccd1 vccd1 sky130_fd_sc_hd__fill_1
X_0929_ _1610_/Q wire38/X vssd1 vssd1 vccd1 vccd1 _0942_/A sky130_fd_sc_hd__xor2_2
XFILLER_29_57 vssd1 vssd1 vccd1 vccd1 sky130_fd_sc_hd__fill_2
XFILLER_28_133 vssd1 vssd1 vccd1 vccd1 sky130_fd_sc_hd__fill_4
XFILLER_28_177 vssd1 vssd1 vccd1 vccd1 sky130_fd_sc_hd__fill_4
XFILLER_43_125 vssd1 vssd1 vccd1 vccd1 sky130_fd_sc_hd__fill_1
XTAP_TAPCELL_ROW_41_304 vssd1 vccd1 sky130_fd_sc_hd__tapvpwrvgnd_1
XFILLER_6_39 vssd1 vssd1 vccd1 vccd1 sky130_fd_sc_hd__fill_1
XPHY_EDGE_ROW_7_Left_54 vssd1 vssd1 vccd1 vccd1 sky130_fd_sc_hd__decap_3
XFILLER_10_70 vssd1 vssd1 vccd1 vccd1 sky130_fd_sc_hd__fill_1
XFILLER_10_92 vssd1 vssd1 vccd1 vccd1 sky130_fd_sc_hd__fill_8
XFILLER_3_254 vssd1 vssd1 vccd1 vccd1 sky130_fd_sc_hd__fill_4
XFILLER_19_90 vssd1 vssd1 vccd1 vccd1 sky130_fd_sc_hd__fill_2
XFILLER_25_136 vssd1 vssd1 vccd1 vccd1 sky130_fd_sc_hd__fill_8
X_1128_ _1128_/A _1128_/B vssd1 vssd1 vccd1 vccd1 _1163_/A sky130_fd_sc_hd__nand2_2
X_1059_ _1083_/A _1102_/A vssd1 vssd1 vccd1 vccd1 _1059_/Y sky130_fd_sc_hd__nand2_2
XFILLER_40_139 vssd1 vssd1 vccd1 vccd1 sky130_fd_sc_hd__fill_1
Xoutput14 _0825_/Y vssd1 vssd1 vccd1 vccd1 gpio_out[8] sky130_fd_sc_hd__clkdlybuf4s25_1
XFILLER_16_169 vssd1 vssd1 vccd1 vccd1 sky130_fd_sc_hd__fill_4
XFILLER_21_80 vssd1 vssd1 vccd1 vccd1 sky130_fd_sc_hd__fill_2
XTAP_TAPCELL_ROW_17_186 vssd1 vccd1 sky130_fd_sc_hd__tapvpwrvgnd_1
XFILLER_42_46 vssd1 vssd1 vccd1 vccd1 sky130_fd_sc_hd__fill_2
XTAP_TAPCELL_ROW_8_143 vssd1 vccd1 sky130_fd_sc_hd__tapvpwrvgnd_1
XANTENNA_clkbuf_4_13_0_clk_A clkbuf_0_clk/X vssd1 vssd1 vccd1 vccd1 sky130_fd_sc_hd__diode_2
XFILLER_12_194 vssd1 vssd1 vccd1 vccd1 sky130_fd_sc_hd__fill_2
XFILLER_8_154 vssd1 vccd1 vssd1 vccd1 sky130_ef_sc_hd__decap_40_12
X_1600_ clkload2/A _1600_/D fanout56/X vssd1 vssd1 vccd1 vccd1 _1600_/Q sky130_fd_sc_hd__dfrtp_2
X_1531_ _1632_/Q _1534_/C vssd1 vssd1 vccd1 vccd1 _1533_/A sky130_fd_sc_hd__and2_2
X_1462_ _1378_/B _1461_/Y _1462_/B1 vssd1 vssd1 vccd1 vccd1 _1462_/Y sky130_fd_sc_hd__o21ai_2
X_1393_ _1391_/Y _1408_/C _1480_/B vssd1 vssd1 vccd1 vccd1 _1393_/Y sky130_fd_sc_hd__o21ai_2
XFILLER_35_264 vssd1 vssd1 vccd1 vccd1 sky130_fd_sc_hd__fill_4
XFILLER_12_27 vssd1 vssd1 vccd1 vccd1 sky130_fd_sc_hd__fill_1
XFILLER_12_49 vssd1 vssd1 vccd1 vccd1 sky130_fd_sc_hd__fill_2
XTAP_TAPCELL_ROW_5_124 vssd1 vccd1 sky130_fd_sc_hd__tapvpwrvgnd_1
XFILLER_18_209 vssd1 vssd1 vccd1 vccd1 sky130_fd_sc_hd__fill_1
XFILLER_26_253 vssd1 vssd1 vccd1 vccd1 sky130_fd_sc_hd__fill_2
XFILLER_37_57 vssd1 vssd1 vccd1 vccd1 sky130_fd_sc_hd__fill_1
XFILLER_26_297 vssd1 vssd1 vccd1 vccd1 sky130_fd_sc_hd__fill_2
XFILLER_41_212 vssd1 vssd1 vccd1 vccd1 sky130_fd_sc_hd__fill_8
XTAP_TAPCELL_ROW_36_281 vssd1 vccd1 sky130_fd_sc_hd__tapvpwrvgnd_1
XFILLER_5_113 vssd1 vssd1 vccd1 vccd1 sky130_fd_sc_hd__fill_8
XPHY_EDGE_ROW_36_Left_83 vssd1 vssd1 vccd1 vccd1 sky130_fd_sc_hd__decap_3
XANTENNA__1603__RESET_B load_slew58/X vssd1 vssd1 vccd1 vccd1 sky130_fd_sc_hd__diode_2
XPHY_EDGE_ROW_20_Left_67 vssd1 vssd1 vccd1 vccd1 sky130_fd_sc_hd__decap_3
XFILLER_32_289 vssd1 vssd1 vccd1 vccd1 sky130_fd_sc_hd__fill_8
X_0962_ _1627_/Q _0962_/B vssd1 vssd1 vccd1 vccd1 _0962_/Y sky130_fd_sc_hd__nand2_2
X_0893_ _1596_/Q _0893_/B _0893_/C vssd1 vssd1 vccd1 vccd1 _0897_/B sky130_fd_sc_hd__and3_2
X_1514_ _1514_/A _1514_/B vssd1 vssd1 vccd1 vccd1 _1514_/Y sky130_fd_sc_hd__nor2_2
X_1445_ _1443_/Y _1451_/B _0893_/C vssd1 vssd1 vccd1 vccd1 _1445_/Y sky130_fd_sc_hd__o21ai_2
X_1376_ _1376_/A _1376_/B vssd1 vssd1 vccd1 vccd1 _1392_/C sky130_fd_sc_hd__and2_2
XANTENNA__1361__S _1378_/B vssd1 vssd1 vccd1 vccd1 sky130_fd_sc_hd__diode_2
XFILLER_9_39 vssd1 vssd1 vccd1 vccd1 sky130_fd_sc_hd__fill_8
X_1230_ _1230_/A _1230_/B vssd1 vssd1 vccd1 vccd1 _1239_/C sky130_fd_sc_hd__xor2_2
X_1161_ _1187_/B _1161_/B vssd1 vssd1 vccd1 vccd1 _1240_/A sky130_fd_sc_hd__nand2_2
X_1092_ _1093_/B _1176_/A vssd1 vssd1 vccd1 vccd1 _1092_/Y sky130_fd_sc_hd__nand2_2
XTAP_TAPCELL_ROW_0_95 vssd1 vccd1 sky130_fd_sc_hd__tapvpwrvgnd_1
X_0945_ _1510_/A _0945_/B vssd1 vssd1 vccd1 vccd1 _1021_/A sky130_fd_sc_hd__xnor2_2
X_0876_ _1378_/A _1519_/A _1489_/A1 vssd1 vssd1 vccd1 vccd1 _1595_/D sky130_fd_sc_hd__a21oi_2
XANTENNA_clkbuf_4_1_0_clk_A clkbuf_0_clk/X vssd1 vssd1 vccd1 vccd1 sky130_fd_sc_hd__diode_2
X_1428_ _1429_/A _1436_/C vssd1 vssd1 vccd1 vccd1 _1444_/C sky130_fd_sc_hd__and2_2
XANTENNA__1487__A2 _0893_/C vssd1 vssd1 vccd1 vccd1 sky130_fd_sc_hd__diode_2
X_1359_ _1358_/X _1356_/X _1426_/B vssd1 vssd1 vccd1 vccd1 _1406_/B sky130_fd_sc_hd__o21ba_4
Xclkload2 clkload2/A vssd1 vssd1 vccd1 vccd1 clkload2/X sky130_fd_sc_hd__clkbuf_4
XANTENNA__1653__Q _1653_/Q vssd1 vssd1 vccd1 vccd1 sky130_fd_sc_hd__diode_2
XFILLER_46_145 vssd1 vccd1 vssd1 vccd1 sky130_ef_sc_hd__decap_40_12
XFILLER_46_167 vssd1 vssd1 vccd1 vccd1 sky130_fd_sc_hd__fill_1
XFILLER_46_189 vssd1 vssd1 vccd1 vccd1 sky130_fd_sc_hd__fill_4
Xload_slew58 fanout57/X vssd1 vssd1 vccd1 vccd1 load_slew58/X sky130_fd_sc_hd__buf_4
X_1213_ _1376_/A _1267_/A _1261_/B _1337_/A vssd1 vssd1 vccd1 vccd1 _1272_/A sky130_fd_sc_hd__o211a_4
X_1144_ _1192_/A vssd1 vssd1 vccd1 vccd1 _1144_/Y sky130_fd_sc_hd__inv_2
X_1075_ _1075_/A _1129_/A vssd1 vssd1 vccd1 vccd1 _1077_/B sky130_fd_sc_hd__nor2_2
XPHY_EDGE_ROW_23_Left_70 vssd1 vssd1 vccd1 vccd1 sky130_fd_sc_hd__decap_3
XFILLER_20_49 vssd1 vssd1 vccd1 vccd1 sky130_fd_sc_hd__fill_1
X_0928_ _0934_/C _0928_/A2 _0789_/Y _0903_/Y vssd1 vssd1 vccd1 vccd1 wire38/A sky130_fd_sc_hd__a211oi_2
X_0859_ _1605_/Q _0887_/B _1416_/A _0856_/X vssd1 vssd1 vccd1 vccd1 _0861_/C sky130_fd_sc_hd__or4b_2
XFILLER_43_104 vssd1 vssd1 vccd1 vccd1 sky130_fd_sc_hd__fill_4
XTAP_TAPCELL_ROW_41_305 vssd1 vccd1 sky130_fd_sc_hd__tapvpwrvgnd_1
XFILLER_6_29 vssd1 vssd1 vccd1 vccd1 sky130_fd_sc_hd__fill_8
XFILLER_3_266 vssd1 vssd1 vccd1 vccd1 sky130_fd_sc_hd__fill_1
X_1127_ _1127_/A _1225_/A _1145_/B vssd1 vssd1 vccd1 vccd1 _1128_/B sky130_fd_sc_hd__nor3_4
X_1058_ _1058_/A _1058_/B vssd1 vssd1 vccd1 vccd1 _1124_/A sky130_fd_sc_hd__xnor2_2
XFILLER_0_203 vssd1 vssd1 vccd1 vccd1 sky130_fd_sc_hd__fill_1
XFILLER_0_247 vssd1 vssd1 vccd1 vccd1 sky130_fd_sc_hd__fill_4
Xoutput15 _0832_/Y vssd1 vssd1 vccd1 vccd1 gpio_out[9] sky130_fd_sc_hd__clkdlybuf4s25_1
XPHY_EDGE_ROW_1_Right_1 vssd1 vssd1 vccd1 vccd1 sky130_fd_sc_hd__decap_3
XANTENNA__0813__B1 _1653_/Q vssd1 vssd1 vccd1 vccd1 sky130_fd_sc_hd__diode_2
XFILLER_39_229 vssd1 vssd1 vccd1 vccd1 sky130_fd_sc_hd__fill_2
XTAP_TAPCELL_ROW_17_187 vssd1 vccd1 sky130_fd_sc_hd__tapvpwrvgnd_1
XFILLER_30_173 vssd1 vssd1 vccd1 vccd1 sky130_fd_sc_hd__fill_2
XFILLER_30_195 vssd1 vssd1 vccd1 vccd1 sky130_fd_sc_hd__fill_1
XFILLER_26_59 vssd1 vssd1 vccd1 vccd1 sky130_fd_sc_hd__fill_2
XFILLER_21_173 vssd1 vssd1 vccd1 vccd1 sky130_fd_sc_hd__fill_2
XFILLER_29_295 vssd1 vssd1 vccd1 vccd1 sky130_fd_sc_hd__fill_4
XFILLER_44_210 vssd1 vssd1 vccd1 vccd1 sky130_fd_sc_hd__fill_4
XFILLER_32_91 vssd1 vssd1 vccd1 vccd1 sky130_fd_sc_hd__fill_1
XFILLER_8_166 vssd1 vssd1 vccd1 vccd1 sky130_fd_sc_hd__fill_8
X_1530_ _1534_/C _1539_/A _1530_/C vssd1 vssd1 vccd1 vccd1 _1631_/D sky130_fd_sc_hd__and3b_2
X_1461_ _1461_/A _1482_/D vssd1 vssd1 vccd1 vccd1 _1461_/Y sky130_fd_sc_hd__nor2_2
X_1392_ _1602_/Q _1603_/Q _1392_/C vssd1 vssd1 vccd1 vccd1 _1408_/C sky130_fd_sc_hd__and3_2
XFILLER_35_298 vssd1 vssd1 vccd1 vccd1 sky130_fd_sc_hd__fill_1
XANTENNA_input6_A nrst vssd1 vssd1 vccd1 vccd1 sky130_fd_sc_hd__diode_2
XTAP_TAPCELL_ROW_5_125 vssd1 vccd1 sky130_fd_sc_hd__tapvpwrvgnd_1
XFILLER_41_279 vssd1 vssd1 vccd1 vccd1 sky130_fd_sc_hd__fill_1
XTAP_TAPCELL_ROW_36_282 vssd1 vccd1 sky130_fd_sc_hd__tapvpwrvgnd_1
XFILLER_5_169 vssd1 vssd1 vccd1 vccd1 sky130_fd_sc_hd__fill_4
XFILLER_17_210 vssd1 vssd1 vccd1 vccd1 sky130_fd_sc_hd__fill_4
XFILLER_17_276 vssd1 vssd1 vccd1 vccd1 sky130_fd_sc_hd__fill_4
XFILLER_17_298 vssd1 vssd1 vccd1 vccd1 sky130_fd_sc_hd__fill_1
X_0961_ _0969_/B _0969_/C _0949_/Y _0960_/X vssd1 vssd1 vccd1 vccd1 _0961_/X sky130_fd_sc_hd__a211o_4
X_0892_ _0892_/A vssd1 vssd1 vccd1 vccd1 _1378_/B sky130_fd_sc_hd__inv_2
XFILLER_4_180 vssd1 vssd1 vccd1 vccd1 sky130_fd_sc_hd__fill_1
X_1513_ _1513_/A vssd1 vssd1 vccd1 vccd1 _1513_/Y sky130_fd_sc_hd__inv_2
X_1444_ _1609_/Q _1610_/Q _1444_/C vssd1 vssd1 vccd1 vccd1 _1451_/B sky130_fd_sc_hd__and3_2
X_1375_ _1376_/A _1376_/B vssd1 vssd1 vccd1 vccd1 _1375_/X sky130_fd_sc_hd__or2_2
XFILLER_23_213 vssd1 vssd1 vccd1 vccd1 sky130_fd_sc_hd__fill_4
XANTENNA__1423__B1 _0893_/C vssd1 vssd1 vccd1 vccd1 sky130_fd_sc_hd__diode_2
XANTENNA__1208__A _1376_/A vssd1 vssd1 vccd1 vccd1 sky130_fd_sc_hd__diode_2
XFILLER_14_202 vssd1 vssd1 vccd1 vccd1 sky130_fd_sc_hd__fill_1
XFILLER_9_29 vssd1 vssd1 vccd1 vccd1 sky130_fd_sc_hd__fill_2
XFILLER_22_290 vssd1 vssd1 vccd1 vccd1 sky130_fd_sc_hd__fill_8
Xfanout50 _1608_/Q vssd1 vssd1 vccd1 vccd1 _0904_/A1 sky130_fd_sc_hd__buf_8
Xfanout61 fanout63/X vssd1 vssd1 vccd1 vccd1 fanout61/X sky130_fd_sc_hd__clkdlybuf4s25_1
XTAP_TAPCELL_ROW_0_96 vssd1 vccd1 sky130_fd_sc_hd__tapvpwrvgnd_1
X_1160_ _1163_/A _1150_/A _1159_/B vssd1 vssd1 vccd1 vccd1 _1161_/B sky130_fd_sc_hd__a21o_2
X_1091_ _1091_/A _1095_/B vssd1 vssd1 vccd1 vccd1 _1093_/C sky130_fd_sc_hd__xnor2_4
X_0944_ _0951_/B _0913_/B _0943_/X vssd1 vssd1 vccd1 vccd1 _0945_/B sky130_fd_sc_hd__a21oi_2
XFILLER_9_261 vssd1 vssd1 vccd1 vccd1 sky130_fd_sc_hd__fill_4
X_0875_ _1378_/A _0875_/B vssd1 vssd1 vccd1 vccd1 _0875_/Y sky130_fd_sc_hd__nor2_2
XFILLER_9_294 vssd1 vssd1 vccd1 vccd1 sky130_fd_sc_hd__fill_4
X_1427_ _1480_/B _1427_/B _1432_/B vssd1 vssd1 vccd1 vccd1 _1427_/X sky130_fd_sc_hd__or3_4
X_1358_ _1358_/A _1358_/B _1441_/A vssd1 vssd1 vccd1 vccd1 _1358_/X sky130_fd_sc_hd__or3b_4
X_1289_ _1288_/A _1287_/Y _1288_/Y _1294_/B vssd1 vssd1 vccd1 vccd1 _1318_/A sky130_fd_sc_hd__a22o_2
XFILLER_11_227 vssd1 vssd1 vccd1 vccd1 sky130_fd_sc_hd__fill_1
Xclkload3 clkload3/A vssd1 vssd1 vccd1 vccd1 clkload3/X sky130_fd_sc_hd__clkbuf_4
XFILLER_46_113 vssd1 vssd1 vccd1 vccd1 sky130_fd_sc_hd__fill_2
XFILLER_46_157 vssd1 vssd1 vccd1 vccd1 sky130_fd_sc_hd__fill_8
XFILLER_6_253 vssd1 vssd1 vccd1 vccd1 sky130_fd_sc_hd__fill_1
XFILLER_37_113 vssd1 vssd1 vccd1 vccd1 sky130_fd_sc_hd__fill_1
X_1212_ _1212_/A _1212_/B vssd1 vssd1 vccd1 vccd1 _1337_/A sky130_fd_sc_hd__xnor2_2
X_1143_ _1143_/A _1143_/B vssd1 vssd1 vccd1 vccd1 _1248_/A sky130_fd_sc_hd__xnor2_2
X_1074_ _1012_/Y _1031_/B _1072_/B _1073_/Y vssd1 vssd1 vccd1 vccd1 _1129_/A sky130_fd_sc_hd__a22o_2
X_0927_ _0934_/C _0934_/B _0903_/Y vssd1 vssd1 vccd1 vccd1 _0937_/A sky130_fd_sc_hd__a21oi_2
X_0858_ _0887_/B vssd1 vssd1 vccd1 vccd1 _0858_/Y sky130_fd_sc_hd__inv_2
X_0789_ _1609_/Q vssd1 vssd1 vccd1 vccd1 _0789_/Y sky130_fd_sc_hd__inv_2
XTAP_TAPCELL_ROW_41_306 vssd1 vccd1 sky130_fd_sc_hd__tapvpwrvgnd_1
XFILLER_3_223 vssd1 vssd1 vccd1 vccd1 sky130_fd_sc_hd__fill_1
XFILLER_10_83 vssd1 vssd1 vccd1 vccd1 sky130_fd_sc_hd__fill_1
XFILLER_19_102 vssd1 vssd1 vccd1 vccd1 sky130_fd_sc_hd__fill_4
XFILLER_19_92 vssd1 vssd1 vccd1 vccd1 sky130_fd_sc_hd__fill_1
XFILLER_27_190 vssd1 vssd1 vccd1 vccd1 sky130_fd_sc_hd__fill_1
XFILLER_34_138 vssd1 vssd1 vccd1 vccd1 sky130_fd_sc_hd__fill_2
X_1126_ _1127_/A _1126_/B vssd1 vssd1 vccd1 vccd1 _1126_/Y sky130_fd_sc_hd__xnor2_2
X_1057_ _1058_/A _1058_/B vssd1 vssd1 vccd1 vccd1 _1057_/X sky130_fd_sc_hd__xor2_2
XFILLER_24_193 vssd1 vssd1 vccd1 vccd1 sky130_fd_sc_hd__fill_2
XFILLER_21_82 vssd1 vssd1 vccd1 vccd1 sky130_fd_sc_hd__fill_1
XFILLER_15_160 vssd1 vssd1 vccd1 vccd1 sky130_fd_sc_hd__fill_2
Xclkbuf_0_clk clk vssd1 vssd1 vccd1 vccd1 clkbuf_0_clk/X sky130_fd_sc_hd__clkbuf_16
XTAP_TAPCELL_ROW_17_188 vssd1 vccd1 sky130_fd_sc_hd__tapvpwrvgnd_1
XPHY_EDGE_ROW_15_Right_15 vssd1 vssd1 vccd1 vccd1 sky130_fd_sc_hd__decap_3
XFILLER_38_285 vssd1 vccd1 vssd1 vccd1 sky130_ef_sc_hd__decap_40_12
X_1109_ _1106_/A _1077_/B _1080_/B vssd1 vssd1 vccd1 vccd1 _1110_/B sky130_fd_sc_hd__a21oi_2
XPHY_EDGE_ROW_24_Right_24 vssd1 vssd1 vccd1 vccd1 sky130_fd_sc_hd__decap_3
XFILLER_21_152 vssd1 vssd1 vccd1 vccd1 sky130_fd_sc_hd__fill_4
XFILLER_42_15 vssd1 vccd1 vssd1 vccd1 sky130_ef_sc_hd__decap_40_12
XPHY_EDGE_ROW_33_Right_33 vssd1 vssd1 vccd1 vccd1 sky130_fd_sc_hd__decap_3
XFILLER_29_274 vssd1 vssd1 vccd1 vccd1 sky130_fd_sc_hd__fill_2
XPHY_EDGE_ROW_42_Right_42 vssd1 vssd1 vccd1 vccd1 sky130_fd_sc_hd__decap_3
XFILLER_12_141 vssd1 vssd1 vccd1 vccd1 sky130_fd_sc_hd__fill_2
XFILLER_12_152 vssd1 vssd1 vccd1 vccd1 sky130_fd_sc_hd__fill_1
XTAP_TAPCELL_ROW_14_169 vssd1 vccd1 sky130_fd_sc_hd__tapvpwrvgnd_1
XFILLER_8_134 vssd1 vssd1 vccd1 vccd1 sky130_fd_sc_hd__fill_4
XFILLER_8_112 vssd1 vssd1 vccd1 vccd1 sky130_fd_sc_hd__fill_1
XFILLER_8_101 vssd1 vssd1 vccd1 vccd1 sky130_fd_sc_hd__fill_2
X_1460_ _1610_/Q _1460_/B _1612_/Q _1460_/D vssd1 vssd1 vccd1 vccd1 _1482_/D sky130_fd_sc_hd__and4_2
X_1391_ _1602_/Q _1392_/C _1603_/Q vssd1 vssd1 vccd1 vccd1 _1391_/Y sky130_fd_sc_hd__a21oi_2
XFILLER_35_244 vssd1 vssd1 vccd1 vccd1 sky130_fd_sc_hd__fill_2
XFILLER_35_277 vssd1 vssd1 vccd1 vccd1 sky130_fd_sc_hd__fill_2
XFILLER_12_29 vssd1 vccd1 vssd1 vccd1 sky130_ef_sc_hd__decap_40_12
X_1589_ clkload0/A _1589_/D load_slew60/X vssd1 vssd1 vccd1 vccd1 _1589_/Q sky130_fd_sc_hd__dfrtp_2
XTAP_TAPCELL_ROW_5_126 vssd1 vccd1 sky130_fd_sc_hd__tapvpwrvgnd_1
XFILLER_26_233 vssd1 vssd1 vccd1 vccd1 sky130_fd_sc_hd__fill_1
XFILLER_41_225 vssd1 vssd1 vccd1 vccd1 sky130_fd_sc_hd__fill_1
XTAP_TAPCELL_ROW_36_283 vssd1 vccd1 sky130_fd_sc_hd__tapvpwrvgnd_1
XTAP_TAPCELL_ROW_28_239 vssd1 vccd1 sky130_fd_sc_hd__tapvpwrvgnd_1
XFILLER_5_137 vssd1 vssd1 vccd1 vccd1 sky130_fd_sc_hd__fill_8
XFILLER_17_233 vssd1 vssd1 vccd1 vccd1 sky130_fd_sc_hd__fill_2
XFILLER_17_255 vssd1 vssd1 vccd1 vccd1 sky130_fd_sc_hd__fill_4
X_0960_ _0984_/A _0976_/A _0960_/C _0960_/D vssd1 vssd1 vccd1 vccd1 _0960_/X sky130_fd_sc_hd__or4_4
X_1512_ _1510_/A _1626_/Q _1510_/B _1514_/A vssd1 vssd1 vccd1 vccd1 _1513_/A sky130_fd_sc_hd__a31o_2
X_0891_ _0870_/B _0888_/Y _0889_/Y _1654_/Q vssd1 vssd1 vccd1 vccd1 _0891_/X sky130_fd_sc_hd__a31o_2
XTAP_TAPCELL_ROW_10_150 vssd1 vccd1 sky130_fd_sc_hd__tapvpwrvgnd_1
XFILLER_4_41 vssd1 vssd1 vccd1 vccd1 sky130_fd_sc_hd__fill_1
XFILLER_4_85 vssd1 vssd1 vccd1 vccd1 sky130_fd_sc_hd__fill_1
X_1443_ _1610_/Q _1460_/D vssd1 vssd1 vccd1 vccd1 _1443_/Y sky130_fd_sc_hd__nor2_2
X_1374_ _1374_/A _1374_/B vssd1 vssd1 vccd1 vccd1 _1374_/Y sky130_fd_sc_hd__nor2_2
XFILLER_23_225 vssd1 vssd1 vccd1 vccd1 sky130_fd_sc_hd__fill_1
XTAP_TAPCELL_ROW_33_264 vssd1 vccd1 sky130_fd_sc_hd__tapvpwrvgnd_1
XFILLER_3_9 vssd1 vssd1 vccd1 vccd1 sky130_fd_sc_hd__fill_4
Xfanout40 _0906_/Y vssd1 vssd1 vccd1 vccd1 _0934_/C sky130_fd_sc_hd__buf_8
Xfanout51 _1606_/Q vssd1 vssd1 vccd1 vccd1 _1416_/A sky130_fd_sc_hd__clkdlybuf4s25_1
XTAP_TAPCELL_ROW_24_220 vssd1 vccd1 sky130_fd_sc_hd__tapvpwrvgnd_1
XFILLER_1_195 vssd1 vssd1 vccd1 vccd1 sky130_fd_sc_hd__fill_2
XTAP_TAPCELL_ROW_0_97 vssd1 vccd1 sky130_fd_sc_hd__tapvpwrvgnd_1
X_1090_ _1090_/A _1090_/B vssd1 vssd1 vccd1 vccd1 _1093_/B sky130_fd_sc_hd__xnor2_2
Xclkload10 _1633_/CLK vssd1 vssd1 vccd1 vccd1 clkload10/X sky130_fd_sc_hd__clkbuf_4
X_0943_ _0951_/A _0890_/Y _0951_/C _1620_/Q _1619_/Q vssd1 vssd1 vccd1 vccd1 _0943_/X
+ sky130_fd_sc_hd__o311a_2
X_0874_ _0861_/X _0865_/X _0870_/Y _0873_/X vssd1 vssd1 vccd1 vccd1 _0875_/B sky130_fd_sc_hd__a211oi_2
X_1426_ _1426_/A _1426_/B _1426_/C vssd1 vssd1 vccd1 vccd1 _1432_/B sky130_fd_sc_hd__and3_4
X_1357_ _1330_/B _1479_/A _1456_/B vssd1 vssd1 vccd1 vccd1 _1358_/A sky130_fd_sc_hd__nand3b_2
X_1288_ _1288_/A _1294_/A vssd1 vssd1 vccd1 vccd1 _1288_/Y sky130_fd_sc_hd__nor2_2
Xclkload4 clkload4/A vssd1 vssd1 vccd1 vccd1 clkload4/X sky130_fd_sc_hd__clkbuf_4
XFILLER_46_169 vssd1 vssd1 vccd1 vccd1 sky130_fd_sc_hd__fill_1
XFILLER_24_82 vssd1 vssd1 vccd1 vccd1 sky130_fd_sc_hd__fill_2
XFILLER_24_93 vssd1 vssd1 vccd1 vccd1 sky130_fd_sc_hd__fill_1
XFILLER_10_294 vssd1 vssd1 vccd1 vccd1 sky130_fd_sc_hd__fill_4
XFILLER_1_53 vssd1 vssd1 vccd1 vccd1 sky130_fd_sc_hd__fill_2
X_1211_ _1192_/A _1192_/B _1212_/A _1173_/A vssd1 vssd1 vccd1 vccd1 _1211_/X sky130_fd_sc_hd__a211o_2
X_1142_ _1116_/X _1142_/A2 _1175_/C1 vssd1 vssd1 vccd1 vccd1 _1143_/B sky130_fd_sc_hd__o21a_2
XFILLER_37_169 vssd1 vssd1 vccd1 vccd1 sky130_fd_sc_hd__fill_2
X_1073_ _1073_/A _1073_/B vssd1 vssd1 vccd1 vccd1 _1073_/Y sky130_fd_sc_hd__nand2_2
XFILLER_20_29 vssd1 vccd1 vssd1 vccd1 sky130_ef_sc_hd__decap_40_12
X_0926_ _0926_/A _0926_/B _0926_/C vssd1 vssd1 vccd1 vccd1 _0926_/X sky130_fd_sc_hd__and3_2
X_0857_ _1613_/Q _1614_/Q vssd1 vssd1 vccd1 vccd1 _0887_/B sky130_fd_sc_hd__or2_4
X_1409_ _1605_/Q _1409_/B vssd1 vssd1 vccd1 vccd1 _1409_/Y sky130_fd_sc_hd__nor2_2
X_0788_ _1600_/Q vssd1 vssd1 vccd1 vccd1 _0788_/Y sky130_fd_sc_hd__inv_2
XFILLER_28_114 vssd1 vssd1 vccd1 vccd1 sky130_fd_sc_hd__fill_1
XFILLER_43_139 vssd1 vssd1 vccd1 vccd1 sky130_fd_sc_hd__fill_2
XTAP_TAPCELL_ROW_41_307 vssd1 vccd1 sky130_fd_sc_hd__tapvpwrvgnd_1
XFILLER_10_51 vssd1 vssd1 vccd1 vccd1 sky130_fd_sc_hd__fill_1
XFILLER_10_62 vssd1 vssd1 vccd1 vccd1 sky130_fd_sc_hd__fill_8
XFILLER_32_3 vssd1 vssd1 vccd1 vccd1 sky130_fd_sc_hd__fill_2
XFILLER_25_117 vssd1 vssd1 vccd1 vccd1 sky130_fd_sc_hd__fill_2
X_1125_ _1124_/A _1106_/B _1122_/B _1124_/Y vssd1 vssd1 vccd1 vccd1 _1145_/B sky130_fd_sc_hd__a2bb2o_2
XFILLER_33_183 vssd1 vssd1 vccd1 vccd1 sky130_fd_sc_hd__fill_1
X_1056_ _1112_/B _1056_/B vssd1 vssd1 vccd1 vccd1 _1056_/Y sky130_fd_sc_hd__nand2b_2
X_0909_ _0951_/A _0951_/C vssd1 vssd1 vccd1 vccd1 _0909_/Y sky130_fd_sc_hd__nor2_2
XFILLER_0_238 vssd1 vssd1 vccd1 vccd1 sky130_fd_sc_hd__fill_4
XFILLER_16_128 vssd1 vssd1 vccd1 vccd1 sky130_fd_sc_hd__fill_2
XFILLER_24_161 vssd1 vssd1 vccd1 vccd1 sky130_fd_sc_hd__fill_1
XFILLER_31_109 vssd1 vssd1 vccd1 vccd1 sky130_fd_sc_hd__fill_2
XFILLER_30_131 vssd1 vssd1 vccd1 vccd1 sky130_fd_sc_hd__fill_8
XFILLER_30_175 vssd1 vssd1 vccd1 vccd1 sky130_fd_sc_hd__fill_1
XFILLER_7_63 vssd1 vccd1 vssd1 vccd1 sky130_ef_sc_hd__decap_40_12
XFILLER_38_253 vssd1 vssd1 vccd1 vccd1 sky130_fd_sc_hd__fill_4
XFILLER_38_297 vssd1 vssd1 vccd1 vccd1 sky130_fd_sc_hd__fill_2
X_1108_ _1105_/X _1076_/Y _1108_/S vssd1 vssd1 vccd1 vccd1 _1108_/X sky130_fd_sc_hd__mux2_1
X_1039_ _1023_/B _1034_/B _1040_/A _1007_/B vssd1 vssd1 vccd1 vccd1 _1044_/A sky130_fd_sc_hd__a211o_4
XFILLER_21_175 vssd1 vssd1 vccd1 vccd1 sky130_fd_sc_hd__fill_1
XFILLER_42_27 vssd1 vssd1 vccd1 vccd1 sky130_fd_sc_hd__fill_1
XFILLER_42_38 vssd1 vssd1 vccd1 vccd1 sky130_fd_sc_hd__fill_8
XFILLER_29_242 vssd1 vssd1 vccd1 vccd1 sky130_fd_sc_hd__fill_8
XFILLER_12_131 vssd1 vssd1 vccd1 vccd1 sky130_fd_sc_hd__fill_1
XFILLER_32_82 vssd1 vssd1 vccd1 vccd1 sky130_fd_sc_hd__fill_2
X_1390_ _1395_/B _1390_/A2 _1388_/X _1480_/B _1389_/Y vssd1 vssd1 vccd1 vccd1 _1390_/X
+ sky130_fd_sc_hd__a311o_2
XFILLER_35_256 vssd1 vssd1 vccd1 vccd1 sky130_fd_sc_hd__fill_2
X_1588_ clkload5/A input4/X _1653_/SET_B vssd1 vssd1 vccd1 vccd1 _1588_/Q sky130_fd_sc_hd__dfrtp_2
XTAP_TAPCELL_ROW_5_127 vssd1 vccd1 sky130_fd_sc_hd__tapvpwrvgnd_1
XANTENNA__0892__Y _1378_/B vssd1 vssd1 vccd1 vccd1 sky130_fd_sc_hd__diode_2
XFILLER_26_267 vssd1 vssd1 vccd1 vccd1 sky130_fd_sc_hd__fill_1
Xrebuffer221 _1464_/A vssd1 vssd1 vccd1 vccd1 _1457_/B sky130_fd_sc_hd__buf_2
Xrebuffer210 _1405_/A1 vssd1 vssd1 vccd1 vccd1 _1420_/A2 sky130_fd_sc_hd__buf_6
X_0890_ _0890_/A vssd1 vssd1 vccd1 vccd1 _0890_/Y sky130_fd_sc_hd__inv_2
X_1511_ _1380_/A _1509_/X _1514_/B _0805_/A _1510_/A vssd1 vssd1 vccd1 vccd1 _1625_/D
+ sky130_fd_sc_hd__a32o_2
X_1442_ _1434_/A _1439_/X _1442_/B1 _1448_/B _1480_/B vssd1 vssd1 vccd1 vccd1 _1442_/X
+ sky130_fd_sc_hd__a221o_2
XTAP_TAPCELL_ROW_10_151 vssd1 vccd1 sky130_fd_sc_hd__tapvpwrvgnd_1
X_1373_ _1373_/A _1373_/B _1373_/C vssd1 vssd1 vccd1 vccd1 _1374_/B sky130_fd_sc_hd__and3_2
XTAP_TAPCELL_ROW_33_265 vssd1 vccd1 sky130_fd_sc_hd__tapvpwrvgnd_1
Xfanout30 _0973_/X vssd1 vssd1 vccd1 vccd1 _1034_/B sky130_fd_sc_hd__clkdlybuf4s25_1
Xfanout52 _1604_/Q vssd1 vssd1 vccd1 vccd1 _1408_/A sky130_fd_sc_hd__clkdlybuf4s25_1
Xfanout63 fanout64/X vssd1 vssd1 vccd1 vccd1 fanout63/X sky130_fd_sc_hd__clkdlybuf4s25_1
XTAP_TAPCELL_ROW_24_221 vssd1 vccd1 sky130_fd_sc_hd__tapvpwrvgnd_1
XTAP_TAPCELL_ROW_0_98 vssd1 vccd1 sky130_fd_sc_hd__tapvpwrvgnd_1
Xclkload11 _1605_/CLK vssd1 vssd1 vccd1 vccd1 clkload11/X sky130_fd_sc_hd__clkbuf_4
X_0942_ _0942_/A _0942_/B _0996_/B _0926_/X vssd1 vssd1 vccd1 vccd1 _0969_/B sky130_fd_sc_hd__or4b_4
X_0873_ _1600_/Q _1609_/Q _1617_/Q _0873_/D vssd1 vssd1 vccd1 vccd1 _0873_/X sky130_fd_sc_hd__or4_2
X_1425_ _1426_/B _1426_/C _1426_/A vssd1 vssd1 vccd1 vccd1 _1427_/B sky130_fd_sc_hd__a21oi_2
XFILLER_18_29 vssd1 vssd1 vccd1 vccd1 sky130_fd_sc_hd__fill_4
X_1356_ _1355_/A _1412_/A _1349_/X _1355_/X vssd1 vssd1 vccd1 vccd1 _1356_/X sky130_fd_sc_hd__o211a_4
X_1287_ _1294_/A _1294_/B vssd1 vssd1 vccd1 vccd1 _1287_/Y sky130_fd_sc_hd__nand2b_2
Xclkload5 clkload5/A vssd1 vssd1 vccd1 vccd1 clkload5/X sky130_fd_sc_hd__clkbuf_4
XFILLER_46_115 vssd1 vssd1 vccd1 vccd1 sky130_fd_sc_hd__fill_1
XFILLER_10_251 vssd1 vssd1 vccd1 vccd1 sky130_fd_sc_hd__fill_1
XFILLER_24_50 vssd1 vssd1 vccd1 vccd1 sky130_fd_sc_hd__fill_4
XFILLER_40_60 vssd1 vssd1 vccd1 vccd1 sky130_fd_sc_hd__fill_2
XFILLER_40_82 vssd1 vssd1 vccd1 vccd1 sky130_fd_sc_hd__fill_2
XFILLER_1_21 vssd1 vssd1 vccd1 vccd1 sky130_fd_sc_hd__fill_8
X_1210_ _1192_/A _1210_/A2 _1173_/A vssd1 vssd1 vccd1 vccd1 _1212_/B sky130_fd_sc_hd__a21oi_4
X_1141_ _1145_/A _1163_/B _1139_/X _1138_/X vssd1 vssd1 vccd1 vccd1 _1223_/B sky130_fd_sc_hd__o31a_4
X_1072_ _1072_/A _1072_/B vssd1 vssd1 vccd1 vccd1 _1075_/A sky130_fd_sc_hd__xnor2_2
X_0925_ _0926_/B _0991_/B vssd1 vssd1 vccd1 vccd1 _0925_/Y sky130_fd_sc_hd__nand2_2
X_0856_ _1610_/Q _1460_/B _1602_/Q _1408_/A vssd1 vssd1 vccd1 vccd1 _0856_/X sky130_fd_sc_hd__and4b_2
X_0787_ _1599_/Q vssd1 vssd1 vccd1 vccd1 _1366_/A sky130_fd_sc_hd__inv_2
X_1408_ _1408_/A _1605_/Q _1408_/C vssd1 vssd1 vccd1 vccd1 _1422_/C sky130_fd_sc_hd__and3_2
XFILLER_28_137 vssd1 vssd1 vccd1 vccd1 sky130_fd_sc_hd__fill_2
X_1339_ _1339_/A _1600_/Q vssd1 vssd1 vccd1 vccd1 _1339_/Y sky130_fd_sc_hd__xnor2_4
XTAP_TAPCELL_ROW_41_308 vssd1 vccd1 sky130_fd_sc_hd__tapvpwrvgnd_1
XFILLER_10_41 vssd1 vssd1 vccd1 vccd1 sky130_fd_sc_hd__fill_8
XFILLER_3_214 vssd1 vssd1 vccd1 vccd1 sky130_fd_sc_hd__fill_1
XFILLER_3_225 vssd1 vssd1 vccd1 vccd1 sky130_fd_sc_hd__fill_2
XFILLER_3_258 vssd1 vssd1 vccd1 vccd1 sky130_fd_sc_hd__fill_2
XFILLER_42_151 vssd1 vssd1 vccd1 vccd1 sky130_fd_sc_hd__fill_1
XFILLER_25_3 vssd1 vssd1 vccd1 vccd1 sky130_fd_sc_hd__fill_2
XPHY_EDGE_ROW_27_Left_74 vssd1 vssd1 vccd1 vccd1 sky130_fd_sc_hd__decap_3
X_1124_ _1124_/A _1124_/B vssd1 vssd1 vccd1 vccd1 _1124_/Y sky130_fd_sc_hd__nand2_2
X_1055_ _0983_/Y _1013_/Y _1031_/B _1054_/X vssd1 vssd1 vccd1 vccd1 _1112_/B sky130_fd_sc_hd__o31a_2
XPHY_EDGE_ROW_11_Left_58 vssd1 vssd1 vccd1 vccd1 sky130_fd_sc_hd__decap_3
X_0908_ _1460_/B _0904_/X _1615_/Q _1612_/Q vssd1 vssd1 vccd1 vccd1 _0951_/C sky130_fd_sc_hd__o211a_4
X_0839_ _1534_/A _1632_/Q _1634_/Q vssd1 vssd1 vccd1 vccd1 _0839_/X sky130_fd_sc_hd__or3_2
XFILLER_24_195 vssd1 vssd1 vccd1 vccd1 sky130_fd_sc_hd__fill_1
XFILLER_46_81 vssd1 vssd1 vccd1 vccd1 sky130_fd_sc_hd__fill_1
XANTENNA__1606__CLK clkload8/A vssd1 vssd1 vccd1 vccd1 sky130_fd_sc_hd__diode_2
XANTENNA__1606__RESET_B load_slew58/X vssd1 vssd1 vccd1 vccd1 sky130_fd_sc_hd__diode_2
XFILLER_7_75 vssd1 vccd1 vssd1 vccd1 sky130_ef_sc_hd__decap_40_12
Xclone171 _0961_/X vssd1 vssd1 vccd1 vccd1 _1002_/B sky130_fd_sc_hd__clkbuf_2
X_1107_ _1129_/B vssd1 vssd1 vccd1 vccd1 _1107_/Y sky130_fd_sc_hd__inv_2
X_1038_ _1034_/B _1034_/C _1007_/B vssd1 vssd1 vccd1 vccd1 _1040_/B sky130_fd_sc_hd__a21o_2
XPHY_EDGE_ROW_5_Right_5 vssd1 vssd1 vccd1 vccd1 sky130_fd_sc_hd__decap_3
XANTENNA_fanout35_X _0893_/C vssd1 vssd1 vccd1 vccd1 sky130_fd_sc_hd__diode_2
XFILLER_32_50 vssd1 vssd1 vccd1 vccd1 sky130_fd_sc_hd__fill_1
XFILLER_32_72 vssd1 vssd1 vccd1 vccd1 sky130_fd_sc_hd__fill_2
XFILLER_35_246 vssd1 vssd1 vccd1 vccd1 sky130_fd_sc_hd__fill_1
XFILLER_35_268 vssd1 vssd1 vccd1 vccd1 sky130_fd_sc_hd__fill_2
XFILLER_35_279 vssd1 vssd1 vccd1 vccd1 sky130_fd_sc_hd__fill_1
X_1587_ clkload1/A _1587_/D _1653_/SET_B vssd1 vssd1 vccd1 vccd1 _1587_/Q sky130_fd_sc_hd__dfrtp_2
X_1656_ clkload1/A _1656_/D _1653_/SET_B vssd1 vssd1 vccd1 vccd1 _1656_/Q sky130_fd_sc_hd__dfrtp_2
XTAP_TAPCELL_ROW_5_128 vssd1 vccd1 sky130_fd_sc_hd__tapvpwrvgnd_1
XFILLER_26_202 vssd1 vssd1 vccd1 vccd1 sky130_fd_sc_hd__fill_4
XPHY_EDGE_ROW_14_Left_61 vssd1 vssd1 vccd1 vccd1 sky130_fd_sc_hd__decap_3
Xrebuffer222 _1464_/A vssd1 vssd1 vccd1 vccd1 _1442_/B1 sky130_fd_sc_hd__buf_2
Xrebuffer200 _1158_/A1 vssd1 vssd1 vccd1 vccd1 _1222_/A sky130_fd_sc_hd__buf_2
XFILLER_17_202 vssd1 vssd1 vccd1 vccd1 sky130_fd_sc_hd__fill_1
XFILLER_17_235 vssd1 vssd1 vccd1 vccd1 sky130_fd_sc_hd__fill_1
XFILLER_27_72 vssd1 vccd1 vssd1 vccd1 sky130_ef_sc_hd__decap_40_12
XANTENNA__1417__B1 _1378_/B vssd1 vssd1 vccd1 vccd1 sky130_fd_sc_hd__diode_2
XFILLER_4_161 vssd1 vssd1 vccd1 vccd1 sky130_fd_sc_hd__fill_1
X_1510_ _1510_/A _1510_/B vssd1 vssd1 vccd1 vccd1 _1514_/B sky130_fd_sc_hd__nand2_2
X_1441_ _1441_/A _1441_/B vssd1 vssd1 vccd1 vccd1 _1448_/C sky130_fd_sc_hd__nand2_2
XTAP_TAPCELL_ROW_10_152 vssd1 vccd1 sky130_fd_sc_hd__tapvpwrvgnd_1
X_1372_ _1372_/A1 _1373_/C _1373_/A vssd1 vssd1 vccd1 vccd1 _1374_/A sky130_fd_sc_hd__a21oi_2
XTAP_TAPCELL_ROW_2_109 vssd1 vccd1 sky130_fd_sc_hd__tapvpwrvgnd_1
XTAP_TAPCELL_ROW_33_266 vssd1 vccd1 sky130_fd_sc_hd__tapvpwrvgnd_1
XFILLER_2_109 vssd1 vssd1 vccd1 vccd1 sky130_fd_sc_hd__fill_1
XANTENNA_input4_A gpio_in[2] vssd1 vssd1 vccd1 vccd1 sky130_fd_sc_hd__diode_2
X_1639_ _1641_/CLK _1639_/D vssd1 vssd1 vccd1 vccd1 _1639_/Q sky130_fd_sc_hd__dfxtp_2
Xfanout31 _0964_/X vssd1 vssd1 vccd1 vccd1 _1002_/C sky130_fd_sc_hd__dlymetal6s4s_1
Xfanout42 _1515_/A1 vssd1 vssd1 vccd1 vccd1 _1378_/A sky130_fd_sc_hd__clkdlybuf4s25_1
Xfanout53 _1601_/Q vssd1 vssd1 vccd1 vccd1 _1376_/A sky130_fd_sc_hd__clkdlybuf4s25_1
Xfanout64 _0800_/X vssd1 vssd1 vccd1 vccd1 fanout64/X sky130_fd_sc_hd__clkdlybuf4s25_1
XTAP_TAPCELL_ROW_24_222 vssd1 vccd1 sky130_fd_sc_hd__tapvpwrvgnd_1
XTAP_TAPCELL_ROW_0_99 vssd1 vccd1 sky130_fd_sc_hd__tapvpwrvgnd_1
X_0941_ _0941_/A _0941_/B vssd1 vssd1 vccd1 vccd1 _0942_/B sky130_fd_sc_hd__or2_2
XFILLER_13_293 vssd1 vssd1 vccd1 vccd1 sky130_fd_sc_hd__fill_4
Xclkload12 _1612_/CLK vssd1 vssd1 vccd1 vccd1 clkload12/X sky130_fd_sc_hd__clkbuf_4
X_0872_ _1654_/Q _1366_/A _0871_/X vssd1 vssd1 vccd1 vccd1 _0873_/D sky130_fd_sc_hd__a21bo_2
X_1424_ _1462_/B1 _1420_/X _1423_/Y _1463_/B2 _1422_/A vssd1 vssd1 vccd1 vccd1 _1607_/D
+ sky130_fd_sc_hd__a32o_2
X_1355_ _1355_/A _1395_/C _1404_/A _1395_/B vssd1 vssd1 vccd1 vccd1 _1355_/X sky130_fd_sc_hd__or4b_4
X_1286_ _1286_/A _1286_/B vssd1 vssd1 vccd1 vccd1 _1294_/B sky130_fd_sc_hd__and2_2
XFILLER_34_29 vssd1 vssd1 vccd1 vccd1 sky130_fd_sc_hd__fill_1
Xclkload6 clkload6/A vssd1 vssd1 vccd1 vccd1 clkload6/X sky130_fd_sc_hd__clkbuf_4
XPHY_EDGE_ROW_41_Left_88 vssd1 vssd1 vccd1 vccd1 sky130_fd_sc_hd__decap_3
XFILLER_46_105 vssd1 vssd1 vccd1 vccd1 sky130_fd_sc_hd__fill_4
XFILLER_46_138 vssd1 vssd1 vccd1 vccd1 sky130_fd_sc_hd__fill_2
XFILLER_10_230 vssd1 vssd1 vccd1 vccd1 sky130_fd_sc_hd__fill_4
XFILLER_41_9 vssd1 vccd1 vssd1 vccd1 sky130_ef_sc_hd__decap_40_12
XFILLER_1_55 vssd1 vssd1 vccd1 vccd1 sky130_fd_sc_hd__fill_1
XFILLER_37_149 vssd1 vssd1 vccd1 vccd1 sky130_fd_sc_hd__fill_4
X_1140_ _1145_/A _1140_/A2 _1139_/X _1140_/B1 vssd1 vssd1 vccd1 vccd1 _1149_/B sky130_fd_sc_hd__o31ai_2
X_1071_ _1071_/A wire26/X vssd1 vssd1 vccd1 vccd1 _1106_/A sky130_fd_sc_hd__nand2_2
X_0924_ _0962_/B _1612_/Q _0922_/B _0923_/X vssd1 vssd1 vccd1 vccd1 _0926_/C sky130_fd_sc_hd__a22oi_2
X_0855_ _1716_/A _0851_/Y _0854_/Y _0853_/Y _0846_/Y vssd1 vssd1 vccd1 vccd1 _0855_/X
+ sky130_fd_sc_hd__a32o_2
X_1407_ _1480_/B _1407_/B _1406_/X vssd1 vssd1 vccd1 vccd1 _1407_/X sky130_fd_sc_hd__or3b_4
X_1338_ _1270_/X _1347_/C _1352_/B _1337_/X vssd1 vssd1 vccd1 vccd1 _1404_/A sky130_fd_sc_hd__o22ai_2
XFILLER_43_108 vssd1 vssd1 vccd1 vccd1 sky130_fd_sc_hd__fill_1
X_1269_ _1347_/A _1347_/B vssd1 vssd1 vccd1 vccd1 _1269_/Y sky130_fd_sc_hd__nand2_2
XANTENNA__0816__A1 _1653_/Q vssd1 vssd1 vccd1 vccd1 sky130_fd_sc_hd__diode_2
XFILLER_42_141 vssd1 vssd1 vccd1 vccd1 sky130_fd_sc_hd__fill_1
XFILLER_18_171 vssd1 vssd1 vccd1 vccd1 sky130_fd_sc_hd__fill_2
XFILLER_25_119 vssd1 vssd1 vccd1 vccd1 sky130_fd_sc_hd__fill_1
X_1123_ _1126_/B _1123_/B vssd1 vssd1 vccd1 vccd1 _1225_/A sky130_fd_sc_hd__nand2_2
X_1054_ _1072_/A _1072_/B _0984_/B vssd1 vssd1 vccd1 vccd1 _1054_/X sky130_fd_sc_hd__a21o_2
XFILLER_31_19 vssd1 vssd1 vccd1 vccd1 sky130_fd_sc_hd__fill_1
X_0907_ _1460_/B _0923_/C _1612_/Q vssd1 vssd1 vccd1 vccd1 _0907_/X sky130_fd_sc_hd__o21a_2
X_0838_ _0841_/C _1528_/B _0831_/Y _0837_/X vssd1 vssd1 vccd1 vccd1 _0838_/X sky130_fd_sc_hd__o211a_2
XFILLER_24_185 vssd1 vssd1 vccd1 vccd1 sky130_fd_sc_hd__fill_8
XPHY_EDGE_ROW_44_Left_91 vssd1 vssd1 vccd1 vccd1 sky130_fd_sc_hd__decap_3
XFILLER_15_130 vssd1 vssd1 vccd1 vccd1 sky130_fd_sc_hd__fill_2
XANTENNA__1462__A1 _1378_/B vssd1 vssd1 vccd1 vccd1 sky130_fd_sc_hd__diode_2
XFILLER_30_111 vssd1 vssd1 vccd1 vccd1 sky130_fd_sc_hd__fill_2
XFILLER_7_32 vssd1 vccd1 vssd1 vccd1 sky130_ef_sc_hd__decap_40_12
XFILLER_7_87 vssd1 vccd1 vssd1 vccd1 sky130_ef_sc_hd__decap_40_12
X_1106_ _1106_/A _1106_/B vssd1 vssd1 vccd1 vccd1 _1129_/B sky130_fd_sc_hd__nand2_2
XFILLER_42_29 vssd1 vssd1 vccd1 vccd1 sky130_fd_sc_hd__fill_2
X_1037_ _1408_/A _1042_/B _1037_/C vssd1 vssd1 vccd1 vccd1 _1037_/X sky130_fd_sc_hd__or3_2
XTAP_TAPCELL_ROW_16_180 vssd1 vccd1 sky130_fd_sc_hd__tapvpwrvgnd_1
XFILLER_21_166 vssd1 vssd1 vccd1 vccd1 sky130_fd_sc_hd__fill_2
XFILLER_29_266 vssd1 vssd1 vccd1 vccd1 sky130_fd_sc_hd__fill_8
XFILLER_44_214 vssd1 vssd1 vccd1 vccd1 sky130_fd_sc_hd__fill_2
XFILLER_44_258 vssd1 vssd1 vccd1 vccd1 sky130_fd_sc_hd__fill_4
XTAP_TAPCELL_ROW_39_294 vssd1 vccd1 sky130_fd_sc_hd__tapvpwrvgnd_1
XFILLER_12_111 vssd1 vssd1 vccd1 vccd1 sky130_fd_sc_hd__fill_8
XPHY_EDGE_ROW_11_Right_11 vssd1 vssd1 vccd1 vccd1 sky130_fd_sc_hd__decap_3
XPHY_EDGE_ROW_20_Right_20 vssd1 vssd1 vccd1 vccd1 sky130_fd_sc_hd__decap_3
XFILLER_35_214 vssd1 vssd1 vccd1 vccd1 sky130_fd_sc_hd__fill_2
XFILLER_35_225 vssd1 vssd1 vccd1 vccd1 sky130_fd_sc_hd__fill_1
XFILLER_35_258 vssd1 vssd1 vccd1 vccd1 sky130_fd_sc_hd__fill_1
X_1586_ clkload1/A _1586_/D _1653_/SET_B vssd1 vssd1 vccd1 vccd1 _1586_/Q sky130_fd_sc_hd__dfrtp_2
X_1655_ clkload4/A _1655_/D _1653_/SET_B vssd1 vssd1 vccd1 vccd1 _1655_/Q sky130_fd_sc_hd__dfrtp_2
XFILLER_41_239 vssd1 vssd1 vccd1 vccd1 sky130_fd_sc_hd__fill_4
Xrebuffer223 _1406_/B vssd1 vssd1 vccd1 vccd1 _1479_/B sky130_fd_sc_hd__buf_2
Xrebuffer212 _1373_/B vssd1 vssd1 vccd1 vccd1 _1372_/A1 sky130_fd_sc_hd__buf_2
Xrebuffer201 _1181_/D vssd1 vssd1 vccd1 vccd1 _1158_/A1 sky130_fd_sc_hd__buf_2
XFILLER_27_84 vssd1 vssd1 vccd1 vccd1 sky130_fd_sc_hd__fill_4
XFILLER_43_50 vssd1 vssd1 vccd1 vccd1 sky130_fd_sc_hd__fill_1
XFILLER_40_294 vssd1 vssd1 vccd1 vccd1 sky130_fd_sc_hd__fill_4
XTAP_TAPCELL_ROW_10_153 vssd1 vccd1 sky130_fd_sc_hd__tapvpwrvgnd_1
XFILLER_4_77 vssd1 vssd1 vccd1 vccd1 sky130_fd_sc_hd__fill_4
X_1440_ _1355_/A _1412_/A _1355_/X _1349_/X _1441_/A vssd1 vssd1 vccd1 vccd1 _1464_/A
+ sky130_fd_sc_hd__o2111a_2
X_1371_ _1489_/A1 _1370_/Y _1367_/X _1378_/A _1600_/Q vssd1 vssd1 vccd1 vccd1 _1600_/D
+ sky130_fd_sc_hd__a32o_2
XFILLER_23_217 vssd1 vssd1 vccd1 vccd1 sky130_fd_sc_hd__fill_2
XTAP_TAPCELL_ROW_33_267 vssd1 vccd1 sky130_fd_sc_hd__tapvpwrvgnd_1
X_1638_ _1641_/CLK _1638_/D vssd1 vssd1 vccd1 vccd1 _1638_/Q sky130_fd_sc_hd__dfxtp_2
X_1569_ _1645_/Q _1646_/Q _1569_/C vssd1 vssd1 vccd1 vccd1 _1573_/C sky130_fd_sc_hd__and3_2
Xfanout21 _1252_/X vssd1 vssd1 vccd1 vccd1 _1265_/B sky130_fd_sc_hd__buf_8
XTAP_TAPCELL_ROW_24_223 vssd1 vccd1 sky130_fd_sc_hd__tapvpwrvgnd_1
Xfanout32 _0961_/X vssd1 vssd1 vccd1 vccd1 _1001_/A1 sky130_fd_sc_hd__buf_8
Xfanout43 _1515_/A1 vssd1 vssd1 vccd1 vccd1 _1463_/B2 sky130_fd_sc_hd__clkdlybuf4s25_1
Xfanout54 fanout57/X vssd1 vssd1 vccd1 vccd1 fanout54/X sky130_fd_sc_hd__clkdlybuf4s25_1
XFILLER_38_61 vssd1 vssd1 vccd1 vccd1 sky130_fd_sc_hd__fill_2
XANTENNA_clkbuf_4_11_0_clk_X clkload8/A vssd1 vssd1 vccd1 vccd1 sky130_fd_sc_hd__diode_2
X_0940_ _0940_/A _0940_/B _1006_/A vssd1 vssd1 vccd1 vccd1 _0996_/B sky130_fd_sc_hd__or3_4
XFILLER_9_221 vssd1 vssd1 vccd1 vccd1 sky130_fd_sc_hd__fill_2
X_0871_ _1603_/Q _1422_/A _1612_/Q _1615_/Q vssd1 vssd1 vccd1 vccd1 _0871_/X sky130_fd_sc_hd__and4b_2
XFILLER_9_298 vssd1 vssd1 vccd1 vccd1 sky130_fd_sc_hd__fill_1
X_1423_ _1421_/Y _1436_/C _0893_/C vssd1 vssd1 vccd1 vccd1 _1423_/Y sky130_fd_sc_hd__o21ai_2
X_1354_ _1366_/A _1354_/B _1341_/B _1339_/Y vssd1 vssd1 vccd1 vccd1 _1395_/C sky130_fd_sc_hd__or4bb_4
X_1285_ _1285_/A _1296_/A _1285_/C vssd1 vssd1 vccd1 vccd1 _1286_/B sky130_fd_sc_hd__or3_2
Xclkload7 clkload7/A vssd1 vssd1 vccd1 vccd1 clkload7/X sky130_fd_sc_hd__clkbuf_4
XTAP_TAPCELL_ROW_21_204 vssd1 vccd1 sky130_fd_sc_hd__tapvpwrvgnd_1
XFILLER_1_9 vssd1 vccd1 vssd1 vccd1 sky130_ef_sc_hd__decap_40_12
XFILLER_24_85 vssd1 vssd1 vccd1 vccd1 sky130_fd_sc_hd__fill_8
XFILLER_6_213 vssd1 vccd1 vssd1 vccd1 sky130_ef_sc_hd__decap_40_12
XFILLER_6_246 vssd1 vssd1 vccd1 vccd1 sky130_fd_sc_hd__fill_2
XFILLER_6_279 vssd1 vccd1 vssd1 vccd1 sky130_ef_sc_hd__decap_40_12
XFILLER_45_183 vssd1 vssd1 vccd1 vccd1 sky130_fd_sc_hd__fill_4
X_1070_ _1057_/X _1059_/Y _1064_/X _1127_/A _1131_/A vssd1 vssd1 vccd1 vccd1 wire26/A
+ sky130_fd_sc_hd__a2111oi_2
X_0923_ _1611_/Q _1612_/Q _0923_/C vssd1 vssd1 vccd1 vccd1 _0923_/X sky130_fd_sc_hd__or3_2
X_0854_ _1631_/Q _0850_/Y _1629_/Q vssd1 vssd1 vccd1 vccd1 _0854_/Y sky130_fd_sc_hd__o21ai_2
XFILLER_28_139 vssd1 vssd1 vccd1 vccd1 sky130_fd_sc_hd__fill_1
X_1406_ _1406_/A _1406_/B _1412_/B vssd1 vssd1 vccd1 vccd1 _1406_/X sky130_fd_sc_hd__or3b_4
X_1337_ _1337_/A _1348_/A _1347_/A _1347_/B vssd1 vssd1 vccd1 vccd1 _1337_/X sky130_fd_sc_hd__and4_2
X_1268_ _1347_/B vssd1 vssd1 vccd1 vccd1 _1268_/Y sky130_fd_sc_hd__inv_2
XFILLER_36_194 vssd1 vssd1 vccd1 vccd1 sky130_fd_sc_hd__fill_2
X_1199_ _1199_/A _1199_/B vssd1 vssd1 vccd1 vccd1 _1203_/A sky130_fd_sc_hd__xnor2_2
X_1122_ _1122_/A _1122_/B vssd1 vssd1 vccd1 vccd1 _1123_/B sky130_fd_sc_hd__or2_2
X_1053_ _0973_/X _1048_/A _1013_/Y vssd1 vssd1 vccd1 vccd1 _1072_/B sky130_fd_sc_hd__a21oi_2
X_0906_ _0905_/X _0910_/D _1627_/Q vssd1 vssd1 vccd1 vccd1 _0906_/Y sky130_fd_sc_hd__o21ai_4
X_0837_ _1629_/Q _1520_/A _0836_/X _0830_/Y vssd1 vssd1 vccd1 vccd1 _0837_/X sky130_fd_sc_hd__o31a_2
XFILLER_0_219 vssd1 vssd1 vccd1 vccd1 sky130_fd_sc_hd__fill_4
XFILLER_24_197 vssd1 vssd1 vccd1 vccd1 sky130_fd_sc_hd__fill_8
XFILLER_46_50 vssd1 vssd1 vccd1 vccd1 sky130_fd_sc_hd__fill_4
XFILLER_7_11 vssd1 vccd1 vssd1 vccd1 sky130_ef_sc_hd__decap_40_12
XFILLER_7_44 vssd1 vccd1 vssd1 vccd1 sky130_ef_sc_hd__decap_40_12
XANTENNA__1615__RESET_B fanout64/X vssd1 vssd1 vccd1 vccd1 sky130_fd_sc_hd__diode_2
XFILLER_7_99 vssd1 vccd1 vssd1 vccd1 sky130_ef_sc_hd__decap_40_12
XFILLER_38_234 vssd1 vssd1 vccd1 vccd1 sky130_fd_sc_hd__fill_4
X_1105_ _1076_/Y _1105_/B vssd1 vssd1 vccd1 vccd1 _1105_/X sky130_fd_sc_hd__and2b_2
XFILLER_21_156 vssd1 vssd1 vccd1 vccd1 sky130_fd_sc_hd__fill_2
X_1036_ _1408_/A _1095_/B vssd1 vssd1 vccd1 vccd1 _1036_/Y sky130_fd_sc_hd__nor2_2
XTAP_TAPCELL_ROW_16_181 vssd1 vccd1 sky130_fd_sc_hd__tapvpwrvgnd_1
XTAP_TAPCELL_ROW_39_295 vssd1 vccd1 sky130_fd_sc_hd__tapvpwrvgnd_1
XFILLER_12_178 vssd1 vssd1 vccd1 vccd1 sky130_fd_sc_hd__fill_1
XFILLER_32_74 vssd1 vssd1 vccd1 vccd1 sky130_fd_sc_hd__fill_1
XFILLER_32_85 vssd1 vssd1 vccd1 vccd1 sky130_fd_sc_hd__fill_4
XFILLER_8_138 vssd1 vssd1 vccd1 vccd1 sky130_fd_sc_hd__fill_2
XFILLER_7_171 vssd1 vssd1 vccd1 vccd1 sky130_fd_sc_hd__fill_1
X_1654_ clkload7/A _1654_/D fanout61/X vssd1 vssd1 vccd1 vccd1 _1654_/Q sky130_fd_sc_hd__dfrtp_2
X_1585_ clkload4/A input5/X load_slew60/X vssd1 vssd1 vccd1 vccd1 _1585_/Q sky130_fd_sc_hd__dfrtp_2
X_1019_ _1018_/Y _1052_/A vssd1 vssd1 vccd1 vccd1 _1020_/B sky130_fd_sc_hd__and2b_2
XFILLER_34_292 vssd1 vssd1 vccd1 vccd1 sky130_fd_sc_hd__fill_4
Xrebuffer224 _1472_/X vssd1 vssd1 vccd1 vccd1 _1479_/C sky130_fd_sc_hd__buf_2
Xrebuffer202 _1138_/X vssd1 vssd1 vccd1 vccd1 _1140_/B1 sky130_fd_sc_hd__buf_2
XANTENNA__1254__B _1265_/B vssd1 vssd1 vccd1 vccd1 sky130_fd_sc_hd__diode_2
XFILLER_17_259 vssd1 vssd1 vccd1 vccd1 sky130_fd_sc_hd__fill_2
XFILLER_25_292 vssd1 vssd1 vccd1 vccd1 sky130_fd_sc_hd__fill_4
XFILLER_40_251 vssd1 vssd1 vccd1 vccd1 sky130_fd_sc_hd__fill_1
XFILLER_4_130 vssd1 vssd1 vccd1 vccd1 sky130_fd_sc_hd__fill_2
XFILLER_4_141 vssd1 vssd1 vccd1 vccd1 sky130_fd_sc_hd__fill_2
X_1370_ _1376_/B _1369_/Y _0892_/A vssd1 vssd1 vccd1 vccd1 _1370_/Y sky130_fd_sc_hd__o21ai_2
XTAP_TAPCELL_ROW_33_268 vssd1 vccd1 sky130_fd_sc_hd__tapvpwrvgnd_1
X_1637_ _1641_/CLK _1637_/D vssd1 vssd1 vccd1 vccd1 _1637_/Q sky130_fd_sc_hd__dfxtp_2
X_1568_ _1645_/Q _1569_/C _1646_/Q vssd1 vssd1 vccd1 vccd1 _1571_/B sky130_fd_sc_hd__a21o_2
X_1499_ _1499_/A _1499_/B vssd1 vssd1 vccd1 vccd1 _1499_/Y sky130_fd_sc_hd__nand2_2
Xfanout22 _1191_/X vssd1 vssd1 vccd1 vccd1 _1210_/A2 sky130_fd_sc_hd__buf_8
Xfanout33 _0892_/A vssd1 vssd1 vccd1 vccd1 _1480_/B sky130_fd_sc_hd__clkdlybuf4s25_1
Xfanout44 _1515_/A1 vssd1 vssd1 vccd1 vccd1 _0805_/A sky130_fd_sc_hd__clkdlybuf4s25_1
XANTENNA__1265__A _1376_/A vssd1 vssd1 vccd1 vccd1 sky130_fd_sc_hd__diode_2
XFILLER_1_177 vssd1 vssd1 vccd1 vccd1 sky130_fd_sc_hd__fill_1
XFILLER_13_284 vssd1 vssd1 vccd1 vccd1 sky130_fd_sc_hd__fill_4
X_0870_ _1368_/C _0870_/B vssd1 vssd1 vccd1 vccd1 _0870_/Y sky130_fd_sc_hd__nand2_2
XTAP_TAPCELL_ROW_30_249 vssd1 vccd1 sky130_fd_sc_hd__tapvpwrvgnd_1
X_1422_ _1422_/A _1606_/Q _1422_/C vssd1 vssd1 vccd1 vccd1 _1436_/C sky130_fd_sc_hd__and3_2
X_1353_ _1353_/A _1406_/A vssd1 vssd1 vccd1 vccd1 _1412_/A sky130_fd_sc_hd__nor2_4
X_1284_ _1315_/A _1316_/A vssd1 vssd1 vccd1 vccd1 _1309_/A sky130_fd_sc_hd__nand2_2
Xclkload8 clkload8/A vssd1 vssd1 vccd1 vccd1 clkload8/X sky130_fd_sc_hd__clkbuf_4
X_0999_ _0995_/Y _1008_/B _1028_/A vssd1 vssd1 vccd1 vccd1 _0999_/X sky130_fd_sc_hd__a21o_2
XTAP_TAPCELL_ROW_21_205 vssd1 vccd1 sky130_fd_sc_hd__tapvpwrvgnd_1
XTAP_TAPCELL_ROW_44_319 vssd1 vccd1 sky130_fd_sc_hd__tapvpwrvgnd_1
XFILLER_10_298 vssd1 vssd1 vccd1 vccd1 sky130_fd_sc_hd__fill_1
XFILLER_40_74 vssd1 vssd1 vccd1 vccd1 sky130_fd_sc_hd__fill_8
XFILLER_40_85 vssd1 vssd1 vccd1 vccd1 sky130_fd_sc_hd__fill_4
XFILLER_40_96 vssd1 vssd1 vccd1 vccd1 sky130_fd_sc_hd__fill_4
XFILLER_6_203 vssd1 vssd1 vccd1 vccd1 sky130_fd_sc_hd__fill_4
XFILLER_6_225 vssd1 vssd1 vccd1 vccd1 sky130_fd_sc_hd__fill_8
XFILLER_1_35 vssd1 vssd1 vccd1 vccd1 sky130_fd_sc_hd__fill_4
XFILLER_1_57 vssd1 vssd1 vccd1 vccd1 sky130_fd_sc_hd__fill_4
XFILLER_1_79 vssd1 vssd1 vccd1 vccd1 sky130_fd_sc_hd__fill_4
X_0922_ _1613_/Q _0922_/B vssd1 vssd1 vccd1 vccd1 _0926_/B sky130_fd_sc_hd__xnor2_2
X_0853_ _0834_/B _0827_/C _1534_/A vssd1 vssd1 vccd1 vccd1 _0853_/Y sky130_fd_sc_hd__o21ai_2
X_1405_ _1405_/A1 _1412_/B _1406_/A vssd1 vssd1 vccd1 vccd1 _1407_/B sky130_fd_sc_hd__a21boi_2
XFILLER_28_129 vssd1 vssd1 vccd1 vccd1 sky130_fd_sc_hd__fill_2
XFILLER_36_151 vssd1 vssd1 vccd1 vccd1 sky130_fd_sc_hd__fill_2
Xinput1 en vssd1 vssd1 vccd1 vccd1 input1/X sky130_fd_sc_hd__clkdlybuf4s25_1
X_1336_ _1336_/A _1336_/B vssd1 vssd1 vccd1 vccd1 _1352_/B sky130_fd_sc_hd__nand2_2
X_1267_ _1267_/A _1267_/B vssd1 vssd1 vccd1 vccd1 _1347_/B sky130_fd_sc_hd__xnor2_2
X_1198_ _1224_/B _1198_/B vssd1 vssd1 vccd1 vccd1 _1298_/A sky130_fd_sc_hd__and2_2
XANTENNA__1483__B1 _0893_/C vssd1 vssd1 vccd1 vccd1 sky130_fd_sc_hd__diode_2
XFILLER_35_85 vssd1 vssd1 vccd1 vccd1 sky130_fd_sc_hd__fill_2
XFILLER_35_96 vssd1 vssd1 vccd1 vccd1 sky130_fd_sc_hd__fill_2
XTAP_TAPCELL_ROW_40_300 vssd1 vccd1 sky130_fd_sc_hd__tapvpwrvgnd_1
X_1121_ _1122_/A _1122_/B vssd1 vssd1 vccd1 vccd1 _1126_/B sky130_fd_sc_hd__nand2_2
X_1052_ _1052_/A _1052_/B vssd1 vssd1 vccd1 vccd1 _1056_/B sky130_fd_sc_hd__xor2_2
XFILLER_18_173 vssd1 vssd1 vccd1 vccd1 sky130_fd_sc_hd__fill_1
XFILLER_33_143 vssd1 vssd1 vccd1 vccd1 sky130_fd_sc_hd__fill_2
X_0905_ _1490_/A _1617_/Q _1618_/Q _1619_/Q _1620_/Q vssd1 vssd1 vccd1 vccd1 _0905_/X
+ sky130_fd_sc_hd__o311a_2
X_0836_ _0836_/A _1630_/Q vssd1 vssd1 vccd1 vccd1 _0836_/X sky130_fd_sc_hd__or2_2
X_1319_ _1331_/A _1331_/B vssd1 vssd1 vccd1 vccd1 _1319_/Y sky130_fd_sc_hd__nand2b_2
XFILLER_15_110 vssd1 vssd1 vccd1 vccd1 sky130_fd_sc_hd__fill_2
XFILLER_15_132 vssd1 vssd1 vccd1 vccd1 sky130_fd_sc_hd__fill_1
XFILLER_15_198 vssd1 vssd1 vccd1 vccd1 sky130_fd_sc_hd__fill_2
XFILLER_46_73 vssd1 vssd1 vccd1 vccd1 sky130_fd_sc_hd__fill_8
Xmax_cap41 _0889_/Y vssd1 vssd1 vccd1 vccd1 _0890_/A sky130_fd_sc_hd__buf_4
XFILLER_7_23 vssd1 vssd1 vccd1 vccd1 sky130_fd_sc_hd__fill_2
Xclone185 _1191_/X vssd1 vssd1 vccd1 vccd1 _1192_/B sky130_fd_sc_hd__clkbuf_2
X_1104_ _1104_/A _1104_/B _1150_/B vssd1 vssd1 vccd1 vccd1 _1139_/C sky130_fd_sc_hd__nor3b_2
X_1035_ _1042_/B _1037_/C vssd1 vssd1 vccd1 vccd1 _1095_/B sky130_fd_sc_hd__or2_2
XFILLER_21_113 vssd1 vssd1 vccd1 vccd1 sky130_fd_sc_hd__fill_2
XTAP_TAPCELL_ROW_16_182 vssd1 vccd1 sky130_fd_sc_hd__tapvpwrvgnd_1
X_0819_ _1534_/A _1632_/Q _0827_/C _0818_/X _1717_/A vssd1 vssd1 vccd1 vccd1 _0819_/X
+ sky130_fd_sc_hd__o311a_2
XTAP_TAPCELL_ROW_8_139 vssd1 vccd1 sky130_fd_sc_hd__tapvpwrvgnd_1
XFILLER_44_216 vssd1 vssd1 vccd1 vccd1 sky130_fd_sc_hd__fill_1
XFILLER_44_238 vssd1 vssd1 vccd1 vccd1 sky130_fd_sc_hd__fill_1
XTAP_TAPCELL_ROW_39_296 vssd1 vccd1 sky130_fd_sc_hd__tapvpwrvgnd_1
XFILLER_35_205 vssd1 vssd1 vccd1 vccd1 sky130_fd_sc_hd__fill_1
XFILLER_7_183 vssd1 vssd1 vccd1 vccd1 sky130_fd_sc_hd__fill_2
X_1584_ clkload1/A _1584_/D load_slew60/X vssd1 vssd1 vccd1 vccd1 _1584_/Q sky130_fd_sc_hd__dfrtp_2
X_1653_ clkload5/A _1653_/D _1653_/SET_B vssd1 vssd1 vccd1 vccd1 _1653_/Q sky130_fd_sc_hd__dfstp_2
XPHY_EDGE_ROW_9_Right_9 vssd1 vssd1 vccd1 vccd1 sky130_fd_sc_hd__decap_3
Xteam_04 vssd1 vssd1 vccd1 vccd1 team_04/HI gpio_oeb[4] sky130_fd_sc_hd__conb_1
X_1018_ _1021_/B _1018_/B vssd1 vssd1 vccd1 vccd1 _1018_/Y sky130_fd_sc_hd__nand2_2
XFILLER_5_109 vssd1 vssd1 vccd1 vccd1 sky130_fd_sc_hd__fill_2
Xrebuffer203 _1176_/X vssd1 vssd1 vccd1 vccd1 _1178_/A sky130_fd_sc_hd__buf_2
XTAP_TAPCELL_ROW_4_120 vssd1 vccd1 sky130_fd_sc_hd__tapvpwrvgnd_1
XANTENNA__1642__CLK clkload8/A vssd1 vssd1 vccd1 vccd1 sky130_fd_sc_hd__diode_2
XFILLER_40_241 vssd1 vssd1 vccd1 vccd1 sky130_fd_sc_hd__fill_8
XFILLER_4_13 vssd1 vssd1 vccd1 vccd1 sky130_fd_sc_hd__fill_2
XFILLER_4_197 vssd1 vssd1 vccd1 vccd1 sky130_fd_sc_hd__fill_4
XFILLER_31_296 vssd1 vssd1 vccd1 vccd1 sky130_fd_sc_hd__fill_2
X_1567_ hold258/X _1569_/C _1566_/Y vssd1 vssd1 vccd1 vccd1 _1645_/D sky130_fd_sc_hd__o21a_2
X_1636_ _1641_/CLK _1636_/D vssd1 vssd1 vccd1 vccd1 _1636_/Q sky130_fd_sc_hd__dfxtp_2
XPHY_EDGE_ROW_18_Left_65 vssd1 vssd1 vccd1 vccd1 sky130_fd_sc_hd__decap_3
X_1498_ _1510_/B vssd1 vssd1 vccd1 vccd1 _1498_/Y sky130_fd_sc_hd__inv_2
Xfanout23 _1248_/A vssd1 vssd1 vccd1 vccd1 _1192_/A sky130_fd_sc_hd__clkdlybuf4s25_1
Xfanout34 _0891_/X vssd1 vssd1 vccd1 vccd1 _0892_/A sky130_fd_sc_hd__clkdlybuf4s25_1
Xfanout45 _1656_/Q vssd1 vssd1 vccd1 vccd1 _1515_/A1 sky130_fd_sc_hd__clkdlybuf4s25_1
Xfanout56 fanout57/X vssd1 vssd1 vccd1 vccd1 fanout56/X sky130_fd_sc_hd__clkdlybuf4s25_1
XFILLER_13_55 vssd1 vssd1 vccd1 vccd1 sky130_fd_sc_hd__fill_1
XANTENNA__1265__B _1265_/B vssd1 vssd1 vccd1 vccd1 sky130_fd_sc_hd__diode_2
XFILLER_38_85 vssd1 vssd1 vccd1 vccd1 sky130_fd_sc_hd__fill_4
XFILLER_9_223 vssd1 vssd1 vccd1 vccd1 sky130_fd_sc_hd__fill_1
XFILLER_9_201 vssd1 vssd1 vccd1 vccd1 sky130_fd_sc_hd__fill_2
X_1421_ _1416_/A _1422_/C _1422_/A vssd1 vssd1 vccd1 vccd1 _1421_/Y sky130_fd_sc_hd__a21oi_2
X_1352_ _1352_/A _1352_/B vssd1 vssd1 vccd1 vccd1 _1406_/A sky130_fd_sc_hd__xnor2_2
X_1283_ _1282_/B _1265_/B _1260_/B _1282_/X vssd1 vssd1 vccd1 vccd1 _1316_/A sky130_fd_sc_hd__o22a_2
XTAP_TAPCELL_ROW_21_206 vssd1 vccd1 sky130_fd_sc_hd__tapvpwrvgnd_1
Xclkload9 clkload9/A vssd1 vssd1 vccd1 vccd1 clkload9/X sky130_fd_sc_hd__clkbuf_4
X_0998_ _1008_/B vssd1 vssd1 vccd1 vccd1 _1029_/A sky130_fd_sc_hd__inv_2
XANTENNA_input2_A gpio_in[0] vssd1 vssd1 vccd1 vccd1 sky130_fd_sc_hd__diode_2
X_1619_ clkload7/A _1619_/D fanout61/X vssd1 vssd1 vccd1 vccd1 _1619_/Q sky130_fd_sc_hd__dfrtp_2
XFILLER_39_182 vssd1 vssd1 vccd1 vccd1 sky130_fd_sc_hd__fill_2
XFILLER_10_255 vssd1 vssd1 vccd1 vccd1 sky130_fd_sc_hd__fill_4
XFILLER_24_54 vssd1 vssd1 vccd1 vccd1 sky130_fd_sc_hd__fill_1
XFILLER_6_248 vssd1 vssd1 vccd1 vccd1 sky130_fd_sc_hd__fill_1
X_0921_ _0922_/B _0858_/Y _0920_/X _1614_/Q vssd1 vssd1 vccd1 vccd1 _0941_/B sky130_fd_sc_hd__a22oi_2
XANTENNA__1609__RESET_B fanout64/X vssd1 vssd1 vccd1 vccd1 sky130_fd_sc_hd__diode_2
X_0852_ _1716_/A _0841_/X _0851_/Y _0847_/X _0846_/Y vssd1 vssd1 vccd1 vccd1 _0852_/X
+ sky130_fd_sc_hd__a32o_2
XFILLER_5_281 vssd1 vccd1 vssd1 vccd1 sky130_ef_sc_hd__decap_40_12
X_1404_ _1404_/A _1404_/B vssd1 vssd1 vccd1 vccd1 _1412_/B sky130_fd_sc_hd__or2_2
X_1335_ _1335_/A _1351_/A vssd1 vssd1 vccd1 vccd1 _1355_/A sky130_fd_sc_hd__xor2_2
Xinput2 gpio_in[0] vssd1 vssd1 vccd1 vccd1 input2/X sky130_fd_sc_hd__clkdlybuf4s25_1
X_1266_ _1266_/A _1600_/Q vssd1 vssd1 vccd1 vccd1 _1266_/X sky130_fd_sc_hd__or2_4
X_1197_ _1199_/A _1199_/B vssd1 vssd1 vccd1 vccd1 _1198_/B sky130_fd_sc_hd__nand2_2
XFILLER_19_32 vssd1 vssd1 vccd1 vccd1 sky130_fd_sc_hd__fill_2
XFILLER_19_76 vssd1 vssd1 vccd1 vccd1 sky130_fd_sc_hd__fill_1
XFILLER_27_174 vssd1 vccd1 vssd1 vccd1 sky130_ef_sc_hd__decap_40_12
XFILLER_35_42 vssd1 vssd1 vccd1 vccd1 sky130_fd_sc_hd__fill_1
XFILLER_42_166 vssd1 vssd1 vccd1 vccd1 sky130_fd_sc_hd__fill_4
XTAP_TAPCELL_ROW_40_301 vssd1 vccd1 sky130_fd_sc_hd__tapvpwrvgnd_1
XFILLER_18_141 vssd1 vssd1 vccd1 vccd1 sky130_fd_sc_hd__fill_8
X_1120_ _1124_/A _1124_/B _1106_/B vssd1 vssd1 vccd1 vccd1 _1122_/B sky130_fd_sc_hd__o21a_2
X_1051_ _0974_/Y _1020_/X _1050_/Y _1018_/Y vssd1 vssd1 vccd1 vccd1 _1108_/S sky130_fd_sc_hd__a22o_2
X_0904_ _0904_/A1 _1607_/Q _1609_/Q _1610_/Q vssd1 vssd1 vccd1 vccd1 _0904_/X sky130_fd_sc_hd__o211a_4
X_0835_ _1716_/A _0821_/Y _0830_/C _0834_/X vssd1 vssd1 vccd1 vccd1 _0835_/X sky130_fd_sc_hd__a31o_2
X_1318_ _1318_/A _1318_/B _1336_/B vssd1 vssd1 vccd1 vccd1 _1325_/A sky130_fd_sc_hd__and3_2
XFILLER_24_111 vssd1 vccd1 vssd1 vccd1 sky130_ef_sc_hd__decap_40_12
XFILLER_24_133 vssd1 vssd1 vccd1 vccd1 sky130_fd_sc_hd__fill_4
X_1249_ _1190_/A _1248_/Y _1249_/B1 vssd1 vssd1 vccd1 vccd1 _1249_/Y sky130_fd_sc_hd__o21ai_2
XFILLER_21_55 vssd1 vssd1 vccd1 vccd1 sky130_fd_sc_hd__fill_1
XFILLER_46_85 vssd1 vssd1 vccd1 vccd1 sky130_fd_sc_hd__fill_4
XPHY_EDGE_ROW_6_Left_53 vssd1 vssd1 vccd1 vccd1 sky130_fd_sc_hd__decap_3
XFILLER_30_169 vssd1 vssd1 vccd1 vccd1 sky130_fd_sc_hd__fill_4
XFILLER_7_57 vssd1 vssd1 vccd1 vccd1 sky130_fd_sc_hd__fill_1
X_1103_ _1104_/A _1104_/B vssd1 vssd1 vccd1 vccd1 _1157_/B sky130_fd_sc_hd__or2_2
X_1034_ _1605_/Q _1034_/B _1034_/C vssd1 vssd1 vccd1 vccd1 _1037_/C sky130_fd_sc_hd__and3_2
XANTENNA_clkbuf_4_8_0_clk_A clkbuf_0_clk/X vssd1 vssd1 vccd1 vccd1 sky130_fd_sc_hd__diode_2
XFILLER_21_169 vssd1 vssd1 vccd1 vccd1 sky130_fd_sc_hd__fill_4
XTAP_TAPCELL_ROW_16_183 vssd1 vccd1 sky130_fd_sc_hd__tapvpwrvgnd_1
X_0818_ _1534_/A _0834_/B _1635_/Q _1634_/Q vssd1 vssd1 vccd1 vccd1 _0818_/X sky130_fd_sc_hd__or4_2
XFILLER_16_11 vssd1 vssd1 vccd1 vccd1 sky130_fd_sc_hd__fill_1
XTAP_TAPCELL_ROW_39_297 vssd1 vccd1 sky130_fd_sc_hd__tapvpwrvgnd_1
XPHY_EDGE_ROW_32_Left_79 vssd1 vssd1 vccd1 vccd1 sky130_fd_sc_hd__decap_3
XTAP_TAPCELL_ROW_13_164 vssd1 vccd1 sky130_fd_sc_hd__tapvpwrvgnd_1
X_1583_ clkload1/A _1583_/D _1653_/SET_B vssd1 vssd1 vccd1 vccd1 _1583_/Q sky130_fd_sc_hd__dfrtp_2
X_1652_ _1652_/CLK _1652_/D vssd1 vssd1 vccd1 vccd1 _1717_/A sky130_fd_sc_hd__dfxtp_2
X_1017_ _1016_/B _1016_/C _1016_/A vssd1 vssd1 vccd1 vccd1 _1018_/B sky130_fd_sc_hd__o21ai_2
Xrebuffer204 _1266_/A vssd1 vssd1 vccd1 vccd1 _1341_/B sky130_fd_sc_hd__buf_2
XTAP_TAPCELL_ROW_4_121 vssd1 vccd1 sky130_fd_sc_hd__tapvpwrvgnd_1
XTAP_TAPCELL_ROW_27_234 vssd1 vccd1 sky130_fd_sc_hd__tapvpwrvgnd_1
XFILLER_40_253 vssd1 vssd1 vccd1 vccd1 sky130_fd_sc_hd__fill_4
XFILLER_4_25 vssd1 vssd1 vccd1 vccd1 sky130_fd_sc_hd__fill_2
X_1566_ hold258/X _1569_/C _1582_/B vssd1 vssd1 vccd1 vccd1 _1566_/Y sky130_fd_sc_hd__a21boi_2
X_1635_ clkload9/A _1635_/D fanout54/X vssd1 vssd1 vccd1 vccd1 _1635_/Q sky130_fd_sc_hd__dfrtp_2
X_1497_ _1499_/A _1499_/B vssd1 vssd1 vccd1 vccd1 _1510_/B sky130_fd_sc_hd__nor2_2
XFILLER_22_253 vssd1 vccd1 vssd1 vccd1 sky130_ef_sc_hd__decap_40_12
Xfanout35 _0891_/X vssd1 vssd1 vccd1 vccd1 _0893_/C sky130_fd_sc_hd__clkdlybuf4s25_1
Xfanout46 _1633_/Q vssd1 vssd1 vccd1 vccd1 _1534_/A sky130_fd_sc_hd__clkdlybuf4s25_1
Xfanout57 _0800_/X vssd1 vssd1 vccd1 vccd1 fanout57/X sky130_fd_sc_hd__clkdlybuf4s25_1
XFILLER_13_78 vssd1 vccd1 vssd1 vccd1 sky130_ef_sc_hd__decap_40_12
XFILLER_1_146 vssd1 vssd1 vccd1 vccd1 sky130_fd_sc_hd__fill_2
XFILLER_13_297 vssd1 vssd1 vccd1 vccd1 sky130_fd_sc_hd__fill_2
XPHY_EDGE_ROW_35_Left_82 vssd1 vssd1 vccd1 vccd1 sky130_fd_sc_hd__decap_3
X_1420_ _1355_/A _1420_/A2 _1413_/A _0892_/A _1419_/Y vssd1 vssd1 vccd1 vccd1 _1420_/X
+ sky130_fd_sc_hd__a311o_2
X_1351_ _1351_/A _1351_/B vssd1 vssd1 vccd1 vccd1 _1353_/A sky130_fd_sc_hd__or2_2
X_1282_ _1282_/A _1282_/B vssd1 vssd1 vccd1 vccd1 _1282_/X sky130_fd_sc_hd__and2_2
XANTENNA__1262__A2 _1265_/B vssd1 vssd1 vccd1 vccd1 sky130_fd_sc_hd__diode_2
XTAP_TAPCELL_ROW_21_207 vssd1 vccd1 sky130_fd_sc_hd__tapvpwrvgnd_1
X_1618_ clkload6/A _1618_/D fanout61/X vssd1 vssd1 vccd1 vccd1 _1618_/Q sky130_fd_sc_hd__dfrtp_2
X_0997_ _0968_/B _0996_/X _0942_/A _0972_/A vssd1 vssd1 vccd1 vccd1 _1008_/B sky130_fd_sc_hd__o2bb2a_2
XFILLER_46_109 vssd1 vssd1 vccd1 vccd1 sky130_fd_sc_hd__fill_2
X_1549_ _1558_/D _1549_/B vssd1 vssd1 vccd1 vccd1 _1639_/D sky130_fd_sc_hd__nor2_2
XFILLER_6_238 vssd1 vssd1 vccd1 vccd1 sky130_fd_sc_hd__fill_8
X_0920_ _0920_/A1 _0912_/B _0907_/X _1613_/Q vssd1 vssd1 vccd1 vccd1 _0920_/X sky130_fd_sc_hd__a211o_2
X_0851_ _1630_/Q _0848_/Y _1631_/Q vssd1 vssd1 vccd1 vccd1 _0851_/Y sky130_fd_sc_hd__a21oi_2
X_1403_ _1408_/A _1463_/B2 _1462_/B1 _1402_/X vssd1 vssd1 vccd1 vccd1 _1604_/D sky130_fd_sc_hd__a22o_2
X_1334_ _1334_/A _1334_/B _1336_/B vssd1 vssd1 vccd1 vccd1 _1351_/A sky130_fd_sc_hd__and3_2
X_1265_ _1376_/A _1265_/B vssd1 vssd1 vccd1 vccd1 _1266_/A sky130_fd_sc_hd__xor2_2
XPHY_EDGE_ROW_18_Right_18 vssd1 vssd1 vccd1 vccd1 sky130_fd_sc_hd__decap_3
Xinput3 gpio_in[1] vssd1 vssd1 vccd1 vccd1 input3/X sky130_fd_sc_hd__clkdlybuf4s25_1
X_1196_ _1210_/A2 _1192_/A _1194_/X _1149_/B vssd1 vssd1 vccd1 vccd1 _1224_/B sky130_fd_sc_hd__a211o_4
XPHY_EDGE_ROW_27_Right_27 vssd1 vssd1 vccd1 vccd1 sky130_fd_sc_hd__decap_3
XFILLER_10_79 vssd1 vssd1 vccd1 vccd1 sky130_fd_sc_hd__fill_4
XPHY_EDGE_ROW_36_Right_36 vssd1 vssd1 vccd1 vccd1 sky130_fd_sc_hd__decap_3
XFILLER_19_66 vssd1 vssd1 vccd1 vccd1 sky130_fd_sc_hd__fill_2
XFILLER_27_131 vssd1 vssd1 vccd1 vccd1 sky130_fd_sc_hd__fill_8
XFILLER_27_186 vssd1 vssd1 vccd1 vccd1 sky130_fd_sc_hd__fill_4
XFILLER_42_101 vssd1 vssd1 vccd1 vccd1 sky130_fd_sc_hd__fill_4
XTAP_TAPCELL_ROW_40_302 vssd1 vccd1 sky130_fd_sc_hd__tapvpwrvgnd_1
XPHY_EDGE_ROW_45_Right_45 vssd1 vssd1 vccd1 vccd1 sky130_fd_sc_hd__decap_3
XFILLER_18_197 vssd1 vccd1 vssd1 vccd1 sky130_ef_sc_hd__decap_40_12
X_1050_ _1052_/A _1052_/B vssd1 vssd1 vccd1 vccd1 _1050_/Y sky130_fd_sc_hd__nand2_2
X_0903_ _1422_/A _1429_/A vssd1 vssd1 vccd1 vccd1 _0903_/Y sky130_fd_sc_hd__nor2_2
X_0834_ _0833_/X _0834_/B _1717_/A vssd1 vssd1 vccd1 vccd1 _0834_/X sky130_fd_sc_hd__and3b_2
XANTENNA_clkbuf_4_4_0_clk_A clkbuf_0_clk/X vssd1 vssd1 vccd1 vccd1 sky130_fd_sc_hd__diode_2
X_1317_ _1439_/A _1439_/B _1317_/C _1426_/A vssd1 vssd1 vccd1 vccd1 _1441_/A sky130_fd_sc_hd__and4_2
X_1248_ _1248_/A _1248_/B vssd1 vssd1 vccd1 vccd1 _1248_/Y sky130_fd_sc_hd__nor2_2
XFILLER_24_123 vssd1 vssd1 vccd1 vccd1 sky130_fd_sc_hd__fill_2
X_1179_ _1092_/Y _1176_/B _1175_/X _1093_/B vssd1 vssd1 vccd1 vccd1 _1205_/B sky130_fd_sc_hd__o22ai_2
X_1102_ _1102_/A _1102_/B vssd1 vssd1 vccd1 vccd1 _1104_/B sky130_fd_sc_hd__nor2_2
XFILLER_46_281 vssd1 vssd1 vccd1 vccd1 sky130_fd_sc_hd__fill_4
X_1033_ _1034_/B _1034_/C _1605_/Q vssd1 vssd1 vccd1 vccd1 _1042_/B sky130_fd_sc_hd__a21oi_4
X_0817_ _1540_/A _1634_/Q vssd1 vssd1 vccd1 vccd1 _0827_/C sky130_fd_sc_hd__nand2_2
XFILLER_29_204 vssd1 vssd1 vccd1 vccd1 sky130_fd_sc_hd__fill_4
XFILLER_44_229 vssd1 vssd1 vccd1 vccd1 sky130_fd_sc_hd__fill_1
XTAP_TAPCELL_ROW_39_298 vssd1 vccd1 sky130_fd_sc_hd__tapvpwrvgnd_1
XPHY_EDGE_ROW_0_Right_0 vssd1 vssd1 vccd1 vccd1 sky130_fd_sc_hd__decap_3
XFILLER_43_295 vssd1 vssd1 vccd1 vccd1 sky130_fd_sc_hd__fill_1
X_1651_ _1652_/CLK _1651_/D vssd1 vssd1 vccd1 vccd1 _1651_/Q sky130_fd_sc_hd__dfxtp_2
XTAP_TAPCELL_ROW_13_165 vssd1 vccd1 sky130_fd_sc_hd__tapvpwrvgnd_1
XFILLER_7_185 vssd1 vssd1 vccd1 vccd1 sky130_fd_sc_hd__fill_1
X_1582_ _1717_/A _1582_/B vssd1 vssd1 vccd1 vccd1 _1652_/D sky130_fd_sc_hd__xnor2_2
XFILLER_34_251 vssd1 vssd1 vccd1 vccd1 sky130_fd_sc_hd__fill_1
Xrebuffer205 _1280_/A vssd1 vssd1 vccd1 vccd1 _1335_/A sky130_fd_sc_hd__buf_2
X_1016_ _1016_/A _1016_/B _1016_/C vssd1 vssd1 vccd1 vccd1 _1021_/B sky130_fd_sc_hd__or3_4
XTAP_TAPCELL_ROW_36_279 vssd1 vccd1 sky130_fd_sc_hd__tapvpwrvgnd_1
XTAP_TAPCELL_ROW_4_122 vssd1 vccd1 sky130_fd_sc_hd__tapvpwrvgnd_1
XFILLER_17_229 vssd1 vssd1 vccd1 vccd1 sky130_fd_sc_hd__fill_4
XFILLER_27_88 vssd1 vssd1 vccd1 vccd1 sky130_fd_sc_hd__fill_2
XTAP_TAPCELL_ROW_27_235 vssd1 vccd1 sky130_fd_sc_hd__tapvpwrvgnd_1
XFILLER_40_298 vssd1 vssd1 vccd1 vccd1 sky130_fd_sc_hd__fill_1
XANTENNA_clkbuf_4_12_0_clk_A clkbuf_0_clk/X vssd1 vssd1 vccd1 vccd1 sky130_fd_sc_hd__diode_2
XFILLER_4_59 vssd1 vccd1 vssd1 vccd1 sky130_ef_sc_hd__decap_40_12
XFILLER_31_298 vssd1 vssd1 vccd1 vccd1 sky130_fd_sc_hd__fill_1
X_1634_ clkload9/A _1634_/D fanout54/X vssd1 vssd1 vccd1 vccd1 _1634_/Q sky130_fd_sc_hd__dfrtp_2
X_1565_ _1582_/B _1565_/B _1565_/C vssd1 vssd1 vccd1 vccd1 _1644_/D sky130_fd_sc_hd__and3_2
X_1496_ _1619_/Q _1494_/B _1495_/X vssd1 vssd1 vccd1 vccd1 _1619_/D sky130_fd_sc_hd__o21a_2
XFILLER_22_265 vssd1 vssd1 vccd1 vccd1 sky130_fd_sc_hd__fill_2
XFILLER_22_298 vssd1 vssd1 vccd1 vccd1 sky130_fd_sc_hd__fill_1
Xfanout36 _0875_/Y vssd1 vssd1 vccd1 vccd1 _1462_/B1 sky130_fd_sc_hd__clkdlybuf4s25_1
Xfanout47 _1628_/Q vssd1 vssd1 vccd1 vccd1 _1520_/A sky130_fd_sc_hd__clkdlybuf4s25_1
XTAP_TAPCELL_ROW_32_260 vssd1 vccd1 sky130_fd_sc_hd__tapvpwrvgnd_1
X_1350_ _1334_/A _1347_/C _1334_/B vssd1 vssd1 vccd1 vccd1 _1351_/B sky130_fd_sc_hd__a21oi_2
X_1281_ _1271_/X _1352_/A _1280_/Y vssd1 vssd1 vccd1 vccd1 _1281_/X sky130_fd_sc_hd__a21o_4
XTAP_TAPCELL_ROW_46_330 vssd1 vccd1 sky130_fd_sc_hd__tapvpwrvgnd_1
X_0996_ _0996_/A _0996_/B vssd1 vssd1 vccd1 vccd1 _0996_/X sky130_fd_sc_hd__or2_2
XTAP_TAPCELL_ROW_21_208 vssd1 vccd1 sky130_fd_sc_hd__tapvpwrvgnd_1
X_1617_ clkload4/A _1617_/D fanout63/X vssd1 vssd1 vccd1 vccd1 _1617_/Q sky130_fd_sc_hd__dfrtp_2
XFILLER_8_291 vssd1 vssd1 vccd1 vccd1 sky130_fd_sc_hd__fill_8
X_1548_ _1548_/A _1548_/B vssd1 vssd1 vccd1 vccd1 _1549_/B sky130_fd_sc_hd__nor2_2
X_1479_ _1479_/A _1479_/B _1479_/C vssd1 vssd1 vccd1 vccd1 _1479_/X sky130_fd_sc_hd__or3_4
XANTENNA__1410__B1 _0893_/C vssd1 vssd1 vccd1 vccd1 sky130_fd_sc_hd__diode_2
XFILLER_40_22 vssd1 vssd1 vccd1 vccd1 sky130_fd_sc_hd__fill_1
XFILLER_1_49 vssd1 vssd1 vccd1 vccd1 sky130_fd_sc_hd__fill_4
X_0850_ _0850_/A vssd1 vssd1 vccd1 vccd1 _0850_/Y sky130_fd_sc_hd__inv_2
X_1402_ _1398_/X _1397_/Y _1401_/Y _1378_/B vssd1 vssd1 vccd1 vccd1 _1402_/X sky130_fd_sc_hd__o22a_2
Xinput4 gpio_in[2] vssd1 vssd1 vccd1 vccd1 input4/X sky130_fd_sc_hd__clkdlybuf4s25_1
X_1333_ _1441_/A _1323_/Y _1330_/Y _1332_/X vssd1 vssd1 vccd1 vccd1 _1426_/B sky130_fd_sc_hd__o211ai_2
X_1264_ _1601_/Q _1265_/B vssd1 vssd1 vccd1 vccd1 _1267_/B sky130_fd_sc_hd__nand2b_2
X_1195_ _1192_/A _1210_/A2 _1194_/X vssd1 vssd1 vccd1 vccd1 _1199_/B sky130_fd_sc_hd__a21o_2
XANTENNA_clkbuf_4_0_0_clk_A clkbuf_0_clk/X vssd1 vssd1 vccd1 vccd1 sky130_fd_sc_hd__diode_2
X_0979_ _1001_/A1 _1002_/C _0978_/X vssd1 vssd1 vccd1 vccd1 _0988_/A sky130_fd_sc_hd__a21oi_4
XFILLER_10_58 vssd1 vssd1 vccd1 vccd1 sky130_fd_sc_hd__fill_1
XFILLER_19_34 vssd1 vssd1 vccd1 vccd1 sky130_fd_sc_hd__fill_1
XFILLER_27_121 vssd1 vssd1 vccd1 vccd1 sky130_fd_sc_hd__fill_1
XFILLER_42_179 vssd1 vssd1 vccd1 vccd1 sky130_fd_sc_hd__fill_2
XTAP_TAPCELL_ROW_40_303 vssd1 vccd1 sky130_fd_sc_hd__tapvpwrvgnd_1
XFILLER_2_220 vssd1 vssd1 vccd1 vccd1 sky130_fd_sc_hd__fill_2
XFILLER_33_113 vssd1 vssd1 vccd1 vccd1 sky130_fd_sc_hd__fill_1
XFILLER_33_135 vssd1 vssd1 vccd1 vccd1 sky130_fd_sc_hd__fill_8
X_0902_ hold261/X _0900_/A _0901_/X vssd1 vssd1 vccd1 vccd1 _1598_/D sky130_fd_sc_hd__a21bo_2
X_0833_ _1635_/Q _1634_/Q _1534_/A vssd1 vssd1 vccd1 vccd1 _0833_/X sky130_fd_sc_hd__or3b_2
X_1316_ _1316_/A _1316_/B vssd1 vssd1 vccd1 vccd1 _1426_/A sky130_fd_sc_hd__xor2_2
X_1247_ _1244_/A _1244_/B _1246_/A vssd1 vssd1 vccd1 vccd1 _1247_/X sky130_fd_sc_hd__a21o_2
X_1178_ _1178_/A _1212_/A vssd1 vssd1 vccd1 vccd1 _1178_/Y sky130_fd_sc_hd__nor2_2
XFILLER_21_24 vssd1 vssd1 vccd1 vccd1 sky130_fd_sc_hd__fill_1
XFILLER_21_35 vssd1 vccd1 vssd1 vccd1 sky130_ef_sc_hd__decap_40_12
XFILLER_21_57 vssd1 vssd1 vccd1 vccd1 sky130_fd_sc_hd__fill_4
XFILLER_15_113 vssd1 vssd1 vccd1 vccd1 sky130_fd_sc_hd__fill_4
XFILLER_46_54 vssd1 vssd1 vccd1 vccd1 sky130_fd_sc_hd__fill_2
X_1101_ _1102_/B _1100_/Y _1100_/A _1082_/C vssd1 vssd1 vccd1 vccd1 _1150_/B sky130_fd_sc_hd__o2bb2a_2
X_1032_ _1032_/A _1032_/B vssd1 vssd1 vccd1 vccd1 _1100_/A sky130_fd_sc_hd__xnor2_2
X_0816_ _1653_/Q _0805_/B _0805_/C _0815_/X _0810_/A vssd1 vssd1 vccd1 vccd1 _1653_/D
+ sky130_fd_sc_hd__a32o_2
XFILLER_12_105 vssd1 vssd1 vccd1 vccd1 sky130_fd_sc_hd__fill_1
XFILLER_32_89 vssd1 vssd1 vccd1 vccd1 sky130_fd_sc_hd__fill_2
XFILLER_28_260 vssd1 vssd1 vccd1 vccd1 sky130_fd_sc_hd__fill_1
XFILLER_43_263 vssd1 vssd1 vccd1 vccd1 sky130_fd_sc_hd__fill_1
X_1581_ _1581_/A _1581_/B vssd1 vssd1 vccd1 vccd1 _1651_/D sky130_fd_sc_hd__xor2_2
X_1650_ _1652_/CLK _1650_/D vssd1 vssd1 vccd1 vccd1 _1650_/Q sky130_fd_sc_hd__dfxtp_2
XTAP_TAPCELL_ROW_13_166 vssd1 vccd1 sky130_fd_sc_hd__tapvpwrvgnd_1
XFILLER_34_230 vssd1 vssd1 vccd1 vccd1 sky130_fd_sc_hd__fill_2
X_1015_ _0972_/A _1016_/C _0975_/X _0984_/A vssd1 vssd1 vccd1 vccd1 _1052_/A sky130_fd_sc_hd__a22o_2
XFILLER_34_296 vssd1 vssd1 vccd1 vccd1 sky130_fd_sc_hd__fill_2
Xrebuffer206 _0940_/B vssd1 vssd1 vccd1 vccd1 _0994_/B1 sky130_fd_sc_hd__buf_2
XTAP_TAPCELL_ROW_4_123 vssd1 vccd1 sky130_fd_sc_hd__tapvpwrvgnd_1
XFILLER_25_296 vssd1 vssd1 vccd1 vccd1 sky130_fd_sc_hd__fill_2
XTAP_TAPCELL_ROW_27_236 vssd1 vccd1 sky130_fd_sc_hd__tapvpwrvgnd_1
XFILLER_40_277 vssd1 vssd1 vccd1 vccd1 sky130_fd_sc_hd__fill_4
XFILLER_4_27 vssd1 vssd1 vccd1 vccd1 sky130_fd_sc_hd__fill_1
XFILLER_16_296 vssd1 vssd1 vccd1 vccd1 sky130_fd_sc_hd__fill_2
X_1564_ _1569_/C vssd1 vssd1 vccd1 vccd1 _1565_/C sky130_fd_sc_hd__inv_2
X_1633_ _1633_/CLK _1633_/D fanout54/X vssd1 vssd1 vccd1 vccd1 _1633_/Q sky130_fd_sc_hd__dfrtp_2
X_1495_ _1619_/Q _0805_/A _1380_/A _1499_/B vssd1 vssd1 vccd1 vccd1 _1495_/X sky130_fd_sc_hd__a22o_2
XTAP_TAPCELL_ROW_1_104 vssd1 vccd1 sky130_fd_sc_hd__tapvpwrvgnd_1
Xfanout37 _0875_/Y vssd1 vssd1 vccd1 vccd1 _1489_/A1 sky130_fd_sc_hd__clkdlybuf4s25_1
XFILLER_22_244 vssd1 vssd1 vccd1 vccd1 sky130_fd_sc_hd__fill_8
Xfanout48 _1616_/Q vssd1 vssd1 vccd1 vccd1 _1490_/A sky130_fd_sc_hd__buf_6
Xfanout59 fanout63/X vssd1 vssd1 vccd1 vccd1 fanout59/X sky130_fd_sc_hd__clkdlybuf4s25_1
XTAP_TAPCELL_ROW_32_261 vssd1 vccd1 sky130_fd_sc_hd__tapvpwrvgnd_1
XFILLER_1_104 vssd1 vssd1 vccd1 vccd1 sky130_fd_sc_hd__fill_8
XFILLER_1_148 vssd1 vssd1 vccd1 vccd1 sky130_fd_sc_hd__fill_1
XFILLER_13_222 vssd1 vssd1 vccd1 vccd1 sky130_fd_sc_hd__fill_2
XFILLER_13_233 vssd1 vssd1 vccd1 vccd1 sky130_fd_sc_hd__fill_2
XFILLER_13_288 vssd1 vssd1 vccd1 vccd1 sky130_fd_sc_hd__fill_2
X_1280_ _1280_/A _1334_/B vssd1 vssd1 vccd1 vccd1 _1280_/Y sky130_fd_sc_hd__nand2_2
XTAP_TAPCELL_ROW_46_331 vssd1 vccd1 sky130_fd_sc_hd__tapvpwrvgnd_1
X_0995_ _0939_/Y _1006_/B _1008_/C _0994_/X vssd1 vssd1 vccd1 vccd1 _0995_/Y sky130_fd_sc_hd__a22oi_2
XFILLER_8_270 vssd1 vssd1 vccd1 vccd1 sky130_fd_sc_hd__fill_2
X_1616_ clkload4/A _1616_/D load_slew60/X vssd1 vssd1 vccd1 vccd1 _1616_/Q sky130_fd_sc_hd__dfrtp_2
X_1547_ _1558_/D vssd1 vssd1 vccd1 vccd1 _1553_/A sky130_fd_sc_hd__inv_2
XFILLER_39_163 vssd1 vssd1 vccd1 vccd1 sky130_fd_sc_hd__fill_1
X_1478_ _1406_/B _1472_/X _1479_/A vssd1 vssd1 vccd1 vccd1 _1480_/A sky130_fd_sc_hd__o21a_2
XFILLER_40_89 vssd1 vssd1 vccd1 vccd1 sky130_fd_sc_hd__fill_1
XFILLER_6_207 vssd1 vssd1 vccd1 vccd1 sky130_fd_sc_hd__fill_1
XFILLER_1_39 vssd1 vssd1 vccd1 vccd1 sky130_fd_sc_hd__fill_2
X_1401_ _1409_/B _1401_/B vssd1 vssd1 vccd1 vccd1 _1401_/Y sky130_fd_sc_hd__nor2_2
Xinput5 gpio_in[3] vssd1 vssd1 vccd1 vccd1 input5/X sky130_fd_sc_hd__clkdlybuf4s25_1
X_1332_ _1331_/Y _1331_/A _1332_/S vssd1 vssd1 vccd1 vccd1 _1332_/X sky130_fd_sc_hd__mux2_1
X_1263_ _1270_/B _1263_/B vssd1 vssd1 vccd1 vccd1 _1348_/A sky130_fd_sc_hd__nor2_2
X_1194_ _1201_/A _1194_/B vssd1 vssd1 vccd1 vccd1 _1194_/X sky130_fd_sc_hd__and2b_2
XFILLER_36_166 vssd1 vssd1 vccd1 vccd1 sky130_fd_sc_hd__fill_1
X_0978_ _0925_/Y _0977_/Y _0990_/A vssd1 vssd1 vccd1 vccd1 _0978_/X sky130_fd_sc_hd__o21ba_2
XFILLER_19_68 vssd1 vssd1 vccd1 vccd1 sky130_fd_sc_hd__fill_1
XFILLER_27_111 vssd1 vssd1 vccd1 vccd1 sky130_fd_sc_hd__fill_1
X_0901_ _1598_/Q _1378_/A _0901_/C vssd1 vssd1 vccd1 vccd1 _0901_/X sky130_fd_sc_hd__or3_2
X_0832_ _0830_/Y _0831_/Y _0828_/X vssd1 vssd1 vccd1 vccd1 _0832_/Y sky130_fd_sc_hd__a21oi_2
X_1315_ _1315_/A _1336_/B vssd1 vssd1 vccd1 vccd1 _1316_/B sky130_fd_sc_hd__nand2_2
X_1246_ _1246_/A _1246_/B vssd1 vssd1 vccd1 vccd1 _1246_/Y sky130_fd_sc_hd__nor2_2
X_1177_ _1177_/A _1177_/B vssd1 vssd1 vccd1 vccd1 _1212_/A sky130_fd_sc_hd__xnor2_2
XTAP_TAPCELL_ROW_19_194 vssd1 vccd1 sky130_fd_sc_hd__tapvpwrvgnd_1
XFILLER_21_47 vssd1 vssd1 vccd1 vccd1 sky130_fd_sc_hd__fill_8
XFILLER_15_169 vssd1 vssd1 vccd1 vccd1 sky130_fd_sc_hd__fill_4
XFILLER_30_139 vssd1 vssd1 vccd1 vccd1 sky130_fd_sc_hd__fill_1
Xclkbuf_4_9_0_clk clkbuf_0_clk/X vssd1 vssd1 vccd1 vccd1 _1648_/CLK sky130_fd_sc_hd__clkbuf_8
XANTENNA__0894__A2 _0893_/C vssd1 vssd1 vccd1 vccd1 sky130_fd_sc_hd__diode_2
X_1100_ _1100_/A _1100_/B vssd1 vssd1 vccd1 vccd1 _1100_/Y sky130_fd_sc_hd__nand2_2
X_1031_ _1031_/A _1031_/B vssd1 vssd1 vccd1 vccd1 _1032_/B sky130_fd_sc_hd__nor2_2
XFILLER_21_106 vssd1 vssd1 vccd1 vccd1 sky130_fd_sc_hd__fill_1
XFILLER_21_128 vssd1 vssd1 vccd1 vccd1 sky130_fd_sc_hd__fill_1
X_0815_ _0806_/X _0808_/Y _0805_/X vssd1 vssd1 vccd1 vccd1 _0815_/X sky130_fd_sc_hd__a21o_2
XANTENNA__1602__RESET_B load_slew58/X vssd1 vssd1 vccd1 vccd1 sky130_fd_sc_hd__diode_2
X_1229_ _1230_/A _1230_/B vssd1 vssd1 vccd1 vccd1 _1240_/B sky130_fd_sc_hd__and2_2
XFILLER_20_161 vssd1 vssd1 vccd1 vccd1 sky130_fd_sc_hd__fill_2
XFILLER_7_154 vssd1 vssd1 vccd1 vccd1 sky130_fd_sc_hd__fill_1
X_1580_ _1581_/B _1580_/B vssd1 vssd1 vccd1 vccd1 _1650_/D sky130_fd_sc_hd__nor2_2
XTAP_TAPCELL_ROW_13_167 vssd1 vccd1 sky130_fd_sc_hd__tapvpwrvgnd_1
XFILLER_34_220 vssd1 vssd1 vccd1 vccd1 sky130_fd_sc_hd__fill_2
XFILLER_34_242 vssd1 vssd1 vccd1 vccd1 sky130_fd_sc_hd__fill_2
XFILLER_34_253 vssd1 vccd1 vssd1 vccd1 sky130_ef_sc_hd__decap_40_12
X_1014_ _1010_/A _1012_/Y _1009_/Y _0984_/Y vssd1 vssd1 vccd1 vccd1 _1020_/A sky130_fd_sc_hd__a31o_4
Xrebuffer207 _0940_/A vssd1 vssd1 vccd1 vccd1 _1008_/C sky130_fd_sc_hd__buf_2
XANTENNA__1283__A2 _1265_/B vssd1 vssd1 vccd1 vccd1 sky130_fd_sc_hd__diode_2
XTAP_TAPCELL_ROW_27_237 vssd1 vccd1 sky130_fd_sc_hd__tapvpwrvgnd_1
XFILLER_4_168 vssd1 vccd1 vssd1 vccd1 sky130_ef_sc_hd__decap_40_12
XFILLER_31_267 vssd1 vssd1 vccd1 vccd1 sky130_fd_sc_hd__fill_1
X_1563_ _1643_/Q _1644_/Q _1563_/C vssd1 vssd1 vccd1 vccd1 _1569_/C sky130_fd_sc_hd__and3_2
X_1632_ _1633_/CLK _1632_/D fanout54/X vssd1 vssd1 vccd1 vccd1 _1632_/Q sky130_fd_sc_hd__dfrtp_2
X_1494_ _1619_/Q _1494_/B vssd1 vssd1 vccd1 vccd1 _1499_/B sky130_fd_sc_hd__nand2_2
XTAP_TAPCELL_ROW_1_105 vssd1 vccd1 sky130_fd_sc_hd__tapvpwrvgnd_1
XFILLER_22_223 vssd1 vssd1 vccd1 vccd1 sky130_fd_sc_hd__fill_2
Xfanout16 fanout16/A vssd1 vssd1 vccd1 vccd1 _1390_/A2 sky130_fd_sc_hd__buf_8
Xfanout49 _1611_/Q vssd1 vssd1 vccd1 vccd1 _1460_/B sky130_fd_sc_hd__dlymetal6s2s_1
XTAP_TAPCELL_ROW_32_262 vssd1 vccd1 sky130_fd_sc_hd__tapvpwrvgnd_1
XFILLER_13_278 vssd1 vssd1 vccd1 vccd1 sky130_fd_sc_hd__fill_2
XFILLER_0_193 vssd1 vssd1 vccd1 vccd1 sky130_fd_sc_hd__fill_2
XTAP_TAPCELL_ROW_46_332 vssd1 vccd1 sky130_fd_sc_hd__tapvpwrvgnd_1
X_0994_ _1002_/B _1002_/C _0994_/B1 _1006_/A vssd1 vssd1 vccd1 vccd1 _0994_/X sky130_fd_sc_hd__a211o_2
X_1615_ clkload6/A _1615_/D fanout64/X vssd1 vssd1 vccd1 vccd1 _1615_/Q sky130_fd_sc_hd__dfrtp_2
X_1546_ _1639_/Q _1548_/B vssd1 vssd1 vccd1 vccd1 _1558_/D sky130_fd_sc_hd__and2_2
X_1477_ _0875_/Y _1476_/Y _1473_/X _1515_/A1 _1614_/Q vssd1 vssd1 vccd1 vccd1 _1614_/D
+ sky130_fd_sc_hd__a32o_2
XFILLER_10_259 vssd1 vssd1 vccd1 vccd1 sky130_fd_sc_hd__fill_2
Xhold260 _1633_/Q vssd1 vssd1 vccd1 vccd1 hold260/X sky130_fd_sc_hd__dlygate4sd3_1
XPHY_EDGE_ROW_39_Left_86 vssd1 vssd1 vccd1 vccd1 sky130_fd_sc_hd__decap_3
X_1400_ _1408_/A _1408_/C vssd1 vssd1 vccd1 vccd1 _1401_/B sky130_fd_sc_hd__nor2_2
X_1331_ _1331_/A _1331_/B vssd1 vssd1 vccd1 vccd1 _1331_/Y sky130_fd_sc_hd__nand2_2
Xinput6 nrst vssd1 vssd1 vccd1 vccd1 input6/X sky130_fd_sc_hd__clkdlybuf4s25_1
X_1262_ _1261_/A _1265_/B _1261_/B vssd1 vssd1 vccd1 vccd1 _1263_/B sky130_fd_sc_hd__a21oi_2
X_1193_ _1170_/Y _1215_/A2 _1234_/A vssd1 vssd1 vccd1 vccd1 _1194_/B sky130_fd_sc_hd__a21o_2
XANTENNA__1627__RESET_B fanout64/X vssd1 vssd1 vccd1 vccd1 sky130_fd_sc_hd__diode_2
XFILLER_10_49 vssd1 vssd1 vccd1 vccd1 sky130_fd_sc_hd__fill_2
X_0977_ _0996_/A _0996_/B _0968_/A vssd1 vssd1 vccd1 vccd1 _0977_/Y sky130_fd_sc_hd__a21oi_2
X_1529_ _0850_/A _1528_/X _1631_/Q _1595_/Q vssd1 vssd1 vccd1 vccd1 _1534_/C sky130_fd_sc_hd__o211a_2
XFILLER_35_13 vssd1 vssd1 vccd1 vccd1 sky130_fd_sc_hd__fill_2
XPHY_EDGE_ROW_14_Right_14 vssd1 vssd1 vccd1 vccd1 sky130_fd_sc_hd__decap_3
XPHY_EDGE_ROW_23_Right_23 vssd1 vssd1 vccd1 vccd1 sky130_fd_sc_hd__decap_3
XFILLER_18_156 vssd1 vssd1 vccd1 vccd1 sky130_fd_sc_hd__fill_2
X_0900_ _0900_/A _0900_/B vssd1 vssd1 vccd1 vccd1 _1597_/D sky130_fd_sc_hd__and2_2
XPHY_EDGE_ROW_32_Right_32 vssd1 vssd1 vccd1 vccd1 sky130_fd_sc_hd__decap_3
XANTENNA__1386__B2 _1378_/B vssd1 vssd1 vccd1 vccd1 sky130_fd_sc_hd__diode_2
X_0831_ _0836_/A _1630_/Q _1528_/B _1717_/A vssd1 vssd1 vccd1 vccd1 _0831_/Y sky130_fd_sc_hd__a31oi_2
X_1314_ _1439_/B _1317_/C vssd1 vssd1 vccd1 vccd1 _1432_/A sky130_fd_sc_hd__and2_2
XPHY_EDGE_ROW_41_Right_41 vssd1 vssd1 vccd1 vccd1 sky130_fd_sc_hd__decap_3
XFILLER_24_137 vssd1 vssd1 vccd1 vccd1 sky130_fd_sc_hd__fill_1
XFILLER_2_83 vssd1 vssd1 vccd1 vccd1 sky130_fd_sc_hd__fill_1
X_1245_ _1246_/B vssd1 vssd1 vccd1 vccd1 _1305_/A sky130_fd_sc_hd__inv_2
X_1176_ _1176_/A _1176_/B vssd1 vssd1 vccd1 vccd1 _1176_/X sky130_fd_sc_hd__xor2_4
XTAP_TAPCELL_ROW_19_195 vssd1 vccd1 sky130_fd_sc_hd__tapvpwrvgnd_1
Xmax_cap24 _1149_/B vssd1 vssd1 vccd1 vccd1 _1199_/A sky130_fd_sc_hd__clkbuf_2
XFILLER_30_107 vssd1 vssd1 vccd1 vccd1 sky130_fd_sc_hd__fill_4
XFILLER_46_89 vssd1 vssd1 vccd1 vccd1 sky130_fd_sc_hd__fill_2
XFILLER_46_240 vssd1 vssd1 vccd1 vccd1 sky130_fd_sc_hd__fill_1
XFILLER_46_251 vssd1 vssd1 vccd1 vccd1 sky130_fd_sc_hd__fill_1
X_1030_ _1028_/B _1029_/Y _1029_/A _1063_/A vssd1 vssd1 vccd1 vccd1 _1102_/A sky130_fd_sc_hd__o2bb2a_2
X_0814_ _0805_/B _0813_/Y _0810_/Y _1654_/Q vssd1 vssd1 vccd1 vccd1 _1654_/D sky130_fd_sc_hd__a2bb2o_2
XPHY_EDGE_ROW_26_Left_73 vssd1 vssd1 vccd1 vccd1 sky130_fd_sc_hd__decap_3
XPHY_EDGE_ROW_10_Left_57 vssd1 vssd1 vccd1 vccd1 sky130_fd_sc_hd__decap_3
X_1228_ _1230_/A _1230_/B vssd1 vssd1 vccd1 vccd1 _1231_/A sky130_fd_sc_hd__nor2_2
XFILLER_12_129 vssd1 vssd1 vccd1 vccd1 sky130_fd_sc_hd__fill_2
XFILLER_16_37 vssd1 vccd1 vssd1 vccd1 sky130_ef_sc_hd__decap_40_12
X_1159_ _1163_/A _1159_/B _1159_/C vssd1 vssd1 vccd1 vccd1 _1187_/B sky130_fd_sc_hd__nand3_2
XFILLER_20_195 vssd1 vssd1 vccd1 vccd1 sky130_fd_sc_hd__fill_1
XTAP_TAPCELL_ROW_38_290 vssd1 vccd1 sky130_fd_sc_hd__tapvpwrvgnd_1
XFILLER_7_111 vssd1 vssd1 vccd1 vccd1 sky130_fd_sc_hd__fill_1
XTAP_TAPCELL_ROW_13_168 vssd1 vccd1 sky130_fd_sc_hd__tapvpwrvgnd_1
XFILLER_7_133 vssd1 vssd1 vccd1 vccd1 sky130_fd_sc_hd__fill_4
XFILLER_34_232 vssd1 vssd1 vccd1 vccd1 sky130_fd_sc_hd__fill_1
XFILLER_34_298 vssd1 vssd1 vccd1 vccd1 sky130_fd_sc_hd__fill_1
X_1013_ _1073_/A _1073_/B vssd1 vssd1 vccd1 vccd1 _1013_/Y sky130_fd_sc_hd__nor2_2
Xrebuffer219 _1466_/B vssd1 vssd1 vccd1 vccd1 _1448_/B sky130_fd_sc_hd__buf_6
Xrebuffer208 _1625_/Q vssd1 vssd1 vccd1 vccd1 _1510_/A sky130_fd_sc_hd__buf_2
XPHY_EDGE_ROW_4_Right_4 vssd1 vssd1 vccd1 vccd1 sky130_fd_sc_hd__decap_3
XTAP_TAPCELL_ROW_27_238 vssd1 vccd1 sky130_fd_sc_hd__tapvpwrvgnd_1
XFILLER_25_298 vssd1 vssd1 vccd1 vccd1 sky130_fd_sc_hd__fill_1
XFILLER_40_213 vssd1 vssd1 vccd1 vccd1 sky130_fd_sc_hd__fill_1
XFILLER_40_257 vssd1 vssd1 vccd1 vccd1 sky130_fd_sc_hd__fill_1
XFILLER_43_24 vssd1 vssd1 vccd1 vccd1 sky130_fd_sc_hd__fill_4
XFILLER_43_79 vssd1 vssd1 vccd1 vccd1 sky130_fd_sc_hd__fill_1
Xclkbuf_4_8_0_clk clkbuf_0_clk/X vssd1 vssd1 vccd1 vccd1 _1652_/CLK sky130_fd_sc_hd__clkbuf_8
XFILLER_4_29 vssd1 vccd1 vssd1 vccd1 sky130_ef_sc_hd__decap_40_12
XTAP_TAPCELL_ROW_10_149 vssd1 vccd1 sky130_fd_sc_hd__tapvpwrvgnd_1
XFILLER_16_298 vssd1 vssd1 vccd1 vccd1 sky130_fd_sc_hd__fill_1
X_1631_ clkload9/A _1631_/D load_slew55/X vssd1 vssd1 vccd1 vccd1 _1631_/Q sky130_fd_sc_hd__dfrtp_2
X_1562_ _1643_/Q _1563_/C _1644_/Q vssd1 vssd1 vccd1 vccd1 _1565_/B sky130_fd_sc_hd__a21o_2
X_1493_ _1380_/A _1491_/Y _1492_/X _0805_/A _1618_/Q vssd1 vssd1 vccd1 vccd1 _1618_/D
+ sky130_fd_sc_hd__a32o_2
XTAP_TAPCELL_ROW_1_106 vssd1 vccd1 sky130_fd_sc_hd__tapvpwrvgnd_1
Xfanout17 _1360_/Y vssd1 vssd1 vccd1 vccd1 _1405_/A1 sky130_fd_sc_hd__buf_6
Xfanout39 _0911_/Y vssd1 vssd1 vccd1 vccd1 _0934_/B sky130_fd_sc_hd__buf_6
XTAP_TAPCELL_ROW_32_263 vssd1 vccd1 sky130_fd_sc_hd__tapvpwrvgnd_1
XTAP_TAPCELL_ROW_24_219 vssd1 vccd1 sky130_fd_sc_hd__tapvpwrvgnd_1
XFILLER_38_57 vssd1 vssd1 vccd1 vccd1 sky130_fd_sc_hd__fill_4
XPHY_EDGE_ROW_13_Left_60 vssd1 vssd1 vccd1 vccd1 sky130_fd_sc_hd__decap_3
XTAP_TAPCELL_ROW_46_333 vssd1 vccd1 sky130_fd_sc_hd__tapvpwrvgnd_1
X_0993_ _1001_/A1 _1002_/C _0994_/B1 vssd1 vssd1 vccd1 vccd1 _1006_/B sky130_fd_sc_hd__a21oi_2
X_1614_ clkload6/A _1614_/D fanout64/X vssd1 vssd1 vccd1 vccd1 _1614_/Q sky130_fd_sc_hd__dfrtp_2
XFILLER_8_272 vssd1 vssd1 vccd1 vccd1 sky130_fd_sc_hd__fill_1
XFILLER_39_132 vssd1 vccd1 vssd1 vccd1 sky130_ef_sc_hd__decap_40_12
X_1545_ _1548_/B _1545_/B vssd1 vssd1 vccd1 vccd1 _1638_/D sky130_fd_sc_hd__nor2_2
X_1476_ _1474_/Y _1485_/C _0891_/X vssd1 vssd1 vccd1 vccd1 _1476_/Y sky130_fd_sc_hd__o21ai_2
XFILLER_10_216 vssd1 vssd1 vccd1 vccd1 sky130_fd_sc_hd__fill_1
XFILLER_40_14 vssd1 vssd1 vccd1 vccd1 sky130_fd_sc_hd__fill_8
XTAP_TAPCELL_ROW_20_200 vssd1 vccd1 sky130_fd_sc_hd__tapvpwrvgnd_1
XFILLER_6_6 vssd1 vssd1 vccd1 vccd1 sky130_fd_sc_hd__fill_8
Xhold250 _1649_/Q vssd1 vssd1 vccd1 vccd1 hold250/X sky130_fd_sc_hd__dlygate4sd3_1
Xhold261 _1598_/Q vssd1 vssd1 vccd1 vccd1 hold261/X sky130_fd_sc_hd__dlygate4sd3_1
XFILLER_45_113 vssd1 vssd1 vccd1 vccd1 sky130_fd_sc_hd__fill_2
XTAP_TAPCELL_ROW_43_314 vssd1 vccd1 sky130_fd_sc_hd__tapvpwrvgnd_1
XFILLER_5_242 vssd1 vccd1 vssd1 vccd1 sky130_ef_sc_hd__decap_40_12
XFILLER_30_91 vssd1 vssd1 vccd1 vccd1 sky130_fd_sc_hd__fill_1
X_1330_ _1479_/A _1330_/B vssd1 vssd1 vccd1 vccd1 _1330_/Y sky130_fd_sc_hd__nand2_2
X_1261_ _1261_/A _1261_/B _1265_/B vssd1 vssd1 vccd1 vccd1 _1270_/B sky130_fd_sc_hd__and3_4
X_1192_ _1192_/A _1192_/B vssd1 vssd1 vccd1 vccd1 _1243_/C sky130_fd_sc_hd__nand2_4
XFILLER_44_190 vssd1 vssd1 vccd1 vccd1 sky130_fd_sc_hd__fill_4
X_0976_ _0976_/A _0976_/B vssd1 vssd1 vccd1 vccd1 _0984_/B sky130_fd_sc_hd__xor2_2
X_1528_ _1630_/Q _1528_/B vssd1 vssd1 vccd1 vccd1 _1528_/X sky130_fd_sc_hd__and2b_2
X_1459_ _1612_/Q _1469_/C vssd1 vssd1 vccd1 vccd1 _1461_/A sky130_fd_sc_hd__nor2_2
XPHY_EDGE_ROW_40_Left_87 vssd1 vssd1 vccd1 vccd1 sky130_fd_sc_hd__decap_3
X_0830_ _0836_/A _1630_/Q _0830_/C vssd1 vssd1 vccd1 vccd1 _0830_/Y sky130_fd_sc_hd__nand3_2
XFILLER_2_51 vssd1 vssd1 vccd1 vccd1 sky130_fd_sc_hd__fill_1
X_1313_ _1313_/A _1313_/B vssd1 vssd1 vccd1 vccd1 _1317_/C sky130_fd_sc_hd__or2_2
X_1244_ _1244_/A _1244_/B vssd1 vssd1 vccd1 vccd1 _1246_/B sky130_fd_sc_hd__xnor2_2
X_1175_ _1603_/Q _1177_/A _1176_/A _1175_/C1 vssd1 vssd1 vccd1 vccd1 _1175_/X sky130_fd_sc_hd__o211a_2
XTAP_TAPCELL_ROW_19_196 vssd1 vccd1 sky130_fd_sc_hd__tapvpwrvgnd_1
XFILLER_32_171 vssd1 vssd1 vccd1 vccd1 sky130_fd_sc_hd__fill_2
X_0959_ _1510_/A _0962_/B _0943_/X _1626_/Q vssd1 vssd1 vccd1 vccd1 _0960_/D sky130_fd_sc_hd__o31ai_2
XFILLER_46_57 vssd1 vssd1 vccd1 vccd1 sky130_fd_sc_hd__fill_2
Xmax_cap25 _1136_/Y vssd1 vssd1 vccd1 vccd1 _1174_/B sky130_fd_sc_hd__buf_6
XFILLER_30_119 vssd1 vccd1 vssd1 vccd1 sky130_ef_sc_hd__decap_40_12
XFILLER_38_219 vssd1 vssd1 vccd1 vccd1 sky130_fd_sc_hd__fill_2
XFILLER_46_285 vssd1 vssd1 vccd1 vccd1 sky130_fd_sc_hd__fill_2
X_0813_ _0805_/A _0805_/C _1653_/Q vssd1 vssd1 vccd1 vccd1 _0813_/Y sky130_fd_sc_hd__a21oi_2
XANTENNA__0865__A _1376_/A vssd1 vssd1 vccd1 vccd1 sky130_fd_sc_hd__diode_2
XFILLER_29_208 vssd1 vssd1 vccd1 vccd1 sky130_fd_sc_hd__fill_2
XFILLER_37_274 vssd1 vssd1 vccd1 vccd1 sky130_fd_sc_hd__fill_4
X_1227_ _1248_/A _1249_/B1 _1194_/X _1149_/X vssd1 vssd1 vccd1 vccd1 _1230_/B sky130_fd_sc_hd__o2bb2a_2
X_1158_ _1158_/A1 _1181_/B _1201_/A vssd1 vssd1 vccd1 vccd1 _1158_/X sky130_fd_sc_hd__a21o_2
XANTENNA__1611__RESET_B load_slew58/X vssd1 vssd1 vccd1 vccd1 sky130_fd_sc_hd__diode_2
XFILLER_12_119 vssd1 vssd1 vccd1 vccd1 sky130_fd_sc_hd__fill_2
XFILLER_16_49 vssd1 vssd1 vccd1 vccd1 sky130_fd_sc_hd__fill_1
XFILLER_20_141 vssd1 vccd1 vssd1 vccd1 sky130_ef_sc_hd__decap_40_12
XFILLER_37_296 vssd1 vssd1 vccd1 vccd1 sky130_fd_sc_hd__fill_2
X_1089_ _1089_/A _1089_/B vssd1 vssd1 vccd1 vccd1 _1089_/Y sky130_fd_sc_hd__nor2_2
XFILLER_32_48 vssd1 vssd1 vccd1 vccd1 sky130_fd_sc_hd__fill_2
XTAP_TAPCELL_ROW_7_134 vssd1 vccd1 sky130_fd_sc_hd__tapvpwrvgnd_1
XTAP_TAPCELL_ROW_38_291 vssd1 vccd1 sky130_fd_sc_hd__tapvpwrvgnd_1
XPHY_EDGE_ROW_43_Left_90 vssd1 vssd1 vccd1 vccd1 sky130_fd_sc_hd__decap_3
XFILLER_14_5 vssd1 vssd1 vccd1 vccd1 sky130_fd_sc_hd__fill_2
X_1012_ _1073_/B vssd1 vssd1 vccd1 vccd1 _1012_/Y sky130_fd_sc_hd__inv_2
XFILLER_34_244 vssd1 vssd1 vccd1 vccd1 sky130_fd_sc_hd__fill_1
XFILLER_40_225 vssd1 vccd1 vssd1 vccd1 sky130_ef_sc_hd__decap_40_12
XFILLER_4_126 vssd1 vssd1 vccd1 vccd1 sky130_fd_sc_hd__fill_4
XFILLER_16_288 vssd1 vssd1 vccd1 vccd1 sky130_fd_sc_hd__fill_8
XFILLER_31_203 vssd1 vssd1 vccd1 vccd1 sky130_fd_sc_hd__fill_1
XFILLER_31_247 vssd1 vssd1 vccd1 vccd1 sky130_fd_sc_hd__fill_1
XFILLER_33_80 vssd1 vssd1 vccd1 vccd1 sky130_fd_sc_hd__fill_4
X_1630_ clkload9/A _1630_/D load_slew55/X vssd1 vssd1 vccd1 vccd1 _1630_/Q sky130_fd_sc_hd__dfrtp_2
XFILLER_3_181 vssd1 vssd1 vccd1 vccd1 sky130_fd_sc_hd__fill_2
XFILLER_3_192 vssd1 vssd1 vccd1 vccd1 sky130_fd_sc_hd__fill_2
X_1561_ _1561_/A _1563_/C vssd1 vssd1 vccd1 vccd1 _1643_/D sky130_fd_sc_hd__xor2_2
X_1492_ _1490_/A _1617_/Q _1490_/D _1618_/Q vssd1 vssd1 vccd1 vccd1 _1492_/X sky130_fd_sc_hd__a31o_2
XTAP_TAPCELL_ROW_1_107 vssd1 vccd1 sky130_fd_sc_hd__tapvpwrvgnd_1
XFILLER_22_225 vssd1 vssd1 vccd1 vccd1 sky130_fd_sc_hd__fill_1
XANTENNA__0860__D_N _1376_/A vssd1 vssd1 vccd1 vccd1 sky130_fd_sc_hd__diode_2
XFILLER_13_214 vssd1 vssd1 vccd1 vccd1 sky130_fd_sc_hd__fill_8
XFILLER_13_225 vssd1 vssd1 vccd1 vccd1 sky130_fd_sc_hd__fill_8
XFILLER_0_173 vssd1 vssd1 vccd1 vccd1 sky130_fd_sc_hd__fill_2
XFILLER_0_195 vssd1 vssd1 vccd1 vccd1 sky130_fd_sc_hd__fill_1
XTAP_TAPCELL_ROW_46_334 vssd1 vccd1 sky130_fd_sc_hd__tapvpwrvgnd_1
X_0992_ _1068_/A _0992_/B _0992_/C vssd1 vssd1 vccd1 vccd1 _0992_/X sky130_fd_sc_hd__or3_4
X_1613_ clkload6/A _1613_/D fanout64/X vssd1 vssd1 vccd1 vccd1 _1613_/Q sky130_fd_sc_hd__dfrtp_2
X_1544_ _1637_/Q _1542_/B hold242/X vssd1 vssd1 vccd1 vccd1 _1544_/Y sky130_fd_sc_hd__a21oi_2
XFILLER_8_251 vssd1 vssd1 vccd1 vccd1 sky130_fd_sc_hd__fill_1
XFILLER_39_111 vssd1 vssd1 vccd1 vccd1 sky130_fd_sc_hd__fill_1
XFILLER_39_144 vssd1 vccd1 vssd1 vccd1 sky130_ef_sc_hd__decap_40_12
XFILLER_5_84 vssd1 vssd1 vccd1 vccd1 sky130_fd_sc_hd__fill_2
Xclkbuf_4_7_0_clk clkbuf_0_clk/X vssd1 vssd1 vccd1 vccd1 clkload7/A sky130_fd_sc_hd__clkbuf_8
X_1475_ _1614_/Q _1475_/B vssd1 vssd1 vccd1 vccd1 _1485_/C sky130_fd_sc_hd__and2_2
XFILLER_40_48 vssd1 vccd1 vssd1 vccd1 sky130_ef_sc_hd__decap_40_12
XTAP_TAPCELL_ROW_20_201 vssd1 vccd1 sky130_fd_sc_hd__tapvpwrvgnd_1
Xhold240 _1590_/Q vssd1 vssd1 vccd1 vccd1 _1589_/D sky130_fd_sc_hd__dlygate4sd3_1
Xhold251 _1643_/Q vssd1 vssd1 vccd1 vccd1 _1561_/A sky130_fd_sc_hd__dlygate4sd3_1
Xhold262 _1621_/Q vssd1 vssd1 vccd1 vccd1 _1501_/A sky130_fd_sc_hd__dlygate4sd3_1
XFILLER_45_147 vssd1 vccd1 vssd1 vccd1 sky130_ef_sc_hd__decap_40_12
Xteam_04_90 vssd1 vssd1 vccd1 vccd1 team_04_90/HI gpio_out[26] sky130_fd_sc_hd__conb_1
XFILLER_14_60 vssd1 vssd1 vccd1 vccd1 sky130_fd_sc_hd__fill_4
XTAP_TAPCELL_ROW_43_315 vssd1 vccd1 sky130_fd_sc_hd__tapvpwrvgnd_1
XFILLER_5_254 vssd1 vssd1 vccd1 vccd1 sky130_fd_sc_hd__fill_4
X_1260_ _1260_/A _1260_/B vssd1 vssd1 vccd1 vccd1 _1313_/A sky130_fd_sc_hd__xnor2_2
X_1191_ _1182_/X _1243_/A _1246_/A _1244_/A _1190_/Y vssd1 vssd1 vccd1 vccd1 _1191_/X
+ sky130_fd_sc_hd__a41o_4
X_0975_ _0976_/A _0976_/B vssd1 vssd1 vccd1 vccd1 _0975_/X sky130_fd_sc_hd__or2_2
XFILLER_10_29 vssd1 vccd1 vssd1 vccd1 sky130_ef_sc_hd__decap_40_12
X_1527_ _0850_/A _1521_/S _1631_/Q vssd1 vssd1 vccd1 vccd1 _1530_/C sky130_fd_sc_hd__a21o_2
XFILLER_35_15 vssd1 vssd1 vccd1 vccd1 sky130_fd_sc_hd__fill_1
X_1458_ _1457_/X _1455_/X _1480_/B vssd1 vssd1 vccd1 vccd1 _1458_/Y sky130_fd_sc_hd__a21oi_4
X_1389_ _1390_/A2 _1388_/X _1395_/B vssd1 vssd1 vccd1 vccd1 _1389_/Y sky130_fd_sc_hd__a21oi_2
XFILLER_35_26 vssd1 vssd1 vccd1 vccd1 sky130_fd_sc_hd__fill_1
XFILLER_18_158 vssd1 vssd1 vccd1 vccd1 sky130_fd_sc_hd__fill_1
XFILLER_25_81 vssd1 vssd1 vccd1 vccd1 sky130_fd_sc_hd__fill_8
XFILLER_2_85 vssd1 vssd1 vccd1 vccd1 sky130_fd_sc_hd__fill_2
X_1312_ _1299_/Y _1313_/B _1311_/X vssd1 vssd1 vccd1 vccd1 _1456_/A sky130_fd_sc_hd__a21bo_2
X_1243_ _1243_/A _1243_/B _1243_/C vssd1 vssd1 vccd1 vccd1 _1244_/B sky130_fd_sc_hd__and3_2
X_1174_ _1174_/A _1174_/B vssd1 vssd1 vccd1 vccd1 _1176_/B sky130_fd_sc_hd__or2_4
XTAP_TAPCELL_ROW_19_197 vssd1 vccd1 sky130_fd_sc_hd__tapvpwrvgnd_1
X_0958_ _1617_/Q _1011_/A vssd1 vssd1 vccd1 vccd1 _0960_/C sky130_fd_sc_hd__nand2b_2
X_0889_ _1490_/A _1617_/Q _1618_/Q vssd1 vssd1 vccd1 vccd1 _0889_/Y sky130_fd_sc_hd__nor3_2
XFILLER_15_117 vssd1 vssd1 vccd1 vccd1 sky130_fd_sc_hd__fill_2
XFILLER_46_231 vssd1 vssd1 vccd1 vccd1 sky130_fd_sc_hd__fill_4
XFILLER_14_161 vssd1 vccd1 vssd1 vccd1 sky130_ef_sc_hd__decap_40_12
XFILLER_46_253 vssd1 vccd1 vssd1 vccd1 sky130_ef_sc_hd__decap_40_12
X_0812_ _0805_/C _0811_/Y _0810_/Y hold257/X vssd1 vssd1 vccd1 vccd1 _1655_/D sky130_fd_sc_hd__a2bb2o_2
X_1226_ _1232_/B vssd1 vssd1 vccd1 vccd1 _1226_/Y sky130_fd_sc_hd__inv_2
X_1157_ _1157_/A _1157_/B vssd1 vssd1 vccd1 vccd1 _1157_/Y sky130_fd_sc_hd__xnor2_4
XFILLER_20_153 vssd1 vssd1 vccd1 vccd1 sky130_fd_sc_hd__fill_8
X_1088_ _1080_/B _1080_/A _1036_/Y _1090_/A vssd1 vssd1 vccd1 vccd1 _1094_/B sky130_fd_sc_hd__a211o_4
XTAP_TAPCELL_ROW_7_135 vssd1 vccd1 sky130_fd_sc_hd__tapvpwrvgnd_1
XTAP_TAPCELL_ROW_38_292 vssd1 vccd1 sky130_fd_sc_hd__tapvpwrvgnd_1
XFILLER_7_113 vssd1 vssd1 vccd1 vccd1 sky130_fd_sc_hd__fill_4
XFILLER_7_179 vssd1 vssd1 vccd1 vccd1 sky130_fd_sc_hd__fill_4
XFILLER_19_297 vssd1 vssd1 vccd1 vccd1 sky130_fd_sc_hd__fill_2
X_1011_ _1011_/A _1011_/B vssd1 vssd1 vccd1 vccd1 _1073_/B sky130_fd_sc_hd__xnor2_2
XFILLER_8_62 vssd1 vccd1 vssd1 vccd1 sky130_ef_sc_hd__decap_40_12
XFILLER_25_201 vssd1 vssd1 vccd1 vccd1 sky130_fd_sc_hd__fill_1
X_1209_ _1209_/A _1209_/B vssd1 vssd1 vccd1 vccd1 _1261_/B sky130_fd_sc_hd__xnor2_4
XFILLER_4_105 vssd1 vssd1 vccd1 vccd1 sky130_fd_sc_hd__fill_4
XFILLER_16_201 vssd1 vssd1 vccd1 vccd1 sky130_fd_sc_hd__fill_2
XFILLER_33_92 vssd1 vssd1 vccd1 vccd1 sky130_fd_sc_hd__fill_4
X_1560_ _1563_/C _1560_/B vssd1 vssd1 vccd1 vccd1 _1642_/D sky130_fd_sc_hd__and2b_2
X_1491_ _1494_/B vssd1 vssd1 vccd1 vccd1 _1491_/Y sky130_fd_sc_hd__inv_2
Xfanout19 _1345_/S vssd1 vssd1 vccd1 vccd1 _1336_/B sky130_fd_sc_hd__buf_2
XTAP_TAPCELL_ROW_1_108 vssd1 vccd1 sky130_fd_sc_hd__tapvpwrvgnd_1
XANTENNA__1489__A2 _0893_/C vssd1 vssd1 vccd1 vccd1 sky130_fd_sc_hd__diode_2
XFILLER_13_248 vssd1 vssd1 vccd1 vccd1 sky130_fd_sc_hd__fill_8
XFILLER_21_281 vssd1 vssd1 vccd1 vccd1 sky130_fd_sc_hd__fill_2
XTAP_TAPCELL_ROW_46_335 vssd1 vccd1 sky130_fd_sc_hd__tapvpwrvgnd_1
X_0991_ _0991_/A _0991_/B vssd1 vssd1 vccd1 vccd1 _0992_/C sky130_fd_sc_hd__xnor2_4
X_1612_ _1612_/CLK _1612_/D _0800_/X vssd1 vssd1 vccd1 vccd1 _1612_/Q sky130_fd_sc_hd__dfrtp_2
X_1543_ _1637_/Q _1636_/Q _1638_/Q vssd1 vssd1 vccd1 vccd1 _1548_/B sky130_fd_sc_hd__and3_2
X_1474_ _1614_/Q _1475_/B vssd1 vssd1 vccd1 vccd1 _1474_/Y sky130_fd_sc_hd__nor2_2
XFILLER_39_156 vssd1 vssd1 vccd1 vccd1 sky130_fd_sc_hd__fill_2
XFILLER_40_38 vssd1 vssd1 vccd1 vccd1 sky130_fd_sc_hd__fill_2
XTAP_TAPCELL_ROW_20_202 vssd1 vccd1 sky130_fd_sc_hd__tapvpwrvgnd_1
Xhold241 _1636_/Q vssd1 vssd1 vccd1 vccd1 _1542_/B sky130_fd_sc_hd__dlygate4sd3_1
Xhold252 _1641_/Q vssd1 vssd1 vccd1 vccd1 _1557_/A sky130_fd_sc_hd__dlygate4sd3_1
Xhold263 _1626_/Q vssd1 vssd1 vccd1 vccd1 hold263/X sky130_fd_sc_hd__dlygate4sd3_1
XFILLER_45_104 vssd1 vssd1 vccd1 vccd1 sky130_fd_sc_hd__fill_8
XFILLER_45_115 vssd1 vssd1 vccd1 vccd1 sky130_fd_sc_hd__fill_1
XFILLER_45_137 vssd1 vssd1 vccd1 vccd1 sky130_fd_sc_hd__fill_1
XFILLER_45_159 vssd1 vssd1 vccd1 vccd1 sky130_fd_sc_hd__fill_4
Xteam_04_91 vssd1 vssd1 vccd1 vccd1 team_04_91/HI gpio_out[27] sky130_fd_sc_hd__conb_1
Xteam_04_80 vssd1 vssd1 vccd1 vccd1 team_04_80/HI gpio_out[16] sky130_fd_sc_hd__conb_1
XTAP_TAPCELL_ROW_43_316 vssd1 vccd1 sky130_fd_sc_hd__tapvpwrvgnd_1
XFILLER_14_72 vssd1 vssd1 vccd1 vccd1 sky130_fd_sc_hd__fill_1
XFILLER_30_82 vssd1 vssd1 vccd1 vccd1 sky130_fd_sc_hd__fill_2
XFILLER_5_211 vssd1 vccd1 vssd1 vccd1 sky130_ef_sc_hd__decap_40_12
XFILLER_5_233 vssd1 vssd1 vccd1 vccd1 sky130_fd_sc_hd__fill_1
X_1190_ _1190_/A vssd1 vssd1 vccd1 vccd1 _1190_/Y sky130_fd_sc_hd__inv_2
X_0974_ _1034_/B vssd1 vssd1 vccd1 vccd1 _0974_/Y sky130_fd_sc_hd__inv_2
X_1526_ _1519_/A _0850_/Y _1539_/A _1525_/X vssd1 vssd1 vccd1 vccd1 _1630_/D sky130_fd_sc_hd__o211a_2
X_1457_ _1464_/B _1457_/B _1479_/B vssd1 vssd1 vccd1 vccd1 _1457_/X sky130_fd_sc_hd__or3_4
XANTENNA__1605__RESET_B load_slew58/X vssd1 vssd1 vccd1 vccd1 sky130_fd_sc_hd__diode_2
XFILLER_27_148 vssd1 vssd1 vccd1 vccd1 sky130_fd_sc_hd__fill_2
XFILLER_42_118 vssd1 vssd1 vccd1 vccd1 sky130_fd_sc_hd__fill_2
X_1388_ _1388_/A _1388_/B _1388_/C vssd1 vssd1 vccd1 vccd1 _1388_/X sky130_fd_sc_hd__or3_2
XFILLER_41_140 vssd1 vssd1 vccd1 vccd1 sky130_fd_sc_hd__fill_1
XFILLER_41_151 vssd1 vccd1 vssd1 vccd1 sky130_ef_sc_hd__decap_40_12
Xclkbuf_4_6_0_clk clkbuf_0_clk/X vssd1 vssd1 vccd1 vccd1 clkload6/A sky130_fd_sc_hd__clkbuf_8
XFILLER_44_6 vssd1 vssd1 vccd1 vccd1 sky130_fd_sc_hd__fill_1
Xrebuffer190 _1094_/X vssd1 vssd1 vccd1 vccd1 _1170_/A sky130_fd_sc_hd__buf_2
X_1311_ _1439_/A _1313_/A _1309_/A _1336_/B _1358_/B vssd1 vssd1 vccd1 vccd1 _1311_/X
+ sky130_fd_sc_hd__a41o_2
XFILLER_2_97 vssd1 vccd1 vssd1 vccd1 sky130_ef_sc_hd__decap_40_12
X_1242_ _1233_/X _1219_/X _1237_/Y _1241_/Y vssd1 vssd1 vccd1 vccd1 _1242_/X sky130_fd_sc_hd__a211o_4
X_1173_ _1173_/A vssd1 vssd1 vccd1 vccd1 _1173_/Y sky130_fd_sc_hd__inv_2
XPHY_EDGE_ROW_10_Right_10 vssd1 vssd1 vccd1 vccd1 sky130_fd_sc_hd__decap_3
XFILLER_32_151 vssd1 vssd1 vccd1 vccd1 sky130_fd_sc_hd__fill_1
XFILLER_32_195 vssd1 vssd1 vccd1 vccd1 sky130_fd_sc_hd__fill_1
XTAP_TAPCELL_ROW_19_198 vssd1 vccd1 sky130_fd_sc_hd__tapvpwrvgnd_1
X_0957_ _0952_/Y _0957_/B vssd1 vssd1 vccd1 vccd1 _1011_/A sky130_fd_sc_hd__and2b_2
X_0888_ _0888_/A _0888_/B vssd1 vssd1 vccd1 vccd1 _0888_/Y sky130_fd_sc_hd__nand2_2
X_1509_ _1510_/A _1510_/B vssd1 vssd1 vccd1 vccd1 _1509_/X sky130_fd_sc_hd__or2_2
XFILLER_46_59 vssd1 vssd1 vccd1 vccd1 sky130_fd_sc_hd__fill_1
Xmax_cap27 wire26/A vssd1 vssd1 vccd1 vccd1 _1078_/A1 sky130_fd_sc_hd__dlygate4sd1_1
XFILLER_46_221 vssd1 vssd1 vccd1 vccd1 sky130_fd_sc_hd__fill_2
XFILLER_46_265 vssd1 vccd1 vssd1 vccd1 sky130_ef_sc_hd__decap_40_12
XTAP_TAPCELL_ROW_16_179 vssd1 vccd1 sky130_fd_sc_hd__tapvpwrvgnd_1
X_0811_ _1653_/Q _0805_/B _0805_/A vssd1 vssd1 vccd1 vccd1 _0811_/Y sky130_fd_sc_hd__a21oi_2
XFILLER_37_298 vssd1 vssd1 vccd1 vccd1 sky130_fd_sc_hd__fill_1
X_1225_ _1225_/A _1225_/B vssd1 vssd1 vccd1 vccd1 _1232_/B sky130_fd_sc_hd__xnor2_2
X_1156_ _1222_/A _1181_/B vssd1 vssd1 vccd1 vccd1 _1234_/A sky130_fd_sc_hd__nand2_2
X_1087_ _1080_/A _1080_/B _1036_/Y vssd1 vssd1 vccd1 vccd1 _1089_/B sky130_fd_sc_hd__a21oi_4
XTAP_TAPCELL_ROW_7_136 vssd1 vccd1 sky130_fd_sc_hd__tapvpwrvgnd_1
XFILLER_11_121 vssd1 vssd1 vccd1 vccd1 sky130_fd_sc_hd__fill_1
XFILLER_28_298 vssd1 vssd1 vccd1 vccd1 sky130_fd_sc_hd__fill_1
XFILLER_43_235 vssd1 vssd1 vccd1 vccd1 sky130_fd_sc_hd__fill_2
XFILLER_43_246 vssd1 vssd1 vccd1 vccd1 sky130_fd_sc_hd__fill_4
XTAP_TAPCELL_ROW_38_293 vssd1 vccd1 sky130_fd_sc_hd__tapvpwrvgnd_1
XFILLER_11_187 vssd1 vccd1 vssd1 vccd1 sky130_ef_sc_hd__decap_40_12
XFILLER_7_169 vssd1 vssd1 vccd1 vccd1 sky130_fd_sc_hd__fill_2
X_1010_ _1010_/A _1010_/B vssd1 vssd1 vccd1 vccd1 _1073_/A sky130_fd_sc_hd__nand2_2
XFILLER_42_290 vssd1 vssd1 vccd1 vccd1 sky130_fd_sc_hd__fill_8
XTAP_TAPCELL_ROW_12_160 vssd1 vccd1 sky130_fd_sc_hd__tapvpwrvgnd_1
XFILLER_8_85 vssd1 vccd1 vssd1 vccd1 sky130_ef_sc_hd__decap_40_12
XFILLER_8_74 vssd1 vssd1 vccd1 vccd1 sky130_fd_sc_hd__fill_4
X_1208_ _1376_/A _1267_/A vssd1 vssd1 vccd1 vccd1 _1261_/A sky130_fd_sc_hd__or2_2
XFILLER_40_249 vssd1 vssd1 vccd1 vccd1 sky130_fd_sc_hd__fill_2
X_1139_ _1139_/A _1150_/C _1139_/C vssd1 vssd1 vccd1 vccd1 _1139_/X sky130_fd_sc_hd__and3_2
XTAP_TAPCELL_ROW_35_274 vssd1 vccd1 sky130_fd_sc_hd__tapvpwrvgnd_1
XTAP_TAPCELL_ROW_26_230 vssd1 vccd1 sky130_fd_sc_hd__tapvpwrvgnd_1
XFILLER_16_268 vssd1 vssd1 vccd1 vccd1 sky130_fd_sc_hd__fill_2
XFILLER_16_279 vssd1 vssd1 vccd1 vccd1 sky130_fd_sc_hd__fill_2
XFILLER_17_94 vssd1 vssd1 vccd1 vccd1 sky130_fd_sc_hd__fill_4
X_1490_ _1490_/A _1617_/Q _1618_/Q _1490_/D vssd1 vssd1 vccd1 vccd1 _1494_/B sky130_fd_sc_hd__and4_2
XPHY_EDGE_ROW_8_Right_8 vssd1 vssd1 vccd1 vccd1 sky130_fd_sc_hd__decap_3
XFILLER_30_293 vssd1 vssd1 vccd1 vccd1 sky130_fd_sc_hd__fill_4
XPHY_EDGE_ROW_39_Right_39 vssd1 vssd1 vccd1 vccd1 sky130_fd_sc_hd__decap_3
XANTENNA__0797__A _1653_/Q vssd1 vssd1 vccd1 vccd1 sky130_fd_sc_hd__diode_2
XFILLER_0_197 vssd1 vssd1 vccd1 vccd1 sky130_fd_sc_hd__fill_4
XFILLER_28_93 vssd1 vssd1 vccd1 vccd1 sky130_fd_sc_hd__fill_1
XTAP_TAPCELL_ROW_46_336 vssd1 vccd1 sky130_fd_sc_hd__tapvpwrvgnd_1
X_1611_ clkload6/A _1611_/D load_slew58/X vssd1 vssd1 vccd1 vccd1 _1611_/Q sky130_fd_sc_hd__dfrtp_2
X_0990_ _0990_/A _0990_/B vssd1 vssd1 vccd1 vccd1 _1068_/A sky130_fd_sc_hd__xnor2_4
XFILLER_8_253 vssd1 vssd1 vccd1 vccd1 sky130_fd_sc_hd__fill_4
XFILLER_5_31 vssd1 vccd1 vssd1 vccd1 sky130_ef_sc_hd__decap_40_12
XFILLER_5_64 vssd1 vccd1 vssd1 vccd1 sky130_ef_sc_hd__decap_40_12
XFILLER_5_86 vssd1 vssd1 vccd1 vccd1 sky130_fd_sc_hd__fill_1
X_1542_ _1542_/A _1542_/B vssd1 vssd1 vccd1 vccd1 _1637_/D sky130_fd_sc_hd__xor2_2
X_1473_ _1466_/Y _1325_/X _1479_/C _1448_/B _1480_/B vssd1 vssd1 vccd1 vccd1 _1473_/X
+ sky130_fd_sc_hd__a221o_2
XFILLER_39_113 vssd1 vssd1 vccd1 vccd1 sky130_fd_sc_hd__fill_4
XTAP_TAPCELL_ROW_20_203 vssd1 vccd1 sky130_fd_sc_hd__tapvpwrvgnd_1
XPHY_EDGE_ROW_17_Left_64 vssd1 vssd1 vccd1 vccd1 sky130_fd_sc_hd__decap_3
Xhold242 _1638_/Q vssd1 vssd1 vccd1 vccd1 hold242/X sky130_fd_sc_hd__dlygate4sd3_1
Xhold253 _1557_/Y vssd1 vssd1 vccd1 vccd1 _1641_/D sky130_fd_sc_hd__dlygate4sd3_1
Xhold264 _1620_/Q vssd1 vssd1 vccd1 vccd1 hold264/X sky130_fd_sc_hd__dlygate4sd3_1
Xteam_04_92 vssd1 vssd1 vccd1 vccd1 team_04_92/HI gpio_out[28] sky130_fd_sc_hd__conb_1
Xteam_04_81 vssd1 vssd1 vccd1 vccd1 team_04_81/HI gpio_out[17] sky130_fd_sc_hd__conb_1
Xteam_04_70 vssd1 vssd1 vccd1 vccd1 team_04_70/HI gpio_oeb[10] sky130_fd_sc_hd__conb_1
XTAP_TAPCELL_ROW_43_317 vssd1 vccd1 sky130_fd_sc_hd__tapvpwrvgnd_1
XFILLER_5_223 vssd1 vssd1 vccd1 vccd1 sky130_fd_sc_hd__fill_1
XFILLER_39_81 vssd1 vssd1 vccd1 vccd1 sky130_fd_sc_hd__fill_1
X_0973_ _0962_/Y _0972_/A _0971_/Y _0960_/D vssd1 vssd1 vccd1 vccd1 _0973_/X sky130_fd_sc_hd__a22o_2
X_1525_ _1629_/Q _1628_/Q _1595_/Q _1630_/Q vssd1 vssd1 vccd1 vccd1 _1525_/X sky130_fd_sc_hd__a31o_2
X_1456_ _1456_/A _1456_/B vssd1 vssd1 vccd1 vccd1 _1464_/B sky130_fd_sc_hd__nand2_2
X_1387_ _1602_/Q _1378_/A _1489_/A1 _1386_/X vssd1 vssd1 vccd1 vccd1 _1602_/D sky130_fd_sc_hd__a22o_2
XPHY_EDGE_ROW_2_Left_49 vssd1 vssd1 vccd1 vccd1 sky130_fd_sc_hd__decap_3
XFILLER_18_138 vssd1 vssd1 vccd1 vccd1 sky130_fd_sc_hd__fill_2
XFILLER_26_193 vssd1 vssd1 vccd1 vccd1 sky130_fd_sc_hd__fill_2
XFILLER_41_163 vssd1 vssd1 vccd1 vccd1 sky130_fd_sc_hd__fill_4
Xrebuffer180 _1281_/X vssd1 vssd1 vccd1 vccd1 _1315_/A sky130_fd_sc_hd__buf_2
X_1310_ _1313_/A _1313_/B vssd1 vssd1 vccd1 vccd1 _1439_/B sky130_fd_sc_hd__nand2_2
X_1241_ _1294_/A _1239_/Y _1240_/Y vssd1 vssd1 vccd1 vccd1 _1241_/Y sky130_fd_sc_hd__o21bai_2
X_1172_ _1602_/Q _1209_/A vssd1 vssd1 vccd1 vccd1 _1173_/A sky130_fd_sc_hd__nor2_2
XFILLER_32_141 vssd1 vssd1 vccd1 vccd1 sky130_fd_sc_hd__fill_8
X_0956_ _1616_/Q _0956_/B vssd1 vssd1 vccd1 vccd1 _0957_/B sky130_fd_sc_hd__nand2_2
X_0887_ _1615_/Q _0887_/B vssd1 vssd1 vccd1 vccd1 _0951_/A sky130_fd_sc_hd__and2_2
XFILLER_46_27 vssd1 vssd1 vccd1 vccd1 sky130_fd_sc_hd__fill_1
XFILLER_46_38 vssd1 vccd1 vssd1 vccd1 sky130_ef_sc_hd__decap_40_12
X_1508_ _1508_/A _1508_/B vssd1 vssd1 vccd1 vccd1 _1624_/D sky130_fd_sc_hd__xnor2_2
X_1439_ _1439_/A _1439_/B vssd1 vssd1 vccd1 vccd1 _1439_/X sky130_fd_sc_hd__xor2_2
XFILLER_23_185 vssd1 vssd1 vccd1 vccd1 sky130_fd_sc_hd__fill_1
Xteam_04_120 vssd1 vssd1 vccd1 vccd1 gpio_out[6] team_04_120/LO sky130_fd_sc_hd__conb_1
XFILLER_46_277 vssd1 vssd1 vccd1 vccd1 sky130_fd_sc_hd__fill_2
XFILLER_14_141 vssd1 vssd1 vccd1 vccd1 sky130_fd_sc_hd__fill_2
XFILLER_14_152 vssd1 vssd1 vccd1 vccd1 sky130_fd_sc_hd__fill_2
X_0810_ _0810_/A _0810_/B vssd1 vssd1 vccd1 vccd1 _0810_/Y sky130_fd_sc_hd__nor2_2
XANTENNA__1213__A1 _1376_/A vssd1 vssd1 vccd1 vccd1 sky130_fd_sc_hd__diode_2
X_1224_ _1224_/A _1224_/B vssd1 vssd1 vccd1 vccd1 _1224_/X sky130_fd_sc_hd__xor2_4
XFILLER_37_288 vssd1 vssd1 vccd1 vccd1 sky130_fd_sc_hd__fill_8
X_1155_ _1181_/B vssd1 vssd1 vccd1 vccd1 _1220_/A sky130_fd_sc_hd__inv_2
X_1086_ _1604_/Q _1086_/B vssd1 vssd1 vccd1 vccd1 _1086_/X sky130_fd_sc_hd__xor2_4
X_0939_ _1008_/C _1006_/A vssd1 vssd1 vccd1 vccd1 _0939_/Y sky130_fd_sc_hd__nor2_2
XTAP_TAPCELL_ROW_7_137 vssd1 vccd1 sky130_fd_sc_hd__tapvpwrvgnd_1
XFILLER_43_225 vssd1 vssd1 vccd1 vccd1 sky130_fd_sc_hd__fill_2
Xclkbuf_4_5_0_clk clkbuf_0_clk/X vssd1 vssd1 vccd1 vccd1 clkload5/A sky130_fd_sc_hd__clkbuf_8
XFILLER_11_133 vssd1 vssd1 vccd1 vccd1 sky130_fd_sc_hd__fill_2
XFILLER_11_199 vssd1 vssd1 vccd1 vccd1 sky130_fd_sc_hd__fill_4
XFILLER_7_137 vssd1 vssd1 vccd1 vccd1 sky130_fd_sc_hd__fill_2
XPHY_EDGE_ROW_5_Left_52 vssd1 vssd1 vccd1 vccd1 sky130_fd_sc_hd__decap_3
XTAP_TAPCELL_ROW_12_161 vssd1 vccd1 sky130_fd_sc_hd__tapvpwrvgnd_1
XFILLER_8_97 vssd1 vssd1 vccd1 vccd1 sky130_fd_sc_hd__fill_4
XFILLER_6_170 vssd1 vccd1 vssd1 vccd1 sky130_ef_sc_hd__decap_40_12
X_1207_ _1602_/Q _1243_/C vssd1 vssd1 vccd1 vccd1 _1267_/A sky130_fd_sc_hd__xor2_4
XFILLER_43_28 vssd1 vssd1 vccd1 vccd1 sky130_fd_sc_hd__fill_1
X_1138_ _1142_/A2 _1135_/X _1139_/A _1183_/A vssd1 vssd1 vccd1 vccd1 _1138_/X sky130_fd_sc_hd__a211o_4
X_1069_ _1127_/A vssd1 vssd1 vccd1 vccd1 _1069_/Y sky130_fd_sc_hd__inv_2
XTAP_TAPCELL_ROW_35_275 vssd1 vccd1 sky130_fd_sc_hd__tapvpwrvgnd_1
XPHY_EDGE_ROW_31_Left_78 vssd1 vssd1 vccd1 vccd1 sky130_fd_sc_hd__decap_3
XFILLER_16_203 vssd1 vssd1 vccd1 vccd1 sky130_fd_sc_hd__fill_1
XTAP_TAPCELL_ROW_26_231 vssd1 vccd1 sky130_fd_sc_hd__tapvpwrvgnd_1
XFILLER_3_173 vssd1 vssd1 vccd1 vccd1 sky130_fd_sc_hd__fill_2
XFILLER_21_283 vssd1 vssd1 vccd1 vccd1 sky130_fd_sc_hd__fill_1
XFILLER_21_294 vssd1 vssd1 vccd1 vccd1 sky130_fd_sc_hd__fill_4
XFILLER_0_121 vssd1 vssd1 vccd1 vccd1 sky130_fd_sc_hd__fill_4
XFILLER_28_72 vssd1 vccd1 vssd1 vccd1 sky130_ef_sc_hd__decap_40_12
XTAP_TAPCELL_ROW_46_337 vssd1 vccd1 sky130_fd_sc_hd__tapvpwrvgnd_1
X_1610_ _1612_/CLK _1610_/D fanout64/X vssd1 vssd1 vccd1 vccd1 _1610_/Q sky130_fd_sc_hd__dfrtp_2
XANTENNA_rebuffer175_A _1265_/B vssd1 vssd1 vccd1 vccd1 sky130_fd_sc_hd__diode_2
XFILLER_5_43 vssd1 vccd1 vssd1 vccd1 sky130_ef_sc_hd__decap_40_12
XFILLER_5_76 vssd1 vssd1 vccd1 vccd1 sky130_fd_sc_hd__fill_8
X_1541_ _1540_/A _1540_/B _1540_/Y _1539_/A vssd1 vssd1 vccd1 vccd1 _1635_/D sky130_fd_sc_hd__o211a_2
X_1472_ _1464_/B _1464_/A _1330_/B vssd1 vssd1 vccd1 vccd1 _1472_/X sky130_fd_sc_hd__o21ba_4
XFILLER_39_158 vssd1 vssd1 vccd1 vccd1 sky130_fd_sc_hd__fill_1
XFILLER_40_29 vssd1 vssd1 vccd1 vccd1 sky130_fd_sc_hd__fill_1
Xhold243 _1544_/Y vssd1 vssd1 vccd1 vccd1 _1545_/B sky130_fd_sc_hd__dlygate4sd3_1
Xhold254 _1637_/Q vssd1 vssd1 vccd1 vccd1 _1542_/A sky130_fd_sc_hd__dlygate4sd3_1
Xhold265 _1596_/Q vssd1 vssd1 vccd1 vccd1 hold265/X sky130_fd_sc_hd__dlygate4sd3_1
Xteam_04_93 vssd1 vssd1 vccd1 vccd1 team_04_93/HI gpio_out[29] sky130_fd_sc_hd__conb_1
Xteam_04_82 vssd1 vssd1 vccd1 vccd1 team_04_82/HI gpio_out[18] sky130_fd_sc_hd__conb_1
Xteam_04_71 vssd1 vssd1 vccd1 vccd1 team_04_71/HI gpio_oeb[11] sky130_fd_sc_hd__conb_1
XTAP_TAPCELL_ROW_43_318 vssd1 vccd1 sky130_fd_sc_hd__tapvpwrvgnd_1
XFILLER_14_85 vssd1 vssd1 vccd1 vccd1 sky130_fd_sc_hd__fill_2
XFILLER_5_268 vssd1 vccd1 vssd1 vccd1 sky130_ef_sc_hd__decap_40_12
XPHY_EDGE_ROW_34_Left_81 vssd1 vssd1 vccd1 vccd1 sky130_fd_sc_hd__decap_3
XFILLER_44_194 vssd1 vssd1 vccd1 vccd1 sky130_fd_sc_hd__fill_2
X_0972_ _0972_/A _0972_/B vssd1 vssd1 vccd1 vccd1 _0976_/B sky130_fd_sc_hd__nand2_2
X_1524_ _1629_/Q _1519_/A _1539_/A _1523_/X vssd1 vssd1 vccd1 vccd1 _1629_/D sky130_fd_sc_hd__a31o_2
X_1455_ _1456_/A _1448_/B _1448_/C _1456_/B vssd1 vssd1 vccd1 vccd1 _1455_/X sky130_fd_sc_hd__a31o_2
X_1386_ _1384_/X _1383_/Y _1385_/X _1378_/B vssd1 vssd1 vccd1 vccd1 _1386_/X sky130_fd_sc_hd__o22a_2
XANTENNA__1614__RESET_B fanout64/X vssd1 vssd1 vccd1 vccd1 sky130_fd_sc_hd__diode_2
Xrebuffer170 _1360_/Y vssd1 vssd1 vccd1 vccd1 _1466_/B sky130_fd_sc_hd__buf_6
Xrebuffer181 _1210_/A2 vssd1 vssd1 vccd1 vccd1 _1216_/A3 sky130_fd_sc_hd__buf_4
XFILLER_1_260 vssd1 vssd1 vccd1 vccd1 sky130_fd_sc_hd__fill_2
X_1240_ _1240_/A _1240_/B vssd1 vssd1 vccd1 vccd1 _1240_/Y sky130_fd_sc_hd__xnor2_2
X_1171_ _1603_/Q _1174_/B vssd1 vssd1 vccd1 vccd1 _1209_/A sky130_fd_sc_hd__xnor2_4
X_0955_ _0984_/A _0976_/A vssd1 vssd1 vccd1 vccd1 _0970_/A sky130_fd_sc_hd__nor2_2
X_0886_ _0861_/C _0883_/X _0884_/X _0885_/X _1615_/Q vssd1 vssd1 vccd1 vccd1 _0888_/B
+ sky130_fd_sc_hd__o41a_2
X_1507_ _1508_/B _1507_/B vssd1 vssd1 vccd1 vccd1 _1623_/D sky130_fd_sc_hd__and2_2
Xmax_cap29 _1009_/D vssd1 vssd1 vccd1 vccd1 _1065_/A sky130_fd_sc_hd__buf_2
X_1438_ _1462_/B1 _1434_/Y _1437_/Y _1463_/B2 _1609_/Q vssd1 vssd1 vccd1 vccd1 _1609_/D
+ sky130_fd_sc_hd__a32o_2
X_1369_ _1599_/Q _1368_/C _1600_/Q vssd1 vssd1 vccd1 vccd1 _1369_/Y sky130_fd_sc_hd__a21oi_2
Xteam_04_121 vssd1 vssd1 vccd1 vccd1 gpio_out[7] team_04_121/LO sky130_fd_sc_hd__conb_1
Xteam_04_110 vssd1 vssd1 vccd1 vccd1 gpio_oeb[24] team_04_110/LO sky130_fd_sc_hd__conb_1
XFILLER_36_83 vssd1 vssd1 vccd1 vccd1 sky130_fd_sc_hd__fill_1
XFILLER_46_223 vssd1 vssd1 vccd1 vccd1 sky130_fd_sc_hd__fill_1
X_1223_ _1199_/B _1223_/B _1224_/A vssd1 vssd1 vccd1 vccd1 _1238_/S sky130_fd_sc_hd__and3b_2
X_1154_ _1154_/A _1154_/B vssd1 vssd1 vccd1 vccd1 _1181_/B sky130_fd_sc_hd__xnor2_4
XFILLER_37_278 vssd1 vssd1 vccd1 vccd1 sky130_fd_sc_hd__fill_2
X_1085_ _1080_/A _1080_/B _1408_/A vssd1 vssd1 vccd1 vccd1 _1091_/A sky130_fd_sc_hd__a21o_2
XFILLER_20_167 vssd1 vssd1 vccd1 vccd1 sky130_fd_sc_hd__fill_1
X_0938_ _1429_/A _0938_/B vssd1 vssd1 vccd1 vccd1 _1006_/A sky130_fd_sc_hd__xnor2_4
X_0869_ _0910_/D _0910_/C _1499_/A _0950_/A vssd1 vssd1 vccd1 vccd1 _0870_/B sky130_fd_sc_hd__and4b_2
XTAP_TAPCELL_ROW_7_138 vssd1 vccd1 sky130_fd_sc_hd__tapvpwrvgnd_1
XFILLER_28_267 vssd1 vssd1 vccd1 vccd1 sky130_fd_sc_hd__fill_4
XFILLER_22_85 vssd1 vssd1 vccd1 vccd1 sky130_fd_sc_hd__fill_2
XFILLER_34_215 vssd1 vssd1 vccd1 vccd1 sky130_fd_sc_hd__fill_1
XFILLER_34_226 vssd1 vssd1 vccd1 vccd1 sky130_fd_sc_hd__fill_4
XTAP_TAPCELL_ROW_12_162 vssd1 vccd1 sky130_fd_sc_hd__tapvpwrvgnd_1
XFILLER_6_182 vssd1 vssd1 vccd1 vccd1 sky130_fd_sc_hd__fill_4
XTAP_TAPCELL_ROW_4_119 vssd1 vccd1 sky130_fd_sc_hd__tapvpwrvgnd_1
XANTENNA_clkbuf_4_7_0_clk_A clkbuf_0_clk/X vssd1 vssd1 vccd1 vccd1 sky130_fd_sc_hd__diode_2
X_1206_ _1192_/A _1210_/A2 _1602_/Q vssd1 vssd1 vccd1 vccd1 _1209_/B sky130_fd_sc_hd__a21o_4
X_1137_ _1135_/X _1142_/A2 _1183_/A vssd1 vssd1 vccd1 vccd1 _1150_/A sky130_fd_sc_hd__a21o_4
XFILLER_33_281 vssd1 vssd1 vccd1 vccd1 sky130_fd_sc_hd__fill_1
X_1068_ _1068_/A _1068_/B vssd1 vssd1 vccd1 vccd1 _1127_/A sky130_fd_sc_hd__xor2_2
XTAP_TAPCELL_ROW_35_276 vssd1 vccd1 sky130_fd_sc_hd__tapvpwrvgnd_1
XFILLER_16_259 vssd1 vssd1 vccd1 vccd1 sky130_fd_sc_hd__fill_2
XFILLER_31_218 vssd1 vssd1 vccd1 vccd1 sky130_fd_sc_hd__fill_2
XTAP_TAPCELL_ROW_26_232 vssd1 vccd1 sky130_fd_sc_hd__tapvpwrvgnd_1
XFILLER_33_51 vssd1 vssd1 vccd1 vccd1 sky130_fd_sc_hd__fill_4
XFILLER_33_84 vssd1 vssd1 vccd1 vccd1 sky130_fd_sc_hd__fill_2
XFILLER_30_273 vssd1 vssd1 vccd1 vccd1 sky130_fd_sc_hd__fill_2
Xclkbuf_4_4_0_clk clkbuf_0_clk/X vssd1 vssd1 vccd1 vccd1 clkload4/A sky130_fd_sc_hd__clkbuf_8
XTAP_TAPCELL_ROW_0_100 vssd1 vccd1 sky130_fd_sc_hd__tapvpwrvgnd_1
XTAP_TAPCELL_ROW_46_338 vssd1 vccd1 sky130_fd_sc_hd__tapvpwrvgnd_1
XFILLER_5_55 vssd1 vssd1 vccd1 vccd1 sky130_fd_sc_hd__fill_1
X_1540_ _1540_/A _1540_/B vssd1 vssd1 vccd1 vccd1 _1540_/Y sky130_fd_sc_hd__nand2_2
X_1471_ _0875_/Y _1467_/X _1470_/Y _1515_/A1 _1613_/Q vssd1 vssd1 vccd1 vccd1 _1613_/D
+ sky130_fd_sc_hd__a32o_2
Xhold233 _1588_/Q vssd1 vssd1 vccd1 vccd1 _1587_/D sky130_fd_sc_hd__dlygate4sd3_1
Xhold244 _1639_/Q vssd1 vssd1 vccd1 vccd1 _1548_/A sky130_fd_sc_hd__dlygate4sd3_1
Xhold255 _1624_/Q vssd1 vssd1 vccd1 vccd1 _1508_/A sky130_fd_sc_hd__dlygate4sd3_1
Xhold266 _1642_/Q vssd1 vssd1 vccd1 vccd1 hold266/X sky130_fd_sc_hd__dlygate4sd3_1
Xteam_04_72 vssd1 vssd1 vccd1 vccd1 team_04_72/HI gpio_oeb[12] sky130_fd_sc_hd__conb_1
Xteam_04_94 vssd1 vssd1 vccd1 vccd1 team_04_94/HI gpio_out[30] sky130_fd_sc_hd__conb_1
Xteam_04_83 vssd1 vssd1 vccd1 vccd1 team_04_83/HI gpio_out[19] sky130_fd_sc_hd__conb_1
XFILLER_14_97 vssd1 vssd1 vccd1 vccd1 sky130_fd_sc_hd__fill_2
XFILLER_5_225 vssd1 vssd1 vccd1 vccd1 sky130_fd_sc_hd__fill_8
XFILLER_5_258 vssd1 vssd1 vccd1 vccd1 sky130_fd_sc_hd__fill_2
XANTENNA_clkbuf_4_15_0_clk_A clkbuf_0_clk/X vssd1 vssd1 vccd1 vccd1 sky130_fd_sc_hd__diode_2
XFILLER_30_85 vssd1 vssd1 vccd1 vccd1 sky130_fd_sc_hd__fill_4
XFILLER_39_61 vssd1 vssd1 vccd1 vccd1 sky130_fd_sc_hd__fill_2
X_0971_ _0949_/Y _1016_/C _0972_/A vssd1 vssd1 vccd1 vccd1 _0971_/Y sky130_fd_sc_hd__o21ai_2
X_1523_ _1595_/Q _1539_/A _1523_/C vssd1 vssd1 vccd1 vccd1 _1523_/X sky130_fd_sc_hd__and3_2
X_1454_ _1462_/B1 _1378_/B _1449_/Y _1453_/X vssd1 vssd1 vccd1 vccd1 _1611_/D sky130_fd_sc_hd__a31o_2
XFILLER_27_107 vssd1 vssd1 vccd1 vccd1 sky130_fd_sc_hd__fill_4
X_1385_ _1602_/Q _1392_/C vssd1 vssd1 vccd1 vccd1 _1385_/X sky130_fd_sc_hd__xor2_2
XANTENNA__1608__CLK clkload8/A vssd1 vssd1 vccd1 vccd1 sky130_fd_sc_hd__diode_2
XFILLER_35_151 vssd1 vssd1 vccd1 vccd1 sky130_fd_sc_hd__fill_2
XFILLER_25_52 vssd1 vssd1 vccd1 vccd1 sky130_fd_sc_hd__fill_4
XFILLER_26_195 vssd1 vssd1 vccd1 vccd1 sky130_fd_sc_hd__fill_1
XFILLER_41_95 vssd1 vssd1 vccd1 vccd1 sky130_fd_sc_hd__fill_2
Xrebuffer160 _0912_/B vssd1 vssd1 vccd1 vccd1 _0928_/A2 sky130_fd_sc_hd__buf_2
Xrebuffer182 _1192_/B vssd1 vssd1 vccd1 vccd1 _1200_/A2 sky130_fd_sc_hd__buf_2
XFILLER_1_250 vssd1 vssd1 vccd1 vccd1 sky130_fd_sc_hd__fill_4
X_1170_ _1170_/A _1170_/B vssd1 vssd1 vccd1 vccd1 _1170_/Y sky130_fd_sc_hd__xnor2_2
X_0954_ _1618_/Q _0954_/B vssd1 vssd1 vccd1 vccd1 _0976_/A sky130_fd_sc_hd__xor2_2
X_0885_ _1621_/Q _1622_/Q _1429_/A _1609_/Q vssd1 vssd1 vccd1 vccd1 _0885_/X sky130_fd_sc_hd__or4_2
X_1506_ _1623_/Q _1506_/B vssd1 vssd1 vccd1 vccd1 _1507_/B sky130_fd_sc_hd__or2_2
X_1437_ _1435_/Y _1460_/D _0893_/C vssd1 vssd1 vccd1 vccd1 _1437_/Y sky130_fd_sc_hd__o21ai_2
X_1368_ _1599_/Q _1600_/Q _1368_/C vssd1 vssd1 vccd1 vccd1 _1376_/B sky130_fd_sc_hd__and3_2
X_1299_ _1302_/C vssd1 vssd1 vccd1 vccd1 _1299_/Y sky130_fd_sc_hd__inv_2
XTAP_TAPCELL_ROW_18_190 vssd1 vccd1 sky130_fd_sc_hd__tapvpwrvgnd_1
XFILLER_11_98 vssd1 vssd1 vccd1 vccd1 sky130_fd_sc_hd__fill_4
Xteam_04_122 vssd1 vssd1 vccd1 vccd1 gpio_out[15] team_04_122/LO sky130_fd_sc_hd__conb_1
Xteam_04_111 vssd1 vssd1 vccd1 vccd1 gpio_oeb[25] team_04_111/LO sky130_fd_sc_hd__conb_1
Xteam_04_100 vssd1 vssd1 vccd1 vccd1 gpio_oeb[2] team_04_100/LO sky130_fd_sc_hd__conb_1
XFILLER_14_110 vssd1 vssd1 vccd1 vccd1 sky130_fd_sc_hd__fill_8
XFILLER_46_279 vssd1 vssd1 vccd1 vccd1 sky130_fd_sc_hd__fill_1
X_1222_ _1222_/A _1282_/B vssd1 vssd1 vccd1 vccd1 _1233_/B sky130_fd_sc_hd__nor2_2
X_1153_ _1093_/Y _1096_/X _1174_/B vssd1 vssd1 vccd1 vccd1 _1154_/B sky130_fd_sc_hd__a21o_2
X_1084_ _1106_/B _1124_/B _1104_/A _1083_/A vssd1 vssd1 vccd1 vccd1 _1139_/A sky130_fd_sc_hd__o2bb2a_2
XANTENNA__1437__B1 _0893_/C vssd1 vssd1 vccd1 vccd1 sky130_fd_sc_hd__diode_2
XANTENNA_clkbuf_4_3_0_clk_A clkbuf_0_clk/X vssd1 vssd1 vccd1 vccd1 sky130_fd_sc_hd__diode_2
X_0937_ _0937_/A _1609_/Q vssd1 vssd1 vccd1 vccd1 _0940_/A sky130_fd_sc_hd__xnor2_2
X_0868_ _1625_/Q _1626_/Q vssd1 vssd1 vccd1 vccd1 _0910_/D sky130_fd_sc_hd__or2_4
X_0799_ _1717_/A vssd1 vssd1 vccd1 vccd1 _1716_/A sky130_fd_sc_hd__inv_2
XFILLER_28_246 vssd1 vssd1 vccd1 vccd1 sky130_fd_sc_hd__fill_2
XFILLER_43_216 vssd1 vssd1 vccd1 vccd1 sky130_fd_sc_hd__fill_1
XFILLER_43_227 vssd1 vssd1 vccd1 vccd1 sky130_fd_sc_hd__fill_1
XFILLER_11_102 vssd1 vssd1 vccd1 vccd1 sky130_fd_sc_hd__fill_2
XFILLER_11_157 vssd1 vssd1 vccd1 vccd1 sky130_fd_sc_hd__fill_2
XFILLER_22_42 vssd1 vccd1 vssd1 vccd1 sky130_ef_sc_hd__decap_40_12
XFILLER_7_117 vssd1 vssd1 vccd1 vccd1 sky130_fd_sc_hd__fill_2
XFILLER_19_279 vssd1 vssd1 vccd1 vccd1 sky130_fd_sc_hd__fill_1
XFILLER_34_238 vssd1 vssd1 vccd1 vccd1 sky130_fd_sc_hd__fill_4
XFILLER_8_22 vssd1 vssd1 vccd1 vccd1 sky130_fd_sc_hd__fill_4
XFILLER_8_11 vssd1 vssd1 vccd1 vccd1 sky130_fd_sc_hd__fill_2
XTAP_TAPCELL_ROW_12_163 vssd1 vccd1 sky130_fd_sc_hd__tapvpwrvgnd_1
X_1205_ _1205_/A _1205_/B vssd1 vssd1 vccd1 vccd1 _1218_/A sky130_fd_sc_hd__xnor2_2
X_1136_ _1135_/X _1133_/Y _1183_/A vssd1 vssd1 vccd1 vccd1 _1136_/Y sky130_fd_sc_hd__a21oi_4
X_1067_ _1068_/A _1068_/B vssd1 vssd1 vccd1 vccd1 _1067_/X sky130_fd_sc_hd__and2b_2
XTAP_TAPCELL_ROW_35_277 vssd1 vccd1 sky130_fd_sc_hd__tapvpwrvgnd_1
XFILLER_16_227 vssd1 vssd1 vccd1 vccd1 sky130_fd_sc_hd__fill_1
XFILLER_17_53 vssd1 vssd1 vccd1 vccd1 sky130_fd_sc_hd__fill_2
XTAP_TAPCELL_ROW_26_233 vssd1 vccd1 sky130_fd_sc_hd__tapvpwrvgnd_1
XFILLER_33_96 vssd1 vssd1 vccd1 vccd1 sky130_fd_sc_hd__fill_2
XTAP_TAPCELL_ROW_0_101 vssd1 vccd1 sky130_fd_sc_hd__tapvpwrvgnd_1
XANTENNA__1608__RESET_B load_slew58/X vssd1 vssd1 vccd1 vccd1 sky130_fd_sc_hd__diode_2
X_1119_ _1128_/A vssd1 vssd1 vccd1 vccd1 _1145_/A sky130_fd_sc_hd__inv_2
XTAP_TAPCELL_ROW_23_214 vssd1 vccd1 sky130_fd_sc_hd__tapvpwrvgnd_1
XPHY_EDGE_ROW_17_Right_17 vssd1 vssd1 vccd1 vccd1 sky130_fd_sc_hd__decap_3
XFILLER_0_167 vssd1 vssd1 vccd1 vccd1 sky130_fd_sc_hd__fill_1
XFILLER_0_178 vssd1 vssd1 vccd1 vccd1 sky130_fd_sc_hd__fill_4
XPHY_EDGE_ROW_26_Right_26 vssd1 vssd1 vccd1 vccd1 sky130_fd_sc_hd__decap_3
XFILLER_0_189 vssd1 vssd1 vccd1 vccd1 sky130_fd_sc_hd__fill_4
XFILLER_28_85 vssd1 vssd1 vccd1 vccd1 sky130_fd_sc_hd__fill_8
XANTENNA_clkbuf_4_11_0_clk_A clkbuf_0_clk/X vssd1 vssd1 vccd1 vccd1 sky130_fd_sc_hd__diode_2
XPHY_EDGE_ROW_35_Right_35 vssd1 vssd1 vccd1 vccd1 sky130_fd_sc_hd__decap_3
X_1470_ _1468_/Y _1475_/B _0891_/X vssd1 vssd1 vccd1 vccd1 _1470_/Y sky130_fd_sc_hd__o21ai_2
XPHY_EDGE_ROW_44_Right_44 vssd1 vssd1 vccd1 vccd1 sky130_fd_sc_hd__decap_3
X_1599_ clkload2/A _1599_/D fanout56/X vssd1 vssd1 vccd1 vccd1 _1599_/Q sky130_fd_sc_hd__dfrtp_2
Xhold234 _1591_/Q vssd1 vssd1 vccd1 vccd1 _1590_/D sky130_fd_sc_hd__dlygate4sd3_1
Xhold245 _1651_/Q vssd1 vssd1 vccd1 vccd1 _1581_/A sky130_fd_sc_hd__dlygate4sd3_1
Xhold256 _1647_/Q vssd1 vssd1 vccd1 vccd1 _1572_/A sky130_fd_sc_hd__dlygate4sd3_1
Xhold267 _1621_/Q vssd1 vssd1 vccd1 vccd1 hold267/X sky130_fd_sc_hd__dlygate4sd3_1
Xteam_04_95 vssd1 vssd1 vccd1 vccd1 team_04_95/HI gpio_out[31] sky130_fd_sc_hd__conb_1
Xteam_04_84 vssd1 vssd1 vccd1 vccd1 team_04_84/HI gpio_out[20] sky130_fd_sc_hd__conb_1
Xteam_04_73 vssd1 vssd1 vccd1 vccd1 team_04_73/HI gpio_oeb[13] sky130_fd_sc_hd__conb_1
Xclkbuf_4_3_0_clk clkbuf_0_clk/X vssd1 vssd1 vccd1 vccd1 clkload3/A sky130_fd_sc_hd__clkbuf_8
X_0970_ _0970_/A _0972_/B vssd1 vssd1 vccd1 vccd1 _1016_/C sky130_fd_sc_hd__and2_2
X_1522_ _1528_/B _0836_/X _0830_/C vssd1 vssd1 vccd1 vccd1 _1523_/C sky130_fd_sc_hd__a21o_2
X_1453_ _1380_/A _1450_/X _1452_/Y _1463_/B2 _1460_/B vssd1 vssd1 vccd1 vccd1 _1453_/X
+ sky130_fd_sc_hd__a32o_2
X_1384_ _1373_/A _1388_/B _1390_/A2 _1373_/C _0892_/A vssd1 vssd1 vccd1 vccd1 _1384_/X
+ sky130_fd_sc_hd__a41o_2
XFILLER_4_9 vssd1 vssd1 vccd1 vccd1 sky130_fd_sc_hd__fill_4
XFILLER_18_108 vssd1 vssd1 vccd1 vccd1 sky130_fd_sc_hd__fill_1
XFILLER_26_141 vssd1 vssd1 vccd1 vccd1 sky130_fd_sc_hd__fill_4
XFILLER_26_185 vssd1 vssd1 vccd1 vccd1 sky130_fd_sc_hd__fill_8
XFILLER_41_111 vssd1 vssd1 vccd1 vccd1 sky130_fd_sc_hd__fill_1
XFILLER_41_188 vssd1 vccd1 vssd1 vccd1 sky130_ef_sc_hd__decap_40_12
Xrebuffer150 _1266_/X vssd1 vssd1 vccd1 vccd1 _1347_/A sky130_fd_sc_hd__buf_2
Xrebuffer161 _1150_/A vssd1 vssd1 vccd1 vccd1 _1159_/C sky130_fd_sc_hd__buf_2
Xrebuffer172 _0995_/Y vssd1 vssd1 vccd1 vccd1 _1032_/A sky130_fd_sc_hd__buf_2
Xrebuffer183 _1242_/X vssd1 vssd1 vccd1 vccd1 _1306_/A1 sky130_fd_sc_hd__buf_2
XFILLER_1_262 vssd1 vssd1 vccd1 vccd1 sky130_fd_sc_hd__fill_1
XFILLER_1_295 vssd1 vssd1 vccd1 vccd1 sky130_fd_sc_hd__fill_1
XFILLER_2_24 vssd1 vssd1 vccd1 vccd1 sky130_fd_sc_hd__fill_4
XFILLER_2_79 vssd1 vssd1 vccd1 vccd1 sky130_fd_sc_hd__fill_4
XFILLER_32_111 vssd1 vssd1 vccd1 vccd1 sky130_fd_sc_hd__fill_1
X_0953_ _1616_/Q _1617_/Q _0956_/B vssd1 vssd1 vccd1 vccd1 _0954_/B sky130_fd_sc_hd__or3_4
X_0884_ _1624_/Q _1623_/Q _1596_/Q _1597_/Q vssd1 vssd1 vccd1 vccd1 _0884_/X sky130_fd_sc_hd__or4_2
X_1505_ _1623_/Q _1506_/B vssd1 vssd1 vccd1 vccd1 _1508_/B sky130_fd_sc_hd__nand2_2
X_1436_ _1608_/Q _1609_/Q _1436_/C vssd1 vssd1 vccd1 vccd1 _1460_/D sky130_fd_sc_hd__and3_2
X_1367_ _1372_/A1 _1388_/C _1364_/Y _0892_/A vssd1 vssd1 vccd1 vccd1 _1367_/X sky130_fd_sc_hd__a211o_4
XFILLER_23_100 vssd1 vssd1 vccd1 vccd1 sky130_fd_sc_hd__fill_4
X_1298_ _1298_/A _1439_/A _1313_/A vssd1 vssd1 vccd1 vccd1 _1302_/C sky130_fd_sc_hd__nand3_2
XFILLER_23_177 vssd1 vssd1 vccd1 vccd1 sky130_fd_sc_hd__fill_8
XTAP_TAPCELL_ROW_18_191 vssd1 vccd1 sky130_fd_sc_hd__tapvpwrvgnd_1
Xteam_04_112 vssd1 vssd1 vccd1 vccd1 gpio_oeb[26] team_04_112/LO sky130_fd_sc_hd__conb_1
Xteam_04_101 vssd1 vssd1 vccd1 vccd1 gpio_oeb[3] team_04_101/LO sky130_fd_sc_hd__conb_1
XFILLER_36_85 vssd1 vssd1 vccd1 vccd1 sky130_fd_sc_hd__fill_2
X_1221_ _1220_/A _1234_/B _1222_/A vssd1 vssd1 vccd1 vccd1 _1235_/A sky130_fd_sc_hd__o21ba_2
X_1152_ _1152_/A _1152_/B vssd1 vssd1 vccd1 vccd1 _1181_/D sky130_fd_sc_hd__nor2_4
X_1083_ _1083_/A _1102_/A _1083_/C vssd1 vssd1 vccd1 vccd1 _1124_/B sky130_fd_sc_hd__and3_2
X_0936_ _1416_/A _0938_/B _0936_/C vssd1 vssd1 vccd1 vccd1 _0940_/B sky130_fd_sc_hd__nor3_4
X_0867_ _1596_/Q _1597_/Q _1598_/Q _0893_/B vssd1 vssd1 vccd1 vccd1 _1368_/C sky130_fd_sc_hd__and4_2
X_0798_ _1595_/Q vssd1 vssd1 vccd1 vccd1 _1519_/A sky130_fd_sc_hd__inv_2
XFILLER_9_192 vssd1 vssd1 vccd1 vccd1 sky130_fd_sc_hd__fill_1
XFILLER_28_203 vssd1 vssd1 vccd1 vccd1 sky130_fd_sc_hd__fill_4
X_1419_ _1420_/A2 _1413_/A _1355_/A vssd1 vssd1 vccd1 vccd1 _1419_/Y sky130_fd_sc_hd__a21oi_2
XFILLER_36_291 vssd1 vssd1 vccd1 vccd1 sky130_fd_sc_hd__fill_8
XFILLER_22_87 vssd1 vssd1 vccd1 vccd1 sky130_fd_sc_hd__fill_1
XFILLER_10_180 vssd1 vssd1 vccd1 vccd1 sky130_fd_sc_hd__fill_2
X_1204_ _1173_/Y _1178_/Y _1192_/B _1192_/A vssd1 vssd1 vccd1 vccd1 _1205_/A sky130_fd_sc_hd__a22oi_2
XFILLER_33_250 vssd1 vssd1 vccd1 vccd1 sky130_fd_sc_hd__fill_1
XFILLER_40_209 vssd1 vssd1 vccd1 vccd1 sky130_fd_sc_hd__fill_4
X_1135_ _1116_/X _1143_/A vssd1 vssd1 vccd1 vccd1 _1135_/X sky130_fd_sc_hd__and2b_2
X_1066_ _1065_/A _1063_/B _1031_/B vssd1 vssd1 vccd1 vccd1 _1068_/B sky130_fd_sc_hd__a21oi_2
XTAP_TAPCELL_ROW_35_278 vssd1 vccd1 sky130_fd_sc_hd__tapvpwrvgnd_1
X_0919_ _0913_/A _0912_/B _0907_/X vssd1 vssd1 vccd1 vccd1 _0922_/B sky130_fd_sc_hd__a21oi_4
XPHY_EDGE_ROW_9_Left_56 vssd1 vssd1 vccd1 vccd1 sky130_fd_sc_hd__decap_3
XFILLER_33_86 vssd1 vssd1 vccd1 vccd1 sky130_fd_sc_hd__fill_1
XFILLER_3_110 vssd1 vssd1 vccd1 vccd1 sky130_fd_sc_hd__fill_2
XFILLER_3_165 vssd1 vssd1 vccd1 vccd1 sky130_fd_sc_hd__fill_2
XFILLER_15_261 vssd1 vssd1 vccd1 vccd1 sky130_fd_sc_hd__fill_1
XFILLER_22_209 vssd1 vssd1 vccd1 vccd1 sky130_fd_sc_hd__fill_1
XFILLER_30_275 vssd1 vssd1 vccd1 vccd1 sky130_fd_sc_hd__fill_1
XFILLER_30_297 vssd1 vssd1 vccd1 vccd1 sky130_fd_sc_hd__fill_2
XTAP_TAPCELL_ROW_32_259 vssd1 vccd1 sky130_fd_sc_hd__tapvpwrvgnd_1
XTAP_TAPCELL_ROW_0_102 vssd1 vccd1 sky130_fd_sc_hd__tapvpwrvgnd_1
X_1118_ _1139_/C _1099_/X _1139_/A vssd1 vssd1 vccd1 vccd1 _1118_/X sky130_fd_sc_hd__a21o_4
X_1049_ _1034_/B _1048_/A _1013_/Y _0983_/Y vssd1 vssd1 vccd1 vccd1 _1052_/B sky130_fd_sc_hd__o2bb2a_2
XTAP_TAPCELL_ROW_23_215 vssd1 vccd1 sky130_fd_sc_hd__tapvpwrvgnd_1
XFILLER_0_113 vssd1 vssd1 vccd1 vccd1 sky130_fd_sc_hd__fill_1
XFILLER_44_41 vssd1 vssd1 vccd1 vccd1 sky130_fd_sc_hd__fill_2
XTAP_TAPCELL_ROW_46_329 vssd1 vccd1 sky130_fd_sc_hd__tapvpwrvgnd_1
XFILLER_12_253 vssd1 vssd1 vccd1 vccd1 sky130_fd_sc_hd__fill_4
XFILLER_8_257 vssd1 vssd1 vccd1 vccd1 sky130_fd_sc_hd__fill_1
XFILLER_5_13 vssd1 vssd1 vccd1 vccd1 sky130_fd_sc_hd__fill_1
XFILLER_39_117 vssd1 vssd1 vccd1 vccd1 sky130_fd_sc_hd__fill_2
Xhold235 _1585_/Q vssd1 vssd1 vccd1 vccd1 _1584_/D sky130_fd_sc_hd__dlygate4sd3_1
X_1598_ clkload2/A _1598_/D fanout56/X vssd1 vssd1 vccd1 vccd1 _1598_/Q sky130_fd_sc_hd__dfrtp_2
Xhold246 _1648_/Q vssd1 vssd1 vccd1 vccd1 hold246/X sky130_fd_sc_hd__dlygate4sd3_1
Xhold257 _1655_/Q vssd1 vssd1 vccd1 vccd1 hold257/X sky130_fd_sc_hd__dlygate4sd3_1
Xteam_04_96 vssd1 vssd1 vccd1 vccd1 team_04_96/HI gpio_out[32] sky130_fd_sc_hd__conb_1
Xteam_04_85 vssd1 vssd1 vccd1 vccd1 team_04_85/HI gpio_out[21] sky130_fd_sc_hd__conb_1
Xteam_04_74 vssd1 vssd1 vccd1 vccd1 team_04_74/HI gpio_oeb[14] sky130_fd_sc_hd__conb_1
XFILLER_30_43 vssd1 vssd1 vccd1 vccd1 sky130_fd_sc_hd__fill_4
XFILLER_39_63 vssd1 vssd1 vccd1 vccd1 sky130_fd_sc_hd__fill_1
XFILLER_44_153 vssd1 vssd1 vccd1 vccd1 sky130_fd_sc_hd__fill_4
XTAP_TAPCELL_ROW_42_310 vssd1 vccd1 sky130_fd_sc_hd__tapvpwrvgnd_1
X_1521_ _1520_/A _1520_/Y _1521_/S vssd1 vssd1 vccd1 vccd1 _1628_/D sky130_fd_sc_hd__mux2_1
X_1452_ _1469_/C vssd1 vssd1 vccd1 vccd1 _1452_/Y sky130_fd_sc_hd__inv_2
X_1383_ _1373_/A _1390_/A2 _1373_/C _1388_/B vssd1 vssd1 vccd1 vccd1 _1383_/Y sky130_fd_sc_hd__a31oi_4
XFILLER_35_153 vssd1 vssd1 vccd1 vccd1 sky130_fd_sc_hd__fill_1
XFILLER_35_197 vssd1 vssd1 vccd1 vccd1 sky130_fd_sc_hd__fill_1
XFILLER_41_167 vssd1 vssd1 vccd1 vccd1 sky130_fd_sc_hd__fill_1
XFILLER_41_86 vssd1 vssd1 vccd1 vccd1 sky130_fd_sc_hd__fill_1
XFILLER_41_97 vssd1 vssd1 vccd1 vccd1 sky130_fd_sc_hd__fill_1
Xrebuffer140 _0941_/B vssd1 vssd1 vccd1 vccd1 _0990_/A sky130_fd_sc_hd__buf_2
Xrebuffer151 _1086_/B vssd1 vssd1 vccd1 vccd1 _1082_/C sky130_fd_sc_hd__buf_2
Xrebuffer162 _1150_/A vssd1 vssd1 vccd1 vccd1 _1175_/C1 sky130_fd_sc_hd__buf_2
Xrebuffer173 _1093_/C vssd1 vssd1 vccd1 vccd1 _1176_/A sky130_fd_sc_hd__buf_2
XPHY_EDGE_ROW_38_Left_85 vssd1 vssd1 vccd1 vccd1 sky130_fd_sc_hd__decap_3
Xrebuffer184 _1356_/X vssd1 vssd1 vccd1 vccd1 rebuffer184/X sky130_fd_sc_hd__buf_2
XPHY_EDGE_ROW_22_Left_69 vssd1 vssd1 vccd1 vccd1 sky130_fd_sc_hd__decap_3
XFILLER_17_120 vssd1 vssd1 vccd1 vccd1 sky130_fd_sc_hd__fill_2
XFILLER_17_153 vssd1 vssd1 vccd1 vccd1 sky130_fd_sc_hd__fill_1
X_0952_ _1490_/A _0956_/B vssd1 vssd1 vccd1 vccd1 _0952_/Y sky130_fd_sc_hd__nor2_2
X_1504_ _1506_/B _1504_/B vssd1 vssd1 vccd1 vccd1 _1622_/D sky130_fd_sc_hd__nor2_2
X_0883_ _1598_/Q _0883_/B _1600_/Q _0871_/X vssd1 vssd1 vccd1 vccd1 _0883_/X sky130_fd_sc_hd__or4b_2
X_1435_ _1609_/Q _1444_/C vssd1 vssd1 vccd1 vccd1 _1435_/Y sky130_fd_sc_hd__nor2_2
X_1366_ _1366_/A _1366_/B vssd1 vssd1 vccd1 vccd1 _1373_/C sky130_fd_sc_hd__nand2_2
X_1297_ _1303_/B _1322_/A vssd1 vssd1 vccd1 vccd1 _1327_/A sky130_fd_sc_hd__and2_2
XTAP_TAPCELL_ROW_18_192 vssd1 vccd1 sky130_fd_sc_hd__tapvpwrvgnd_1
Xclkbuf_4_2_0_clk clkbuf_0_clk/X vssd1 vssd1 vccd1 vccd1 clkload2/A sky130_fd_sc_hd__clkbuf_8
Xteam_04_113 vssd1 vssd1 vccd1 vccd1 gpio_oeb[27] team_04_113/LO sky130_fd_sc_hd__conb_1
Xteam_04_102 vssd1 vssd1 vccd1 vccd1 gpio_oeb[16] team_04_102/LO sky130_fd_sc_hd__conb_1
XFILLER_36_42 vssd1 vssd1 vccd1 vccd1 sky130_fd_sc_hd__fill_4
X_1220_ _1220_/A _1234_/B vssd1 vssd1 vccd1 vccd1 _1282_/B sky130_fd_sc_hd__xnor2_2
X_1151_ _1150_/C _1175_/C1 _1150_/B vssd1 vssd1 vccd1 vccd1 _1152_/B sky130_fd_sc_hd__a21oi_2
XFILLER_45_281 vssd1 vccd1 vssd1 vccd1 sky130_ef_sc_hd__decap_40_12
X_1082_ _1102_/A _1083_/C _1082_/C vssd1 vssd1 vccd1 vccd1 _1104_/A sky130_fd_sc_hd__and3_2
X_0935_ _0938_/B _0936_/C vssd1 vssd1 vccd1 vccd1 _1005_/A sky130_fd_sc_hd__or2_2
X_0866_ _1621_/Q _1622_/Q _1624_/Q _1623_/Q vssd1 vssd1 vccd1 vccd1 _0893_/B sky130_fd_sc_hd__and4_2
X_0797_ _1653_/Q vssd1 vssd1 vccd1 vccd1 _0797_/Y sky130_fd_sc_hd__inv_2
X_1418_ _1462_/B1 _1414_/X _1417_/X _1463_/B2 _1416_/A vssd1 vssd1 vccd1 vccd1 _1606_/D
+ sky130_fd_sc_hd__a32o_2
X_1349_ _1395_/A _1395_/B _1355_/A _1404_/A vssd1 vssd1 vccd1 vccd1 _1349_/X sky130_fd_sc_hd__a211o_2
XFILLER_11_104 vssd1 vssd1 vccd1 vccd1 sky130_fd_sc_hd__fill_1
XFILLER_19_204 vssd1 vssd1 vccd1 vccd1 sky130_fd_sc_hd__fill_4
XTAP_TAPCELL_ROW_6_130 vssd1 vccd1 sky130_fd_sc_hd__tapvpwrvgnd_1
XFILLER_34_207 vssd1 vssd1 vccd1 vccd1 sky130_fd_sc_hd__fill_8
XFILLER_8_46 vssd1 vssd1 vccd1 vccd1 sky130_fd_sc_hd__fill_2
XFILLER_8_13 vssd1 vssd1 vccd1 vccd1 sky130_fd_sc_hd__fill_1
XFILLER_6_130 vssd1 vssd1 vccd1 vccd1 sky130_fd_sc_hd__fill_8
XFILLER_6_141 vssd1 vssd1 vccd1 vccd1 sky130_fd_sc_hd__fill_1
XFILLER_26_3 vssd1 vssd1 vccd1 vccd1 sky130_fd_sc_hd__fill_4
X_1203_ _1203_/A _1258_/A vssd1 vssd1 vccd1 vccd1 _1285_/A sky130_fd_sc_hd__or2_2
X_1134_ _1128_/A _1128_/B _1132_/Y vssd1 vssd1 vccd1 vccd1 _1183_/B sky130_fd_sc_hd__a21o_2
XPHY_EDGE_ROW_25_Left_72 vssd1 vssd1 vccd1 vccd1 sky130_fd_sc_hd__decap_3
X_1065_ _1065_/A _1065_/B vssd1 vssd1 vccd1 vccd1 _1122_/A sky130_fd_sc_hd__xnor2_2
XANTENNA__1375__A _1376_/A vssd1 vssd1 vccd1 vccd1 sky130_fd_sc_hd__diode_2
X_0918_ _0988_/B vssd1 vssd1 vccd1 vccd1 _0918_/Y sky130_fd_sc_hd__inv_2
X_0849_ _1629_/Q _1520_/A _1630_/Q vssd1 vssd1 vccd1 vccd1 _0850_/A sky130_fd_sc_hd__and3_2
XFILLER_17_55 vssd1 vssd1 vccd1 vccd1 sky130_fd_sc_hd__fill_1
XFILLER_24_240 vssd1 vssd1 vccd1 vccd1 sky130_fd_sc_hd__fill_2
XFILLER_24_262 vssd1 vssd1 vccd1 vccd1 sky130_fd_sc_hd__fill_2
XFILLER_3_133 vssd1 vssd1 vccd1 vccd1 sky130_fd_sc_hd__fill_2
XFILLER_3_144 vssd1 vssd1 vccd1 vccd1 sky130_fd_sc_hd__fill_1
XFILLER_30_210 vssd1 vssd1 vccd1 vccd1 sky130_fd_sc_hd__fill_4
X_1117_ _1143_/A _1116_/X _1108_/X vssd1 vssd1 vccd1 vccd1 _1183_/A sky130_fd_sc_hd__a21o_4
XTAP_TAPCELL_ROW_0_103 vssd1 vccd1 sky130_fd_sc_hd__tapvpwrvgnd_1
X_1048_ _1048_/A _1048_/B vssd1 vssd1 vccd1 vccd1 _1105_/B sky130_fd_sc_hd__and2_2
XTAP_TAPCELL_ROW_23_216 vssd1 vccd1 sky130_fd_sc_hd__tapvpwrvgnd_1
XPHY_EDGE_ROW_3_Right_3 vssd1 vssd1 vccd1 vccd1 sky130_fd_sc_hd__decap_3
XFILLER_21_298 vssd1 vssd1 vccd1 vccd1 sky130_fd_sc_hd__fill_1
XFILLER_0_125 vssd1 vssd1 vccd1 vccd1 sky130_fd_sc_hd__fill_1
XFILLER_0_147 vssd1 vccd1 vssd1 vccd1 sky130_ef_sc_hd__decap_40_12
XFILLER_0_169 vssd1 vssd1 vccd1 vccd1 sky130_fd_sc_hd__fill_4
Xhold236 _1594_/Q vssd1 vssd1 vccd1 vccd1 _1593_/D sky130_fd_sc_hd__dlygate4sd3_1
Xhold247 _1574_/Y vssd1 vssd1 vccd1 vccd1 _1575_/B sky130_fd_sc_hd__dlygate4sd3_1
Xhold258 _1645_/Q vssd1 vssd1 vccd1 vccd1 hold258/X sky130_fd_sc_hd__dlygate4sd3_1
X_1597_ clkload3/A _1597_/D fanout56/X vssd1 vssd1 vccd1 vccd1 _1597_/Q sky130_fd_sc_hd__dfrtp_2
Xteam_04_97 vssd1 vssd1 vccd1 vccd1 team_04_97/HI gpio_out[33] sky130_fd_sc_hd__conb_1
Xteam_04_86 vssd1 vssd1 vccd1 vccd1 team_04_86/HI gpio_out[22] sky130_fd_sc_hd__conb_1
Xteam_04_75 vssd1 vssd1 vccd1 vccd1 team_04_75/HI gpio_oeb[15] sky130_fd_sc_hd__conb_1
XFILLER_30_55 vssd1 vssd1 vccd1 vccd1 sky130_fd_sc_hd__fill_4
XFILLER_39_97 vssd1 vccd1 vssd1 vccd1 sky130_ef_sc_hd__decap_40_12
XFILLER_44_110 vssd1 vssd1 vccd1 vccd1 sky130_fd_sc_hd__fill_2
XTAP_TAPCELL_ROW_42_311 vssd1 vccd1 sky130_fd_sc_hd__tapvpwrvgnd_1
XFILLER_4_250 vssd1 vssd1 vccd1 vccd1 sky130_fd_sc_hd__fill_2
X_1520_ _1520_/A _1653_/Q vssd1 vssd1 vccd1 vccd1 _1520_/Y sky130_fd_sc_hd__nor2_2
X_1451_ _1460_/B _1451_/B vssd1 vssd1 vccd1 vccd1 _1469_/C sky130_fd_sc_hd__and2_2
X_1382_ _1489_/A1 _1378_/B _1374_/Y _1381_/X vssd1 vssd1 vccd1 vccd1 _1601_/D sky130_fd_sc_hd__a31o_2
XFILLER_35_143 vssd1 vssd1 vccd1 vccd1 sky130_fd_sc_hd__fill_8
X_1649_ _1652_/CLK _1649_/D vssd1 vssd1 vccd1 vccd1 _1649_/Q sky130_fd_sc_hd__dfxtp_2
XANTENNA_input5_A gpio_in[3] vssd1 vssd1 vccd1 vccd1 sky130_fd_sc_hd__diode_2
XFILLER_25_33 vssd1 vssd1 vccd1 vccd1 sky130_fd_sc_hd__fill_1
XFILLER_41_21 vssd1 vssd1 vccd1 vccd1 sky130_fd_sc_hd__fill_4
XFILLER_41_43 vssd1 vccd1 vssd1 vccd1 sky130_ef_sc_hd__decap_40_12
Xrebuffer130 _1044_/Y vssd1 vssd1 vccd1 vccd1 _1060_/B1 sky130_fd_sc_hd__buf_6
Xrebuffer141 _0926_/A vssd1 vssd1 vccd1 vccd1 _0988_/B sky130_fd_sc_hd__buf_2
Xrebuffer152 _1086_/B vssd1 vssd1 vccd1 vccd1 _1106_/B sky130_fd_sc_hd__buf_4
Xrebuffer163 _1157_/Y vssd1 vssd1 vccd1 vccd1 _1201_/A sky130_fd_sc_hd__buf_2
Xrebuffer174 _1099_/X vssd1 vssd1 vccd1 vccd1 _1150_/C sky130_fd_sc_hd__buf_2
Xrebuffer196 _1390_/A2 vssd1 vssd1 vccd1 vccd1 _1373_/B sky130_fd_sc_hd__buf_6
XFILLER_17_110 vssd1 vssd1 vccd1 vccd1 sky130_fd_sc_hd__fill_2
XFILLER_17_187 vssd1 vssd1 vccd1 vccd1 sky130_fd_sc_hd__fill_1
XFILLER_32_157 vssd1 vssd1 vccd1 vccd1 sky130_fd_sc_hd__fill_1
XFILLER_40_190 vssd1 vssd1 vccd1 vccd1 sky130_fd_sc_hd__fill_4
X_0951_ _0951_/A _0951_/B _0951_/C vssd1 vssd1 vccd1 vccd1 _0956_/B sky130_fd_sc_hd__or3_4
X_0882_ _1599_/Q _1376_/A vssd1 vssd1 vccd1 vccd1 _0883_/B sky130_fd_sc_hd__nand2_2
X_1503_ hold267/X _1502_/C hold259/X vssd1 vssd1 vccd1 vccd1 _1504_/B sky130_fd_sc_hd__a21oi_2
X_1434_ _1434_/A _1434_/B vssd1 vssd1 vccd1 vccd1 _1434_/Y sky130_fd_sc_hd__nand2_2
X_1365_ _1366_/A _1366_/B vssd1 vssd1 vccd1 vccd1 _1388_/C sky130_fd_sc_hd__and2_2
X_1296_ _1296_/A _1296_/B vssd1 vssd1 vccd1 vccd1 _1322_/A sky130_fd_sc_hd__xnor2_2
XFILLER_23_113 vssd1 vssd1 vccd1 vccd1 sky130_fd_sc_hd__fill_4
XTAP_TAPCELL_ROW_18_193 vssd1 vccd1 sky130_fd_sc_hd__tapvpwrvgnd_1
XFILLER_11_57 vssd1 vccd1 vssd1 vccd1 sky130_ef_sc_hd__decap_40_12
Xteam_04_114 vssd1 vssd1 vccd1 vccd1 gpio_oeb[28] team_04_114/LO sky130_fd_sc_hd__conb_1
Xteam_04_103 vssd1 vssd1 vccd1 vccd1 gpio_oeb[17] team_04_103/LO sky130_fd_sc_hd__conb_1
XANTENNA_fanout63_A fanout64/X vssd1 vssd1 vccd1 vccd1 sky130_fd_sc_hd__diode_2
XANTENNA__1382__A2 _1378_/B vssd1 vssd1 vccd1 vccd1 sky130_fd_sc_hd__diode_2
X_1150_ _1150_/A _1150_/B _1150_/C vssd1 vssd1 vccd1 vccd1 _1157_/A sky130_fd_sc_hd__and3_4
X_1081_ _1083_/C _1106_/B vssd1 vssd1 vccd1 vccd1 _1102_/B sky130_fd_sc_hd__and2_2
X_0934_ _1422_/A _0934_/B _0934_/C vssd1 vssd1 vccd1 vccd1 _0936_/C sky130_fd_sc_hd__and3_4
X_0865_ _1376_/A _0865_/B _0865_/C _1654_/Q vssd1 vssd1 vccd1 vccd1 _0865_/X sky130_fd_sc_hd__or4b_2
XTAP_TAPCELL_ROW_15_174 vssd1 vccd1 sky130_fd_sc_hd__tapvpwrvgnd_1
X_1417_ _1415_/Y _1416_/X _1378_/B vssd1 vssd1 vccd1 vccd1 _1417_/X sky130_fd_sc_hd__a21o_2
X_0796_ _1635_/Q vssd1 vssd1 vccd1 vccd1 _1540_/A sky130_fd_sc_hd__inv_2
X_1348_ _1348_/A _1348_/B vssd1 vssd1 vccd1 vccd1 _1395_/B sky130_fd_sc_hd__xnor2_2
X_1279_ _1279_/A _1279_/B vssd1 vssd1 vccd1 vccd1 _1334_/B sky130_fd_sc_hd__xor2_2
XTAP_TAPCELL_ROW_6_131 vssd1 vccd1 sky130_fd_sc_hd__tapvpwrvgnd_1
XTAP_TAPCELL_ROW_29_244 vssd1 vccd1 sky130_fd_sc_hd__tapvpwrvgnd_1
XFILLER_10_171 vssd1 vssd1 vccd1 vccd1 sky130_fd_sc_hd__fill_1
XFILLER_10_182 vssd1 vssd1 vccd1 vccd1 sky130_fd_sc_hd__fill_1
XFILLER_18_260 vssd1 vssd1 vccd1 vccd1 sky130_fd_sc_hd__fill_4
Xclkbuf_4_1_0_clk clkbuf_0_clk/X vssd1 vssd1 vccd1 vccd1 clkload1/A sky130_fd_sc_hd__clkbuf_8
X_1202_ _1203_/A _1258_/A vssd1 vssd1 vccd1 vccd1 _1233_/A sky130_fd_sc_hd__nor2_2
X_1133_ _1128_/B _1118_/X _1132_/Y vssd1 vssd1 vccd1 vccd1 _1133_/Y sky130_fd_sc_hd__a21oi_4
X_1064_ _1065_/A _1065_/B vssd1 vssd1 vccd1 vccd1 _1064_/X sky130_fd_sc_hd__xor2_2
X_0917_ _0962_/B _0909_/Y _0916_/X _1615_/Q vssd1 vssd1 vccd1 vccd1 _0926_/A sky130_fd_sc_hd__o22ai_4
X_0848_ _1629_/Q _1520_/A vssd1 vssd1 vccd1 vccd1 _0848_/Y sky130_fd_sc_hd__nand2_2
XFILLER_33_55 vssd1 vssd1 vccd1 vccd1 sky130_fd_sc_hd__fill_1
XFILLER_3_167 vssd1 vssd1 vccd1 vccd1 sky130_fd_sc_hd__fill_1
XFILLER_15_296 vssd1 vssd1 vccd1 vccd1 sky130_fd_sc_hd__fill_2
XFILLER_0_81 vssd1 vssd1 vccd1 vccd1 sky130_fd_sc_hd__fill_2
X_1116_ _1116_/A _1185_/A vssd1 vssd1 vccd1 vccd1 _1116_/X sky130_fd_sc_hd__or2_2
X_1047_ _1034_/B _1020_/X _1021_/Y vssd1 vssd1 vccd1 vccd1 _1048_/B sky130_fd_sc_hd__o21ai_2
XFILLER_21_266 vssd1 vssd1 vccd1 vccd1 sky130_fd_sc_hd__fill_2
XTAP_TAPCELL_ROW_23_217 vssd1 vccd1 sky130_fd_sc_hd__tapvpwrvgnd_1
XFILLER_0_159 vssd1 vssd1 vccd1 vccd1 sky130_fd_sc_hd__fill_8
XFILLER_44_43 vssd1 vssd1 vccd1 vccd1 sky130_fd_sc_hd__fill_1
XFILLER_8_215 vssd1 vssd1 vccd1 vccd1 sky130_fd_sc_hd__fill_2
XPHY_EDGE_ROW_13_Right_13 vssd1 vssd1 vccd1 vccd1 sky130_fd_sc_hd__decap_3
XPHY_EDGE_ROW_22_Right_22 vssd1 vssd1 vccd1 vccd1 sky130_fd_sc_hd__decap_3
XFILLER_7_281 vssd1 vccd1 vssd1 vccd1 sky130_ef_sc_hd__decap_40_12
X_1596_ clkload2/A _1596_/D fanout56/X vssd1 vssd1 vccd1 vccd1 _1596_/Q sky130_fd_sc_hd__dfrtp_2
Xhold237 _1584_/Q vssd1 vssd1 vccd1 vccd1 _1583_/D sky130_fd_sc_hd__dlygate4sd3_1
Xhold248 _1650_/Q vssd1 vssd1 vccd1 vccd1 hold248/X sky130_fd_sc_hd__dlygate4sd3_1
Xhold259 _1622_/Q vssd1 vssd1 vccd1 vccd1 hold259/X sky130_fd_sc_hd__dlygate4sd3_1
XFILLER_38_141 vssd1 vccd1 vssd1 vccd1 sky130_ef_sc_hd__decap_40_12
XPHY_EDGE_ROW_31_Right_31 vssd1 vssd1 vccd1 vccd1 sky130_fd_sc_hd__decap_3
Xteam_04_98 vssd1 vssd1 vccd1 vccd1 gpio_oeb[0] team_04_98/LO sky130_fd_sc_hd__conb_1
Xteam_04_87 vssd1 vssd1 vccd1 vccd1 team_04_87/HI gpio_out[23] sky130_fd_sc_hd__conb_1
Xteam_04_76 vssd1 vssd1 vccd1 vccd1 team_04_76/HI gpio_out[0] sky130_fd_sc_hd__conb_1
Xteam_04_65 vssd1 vssd1 vccd1 vccd1 team_04_65/HI gpio_oeb[5] sky130_fd_sc_hd__conb_1
XPHY_EDGE_ROW_40_Right_40 vssd1 vssd1 vccd1 vccd1 sky130_fd_sc_hd__decap_3
XFILLER_30_89 vssd1 vssd1 vccd1 vccd1 sky130_fd_sc_hd__fill_2
XFILLER_39_54 vssd1 vssd1 vccd1 vccd1 sky130_fd_sc_hd__fill_2
XFILLER_29_163 vssd1 vssd1 vccd1 vccd1 sky130_fd_sc_hd__fill_4
XTAP_TAPCELL_ROW_42_312 vssd1 vccd1 sky130_fd_sc_hd__tapvpwrvgnd_1
X_1450_ _1460_/B _1451_/B vssd1 vssd1 vccd1 vccd1 _1450_/X sky130_fd_sc_hd__or2_2
X_1381_ _1375_/X _1377_/Y _1380_/A _1378_/A _1376_/A vssd1 vssd1 vccd1 vccd1 _1381_/X
+ sky130_fd_sc_hd__a32o_2
XANTENNA_clkbuf_0_clk_X clkbuf_0_clk/X vssd1 vssd1 vccd1 vccd1 sky130_fd_sc_hd__diode_2
X_1579_ _1649_/Q _1578_/C hold248/X vssd1 vssd1 vccd1 vccd1 _1579_/Y sky130_fd_sc_hd__a21oi_2
X_1648_ _1648_/CLK _1648_/D vssd1 vssd1 vccd1 vccd1 _1648_/Q sky130_fd_sc_hd__dfxtp_2
X_1717_ _1717_/A vssd1 vssd1 vccd1 vccd1 _1717_/X sky130_fd_sc_hd__buf_2
XFILLER_41_55 vssd1 vssd1 vccd1 vccd1 sky130_fd_sc_hd__fill_1
Xrebuffer131 _1044_/Y vssd1 vssd1 vccd1 vccd1 _1098_/A sky130_fd_sc_hd__buf_2
Xrebuffer142 _1023_/B vssd1 vssd1 vccd1 vccd1 _1048_/A sky130_fd_sc_hd__buf_2
Xrebuffer153 _1044_/Y vssd1 vssd1 vccd1 vccd1 _1045_/B1 sky130_fd_sc_hd__buf_2
Xrebuffer164 _1181_/C vssd1 vssd1 vccd1 vccd1 _1166_/A1 sky130_fd_sc_hd__buf_2
Xrebuffer197 _1390_/A2 vssd1 vssd1 vccd1 vccd1 _1397_/A1 sky130_fd_sc_hd__buf_6
Xrebuffer186 _0904_/X vssd1 vssd1 vccd1 vccd1 _0923_/C sky130_fd_sc_hd__buf_2
Xrebuffer175 _1265_/B vssd1 vssd1 vccd1 vccd1 _1278_/A sky130_fd_sc_hd__buf_4
XFILLER_1_254 vssd1 vssd1 vccd1 vccd1 sky130_fd_sc_hd__fill_1
X_0950_ _0950_/A _0950_/B vssd1 vssd1 vccd1 vccd1 _0984_/A sky130_fd_sc_hd__xnor2_2
X_0881_ _1460_/B _1612_/Q _0880_/X _0887_/B vssd1 vssd1 vccd1 vccd1 _0888_/A sky130_fd_sc_hd__a31o_2
X_1502_ _1621_/Q _1622_/Q _1502_/C vssd1 vssd1 vccd1 vccd1 _1506_/B sky130_fd_sc_hd__and3_2
X_1433_ _1432_/A _1432_/B _1378_/B vssd1 vssd1 vccd1 vccd1 _1434_/B sky130_fd_sc_hd__o21a_2
X_1364_ _1390_/A2 _1366_/A _1366_/B vssd1 vssd1 vccd1 vccd1 _1364_/Y sky130_fd_sc_hd__a21oi_4
X_1295_ _1295_/A vssd1 vssd1 vccd1 vccd1 _1303_/B sky130_fd_sc_hd__inv_2
XANTENNA__1378__B _1378_/B vssd1 vssd1 vccd1 vccd1 sky130_fd_sc_hd__diode_2
XFILLER_11_36 vssd1 vccd1 vssd1 vccd1 sky130_ef_sc_hd__decap_40_12
XFILLER_11_69 vssd1 vssd1 vccd1 vccd1 sky130_fd_sc_hd__fill_8
XFILLER_2_9 vssd1 vccd1 vssd1 vccd1 sky130_ef_sc_hd__decap_40_12
Xteam_04_115 vssd1 vssd1 vccd1 vccd1 gpio_oeb[29] team_04_115/LO sky130_fd_sc_hd__conb_1
Xteam_04_104 vssd1 vssd1 vccd1 vccd1 gpio_oeb[18] team_04_104/LO sky130_fd_sc_hd__conb_1
X_1080_ _1080_/A _1080_/B vssd1 vssd1 vccd1 vccd1 _1086_/B sky130_fd_sc_hd__nand2_8
XTAP_TAPCELL_ROW_15_175 vssd1 vccd1 sky130_fd_sc_hd__tapvpwrvgnd_1
X_0933_ _0934_/C _0934_/B _1422_/A vssd1 vssd1 vccd1 vccd1 _0938_/B sky130_fd_sc_hd__a21oi_4
X_0864_ _1602_/Q _1408_/A _1605_/Q _1416_/A vssd1 vssd1 vccd1 vccd1 _0865_/C sky130_fd_sc_hd__or4bb_2
X_0795_ _1632_/Q vssd1 vssd1 vccd1 vccd1 _0834_/B sky130_fd_sc_hd__inv_2
X_1416_ _1416_/A _1422_/C vssd1 vssd1 vccd1 vccd1 _1416_/X sky130_fd_sc_hd__or2_2
X_1347_ _1347_/A _1347_/B _1347_/C vssd1 vssd1 vccd1 vccd1 _1348_/B sky130_fd_sc_hd__and3_2
X_1278_ _1278_/A _1278_/B vssd1 vssd1 vccd1 vccd1 _1279_/B sky130_fd_sc_hd__nand2_2
XTAP_TAPCELL_ROW_38_289 vssd1 vccd1 sky130_fd_sc_hd__tapvpwrvgnd_1
XTAP_TAPCELL_ROW_6_132 vssd1 vccd1 sky130_fd_sc_hd__tapvpwrvgnd_1
XTAP_TAPCELL_ROW_29_245 vssd1 vccd1 sky130_fd_sc_hd__tapvpwrvgnd_1
XFILLER_27_294 vssd1 vssd1 vccd1 vccd1 sky130_fd_sc_hd__fill_4
XFILLER_42_253 vssd1 vssd1 vccd1 vccd1 sky130_fd_sc_hd__fill_4
XFILLER_8_26 vssd1 vssd1 vccd1 vccd1 sky130_fd_sc_hd__fill_2
X_1201_ _1201_/A _1201_/B vssd1 vssd1 vccd1 vccd1 _1258_/A sky130_fd_sc_hd__xnor2_2
XFILLER_18_250 vssd1 vssd1 vccd1 vccd1 sky130_fd_sc_hd__fill_2
X_1132_ _1187_/A _1159_/B vssd1 vssd1 vccd1 vccd1 _1132_/Y sky130_fd_sc_hd__nand2_2
X_1063_ _1063_/A _1063_/B vssd1 vssd1 vccd1 vccd1 _1065_/B sky130_fd_sc_hd__and2_2
XFILLER_33_242 vssd1 vssd1 vccd1 vccd1 sky130_fd_sc_hd__fill_1
X_0916_ _0887_/B _0907_/X _0920_/A1 vssd1 vssd1 vccd1 vccd1 _0916_/X sky130_fd_sc_hd__o21ba_2
X_0847_ _1534_/A _1632_/Q _1635_/Q _1634_/Q vssd1 vssd1 vccd1 vccd1 _0847_/X sky130_fd_sc_hd__or4_2
XFILLER_24_242 vssd1 vssd1 vccd1 vccd1 sky130_fd_sc_hd__fill_1
XFILLER_24_264 vssd1 vssd1 vccd1 vccd1 sky130_fd_sc_hd__fill_1
XFILLER_3_102 vssd1 vssd1 vccd1 vccd1 sky130_fd_sc_hd__fill_8
XTAP_TAPCELL_ROW_34_270 vssd1 vccd1 sky130_fd_sc_hd__tapvpwrvgnd_1
XFILLER_3_113 vssd1 vssd1 vccd1 vccd1 sky130_fd_sc_hd__fill_2
XFILLER_3_135 vssd1 vssd1 vccd1 vccd1 sky130_fd_sc_hd__fill_1
X_1115_ _1077_/B _1107_/Y _1114_/X vssd1 vssd1 vccd1 vccd1 _1185_/A sky130_fd_sc_hd__a21oi_2
X_1046_ _1100_/A _1100_/B vssd1 vssd1 vccd1 vccd1 _1083_/C sky130_fd_sc_hd__or2_2
XTAP_TAPCELL_ROW_23_218 vssd1 vccd1 sky130_fd_sc_hd__tapvpwrvgnd_1
XANTENNA__1626__RESET_B fanout64/X vssd1 vssd1 vccd1 vccd1 sky130_fd_sc_hd__diode_2
XFILLER_12_201 vssd1 vccd1 vssd1 vccd1 sky130_ef_sc_hd__decap_40_12
XFILLER_12_234 vssd1 vssd1 vccd1 vccd1 sky130_fd_sc_hd__fill_1
Xclkbuf_4_0_0_clk clkbuf_0_clk/X vssd1 vssd1 vccd1 vccd1 clkload0/A sky130_fd_sc_hd__clkbuf_8
XFILLER_8_249 vssd1 vssd1 vccd1 vccd1 sky130_fd_sc_hd__fill_2
XFILLER_39_109 vssd1 vssd1 vccd1 vccd1 sky130_fd_sc_hd__fill_2
XFILLER_7_293 vssd1 vssd1 vccd1 vccd1 sky130_fd_sc_hd__fill_4
X_1595_ _1633_/CLK _1595_/D load_slew55/X vssd1 vssd1 vccd1 vccd1 _1595_/Q sky130_fd_sc_hd__dfrtp_2
Xhold238 _1587_/Q vssd1 vssd1 vccd1 vccd1 _1586_/D sky130_fd_sc_hd__dlygate4sd3_1
Xhold249 _1579_/Y vssd1 vssd1 vccd1 vccd1 _1580_/B sky130_fd_sc_hd__dlygate4sd3_1
Xteam_04_88 vssd1 vssd1 vccd1 vccd1 team_04_88/HI gpio_out[24] sky130_fd_sc_hd__conb_1
Xteam_04_77 vssd1 vssd1 vccd1 vccd1 team_04_77/HI gpio_out[1] sky130_fd_sc_hd__conb_1
Xteam_04_66 vssd1 vssd1 vccd1 vccd1 team_04_66/HI gpio_oeb[6] sky130_fd_sc_hd__conb_1
XFILLER_14_69 vssd1 vssd1 vccd1 vccd1 sky130_fd_sc_hd__fill_1
Xteam_04_99 vssd1 vssd1 vccd1 vccd1 gpio_oeb[1] team_04_99/LO sky130_fd_sc_hd__conb_1
X_1029_ _1029_/A _1029_/B vssd1 vssd1 vccd1 vccd1 _1029_/Y sky130_fd_sc_hd__nand2_2
XFILLER_39_11 vssd1 vssd1 vccd1 vccd1 sky130_fd_sc_hd__fill_1
XFILLER_44_112 vssd1 vssd1 vccd1 vccd1 sky130_fd_sc_hd__fill_1
XFILLER_44_167 vssd1 vssd1 vccd1 vccd1 sky130_fd_sc_hd__fill_1
XTAP_TAPCELL_ROW_42_313 vssd1 vccd1 sky130_fd_sc_hd__tapvpwrvgnd_1
X_1380_ _1380_/A vssd1 vssd1 vccd1 vccd1 _1514_/A sky130_fd_sc_hd__inv_2
XFILLER_35_167 vssd1 vssd1 vccd1 vccd1 sky130_fd_sc_hd__fill_1
XFILLER_35_189 vssd1 vssd1 vccd1 vccd1 sky130_fd_sc_hd__fill_8
X_1716_ _1716_/A vssd1 vssd1 vccd1 vccd1 _1716_/X sky130_fd_sc_hd__buf_2
XFILLER_6_81 vssd1 vssd1 vccd1 vccd1 sky130_fd_sc_hd__fill_2
X_1578_ _1649_/Q _1650_/Q _1578_/C vssd1 vssd1 vccd1 vccd1 _1581_/B sky130_fd_sc_hd__and3_2
X_1647_ _1652_/CLK _1647_/D vssd1 vssd1 vccd1 vccd1 _1647_/Q sky130_fd_sc_hd__dfxtp_2
XFILLER_26_101 vssd1 vssd1 vccd1 vccd1 sky130_fd_sc_hd__fill_2
XFILLER_26_112 vssd1 vssd1 vccd1 vccd1 sky130_fd_sc_hd__fill_1
XFILLER_25_57 vssd1 vssd1 vccd1 vccd1 sky130_fd_sc_hd__fill_4
XFILLER_41_34 vssd1 vssd1 vccd1 vccd1 sky130_fd_sc_hd__fill_4
Xrebuffer132 _1040_/X vssd1 vssd1 vccd1 vccd1 _1094_/A sky130_fd_sc_hd__buf_2
XFILLER_41_78 vssd1 vssd1 vccd1 vccd1 sky130_fd_sc_hd__fill_8
Xrebuffer143 _1023_/B vssd1 vssd1 vccd1 vccd1 _1034_/C sky130_fd_sc_hd__buf_2
Xrebuffer154 _1191_/X vssd1 vssd1 vccd1 vccd1 _1249_/B1 sky130_fd_sc_hd__buf_2
Xrebuffer165 _1354_/B vssd1 vssd1 vccd1 vccd1 _1388_/B sky130_fd_sc_hd__buf_2
Xrebuffer198 rebuffer199/X vssd1 vssd1 vccd1 vccd1 fanout16/A sky130_fd_sc_hd__buf_6
Xrebuffer187 _1218_/A vssd1 vssd1 vccd1 vccd1 _1279_/A sky130_fd_sc_hd__buf_2
Xrebuffer176 _1271_/X vssd1 vssd1 vccd1 vccd1 _1336_/A sky130_fd_sc_hd__buf_2
X_0880_ _1429_/A _1609_/Q _1610_/Q _0880_/D vssd1 vssd1 vccd1 vccd1 _0880_/X sky130_fd_sc_hd__or4_2
X_1501_ _1501_/A _1502_/C vssd1 vssd1 vccd1 vccd1 _1621_/D sky130_fd_sc_hd__xor2_2
X_1432_ _1432_/A _1432_/B vssd1 vssd1 vccd1 vccd1 _1434_/A sky130_fd_sc_hd__nand2_2
X_1363_ _1599_/Q _1378_/A _1489_/A1 _1362_/Y vssd1 vssd1 vccd1 vccd1 _1599_/D sky130_fd_sc_hd__a22o_2
X_1294_ _1294_/A _1294_/B vssd1 vssd1 vccd1 vccd1 _1295_/A sky130_fd_sc_hd__xor2_2
XFILLER_11_48 vssd1 vssd1 vccd1 vccd1 sky130_fd_sc_hd__fill_8
Xteam_04_116 vssd1 vssd1 vccd1 vccd1 gpio_oeb[30] team_04_116/LO sky130_fd_sc_hd__conb_1
Xteam_04_105 vssd1 vssd1 vccd1 vccd1 gpio_oeb[19] team_04_105/LO sky130_fd_sc_hd__conb_1
XFILLER_39_281 vssd1 vccd1 vssd1 vccd1 sky130_ef_sc_hd__decap_40_12
XFILLER_22_192 vssd1 vssd1 vccd1 vccd1 sky130_fd_sc_hd__fill_4
XFILLER_37_229 vssd1 vssd1 vccd1 vccd1 sky130_fd_sc_hd__fill_1
X_0932_ _0988_/B _0990_/A _0926_/X _0931_/X vssd1 vssd1 vccd1 vccd1 _0969_/C sky130_fd_sc_hd__a22o_2
XTAP_TAPCELL_ROW_15_176 vssd1 vccd1 sky130_fd_sc_hd__tapvpwrvgnd_1
X_0863_ _1614_/Q _1490_/A _1618_/Q _0863_/D vssd1 vssd1 vccd1 vccd1 _0865_/B sky130_fd_sc_hd__nand4_2
X_0794_ _1631_/Q vssd1 vssd1 vccd1 vccd1 _0836_/A sky130_fd_sc_hd__inv_2
XFILLER_28_207 vssd1 vssd1 vccd1 vccd1 sky130_fd_sc_hd__fill_2
XFILLER_3_71 vssd1 vssd1 vccd1 vccd1 sky130_fd_sc_hd__fill_4
XFILLER_3_82 vssd1 vssd1 vccd1 vccd1 sky130_fd_sc_hd__fill_4
X_1415_ _1416_/A _1422_/C vssd1 vssd1 vccd1 vccd1 _1415_/Y sky130_fd_sc_hd__nand2_2
X_1346_ _1342_/A _1342_/B _1388_/B _1366_/B vssd1 vssd1 vccd1 vccd1 _1395_/A sky130_fd_sc_hd__a211o_2
X_1277_ _1277_/A _1277_/B vssd1 vssd1 vccd1 vccd1 _1280_/A sky130_fd_sc_hd__xor2_2
XTAP_TAPCELL_ROW_6_133 vssd1 vccd1 sky130_fd_sc_hd__tapvpwrvgnd_1
XTAP_TAPCELL_ROW_29_246 vssd1 vccd1 sky130_fd_sc_hd__tapvpwrvgnd_1
XFILLER_42_298 vssd1 vssd1 vccd1 vccd1 sky130_fd_sc_hd__fill_1
XFILLER_8_38 vssd1 vssd1 vccd1 vccd1 sky130_fd_sc_hd__fill_8
XFILLER_6_111 vssd1 vssd1 vccd1 vccd1 sky130_fd_sc_hd__fill_1
X_1200_ _1248_/A _1200_/A2 _1194_/B vssd1 vssd1 vccd1 vccd1 _1201_/B sky130_fd_sc_hd__a21boi_2
XFILLER_18_295 vssd1 vssd1 vccd1 vccd1 sky130_fd_sc_hd__fill_4
X_1131_ _1131_/A _1131_/B vssd1 vssd1 vccd1 vccd1 _1159_/B sky130_fd_sc_hd__xor2_2
X_1062_ _1031_/A _1009_/C _1058_/A _0999_/X vssd1 vssd1 vccd1 vccd1 _1063_/B sky130_fd_sc_hd__a211o_2
XFILLER_33_287 vssd1 vccd1 vssd1 vccd1 sky130_ef_sc_hd__decap_40_12
X_0915_ _0915_/A _1460_/B vssd1 vssd1 vccd1 vccd1 _0941_/A sky130_fd_sc_hd__xnor2_2
X_0846_ _1634_/Q _0845_/Y _1716_/A _1635_/Q vssd1 vssd1 vccd1 vccd1 _0846_/Y sky130_fd_sc_hd__a211oi_2
X_1329_ _1328_/A _1328_/B _1325_/A _1325_/B vssd1 vssd1 vccd1 vccd1 _1330_/B sky130_fd_sc_hd__a211o_2
XTAP_TAPCELL_ROW_3_114 vssd1 vccd1 sky130_fd_sc_hd__tapvpwrvgnd_1
XFILLER_33_57 vssd1 vssd1 vccd1 vccd1 sky130_fd_sc_hd__fill_4
XTAP_TAPCELL_ROW_34_271 vssd1 vccd1 sky130_fd_sc_hd__tapvpwrvgnd_1
XFILLER_3_169 vssd1 vssd1 vccd1 vccd1 sky130_fd_sc_hd__fill_4
XFILLER_15_298 vssd1 vssd1 vccd1 vccd1 sky130_fd_sc_hd__fill_1
XPHY_EDGE_ROW_29_Left_76 vssd1 vssd1 vccd1 vccd1 sky130_fd_sc_hd__decap_3
XANTENNA__1430__B1 _0893_/C vssd1 vssd1 vccd1 vccd1 sky130_fd_sc_hd__diode_2
XFILLER_24_3 vssd1 vssd1 vccd1 vccd1 sky130_fd_sc_hd__fill_2
X_1114_ _1129_/A _1129_/B _1075_/A vssd1 vssd1 vccd1 vccd1 _1114_/X sky130_fd_sc_hd__o21a_2
XFILLER_0_83 vssd1 vssd1 vccd1 vccd1 sky130_fd_sc_hd__fill_1
X_1045_ _1037_/X _1040_/X _1089_/A _1045_/B1 vssd1 vssd1 vccd1 vccd1 _1100_/B sky130_fd_sc_hd__a31oi_4
XFILLER_21_268 vssd1 vssd1 vccd1 vccd1 sky130_fd_sc_hd__fill_1
X_0829_ _1520_/A _1629_/Q vssd1 vssd1 vccd1 vccd1 _0830_/C sky130_fd_sc_hd__and2b_2
XFILLER_0_139 vssd1 vssd1 vccd1 vccd1 sky130_fd_sc_hd__fill_1
XFILLER_12_213 vssd1 vssd1 vccd1 vccd1 sky130_fd_sc_hd__fill_1
XFILLER_12_257 vssd1 vssd1 vccd1 vccd1 sky130_fd_sc_hd__fill_2
XFILLER_8_206 vssd1 vssd1 vccd1 vccd1 sky130_fd_sc_hd__fill_1
XFILLER_7_250 vssd1 vssd1 vccd1 vccd1 sky130_fd_sc_hd__fill_1
X_1594_ clkload0/A input2/X load_slew60/X vssd1 vssd1 vccd1 vccd1 _1594_/Q sky130_fd_sc_hd__dfrtp_2
Xhold239 _1593_/Q vssd1 vssd1 vccd1 vccd1 _1592_/D sky130_fd_sc_hd__dlygate4sd3_1
XPHY_EDGE_ROW_7_Right_7 vssd1 vssd1 vccd1 vccd1 sky130_fd_sc_hd__decap_3
Xteam_04_89 vssd1 vssd1 vccd1 vccd1 team_04_89/HI gpio_out[25] sky130_fd_sc_hd__conb_1
Xteam_04_78 vssd1 vssd1 vccd1 vccd1 team_04_78/HI gpio_out[2] sky130_fd_sc_hd__conb_1
Xteam_04_67 vssd1 vssd1 vccd1 vccd1 team_04_67/HI gpio_oeb[7] sky130_fd_sc_hd__conb_1
X_1028_ _1028_/A _1028_/B vssd1 vssd1 vccd1 vccd1 _1083_/A sky130_fd_sc_hd__xnor2_2
XFILLER_29_110 vssd1 vssd1 vccd1 vccd1 sky130_fd_sc_hd__fill_2
XFILLER_44_157 vssd1 vssd1 vccd1 vccd1 sky130_fd_sc_hd__fill_2
XFILLER_4_253 vssd1 vccd1 vssd1 vccd1 sky130_ef_sc_hd__decap_40_12
XFILLER_4_297 vssd1 vssd1 vccd1 vccd1 sky130_fd_sc_hd__fill_2
XFILLER_35_113 vssd1 vssd1 vccd1 vccd1 sky130_fd_sc_hd__fill_4
X_1646_ _1648_/CLK _1646_/D vssd1 vssd1 vccd1 vccd1 _1646_/Q sky130_fd_sc_hd__dfxtp_2
X_1577_ hold250/X _1578_/C _1576_/Y vssd1 vssd1 vccd1 vccd1 _1649_/D sky130_fd_sc_hd__a21oi_2
XPHY_EDGE_ROW_16_Left_63 vssd1 vssd1 vccd1 vccd1 sky130_fd_sc_hd__decap_3
XFILLER_25_69 vssd1 vccd1 vssd1 vccd1 sky130_ef_sc_hd__decap_40_12
XFILLER_34_190 vssd1 vssd1 vccd1 vccd1 sky130_fd_sc_hd__fill_1
Xrebuffer133 _1133_/Y vssd1 vssd1 vccd1 vccd1 _1142_/A2 sky130_fd_sc_hd__buf_6
Xrebuffer144 _0911_/Y vssd1 vssd1 vccd1 vccd1 _0947_/B1 sky130_fd_sc_hd__buf_2
Xrebuffer155 _0934_/C vssd1 vssd1 vccd1 vccd1 _0913_/A sky130_fd_sc_hd__buf_2
Xrebuffer166 _1339_/Y vssd1 vssd1 vccd1 vccd1 _1366_/B sky130_fd_sc_hd__buf_2
Xrebuffer199 _1360_/Y vssd1 vssd1 vccd1 vccd1 rebuffer199/X sky130_fd_sc_hd__buf_6
Xrebuffer188 _1219_/X vssd1 vssd1 vccd1 vccd1 _1282_/A sky130_fd_sc_hd__buf_2
Xrebuffer177 _1023_/B vssd1 vssd1 vccd1 vccd1 _1024_/B sky130_fd_sc_hd__buf_2
XANTENNA__1610__RESET_B fanout64/X vssd1 vssd1 vccd1 vccd1 sky130_fd_sc_hd__diode_2
XFILLER_17_124 vssd1 vssd1 vccd1 vccd1 sky130_fd_sc_hd__fill_1
XFILLER_2_29 vssd1 vssd1 vccd1 vccd1 sky130_fd_sc_hd__fill_1
XFILLER_32_138 vssd1 vssd1 vccd1 vccd1 sky130_fd_sc_hd__fill_2
XFILLER_32_149 vssd1 vssd1 vccd1 vccd1 sky130_fd_sc_hd__fill_2
X_1500_ _1380_/A _1498_/Y _1499_/Y _0805_/A hold264/X vssd1 vssd1 vccd1 vccd1 _1620_/D
+ sky130_fd_sc_hd__a32o_2
X_1431_ _1462_/B1 _1430_/Y _1427_/X _1463_/B2 _1429_/A vssd1 vssd1 vccd1 vccd1 _1608_/D
+ sky130_fd_sc_hd__a32o_2
X_1362_ _1366_/A _1362_/B vssd1 vssd1 vccd1 vccd1 _1362_/Y sky130_fd_sc_hd__xnor2_2
X_1293_ _1318_/A _1293_/B vssd1 vssd1 vccd1 vccd1 _1293_/Y sky130_fd_sc_hd__nand2_2
X_1629_ clkload9/A _1629_/D load_slew55/X vssd1 vssd1 vccd1 vccd1 _1629_/Q sky130_fd_sc_hd__dfrtp_2
Xteam_04_117 vssd1 vssd1 vccd1 vccd1 gpio_oeb[31] team_04_117/LO sky130_fd_sc_hd__conb_1
Xteam_04_106 vssd1 vssd1 vccd1 vccd1 gpio_oeb[20] team_04_106/LO sky130_fd_sc_hd__conb_1
XANTENNA_input3_A gpio_in[1] vssd1 vssd1 vccd1 vccd1 sky130_fd_sc_hd__diode_2
XFILLER_39_293 vssd1 vssd1 vccd1 vccd1 sky130_fd_sc_hd__fill_4
XFILLER_36_79 vssd1 vssd1 vccd1 vccd1 sky130_fd_sc_hd__fill_4
XPHY_EDGE_ROW_1_Left_48 vssd1 vssd1 vccd1 vccd1 sky130_fd_sc_hd__decap_3
XANTENNA__0811__A1 _1653_/Q vssd1 vssd1 vccd1 vccd1 sky130_fd_sc_hd__diode_2
X_0931_ _0968_/A _0996_/A vssd1 vssd1 vccd1 vccd1 _0931_/X sky130_fd_sc_hd__or2_2
X_0862_ _1460_/B _1613_/Q _1429_/A _1610_/Q vssd1 vssd1 vccd1 vccd1 _0863_/D sky130_fd_sc_hd__and4b_2
XTAP_TAPCELL_ROW_15_177 vssd1 vccd1 sky130_fd_sc_hd__tapvpwrvgnd_1
X_0793_ _1542_/B vssd1 vssd1 vccd1 vccd1 _1636_/D sky130_fd_sc_hd__inv_2
X_1414_ _1406_/X _1353_/A _1413_/Y _1420_/A2 _0892_/A vssd1 vssd1 vccd1 vccd1 _1414_/X
+ sky130_fd_sc_hd__a221o_2
X_1345_ _1268_/Y _1344_/Y _1345_/S vssd1 vssd1 vccd1 vccd1 _1354_/B sky130_fd_sc_hd__mux2_4
X_1276_ _1279_/A _1278_/B _1278_/A vssd1 vssd1 vccd1 vccd1 _1277_/B sky130_fd_sc_hd__a21bo_2
XFILLER_11_119 vssd1 vssd1 vccd1 vccd1 sky130_fd_sc_hd__fill_2
XFILLER_36_274 vssd1 vssd1 vccd1 vccd1 sky130_fd_sc_hd__fill_1
XTAP_TAPCELL_ROW_29_247 vssd1 vccd1 sky130_fd_sc_hd__tapvpwrvgnd_1
XFILLER_10_141 vssd1 vssd1 vccd1 vccd1 sky130_fd_sc_hd__fill_4
XFILLER_6_123 vssd1 vssd1 vccd1 vccd1 sky130_fd_sc_hd__fill_2
X_1130_ _1122_/A _1069_/Y _1122_/B _1067_/X vssd1 vssd1 vccd1 vccd1 _1131_/B sky130_fd_sc_hd__a31o_2
XFILLER_33_233 vssd1 vssd1 vccd1 vccd1 sky130_fd_sc_hd__fill_1
XFILLER_33_266 vssd1 vssd1 vccd1 vccd1 sky130_fd_sc_hd__fill_1
X_1061_ _1100_/A _1061_/B _1124_/A _1100_/B vssd1 vssd1 vccd1 vccd1 _1071_/A sky130_fd_sc_hd__or4_4
X_0914_ _0934_/C _0912_/B _0923_/C vssd1 vssd1 vccd1 vccd1 _0915_/A sky130_fd_sc_hd__a21oi_4
X_0845_ _1534_/A _1632_/Q vssd1 vssd1 vccd1 vccd1 _0845_/Y sky130_fd_sc_hd__nand2_2
X_1328_ _1328_/A _1328_/B vssd1 vssd1 vccd1 vccd1 _1466_/A sky130_fd_sc_hd__nand2_2
X_1259_ _1282_/A _1282_/B _1278_/A vssd1 vssd1 vccd1 vccd1 _1260_/B sky130_fd_sc_hd__o21ai_2
XTAP_TAPCELL_ROW_3_115 vssd1 vccd1 sky130_fd_sc_hd__tapvpwrvgnd_1
XTAP_TAPCELL_ROW_34_272 vssd1 vccd1 sky130_fd_sc_hd__tapvpwrvgnd_1
XFILLER_3_115 vssd1 vssd1 vccd1 vccd1 sky130_fd_sc_hd__fill_1
XANTENNA_fanout64_X fanout64/X vssd1 vssd1 vccd1 vccd1 sky130_fd_sc_hd__diode_2
XFILLER_15_200 vssd1 vssd1 vccd1 vccd1 sky130_fd_sc_hd__fill_1
XFILLER_30_203 vssd1 vssd1 vccd1 vccd1 sky130_fd_sc_hd__fill_2
XPHY_EDGE_ROW_4_Left_51 vssd1 vssd1 vccd1 vccd1 sky130_fd_sc_hd__decap_3
XFILLER_15_288 vssd1 vssd1 vccd1 vccd1 sky130_fd_sc_hd__fill_8
XFILLER_30_269 vssd1 vssd1 vccd1 vccd1 sky130_fd_sc_hd__fill_4
X_1113_ _1113_/A _1113_/B vssd1 vssd1 vccd1 vccd1 _1116_/A sky130_fd_sc_hd__or2_2
X_1044_ _1044_/A _1044_/B vssd1 vssd1 vccd1 vccd1 _1044_/Y sky130_fd_sc_hd__xnor2_4
X_0828_ _0827_/C _0826_/Y _0827_/X _1717_/A vssd1 vssd1 vccd1 vccd1 _0828_/X sky130_fd_sc_hd__o211a_2
XPHY_EDGE_ROW_46_Left_93 vssd1 vssd1 vccd1 vccd1 sky130_fd_sc_hd__decap_3
XFILLER_12_269 vssd1 vssd1 vccd1 vccd1 sky130_fd_sc_hd__fill_4
XPHY_EDGE_ROW_30_Left_77 vssd1 vssd1 vccd1 vccd1 sky130_fd_sc_hd__decap_3
X_1593_ clkload0/A _1593_/D load_slew60/X vssd1 vssd1 vccd1 vccd1 _1593_/Q sky130_fd_sc_hd__dfrtp_2
Xteam_04_79 vssd1 vssd1 vccd1 vccd1 team_04_79/HI gpio_out[3] sky130_fd_sc_hd__conb_1
Xteam_04_68 vssd1 vssd1 vccd1 vccd1 team_04_68/HI gpio_oeb[8] sky130_fd_sc_hd__conb_1
X_1027_ _1028_/A _1028_/B vssd1 vssd1 vccd1 vccd1 _1058_/B sky130_fd_sc_hd__and2b_2
XFILLER_39_57 vssd1 vssd1 vccd1 vccd1 sky130_fd_sc_hd__fill_4
XFILLER_4_265 vssd1 vssd1 vccd1 vccd1 sky130_fd_sc_hd__fill_4
XFILLER_35_169 vssd1 vssd1 vccd1 vccd1 sky130_fd_sc_hd__fill_4
XFILLER_6_83 vssd1 vssd1 vccd1 vccd1 sky130_fd_sc_hd__fill_1
X_1576_ hold250/X _1578_/C _1582_/B vssd1 vssd1 vccd1 vccd1 _1576_/Y sky130_fd_sc_hd__o21ai_2
X_1645_ _1648_/CLK _1645_/D vssd1 vssd1 vccd1 vccd1 _1645_/Q sky130_fd_sc_hd__dfxtp_2
XFILLER_41_25 vssd1 vssd1 vccd1 vccd1 sky130_fd_sc_hd__fill_2
Xrebuffer123 _1224_/X vssd1 vssd1 vccd1 vccd1 _1296_/A sky130_fd_sc_hd__buf_2
Xrebuffer134 _1339_/A vssd1 vssd1 vccd1 vccd1 _1347_/C sky130_fd_sc_hd__buf_2
Xrebuffer145 _0941_/A vssd1 vssd1 vccd1 vccd1 _0968_/A sky130_fd_sc_hd__buf_2
Xrebuffer156 _0934_/C vssd1 vssd1 vccd1 vccd1 _0920_/A1 sky130_fd_sc_hd__buf_2
Xrebuffer167 _1118_/X vssd1 vssd1 vccd1 vccd1 _1128_/A sky130_fd_sc_hd__buf_2
Xrebuffer189 _1218_/B vssd1 vssd1 vccd1 vccd1 _1274_/A sky130_fd_sc_hd__buf_2
Xrebuffer178 _0992_/C vssd1 vssd1 vccd1 vccd1 _1058_/A sky130_fd_sc_hd__buf_2
XFILLER_40_194 vssd1 vssd1 vccd1 vccd1 sky130_fd_sc_hd__fill_2
X_1430_ _1444_/C _1429_/Y _0893_/C vssd1 vssd1 vccd1 vccd1 _1430_/Y sky130_fd_sc_hd__o21ai_2
XPHY_EDGE_ROW_33_Left_80 vssd1 vssd1 vccd1 vccd1 sky130_fd_sc_hd__decap_3
X_1361_ _1368_/C _1373_/B _1378_/B vssd1 vssd1 vccd1 vccd1 _1362_/B sky130_fd_sc_hd__mux2_1
X_1292_ _1240_/Y _1291_/X _1305_/B vssd1 vssd1 vccd1 vccd1 _1293_/B sky130_fd_sc_hd__a21oi_2
XFILLER_23_117 vssd1 vssd1 vccd1 vccd1 sky130_fd_sc_hd__fill_2
XFILLER_31_161 vssd1 vssd1 vccd1 vccd1 sky130_fd_sc_hd__fill_4
X_1559_ _1640_/Q _1641_/Q _1558_/D hold266/X vssd1 vssd1 vccd1 vccd1 _1560_/B sky130_fd_sc_hd__a31o_2
X_1628_ _1633_/CLK _1628_/D load_slew55/X vssd1 vssd1 vccd1 vccd1 _1628_/Q sky130_fd_sc_hd__dfrtp_2
Xteam_04_118 vssd1 vssd1 vccd1 vccd1 gpio_oeb[32] team_04_118/LO sky130_fd_sc_hd__conb_1
Xteam_04_107 vssd1 vssd1 vccd1 vccd1 gpio_oeb[21] team_04_107/LO sky130_fd_sc_hd__conb_1
XFILLER_46_209 vssd1 vccd1 vssd1 vccd1 sky130_ef_sc_hd__decap_40_12
XFILLER_22_183 vssd1 vssd1 vccd1 vccd1 sky130_fd_sc_hd__fill_2
XFILLER_45_253 vssd1 vccd1 vssd1 vccd1 sky130_ef_sc_hd__decap_40_12
XFILLER_13_150 vssd1 vssd1 vccd1 vccd1 sky130_fd_sc_hd__fill_1
XFILLER_20_109 vssd1 vssd1 vccd1 vccd1 sky130_fd_sc_hd__fill_2
X_0930_ _1610_/Q wire38/X vssd1 vssd1 vccd1 vccd1 _0996_/A sky130_fd_sc_hd__xnor2_2
X_0861_ _1490_/A _1618_/Q _0861_/C _0861_/D vssd1 vssd1 vccd1 vccd1 _0861_/X sky130_fd_sc_hd__or4_2
X_0792_ _1627_/Q vssd1 vssd1 vccd1 vccd1 _0910_/C sky130_fd_sc_hd__inv_2
XTAP_TAPCELL_ROW_15_178 vssd1 vccd1 sky130_fd_sc_hd__tapvpwrvgnd_1
X_1413_ _1413_/A vssd1 vssd1 vccd1 vccd1 _1413_/Y sky130_fd_sc_hd__inv_2
XFILLER_28_209 vssd1 vssd1 vccd1 vccd1 sky130_fd_sc_hd__fill_1
X_1344_ _1267_/A _1347_/A _1269_/Y vssd1 vssd1 vccd1 vccd1 _1344_/Y sky130_fd_sc_hd__o21ai_2
X_1275_ _1336_/A _1352_/A vssd1 vssd1 vccd1 vccd1 _1334_/A sky130_fd_sc_hd__nand2_2
XFILLER_27_242 vssd1 vssd1 vccd1 vccd1 sky130_fd_sc_hd__fill_2
XTAP_TAPCELL_ROW_29_248 vssd1 vccd1 sky130_fd_sc_hd__tapvpwrvgnd_1
XPHY_EDGE_ROW_29_Right_29 vssd1 vssd1 vccd1 vccd1 sky130_fd_sc_hd__decap_3
XTAP_TAPCELL_ROW_12_159 vssd1 vccd1 sky130_fd_sc_hd__tapvpwrvgnd_1
XPHY_EDGE_ROW_38_Right_38 vssd1 vssd1 vccd1 vccd1 sky130_fd_sc_hd__decap_3
XFILLER_10_197 vssd1 vssd1 vccd1 vccd1 sky130_fd_sc_hd__fill_4
XFILLER_12_60 vssd1 vccd1 vssd1 vccd1 sky130_ef_sc_hd__decap_40_12
XFILLER_18_231 vssd1 vssd1 vccd1 vccd1 sky130_fd_sc_hd__fill_4
XFILLER_19_7 vssd1 vssd1 vccd1 vccd1 sky130_fd_sc_hd__fill_4
X_1060_ _1083_/A _1102_/A _1060_/B1 vssd1 vssd1 vccd1 vccd1 _1061_/B sky130_fd_sc_hd__a21oi_2
XFILLER_18_253 vssd1 vssd1 vccd1 vccd1 sky130_fd_sc_hd__fill_2
X_0913_ _0913_/A _0913_/B vssd1 vssd1 vccd1 vccd1 _0913_/Y sky130_fd_sc_hd__nand2_2
X_0844_ _0837_/X _0842_/X _0843_/X vssd1 vssd1 vccd1 vccd1 _0844_/X sky130_fd_sc_hd__a21o_2
XTAP_TAPCELL_ROW_3_116 vssd1 vccd1 sky130_fd_sc_hd__tapvpwrvgnd_1
X_1327_ _1327_/A _1327_/B _1336_/B vssd1 vssd1 vccd1 vccd1 _1328_/B sky130_fd_sc_hd__nand3_2
X_1258_ _1258_/A _1258_/B vssd1 vssd1 vccd1 vccd1 _1439_/A sky130_fd_sc_hd__xor2_2
X_1189_ _1116_/X _1185_/B _1186_/A _1116_/A vssd1 vssd1 vccd1 vccd1 _1190_/A sky130_fd_sc_hd__a2bb2o_2
XTAP_TAPCELL_ROW_26_229 vssd1 vccd1 sky130_fd_sc_hd__tapvpwrvgnd_1
XTAP_TAPCELL_ROW_34_273 vssd1 vccd1 sky130_fd_sc_hd__tapvpwrvgnd_1
XFILLER_15_223 vssd1 vssd1 vccd1 vccd1 sky130_fd_sc_hd__fill_1
XFILLER_0_41 vssd1 vccd1 vssd1 vccd1 sky130_ef_sc_hd__decap_40_12
XFILLER_0_85 vssd1 vccd1 vssd1 vccd1 sky130_ef_sc_hd__decap_40_12
X_1112_ _1110_/B _1112_/B vssd1 vssd1 vccd1 vccd1 _1113_/B sky130_fd_sc_hd__and2b_2
X_1043_ _1094_/A _1089_/A vssd1 vssd1 vccd1 vccd1 _1043_/Y sky130_fd_sc_hd__nand2_2
XTAP_TAPCELL_ROW_31_254 vssd1 vccd1 sky130_fd_sc_hd__tapvpwrvgnd_1
X_0827_ _1534_/A _0834_/B _0827_/C vssd1 vssd1 vccd1 vccd1 _0827_/X sky130_fd_sc_hd__or3_2
XFILLER_12_226 vssd1 vssd1 vccd1 vccd1 sky130_fd_sc_hd__fill_2
XFILLER_12_248 vssd1 vssd1 vccd1 vccd1 sky130_fd_sc_hd__fill_4
XTAP_TAPCELL_ROW_22_210 vssd1 vccd1 sky130_fd_sc_hd__tapvpwrvgnd_1
XANTENNA__1604__RESET_B load_slew58/X vssd1 vssd1 vccd1 vccd1 sky130_fd_sc_hd__diode_2
XTAP_TAPCELL_ROW_45_324 vssd1 vccd1 sky130_fd_sc_hd__tapvpwrvgnd_1
XFILLER_11_281 vssd1 vssd1 vccd1 vccd1 sky130_fd_sc_hd__fill_1
X_1592_ clkload4/A _1592_/D load_slew60/X vssd1 vssd1 vccd1 vccd1 _1592_/Q sky130_fd_sc_hd__dfrtp_2
Xteam_04_69 vssd1 vssd1 vccd1 vccd1 team_04_69/HI gpio_oeb[9] sky130_fd_sc_hd__conb_1
X_1026_ _1034_/B _1023_/B _1029_/B _1029_/A vssd1 vssd1 vccd1 vccd1 _1028_/B sky130_fd_sc_hd__o2bb2a_2
XFILLER_29_123 vssd1 vssd1 vccd1 vccd1 sky130_fd_sc_hd__fill_2
XFILLER_29_167 vssd1 vssd1 vccd1 vccd1 sky130_fd_sc_hd__fill_1
XFILLER_44_126 vssd1 vssd1 vccd1 vccd1 sky130_fd_sc_hd__fill_1
XFILLER_44_159 vssd1 vssd1 vccd1 vccd1 sky130_fd_sc_hd__fill_1
XFILLER_4_222 vssd1 vssd1 vccd1 vccd1 sky130_fd_sc_hd__fill_4
XFILLER_29_80 vssd1 vssd1 vccd1 vccd1 sky130_fd_sc_hd__fill_1
XFILLER_29_91 vssd1 vssd1 vccd1 vccd1 sky130_fd_sc_hd__fill_4
X_1575_ _1578_/C _1575_/B vssd1 vssd1 vccd1 vccd1 _1648_/D sky130_fd_sc_hd__nor2_2
X_1644_ _1648_/CLK _1644_/D vssd1 vssd1 vccd1 vccd1 _1644_/Q sky130_fd_sc_hd__dfxtp_2
X_1009_ _0992_/X _1009_/B _1009_/C _1009_/D vssd1 vssd1 vccd1 vccd1 _1009_/Y sky130_fd_sc_hd__nand4b_4
Xrebuffer124 _1182_/X vssd1 vssd1 vccd1 vccd1 _1243_/B sky130_fd_sc_hd__buf_2
Xrebuffer135 _1345_/S vssd1 vssd1 vccd1 vccd1 _1339_/A sky130_fd_sc_hd__buf_2
Xrebuffer146 _1086_/X vssd1 vssd1 vccd1 vccd1 _1177_/A sky130_fd_sc_hd__buf_2
Xrebuffer157 _0906_/Y vssd1 vssd1 vccd1 vccd1 _0951_/B sky130_fd_sc_hd__buf_2
Xrebuffer168 _0904_/A1 vssd1 vssd1 vccd1 vccd1 _1429_/A sky130_fd_sc_hd__buf_2
Xrebuffer179 _1252_/X vssd1 vssd1 vccd1 vccd1 _1286_/A sky130_fd_sc_hd__buf_2
XFILLER_1_225 vssd1 vssd1 vccd1 vccd1 sky130_fd_sc_hd__fill_2
X_1360_ _1358_/X _1356_/X _1426_/B vssd1 vssd1 vccd1 vccd1 _1360_/Y sky130_fd_sc_hd__o21bai_4
X_1291_ _1286_/B _1288_/Y _1286_/A vssd1 vssd1 vccd1 vccd1 _1291_/X sky130_fd_sc_hd__a21bo_2
X_1558_ _1640_/Q _1641_/Q _1642_/Q _1558_/D vssd1 vssd1 vccd1 vccd1 _1563_/C sky130_fd_sc_hd__and4_2
X_1627_ clkload7/A _1627_/D fanout64/X vssd1 vssd1 vccd1 vccd1 _1627_/Q sky130_fd_sc_hd__dfrtp_2
Xteam_04_119 vssd1 vssd1 vccd1 vccd1 gpio_oeb[33] team_04_119/LO sky130_fd_sc_hd__conb_1
Xteam_04_108 vssd1 vssd1 vccd1 vccd1 gpio_oeb[22] team_04_108/LO sky130_fd_sc_hd__conb_1
X_1489_ _1489_/A1 _0893_/C _1488_/X _0805_/A _1617_/Q vssd1 vssd1 vccd1 vccd1 _1617_/D
+ sky130_fd_sc_hd__a32o_2
XTAP_TAPCELL_ROW_9_144 vssd1 vccd1 sky130_fd_sc_hd__tapvpwrvgnd_1
XFILLER_13_140 vssd1 vssd1 vccd1 vccd1 sky130_fd_sc_hd__fill_1
XFILLER_26_70 vssd1 vssd1 vccd1 vccd1 sky130_fd_sc_hd__fill_1
XFILLER_45_265 vssd1 vccd1 vssd1 vccd1 sky130_ef_sc_hd__decap_40_12
XFILLER_9_100 vssd1 vssd1 vccd1 vccd1 sky130_fd_sc_hd__fill_2
XFILLER_42_91 vssd1 vssd1 vccd1 vccd1 sky130_fd_sc_hd__fill_1
X_0860_ _1654_/Q _1599_/Q _1429_/A _1376_/A vssd1 vssd1 vccd1 vccd1 _0861_/D sky130_fd_sc_hd__or4b_2
X_0791_ _1620_/Q vssd1 vssd1 vccd1 vccd1 _1499_/A sky130_fd_sc_hd__inv_2
XFILLER_3_63 vssd1 vssd1 vccd1 vccd1 sky130_fd_sc_hd__fill_4
X_1412_ _1412_/A _1412_/B vssd1 vssd1 vccd1 vccd1 _1413_/A sky130_fd_sc_hd__nand2_2
X_1343_ _1388_/A vssd1 vssd1 vccd1 vccd1 _1373_/A sky130_fd_sc_hd__inv_2
XFILLER_36_210 vssd1 vssd1 vccd1 vccd1 sky130_fd_sc_hd__fill_1
X_1274_ _1274_/A _1274_/B vssd1 vssd1 vccd1 vccd1 _1352_/A sky130_fd_sc_hd__xnor2_2
X_0989_ _0961_/X _0964_/X _0977_/Y _0925_/Y vssd1 vssd1 vccd1 vccd1 _0990_/B sky130_fd_sc_hd__o2bb2a_4
XFILLER_27_298 vssd1 vssd1 vccd1 vccd1 sky130_fd_sc_hd__fill_1
XFILLER_42_257 vssd1 vssd1 vccd1 vccd1 sky130_fd_sc_hd__fill_2
XFILLER_10_110 vssd1 vssd1 vccd1 vccd1 sky130_fd_sc_hd__fill_2
XFILLER_12_72 vssd1 vccd1 vssd1 vccd1 sky130_ef_sc_hd__decap_40_12
XANTENNA__1433__B1 _1378_/B vssd1 vssd1 vccd1 vccd1 sky130_fd_sc_hd__diode_2
X_0912_ _0913_/A _0912_/B vssd1 vssd1 vccd1 vccd1 _0962_/B sky130_fd_sc_hd__and2_2
X_0843_ _1635_/Q _0826_/Y _0839_/X _1717_/A vssd1 vssd1 vccd1 vccd1 _0843_/X sky130_fd_sc_hd__o211a_2
X_1326_ _1322_/A _1327_/B _1336_/B _1303_/B vssd1 vssd1 vccd1 vccd1 _1328_/A sky130_fd_sc_hd__a31o_2
XTAP_TAPCELL_ROW_3_117 vssd1 vccd1 sky130_fd_sc_hd__tapvpwrvgnd_1
XFILLER_17_17 vssd1 vssd1 vccd1 vccd1 sky130_fd_sc_hd__fill_1
X_1257_ _1298_/A _1257_/B vssd1 vssd1 vccd1 vccd1 _1358_/B sky130_fd_sc_hd__xnor2_2
X_1188_ _1243_/A _1243_/B _1246_/A _1244_/A vssd1 vssd1 vccd1 vccd1 _1248_/B sky130_fd_sc_hd__and4_2
XFILLER_30_205 vssd1 vssd1 vccd1 vccd1 sky130_fd_sc_hd__fill_1
XTAP_TAPCELL_ROW_40_299 vssd1 vccd1 sky130_fd_sc_hd__tapvpwrvgnd_1
XANTENNA_load_slew58_X load_slew58/X vssd1 vssd1 vccd1 vccd1 sky130_fd_sc_hd__diode_2
XFILLER_0_53 vssd1 vssd1 vccd1 vccd1 sky130_fd_sc_hd__fill_2
XFILLER_0_64 vssd1 vssd1 vccd1 vccd1 sky130_fd_sc_hd__fill_1
XFILLER_0_97 vssd1 vssd1 vccd1 vccd1 sky130_fd_sc_hd__fill_8
X_1111_ _1056_/B _1113_/A _1076_/Y _1105_/B vssd1 vssd1 vccd1 vccd1 _1143_/A sky130_fd_sc_hd__a2bb2o_2
X_1042_ _1042_/A _1042_/B vssd1 vssd1 vccd1 vccd1 _1089_/A sky130_fd_sc_hd__xnor2_2
XTAP_TAPCELL_ROW_31_255 vssd1 vccd1 sky130_fd_sc_hd__tapvpwrvgnd_1
XANTENNA_clkbuf_4_6_0_clk_A clkbuf_0_clk/X vssd1 vssd1 vccd1 vccd1 sky130_fd_sc_hd__diode_2
X_0826_ _1534_/A _0834_/B vssd1 vssd1 vccd1 vccd1 _0826_/Y sky130_fd_sc_hd__nand2_2
Xclkbuf_4_15_0_clk clkbuf_0_clk/X vssd1 vssd1 vccd1 vccd1 _1612_/CLK sky130_fd_sc_hd__clkbuf_8
X_1309_ _1309_/A _1336_/B vssd1 vssd1 vccd1 vccd1 _1313_/B sky130_fd_sc_hd__and2_2
XFILLER_44_37 vssd1 vssd1 vccd1 vccd1 sky130_fd_sc_hd__fill_4
XTAP_TAPCELL_ROW_22_211 vssd1 vccd1 sky130_fd_sc_hd__tapvpwrvgnd_1
XTAP_TAPCELL_ROW_45_325 vssd1 vccd1 sky130_fd_sc_hd__tapvpwrvgnd_1
XFILLER_7_231 vssd1 vssd1 vccd1 vccd1 sky130_fd_sc_hd__fill_1
XFILLER_7_297 vssd1 vssd1 vccd1 vccd1 sky130_fd_sc_hd__fill_2
X_1591_ clkload3/A input3/X fanout56/X vssd1 vssd1 vccd1 vccd1 _1591_/Q sky130_fd_sc_hd__dfrtp_2
XFILLER_22_3 vssd1 vssd1 vccd1 vccd1 sky130_fd_sc_hd__fill_4
XFILLER_38_102 vssd1 vssd1 vccd1 vccd1 sky130_fd_sc_hd__fill_4
XFILLER_14_29 vssd1 vssd1 vccd1 vccd1 sky130_fd_sc_hd__fill_2
X_1025_ _1032_/A _1031_/A vssd1 vssd1 vccd1 vccd1 _1029_/B sky130_fd_sc_hd__nor2_2
X_0809_ _0802_/Y _0805_/X _0806_/X _0810_/B vssd1 vssd1 vccd1 vccd1 _1656_/D sky130_fd_sc_hd__a22o_2
XFILLER_29_113 vssd1 vssd1 vccd1 vccd1 sky130_fd_sc_hd__fill_4
XFILLER_4_201 vssd1 vssd1 vccd1 vccd1 sky130_fd_sc_hd__fill_1
XFILLER_43_182 vssd1 vssd1 vccd1 vccd1 sky130_fd_sc_hd__fill_4
XFILLER_43_193 vssd1 vssd1 vccd1 vccd1 sky130_fd_sc_hd__fill_2
X_1643_ _1648_/CLK _1643_/D vssd1 vssd1 vccd1 vccd1 _1643_/Q sky130_fd_sc_hd__dfxtp_2
XFILLER_6_85 vssd1 vccd1 vssd1 vccd1 sky130_ef_sc_hd__decap_40_12
X_1574_ _1647_/Q _1573_/C hold246/X vssd1 vssd1 vccd1 vccd1 _1574_/Y sky130_fd_sc_hd__a21oi_2
X_1008_ _1028_/A _1008_/B _1008_/C vssd1 vssd1 vccd1 vccd1 _1009_/C sky130_fd_sc_hd__and3b_2
Xrebuffer125 _1180_/Y vssd1 vssd1 vccd1 vccd1 _1215_/A2 sky130_fd_sc_hd__buf_2
Xrebuffer136 _1304_/X vssd1 vssd1 vccd1 vccd1 _1331_/A sky130_fd_sc_hd__buf_2
Xrebuffer147 _1089_/B vssd1 vssd1 vccd1 vccd1 _1090_/B sky130_fd_sc_hd__buf_2
Xrebuffer158 _1009_/Y vssd1 vssd1 vccd1 vccd1 _1010_/B sky130_fd_sc_hd__buf_2
Xrebuffer169 _1607_/Q vssd1 vssd1 vccd1 vccd1 _1422_/A sky130_fd_sc_hd__buf_2
XFILLER_17_138 vssd1 vssd1 vccd1 vccd1 sky130_fd_sc_hd__fill_2
XFILLER_17_149 vssd1 vssd1 vccd1 vccd1 sky130_fd_sc_hd__fill_4
XANTENNA_clkbuf_4_14_0_clk_A clkbuf_0_clk/X vssd1 vssd1 vccd1 vccd1 sky130_fd_sc_hd__diode_2
XFILLER_40_141 vssd1 vccd1 vssd1 vccd1 sky130_ef_sc_hd__decap_40_12
XFILLER_31_82 vssd1 vccd1 vssd1 vccd1 sky130_ef_sc_hd__decap_40_12
X_1290_ _1306_/A1 _1290_/B vssd1 vssd1 vccd1 vccd1 _1305_/B sky130_fd_sc_hd__and2b_2
X_1626_ clkload7/A _1626_/D fanout64/X vssd1 vssd1 vccd1 vccd1 _1626_/Q sky130_fd_sc_hd__dfrtp_2
XFILLER_39_252 vssd1 vssd1 vccd1 vccd1 sky130_fd_sc_hd__fill_4
X_1557_ _1557_/A _1557_/B vssd1 vssd1 vccd1 vccd1 _1557_/Y sky130_fd_sc_hd__xnor2_2
Xteam_04_109 vssd1 vssd1 vccd1 vccd1 gpio_oeb[23] team_04_109/LO sky130_fd_sc_hd__conb_1
X_1488_ _1617_/Q _1488_/B vssd1 vssd1 vccd1 vccd1 _1488_/X sky130_fd_sc_hd__xor2_2
XFILLER_22_141 vssd1 vssd1 vccd1 vccd1 sky130_fd_sc_hd__fill_2
XTAP_TAPCELL_ROW_9_145 vssd1 vccd1 sky130_fd_sc_hd__tapvpwrvgnd_1
XFILLER_26_93 vssd1 vssd1 vccd1 vccd1 sky130_fd_sc_hd__fill_1
XFILLER_45_277 vssd1 vssd1 vccd1 vccd1 sky130_fd_sc_hd__fill_2
XFILLER_13_196 vssd1 vssd1 vccd1 vccd1 sky130_fd_sc_hd__fill_1
X_0790_ _1619_/Q vssd1 vssd1 vccd1 vccd1 _0950_/A sky130_fd_sc_hd__inv_2
XFILLER_9_167 vssd1 vssd1 vccd1 vccd1 sky130_fd_sc_hd__fill_1
XFILLER_3_42 vssd1 vssd1 vccd1 vccd1 sky130_fd_sc_hd__fill_4
XFILLER_3_86 vssd1 vssd1 vccd1 vccd1 sky130_fd_sc_hd__fill_2
X_1411_ _1462_/B1 _1410_/Y _1407_/X _1463_/B2 _1605_/Q vssd1 vssd1 vccd1 vccd1 _1605_/D
+ sky130_fd_sc_hd__a32o_2
X_1342_ _1342_/A _1342_/B vssd1 vssd1 vccd1 vccd1 _1388_/A sky130_fd_sc_hd__and2_2
X_1273_ _1272_/A _1278_/A vssd1 vssd1 vccd1 vccd1 _1274_/B sky130_fd_sc_hd__nand2b_2
XFILLER_36_233 vssd1 vssd1 vccd1 vccd1 sky130_fd_sc_hd__fill_1
XFILLER_36_266 vssd1 vssd1 vccd1 vccd1 sky130_fd_sc_hd__fill_8
Xwire26 wire26/A vssd1 vssd1 vccd1 vccd1 wire26/X sky130_fd_sc_hd__dlygate4sd1_1
X_0988_ _0988_/A _0988_/B vssd1 vssd1 vccd1 vccd1 _0992_/B sky130_fd_sc_hd__xnor2_4
X_1609_ _1612_/CLK _1609_/D fanout64/X vssd1 vssd1 vccd1 vccd1 _1609_/Q sky130_fd_sc_hd__dfrtp_2
XANTENNA_input1_A en vssd1 vssd1 vccd1 vccd1 sky130_fd_sc_hd__diode_2
XFILLER_27_211 vssd1 vssd1 vccd1 vccd1 sky130_fd_sc_hd__fill_4
XFILLER_10_100 vssd1 vssd1 vccd1 vccd1 sky130_fd_sc_hd__fill_1
XFILLER_27_266 vssd1 vssd1 vccd1 vccd1 sky130_fd_sc_hd__fill_2
XFILLER_42_203 vssd1 vssd1 vccd1 vccd1 sky130_fd_sc_hd__fill_2
XFILLER_12_51 vssd1 vssd1 vccd1 vccd1 sky130_fd_sc_hd__fill_1
XFILLER_18_255 vssd1 vssd1 vccd1 vccd1 sky130_fd_sc_hd__fill_1
XFILLER_33_225 vssd1 vssd1 vccd1 vccd1 sky130_fd_sc_hd__fill_8
XFILLER_41_291 vssd1 vssd1 vccd1 vccd1 sky130_fd_sc_hd__fill_8
X_0911_ _0951_/C _0951_/A _0910_/Y _0890_/A vssd1 vssd1 vccd1 vccd1 _0911_/Y sky130_fd_sc_hd__o211ai_2
X_0842_ _1520_/A _0841_/C _1716_/A vssd1 vssd1 vccd1 vccd1 _0842_/X sky130_fd_sc_hd__o21a_2
X_1325_ _1325_/A _1325_/B vssd1 vssd1 vccd1 vccd1 _1325_/X sky130_fd_sc_hd__or2_2
X_1256_ _1285_/A _1258_/B vssd1 vssd1 vccd1 vccd1 _1296_/B sky130_fd_sc_hd__or2_2
XTAP_TAPCELL_ROW_3_118 vssd1 vccd1 sky130_fd_sc_hd__tapvpwrvgnd_1
XANTENNA__0882__B _1376_/A vssd1 vssd1 vccd1 vccd1 sky130_fd_sc_hd__diode_2
XANTENNA_clkbuf_4_2_0_clk_A clkbuf_0_clk/X vssd1 vssd1 vccd1 vccd1 sky130_fd_sc_hd__diode_2
X_1187_ _1187_/A _1187_/B vssd1 vssd1 vccd1 vccd1 _1244_/A sky130_fd_sc_hd__xor2_2
XFILLER_15_225 vssd1 vccd1 vssd1 vccd1 sky130_ef_sc_hd__decap_40_12
X_1110_ _1112_/B _1110_/B vssd1 vssd1 vccd1 vccd1 _1113_/A sky130_fd_sc_hd__and2b_2
X_1041_ _1042_/A _1042_/B vssd1 vssd1 vccd1 vccd1 _1090_/A sky130_fd_sc_hd__xor2_2
XFILLER_21_239 vssd1 vssd1 vccd1 vccd1 sky130_fd_sc_hd__fill_4
X_0825_ _0820_/X _0824_/Y _0819_/X vssd1 vssd1 vccd1 vccd1 _0825_/Y sky130_fd_sc_hd__a21oi_2
XTAP_TAPCELL_ROW_31_256 vssd1 vccd1 sky130_fd_sc_hd__tapvpwrvgnd_1
X_1308_ _1332_/S _1304_/X _1331_/B vssd1 vssd1 vccd1 vccd1 _1345_/S sky130_fd_sc_hd__a21o_4
X_1239_ _1240_/A _1296_/A _1239_/C vssd1 vssd1 vccd1 vccd1 _1239_/Y sky130_fd_sc_hd__nand3_2
XFILLER_12_228 vssd1 vssd1 vccd1 vccd1 sky130_fd_sc_hd__fill_1
XTAP_TAPCELL_ROW_22_212 vssd1 vccd1 sky130_fd_sc_hd__tapvpwrvgnd_1
XPHY_EDGE_ROW_8_Left_55 vssd1 vssd1 vccd1 vccd1 sky130_fd_sc_hd__decap_3
XANTENNA__1613__RESET_B fanout64/X vssd1 vssd1 vccd1 vccd1 sky130_fd_sc_hd__diode_2
XTAP_TAPCELL_ROW_45_326 vssd1 vccd1 sky130_fd_sc_hd__tapvpwrvgnd_1
XFILLER_34_82 vssd1 vssd1 vccd1 vccd1 sky130_fd_sc_hd__fill_2
XFILLER_7_265 vssd1 vssd1 vccd1 vccd1 sky130_fd_sc_hd__fill_2
X_1590_ clkload2/A _1590_/D fanout54/X vssd1 vssd1 vccd1 vccd1 _1590_/Q sky130_fd_sc_hd__dfrtp_2
Xload_slew60 fanout59/X vssd1 vssd1 vccd1 vccd1 load_slew60/X sky130_fd_sc_hd__buf_2
X_1024_ _1034_/B _1024_/B vssd1 vssd1 vccd1 vccd1 _1063_/A sky130_fd_sc_hd__nand2_2
XFILLER_30_29 vssd1 vssd1 vccd1 vccd1 sky130_fd_sc_hd__fill_1
X_0808_ _0810_/B vssd1 vssd1 vccd1 vccd1 _0808_/Y sky130_fd_sc_hd__inv_2
XFILLER_29_169 vssd1 vssd1 vccd1 vccd1 sky130_fd_sc_hd__fill_8
XFILLER_44_106 vssd1 vssd1 vccd1 vccd1 sky130_fd_sc_hd__fill_4
XANTENNA_clkbuf_4_10_0_clk_A clkbuf_0_clk/X vssd1 vssd1 vccd1 vccd1 sky130_fd_sc_hd__diode_2
XFILLER_35_117 vssd1 vssd1 vccd1 vccd1 sky130_fd_sc_hd__fill_1
X_1642_ clkload8/A _1642_/D vssd1 vssd1 vccd1 vccd1 _1642_/Q sky130_fd_sc_hd__dfxtp_2
Xclkbuf_4_14_0_clk clkbuf_0_clk/X vssd1 vssd1 vccd1 vccd1 _1605_/CLK sky130_fd_sc_hd__clkbuf_8
XFILLER_6_97 vssd1 vccd1 vssd1 vccd1 sky130_ef_sc_hd__decap_40_12
X_1573_ _1647_/Q _1648_/Q _1573_/C vssd1 vssd1 vccd1 vccd1 _1578_/C sky130_fd_sc_hd__and3_2
XFILLER_26_139 vssd1 vssd1 vccd1 vccd1 sky130_fd_sc_hd__fill_1
X_1007_ _1040_/A _1007_/B _1044_/B vssd1 vssd1 vccd1 vccd1 _1009_/B sky130_fd_sc_hd__nor3b_4
Xrebuffer126 _1009_/B vssd1 vssd1 vccd1 vccd1 _1031_/A sky130_fd_sc_hd__buf_2
Xrebuffer137 _1157_/A vssd1 vssd1 vccd1 vccd1 _1152_/A sky130_fd_sc_hd__buf_2
Xrebuffer148 _1163_/B vssd1 vssd1 vccd1 vccd1 _1140_/A2 sky130_fd_sc_hd__buf_2
Xrebuffer159 _0912_/B vssd1 vssd1 vccd1 vccd1 _0913_/B sky130_fd_sc_hd__buf_2
XFILLER_15_51 vssd1 vssd1 vccd1 vccd1 sky130_fd_sc_hd__fill_4
XFILLER_40_120 vssd1 vssd1 vccd1 vccd1 sky130_fd_sc_hd__fill_2
XFILLER_40_153 vssd1 vccd1 vssd1 vccd1 sky130_ef_sc_hd__decap_40_12
XFILLER_31_94 vssd1 vssd1 vccd1 vccd1 sky130_fd_sc_hd__fill_4
XFILLER_40_197 vssd1 vccd1 vssd1 vccd1 sky130_ef_sc_hd__decap_40_12
XFILLER_16_194 vssd1 vssd1 vccd1 vccd1 sky130_fd_sc_hd__fill_2
XTAP_TAPCELL_ROW_18_189 vssd1 vccd1 sky130_fd_sc_hd__tapvpwrvgnd_1
X_1556_ _1582_/B _1557_/B _1556_/C vssd1 vssd1 vccd1 vccd1 _1640_/D sky130_fd_sc_hd__and3_2
X_1625_ clkload5/A _1625_/D fanout63/X vssd1 vssd1 vccd1 vccd1 _1625_/Q sky130_fd_sc_hd__dfrtp_2
XFILLER_39_231 vssd1 vssd1 vccd1 vccd1 sky130_fd_sc_hd__fill_1
X_1487_ _1489_/A1 _0893_/C _1486_/X _0805_/A _1490_/A vssd1 vssd1 vccd1 vccd1 _1616_/D
+ sky130_fd_sc_hd__a32o_2
XFILLER_39_297 vssd1 vssd1 vccd1 vccd1 sky130_fd_sc_hd__fill_2
XFILLER_22_175 vssd1 vssd1 vccd1 vccd1 sky130_fd_sc_hd__fill_8
XFILLER_22_197 vssd1 vccd1 vssd1 vccd1 sky130_ef_sc_hd__decap_40_12
XTAP_TAPCELL_ROW_9_146 vssd1 vccd1 sky130_fd_sc_hd__tapvpwrvgnd_1
XFILLER_45_223 vssd1 vssd1 vccd1 vccd1 sky130_fd_sc_hd__fill_1
XPHY_EDGE_ROW_37_Left_84 vssd1 vssd1 vccd1 vccd1 sky130_fd_sc_hd__decap_3
XFILLER_26_61 vssd1 vssd1 vccd1 vccd1 sky130_fd_sc_hd__fill_1
XFILLER_9_102 vssd1 vssd1 vccd1 vccd1 sky130_fd_sc_hd__fill_1
X_1410_ _1422_/C _1409_/Y _0893_/C vssd1 vssd1 vccd1 vccd1 _1410_/Y sky130_fd_sc_hd__o21ai_2
XPHY_EDGE_ROW_21_Left_68 vssd1 vssd1 vccd1 vccd1 sky130_fd_sc_hd__decap_3
XFILLER_3_54 vssd1 vssd1 vccd1 vccd1 sky130_fd_sc_hd__fill_2
X_1341_ _1600_/Q _1341_/B _1347_/C vssd1 vssd1 vccd1 vccd1 _1342_/B sky130_fd_sc_hd__or3b_2
X_1272_ _1272_/A _1274_/A vssd1 vssd1 vccd1 vccd1 _1278_/B sky130_fd_sc_hd__or2_2
Xwire38 wire38/A vssd1 vssd1 vccd1 vccd1 wire38/X sky130_fd_sc_hd__clkbuf_2
X_0987_ _0925_/Y _1016_/B _0977_/Y _0986_/X vssd1 vssd1 vccd1 vccd1 _1009_/D sky130_fd_sc_hd__o31ai_4
XTAP_TAPCELL_ROW_14_170 vssd1 vccd1 sky130_fd_sc_hd__tapvpwrvgnd_1
X_1608_ clkload8/A _1608_/D load_slew58/X vssd1 vssd1 vccd1 vccd1 _1608_/Q sky130_fd_sc_hd__dfrtp_2
X_1539_ _1539_/A _1539_/B _1540_/B vssd1 vssd1 vccd1 vccd1 _1634_/D sky130_fd_sc_hd__and3_2
XFILLER_10_112 vssd1 vssd1 vccd1 vccd1 sky130_fd_sc_hd__fill_1
XFILLER_42_248 vssd1 vssd1 vccd1 vccd1 sky130_fd_sc_hd__fill_4
XTAP_TAPCELL_ROW_37_284 vssd1 vccd1 sky130_fd_sc_hd__tapvpwrvgnd_1
XFILLER_10_167 vssd1 vssd1 vccd1 vccd1 sky130_fd_sc_hd__fill_4
XFILLER_12_41 vssd1 vssd1 vccd1 vccd1 sky130_fd_sc_hd__fill_2
XFILLER_12_85 vssd1 vccd1 vssd1 vccd1 sky130_ef_sc_hd__decap_40_12
XFILLER_6_138 vssd1 vssd1 vccd1 vccd1 sky130_fd_sc_hd__fill_2
XTAP_TAPCELL_ROW_28_240 vssd1 vccd1 sky130_fd_sc_hd__tapvpwrvgnd_1
XPHY_EDGE_ROW_16_Right_16 vssd1 vssd1 vccd1 vccd1 sky130_fd_sc_hd__decap_3
X_0910_ _0950_/A _1499_/A _0910_/C _0910_/D vssd1 vssd1 vccd1 vccd1 _0910_/Y sky130_fd_sc_hd__nor4_2
X_0841_ _1629_/Q _1520_/A _0841_/C vssd1 vssd1 vccd1 vccd1 _0841_/X sky130_fd_sc_hd__or3_2
XPHY_EDGE_ROW_25_Right_25 vssd1 vssd1 vccd1 vccd1 sky130_fd_sc_hd__decap_3
XFILLER_45_3 vssd1 vssd1 vccd1 vccd1 sky130_fd_sc_hd__fill_1
X_1324_ _1318_/B _1336_/B _1318_/A vssd1 vssd1 vccd1 vccd1 _1325_/B sky130_fd_sc_hd__a21oi_2
X_1255_ _1258_/A _1258_/B vssd1 vssd1 vccd1 vccd1 _1257_/B sky130_fd_sc_hd__or2_2
X_1186_ _1186_/A _1186_/B vssd1 vssd1 vccd1 vccd1 _1246_/A sky130_fd_sc_hd__and2_2
XPHY_EDGE_ROW_34_Right_34 vssd1 vssd1 vccd1 vccd1 sky130_fd_sc_hd__decap_3
XPHY_EDGE_ROW_43_Right_43 vssd1 vssd1 vccd1 vccd1 sky130_fd_sc_hd__decap_3
XFILLER_15_237 vssd1 vssd1 vccd1 vccd1 sky130_fd_sc_hd__fill_4
XFILLER_23_281 vssd1 vssd1 vccd1 vccd1 sky130_fd_sc_hd__fill_1
XFILLER_2_141 vssd1 vssd1 vccd1 vccd1 sky130_fd_sc_hd__fill_4
X_1040_ _1040_/A _1040_/B vssd1 vssd1 vccd1 vccd1 _1040_/X sky130_fd_sc_hd__xor2_4
XFILLER_0_55 vssd1 vssd1 vccd1 vccd1 sky130_fd_sc_hd__fill_1
XFILLER_14_292 vssd1 vssd1 vccd1 vccd1 sky130_fd_sc_hd__fill_4
XFILLER_21_207 vssd1 vssd1 vccd1 vccd1 sky130_fd_sc_hd__fill_4
XFILLER_9_31 vssd1 vssd1 vccd1 vccd1 sky130_fd_sc_hd__fill_1
X_0824_ _0821_/Y _1528_/B _1717_/A vssd1 vssd1 vccd1 vccd1 _0824_/Y sky130_fd_sc_hd__a21oi_2
XTAP_TAPCELL_ROW_31_257 vssd1 vccd1 sky130_fd_sc_hd__tapvpwrvgnd_1
XPHY_EDGE_ROW_24_Left_71 vssd1 vssd1 vccd1 vccd1 sky130_fd_sc_hd__decap_3
XFILLER_9_64 vssd1 vssd1 vccd1 vccd1 sky130_fd_sc_hd__fill_8
X_1307_ _1307_/A _1307_/B vssd1 vssd1 vccd1 vccd1 _1331_/B sky130_fd_sc_hd__xnor2_2
X_1238_ _1226_/Y _1225_/A _1238_/S vssd1 vssd1 vccd1 vccd1 _1294_/A sky130_fd_sc_hd__mux2_4
X_1169_ _1092_/Y _1174_/A _1175_/C1 vssd1 vssd1 vccd1 vccd1 _1170_/B sky130_fd_sc_hd__o21a_2
XTAP_TAPCELL_ROW_22_213 vssd1 vccd1 sky130_fd_sc_hd__tapvpwrvgnd_1
XFILLER_18_95 vssd1 vssd1 vccd1 vccd1 sky130_fd_sc_hd__fill_4
XFILLER_34_50 vssd1 vssd1 vccd1 vccd1 sky130_fd_sc_hd__fill_2
XTAP_TAPCELL_ROW_45_327 vssd1 vccd1 sky130_fd_sc_hd__tapvpwrvgnd_1
X_1023_ _1034_/B _1023_/B vssd1 vssd1 vccd1 vccd1 _1031_/B sky130_fd_sc_hd__and2_2
X_0807_ _1586_/Q _1587_/Q vssd1 vssd1 vccd1 vccd1 _0810_/B sky130_fd_sc_hd__and2b_2
XPHY_EDGE_ROW_2_Right_2 vssd1 vssd1 vccd1 vccd1 sky130_fd_sc_hd__decap_3
XFILLER_37_181 vssd1 vssd1 vccd1 vccd1 sky130_fd_sc_hd__fill_4
XFILLER_20_41 vssd1 vssd1 vccd1 vccd1 sky130_fd_sc_hd__fill_8
XFILLER_20_85 vssd1 vssd1 vccd1 vccd1 sky130_fd_sc_hd__fill_4
XFILLER_28_181 vssd1 vssd1 vccd1 vccd1 sky130_fd_sc_hd__fill_1
XFILLER_43_195 vssd1 vssd1 vccd1 vccd1 sky130_fd_sc_hd__fill_1
XFILLER_45_93 vssd1 vssd1 vccd1 vccd1 sky130_fd_sc_hd__fill_2
X_1572_ _1572_/A _1573_/C vssd1 vssd1 vccd1 vccd1 _1647_/D sky130_fd_sc_hd__xor2_2
X_1641_ _1641_/CLK _1641_/D vssd1 vssd1 vccd1 vccd1 _1641_/Q sky130_fd_sc_hd__dfxtp_2
X_1006_ _1006_/A _1006_/B vssd1 vssd1 vccd1 vccd1 _1044_/B sky130_fd_sc_hd__xnor2_2
Xrebuffer127 _0934_/B vssd1 vssd1 vccd1 vccd1 _0912_/B sky130_fd_sc_hd__buf_8
Xrebuffer138 rebuffer184/X vssd1 vssd1 vccd1 vccd1 _1441_/B sky130_fd_sc_hd__buf_2
Xrebuffer149 _1136_/Y vssd1 vssd1 vccd1 vccd1 _1163_/B sky130_fd_sc_hd__buf_4
XFILLER_15_85 vssd1 vssd1 vccd1 vccd1 sky130_fd_sc_hd__fill_2
XFILLER_31_165 vssd1 vssd1 vccd1 vccd1 sky130_fd_sc_hd__fill_2
X_1555_ _1640_/Q _1558_/D vssd1 vssd1 vccd1 vccd1 _1556_/C sky130_fd_sc_hd__or2_2
X_1624_ clkload3/A _1624_/D fanout56/X vssd1 vssd1 vccd1 vccd1 _1624_/Q sky130_fd_sc_hd__dfrtp_2
XFILLER_39_243 vssd1 vssd1 vccd1 vccd1 sky130_fd_sc_hd__fill_2
X_1486_ _1490_/A _1490_/D _1488_/B vssd1 vssd1 vccd1 vccd1 _1486_/X sky130_fd_sc_hd__o21ba_2
XFILLER_22_187 vssd1 vssd1 vccd1 vccd1 sky130_fd_sc_hd__fill_2
Xclkbuf_4_13_0_clk clkbuf_0_clk/X vssd1 vssd1 vccd1 vccd1 _1633_/CLK sky130_fd_sc_hd__clkbuf_8
XTAP_TAPCELL_ROW_9_147 vssd1 vccd1 sky130_fd_sc_hd__tapvpwrvgnd_1
XFILLER_45_279 vssd1 vssd1 vccd1 vccd1 sky130_fd_sc_hd__fill_1
XANTENNA__1445__B1 _0893_/C vssd1 vssd1 vccd1 vccd1 sky130_fd_sc_hd__diode_2
XFILLER_13_110 vssd1 vssd1 vccd1 vccd1 sky130_fd_sc_hd__fill_2
XFILLER_13_121 vssd1 vssd1 vccd1 vccd1 sky130_fd_sc_hd__fill_2
XFILLER_42_83 vssd1 vssd1 vccd1 vccd1 sky130_fd_sc_hd__fill_1
XFILLER_9_169 vssd1 vssd1 vccd1 vccd1 sky130_fd_sc_hd__fill_8
X_1340_ _0788_/Y _1347_/C _1341_/B vssd1 vssd1 vccd1 vccd1 _1342_/A sky130_fd_sc_hd__a21bo_2
XFILLER_3_88 vssd1 vssd1 vccd1 vccd1 sky130_fd_sc_hd__fill_1
X_1271_ _1266_/X _1348_/A _1347_/B _1270_/X vssd1 vssd1 vccd1 vccd1 _1271_/X sky130_fd_sc_hd__a31o_4
X_0986_ _0991_/B _0991_/A _0926_/B vssd1 vssd1 vccd1 vccd1 _0986_/X sky130_fd_sc_hd__a21o_2
XTAP_TAPCELL_ROW_14_171 vssd1 vccd1 sky130_fd_sc_hd__tapvpwrvgnd_1
X_1607_ _1612_/CLK _1607_/D load_slew58/X vssd1 vssd1 vccd1 vccd1 _1607_/Q sky130_fd_sc_hd__dfrtp_2
X_1538_ _1634_/Q _1538_/B vssd1 vssd1 vccd1 vccd1 _1540_/B sky130_fd_sc_hd__nand2_2
X_1469_ _1612_/Q _1613_/Q _1469_/C vssd1 vssd1 vccd1 vccd1 _1475_/B sky130_fd_sc_hd__and3_2
XANTENNA__1520__B _1653_/Q vssd1 vssd1 vccd1 vccd1 sky130_fd_sc_hd__diode_2
XFILLER_42_205 vssd1 vssd1 vccd1 vccd1 sky130_fd_sc_hd__fill_1
XTAP_TAPCELL_ROW_37_285 vssd1 vccd1 sky130_fd_sc_hd__tapvpwrvgnd_1
XANTENNA__1607__RESET_B load_slew58/X vssd1 vssd1 vccd1 vccd1 sky130_fd_sc_hd__diode_2
XFILLER_12_97 vssd1 vssd1 vccd1 vccd1 sky130_fd_sc_hd__fill_8
XFILLER_18_235 vssd1 vssd1 vccd1 vccd1 sky130_fd_sc_hd__fill_2
XFILLER_33_238 vssd1 vssd1 vccd1 vccd1 sky130_fd_sc_hd__fill_4
XTAP_TAPCELL_ROW_28_241 vssd1 vccd1 sky130_fd_sc_hd__tapvpwrvgnd_1
X_0840_ _0828_/X _0833_/X _0839_/X _0838_/X vssd1 vssd1 vccd1 vccd1 _0840_/X sky130_fd_sc_hd__a31o_2
X_1323_ _1456_/A _1479_/A _1456_/B vssd1 vssd1 vccd1 vccd1 _1323_/Y sky130_fd_sc_hd__nand3_2
XFILLER_24_205 vssd1 vssd1 vccd1 vccd1 sky130_fd_sc_hd__fill_2
X_1254_ _1285_/C _1265_/B vssd1 vssd1 vccd1 vccd1 _1258_/B sky130_fd_sc_hd__nand2b_2
X_1185_ _1185_/A _1185_/B vssd1 vssd1 vccd1 vccd1 _1186_/B sky130_fd_sc_hd__nand2_2
X_0969_ _0960_/C _0969_/B _0969_/C vssd1 vssd1 vccd1 vccd1 _0972_/B sky130_fd_sc_hd__nand3b_2
XFILLER_23_85 vssd1 vssd1 vccd1 vccd1 sky130_fd_sc_hd__fill_2
XANTENNA_clkload8_A clkload8/A vssd1 vssd1 vccd1 vccd1 sky130_fd_sc_hd__diode_2
XFILLER_0_12 vssd1 vccd1 vssd1 vccd1 sky130_ef_sc_hd__decap_40_12
XTAP_TAPCELL_ROW_31_258 vssd1 vccd1 sky130_fd_sc_hd__tapvpwrvgnd_1
X_0823_ _1629_/Q _1520_/A vssd1 vssd1 vccd1 vccd1 _1528_/B sky130_fd_sc_hd__and2b_2
X_1306_ _1306_/A1 _1246_/B _1286_/A vssd1 vssd1 vccd1 vccd1 _1307_/B sky130_fd_sc_hd__o21a_2
XANTENNA__0893__C _0893_/C vssd1 vssd1 vccd1 vccd1 sky130_fd_sc_hd__diode_2
X_1237_ _1233_/A _1236_/Y _1233_/C vssd1 vssd1 vccd1 vccd1 _1237_/Y sky130_fd_sc_hd__a21boi_2
X_1168_ _1603_/Q _1174_/B vssd1 vssd1 vccd1 vccd1 _1177_/B sky130_fd_sc_hd__nor2_2
X_1099_ _1096_/X _1093_/Y _1154_/A vssd1 vssd1 vccd1 vccd1 _1099_/X sky130_fd_sc_hd__a21o_4
XANTENNA__1640__CLK clkload8/A vssd1 vssd1 vccd1 vccd1 sky130_fd_sc_hd__diode_2
XFILLER_20_296 vssd1 vssd1 vccd1 vccd1 sky130_fd_sc_hd__fill_2
XTAP_TAPCELL_ROW_45_328 vssd1 vccd1 sky130_fd_sc_hd__tapvpwrvgnd_1
XFILLER_7_223 vssd1 vssd1 vccd1 vccd1 sky130_fd_sc_hd__fill_1
XFILLER_38_138 vssd1 vssd1 vccd1 vccd1 sky130_fd_sc_hd__fill_2
XFILLER_46_193 vssd1 vssd1 vccd1 vccd1 sky130_fd_sc_hd__fill_2
Xload_slew62 fanout61/X vssd1 vssd1 vccd1 vccd1 _1653_/SET_B sky130_fd_sc_hd__buf_2
X_1022_ _1020_/B _1020_/A _1021_/Y vssd1 vssd1 vccd1 vccd1 _1023_/B sky130_fd_sc_hd__a21o_4
X_0806_ _1654_/Q _1655_/Q vssd1 vssd1 vccd1 vccd1 _0806_/X sky130_fd_sc_hd__or2_2
XTAP_TAPCELL_ROW_42_309 vssd1 vccd1 sky130_fd_sc_hd__tapvpwrvgnd_1
XFILLER_29_95 vssd1 vssd1 vccd1 vccd1 sky130_fd_sc_hd__fill_2
XFILLER_43_141 vssd1 vssd1 vccd1 vccd1 sky130_fd_sc_hd__fill_1
X_1571_ _1582_/B _1571_/B _1571_/C vssd1 vssd1 vccd1 vccd1 _1646_/D sky130_fd_sc_hd__and3_2
X_1640_ clkload8/A _1640_/D vssd1 vssd1 vccd1 vccd1 _1640_/Q sky130_fd_sc_hd__dfxtp_2
XFILLER_3_292 vssd1 vssd1 vccd1 vccd1 sky130_fd_sc_hd__fill_1
XFILLER_34_141 vssd1 vssd1 vccd1 vccd1 sky130_fd_sc_hd__fill_1
X_1005_ _1005_/A _1005_/B vssd1 vssd1 vccd1 vccd1 _1040_/A sky130_fd_sc_hd__xor2_2
Xrebuffer128 _0926_/C vssd1 vssd1 vccd1 vccd1 _0991_/B sky130_fd_sc_hd__buf_2
Xrebuffer139 rebuffer184/X vssd1 vssd1 vccd1 vccd1 _1426_/C sky130_fd_sc_hd__buf_2
XFILLER_40_100 vssd1 vssd1 vccd1 vccd1 sky130_fd_sc_hd__fill_2
XFILLER_31_41 vssd1 vssd1 vccd1 vccd1 sky130_fd_sc_hd__fill_4
XFILLER_0_251 vssd1 vssd1 vccd1 vccd1 sky130_fd_sc_hd__fill_1
XFILLER_16_130 vssd1 vssd1 vccd1 vccd1 sky130_fd_sc_hd__fill_1
XFILLER_31_111 vssd1 vssd1 vccd1 vccd1 sky130_fd_sc_hd__fill_1
XFILLER_31_199 vssd1 vssd1 vccd1 vccd1 sky130_fd_sc_hd__fill_4
X_1554_ _1640_/Q _1558_/D vssd1 vssd1 vccd1 vccd1 _1557_/B sky130_fd_sc_hd__nand2_2
X_1623_ clkload3/A _1623_/D load_slew60/X vssd1 vssd1 vccd1 vccd1 _1623_/Q sky130_fd_sc_hd__dfrtp_2
X_1485_ _1615_/Q _1490_/A _1485_/C vssd1 vssd1 vccd1 vccd1 _1488_/B sky130_fd_sc_hd__and3_2
.ends
