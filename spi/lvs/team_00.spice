* NGSPICE file created from team_00.ext - technology: sky130A

* Black-box entry subcircuit for sky130_fd_sc_hd__fill_2 abstract view
.subckt sky130_fd_sc_hd__fill_2 VGND VNB VPB VPWR
.ends

* Black-box entry subcircuit for sky130_fd_sc_hd__fill_1 abstract view
.subckt sky130_fd_sc_hd__fill_1 VGND VNB VPB VPWR
.ends

* Black-box entry subcircuit for sky130_ef_sc_hd__decap_40_12 abstract view
.subckt sky130_ef_sc_hd__decap_40_12 VNB VPB VGND VPWR
.ends

* Black-box entry subcircuit for sky130_fd_sc_hd__diode_2 abstract view
.subckt sky130_fd_sc_hd__diode_2 DIODE VGND VNB VPB VPWR
.ends

* Black-box entry subcircuit for sky130_fd_sc_hd__decap_3 abstract view
.subckt sky130_fd_sc_hd__decap_3 VGND VNB VPB VPWR
.ends

* Black-box entry subcircuit for sky130_fd_sc_hd__fill_4 abstract view
.subckt sky130_fd_sc_hd__fill_4 VGND VNB VPB VPWR
.ends

* Black-box entry subcircuit for sky130_fd_sc_hd__tapvpwrvgnd_1 abstract view
.subckt sky130_fd_sc_hd__tapvpwrvgnd_1 VGND VPWR
.ends

* Black-box entry subcircuit for sky130_fd_sc_hd__inv_2 abstract view
.subckt sky130_fd_sc_hd__inv_2 A VGND VNB VPB VPWR Y
.ends

* Black-box entry subcircuit for sky130_fd_sc_hd__and2b_2 abstract view
.subckt sky130_fd_sc_hd__and2b_2 A_N B VGND VNB VPB VPWR X
.ends

* Black-box entry subcircuit for sky130_fd_sc_hd__dfrtp_2 abstract view
.subckt sky130_fd_sc_hd__dfrtp_2 CLK D RESET_B VGND VNB VPB VPWR Q
.ends

* Black-box entry subcircuit for sky130_fd_sc_hd__buf_2 abstract view
.subckt sky130_fd_sc_hd__buf_2 A VGND VNB VPB VPWR X
.ends

* Black-box entry subcircuit for sky130_fd_sc_hd__clkdlybuf4s25_1 abstract view
.subckt sky130_fd_sc_hd__clkdlybuf4s25_1 A VGND VNB VPB VPWR X
.ends

* Black-box entry subcircuit for sky130_fd_sc_hd__conb_1 abstract view
.subckt sky130_fd_sc_hd__conb_1 VGND VNB VPB VPWR HI LO
.ends

* Black-box entry subcircuit for sky130_fd_sc_hd__fill_8 abstract view
.subckt sky130_fd_sc_hd__fill_8 VGND VNB VPB VPWR
.ends

* Black-box entry subcircuit for sky130_fd_sc_hd__a21oi_2 abstract view
.subckt sky130_fd_sc_hd__a21oi_2 A1 A2 B1 VGND VNB VPB VPWR Y
.ends

* Black-box entry subcircuit for sky130_fd_sc_hd__nor2_2 abstract view
.subckt sky130_fd_sc_hd__nor2_2 A B VGND VNB VPB VPWR Y
.ends

* Black-box entry subcircuit for sky130_fd_sc_hd__a211o_2 abstract view
.subckt sky130_fd_sc_hd__a211o_2 A1 A2 B1 C1 VGND VNB VPB VPWR X
.ends

* Black-box entry subcircuit for sky130_fd_sc_hd__nand2_2 abstract view
.subckt sky130_fd_sc_hd__nand2_2 A B VGND VNB VPB VPWR Y
.ends

* Black-box entry subcircuit for sky130_fd_sc_hd__a41o_2 abstract view
.subckt sky130_fd_sc_hd__a41o_2 A1 A2 A3 A4 B1 VGND VNB VPB VPWR X
.ends

* Black-box entry subcircuit for sky130_fd_sc_hd__xnor2_2 abstract view
.subckt sky130_fd_sc_hd__xnor2_2 A B VGND VNB VPB VPWR Y
.ends

* Black-box entry subcircuit for sky130_fd_sc_hd__or2_2 abstract view
.subckt sky130_fd_sc_hd__or2_2 A B VGND VNB VPB VPWR X
.ends

* Black-box entry subcircuit for sky130_fd_sc_hd__a22o_2 abstract view
.subckt sky130_fd_sc_hd__a22o_2 A1 A2 B1 B2 VGND VNB VPB VPWR X
.ends

* Black-box entry subcircuit for sky130_fd_sc_hd__xor2_2 abstract view
.subckt sky130_fd_sc_hd__xor2_2 A B VGND VNB VPB VPWR X
.ends

* Black-box entry subcircuit for sky130_fd_sc_hd__and3_2 abstract view
.subckt sky130_fd_sc_hd__and3_2 A B C VGND VNB VPB VPWR X
.ends

* Black-box entry subcircuit for sky130_fd_sc_hd__o21ai_2 abstract view
.subckt sky130_fd_sc_hd__o21ai_2 A1 A2 B1 VGND VNB VPB VPWR Y
.ends

* Black-box entry subcircuit for sky130_fd_sc_hd__a21o_2 abstract view
.subckt sky130_fd_sc_hd__a21o_2 A1 A2 B1 VGND VNB VPB VPWR X
.ends

* Black-box entry subcircuit for sky130_fd_sc_hd__o211a_2 abstract view
.subckt sky130_fd_sc_hd__o211a_2 A1 A2 B1 C1 VGND VNB VPB VPWR X
.ends

* Black-box entry subcircuit for sky130_fd_sc_hd__and4_2 abstract view
.subckt sky130_fd_sc_hd__and4_2 A B C D VGND VNB VPB VPWR X
.ends

* Black-box entry subcircuit for sky130_fd_sc_hd__o21a_2 abstract view
.subckt sky130_fd_sc_hd__o21a_2 A1 A2 B1 VGND VNB VPB VPWR X
.ends

* Black-box entry subcircuit for sky130_fd_sc_hd__a32o_2 abstract view
.subckt sky130_fd_sc_hd__a32o_2 A1 A2 A3 B1 B2 VGND VNB VPB VPWR X
.ends

* Black-box entry subcircuit for sky130_fd_sc_hd__nor3_2 abstract view
.subckt sky130_fd_sc_hd__nor3_2 A B C VGND VNB VPB VPWR Y
.ends

* Black-box entry subcircuit for sky130_fd_sc_hd__and2_2 abstract view
.subckt sky130_fd_sc_hd__and2_2 A B VGND VNB VPB VPWR X
.ends

* Black-box entry subcircuit for sky130_fd_sc_hd__a31oi_2 abstract view
.subckt sky130_fd_sc_hd__a31oi_2 A1 A2 A3 B1 VGND VNB VPB VPWR Y
.ends

* Black-box entry subcircuit for sky130_fd_sc_hd__or4_2 abstract view
.subckt sky130_fd_sc_hd__or4_2 A B C D VGND VNB VPB VPWR X
.ends

* Black-box entry subcircuit for sky130_fd_sc_hd__o22ai_2 abstract view
.subckt sky130_fd_sc_hd__o22ai_2 A1 A2 B1 B2 VGND VNB VPB VPWR Y
.ends

* Black-box entry subcircuit for sky130_fd_sc_hd__nand2b_2 abstract view
.subckt sky130_fd_sc_hd__nand2b_2 A_N B VGND VNB VPB VPWR Y
.ends

* Black-box entry subcircuit for sky130_fd_sc_hd__a311oi_2 abstract view
.subckt sky130_fd_sc_hd__a311oi_2 A1 A2 A3 B1 C1 VGND VNB VPB VPWR Y
.ends

* Black-box entry subcircuit for sky130_fd_sc_hd__and3b_2 abstract view
.subckt sky130_fd_sc_hd__and3b_2 A_N B C VGND VNB VPB VPWR X
.ends

* Black-box entry subcircuit for sky130_fd_sc_hd__o2bb2ai_2 abstract view
.subckt sky130_fd_sc_hd__o2bb2ai_2 A1_N A2_N B1 B2 VGND VNB VPB VPWR Y
.ends

* Black-box entry subcircuit for sky130_fd_sc_hd__and4bb_2 abstract view
.subckt sky130_fd_sc_hd__and4bb_2 A_N B_N C D VGND VNB VPB VPWR X
.ends

* Black-box entry subcircuit for sky130_fd_sc_hd__o2111ai_2 abstract view
.subckt sky130_fd_sc_hd__o2111ai_2 A1 A2 B1 C1 D1 VGND VNB VPB VPWR Y
.ends

* Black-box entry subcircuit for sky130_fd_sc_hd__a2bb2oi_2 abstract view
.subckt sky130_fd_sc_hd__a2bb2oi_2 A1_N A2_N B1 B2 VGND VNB VPB VPWR Y
.ends

* Black-box entry subcircuit for sky130_fd_sc_hd__a31o_2 abstract view
.subckt sky130_fd_sc_hd__a31o_2 A1 A2 A3 B1 VGND VNB VPB VPWR X
.ends

* Black-box entry subcircuit for sky130_fd_sc_hd__or3b_2 abstract view
.subckt sky130_fd_sc_hd__or3b_2 A B C_N VGND VNB VPB VPWR X
.ends

* Black-box entry subcircuit for sky130_fd_sc_hd__a22oi_2 abstract view
.subckt sky130_fd_sc_hd__a22oi_2 A1 A2 B1 B2 VGND VNB VPB VPWR Y
.ends

* Black-box entry subcircuit for sky130_fd_sc_hd__a21bo_2 abstract view
.subckt sky130_fd_sc_hd__a21bo_2 A1 A2 B1_N VGND VNB VPB VPWR X
.ends

* Black-box entry subcircuit for sky130_fd_sc_hd__o21bai_2 abstract view
.subckt sky130_fd_sc_hd__o21bai_2 A1 A2 B1_N VGND VNB VPB VPWR Y
.ends

* Black-box entry subcircuit for sky130_fd_sc_hd__clkbuf_16 abstract view
.subckt sky130_fd_sc_hd__clkbuf_16 A VGND VNB VPB VPWR X
.ends

* Black-box entry subcircuit for sky130_fd_sc_hd__o31a_2 abstract view
.subckt sky130_fd_sc_hd__o31a_2 A1 A2 A3 B1 VGND VNB VPB VPWR X
.ends

* Black-box entry subcircuit for sky130_fd_sc_hd__o22a_2 abstract view
.subckt sky130_fd_sc_hd__o22a_2 A1 A2 B1 B2 VGND VNB VPB VPWR X
.ends

* Black-box entry subcircuit for sky130_fd_sc_hd__or3_2 abstract view
.subckt sky130_fd_sc_hd__or3_2 A B C VGND VNB VPB VPWR X
.ends

* Black-box entry subcircuit for sky130_fd_sc_hd__or4b_2 abstract view
.subckt sky130_fd_sc_hd__or4b_2 A B C D_N VGND VNB VPB VPWR X
.ends

* Black-box entry subcircuit for sky130_fd_sc_hd__o2bb2a_2 abstract view
.subckt sky130_fd_sc_hd__o2bb2a_2 A1_N A2_N B1 B2 VGND VNB VPB VPWR X
.ends

* Black-box entry subcircuit for sky130_fd_sc_hd__a221o_2 abstract view
.subckt sky130_fd_sc_hd__a221o_2 A1 A2 B1 B2 C1 VGND VNB VPB VPWR X
.ends

* Black-box entry subcircuit for sky130_fd_sc_hd__nand4_2 abstract view
.subckt sky130_fd_sc_hd__nand4_2 A B C D VGND VNB VPB VPWR Y
.ends

* Black-box entry subcircuit for sky130_fd_sc_hd__nand3_2 abstract view
.subckt sky130_fd_sc_hd__nand3_2 A B C VGND VNB VPB VPWR Y
.ends

* Black-box entry subcircuit for sky130_fd_sc_hd__o211ai_2 abstract view
.subckt sky130_fd_sc_hd__o211ai_2 A1 A2 B1 C1 VGND VNB VPB VPWR Y
.ends

* Black-box entry subcircuit for sky130_fd_sc_hd__a2bb2o_2 abstract view
.subckt sky130_fd_sc_hd__a2bb2o_2 A1_N A2_N B1 B2 VGND VNB VPB VPWR X
.ends

* Black-box entry subcircuit for sky130_fd_sc_hd__a21boi_2 abstract view
.subckt sky130_fd_sc_hd__a21boi_2 A1 A2 B1_N VGND VNB VPB VPWR Y
.ends

* Black-box entry subcircuit for sky130_fd_sc_hd__a32oi_2 abstract view
.subckt sky130_fd_sc_hd__a32oi_2 A1 A2 A3 B1 B2 VGND VNB VPB VPWR Y
.ends

* Black-box entry subcircuit for sky130_fd_sc_hd__nand3b_2 abstract view
.subckt sky130_fd_sc_hd__nand3b_2 A_N B C VGND VNB VPB VPWR Y
.ends

* Black-box entry subcircuit for sky130_fd_sc_hd__o221a_2 abstract view
.subckt sky130_fd_sc_hd__o221a_2 A1 A2 B1 B2 C1 VGND VNB VPB VPWR X
.ends

* Black-box entry subcircuit for sky130_fd_sc_hd__and4b_2 abstract view
.subckt sky130_fd_sc_hd__and4b_2 A_N B C D VGND VNB VPB VPWR X
.ends

* Black-box entry subcircuit for sky130_fd_sc_hd__mux2_1 abstract view
.subckt sky130_fd_sc_hd__mux2_1 A0 A1 S VGND VNB VPB VPWR X
.ends

* Black-box entry subcircuit for sky130_fd_sc_hd__a2111o_2 abstract view
.subckt sky130_fd_sc_hd__a2111o_2 A1 A2 B1 C1 D1 VGND VNB VPB VPWR X
.ends

* Black-box entry subcircuit for sky130_fd_sc_hd__o21ba_2 abstract view
.subckt sky130_fd_sc_hd__o21ba_2 A1 A2 B1_N VGND VNB VPB VPWR X
.ends

* Black-box entry subcircuit for sky130_fd_sc_hd__buf_1 abstract view
.subckt sky130_fd_sc_hd__buf_1 A VGND VNB VPB VPWR X
.ends

* Black-box entry subcircuit for sky130_fd_sc_hd__nand4b_2 abstract view
.subckt sky130_fd_sc_hd__nand4b_2 A_N B C D VGND VNB VPB VPWR Y
.ends

* Black-box entry subcircuit for sky130_fd_sc_hd__buf_4 abstract view
.subckt sky130_fd_sc_hd__buf_4 A VGND VNB VPB VPWR X
.ends

* Black-box entry subcircuit for sky130_fd_sc_hd__clkbuf_2 abstract view
.subckt sky130_fd_sc_hd__clkbuf_2 A VGND VNB VPB VPWR X
.ends

* Black-box entry subcircuit for sky130_fd_sc_hd__or4bb_2 abstract view
.subckt sky130_fd_sc_hd__or4bb_2 A B C_N D_N VGND VNB VPB VPWR X
.ends

* Black-box entry subcircuit for sky130_fd_sc_hd__o32a_2 abstract view
.subckt sky130_fd_sc_hd__o32a_2 A1 A2 A3 B1 B2 VGND VNB VPB VPWR X
.ends

* Black-box entry subcircuit for sky130_fd_sc_hd__nor3b_2 abstract view
.subckt sky130_fd_sc_hd__nor3b_2 A B C_N VGND VNB VPB VPWR Y
.ends

* Black-box entry subcircuit for sky130_fd_sc_hd__clkbuf_4 abstract view
.subckt sky130_fd_sc_hd__clkbuf_4 A VGND VNB VPB VPWR X
.ends

* Black-box entry subcircuit for sky130_fd_sc_hd__a311o_2 abstract view
.subckt sky130_fd_sc_hd__a311o_2 A1 A2 A3 B1 C1 VGND VNB VPB VPWR X
.ends

.subckt team_00 clk done en gpio_in[0] gpio_in[10] gpio_in[11] gpio_in[12] gpio_in[13]
+ gpio_in[14] gpio_in[15] gpio_in[16] gpio_in[17] gpio_in[18] gpio_in[19] gpio_in[1]
+ gpio_in[20] gpio_in[21] gpio_in[22] gpio_in[23] gpio_in[24] gpio_in[25] gpio_in[26]
+ gpio_in[27] gpio_in[28] gpio_in[29] gpio_in[2] gpio_in[30] gpio_in[31] gpio_in[32]
+ gpio_in[33] gpio_in[3] gpio_in[4] gpio_in[5] gpio_in[6] gpio_in[7] gpio_in[8] gpio_in[9]
+ gpio_oeb[0] gpio_oeb[10] gpio_oeb[11] gpio_oeb[12] gpio_oeb[13] gpio_oeb[14] gpio_oeb[15]
+ gpio_oeb[16] gpio_oeb[17] gpio_oeb[18] gpio_oeb[19] gpio_oeb[1] gpio_oeb[20] gpio_oeb[21]
+ gpio_oeb[22] gpio_oeb[23] gpio_oeb[24] gpio_oeb[25] gpio_oeb[26] gpio_oeb[27] gpio_oeb[28]
+ gpio_oeb[29] gpio_oeb[2] gpio_oeb[30] gpio_oeb[31] gpio_oeb[32] gpio_oeb[33] gpio_oeb[3]
+ gpio_oeb[4] gpio_oeb[5] gpio_oeb[6] gpio_oeb[7] gpio_oeb[8] gpio_oeb[9] gpio_out[0]
+ gpio_out[10] gpio_out[11] gpio_out[12] gpio_out[13] gpio_out[14] gpio_out[15] gpio_out[16]
+ gpio_out[17] gpio_out[18] gpio_out[19] gpio_out[1] gpio_out[20] gpio_out[21] gpio_out[22]
+ gpio_out[23] gpio_out[24] gpio_out[25] gpio_out[26] gpio_out[27] gpio_out[28] gpio_out[29]
+ gpio_out[2] gpio_out[30] gpio_out[31] gpio_out[32] gpio_out[33] gpio_out[3] gpio_out[4]
+ gpio_out[5] gpio_out[6] gpio_out[7] gpio_out[8] gpio_out[9] la_data_in[0] la_data_in[10]
+ la_data_in[11] la_data_in[12] la_data_in[13] la_data_in[14] la_data_in[15] la_data_in[16]
+ la_data_in[17] la_data_in[18] la_data_in[19] la_data_in[1] la_data_in[20] la_data_in[21]
+ la_data_in[22] la_data_in[23] la_data_in[24] la_data_in[25] la_data_in[26] la_data_in[27]
+ la_data_in[28] la_data_in[29] la_data_in[2] la_data_in[30] la_data_in[31] la_data_in[3]
+ la_data_in[4] la_data_in[5] la_data_in[6] la_data_in[7] la_data_in[8] la_data_in[9]
+ la_data_out[0] la_data_out[10] la_data_out[11] la_data_out[12] la_data_out[13] la_data_out[14]
+ la_data_out[15] la_data_out[16] la_data_out[17] la_data_out[18] la_data_out[19]
+ la_data_out[1] la_data_out[20] la_data_out[21] la_data_out[22] la_data_out[23] la_data_out[24]
+ la_data_out[25] la_data_out[26] la_data_out[27] la_data_out[28] la_data_out[29]
+ la_data_out[2] la_data_out[30] la_data_out[31] la_data_out[3] la_data_out[4] la_data_out[5]
+ la_data_out[6] la_data_out[7] la_data_out[8] la_data_out[9] la_oenb[0] la_oenb[10]
+ la_oenb[11] la_oenb[12] la_oenb[13] la_oenb[14] la_oenb[15] la_oenb[16] la_oenb[17]
+ la_oenb[18] la_oenb[19] la_oenb[1] la_oenb[20] la_oenb[21] la_oenb[22] la_oenb[23]
+ la_oenb[24] la_oenb[25] la_oenb[26] la_oenb[27] la_oenb[28] la_oenb[29] la_oenb[2]
+ la_oenb[30] la_oenb[31] la_oenb[3] la_oenb[4] la_oenb[5] la_oenb[6] la_oenb[7] la_oenb[8]
+ la_oenb[9] nrst prescaler[0] prescaler[10] prescaler[11] prescaler[12] prescaler[13]
+ prescaler[1] prescaler[2] prescaler[3] prescaler[4] prescaler[5] prescaler[6] prescaler[7]
+ prescaler[8] prescaler[9] vccd1 vssd1
XFILLER_39_233 vssd1 vssd1 vccd1 vccd1 sky130_fd_sc_hd__fill_2
XFILLER_39_277 vssd1 vssd1 vccd1 vccd1 sky130_fd_sc_hd__fill_2
XFILLER_22_177 vssd1 vssd1 vccd1 vccd1 sky130_fd_sc_hd__fill_1
XFILLER_52_29 vssd1 vccd1 vssd1 vccd1 sky130_ef_sc_hd__decap_40_12
XANTENNA__1466__RESET_B wire142/X vssd1 vssd1 vccd1 vccd1 sky130_fd_sc_hd__diode_2
XFILLER_45_225 vssd1 vccd1 vssd1 vccd1 sky130_ef_sc_hd__decap_40_12
XPHY_EDGE_ROW_37_Left_97 vssd1 vssd1 vccd1 vccd1 sky130_fd_sc_hd__decap_3
XFILLER_13_177 vssd1 vccd1 vssd1 vccd1 sky130_ef_sc_hd__decap_40_12
XFILLER_9_137 vssd1 vssd1 vccd1 vccd1 sky130_fd_sc_hd__fill_4
XTAP_TAPCELL_ROW_8_181 vssd1 vccd1 sky130_fd_sc_hd__tapvpwrvgnd_1
X_1270_ _1270_/A vssd1 vssd1 vccd1 vccd1 _1465_/D sky130_fd_sc_hd__inv_2
XFILLER_51_217 vssd1 vssd1 vccd1 vccd1 sky130_fd_sc_hd__fill_4
XFILLER_8_192 vssd1 vssd1 vccd1 vccd1 sky130_fd_sc_hd__fill_4
X_0985_ _0971_/B _0985_/B vssd1 vssd1 vccd1 vccd1 _0986_/B sky130_fd_sc_hd__and2b_2
XFILLER_47_29 vssd1 vssd1 vccd1 vccd1 sky130_fd_sc_hd__fill_2
X_1399_ _1438_/B _1427_/A vssd1 vssd1 vccd1 vccd1 _1435_/B sky130_fd_sc_hd__and2b_2
X_1468_ _1471_/CLK _1468_/D load_slew140/X vssd1 vssd1 vccd1 vccd1 _1468_/Q sky130_fd_sc_hd__dfrtp_2
X_1537_ _1543_/A vssd1 vssd1 vccd1 vccd1 _1537_/X sky130_fd_sc_hd__buf_2
Xfanout105 _0901_/X vssd1 vssd1 vccd1 vccd1 _1303_/C1 sky130_fd_sc_hd__clkdlybuf4s25_1
Xfanout116 _1474_/Q vssd1 vssd1 vccd1 vccd1 _1389_/A sky130_fd_sc_hd__clkdlybuf4s25_1
Xfanout127 _0723_/X vssd1 vssd1 vccd1 vccd1 _1192_/B sky130_fd_sc_hd__clkdlybuf4s25_1
Xfanout138 input6/X vssd1 vssd1 vccd1 vccd1 fanout138/X sky130_fd_sc_hd__clkdlybuf4s25_1
XFILLER_27_225 vssd1 vssd1 vccd1 vccd1 sky130_fd_sc_hd__fill_4
XFILLER_35_291 vssd1 vssd1 vccd1 vccd1 sky130_fd_sc_hd__fill_1
XFILLER_42_217 vssd1 vccd1 vssd1 vccd1 sky130_ef_sc_hd__decap_40_12
XFILLER_42_239 vssd1 vssd1 vccd1 vccd1 sky130_fd_sc_hd__fill_1
Xteam_00_159 vssd1 vssd1 vccd1 vccd1 team_00_159/HI la_data_out[12] sky130_fd_sc_hd__conb_1
Xteam_00_148 vssd1 vssd1 vccd1 vccd1 team_00_148/HI la_data_out[1] sky130_fd_sc_hd__conb_1
XFILLER_2_357 vssd1 vssd1 vccd1 vccd1 sky130_fd_sc_hd__fill_4
XFILLER_37_84 vssd1 vssd1 vccd1 vccd1 sky130_fd_sc_hd__fill_8
XFILLER_58_361 vssd1 vssd1 vccd1 vccd1 sky130_fd_sc_hd__fill_2
XTAP_TAPCELL_ROW_5_162 vssd1 vccd1 sky130_fd_sc_hd__tapvpwrvgnd_1
XFILLER_26_291 vssd1 vssd1 vccd1 vccd1 sky130_fd_sc_hd__fill_1
XFILLER_41_261 vssd1 vssd1 vccd1 vccd1 sky130_fd_sc_hd__fill_1
XFILLER_41_272 vssd1 vssd1 vccd1 vccd1 sky130_fd_sc_hd__fill_8
X_0770_ _1096_/A _0768_/X _0767_/Y vssd1 vssd1 vccd1 vccd1 _0780_/A sky130_fd_sc_hd__a21oi_2
XFILLER_56_309 vssd1 vccd1 vssd1 vccd1 sky130_ef_sc_hd__decap_40_12
X_1322_ _1444_/Q _1445_/Q _1446_/Q vssd1 vssd1 vccd1 vccd1 _1323_/C sky130_fd_sc_hd__a21oi_2
X_1253_ _1375_/B _1375_/C vssd1 vssd1 vccd1 vccd1 _1463_/D sky130_fd_sc_hd__nor2_2
XFILLER_24_228 vssd1 vccd1 vssd1 vccd1 sky130_ef_sc_hd__decap_40_12
X_1184_ _1329_/A _1183_/Y _1182_/X _0902_/A vssd1 vssd1 vccd1 vccd1 _1184_/X sky130_fd_sc_hd__a211o_2
XTAP_TAPCELL_ROW_19_253 vssd1 vccd1 sky130_fd_sc_hd__tapvpwrvgnd_1
XFILLER_32_283 vssd1 vccd1 vssd1 vccd1 sky130_ef_sc_hd__decap_40_12
X_0968_ _0968_/A _0968_/B vssd1 vssd1 vccd1 vccd1 _0969_/B sky130_fd_sc_hd__nand2_2
X_0899_ _0997_/A _0998_/A _0998_/B _0997_/B _0898_/X vssd1 vssd1 vccd1 vccd1 _0900_/B
+ sky130_fd_sc_hd__a41o_2
XFILLER_59_125 vssd1 vccd1 vssd1 vccd1 sky130_ef_sc_hd__decap_40_12
XFILLER_59_169 vssd1 vccd1 vssd1 vccd1 sky130_ef_sc_hd__decap_40_12
XTAP_TAPCELL_ROW_2_143 vssd1 vccd1 sky130_fd_sc_hd__tapvpwrvgnd_1
XFILLER_15_239 vssd1 vssd1 vccd1 vccd1 sky130_fd_sc_hd__fill_2
XTAP_TAPCELL_ROW_25_289 vssd1 vccd1 sky130_fd_sc_hd__tapvpwrvgnd_1
XFILLER_2_121 vssd1 vccd1 vssd1 vccd1 sky130_ef_sc_hd__decap_40_12
XFILLER_2_165 vssd1 vccd1 vssd1 vccd1 sky130_ef_sc_hd__decap_40_12
XFILLER_38_309 vssd1 vssd1 vccd1 vccd1 sky130_fd_sc_hd__fill_2
XANTENNA_input10_X _0943_/A vssd1 vssd1 vccd1 vccd1 sky130_fd_sc_hd__diode_2
XFILLER_9_55 vssd1 vssd1 vccd1 vccd1 sky130_fd_sc_hd__fill_1
X_0822_ _0965_/A _0822_/B vssd1 vssd1 vccd1 vccd1 _0831_/A sky130_fd_sc_hd__xnor2_2
XTAP_TAPCELL_ROW_16_234 vssd1 vccd1 sky130_fd_sc_hd__tapvpwrvgnd_1
X_0753_ _0767_/A _0754_/B vssd1 vssd1 vccd1 vccd1 _0865_/A sky130_fd_sc_hd__or2_2
XPHY_EDGE_ROW_24_Left_84 vssd1 vssd1 vccd1 vccd1 sky130_fd_sc_hd__decap_3
XFILLER_56_139 vssd1 vssd1 vccd1 vccd1 sky130_fd_sc_hd__fill_1
X_1305_ _1228_/B _1303_/X _1304_/X vssd1 vssd1 vccd1 vccd1 _1470_/D sky130_fd_sc_hd__a21oi_2
X_1236_ _1294_/S _1234_/Y _1235_/X _1303_/C1 vssd1 vssd1 vccd1 vccd1 _1236_/X sky130_fd_sc_hd__a211o_2
XFILLER_37_364 vssd1 vssd1 vccd1 vccd1 sky130_fd_sc_hd__fill_1
XFILLER_52_301 vssd1 vssd1 vccd1 vccd1 sky130_fd_sc_hd__fill_4
XFILLER_52_345 vssd1 vccd1 vssd1 vccd1 sky130_ef_sc_hd__decap_40_12
X_1167_ _1174_/B _1167_/B vssd1 vssd1 vccd1 vccd1 _1167_/X sky130_fd_sc_hd__or2_2
X_1098_ _1453_/Q _1093_/X _1099_/B _1452_/Q vssd1 vssd1 vccd1 vccd1 _1100_/C sky130_fd_sc_hd__a22o_2
XANTENNA__0908__A3 _0942_/B vssd1 vssd1 vccd1 vccd1 sky130_fd_sc_hd__diode_2
XANTENNA_fanout128_X _1313_/B1 vssd1 vssd1 vccd1 vccd1 sky130_fd_sc_hd__diode_2
XFILLER_20_231 vssd1 vssd1 vccd1 vccd1 sky130_fd_sc_hd__fill_2
XFILLER_20_253 vssd1 vssd1 vccd1 vccd1 sky130_fd_sc_hd__fill_2
XANTENNA__1318__B1 _1330_/B1 vssd1 vssd1 vccd1 vccd1 sky130_fd_sc_hd__diode_2
XFILLER_18_64 vssd1 vssd1 vccd1 vccd1 sky130_fd_sc_hd__fill_4
XFILLER_28_342 vssd1 vssd1 vccd1 vccd1 sky130_fd_sc_hd__fill_8
XFILLER_47_106 vssd1 vssd1 vccd1 vccd1 sky130_fd_sc_hd__fill_4
XFILLER_55_161 vssd1 vssd1 vccd1 vccd1 sky130_fd_sc_hd__fill_4
XANTENNA__1465__CLK _1471_/CLK vssd1 vssd1 vccd1 vccd1 sky130_fd_sc_hd__diode_2
XFILLER_34_85 vssd1 vccd1 vssd1 vccd1 sky130_ef_sc_hd__decap_40_12
XFILLER_43_345 vssd1 vssd1 vccd1 vccd1 sky130_fd_sc_hd__fill_4
XTAP_TAPCELL_ROW_13_215 vssd1 vccd1 sky130_fd_sc_hd__tapvpwrvgnd_1
XFILLER_15_6 vssd1 vccd1 vssd1 vccd1 sky130_ef_sc_hd__decap_40_12
XFILLER_53_109 vssd1 vssd1 vccd1 vccd1 sky130_fd_sc_hd__fill_2
X_1021_ _1021_/A vssd1 vssd1 vccd1 vccd1 _1037_/B sky130_fd_sc_hd__inv_2
X_0805_ _0806_/A _0806_/B vssd1 vssd1 vccd1 vccd1 _0805_/Y sky130_fd_sc_hd__nor2_2
X_0736_ _0736_/A _0736_/B vssd1 vssd1 vccd1 vccd1 _0766_/B sky130_fd_sc_hd__xor2_2
X_1219_ _1459_/Q _1285_/C vssd1 vssd1 vccd1 vccd1 _1219_/Y sky130_fd_sc_hd__nand2_2
XTAP_TAPCELL_ROW_27_307 vssd1 vccd1 sky130_fd_sc_hd__tapvpwrvgnd_1
XANTENNA__1236__C1 _1303_/C1 vssd1 vssd1 vccd1 vccd1 sky130_fd_sc_hd__diode_2
XFILLER_25_345 vssd1 vssd1 vccd1 vccd1 sky130_fd_sc_hd__fill_2
XFILLER_52_153 vssd1 vccd1 vssd1 vccd1 sky130_ef_sc_hd__decap_40_12
XFILLER_52_197 vssd1 vccd1 vssd1 vccd1 sky130_ef_sc_hd__decap_40_12
XFILLER_4_249 vssd1 vssd1 vccd1 vccd1 sky130_fd_sc_hd__fill_2
XFILLER_20_98 vssd1 vssd1 vccd1 vccd1 sky130_fd_sc_hd__fill_8
XANTENNA_input18_A prescaler[7] vssd1 vssd1 vccd1 vccd1 sky130_fd_sc_hd__diode_2
XFILLER_16_345 vssd1 vssd1 vccd1 vccd1 sky130_fd_sc_hd__fill_4
XFILLER_28_172 vssd1 vccd1 vssd1 vccd1 sky130_ef_sc_hd__decap_40_12
XFILLER_45_40 vssd1 vssd1 vccd1 vccd1 sky130_fd_sc_hd__fill_4
XANTENNA__1227__C1 _1303_/C1 vssd1 vssd1 vccd1 vccd1 sky130_fd_sc_hd__diode_2
XFILLER_31_337 vssd1 vssd1 vccd1 vccd1 sky130_fd_sc_hd__fill_1
XTAP_TAPCELL_ROW_41_398 vssd1 vccd1 sky130_fd_sc_hd__tapvpwrvgnd_1
XFILLER_3_293 vssd1 vccd1 vssd1 vccd1 sky130_ef_sc_hd__decap_40_12
XFILLER_13_3 vssd1 vccd1 vssd1 vccd1 sky130_ef_sc_hd__decap_40_12
XFILLER_19_183 vssd1 vssd1 vccd1 vccd1 sky130_fd_sc_hd__fill_1
XFILLER_34_197 vssd1 vccd1 vssd1 vccd1 sky130_ef_sc_hd__decap_40_12
X_1004_ _1005_/A _1005_/B vssd1 vssd1 vccd1 vccd1 _1004_/Y sky130_fd_sc_hd__nor2_2
XFILLER_57_223 vssd1 vssd1 vccd1 vccd1 sky130_fd_sc_hd__fill_1
X_0719_ _1477_/Q _1438_/A _1431_/B vssd1 vssd1 vccd1 vccd1 _1439_/B sky130_fd_sc_hd__and3_2
XPHY_EDGE_ROW_11_Left_71 vssd1 vssd1 vccd1 vccd1 sky130_fd_sc_hd__decap_3
XFILLER_13_337 vssd1 vccd1 vssd1 vccd1 sky130_ef_sc_hd__decap_40_12
XFILLER_15_54 vssd1 vssd1 vccd1 vccd1 sky130_fd_sc_hd__fill_2
XFILLER_31_53 vssd1 vssd1 vccd1 vccd1 sky130_fd_sc_hd__fill_2
Xoutput75 _1436_/Y vssd1 vssd1 vccd1 vccd1 gpio_out[27] sky130_fd_sc_hd__clkdlybuf4s25_1
Xoutput64 _1426_/Y vssd1 vssd1 vccd1 vccd1 gpio_out[17] sky130_fd_sc_hd__clkdlybuf4s25_1
Xoutput53 _1518_/X vssd1 vssd1 vccd1 vccd1 gpio_oeb[7] sky130_fd_sc_hd__clkdlybuf4s25_1
Xoutput42 _1539_/X vssd1 vssd1 vccd1 vccd1 gpio_oeb[28] sky130_fd_sc_hd__clkdlybuf4s25_1
Xoutput31 _1529_/X vssd1 vssd1 vccd1 vccd1 gpio_oeb[18] sky130_fd_sc_hd__clkdlybuf4s25_1
XFILLER_48_234 vssd1 vccd1 vssd1 vccd1 sky130_ef_sc_hd__decap_40_12
XFILLER_48_289 vssd1 vccd1 vssd1 vccd1 sky130_ef_sc_hd__decap_40_12
XFILLER_56_83 vssd1 vssd1 vccd1 vccd1 sky130_fd_sc_hd__fill_1
Xoutput86 _1408_/X vssd1 vssd1 vccd1 vccd1 gpio_out[6] sky130_fd_sc_hd__clkdlybuf4s25_1
XFILLER_16_197 vssd1 vssd1 vccd1 vccd1 sky130_fd_sc_hd__fill_4
XFILLER_31_134 vssd1 vccd1 vssd1 vccd1 sky130_ef_sc_hd__decap_40_12
XFILLER_31_167 vssd1 vssd1 vccd1 vccd1 sky130_fd_sc_hd__fill_1
XFILLER_8_363 vssd1 vssd1 vccd1 vccd1 sky130_fd_sc_hd__fill_1
XFILLER_39_223 vssd1 vssd1 vccd1 vccd1 sky130_fd_sc_hd__fill_1
XFILLER_10_307 vssd1 vssd1 vccd1 vccd1 sky130_fd_sc_hd__fill_1
XFILLER_22_145 vssd1 vssd1 vccd1 vccd1 sky130_fd_sc_hd__fill_2
XANTENNA_fanout110_X _0715_/B vssd1 vssd1 vccd1 vccd1 sky130_fd_sc_hd__diode_2
XFILLER_13_167 vssd1 vssd1 vccd1 vccd1 sky130_fd_sc_hd__fill_1
XFILLER_26_64 vssd1 vccd1 vssd1 vccd1 sky130_ef_sc_hd__decap_40_12
XFILLER_45_237 vssd1 vccd1 vssd1 vccd1 sky130_ef_sc_hd__decap_40_12
XFILLER_53_281 vssd1 vccd1 vssd1 vccd1 sky130_ef_sc_hd__decap_40_12
XFILLER_9_105 vssd1 vssd1 vccd1 vccd1 sky130_fd_sc_hd__fill_4
XFILLER_13_189 vssd1 vccd1 vssd1 vccd1 sky130_ef_sc_hd__decap_40_12
XFILLER_42_85 vssd1 vssd1 vccd1 vccd1 sky130_fd_sc_hd__fill_2
XFILLER_5_333 vssd1 vssd1 vccd1 vccd1 sky130_fd_sc_hd__fill_2
XTAP_TAPCELL_ROW_51_460 vssd1 vccd1 sky130_fd_sc_hd__tapvpwrvgnd_1
XFILLER_3_57 vssd1 vccd1 vssd1 vccd1 sky130_ef_sc_hd__decap_40_12
XTAP_TAPCELL_ROW_8_182 vssd1 vccd1 sky130_fd_sc_hd__tapvpwrvgnd_1
X_0984_ _0984_/A _0984_/B vssd1 vssd1 vccd1 vccd1 _0984_/X sky130_fd_sc_hd__or2_2
X_1536_ _1541_/A vssd1 vssd1 vccd1 vccd1 _1536_/X sky130_fd_sc_hd__buf_2
X_1398_ _1425_/A _1442_/C vssd1 vssd1 vccd1 vccd1 _1417_/A sky130_fd_sc_hd__nand2_2
X_1467_ _1471_/CLK _1467_/D wire142/X vssd1 vssd1 vccd1 vccd1 _1467_/Q sky130_fd_sc_hd__dfrtp_2
Xfanout117 _1473_/Q vssd1 vssd1 vccd1 vccd1 _1381_/A sky130_fd_sc_hd__clkdlybuf4s25_1
Xfanout128 _0712_/X vssd1 vssd1 vccd1 vccd1 _1313_/B1 sky130_fd_sc_hd__clkdlybuf4s25_1
Xfanout139 wire142/X vssd1 vssd1 vccd1 vccd1 fanout139/X sky130_fd_sc_hd__clkdlybuf4s25_1
Xteam_00_149 vssd1 vssd1 vccd1 vccd1 team_00_149/HI la_data_out[2] sky130_fd_sc_hd__conb_1
XFILLER_35_281 vssd1 vssd1 vccd1 vccd1 sky130_fd_sc_hd__fill_8
XFILLER_42_229 vssd1 vssd1 vccd1 vccd1 sky130_fd_sc_hd__fill_8
XFILLER_50_251 vssd1 vssd1 vccd1 vccd1 sky130_fd_sc_hd__fill_1
XFILLER_10_137 vssd1 vssd1 vccd1 vccd1 sky130_fd_sc_hd__fill_2
XANTENNA__1363__B2 input7/X vssd1 vssd1 vccd1 vccd1 sky130_fd_sc_hd__diode_2
XFILLER_12_99 vssd1 vssd1 vccd1 vccd1 sky130_fd_sc_hd__fill_4
XFILLER_37_63 vssd1 vssd1 vccd1 vccd1 sky130_fd_sc_hd__fill_1
XTAP_TAPCELL_ROW_5_163 vssd1 vccd1 sky130_fd_sc_hd__tapvpwrvgnd_1
XFILLER_41_251 vssd1 vssd1 vccd1 vccd1 sky130_fd_sc_hd__fill_2
XFILLER_53_51 vssd1 vssd1 vccd1 vccd1 sky130_fd_sc_hd__fill_4
XTAP_TAPCELL_ROW_11_198 vssd1 vccd1 sky130_fd_sc_hd__tapvpwrvgnd_1
XANTENNA__1106__A1 _0767_/A vssd1 vssd1 vccd1 vccd1 sky130_fd_sc_hd__diode_2
XFILLER_38_5 vssd1 vssd1 vccd1 vccd1 sky130_fd_sc_hd__fill_4
X_1321_ _1446_/Q _1329_/A _1327_/C vssd1 vssd1 vccd1 vccd1 _1321_/X sky130_fd_sc_hd__and3_2
X_1252_ _1463_/Q _1252_/A2 _0715_/B vssd1 vssd1 vccd1 vccd1 _1375_/C sky130_fd_sc_hd__o21ai_2
XFILLER_24_218 vssd1 vssd1 vccd1 vccd1 sky130_fd_sc_hd__fill_4
X_1183_ _1454_/Q _1205_/B vssd1 vssd1 vccd1 vccd1 _1183_/Y sky130_fd_sc_hd__nand2_2
XTAP_TAPCELL_ROW_19_254 vssd1 vccd1 sky130_fd_sc_hd__tapvpwrvgnd_1
XANTENNA__1290__B1 _1340_/A vssd1 vssd1 vccd1 vccd1 sky130_fd_sc_hd__diode_2
XFILLER_32_251 vssd1 vssd1 vccd1 vccd1 sky130_fd_sc_hd__fill_1
XFILLER_32_295 vssd1 vssd1 vccd1 vccd1 sky130_fd_sc_hd__fill_4
X_0967_ _0942_/B _0881_/B _0879_/X vssd1 vssd1 vccd1 vccd1 _0987_/A sky130_fd_sc_hd__a21o_2
XPHY_EDGE_ROW_49_Left_109 vssd1 vssd1 vccd1 vccd1 sky130_fd_sc_hd__decap_3
XFILLER_58_18 vssd1 vssd1 vccd1 vccd1 sky130_fd_sc_hd__fill_8
XFILLER_58_29 vssd1 vccd1 vssd1 vccd1 sky130_ef_sc_hd__decap_40_12
XFILLER_59_137 vssd1 vssd1 vccd1 vccd1 sky130_fd_sc_hd__fill_2
X_1519_ _1541_/A vssd1 vssd1 vccd1 vccd1 _1519_/X sky130_fd_sc_hd__buf_2
X_0898_ _0777_/X _0873_/Y _0872_/Y vssd1 vssd1 vccd1 vccd1 _0898_/X sky130_fd_sc_hd__a21o_2
XPHY_EDGE_ROW_58_Left_118 vssd1 vssd1 vccd1 vccd1 sky130_fd_sc_hd__decap_3
XPHY_EDGE_ROW_12_Right_12 vssd1 vssd1 vccd1 vccd1 sky130_fd_sc_hd__decap_3
XTAP_TAPCELL_ROW_2_144 vssd1 vccd1 sky130_fd_sc_hd__tapvpwrvgnd_1
XPHY_EDGE_ROW_21_Right_21 vssd1 vssd1 vccd1 vccd1 sky130_fd_sc_hd__decap_3
XFILLER_15_229 vssd1 vssd1 vccd1 vccd1 sky130_fd_sc_hd__fill_2
XFILLER_23_21 vssd1 vssd1 vccd1 vccd1 sky130_fd_sc_hd__fill_2
XFILLER_23_295 vssd1 vssd1 vccd1 vccd1 sky130_fd_sc_hd__fill_1
XFILLER_23_54 vssd1 vssd1 vccd1 vccd1 sky130_fd_sc_hd__fill_2
XPHY_EDGE_ROW_30_Right_30 vssd1 vssd1 vccd1 vccd1 sky130_fd_sc_hd__decap_3
XFILLER_2_133 vssd1 vssd1 vccd1 vccd1 sky130_fd_sc_hd__fill_4
XFILLER_2_177 vssd1 vccd1 vssd1 vccd1 sky130_ef_sc_hd__decap_40_12
XANTENNA__1450__RESET_B load_slew137/X vssd1 vssd1 vccd1 vccd1 sky130_fd_sc_hd__diode_2
XFILLER_14_240 vssd1 vccd1 vssd1 vccd1 sky130_ef_sc_hd__decap_40_12
XFILLER_46_332 vssd1 vssd1 vccd1 vccd1 sky130_fd_sc_hd__fill_1
XFILLER_46_343 vssd1 vssd1 vccd1 vccd1 sky130_fd_sc_hd__fill_2
XFILLER_46_365 vssd1 vssd1 vccd1 vccd1 sky130_fd_sc_hd__fill_2
XTAP_TAPCELL_ROW_16_235 vssd1 vccd1 sky130_fd_sc_hd__tapvpwrvgnd_1
XANTENNA__1169__B _1205_/B vssd1 vssd1 vccd1 vccd1 sky130_fd_sc_hd__diode_2
X_0821_ _0821_/A _0821_/B vssd1 vssd1 vccd1 vccd1 _0848_/A sky130_fd_sc_hd__xor2_2
X_0752_ _0880_/B _0752_/B vssd1 vssd1 vccd1 vccd1 _0754_/B sky130_fd_sc_hd__xnor2_2
XFILLER_43_3 vssd1 vssd1 vccd1 vccd1 sky130_fd_sc_hd__fill_2
XFILLER_49_181 vssd1 vccd1 vssd1 vccd1 sky130_ef_sc_hd__decap_40_12
X_1304_ _1029_/A _1309_/B1 _1313_/B1 vssd1 vssd1 vccd1 vccd1 _1304_/X sky130_fd_sc_hd__a21o_2
X_1235_ _1307_/A1 _1307_/A2 _1307_/B1 _1233_/X vssd1 vssd1 vccd1 vccd1 _1235_/X sky130_fd_sc_hd__o211a_2
X_1166_ _1451_/Q _1165_/C _1452_/Q vssd1 vssd1 vccd1 vccd1 _1167_/B sky130_fd_sc_hd__a21oi_2
XFILLER_52_357 vssd1 vssd1 vccd1 vccd1 sky130_fd_sc_hd__fill_4
X_1097_ _1097_/A _1097_/B vssd1 vssd1 vccd1 vccd1 _1099_/B sky130_fd_sc_hd__nand2_2
XFILLER_43_313 vssd1 vssd1 vccd1 vccd1 sky130_fd_sc_hd__fill_8
XFILLER_43_357 vssd1 vssd1 vccd1 vccd1 sky130_fd_sc_hd__fill_2
XFILLER_47_129 vssd1 vssd1 vccd1 vccd1 sky130_fd_sc_hd__fill_2
XANTENNA__0902__A _0902_/A vssd1 vssd1 vccd1 vccd1 sky130_fd_sc_hd__diode_2
XFILLER_11_221 vssd1 vssd1 vccd1 vccd1 sky130_fd_sc_hd__fill_2
XFILLER_34_97 vssd1 vssd1 vccd1 vccd1 sky130_fd_sc_hd__fill_1
XFILLER_7_225 vssd1 vssd1 vccd1 vccd1 sky130_fd_sc_hd__fill_2
XTAP_TAPCELL_ROW_13_216 vssd1 vccd1 sky130_fd_sc_hd__tapvpwrvgnd_1
XFILLER_46_151 vssd1 vccd1 vssd1 vccd1 sky130_ef_sc_hd__decap_40_12
XFILLER_59_83 vssd1 vssd1 vccd1 vccd1 sky130_fd_sc_hd__fill_1
X_1020_ _1020_/A _1020_/B _1020_/C vssd1 vssd1 vccd1 vccd1 _1021_/A sky130_fd_sc_hd__and3_2
XANTENNA__1245__B1 _0715_/B vssd1 vssd1 vccd1 vccd1 sky130_fd_sc_hd__diode_2
XFILLER_34_313 vssd1 vssd1 vccd1 vccd1 sky130_fd_sc_hd__fill_2
XFILLER_46_195 vssd1 vssd1 vccd1 vccd1 sky130_fd_sc_hd__fill_1
XANTENNA__0812__A input7/X vssd1 vssd1 vccd1 vccd1 sky130_fd_sc_hd__diode_2
X_0804_ _0804_/A _0804_/B vssd1 vssd1 vccd1 vccd1 _0806_/B sky130_fd_sc_hd__or2_2
X_0735_ _0862_/A _0767_/A _0731_/Y vssd1 vssd1 vccd1 vccd1 _0766_/A sky130_fd_sc_hd__o21ai_2
XFILLER_25_335 vssd1 vssd1 vccd1 vccd1 sky130_fd_sc_hd__fill_1
XFILLER_37_195 vssd1 vssd1 vccd1 vccd1 sky130_fd_sc_hd__fill_1
XFILLER_52_121 vssd1 vccd1 vssd1 vccd1 sky130_ef_sc_hd__decap_40_12
X_1218_ _1218_/A _1232_/C vssd1 vssd1 vccd1 vccd1 _1218_/X sky130_fd_sc_hd__or2_2
X_1149_ _1449_/Q _1140_/B _1320_/C1 vssd1 vssd1 vccd1 vccd1 _1149_/Y sky130_fd_sc_hd__o21ai_2
XFILLER_40_338 vssd1 vssd1 vccd1 vccd1 sky130_fd_sc_hd__fill_1
XFILLER_40_349 vssd1 vssd1 vccd1 vccd1 sky130_fd_sc_hd__fill_1
XFILLER_52_165 vssd1 vccd1 vssd1 vccd1 sky130_ef_sc_hd__decap_40_12
XANTENNA_fanout98_A _1127_/Y vssd1 vssd1 vccd1 vccd1 sky130_fd_sc_hd__diode_2
XANTENNA__1272__B _1285_/C vssd1 vssd1 vccd1 vccd1 sky130_fd_sc_hd__diode_2
XFILLER_28_184 vssd1 vssd1 vccd1 vccd1 sky130_fd_sc_hd__fill_4
XFILLER_43_121 vssd1 vccd1 vssd1 vccd1 sky130_ef_sc_hd__decap_40_12
XFILLER_45_52 vssd1 vssd1 vccd1 vccd1 sky130_fd_sc_hd__fill_4
XFILLER_3_261 vssd1 vccd1 vssd1 vccd1 sky130_ef_sc_hd__decap_40_12
X_1003_ _1006_/B _1003_/B vssd1 vssd1 vccd1 vccd1 _1005_/B sky130_fd_sc_hd__and2b_2
XFILLER_22_349 vssd1 vssd1 vccd1 vccd1 sky130_fd_sc_hd__fill_2
XFILLER_34_154 vssd1 vssd1 vccd1 vccd1 sky130_fd_sc_hd__fill_2
XANTENNA_fanout100_A _1124_/X vssd1 vssd1 vccd1 vccd1 sky130_fd_sc_hd__diode_2
X_0718_ _1389_/A _1381_/A _1384_/C vssd1 vssd1 vccd1 vccd1 _1431_/B sky130_fd_sc_hd__and3_2
XPHY_EDGE_ROW_6_Right_6 vssd1 vssd1 vccd1 vccd1 sky130_fd_sc_hd__decap_3
XANTENNA__1455__CLK _1463_/CLK vssd1 vssd1 vccd1 vccd1 sky130_fd_sc_hd__diode_2
XFILLER_13_349 vssd1 vssd1 vccd1 vccd1 sky130_fd_sc_hd__fill_4
XFILLER_15_22 vssd1 vssd1 vccd1 vccd1 sky130_fd_sc_hd__fill_1
XFILLER_57_279 vssd1 vssd1 vccd1 vccd1 sky130_fd_sc_hd__fill_1
XFILLER_31_21 vssd1 vssd1 vccd1 vccd1 sky130_fd_sc_hd__fill_1
XANTENNA__0735__A2 _0767_/A vssd1 vssd1 vccd1 vccd1 sky130_fd_sc_hd__diode_2
XFILLER_0_253 vssd1 vccd1 vssd1 vccd1 sky130_ef_sc_hd__decap_40_12
Xoutput21 _1472_/Q vssd1 vssd1 vccd1 vccd1 done sky130_fd_sc_hd__clkdlybuf4s25_1
Xoutput87 _1410_/Y vssd1 vssd1 vccd1 vccd1 gpio_out[7] sky130_fd_sc_hd__clkdlybuf4s25_1
Xoutput76 _1437_/X vssd1 vssd1 vccd1 vccd1 gpio_out[28] sky130_fd_sc_hd__clkdlybuf4s25_1
Xoutput65 _1427_/X vssd1 vssd1 vccd1 vccd1 gpio_out[18] sky130_fd_sc_hd__clkdlybuf4s25_1
Xoutput54 _1519_/X vssd1 vssd1 vccd1 vccd1 gpio_oeb[8] sky130_fd_sc_hd__clkdlybuf4s25_1
Xoutput43 _1540_/X vssd1 vssd1 vccd1 vccd1 gpio_oeb[29] sky130_fd_sc_hd__clkdlybuf4s25_1
Xoutput32 _1530_/X vssd1 vssd1 vccd1 vccd1 gpio_oeb[19] sky130_fd_sc_hd__clkdlybuf4s25_1
XFILLER_16_110 vssd1 vccd1 vssd1 vccd1 sky130_ef_sc_hd__decap_40_12
XFILLER_48_213 vssd1 vssd1 vccd1 vccd1 sky130_fd_sc_hd__fill_2
XFILLER_48_246 vssd1 vssd1 vccd1 vccd1 sky130_fd_sc_hd__fill_4
XTAP_TAPCELL_ROW_46_425 vssd1 vccd1 sky130_fd_sc_hd__tapvpwrvgnd_1
XFILLER_16_154 vssd1 vssd1 vccd1 vccd1 sky130_fd_sc_hd__fill_1
XFILLER_16_165 vssd1 vssd1 vccd1 vccd1 sky130_fd_sc_hd__fill_4
XFILLER_31_113 vssd1 vssd1 vccd1 vccd1 sky130_fd_sc_hd__fill_8
XFILLER_31_146 vssd1 vssd1 vccd1 vccd1 sky130_fd_sc_hd__fill_1
XTAP_TAPCELL_ROW_54_480 vssd1 vccd1 sky130_fd_sc_hd__tapvpwrvgnd_1
XPHY_EDGE_ROW_59_Right_59 vssd1 vssd1 vccd1 vccd1 sky130_fd_sc_hd__decap_3
XFILLER_39_235 vssd1 vssd1 vccd1 vccd1 sky130_fd_sc_hd__fill_1
XFILLER_39_279 vssd1 vssd1 vccd1 vccd1 sky130_fd_sc_hd__fill_1
XFILLER_54_249 vssd1 vssd1 vccd1 vccd1 sky130_fd_sc_hd__fill_2
XANTENNA_fanout103_X _1330_/B1 vssd1 vssd1 vccd1 vccd1 sky130_fd_sc_hd__diode_2
XFILLER_45_205 vssd1 vssd1 vccd1 vccd1 sky130_fd_sc_hd__fill_1
XFILLER_45_249 vssd1 vssd1 vccd1 vccd1 sky130_fd_sc_hd__fill_2
XFILLER_13_113 vssd1 vssd1 vccd1 vccd1 sky130_fd_sc_hd__fill_4
XFILLER_26_76 vssd1 vssd1 vccd1 vccd1 sky130_fd_sc_hd__fill_2
XFILLER_53_293 vssd1 vccd1 vssd1 vccd1 sky130_ef_sc_hd__decap_40_12
XTAP_TAPCELL_ROW_51_461 vssd1 vccd1 sky130_fd_sc_hd__tapvpwrvgnd_1
XTAP_TAPCELL_ROW_43_406 vssd1 vccd1 sky130_fd_sc_hd__tapvpwrvgnd_1
XANTENNA__0910__A input9/X vssd1 vssd1 vccd1 vccd1 sky130_fd_sc_hd__diode_2
XANTENNA__1475__RESET_B wire142/X vssd1 vssd1 vccd1 vccd1 sky130_fd_sc_hd__diode_2
XFILLER_3_69 vssd1 vccd1 vssd1 vccd1 sky130_ef_sc_hd__decap_40_12
XTAP_TAPCELL_ROW_8_183 vssd1 vccd1 sky130_fd_sc_hd__tapvpwrvgnd_1
XFILLER_29_290 vssd1 vssd1 vccd1 vccd1 sky130_fd_sc_hd__fill_4
XFILLER_36_238 vssd1 vssd1 vccd1 vccd1 sky130_fd_sc_hd__fill_1
X_0983_ _0984_/A _0984_/B vssd1 vssd1 vccd1 vccd1 _1005_/A sky130_fd_sc_hd__nor2_2
X_1535_ _1535_/A vssd1 vssd1 vccd1 vccd1 _1535_/X sky130_fd_sc_hd__buf_2
Xfanout107 _0724_/X vssd1 vssd1 vccd1 vccd1 _1332_/A1 sky130_fd_sc_hd__clkdlybuf4s25_1
Xfanout118 _1473_/Q vssd1 vssd1 vccd1 vccd1 _1416_/B sky130_fd_sc_hd__clkdlybuf4s25_1
Xfanout129 _1535_/A vssd1 vssd1 vccd1 vccd1 _1541_/A sky130_fd_sc_hd__clkdlybuf4s25_1
X_1397_ _1439_/A _1439_/C _1425_/A vssd1 vssd1 vccd1 vccd1 _1422_/D sky130_fd_sc_hd__and3_2
X_1466_ _1471_/CLK _1466_/D wire142/X vssd1 vssd1 vccd1 vccd1 _1466_/Q sky130_fd_sc_hd__dfrtp_2
XFILLER_6_109 vssd1 vccd1 vssd1 vccd1 sky130_ef_sc_hd__decap_40_12
XTAP_TAPCELL_ROW_5_164 vssd1 vccd1 sky130_fd_sc_hd__tapvpwrvgnd_1
XANTENNA__1280__B _1285_/C vssd1 vssd1 vccd1 vccd1 sky130_fd_sc_hd__diode_2
XFILLER_58_363 vssd1 vssd1 vccd1 vccd1 sky130_fd_sc_hd__fill_1
XFILLER_41_230 vssd1 vssd1 vccd1 vccd1 sky130_fd_sc_hd__fill_4
X_1320_ _1332_/A1 _1318_/X _1319_/X _1320_/C1 vssd1 vssd1 vccd1 vccd1 _1445_/D sky130_fd_sc_hd__o211a_2
XTAP_TAPCELL_ROW_11_199 vssd1 vccd1 sky130_fd_sc_hd__tapvpwrvgnd_1
X_1251_ _1330_/B1 _1250_/X _1332_/A1 vssd1 vssd1 vccd1 vccd1 _1375_/B sky130_fd_sc_hd__a21oi_2
X_1182_ _1206_/A1 _1206_/A2 _1206_/B1 _1181_/Y vssd1 vssd1 vccd1 vccd1 _1182_/X sky130_fd_sc_hd__o211a_2
XFILLER_17_271 vssd1 vssd1 vccd1 vccd1 sky130_fd_sc_hd__fill_8
XFILLER_32_241 vssd1 vssd1 vccd1 vccd1 sky130_fd_sc_hd__fill_8
XTAP_TAPCELL_ROW_19_255 vssd1 vccd1 sky130_fd_sc_hd__tapvpwrvgnd_1
X_0966_ _0968_/A _0968_/B vssd1 vssd1 vccd1 vccd1 _0966_/Y sky130_fd_sc_hd__nor2_2
X_0897_ _0897_/A _0897_/B vssd1 vssd1 vccd1 vccd1 _0997_/C sky130_fd_sc_hd__xor2_2
X_1449_ _1463_/CLK _1449_/D load_slew137/X vssd1 vssd1 vccd1 vccd1 _1449_/Q sky130_fd_sc_hd__dfrtp_2
X_1518_ _1541_/A vssd1 vssd1 vccd1 vccd1 _1518_/X sky130_fd_sc_hd__buf_2
XFILLER_55_333 vssd1 vssd1 vccd1 vccd1 sky130_fd_sc_hd__fill_2
XTAP_TAPCELL_ROW_2_145 vssd1 vccd1 sky130_fd_sc_hd__tapvpwrvgnd_1
XFILLER_23_11 vssd1 vssd1 vccd1 vccd1 sky130_fd_sc_hd__fill_1
XFILLER_23_99 vssd1 vccd1 vssd1 vccd1 sky130_ef_sc_hd__decap_40_12
XFILLER_3_3 vssd1 vccd1 vssd1 vccd1 sky130_ef_sc_hd__decap_40_12
XFILLER_0_15 vssd1 vccd1 vssd1 vccd1 sky130_ef_sc_hd__decap_40_12
XFILLER_2_189 vssd1 vssd1 vccd1 vccd1 sky130_fd_sc_hd__fill_4
XFILLER_48_41 vssd1 vccd1 vssd1 vccd1 sky130_ef_sc_hd__decap_40_12
XFILLER_48_85 vssd1 vssd1 vccd1 vccd1 sky130_fd_sc_hd__fill_4
XFILLER_58_193 vssd1 vssd1 vccd1 vccd1 sky130_fd_sc_hd__fill_2
XTAP_TAPCELL_ROW_16_236 vssd1 vccd1 sky130_fd_sc_hd__tapvpwrvgnd_1
XFILLER_9_57 vssd1 vccd1 vssd1 vccd1 sky130_ef_sc_hd__decap_40_12
X_0820_ _0820_/A _0822_/B vssd1 vssd1 vccd1 vccd1 _0821_/B sky130_fd_sc_hd__nand2_2
X_0751_ _0880_/B _0752_/B vssd1 vssd1 vccd1 vccd1 _0751_/Y sky130_fd_sc_hd__nand2_2
XFILLER_36_3 vssd1 vssd1 vccd1 vccd1 sky130_fd_sc_hd__fill_1
X_1303_ _1294_/S _1300_/Y _1302_/X _1303_/C1 vssd1 vssd1 vccd1 vccd1 _1303_/X sky130_fd_sc_hd__a211o_2
XFILLER_49_193 vssd1 vccd1 vssd1 vccd1 sky130_ef_sc_hd__decap_40_12
X_1234_ _1461_/Q _1327_/C vssd1 vssd1 vccd1 vccd1 _1234_/Y sky130_fd_sc_hd__nand2_2
X_1165_ _1452_/Q _1451_/Q _1165_/C vssd1 vssd1 vccd1 vccd1 _1174_/B sky130_fd_sc_hd__and3_2
X_1096_ _1096_/A _1096_/B vssd1 vssd1 vccd1 vccd1 _1097_/B sky130_fd_sc_hd__or2_2
XFILLER_20_211 vssd1 vccd1 vssd1 vccd1 sky130_ef_sc_hd__decap_40_12
XFILLER_20_277 vssd1 vssd1 vccd1 vccd1 sky130_fd_sc_hd__fill_4
X_0949_ _0973_/A _0973_/B vssd1 vssd1 vccd1 vccd1 _1020_/B sky130_fd_sc_hd__nor2_2
XFILLER_18_44 vssd1 vssd1 vccd1 vccd1 sky130_fd_sc_hd__fill_4
XFILLER_34_21 vssd1 vssd1 vccd1 vccd1 sky130_fd_sc_hd__fill_1
XFILLER_34_54 vssd1 vccd1 vssd1 vccd1 sky130_ef_sc_hd__decap_40_12
XFILLER_43_303 vssd1 vssd1 vccd1 vccd1 sky130_fd_sc_hd__fill_2
XFILLER_11_277 vssd1 vssd1 vccd1 vccd1 sky130_fd_sc_hd__fill_1
XFILLER_50_31 vssd1 vssd1 vccd1 vccd1 sky130_fd_sc_hd__fill_1
XFILLER_50_53 vssd1 vssd1 vccd1 vccd1 sky130_fd_sc_hd__fill_2
XFILLER_19_333 vssd1 vssd1 vccd1 vccd1 sky130_fd_sc_hd__fill_2
XFILLER_46_163 vssd1 vccd1 vssd1 vccd1 sky130_ef_sc_hd__decap_40_12
X_0803_ _0803_/A _0803_/B vssd1 vssd1 vccd1 vccd1 _0806_/A sky130_fd_sc_hd__xnor2_2
X_0734_ _0736_/A _0736_/B vssd1 vssd1 vccd1 vccd1 _0734_/Y sky130_fd_sc_hd__nor2_2
XFILLER_25_325 vssd1 vssd1 vccd1 vccd1 sky130_fd_sc_hd__fill_8
XFILLER_52_133 vssd1 vssd1 vccd1 vccd1 sky130_fd_sc_hd__fill_4
XFILLER_52_177 vssd1 vccd1 vssd1 vccd1 sky130_ef_sc_hd__decap_40_12
X_1217_ _1459_/Q _1458_/Q _1457_/Q _1217_/D vssd1 vssd1 vccd1 vccd1 _1232_/C sky130_fd_sc_hd__and4_2
X_1148_ _1190_/A _1146_/Y _1147_/X _0902_/A vssd1 vssd1 vccd1 vccd1 _1148_/X sky130_fd_sc_hd__a211o_2
X_1079_ _1460_/Q _1079_/B vssd1 vssd1 vccd1 vccd1 _1081_/C sky130_fd_sc_hd__xnor2_2
XFILLER_20_67 vssd1 vssd1 vccd1 vccd1 sky130_fd_sc_hd__fill_1
XFILLER_20_89 vssd1 vssd1 vccd1 vccd1 sky130_fd_sc_hd__fill_2
XFILLER_28_141 vssd1 vssd1 vccd1 vccd1 sky130_fd_sc_hd__fill_1
XFILLER_29_65 vssd1 vssd1 vccd1 vccd1 sky130_fd_sc_hd__fill_8
XFILLER_29_87 vssd1 vssd1 vccd1 vccd1 sky130_fd_sc_hd__fill_8
XFILLER_43_133 vssd1 vccd1 vssd1 vccd1 sky130_ef_sc_hd__decap_40_12
XFILLER_45_86 vssd1 vssd1 vccd1 vccd1 sky130_fd_sc_hd__fill_8
XANTENNA__1163__B1 _1320_/C1 vssd1 vssd1 vccd1 vccd1 sky130_fd_sc_hd__diode_2
XFILLER_3_273 vssd1 vssd1 vccd1 vccd1 sky130_fd_sc_hd__fill_4
XFILLER_19_141 vssd1 vssd1 vccd1 vccd1 sky130_fd_sc_hd__fill_2
XFILLER_22_306 vssd1 vssd1 vccd1 vccd1 sky130_fd_sc_hd__fill_2
XFILLER_34_166 vssd1 vssd1 vccd1 vccd1 sky130_fd_sc_hd__fill_2
X_1002_ _1065_/B _1065_/C _0984_/X _1065_/A vssd1 vssd1 vccd1 vccd1 _1055_/B sky130_fd_sc_hd__a211o_2
XTAP_TAPCELL_ROW_49_445 vssd1 vccd1 sky130_fd_sc_hd__tapvpwrvgnd_1
XTAP_TAPCELL_ROW_32_334 vssd1 vccd1 sky130_fd_sc_hd__tapvpwrvgnd_1
X_0717_ _1381_/A _1339_/A _0716_/Y vssd1 vssd1 vccd1 vccd1 _1473_/D sky130_fd_sc_hd__o21a_2
XFILLER_57_225 vssd1 vccd1 vssd1 vccd1 sky130_ef_sc_hd__decap_40_12
XANTENNA__0733__A _0771_/A vssd1 vssd1 vccd1 vccd1 sky130_fd_sc_hd__diode_2
XFILLER_25_111 vssd1 vssd1 vccd1 vccd1 sky130_fd_sc_hd__fill_1
XFILLER_25_155 vssd1 vccd1 vssd1 vccd1 sky130_ef_sc_hd__decap_40_12
XFILLER_25_188 vssd1 vssd1 vccd1 vccd1 sky130_fd_sc_hd__fill_1
XFILLER_40_136 vssd1 vssd1 vccd1 vccd1 sky130_fd_sc_hd__fill_4
XFILLER_31_55 vssd1 vssd1 vccd1 vccd1 sky130_fd_sc_hd__fill_1
XFILLER_0_265 vssd1 vccd1 vssd1 vccd1 sky130_ef_sc_hd__decap_40_12
Xoutput22 _1511_/X vssd1 vssd1 vccd1 vccd1 gpio_oeb[0] sky130_fd_sc_hd__clkdlybuf4s25_1
Xoutput88 _1412_/X vssd1 vssd1 vccd1 vccd1 gpio_out[8] sky130_fd_sc_hd__clkdlybuf4s25_1
Xoutput77 _1438_/X vssd1 vssd1 vccd1 vccd1 gpio_out[29] sky130_fd_sc_hd__clkdlybuf4s25_1
Xoutput66 _1428_/Y vssd1 vssd1 vccd1 vccd1 gpio_out[19] sky130_fd_sc_hd__clkdlybuf4s25_1
Xoutput55 _1520_/X vssd1 vssd1 vccd1 vccd1 gpio_oeb[9] sky130_fd_sc_hd__clkdlybuf4s25_1
Xoutput44 _1513_/X vssd1 vssd1 vccd1 vccd1 gpio_oeb[2] sky130_fd_sc_hd__clkdlybuf4s25_1
Xoutput33 _1512_/X vssd1 vssd1 vccd1 vccd1 gpio_oeb[1] sky130_fd_sc_hd__clkdlybuf4s25_1
XFILLER_16_122 vssd1 vccd1 vssd1 vccd1 sky130_ef_sc_hd__decap_40_12
XFILLER_56_41 vssd1 vccd1 vssd1 vccd1 sky130_ef_sc_hd__decap_40_12
XFILLER_56_85 vssd1 vccd1 vssd1 vccd1 sky130_ef_sc_hd__decap_40_12
XTAP_TAPCELL_ROW_46_426 vssd1 vccd1 sky130_fd_sc_hd__tapvpwrvgnd_1
XFILLER_8_321 vssd1 vccd1 vssd1 vccd1 sky130_ef_sc_hd__decap_40_12
XTAP_TAPCELL_ROW_54_481 vssd1 vccd1 sky130_fd_sc_hd__tapvpwrvgnd_1
XFILLER_8_365 vssd1 vssd1 vccd1 vccd1 sky130_fd_sc_hd__fill_8
XFILLER_10_309 vssd1 vccd1 vssd1 vccd1 sky130_ef_sc_hd__decap_40_12
XTAP_TAPCELL_ROW_43_407 vssd1 vccd1 sky130_fd_sc_hd__tapvpwrvgnd_1
XFILLER_13_147 vssd1 vssd1 vccd1 vccd1 sky130_fd_sc_hd__fill_1
XFILLER_13_169 vssd1 vssd1 vccd1 vccd1 sky130_fd_sc_hd__fill_4
XFILLER_42_43 vssd1 vccd1 vssd1 vccd1 sky130_ef_sc_hd__decap_40_12
XFILLER_53_261 vssd1 vccd1 vssd1 vccd1 sky130_ef_sc_hd__decap_40_12
XTAP_TAPCELL_ROW_51_462 vssd1 vccd1 sky130_fd_sc_hd__tapvpwrvgnd_1
XFILLER_5_335 vssd1 vssd1 vccd1 vccd1 sky130_fd_sc_hd__fill_1
XANTENNA__1444__RESET_B load_slew137/X vssd1 vssd1 vccd1 vccd1 sky130_fd_sc_hd__diode_2
XFILLER_3_15 vssd1 vccd1 vssd1 vccd1 sky130_ef_sc_hd__decap_40_12
XTAP_TAPCELL_ROW_8_184 vssd1 vccd1 sky130_fd_sc_hd__tapvpwrvgnd_1
XANTENNA__1445__CLK _1459_/CLK vssd1 vssd1 vccd1 vccd1 sky130_fd_sc_hd__diode_2
XFILLER_8_184 vssd1 vssd1 vccd1 vccd1 sky130_fd_sc_hd__fill_2
X_0982_ _0982_/A _0986_/A vssd1 vssd1 vccd1 vccd1 _0984_/B sky130_fd_sc_hd__nor2_2
XFILLER_59_309 vssd1 vccd1 vssd1 vccd1 sky130_ef_sc_hd__decap_40_12
X_1465_ _1471_/CLK _1465_/D wire142/A vssd1 vssd1 vccd1 vccd1 _1465_/Q sky130_fd_sc_hd__dfrtp_2
X_1534_ _1535_/A vssd1 vssd1 vccd1 vccd1 _1534_/X sky130_fd_sc_hd__buf_2
Xfanout108 _0724_/X vssd1 vssd1 vccd1 vccd1 _1309_/B1 sky130_fd_sc_hd__clkdlybuf4s25_1
Xfanout119 _1192_/B vssd1 vssd1 vccd1 vccd1 _1140_/B sky130_fd_sc_hd__clkdlybuf4s25_1
XFILLER_42_209 vssd1 vssd1 vccd1 vccd1 sky130_fd_sc_hd__fill_2
X_1396_ _1439_/A _1439_/C vssd1 vssd1 vccd1 vccd1 _1425_/B sky130_fd_sc_hd__nand2_2
XFILLER_10_139 vssd1 vssd1 vccd1 vccd1 sky130_fd_sc_hd__fill_1
XFILLER_35_261 vssd1 vssd1 vccd1 vccd1 sky130_fd_sc_hd__fill_8
XFILLER_50_253 vssd1 vccd1 vssd1 vccd1 sky130_ef_sc_hd__decap_40_12
XFILLER_12_68 vssd1 vssd1 vccd1 vccd1 sky130_fd_sc_hd__fill_2
XFILLER_2_305 vssd1 vssd1 vccd1 vccd1 sky130_fd_sc_hd__fill_2
XFILLER_37_21 vssd1 vssd1 vccd1 vccd1 sky130_fd_sc_hd__fill_1
XANTENNA__0905__B _0942_/B vssd1 vssd1 vccd1 vccd1 sky130_fd_sc_hd__diode_2
XANTENNA__1468__CLK _1471_/CLK vssd1 vssd1 vccd1 vccd1 sky130_fd_sc_hd__diode_2
XFILLER_41_253 vssd1 vssd1 vccd1 vccd1 sky130_fd_sc_hd__fill_1
XFILLER_5_165 vssd1 vssd1 vccd1 vccd1 sky130_fd_sc_hd__fill_2
XFILLER_24_209 vssd1 vssd1 vccd1 vccd1 sky130_fd_sc_hd__fill_2
X_1250_ _1463_/Q _1288_/A _1285_/C _1248_/Y _1249_/X vssd1 vssd1 vccd1 vccd1 _1250_/X
+ sky130_fd_sc_hd__a32o_2
X_1181_ _1454_/Q _1189_/C vssd1 vssd1 vccd1 vccd1 _1181_/Y sky130_fd_sc_hd__xnor2_2
XFILLER_17_294 vssd1 vssd1 vccd1 vccd1 sky130_fd_sc_hd__fill_2
XFILLER_32_253 vssd1 vssd1 vccd1 vccd1 sky130_fd_sc_hd__fill_2
X_0965_ _0965_/A _0965_/B vssd1 vssd1 vccd1 vccd1 _0968_/B sky130_fd_sc_hd__xnor2_2
X_0896_ _0897_/A _0897_/B vssd1 vssd1 vccd1 vccd1 _0999_/A sky130_fd_sc_hd__or2_2
XFILLER_59_139 vssd1 vssd1 vccd1 vccd1 sky130_fd_sc_hd__fill_1
X_1448_ _1463_/CLK _1448_/D load_slew137/X vssd1 vssd1 vccd1 vccd1 _1448_/Q sky130_fd_sc_hd__dfrtp_2
X_1517_ _1535_/A vssd1 vssd1 vccd1 vccd1 _1517_/X sky130_fd_sc_hd__buf_2
XFILLER_23_231 vssd1 vssd1 vccd1 vccd1 sky130_fd_sc_hd__fill_1
X_1379_ _1379_/A _1379_/B _1379_/C vssd1 vssd1 vccd1 vccd1 _1443_/D sky130_fd_sc_hd__nor3_2
XFILLER_23_45 vssd1 vssd1 vccd1 vccd1 sky130_fd_sc_hd__fill_2
XFILLER_23_89 vssd1 vssd1 vccd1 vccd1 sky130_fd_sc_hd__fill_2
XFILLER_0_27 vssd1 vssd1 vccd1 vccd1 sky130_fd_sc_hd__fill_1
XFILLER_46_345 vssd1 vssd1 vccd1 vccd1 sky130_fd_sc_hd__fill_1
XFILLER_48_31 vssd1 vssd1 vccd1 vccd1 sky130_fd_sc_hd__fill_1
XFILLER_48_53 vssd1 vssd1 vccd1 vccd1 sky130_fd_sc_hd__fill_4
XFILLER_48_97 vssd1 vssd1 vccd1 vccd1 sky130_fd_sc_hd__fill_1
XFILLER_14_253 vssd1 vssd1 vccd1 vccd1 sky130_fd_sc_hd__fill_4
XFILLER_14_286 vssd1 vssd1 vccd1 vccd1 sky130_fd_sc_hd__fill_2
XFILLER_9_69 vssd1 vccd1 vssd1 vccd1 sky130_ef_sc_hd__decap_40_12
Xfanout90 _1190_/A vssd1 vssd1 vccd1 vccd1 _1329_/A sky130_fd_sc_hd__clkdlybuf4s25_1
X_0750_ _0858_/B _0750_/B vssd1 vssd1 vccd1 vccd1 _0752_/B sky130_fd_sc_hd__xor2_2
XFILLER_43_5 vssd1 vssd1 vccd1 vccd1 sky130_fd_sc_hd__fill_1
XFILLER_56_109 vssd1 vccd1 vssd1 vccd1 sky130_ef_sc_hd__decap_40_12
X_1302_ _1045_/X _1124_/X _1127_/Y _1301_/X vssd1 vssd1 vccd1 vccd1 _1302_/X sky130_fd_sc_hd__o211a_2
X_1233_ _1233_/A _1240_/B vssd1 vssd1 vccd1 vccd1 _1233_/X sky130_fd_sc_hd__or2_2
XFILLER_37_345 vssd1 vssd1 vccd1 vccd1 sky130_fd_sc_hd__fill_2
XFILLER_49_161 vssd1 vssd1 vccd1 vccd1 sky130_fd_sc_hd__fill_4
X_1164_ _1180_/A1 _1162_/X _1163_/Y vssd1 vssd1 vccd1 vccd1 _1451_/D sky130_fd_sc_hd__a21oi_2
X_1095_ _1100_/B vssd1 vssd1 vccd1 vccd1 _1095_/Y sky130_fd_sc_hd__inv_2
XFILLER_20_223 vssd1 vssd1 vccd1 vccd1 sky130_fd_sc_hd__fill_8
X_0948_ _0946_/A _0946_/B _0947_/Y vssd1 vssd1 vccd1 vccd1 _0973_/B sky130_fd_sc_hd__o21a_2
X_0879_ _0953_/B _0880_/B vssd1 vssd1 vccd1 vccd1 _0879_/X sky130_fd_sc_hd__and2_2
XFILLER_18_34 vssd1 vssd1 vccd1 vccd1 sky130_fd_sc_hd__fill_4
XFILLER_11_223 vssd1 vssd1 vccd1 vccd1 sky130_fd_sc_hd__fill_1
XFILLER_34_66 vssd1 vccd1 vssd1 vccd1 sky130_ef_sc_hd__decap_40_12
XTAP_TAPCELL_ROW_38_373 vssd1 vccd1 sky130_fd_sc_hd__tapvpwrvgnd_1
XFILLER_11_245 vssd1 vssd1 vccd1 vccd1 sky130_fd_sc_hd__fill_1
XFILLER_59_41 vssd1 vccd1 vssd1 vccd1 sky130_ef_sc_hd__decap_40_12
XFILLER_59_85 vssd1 vccd1 vssd1 vccd1 sky130_ef_sc_hd__decap_40_12
XFILLER_19_345 vssd1 vssd1 vccd1 vccd1 sky130_fd_sc_hd__fill_2
XFILLER_46_175 vssd1 vccd1 vssd1 vccd1 sky130_ef_sc_hd__decap_40_12
XPHY_EDGE_ROW_28_Left_88 vssd1 vssd1 vccd1 vccd1 sky130_fd_sc_hd__decap_3
X_0802_ _0802_/A _0802_/B vssd1 vssd1 vccd1 vccd1 _0845_/A sky130_fd_sc_hd__xnor2_2
X_0733_ _0771_/A _0771_/B vssd1 vssd1 vccd1 vccd1 _0736_/B sky130_fd_sc_hd__or2_2
X_1216_ _1458_/Q _1457_/Q _1217_/D _1459_/Q vssd1 vssd1 vccd1 vccd1 _1218_/A sky130_fd_sc_hd__a31oi_2
XFILLER_1_81 vssd1 vccd1 vssd1 vccd1 sky130_ef_sc_hd__decap_40_12
XFILLER_25_337 vssd1 vssd1 vccd1 vccd1 sky130_fd_sc_hd__fill_8
XFILLER_40_307 vssd1 vssd1 vccd1 vccd1 sky130_fd_sc_hd__fill_1
XFILLER_52_189 vssd1 vssd1 vccd1 vccd1 sky130_fd_sc_hd__fill_4
X_1147_ _1206_/A1 _1206_/A2 _1206_/B1 _1145_/X vssd1 vssd1 vccd1 vccd1 _1147_/X sky130_fd_sc_hd__o211a_2
X_1078_ _1463_/Q _1375_/A _1075_/X _1077_/Y vssd1 vssd1 vccd1 vccd1 _1119_/B sky130_fd_sc_hd__a211o_2
XTAP_TAPCELL_ROW_35_354 vssd1 vccd1 sky130_fd_sc_hd__tapvpwrvgnd_1
XFILLER_28_197 vssd1 vssd1 vccd1 vccd1 sky130_fd_sc_hd__fill_4
XFILLER_45_65 vssd1 vssd1 vccd1 vccd1 sky130_fd_sc_hd__fill_2
XANTENNA__0913__B _0943_/A vssd1 vssd1 vccd1 vccd1 sky130_fd_sc_hd__diode_2
XFILLER_43_145 vssd1 vssd1 vccd1 vccd1 sky130_fd_sc_hd__fill_2
XFILLER_6_15 vssd1 vccd1 vssd1 vccd1 sky130_ef_sc_hd__decap_40_12
XTAP_TAPCELL_ROW_49_446 vssd1 vccd1 sky130_fd_sc_hd__tapvpwrvgnd_1
XFILLER_34_156 vssd1 vssd1 vccd1 vccd1 sky130_fd_sc_hd__fill_1
XFILLER_34_178 vssd1 vssd1 vccd1 vccd1 sky130_fd_sc_hd__fill_4
X_1001_ _1065_/B _1065_/C _1065_/A vssd1 vssd1 vccd1 vccd1 _1066_/A sky130_fd_sc_hd__a21o_2
XANTENNA__0823__B input7/X vssd1 vssd1 vccd1 vccd1 sky130_fd_sc_hd__diode_2
XTAP_TAPCELL_ROW_40_390 vssd1 vccd1 sky130_fd_sc_hd__tapvpwrvgnd_1
XTAP_TAPCELL_ROW_32_335 vssd1 vccd1 sky130_fd_sc_hd__tapvpwrvgnd_1
X_0716_ _1381_/A _1339_/A _1313_/B1 vssd1 vssd1 vccd1 vccd1 _0716_/Y sky130_fd_sc_hd__a21oi_2
XFILLER_57_237 vssd1 vccd1 vssd1 vccd1 sky130_ef_sc_hd__decap_40_12
XFILLER_15_46 vssd1 vssd1 vccd1 vccd1 sky130_fd_sc_hd__fill_8
XFILLER_15_57 vssd1 vssd1 vccd1 vccd1 sky130_fd_sc_hd__fill_2
XFILLER_25_134 vssd1 vssd1 vccd1 vccd1 sky130_fd_sc_hd__fill_2
XFILLER_25_167 vssd1 vssd1 vccd1 vccd1 sky130_fd_sc_hd__fill_1
XFILLER_40_126 vssd1 vssd1 vccd1 vccd1 sky130_fd_sc_hd__fill_2
XFILLER_40_159 vssd1 vccd1 vssd1 vccd1 sky130_ef_sc_hd__decap_40_12
Xoutput23 _1521_/X vssd1 vssd1 vccd1 vccd1 gpio_oeb[10] sky130_fd_sc_hd__clkdlybuf4s25_1
Xoutput34 _1531_/X vssd1 vssd1 vccd1 vccd1 gpio_oeb[20] sky130_fd_sc_hd__clkdlybuf4s25_1
XFILLER_0_277 vssd1 vssd1 vccd1 vccd1 sky130_fd_sc_hd__fill_2
Xoutput89 _1414_/Y vssd1 vssd1 vccd1 vccd1 gpio_out[9] sky130_fd_sc_hd__clkdlybuf4s25_1
Xoutput78 _1400_/X vssd1 vssd1 vccd1 vccd1 gpio_out[2] sky130_fd_sc_hd__clkdlybuf4s25_1
Xoutput67 _1394_/X vssd1 vssd1 vccd1 vccd1 gpio_out[1] sky130_fd_sc_hd__clkdlybuf4s25_1
Xoutput56 _1383_/Y vssd1 vssd1 vccd1 vccd1 gpio_out[0] sky130_fd_sc_hd__clkdlybuf4s25_1
Xoutput45 _1541_/X vssd1 vssd1 vccd1 vccd1 gpio_oeb[30] sky130_fd_sc_hd__clkdlybuf4s25_1
XANTENNA_clkbuf_2_0__f_clk_X _1463_/CLK vssd1 vssd1 vccd1 vccd1 sky130_fd_sc_hd__diode_2
XANTENNA_input16_A prescaler[5] vssd1 vssd1 vccd1 vccd1 sky130_fd_sc_hd__diode_2
XFILLER_16_134 vssd1 vssd1 vccd1 vccd1 sky130_fd_sc_hd__fill_1
XFILLER_56_53 vssd1 vccd1 vssd1 vccd1 sky130_ef_sc_hd__decap_40_12
XFILLER_56_97 vssd1 vccd1 vssd1 vccd1 sky130_ef_sc_hd__decap_40_12
XTAP_TAPCELL_ROW_46_427 vssd1 vccd1 sky130_fd_sc_hd__tapvpwrvgnd_1
XFILLER_8_333 vssd1 vccd1 vssd1 vccd1 sky130_ef_sc_hd__decap_40_12
XTAP_TAPCELL_ROW_54_482 vssd1 vccd1 sky130_fd_sc_hd__tapvpwrvgnd_1
XFILLER_11_3 vssd1 vccd1 vssd1 vccd1 sky130_ef_sc_hd__decap_40_12
XFILLER_39_259 vssd1 vssd1 vccd1 vccd1 sky130_fd_sc_hd__fill_2
XFILLER_47_281 vssd1 vccd1 vssd1 vccd1 sky130_ef_sc_hd__decap_40_12
XFILLER_22_104 vssd1 vssd1 vccd1 vccd1 sky130_fd_sc_hd__fill_4
XFILLER_22_159 vssd1 vccd1 vssd1 vccd1 sky130_ef_sc_hd__decap_40_12
XPHY_EDGE_ROW_15_Left_75 vssd1 vssd1 vccd1 vccd1 sky130_fd_sc_hd__decap_3
XANTENNA_input8_A prescaler[10] vssd1 vssd1 vccd1 vccd1 sky130_fd_sc_hd__diode_2
XFILLER_26_34 vssd1 vssd1 vccd1 vccd1 sky130_fd_sc_hd__fill_4
XFILLER_38_292 vssd1 vssd1 vccd1 vccd1 sky130_fd_sc_hd__fill_1
XFILLER_53_273 vssd1 vssd1 vccd1 vccd1 sky130_fd_sc_hd__fill_4
XTAP_TAPCELL_ROW_43_408 vssd1 vccd1 sky130_fd_sc_hd__tapvpwrvgnd_1
XFILLER_13_159 vssd1 vssd1 vccd1 vccd1 sky130_fd_sc_hd__fill_8
XFILLER_42_55 vssd1 vssd1 vccd1 vccd1 sky130_fd_sc_hd__fill_4
XTAP_TAPCELL_ROW_51_463 vssd1 vccd1 sky130_fd_sc_hd__tapvpwrvgnd_1
XFILLER_3_27 vssd1 vccd1 vssd1 vccd1 sky130_ef_sc_hd__decap_40_12
XFILLER_29_281 vssd1 vssd1 vccd1 vccd1 sky130_fd_sc_hd__fill_2
X_0981_ _0950_/Y _1055_/A _1008_/A vssd1 vssd1 vccd1 vccd1 _0981_/X sky130_fd_sc_hd__o21a_2
XFILLER_59_3 vssd1 vccd1 vssd1 vccd1 sky130_ef_sc_hd__decap_40_12
XFILLER_8_141 vssd1 vccd1 vssd1 vccd1 sky130_ef_sc_hd__decap_40_12
X_1395_ _1439_/A _1439_/C vssd1 vssd1 vccd1 vccd1 _1442_/C sky130_fd_sc_hd__and2_2
X_1464_ _1471_/CLK _1464_/D wire142/A vssd1 vssd1 vccd1 vccd1 _1464_/Q sky130_fd_sc_hd__dfrtp_2
X_1533_ _1543_/A vssd1 vssd1 vccd1 vccd1 _1533_/X sky130_fd_sc_hd__buf_2
Xfanout109 _0715_/B vssd1 vssd1 vccd1 vccd1 _1320_/C1 sky130_fd_sc_hd__clkdlybuf4s25_1
XFILLER_50_221 vssd1 vccd1 vssd1 vccd1 sky130_ef_sc_hd__decap_40_12
XFILLER_50_265 vssd1 vccd1 vssd1 vccd1 sky130_ef_sc_hd__decap_40_12
XFILLER_58_321 vssd1 vccd1 vssd1 vccd1 sky130_ef_sc_hd__decap_40_12
XFILLER_58_365 vssd1 vssd1 vccd1 vccd1 sky130_fd_sc_hd__fill_4
XFILLER_26_251 vssd1 vssd1 vccd1 vccd1 sky130_fd_sc_hd__fill_1
XFILLER_41_221 vssd1 vssd1 vccd1 vccd1 sky130_fd_sc_hd__fill_2
XFILLER_5_111 vssd1 vssd1 vccd1 vccd1 sky130_fd_sc_hd__fill_1
XFILLER_1_361 vssd1 vssd1 vccd1 vccd1 sky130_fd_sc_hd__fill_8
X_1180_ _1180_/A1 _1178_/X _1179_/Y vssd1 vssd1 vccd1 vccd1 _1453_/D sky130_fd_sc_hd__a21oi_2
XANTENNA__1275__B1 _1313_/B1 vssd1 vssd1 vccd1 vccd1 sky130_fd_sc_hd__diode_2
XFILLER_32_265 vssd1 vssd1 vccd1 vccd1 sky130_fd_sc_hd__fill_2
X_0964_ _0964_/A _0964_/B vssd1 vssd1 vccd1 vccd1 _0971_/B sky130_fd_sc_hd__xor2_2
X_1516_ _1541_/A vssd1 vssd1 vccd1 vccd1 _1516_/X sky130_fd_sc_hd__buf_2
X_0895_ _0913_/A _0871_/B _0869_/X vssd1 vssd1 vccd1 vccd1 _0897_/B sky130_fd_sc_hd__a21oi_2
XFILLER_4_81 vssd1 vssd1 vccd1 vccd1 sky130_fd_sc_hd__fill_2
X_1378_ _1378_/A _1378_/B _1378_/C _1378_/D vssd1 vssd1 vccd1 vccd1 _1379_/C sky130_fd_sc_hd__or4_2
X_1447_ _1459_/CLK _1447_/D fanout138/X vssd1 vssd1 vccd1 vccd1 _1447_/Q sky130_fd_sc_hd__dfrtp_2
XFILLER_23_221 vssd1 vssd1 vccd1 vccd1 sky130_fd_sc_hd__fill_2
XFILLER_55_335 vssd1 vssd1 vccd1 vccd1 sky130_fd_sc_hd__fill_1
XFILLER_23_57 vssd1 vssd1 vccd1 vccd1 sky130_fd_sc_hd__fill_2
XFILLER_48_21 vssd1 vssd1 vccd1 vccd1 sky130_fd_sc_hd__fill_2
XPHY_EDGE_ROW_45_Left_105 vssd1 vssd1 vccd1 vccd1 sky130_fd_sc_hd__decap_3
XFILLER_48_65 vssd1 vssd1 vccd1 vccd1 sky130_fd_sc_hd__fill_1
XFILLER_58_195 vssd1 vssd1 vccd1 vccd1 sky130_fd_sc_hd__fill_1
XFILLER_9_15 vssd1 vccd1 vssd1 vccd1 sky130_ef_sc_hd__decap_40_12
Xfanout91 _1211_/A vssd1 vssd1 vccd1 vccd1 _1190_/A sky130_fd_sc_hd__clkdlybuf4s25_1
XTAP_TAPCELL_ROW_24_282 vssd1 vccd1 sky130_fd_sc_hd__tapvpwrvgnd_1
XPHY_EDGE_ROW_54_Left_114 vssd1 vssd1 vccd1 vccd1 sky130_fd_sc_hd__decap_3
XANTENNA__1193__C1 _1320_/C1 vssd1 vssd1 vccd1 vccd1 sky130_fd_sc_hd__diode_2
X_1301_ _1301_/A _1306_/B vssd1 vssd1 vccd1 vccd1 _1301_/X sky130_fd_sc_hd__or2_2
X_1232_ _1461_/Q _1460_/Q _1232_/C vssd1 vssd1 vccd1 vccd1 _1240_/B sky130_fd_sc_hd__and3_2
XFILLER_52_305 vssd1 vssd1 vccd1 vccd1 sky130_fd_sc_hd__fill_2
X_1163_ _1451_/Q _1180_/A1 _1320_/C1 vssd1 vssd1 vccd1 vccd1 _1163_/Y sky130_fd_sc_hd__o21ai_2
X_1094_ _1454_/Q _1372_/A _1093_/X _1453_/Q vssd1 vssd1 vccd1 vccd1 _1100_/B sky130_fd_sc_hd__o22ai_2
XFILLER_20_268 vssd1 vssd1 vccd1 vccd1 sky130_fd_sc_hd__fill_2
X_0947_ _0951_/A _0951_/B vssd1 vssd1 vccd1 vccd1 _0947_/Y sky130_fd_sc_hd__nand2b_2
XANTENNA__1184__C1 _0902_/A vssd1 vssd1 vccd1 vccd1 sky130_fd_sc_hd__diode_2
XANTENNA__1458__CLK _1459_/CLK vssd1 vssd1 vccd1 vccd1 sky130_fd_sc_hd__diode_2
X_0878_ _0941_/A _0956_/A _0859_/Y vssd1 vssd1 vccd1 vccd1 _0887_/A sky130_fd_sc_hd__o21ai_2
XFILLER_18_68 vssd1 vssd1 vccd1 vccd1 sky130_fd_sc_hd__fill_1
XFILLER_43_305 vssd1 vssd1 vccd1 vccd1 sky130_fd_sc_hd__fill_1
XFILLER_55_165 vssd1 vssd1 vccd1 vccd1 sky130_fd_sc_hd__fill_2
XFILLER_34_78 vssd1 vssd1 vccd1 vccd1 sky130_fd_sc_hd__fill_4
XTAP_TAPCELL_ROW_38_374 vssd1 vccd1 sky130_fd_sc_hd__tapvpwrvgnd_1
XTAP_TAPCELL_ROW_21_263 vssd1 vccd1 sky130_fd_sc_hd__tapvpwrvgnd_1
XFILLER_59_53 vssd1 vssd1 vccd1 vccd1 sky130_fd_sc_hd__fill_2
XFILLER_59_97 vssd1 vccd1 vssd1 vccd1 sky130_ef_sc_hd__decap_40_12
XPHY_EDGE_ROW_3_Left_63 vssd1 vssd1 vccd1 vccd1 sky130_fd_sc_hd__decap_3
XFILLER_19_335 vssd1 vssd1 vccd1 vccd1 sky130_fd_sc_hd__fill_1
XFILLER_46_187 vssd1 vssd1 vccd1 vccd1 sky130_fd_sc_hd__fill_8
X_0801_ _0802_/B _0802_/A vssd1 vssd1 vccd1 vccd1 _0801_/X sky130_fd_sc_hd__and2b_2
XFILLER_41_3 vssd1 vssd1 vccd1 vccd1 sky130_fd_sc_hd__fill_4
X_0732_ _0825_/A _0732_/B vssd1 vssd1 vccd1 vccd1 _0771_/B sky130_fd_sc_hd__xnor2_2
X_1215_ _1353_/B _1353_/C vssd1 vssd1 vccd1 vccd1 _1458_/D sky130_fd_sc_hd__and2_2
X_1146_ _1449_/Q _1205_/B vssd1 vssd1 vccd1 vccd1 _1146_/Y sky130_fd_sc_hd__nand2_2
XFILLER_1_93 vssd1 vccd1 vssd1 vccd1 sky130_ef_sc_hd__decap_40_12
X_1077_ _1462_/Q _1077_/B vssd1 vssd1 vccd1 vccd1 _1077_/Y sky130_fd_sc_hd__nor2_2
XTAP_TAPCELL_ROW_35_355 vssd1 vccd1 sky130_fd_sc_hd__tapvpwrvgnd_1
XFILLER_4_209 vssd1 vccd1 vssd1 vccd1 sky130_ef_sc_hd__decap_40_12
XFILLER_16_349 vssd1 vssd1 vccd1 vccd1 sky130_fd_sc_hd__fill_2
XFILLER_43_113 vssd1 vssd1 vccd1 vccd1 sky130_fd_sc_hd__fill_2
XFILLER_45_44 vssd1 vssd1 vccd1 vccd1 sky130_fd_sc_hd__fill_2
XTAP_TAPCELL_ROW_26_300 vssd1 vccd1 sky130_fd_sc_hd__tapvpwrvgnd_1
XANTENNA__1148__C1 _0902_/A vssd1 vssd1 vccd1 vccd1 sky130_fd_sc_hd__diode_2
XFILLER_6_27 vssd1 vssd1 vccd1 vccd1 sky130_fd_sc_hd__fill_1
XFILLER_20_8 vssd1 vssd1 vccd1 vccd1 sky130_fd_sc_hd__fill_2
X_1000_ _0997_/C _0898_/X _0997_/D _0999_/Y _0994_/Y vssd1 vssd1 vccd1 vccd1 _1065_/C
+ sky130_fd_sc_hd__a311oi_2
XTAP_TAPCELL_ROW_49_447 vssd1 vccd1 sky130_fd_sc_hd__tapvpwrvgnd_1
XANTENNA__1320__C1 _1320_/C1 vssd1 vssd1 vccd1 vccd1 sky130_fd_sc_hd__diode_2
XFILLER_34_168 vssd1 vssd1 vccd1 vccd1 sky130_fd_sc_hd__fill_1
XTAP_TAPCELL_ROW_32_336 vssd1 vccd1 sky130_fd_sc_hd__tapvpwrvgnd_1
XANTENNA_clkbuf_0_clk_A clk vssd1 vssd1 vccd1 vccd1 sky130_fd_sc_hd__diode_2
X_0715_ _0711_/X _0715_/B _0715_/C vssd1 vssd1 vccd1 vccd1 _1474_/D sky130_fd_sc_hd__and3b_2
XTAP_TAPCELL_ROW_40_391 vssd1 vccd1 sky130_fd_sc_hd__tapvpwrvgnd_1
XANTENNA__1139__C1 _0902_/A vssd1 vssd1 vccd1 vccd1 sky130_fd_sc_hd__diode_2
XFILLER_57_205 vssd1 vccd1 vssd1 vccd1 sky130_ef_sc_hd__decap_40_12
XFILLER_25_113 vssd1 vssd1 vccd1 vccd1 sky130_fd_sc_hd__fill_4
XFILLER_57_249 vssd1 vccd1 vssd1 vccd1 sky130_ef_sc_hd__decap_40_12
X_1129_ _1448_/Q _0771_/A _1445_/Q _1444_/Q vssd1 vssd1 vccd1 vccd1 _1130_/B sky130_fd_sc_hd__a211o_2
XFILLER_15_36 vssd1 vssd1 vccd1 vccd1 sky130_fd_sc_hd__fill_2
XFILLER_33_190 vssd1 vssd1 vccd1 vccd1 sky130_fd_sc_hd__fill_1
XFILLER_40_149 vssd1 vssd1 vccd1 vccd1 sky130_fd_sc_hd__fill_1
XFILLER_31_68 vssd1 vssd1 vccd1 vccd1 sky130_fd_sc_hd__fill_2
Xoutput24 _1522_/X vssd1 vssd1 vccd1 vccd1 gpio_oeb[11] sky130_fd_sc_hd__clkdlybuf4s25_1
Xoutput57 _1415_/X vssd1 vssd1 vccd1 vccd1 gpio_out[10] sky130_fd_sc_hd__clkdlybuf4s25_1
Xoutput46 _1542_/X vssd1 vssd1 vccd1 vccd1 gpio_oeb[31] sky130_fd_sc_hd__clkdlybuf4s25_1
Xoutput35 _1532_/X vssd1 vssd1 vccd1 vccd1 gpio_oeb[21] sky130_fd_sc_hd__clkdlybuf4s25_1
XFILLER_56_65 vssd1 vccd1 vssd1 vccd1 sky130_ef_sc_hd__decap_40_12
Xoutput79 _1439_/X vssd1 vssd1 vccd1 vccd1 gpio_out[30] sky130_fd_sc_hd__clkdlybuf4s25_1
Xoutput68 _1429_/Y vssd1 vssd1 vccd1 vccd1 gpio_out[20] sky130_fd_sc_hd__clkdlybuf4s25_1
XTAP_TAPCELL_ROW_54_483 vssd1 vccd1 sky130_fd_sc_hd__tapvpwrvgnd_1
XTAP_TAPCELL_ROW_46_428 vssd1 vccd1 sky130_fd_sc_hd__tapvpwrvgnd_1
XPHY_EDGE_ROW_19_Right_19 vssd1 vssd1 vccd1 vccd1 sky130_fd_sc_hd__decap_3
XFILLER_8_345 vssd1 vccd1 vssd1 vccd1 sky130_ef_sc_hd__decap_40_12
XPHY_EDGE_ROW_28_Right_28 vssd1 vssd1 vccd1 vccd1 sky130_fd_sc_hd__decap_3
XFILLER_47_293 vssd1 vccd1 vssd1 vccd1 sky130_ef_sc_hd__decap_40_12
XPHY_EDGE_ROW_37_Right_37 vssd1 vssd1 vccd1 vccd1 sky130_fd_sc_hd__decap_3
XFILLER_30_193 vssd1 vssd1 vccd1 vccd1 sky130_fd_sc_hd__fill_2
XFILLER_7_81 vssd1 vccd1 vssd1 vccd1 sky130_ef_sc_hd__decap_40_12
XPHY_EDGE_ROW_46_Right_46 vssd1 vssd1 vccd1 vccd1 sky130_fd_sc_hd__decap_3
XPHY_EDGE_ROW_55_Right_55 vssd1 vssd1 vccd1 vccd1 sky130_fd_sc_hd__decap_3
XFILLER_13_127 vssd1 vccd1 vssd1 vccd1 sky130_ef_sc_hd__decap_40_12
XTAP_TAPCELL_ROW_43_409 vssd1 vccd1 sky130_fd_sc_hd__tapvpwrvgnd_1
XFILLER_5_337 vssd1 vccd1 vssd1 vccd1 sky130_ef_sc_hd__decap_40_12
XFILLER_9_109 vssd1 vssd1 vccd1 vccd1 sky130_fd_sc_hd__fill_2
XFILLER_3_39 vssd1 vccd1 vssd1 vccd1 sky130_ef_sc_hd__decap_40_12
XTAP_TAPCELL_ROW_59_520 vssd1 vccd1 sky130_fd_sc_hd__tapvpwrvgnd_1
X_0980_ _0950_/Y _0978_/B _1049_/A _0979_/X vssd1 vssd1 vccd1 vccd1 _1008_/A sky130_fd_sc_hd__o2bb2ai_2
XPHY_EDGE_ROW_32_Left_92 vssd1 vssd1 vccd1 vccd1 sky130_fd_sc_hd__decap_3
XFILLER_8_153 vssd1 vssd1 vccd1 vccd1 sky130_fd_sc_hd__fill_2
X_1532_ _1535_/A vssd1 vssd1 vccd1 vccd1 _1532_/X sky130_fd_sc_hd__buf_2
X_1394_ _1478_/Q _1426_/A _1439_/C _1425_/A vssd1 vssd1 vccd1 vccd1 _1394_/X sky130_fd_sc_hd__and4bb_2
X_1463_ _1463_/CLK _1463_/D wire142/X vssd1 vssd1 vccd1 vccd1 _1463_/Q sky130_fd_sc_hd__dfrtp_2
XFILLER_27_219 vssd1 vssd1 vccd1 vccd1 sky130_fd_sc_hd__fill_4
XFILLER_50_233 vssd1 vccd1 vssd1 vccd1 sky130_ef_sc_hd__decap_40_12
XFILLER_12_15 vssd1 vccd1 vssd1 vccd1 sky130_ef_sc_hd__decap_40_12
XFILLER_50_277 vssd1 vccd1 vssd1 vccd1 sky130_ef_sc_hd__decap_40_12
XFILLER_2_307 vssd1 vssd1 vccd1 vccd1 sky130_fd_sc_hd__fill_1
XFILLER_58_333 vssd1 vccd1 vssd1 vccd1 sky130_ef_sc_hd__decap_40_12
XFILLER_26_285 vssd1 vssd1 vccd1 vccd1 sky130_fd_sc_hd__fill_2
XFILLER_53_55 vssd1 vssd1 vccd1 vccd1 sky130_fd_sc_hd__fill_1
XFILLER_5_167 vssd1 vssd1 vccd1 vccd1 sky130_fd_sc_hd__fill_1
XFILLER_38_9 vssd1 vssd1 vccd1 vccd1 sky130_fd_sc_hd__fill_2
XFILLER_49_333 vssd1 vssd1 vccd1 vccd1 sky130_fd_sc_hd__fill_2
XFILLER_17_241 vssd1 vssd1 vccd1 vccd1 sky130_fd_sc_hd__fill_8
XFILLER_32_299 vssd1 vssd1 vccd1 vccd1 sky130_fd_sc_hd__fill_2
X_0963_ _0963_/A _0963_/B vssd1 vssd1 vccd1 vccd1 _0982_/A sky130_fd_sc_hd__xnor2_2
X_0894_ _0993_/B _0894_/B vssd1 vssd1 vccd1 vccd1 _0897_/A sky130_fd_sc_hd__or2_2
X_1515_ _1543_/A vssd1 vssd1 vccd1 vccd1 _1515_/X sky130_fd_sc_hd__buf_2
XTAP_TAPCELL_ROW_10_191 vssd1 vccd1 sky130_fd_sc_hd__tapvpwrvgnd_1
X_1377_ _1375_/Y _1376_/X _1351_/X _1353_/Y _1374_/X vssd1 vssd1 vccd1 vccd1 _1378_/D
+ sky130_fd_sc_hd__o2111ai_2
X_1446_ _1459_/CLK _1446_/D fanout138/X vssd1 vssd1 vccd1 vccd1 _1446_/Q sky130_fd_sc_hd__dfrtp_2
XFILLER_23_25 vssd1 vccd1 vssd1 vccd1 sky130_ef_sc_hd__decap_40_12
XFILLER_23_277 vssd1 vssd1 vccd1 vccd1 sky130_fd_sc_hd__fill_2
XFILLER_2_137 vssd1 vssd1 vccd1 vccd1 sky130_fd_sc_hd__fill_2
XFILLER_58_141 vssd1 vccd1 vssd1 vccd1 sky130_ef_sc_hd__decap_40_12
XFILLER_0_29 vssd1 vccd1 vssd1 vccd1 sky130_ef_sc_hd__decap_40_12
XFILLER_14_266 vssd1 vccd1 vssd1 vccd1 sky130_ef_sc_hd__decap_40_12
XFILLER_14_288 vssd1 vssd1 vccd1 vccd1 sky130_fd_sc_hd__fill_1
XFILLER_9_27 vssd1 vccd1 vssd1 vccd1 sky130_ef_sc_hd__decap_40_12
Xfanout92 _1211_/A vssd1 vssd1 vccd1 vccd1 _1288_/A sky130_fd_sc_hd__clkdlybuf4s25_1
XTAP_TAPCELL_ROW_24_283 vssd1 vccd1 sky130_fd_sc_hd__tapvpwrvgnd_1
XFILLER_1_181 vssd1 vccd1 vssd1 vccd1 sky130_ef_sc_hd__decap_40_12
XFILLER_37_347 vssd1 vssd1 vccd1 vccd1 sky130_fd_sc_hd__fill_1
X_1300_ _1470_/Q _1327_/C vssd1 vssd1 vccd1 vccd1 _1300_/Y sky130_fd_sc_hd__nand2_2
X_1231_ _1460_/Q _1232_/C _1461_/Q vssd1 vssd1 vccd1 vccd1 _1233_/A sky130_fd_sc_hd__a21oi_2
X_1162_ _1190_/A _1160_/Y _1161_/X _0902_/A vssd1 vssd1 vccd1 vccd1 _1162_/X sky130_fd_sc_hd__a211o_2
X_1093_ _1093_/A _1093_/B vssd1 vssd1 vccd1 vccd1 _1093_/X sky130_fd_sc_hd__or2_2
XFILLER_9_281 vssd1 vccd1 vssd1 vccd1 sky130_ef_sc_hd__decap_40_12
X_0946_ _0946_/A _0946_/B vssd1 vssd1 vccd1 vccd1 _0951_/B sky130_fd_sc_hd__xor2_2
X_0877_ _0866_/A _0864_/Y _0863_/Y vssd1 vssd1 vccd1 vccd1 _0890_/A sky130_fd_sc_hd__a21o_2
XANTENNA_fanout109_A _0715_/B vssd1 vssd1 vccd1 vccd1 sky130_fd_sc_hd__diode_2
X_1429_ _1429_/A _1436_/B vssd1 vssd1 vccd1 vccd1 _1429_/Y sky130_fd_sc_hd__nor2_2
XFILLER_55_111 vssd1 vssd1 vccd1 vccd1 sky130_fd_sc_hd__fill_1
XTAP_TAPCELL_ROW_38_375 vssd1 vccd1 sky130_fd_sc_hd__tapvpwrvgnd_1
XFILLER_11_203 vssd1 vssd1 vccd1 vccd1 sky130_fd_sc_hd__fill_1
XFILLER_11_225 vssd1 vccd1 vssd1 vccd1 sky130_ef_sc_hd__decap_40_12
XFILLER_11_269 vssd1 vssd1 vccd1 vccd1 sky130_fd_sc_hd__fill_8
XFILLER_34_35 vssd1 vssd1 vccd1 vccd1 sky130_fd_sc_hd__fill_4
XFILLER_51_361 vssd1 vssd1 vccd1 vccd1 sky130_fd_sc_hd__fill_1
XFILLER_1_3 vssd1 vccd1 vssd1 vccd1 sky130_ef_sc_hd__decap_40_12
XTAP_TAPCELL_ROW_21_264 vssd1 vccd1 sky130_fd_sc_hd__tapvpwrvgnd_1
XTAP_TAPCELL_ROW_29_320 vssd1 vccd1 sky130_fd_sc_hd__tapvpwrvgnd_1
XANTENNA__0943__A _0943_/A vssd1 vssd1 vccd1 vccd1 sky130_fd_sc_hd__diode_2
X_0800_ _0799_/A _0797_/Y _0808_/B _0953_/B vssd1 vssd1 vccd1 vccd1 _0802_/B sky130_fd_sc_hd__a2bb2oi_2
X_0731_ _0825_/A _0732_/B vssd1 vssd1 vccd1 vccd1 _0731_/Y sky130_fd_sc_hd__nand2_2
XFILLER_34_3 vssd1 vccd1 vssd1 vccd1 sky130_ef_sc_hd__decap_40_12
XFILLER_37_100 vssd1 vccd1 vssd1 vccd1 sky130_ef_sc_hd__decap_40_12
X_1214_ _1458_/Q _1214_/A2 _1320_/C1 vssd1 vssd1 vccd1 vccd1 _1353_/C sky130_fd_sc_hd__o21a_2
X_1145_ _1145_/A _1153_/B vssd1 vssd1 vccd1 vccd1 _1145_/X sky130_fd_sc_hd__or2_2
XFILLER_40_309 vssd1 vssd1 vccd1 vccd1 sky130_fd_sc_hd__fill_2
X_1076_ _1462_/Q _1077_/B vssd1 vssd1 vccd1 vccd1 _1076_/Y sky130_fd_sc_hd__nand2_2
XTAP_TAPCELL_ROW_35_356 vssd1 vccd1 sky130_fd_sc_hd__tapvpwrvgnd_1
XANTENNA__1157__B1 _1313_/B1 vssd1 vssd1 vccd1 vccd1 sky130_fd_sc_hd__diode_2
XFILLER_20_59 vssd1 vssd1 vccd1 vccd1 sky130_fd_sc_hd__fill_8
X_0929_ _0929_/A _0929_/B vssd1 vssd1 vccd1 vccd1 _0930_/B sky130_fd_sc_hd__nand2_2
XFILLER_29_57 vssd1 vssd1 vccd1 vccd1 sky130_fd_sc_hd__fill_1
XANTENNA__0763__A _0943_/A vssd1 vssd1 vccd1 vccd1 sky130_fd_sc_hd__diode_2
XFILLER_16_306 vssd1 vssd1 vccd1 vccd1 sky130_fd_sc_hd__fill_2
XFILLER_28_188 vssd1 vssd1 vccd1 vccd1 sky130_fd_sc_hd__fill_1
XFILLER_43_103 vssd1 vssd1 vccd1 vccd1 sky130_fd_sc_hd__fill_2
XFILLER_43_147 vssd1 vssd1 vccd1 vccd1 sky130_fd_sc_hd__fill_1
XFILLER_45_23 vssd1 vssd1 vccd1 vccd1 sky130_fd_sc_hd__fill_2
XFILLER_45_67 vssd1 vssd1 vccd1 vccd1 sky130_fd_sc_hd__fill_1
XTAP_TAPCELL_ROW_26_301 vssd1 vccd1 sky130_fd_sc_hd__tapvpwrvgnd_1
XANTENNA__1478__RESET_B wire142/X vssd1 vssd1 vccd1 vccd1 sky130_fd_sc_hd__diode_2
XFILLER_10_70 vssd1 vccd1 vssd1 vccd1 sky130_ef_sc_hd__decap_40_12
XFILLER_3_221 vssd1 vssd1 vccd1 vccd1 sky130_fd_sc_hd__fill_2
XFILLER_19_166 vssd1 vssd1 vccd1 vccd1 sky130_fd_sc_hd__fill_2
XFILLER_19_199 vssd1 vssd1 vccd1 vccd1 sky130_fd_sc_hd__fill_4
XTAP_TAPCELL_ROW_49_448 vssd1 vccd1 sky130_fd_sc_hd__tapvpwrvgnd_1
XANTENNA__1448__CLK _1463_/CLK vssd1 vssd1 vccd1 vccd1 sky130_fd_sc_hd__diode_2
XFILLER_22_309 vssd1 vccd1 vssd1 vccd1 sky130_ef_sc_hd__decap_40_12
XFILLER_34_125 vssd1 vssd1 vccd1 vccd1 sky130_fd_sc_hd__fill_1
XFILLER_34_136 vssd1 vssd1 vccd1 vccd1 sky130_fd_sc_hd__fill_4
XFILLER_42_180 vssd1 vccd1 vssd1 vccd1 sky130_ef_sc_hd__decap_40_12
XTAP_TAPCELL_ROW_32_337 vssd1 vccd1 sky130_fd_sc_hd__tapvpwrvgnd_1
X_0714_ _1381_/A _1339_/A _0710_/Y _1389_/A vssd1 vssd1 vccd1 vccd1 _0715_/C sky130_fd_sc_hd__a22o_2
XTAP_TAPCELL_ROW_40_392 vssd1 vccd1 sky130_fd_sc_hd__tapvpwrvgnd_1
XFILLER_57_217 vssd1 vssd1 vccd1 vccd1 sky130_fd_sc_hd__fill_4
XANTENNA__1311__B1 _1330_/B1 vssd1 vssd1 vccd1 vccd1 sky130_fd_sc_hd__diode_2
XFILLER_13_309 vssd1 vccd1 vssd1 vccd1 sky130_ef_sc_hd__decap_40_12
XFILLER_25_136 vssd1 vssd1 vccd1 vccd1 sky130_fd_sc_hd__fill_1
XFILLER_25_169 vssd1 vccd1 vssd1 vccd1 sky130_ef_sc_hd__decap_40_12
X_1128_ _1206_/A1 _1206_/A2 _1206_/B1 vssd1 vssd1 vccd1 vccd1 _1211_/A sky130_fd_sc_hd__o21ai_2
X_1059_ _1059_/A _1059_/B _1059_/C vssd1 vssd1 vccd1 vccd1 _1059_/X sky130_fd_sc_hd__and3_2
XFILLER_40_128 vssd1 vssd1 vccd1 vccd1 sky130_fd_sc_hd__fill_1
Xoutput25 _1523_/X vssd1 vssd1 vccd1 vccd1 gpio_oeb[12] sky130_fd_sc_hd__clkdlybuf4s25_1
Xoutput69 _1430_/Y vssd1 vssd1 vccd1 vccd1 gpio_out[21] sky130_fd_sc_hd__clkdlybuf4s25_1
Xoutput58 _1417_/Y vssd1 vssd1 vccd1 vccd1 gpio_out[11] sky130_fd_sc_hd__clkdlybuf4s25_1
Xoutput47 _1543_/X vssd1 vssd1 vccd1 vccd1 gpio_oeb[32] sky130_fd_sc_hd__clkdlybuf4s25_1
Xoutput36 _1533_/X vssd1 vssd1 vccd1 vccd1 gpio_oeb[22] sky130_fd_sc_hd__clkdlybuf4s25_1
XANTENNA__1302__B1 _1127_/Y vssd1 vssd1 vccd1 vccd1 sky130_fd_sc_hd__diode_2
XFILLER_0_279 vssd1 vssd1 vccd1 vccd1 sky130_fd_sc_hd__fill_1
XFILLER_56_77 vssd1 vssd1 vccd1 vccd1 sky130_fd_sc_hd__fill_4
XTAP_TAPCELL_ROW_46_429 vssd1 vccd1 sky130_fd_sc_hd__tapvpwrvgnd_1
XFILLER_16_169 vssd1 vssd1 vccd1 vccd1 sky130_fd_sc_hd__fill_2
XFILLER_8_357 vssd1 vssd1 vccd1 vccd1 sky130_fd_sc_hd__fill_4
XFILLER_54_209 vssd1 vccd1 vssd1 vccd1 sky130_ef_sc_hd__decap_40_12
XFILLER_22_139 vssd1 vssd1 vccd1 vccd1 sky130_fd_sc_hd__fill_1
XFILLER_7_93 vssd1 vccd1 vssd1 vccd1 sky130_ef_sc_hd__decap_40_12
XFILLER_13_106 vssd1 vssd1 vccd1 vccd1 sky130_fd_sc_hd__fill_4
XFILLER_13_139 vssd1 vssd1 vccd1 vccd1 sky130_fd_sc_hd__fill_8
XFILLER_21_183 vssd1 vssd1 vccd1 vccd1 sky130_fd_sc_hd__fill_2
XFILLER_5_305 vssd1 vccd1 vssd1 vccd1 sky130_ef_sc_hd__decap_40_12
XFILLER_5_349 vssd1 vccd1 vssd1 vccd1 sky130_ef_sc_hd__decap_40_12
XTAP_TAPCELL_ROW_59_521 vssd1 vccd1 sky130_fd_sc_hd__tapvpwrvgnd_1
XTAP_TAPCELL_ROW_59_510 vssd1 vccd1 sky130_fd_sc_hd__tapvpwrvgnd_1
XFILLER_29_294 vssd1 vssd1 vccd1 vccd1 sky130_fd_sc_hd__fill_2
XFILLER_44_253 vssd1 vssd1 vccd1 vccd1 sky130_fd_sc_hd__fill_4
XFILLER_8_121 vssd1 vccd1 vssd1 vccd1 sky130_ef_sc_hd__decap_40_12
X_1462_ _1463_/CLK _1462_/D load_slew137/X vssd1 vssd1 vccd1 vccd1 _1462_/Q sky130_fd_sc_hd__dfrtp_2
X_1531_ _1543_/A vssd1 vssd1 vccd1 vccd1 _1531_/X sky130_fd_sc_hd__buf_2
X_1393_ _1442_/B _1393_/B vssd1 vssd1 vccd1 vccd1 _1425_/A sky130_fd_sc_hd__and2_2
XFILLER_35_242 vssd1 vssd1 vccd1 vccd1 sky130_fd_sc_hd__fill_1
XFILLER_35_275 vssd1 vssd1 vccd1 vccd1 sky130_fd_sc_hd__fill_4
XFILLER_50_245 vssd1 vssd1 vccd1 vccd1 sky130_fd_sc_hd__fill_4
XANTENNA_fanout139_A wire142/X vssd1 vssd1 vccd1 vccd1 sky130_fd_sc_hd__diode_2
XFILLER_10_109 vssd1 vccd1 vssd1 vccd1 sky130_ef_sc_hd__decap_40_12
XFILLER_12_27 vssd1 vssd1 vccd1 vccd1 sky130_fd_sc_hd__fill_1
XFILLER_12_49 vssd1 vssd1 vccd1 vccd1 sky130_fd_sc_hd__fill_2
XFILLER_50_289 vssd1 vccd1 vssd1 vccd1 sky130_ef_sc_hd__decap_40_12
XFILLER_58_301 vssd1 vssd1 vccd1 vccd1 sky130_fd_sc_hd__fill_4
XFILLER_26_253 vssd1 vssd1 vccd1 vccd1 sky130_fd_sc_hd__fill_8
XFILLER_37_35 vssd1 vssd1 vccd1 vccd1 sky130_fd_sc_hd__fill_1
XFILLER_37_57 vssd1 vssd1 vccd1 vccd1 sky130_fd_sc_hd__fill_4
XFILLER_58_345 vssd1 vccd1 vssd1 vccd1 sky130_ef_sc_hd__decap_40_12
XANTENNA__0771__A _0771_/A vssd1 vssd1 vccd1 vccd1 sky130_fd_sc_hd__diode_2
XFILLER_41_223 vssd1 vssd1 vccd1 vccd1 sky130_fd_sc_hd__fill_1
XFILLER_41_234 vssd1 vssd1 vccd1 vccd1 sky130_fd_sc_hd__fill_2
XFILLER_5_113 vssd1 vccd1 vssd1 vccd1 sky130_ef_sc_hd__decap_40_12
XFILLER_49_345 vssd1 vssd1 vccd1 vccd1 sky130_fd_sc_hd__fill_1
XFILLER_17_231 vssd1 vssd1 vccd1 vccd1 sky130_fd_sc_hd__fill_1
XFILLER_32_267 vssd1 vssd1 vccd1 vccd1 sky130_fd_sc_hd__fill_1
X_0962_ _0963_/B _0963_/A vssd1 vssd1 vccd1 vccd1 _0979_/B sky130_fd_sc_hd__and2b_2
X_0893_ _0893_/A _0893_/B vssd1 vssd1 vccd1 vccd1 _0894_/B sky130_fd_sc_hd__nor2_2
XFILLER_4_83 vssd1 vssd1 vccd1 vccd1 sky130_fd_sc_hd__fill_1
XFILLER_59_109 vssd1 vssd1 vccd1 vccd1 sky130_fd_sc_hd__fill_2
X_1445_ _1459_/CLK _1445_/D load_slew137/X vssd1 vssd1 vccd1 vccd1 _1445_/Q sky130_fd_sc_hd__dfrtp_2
X_1514_ _1535_/A vssd1 vssd1 vccd1 vccd1 _1514_/X sky130_fd_sc_hd__buf_2
XTAP_TAPCELL_ROW_10_192 vssd1 vccd1 sky130_fd_sc_hd__tapvpwrvgnd_1
XFILLER_55_337 vssd1 vccd1 vssd1 vccd1 sky130_ef_sc_hd__decap_40_12
X_1376_ _1375_/B _1375_/C _1375_/A vssd1 vssd1 vccd1 vccd1 _1376_/X sky130_fd_sc_hd__o21a_2
XFILLER_23_223 vssd1 vssd1 vccd1 vccd1 sky130_fd_sc_hd__fill_1
XFILLER_23_289 vssd1 vssd1 vccd1 vccd1 sky130_fd_sc_hd__fill_1
XFILLER_23_37 vssd1 vssd1 vccd1 vccd1 sky130_fd_sc_hd__fill_8
XFILLER_23_59 vssd1 vssd1 vccd1 vccd1 sky130_fd_sc_hd__fill_1
XFILLER_48_89 vssd1 vssd1 vccd1 vccd1 sky130_fd_sc_hd__fill_2
XFILLER_58_153 vssd1 vccd1 vssd1 vccd1 sky130_ef_sc_hd__decap_40_12
XFILLER_14_212 vssd1 vccd1 vssd1 vccd1 sky130_ef_sc_hd__decap_40_12
XFILLER_58_197 vssd1 vccd1 vssd1 vccd1 sky130_ef_sc_hd__decap_40_12
XFILLER_14_278 vssd1 vssd1 vccd1 vccd1 sky130_fd_sc_hd__fill_8
XFILLER_9_39 vssd1 vccd1 vssd1 vccd1 sky130_ef_sc_hd__decap_40_12
Xfanout93 _1211_/A vssd1 vssd1 vccd1 vccd1 _1294_/S sky130_fd_sc_hd__clkdlybuf4s25_1
XTAP_TAPCELL_ROW_24_284 vssd1 vccd1 sky130_fd_sc_hd__tapvpwrvgnd_1
XANTENNA__1193__A1 _1332_/A1 vssd1 vssd1 vccd1 vccd1 sky130_fd_sc_hd__diode_2
XANTENNA__1124__X _1124_/X vssd1 vssd1 vccd1 vccd1 sky130_fd_sc_hd__diode_2
XFILLER_1_193 vssd1 vccd1 vssd1 vccd1 sky130_ef_sc_hd__decap_40_12
XFILLER_37_337 vssd1 vssd1 vccd1 vccd1 sky130_fd_sc_hd__fill_8
XFILLER_52_307 vssd1 vssd1 vccd1 vccd1 sky130_fd_sc_hd__fill_1
X_1230_ _1354_/B vssd1 vssd1 vccd1 vccd1 _1460_/D sky130_fd_sc_hd__inv_2
X_1161_ _1206_/A1 _1206_/A2 _1206_/B1 _1159_/Y vssd1 vssd1 vccd1 vccd1 _1161_/X sky130_fd_sc_hd__o211a_2
X_1092_ _1092_/A _1097_/A vssd1 vssd1 vccd1 vccd1 _1093_/B sky130_fd_sc_hd__and2_2
XFILLER_9_293 vssd1 vccd1 vssd1 vccd1 sky130_ef_sc_hd__decap_40_12
X_0945_ _0943_/A _0943_/B _0904_/X vssd1 vssd1 vccd1 vccd1 _0951_/A sky130_fd_sc_hd__a21oi_2
X_0876_ _0997_/B _0876_/B vssd1 vssd1 vccd1 vccd1 _0901_/D sky130_fd_sc_hd__xnor2_2
X_1428_ _1428_/A _1436_/B vssd1 vssd1 vccd1 vccd1 _1428_/Y sky130_fd_sc_hd__nor2_2
XFILLER_18_48 vssd1 vssd1 vccd1 vccd1 sky130_fd_sc_hd__fill_2
XFILLER_55_167 vssd1 vssd1 vccd1 vccd1 sky130_fd_sc_hd__fill_1
X_1359_ _1348_/Y _1349_/X _1358_/Y _1347_/X _1343_/X vssd1 vssd1 vccd1 vccd1 _1362_/B
+ sky130_fd_sc_hd__o2111ai_2
XTAP_TAPCELL_ROW_38_376 vssd1 vccd1 sky130_fd_sc_hd__tapvpwrvgnd_1
XFILLER_11_237 vssd1 vssd1 vccd1 vccd1 sky130_fd_sc_hd__fill_8
XFILLER_50_13 vssd1 vccd1 vssd1 vccd1 sky130_ef_sc_hd__decap_40_12
Xwire106 _0901_/D vssd1 vssd1 vccd1 vccd1 _1352_/A sky130_fd_sc_hd__buf_2
XTAP_TAPCELL_ROW_21_265 vssd1 vccd1 sky130_fd_sc_hd__tapvpwrvgnd_1
XFILLER_50_68 vssd1 vssd1 vccd1 vccd1 sky130_fd_sc_hd__fill_1
XFILLER_59_55 vssd1 vssd1 vccd1 vccd1 sky130_fd_sc_hd__fill_1
XFILLER_19_337 vssd1 vssd1 vccd1 vccd1 sky130_fd_sc_hd__fill_8
XFILLER_42_373 vssd1 vssd1 vccd1 vccd1 sky130_fd_sc_hd__fill_2
XTAP_TAPCELL_ROW_12_210 vssd1 vccd1 sky130_fd_sc_hd__tapvpwrvgnd_1
X_0730_ _0730_/A _1366_/A vssd1 vssd1 vccd1 vccd1 _0732_/B sky130_fd_sc_hd__xor2_2
X_1213_ _1330_/B1 _1211_/X _1212_/X _1332_/A1 vssd1 vssd1 vccd1 vccd1 _1353_/B sky130_fd_sc_hd__a31o_2
XFILLER_1_51 vssd1 vssd1 vccd1 vccd1 sky130_fd_sc_hd__fill_4
XFILLER_37_145 vssd1 vssd1 vccd1 vccd1 sky130_fd_sc_hd__fill_2
XFILLER_52_137 vssd1 vssd1 vccd1 vccd1 sky130_fd_sc_hd__fill_2
X_1144_ _1448_/Q _1449_/Q _1329_/B vssd1 vssd1 vccd1 vccd1 _1153_/B sky130_fd_sc_hd__and3_2
X_1075_ _1462_/Q _1077_/B vssd1 vssd1 vccd1 vccd1 _1075_/X sky130_fd_sc_hd__and2_2
XTAP_TAPCELL_ROW_35_357 vssd1 vccd1 sky130_fd_sc_hd__tapvpwrvgnd_1
X_0928_ _0943_/A input9/X vssd1 vssd1 vccd1 vccd1 _0929_/B sky130_fd_sc_hd__or2_2
X_0859_ _0953_/B _0860_/B vssd1 vssd1 vccd1 vccd1 _0859_/Y sky130_fd_sc_hd__nand2_2
XFILLER_29_25 vssd1 vssd1 vccd1 vccd1 sky130_fd_sc_hd__fill_4
XFILLER_45_46 vssd1 vssd1 vccd1 vccd1 sky130_fd_sc_hd__fill_1
XFILLER_45_57 vssd1 vssd1 vccd1 vccd1 sky130_fd_sc_hd__fill_8
XFILLER_51_181 vssd1 vccd1 vssd1 vccd1 sky130_ef_sc_hd__decap_40_12
XFILLER_6_29 vssd1 vccd1 vssd1 vccd1 sky130_ef_sc_hd__decap_40_12
XFILLER_10_82 vssd1 vssd1 vccd1 vccd1 sky130_fd_sc_hd__fill_2
XFILLER_3_277 vssd1 vssd1 vccd1 vccd1 sky130_fd_sc_hd__fill_2
XANTENNA__0954__A input9/X vssd1 vssd1 vccd1 vccd1 sky130_fd_sc_hd__diode_2
XANTENNA__1320__A1 _1332_/A1 vssd1 vssd1 vccd1 vccd1 sky130_fd_sc_hd__diode_2
XFILLER_59_281 vssd1 vssd1 vccd1 vccd1 sky130_fd_sc_hd__fill_4
XFILLER_59_292 vssd1 vccd1 vssd1 vccd1 sky130_ef_sc_hd__decap_40_12
XTAP_TAPCELL_ROW_49_449 vssd1 vccd1 sky130_fd_sc_hd__tapvpwrvgnd_1
XFILLER_42_192 vssd1 vssd1 vccd1 vccd1 sky130_fd_sc_hd__fill_4
XTAP_TAPCELL_ROW_32_338 vssd1 vccd1 sky130_fd_sc_hd__tapvpwrvgnd_1
X_0713_ _1543_/A input5/X input3/X vssd1 vssd1 vccd1 vccd1 _1340_/A sky130_fd_sc_hd__or3b_2
XFILLER_15_38 vssd1 vssd1 vccd1 vccd1 sky130_fd_sc_hd__fill_1
XFILLER_40_107 vssd1 vssd1 vccd1 vccd1 sky130_fd_sc_hd__fill_4
XFILLER_40_118 vssd1 vssd1 vccd1 vccd1 sky130_fd_sc_hd__fill_8
X_1127_ _1030_/Y _1035_/X _1126_/Y _1125_/X vssd1 vssd1 vccd1 vccd1 _1127_/Y sky130_fd_sc_hd__a31oi_2
X_1058_ _1466_/Q _1058_/B vssd1 vssd1 vccd1 vccd1 _1058_/Y sky130_fd_sc_hd__nand2_2
XFILLER_0_225 vssd1 vccd1 vssd1 vccd1 sky130_ef_sc_hd__decap_40_12
Xoutput26 _1524_/X vssd1 vssd1 vccd1 vccd1 gpio_oeb[13] sky130_fd_sc_hd__clkdlybuf4s25_1
Xoutput59 _1418_/X vssd1 vssd1 vccd1 vccd1 gpio_out[12] sky130_fd_sc_hd__clkdlybuf4s25_1
Xoutput48 _1535_/A vssd1 vssd1 vccd1 vccd1 gpio_oeb[33] sky130_fd_sc_hd__clkdlybuf4s25_1
Xoutput37 _1534_/X vssd1 vssd1 vccd1 vccd1 gpio_oeb[23] sky130_fd_sc_hd__clkdlybuf4s25_1
XPHY_EDGE_ROW_1_Right_1 vssd1 vssd1 vccd1 vccd1 sky130_fd_sc_hd__decap_3
XFILLER_56_251 vssd1 vssd1 vccd1 vccd1 sky130_fd_sc_hd__fill_1
XFILLER_12_321 vssd1 vccd1 vssd1 vccd1 sky130_ef_sc_hd__decap_40_12
XFILLER_12_365 vssd1 vssd1 vccd1 vccd1 sky130_fd_sc_hd__fill_2
XFILLER_30_195 vssd1 vssd1 vccd1 vccd1 sky130_fd_sc_hd__fill_1
XANTENNA__0859__A _0953_/B vssd1 vssd1 vccd1 vccd1 sky130_fd_sc_hd__diode_2
XANTENNA__1296__B1 _1313_/B1 vssd1 vssd1 vccd1 vccd1 sky130_fd_sc_hd__diode_2
XFILLER_38_284 vssd1 vssd1 vccd1 vccd1 sky130_fd_sc_hd__fill_8
XFILLER_53_221 vssd1 vssd1 vccd1 vccd1 sky130_fd_sc_hd__fill_2
XFILLER_5_317 vssd1 vccd1 vssd1 vccd1 sky130_ef_sc_hd__decap_40_12
XTAP_TAPCELL_ROW_59_522 vssd1 vccd1 sky130_fd_sc_hd__tapvpwrvgnd_1
XTAP_TAPCELL_ROW_59_511 vssd1 vccd1 sky130_fd_sc_hd__tapvpwrvgnd_1
XANTENNA_input14_A prescaler[3] vssd1 vssd1 vccd1 vccd1 sky130_fd_sc_hd__diode_2
XFILLER_29_262 vssd1 vssd1 vccd1 vccd1 sky130_fd_sc_hd__fill_4
XTAP_TAPCELL_ROW_42_400 vssd1 vccd1 sky130_fd_sc_hd__tapvpwrvgnd_1
XFILLER_16_81 vssd1 vssd1 vccd1 vccd1 sky130_fd_sc_hd__fill_2
XFILLER_8_133 vssd1 vssd1 vccd1 vccd1 sky130_fd_sc_hd__fill_4
XANTENNA__1462__RESET_B load_slew137/X vssd1 vssd1 vccd1 vccd1 sky130_fd_sc_hd__diode_2
XFILLER_4_361 vssd1 vssd1 vccd1 vccd1 sky130_fd_sc_hd__fill_2
X_1392_ _1477_/Q _1392_/B vssd1 vssd1 vccd1 vccd1 _1393_/B sky130_fd_sc_hd__nand2_2
X_1461_ _1478_/CLK _1461_/D fanout139/X vssd1 vssd1 vccd1 vccd1 _1461_/Q sky130_fd_sc_hd__dfrtp_2
X_1530_ _1530_/A vssd1 vssd1 vccd1 vccd1 _1530_/X sky130_fd_sc_hd__buf_2
XPHY_EDGE_ROW_19_Left_79 vssd1 vssd1 vccd1 vccd1 sky130_fd_sc_hd__decap_3
XFILLER_2_309 vssd1 vccd1 vssd1 vccd1 sky130_ef_sc_hd__decap_40_12
XANTENNA_input6_A nrst vssd1 vssd1 vccd1 vccd1 sky130_fd_sc_hd__diode_2
XFILLER_58_357 vssd1 vssd1 vccd1 vccd1 sky130_fd_sc_hd__fill_4
XFILLER_41_213 vssd1 vssd1 vccd1 vccd1 sky130_fd_sc_hd__fill_8
XFILLER_53_57 vssd1 vccd1 vssd1 vccd1 sky130_ef_sc_hd__decap_40_12
XFILLER_5_125 vssd1 vccd1 vssd1 vccd1 sky130_ef_sc_hd__decap_40_12
XFILLER_5_169 vssd1 vccd1 vssd1 vccd1 sky130_ef_sc_hd__decap_40_12
XFILLER_49_335 vssd1 vssd1 vccd1 vccd1 sky130_fd_sc_hd__fill_1
X_0961_ _0964_/A _0960_/B _0957_/Y vssd1 vssd1 vccd1 vccd1 _0963_/B sky130_fd_sc_hd__a21oi_2
XFILLER_57_3 vssd1 vccd1 vssd1 vccd1 sky130_ef_sc_hd__decap_40_12
X_0892_ _0993_/B vssd1 vssd1 vccd1 vccd1 _0994_/A sky130_fd_sc_hd__inv_2
XTAP_TAPCELL_ROW_10_193 vssd1 vccd1 sky130_fd_sc_hd__tapvpwrvgnd_1
X_1375_ _1375_/A _1375_/B _1375_/C vssd1 vssd1 vccd1 vccd1 _1375_/Y sky130_fd_sc_hd__nor3_2
X_1444_ _1463_/CLK _1444_/D load_slew137/X vssd1 vssd1 vccd1 vccd1 _1444_/Q sky130_fd_sc_hd__dfrtp_2
X_1513_ _1535_/A vssd1 vssd1 vccd1 vccd1 _1513_/X sky130_fd_sc_hd__buf_2
XANTENNA__1266__A3 _1285_/C vssd1 vssd1 vccd1 vccd1 sky130_fd_sc_hd__diode_2
XFILLER_23_213 vssd1 vssd1 vccd1 vccd1 sky130_fd_sc_hd__fill_8
XFILLER_55_305 vssd1 vccd1 vssd1 vccd1 sky130_ef_sc_hd__decap_40_12
XFILLER_55_349 vssd1 vccd1 vssd1 vccd1 sky130_ef_sc_hd__decap_40_12
XTAP_TAPCELL_ROW_2_139 vssd1 vccd1 sky130_fd_sc_hd__tapvpwrvgnd_1
XFILLER_23_279 vssd1 vssd1 vccd1 vccd1 sky130_fd_sc_hd__fill_1
XFILLER_2_139 vssd1 vssd1 vccd1 vccd1 sky130_fd_sc_hd__fill_1
XANTENNA_input9_X input9/X vssd1 vssd1 vccd1 vccd1 sky130_fd_sc_hd__diode_2
XFILLER_48_57 vssd1 vssd1 vccd1 vccd1 sky130_fd_sc_hd__fill_1
XFILLER_48_68 vssd1 vccd1 vssd1 vccd1 sky130_ef_sc_hd__decap_40_12
XFILLER_58_121 vssd1 vccd1 vssd1 vccd1 sky130_ef_sc_hd__decap_40_12
XFILLER_58_165 vssd1 vccd1 vssd1 vccd1 sky130_ef_sc_hd__decap_40_12
XFILLER_14_224 vssd1 vssd1 vccd1 vccd1 sky130_fd_sc_hd__fill_2
XFILLER_54_371 vssd1 vssd1 vccd1 vccd1 sky130_fd_sc_hd__fill_1
XFILLER_22_290 vssd1 vccd1 vssd1 vccd1 sky130_ef_sc_hd__decap_40_12
Xfanout94 _1327_/C vssd1 vssd1 vccd1 vccd1 _1205_/B sky130_fd_sc_hd__clkdlybuf4s25_1
XTAP_TAPCELL_ROW_24_285 vssd1 vccd1 sky130_fd_sc_hd__tapvpwrvgnd_1
XANTENNA__1178__C1 _0902_/A vssd1 vssd1 vccd1 vccd1 sky130_fd_sc_hd__diode_2
XFILLER_1_161 vssd1 vssd1 vccd1 vccd1 sky130_fd_sc_hd__fill_4
XFILLER_37_316 vssd1 vccd1 vssd1 vccd1 sky130_ef_sc_hd__decap_40_12
XFILLER_49_165 vssd1 vssd1 vccd1 vccd1 sky130_fd_sc_hd__fill_2
X_1160_ _1451_/Q _1205_/B vssd1 vssd1 vccd1 vccd1 _1160_/Y sky130_fd_sc_hd__nand2_2
X_1091_ _1455_/Q _1342_/A vssd1 vssd1 vccd1 vccd1 _1101_/B sky130_fd_sc_hd__or2_2
XANTENNA__1300__B _1327_/C vssd1 vssd1 vccd1 vccd1 sky130_fd_sc_hd__diode_2
X_0944_ _0956_/A _0956_/B vssd1 vssd1 vccd1 vccd1 _0946_/B sky130_fd_sc_hd__or2_2
XPHY_EDGE_ROW_41_Left_101 vssd1 vssd1 vccd1 vccd1 sky130_fd_sc_hd__decap_3
XFILLER_9_272 vssd1 vssd1 vccd1 vccd1 sky130_fd_sc_hd__fill_1
X_0875_ _0997_/A _0998_/A _0998_/B _0777_/X vssd1 vssd1 vccd1 vccd1 _0876_/B sky130_fd_sc_hd__a31o_2
XFILLER_18_27 vssd1 vssd1 vccd1 vccd1 sky130_fd_sc_hd__fill_1
XFILLER_18_38 vssd1 vssd1 vccd1 vccd1 sky130_fd_sc_hd__fill_1
XFILLER_55_113 vssd1 vccd1 vssd1 vccd1 sky130_ef_sc_hd__decap_40_12
X_1358_ _0729_/A _1449_/D _1466_/D _1058_/B vssd1 vssd1 vccd1 vccd1 _1358_/Y sky130_fd_sc_hd__a22oi_2
X_1427_ _1427_/A _1427_/B _1438_/D vssd1 vssd1 vccd1 vccd1 _1427_/X sky130_fd_sc_hd__and3_2
XPHY_EDGE_ROW_50_Left_110 vssd1 vssd1 vccd1 vccd1 sky130_fd_sc_hd__decap_3
XFILLER_34_15 vssd1 vssd1 vccd1 vccd1 sky130_fd_sc_hd__fill_4
X_1289_ _1285_/X _1288_/Y _1330_/B1 vssd1 vssd1 vccd1 vccd1 _1289_/Y sky130_fd_sc_hd__o21ai_2
XTAP_TAPCELL_ROW_38_377 vssd1 vccd1 sky130_fd_sc_hd__tapvpwrvgnd_1
XFILLER_50_25 vssd1 vssd1 vccd1 vccd1 sky130_fd_sc_hd__fill_2
XFILLER_7_209 vssd1 vccd1 vssd1 vccd1 sky130_ef_sc_hd__decap_40_12
XTAP_TAPCELL_ROW_21_266 vssd1 vccd1 sky130_fd_sc_hd__tapvpwrvgnd_1
XFILLER_6_253 vssd1 vccd1 vssd1 vccd1 sky130_ef_sc_hd__decap_40_12
XFILLER_37_113 vssd1 vccd1 vssd1 vccd1 sky130_ef_sc_hd__decap_40_12
X_1212_ _1458_/Q _1285_/C _1288_/A vssd1 vssd1 vccd1 vccd1 _1212_/X sky130_fd_sc_hd__a21bo_2
X_1143_ _1448_/Q _1329_/B _1449_/Q vssd1 vssd1 vccd1 vccd1 _1145_/A sky130_fd_sc_hd__a21oi_2
X_1074_ _1463_/Q _1375_/A vssd1 vssd1 vccd1 vccd1 _1074_/Y sky130_fd_sc_hd__nand2_2
XTAP_TAPCELL_ROW_35_358 vssd1 vccd1 sky130_fd_sc_hd__tapvpwrvgnd_1
X_0927_ _0927_/A _0927_/B vssd1 vssd1 vccd1 vccd1 _0934_/A sky130_fd_sc_hd__nand2_2
XANTENNA__1157__A2 _1332_/A1 vssd1 vssd1 vccd1 vccd1 sky130_fd_sc_hd__diode_2
XANTENNA__1471__CLK _1471_/CLK vssd1 vssd1 vccd1 vccd1 sky130_fd_sc_hd__diode_2
X_0858_ _0880_/B _0858_/B vssd1 vssd1 vccd1 vccd1 _0860_/B sky130_fd_sc_hd__xor2_2
X_0789_ _0942_/B _0792_/B vssd1 vssd1 vccd1 vccd1 _0838_/B sky130_fd_sc_hd__nand2_2
XANTENNA__1205__B _1205_/B vssd1 vssd1 vccd1 vccd1 sky130_fd_sc_hd__diode_2
XFILLER_45_25 vssd1 vssd1 vccd1 vccd1 sky130_fd_sc_hd__fill_1
XFILLER_24_341 vssd1 vssd1 vccd1 vccd1 sky130_fd_sc_hd__fill_4
XFILLER_51_193 vssd1 vccd1 vssd1 vccd1 sky130_ef_sc_hd__decap_40_12
XPHY_EDGE_ROW_7_Left_67 vssd1 vssd1 vccd1 vccd1 sky130_fd_sc_hd__decap_3
XFILLER_3_223 vssd1 vssd1 vccd1 vccd1 sky130_fd_sc_hd__fill_1
XFILLER_19_113 vssd1 vccd1 vssd1 vccd1 sky130_ef_sc_hd__decap_40_12
XFILLER_34_105 vssd1 vccd1 vssd1 vccd1 sky130_ef_sc_hd__decap_40_12
XTAP_TAPCELL_ROW_32_339 vssd1 vccd1 sky130_fd_sc_hd__tapvpwrvgnd_1
X_0712_ input5/X input3/X input1/X vssd1 vssd1 vccd1 vccd1 _0712_/X sky130_fd_sc_hd__and3b_2
X_1126_ _1044_/A _1042_/Y _1044_/B vssd1 vssd1 vccd1 vccd1 _1126_/Y sky130_fd_sc_hd__o21bai_2
XANTENNA__0880__A _0953_/B vssd1 vssd1 vccd1 vccd1 sky130_fd_sc_hd__diode_2
XFILLER_15_28 vssd1 vssd1 vccd1 vccd1 sky130_fd_sc_hd__fill_8
XFILLER_21_311 vssd1 vccd1 vssd1 vccd1 sky130_ef_sc_hd__decap_40_12
X_1057_ _1059_/B _1059_/C _1059_/A vssd1 vssd1 vccd1 vccd1 _1057_/Y sky130_fd_sc_hd__a21oi_2
XFILLER_0_204 vssd1 vccd1 vssd1 vccd1 sky130_ef_sc_hd__decap_40_12
XFILLER_0_237 vssd1 vccd1 vssd1 vccd1 sky130_ef_sc_hd__decap_40_12
Xoutput27 _1525_/X vssd1 vssd1 vccd1 vccd1 gpio_oeb[14] sky130_fd_sc_hd__clkdlybuf4s25_1
Xoutput49 _1514_/X vssd1 vssd1 vccd1 vccd1 gpio_oeb[3] sky130_fd_sc_hd__clkdlybuf4s25_1
Xoutput38 _1535_/X vssd1 vssd1 vccd1 vccd1 gpio_oeb[24] sky130_fd_sc_hd__clkdlybuf4s25_1
XANTENNA__1302__A2 _1124_/X vssd1 vssd1 vccd1 vccd1 sky130_fd_sc_hd__diode_2
XFILLER_16_138 vssd1 vssd1 vccd1 vccd1 sky130_fd_sc_hd__fill_2
XFILLER_12_333 vssd1 vccd1 vssd1 vccd1 sky130_ef_sc_hd__decap_40_12
XFILLER_24_193 vssd1 vssd1 vccd1 vccd1 sky130_fd_sc_hd__fill_1
XFILLER_21_71 vssd1 vssd1 vccd1 vccd1 sky130_fd_sc_hd__fill_2
XFILLER_21_93 vssd1 vssd1 vccd1 vccd1 sky130_fd_sc_hd__fill_1
XANTENNA__0965__A _0965_/A vssd1 vssd1 vccd1 vccd1 sky130_fd_sc_hd__diode_2
XFILLER_39_208 vssd1 vssd1 vccd1 vccd1 sky130_fd_sc_hd__fill_8
XFILLER_22_108 vssd1 vssd1 vccd1 vccd1 sky130_fd_sc_hd__fill_2
Xclkbuf_0_clk clk vssd1 vssd1 vccd1 vccd1 clkbuf_0_clk/X sky130_fd_sc_hd__clkbuf_16
XTAP_TAPCELL_ROW_45_420 vssd1 vccd1 sky130_fd_sc_hd__tapvpwrvgnd_1
XFILLER_7_51 vssd1 vssd1 vccd1 vccd1 sky130_fd_sc_hd__fill_4
XPHY_EDGE_ROW_15_Right_15 vssd1 vssd1 vccd1 vccd1 sky130_fd_sc_hd__decap_3
XFILLER_26_27 vssd1 vssd1 vccd1 vccd1 sky130_fd_sc_hd__fill_1
X_1109_ _1109_/A _1109_/B vssd1 vssd1 vccd1 vccd1 _1109_/X sky130_fd_sc_hd__or2_2
XPHY_EDGE_ROW_24_Right_24 vssd1 vssd1 vccd1 vccd1 sky130_fd_sc_hd__decap_3
XFILLER_21_141 vssd1 vccd1 vssd1 vccd1 sky130_ef_sc_hd__decap_40_12
XFILLER_21_185 vssd1 vssd1 vccd1 vccd1 sky130_fd_sc_hd__fill_1
XFILLER_42_15 vssd1 vssd1 vccd1 vccd1 sky130_fd_sc_hd__fill_4
XFILLER_53_277 vssd1 vssd1 vccd1 vccd1 sky130_fd_sc_hd__fill_2
XANTENNA_fanout94_A _1327_/C vssd1 vssd1 vccd1 vccd1 sky130_fd_sc_hd__diode_2
XFILLER_5_329 vssd1 vssd1 vccd1 vccd1 sky130_fd_sc_hd__fill_4
XPHY_EDGE_ROW_33_Right_33 vssd1 vssd1 vccd1 vccd1 sky130_fd_sc_hd__decap_3
XFILLER_29_252 vssd1 vssd1 vccd1 vccd1 sky130_fd_sc_hd__fill_2
XTAP_TAPCELL_ROW_8_178 vssd1 vccd1 sky130_fd_sc_hd__tapvpwrvgnd_1
XTAP_TAPCELL_ROW_59_512 vssd1 vccd1 sky130_fd_sc_hd__tapvpwrvgnd_1
XTAP_TAPCELL_ROW_42_401 vssd1 vccd1 sky130_fd_sc_hd__tapvpwrvgnd_1
XPHY_EDGE_ROW_42_Right_42 vssd1 vssd1 vccd1 vccd1 sky130_fd_sc_hd__decap_3
XPHY_EDGE_ROW_51_Right_51 vssd1 vssd1 vccd1 vccd1 sky130_fd_sc_hd__decap_3
XANTENNA__1127__Y _1127_/Y vssd1 vssd1 vccd1 vccd1 sky130_fd_sc_hd__diode_2
XFILLER_4_373 vssd1 vssd1 vccd1 vccd1 sky130_fd_sc_hd__fill_2
X_1391_ _1478_/Q _1416_/B _1442_/B input1/X vssd1 vssd1 vccd1 vccd1 _1439_/C sky130_fd_sc_hd__o31a_2
X_1460_ _1471_/CLK _1460_/D fanout139/X vssd1 vssd1 vccd1 vccd1 _1460_/Q sky130_fd_sc_hd__dfrtp_2
XANTENNA__0722__B1 _1313_/B1 vssd1 vssd1 vccd1 vccd1 sky130_fd_sc_hd__diode_2
XFILLER_35_299 vssd1 vccd1 vssd1 vccd1 sky130_ef_sc_hd__decap_40_12
XFILLER_12_29 vssd1 vccd1 vssd1 vccd1 sky130_ef_sc_hd__decap_40_12
XTAP_TAPCELL_ROW_5_159 vssd1 vccd1 sky130_fd_sc_hd__tapvpwrvgnd_1
XFILLER_41_236 vssd1 vssd1 vccd1 vccd1 sky130_fd_sc_hd__fill_1
XFILLER_41_247 vssd1 vssd1 vccd1 vccd1 sky130_fd_sc_hd__fill_4
XFILLER_53_69 vssd1 vccd1 vssd1 vccd1 sky130_ef_sc_hd__decap_40_12
XFILLER_5_137 vssd1 vccd1 vssd1 vccd1 sky130_ef_sc_hd__decap_40_12
XPHY_EDGE_ROW_36_Left_96 vssd1 vssd1 vccd1 vccd1 sky130_fd_sc_hd__decap_3
XFILLER_40_280 vssd1 vssd1 vccd1 vccd1 sky130_fd_sc_hd__fill_1
X_0960_ _0957_/Y _0960_/B vssd1 vssd1 vccd1 vccd1 _0964_/B sky130_fd_sc_hd__and2b_2
X_1512_ _1543_/A vssd1 vssd1 vccd1 vccd1 _1512_/X sky130_fd_sc_hd__buf_2
X_0891_ _0893_/A _0893_/B vssd1 vssd1 vccd1 vccd1 _0993_/B sky130_fd_sc_hd__and2_2
XTAP_TAPCELL_ROW_10_194 vssd1 vccd1 sky130_fd_sc_hd__tapvpwrvgnd_1
XFILLER_4_41 vssd1 vccd1 vssd1 vccd1 sky130_ef_sc_hd__decap_40_12
XFILLER_4_85 vssd1 vccd1 vssd1 vccd1 sky130_ef_sc_hd__decap_40_12
X_1374_ _1099_/B _1452_/D _1454_/D _1372_/A vssd1 vssd1 vccd1 vccd1 _1374_/X sky130_fd_sc_hd__o22a_2
X_1443_ _1471_/CLK _1443_/D load_slew140/X vssd1 vssd1 vccd1 vccd1 _1443_/Q sky130_fd_sc_hd__dfrtp_2
XFILLER_23_225 vssd1 vssd1 vccd1 vccd1 sky130_fd_sc_hd__fill_4
XFILLER_55_317 vssd1 vccd1 vssd1 vccd1 sky130_ef_sc_hd__decap_40_12
XFILLER_23_17 vssd1 vssd1 vccd1 vccd1 sky130_fd_sc_hd__fill_4
XFILLER_58_133 vssd1 vssd1 vccd1 vccd1 sky130_fd_sc_hd__fill_4
XFILLER_58_177 vssd1 vccd1 vssd1 vccd1 sky130_ef_sc_hd__decap_40_12
XFILLER_54_361 vssd1 vssd1 vccd1 vccd1 sky130_fd_sc_hd__fill_2
XTAP_TAPCELL_ROW_24_286 vssd1 vccd1 sky130_fd_sc_hd__tapvpwrvgnd_1
XFILLER_13_61 vssd1 vssd1 vccd1 vccd1 sky130_fd_sc_hd__fill_2
XFILLER_13_83 vssd1 vssd1 vccd1 vccd1 sky130_fd_sc_hd__fill_4
XFILLER_13_94 vssd1 vccd1 vssd1 vccd1 sky130_ef_sc_hd__decap_40_12
Xfanout95 _1327_/C vssd1 vssd1 vccd1 vccd1 _1285_/C sky130_fd_sc_hd__clkdlybuf4s25_1
XFILLER_49_111 vssd1 vssd1 vccd1 vccd1 sky130_fd_sc_hd__fill_1
XFILLER_37_328 vssd1 vssd1 vccd1 vccd1 sky130_fd_sc_hd__fill_8
XFILLER_52_309 vssd1 vccd1 vssd1 vccd1 sky130_ef_sc_hd__decap_40_12
X_1090_ _1454_/Q _1372_/A vssd1 vssd1 vccd1 vccd1 _1100_/A sky130_fd_sc_hd__and2_2
X_0943_ _0943_/A _0943_/B vssd1 vssd1 vccd1 vccd1 _0956_/B sky130_fd_sc_hd__xnor2_2
X_0874_ _0874_/A _0874_/B vssd1 vssd1 vccd1 vccd1 _0997_/B sky130_fd_sc_hd__xor2_2
XFILLER_28_306 vssd1 vssd1 vccd1 vccd1 sky130_fd_sc_hd__fill_2
XFILLER_55_125 vssd1 vccd1 vssd1 vccd1 sky130_ef_sc_hd__decap_40_12
X_1357_ _1357_/A _1357_/B _1357_/C vssd1 vssd1 vccd1 vccd1 _1379_/A sky130_fd_sc_hd__or3_2
X_1426_ _1426_/A _1436_/B vssd1 vssd1 vccd1 vccd1 _1426_/Y sky130_fd_sc_hd__nor2_2
X_1288_ _1288_/A _1299_/C _1288_/C vssd1 vssd1 vccd1 vccd1 _1288_/Y sky130_fd_sc_hd__nor3_2
XFILLER_34_27 vssd1 vssd1 vccd1 vccd1 sky130_fd_sc_hd__fill_1
XFILLER_55_169 vssd1 vccd1 vssd1 vccd1 sky130_ef_sc_hd__decap_40_12
XTAP_TAPCELL_ROW_38_378 vssd1 vccd1 sky130_fd_sc_hd__tapvpwrvgnd_1
XTAP_TAPCELL_ROW_21_267 vssd1 vccd1 sky130_fd_sc_hd__tapvpwrvgnd_1
XFILLER_59_57 vssd1 vccd1 vssd1 vccd1 sky130_ef_sc_hd__decap_40_12
XFILLER_19_317 vssd1 vccd1 vssd1 vccd1 sky130_ef_sc_hd__decap_40_12
XFILLER_34_309 vssd1 vssd1 vccd1 vccd1 sky130_fd_sc_hd__fill_4
XFILLER_10_261 vssd1 vccd1 vssd1 vccd1 sky130_ef_sc_hd__decap_40_12
XFILLER_24_60 vssd1 vssd1 vccd1 vccd1 sky130_fd_sc_hd__fill_4
XFILLER_24_93 vssd1 vssd1 vccd1 vccd1 sky130_fd_sc_hd__fill_4
XFILLER_40_81 vssd1 vssd1 vccd1 vccd1 sky130_fd_sc_hd__fill_2
XFILLER_41_7 vssd1 vssd1 vccd1 vccd1 sky130_fd_sc_hd__fill_1
XFILLER_6_232 vssd1 vccd1 vssd1 vccd1 sky130_ef_sc_hd__decap_40_12
XFILLER_6_265 vssd1 vccd1 vssd1 vccd1 sky130_ef_sc_hd__decap_40_12
XFILLER_37_125 vssd1 vccd1 vssd1 vccd1 sky130_ef_sc_hd__decap_40_12
X_1211_ _1211_/A _1211_/B vssd1 vssd1 vccd1 vccd1 _1211_/X sky130_fd_sc_hd__or2_2
X_1142_ _1142_/A vssd1 vssd1 vccd1 vccd1 _1448_/D sky130_fd_sc_hd__inv_2
XFILLER_37_169 vssd1 vssd1 vccd1 vccd1 sky130_fd_sc_hd__fill_1
XFILLER_52_139 vssd1 vssd1 vccd1 vccd1 sky130_fd_sc_hd__fill_1
X_1073_ _1463_/Q _1375_/A vssd1 vssd1 vccd1 vccd1 _1119_/A sky130_fd_sc_hd__nor2_2
XTAP_TAPCELL_ROW_35_359 vssd1 vccd1 sky130_fd_sc_hd__tapvpwrvgnd_1
XPHY_EDGE_ROW_23_Left_83 vssd1 vssd1 vccd1 vccd1 sky130_fd_sc_hd__decap_3
X_0926_ _0915_/B _0914_/C _0953_/B vssd1 vssd1 vccd1 vccd1 _0927_/B sky130_fd_sc_hd__a21o_2
X_0857_ _0956_/A _0965_/A _0751_/Y vssd1 vssd1 vccd1 vccd1 _0866_/A sky130_fd_sc_hd__o21ai_2
XFILLER_29_16 vssd1 vssd1 vccd1 vccd1 sky130_fd_sc_hd__fill_4
X_1409_ _1474_/Q _1416_/B _1438_/B _1418_/A vssd1 vssd1 vccd1 vccd1 _1432_/A sky130_fd_sc_hd__or4b_2
X_0788_ _0788_/A _0788_/B vssd1 vssd1 vccd1 vccd1 _0792_/B sky130_fd_sc_hd__xnor2_2
XFILLER_16_309 vssd1 vccd1 vssd1 vccd1 sky130_ef_sc_hd__decap_40_12
XFILLER_45_15 vssd1 vssd1 vccd1 vccd1 sky130_fd_sc_hd__fill_8
XFILLER_51_161 vssd1 vssd1 vccd1 vccd1 sky130_fd_sc_hd__fill_4
XFILLER_19_125 vssd1 vccd1 vssd1 vccd1 sky130_ef_sc_hd__decap_40_12
XFILLER_3_279 vssd1 vssd1 vccd1 vccd1 sky130_fd_sc_hd__fill_1
XFILLER_19_169 vssd1 vssd1 vccd1 vccd1 sky130_fd_sc_hd__fill_2
XFILLER_34_117 vssd1 vssd1 vccd1 vccd1 sky130_fd_sc_hd__fill_8
XFILLER_42_161 vssd1 vssd1 vccd1 vccd1 sky130_fd_sc_hd__fill_1
X_0711_ _0711_/A _1389_/A _1381_/A _1443_/Q vssd1 vssd1 vccd1 vccd1 _0711_/X sky130_fd_sc_hd__and4_2
XANTENNA__0698__A input7/X vssd1 vssd1 vccd1 vccd1 sky130_fd_sc_hd__diode_2
X_1125_ _1036_/A _1035_/B _1036_/C vssd1 vssd1 vccd1 vccd1 _1125_/X sky130_fd_sc_hd__a21o_2
XTAP_TAPCELL_ROW_48_440 vssd1 vccd1 sky130_fd_sc_hd__tapvpwrvgnd_1
XFILLER_15_18 vssd1 vssd1 vccd1 vccd1 sky130_fd_sc_hd__fill_4
XFILLER_21_301 vssd1 vssd1 vccd1 vccd1 sky130_fd_sc_hd__fill_1
XFILLER_21_323 vssd1 vccd1 vssd1 vccd1 sky130_ef_sc_hd__decap_40_12
XFILLER_21_345 vssd1 vssd1 vccd1 vccd1 sky130_fd_sc_hd__fill_2
X_1056_ _1059_/B _1059_/C vssd1 vssd1 vccd1 vccd1 _1058_/B sky130_fd_sc_hd__nand2_2
Xoutput39 _1536_/X vssd1 vssd1 vccd1 vccd1 gpio_oeb[25] sky130_fd_sc_hd__clkdlybuf4s25_1
Xoutput28 _1526_/X vssd1 vssd1 vccd1 vccd1 gpio_oeb[15] sky130_fd_sc_hd__clkdlybuf4s25_1
X_0909_ _0919_/B _0909_/B vssd1 vssd1 vccd1 vccd1 _0921_/A sky130_fd_sc_hd__nand2_2
XFILLER_0_216 vssd1 vssd1 vccd1 vccd1 sky130_fd_sc_hd__fill_8
XFILLER_0_249 vssd1 vssd1 vccd1 vccd1 sky130_fd_sc_hd__fill_2
XFILLER_48_209 vssd1 vssd1 vccd1 vccd1 sky130_fd_sc_hd__fill_4
XFILLER_31_109 vssd1 vssd1 vccd1 vccd1 sky130_fd_sc_hd__fill_2
XFILLER_56_253 vssd1 vccd1 vssd1 vccd1 sky130_ef_sc_hd__decap_40_12
XFILLER_12_345 vssd1 vccd1 vssd1 vccd1 sky130_ef_sc_hd__decap_40_12
XFILLER_8_305 vssd1 vssd1 vccd1 vccd1 sky130_fd_sc_hd__fill_2
XFILLER_21_61 vssd1 vssd1 vccd1 vccd1 sky130_fd_sc_hd__fill_1
XFILLER_30_120 vssd1 vccd1 vssd1 vccd1 sky130_ef_sc_hd__decap_40_12
XFILLER_30_164 vssd1 vssd1 vccd1 vccd1 sky130_fd_sc_hd__fill_2
XTAP_TAPCELL_ROW_45_421 vssd1 vccd1 sky130_fd_sc_hd__tapvpwrvgnd_1
XFILLER_30_197 vssd1 vssd1 vccd1 vccd1 sky130_fd_sc_hd__fill_8
XFILLER_38_253 vssd1 vssd1 vccd1 vccd1 sky130_fd_sc_hd__fill_4
XFILLER_53_223 vssd1 vssd1 vccd1 vccd1 sky130_fd_sc_hd__fill_1
X_1108_ _1107_/Y _1104_/X _1451_/Q _0767_/A vssd1 vssd1 vccd1 vccd1 _1109_/B sky130_fd_sc_hd__o2bb2a_2
X_1039_ _1039_/A _1039_/B _1039_/C vssd1 vssd1 vccd1 vccd1 _1044_/A sky130_fd_sc_hd__and3_2
XFILLER_21_153 vssd1 vccd1 vssd1 vccd1 sky130_ef_sc_hd__decap_40_12
XPHY_EDGE_ROW_10_Left_70 vssd1 vssd1 vccd1 vccd1 sky130_fd_sc_hd__decap_3
XTAP_TAPCELL_ROW_8_179 vssd1 vccd1 sky130_fd_sc_hd__tapvpwrvgnd_1
XTAP_TAPCELL_ROW_59_513 vssd1 vccd1 sky130_fd_sc_hd__tapvpwrvgnd_1
XFILLER_16_50 vssd1 vssd1 vccd1 vccd1 sky130_fd_sc_hd__fill_1
XFILLER_16_72 vssd1 vssd1 vccd1 vccd1 sky130_fd_sc_hd__fill_2
XFILLER_16_83 vssd1 vssd1 vccd1 vccd1 sky130_fd_sc_hd__fill_1
XTAP_TAPCELL_ROW_42_402 vssd1 vccd1 sky130_fd_sc_hd__tapvpwrvgnd_1
XFILLER_32_82 vssd1 vssd1 vccd1 vccd1 sky130_fd_sc_hd__fill_2
XFILLER_4_363 vssd1 vssd1 vccd1 vccd1 sky130_fd_sc_hd__fill_1
X_1390_ _1427_/B _1438_/C vssd1 vssd1 vccd1 vccd1 _1426_/A sky130_fd_sc_hd__nand2_2
XANTENNA__1471__RESET_B wire142/X vssd1 vssd1 vccd1 vccd1 sky130_fd_sc_hd__diode_2
XFILLER_35_234 vssd1 vssd1 vccd1 vccd1 sky130_fd_sc_hd__fill_8
XFILLER_35_245 vssd1 vccd1 vssd1 vccd1 sky130_ef_sc_hd__decap_40_12
XFILLER_35_289 vssd1 vssd1 vccd1 vccd1 sky130_fd_sc_hd__fill_2
XFILLER_26_223 vssd1 vssd1 vccd1 vccd1 sky130_fd_sc_hd__fill_1
XFILLER_26_289 vssd1 vssd1 vccd1 vccd1 sky130_fd_sc_hd__fill_2
XFILLER_41_259 vssd1 vssd1 vccd1 vccd1 sky130_fd_sc_hd__fill_2
XFILLER_53_15 vssd1 vccd1 vssd1 vccd1 sky130_ef_sc_hd__decap_40_12
Xteam_00 vssd1 vssd1 vccd1 vccd1 team_00/HI la_data_out[0] sky130_fd_sc_hd__conb_1
XFILLER_5_105 vssd1 vssd1 vccd1 vccd1 sky130_fd_sc_hd__fill_4
XFILLER_5_149 vssd1 vccd1 vssd1 vccd1 sky130_ef_sc_hd__decap_40_12
XFILLER_1_333 vssd1 vssd1 vccd1 vccd1 sky130_fd_sc_hd__fill_2
XFILLER_49_337 vssd1 vssd1 vccd1 vccd1 sky130_fd_sc_hd__fill_8
XFILLER_27_93 vssd1 vssd1 vccd1 vccd1 sky130_fd_sc_hd__fill_2
Xclkbuf_2_0__f_clk clkbuf_0_clk/X vssd1 vssd1 vccd1 vccd1 _1463_/CLK sky130_fd_sc_hd__clkbuf_16
XFILLER_43_70 vssd1 vssd1 vccd1 vccd1 sky130_fd_sc_hd__fill_2
X_0890_ _0890_/A _0890_/B vssd1 vssd1 vccd1 vccd1 _0893_/B sky130_fd_sc_hd__xor2_2
XFILLER_4_193 vssd1 vssd1 vccd1 vccd1 sky130_fd_sc_hd__fill_2
X_1442_ _1478_/Q _1442_/B _1442_/C vssd1 vssd1 vccd1 vccd1 _1442_/X sky130_fd_sc_hd__and3_2
X_1511_ _1541_/A vssd1 vssd1 vccd1 vccd1 _1511_/X sky130_fd_sc_hd__buf_2
XTAP_TAPCELL_ROW_10_195 vssd1 vccd1 sky130_fd_sc_hd__tapvpwrvgnd_1
XFILLER_4_53 vssd1 vccd1 vssd1 vccd1 sky130_ef_sc_hd__decap_40_12
XFILLER_4_97 vssd1 vccd1 vssd1 vccd1 sky130_ef_sc_hd__decap_40_12
XFILLER_55_329 vssd1 vssd1 vccd1 vccd1 sky130_fd_sc_hd__fill_4
X_1373_ _1353_/A _1458_/D _1345_/X _1371_/Y _1372_/Y vssd1 vssd1 vccd1 vccd1 _1378_/C
+ sky130_fd_sc_hd__o2111ai_2
XFILLER_31_281 vssd1 vssd1 vccd1 vccd1 sky130_fd_sc_hd__fill_4
XFILLER_58_189 vssd1 vssd1 vccd1 vccd1 sky130_fd_sc_hd__fill_4
XFILLER_14_226 vssd1 vssd1 vccd1 vccd1 sky130_fd_sc_hd__fill_1
XFILLER_14_259 vssd1 vssd1 vccd1 vccd1 sky130_fd_sc_hd__fill_1
Xfanout96 _1133_/X vssd1 vssd1 vccd1 vccd1 _1327_/C sky130_fd_sc_hd__clkdlybuf4s25_1
XTAP_TAPCELL_ROW_24_287 vssd1 vccd1 sky130_fd_sc_hd__tapvpwrvgnd_1
XFILLER_49_167 vssd1 vssd1 vccd1 vccd1 sky130_fd_sc_hd__fill_1
XFILLER_13_281 vssd1 vssd1 vccd1 vccd1 sky130_fd_sc_hd__fill_1
X_0942_ input9/X _0942_/B vssd1 vssd1 vccd1 vccd1 _0943_/B sky130_fd_sc_hd__xor2_2
X_0873_ _0874_/A _0874_/B vssd1 vssd1 vccd1 vccd1 _0873_/Y sky130_fd_sc_hd__nand2_2
X_1425_ _1425_/A _1425_/B vssd1 vssd1 vccd1 vccd1 _1436_/B sky130_fd_sc_hd__or2_2
XFILLER_28_318 vssd1 vccd1 vssd1 vccd1 sky130_ef_sc_hd__decap_40_12
XFILLER_55_137 vssd1 vccd1 vssd1 vccd1 sky130_ef_sc_hd__decap_40_12
X_1356_ _1077_/B _1462_/D _1270_/A _1069_/B _1355_/X vssd1 vssd1 vccd1 vccd1 _1357_/C
+ sky130_fd_sc_hd__a221o_2
X_1287_ _1468_/Q _1287_/B vssd1 vssd1 vccd1 vccd1 _1288_/C sky130_fd_sc_hd__nor2_2
XTAP_TAPCELL_ROW_38_379 vssd1 vccd1 sky130_fd_sc_hd__tapvpwrvgnd_1
XFILLER_34_39 vssd1 vssd1 vccd1 vccd1 sky130_fd_sc_hd__fill_2
XANTENNA__1219__B _1285_/C vssd1 vssd1 vccd1 vccd1 sky130_fd_sc_hd__diode_2
XFILLER_50_27 vssd1 vssd1 vccd1 vccd1 sky130_fd_sc_hd__fill_1
XFILLER_50_49 vssd1 vssd1 vccd1 vccd1 sky130_fd_sc_hd__fill_4
XTAP_TAPCELL_ROW_21_268 vssd1 vccd1 sky130_fd_sc_hd__tapvpwrvgnd_1
XANTENNA__1332__A1 _1332_/A1 vssd1 vssd1 vccd1 vccd1 sky130_fd_sc_hd__diode_2
XFILLER_19_329 vssd1 vssd1 vccd1 vccd1 sky130_fd_sc_hd__fill_4
XFILLER_59_69 vssd1 vccd1 vssd1 vccd1 sky130_ef_sc_hd__decap_40_12
XFILLER_42_321 vssd1 vssd1 vccd1 vccd1 sky130_fd_sc_hd__fill_8
XFILLER_46_126 vssd1 vccd1 vssd1 vccd1 sky130_ef_sc_hd__decap_40_12
XFILLER_10_251 vssd1 vssd1 vccd1 vccd1 sky130_fd_sc_hd__fill_1
XFILLER_10_273 vssd1 vccd1 vssd1 vccd1 sky130_ef_sc_hd__decap_40_12
XFILLER_6_244 vssd1 vssd1 vccd1 vccd1 sky130_fd_sc_hd__fill_8
XFILLER_6_277 vssd1 vccd1 vssd1 vccd1 sky130_ef_sc_hd__decap_40_12
XFILLER_37_137 vssd1 vssd1 vccd1 vccd1 sky130_fd_sc_hd__fill_8
X_1210_ _1458_/Q _1210_/B vssd1 vssd1 vccd1 vccd1 _1211_/B sky130_fd_sc_hd__xnor2_2
X_1141_ _1140_/B _1139_/X _1140_/Y _1313_/B1 vssd1 vssd1 vccd1 vccd1 _1142_/A sky130_fd_sc_hd__a211o_2
X_1072_ _1072_/A _1072_/B vssd1 vssd1 vccd1 vccd1 _1375_/A sky130_fd_sc_hd__xnor2_2
X_0925_ _0915_/B _0924_/Y _0915_/Y vssd1 vssd1 vccd1 vccd1 _0937_/A sky130_fd_sc_hd__a21oi_2
X_0856_ _0758_/A _0756_/Y _0755_/Y vssd1 vssd1 vccd1 vccd1 _0868_/A sky130_fd_sc_hd__a21o_2
X_0787_ _0774_/C _0790_/B vssd1 vssd1 vccd1 vccd1 _0788_/B sky130_fd_sc_hd__and2b_2
X_1408_ _1418_/A _1431_/B _1422_/D vssd1 vssd1 vccd1 vccd1 _1408_/X sky130_fd_sc_hd__and3b_2
XFILLER_36_170 vssd1 vssd1 vccd1 vccd1 sky130_fd_sc_hd__fill_4
X_1339_ _1339_/A _1439_/B vssd1 vssd1 vccd1 vccd1 _1340_/C sky130_fd_sc_hd__nand2_2
XFILLER_24_365 vssd1 vssd1 vccd1 vccd1 sky130_fd_sc_hd__fill_2
XFILLER_10_41 vssd1 vccd1 vssd1 vccd1 sky130_ef_sc_hd__decap_40_12
XFILLER_10_85 vssd1 vssd1 vccd1 vccd1 sky130_fd_sc_hd__fill_2
XFILLER_3_225 vssd1 vccd1 vssd1 vccd1 sky130_ef_sc_hd__decap_40_12
XFILLER_19_137 vssd1 vssd1 vccd1 vccd1 sky130_fd_sc_hd__fill_4
XFILLER_59_251 vssd1 vssd1 vccd1 vccd1 sky130_fd_sc_hd__fill_1
XFILLER_15_321 vssd1 vccd1 vssd1 vccd1 sky130_ef_sc_hd__decap_40_12
XFILLER_27_192 vssd1 vssd1 vccd1 vccd1 sky130_fd_sc_hd__fill_1
XFILLER_30_302 vssd1 vssd1 vccd1 vccd1 sky130_fd_sc_hd__fill_4
XFILLER_51_81 vssd1 vccd1 vssd1 vccd1 sky130_ef_sc_hd__decap_40_12
X_0710_ _1478_/Q _1381_/A _1443_/Q _1341_/B vssd1 vssd1 vccd1 vccd1 _0710_/Y sky130_fd_sc_hd__nand4_2
XFILLER_25_3 vssd1 vssd1 vccd1 vccd1 sky130_fd_sc_hd__fill_1
X_1124_ _1133_/C _1120_/X _1121_/X _1123_/X vssd1 vssd1 vccd1 vccd1 _1124_/X sky130_fd_sc_hd__o211a_2
X_1055_ _1055_/A _1055_/B _1055_/C vssd1 vssd1 vccd1 vccd1 _1059_/C sky130_fd_sc_hd__nand3_2
XTAP_TAPCELL_ROW_48_441 vssd1 vccd1 sky130_fd_sc_hd__tapvpwrvgnd_1
XFILLER_21_335 vssd1 vssd1 vccd1 vccd1 sky130_fd_sc_hd__fill_1
XFILLER_31_29 vssd1 vccd1 vssd1 vccd1 sky130_ef_sc_hd__decap_40_12
XFILLER_33_151 vssd1 vssd1 vccd1 vccd1 sky130_fd_sc_hd__fill_2
XTAP_TAPCELL_ROW_31_330 vssd1 vccd1 sky130_fd_sc_hd__tapvpwrvgnd_1
Xoutput29 _1527_/X vssd1 vssd1 vccd1 vccd1 gpio_oeb[16] sky130_fd_sc_hd__clkdlybuf4s25_1
X_0908_ _0919_/A input9/X _0942_/B _0943_/A vssd1 vssd1 vccd1 vccd1 _0909_/B sky130_fd_sc_hd__a31o_2
X_0839_ _0845_/A _0845_/B _0791_/Y _0801_/X vssd1 vssd1 vccd1 vccd1 _0998_/B sky130_fd_sc_hd__a211o_2
XFILLER_56_15 vssd1 vccd1 vssd1 vccd1 sky130_ef_sc_hd__decap_40_12
XFILLER_56_221 vssd1 vccd1 vssd1 vccd1 sky130_ef_sc_hd__decap_40_12
XFILLER_56_265 vssd1 vccd1 vssd1 vccd1 sky130_ef_sc_hd__decap_40_12
XTAP_TAPCELL_ROW_54_477 vssd1 vccd1 sky130_fd_sc_hd__tapvpwrvgnd_1
XFILLER_12_357 vssd1 vssd1 vccd1 vccd1 sky130_fd_sc_hd__fill_2
XFILLER_21_73 vssd1 vssd1 vccd1 vccd1 sky130_fd_sc_hd__fill_1
XFILLER_47_243 vssd1 vccd1 vssd1 vccd1 sky130_ef_sc_hd__decap_40_12
XTAP_TAPCELL_ROW_45_422 vssd1 vccd1 sky130_fd_sc_hd__tapvpwrvgnd_1
XFILLER_15_173 vssd1 vssd1 vccd1 vccd1 sky130_fd_sc_hd__fill_2
XFILLER_30_132 vssd1 vssd1 vccd1 vccd1 sky130_fd_sc_hd__fill_8
XANTENNA__1214__B1 _1320_/C1 vssd1 vssd1 vccd1 vccd1 sky130_fd_sc_hd__diode_2
XFILLER_7_361 vssd1 vccd1 vssd1 vccd1 sky130_ef_sc_hd__decap_40_12
XFILLER_53_279 vssd1 vssd1 vccd1 vccd1 sky130_fd_sc_hd__fill_1
X_1107_ _1348_/A _1450_/Q _1449_/Q _0729_/A vssd1 vssd1 vccd1 vccd1 _1107_/Y sky130_fd_sc_hd__o211ai_2
X_1038_ _1039_/B _1039_/C vssd1 vssd1 vccd1 vccd1 _1038_/Y sky130_fd_sc_hd__nand2_2
XPHY_EDGE_ROW_5_Right_5 vssd1 vssd1 vccd1 vccd1 sky130_fd_sc_hd__decap_3
XFILLER_21_165 vssd1 vssd1 vccd1 vccd1 sky130_fd_sc_hd__fill_2
XTAP_TAPCELL_ROW_51_458 vssd1 vccd1 sky130_fd_sc_hd__tapvpwrvgnd_1
XANTENNA__1141__C1 _1313_/B1 vssd1 vssd1 vccd1 vccd1 sky130_fd_sc_hd__diode_2
XFILLER_29_221 vssd1 vssd1 vccd1 vccd1 sky130_fd_sc_hd__fill_2
XTAP_TAPCELL_ROW_59_514 vssd1 vccd1 sky130_fd_sc_hd__tapvpwrvgnd_1
XFILLER_12_110 vssd1 vccd1 vssd1 vccd1 sky130_ef_sc_hd__decap_40_12
XFILLER_12_154 vssd1 vssd1 vccd1 vccd1 sky130_fd_sc_hd__fill_4
XFILLER_44_257 vssd1 vssd1 vccd1 vccd1 sky130_fd_sc_hd__fill_1
XTAP_TAPCELL_ROW_42_403 vssd1 vccd1 sky130_fd_sc_hd__tapvpwrvgnd_1
XANTENNA__1137__B _1205_/B vssd1 vssd1 vccd1 vccd1 sky130_fd_sc_hd__diode_2
XFILLER_8_169 vssd1 vssd1 vccd1 vccd1 sky130_fd_sc_hd__fill_1
XFILLER_35_257 vssd1 vssd1 vccd1 vccd1 sky130_fd_sc_hd__fill_2
XFILLER_35_279 vssd1 vssd1 vccd1 vccd1 sky130_fd_sc_hd__fill_1
XFILLER_50_249 vssd1 vssd1 vccd1 vccd1 sky130_fd_sc_hd__fill_2
XANTENNA__1199__C1 _0902_/A vssd1 vssd1 vccd1 vccd1 sky130_fd_sc_hd__diode_2
XFILLER_58_305 vssd1 vssd1 vccd1 vccd1 sky130_fd_sc_hd__fill_2
XFILLER_7_191 vssd1 vssd1 vccd1 vccd1 sky130_fd_sc_hd__fill_1
XFILLER_53_27 vssd1 vccd1 vssd1 vccd1 sky130_ef_sc_hd__decap_40_12
XANTENNA__1451__CLK _1463_/CLK vssd1 vssd1 vccd1 vccd1 sky130_fd_sc_hd__diode_2
XFILLER_49_305 vssd1 vccd1 vssd1 vccd1 sky130_ef_sc_hd__decap_40_12
XANTENNA_input12_A prescaler[1] vssd1 vssd1 vccd1 vccd1 sky130_fd_sc_hd__diode_2
XFILLER_17_279 vssd1 vssd1 vccd1 vccd1 sky130_fd_sc_hd__fill_1
XFILLER_32_205 vssd1 vccd1 vssd1 vccd1 sky130_ef_sc_hd__decap_40_12
XFILLER_4_65 vssd1 vccd1 vssd1 vccd1 sky130_ef_sc_hd__decap_40_12
X_1441_ _1477_/Q _1435_/A input1/X _1441_/D vssd1 vssd1 vccd1 vccd1 _1441_/X sky130_fd_sc_hd__and4bb_2
XTAP_TAPCELL_ROW_10_196 vssd1 vccd1 sky130_fd_sc_hd__tapvpwrvgnd_1
X_1372_ _1372_/A _1454_/D vssd1 vssd1 vccd1 vccd1 _1372_/Y sky130_fd_sc_hd__nand2_2
XFILLER_31_271 vssd1 vssd1 vccd1 vccd1 sky130_fd_sc_hd__fill_1
XFILLER_2_109 vssd1 vccd1 vssd1 vccd1 sky130_ef_sc_hd__decap_40_12
XANTENNA_input4_A la_oenb[0] vssd1 vssd1 vccd1 vccd1 sky130_fd_sc_hd__diode_2
XFILLER_54_363 vssd1 vssd1 vccd1 vccd1 sky130_fd_sc_hd__fill_1
XFILLER_13_41 vssd1 vssd1 vccd1 vccd1 sky130_fd_sc_hd__fill_2
XFILLER_22_271 vssd1 vssd1 vccd1 vccd1 sky130_fd_sc_hd__fill_4
XFILLER_22_282 vssd1 vssd1 vccd1 vccd1 sky130_fd_sc_hd__fill_4
Xfanout97 _1127_/Y vssd1 vssd1 vccd1 vccd1 _1307_/B1 sky130_fd_sc_hd__clkdlybuf4s25_1
XTAP_TAPCELL_ROW_24_288 vssd1 vccd1 sky130_fd_sc_hd__tapvpwrvgnd_1
XFILLER_38_93 vssd1 vssd1 vccd1 vccd1 sky130_fd_sc_hd__fill_1
XFILLER_49_113 vssd1 vccd1 vssd1 vccd1 sky130_ef_sc_hd__decap_40_12
XFILLER_54_81 vssd1 vssd1 vccd1 vccd1 sky130_fd_sc_hd__fill_2
X_0941_ _0941_/A _0941_/B vssd1 vssd1 vccd1 vccd1 _0946_/A sky130_fd_sc_hd__xnor2_2
XFILLER_55_3 vssd1 vccd1 vssd1 vccd1 sky130_ef_sc_hd__decap_40_12
XFILLER_9_264 vssd1 vssd1 vccd1 vccd1 sky130_fd_sc_hd__fill_8
X_0872_ _0874_/A _0874_/B vssd1 vssd1 vccd1 vccd1 _0872_/Y sky130_fd_sc_hd__nor2_2
XANTENNA__1326__C1 _0715_/B vssd1 vssd1 vccd1 vccd1 sky130_fd_sc_hd__diode_2
X_1355_ _1058_/B _1466_/D _1464_/D _1068_/B vssd1 vssd1 vccd1 vccd1 _1355_/X sky130_fd_sc_hd__a2bb2o_2
X_1424_ _1425_/A _1425_/B vssd1 vssd1 vccd1 vccd1 _1438_/D sky130_fd_sc_hd__nor2_2
XFILLER_55_105 vssd1 vssd1 vccd1 vccd1 sky130_fd_sc_hd__fill_4
XFILLER_55_149 vssd1 vccd1 vssd1 vccd1 sky130_ef_sc_hd__decap_40_12
X_1286_ _1468_/Q _1287_/B vssd1 vssd1 vccd1 vccd1 _1299_/C sky130_fd_sc_hd__and2_2
XFILLER_34_29 vssd1 vssd1 vccd1 vccd1 sky130_fd_sc_hd__fill_1
XFILLER_51_333 vssd1 vssd1 vccd1 vccd1 sky130_fd_sc_hd__fill_2
XFILLER_59_15 vssd1 vccd1 vssd1 vccd1 sky130_ef_sc_hd__decap_40_12
XANTENNA_input7_X input7/X vssd1 vssd1 vccd1 vccd1 sky130_fd_sc_hd__diode_2
XFILLER_46_138 vssd1 vssd1 vccd1 vccd1 sky130_fd_sc_hd__fill_2
XFILLER_39_190 vssd1 vssd1 vccd1 vccd1 sky130_fd_sc_hd__fill_8
XFILLER_54_193 vssd1 vssd1 vccd1 vccd1 sky130_fd_sc_hd__fill_2
XFILLER_10_230 vssd1 vssd1 vccd1 vccd1 sky130_fd_sc_hd__fill_1
XFILLER_10_285 vssd1 vccd1 vssd1 vccd1 sky130_ef_sc_hd__decap_40_12
XFILLER_40_83 vssd1 vssd1 vccd1 vccd1 sky130_fd_sc_hd__fill_1
XFILLER_6_289 vssd1 vccd1 vssd1 vccd1 sky130_ef_sc_hd__decap_40_12
XFILLER_1_55 vssd1 vssd1 vccd1 vccd1 sky130_fd_sc_hd__fill_1
X_1140_ _1448_/Q _1140_/B vssd1 vssd1 vccd1 vccd1 _1140_/Y sky130_fd_sc_hd__nor2_2
X_1071_ _0997_/C _0900_/B _0999_/A vssd1 vssd1 vccd1 vccd1 _1072_/B sky130_fd_sc_hd__a21boi_2
XFILLER_33_355 vssd1 vssd1 vccd1 vccd1 sky130_fd_sc_hd__fill_4
X_0924_ _0924_/A _0927_/A vssd1 vssd1 vccd1 vccd1 _0924_/Y sky130_fd_sc_hd__xnor2_2
X_0855_ _0943_/A _0763_/B _0761_/Y vssd1 vssd1 vccd1 vccd1 _0874_/A sky130_fd_sc_hd__a21oi_2
X_0786_ _0799_/A _0786_/B vssd1 vssd1 vccd1 vccd1 _0790_/B sky130_fd_sc_hd__nand2b_2
XFILLER_29_29 vssd1 vssd1 vccd1 vccd1 sky130_fd_sc_hd__fill_1
X_1338_ _1438_/A _1339_/A _1431_/B _1477_/Q vssd1 vssd1 vccd1 vccd1 _1340_/B sky130_fd_sc_hd__a31o_2
X_1407_ _1417_/A _1430_/A vssd1 vssd1 vccd1 vccd1 _1407_/Y sky130_fd_sc_hd__nor2_2
X_1269_ _1269_/A _1269_/B vssd1 vssd1 vccd1 vccd1 _1270_/A sky130_fd_sc_hd__or2_2
XTAP_TAPCELL_ROW_34_350 vssd1 vccd1 sky130_fd_sc_hd__tapvpwrvgnd_1
XFILLER_10_53 vssd1 vssd1 vccd1 vccd1 sky130_fd_sc_hd__fill_4
XFILLER_10_97 vssd1 vccd1 vssd1 vccd1 sky130_ef_sc_hd__decap_40_12
XFILLER_3_237 vssd1 vccd1 vssd1 vccd1 sky130_ef_sc_hd__decap_40_12
XFILLER_27_171 vssd1 vssd1 vccd1 vccd1 sky130_fd_sc_hd__fill_1
XFILLER_15_333 vssd1 vssd1 vccd1 vccd1 sky130_fd_sc_hd__fill_2
XFILLER_35_50 vssd1 vssd1 vccd1 vccd1 sky130_fd_sc_hd__fill_4
XFILLER_42_141 vssd1 vssd1 vccd1 vccd1 sky130_fd_sc_hd__fill_4
XTAP_TAPCELL_ROW_57_497 vssd1 vccd1 sky130_fd_sc_hd__tapvpwrvgnd_1
XFILLER_51_93 vssd1 vccd1 vssd1 vccd1 sky130_ef_sc_hd__decap_40_12
XTAP_TAPCELL_ROW_40_386 vssd1 vccd1 sky130_fd_sc_hd__tapvpwrvgnd_1
X_1123_ _1064_/X _1122_/X _1070_/A _1070_/B vssd1 vssd1 vccd1 vccd1 _1123_/X sky130_fd_sc_hd__a211o_2
X_1054_ _1052_/A _1052_/B _1467_/Q vssd1 vssd1 vccd1 vccd1 _1054_/X sky130_fd_sc_hd__a21bo_2
XTAP_TAPCELL_ROW_48_442 vssd1 vccd1 sky130_fd_sc_hd__tapvpwrvgnd_1
X_0907_ _0912_/A _0929_/A vssd1 vssd1 vccd1 vccd1 _0919_/B sky130_fd_sc_hd__or2_2
XTAP_TAPCELL_ROW_31_331 vssd1 vccd1 sky130_fd_sc_hd__tapvpwrvgnd_1
X_0838_ _0838_/A _0838_/B _0838_/C vssd1 vssd1 vccd1 vccd1 _0998_/A sky130_fd_sc_hd__nand3_2
X_0769_ _1366_/A _0783_/A vssd1 vssd1 vccd1 vccd1 _0781_/B sky130_fd_sc_hd__xor2_2
XFILLER_56_233 vssd1 vccd1 vssd1 vccd1 sky130_ef_sc_hd__decap_40_12
XFILLER_56_27 vssd1 vssd1 vccd1 vccd1 sky130_fd_sc_hd__fill_1
XFILLER_56_277 vssd1 vccd1 vssd1 vccd1 sky130_ef_sc_hd__decap_40_12
XFILLER_24_141 vssd1 vssd1 vccd1 vccd1 sky130_fd_sc_hd__fill_4
XFILLER_8_307 vssd1 vssd1 vccd1 vccd1 sky130_fd_sc_hd__fill_1
XTAP_TAPCELL_ROW_54_478 vssd1 vccd1 sky130_fd_sc_hd__tapvpwrvgnd_1
XFILLER_47_200 vssd1 vssd1 vccd1 vccd1 sky130_fd_sc_hd__fill_4
XFILLER_46_82 vssd1 vssd1 vccd1 vccd1 sky130_fd_sc_hd__fill_2
XFILLER_47_255 vssd1 vccd1 vssd1 vccd1 sky130_ef_sc_hd__decap_40_12
XTAP_TAPCELL_ROW_45_423 vssd1 vccd1 sky130_fd_sc_hd__tapvpwrvgnd_1
XFILLER_15_185 vssd1 vccd1 vssd1 vccd1 sky130_ef_sc_hd__decap_40_12
XFILLER_7_373 vssd1 vssd1 vccd1 vccd1 sky130_fd_sc_hd__fill_2
X_1106_ _0767_/A _1451_/Q _1103_/Y _1105_/X vssd1 vssd1 vccd1 vccd1 _1109_/A sky130_fd_sc_hd__o211a_2
XFILLER_42_29 vssd1 vssd1 vccd1 vccd1 sky130_fd_sc_hd__fill_1
XFILLER_53_225 vssd1 vccd1 vssd1 vccd1 sky130_ef_sc_hd__decap_40_12
X_1037_ _1037_/A _1037_/B _1037_/C vssd1 vssd1 vccd1 vccd1 _1039_/C sky130_fd_sc_hd__nand3_2
XTAP_TAPCELL_ROW_51_459 vssd1 vccd1 sky130_fd_sc_hd__tapvpwrvgnd_1
XFILLER_21_188 vssd1 vssd1 vccd1 vccd1 sky130_fd_sc_hd__fill_1
XANTENNA__0716__B1 _1313_/B1 vssd1 vssd1 vccd1 vccd1 sky130_fd_sc_hd__diode_2
XTAP_TAPCELL_ROW_59_515 vssd1 vccd1 sky130_fd_sc_hd__tapvpwrvgnd_1
XFILLER_16_41 vssd1 vssd1 vccd1 vccd1 sky130_fd_sc_hd__fill_2
XFILLER_29_244 vssd1 vssd1 vccd1 vccd1 sky130_fd_sc_hd__fill_8
XFILLER_29_266 vssd1 vssd1 vccd1 vccd1 sky130_fd_sc_hd__fill_1
XPHY_EDGE_ROW_48_Left_108 vssd1 vssd1 vccd1 vccd1 sky130_fd_sc_hd__decap_3
XFILLER_12_122 vssd1 vssd1 vccd1 vccd1 sky130_fd_sc_hd__fill_1
XFILLER_8_137 vssd1 vssd1 vccd1 vccd1 sky130_fd_sc_hd__fill_2
XTAP_TAPCELL_ROW_42_404 vssd1 vccd1 sky130_fd_sc_hd__tapvpwrvgnd_1
XPHY_EDGE_ROW_57_Left_117 vssd1 vssd1 vccd1 vccd1 sky130_fd_sc_hd__decap_3
XPHY_EDGE_ROW_11_Right_11 vssd1 vssd1 vccd1 vccd1 sky130_fd_sc_hd__decap_3
XFILLER_4_321 vssd1 vccd1 vssd1 vccd1 sky130_ef_sc_hd__decap_40_12
XFILLER_4_365 vssd1 vssd1 vccd1 vccd1 sky130_fd_sc_hd__fill_8
XPHY_EDGE_ROW_20_Right_20 vssd1 vssd1 vccd1 vccd1 sky130_fd_sc_hd__decap_3
XFILLER_57_81 vssd1 vccd1 vssd1 vccd1 sky130_ef_sc_hd__decap_40_12
XFILLER_35_269 vssd1 vssd1 vccd1 vccd1 sky130_fd_sc_hd__fill_2
XFILLER_26_269 vssd1 vssd1 vccd1 vccd1 sky130_fd_sc_hd__fill_1
XFILLER_53_39 vssd1 vccd1 vssd1 vccd1 sky130_ef_sc_hd__decap_40_12
XFILLER_17_203 vssd1 vssd1 vccd1 vccd1 sky130_fd_sc_hd__fill_2
XFILLER_1_335 vssd1 vssd1 vccd1 vccd1 sky130_fd_sc_hd__fill_1
XFILLER_49_317 vssd1 vccd1 vssd1 vccd1 sky130_ef_sc_hd__decap_40_12
XFILLER_57_361 vssd1 vssd1 vccd1 vccd1 sky130_fd_sc_hd__fill_8
XFILLER_17_225 vssd1 vssd1 vccd1 vccd1 sky130_fd_sc_hd__fill_4
XFILLER_32_217 vssd1 vccd1 vssd1 vccd1 sky130_ef_sc_hd__decap_40_12
XFILLER_4_195 vssd1 vssd1 vccd1 vccd1 sky130_fd_sc_hd__fill_1
XFILLER_4_77 vssd1 vssd1 vccd1 vccd1 sky130_fd_sc_hd__fill_4
X_1371_ _1038_/Y _1297_/A _1297_/B _1354_/B _1354_/A vssd1 vssd1 vccd1 vccd1 _1371_/Y
+ sky130_fd_sc_hd__a32oi_2
X_1440_ _1477_/Q _1416_/B _1440_/C _1442_/C vssd1 vssd1 vccd1 vccd1 _1440_/X sky130_fd_sc_hd__and4bb_2
XTAP_TAPCELL_ROW_10_197 vssd1 vccd1 sky130_fd_sc_hd__tapvpwrvgnd_1
Xfanout98 _1127_/Y vssd1 vssd1 vccd1 vccd1 _1206_/B1 sky130_fd_sc_hd__clkdlybuf4s25_1
XANTENNA_fanout95_X _1285_/C vssd1 vssd1 vccd1 vccd1 sky130_fd_sc_hd__diode_2
XFILLER_1_165 vssd1 vssd1 vccd1 vccd1 sky130_fd_sc_hd__fill_2
XFILLER_38_50 vssd1 vssd1 vccd1 vccd1 sky130_fd_sc_hd__fill_1
XFILLER_49_125 vssd1 vccd1 vssd1 vccd1 sky130_ef_sc_hd__decap_40_12
XFILLER_49_169 vssd1 vccd1 vssd1 vccd1 sky130_ef_sc_hd__decap_40_12
X_0940_ _0940_/A _0940_/B vssd1 vssd1 vccd1 vccd1 _0973_/A sky130_fd_sc_hd__or2_2
X_0871_ _0913_/A _0871_/B vssd1 vssd1 vccd1 vccd1 _0874_/B sky130_fd_sc_hd__xnor2_2
X_1354_ _1354_/A _1354_/B vssd1 vssd1 vccd1 vccd1 _1354_/Y sky130_fd_sc_hd__nor2_2
X_1423_ _1440_/C _1420_/X _1441_/D _1422_/D vssd1 vssd1 vccd1 vccd1 _1423_/X sky130_fd_sc_hd__o211a_2
X_1285_ _1468_/Q _1288_/A _1285_/C vssd1 vssd1 vccd1 vccd1 _1285_/X sky130_fd_sc_hd__and3_2
XFILLER_34_19 vssd1 vssd1 vccd1 vccd1 sky130_fd_sc_hd__fill_2
XFILLER_11_209 vssd1 vccd1 vssd1 vccd1 sky130_ef_sc_hd__decap_40_12
XFILLER_50_29 vssd1 vssd1 vccd1 vccd1 sky130_fd_sc_hd__fill_2
XFILLER_59_27 vssd1 vssd1 vccd1 vccd1 sky130_fd_sc_hd__fill_1
XTAP_TAPCELL_ROW_29_315 vssd1 vccd1 sky130_fd_sc_hd__tapvpwrvgnd_1
XTAP_TAPCELL_ROW_37_370 vssd1 vccd1 sky130_fd_sc_hd__tapvpwrvgnd_1
XTAP_TAPCELL_ROW_12_204 vssd1 vccd1 sky130_fd_sc_hd__tapvpwrvgnd_1
XFILLER_10_297 vssd1 vssd1 vccd1 vccd1 sky130_fd_sc_hd__fill_8
XFILLER_40_95 vssd1 vccd1 vssd1 vccd1 sky130_ef_sc_hd__decap_40_12
XFILLER_49_93 vssd1 vssd1 vccd1 vccd1 sky130_fd_sc_hd__fill_4
XFILLER_33_334 vssd1 vssd1 vccd1 vccd1 sky130_fd_sc_hd__fill_2
XFILLER_52_109 vssd1 vccd1 vssd1 vccd1 sky130_ef_sc_hd__decap_40_12
X_1070_ _1070_/A _1070_/B _1070_/C _1070_/D vssd1 vssd1 vccd1 vccd1 _1133_/C sky130_fd_sc_hd__or4_2
XANTENNA__1244__C1 _1303_/C1 vssd1 vssd1 vccd1 vccd1 sky130_fd_sc_hd__diode_2
XANTENNA__1464__CLK _1471_/CLK vssd1 vssd1 vccd1 vccd1 sky130_fd_sc_hd__diode_2
X_0923_ _1018_/A vssd1 vssd1 vccd1 vccd1 _0923_/Y sky130_fd_sc_hd__inv_2
X_0854_ _1353_/A _0854_/B _0854_/C vssd1 vssd1 vccd1 vccd1 _0901_/C sky130_fd_sc_hd__and3_2
X_0785_ _0793_/A _0793_/B vssd1 vssd1 vccd1 vccd1 _0786_/B sky130_fd_sc_hd__and2b_2
XPHY_EDGE_ROW_49_Right_49 vssd1 vssd1 vccd1 vccd1 sky130_fd_sc_hd__decap_3
XFILLER_28_106 vssd1 vssd1 vccd1 vccd1 sky130_fd_sc_hd__fill_2
XFILLER_28_128 vssd1 vssd1 vccd1 vccd1 sky130_fd_sc_hd__fill_4
X_1337_ _1337_/A _1337_/B vssd1 vssd1 vccd1 vccd1 _1476_/D sky130_fd_sc_hd__nor2_2
X_1406_ _1418_/A _1438_/B _1438_/C vssd1 vssd1 vccd1 vccd1 _1430_/A sky130_fd_sc_hd__nand3b_2
X_1268_ _1069_/A _1309_/B1 _1313_/B1 vssd1 vssd1 vccd1 vccd1 _1269_/B sky130_fd_sc_hd__a21o_2
XPHY_EDGE_ROW_58_Right_58 vssd1 vssd1 vccd1 vccd1 sky130_fd_sc_hd__decap_3
XFILLER_24_345 vssd1 vssd1 vccd1 vccd1 sky130_fd_sc_hd__fill_2
X_1199_ _1329_/A _1197_/Y _1198_/X _0902_/A vssd1 vssd1 vccd1 vccd1 _1199_/X sky130_fd_sc_hd__a211o_2
XTAP_TAPCELL_ROW_34_351 vssd1 vccd1 sky130_fd_sc_hd__tapvpwrvgnd_1
XFILLER_3_205 vssd1 vccd1 vssd1 vccd1 sky130_ef_sc_hd__decap_40_12
XFILLER_3_249 vssd1 vccd1 vssd1 vccd1 sky130_ef_sc_hd__decap_40_12
XFILLER_59_253 vssd1 vccd1 vssd1 vccd1 sky130_ef_sc_hd__decap_40_12
XFILLER_15_345 vssd1 vssd1 vccd1 vccd1 sky130_fd_sc_hd__fill_2
XTAP_TAPCELL_ROW_57_498 vssd1 vccd1 sky130_fd_sc_hd__tapvpwrvgnd_1
XFILLER_30_326 vssd1 vssd1 vccd1 vccd1 sky130_fd_sc_hd__fill_1
XFILLER_35_84 vssd1 vccd1 vssd1 vccd1 sky130_ef_sc_hd__decap_40_12
XFILLER_42_153 vssd1 vssd1 vccd1 vccd1 sky130_fd_sc_hd__fill_8
XFILLER_42_197 vssd1 vssd1 vccd1 vccd1 sky130_fd_sc_hd__fill_4
XTAP_TAPCELL_ROW_40_387 vssd1 vccd1 sky130_fd_sc_hd__tapvpwrvgnd_1
XPHY_EDGE_ROW_27_Left_87 vssd1 vssd1 vccd1 vccd1 sky130_fd_sc_hd__decap_3
X_1122_ _1069_/A _1069_/B _1067_/Y vssd1 vssd1 vccd1 vccd1 _1122_/X sky130_fd_sc_hd__a21o_2
XTAP_TAPCELL_ROW_48_443 vssd1 vccd1 sky130_fd_sc_hd__tapvpwrvgnd_1
XFILLER_18_194 vssd1 vssd1 vccd1 vccd1 sky130_fd_sc_hd__fill_2
XFILLER_21_337 vssd1 vssd1 vccd1 vccd1 sky130_fd_sc_hd__fill_8
XFILLER_25_109 vssd1 vssd1 vccd1 vccd1 sky130_fd_sc_hd__fill_2
XFILLER_33_186 vssd1 vssd1 vccd1 vccd1 sky130_fd_sc_hd__fill_4
X_1053_ _1048_/X _1049_/X _1467_/Q vssd1 vssd1 vccd1 vccd1 _1070_/A sky130_fd_sc_hd__a21oi_2
X_0906_ _0943_/A input9/X vssd1 vssd1 vccd1 vccd1 _0929_/A sky130_fd_sc_hd__nand2_2
X_0837_ _0845_/A _0845_/B _0801_/X vssd1 vssd1 vccd1 vccd1 _0844_/A sky130_fd_sc_hd__a21o_2
XTAP_TAPCELL_ROW_31_332 vssd1 vccd1 sky130_fd_sc_hd__tapvpwrvgnd_1
X_0768_ _1366_/A _0783_/A vssd1 vssd1 vccd1 vccd1 _0768_/X sky130_fd_sc_hd__or2_2
X_0699_ _1470_/Q vssd1 vssd1 vccd1 vccd1 _1029_/A sky130_fd_sc_hd__inv_2
XFILLER_56_245 vssd1 vssd1 vccd1 vccd1 sky130_fd_sc_hd__fill_4
XFILLER_56_289 vssd1 vccd1 vssd1 vccd1 sky130_ef_sc_hd__decap_40_12
XANTENNA__0713__X _1340_/A vssd1 vssd1 vccd1 vccd1 sky130_fd_sc_hd__diode_2
XFILLER_12_359 vssd1 vssd1 vccd1 vccd1 sky130_fd_sc_hd__fill_1
XTAP_TAPCELL_ROW_54_479 vssd1 vccd1 sky130_fd_sc_hd__tapvpwrvgnd_1
XFILLER_21_20 vssd1 vssd1 vccd1 vccd1 sky130_fd_sc_hd__fill_1
XFILLER_21_53 vssd1 vssd1 vccd1 vccd1 sky130_fd_sc_hd__fill_2
XFILLER_47_223 vssd1 vssd1 vccd1 vccd1 sky130_fd_sc_hd__fill_1
XFILLER_15_175 vssd1 vssd1 vccd1 vccd1 sky130_fd_sc_hd__fill_1
XFILLER_46_72 vssd1 vssd1 vccd1 vccd1 sky130_fd_sc_hd__fill_2
XFILLER_47_267 vssd1 vccd1 vssd1 vccd1 sky130_ef_sc_hd__decap_40_12
XTAP_TAPCELL_ROW_45_424 vssd1 vccd1 sky130_fd_sc_hd__tapvpwrvgnd_1
XFILLER_30_189 vssd1 vssd1 vccd1 vccd1 sky130_fd_sc_hd__fill_4
XFILLER_7_55 vssd1 vssd1 vccd1 vccd1 sky130_fd_sc_hd__fill_1
XFILLER_30_3 vssd1 vssd1 vccd1 vccd1 sky130_fd_sc_hd__fill_4
XFILLER_53_237 vssd1 vccd1 vssd1 vccd1 sky130_ef_sc_hd__decap_40_12
X_1105_ _1448_/Q _0771_/A _1450_/Q _1348_/A _1104_/X vssd1 vssd1 vccd1 vccd1 _1105_/X
+ sky130_fd_sc_hd__o221a_2
XFILLER_21_167 vssd1 vssd1 vccd1 vccd1 sky130_fd_sc_hd__fill_1
X_1036_ _1036_/A _1036_/B _1036_/C _1035_/B vssd1 vssd1 vccd1 vccd1 _1133_/A sky130_fd_sc_hd__or4b_2
XFILLER_29_201 vssd1 vccd1 vssd1 vccd1 sky130_ef_sc_hd__decap_40_12
XFILLER_29_223 vssd1 vssd1 vccd1 vccd1 sky130_fd_sc_hd__fill_1
XTAP_TAPCELL_ROW_59_516 vssd1 vccd1 sky130_fd_sc_hd__tapvpwrvgnd_1
XFILLER_16_64 vssd1 vssd1 vccd1 vccd1 sky130_fd_sc_hd__fill_8
XFILLER_29_278 vssd1 vssd1 vccd1 vccd1 sky130_fd_sc_hd__fill_2
XTAP_TAPCELL_ROW_42_405 vssd1 vccd1 sky130_fd_sc_hd__tapvpwrvgnd_1
XFILLER_32_41 vssd1 vssd1 vccd1 vccd1 sky130_fd_sc_hd__fill_4
XFILLER_32_74 vssd1 vssd1 vccd1 vccd1 sky130_fd_sc_hd__fill_2
XFILLER_4_333 vssd1 vccd1 vssd1 vccd1 sky130_ef_sc_hd__decap_40_12
XFILLER_35_204 vssd1 vssd1 vccd1 vccd1 sky130_fd_sc_hd__fill_2
XFILLER_57_93 vssd1 vccd1 vssd1 vccd1 sky130_ef_sc_hd__decap_40_12
XFILLER_7_171 vssd1 vccd1 vssd1 vccd1 sky130_ef_sc_hd__decap_40_12
XFILLER_37_19 vssd1 vssd1 vccd1 vccd1 sky130_fd_sc_hd__fill_2
XFILLER_58_307 vssd1 vssd1 vccd1 vccd1 sky130_fd_sc_hd__fill_1
X_1019_ _1019_/A vssd1 vssd1 vccd1 vccd1 _1023_/B sky130_fd_sc_hd__inv_2
XPHY_EDGE_ROW_14_Left_74 vssd1 vssd1 vccd1 vccd1 sky130_fd_sc_hd__decap_3
XFILLER_49_329 vssd1 vssd1 vccd1 vccd1 sky130_fd_sc_hd__fill_4
XTAP_TAPCELL_ROW_4_152 vssd1 vccd1 sky130_fd_sc_hd__tapvpwrvgnd_1
XFILLER_25_281 vssd1 vccd1 vssd1 vccd1 sky130_ef_sc_hd__decap_40_12
XFILLER_27_85 vssd1 vssd1 vccd1 vccd1 sky130_fd_sc_hd__fill_8
XFILLER_32_229 vssd1 vssd1 vccd1 vccd1 sky130_fd_sc_hd__fill_4
XFILLER_40_262 vssd1 vssd1 vccd1 vccd1 sky130_fd_sc_hd__fill_1
XFILLER_43_95 vssd1 vssd1 vccd1 vccd1 sky130_fd_sc_hd__fill_8
XFILLER_4_141 vssd1 vccd1 vssd1 vccd1 sky130_ef_sc_hd__decap_40_12
X_1370_ _1370_/A _1370_/B _1370_/C _1370_/D vssd1 vssd1 vccd1 vccd1 _1378_/B sky130_fd_sc_hd__nand4_2
XFILLER_23_229 vssd1 vssd1 vccd1 vccd1 sky130_fd_sc_hd__fill_2
XTAP_TAPCELL_ROW_18_243 vssd1 vccd1 sky130_fd_sc_hd__tapvpwrvgnd_1
XFILLER_31_295 vssd1 vssd1 vccd1 vccd1 sky130_fd_sc_hd__fill_1
XFILLER_54_321 vssd1 vccd1 vssd1 vccd1 sky130_ef_sc_hd__decap_40_12
XFILLER_58_137 vssd1 vssd1 vccd1 vccd1 sky130_fd_sc_hd__fill_2
XTAP_TAPCELL_ROW_1_133 vssd1 vccd1 sky130_fd_sc_hd__tapvpwrvgnd_1
XFILLER_54_365 vssd1 vssd1 vccd1 vccd1 sky130_fd_sc_hd__fill_4
XFILLER_13_87 vssd1 vssd1 vccd1 vccd1 sky130_fd_sc_hd__fill_1
Xfanout99 _1124_/X vssd1 vssd1 vccd1 vccd1 _1307_/A2 sky130_fd_sc_hd__clkdlybuf4s25_1
XFILLER_1_111 vssd1 vssd1 vccd1 vccd1 sky130_fd_sc_hd__fill_1
XFILLER_49_137 vssd1 vccd1 vssd1 vccd1 sky130_ef_sc_hd__decap_40_12
XFILLER_8_3 vssd1 vccd1 vssd1 vccd1 sky130_ef_sc_hd__decap_40_12
XFILLER_38_40 vssd1 vssd1 vccd1 vccd1 sky130_fd_sc_hd__fill_8
XFILLER_57_181 vssd1 vccd1 vssd1 vccd1 sky130_ef_sc_hd__decap_40_12
XFILLER_54_83 vssd1 vssd1 vccd1 vccd1 sky130_fd_sc_hd__fill_1
XFILLER_9_233 vssd1 vssd1 vccd1 vccd1 sky130_fd_sc_hd__fill_4
X_0870_ _0870_/A _0870_/B vssd1 vssd1 vccd1 vccd1 _0871_/B sky130_fd_sc_hd__xnor2_2
XTAP_TAPCELL_ROW_15_224 vssd1 vccd1 sky130_fd_sc_hd__tapvpwrvgnd_1
X_1422_ _1418_/A _1422_/B _1422_/C _1422_/D vssd1 vssd1 vccd1 vccd1 _1422_/X sky130_fd_sc_hd__and4b_2
XANTENNA__1326__A1 _1332_/A1 vssd1 vssd1 vccd1 vccd1 sky130_fd_sc_hd__diode_2
X_1353_ _1353_/A _1353_/B _1353_/C vssd1 vssd1 vccd1 vccd1 _1353_/Y sky130_fd_sc_hd__nand3_2
X_1284_ _1310_/A2 _1282_/X _1283_/Y vssd1 vssd1 vccd1 vccd1 _1467_/D sky130_fd_sc_hd__a21oi_2
XFILLER_36_321 vssd1 vssd1 vccd1 vccd1 sky130_fd_sc_hd__fill_4
XFILLER_36_365 vssd1 vssd1 vccd1 vccd1 sky130_fd_sc_hd__fill_2
XFILLER_51_335 vssd1 vssd1 vccd1 vccd1 sky130_fd_sc_hd__fill_1
X_0999_ _0999_/A _1072_/A vssd1 vssd1 vccd1 vccd1 _0999_/Y sky130_fd_sc_hd__nor2_2
XFILLER_27_321 vssd1 vccd1 vssd1 vccd1 sky130_ef_sc_hd__decap_40_12
XTAP_TAPCELL_ROW_29_316 vssd1 vccd1 sky130_fd_sc_hd__tapvpwrvgnd_1
XFILLER_24_64 vssd1 vssd1 vccd1 vccd1 sky130_fd_sc_hd__fill_1
XFILLER_24_75 vssd1 vssd1 vccd1 vccd1 sky130_fd_sc_hd__fill_2
XFILLER_24_97 vssd1 vssd1 vccd1 vccd1 sky130_fd_sc_hd__fill_2
XFILLER_42_335 vssd1 vssd1 vccd1 vccd1 sky130_fd_sc_hd__fill_2
XFILLER_54_195 vssd1 vssd1 vccd1 vccd1 sky130_fd_sc_hd__fill_1
XTAP_TAPCELL_ROW_37_371 vssd1 vccd1 sky130_fd_sc_hd__tapvpwrvgnd_1
XTAP_TAPCELL_ROW_12_205 vssd1 vccd1 sky130_fd_sc_hd__tapvpwrvgnd_1
XFILLER_40_85 vssd1 vssd1 vccd1 vccd1 sky130_fd_sc_hd__fill_4
XTAP_TAPCELL_ROW_20_260 vssd1 vccd1 sky130_fd_sc_hd__tapvpwrvgnd_1
XANTENNA_input20_X _0953_/B vssd1 vssd1 vccd1 vccd1 sky130_fd_sc_hd__diode_2
XFILLER_18_321 vssd1 vccd1 vssd1 vccd1 sky130_ef_sc_hd__decap_40_12
XFILLER_18_365 vssd1 vssd1 vccd1 vccd1 sky130_fd_sc_hd__fill_2
XFILLER_1_57 vssd1 vccd1 vssd1 vccd1 sky130_ef_sc_hd__decap_40_12
XFILLER_45_173 vssd1 vssd1 vccd1 vccd1 sky130_fd_sc_hd__fill_2
X_0922_ _0922_/A _0922_/B vssd1 vssd1 vccd1 vccd1 _1018_/A sky130_fd_sc_hd__and2_2
X_0853_ _0768_/X _0825_/B _1342_/A _0853_/D vssd1 vssd1 vccd1 vccd1 _0854_/C sky130_fd_sc_hd__and4bb_2
X_1405_ _1417_/A _1429_/A vssd1 vssd1 vccd1 vccd1 _1405_/Y sky130_fd_sc_hd__nor2_2
X_0784_ _0767_/A _0812_/B _0804_/A vssd1 vssd1 vccd1 vccd1 _0793_/B sky130_fd_sc_hd__o21ai_2
X_1336_ _1438_/A _1339_/A _1431_/B _0712_/X vssd1 vssd1 vccd1 vccd1 _1337_/B sky130_fd_sc_hd__a31o_2
Xinput1 en vssd1 vssd1 vccd1 vccd1 input1/X sky130_fd_sc_hd__clkdlybuf4s25_1
X_1267_ _1330_/B1 _1266_/X _1332_/A1 vssd1 vssd1 vccd1 vccd1 _1269_/A sky130_fd_sc_hd__a21oi_2
X_1198_ _1206_/A1 _1206_/A2 _1206_/B1 _1196_/X vssd1 vssd1 vccd1 vccd1 _1198_/X sky130_fd_sc_hd__o211a_2
XFILLER_51_165 vssd1 vssd1 vccd1 vccd1 sky130_fd_sc_hd__fill_2
XTAP_TAPCELL_ROW_34_352 vssd1 vccd1 sky130_fd_sc_hd__tapvpwrvgnd_1
XANTENNA__1250__A3 _1285_/C vssd1 vssd1 vccd1 vccd1 sky130_fd_sc_hd__diode_2
XFILLER_3_217 vssd1 vssd1 vccd1 vccd1 sky130_fd_sc_hd__fill_4
XFILLER_19_31 vssd1 vssd1 vccd1 vccd1 sky130_fd_sc_hd__fill_1
XFILLER_19_53 vssd1 vssd1 vccd1 vccd1 sky130_fd_sc_hd__fill_2
XFILLER_59_265 vssd1 vccd1 vssd1 vccd1 sky130_ef_sc_hd__decap_40_12
XFILLER_15_335 vssd1 vssd1 vccd1 vccd1 sky130_fd_sc_hd__fill_1
XFILLER_42_121 vssd1 vssd1 vccd1 vccd1 sky130_fd_sc_hd__fill_2
XTAP_TAPCELL_ROW_57_499 vssd1 vccd1 sky130_fd_sc_hd__tapvpwrvgnd_1
XFILLER_35_96 vssd1 vssd1 vccd1 vccd1 sky130_fd_sc_hd__fill_2
XTAP_TAPCELL_ROW_40_388 vssd1 vccd1 sky130_fd_sc_hd__tapvpwrvgnd_1
XPHY_EDGE_ROW_2_Left_62 vssd1 vssd1 vccd1 vccd1 sky130_fd_sc_hd__decap_3
XANTENNA__1162__C1 _0902_/A vssd1 vssd1 vccd1 vccd1 sky130_fd_sc_hd__diode_2
X_1121_ _1070_/A _1058_/Y _1054_/X vssd1 vssd1 vccd1 vccd1 _1121_/X sky130_fd_sc_hd__o21a_2
X_1052_ _1052_/A _1052_/B vssd1 vssd1 vccd1 vccd1 _1347_/A sky130_fd_sc_hd__nand2_2
XTAP_TAPCELL_ROW_48_444 vssd1 vccd1 sky130_fd_sc_hd__tapvpwrvgnd_1
XANTENNA__1474__RESET_B wire142/X vssd1 vssd1 vccd1 vccd1 sky130_fd_sc_hd__diode_2
XFILLER_18_162 vssd1 vssd1 vccd1 vccd1 sky130_fd_sc_hd__fill_1
XTAP_TAPCELL_ROW_31_333 vssd1 vccd1 sky130_fd_sc_hd__tapvpwrvgnd_1
X_0905_ _0919_/A _0942_/B vssd1 vssd1 vccd1 vccd1 _0912_/A sky130_fd_sc_hd__nand2_2
X_0836_ _0846_/A _0846_/B _0809_/Y vssd1 vssd1 vccd1 vccd1 _0845_/B sky130_fd_sc_hd__o21ai_2
X_0767_ _0767_/A _1348_/A vssd1 vssd1 vccd1 vccd1 _0767_/Y sky130_fd_sc_hd__nor2_2
XFILLER_56_29 vssd1 vccd1 vssd1 vccd1 sky130_ef_sc_hd__decap_40_12
X_0698_ input7/X vssd1 vssd1 vccd1 vccd1 _0771_/A sky130_fd_sc_hd__inv_2
XFILLER_24_121 vssd1 vssd1 vccd1 vccd1 sky130_fd_sc_hd__fill_8
X_1319_ _1445_/Q _1325_/B vssd1 vssd1 vccd1 vccd1 _1319_/X sky130_fd_sc_hd__or2_2
XANTENNA__1208__B1 _1320_/C1 vssd1 vssd1 vccd1 vccd1 sky130_fd_sc_hd__diode_2
XFILLER_8_309 vssd1 vccd1 vssd1 vccd1 sky130_ef_sc_hd__decap_40_12
XANTENNA__1257__B _1285_/C vssd1 vssd1 vccd1 vccd1 sky130_fd_sc_hd__diode_2
XANTENNA__1454__CLK _1459_/CLK vssd1 vssd1 vccd1 vccd1 sky130_fd_sc_hd__diode_2
XFILLER_47_279 vssd1 vssd1 vccd1 vccd1 sky130_fd_sc_hd__fill_1
XFILLER_15_132 vssd1 vccd1 vssd1 vccd1 sky130_ef_sc_hd__decap_40_12
XFILLER_15_165 vssd1 vssd1 vccd1 vccd1 sky130_fd_sc_hd__fill_2
XFILLER_23_3 vssd1 vssd1 vccd1 vccd1 sky130_fd_sc_hd__fill_8
XFILLER_53_205 vssd1 vccd1 vssd1 vccd1 sky130_ef_sc_hd__decap_40_12
XFILLER_53_249 vssd1 vccd1 vssd1 vccd1 sky130_ef_sc_hd__decap_40_12
X_1104_ _0767_/A _1451_/Q _0703_/Y _0783_/A vssd1 vssd1 vccd1 vccd1 _1104_/X sky130_fd_sc_hd__o2bb2a_2
X_1035_ _1036_/C _1035_/B vssd1 vssd1 vccd1 vccd1 _1035_/X sky130_fd_sc_hd__and2b_2
XFILLER_21_113 vssd1 vssd1 vccd1 vccd1 sky130_fd_sc_hd__fill_2
X_0819_ _1348_/A input7/X _0804_/A _0813_/B vssd1 vssd1 vccd1 vccd1 _0822_/B sky130_fd_sc_hd__a22o_2
XFILLER_29_213 vssd1 vssd1 vccd1 vccd1 sky130_fd_sc_hd__fill_2
XTAP_TAPCELL_ROW_59_517 vssd1 vccd1 sky130_fd_sc_hd__tapvpwrvgnd_1
XFILLER_16_98 vssd1 vccd1 vssd1 vccd1 sky130_ef_sc_hd__decap_40_12
XFILLER_4_301 vssd1 vssd1 vccd1 vccd1 sky130_fd_sc_hd__fill_4
XFILLER_8_139 vssd1 vssd1 vccd1 vccd1 sky130_fd_sc_hd__fill_1
XFILLER_4_345 vssd1 vccd1 vssd1 vccd1 sky130_ef_sc_hd__decap_40_12
XTAP_TAPCELL_ROW_7_172 vssd1 vccd1 sky130_fd_sc_hd__tapvpwrvgnd_1
XFILLER_43_260 vssd1 vssd1 vccd1 vccd1 sky130_fd_sc_hd__fill_1
XFILLER_7_161 vssd1 vssd1 vccd1 vccd1 sky130_fd_sc_hd__fill_4
XFILLER_7_183 vssd1 vssd1 vccd1 vccd1 sky130_fd_sc_hd__fill_8
XPHY_EDGE_ROW_9_Right_9 vssd1 vssd1 vccd1 vccd1 sky130_fd_sc_hd__decap_3
X_1018_ _1018_/A _1018_/B _1020_/C vssd1 vssd1 vccd1 vccd1 _1019_/A sky130_fd_sc_hd__and3_2
XFILLER_5_109 vssd1 vssd1 vccd1 vccd1 sky130_fd_sc_hd__fill_2
XFILLER_1_337 vssd1 vccd1 vssd1 vccd1 sky130_ef_sc_hd__decap_40_12
XFILLER_17_205 vssd1 vssd1 vccd1 vccd1 sky130_fd_sc_hd__fill_1
XFILLER_17_216 vssd1 vssd1 vccd1 vccd1 sky130_fd_sc_hd__fill_8
XTAP_TAPCELL_ROW_4_153 vssd1 vccd1 sky130_fd_sc_hd__tapvpwrvgnd_1
XFILLER_25_293 vssd1 vssd1 vccd1 vccd1 sky130_fd_sc_hd__fill_4
XFILLER_4_153 vssd1 vccd1 vssd1 vccd1 sky130_ef_sc_hd__decap_40_12
XANTENNA__1105__A2 _0771_/A vssd1 vssd1 vccd1 vccd1 sky130_fd_sc_hd__diode_2
XFILLER_4_197 vssd1 vccd1 vssd1 vccd1 sky130_ef_sc_hd__decap_40_12
XPHY_EDGE_ROW_31_Left_91 vssd1 vssd1 vccd1 vccd1 sky130_fd_sc_hd__decap_3
XTAP_TAPCELL_ROW_18_244 vssd1 vccd1 sky130_fd_sc_hd__tapvpwrvgnd_1
XANTENNA__0855__A1 _0943_/A vssd1 vssd1 vccd1 vccd1 sky130_fd_sc_hd__diode_2
XFILLER_54_333 vssd1 vccd1 vssd1 vccd1 sky130_ef_sc_hd__decap_40_12
XTAP_TAPCELL_ROW_1_134 vssd1 vccd1 sky130_fd_sc_hd__tapvpwrvgnd_1
XFILLER_1_167 vssd1 vssd1 vccd1 vccd1 sky130_fd_sc_hd__fill_1
XFILLER_49_149 vssd1 vccd1 vssd1 vccd1 sky130_ef_sc_hd__decap_40_12
XANTENNA_input10_A prescaler[12] vssd1 vssd1 vccd1 vccd1 sky130_fd_sc_hd__diode_2
XFILLER_38_85 vssd1 vssd1 vccd1 vccd1 sky130_fd_sc_hd__fill_8
XFILLER_57_193 vssd1 vccd1 vssd1 vccd1 sky130_ef_sc_hd__decap_40_12
XTAP_TAPCELL_ROW_15_225 vssd1 vccd1 sky130_fd_sc_hd__tapvpwrvgnd_1
XFILLER_9_223 vssd1 vssd1 vccd1 vccd1 sky130_fd_sc_hd__fill_1
XTAP_TAPCELL_ROW_23_280 vssd1 vccd1 sky130_fd_sc_hd__tapvpwrvgnd_1
X_1421_ _1435_/A _1438_/B _1427_/A _1422_/D vssd1 vssd1 vccd1 vccd1 _1421_/X sky130_fd_sc_hd__and4_2
XFILLER_48_160 vssd1 vccd1 vssd1 vccd1 sky130_ef_sc_hd__decap_40_12
X_1352_ _1352_/A _1461_/D vssd1 vssd1 vccd1 vccd1 _1365_/C sky130_fd_sc_hd__xnor2_2
X_1283_ _1467_/Q _1310_/A2 _0715_/B vssd1 vssd1 vccd1 vccd1 _1283_/Y sky130_fd_sc_hd__o21ai_2
X_0998_ _0998_/A _0998_/B _0998_/C vssd1 vssd1 vccd1 vccd1 _1065_/B sky130_fd_sc_hd__nand3_2
XANTENNA_input2_A la_data_in[0] vssd1 vssd1 vccd1 vccd1 sky130_fd_sc_hd__diode_2
XFILLER_59_29 vssd1 vccd1 vssd1 vccd1 sky130_ef_sc_hd__decap_40_12
XFILLER_27_333 vssd1 vssd1 vccd1 vccd1 sky130_fd_sc_hd__fill_2
XFILLER_39_171 vssd1 vssd1 vccd1 vccd1 sky130_fd_sc_hd__fill_1
XFILLER_46_108 vssd1 vssd1 vccd1 vccd1 sky130_fd_sc_hd__fill_8
XFILLER_54_141 vssd1 vccd1 vssd1 vccd1 sky130_ef_sc_hd__decap_40_12
XTAP_TAPCELL_ROW_37_372 vssd1 vccd1 sky130_fd_sc_hd__tapvpwrvgnd_1
XTAP_TAPCELL_ROW_29_317 vssd1 vccd1 sky130_fd_sc_hd__tapvpwrvgnd_1
XTAP_TAPCELL_ROW_12_206 vssd1 vccd1 sky130_fd_sc_hd__tapvpwrvgnd_1
XTAP_TAPCELL_ROW_20_261 vssd1 vccd1 sky130_fd_sc_hd__tapvpwrvgnd_1
XFILLER_18_333 vssd1 vccd1 vssd1 vccd1 sky130_ef_sc_hd__decap_40_12
XFILLER_1_69 vssd1 vccd1 vssd1 vccd1 sky130_ef_sc_hd__decap_40_12
XFILLER_49_62 vssd1 vssd1 vccd1 vccd1 sky130_fd_sc_hd__fill_1
X_0921_ _0921_/A _1011_/A vssd1 vssd1 vccd1 vccd1 _0922_/B sky130_fd_sc_hd__nand2_2
XFILLER_53_3 vssd1 vccd1 vssd1 vccd1 sky130_ef_sc_hd__decap_40_12
X_0852_ _1364_/A _1345_/A _1372_/A vssd1 vssd1 vccd1 vccd1 _0901_/B sky130_fd_sc_hd__and3_2
X_0783_ _0783_/A _1103_/A vssd1 vssd1 vccd1 vccd1 _0812_/B sky130_fd_sc_hd__nor2_2
XFILLER_5_281 vssd1 vccd1 vssd1 vccd1 sky130_ef_sc_hd__decap_40_12
X_1335_ _1384_/C _0711_/X _1438_/A vssd1 vssd1 vccd1 vccd1 _1337_/A sky130_fd_sc_hd__a21oi_2
X_1404_ _1418_/A _1437_/B vssd1 vssd1 vccd1 vccd1 _1429_/A sky130_fd_sc_hd__nand2b_2
XFILLER_36_141 vssd1 vssd1 vccd1 vccd1 sky130_fd_sc_hd__fill_1
XFILLER_36_163 vssd1 vssd1 vccd1 vccd1 sky130_fd_sc_hd__fill_4
XFILLER_51_111 vssd1 vssd1 vccd1 vccd1 sky130_fd_sc_hd__fill_1
Xinput2 la_data_in[0] vssd1 vssd1 vccd1 vccd1 input2/X sky130_fd_sc_hd__clkdlybuf4s25_1
X_1266_ _1465_/Q _1288_/A _1285_/C _1264_/Y _1265_/X vssd1 vssd1 vccd1 vccd1 _1266_/X
+ sky130_fd_sc_hd__a32o_2
X_1197_ _1456_/Q _1205_/B vssd1 vssd1 vccd1 vccd1 _1197_/Y sky130_fd_sc_hd__nand2_2
XFILLER_24_347 vssd1 vssd1 vccd1 vccd1 sky130_fd_sc_hd__fill_1
XTAP_TAPCELL_ROW_34_353 vssd1 vccd1 sky130_fd_sc_hd__tapvpwrvgnd_1
XANTENNA__1171__B1 _1320_/C1 vssd1 vssd1 vccd1 vccd1 sky130_fd_sc_hd__diode_2
XFILLER_19_87 vssd1 vccd1 vssd1 vccd1 sky130_ef_sc_hd__decap_40_12
XFILLER_59_222 vssd1 vssd1 vccd1 vccd1 sky130_fd_sc_hd__fill_2
XFILLER_59_277 vssd1 vssd1 vccd1 vccd1 sky130_fd_sc_hd__fill_2
XFILLER_59_288 vssd1 vssd1 vccd1 vccd1 sky130_fd_sc_hd__fill_1
XFILLER_30_306 vssd1 vssd1 vccd1 vccd1 sky130_fd_sc_hd__fill_2
XFILLER_35_31 vssd1 vssd1 vccd1 vccd1 sky130_fd_sc_hd__fill_8
XTAP_TAPCELL_ROW_40_389 vssd1 vccd1 sky130_fd_sc_hd__tapvpwrvgnd_1
XFILLER_2_251 vssd1 vssd1 vccd1 vccd1 sky130_fd_sc_hd__fill_1
XFILLER_18_174 vssd1 vccd1 vssd1 vccd1 sky130_ef_sc_hd__decap_40_12
XFILLER_33_111 vssd1 vssd1 vccd1 vccd1 sky130_fd_sc_hd__fill_1
X_1120_ _1132_/A _1115_/X _1116_/X _1119_/X vssd1 vssd1 vccd1 vccd1 _1120_/X sky130_fd_sc_hd__o211a_2
X_1051_ _1050_/A _1059_/B _1050_/B vssd1 vssd1 vccd1 vccd1 _1052_/B sky130_fd_sc_hd__a21o_2
X_0904_ input9/X _0942_/B vssd1 vssd1 vccd1 vccd1 _0904_/X sky130_fd_sc_hd__and2_2
X_0835_ _0817_/B _0847_/B _0815_/Y vssd1 vssd1 vccd1 vccd1 _0846_/B sky130_fd_sc_hd__a21oi_2
X_0766_ _0766_/A _0766_/B vssd1 vssd1 vccd1 vccd1 _0853_/D sky130_fd_sc_hd__xnor2_2
X_0697_ _1103_/A vssd1 vssd1 vccd1 vccd1 _0729_/A sky130_fd_sc_hd__inv_2
X_1318_ _1315_/X _1317_/Y _1330_/B1 vssd1 vssd1 vccd1 vccd1 _1318_/X sky130_fd_sc_hd__o21a_2
XFILLER_12_306 vssd1 vssd1 vccd1 vccd1 sky130_fd_sc_hd__fill_2
X_1249_ _1307_/A1 _1307_/A2 _1307_/B1 _1247_/X vssd1 vssd1 vccd1 vccd1 _1249_/X sky130_fd_sc_hd__o211a_2
XFILLER_21_55 vssd1 vssd1 vccd1 vccd1 sky130_fd_sc_hd__fill_1
XFILLER_46_85 vssd1 vssd1 vccd1 vccd1 sky130_fd_sc_hd__fill_2
XFILLER_15_111 vssd1 vssd1 vccd1 vccd1 sky130_fd_sc_hd__fill_1
XFILLER_15_144 vssd1 vssd1 vccd1 vccd1 sky130_fd_sc_hd__fill_2
XFILLER_11_361 vssd1 vssd1 vccd1 vccd1 sky130_fd_sc_hd__fill_4
XFILLER_11_372 vssd1 vssd1 vccd1 vccd1 sky130_fd_sc_hd__fill_2
XFILLER_7_57 vssd1 vccd1 vssd1 vccd1 sky130_ef_sc_hd__decap_40_12
XANTENNA__1183__B _1205_/B vssd1 vssd1 vccd1 vccd1 sky130_fd_sc_hd__diode_2
XANTENNA__0808__A _0953_/B vssd1 vssd1 vccd1 vccd1 sky130_fd_sc_hd__diode_2
XFILLER_53_217 vssd1 vssd1 vccd1 vccd1 sky130_fd_sc_hd__fill_4
X_1103_ _1103_/A _1449_/Q vssd1 vssd1 vccd1 vccd1 _1103_/Y sky130_fd_sc_hd__xnor2_2
X_1034_ _1033_/B _1033_/C _1471_/Q vssd1 vssd1 vccd1 vccd1 _1035_/B sky130_fd_sc_hd__a21o_2
XFILLER_21_169 vssd1 vssd1 vccd1 vccd1 sky130_fd_sc_hd__fill_1
XANTENNA_fanout110_A _1340_/A vssd1 vssd1 vccd1 vccd1 sky130_fd_sc_hd__diode_2
X_0818_ _0818_/A _0818_/B vssd1 vssd1 vccd1 vccd1 _0821_/A sky130_fd_sc_hd__xnor2_2
X_0749_ _0965_/A _0883_/A _0740_/Y vssd1 vssd1 vccd1 vccd1 _0758_/A sky130_fd_sc_hd__o21ai_2
XFILLER_29_225 vssd1 vccd1 vssd1 vccd1 sky130_ef_sc_hd__decap_40_12
XFILLER_44_217 vssd1 vccd1 vssd1 vccd1 sky130_ef_sc_hd__decap_40_12
XTAP_TAPCELL_ROW_59_518 vssd1 vccd1 sky130_fd_sc_hd__tapvpwrvgnd_1
XFILLER_12_103 vssd1 vssd1 vccd1 vccd1 sky130_fd_sc_hd__fill_2
XFILLER_12_158 vssd1 vssd1 vccd1 vccd1 sky130_fd_sc_hd__fill_2
XTAP_TAPCELL_ROW_50_451 vssd1 vccd1 sky130_fd_sc_hd__tapvpwrvgnd_1
XFILLER_32_76 vssd1 vssd1 vccd1 vccd1 sky130_fd_sc_hd__fill_1
XFILLER_4_357 vssd1 vssd1 vccd1 vccd1 sky130_fd_sc_hd__fill_4
XFILLER_57_51 vssd1 vssd1 vccd1 vccd1 sky130_fd_sc_hd__fill_4
XTAP_TAPCELL_ROW_7_173 vssd1 vccd1 sky130_fd_sc_hd__tapvpwrvgnd_1
XFILLER_35_206 vssd1 vssd1 vccd1 vccd1 sky130_fd_sc_hd__fill_1
XFILLER_50_209 vssd1 vccd1 vssd1 vccd1 sky130_ef_sc_hd__decap_40_12
XFILLER_43_272 vssd1 vssd1 vccd1 vccd1 sky130_fd_sc_hd__fill_1
XPHY_EDGE_ROW_44_Left_104 vssd1 vssd1 vccd1 vccd1 sky130_fd_sc_hd__decap_3
XFILLER_58_309 vssd1 vccd1 vssd1 vccd1 sky130_ef_sc_hd__decap_40_12
XPHY_EDGE_ROW_53_Left_113 vssd1 vssd1 vccd1 vccd1 sky130_fd_sc_hd__decap_3
XANTENNA__1444__CLK _1463_/CLK vssd1 vssd1 vccd1 vccd1 sky130_fd_sc_hd__diode_2
XFILLER_34_250 vssd1 vssd1 vccd1 vccd1 sky130_fd_sc_hd__fill_2
XFILLER_34_283 vssd1 vccd1 vssd1 vccd1 sky130_ef_sc_hd__decap_40_12
X_1017_ _1018_/B _1020_/C _1018_/A vssd1 vssd1 vccd1 vccd1 _1023_/A sky130_fd_sc_hd__a21o_2
XFILLER_1_305 vssd1 vccd1 vssd1 vccd1 sky130_ef_sc_hd__decap_40_12
XFILLER_1_349 vssd1 vccd1 vssd1 vccd1 sky130_ef_sc_hd__decap_40_12
XFILLER_27_54 vssd1 vssd1 vccd1 vccd1 sky130_fd_sc_hd__fill_2
XFILLER_27_76 vssd1 vssd1 vccd1 vccd1 sky130_fd_sc_hd__fill_2
XTAP_TAPCELL_ROW_4_154 vssd1 vccd1 sky130_fd_sc_hd__tapvpwrvgnd_1
XFILLER_4_121 vssd1 vccd1 vssd1 vccd1 sky130_ef_sc_hd__decap_40_12
XFILLER_4_165 vssd1 vccd1 vssd1 vccd1 sky130_ef_sc_hd__decap_40_12
XFILLER_0_360 vssd1 vssd1 vccd1 vccd1 sky130_fd_sc_hd__fill_4
XFILLER_0_371 vssd1 vssd1 vccd1 vccd1 sky130_fd_sc_hd__fill_1
XANTENNA__1274__C1 _1303_/C1 vssd1 vssd1 vccd1 vccd1 sky130_fd_sc_hd__diode_2
XANTENNA__1467__CLK _1471_/CLK vssd1 vssd1 vccd1 vccd1 sky130_fd_sc_hd__diode_2
XFILLER_16_272 vssd1 vssd1 vccd1 vccd1 sky130_fd_sc_hd__fill_4
XTAP_TAPCELL_ROW_18_245 vssd1 vccd1 sky130_fd_sc_hd__tapvpwrvgnd_1
XFILLER_58_139 vssd1 vssd1 vccd1 vccd1 sky130_fd_sc_hd__fill_1
XFILLER_54_301 vssd1 vssd1 vccd1 vccd1 sky130_fd_sc_hd__fill_4
XFILLER_54_345 vssd1 vccd1 vssd1 vccd1 sky130_ef_sc_hd__decap_40_12
XTAP_TAPCELL_ROW_1_135 vssd1 vccd1 sky130_fd_sc_hd__tapvpwrvgnd_1
XANTENNA__0715__B _0715_/B vssd1 vssd1 vccd1 vccd1 sky130_fd_sc_hd__diode_2
XFILLER_13_23 vssd1 vssd1 vccd1 vccd1 sky130_fd_sc_hd__fill_1
XFILLER_22_253 vssd1 vssd1 vccd1 vccd1 sky130_fd_sc_hd__fill_4
XFILLER_22_275 vssd1 vssd1 vccd1 vccd1 sky130_fd_sc_hd__fill_2
XFILLER_22_286 vssd1 vssd1 vccd1 vccd1 sky130_fd_sc_hd__fill_2
XFILLER_1_113 vssd1 vccd1 vssd1 vccd1 sky130_ef_sc_hd__decap_40_12
XFILLER_45_301 vssd1 vssd1 vccd1 vccd1 sky130_fd_sc_hd__fill_1
XFILLER_57_161 vssd1 vssd1 vccd1 vccd1 sky130_fd_sc_hd__fill_4
XANTENNA__0906__A _0943_/A vssd1 vssd1 vccd1 vccd1 sky130_fd_sc_hd__diode_2
XFILLER_45_345 vssd1 vssd1 vccd1 vccd1 sky130_fd_sc_hd__fill_1
XFILLER_54_41 vssd1 vccd1 vssd1 vccd1 sky130_ef_sc_hd__decap_40_12
XFILLER_54_85 vssd1 vccd1 vssd1 vccd1 sky130_ef_sc_hd__decap_40_12
XTAP_TAPCELL_ROW_15_226 vssd1 vccd1 sky130_fd_sc_hd__tapvpwrvgnd_1
XFILLER_13_297 vssd1 vccd1 vssd1 vccd1 sky130_ef_sc_hd__decap_40_12
XTAP_TAPCELL_ROW_23_281 vssd1 vccd1 sky130_fd_sc_hd__tapvpwrvgnd_1
X_1351_ _1297_/A _1297_/B _1038_/Y vssd1 vssd1 vccd1 vccd1 _1351_/X sky130_fd_sc_hd__a21o_2
X_1420_ _1389_/A _1438_/B _1435_/A vssd1 vssd1 vccd1 vccd1 _1420_/X sky130_fd_sc_hd__o21a_2
XFILLER_48_172 vssd1 vccd1 vssd1 vccd1 sky130_ef_sc_hd__decap_40_12
XFILLER_55_109 vssd1 vssd1 vccd1 vccd1 sky130_fd_sc_hd__fill_2
X_1282_ _1288_/A _1280_/Y _1281_/X _1303_/C1 vssd1 vssd1 vccd1 vccd1 _1282_/X sky130_fd_sc_hd__a211o_2
XFILLER_51_337 vssd1 vccd1 vssd1 vccd1 sky130_ef_sc_hd__decap_40_12
X_0997_ _0997_/A _0997_/B _0997_/C _0997_/D vssd1 vssd1 vccd1 vccd1 _0998_/C sky130_fd_sc_hd__and4_2
XTAP_TAPCELL_ROW_29_318 vssd1 vccd1 sky130_fd_sc_hd__tapvpwrvgnd_1
XFILLER_27_345 vssd1 vssd1 vccd1 vccd1 sky130_fd_sc_hd__fill_2
XFILLER_42_337 vssd1 vssd1 vccd1 vccd1 sky130_fd_sc_hd__fill_1
XFILLER_54_153 vssd1 vccd1 vssd1 vccd1 sky130_ef_sc_hd__decap_40_12
XFILLER_54_197 vssd1 vccd1 vssd1 vccd1 sky130_ef_sc_hd__decap_40_12
XTAP_TAPCELL_ROW_20_262 vssd1 vccd1 sky130_fd_sc_hd__tapvpwrvgnd_1
XTAP_TAPCELL_ROW_12_207 vssd1 vccd1 sky130_fd_sc_hd__tapvpwrvgnd_1
XANTENNA__1308__A3 _1285_/C vssd1 vssd1 vccd1 vccd1 sky130_fd_sc_hd__diode_2
XANTENNA__0819__A2 input7/X vssd1 vssd1 vccd1 vccd1 sky130_fd_sc_hd__diode_2
XFILLER_18_345 vssd1 vssd1 vccd1 vccd1 sky130_fd_sc_hd__fill_2
XFILLER_1_15 vssd1 vccd1 vssd1 vccd1 sky130_ef_sc_hd__decap_40_12
XANTENNA__1229__C1 _1313_/B1 vssd1 vssd1 vccd1 vccd1 sky130_fd_sc_hd__diode_2
XFILLER_45_175 vssd1 vssd1 vccd1 vccd1 sky130_fd_sc_hd__fill_1
X_0920_ _0919_/A _0919_/Y _0922_/A vssd1 vssd1 vccd1 vccd1 _1026_/A sky130_fd_sc_hd__mux2_1
X_0851_ _0851_/A _0851_/B vssd1 vssd1 vccd1 vccd1 _1372_/A sky130_fd_sc_hd__nand2_2
X_0782_ _0783_/A _1103_/A vssd1 vssd1 vccd1 vccd1 _0804_/A sky130_fd_sc_hd__nand2_2
XFILLER_46_3 vssd1 vccd1 vssd1 vccd1 sky130_ef_sc_hd__decap_40_12
XFILLER_5_293 vssd1 vccd1 vssd1 vccd1 sky130_ef_sc_hd__decap_40_12
X_1334_ _1384_/C _0711_/X _1333_/Y vssd1 vssd1 vccd1 vccd1 _1475_/D sky130_fd_sc_hd__o21a_2
X_1403_ _1474_/Q _1416_/B _1438_/B vssd1 vssd1 vccd1 vccd1 _1437_/B sky130_fd_sc_hd__and3b_2
X_1265_ _1307_/A1 _1307_/A2 _1307_/B1 _1262_/X vssd1 vssd1 vccd1 vccd1 _1265_/X sky130_fd_sc_hd__o211a_2
XPHY_EDGE_ROW_18_Right_18 vssd1 vssd1 vccd1 vccd1 sky130_fd_sc_hd__decap_3
XFILLER_36_197 vssd1 vssd1 vccd1 vccd1 sky130_fd_sc_hd__fill_2
Xinput3 la_data_in[1] vssd1 vssd1 vccd1 vccd1 input3/X sky130_fd_sc_hd__clkdlybuf4s25_1
X_1196_ _1196_/A _1217_/D vssd1 vssd1 vccd1 vccd1 _1196_/X sky130_fd_sc_hd__or2_2
XPHY_EDGE_ROW_27_Right_27 vssd1 vssd1 vccd1 vccd1 sky130_fd_sc_hd__decap_3
XFILLER_51_167 vssd1 vssd1 vccd1 vccd1 sky130_fd_sc_hd__fill_1
XPHY_EDGE_ROW_36_Right_36 vssd1 vssd1 vccd1 vccd1 sky130_fd_sc_hd__decap_3
XFILLER_19_11 vssd1 vssd1 vccd1 vccd1 sky130_fd_sc_hd__fill_1
XFILLER_19_55 vssd1 vssd1 vccd1 vccd1 sky130_fd_sc_hd__fill_1
XFILLER_19_99 vssd1 vssd1 vccd1 vccd1 sky130_fd_sc_hd__fill_8
XFILLER_15_337 vssd1 vssd1 vccd1 vccd1 sky130_fd_sc_hd__fill_8
XFILLER_30_318 vssd1 vssd1 vccd1 vccd1 sky130_fd_sc_hd__fill_8
XFILLER_35_54 vssd1 vssd1 vccd1 vccd1 sky130_fd_sc_hd__fill_2
XFILLER_35_65 vssd1 vssd1 vccd1 vccd1 sky130_fd_sc_hd__fill_1
XFILLER_35_98 vssd1 vssd1 vccd1 vccd1 sky130_fd_sc_hd__fill_1
XFILLER_42_123 vssd1 vssd1 vccd1 vccd1 sky130_fd_sc_hd__fill_1
XPHY_EDGE_ROW_45_Right_45 vssd1 vssd1 vccd1 vccd1 sky130_fd_sc_hd__decap_3
XANTENNA__0903__B _0943_/A vssd1 vssd1 vccd1 vccd1 sky130_fd_sc_hd__diode_2
XFILLER_51_31 vssd1 vssd1 vccd1 vccd1 sky130_fd_sc_hd__fill_1
XPHY_EDGE_ROW_54_Right_54 vssd1 vssd1 vccd1 vccd1 sky130_fd_sc_hd__decap_3
XFILLER_18_186 vssd1 vssd1 vccd1 vccd1 sky130_fd_sc_hd__fill_2
XFILLER_18_197 vssd1 vssd1 vccd1 vccd1 sky130_fd_sc_hd__fill_4
XFILLER_33_123 vssd1 vccd1 vssd1 vccd1 sky130_ef_sc_hd__decap_40_12
X_1050_ _1050_/A _1050_/B _1059_/B vssd1 vssd1 vccd1 vccd1 _1052_/A sky130_fd_sc_hd__nand3_2
XTAP_TAPCELL_ROW_56_490 vssd1 vccd1 sky130_fd_sc_hd__tapvpwrvgnd_1
X_0903_ _0913_/A _0943_/A vssd1 vssd1 vccd1 vccd1 _0915_/B sky130_fd_sc_hd__nand2_2
X_0834_ _0820_/A _0821_/A _0822_/B _0849_/A vssd1 vssd1 vccd1 vccd1 _0847_/B sky130_fd_sc_hd__a31o_2
X_0765_ _0766_/A _0766_/B vssd1 vssd1 vccd1 vccd1 _0788_/A sky130_fd_sc_hd__xor2_2
X_0696_ _0783_/A vssd1 vssd1 vccd1 vccd1 _1348_/A sky130_fd_sc_hd__inv_2
X_1317_ _1329_/A _1317_/B vssd1 vssd1 vccd1 vccd1 _1317_/Y sky130_fd_sc_hd__nor2_2
X_1248_ _1463_/Q _1255_/C vssd1 vssd1 vccd1 vccd1 _1248_/Y sky130_fd_sc_hd__nand2_2
XFILLER_24_145 vssd1 vssd1 vccd1 vccd1 sky130_fd_sc_hd__fill_1
X_1179_ _1453_/Q _1180_/A1 _1320_/C1 vssd1 vssd1 vccd1 vccd1 _1179_/Y sky130_fd_sc_hd__o21ai_2
XANTENNA__0967__A1 _0942_/B vssd1 vssd1 vccd1 vccd1 sky130_fd_sc_hd__diode_2
XFILLER_21_34 vssd1 vssd1 vccd1 vccd1 sky130_fd_sc_hd__fill_2
XFILLER_21_67 vssd1 vssd1 vccd1 vccd1 sky130_fd_sc_hd__fill_4
XFILLER_21_89 vssd1 vssd1 vccd1 vccd1 sky130_fd_sc_hd__fill_4
XFILLER_46_42 vssd1 vssd1 vccd1 vccd1 sky130_fd_sc_hd__fill_4
XFILLER_55_281 vssd1 vccd1 vssd1 vccd1 sky130_ef_sc_hd__decap_40_12
XANTENNA__0914__A _0953_/B vssd1 vssd1 vccd1 vccd1 sky130_fd_sc_hd__diode_2
XANTENNA__0958__A1 input9/X vssd1 vssd1 vccd1 vccd1 sky130_fd_sc_hd__diode_2
XFILLER_15_167 vssd1 vssd1 vccd1 vccd1 sky130_fd_sc_hd__fill_1
XFILLER_7_333 vssd1 vssd1 vccd1 vccd1 sky130_fd_sc_hd__fill_2
XTAP_TAPCELL_ROW_53_471 vssd1 vccd1 sky130_fd_sc_hd__tapvpwrvgnd_1
XFILLER_7_69 vssd1 vccd1 vssd1 vccd1 sky130_ef_sc_hd__decap_40_12
X_1102_ _1131_/A _1131_/B vssd1 vssd1 vccd1 vccd1 _1102_/Y sky130_fd_sc_hd__nor2_2
XFILLER_21_115 vssd1 vssd1 vccd1 vccd1 sky130_fd_sc_hd__fill_1
X_1033_ _1471_/Q _1033_/B _1033_/C vssd1 vssd1 vccd1 vccd1 _1036_/C sky130_fd_sc_hd__and3_2
X_0817_ _0815_/Y _0817_/B vssd1 vssd1 vccd1 vccd1 _0847_/A sky130_fd_sc_hd__and2b_2
X_0748_ _0746_/A _0746_/B _0744_/Y vssd1 vssd1 vccd1 vccd1 _0869_/A sky130_fd_sc_hd__a21o_2
XTAP_TAPCELL_ROW_59_519 vssd1 vccd1 sky130_fd_sc_hd__tapvpwrvgnd_1
XFILLER_16_12 vssd1 vssd1 vccd1 vccd1 sky130_fd_sc_hd__fill_2
XFILLER_37_270 vssd1 vssd1 vccd1 vccd1 sky130_fd_sc_hd__fill_2
XFILLER_52_251 vssd1 vssd1 vccd1 vccd1 sky130_fd_sc_hd__fill_1
XTAP_TAPCELL_ROW_50_452 vssd1 vccd1 sky130_fd_sc_hd__tapvpwrvgnd_1
XPHY_EDGE_ROW_0_Right_0 vssd1 vssd1 vccd1 vccd1 sky130_fd_sc_hd__decap_3
XFILLER_32_66 vssd1 vssd1 vccd1 vccd1 sky130_fd_sc_hd__fill_8
XTAP_TAPCELL_ROW_7_174 vssd1 vccd1 sky130_fd_sc_hd__tapvpwrvgnd_1
XFILLER_35_218 vssd1 vssd1 vccd1 vccd1 sky130_fd_sc_hd__fill_1
XANTENNA__1108__B2 _0767_/A vssd1 vssd1 vccd1 vccd1 sky130_fd_sc_hd__diode_2
XFILLER_19_281 vssd1 vssd1 vccd1 vccd1 sky130_fd_sc_hd__fill_4
X_1016_ _1055_/B _1008_/X _1041_/B _0981_/X _0923_/Y vssd1 vssd1 vccd1 vccd1 _1026_/B
+ sky130_fd_sc_hd__a2111o_2
XFILLER_1_317 vssd1 vccd1 vssd1 vccd1 sky130_ef_sc_hd__decap_40_12
XTAP_TAPCELL_ROW_4_155 vssd1 vccd1 sky130_fd_sc_hd__tapvpwrvgnd_1
XANTENNA__1283__B1 _0715_/B vssd1 vssd1 vccd1 vccd1 sky130_fd_sc_hd__diode_2
XFILLER_17_229 vssd1 vssd1 vccd1 vccd1 sky130_fd_sc_hd__fill_2
XFILLER_27_22 vssd1 vccd1 vssd1 vccd1 sky130_ef_sc_hd__decap_40_12
XANTENNA__0911__B _0942_/B vssd1 vssd1 vccd1 vccd1 sky130_fd_sc_hd__diode_2
XFILLER_40_276 vssd1 vssd1 vccd1 vccd1 sky130_fd_sc_hd__fill_4
XFILLER_4_133 vssd1 vssd1 vccd1 vccd1 sky130_fd_sc_hd__fill_4
XFILLER_4_177 vssd1 vccd1 vssd1 vccd1 sky130_ef_sc_hd__decap_40_12
XFILLER_4_26 vssd1 vssd1 vccd1 vccd1 sky130_fd_sc_hd__fill_2
XFILLER_48_321 vssd1 vccd1 vssd1 vccd1 sky130_ef_sc_hd__decap_40_12
XFILLER_48_365 vssd1 vssd1 vccd1 vccd1 sky130_fd_sc_hd__fill_2
XFILLER_16_284 vssd1 vssd1 vccd1 vccd1 sky130_fd_sc_hd__fill_2
XFILLER_31_243 vssd1 vccd1 vssd1 vccd1 sky130_ef_sc_hd__decap_40_12
XTAP_TAPCELL_ROW_18_246 vssd1 vccd1 sky130_fd_sc_hd__tapvpwrvgnd_1
XFILLER_31_287 vssd1 vssd1 vccd1 vccd1 sky130_fd_sc_hd__fill_8
XPHY_EDGE_ROW_18_Left_78 vssd1 vssd1 vccd1 vccd1 sky130_fd_sc_hd__decap_3
XFILLER_54_357 vssd1 vssd1 vccd1 vccd1 sky130_fd_sc_hd__fill_4
XTAP_TAPCELL_ROW_1_136 vssd1 vccd1 sky130_fd_sc_hd__tapvpwrvgnd_1
XFILLER_13_57 vssd1 vssd1 vccd1 vccd1 sky130_fd_sc_hd__fill_4
XFILLER_13_68 vssd1 vssd1 vccd1 vccd1 sky130_fd_sc_hd__fill_8
XFILLER_1_125 vssd1 vccd1 vssd1 vccd1 sky130_ef_sc_hd__decap_40_12
XFILLER_1_169 vssd1 vccd1 vssd1 vccd1 sky130_ef_sc_hd__decap_40_12
XFILLER_38_76 vssd1 vssd1 vccd1 vccd1 sky130_fd_sc_hd__fill_8
XANTENNA__0906__B input9/X vssd1 vssd1 vccd1 vccd1 sky130_fd_sc_hd__diode_2
XFILLER_13_265 vssd1 vssd1 vccd1 vccd1 sky130_fd_sc_hd__fill_1
XFILLER_54_53 vssd1 vccd1 vssd1 vccd1 sky130_ef_sc_hd__decap_40_12
XFILLER_54_97 vssd1 vccd1 vssd1 vccd1 sky130_ef_sc_hd__decap_40_12
XTAP_TAPCELL_ROW_15_227 vssd1 vccd1 sky130_fd_sc_hd__tapvpwrvgnd_1
X_1350_ _1350_/A _1470_/D vssd1 vssd1 vccd1 vccd1 _1365_/A sky130_fd_sc_hd__xnor2_2
X_1281_ _1307_/A1 _1307_/A2 _1307_/B1 _1279_/X vssd1 vssd1 vccd1 vccd1 _1281_/X sky130_fd_sc_hd__o211a_2
XFILLER_48_184 vssd1 vccd1 vssd1 vccd1 sky130_ef_sc_hd__decap_40_12
XFILLER_51_305 vssd1 vccd1 vssd1 vccd1 sky130_ef_sc_hd__decap_40_12
XFILLER_51_349 vssd1 vccd1 vssd1 vccd1 sky130_ef_sc_hd__decap_40_12
X_0996_ _1006_/C _0996_/B vssd1 vssd1 vccd1 vccd1 _1072_/A sky130_fd_sc_hd__xnor2_2
XFILLER_27_335 vssd1 vssd1 vccd1 vccd1 sky130_fd_sc_hd__fill_1
XFILLER_54_121 vssd1 vccd1 vssd1 vccd1 sky130_ef_sc_hd__decap_40_12
XTAP_TAPCELL_ROW_29_319 vssd1 vccd1 sky130_fd_sc_hd__tapvpwrvgnd_1
XFILLER_24_67 vssd1 vssd1 vccd1 vccd1 sky130_fd_sc_hd__fill_8
XFILLER_54_165 vssd1 vccd1 vssd1 vccd1 sky130_ef_sc_hd__decap_40_12
XTAP_TAPCELL_ROW_12_208 vssd1 vccd1 sky130_fd_sc_hd__tapvpwrvgnd_1
XFILLER_10_213 vssd1 vssd1 vccd1 vccd1 sky130_fd_sc_hd__fill_1
XFILLER_40_33 vssd1 vssd1 vccd1 vccd1 sky130_fd_sc_hd__fill_2
XFILLER_40_55 vssd1 vccd1 vssd1 vccd1 sky130_ef_sc_hd__decap_40_12
XANTENNA__1457__CLK _1459_/CLK vssd1 vssd1 vccd1 vccd1 sky130_fd_sc_hd__diode_2
XFILLER_49_42 vssd1 vssd1 vccd1 vccd1 sky130_fd_sc_hd__fill_4
XFILLER_49_75 vssd1 vssd1 vccd1 vccd1 sky130_fd_sc_hd__fill_1
XFILLER_6_3 vssd1 vccd1 vssd1 vccd1 sky130_ef_sc_hd__decap_40_12
XFILLER_1_27 vssd1 vccd1 vssd1 vccd1 sky130_ef_sc_hd__decap_40_12
X_0850_ _0848_/B _0831_/X _1093_/A vssd1 vssd1 vccd1 vccd1 _0851_/B sky130_fd_sc_hd__a21o_2
XFILLER_5_261 vssd1 vccd1 vssd1 vccd1 sky130_ef_sc_hd__decap_40_12
X_1402_ _1417_/A _1428_/A vssd1 vssd1 vccd1 vccd1 _1402_/Y sky130_fd_sc_hd__nor2_2
X_0781_ _1096_/A _0781_/B vssd1 vssd1 vccd1 vccd1 _0793_/A sky130_fd_sc_hd__xnor2_2
XFILLER_39_3 vssd1 vssd1 vccd1 vccd1 sky130_fd_sc_hd__fill_2
X_1333_ _1384_/C _0711_/X _0712_/X vssd1 vssd1 vccd1 vccd1 _1333_/Y sky130_fd_sc_hd__a21oi_2
Xinput4 la_oenb[0] vssd1 vssd1 vccd1 vccd1 input4/X sky130_fd_sc_hd__clkdlybuf4s25_1
X_1264_ _1278_/C vssd1 vssd1 vccd1 vccd1 _1264_/Y sky130_fd_sc_hd__inv_2
XFILLER_24_305 vssd1 vssd1 vccd1 vccd1 sky130_fd_sc_hd__fill_2
XFILLER_36_187 vssd1 vssd1 vccd1 vccd1 sky130_fd_sc_hd__fill_4
XFILLER_51_113 vssd1 vccd1 vssd1 vccd1 sky130_ef_sc_hd__decap_40_12
Xclkbuf_2_1__f_clk clkbuf_0_clk/X vssd1 vssd1 vccd1 vccd1 _1459_/CLK sky130_fd_sc_hd__clkbuf_16
X_1195_ _1456_/Q _1195_/B vssd1 vssd1 vccd1 vccd1 _1217_/D sky130_fd_sc_hd__and2_2
X_0979_ _1020_/A _0979_/B _0979_/C vssd1 vssd1 vccd1 vccd1 _0979_/X sky130_fd_sc_hd__and3_2
XFILLER_27_110 vssd1 vssd1 vccd1 vccd1 sky130_fd_sc_hd__fill_2
XFILLER_59_279 vssd1 vssd1 vccd1 vccd1 sky130_fd_sc_hd__fill_1
XFILLER_35_77 vssd1 vssd1 vccd1 vccd1 sky130_fd_sc_hd__fill_1
XFILLER_51_21 vssd1 vssd1 vccd1 vccd1 sky130_fd_sc_hd__fill_8
XFILLER_51_65 vssd1 vssd1 vccd1 vccd1 sky130_fd_sc_hd__fill_2
XFILLER_18_8 vssd1 vssd1 vccd1 vccd1 sky130_fd_sc_hd__fill_1
XFILLER_2_253 vssd1 vccd1 vssd1 vccd1 sky130_ef_sc_hd__decap_40_12
XFILLER_33_113 vssd1 vssd1 vccd1 vccd1 sky130_fd_sc_hd__fill_1
XFILLER_33_135 vssd1 vccd1 vssd1 vccd1 sky130_ef_sc_hd__decap_40_12
XTAP_TAPCELL_ROW_56_491 vssd1 vccd1 sky130_fd_sc_hd__tapvpwrvgnd_1
XANTENNA__1197__B _1205_/B vssd1 vssd1 vccd1 vccd1 sky130_fd_sc_hd__diode_2
X_0902_ _0902_/A vssd1 vssd1 vccd1 vccd1 _0902_/Y sky130_fd_sc_hd__inv_2
X_0833_ _0848_/B _0851_/A _0848_/A vssd1 vssd1 vccd1 vccd1 _0849_/A sky130_fd_sc_hd__a21oi_2
X_0764_ _0764_/A _0764_/B vssd1 vssd1 vccd1 vccd1 _0775_/A sky130_fd_sc_hd__xnor2_2
X_0695_ _1366_/A vssd1 vssd1 vccd1 vccd1 _0767_/A sky130_fd_sc_hd__inv_2
XFILLER_2_81 vssd1 vssd1 vccd1 vccd1 sky130_fd_sc_hd__fill_2
XFILLER_56_249 vssd1 vssd1 vccd1 vccd1 sky130_fd_sc_hd__fill_2
X_1316_ _1444_/Q _1445_/Q vssd1 vssd1 vccd1 vccd1 _1317_/B sky130_fd_sc_hd__xnor2_2
X_1247_ _1463_/Q _1255_/C vssd1 vssd1 vccd1 vccd1 _1247_/X sky130_fd_sc_hd__or2_2
X_1178_ _1190_/A _1176_/Y _1177_/X _0902_/A vssd1 vssd1 vccd1 vccd1 _1178_/X sky130_fd_sc_hd__a211o_2
XANTENNA__1310__C1 _1340_/A vssd1 vssd1 vccd1 vccd1 sky130_fd_sc_hd__diode_2
XFILLER_24_157 vssd1 vssd1 vccd1 vccd1 sky130_fd_sc_hd__fill_4
XFILLER_21_57 vssd1 vssd1 vccd1 vccd1 sky130_fd_sc_hd__fill_4
XFILLER_15_113 vssd1 vssd1 vccd1 vccd1 sky130_fd_sc_hd__fill_4
XFILLER_46_87 vssd1 vssd1 vccd1 vccd1 sky130_fd_sc_hd__fill_1
XFILLER_55_293 vssd1 vccd1 vssd1 vccd1 sky130_ef_sc_hd__decap_40_12
XPHY_EDGE_ROW_6_Left_66 vssd1 vssd1 vccd1 vccd1 sky130_fd_sc_hd__decap_3
XFILLER_11_374 vssd1 vssd1 vccd1 vccd1 sky130_fd_sc_hd__fill_1
XFILLER_7_15 vssd1 vccd1 vssd1 vccd1 sky130_ef_sc_hd__decap_40_12
XTAP_TAPCELL_ROW_53_472 vssd1 vccd1 sky130_fd_sc_hd__tapvpwrvgnd_1
XFILLER_30_7 vssd1 vssd1 vccd1 vccd1 sky130_fd_sc_hd__fill_2
XFILLER_38_238 vssd1 vssd1 vccd1 vccd1 sky130_fd_sc_hd__fill_1
X_1101_ _1101_/A _1101_/B vssd1 vssd1 vccd1 vccd1 _1131_/B sky130_fd_sc_hd__nand2_2
X_1032_ _1033_/B _1033_/C vssd1 vssd1 vccd1 vccd1 _1344_/A sky130_fd_sc_hd__nand2_2
XFILLER_46_282 vssd1 vssd1 vccd1 vccd1 sky130_fd_sc_hd__fill_2
X_0816_ _0816_/A _0816_/B vssd1 vssd1 vccd1 vccd1 _0817_/B sky130_fd_sc_hd__nand2_2
X_0747_ _0764_/B _0764_/A vssd1 vssd1 vccd1 vccd1 _0762_/A sky130_fd_sc_hd__nand2b_2
XFILLER_32_23 vssd1 vssd1 vccd1 vccd1 sky130_fd_sc_hd__fill_4
XFILLER_32_45 vssd1 vssd1 vccd1 vccd1 sky130_fd_sc_hd__fill_2
XFILLER_8_109 vssd1 vccd1 vssd1 vccd1 sky130_ef_sc_hd__decap_40_12
XTAP_TAPCELL_ROW_50_453 vssd1 vccd1 sky130_fd_sc_hd__tapvpwrvgnd_1
XTAP_TAPCELL_ROW_7_175 vssd1 vccd1 sky130_fd_sc_hd__tapvpwrvgnd_1
XANTENNA__0800__B2 _0953_/B vssd1 vssd1 vccd1 vccd1 sky130_fd_sc_hd__diode_2
XFILLER_7_197 vssd1 vccd1 vssd1 vccd1 sky130_ef_sc_hd__decap_40_12
XFILLER_19_293 vssd1 vssd1 vccd1 vccd1 sky130_fd_sc_hd__fill_1
X_1015_ _1055_/B _1008_/X _1041_/B _0981_/X vssd1 vssd1 vccd1 vccd1 _1037_/A sky130_fd_sc_hd__a211o_2
XFILLER_1_329 vssd1 vssd1 vccd1 vccd1 sky130_fd_sc_hd__fill_4
XFILLER_27_34 vssd1 vccd1 vssd1 vccd1 sky130_ef_sc_hd__decap_40_12
XFILLER_57_333 vssd1 vssd1 vccd1 vccd1 sky130_fd_sc_hd__fill_2
XTAP_TAPCELL_ROW_4_156 vssd1 vccd1 sky130_fd_sc_hd__tapvpwrvgnd_1
XFILLER_4_189 vssd1 vssd1 vccd1 vccd1 sky130_fd_sc_hd__fill_4
XFILLER_16_241 vssd1 vssd1 vccd1 vccd1 sky130_fd_sc_hd__fill_1
XFILLER_48_333 vssd1 vssd1 vccd1 vccd1 sky130_fd_sc_hd__fill_8
XTAP_TAPCELL_ROW_18_247 vssd1 vccd1 sky130_fd_sc_hd__tapvpwrvgnd_1
XFILLER_16_296 vssd1 vssd1 vccd1 vccd1 sky130_fd_sc_hd__fill_4
XFILLER_31_255 vssd1 vccd1 vssd1 vccd1 sky130_ef_sc_hd__decap_40_12
XFILLER_54_369 vssd1 vssd1 vccd1 vccd1 sky130_fd_sc_hd__fill_2
XTAP_TAPCELL_ROW_1_137 vssd1 vccd1 sky130_fd_sc_hd__tapvpwrvgnd_1
XFILLER_1_137 vssd1 vccd1 vssd1 vccd1 sky130_ef_sc_hd__decap_40_12
XFILLER_45_325 vssd1 vssd1 vccd1 vccd1 sky130_fd_sc_hd__fill_4
XFILLER_13_222 vssd1 vssd1 vccd1 vccd1 sky130_fd_sc_hd__fill_2
XFILLER_54_65 vssd1 vccd1 vssd1 vccd1 sky130_ef_sc_hd__decap_40_12
XFILLER_9_237 vssd1 vssd1 vccd1 vccd1 sky130_fd_sc_hd__fill_1
XTAP_TAPCELL_ROW_15_228 vssd1 vccd1 sky130_fd_sc_hd__tapvpwrvgnd_1
XPHY_EDGE_ROW_35_Left_95 vssd1 vssd1 vccd1 vccd1 sky130_fd_sc_hd__decap_3
XFILLER_0_181 vssd1 vssd1 vccd1 vccd1 sky130_fd_sc_hd__fill_2
XFILLER_48_141 vssd1 vssd1 vccd1 vccd1 sky130_fd_sc_hd__fill_2
X_1280_ _1467_/Q _1285_/C vssd1 vssd1 vccd1 vccd1 _1280_/Y sky130_fd_sc_hd__nand2_2
XFILLER_36_325 vssd1 vssd1 vccd1 vccd1 sky130_fd_sc_hd__fill_2
XFILLER_36_336 vssd1 vssd1 vccd1 vccd1 sky130_fd_sc_hd__fill_2
XFILLER_51_317 vssd1 vccd1 vssd1 vccd1 sky130_ef_sc_hd__decap_40_12
X_0995_ _1006_/C _0996_/B vssd1 vssd1 vccd1 vccd1 _0997_/D sky130_fd_sc_hd__xor2_2
XFILLER_5_81 vssd1 vccd1 vssd1 vccd1 sky130_ef_sc_hd__decap_40_12
XFILLER_54_133 vssd1 vssd1 vccd1 vccd1 sky130_fd_sc_hd__fill_4
X_1478_ _1478_/CLK _1478_/D wire142/X vssd1 vssd1 vccd1 vccd1 _1478_/Q sky130_fd_sc_hd__dfrtp_2
XFILLER_54_177 vssd1 vccd1 vssd1 vccd1 sky130_ef_sc_hd__decap_40_12
XTAP_TAPCELL_ROW_12_209 vssd1 vccd1 sky130_fd_sc_hd__tapvpwrvgnd_1
XFILLER_40_67 vssd1 vssd1 vccd1 vccd1 sky130_fd_sc_hd__fill_1
XFILLER_40_89 vssd1 vssd1 vccd1 vccd1 sky130_fd_sc_hd__fill_1
XFILLER_18_347 vssd1 vssd1 vccd1 vccd1 sky130_fd_sc_hd__fill_1
XFILLER_1_39 vssd1 vccd1 vssd1 vccd1 sky130_ef_sc_hd__decap_40_12
XFILLER_45_111 vssd1 vssd1 vccd1 vccd1 sky130_fd_sc_hd__fill_1
XFILLER_45_155 vssd1 vccd1 vssd1 vccd1 sky130_ef_sc_hd__decap_40_12
X_0780_ _0780_/A _0780_/B vssd1 vssd1 vccd1 vccd1 _0799_/A sky130_fd_sc_hd__xnor2_2
XFILLER_5_273 vssd1 vssd1 vccd1 vccd1 sky130_fd_sc_hd__fill_4
X_1401_ _1474_/Q _1416_/B _1418_/A _1438_/B vssd1 vssd1 vccd1 vccd1 _1428_/A sky130_fd_sc_hd__or4b_2
X_1332_ _1332_/A1 _1330_/X _1331_/Y vssd1 vssd1 vccd1 vccd1 _1447_/D sky130_fd_sc_hd__o21ba_2
Xinput5 la_oenb[1] vssd1 vssd1 vccd1 vccd1 input5/X sky130_fd_sc_hd__clkdlybuf4s25_1
X_1263_ _1465_/Q _1263_/B vssd1 vssd1 vccd1 vccd1 _1278_/C sky130_fd_sc_hd__and2_2
X_1194_ _1456_/Q _1195_/B vssd1 vssd1 vccd1 vccd1 _1196_/A sky130_fd_sc_hd__nor2_2
XFILLER_24_317 vssd1 vccd1 vssd1 vccd1 sky130_ef_sc_hd__decap_40_12
XFILLER_36_199 vssd1 vssd1 vccd1 vccd1 sky130_fd_sc_hd__fill_1
XFILLER_51_125 vssd1 vccd1 vssd1 vccd1 sky130_ef_sc_hd__decap_40_12
XFILLER_51_169 vssd1 vccd1 vssd1 vccd1 sky130_ef_sc_hd__decap_40_12
XFILLER_10_15 vssd1 vccd1 vssd1 vccd1 sky130_ef_sc_hd__decap_40_12
X_0978_ _0978_/A _0978_/B _1050_/A vssd1 vssd1 vccd1 vccd1 _1055_/A sky130_fd_sc_hd__nand3_2
XANTENNA__1156__B1 _1332_/A1 vssd1 vssd1 vccd1 vccd1 sky130_fd_sc_hd__diode_2
XFILLER_59_214 vssd1 vssd1 vccd1 vccd1 sky130_fd_sc_hd__fill_8
XFILLER_59_225 vssd1 vccd1 vssd1 vccd1 sky130_ef_sc_hd__decap_40_12
XFILLER_19_57 vssd1 vccd1 vssd1 vccd1 sky130_ef_sc_hd__decap_40_12
XANTENNA__0753__A _0767_/A vssd1 vssd1 vccd1 vccd1 sky130_fd_sc_hd__diode_2
XFILLER_42_169 vssd1 vssd1 vccd1 vccd1 sky130_fd_sc_hd__fill_2
XFILLER_51_44 vssd1 vccd1 vssd1 vccd1 sky130_ef_sc_hd__decap_40_12
XFILLER_2_221 vssd1 vccd1 vssd1 vccd1 sky130_ef_sc_hd__decap_40_12
XFILLER_2_265 vssd1 vccd1 vssd1 vccd1 sky130_ef_sc_hd__decap_40_12
XANTENNA__0928__A _0943_/A vssd1 vssd1 vccd1 vccd1 sky130_fd_sc_hd__diode_2
XFILLER_18_188 vssd1 vssd1 vccd1 vccd1 sky130_fd_sc_hd__fill_1
XFILLER_33_147 vssd1 vssd1 vccd1 vccd1 sky130_fd_sc_hd__fill_4
XTAP_TAPCELL_ROW_56_492 vssd1 vccd1 sky130_fd_sc_hd__tapvpwrvgnd_1
X_0901_ _1079_/B _0901_/B _0901_/C _0901_/D vssd1 vssd1 vccd1 vccd1 _0901_/X sky130_fd_sc_hd__and4_2
X_0832_ _0832_/A _0832_/B _1097_/A _0831_/A vssd1 vssd1 vccd1 vccd1 _0851_/A sky130_fd_sc_hd__or4b_2
X_0763_ _0943_/A _0763_/B vssd1 vssd1 vccd1 vccd1 _0778_/A sky130_fd_sc_hd__xnor2_2
X_1315_ _1445_/Q _1329_/A _1327_/C vssd1 vssd1 vccd1 vccd1 _1315_/X sky130_fd_sc_hd__and3_2
X_0694_ _0730_/A vssd1 vssd1 vccd1 vccd1 _0862_/A sky130_fd_sc_hd__inv_2
XPHY_EDGE_ROW_22_Left_82 vssd1 vssd1 vccd1 vccd1 sky130_fd_sc_hd__decap_3
X_1246_ _1310_/A2 _1244_/X _1245_/Y vssd1 vssd1 vccd1 vccd1 _1462_/D sky130_fd_sc_hd__a21oi_2
X_1177_ _1206_/A1 _1206_/A2 _1206_/B1 _1175_/X vssd1 vssd1 vccd1 vccd1 _1177_/X sky130_fd_sc_hd__o211a_2
XANTENNA__1447__CLK _1459_/CLK vssd1 vssd1 vccd1 vccd1 sky130_fd_sc_hd__diode_2
XFILLER_12_309 vssd1 vccd1 vssd1 vccd1 sky130_ef_sc_hd__decap_40_12
XFILLER_24_136 vssd1 vssd1 vccd1 vccd1 sky130_fd_sc_hd__fill_4
XFILLER_32_180 vssd1 vccd1 vssd1 vccd1 sky130_ef_sc_hd__decap_40_12
XFILLER_15_125 vssd1 vssd1 vccd1 vccd1 sky130_fd_sc_hd__fill_2
XFILLER_15_169 vssd1 vssd1 vccd1 vccd1 sky130_fd_sc_hd__fill_4
XFILLER_55_261 vssd1 vccd1 vssd1 vccd1 sky130_ef_sc_hd__decap_40_12
XTAP_TAPCELL_ROW_53_473 vssd1 vccd1 sky130_fd_sc_hd__tapvpwrvgnd_1
XFILLER_7_27 vssd1 vccd1 vssd1 vccd1 sky130_ef_sc_hd__decap_40_12
XFILLER_7_335 vssd1 vssd1 vccd1 vccd1 sky130_fd_sc_hd__fill_1
XFILLER_11_80 vssd1 vssd1 vccd1 vccd1 sky130_fd_sc_hd__fill_4
X_1100_ _1100_/A _1100_/B _1100_/C _1100_/D vssd1 vssd1 vccd1 vccd1 _1131_/A sky130_fd_sc_hd__or4_2
X_1031_ _0930_/A _0922_/A _0919_/B vssd1 vssd1 vccd1 vccd1 _1033_/C sky130_fd_sc_hd__o21a_2
X_0815_ _0816_/A _0816_/B vssd1 vssd1 vccd1 vccd1 _0815_/Y sky130_fd_sc_hd__nor2_2
X_0746_ _0746_/A _0746_/B vssd1 vssd1 vccd1 vccd1 _0764_/B sky130_fd_sc_hd__xnor2_2
XFILLER_37_272 vssd1 vssd1 vccd1 vccd1 sky130_fd_sc_hd__fill_1
XFILLER_52_253 vssd1 vccd1 vssd1 vccd1 sky130_ef_sc_hd__decap_40_12
X_1229_ _1228_/B _1227_/X _1228_/Y _1313_/B1 vssd1 vssd1 vccd1 vccd1 _1354_/B sky130_fd_sc_hd__a211o_2
XFILLER_12_139 vssd1 vssd1 vccd1 vccd1 sky130_fd_sc_hd__fill_1
XFILLER_4_305 vssd1 vssd1 vccd1 vccd1 sky130_fd_sc_hd__fill_2
XTAP_TAPCELL_ROW_50_454 vssd1 vccd1 sky130_fd_sc_hd__tapvpwrvgnd_1
XANTENNA_input19_A prescaler[8] vssd1 vssd1 vccd1 vccd1 sky130_fd_sc_hd__diode_2
XTAP_TAPCELL_ROW_7_176 vssd1 vccd1 sky130_fd_sc_hd__tapvpwrvgnd_1
XFILLER_28_294 vssd1 vssd1 vccd1 vccd1 sky130_fd_sc_hd__fill_4
XFILLER_7_165 vssd1 vssd1 vccd1 vccd1 sky130_fd_sc_hd__fill_2
XFILLER_3_371 vssd1 vssd1 vccd1 vccd1 sky130_fd_sc_hd__fill_1
XFILLER_19_272 vssd1 vssd1 vccd1 vccd1 sky130_fd_sc_hd__fill_1
XFILLER_26_209 vssd1 vssd1 vccd1 vccd1 sky130_fd_sc_hd__fill_2
XFILLER_34_242 vssd1 vssd1 vccd1 vccd1 sky130_fd_sc_hd__fill_8
XFILLER_34_253 vssd1 vssd1 vccd1 vccd1 sky130_fd_sc_hd__fill_4
X_1014_ _1020_/C _1014_/B vssd1 vssd1 vccd1 vccd1 _1041_/B sky130_fd_sc_hd__xnor2_2
XFILLER_8_81 vssd1 vssd1 vccd1 vccd1 sky130_fd_sc_hd__fill_2
X_0729_ _0729_/A _0729_/B vssd1 vssd1 vccd1 vccd1 _0736_/A sky130_fd_sc_hd__xnor2_2
XFILLER_27_46 vssd1 vssd1 vccd1 vccd1 sky130_fd_sc_hd__fill_8
XFILLER_27_57 vssd1 vssd1 vccd1 vccd1 sky130_fd_sc_hd__fill_2
XFILLER_27_68 vssd1 vssd1 vccd1 vccd1 sky130_fd_sc_hd__fill_8
XTAP_TAPCELL_ROW_4_157 vssd1 vccd1 sky130_fd_sc_hd__tapvpwrvgnd_1
XPHY_EDGE_ROW_40_Left_100 vssd1 vssd1 vccd1 vccd1 sky130_fd_sc_hd__decap_3
XFILLER_25_297 vssd1 vssd1 vccd1 vccd1 sky130_fd_sc_hd__fill_1
XFILLER_43_34 vssd1 vccd1 vssd1 vccd1 sky130_ef_sc_hd__decap_40_12
XFILLER_48_301 vssd1 vssd1 vccd1 vccd1 sky130_fd_sc_hd__fill_4
XANTENNA__1259__C1 _1303_/C1 vssd1 vssd1 vccd1 vccd1 sky130_fd_sc_hd__diode_2
XFILLER_16_253 vssd1 vssd1 vccd1 vccd1 sky130_fd_sc_hd__fill_4
XFILLER_17_90 vssd1 vssd1 vccd1 vccd1 sky130_fd_sc_hd__fill_1
XTAP_TAPCELL_ROW_18_248 vssd1 vccd1 sky130_fd_sc_hd__tapvpwrvgnd_1
XFILLER_16_286 vssd1 vssd1 vccd1 vccd1 sky130_fd_sc_hd__fill_1
XFILLER_31_267 vssd1 vssd1 vccd1 vccd1 sky130_fd_sc_hd__fill_4
XFILLER_58_109 vssd1 vccd1 vssd1 vccd1 sky130_ef_sc_hd__decap_40_12
XTAP_TAPCELL_ROW_1_138 vssd1 vccd1 sky130_fd_sc_hd__tapvpwrvgnd_1
XFILLER_13_15 vssd1 vssd1 vccd1 vccd1 sky130_fd_sc_hd__fill_4
XANTENNA__0776__A1 input9/X vssd1 vssd1 vccd1 vccd1 sky130_fd_sc_hd__diode_2
XFILLER_13_37 vssd1 vssd1 vccd1 vccd1 sky130_fd_sc_hd__fill_4
XFILLER_1_105 vssd1 vssd1 vccd1 vccd1 sky130_fd_sc_hd__fill_4
XFILLER_1_149 vssd1 vccd1 vssd1 vccd1 sky130_ef_sc_hd__decap_40_12
XFILLER_13_201 vssd1 vssd1 vccd1 vccd1 sky130_fd_sc_hd__fill_1
XFILLER_54_77 vssd1 vssd1 vccd1 vccd1 sky130_fd_sc_hd__fill_4
XTAP_TAPCELL_ROW_15_229 vssd1 vccd1 sky130_fd_sc_hd__tapvpwrvgnd_1
XFILLER_48_9 vssd1 vccd1 vssd1 vccd1 sky130_ef_sc_hd__decap_40_12
XFILLER_36_348 vssd1 vssd1 vccd1 vccd1 sky130_fd_sc_hd__fill_8
XFILLER_48_197 vssd1 vccd1 vssd1 vccd1 sky130_ef_sc_hd__decap_40_12
XFILLER_51_329 vssd1 vssd1 vccd1 vccd1 sky130_fd_sc_hd__fill_4
X_0994_ _0994_/A _1006_/C vssd1 vssd1 vccd1 vccd1 _0994_/Y sky130_fd_sc_hd__nor2_2
XFILLER_5_93 vssd1 vccd1 vssd1 vccd1 sky130_ef_sc_hd__decap_40_12
X_1477_ _1478_/CLK _1477_/D fanout139/X vssd1 vssd1 vccd1 vccd1 _1477_/Q sky130_fd_sc_hd__dfrtp_2
XFILLER_27_337 vssd1 vssd1 vccd1 vccd1 sky130_fd_sc_hd__fill_8
XFILLER_39_164 vssd1 vssd1 vccd1 vccd1 sky130_fd_sc_hd__fill_4
XFILLER_24_36 vssd1 vccd1 vssd1 vccd1 sky130_ef_sc_hd__decap_40_12
XFILLER_42_329 vssd1 vssd1 vccd1 vccd1 sky130_fd_sc_hd__fill_1
XFILLER_54_189 vssd1 vssd1 vccd1 vccd1 sky130_fd_sc_hd__fill_4
XANTENNA__0749__A1 _0965_/A vssd1 vssd1 vccd1 vccd1 sky130_fd_sc_hd__diode_2
XFILLER_40_35 vssd1 vssd1 vccd1 vccd1 sky130_fd_sc_hd__fill_1
XFILLER_45_101 vssd1 vssd1 vccd1 vccd1 sky130_fd_sc_hd__fill_8
XFILLER_45_167 vssd1 vssd1 vccd1 vccd1 sky130_fd_sc_hd__fill_1
XTAP_TAPCELL_ROW_28_310 vssd1 vccd1 sky130_fd_sc_hd__tapvpwrvgnd_1
XFILLER_14_80 vssd1 vssd1 vccd1 vccd1 sky130_fd_sc_hd__fill_2
X_1331_ _1447_/Q _1325_/B _0715_/B vssd1 vssd1 vccd1 vccd1 _1331_/Y sky130_fd_sc_hd__o21ai_2
X_1400_ _1427_/A _1427_/B _1422_/D vssd1 vssd1 vccd1 vccd1 _1400_/X sky130_fd_sc_hd__and3_2
XFILLER_24_307 vssd1 vssd1 vccd1 vccd1 sky130_fd_sc_hd__fill_1
XFILLER_36_123 vssd1 vssd1 vccd1 vccd1 sky130_fd_sc_hd__fill_4
XFILLER_36_167 vssd1 vssd1 vccd1 vccd1 sky130_fd_sc_hd__fill_1
Xinput6 nrst vssd1 vssd1 vccd1 vccd1 input6/X sky130_fd_sc_hd__clkdlybuf4s25_1
X_1262_ _1465_/Q _1263_/B vssd1 vssd1 vccd1 vccd1 _1262_/X sky130_fd_sc_hd__or2_2
X_1193_ _1332_/A1 _1191_/X _1192_/X _1320_/C1 vssd1 vssd1 vccd1 vccd1 _1455_/D sky130_fd_sc_hd__o211a_2
XFILLER_24_329 vssd1 vccd1 vssd1 vccd1 sky130_ef_sc_hd__decap_40_12
XFILLER_32_340 vssd1 vssd1 vccd1 vccd1 sky130_fd_sc_hd__fill_4
XFILLER_51_137 vssd1 vccd1 vssd1 vccd1 sky130_ef_sc_hd__decap_40_12
XFILLER_10_27 vssd1 vssd1 vccd1 vccd1 sky130_fd_sc_hd__fill_1
X_0977_ _1050_/A vssd1 vssd1 vccd1 vccd1 _1049_/A sky130_fd_sc_hd__inv_2
XANTENNA__1156__A1 _1330_/B1 vssd1 vssd1 vccd1 vccd1 sky130_fd_sc_hd__diode_2
XFILLER_19_69 vssd1 vssd1 vccd1 vccd1 sky130_fd_sc_hd__fill_4
XFILLER_59_237 vssd1 vccd1 vssd1 vccd1 sky130_ef_sc_hd__decap_40_12
X_1529_ _1530_/A vssd1 vssd1 vccd1 vccd1 _1529_/X sky130_fd_sc_hd__buf_2
XFILLER_27_123 vssd1 vccd1 vssd1 vccd1 sky130_ef_sc_hd__decap_40_12
XFILLER_27_167 vssd1 vssd1 vccd1 vccd1 sky130_fd_sc_hd__fill_1
XFILLER_35_57 vssd1 vssd1 vccd1 vccd1 sky130_fd_sc_hd__fill_8
XPHY_EDGE_ROW_14_Right_14 vssd1 vssd1 vccd1 vccd1 sky130_fd_sc_hd__decap_3
XFILLER_2_233 vssd1 vccd1 vssd1 vccd1 sky130_ef_sc_hd__decap_40_12
XFILLER_2_277 vssd1 vccd1 vssd1 vccd1 sky130_ef_sc_hd__decap_40_12
XPHY_EDGE_ROW_23_Right_23 vssd1 vssd1 vccd1 vccd1 sky130_fd_sc_hd__decap_3
XANTENNA__0928__B input9/X vssd1 vssd1 vccd1 vccd1 sky130_fd_sc_hd__diode_2
XTAP_TAPCELL_ROW_48_438 vssd1 vccd1 sky130_fd_sc_hd__tapvpwrvgnd_1
XFILLER_14_351 vssd1 vssd1 vccd1 vccd1 sky130_fd_sc_hd__fill_1
X_0900_ _0997_/C _0900_/B vssd1 vssd1 vccd1 vccd1 _1077_/B sky130_fd_sc_hd__xnor2_2
XTAP_TAPCELL_ROW_56_493 vssd1 vccd1 sky130_fd_sc_hd__tapvpwrvgnd_1
XPHY_EDGE_ROW_32_Right_32 vssd1 vssd1 vccd1 vccd1 sky130_fd_sc_hd__decap_3
X_0831_ _0831_/A _0832_/A vssd1 vssd1 vccd1 vccd1 _0831_/X sky130_fd_sc_hd__or2_2
X_0762_ _0762_/A _0762_/B vssd1 vssd1 vccd1 vccd1 _0763_/B sky130_fd_sc_hd__xor2_2
X_0693_ _0739_/B vssd1 vssd1 vccd1 vccd1 _0883_/A sky130_fd_sc_hd__inv_2
XFILLER_44_3 vssd1 vccd1 vssd1 vccd1 sky130_ef_sc_hd__decap_40_12
X_1314_ _1192_/B _1312_/X _1313_/X vssd1 vssd1 vccd1 vccd1 _1444_/D sky130_fd_sc_hd__a21oi_2
XPHY_EDGE_ROW_41_Right_41 vssd1 vssd1 vccd1 vccd1 sky130_fd_sc_hd__decap_3
XFILLER_2_83 vssd1 vssd1 vccd1 vccd1 sky130_fd_sc_hd__fill_1
XFILLER_49_281 vssd1 vccd1 vssd1 vccd1 sky130_ef_sc_hd__decap_40_12
X_1245_ _1462_/Q _1252_/A2 _0715_/B vssd1 vssd1 vccd1 vccd1 _1245_/Y sky130_fd_sc_hd__o21ai_2
X_1176_ _1453_/Q _1205_/B vssd1 vssd1 vccd1 vccd1 _1176_/Y sky130_fd_sc_hd__nand2_2
XPHY_EDGE_ROW_50_Right_50 vssd1 vssd1 vccd1 vccd1 sky130_fd_sc_hd__decap_3
XFILLER_20_321 vssd1 vccd1 vssd1 vccd1 sky130_ef_sc_hd__decap_40_12
XFILLER_20_365 vssd1 vssd1 vccd1 vccd1 sky130_fd_sc_hd__fill_2
XFILLER_32_192 vssd1 vssd1 vccd1 vccd1 sky130_fd_sc_hd__fill_4
XFILLER_55_273 vssd1 vssd1 vccd1 vccd1 sky130_fd_sc_hd__fill_4
XTAP_TAPCELL_ROW_53_474 vssd1 vccd1 sky130_fd_sc_hd__tapvpwrvgnd_1
XTAP_TAPCELL_ROW_45_419 vssd1 vccd1 sky130_fd_sc_hd__tapvpwrvgnd_1
XFILLER_11_365 vssd1 vssd1 vccd1 vccd1 sky130_fd_sc_hd__fill_2
XFILLER_7_39 vssd1 vccd1 vssd1 vccd1 sky130_ef_sc_hd__decap_40_12
XFILLER_30_9 vssd1 vssd1 vccd1 vccd1 sky130_fd_sc_hd__fill_1
XFILLER_46_251 vssd1 vssd1 vccd1 vccd1 sky130_fd_sc_hd__fill_1
XFILLER_46_284 vssd1 vssd1 vccd1 vccd1 sky130_fd_sc_hd__fill_1
X_1030_ _1036_/A _1036_/B vssd1 vssd1 vccd1 vccd1 _1030_/Y sky130_fd_sc_hd__nor2_2
Xinput20 prescaler[9] vssd1 vssd1 vccd1 vccd1 _0953_/B sky130_fd_sc_hd__buf_2
X_0814_ _0956_/A _0818_/B vssd1 vssd1 vccd1 vccd1 _0816_/B sky130_fd_sc_hd__or2_2
X_0745_ _0745_/A _0745_/B vssd1 vssd1 vccd1 vccd1 _0746_/B sky130_fd_sc_hd__xor2_2
X_1228_ _1460_/Q _1228_/B vssd1 vssd1 vccd1 vccd1 _1228_/Y sky130_fd_sc_hd__nor2_2
XFILLER_37_262 vssd1 vssd1 vccd1 vccd1 sky130_fd_sc_hd__fill_8
XFILLER_52_221 vssd1 vccd1 vssd1 vccd1 sky130_ef_sc_hd__decap_40_12
XFILLER_52_265 vssd1 vccd1 vssd1 vccd1 sky130_ef_sc_hd__decap_40_12
X_1159_ _1451_/Q _1165_/C vssd1 vssd1 vccd1 vccd1 _1159_/Y sky130_fd_sc_hd__xnor2_2
XTAP_TAPCELL_ROW_50_455 vssd1 vccd1 sky130_fd_sc_hd__tapvpwrvgnd_1
XANTENNA_fanout99_A _1124_/X vssd1 vssd1 vccd1 vccd1 sky130_fd_sc_hd__diode_2
XTAP_TAPCELL_ROW_7_177 vssd1 vccd1 sky130_fd_sc_hd__tapvpwrvgnd_1
XFILLER_28_251 vssd1 vssd1 vccd1 vccd1 sky130_fd_sc_hd__fill_1
XFILLER_57_55 vssd1 vssd1 vccd1 vccd1 sky130_fd_sc_hd__fill_1
XFILLER_7_111 vssd1 vssd1 vccd1 vccd1 sky130_fd_sc_hd__fill_1
XFILLER_3_361 vssd1 vssd1 vccd1 vccd1 sky130_fd_sc_hd__fill_8
XFILLER_34_232 vssd1 vssd1 vccd1 vccd1 sky130_fd_sc_hd__fill_2
X_1013_ _1020_/A _1020_/B _1018_/B vssd1 vssd1 vccd1 vccd1 _1014_/B sky130_fd_sc_hd__a21o_2
X_0728_ _0729_/A _0729_/B vssd1 vssd1 vccd1 vccd1 _0745_/A sky130_fd_sc_hd__or2_2
XPHY_EDGE_ROW_4_Right_4 vssd1 vssd1 vccd1 vccd1 sky130_fd_sc_hd__decap_3
XANTENNA__1268__B1 _1313_/B1 vssd1 vssd1 vccd1 vccd1 sky130_fd_sc_hd__diode_2
XFILLER_25_210 vssd1 vssd1 vccd1 vccd1 sky130_fd_sc_hd__fill_2
XFILLER_57_335 vssd1 vssd1 vccd1 vccd1 sky130_fd_sc_hd__fill_1
XTAP_TAPCELL_ROW_4_158 vssd1 vccd1 sky130_fd_sc_hd__tapvpwrvgnd_1
XFILLER_25_254 vssd1 vssd1 vccd1 vccd1 sky130_fd_sc_hd__fill_2
XFILLER_25_276 vssd1 vssd1 vccd1 vccd1 sky130_fd_sc_hd__fill_4
XFILLER_43_46 vssd1 vssd1 vccd1 vccd1 sky130_fd_sc_hd__fill_2
XFILLER_4_18 vssd1 vssd1 vccd1 vccd1 sky130_fd_sc_hd__fill_8
XFILLER_4_29 vssd1 vccd1 vssd1 vccd1 sky130_ef_sc_hd__decap_40_12
XFILLER_16_276 vssd1 vssd1 vccd1 vccd1 sky130_fd_sc_hd__fill_1
XTAP_TAPCELL_ROW_18_249 vssd1 vccd1 sky130_fd_sc_hd__tapvpwrvgnd_1
XFILLER_31_279 vssd1 vssd1 vccd1 vccd1 sky130_fd_sc_hd__fill_1
XANTENNA_clkbuf_2_2__f_clk_X _1471_/CLK vssd1 vssd1 vccd1 vccd1 sky130_fd_sc_hd__diode_2
XFILLER_39_302 vssd1 vccd1 vssd1 vccd1 sky130_ef_sc_hd__decap_40_12
XFILLER_39_335 vssd1 vssd1 vccd1 vccd1 sky130_fd_sc_hd__fill_1
XFILLER_54_305 vssd1 vssd1 vccd1 vccd1 sky130_fd_sc_hd__fill_2
XFILLER_22_224 vssd1 vccd1 vssd1 vccd1 sky130_ef_sc_hd__decap_40_12
XFILLER_22_257 vssd1 vssd1 vccd1 vccd1 sky130_fd_sc_hd__fill_1
XANTENNA_fanout104_X _0902_/A vssd1 vssd1 vccd1 vccd1 sky130_fd_sc_hd__diode_2
XFILLER_38_13 vssd1 vccd1 vssd1 vccd1 sky130_ef_sc_hd__decap_40_12
XFILLER_57_165 vssd1 vssd1 vccd1 vccd1 sky130_fd_sc_hd__fill_2
XFILLER_13_257 vssd1 vssd1 vccd1 vccd1 sky130_fd_sc_hd__fill_1
XFILLER_13_268 vssd1 vccd1 vssd1 vccd1 sky130_ef_sc_hd__decap_40_12
XFILLER_36_327 vssd1 vssd1 vccd1 vccd1 sky130_fd_sc_hd__fill_1
X_0993_ _0993_/A _0993_/B vssd1 vssd1 vccd1 vccd1 _0996_/B sky130_fd_sc_hd__nor2_2
XFILLER_8_261 vssd1 vccd1 vssd1 vccd1 sky130_ef_sc_hd__decap_40_12
XFILLER_39_121 vssd1 vssd1 vccd1 vccd1 sky130_fd_sc_hd__fill_4
XFILLER_39_143 vssd1 vssd1 vccd1 vccd1 sky130_fd_sc_hd__fill_4
X_1476_ _1478_/CLK _1476_/D fanout139/X vssd1 vssd1 vccd1 vccd1 _1476_/Q sky130_fd_sc_hd__dfrtp_2
XFILLER_39_154 vssd1 vssd1 vccd1 vccd1 sky130_fd_sc_hd__fill_1
XFILLER_39_198 vssd1 vssd1 vccd1 vccd1 sky130_fd_sc_hd__fill_2
XFILLER_10_249 vssd1 vssd1 vccd1 vccd1 sky130_fd_sc_hd__fill_2
XFILLER_24_48 vssd1 vccd1 vssd1 vccd1 sky130_ef_sc_hd__decap_40_12
XANTENNA__0767__A _0767_/A vssd1 vssd1 vccd1 vccd1 sky130_fd_sc_hd__diode_2
XFILLER_18_305 vssd1 vssd1 vccd1 vccd1 sky130_fd_sc_hd__fill_2
XFILLER_45_113 vssd1 vssd1 vccd1 vccd1 sky130_fd_sc_hd__fill_4
XTAP_TAPCELL_ROW_28_311 vssd1 vccd1 sky130_fd_sc_hd__tapvpwrvgnd_1
XTAP_TAPCELL_ROW_11_200 vssd1 vccd1 sky130_fd_sc_hd__tapvpwrvgnd_1
X_1330_ _1327_/X _1329_/Y _1330_/B1 vssd1 vssd1 vccd1 vccd1 _1330_/X sky130_fd_sc_hd__o21a_2
X_1261_ _1310_/A2 _1259_/X _1260_/Y vssd1 vssd1 vccd1 vccd1 _1464_/D sky130_fd_sc_hd__a21oi_2
XFILLER_51_105 vssd1 vssd1 vccd1 vccd1 sky130_fd_sc_hd__fill_4
Xinput7 prescaler[0] vssd1 vssd1 vccd1 vccd1 input7/X sky130_fd_sc_hd__buf_1
X_1192_ _1455_/Q _1192_/B vssd1 vssd1 vccd1 vccd1 _1192_/X sky130_fd_sc_hd__or2_2
XFILLER_51_149 vssd1 vccd1 vssd1 vccd1 sky130_ef_sc_hd__decap_40_12
X_0976_ _0984_/A _0979_/C vssd1 vssd1 vccd1 vccd1 _1050_/A sky130_fd_sc_hd__nand2_2
XTAP_TAPCELL_ROW_34_347 vssd1 vccd1 sky130_fd_sc_hd__tapvpwrvgnd_1
XFILLER_19_37 vssd1 vccd1 vssd1 vccd1 sky130_ef_sc_hd__decap_40_12
XFILLER_27_102 vssd1 vssd1 vccd1 vccd1 sky130_fd_sc_hd__fill_8
XFILLER_27_113 vssd1 vssd1 vccd1 vccd1 sky130_fd_sc_hd__fill_4
XFILLER_27_135 vssd1 vccd1 vssd1 vccd1 sky130_ef_sc_hd__decap_40_12
XFILLER_59_249 vssd1 vssd1 vccd1 vccd1 sky130_fd_sc_hd__fill_2
X_1459_ _1459_/CLK _1459_/D fanout139/X vssd1 vssd1 vccd1 vccd1 _1459_/Q sky130_fd_sc_hd__dfrtp_2
X_1528_ _1543_/A vssd1 vssd1 vccd1 vccd1 _1528_/X sky130_fd_sc_hd__buf_2
XFILLER_42_105 vssd1 vssd1 vccd1 vccd1 sky130_fd_sc_hd__fill_1
XFILLER_50_193 vssd1 vssd1 vccd1 vccd1 sky130_fd_sc_hd__fill_2
XFILLER_51_57 vssd1 vssd1 vccd1 vccd1 sky130_fd_sc_hd__fill_8
XFILLER_2_245 vssd1 vssd1 vccd1 vccd1 sky130_fd_sc_hd__fill_4
XFILLER_2_289 vssd1 vccd1 vssd1 vccd1 sky130_ef_sc_hd__decap_40_12
XFILLER_18_102 vssd1 vssd1 vccd1 vccd1 sky130_fd_sc_hd__fill_1
XFILLER_18_135 vssd1 vssd1 vccd1 vccd1 sky130_fd_sc_hd__fill_4
XFILLER_33_105 vssd1 vssd1 vccd1 vccd1 sky130_fd_sc_hd__fill_4
XTAP_TAPCELL_ROW_48_439 vssd1 vccd1 sky130_fd_sc_hd__tapvpwrvgnd_1
X_0830_ _1092_/A _1097_/A vssd1 vssd1 vccd1 vccd1 _1093_/A sky130_fd_sc_hd__nor2_2
XTAP_TAPCELL_ROW_56_494 vssd1 vccd1 sky130_fd_sc_hd__tapvpwrvgnd_1
XTAP_TAPCELL_ROW_31_328 vssd1 vccd1 sky130_fd_sc_hd__tapvpwrvgnd_1
X_0761_ _0762_/A _0762_/B vssd1 vssd1 vccd1 vccd1 _0761_/Y sky130_fd_sc_hd__nor2_2
X_0692_ _0820_/A vssd1 vssd1 vccd1 vccd1 _0965_/A sky130_fd_sc_hd__inv_2
XFILLER_49_293 vssd1 vccd1 vssd1 vccd1 sky130_ef_sc_hd__decap_40_12
X_1313_ _0688_/Y _1332_/A1 _1313_/B1 vssd1 vssd1 vccd1 vccd1 _1313_/X sky130_fd_sc_hd__a21o_2
X_1244_ _1288_/A _1242_/Y _1243_/X _1303_/C1 vssd1 vssd1 vccd1 vccd1 _1244_/X sky130_fd_sc_hd__a211o_2
X_1175_ _1175_/A _1189_/C vssd1 vssd1 vccd1 vccd1 _1175_/X sky130_fd_sc_hd__or2_2
XFILLER_20_333 vssd1 vccd1 vssd1 vccd1 sky130_ef_sc_hd__decap_40_12
XFILLER_21_16 vssd1 vssd1 vccd1 vccd1 sky130_fd_sc_hd__fill_4
XFILLER_21_49 vssd1 vssd1 vccd1 vccd1 sky130_fd_sc_hd__fill_1
X_0959_ _0959_/A _0959_/B vssd1 vssd1 vccd1 vccd1 _0960_/B sky130_fd_sc_hd__nand2_2
XANTENNA__1129__A2 _0771_/A vssd1 vssd1 vccd1 vccd1 sky130_fd_sc_hd__diode_2
XFILLER_46_46 vssd1 vssd1 vccd1 vccd1 sky130_fd_sc_hd__fill_2
XTAP_TAPCELL_ROW_53_475 vssd1 vccd1 sky130_fd_sc_hd__tapvpwrvgnd_1
XFILLER_7_337 vssd1 vccd1 vssd1 vccd1 sky130_ef_sc_hd__decap_40_12
XANTENNA__0955__A _0965_/A vssd1 vssd1 vccd1 vccd1 sky130_fd_sc_hd__diode_2
XFILLER_46_241 vssd1 vssd1 vccd1 vccd1 sky130_fd_sc_hd__fill_8
XFILLER_14_160 vssd1 vccd1 vssd1 vccd1 sky130_ef_sc_hd__decap_40_12
Xinput10 prescaler[12] vssd1 vssd1 vccd1 vccd1 _0943_/A sky130_fd_sc_hd__buf_2
X_0813_ _1366_/A _0813_/B vssd1 vssd1 vccd1 vccd1 _0818_/B sky130_fd_sc_hd__xnor2_2
XANTENNA_load_slew137_X load_slew137/X vssd1 vssd1 vccd1 vccd1 sky130_fd_sc_hd__diode_2
X_0744_ _0745_/A _0745_/B vssd1 vssd1 vccd1 vccd1 _0744_/Y sky130_fd_sc_hd__nor2_2
XANTENNA__1295__A1 _1303_/C1 vssd1 vssd1 vccd1 vccd1 sky130_fd_sc_hd__diode_2
X_1227_ _1294_/S _1226_/Y _1225_/X _1303_/C1 vssd1 vssd1 vccd1 vccd1 _1227_/X sky130_fd_sc_hd__a211o_2
X_1158_ _1348_/B _1348_/C vssd1 vssd1 vccd1 vccd1 _1450_/D sky130_fd_sc_hd__nor2_2
XANTENNA_fanout134_X _0942_/B vssd1 vssd1 vccd1 vccd1 sky130_fd_sc_hd__diode_2
XFILLER_20_141 vssd1 vssd1 vccd1 vccd1 sky130_fd_sc_hd__fill_4
XFILLER_52_233 vssd1 vccd1 vssd1 vccd1 sky130_ef_sc_hd__decap_40_12
XFILLER_52_277 vssd1 vccd1 vssd1 vccd1 sky130_ef_sc_hd__decap_40_12
X_1089_ _1455_/Q _1342_/A vssd1 vssd1 vccd1 vccd1 _1101_/A sky130_fd_sc_hd__nand2_2
XTAP_TAPCELL_ROW_50_456 vssd1 vccd1 sky130_fd_sc_hd__tapvpwrvgnd_1
XFILLER_4_307 vssd1 vssd1 vccd1 vccd1 sky130_fd_sc_hd__fill_1
XFILLER_28_285 vssd1 vssd1 vccd1 vccd1 sky130_fd_sc_hd__fill_2
XFILLER_43_266 vssd1 vssd1 vccd1 vccd1 sky130_fd_sc_hd__fill_4
XFILLER_43_299 vssd1 vssd1 vccd1 vccd1 sky130_fd_sc_hd__fill_4
XFILLER_7_167 vssd1 vssd1 vccd1 vccd1 sky130_fd_sc_hd__fill_1
X_1012_ _1012_/A vssd1 vssd1 vccd1 vccd1 _1020_/C sky130_fd_sc_hd__inv_2
XFILLER_19_285 vssd1 vssd1 vccd1 vccd1 sky130_fd_sc_hd__fill_1
XFILLER_8_83 vssd1 vssd1 vccd1 vccd1 sky130_fd_sc_hd__fill_1
X_0727_ _0820_/A _0727_/B vssd1 vssd1 vccd1 vccd1 _0729_/B sky130_fd_sc_hd__xnor2_2
XFILLER_25_233 vssd1 vssd1 vccd1 vccd1 sky130_fd_sc_hd__fill_4
XFILLER_0_321 vssd1 vccd1 vssd1 vccd1 sky130_ef_sc_hd__decap_40_12
XFILLER_4_137 vssd1 vssd1 vccd1 vccd1 sky130_fd_sc_hd__fill_2
XFILLER_0_365 vssd1 vssd1 vccd1 vccd1 sky130_fd_sc_hd__fill_4
XANTENNA__0952__B _0953_/B vssd1 vssd1 vccd1 vccd1 sky130_fd_sc_hd__diode_2
XFILLER_17_70 vssd1 vssd1 vccd1 vccd1 sky130_fd_sc_hd__fill_1
XFILLER_31_225 vssd1 vssd1 vccd1 vccd1 sky130_fd_sc_hd__fill_4
XFILLER_39_314 vssd1 vccd1 vssd1 vccd1 sky130_ef_sc_hd__decap_40_12
XFILLER_3_181 vssd1 vccd1 vssd1 vccd1 sky130_ef_sc_hd__decap_40_12
XFILLER_22_236 vssd1 vccd1 vssd1 vccd1 sky130_ef_sc_hd__decap_40_12
XFILLER_38_25 vssd1 vssd1 vccd1 vccd1 sky130_fd_sc_hd__fill_2
XFILLER_57_111 vssd1 vssd1 vccd1 vccd1 sky130_fd_sc_hd__fill_1
XFILLER_13_214 vssd1 vssd1 vccd1 vccd1 sky130_fd_sc_hd__fill_8
XFILLER_13_225 vssd1 vccd1 vssd1 vccd1 sky130_ef_sc_hd__decap_40_12
XFILLER_53_361 vssd1 vccd1 vssd1 vccd1 sky130_ef_sc_hd__decap_40_12
XFILLER_0_195 vssd1 vssd1 vccd1 vccd1 sky130_fd_sc_hd__fill_1
XFILLER_48_122 vssd1 vccd1 vssd1 vccd1 sky130_ef_sc_hd__decap_40_12
X_0992_ _1006_/B _0992_/B vssd1 vssd1 vccd1 vccd1 _1065_/A sky130_fd_sc_hd__xnor2_2
XTAP_TAPCELL_ROW_14_220 vssd1 vccd1 sky130_fd_sc_hd__tapvpwrvgnd_1
XFILLER_5_51 vssd1 vssd1 vccd1 vccd1 sky130_fd_sc_hd__fill_4
XFILLER_8_273 vssd1 vccd1 vssd1 vccd1 sky130_ef_sc_hd__decap_40_12
XANTENNA__1455__RESET_B load_slew137/X vssd1 vssd1 vccd1 vccd1 sky130_fd_sc_hd__diode_2
X_1475_ _1478_/CLK _1475_/D wire142/X vssd1 vssd1 vccd1 vccd1 _1475_/Q sky130_fd_sc_hd__dfrtp_2
XFILLER_42_309 vssd1 vssd1 vccd1 vccd1 sky130_fd_sc_hd__fill_4
XTAP_TAPCELL_ROW_37_367 vssd1 vccd1 sky130_fd_sc_hd__tapvpwrvgnd_1
XFILLER_40_26 vssd1 vssd1 vccd1 vccd1 sky130_fd_sc_hd__fill_2
XFILLER_50_353 vssd1 vssd1 vccd1 vccd1 sky130_fd_sc_hd__fill_2
XTAP_TAPCELL_ROW_20_256 vssd1 vccd1 sky130_fd_sc_hd__tapvpwrvgnd_1
XFILLER_49_24 vssd1 vssd1 vccd1 vccd1 sky130_fd_sc_hd__fill_1
XFILLER_49_46 vssd1 vssd1 vccd1 vccd1 sky130_fd_sc_hd__fill_1
XANTENNA__1331__B1 _0715_/B vssd1 vssd1 vccd1 vccd1 sky130_fd_sc_hd__diode_2
XFILLER_45_169 vssd1 vssd1 vccd1 vccd1 sky130_fd_sc_hd__fill_4
XTAP_TAPCELL_ROW_28_312 vssd1 vccd1 sky130_fd_sc_hd__tapvpwrvgnd_1
XPHY_EDGE_ROW_39_Left_99 vssd1 vssd1 vccd1 vccd1 sky130_fd_sc_hd__decap_3
XTAP_TAPCELL_ROW_11_201 vssd1 vccd1 sky130_fd_sc_hd__tapvpwrvgnd_1
XFILLER_14_93 vssd1 vssd1 vccd1 vccd1 sky130_fd_sc_hd__fill_4
XFILLER_5_221 vssd1 vssd1 vccd1 vccd1 sky130_fd_sc_hd__fill_2
Xinput8 prescaler[10] vssd1 vssd1 vccd1 vccd1 input8/X sky130_fd_sc_hd__clkdlybuf4s25_1
X_1260_ _1464_/Q _1310_/A2 _0715_/B vssd1 vssd1 vccd1 vccd1 _1260_/Y sky130_fd_sc_hd__o21ai_2
X_1191_ _1187_/X _1190_/Y _1330_/B1 vssd1 vssd1 vccd1 vccd1 _1191_/X sky130_fd_sc_hd__o21a_2
XFILLER_36_103 vssd1 vssd1 vccd1 vccd1 sky130_fd_sc_hd__fill_2
XFILLER_36_136 vssd1 vssd1 vccd1 vccd1 sky130_fd_sc_hd__fill_4
XTAP_TAPCELL_ROW_34_348 vssd1 vccd1 sky130_fd_sc_hd__tapvpwrvgnd_1
X_0975_ _0979_/B _0979_/C vssd1 vssd1 vccd1 vccd1 _0978_/B sky130_fd_sc_hd__nand2_2
XFILLER_10_29 vssd1 vccd1 vssd1 vccd1 sky130_ef_sc_hd__decap_40_12
X_1527_ _1530_/A vssd1 vssd1 vccd1 vccd1 _1527_/X sky130_fd_sc_hd__buf_2
XANTENNA__1313__B1 _1313_/B1 vssd1 vssd1 vccd1 vccd1 sky130_fd_sc_hd__diode_2
XFILLER_19_49 vssd1 vssd1 vccd1 vccd1 sky130_fd_sc_hd__fill_4
XFILLER_27_147 vssd1 vccd1 vssd1 vccd1 sky130_ef_sc_hd__decap_40_12
X_1389_ _1389_/A _1422_/C vssd1 vssd1 vccd1 vccd1 _1438_/C sky130_fd_sc_hd__and2_2
X_1458_ _1459_/CLK _1458_/D fanout138/X vssd1 vssd1 vccd1 vccd1 _1458_/Q sky130_fd_sc_hd__dfrtp_2
XFILLER_23_331 vssd1 vssd1 vccd1 vccd1 sky130_fd_sc_hd__fill_4
XFILLER_27_169 vssd1 vssd1 vccd1 vccd1 sky130_fd_sc_hd__fill_2
XFILLER_51_69 vssd1 vccd1 vssd1 vccd1 sky130_ef_sc_hd__decap_40_12
XANTENNA__1304__B1 _1313_/B1 vssd1 vssd1 vccd1 vccd1 sky130_fd_sc_hd__diode_2
XTAP_TAPCELL_ROW_56_495 vssd1 vccd1 sky130_fd_sc_hd__tapvpwrvgnd_1
X_0760_ _0869_/A _0869_/B vssd1 vssd1 vccd1 vccd1 _0762_/B sky130_fd_sc_hd__xnor2_2
XTAP_TAPCELL_ROW_31_329 vssd1 vccd1 sky130_fd_sc_hd__tapvpwrvgnd_1
X_0691_ _0818_/A vssd1 vssd1 vccd1 vccd1 _0956_/A sky130_fd_sc_hd__inv_2
XFILLER_2_41 vssd1 vccd1 vssd1 vccd1 sky130_ef_sc_hd__decap_40_12
XFILLER_2_85 vssd1 vccd1 vssd1 vccd1 sky130_ef_sc_hd__decap_40_12
XFILLER_49_261 vssd1 vccd1 vssd1 vccd1 sky130_ef_sc_hd__decap_40_12
XFILLER_56_209 vssd1 vccd1 vssd1 vccd1 sky130_ef_sc_hd__decap_40_12
X_1312_ _0688_/Y _1190_/A _1327_/C _1311_/Y vssd1 vssd1 vccd1 vccd1 _1312_/X sky130_fd_sc_hd__a31o_2
X_1243_ _1307_/A1 _1307_/A2 _1307_/B1 _1241_/X vssd1 vssd1 vccd1 vccd1 _1243_/X sky130_fd_sc_hd__o211a_2
X_1174_ _1453_/Q _1174_/B vssd1 vssd1 vccd1 vccd1 _1189_/C sky130_fd_sc_hd__and2_2
XFILLER_20_345 vssd1 vssd1 vccd1 vccd1 sky130_fd_sc_hd__fill_2
X_0958_ input9/X _0954_/B _0952_/X vssd1 vssd1 vccd1 vccd1 _0964_/A sky130_fd_sc_hd__a21o_2
X_0889_ _0993_/A vssd1 vssd1 vccd1 vccd1 _1006_/A sky130_fd_sc_hd__inv_2
XFILLER_15_117 vssd1 vssd1 vccd1 vccd1 sky130_fd_sc_hd__fill_2
XFILLER_11_367 vssd1 vssd1 vccd1 vccd1 sky130_fd_sc_hd__fill_1
XFILLER_23_183 vssd1 vssd1 vccd1 vccd1 sky130_fd_sc_hd__fill_1
XFILLER_30_109 vssd1 vssd1 vccd1 vccd1 sky130_fd_sc_hd__fill_2
XFILLER_7_305 vssd1 vccd1 vssd1 vccd1 sky130_ef_sc_hd__decap_40_12
XTAP_TAPCELL_ROW_53_476 vssd1 vccd1 sky130_fd_sc_hd__tapvpwrvgnd_1
XFILLER_7_349 vssd1 vccd1 vssd1 vccd1 sky130_ef_sc_hd__decap_40_12
XFILLER_38_209 vssd1 vssd1 vccd1 vccd1 sky130_fd_sc_hd__fill_2
XFILLER_14_172 vssd1 vccd1 vssd1 vccd1 sky130_ef_sc_hd__decap_40_12
Xinput11 prescaler[13] vssd1 vssd1 vccd1 vccd1 _0919_/A sky130_fd_sc_hd__buf_1
X_0812_ input7/X _0812_/B vssd1 vssd1 vccd1 vccd1 _0813_/B sky130_fd_sc_hd__nor2_2
X_0743_ _1348_/A _0743_/B vssd1 vssd1 vccd1 vccd1 _0745_/B sky130_fd_sc_hd__xnor2_2
XPHY_EDGE_ROW_26_Left_86 vssd1 vssd1 vccd1 vccd1 sky130_fd_sc_hd__decap_3
XFILLER_16_17 vssd1 vssd1 vccd1 vccd1 sky130_fd_sc_hd__fill_2
X_1226_ _1460_/Q _1327_/C vssd1 vssd1 vccd1 vccd1 _1226_/Y sky130_fd_sc_hd__nand2_2
X_1157_ _0703_/Y _1332_/A1 _1313_/B1 vssd1 vssd1 vccd1 vccd1 _1348_/C sky130_fd_sc_hd__a21o_2
XANTENNA__0881__A _0942_/B vssd1 vssd1 vccd1 vccd1 sky130_fd_sc_hd__diode_2
XANTENNA__1460__CLK _1471_/CLK vssd1 vssd1 vccd1 vccd1 sky130_fd_sc_hd__diode_2
XFILLER_20_164 vssd1 vssd1 vccd1 vccd1 sky130_fd_sc_hd__fill_1
XFILLER_32_27 vssd1 vssd1 vccd1 vccd1 sky130_fd_sc_hd__fill_1
XFILLER_52_245 vssd1 vssd1 vccd1 vccd1 sky130_fd_sc_hd__fill_4
XFILLER_52_289 vssd1 vccd1 vssd1 vccd1 sky130_ef_sc_hd__decap_40_12
X_1088_ _1457_/Q _0854_/B _1345_/A _1456_/Q vssd1 vssd1 vccd1 vccd1 _1114_/B sky130_fd_sc_hd__a22o_2
XTAP_TAPCELL_ROW_50_457 vssd1 vccd1 sky130_fd_sc_hd__tapvpwrvgnd_1
XFILLER_57_57 vssd1 vccd1 vssd1 vccd1 sky130_ef_sc_hd__decap_40_12
XFILLER_28_253 vssd1 vccd1 vssd1 vccd1 sky130_ef_sc_hd__decap_40_12
XFILLER_11_131 vssd1 vssd1 vccd1 vccd1 sky130_fd_sc_hd__fill_8
XFILLER_11_164 vssd1 vssd1 vccd1 vccd1 sky130_fd_sc_hd__fill_2
XFILLER_22_82 vssd1 vssd1 vccd1 vccd1 sky130_fd_sc_hd__fill_2
XFILLER_7_113 vssd1 vccd1 vssd1 vccd1 sky130_ef_sc_hd__decap_40_12
XFILLER_19_242 vssd1 vssd1 vccd1 vccd1 sky130_fd_sc_hd__fill_4
XFILLER_34_234 vssd1 vssd1 vccd1 vccd1 sky130_fd_sc_hd__fill_1
X_1011_ _1011_/A _1011_/B vssd1 vssd1 vccd1 vccd1 _1012_/A sky130_fd_sc_hd__nand2_2
X_0726_ _0820_/A _0727_/B vssd1 vssd1 vccd1 vccd1 _0726_/Y sky130_fd_sc_hd__nand2_2
XFILLER_57_337 vssd1 vccd1 vssd1 vccd1 sky130_ef_sc_hd__decap_40_12
X_1209_ _1214_/A2 _1207_/X _1208_/Y vssd1 vssd1 vccd1 vccd1 _1457_/D sky130_fd_sc_hd__a21oi_2
XFILLER_43_48 vssd1 vssd1 vccd1 vccd1 sky130_fd_sc_hd__fill_1
XFILLER_0_300 vssd1 vssd1 vccd1 vccd1 sky130_fd_sc_hd__fill_8
XFILLER_0_333 vssd1 vssd1 vccd1 vccd1 sky130_fd_sc_hd__fill_2
XFILLER_0_344 vssd1 vssd1 vccd1 vccd1 sky130_fd_sc_hd__fill_1
XANTENNA__1361__D1 _0902_/A vssd1 vssd1 vccd1 vccd1 sky130_fd_sc_hd__diode_2
XANTENNA_input17_A prescaler[6] vssd1 vssd1 vccd1 vccd1 sky130_fd_sc_hd__diode_2
XFILLER_16_201 vssd1 vssd1 vccd1 vccd1 sky130_fd_sc_hd__fill_2
XFILLER_16_223 vssd1 vssd1 vccd1 vccd1 sky130_fd_sc_hd__fill_8
XTAP_TAPCELL_ROW_26_295 vssd1 vccd1 sky130_fd_sc_hd__tapvpwrvgnd_1
XFILLER_12_3 vssd1 vccd1 vssd1 vccd1 sky130_ef_sc_hd__decap_40_12
XFILLER_39_326 vssd1 vssd1 vccd1 vccd1 sky130_fd_sc_hd__fill_2
XFILLER_39_337 vssd1 vssd1 vccd1 vccd1 sky130_fd_sc_hd__fill_2
XFILLER_3_193 vssd1 vccd1 vssd1 vccd1 sky130_ef_sc_hd__decap_40_12
XFILLER_54_307 vssd1 vssd1 vccd1 vccd1 sky130_fd_sc_hd__fill_1
XTAP_TAPCELL_ROW_17_240 vssd1 vccd1 sky130_fd_sc_hd__tapvpwrvgnd_1
XFILLER_22_248 vssd1 vssd1 vccd1 vccd1 sky130_fd_sc_hd__fill_4
X_0709_ _1443_/Q _1439_/A vssd1 vssd1 vccd1 vccd1 _1339_/A sky130_fd_sc_hd__and2_2
XANTENNA_input9_A prescaler[11] vssd1 vssd1 vccd1 vccd1 sky130_fd_sc_hd__diode_2
XFILLER_38_48 vssd1 vssd1 vccd1 vccd1 sky130_fd_sc_hd__fill_2
XFILLER_45_329 vssd1 vssd1 vccd1 vccd1 sky130_fd_sc_hd__fill_1
XFILLER_57_167 vssd1 vssd1 vccd1 vccd1 sky130_fd_sc_hd__fill_1
XPHY_EDGE_ROW_13_Left_73 vssd1 vssd1 vccd1 vccd1 sky130_fd_sc_hd__decap_3
XFILLER_13_237 vssd1 vccd1 vssd1 vccd1 sky130_ef_sc_hd__decap_40_12
XFILLER_53_373 vssd1 vssd1 vccd1 vccd1 sky130_fd_sc_hd__fill_2
XFILLER_9_219 vssd1 vssd1 vccd1 vccd1 sky130_fd_sc_hd__fill_4
XTAP_TAPCELL_ROW_0_130 vssd1 vccd1 sky130_fd_sc_hd__tapvpwrvgnd_1
XFILLER_21_281 vssd1 vssd1 vccd1 vccd1 sky130_fd_sc_hd__fill_4
XTAP_TAPCELL_ROW_23_276 vssd1 vccd1 sky130_fd_sc_hd__tapvpwrvgnd_1
XFILLER_0_141 vssd1 vccd1 vssd1 vccd1 sky130_ef_sc_hd__decap_40_12
XFILLER_48_112 vssd1 vssd1 vccd1 vccd1 sky130_fd_sc_hd__fill_4
XFILLER_48_134 vssd1 vssd1 vccd1 vccd1 sky130_fd_sc_hd__fill_4
XFILLER_44_80 vssd1 vssd1 vccd1 vccd1 sky130_fd_sc_hd__fill_4
XFILLER_8_230 vssd1 vssd1 vccd1 vccd1 sky130_fd_sc_hd__fill_4
X_0991_ _1006_/A _0990_/B _1003_/B vssd1 vssd1 vccd1 vccd1 _0992_/B sky130_fd_sc_hd__o21ba_2
XTAP_TAPCELL_ROW_14_221 vssd1 vccd1 sky130_fd_sc_hd__tapvpwrvgnd_1
XFILLER_8_285 vssd1 vccd1 vssd1 vccd1 sky130_ef_sc_hd__decap_40_12
X_1474_ _1478_/CLK _1474_/D wire142/X vssd1 vssd1 vccd1 vccd1 _1474_/Q sky130_fd_sc_hd__dfrtp_2
X_1543_ _1543_/A vssd1 vssd1 vccd1 vccd1 _1543_/X sky130_fd_sc_hd__buf_2
XFILLER_39_178 vssd1 vccd1 vssd1 vccd1 sky130_ef_sc_hd__decap_40_12
XFILLER_50_321 vssd1 vccd1 vssd1 vccd1 sky130_ef_sc_hd__decap_40_12
XFILLER_50_365 vssd1 vssd1 vccd1 vccd1 sky130_fd_sc_hd__fill_2
XFILLER_54_137 vssd1 vssd1 vccd1 vccd1 sky130_fd_sc_hd__fill_2
XTAP_TAPCELL_ROW_37_368 vssd1 vccd1 sky130_fd_sc_hd__tapvpwrvgnd_1
XTAP_TAPCELL_ROW_20_257 vssd1 vccd1 sky130_fd_sc_hd__tapvpwrvgnd_1
XFILLER_18_307 vssd1 vssd1 vccd1 vccd1 sky130_fd_sc_hd__fill_1
XTAP_TAPCELL_ROW_28_313 vssd1 vccd1 sky130_fd_sc_hd__tapvpwrvgnd_1
XFILLER_53_181 vssd1 vccd1 vssd1 vccd1 sky130_ef_sc_hd__decap_40_12
XTAP_TAPCELL_ROW_11_202 vssd1 vccd1 sky130_fd_sc_hd__tapvpwrvgnd_1
XFILLER_30_60 vssd1 vccd1 vssd1 vccd1 sky130_ef_sc_hd__decap_40_12
XFILLER_30_82 vssd1 vssd1 vccd1 vccd1 sky130_fd_sc_hd__fill_2
XFILLER_5_277 vssd1 vssd1 vccd1 vccd1 sky130_fd_sc_hd__fill_2
Xinput9 prescaler[11] vssd1 vssd1 vccd1 vccd1 input9/X sky130_fd_sc_hd__buf_2
X_1190_ _1190_/A _1190_/B _1195_/B vssd1 vssd1 vccd1 vccd1 _1190_/Y sky130_fd_sc_hd__nor3_2
XFILLER_32_321 vssd1 vssd1 vccd1 vccd1 sky130_fd_sc_hd__fill_4
XTAP_TAPCELL_ROW_34_349 vssd1 vccd1 sky130_fd_sc_hd__tapvpwrvgnd_1
X_0974_ _0979_/B _0984_/A _0979_/C vssd1 vssd1 vccd1 vccd1 _0978_/A sky130_fd_sc_hd__or3_2
XFILLER_19_17 vssd1 vccd1 vssd1 vccd1 sky130_ef_sc_hd__decap_40_12
X_1457_ _1459_/CLK _1457_/D fanout138/X vssd1 vssd1 vccd1 vccd1 _1457_/Q sky130_fd_sc_hd__dfrtp_2
X_1526_ _1535_/A vssd1 vssd1 vccd1 vccd1 _1526_/X sky130_fd_sc_hd__buf_2
XFILLER_27_159 vssd1 vssd1 vccd1 vccd1 sky130_fd_sc_hd__fill_8
X_1388_ _1416_/B _1411_/B vssd1 vssd1 vccd1 vccd1 _1422_/C sky130_fd_sc_hd__nor2_2
XFILLER_35_181 vssd1 vccd1 vssd1 vccd1 sky130_ef_sc_hd__decap_40_12
XFILLER_50_195 vssd1 vssd1 vccd1 vccd1 sky130_fd_sc_hd__fill_1
XFILLER_58_251 vssd1 vssd1 vccd1 vccd1 sky130_fd_sc_hd__fill_1
XFILLER_14_321 vssd1 vccd1 vssd1 vccd1 sky130_ef_sc_hd__decap_40_12
XFILLER_14_365 vssd1 vssd1 vccd1 vccd1 sky130_fd_sc_hd__fill_2
XTAP_TAPCELL_ROW_56_496 vssd1 vccd1 sky130_fd_sc_hd__tapvpwrvgnd_1
XFILLER_25_93 vssd1 vssd1 vccd1 vccd1 sky130_fd_sc_hd__fill_2
X_0690_ _0880_/B vssd1 vssd1 vccd1 vccd1 _0941_/A sky130_fd_sc_hd__inv_2
X_1311_ _0688_/Y _1190_/A _1330_/B1 vssd1 vssd1 vccd1 vccd1 _1311_/Y sky130_fd_sc_hd__o21ai_2
XPHY_EDGE_ROW_47_Left_107 vssd1 vssd1 vccd1 vccd1 sky130_fd_sc_hd__decap_3
XFILLER_2_53 vssd1 vccd1 vssd1 vccd1 sky130_ef_sc_hd__decap_40_12
XFILLER_2_97 vssd1 vccd1 vssd1 vccd1 sky130_ef_sc_hd__decap_40_12
XFILLER_49_273 vssd1 vssd1 vccd1 vccd1 sky130_fd_sc_hd__fill_4
X_1242_ _1462_/Q _1285_/C vssd1 vssd1 vccd1 vccd1 _1242_/Y sky130_fd_sc_hd__nand2_2
X_1173_ _1453_/Q _1174_/B vssd1 vssd1 vccd1 vccd1 _1175_/A sky130_fd_sc_hd__nor2_2
XPHY_EDGE_ROW_56_Left_116 vssd1 vssd1 vccd1 vccd1 sky130_fd_sc_hd__decap_3
XPHY_EDGE_ROW_10_Right_10 vssd1 vssd1 vccd1 vccd1 sky130_fd_sc_hd__decap_3
XFILLER_24_129 vssd1 vssd1 vccd1 vccd1 sky130_fd_sc_hd__fill_1
XANTENNA__0879__A _0953_/B vssd1 vssd1 vccd1 vccd1 sky130_fd_sc_hd__diode_2
X_0957_ _0959_/A _0959_/B vssd1 vssd1 vccd1 vccd1 _0957_/Y sky130_fd_sc_hd__nor2_2
X_0888_ _0890_/A _0890_/B vssd1 vssd1 vccd1 vccd1 _0993_/A sky130_fd_sc_hd__and2_2
XFILLER_46_15 vssd1 vssd1 vccd1 vccd1 sky130_fd_sc_hd__fill_4
XFILLER_15_107 vssd1 vssd1 vccd1 vccd1 sky130_fd_sc_hd__fill_4
XFILLER_55_221 vssd1 vssd1 vccd1 vccd1 sky130_fd_sc_hd__fill_2
XANTENNA__1222__B1 _0715_/B vssd1 vssd1 vccd1 vccd1 sky130_fd_sc_hd__diode_2
XFILLER_23_173 vssd1 vssd1 vccd1 vccd1 sky130_fd_sc_hd__fill_2
XFILLER_7_317 vssd1 vccd1 vssd1 vccd1 sky130_ef_sc_hd__decap_40_12
XANTENNA__0789__A _0942_/B vssd1 vssd1 vccd1 vccd1 sky130_fd_sc_hd__diode_2
XFILLER_11_51 vssd1 vssd1 vccd1 vccd1 sky130_fd_sc_hd__fill_4
XANTENNA__1289__B1 _1330_/B1 vssd1 vssd1 vccd1 vccd1 sky130_fd_sc_hd__diode_2
XFILLER_14_184 vssd1 vccd1 vssd1 vccd1 sky130_ef_sc_hd__decap_40_12
XFILLER_36_70 vssd1 vssd1 vccd1 vccd1 sky130_fd_sc_hd__fill_1
XPHY_EDGE_ROW_1_Left_61 vssd1 vssd1 vccd1 vccd1 sky130_fd_sc_hd__decap_3
XANTENNA__1213__B1 _1332_/A1 vssd1 vssd1 vccd1 vccd1 sky130_fd_sc_hd__diode_2
XFILLER_6_361 vssd1 vssd1 vccd1 vccd1 sky130_fd_sc_hd__fill_2
Xinput12 prescaler[1] vssd1 vssd1 vccd1 vccd1 _1103_/A sky130_fd_sc_hd__clkdlybuf4s25_1
X_0811_ _0880_/B _0811_/B vssd1 vssd1 vccd1 vccd1 _0816_/A sky130_fd_sc_hd__xnor2_2
X_0742_ _1348_/A _0743_/B vssd1 vssd1 vccd1 vccd1 _0757_/A sky130_fd_sc_hd__or2_2
XFILLER_42_3 vssd1 vccd1 vssd1 vccd1 sky130_ef_sc_hd__decap_40_12
XFILLER_16_29 vssd1 vccd1 vssd1 vccd1 sky130_ef_sc_hd__decap_40_12
X_1225_ _1307_/A1 _1307_/A2 _1307_/B1 _1224_/Y vssd1 vssd1 vccd1 vccd1 _1225_/X sky130_fd_sc_hd__o211a_2
X_1156_ _1330_/B1 _1155_/X _1332_/A1 vssd1 vssd1 vccd1 vccd1 _1348_/B sky130_fd_sc_hd__a21oi_2
X_1087_ _1082_/Y _1087_/B _1087_/C _1087_/D vssd1 vssd1 vccd1 vccd1 _1114_/A sky130_fd_sc_hd__nand4b_2
XFILLER_20_121 vssd1 vccd1 vssd1 vccd1 sky130_ef_sc_hd__decap_40_12
XFILLER_4_309 vssd1 vccd1 vssd1 vccd1 sky130_ef_sc_hd__decap_40_12
XFILLER_28_265 vssd1 vccd1 vssd1 vccd1 sky130_ef_sc_hd__decap_40_12
XFILLER_57_69 vssd1 vccd1 vssd1 vccd1 sky130_ef_sc_hd__decap_40_12
XTAP_TAPCELL_ROW_58_503 vssd1 vccd1 sky130_fd_sc_hd__tapvpwrvgnd_1
XFILLER_11_110 vssd1 vssd1 vccd1 vccd1 sky130_fd_sc_hd__fill_2
XFILLER_28_298 vssd1 vssd1 vccd1 vccd1 sky130_fd_sc_hd__fill_1
XFILLER_43_246 vssd1 vccd1 vssd1 vccd1 sky130_ef_sc_hd__decap_40_12
XFILLER_11_187 vssd1 vccd1 vssd1 vccd1 sky130_ef_sc_hd__decap_40_12
XFILLER_22_61 vssd1 vssd1 vccd1 vccd1 sky130_fd_sc_hd__fill_1
XFILLER_7_125 vssd1 vccd1 vssd1 vccd1 sky130_ef_sc_hd__decap_40_12
XFILLER_34_257 vssd1 vssd1 vccd1 vccd1 sky130_fd_sc_hd__fill_1
X_1010_ _0917_/B _1010_/B vssd1 vssd1 vccd1 vccd1 _1011_/B sky130_fd_sc_hd__nand2b_2
XFILLER_8_41 vssd1 vccd1 vssd1 vccd1 sky130_ef_sc_hd__decap_40_12
XFILLER_8_85 vssd1 vccd1 vssd1 vccd1 sky130_ef_sc_hd__decap_40_12
XANTENNA__1449__RESET_B load_slew137/X vssd1 vssd1 vccd1 vccd1 sky130_fd_sc_hd__diode_2
X_0725_ _0739_/B _0730_/A vssd1 vssd1 vccd1 vccd1 _0727_/B sky130_fd_sc_hd__xor2_2
XFILLER_57_305 vssd1 vccd1 vssd1 vccd1 sky130_ef_sc_hd__decap_40_12
XFILLER_57_349 vssd1 vccd1 vssd1 vccd1 sky130_ef_sc_hd__decap_40_12
X_1208_ _1457_/Q _1214_/A2 _1320_/C1 vssd1 vssd1 vccd1 vccd1 _1208_/Y sky130_fd_sc_hd__o21ai_2
X_1139_ _1190_/A _1137_/Y _1138_/X _0902_/A vssd1 vssd1 vccd1 vccd1 _1139_/X sky130_fd_sc_hd__a211o_2
XFILLER_4_139 vssd1 vssd1 vccd1 vccd1 sky130_fd_sc_hd__fill_1
XANTENNA_fanout97_A _1127_/Y vssd1 vssd1 vccd1 vccd1 sky130_fd_sc_hd__diode_2
XFILLER_48_305 vssd1 vssd1 vccd1 vccd1 sky130_fd_sc_hd__fill_2
XFILLER_16_257 vssd1 vssd1 vccd1 vccd1 sky130_fd_sc_hd__fill_1
XFILLER_17_50 vssd1 vssd1 vccd1 vccd1 sky130_fd_sc_hd__fill_4
XTAP_TAPCELL_ROW_3_150 vssd1 vccd1 sky130_fd_sc_hd__tapvpwrvgnd_1
XFILLER_31_216 vssd1 vssd1 vccd1 vccd1 sky130_fd_sc_hd__fill_8
XTAP_TAPCELL_ROW_26_296 vssd1 vccd1 sky130_fd_sc_hd__tapvpwrvgnd_1
XFILLER_3_161 vssd1 vssd1 vccd1 vccd1 sky130_fd_sc_hd__fill_4
XANTENNA__1450__CLK _1463_/CLK vssd1 vssd1 vccd1 vccd1 sky130_fd_sc_hd__diode_2
XTAP_TAPCELL_ROW_17_241 vssd1 vccd1 sky130_fd_sc_hd__tapvpwrvgnd_1
XPHY_EDGE_ROW_8_Right_8 vssd1 vssd1 vccd1 vccd1 sky130_fd_sc_hd__decap_3
XFILLER_1_109 vssd1 vssd1 vccd1 vccd1 sky130_fd_sc_hd__fill_2
XFILLER_38_27 vssd1 vssd1 vccd1 vccd1 sky130_fd_sc_hd__fill_1
X_0708_ _0705_/Y _1341_/B _0711_/A vssd1 vssd1 vccd1 vccd1 _1439_/A sky130_fd_sc_hd__a21o_2
XPHY_EDGE_ROW_39_Right_39 vssd1 vssd1 vccd1 vccd1 sky130_fd_sc_hd__decap_3
XFILLER_38_360 vssd1 vssd1 vccd1 vccd1 sky130_fd_sc_hd__fill_4
XFILLER_54_15 vssd1 vccd1 vssd1 vccd1 sky130_ef_sc_hd__decap_40_12
XFILLER_57_113 vssd1 vccd1 vssd1 vccd1 sky130_ef_sc_hd__decap_40_12
XTAP_TAPCELL_ROW_0_131 vssd1 vccd1 sky130_fd_sc_hd__tapvpwrvgnd_1
XTAP_TAPCELL_ROW_0_120 vssd1 vccd1 sky130_fd_sc_hd__tapvpwrvgnd_1
XTAP_TAPCELL_ROW_23_277 vssd1 vccd1 sky130_fd_sc_hd__tapvpwrvgnd_1
XPHY_EDGE_ROW_48_Right_48 vssd1 vssd1 vccd1 vccd1 sky130_fd_sc_hd__decap_3
XPHY_EDGE_ROW_57_Right_57 vssd1 vssd1 vccd1 vccd1 sky130_fd_sc_hd__decap_3
XFILLER_0_153 vssd1 vccd1 vssd1 vccd1 sky130_ef_sc_hd__decap_40_12
XFILLER_0_197 vssd1 vssd1 vccd1 vccd1 sky130_fd_sc_hd__fill_4
XFILLER_8_297 vssd1 vssd1 vccd1 vccd1 sky130_fd_sc_hd__fill_8
X_0990_ _1003_/B _0990_/B vssd1 vssd1 vccd1 vccd1 _1006_/C sky130_fd_sc_hd__or2_2
XTAP_TAPCELL_ROW_14_222 vssd1 vccd1 sky130_fd_sc_hd__tapvpwrvgnd_1
XPHY_EDGE_ROW_30_Left_90 vssd1 vssd1 vccd1 vccd1 sky130_fd_sc_hd__decap_3
X_1473_ _1478_/CLK _1473_/D input6/X vssd1 vssd1 vccd1 vccd1 _1473_/Q sky130_fd_sc_hd__dfrtp_2
X_1542_ _1542_/A vssd1 vssd1 vccd1 vccd1 _1542_/X sky130_fd_sc_hd__buf_2
XFILLER_50_333 vssd1 vccd1 vssd1 vccd1 sky130_ef_sc_hd__decap_40_12
XFILLER_50_355 vssd1 vssd1 vccd1 vccd1 sky130_fd_sc_hd__fill_1
XTAP_TAPCELL_ROW_37_369 vssd1 vccd1 sky130_fd_sc_hd__tapvpwrvgnd_1
XTAP_TAPCELL_ROW_20_258 vssd1 vccd1 sky130_fd_sc_hd__tapvpwrvgnd_1
XFILLER_26_341 vssd1 vssd1 vccd1 vccd1 sky130_fd_sc_hd__fill_4
XFILLER_53_193 vssd1 vccd1 vssd1 vccd1 sky130_ef_sc_hd__decap_40_12
XTAP_TAPCELL_ROW_28_314 vssd1 vccd1 sky130_fd_sc_hd__tapvpwrvgnd_1
XTAP_TAPCELL_ROW_11_203 vssd1 vccd1 sky130_fd_sc_hd__tapvpwrvgnd_1
XFILLER_30_72 vssd1 vssd1 vccd1 vccd1 sky130_fd_sc_hd__fill_1
XFILLER_5_223 vssd1 vssd1 vccd1 vccd1 sky130_fd_sc_hd__fill_1
XFILLER_36_127 vssd1 vssd1 vccd1 vccd1 sky130_fd_sc_hd__fill_1
XFILLER_36_149 vssd1 vssd1 vccd1 vccd1 sky130_fd_sc_hd__fill_4
XFILLER_44_182 vssd1 vssd1 vccd1 vccd1 sky130_fd_sc_hd__fill_1
X_0973_ _0973_/A _0973_/B vssd1 vssd1 vccd1 vccd1 _0979_/C sky130_fd_sc_hd__xor2_2
XFILLER_19_29 vssd1 vssd1 vccd1 vccd1 sky130_fd_sc_hd__fill_2
X_1387_ _1478_/Q _1442_/B vssd1 vssd1 vccd1 vccd1 _1411_/B sky130_fd_sc_hd__nor2_2
X_1456_ _1459_/CLK _1456_/D fanout138/X vssd1 vssd1 vccd1 vccd1 _1456_/Q sky130_fd_sc_hd__dfrtp_2
X_1525_ _1543_/A vssd1 vssd1 vccd1 vccd1 _1525_/X sky130_fd_sc_hd__buf_2
XANTENNA__1313__A2 _1332_/A1 vssd1 vssd1 vccd1 vccd1 sky130_fd_sc_hd__diode_2
XFILLER_35_39 vssd1 vssd1 vccd1 vccd1 sky130_fd_sc_hd__fill_1
XFILLER_35_193 vssd1 vssd1 vccd1 vccd1 sky130_fd_sc_hd__fill_4
XFILLER_50_141 vssd1 vccd1 vssd1 vccd1 sky130_ef_sc_hd__decap_40_12
XFILLER_4_6 vssd1 vccd1 vssd1 vccd1 sky130_ef_sc_hd__decap_40_12
XFILLER_14_333 vssd1 vccd1 vssd1 vccd1 sky130_ef_sc_hd__decap_40_12
XFILLER_41_152 vssd1 vccd1 vssd1 vccd1 sky130_ef_sc_hd__decap_40_12
XFILLER_1_281 vssd1 vccd1 vssd1 vccd1 sky130_ef_sc_hd__decap_40_12
X_1310_ _1471_/Q _1310_/A2 _1309_/X _1340_/A vssd1 vssd1 vccd1 vccd1 _1471_/D sky130_fd_sc_hd__o211a_2
X_1241_ _1241_/A _1255_/C vssd1 vssd1 vccd1 vccd1 _1241_/X sky130_fd_sc_hd__or2_2
XFILLER_17_160 vssd1 vssd1 vccd1 vccd1 sky130_fd_sc_hd__fill_2
XFILLER_2_65 vssd1 vccd1 vssd1 vccd1 sky130_ef_sc_hd__decap_40_12
X_1172_ _1180_/A1 _1170_/X _1171_/Y vssd1 vssd1 vccd1 vccd1 _1452_/D sky130_fd_sc_hd__a21oi_2
XFILLER_20_347 vssd1 vssd1 vccd1 vccd1 sky130_fd_sc_hd__fill_1
X_0956_ _0956_/A _0956_/B vssd1 vssd1 vccd1 vccd1 _0959_/B sky130_fd_sc_hd__xnor2_2
X_0887_ _0887_/A _0887_/B vssd1 vssd1 vccd1 vccd1 _0890_/B sky130_fd_sc_hd__xnor2_2
X_1439_ _1439_/A _1439_/B _1439_/C vssd1 vssd1 vccd1 vccd1 _1439_/X sky130_fd_sc_hd__and3_2
XFILLER_15_119 vssd1 vssd1 vccd1 vccd1 sky130_fd_sc_hd__fill_1
XFILLER_55_277 vssd1 vssd1 vccd1 vccd1 sky130_fd_sc_hd__fill_2
XFILLER_7_329 vssd1 vssd1 vccd1 vccd1 sky130_fd_sc_hd__fill_4
XFILLER_46_233 vssd1 vssd1 vccd1 vccd1 sky130_fd_sc_hd__fill_2
XFILLER_46_266 vssd1 vccd1 vssd1 vccd1 sky130_ef_sc_hd__decap_40_12
XTAP_TAPCELL_ROW_44_412 vssd1 vccd1 sky130_fd_sc_hd__tapvpwrvgnd_1
XFILLER_14_141 vssd1 vssd1 vccd1 vccd1 sky130_fd_sc_hd__fill_2
XFILLER_36_93 vssd1 vssd1 vccd1 vccd1 sky130_fd_sc_hd__fill_2
XFILLER_52_81 vssd1 vssd1 vccd1 vccd1 sky130_fd_sc_hd__fill_2
Xinput13 prescaler[2] vssd1 vssd1 vccd1 vccd1 _0783_/A sky130_fd_sc_hd__clkdlybuf4s25_1
X_0810_ _0810_/A _0810_/B vssd1 vssd1 vccd1 vccd1 _0846_/A sky130_fd_sc_hd__xor2_2
XANTENNA__1213__A1 _1330_/B1 vssd1 vssd1 vccd1 vccd1 sky130_fd_sc_hd__diode_2
XFILLER_6_373 vssd1 vssd1 vccd1 vccd1 sky130_fd_sc_hd__fill_2
X_0741_ _0818_/A _0741_/B vssd1 vssd1 vccd1 vccd1 _0743_/B sky130_fd_sc_hd__xnor2_2
XFILLER_37_233 vssd1 vssd1 vccd1 vccd1 sky130_fd_sc_hd__fill_1
X_1224_ _1460_/Q _1232_/C vssd1 vssd1 vccd1 vccd1 _1224_/Y sky130_fd_sc_hd__xnor2_2
X_1155_ _1450_/Q _1190_/A _1205_/B _1152_/Y _1154_/X vssd1 vssd1 vccd1 vccd1 _1155_/X
+ sky130_fd_sc_hd__a32o_2
X_1086_ _1458_/Q _1353_/A _0854_/B _1457_/Q vssd1 vssd1 vccd1 vccd1 _1087_/D sky130_fd_sc_hd__o22a_2
XFILLER_20_133 vssd1 vssd1 vccd1 vccd1 sky130_fd_sc_hd__fill_1
XFILLER_20_199 vssd1 vccd1 vssd1 vccd1 sky130_ef_sc_hd__decap_40_12
XFILLER_32_29 vssd1 vccd1 vssd1 vccd1 sky130_ef_sc_hd__decap_40_12
X_0939_ _0939_/A _0939_/B vssd1 vssd1 vccd1 vccd1 _0940_/B sky130_fd_sc_hd__nor2_2
XFILLER_57_15 vssd1 vccd1 vssd1 vccd1 sky130_ef_sc_hd__decap_40_12
XFILLER_28_211 vssd1 vssd1 vccd1 vccd1 sky130_fd_sc_hd__fill_2
XFILLER_28_277 vssd1 vssd1 vccd1 vccd1 sky130_fd_sc_hd__fill_8
XFILLER_43_203 vssd1 vssd1 vccd1 vccd1 sky130_fd_sc_hd__fill_1
XFILLER_43_225 vssd1 vssd1 vccd1 vccd1 sky130_fd_sc_hd__fill_1
Xclkbuf_2_2__f_clk clkbuf_0_clk/X vssd1 vssd1 vccd1 vccd1 _1471_/CLK sky130_fd_sc_hd__clkbuf_16
XTAP_TAPCELL_ROW_58_504 vssd1 vccd1 sky130_fd_sc_hd__tapvpwrvgnd_1
XFILLER_43_258 vssd1 vssd1 vccd1 vccd1 sky130_fd_sc_hd__fill_2
XFILLER_11_199 vssd1 vssd1 vccd1 vccd1 sky130_fd_sc_hd__fill_4
XFILLER_7_137 vssd1 vccd1 vssd1 vccd1 sky130_ef_sc_hd__decap_40_12
XTAP_TAPCELL_ROW_6_170 vssd1 vccd1 sky130_fd_sc_hd__tapvpwrvgnd_1
XFILLER_47_70 vssd1 vccd1 vssd1 vccd1 sky130_ef_sc_hd__decap_40_12
XFILLER_8_53 vssd1 vccd1 vssd1 vccd1 sky130_ef_sc_hd__decap_40_12
XFILLER_8_97 vssd1 vccd1 vssd1 vccd1 sky130_ef_sc_hd__decap_40_12
X_0724_ _1530_/A input4/X input2/X vssd1 vssd1 vccd1 vccd1 _0724_/X sky130_fd_sc_hd__or3b_2
XFILLER_57_317 vssd1 vccd1 vssd1 vccd1 sky130_ef_sc_hd__decap_40_12
X_1207_ _1329_/A _1205_/Y _1206_/X _0902_/A vssd1 vssd1 vccd1 vccd1 _1207_/X sky130_fd_sc_hd__a211o_2
XFILLER_33_291 vssd1 vssd1 vccd1 vccd1 sky130_fd_sc_hd__fill_1
X_1138_ _1206_/A1 _1206_/A2 _1206_/B1 _1136_/Y vssd1 vssd1 vccd1 vccd1 _1138_/X sky130_fd_sc_hd__o211a_2
X_1069_ _1069_/A _1069_/B vssd1 vssd1 vccd1 vccd1 _1070_/D sky130_fd_sc_hd__xnor2_2
XFILLER_0_335 vssd1 vssd1 vccd1 vccd1 sky130_fd_sc_hd__fill_1
XFILLER_16_203 vssd1 vssd1 vccd1 vccd1 sky130_fd_sc_hd__fill_1
XFILLER_17_84 vssd1 vssd1 vccd1 vccd1 sky130_fd_sc_hd__fill_4
XFILLER_56_361 vssd1 vssd1 vccd1 vccd1 sky130_fd_sc_hd__fill_2
XTAP_TAPCELL_ROW_3_151 vssd1 vccd1 sky130_fd_sc_hd__tapvpwrvgnd_1
XFILLER_33_94 vssd1 vssd1 vccd1 vccd1 sky130_fd_sc_hd__fill_4
XTAP_TAPCELL_ROW_26_297 vssd1 vccd1 sky130_fd_sc_hd__tapvpwrvgnd_1
XFILLER_39_328 vssd1 vssd1 vccd1 vccd1 sky130_fd_sc_hd__fill_1
XFILLER_39_339 vssd1 vssd1 vccd1 vccd1 sky130_fd_sc_hd__fill_1
XFILLER_54_309 vssd1 vccd1 vssd1 vccd1 sky130_ef_sc_hd__decap_40_12
XTAP_TAPCELL_ROW_17_242 vssd1 vccd1 sky130_fd_sc_hd__tapvpwrvgnd_1
Xmax_cap143 _0858_/B vssd1 vssd1 vccd1 vccd1 _0818_/A sky130_fd_sc_hd__buf_2
X_0707_ _1477_/Q _1427_/B vssd1 vssd1 vccd1 vccd1 _1341_/B sky130_fd_sc_hd__and2b_2
XFILLER_57_125 vssd1 vccd1 vssd1 vccd1 sky130_ef_sc_hd__decap_40_12
XFILLER_54_27 vssd1 vssd1 vccd1 vccd1 sky130_fd_sc_hd__fill_1
XFILLER_57_169 vssd1 vccd1 vssd1 vccd1 sky130_ef_sc_hd__decap_40_12
XTAP_TAPCELL_ROW_0_132 vssd1 vccd1 sky130_fd_sc_hd__tapvpwrvgnd_1
XTAP_TAPCELL_ROW_0_121 vssd1 vccd1 sky130_fd_sc_hd__tapvpwrvgnd_1
XTAP_TAPCELL_ROW_23_278 vssd1 vccd1 sky130_fd_sc_hd__tapvpwrvgnd_1
XFILLER_0_165 vssd1 vssd1 vccd1 vccd1 sky130_fd_sc_hd__fill_2
XFILLER_36_309 vssd1 vccd1 vssd1 vccd1 sky130_ef_sc_hd__decap_40_12
XTAP_TAPCELL_ROW_14_223 vssd1 vccd1 sky130_fd_sc_hd__tapvpwrvgnd_1
XFILLER_12_294 vssd1 vccd1 vssd1 vccd1 sky130_ef_sc_hd__decap_40_12
XANTENNA__1315__C _1327_/C vssd1 vssd1 vccd1 vccd1 sky130_fd_sc_hd__diode_2
XFILLER_39_125 vssd1 vssd1 vccd1 vccd1 sky130_fd_sc_hd__fill_2
X_1472_ _1478_/CLK _1472_/D load_slew140/X vssd1 vssd1 vccd1 vccd1 _1472_/Q sky130_fd_sc_hd__dfrtp_2
X_1541_ _1541_/A vssd1 vssd1 vccd1 vccd1 _1541_/X sky130_fd_sc_hd__buf_2
XFILLER_39_169 vssd1 vssd1 vccd1 vccd1 sky130_fd_sc_hd__fill_2
XFILLER_54_139 vssd1 vssd1 vccd1 vccd1 sky130_fd_sc_hd__fill_1
XFILLER_10_209 vssd1 vssd1 vccd1 vccd1 sky130_fd_sc_hd__fill_4
XFILLER_40_18 vssd1 vssd1 vccd1 vccd1 sky130_fd_sc_hd__fill_8
XFILLER_50_301 vssd1 vssd1 vccd1 vccd1 sky130_fd_sc_hd__fill_4
XFILLER_50_345 vssd1 vssd1 vccd1 vccd1 sky130_fd_sc_hd__fill_8
XFILLER_40_29 vssd1 vssd1 vccd1 vccd1 sky130_fd_sc_hd__fill_4
XFILLER_49_16 vssd1 vssd1 vccd1 vccd1 sky130_fd_sc_hd__fill_8
XTAP_TAPCELL_ROW_20_259 vssd1 vccd1 sky130_fd_sc_hd__tapvpwrvgnd_1
XFILLER_18_309 vssd1 vccd1 vssd1 vccd1 sky130_ef_sc_hd__decap_40_12
XFILLER_45_117 vssd1 vssd1 vccd1 vccd1 sky130_fd_sc_hd__fill_2
XFILLER_41_323 vssd1 vssd1 vccd1 vccd1 sky130_fd_sc_hd__fill_2
XFILLER_45_128 vssd1 vccd1 vssd1 vccd1 sky130_ef_sc_hd__decap_40_12
XFILLER_53_161 vssd1 vssd1 vccd1 vccd1 sky130_fd_sc_hd__fill_4
XFILLER_5_279 vssd1 vssd1 vccd1 vccd1 sky130_fd_sc_hd__fill_1
XFILLER_17_320 vssd1 vccd1 vssd1 vccd1 sky130_ef_sc_hd__decap_40_12
XFILLER_29_180 vssd1 vssd1 vccd1 vccd1 sky130_fd_sc_hd__fill_1
XFILLER_51_109 vssd1 vssd1 vccd1 vccd1 sky130_fd_sc_hd__fill_2
XFILLER_55_81 vssd1 vccd1 vssd1 vccd1 sky130_ef_sc_hd__decap_40_12
X_0972_ _0982_/A _0986_/A vssd1 vssd1 vccd1 vccd1 _0984_/A sky130_fd_sc_hd__and2_2
X_1524_ _1530_/A vssd1 vssd1 vccd1 vccd1 _1524_/X sky130_fd_sc_hd__buf_2
XFILLER_27_117 vssd1 vssd1 vccd1 vccd1 sky130_fd_sc_hd__fill_1
XFILLER_59_209 vssd1 vssd1 vccd1 vccd1 sky130_fd_sc_hd__fill_2
X_1386_ _1477_/Q _1392_/B vssd1 vssd1 vccd1 vccd1 _1442_/B sky130_fd_sc_hd__or2_2
X_1455_ _1463_/CLK _1455_/D load_slew137/X vssd1 vssd1 vccd1 vccd1 _1455_/Q sky130_fd_sc_hd__dfrtp_2
XANTENNA__1463__CLK _1463_/CLK vssd1 vssd1 vccd1 vccd1 sky130_fd_sc_hd__diode_2
XFILLER_23_345 vssd1 vssd1 vccd1 vccd1 sky130_fd_sc_hd__fill_2
XFILLER_50_153 vssd1 vccd1 vssd1 vccd1 sky130_ef_sc_hd__decap_40_12
XFILLER_50_197 vssd1 vccd1 vssd1 vccd1 sky130_ef_sc_hd__decap_40_12
XFILLER_2_249 vssd1 vssd1 vccd1 vccd1 sky130_fd_sc_hd__fill_2
XFILLER_18_139 vssd1 vssd1 vccd1 vccd1 sky130_fd_sc_hd__fill_1
XFILLER_33_109 vssd1 vssd1 vccd1 vccd1 sky130_fd_sc_hd__fill_2
XFILLER_58_253 vssd1 vccd1 vssd1 vccd1 sky130_ef_sc_hd__decap_40_12
XFILLER_14_345 vssd1 vssd1 vccd1 vccd1 sky130_fd_sc_hd__fill_4
XFILLER_25_95 vssd1 vssd1 vccd1 vccd1 sky130_fd_sc_hd__fill_1
XFILLER_41_142 vssd1 vssd1 vccd1 vccd1 sky130_fd_sc_hd__fill_4
XFILLER_41_164 vssd1 vssd1 vccd1 vccd1 sky130_fd_sc_hd__fill_4
XFILLER_41_94 vssd1 vssd1 vccd1 vccd1 sky130_fd_sc_hd__fill_8
XFILLER_51_9 vssd1 vccd1 vssd1 vccd1 sky130_ef_sc_hd__decap_40_12
XANTENNA__1146__B _1205_/B vssd1 vssd1 vccd1 vccd1 sky130_fd_sc_hd__diode_2
XFILLER_1_293 vssd1 vccd1 vssd1 vccd1 sky130_ef_sc_hd__decap_40_12
XFILLER_2_77 vssd1 vssd1 vccd1 vccd1 sky130_fd_sc_hd__fill_4
XFILLER_37_7 vssd1 vssd1 vccd1 vccd1 sky130_fd_sc_hd__fill_1
X_1240_ _1462_/Q _1240_/B vssd1 vssd1 vccd1 vccd1 _1255_/C sky130_fd_sc_hd__and2_2
X_1171_ _1452_/Q _1180_/A1 _1320_/C1 vssd1 vssd1 vccd1 vccd1 _1171_/Y sky130_fd_sc_hd__o21ai_2
XFILLER_32_131 vssd1 vssd1 vccd1 vccd1 sky130_fd_sc_hd__fill_8
XTAP_TAPCELL_ROW_47_432 vssd1 vccd1 sky130_fd_sc_hd__tapvpwrvgnd_1
XFILLER_20_304 vssd1 vssd1 vccd1 vccd1 sky130_fd_sc_hd__fill_4
X_0955_ _0965_/A _0965_/B vssd1 vssd1 vccd1 vccd1 _0959_/A sky130_fd_sc_hd__or2_2
X_0886_ _0887_/B _0887_/A vssd1 vssd1 vccd1 vccd1 _0989_/B sky130_fd_sc_hd__and2b_2
XTAP_TAPCELL_ROW_30_321 vssd1 vccd1 sky130_fd_sc_hd__tapvpwrvgnd_1
XFILLER_55_223 vssd1 vssd1 vccd1 vccd1 sky130_fd_sc_hd__fill_1
X_1369_ _1093_/X _1453_/D _1464_/D _1068_/B vssd1 vssd1 vccd1 vccd1 _1370_/D sky130_fd_sc_hd__o22a_2
X_1438_ _1438_/A _1438_/B _1438_/C _1438_/D vssd1 vssd1 vccd1 vccd1 _1438_/X sky130_fd_sc_hd__and4_2
XFILLER_11_304 vssd1 vccd1 vssd1 vccd1 sky130_ef_sc_hd__decap_40_12
XFILLER_11_337 vssd1 vccd1 vssd1 vccd1 sky130_ef_sc_hd__decap_40_12
XANTENNA__1207__C1 _0902_/A vssd1 vssd1 vccd1 vccd1 sky130_fd_sc_hd__diode_2
XFILLER_46_278 vssd1 vssd1 vccd1 vccd1 sky130_fd_sc_hd__fill_4
XTAP_TAPCELL_ROW_44_413 vssd1 vccd1 sky130_fd_sc_hd__tapvpwrvgnd_1
XFILLER_14_197 vssd1 vssd1 vccd1 vccd1 sky130_fd_sc_hd__fill_8
Xinput14 prescaler[3] vssd1 vssd1 vccd1 vccd1 _1366_/A sky130_fd_sc_hd__buf_2
X_0740_ _0818_/A _0741_/B vssd1 vssd1 vccd1 vccd1 _0740_/Y sky130_fd_sc_hd__nand2_2
XFILLER_6_363 vssd1 vssd1 vccd1 vccd1 sky130_fd_sc_hd__fill_1
X_1223_ _1237_/A2 _1221_/X _1222_/Y vssd1 vssd1 vccd1 vccd1 _1459_/D sky130_fd_sc_hd__a21oi_2
X_1154_ _1206_/A1 _1206_/A2 _1206_/B1 _1153_/X vssd1 vssd1 vccd1 vccd1 _1154_/X sky130_fd_sc_hd__o211a_2
XTAP_TAPCELL_ROW_9_190 vssd1 vccd1 sky130_fd_sc_hd__tapvpwrvgnd_1
X_1085_ _1082_/Y _1087_/C _1087_/B vssd1 vssd1 vccd1 vccd1 _1085_/X sky130_fd_sc_hd__o21a_2
XFILLER_20_145 vssd1 vssd1 vccd1 vccd1 sky130_fd_sc_hd__fill_2
XFILLER_20_156 vssd1 vssd1 vccd1 vccd1 sky130_fd_sc_hd__fill_8
X_0938_ _1018_/B _0938_/B vssd1 vssd1 vccd1 vccd1 _1020_/A sky130_fd_sc_hd__nor2_2
X_0869_ _0869_/A _0869_/B _0870_/B vssd1 vssd1 vccd1 vccd1 _0869_/X sky130_fd_sc_hd__and3_2
XFILLER_57_27 vssd1 vccd1 vssd1 vccd1 sky130_ef_sc_hd__decap_40_12
XTAP_TAPCELL_ROW_58_505 vssd1 vccd1 sky130_fd_sc_hd__tapvpwrvgnd_1
XFILLER_11_145 vssd1 vccd1 vssd1 vccd1 sky130_ef_sc_hd__decap_40_12
XFILLER_11_178 vssd1 vssd1 vccd1 vccd1 sky130_fd_sc_hd__fill_1
XFILLER_22_41 vssd1 vssd1 vccd1 vccd1 sky130_fd_sc_hd__fill_4
XFILLER_51_281 vssd1 vccd1 vssd1 vccd1 sky130_ef_sc_hd__decap_40_12
XFILLER_7_105 vssd1 vssd1 vccd1 vccd1 sky130_fd_sc_hd__fill_4
XFILLER_22_85 vssd1 vssd1 vccd1 vccd1 sky130_fd_sc_hd__fill_4
XFILLER_3_333 vssd1 vssd1 vccd1 vccd1 sky130_fd_sc_hd__fill_2
XFILLER_7_149 vssd1 vccd1 vssd1 vccd1 sky130_ef_sc_hd__decap_40_12
XFILLER_14_9 vssd1 vssd1 vccd1 vccd1 sky130_fd_sc_hd__fill_4
XFILLER_47_82 vssd1 vccd1 vssd1 vccd1 sky130_ef_sc_hd__decap_40_12
XTAP_TAPCELL_ROW_6_171 vssd1 vccd1 sky130_fd_sc_hd__tapvpwrvgnd_1
XFILLER_19_278 vssd1 vssd1 vccd1 vccd1 sky130_fd_sc_hd__fill_2
XANTENNA__0945__A1 _0943_/A vssd1 vssd1 vccd1 vccd1 sky130_fd_sc_hd__diode_2
XFILLER_8_65 vssd1 vccd1 vssd1 vccd1 sky130_ef_sc_hd__decap_40_12
X_0723_ input4/X input2/X input1/X vssd1 vssd1 vccd1 vccd1 _0723_/X sky130_fd_sc_hd__and3b_2
XFILLER_6_193 vssd1 vssd1 vccd1 vccd1 sky130_fd_sc_hd__fill_2
XFILLER_57_329 vssd1 vssd1 vccd1 vccd1 sky130_fd_sc_hd__fill_4
X_1206_ _1206_/A1 _1206_/A2 _1206_/B1 _1204_/Y vssd1 vssd1 vccd1 vccd1 _1206_/X sky130_fd_sc_hd__o211a_2
X_1137_ _1448_/Q _1205_/B vssd1 vssd1 vccd1 vccd1 _1137_/Y sky130_fd_sc_hd__nand2_2
XFILLER_40_218 vssd1 vssd1 vccd1 vccd1 sky130_fd_sc_hd__fill_2
X_1068_ _1464_/Q _1068_/B vssd1 vssd1 vccd1 vccd1 _1070_/C sky130_fd_sc_hd__xnor2_2
XFILLER_0_369 vssd1 vssd1 vccd1 vccd1 sky130_fd_sc_hd__fill_2
XFILLER_48_307 vssd1 vssd1 vccd1 vccd1 sky130_fd_sc_hd__fill_1
XFILLER_24_281 vssd1 vssd1 vccd1 vccd1 sky130_fd_sc_hd__fill_4
XFILLER_31_207 vssd1 vssd1 vccd1 vccd1 sky130_fd_sc_hd__fill_2
XFILLER_31_229 vssd1 vssd1 vccd1 vccd1 sky130_fd_sc_hd__fill_1
XFILLER_56_373 vssd1 vssd1 vccd1 vccd1 sky130_fd_sc_hd__fill_2
XTAP_TAPCELL_ROW_26_298 vssd1 vccd1 sky130_fd_sc_hd__tapvpwrvgnd_1
XANTENNA_max_cap135_A input7/X vssd1 vssd1 vccd1 vccd1 sky130_fd_sc_hd__diode_2
XFILLER_58_81 vssd1 vssd1 vccd1 vccd1 sky130_fd_sc_hd__fill_2
XFILLER_15_281 vssd1 vssd1 vccd1 vccd1 sky130_fd_sc_hd__fill_4
Xmax_cap144 _0750_/B vssd1 vssd1 vccd1 vccd1 _0820_/A sky130_fd_sc_hd__buf_4
X_0706_ _1418_/A _1384_/C vssd1 vssd1 vccd1 vccd1 _1427_/B sky130_fd_sc_hd__nor2_2
XANTENNA__1343__A1 _0771_/A vssd1 vssd1 vccd1 vccd1 sky130_fd_sc_hd__diode_2
XFILLER_38_29 vssd1 vssd1 vccd1 vccd1 sky130_fd_sc_hd__fill_4
XFILLER_57_137 vssd1 vccd1 vssd1 vccd1 sky130_ef_sc_hd__decap_40_12
XTAP_TAPCELL_ROW_0_122 vssd1 vccd1 sky130_fd_sc_hd__tapvpwrvgnd_1
XFILLER_21_273 vssd1 vssd1 vccd1 vccd1 sky130_fd_sc_hd__fill_2
XTAP_TAPCELL_ROW_23_279 vssd1 vccd1 sky130_fd_sc_hd__tapvpwrvgnd_1
XANTENNA_input15_A prescaler[4] vssd1 vssd1 vccd1 vccd1 sky130_fd_sc_hd__diode_2
XFILLER_44_321 vssd1 vssd1 vccd1 vccd1 sky130_fd_sc_hd__fill_4
XFILLER_48_148 vssd1 vccd1 vssd1 vccd1 sky130_ef_sc_hd__decap_40_12
XFILLER_44_365 vssd1 vssd1 vccd1 vccd1 sky130_fd_sc_hd__fill_2
XFILLER_44_72 vssd1 vssd1 vccd1 vccd1 sky130_fd_sc_hd__fill_2
XFILLER_8_211 vssd1 vssd1 vccd1 vccd1 sky130_fd_sc_hd__fill_1
XFILLER_5_55 vssd1 vssd1 vccd1 vccd1 sky130_fd_sc_hd__fill_1
X_1540_ _1543_/A vssd1 vssd1 vccd1 vccd1 _1540_/X sky130_fd_sc_hd__buf_2
XFILLER_10_3 vssd1 vccd1 vssd1 vccd1 sky130_ef_sc_hd__decap_40_12
X_1471_ _1471_/CLK _1471_/D wire142/X vssd1 vssd1 vccd1 vccd1 _1471_/Q sky130_fd_sc_hd__dfrtp_2
XFILLER_35_343 vssd1 vssd1 vccd1 vccd1 sky130_fd_sc_hd__fill_4
XFILLER_47_181 vssd1 vssd1 vccd1 vccd1 sky130_fd_sc_hd__fill_2
XFILLER_47_192 vssd1 vssd1 vccd1 vccd1 sky130_fd_sc_hd__fill_1
XPHY_EDGE_ROW_17_Left_77 vssd1 vssd1 vccd1 vccd1 sky130_fd_sc_hd__decap_3
XANTENNA__1473__RESET_B input6/X vssd1 vssd1 vccd1 vccd1 sky130_fd_sc_hd__diode_2
XANTENNA_input7_A prescaler[0] vssd1 vssd1 vccd1 vccd1 sky130_fd_sc_hd__diode_2
XTAP_TAPCELL_ROW_36_360 vssd1 vccd1 sky130_fd_sc_hd__tapvpwrvgnd_1
XANTENNA__1252__B1 _0715_/B vssd1 vssd1 vccd1 vccd1 sky130_fd_sc_hd__diode_2
XFILLER_5_225 vssd1 vccd1 vssd1 vccd1 sky130_ef_sc_hd__decap_40_12
XFILLER_30_85 vssd1 vccd1 vssd1 vccd1 sky130_ef_sc_hd__decap_40_12
XFILLER_17_332 vssd1 vssd1 vccd1 vccd1 sky130_fd_sc_hd__fill_4
XFILLER_55_93 vssd1 vccd1 vssd1 vccd1 sky130_ef_sc_hd__decap_40_12
X_0971_ _0985_/B _0971_/B vssd1 vssd1 vccd1 vccd1 _0986_/A sky130_fd_sc_hd__and2b_2
X_1454_ _1459_/CLK _1454_/D fanout138/X vssd1 vssd1 vccd1 vccd1 _1454_/Q sky130_fd_sc_hd__dfrtp_2
X_1523_ _1541_/A vssd1 vssd1 vccd1 vccd1 _1523_/X sky130_fd_sc_hd__buf_2
X_1385_ _1392_/B vssd1 vssd1 vccd1 vccd1 _1440_/C sky130_fd_sc_hd__inv_2
XFILLER_23_335 vssd1 vssd1 vccd1 vccd1 sky130_fd_sc_hd__fill_1
XFILLER_50_165 vssd1 vccd1 vssd1 vccd1 sky130_ef_sc_hd__decap_40_12
XTAP_TAPCELL_ROW_33_341 vssd1 vccd1 sky130_fd_sc_hd__tapvpwrvgnd_1
XFILLER_51_29 vssd1 vssd1 vccd1 vccd1 sky130_fd_sc_hd__fill_2
XFILLER_58_221 vssd1 vccd1 vssd1 vccd1 sky130_ef_sc_hd__decap_40_12
XANTENNA__1170__C1 _0902_/A vssd1 vssd1 vccd1 vccd1 sky130_fd_sc_hd__diode_2
XFILLER_26_162 vssd1 vssd1 vccd1 vccd1 sky130_fd_sc_hd__fill_1
XFILLER_58_265 vssd1 vccd1 vssd1 vccd1 sky130_ef_sc_hd__decap_40_12
XFILLER_41_187 vssd1 vssd1 vccd1 vccd1 sky130_fd_sc_hd__fill_2
XFILLER_1_261 vssd1 vccd1 vssd1 vccd1 sky130_ef_sc_hd__decap_40_12
XFILLER_49_221 vssd1 vssd1 vccd1 vccd1 sky130_fd_sc_hd__fill_2
X_1170_ _1190_/A _1169_/Y _1168_/X _0902_/A vssd1 vssd1 vccd1 vccd1 _1170_/X sky130_fd_sc_hd__a211o_2
XFILLER_17_184 vssd1 vssd1 vccd1 vccd1 sky130_fd_sc_hd__fill_4
XFILLER_17_195 vssd1 vssd1 vccd1 vccd1 sky130_fd_sc_hd__fill_8
XFILLER_32_110 vssd1 vssd1 vccd1 vccd1 sky130_fd_sc_hd__fill_8
XTAP_TAPCELL_ROW_47_433 vssd1 vccd1 sky130_fd_sc_hd__tapvpwrvgnd_1
XFILLER_9_361 vssd1 vccd1 vssd1 vccd1 sky130_ef_sc_hd__decap_40_12
X_0954_ input9/X _0954_/B vssd1 vssd1 vccd1 vccd1 _0965_/B sky130_fd_sc_hd__xnor2_2
X_0885_ _0885_/A _0885_/B vssd1 vssd1 vccd1 vccd1 _0887_/B sky130_fd_sc_hd__xnor2_2
XTAP_TAPCELL_ROW_30_322 vssd1 vccd1 sky130_fd_sc_hd__tapvpwrvgnd_1
X_1437_ _1476_/Q _1437_/B _1438_/D vssd1 vssd1 vccd1 vccd1 _1437_/X sky130_fd_sc_hd__and3_2
XFILLER_55_279 vssd1 vssd1 vccd1 vccd1 sky130_fd_sc_hd__fill_1
X_1368_ _0854_/B _1457_/D _1462_/D _1077_/B vssd1 vssd1 vccd1 vccd1 _1370_/C sky130_fd_sc_hd__o2bb2a_2
X_1299_ _1470_/Q _1469_/Q _1299_/C vssd1 vssd1 vccd1 vccd1 _1306_/B sky130_fd_sc_hd__and3_2
XPHY_EDGE_ROW_43_Left_103 vssd1 vssd1 vccd1 vccd1 sky130_fd_sc_hd__decap_3
XFILLER_11_316 vssd1 vccd1 vssd1 vccd1 sky130_ef_sc_hd__decap_40_12
XFILLER_11_349 vssd1 vccd1 vssd1 vccd1 sky130_ef_sc_hd__decap_40_12
XFILLER_23_165 vssd1 vssd1 vccd1 vccd1 sky130_fd_sc_hd__fill_2
XFILLER_11_65 vssd1 vssd1 vccd1 vccd1 sky130_fd_sc_hd__fill_2
XFILLER_11_98 vssd1 vccd1 vssd1 vccd1 sky130_ef_sc_hd__decap_40_12
XPHY_EDGE_ROW_52_Left_112 vssd1 vssd1 vccd1 vccd1 sky130_fd_sc_hd__decap_3
XFILLER_14_132 vssd1 vssd1 vccd1 vccd1 sky130_fd_sc_hd__fill_8
XFILLER_46_235 vssd1 vssd1 vccd1 vccd1 sky130_fd_sc_hd__fill_1
XTAP_TAPCELL_ROW_44_414 vssd1 vccd1 sky130_fd_sc_hd__tapvpwrvgnd_1
XFILLER_52_83 vssd1 vssd1 vccd1 vccd1 sky130_fd_sc_hd__fill_1
Xinput15 prescaler[4] vssd1 vssd1 vccd1 vccd1 _0730_/A sky130_fd_sc_hd__buf_1
XANTENNA__1453__CLK _1463_/CLK vssd1 vssd1 vccd1 vccd1 sky130_fd_sc_hd__diode_2
X_1222_ _1459_/Q _1252_/A2 _0715_/B vssd1 vssd1 vccd1 vccd1 _1222_/Y sky130_fd_sc_hd__o21ai_2
X_1153_ _1450_/Q _1153_/B vssd1 vssd1 vccd1 vccd1 _1153_/X sky130_fd_sc_hd__or2_2
X_1084_ _1458_/Q _1353_/A vssd1 vssd1 vccd1 vccd1 _1087_/C sky130_fd_sc_hd__nand2_2
XFILLER_52_249 vssd1 vssd1 vccd1 vccd1 sky130_fd_sc_hd__fill_2
X_0937_ _0937_/A _0937_/B _0940_/A vssd1 vssd1 vccd1 vccd1 _0938_/B sky130_fd_sc_hd__nor3_2
X_0868_ _0868_/A _0868_/B vssd1 vssd1 vccd1 vccd1 _0870_/B sky130_fd_sc_hd__xor2_2
X_0799_ _0799_/A _0799_/B vssd1 vssd1 vccd1 vccd1 _0808_/B sky130_fd_sc_hd__xnor2_2
XFILLER_57_39 vssd1 vccd1 vssd1 vccd1 sky130_ef_sc_hd__decap_40_12
XTAP_TAPCELL_ROW_58_506 vssd1 vccd1 sky130_fd_sc_hd__tapvpwrvgnd_1
XFILLER_11_113 vssd1 vssd1 vccd1 vccd1 sky130_fd_sc_hd__fill_2
XFILLER_22_20 vssd1 vssd1 vccd1 vccd1 sky130_fd_sc_hd__fill_2
XFILLER_51_293 vssd1 vccd1 vssd1 vccd1 sky130_ef_sc_hd__decap_40_12
XPHY_EDGE_ROW_5_Left_65 vssd1 vssd1 vccd1 vccd1 sky130_fd_sc_hd__decap_3
XFILLER_19_246 vssd1 vssd1 vccd1 vccd1 sky130_fd_sc_hd__fill_2
XFILLER_47_94 vssd1 vccd1 vssd1 vccd1 sky130_ef_sc_hd__decap_40_12
XFILLER_42_271 vssd1 vccd1 vssd1 vccd1 sky130_ef_sc_hd__decap_40_12
XFILLER_10_190 vssd1 vssd1 vccd1 vccd1 sky130_fd_sc_hd__fill_1
XFILLER_8_77 vssd1 vssd1 vccd1 vccd1 sky130_fd_sc_hd__fill_4
X_0722_ _0720_/Y _0721_/X _1313_/B1 vssd1 vssd1 vccd1 vccd1 _1478_/D sky130_fd_sc_hd__a21oi_2
X_1205_ _1457_/Q _1205_/B vssd1 vssd1 vccd1 vccd1 _1205_/Y sky130_fd_sc_hd__nand2_2
X_1136_ _1448_/Q _1329_/B vssd1 vssd1 vccd1 vccd1 _1136_/Y sky130_fd_sc_hd__xnor2_2
X_1067_ _1464_/Q _1068_/B vssd1 vssd1 vccd1 vccd1 _1067_/Y sky130_fd_sc_hd__nand2_2
XFILLER_0_337 vssd1 vssd1 vccd1 vccd1 sky130_fd_sc_hd__fill_4
XFILLER_4_109 vssd1 vccd1 vssd1 vccd1 sky130_ef_sc_hd__decap_40_12
XFILLER_0_348 vssd1 vccd1 vssd1 vccd1 sky130_ef_sc_hd__decap_40_12
XFILLER_56_363 vssd1 vssd1 vccd1 vccd1 sky130_fd_sc_hd__fill_1
XFILLER_33_41 vssd1 vssd1 vccd1 vccd1 sky130_fd_sc_hd__fill_4
XTAP_TAPCELL_ROW_26_299 vssd1 vccd1 sky130_fd_sc_hd__tapvpwrvgnd_1
XFILLER_33_63 vssd1 vssd1 vccd1 vccd1 sky130_fd_sc_hd__fill_4
XFILLER_15_271 vssd1 vssd1 vccd1 vccd1 sky130_fd_sc_hd__fill_1
Xmax_cap145 _0739_/B vssd1 vssd1 vccd1 vccd1 _0825_/A sky130_fd_sc_hd__buf_2
X_0705_ _1389_/A _1381_/A vssd1 vssd1 vccd1 vccd1 _0705_/Y sky130_fd_sc_hd__nand2_2
XFILLER_57_105 vssd1 vssd1 vccd1 vccd1 sky130_fd_sc_hd__fill_4
XFILLER_57_149 vssd1 vccd1 vssd1 vccd1 sky130_ef_sc_hd__decap_40_12
XFILLER_53_333 vssd1 vssd1 vccd1 vccd1 sky130_fd_sc_hd__fill_2
XFILLER_54_29 vssd1 vccd1 vssd1 vccd1 sky130_ef_sc_hd__decap_40_12
X_1119_ _1119_/A _1119_/B _1119_/C vssd1 vssd1 vccd1 vccd1 _1119_/X sky130_fd_sc_hd__or3_2
XTAP_TAPCELL_ROW_0_123 vssd1 vccd1 sky130_fd_sc_hd__tapvpwrvgnd_1
XFILLER_21_285 vssd1 vssd1 vccd1 vccd1 sky130_fd_sc_hd__fill_2
XPHY_EDGE_ROW_17_Right_17 vssd1 vssd1 vccd1 vccd1 sky130_fd_sc_hd__decap_3
XANTENNA_fanout95_A _1327_/C vssd1 vssd1 vccd1 vccd1 sky130_fd_sc_hd__diode_2
XFILLER_0_167 vssd1 vssd1 vccd1 vccd1 sky130_fd_sc_hd__fill_1
XFILLER_48_105 vssd1 vssd1 vccd1 vccd1 sky130_fd_sc_hd__fill_1
XFILLER_48_116 vssd1 vssd1 vccd1 vccd1 sky130_fd_sc_hd__fill_2
XPHY_EDGE_ROW_26_Right_26 vssd1 vssd1 vccd1 vccd1 sky130_fd_sc_hd__decap_3
XFILLER_28_52 vssd1 vssd1 vccd1 vccd1 sky130_fd_sc_hd__fill_4
XFILLER_28_85 vssd1 vssd1 vccd1 vccd1 sky130_fd_sc_hd__fill_2
XFILLER_48_138 vssd1 vssd1 vccd1 vccd1 sky130_fd_sc_hd__fill_2
XFILLER_56_193 vssd1 vssd1 vccd1 vccd1 sky130_fd_sc_hd__fill_2
XTAP_TAPCELL_ROW_39_380 vssd1 vccd1 sky130_fd_sc_hd__tapvpwrvgnd_1
XFILLER_12_241 vssd1 vssd1 vccd1 vccd1 sky130_fd_sc_hd__fill_4
XPHY_EDGE_ROW_35_Right_35 vssd1 vssd1 vccd1 vccd1 sky130_fd_sc_hd__decap_3
X_1470_ _1478_/CLK _1470_/D load_slew140/X vssd1 vssd1 vccd1 vccd1 _1470_/Q sky130_fd_sc_hd__dfrtp_2
XFILLER_39_127 vssd1 vssd1 vccd1 vccd1 sky130_fd_sc_hd__fill_1
XPHY_EDGE_ROW_44_Right_44 vssd1 vssd1 vccd1 vccd1 sky130_fd_sc_hd__decap_3
XFILLER_35_311 vssd1 vssd1 vccd1 vccd1 sky130_fd_sc_hd__fill_4
XPHY_EDGE_ROW_53_Right_53 vssd1 vssd1 vccd1 vccd1 sky130_fd_sc_hd__decap_3
XFILLER_26_300 vssd1 vssd1 vccd1 vccd1 sky130_fd_sc_hd__fill_8
XFILLER_38_182 vssd1 vssd1 vccd1 vccd1 sky130_fd_sc_hd__fill_1
XFILLER_45_119 vssd1 vssd1 vccd1 vccd1 sky130_fd_sc_hd__fill_1
XFILLER_14_54 vssd1 vssd1 vccd1 vccd1 sky130_fd_sc_hd__fill_2
XFILLER_14_76 vssd1 vssd1 vccd1 vccd1 sky130_fd_sc_hd__fill_4
XFILLER_41_314 vssd1 vssd1 vccd1 vccd1 sky130_fd_sc_hd__fill_1
XFILLER_41_325 vssd1 vssd1 vccd1 vccd1 sky130_fd_sc_hd__fill_1
XTAP_TAPCELL_ROW_36_361 vssd1 vccd1 sky130_fd_sc_hd__tapvpwrvgnd_1
XFILLER_30_97 vssd1 vccd1 vssd1 vccd1 sky130_ef_sc_hd__decap_40_12
XFILLER_5_237 vssd1 vccd1 vssd1 vccd1 sky130_ef_sc_hd__decap_40_12
XFILLER_39_73 vssd1 vssd1 vccd1 vccd1 sky130_fd_sc_hd__fill_2
XFILLER_32_325 vssd1 vssd1 vccd1 vccd1 sky130_fd_sc_hd__fill_2
XFILLER_44_141 vssd1 vccd1 vssd1 vccd1 sky130_ef_sc_hd__decap_40_12
XPHY_EDGE_ROW_34_Left_94 vssd1 vssd1 vccd1 vccd1 sky130_fd_sc_hd__decap_3
X_0970_ _0987_/A _0969_/B _0966_/Y vssd1 vssd1 vccd1 vccd1 _0985_/B sky130_fd_sc_hd__a21oi_2
X_1453_ _1463_/CLK _1453_/D fanout136/X vssd1 vssd1 vccd1 vccd1 _1453_/Q sky130_fd_sc_hd__dfrtp_2
X_1522_ _1541_/A vssd1 vssd1 vccd1 vccd1 _1522_/X sky130_fd_sc_hd__buf_2
X_1384_ _1389_/A _1438_/A _1384_/C vssd1 vssd1 vccd1 vccd1 _1392_/B sky130_fd_sc_hd__or3_2
XFILLER_50_177 vssd1 vccd1 vssd1 vccd1 sky130_ef_sc_hd__decap_40_12
XTAP_TAPCELL_ROW_33_342 vssd1 vccd1 sky130_fd_sc_hd__tapvpwrvgnd_1
XFILLER_58_233 vssd1 vccd1 vssd1 vccd1 sky130_ef_sc_hd__decap_40_12
XFILLER_14_303 vssd1 vssd1 vccd1 vccd1 sky130_fd_sc_hd__fill_4
XFILLER_26_141 vssd1 vccd1 vssd1 vccd1 sky130_ef_sc_hd__decap_40_12
XFILLER_41_111 vssd1 vssd1 vccd1 vccd1 sky130_fd_sc_hd__fill_1
XFILLER_58_277 vssd1 vccd1 vssd1 vccd1 sky130_ef_sc_hd__decap_40_12
XFILLER_17_130 vssd1 vccd1 vssd1 vccd1 sky130_ef_sc_hd__decap_40_12
XFILLER_1_273 vssd1 vssd1 vccd1 vccd1 sky130_fd_sc_hd__fill_4
XFILLER_49_277 vssd1 vssd1 vccd1 vccd1 sky130_fd_sc_hd__fill_2
XTAP_TAPCELL_ROW_47_434 vssd1 vccd1 sky130_fd_sc_hd__tapvpwrvgnd_1
XFILLER_32_177 vssd1 vssd1 vccd1 vccd1 sky130_fd_sc_hd__fill_1
XFILLER_9_373 vssd1 vssd1 vccd1 vccd1 sky130_fd_sc_hd__fill_2
X_0953_ input8/X _0953_/B vssd1 vssd1 vccd1 vccd1 _0954_/B sky130_fd_sc_hd__xor2_2
X_0884_ _0885_/A _0885_/B vssd1 vssd1 vccd1 vccd1 _0989_/A sky130_fd_sc_hd__nor2_2
XTAP_TAPCELL_ROW_30_323 vssd1 vccd1 sky130_fd_sc_hd__tapvpwrvgnd_1
X_1367_ _1093_/X _1453_/D _1449_/D _0729_/A vssd1 vssd1 vccd1 vccd1 _1370_/B sky130_fd_sc_hd__o2bb2a_2
X_1436_ _1436_/A _1436_/B vssd1 vssd1 vccd1 vccd1 _1436_/Y sky130_fd_sc_hd__nor2_2
XFILLER_23_111 vssd1 vssd1 vccd1 vccd1 sky130_fd_sc_hd__fill_1
XFILLER_46_19 vssd1 vssd1 vccd1 vccd1 sky130_fd_sc_hd__fill_2
XFILLER_55_225 vssd1 vccd1 vssd1 vccd1 sky130_ef_sc_hd__decap_40_12
X_1298_ _1469_/Q _1299_/C _1470_/Q vssd1 vssd1 vccd1 vccd1 _1301_/A sky130_fd_sc_hd__a21oi_2
XFILLER_11_328 vssd1 vssd1 vccd1 vccd1 sky130_fd_sc_hd__fill_8
XFILLER_11_55 vssd1 vssd1 vccd1 vccd1 sky130_fd_sc_hd__fill_1
XFILLER_2_6 vssd1 vccd1 vssd1 vccd1 sky130_ef_sc_hd__decap_40_12
XFILLER_46_203 vssd1 vccd1 vssd1 vccd1 sky130_ef_sc_hd__decap_40_12
XFILLER_46_225 vssd1 vssd1 vccd1 vccd1 sky130_fd_sc_hd__fill_8
XFILLER_36_85 vssd1 vssd1 vccd1 vccd1 sky130_fd_sc_hd__fill_8
XTAP_TAPCELL_ROW_52_470 vssd1 vccd1 sky130_fd_sc_hd__tapvpwrvgnd_1
XTAP_TAPCELL_ROW_44_415 vssd1 vccd1 sky130_fd_sc_hd__tapvpwrvgnd_1
XFILLER_10_361 vssd1 vssd1 vccd1 vccd1 sky130_fd_sc_hd__fill_2
XFILLER_6_321 vssd1 vccd1 vssd1 vccd1 sky130_ef_sc_hd__decap_40_12
XFILLER_6_365 vssd1 vssd1 vccd1 vccd1 sky130_fd_sc_hd__fill_8
Xinput16 prescaler[5] vssd1 vssd1 vccd1 vccd1 _0739_/B sky130_fd_sc_hd__buf_1
X_1221_ _1294_/S _1219_/Y _1220_/X _1303_/C1 vssd1 vssd1 vccd1 vccd1 _1221_/X sky130_fd_sc_hd__a211o_2
X_1152_ _1165_/C vssd1 vssd1 vccd1 vccd1 _1152_/Y sky130_fd_sc_hd__inv_2
X_1083_ _1459_/Q _1364_/A vssd1 vssd1 vccd1 vccd1 _1087_/B sky130_fd_sc_hd__nand2_2
XFILLER_20_136 vssd1 vssd1 vccd1 vccd1 sky130_fd_sc_hd__fill_4
XFILLER_20_147 vssd1 vssd1 vccd1 vccd1 sky130_fd_sc_hd__fill_1
X_0936_ _0937_/B _0940_/A _0937_/A vssd1 vssd1 vccd1 vccd1 _1018_/B sky130_fd_sc_hd__o21a_2
XFILLER_9_192 vssd1 vssd1 vccd1 vccd1 sky130_fd_sc_hd__fill_1
X_0867_ _0868_/A _0868_/B vssd1 vssd1 vccd1 vccd1 _0893_/A sky130_fd_sc_hd__and2_2
X_0798_ _0803_/A _0803_/B _0786_/B vssd1 vssd1 vccd1 vccd1 _0799_/B sky130_fd_sc_hd__a21o_2
XPHY_EDGE_ROW_21_Left_81 vssd1 vssd1 vccd1 vccd1 sky130_fd_sc_hd__decap_3
X_1419_ _1435_/A _1438_/B _1438_/C _1422_/D vssd1 vssd1 vccd1 vccd1 _1419_/X sky130_fd_sc_hd__and4_2
XTAP_TAPCELL_ROW_58_507 vssd1 vccd1 sky130_fd_sc_hd__tapvpwrvgnd_1
XFILLER_51_261 vssd1 vccd1 vssd1 vccd1 sky130_ef_sc_hd__decap_40_12
XFILLER_11_125 vssd1 vssd1 vccd1 vccd1 sky130_fd_sc_hd__fill_1
XFILLER_11_169 vssd1 vssd1 vccd1 vccd1 sky130_fd_sc_hd__fill_4
XFILLER_0_3 vssd1 vccd1 vssd1 vccd1 sky130_ef_sc_hd__decap_40_12
XFILLER_3_335 vssd1 vssd1 vccd1 vccd1 sky130_fd_sc_hd__fill_1
XFILLER_34_228 vssd1 vssd1 vccd1 vccd1 sky130_fd_sc_hd__fill_4
XFILLER_59_361 vssd1 vssd1 vccd1 vccd1 sky130_fd_sc_hd__fill_2
Xteam_00_170 vssd1 vssd1 vccd1 vccd1 team_00_170/HI la_data_out[23] sky130_fd_sc_hd__conb_1
XFILLER_42_261 vssd1 vssd1 vccd1 vccd1 sky130_fd_sc_hd__fill_2
XFILLER_42_283 vssd1 vssd1 vccd1 vccd1 sky130_fd_sc_hd__fill_2
XFILLER_10_180 vssd1 vssd1 vccd1 vccd1 sky130_fd_sc_hd__fill_8
XFILLER_6_195 vssd1 vssd1 vccd1 vccd1 sky130_fd_sc_hd__fill_1
X_0721_ _1389_/A _1381_/A _1443_/Q _1341_/B _0711_/A vssd1 vssd1 vccd1 vccd1 _0721_/X
+ sky130_fd_sc_hd__a41o_2
XFILLER_33_3 vssd1 vssd1 vccd1 vccd1 sky130_fd_sc_hd__fill_4
X_1204_ _1204_/A _1210_/B vssd1 vssd1 vccd1 vccd1 _1204_/Y sky130_fd_sc_hd__nand2_2
XFILLER_25_206 vssd1 vssd1 vccd1 vccd1 sky130_fd_sc_hd__fill_4
X_1135_ _1447_/Q _1328_/B vssd1 vssd1 vccd1 vccd1 _1329_/B sky130_fd_sc_hd__and2_2
X_1066_ _1066_/A _1066_/B vssd1 vssd1 vccd1 vccd1 _1068_/B sky130_fd_sc_hd__nand2_2
XANTENNA__1467__RESET_B wire142/X vssd1 vssd1 vccd1 vccd1 sky130_fd_sc_hd__diode_2
X_0919_ _0919_/A _0919_/B vssd1 vssd1 vccd1 vccd1 _0919_/Y sky130_fd_sc_hd__nand2_2
XFILLER_16_239 vssd1 vssd1 vccd1 vccd1 sky130_fd_sc_hd__fill_2
XFILLER_17_54 vssd1 vssd1 vccd1 vccd1 sky130_fd_sc_hd__fill_2
XFILLER_48_309 vssd1 vccd1 vssd1 vccd1 sky130_ef_sc_hd__decap_40_12
XANTENNA__1282__C1 _1303_/C1 vssd1 vssd1 vccd1 vccd1 sky130_fd_sc_hd__diode_2
XANTENNA__1443__CLK _1471_/CLK vssd1 vssd1 vccd1 vccd1 sky130_fd_sc_hd__diode_2
XFILLER_33_53 vssd1 vssd1 vccd1 vccd1 sky130_fd_sc_hd__fill_2
XFILLER_3_165 vssd1 vssd1 vccd1 vccd1 sky130_fd_sc_hd__fill_2
XFILLER_58_83 vssd1 vssd1 vccd1 vccd1 sky130_fd_sc_hd__fill_1
XFILLER_15_250 vssd1 vssd1 vccd1 vccd1 sky130_fd_sc_hd__fill_8
XFILLER_30_253 vssd1 vssd1 vccd1 vccd1 sky130_fd_sc_hd__fill_1
Xmax_cap135 input7/X vssd1 vssd1 vccd1 vccd1 _1096_/B sky130_fd_sc_hd__clkbuf_2
Xmax_cap146 _0730_/A vssd1 vssd1 vccd1 vccd1 _1096_/A sky130_fd_sc_hd__buf_2
X_0704_ _1389_/A _1381_/A vssd1 vssd1 vccd1 vccd1 _1427_/A sky130_fd_sc_hd__and2_2
XTAP_TAPCELL_ROW_0_124 vssd1 vccd1 sky130_fd_sc_hd__tapvpwrvgnd_1
XANTENNA__1466__CLK _1471_/CLK vssd1 vssd1 vccd1 vccd1 sky130_fd_sc_hd__diode_2
X_1118_ _1461_/Q _1352_/A _1117_/X vssd1 vssd1 vccd1 vccd1 _1119_/C sky130_fd_sc_hd__a21oi_2
X_1049_ _1049_/A _1050_/B _1059_/B vssd1 vssd1 vccd1 vccd1 _1049_/X sky130_fd_sc_hd__or3b_2
XFILLER_0_113 vssd1 vssd1 vccd1 vccd1 sky130_fd_sc_hd__fill_8
XFILLER_0_124 vssd1 vccd1 vssd1 vccd1 sky130_ef_sc_hd__decap_40_12
XFILLER_28_20 vssd1 vssd1 vccd1 vccd1 sky130_fd_sc_hd__fill_1
XFILLER_28_31 vssd1 vssd1 vccd1 vccd1 sky130_fd_sc_hd__fill_8
XTAP_TAPCELL_ROW_39_381 vssd1 vccd1 sky130_fd_sc_hd__tapvpwrvgnd_1
XFILLER_44_74 vssd1 vssd1 vccd1 vccd1 sky130_fd_sc_hd__fill_1
XFILLER_44_85 vssd1 vssd1 vccd1 vccd1 sky130_fd_sc_hd__fill_4
XFILLER_8_202 vssd1 vssd1 vccd1 vccd1 sky130_fd_sc_hd__fill_4
XTAP_TAPCELL_ROW_22_270 vssd1 vccd1 sky130_fd_sc_hd__tapvpwrvgnd_1
XFILLER_5_57 vssd1 vccd1 vssd1 vccd1 sky130_ef_sc_hd__decap_40_12
XFILLER_47_150 vssd1 vccd1 vssd1 vccd1 sky130_ef_sc_hd__decap_40_12
XFILLER_54_109 vssd1 vccd1 vssd1 vccd1 sky130_ef_sc_hd__decap_40_12
XFILLER_35_334 vssd1 vssd1 vccd1 vccd1 sky130_fd_sc_hd__fill_2
XFILLER_26_345 vssd1 vssd1 vccd1 vccd1 sky130_fd_sc_hd__fill_2
XFILLER_38_161 vssd1 vccd1 vssd1 vccd1 sky130_ef_sc_hd__decap_40_12
XFILLER_45_109 vssd1 vssd1 vccd1 vccd1 sky130_fd_sc_hd__fill_2
XTAP_TAPCELL_ROW_36_362 vssd1 vccd1 sky130_fd_sc_hd__tapvpwrvgnd_1
XFILLER_41_337 vssd1 vssd1 vccd1 vccd1 sky130_fd_sc_hd__fill_2
XFILLER_5_205 vssd1 vccd1 vssd1 vccd1 sky130_ef_sc_hd__decap_40_12
XFILLER_5_249 vssd1 vccd1 vssd1 vccd1 sky130_ef_sc_hd__decap_40_12
XANTENNA_input20_A prescaler[9] vssd1 vssd1 vccd1 vccd1 sky130_fd_sc_hd__diode_2
XFILLER_39_96 vssd1 vccd1 vssd1 vccd1 sky130_ef_sc_hd__decap_40_12
XFILLER_44_153 vssd1 vssd1 vccd1 vccd1 sky130_fd_sc_hd__fill_4
XFILLER_44_197 vssd1 vssd1 vccd1 vccd1 sky130_fd_sc_hd__fill_4
XFILLER_55_51 vssd1 vssd1 vccd1 vccd1 sky130_fd_sc_hd__fill_4
XANTENNA__1176__B _1205_/B vssd1 vssd1 vccd1 vccd1 sky130_fd_sc_hd__diode_2
X_1383_ _1411_/A _1383_/B vssd1 vssd1 vccd1 vccd1 _1383_/Y sky130_fd_sc_hd__nor2_2
X_1452_ _1459_/CLK _1452_/D fanout136/X vssd1 vssd1 vccd1 vccd1 _1452_/Q sky130_fd_sc_hd__dfrtp_2
X_1521_ _1535_/A vssd1 vssd1 vccd1 vccd1 _1521_/X sky130_fd_sc_hd__buf_2
XANTENNA_fanout138_A input6/X vssd1 vssd1 vccd1 vccd1 sky130_fd_sc_hd__diode_2
XFILLER_23_337 vssd1 vssd1 vccd1 vccd1 sky130_fd_sc_hd__fill_8
XFILLER_35_197 vssd1 vssd1 vccd1 vccd1 sky130_fd_sc_hd__fill_2
XFILLER_50_189 vssd1 vssd1 vccd1 vccd1 sky130_fd_sc_hd__fill_4
XTAP_TAPCELL_ROW_33_343 vssd1 vccd1 sky130_fd_sc_hd__tapvpwrvgnd_1
XFILLER_58_245 vssd1 vssd1 vccd1 vccd1 sky130_fd_sc_hd__fill_4
XFILLER_58_289 vssd1 vccd1 vssd1 vccd1 sky130_ef_sc_hd__decap_40_12
XFILLER_26_197 vssd1 vccd1 vssd1 vccd1 sky130_ef_sc_hd__decap_40_12
XFILLER_41_134 vssd1 vssd1 vccd1 vccd1 sky130_fd_sc_hd__fill_1
XFILLER_41_178 vssd1 vssd1 vccd1 vccd1 sky130_fd_sc_hd__fill_1
XFILLER_41_42 vssd1 vccd1 vssd1 vccd1 sky130_ef_sc_hd__decap_40_12
XFILLER_41_86 vssd1 vssd1 vccd1 vccd1 sky130_fd_sc_hd__fill_2
XFILLER_49_223 vssd1 vssd1 vccd1 vccd1 sky130_fd_sc_hd__fill_1
XFILLER_17_142 vssd1 vccd1 vssd1 vccd1 sky130_ef_sc_hd__decap_40_12
XTAP_TAPCELL_ROW_47_435 vssd1 vccd1 sky130_fd_sc_hd__tapvpwrvgnd_1
X_0952_ input8/X _0953_/B vssd1 vssd1 vccd1 vccd1 _0952_/X sky130_fd_sc_hd__and2_2
XTAP_TAPCELL_ROW_30_324 vssd1 vccd1 sky130_fd_sc_hd__tapvpwrvgnd_1
X_0883_ _0883_/A _0883_/B vssd1 vssd1 vccd1 vccd1 _0885_/B sky130_fd_sc_hd__xnor2_2
X_1366_ _1366_/A _1451_/D vssd1 vssd1 vccd1 vccd1 _1370_/A sky130_fd_sc_hd__xnor2_2
X_1435_ _1435_/A _1435_/B _1438_/D vssd1 vssd1 vccd1 vccd1 _1435_/X sky130_fd_sc_hd__and3_2
XFILLER_23_145 vssd1 vssd1 vccd1 vccd1 sky130_fd_sc_hd__fill_2
XFILLER_55_237 vssd1 vccd1 vssd1 vccd1 sky130_ef_sc_hd__decap_40_12
X_1297_ _1297_/A _1297_/B vssd1 vssd1 vccd1 vccd1 _1469_/D sky130_fd_sc_hd__and2_2
XFILLER_23_167 vssd1 vssd1 vccd1 vccd1 sky130_fd_sc_hd__fill_1
XFILLER_36_64 vssd1 vssd1 vccd1 vccd1 sky130_fd_sc_hd__fill_4
XFILLER_46_215 vssd1 vssd1 vccd1 vccd1 sky130_fd_sc_hd__fill_2
XANTENNA__0904__A input9/X vssd1 vssd1 vccd1 vccd1 sky130_fd_sc_hd__diode_2
XFILLER_52_41 vssd1 vccd1 vssd1 vccd1 sky130_ef_sc_hd__decap_40_12
XFILLER_52_85 vssd1 vccd1 vssd1 vccd1 sky130_ef_sc_hd__decap_40_12
XTAP_TAPCELL_ROW_44_416 vssd1 vccd1 sky130_fd_sc_hd__tapvpwrvgnd_1
XFILLER_10_373 vssd1 vssd1 vccd1 vccd1 sky130_fd_sc_hd__fill_2
XFILLER_6_333 vssd1 vccd1 vssd1 vccd1 sky130_ef_sc_hd__decap_40_12
Xinput17 prescaler[6] vssd1 vssd1 vccd1 vccd1 _0750_/B sky130_fd_sc_hd__buf_1
XFILLER_37_204 vssd1 vssd1 vccd1 vccd1 sky130_fd_sc_hd__fill_2
X_1220_ _1307_/A1 _1307_/A2 _1307_/B1 _1218_/X vssd1 vssd1 vccd1 vccd1 _1220_/X sky130_fd_sc_hd__o211a_2
X_1151_ _1450_/Q _1153_/B vssd1 vssd1 vccd1 vccd1 _1165_/C sky130_fd_sc_hd__and2_2
XFILLER_45_281 vssd1 vssd1 vccd1 vccd1 sky130_fd_sc_hd__fill_4
X_1082_ _1459_/Q _1364_/A vssd1 vssd1 vccd1 vccd1 _1082_/Y sky130_fd_sc_hd__nor2_2
X_0935_ _0939_/A _0939_/B vssd1 vssd1 vccd1 vccd1 _0940_/A sky130_fd_sc_hd__and2_2
X_0866_ _0866_/A _0866_/B vssd1 vssd1 vccd1 vccd1 _0868_/B sky130_fd_sc_hd__xnor2_2
X_0797_ _0803_/A _0803_/B vssd1 vssd1 vccd1 vccd1 _0797_/Y sky130_fd_sc_hd__nand2_2
X_1349_ _1348_/B _1348_/C _1348_/A vssd1 vssd1 vccd1 vccd1 _1349_/X sky130_fd_sc_hd__o21a_2
X_1418_ _1418_/A _1422_/D _1437_/B vssd1 vssd1 vccd1 vccd1 _1418_/X sky130_fd_sc_hd__and3_2
XTAP_TAPCELL_ROW_58_508 vssd1 vccd1 sky130_fd_sc_hd__tapvpwrvgnd_1
XFILLER_51_273 vssd1 vssd1 vccd1 vccd1 sky130_fd_sc_hd__fill_4
XFILLER_22_22 vssd1 vssd1 vccd1 vccd1 sky130_fd_sc_hd__fill_1
XFILLER_22_33 vssd1 vssd1 vccd1 vccd1 sky130_fd_sc_hd__fill_1
XFILLER_3_369 vssd1 vssd1 vccd1 vccd1 sky130_fd_sc_hd__fill_2
XFILLER_59_373 vssd1 vssd1 vccd1 vccd1 sky130_fd_sc_hd__fill_2
XFILLER_19_248 vssd1 vssd1 vccd1 vccd1 sky130_fd_sc_hd__fill_1
Xteam_00_171 vssd1 vssd1 vccd1 vccd1 team_00_171/HI la_data_out[24] sky130_fd_sc_hd__conb_1
Xteam_00_160 vssd1 vssd1 vccd1 vccd1 team_00_160/HI la_data_out[13] sky130_fd_sc_hd__conb_1
XFILLER_42_251 vssd1 vssd1 vccd1 vccd1 sky130_fd_sc_hd__fill_1
X_0720_ _1443_/Q _1439_/B vssd1 vssd1 vccd1 vccd1 _0720_/Y sky130_fd_sc_hd__nand2_2
XFILLER_6_141 vssd1 vccd1 vssd1 vccd1 sky130_ef_sc_hd__decap_40_12
XFILLER_26_3 vssd1 vssd1 vccd1 vccd1 sky130_fd_sc_hd__fill_4
X_1203_ _1457_/Q _1217_/D vssd1 vssd1 vccd1 vccd1 _1210_/B sky130_fd_sc_hd__nand2_2
X_1134_ _1446_/Q _1444_/Q _1445_/Q vssd1 vssd1 vccd1 vccd1 _1328_/B sky130_fd_sc_hd__and3_2
X_1065_ _1065_/A _1065_/B _1065_/C vssd1 vssd1 vccd1 vccd1 _1066_/B sky130_fd_sc_hd__nand3_2
X_0918_ _0921_/A _1011_/A vssd1 vssd1 vccd1 vccd1 _0922_/A sky130_fd_sc_hd__or2_2
X_0849_ _0849_/A _0849_/B vssd1 vssd1 vccd1 vccd1 _1342_/A sky130_fd_sc_hd__or2_2
XFILLER_17_88 vssd1 vssd1 vccd1 vccd1 sky130_fd_sc_hd__fill_2
XFILLER_56_321 vssd1 vccd1 vssd1 vccd1 sky130_ef_sc_hd__decap_40_12
XFILLER_56_365 vssd1 vssd1 vccd1 vccd1 sky130_fd_sc_hd__fill_8
XFILLER_24_240 vssd1 vssd1 vccd1 vccd1 sky130_fd_sc_hd__fill_2
XFILLER_33_98 vssd1 vssd1 vccd1 vccd1 sky130_fd_sc_hd__fill_2
XFILLER_3_111 vssd1 vssd1 vccd1 vccd1 sky130_fd_sc_hd__fill_1
XFILLER_15_295 vssd1 vssd1 vccd1 vccd1 sky130_fd_sc_hd__fill_1
X_0703_ _1450_/Q vssd1 vssd1 vccd1 vccd1 _0703_/Y sky130_fd_sc_hd__inv_2
XTAP_TAPCELL_ROW_25_290 vssd1 vccd1 sky130_fd_sc_hd__tapvpwrvgnd_1
Xmax_cap147 _0919_/A vssd1 vssd1 vccd1 vccd1 _0913_/A sky130_fd_sc_hd__buf_2
XFILLER_38_343 vssd1 vssd1 vccd1 vccd1 sky130_fd_sc_hd__fill_2
XFILLER_38_365 vssd1 vssd1 vccd1 vccd1 sky130_fd_sc_hd__fill_2
XFILLER_53_335 vssd1 vssd1 vccd1 vccd1 sky130_fd_sc_hd__fill_1
X_1117_ _1461_/Q _1352_/A _1079_/B _1460_/Q vssd1 vssd1 vccd1 vccd1 _1117_/X sky130_fd_sc_hd__o211a_2
XTAP_TAPCELL_ROW_0_125 vssd1 vccd1 sky130_fd_sc_hd__tapvpwrvgnd_1
X_1048_ _1050_/A _1059_/B _1050_/B vssd1 vssd1 vccd1 vccd1 _1048_/X sky130_fd_sc_hd__a21bo_2
XPHY_EDGE_ROW_3_Right_3 vssd1 vssd1 vccd1 vccd1 sky130_fd_sc_hd__decap_3
XFILLER_0_103 vssd1 vssd1 vccd1 vccd1 sky130_fd_sc_hd__fill_2
XFILLER_0_136 vssd1 vssd1 vccd1 vccd1 sky130_fd_sc_hd__fill_4
XFILLER_0_169 vssd1 vccd1 vssd1 vccd1 sky130_ef_sc_hd__decap_40_12
XFILLER_48_118 vssd1 vssd1 vccd1 vccd1 sky130_fd_sc_hd__fill_1
XFILLER_12_221 vssd1 vssd1 vccd1 vccd1 sky130_fd_sc_hd__fill_2
XFILLER_28_87 vssd1 vssd1 vccd1 vccd1 sky130_fd_sc_hd__fill_1
XFILLER_44_31 vssd1 vssd1 vccd1 vccd1 sky130_fd_sc_hd__fill_2
XFILLER_44_64 vssd1 vssd1 vccd1 vccd1 sky130_fd_sc_hd__fill_8
XFILLER_56_195 vssd1 vssd1 vccd1 vccd1 sky130_fd_sc_hd__fill_1
XTAP_TAPCELL_ROW_39_382 vssd1 vccd1 sky130_fd_sc_hd__tapvpwrvgnd_1
XTAP_TAPCELL_ROW_22_271 vssd1 vccd1 sky130_fd_sc_hd__tapvpwrvgnd_1
XFILLER_5_69 vssd1 vccd1 vssd1 vccd1 sky130_ef_sc_hd__decap_40_12
XFILLER_35_324 vssd1 vssd1 vccd1 vccd1 sky130_fd_sc_hd__fill_1
XFILLER_47_162 vssd1 vssd1 vccd1 vccd1 sky130_fd_sc_hd__fill_4
XFILLER_50_305 vssd1 vssd1 vccd1 vccd1 sky130_fd_sc_hd__fill_2
XANTENNA__0822__A _0965_/A vssd1 vssd1 vccd1 vccd1 sky130_fd_sc_hd__diode_2
XANTENNA__1237__B1 _0715_/B vssd1 vssd1 vccd1 vccd1 sky130_fd_sc_hd__diode_2
XFILLER_38_173 vssd1 vssd1 vccd1 vccd1 sky130_fd_sc_hd__fill_1
XFILLER_38_195 vssd1 vssd1 vccd1 vccd1 sky130_fd_sc_hd__fill_1
XFILLER_41_349 vssd1 vssd1 vccd1 vccd1 sky130_fd_sc_hd__fill_2
XFILLER_53_165 vssd1 vssd1 vccd1 vccd1 sky130_fd_sc_hd__fill_2
XTAP_TAPCELL_ROW_36_363 vssd1 vccd1 sky130_fd_sc_hd__tapvpwrvgnd_1
XTAP_TAPCELL_ROW_28_308 vssd1 vccd1 sky130_fd_sc_hd__tapvpwrvgnd_1
XFILLER_14_56 vssd1 vssd1 vccd1 vccd1 sky130_fd_sc_hd__fill_1
XFILLER_5_217 vssd1 vssd1 vccd1 vccd1 sky130_fd_sc_hd__fill_4
XANTENNA_input13_A prescaler[2] vssd1 vssd1 vccd1 vccd1 sky130_fd_sc_hd__diode_2
XFILLER_39_53 vssd1 vssd1 vccd1 vccd1 sky130_fd_sc_hd__fill_2
XFILLER_39_75 vssd1 vssd1 vccd1 vccd1 sky130_fd_sc_hd__fill_1
XFILLER_32_327 vssd1 vssd1 vccd1 vccd1 sky130_fd_sc_hd__fill_1
XFILLER_58_6 vssd1 vccd1 vssd1 vccd1 sky130_ef_sc_hd__decap_40_12
X_1520_ _1541_/A vssd1 vssd1 vccd1 vccd1 _1520_/X sky130_fd_sc_hd__buf_2
XTAP_TAPCELL_ROW_42_399 vssd1 vccd1 sky130_fd_sc_hd__tapvpwrvgnd_1
XANTENNA__1456__CLK _1459_/CLK vssd1 vssd1 vccd1 vccd1 sky130_fd_sc_hd__diode_2
X_1382_ _1477_/Q _1478_/Q _1435_/A _1530_/A vssd1 vssd1 vccd1 vccd1 _1383_/B sky130_fd_sc_hd__or4_2
X_1451_ _1463_/CLK _1451_/D fanout136/X vssd1 vssd1 vccd1 vccd1 _1451_/Q sky130_fd_sc_hd__dfrtp_2
XFILLER_35_121 vssd1 vssd1 vccd1 vccd1 sky130_fd_sc_hd__fill_2
XTAP_TAPCELL_ROW_33_344 vssd1 vccd1 sky130_fd_sc_hd__tapvpwrvgnd_1
XFILLER_2_209 vssd1 vccd1 vssd1 vccd1 sky130_ef_sc_hd__decap_40_12
XANTENNA_input5_A la_oenb[1] vssd1 vssd1 vccd1 vccd1 sky130_fd_sc_hd__diode_2
XFILLER_14_349 vssd1 vssd1 vccd1 vccd1 sky130_fd_sc_hd__fill_2
XFILLER_41_102 vssd1 vssd1 vccd1 vccd1 sky130_fd_sc_hd__fill_2
XFILLER_41_113 vssd1 vssd1 vccd1 vccd1 sky130_fd_sc_hd__fill_4
XFILLER_41_146 vssd1 vssd1 vccd1 vccd1 sky130_fd_sc_hd__fill_1
XFILLER_41_54 vssd1 vssd1 vccd1 vccd1 sky130_fd_sc_hd__fill_2
XFILLER_2_26 vssd1 vssd1 vccd1 vccd1 sky130_fd_sc_hd__fill_2
XFILLER_17_121 vssd1 vssd1 vccd1 vccd1 sky130_fd_sc_hd__fill_2
XFILLER_17_154 vssd1 vssd1 vccd1 vccd1 sky130_fd_sc_hd__fill_2
XFILLER_49_279 vssd1 vssd1 vccd1 vccd1 sky130_fd_sc_hd__fill_1
XTAP_TAPCELL_ROW_47_436 vssd1 vccd1 sky130_fd_sc_hd__tapvpwrvgnd_1
X_0951_ _0951_/A _0951_/B vssd1 vssd1 vccd1 vccd1 _0963_/A sky130_fd_sc_hd__xnor2_2
X_0882_ _0883_/A _0883_/B vssd1 vssd1 vccd1 vccd1 _0968_/A sky130_fd_sc_hd__or2_2
XTAP_TAPCELL_ROW_30_325 vssd1 vccd1 sky130_fd_sc_hd__tapvpwrvgnd_1
XFILLER_56_3 vssd1 vccd1 vssd1 vccd1 sky130_ef_sc_hd__decap_40_12
XANTENNA__1104__A1_N _0767_/A vssd1 vssd1 vccd1 vccd1 sky130_fd_sc_hd__diode_2
XFILLER_55_205 vssd1 vccd1 vssd1 vccd1 sky130_ef_sc_hd__decap_40_12
XFILLER_55_249 vssd1 vccd1 vssd1 vccd1 sky130_ef_sc_hd__decap_40_12
X_1365_ _1365_/A _1365_/B _1365_/C _1363_/X vssd1 vssd1 vccd1 vccd1 _1378_/A sky130_fd_sc_hd__or4b_2
X_1434_ _1434_/A _1436_/B vssd1 vssd1 vccd1 vccd1 _1434_/Y sky130_fd_sc_hd__nor2_2
X_1296_ _1039_/A _1309_/B1 _1313_/B1 vssd1 vssd1 vccd1 vccd1 _1297_/B sky130_fd_sc_hd__a21oi_2
XFILLER_23_113 vssd1 vccd1 vssd1 vccd1 sky130_ef_sc_hd__decap_40_12
XFILLER_11_57 vssd1 vssd1 vccd1 vccd1 sky130_fd_sc_hd__fill_8
XFILLER_46_249 vssd1 vssd1 vccd1 vccd1 sky130_fd_sc_hd__fill_2
XTAP_TAPCELL_ROW_44_417 vssd1 vccd1 sky130_fd_sc_hd__tapvpwrvgnd_1
XANTENNA__0904__B _0942_/B vssd1 vssd1 vccd1 vccd1 sky130_fd_sc_hd__diode_2
XFILLER_14_146 vssd1 vssd1 vccd1 vccd1 sky130_fd_sc_hd__fill_1
XFILLER_52_53 vssd1 vccd1 vssd1 vccd1 sky130_ef_sc_hd__decap_40_12
XFILLER_52_97 vssd1 vccd1 vssd1 vccd1 sky130_ef_sc_hd__decap_40_12
XFILLER_6_301 vssd1 vssd1 vccd1 vccd1 sky130_fd_sc_hd__fill_4
Xinput18 prescaler[7] vssd1 vssd1 vccd1 vccd1 _0858_/B sky130_fd_sc_hd__buf_1
XFILLER_10_363 vssd1 vssd1 vccd1 vccd1 sky130_fd_sc_hd__fill_1
XFILLER_6_345 vssd1 vccd1 vssd1 vccd1 sky130_ef_sc_hd__decap_40_12
X_1150_ _1180_/A1 _1148_/X _1149_/Y vssd1 vssd1 vccd1 vccd1 _1449_/D sky130_fd_sc_hd__a21oi_2
XFILLER_45_293 vssd1 vssd1 vccd1 vccd1 sky130_fd_sc_hd__fill_8
X_1081_ _1119_/A _1119_/B _1081_/C _1081_/D vssd1 vssd1 vccd1 vccd1 _1132_/A sky130_fd_sc_hd__or4_2
XFILLER_9_183 vssd1 vssd1 vccd1 vccd1 sky130_fd_sc_hd__fill_2
X_0934_ _0934_/A _0934_/B vssd1 vssd1 vccd1 vccd1 _0939_/B sky130_fd_sc_hd__xor2_2
X_0865_ _0865_/A _0865_/B vssd1 vssd1 vccd1 vccd1 _0866_/B sky130_fd_sc_hd__xnor2_2
X_1417_ _1417_/A _1436_/A vssd1 vssd1 vccd1 vccd1 _1417_/Y sky130_fd_sc_hd__nor2_2
X_0796_ _1366_/A _0795_/Y _0804_/A vssd1 vssd1 vccd1 vccd1 _0803_/B sky130_fd_sc_hd__mux2_1
XFILLER_36_260 vssd1 vssd1 vccd1 vccd1 sky130_fd_sc_hd__fill_1
X_1348_ _1348_/A _1348_/B _1348_/C vssd1 vssd1 vccd1 vccd1 _1348_/Y sky130_fd_sc_hd__nor3_2
X_1279_ _1279_/A _1287_/B vssd1 vssd1 vccd1 vccd1 _1279_/X sky130_fd_sc_hd__or2_2
XTAP_TAPCELL_ROW_58_509 vssd1 vccd1 sky130_fd_sc_hd__tapvpwrvgnd_1
XFILLER_36_282 vssd1 vccd1 vssd1 vccd1 sky130_ef_sc_hd__decap_40_12
XFILLER_7_109 vssd1 vssd1 vccd1 vccd1 sky130_fd_sc_hd__fill_2
XFILLER_22_45 vssd1 vssd1 vccd1 vccd1 sky130_fd_sc_hd__fill_1
XFILLER_22_89 vssd1 vssd1 vccd1 vccd1 sky130_fd_sc_hd__fill_2
XFILLER_3_337 vssd1 vccd1 vssd1 vccd1 sky130_ef_sc_hd__decap_40_12
XFILLER_47_31 vssd1 vssd1 vccd1 vccd1 sky130_fd_sc_hd__fill_1
XFILLER_59_341 vssd1 vssd1 vccd1 vccd1 sky130_fd_sc_hd__fill_2
XFILLER_59_363 vssd1 vssd1 vccd1 vccd1 sky130_fd_sc_hd__fill_1
XANTENNA__0915__A _0942_/B vssd1 vssd1 vccd1 vccd1 sky130_fd_sc_hd__diode_2
XFILLER_42_263 vssd1 vssd1 vccd1 vccd1 sky130_fd_sc_hd__fill_1
Xteam_00_172 vssd1 vssd1 vccd1 vccd1 team_00_172/HI la_data_out[25] sky130_fd_sc_hd__conb_1
Xteam_00_161 vssd1 vssd1 vccd1 vccd1 team_00_161/HI la_data_out[14] sky130_fd_sc_hd__conb_1
Xteam_00_150 vssd1 vssd1 vccd1 vccd1 team_00_150/HI la_data_out[3] sky130_fd_sc_hd__conb_1
XFILLER_42_285 vssd1 vssd1 vccd1 vccd1 sky130_fd_sc_hd__fill_1
XFILLER_42_296 vssd1 vccd1 vssd1 vccd1 sky130_ef_sc_hd__decap_40_12
XFILLER_6_153 vssd1 vccd1 vssd1 vccd1 sky130_ef_sc_hd__decap_40_12
XFILLER_6_197 vssd1 vccd1 vssd1 vccd1 sky130_ef_sc_hd__decap_40_12
XFILLER_19_3 vssd1 vssd1 vccd1 vccd1 sky130_fd_sc_hd__fill_2
X_1202_ _1457_/Q _1217_/D vssd1 vssd1 vccd1 vccd1 _1204_/A sky130_fd_sc_hd__or2_2
X_1133_ _1133_/A _1133_/B _1133_/C _1133_/D vssd1 vssd1 vccd1 vccd1 _1133_/X sky130_fd_sc_hd__or4_2
X_1064_ _1069_/A _1069_/B vssd1 vssd1 vccd1 vccd1 _1064_/X sky130_fd_sc_hd__or2_2
XFILLER_18_293 vssd1 vccd1 vssd1 vccd1 sky130_ef_sc_hd__decap_40_12
X_0917_ _1010_/B _0917_/B vssd1 vssd1 vccd1 vccd1 _1011_/A sky130_fd_sc_hd__nand2b_2
X_0848_ _0848_/A _0848_/B _0851_/A vssd1 vssd1 vccd1 vccd1 _0849_/B sky130_fd_sc_hd__and3_2
X_0779_ input9/X _0779_/B vssd1 vssd1 vccd1 vccd1 _0838_/A sky130_fd_sc_hd__xnor2_2
XFILLER_17_78 vssd1 vssd1 vccd1 vccd1 sky130_fd_sc_hd__fill_1
XFILLER_56_333 vssd1 vccd1 vssd1 vccd1 sky130_ef_sc_hd__decap_40_12
XPHY_EDGE_ROW_9_Left_69 vssd1 vssd1 vccd1 vccd1 sky130_fd_sc_hd__decap_3
XFILLER_24_285 vssd1 vssd1 vccd1 vccd1 sky130_fd_sc_hd__fill_2
XFILLER_33_55 vssd1 vssd1 vccd1 vccd1 sky130_fd_sc_hd__fill_1
XFILLER_33_77 vssd1 vssd1 vccd1 vccd1 sky130_fd_sc_hd__fill_4
XFILLER_3_167 vssd1 vssd1 vccd1 vccd1 sky130_fd_sc_hd__fill_1
XFILLER_47_333 vssd1 vssd1 vccd1 vccd1 sky130_fd_sc_hd__fill_2
XFILLER_58_41 vssd1 vccd1 vssd1 vccd1 sky130_ef_sc_hd__decap_40_12
XFILLER_58_85 vssd1 vccd1 vssd1 vccd1 sky130_ef_sc_hd__decap_40_12
XFILLER_59_160 vssd1 vssd1 vccd1 vccd1 sky130_fd_sc_hd__fill_8
XFILLER_15_241 vssd1 vssd1 vccd1 vccd1 sky130_fd_sc_hd__fill_1
XFILLER_15_285 vssd1 vssd1 vccd1 vccd1 sky130_fd_sc_hd__fill_2
XTAP_TAPCELL_ROW_25_291 vssd1 vccd1 sky130_fd_sc_hd__tapvpwrvgnd_1
XFILLER_30_277 vssd1 vssd1 vccd1 vccd1 sky130_fd_sc_hd__fill_2
X_0702_ _1465_/Q vssd1 vssd1 vccd1 vccd1 _1069_/A sky130_fd_sc_hd__inv_2
XFILLER_38_311 vssd1 vssd1 vccd1 vccd1 sky130_fd_sc_hd__fill_1
XFILLER_0_81 vssd1 vssd1 vccd1 vccd1 sky130_fd_sc_hd__fill_2
X_1116_ _1119_/A _1076_/Y _1074_/Y vssd1 vssd1 vccd1 vccd1 _1116_/X sky130_fd_sc_hd__o21a_2
X_1047_ _1055_/B _1055_/C _1055_/A vssd1 vssd1 vccd1 vccd1 _1059_/B sky130_fd_sc_hd__a21o_2
XTAP_TAPCELL_ROW_0_126 vssd1 vccd1 sky130_fd_sc_hd__tapvpwrvgnd_1
XFILLER_21_222 vssd1 vssd1 vccd1 vccd1 sky130_fd_sc_hd__fill_2
XFILLER_29_333 vssd1 vssd1 vccd1 vccd1 sky130_fd_sc_hd__fill_1
XFILLER_29_344 vssd1 vssd1 vccd1 vccd1 sky130_fd_sc_hd__fill_2
XFILLER_56_141 vssd1 vccd1 vssd1 vccd1 sky130_ef_sc_hd__decap_40_12
XFILLER_44_347 vssd1 vssd1 vccd1 vccd1 sky130_fd_sc_hd__fill_1
XFILLER_44_43 vssd1 vssd1 vccd1 vccd1 sky130_fd_sc_hd__fill_1
XTAP_TAPCELL_ROW_39_383 vssd1 vccd1 sky130_fd_sc_hd__tapvpwrvgnd_1
XTAP_TAPCELL_ROW_14_217 vssd1 vccd1 sky130_fd_sc_hd__tapvpwrvgnd_1
XFILLER_12_255 vssd1 vssd1 vccd1 vccd1 sky130_fd_sc_hd__fill_1
XFILLER_5_15 vssd1 vccd1 vssd1 vccd1 sky130_ef_sc_hd__decap_40_12
XTAP_TAPCELL_ROW_22_272 vssd1 vccd1 sky130_fd_sc_hd__tapvpwrvgnd_1
XANTENNA__1191__B1 _1330_/B1 vssd1 vssd1 vccd1 vccd1 sky130_fd_sc_hd__diode_2
XFILLER_39_108 vssd1 vssd1 vccd1 vccd1 sky130_fd_sc_hd__fill_4
XPHY_EDGE_ROW_59_Left_119 vssd1 vssd1 vccd1 vccd1 sky130_fd_sc_hd__decap_3
XPHY_EDGE_ROW_13_Right_13 vssd1 vssd1 vccd1 vccd1 sky130_fd_sc_hd__decap_3
XPHY_EDGE_ROW_22_Right_22 vssd1 vssd1 vccd1 vccd1 sky130_fd_sc_hd__decap_3
XFILLER_7_281 vssd1 vccd1 vssd1 vccd1 sky130_ef_sc_hd__decap_40_12
Xload_slew140 fanout139/X vssd1 vssd1 vccd1 vccd1 load_slew140/X sky130_fd_sc_hd__clkbuf_2
XTAP_TAPCELL_ROW_28_309 vssd1 vccd1 sky130_fd_sc_hd__tapvpwrvgnd_1
XPHY_EDGE_ROW_31_Right_31 vssd1 vssd1 vccd1 vccd1 sky130_fd_sc_hd__decap_3
XFILLER_14_13 vssd1 vssd1 vccd1 vccd1 sky130_fd_sc_hd__fill_2
XFILLER_26_347 vssd1 vssd1 vccd1 vccd1 sky130_fd_sc_hd__fill_1
XFILLER_53_111 vssd1 vssd1 vccd1 vccd1 sky130_fd_sc_hd__fill_1
XTAP_TAPCELL_ROW_36_364 vssd1 vccd1 sky130_fd_sc_hd__tapvpwrvgnd_1
XPHY_EDGE_ROW_40_Right_40 vssd1 vssd1 vccd1 vccd1 sky130_fd_sc_hd__decap_3
XFILLER_30_78 vssd1 vssd1 vccd1 vccd1 sky130_fd_sc_hd__fill_4
XFILLER_39_87 vssd1 vssd1 vccd1 vccd1 sky130_fd_sc_hd__fill_4
XFILLER_4_251 vssd1 vssd1 vccd1 vccd1 sky130_fd_sc_hd__fill_1
X_1450_ _1463_/CLK _1450_/D load_slew137/X vssd1 vssd1 vccd1 vccd1 _1450_/Q sky130_fd_sc_hd__dfrtp_2
X_1381_ _1381_/A _1422_/B vssd1 vssd1 vccd1 vccd1 _1411_/A sky130_fd_sc_hd__nand2_2
XFILLER_35_144 vssd1 vccd1 vssd1 vccd1 sky130_ef_sc_hd__decap_40_12
XFILLER_35_177 vssd1 vssd1 vccd1 vccd1 sky130_fd_sc_hd__fill_2
XFILLER_50_103 vssd1 vccd1 vssd1 vccd1 sky130_ef_sc_hd__decap_40_12
XTAP_TAPCELL_ROW_33_345 vssd1 vccd1 sky130_fd_sc_hd__tapvpwrvgnd_1
XFILLER_41_169 vssd1 vssd1 vccd1 vccd1 sky130_fd_sc_hd__fill_1
XPHY_EDGE_ROW_38_Left_98 vssd1 vssd1 vccd1 vccd1 sky130_fd_sc_hd__decap_3
XANTENNA__1293__B _1327_/C vssd1 vssd1 vccd1 vccd1 sky130_fd_sc_hd__diode_2
XANTENNA_fanout96_X _1327_/C vssd1 vssd1 vccd1 vccd1 sky130_fd_sc_hd__diode_2
XFILLER_1_221 vssd1 vssd1 vccd1 vccd1 sky130_fd_sc_hd__fill_2
XFILLER_49_225 vssd1 vccd1 vssd1 vccd1 sky130_ef_sc_hd__decap_40_12
XFILLER_17_111 vssd1 vssd1 vccd1 vccd1 sky130_fd_sc_hd__fill_1
XFILLER_17_166 vssd1 vssd1 vccd1 vccd1 sky130_fd_sc_hd__fill_2
XTAP_TAPCELL_ROW_47_437 vssd1 vccd1 sky130_fd_sc_hd__tapvpwrvgnd_1
XANTENNA__1187__C _1205_/B vssd1 vssd1 vccd1 vccd1 sky130_fd_sc_hd__diode_2
XFILLER_20_309 vssd1 vccd1 vssd1 vccd1 sky130_ef_sc_hd__decap_40_12
XFILLER_32_169 vssd1 vssd1 vccd1 vccd1 sky130_fd_sc_hd__fill_1
X_0950_ _1020_/A _1020_/B vssd1 vssd1 vccd1 vccd1 _0950_/Y sky130_fd_sc_hd__xnor2_2
X_0881_ _0942_/B _0881_/B vssd1 vssd1 vccd1 vccd1 _0883_/B sky130_fd_sc_hd__xnor2_2
XTAP_TAPCELL_ROW_30_326 vssd1 vccd1 sky130_fd_sc_hd__tapvpwrvgnd_1
X_1433_ _1435_/A _1441_/D _1438_/D vssd1 vssd1 vccd1 vccd1 _1433_/X sky130_fd_sc_hd__and3_2
XFILLER_55_217 vssd1 vssd1 vccd1 vccd1 sky130_fd_sc_hd__fill_4
X_1364_ _1364_/A _1459_/D vssd1 vssd1 vccd1 vccd1 _1365_/B sky130_fd_sc_hd__xnor2_2
X_1295_ _1303_/C1 _1294_/X _1228_/B vssd1 vssd1 vccd1 vccd1 _1297_/A sky130_fd_sc_hd__o21ai_2
XFILLER_23_125 vssd1 vccd1 vssd1 vccd1 sky130_ef_sc_hd__decap_40_12
XFILLER_23_169 vssd1 vssd1 vccd1 vccd1 sky130_fd_sc_hd__fill_4
XANTENNA__1446__CLK _1459_/CLK vssd1 vssd1 vccd1 vccd1 sky130_fd_sc_hd__diode_2
XTAP_TAPCELL_ROW_44_418 vssd1 vccd1 sky130_fd_sc_hd__tapvpwrvgnd_1
XFILLER_52_65 vssd1 vccd1 vssd1 vccd1 sky130_ef_sc_hd__decap_40_12
Xinput19 prescaler[8] vssd1 vssd1 vccd1 vccd1 _0880_/B sky130_fd_sc_hd__buf_2
XFILLER_6_357 vssd1 vssd1 vccd1 vccd1 sky130_fd_sc_hd__fill_4
XFILLER_28_8 vssd1 vccd1 vssd1 vccd1 sky130_ef_sc_hd__decap_40_12
XFILLER_37_206 vssd1 vssd1 vccd1 vccd1 sky130_fd_sc_hd__fill_1
XFILLER_37_217 vssd1 vssd1 vccd1 vccd1 sky130_fd_sc_hd__fill_1
X_1080_ _1461_/Q _1352_/A vssd1 vssd1 vccd1 vccd1 _1081_/D sky130_fd_sc_hd__xnor2_2
XFILLER_20_106 vssd1 vssd1 vccd1 vccd1 sky130_fd_sc_hd__fill_2
XFILLER_52_209 vssd1 vccd1 vssd1 vccd1 sky130_ef_sc_hd__decap_40_12
X_0933_ _0930_/A _0930_/B _0929_/A vssd1 vssd1 vccd1 vccd1 _0939_/A sky130_fd_sc_hd__o21ai_2
X_0864_ _0865_/A _0865_/B vssd1 vssd1 vccd1 vccd1 _0864_/Y sky130_fd_sc_hd__nand2_2
X_0795_ _0812_/B _0804_/B vssd1 vssd1 vccd1 vccd1 _0795_/Y sky130_fd_sc_hd__nor2_2
XFILLER_3_81 vssd1 vccd1 vssd1 vccd1 sky130_ef_sc_hd__decap_40_12
X_1347_ _1347_/A _1467_/D vssd1 vssd1 vccd1 vccd1 _1347_/X sky130_fd_sc_hd__xor2_2
X_1416_ _1474_/Q _1416_/B _1418_/A _1384_/C vssd1 vssd1 vccd1 vccd1 _1436_/A sky130_fd_sc_hd__or4bb_2
XANTENNA__1469__CLK _1471_/CLK vssd1 vssd1 vccd1 vccd1 sky130_fd_sc_hd__diode_2
XFILLER_28_239 vssd1 vccd1 vssd1 vccd1 sky130_ef_sc_hd__decap_40_12
XFILLER_36_294 vssd1 vssd1 vccd1 vccd1 sky130_fd_sc_hd__fill_4
X_1278_ _1467_/Q _1466_/Q _1278_/C vssd1 vssd1 vccd1 vccd1 _1287_/B sky130_fd_sc_hd__and3_2
XFILLER_11_139 vssd1 vssd1 vccd1 vccd1 sky130_fd_sc_hd__fill_1
XFILLER_22_68 vssd1 vssd1 vccd1 vccd1 sky130_fd_sc_hd__fill_1
XFILLER_3_305 vssd1 vccd1 vssd1 vccd1 sky130_ef_sc_hd__decap_40_12
XFILLER_3_349 vssd1 vccd1 vssd1 vccd1 sky130_ef_sc_hd__decap_40_12
Xfanout130 _1542_/A vssd1 vssd1 vccd1 vccd1 _1535_/A sky130_fd_sc_hd__clkdlybuf4s25_1
Xfanout141 input6/X vssd1 vssd1 vccd1 vccd1 wire142/A sky130_fd_sc_hd__clkdlybuf4s25_1
Xteam_00_151 vssd1 vssd1 vccd1 vccd1 team_00_151/HI la_data_out[4] sky130_fd_sc_hd__conb_1
XTAP_TAPCELL_ROW_6_165 vssd1 vccd1 sky130_fd_sc_hd__tapvpwrvgnd_1
XFILLER_27_250 vssd1 vssd1 vccd1 vccd1 sky130_fd_sc_hd__fill_2
XFILLER_34_209 vssd1 vssd1 vccd1 vccd1 sky130_fd_sc_hd__fill_4
XFILLER_42_253 vssd1 vssd1 vccd1 vccd1 sky130_fd_sc_hd__fill_8
XFILLER_8_15 vssd1 vccd1 vssd1 vccd1 sky130_ef_sc_hd__decap_40_12
Xteam_00_173 vssd1 vssd1 vccd1 vccd1 team_00_173/HI la_data_out[26] sky130_fd_sc_hd__conb_1
Xteam_00_162 vssd1 vssd1 vccd1 vccd1 team_00_162/HI la_data_out[15] sky130_fd_sc_hd__conb_1
XFILLER_10_172 vssd1 vssd1 vccd1 vccd1 sky130_fd_sc_hd__fill_2
XFILLER_6_121 vssd1 vccd1 vssd1 vccd1 sky130_ef_sc_hd__decap_40_12
XFILLER_6_165 vssd1 vccd1 vssd1 vccd1 sky130_ef_sc_hd__decap_40_12
X_1201_ _1325_/B _1199_/X _1200_/Y vssd1 vssd1 vccd1 vccd1 _1456_/D sky130_fd_sc_hd__a21oi_2
XFILLER_33_220 vssd1 vssd1 vccd1 vccd1 sky130_fd_sc_hd__fill_4
X_1132_ _1132_/A _1132_/B _1132_/C vssd1 vssd1 vccd1 vccd1 _1133_/D sky130_fd_sc_hd__or3_2
X_1063_ _1063_/A _1063_/B vssd1 vssd1 vccd1 vccd1 _1069_/B sky130_fd_sc_hd__xnor2_2
XPHY_EDGE_ROW_25_Left_85 vssd1 vssd1 vccd1 vccd1 sky130_fd_sc_hd__decap_3
X_0916_ _0924_/A _0927_/A _0915_/Y vssd1 vssd1 vccd1 vccd1 _0917_/B sky130_fd_sc_hd__o21bai_2
X_0847_ _0847_/A _0847_/B vssd1 vssd1 vccd1 vccd1 _1345_/A sky130_fd_sc_hd__xnor2_2
X_0778_ _0778_/A _0778_/B vssd1 vssd1 vccd1 vccd1 _0997_/A sky130_fd_sc_hd__xnor2_2
XANTENNA__0857__A2 _0965_/A vssd1 vssd1 vccd1 vccd1 sky130_fd_sc_hd__diode_2
XFILLER_56_301 vssd1 vssd1 vccd1 vccd1 sky130_fd_sc_hd__fill_4
XFILLER_56_345 vssd1 vccd1 vssd1 vccd1 sky130_ef_sc_hd__decap_40_12
XTAP_TAPCELL_ROW_3_146 vssd1 vccd1 sky130_fd_sc_hd__tapvpwrvgnd_1
XANTENNA__1445__RESET_B load_slew137/X vssd1 vssd1 vccd1 vccd1 sky130_fd_sc_hd__diode_2
XFILLER_24_264 vssd1 vccd1 vssd1 vccd1 sky130_ef_sc_hd__decap_40_12
XFILLER_24_297 vssd1 vssd1 vccd1 vccd1 sky130_fd_sc_hd__fill_1
XFILLER_33_45 vssd1 vssd1 vccd1 vccd1 sky130_fd_sc_hd__fill_1
XFILLER_33_67 vssd1 vssd1 vccd1 vccd1 sky130_fd_sc_hd__fill_2
XANTENNA__1285__C _1285_/C vssd1 vssd1 vccd1 vccd1 sky130_fd_sc_hd__diode_2
XFILLER_3_113 vssd1 vccd1 vssd1 vccd1 sky130_ef_sc_hd__decap_40_12
XFILLER_58_53 vssd1 vccd1 vssd1 vccd1 sky130_ef_sc_hd__decap_40_12
XFILLER_15_220 vssd1 vssd1 vccd1 vccd1 sky130_fd_sc_hd__fill_4
XFILLER_58_97 vssd1 vccd1 vssd1 vccd1 sky130_ef_sc_hd__decap_40_12
XFILLER_30_267 vssd1 vssd1 vccd1 vccd1 sky130_fd_sc_hd__fill_2
XTAP_TAPCELL_ROW_25_292 vssd1 vccd1 sky130_fd_sc_hd__tapvpwrvgnd_1
XTAP_TAPCELL_ROW_17_237 vssd1 vccd1 sky130_fd_sc_hd__tapvpwrvgnd_1
XANTENNA__0784__A1 _0767_/A vssd1 vssd1 vccd1 vccd1 sky130_fd_sc_hd__diode_2
X_0701_ _1466_/Q vssd1 vssd1 vccd1 vccd1 _1059_/A sky130_fd_sc_hd__inv_2
XFILLER_31_3 vssd1 vssd1 vccd1 vccd1 sky130_fd_sc_hd__fill_4
XFILLER_38_345 vssd1 vssd1 vccd1 vccd1 sky130_fd_sc_hd__fill_1
XFILLER_57_109 vssd1 vssd1 vccd1 vccd1 sky130_fd_sc_hd__fill_2
XFILLER_53_337 vssd1 vccd1 vssd1 vccd1 sky130_ef_sc_hd__decap_40_12
X_1115_ _1114_/A _1113_/Y _1085_/X vssd1 vssd1 vccd1 vccd1 _1115_/X sky130_fd_sc_hd__o21a_2
X_1046_ _0950_/Y _0978_/B _0979_/X vssd1 vssd1 vccd1 vccd1 _1050_/B sky130_fd_sc_hd__a21o_2
XTAP_TAPCELL_ROW_0_127 vssd1 vccd1 sky130_fd_sc_hd__tapvpwrvgnd_1
XFILLER_21_245 vssd1 vccd1 vssd1 vccd1 sky130_ef_sc_hd__decap_40_12
XFILLER_21_289 vssd1 vccd1 vssd1 vccd1 sky130_ef_sc_hd__decap_40_12
XANTENNA_fanout109_X _1320_/C1 vssd1 vssd1 vccd1 vccd1 sky130_fd_sc_hd__diode_2
XFILLER_56_153 vssd1 vccd1 vssd1 vccd1 sky130_ef_sc_hd__decap_40_12
XFILLER_56_197 vssd1 vccd1 vssd1 vccd1 sky130_ef_sc_hd__decap_40_12
XTAP_TAPCELL_ROW_39_384 vssd1 vccd1 sky130_fd_sc_hd__tapvpwrvgnd_1
XTAP_TAPCELL_ROW_14_218 vssd1 vccd1 sky130_fd_sc_hd__tapvpwrvgnd_1
XFILLER_5_27 vssd1 vccd1 vssd1 vccd1 sky130_ef_sc_hd__decap_40_12
XTAP_TAPCELL_ROW_22_273 vssd1 vccd1 sky130_fd_sc_hd__tapvpwrvgnd_1
XFILLER_47_131 vssd1 vssd1 vccd1 vccd1 sky130_fd_sc_hd__fill_1
XFILLER_35_315 vssd1 vssd1 vccd1 vccd1 sky130_fd_sc_hd__fill_1
XFILLER_50_307 vssd1 vssd1 vccd1 vccd1 sky130_fd_sc_hd__fill_1
Xclkbuf_2_3__f_clk clkbuf_0_clk/X vssd1 vssd1 vccd1 vccd1 _1478_/CLK sky130_fd_sc_hd__clkbuf_16
XFILLER_7_293 vssd1 vccd1 vssd1 vccd1 sky130_ef_sc_hd__decap_40_12
XFILLER_38_197 vssd1 vccd1 vssd1 vccd1 sky130_ef_sc_hd__decap_40_12
XFILLER_53_167 vssd1 vssd1 vccd1 vccd1 sky130_fd_sc_hd__fill_1
X_1029_ _1029_/A _1033_/B _1029_/C vssd1 vssd1 vccd1 vccd1 _1036_/B sky130_fd_sc_hd__and3_2
XTAP_TAPCELL_ROW_36_365 vssd1 vccd1 sky130_fd_sc_hd__tapvpwrvgnd_1
XPHY_EDGE_ROW_12_Left_72 vssd1 vssd1 vccd1 vccd1 sky130_fd_sc_hd__decap_3
XFILLER_39_55 vssd1 vssd1 vccd1 vccd1 sky130_fd_sc_hd__fill_1
XFILLER_17_337 vssd1 vccd1 vssd1 vccd1 sky130_ef_sc_hd__decap_40_12
XFILLER_32_307 vssd1 vssd1 vccd1 vccd1 sky130_fd_sc_hd__fill_1
X_1380_ _1389_/A _1438_/B vssd1 vssd1 vccd1 vccd1 _1422_/B sky130_fd_sc_hd__nor2_2
XFILLER_31_362 vssd1 vssd1 vccd1 vccd1 sky130_fd_sc_hd__fill_1
XFILLER_35_123 vssd1 vssd1 vccd1 vccd1 sky130_fd_sc_hd__fill_1
XFILLER_35_156 vssd1 vccd1 vssd1 vccd1 sky130_ef_sc_hd__decap_40_12
XFILLER_50_115 vssd1 vccd1 vssd1 vccd1 sky130_ef_sc_hd__decap_40_12
XTAP_TAPCELL_ROW_33_346 vssd1 vccd1 sky130_fd_sc_hd__tapvpwrvgnd_1
XFILLER_6_81 vssd1 vssd1 vccd1 vccd1 sky130_fd_sc_hd__fill_2
XFILLER_14_307 vssd1 vssd1 vccd1 vccd1 sky130_fd_sc_hd__fill_1
XFILLER_26_112 vssd1 vssd1 vccd1 vccd1 sky130_fd_sc_hd__fill_2
XFILLER_26_134 vssd1 vssd1 vccd1 vccd1 sky130_fd_sc_hd__fill_4
XFILLER_22_351 vssd1 vssd1 vccd1 vccd1 sky130_fd_sc_hd__fill_1
XFILLER_25_57 vssd1 vssd1 vccd1 vccd1 sky130_fd_sc_hd__fill_1
XFILLER_41_126 vssd1 vssd1 vccd1 vccd1 sky130_fd_sc_hd__fill_8
XFILLER_41_78 vssd1 vssd1 vccd1 vccd1 sky130_fd_sc_hd__fill_8
XFILLER_9_3 vssd1 vccd1 vssd1 vccd1 sky130_ef_sc_hd__decap_40_12
XFILLER_1_277 vssd1 vssd1 vccd1 vccd1 sky130_fd_sc_hd__fill_2
XFILLER_49_237 vssd1 vccd1 vssd1 vccd1 sky130_ef_sc_hd__decap_40_12
XFILLER_57_281 vssd1 vccd1 vssd1 vccd1 sky130_ef_sc_hd__decap_40_12
XFILLER_17_123 vssd1 vssd1 vccd1 vccd1 sky130_fd_sc_hd__fill_1
XFILLER_17_156 vssd1 vssd1 vccd1 vccd1 sky130_fd_sc_hd__fill_1
XFILLER_9_333 vssd1 vssd1 vccd1 vccd1 sky130_fd_sc_hd__fill_2
X_0880_ _0953_/B _0880_/B vssd1 vssd1 vccd1 vccd1 _0881_/B sky130_fd_sc_hd__xor2_2
XTAP_TAPCELL_ROW_30_327 vssd1 vccd1 sky130_fd_sc_hd__tapvpwrvgnd_1
X_1363_ _1069_/B _1269_/A _1269_/B _1142_/A input7/X vssd1 vssd1 vccd1 vccd1 _1363_/X
+ sky130_fd_sc_hd__o32a_2
X_1432_ _1432_/A _1436_/B vssd1 vssd1 vccd1 vccd1 _1432_/Y sky130_fd_sc_hd__nor2_2
X_1294_ _1292_/Y _1293_/Y _1294_/S vssd1 vssd1 vccd1 vccd1 _1294_/X sky130_fd_sc_hd__mux2_1
XANTENNA_fanout136_A input6/X vssd1 vssd1 vccd1 vccd1 sky130_fd_sc_hd__diode_2
XFILLER_23_137 vssd1 vssd1 vccd1 vccd1 sky130_fd_sc_hd__fill_8
XFILLER_11_15 vssd1 vccd1 vssd1 vccd1 sky130_ef_sc_hd__decap_40_12
XANTENNA__0754__A _0767_/A vssd1 vssd1 vccd1 vccd1 sky130_fd_sc_hd__diode_2
XFILLER_39_281 vssd1 vccd1 vssd1 vccd1 sky130_ef_sc_hd__decap_40_12
XFILLER_54_251 vssd1 vssd1 vccd1 vccd1 sky130_fd_sc_hd__fill_1
XFILLER_10_321 vssd1 vccd1 vssd1 vccd1 sky130_ef_sc_hd__decap_40_12
XFILLER_10_365 vssd1 vssd1 vccd1 vccd1 sky130_fd_sc_hd__fill_8
XFILLER_52_77 vssd1 vssd1 vccd1 vccd1 sky130_fd_sc_hd__fill_4
XTAP_TAPCELL_ROW_9_185 vssd1 vccd1 sky130_fd_sc_hd__tapvpwrvgnd_1
XFILLER_37_229 vssd1 vssd1 vccd1 vccd1 sky130_fd_sc_hd__fill_4
XFILLER_45_251 vssd1 vssd1 vccd1 vccd1 sky130_fd_sc_hd__fill_1
XFILLER_45_273 vssd1 vssd1 vccd1 vccd1 sky130_fd_sc_hd__fill_4
XFILLER_9_141 vssd1 vssd1 vccd1 vccd1 sky130_fd_sc_hd__fill_2
X_0932_ _0934_/A _0934_/B vssd1 vssd1 vccd1 vccd1 _0937_/B sky130_fd_sc_hd__nor2_2
X_0863_ _0865_/A _0865_/B vssd1 vssd1 vccd1 vccd1 _0863_/Y sky130_fd_sc_hd__nor2_2
X_0794_ _1366_/A _1096_/B vssd1 vssd1 vccd1 vccd1 _0804_/B sky130_fd_sc_hd__nand2b_2
XFILLER_28_207 vssd1 vssd1 vccd1 vccd1 sky130_fd_sc_hd__fill_4
XFILLER_3_93 vssd1 vccd1 vssd1 vccd1 sky130_ef_sc_hd__decap_40_12
X_1346_ _1346_/A _1468_/D vssd1 vssd1 vccd1 vccd1 _1362_/A sky130_fd_sc_hd__xnor2_2
X_1415_ _1435_/A _1422_/D _1435_/B vssd1 vssd1 vccd1 vccd1 _1415_/X sky130_fd_sc_hd__and3_2
XFILLER_51_221 vssd1 vssd1 vccd1 vccd1 sky130_fd_sc_hd__fill_2
X_1277_ _1466_/Q _1278_/C _1467_/Q vssd1 vssd1 vccd1 vccd1 _1279_/A sky130_fd_sc_hd__a21oi_2
XANTENNA_clkbuf_2_1__f_clk_X _1459_/CLK vssd1 vssd1 vccd1 vccd1 sky130_fd_sc_hd__diode_2
XFILLER_3_317 vssd1 vccd1 vssd1 vccd1 sky130_ef_sc_hd__decap_40_12
Xfanout131 _1542_/A vssd1 vssd1 vccd1 vccd1 _1543_/A sky130_fd_sc_hd__clkdlybuf4s25_1
XFILLER_19_229 vssd1 vssd1 vccd1 vccd1 sky130_fd_sc_hd__fill_1
XFILLER_59_332 vssd1 vssd1 vccd1 vccd1 sky130_fd_sc_hd__fill_1
XFILLER_59_365 vssd1 vssd1 vccd1 vccd1 sky130_fd_sc_hd__fill_8
Xteam_00_174 vssd1 vssd1 vccd1 vccd1 team_00_174/HI la_data_out[27] sky130_fd_sc_hd__conb_1
Xteam_00_163 vssd1 vssd1 vccd1 vccd1 team_00_163/HI la_data_out[16] sky130_fd_sc_hd__conb_1
Xteam_00_152 vssd1 vssd1 vccd1 vccd1 team_00_152/HI la_data_out[5] sky130_fd_sc_hd__conb_1
XTAP_TAPCELL_ROW_6_166 vssd1 vccd1 sky130_fd_sc_hd__tapvpwrvgnd_1
XTAP_TAPCELL_ROW_57_500 vssd1 vccd1 sky130_fd_sc_hd__tapvpwrvgnd_1
XFILLER_8_27 vssd1 vssd1 vccd1 vccd1 sky130_fd_sc_hd__fill_1
XFILLER_6_133 vssd1 vssd1 vccd1 vccd1 sky130_fd_sc_hd__fill_4
XFILLER_6_177 vssd1 vccd1 vssd1 vccd1 sky130_ef_sc_hd__decap_40_12
XFILLER_2_361 vssd1 vssd1 vccd1 vccd1 sky130_fd_sc_hd__fill_2
XFILLER_33_7 vssd1 vssd1 vccd1 vccd1 sky130_fd_sc_hd__fill_2
X_1200_ _1456_/Q _1325_/B _1320_/C1 vssd1 vssd1 vccd1 vccd1 _1200_/Y sky130_fd_sc_hd__o21ai_2
XPHY_EDGE_ROW_0_Left_60 vssd1 vssd1 vccd1 vccd1 sky130_fd_sc_hd__decap_3
X_1131_ _1131_/A _1131_/B _1131_/C vssd1 vssd1 vccd1 vccd1 _1132_/C sky130_fd_sc_hd__or3_2
X_1062_ _1066_/A _1062_/B vssd1 vssd1 vccd1 vccd1 _1063_/B sky130_fd_sc_hd__nand2_2
X_0915_ _0942_/B _0915_/B vssd1 vssd1 vccd1 vccd1 _0915_/Y sky130_fd_sc_hd__nor2_2
XANTENNA__1200__B1 _1320_/C1 vssd1 vssd1 vccd1 vccd1 sky130_fd_sc_hd__diode_2
XFILLER_0_309 vssd1 vccd1 vssd1 vccd1 sky130_ef_sc_hd__decap_40_12
X_0846_ _0846_/A _0846_/B vssd1 vssd1 vccd1 vccd1 _0854_/B sky130_fd_sc_hd__xnor2_2
X_0777_ _0778_/A _0778_/B vssd1 vssd1 vccd1 vccd1 _0777_/X sky130_fd_sc_hd__and2b_2
XFILLER_56_357 vssd1 vssd1 vccd1 vccd1 sky130_fd_sc_hd__fill_4
X_1329_ _1329_/A _1329_/B _1328_/X vssd1 vssd1 vccd1 vccd1 _1329_/Y sky130_fd_sc_hd__nor3b_2
XTAP_TAPCELL_ROW_3_147 vssd1 vccd1 sky130_fd_sc_hd__tapvpwrvgnd_1
XANTENNA__1267__B1 _1332_/A1 vssd1 vssd1 vccd1 vccd1 sky130_fd_sc_hd__diode_2
XFILLER_3_125 vssd1 vccd1 vssd1 vccd1 sky130_ef_sc_hd__decap_40_12
XFILLER_3_169 vssd1 vccd1 vssd1 vccd1 sky130_ef_sc_hd__decap_40_12
XFILLER_58_65 vssd1 vccd1 vssd1 vccd1 sky130_ef_sc_hd__decap_40_12
XFILLER_47_335 vssd1 vssd1 vccd1 vccd1 sky130_fd_sc_hd__fill_1
XFILLER_59_184 vssd1 vccd1 vssd1 vccd1 sky130_ef_sc_hd__decap_40_12
XTAP_TAPCELL_ROW_17_238 vssd1 vccd1 sky130_fd_sc_hd__tapvpwrvgnd_1
XANTENNA__0942__A input9/X vssd1 vssd1 vccd1 vccd1 sky130_fd_sc_hd__diode_2
X_0700_ _1469_/Q vssd1 vssd1 vccd1 vccd1 _1039_/A sky130_fd_sc_hd__inv_2
XTAP_TAPCELL_ROW_25_293 vssd1 vccd1 sky130_fd_sc_hd__tapvpwrvgnd_1
XANTENNA__1459__CLK _1459_/CLK vssd1 vssd1 vccd1 vccd1 sky130_fd_sc_hd__diode_2
XFILLER_38_335 vssd1 vssd1 vccd1 vccd1 sky130_fd_sc_hd__fill_8
XFILLER_53_305 vssd1 vccd1 vssd1 vccd1 sky130_ef_sc_hd__decap_40_12
X_1114_ _1114_/A _1114_/B _1112_/X vssd1 vssd1 vccd1 vccd1 _1132_/B sky130_fd_sc_hd__or3b_2
XFILLER_0_83 vssd1 vssd1 vccd1 vccd1 sky130_fd_sc_hd__fill_1
XFILLER_53_349 vssd1 vccd1 vssd1 vccd1 sky130_ef_sc_hd__decap_40_12
X_1045_ _1133_/A _1133_/B vssd1 vssd1 vccd1 vccd1 _1045_/X sky130_fd_sc_hd__or2_2
XTAP_TAPCELL_ROW_0_128 vssd1 vccd1 sky130_fd_sc_hd__tapvpwrvgnd_1
XFILLER_21_257 vssd1 vccd1 vssd1 vccd1 sky130_ef_sc_hd__decap_40_12
X_0829_ _1096_/A _1096_/B vssd1 vssd1 vccd1 vccd1 _1097_/A sky130_fd_sc_hd__nand2_2
XFILLER_9_81 vssd1 vccd1 vssd1 vccd1 sky130_ef_sc_hd__decap_40_12
XFILLER_29_346 vssd1 vssd1 vccd1 vccd1 sky130_fd_sc_hd__fill_1
XFILLER_56_121 vssd1 vccd1 vssd1 vccd1 sky130_ef_sc_hd__decap_40_12
XFILLER_56_165 vssd1 vccd1 vssd1 vccd1 sky130_ef_sc_hd__decap_40_12
XTAP_TAPCELL_ROW_39_385 vssd1 vccd1 sky130_fd_sc_hd__tapvpwrvgnd_1
XFILLER_12_213 vssd1 vssd1 vccd1 vccd1 sky130_fd_sc_hd__fill_8
XFILLER_44_89 vssd1 vssd1 vccd1 vccd1 sky130_fd_sc_hd__fill_2
XFILLER_8_206 vssd1 vssd1 vccd1 vccd1 sky130_fd_sc_hd__fill_1
XFILLER_8_217 vssd1 vssd1 vccd1 vccd1 sky130_fd_sc_hd__fill_2
XTAP_TAPCELL_ROW_22_274 vssd1 vccd1 sky130_fd_sc_hd__tapvpwrvgnd_1
XTAP_TAPCELL_ROW_14_219 vssd1 vccd1 sky130_fd_sc_hd__tapvpwrvgnd_1
XFILLER_5_39 vssd1 vccd1 vssd1 vccd1 sky130_ef_sc_hd__decap_40_12
XFILLER_47_110 vssd1 vssd1 vccd1 vccd1 sky130_fd_sc_hd__fill_2
Xload_slew120 _1140_/B vssd1 vssd1 vccd1 vccd1 _1180_/A1 sky130_fd_sc_hd__clkbuf_4
XPHY_EDGE_ROW_7_Right_7 vssd1 vssd1 vccd1 vccd1 sky130_fd_sc_hd__decap_3
XFILLER_38_187 vssd1 vssd1 vccd1 vccd1 sky130_fd_sc_hd__fill_8
XFILLER_53_113 vssd1 vccd1 vssd1 vccd1 sky130_ef_sc_hd__decap_40_12
XFILLER_14_37 vssd1 vssd1 vccd1 vccd1 sky130_fd_sc_hd__fill_2
X_1028_ _1033_/B _1029_/C _1029_/A vssd1 vssd1 vccd1 vccd1 _1036_/A sky130_fd_sc_hd__a21oi_2
XTAP_TAPCELL_ROW_36_366 vssd1 vccd1 sky130_fd_sc_hd__tapvpwrvgnd_1
XFILLER_39_34 vssd1 vssd1 vccd1 vccd1 sky130_fd_sc_hd__fill_4
XFILLER_39_45 vssd1 vssd1 vccd1 vccd1 sky130_fd_sc_hd__fill_8
XFILLER_17_349 vssd1 vssd1 vccd1 vccd1 sky130_fd_sc_hd__fill_2
XFILLER_29_176 vssd1 vssd1 vccd1 vccd1 sky130_fd_sc_hd__fill_4
XFILLER_55_55 vssd1 vssd1 vccd1 vccd1 sky130_fd_sc_hd__fill_1
XFILLER_4_253 vssd1 vccd1 vssd1 vccd1 sky130_ef_sc_hd__decap_40_12
XFILLER_35_113 vssd1 vssd1 vccd1 vccd1 sky130_fd_sc_hd__fill_8
XFILLER_23_319 vssd1 vccd1 vssd1 vccd1 sky130_ef_sc_hd__decap_40_12
XFILLER_50_127 vssd1 vccd1 vssd1 vccd1 sky130_ef_sc_hd__decap_40_12
XFILLER_58_249 vssd1 vssd1 vccd1 vccd1 sky130_fd_sc_hd__fill_2
XFILLER_25_47 vssd1 vssd1 vccd1 vccd1 sky130_fd_sc_hd__fill_4
XFILLER_41_57 vssd1 vccd1 vssd1 vccd1 sky130_ef_sc_hd__decap_40_12
XFILLER_1_223 vssd1 vssd1 vccd1 vccd1 sky130_fd_sc_hd__fill_1
XFILLER_49_205 vssd1 vccd1 vssd1 vccd1 sky130_ef_sc_hd__decap_40_12
XANTENNA__1303__C1 _1303_/C1 vssd1 vssd1 vccd1 vccd1 sky130_fd_sc_hd__diode_2
XANTENNA_input11_A prescaler[13] vssd1 vssd1 vccd1 vccd1 sky130_fd_sc_hd__diode_2
XFILLER_17_113 vssd1 vssd1 vccd1 vccd1 sky130_fd_sc_hd__fill_8
XFILLER_2_18 vssd1 vssd1 vccd1 vccd1 sky130_fd_sc_hd__fill_8
XFILLER_2_29 vssd1 vccd1 vssd1 vccd1 sky130_ef_sc_hd__decap_40_12
XFILLER_49_249 vssd1 vccd1 vssd1 vccd1 sky130_ef_sc_hd__decap_40_12
XFILLER_57_293 vssd1 vccd1 vssd1 vccd1 sky130_ef_sc_hd__decap_40_12
XFILLER_15_80 vssd1 vssd1 vccd1 vccd1 sky130_fd_sc_hd__fill_1
X_1362_ _1362_/A _1362_/B _1362_/C _1362_/D vssd1 vssd1 vccd1 vccd1 _1379_/B sky130_fd_sc_hd__or4_2
X_1431_ _1435_/A _1431_/B _1438_/D vssd1 vssd1 vccd1 vccd1 _1431_/X sky130_fd_sc_hd__and3b_2
X_1293_ _1469_/Q _1327_/C vssd1 vssd1 vccd1 vccd1 _1293_/Y sky130_fd_sc_hd__nand2_2
XANTENNA__0860__A _0953_/B vssd1 vssd1 vccd1 vccd1 sky130_fd_sc_hd__diode_2
XFILLER_31_171 vssd1 vssd1 vccd1 vccd1 sky130_fd_sc_hd__fill_2
XFILLER_11_27 vssd1 vccd1 vssd1 vccd1 sky130_ef_sc_hd__decap_40_12
XANTENNA_input3_A la_data_in[1] vssd1 vssd1 vccd1 vccd1 sky130_fd_sc_hd__diode_2
XFILLER_36_46 vssd1 vssd1 vccd1 vccd1 sky130_fd_sc_hd__fill_2
XFILLER_39_293 vssd1 vssd1 vccd1 vccd1 sky130_fd_sc_hd__fill_1
XFILLER_36_68 vssd1 vssd1 vccd1 vccd1 sky130_fd_sc_hd__fill_2
XTAP_TAPCELL_ROW_52_464 vssd1 vccd1 sky130_fd_sc_hd__tapvpwrvgnd_1
XFILLER_10_333 vssd1 vccd1 vssd1 vccd1 sky130_ef_sc_hd__decap_40_12
XFILLER_22_171 vssd1 vssd1 vccd1 vccd1 sky130_fd_sc_hd__fill_4
XTAP_TAPCELL_ROW_9_186 vssd1 vccd1 sky130_fd_sc_hd__tapvpwrvgnd_1
XFILLER_20_108 vssd1 vssd1 vccd1 vccd1 sky130_fd_sc_hd__fill_1
X_0931_ _0941_/A _0941_/B vssd1 vssd1 vccd1 vccd1 _0934_/B sky130_fd_sc_hd__or2_2
X_0862_ _0862_/A _0862_/B vssd1 vssd1 vccd1 vccd1 _0865_/B sky130_fd_sc_hd__xnor2_2
XFILLER_54_3 vssd1 vccd1 vssd1 vccd1 sky130_ef_sc_hd__decap_40_12
X_0793_ _0793_/A _0793_/B vssd1 vssd1 vccd1 vccd1 _0803_/A sky130_fd_sc_hd__xnor2_2
XFILLER_28_219 vssd1 vssd1 vccd1 vccd1 sky130_fd_sc_hd__fill_8
X_1345_ _1345_/A _1456_/D vssd1 vssd1 vccd1 vccd1 _1345_/X sky130_fd_sc_hd__xor2_2
X_1414_ _1417_/A _1434_/A vssd1 vssd1 vccd1 vccd1 _1414_/Y sky130_fd_sc_hd__nor2_2
X_1276_ _1310_/A2 _1274_/X _1275_/X vssd1 vssd1 vccd1 vccd1 _1466_/D sky130_fd_sc_hd__a21oi_2
XFILLER_51_277 vssd1 vssd1 vccd1 vccd1 sky130_fd_sc_hd__fill_2
XFILLER_22_59 vssd1 vssd1 vccd1 vccd1 sky130_fd_sc_hd__fill_2
XANTENNA_input6_X input6/X vssd1 vssd1 vccd1 vccd1 sky130_fd_sc_hd__diode_2
XFILLER_3_329 vssd1 vssd1 vccd1 vccd1 sky130_fd_sc_hd__fill_4
Xfanout110 _1340_/A vssd1 vssd1 vccd1 vccd1 _0715_/B sky130_fd_sc_hd__clkdlybuf4s25_1
Xfanout121 _1192_/B vssd1 vssd1 vccd1 vccd1 _1214_/A2 sky130_fd_sc_hd__clkdlybuf4s25_1
Xfanout132 _1542_/A vssd1 vssd1 vccd1 vccd1 _1530_/A sky130_fd_sc_hd__clkdlybuf4s25_1
XTAP_TAPCELL_ROW_6_167 vssd1 vccd1 sky130_fd_sc_hd__tapvpwrvgnd_1
XFILLER_27_252 vssd1 vssd1 vccd1 vccd1 sky130_fd_sc_hd__fill_1
XFILLER_42_211 vssd1 vssd1 vccd1 vccd1 sky130_fd_sc_hd__fill_1
Xteam_00_175 vssd1 vssd1 vccd1 vccd1 team_00_175/HI la_data_out[28] sky130_fd_sc_hd__conb_1
Xteam_00_164 vssd1 vssd1 vccd1 vccd1 team_00_164/HI la_data_out[17] sky130_fd_sc_hd__conb_1
Xteam_00_153 vssd1 vssd1 vccd1 vccd1 team_00_153/HI la_data_out[6] sky130_fd_sc_hd__conb_1
XTAP_TAPCELL_ROW_57_501 vssd1 vccd1 sky130_fd_sc_hd__tapvpwrvgnd_1
XFILLER_10_174 vssd1 vssd1 vccd1 vccd1 sky130_fd_sc_hd__fill_1
XFILLER_6_189 vssd1 vssd1 vccd1 vccd1 sky130_fd_sc_hd__fill_4
XFILLER_26_7 vssd1 vssd1 vccd1 vccd1 sky130_fd_sc_hd__fill_1
X_1130_ _1447_/Q _1130_/B _1446_/Q _1109_/A vssd1 vssd1 vccd1 vccd1 _1131_/C sky130_fd_sc_hd__or4b_2
XFILLER_18_285 vssd1 vssd1 vccd1 vccd1 sky130_fd_sc_hd__fill_2
XFILLER_33_233 vssd1 vssd1 vccd1 vccd1 sky130_fd_sc_hd__fill_2
X_1061_ _1004_/Y _1061_/B vssd1 vssd1 vccd1 vccd1 _1063_/A sky130_fd_sc_hd__nand2b_2
X_0914_ _0953_/B _0915_/B _0914_/C vssd1 vssd1 vccd1 vccd1 _0927_/A sky130_fd_sc_hd__nand3_2
X_0845_ _0845_/A _0845_/B vssd1 vssd1 vccd1 vccd1 _1353_/A sky130_fd_sc_hd__xnor2_2
X_0776_ input9/X _0779_/B _0774_/X vssd1 vssd1 vccd1 vccd1 _0778_/B sky130_fd_sc_hd__a21o_2
XANTENNA__1267__A1 _1330_/B1 vssd1 vssd1 vccd1 vccd1 sky130_fd_sc_hd__diode_2
X_1328_ _1447_/Q _1328_/B vssd1 vssd1 vccd1 vccd1 _1328_/X sky130_fd_sc_hd__or2_2
X_1259_ _1288_/A _1257_/Y _1258_/X _1303_/C1 vssd1 vssd1 vccd1 vccd1 _1259_/X sky130_fd_sc_hd__a211o_2
XTAP_TAPCELL_ROW_3_148 vssd1 vccd1 sky130_fd_sc_hd__tapvpwrvgnd_1
XFILLER_24_222 vssd1 vssd1 vccd1 vccd1 sky130_fd_sc_hd__fill_1
XFILLER_3_137 vssd1 vccd1 vssd1 vccd1 sky130_ef_sc_hd__decap_40_12
XFILLER_58_77 vssd1 vssd1 vccd1 vccd1 sky130_fd_sc_hd__fill_4
XFILLER_59_141 vssd1 vssd1 vccd1 vccd1 sky130_fd_sc_hd__fill_8
XFILLER_59_152 vssd1 vssd1 vccd1 vccd1 sky130_fd_sc_hd__fill_4
XTAP_TAPCELL_ROW_17_239 vssd1 vccd1 sky130_fd_sc_hd__tapvpwrvgnd_1
XANTENNA__0942__B _0942_/B vssd1 vssd1 vccd1 vccd1 sky130_fd_sc_hd__diode_2
XFILLER_23_91 vssd1 vssd1 vccd1 vccd1 sky130_fd_sc_hd__fill_1
XFILLER_30_225 vssd1 vssd1 vccd1 vccd1 sky130_fd_sc_hd__fill_4
XFILLER_30_269 vssd1 vssd1 vccd1 vccd1 sky130_fd_sc_hd__fill_1
XTAP_TAPCELL_ROW_25_294 vssd1 vccd1 sky130_fd_sc_hd__tapvpwrvgnd_1
XFILLER_53_317 vssd1 vccd1 vssd1 vccd1 sky130_ef_sc_hd__decap_40_12
X_1113_ _1111_/X _1112_/X _1114_/B vssd1 vssd1 vccd1 vccd1 _1113_/Y sky130_fd_sc_hd__a21oi_2
X_1044_ _1044_/A _1044_/B _1042_/Y _1043_/X vssd1 vssd1 vccd1 vccd1 _1133_/B sky130_fd_sc_hd__or4bb_2
XTAP_TAPCELL_ROW_0_129 vssd1 vccd1 sky130_fd_sc_hd__tapvpwrvgnd_1
XFILLER_21_225 vssd1 vssd1 vccd1 vccd1 sky130_fd_sc_hd__fill_2
XFILLER_21_269 vssd1 vssd1 vccd1 vccd1 sky130_fd_sc_hd__fill_4
X_0828_ _0832_/A _0832_/B vssd1 vssd1 vccd1 vccd1 _1092_/A sky130_fd_sc_hd__or2_2
X_0759_ _0869_/A _0869_/B vssd1 vssd1 vccd1 vccd1 _0870_/A sky130_fd_sc_hd__nand2_2
XFILLER_9_93 vssd1 vccd1 vssd1 vccd1 sky130_ef_sc_hd__decap_40_12
XANTENNA__1185__B1 _1320_/C1 vssd1 vssd1 vccd1 vccd1 sky130_fd_sc_hd__diode_2
XFILLER_44_35 vssd1 vssd1 vccd1 vccd1 sky130_fd_sc_hd__fill_8
XFILLER_52_361 vssd1 vssd1 vccd1 vccd1 sky130_fd_sc_hd__fill_2
XFILLER_56_133 vssd1 vssd1 vccd1 vccd1 sky130_fd_sc_hd__fill_4
XFILLER_56_177 vssd1 vccd1 vssd1 vccd1 sky130_ef_sc_hd__decap_40_12
XFILLER_12_258 vssd1 vssd1 vccd1 vccd1 sky130_fd_sc_hd__fill_2
XTAP_TAPCELL_ROW_22_275 vssd1 vccd1 sky130_fd_sc_hd__tapvpwrvgnd_1
XFILLER_47_166 vssd1 vssd1 vccd1 vccd1 sky130_fd_sc_hd__fill_2
XFILLER_47_188 vssd1 vssd1 vccd1 vccd1 sky130_fd_sc_hd__fill_4
XFILLER_50_309 vssd1 vccd1 vssd1 vccd1 sky130_ef_sc_hd__decap_40_12
XFILLER_26_317 vssd1 vccd1 vssd1 vccd1 sky130_ef_sc_hd__decap_40_12
XFILLER_53_125 vssd1 vccd1 vssd1 vccd1 sky130_ef_sc_hd__decap_40_12
XFILLER_53_169 vssd1 vccd1 vssd1 vccd1 sky130_ef_sc_hd__decap_40_12
X_1027_ _1033_/B _1029_/C vssd1 vssd1 vccd1 vccd1 _1350_/A sky130_fd_sc_hd__nand2_2
XPHY_EDGE_ROW_46_Left_106 vssd1 vssd1 vccd1 vccd1 sky130_fd_sc_hd__decap_3
XFILLER_30_48 vssd1 vccd1 vssd1 vccd1 sky130_ef_sc_hd__decap_40_12
XPHY_EDGE_ROW_55_Left_115 vssd1 vssd1 vccd1 vccd1 sky130_fd_sc_hd__decap_3
XANTENNA__1330__B1 _1330_/B1 vssd1 vssd1 vccd1 vccd1 sky130_fd_sc_hd__diode_2
XFILLER_29_100 vssd1 vccd1 vssd1 vccd1 sky130_ef_sc_hd__decap_40_12
XFILLER_39_57 vssd1 vccd1 vssd1 vccd1 sky130_ef_sc_hd__decap_40_12
XANTENNA__1449__CLK _1463_/CLK vssd1 vssd1 vccd1 vccd1 sky130_fd_sc_hd__diode_2
XFILLER_32_309 vssd1 vccd1 vssd1 vccd1 sky130_ef_sc_hd__decap_40_12
XFILLER_4_221 vssd1 vccd1 vssd1 vccd1 sky130_ef_sc_hd__decap_40_12
XANTENNA__1149__B1 _1320_/C1 vssd1 vssd1 vccd1 vccd1 sky130_fd_sc_hd__diode_2
XFILLER_4_265 vssd1 vccd1 vssd1 vccd1 sky130_ef_sc_hd__decap_40_12
XFILLER_35_169 vssd1 vssd1 vccd1 vccd1 sky130_fd_sc_hd__fill_8
XFILLER_50_139 vssd1 vssd1 vccd1 vccd1 sky130_fd_sc_hd__fill_1
XFILLER_6_83 vssd1 vssd1 vccd1 vccd1 sky130_fd_sc_hd__fill_1
XANTENNA__1155__A3 _1205_/B vssd1 vssd1 vccd1 vccd1 sky130_fd_sc_hd__diode_2
XFILLER_14_309 vssd1 vccd1 vssd1 vccd1 sky130_ef_sc_hd__decap_40_12
XFILLER_41_117 vssd1 vssd1 vccd1 vccd1 sky130_fd_sc_hd__fill_2
XFILLER_41_69 vssd1 vssd1 vccd1 vccd1 sky130_fd_sc_hd__fill_2
XFILLER_1_279 vssd1 vssd1 vccd1 vccd1 sky130_fd_sc_hd__fill_1
XFILLER_49_217 vssd1 vssd1 vccd1 vccd1 sky130_fd_sc_hd__fill_4
XFILLER_17_169 vssd1 vssd1 vccd1 vccd1 sky130_fd_sc_hd__fill_8
XFILLER_57_261 vssd1 vccd1 vssd1 vccd1 sky130_ef_sc_hd__decap_40_12
XFILLER_13_353 vssd1 vssd1 vccd1 vccd1 sky130_fd_sc_hd__fill_2
XFILLER_32_139 vssd1 vssd1 vccd1 vccd1 sky130_fd_sc_hd__fill_1
XFILLER_40_183 vssd1 vccd1 vssd1 vccd1 sky130_ef_sc_hd__decap_40_12
XFILLER_9_335 vssd1 vssd1 vccd1 vccd1 sky130_fd_sc_hd__fill_1
XTAP_TAPCELL_ROW_55_484 vssd1 vccd1 sky130_fd_sc_hd__tapvpwrvgnd_1
X_1430_ _1430_/A _1436_/B vssd1 vssd1 vccd1 vccd1 _1430_/Y sky130_fd_sc_hd__nor2_2
XFILLER_48_250 vssd1 vssd1 vccd1 vccd1 sky130_fd_sc_hd__fill_2
X_1361_ _1342_/A _1455_/D _1444_/D _1445_/D _0902_/A vssd1 vssd1 vccd1 vccd1 _1362_/D
+ sky130_fd_sc_hd__a2111o_2
Xoutput80 _1440_/X vssd1 vssd1 vccd1 vccd1 gpio_out[31] sky130_fd_sc_hd__clkdlybuf4s25_1
X_1292_ _1469_/Q _1299_/C vssd1 vssd1 vccd1 vccd1 _1292_/Y sky130_fd_sc_hd__xnor2_2
XFILLER_11_39 vssd1 vccd1 vssd1 vccd1 sky130_ef_sc_hd__decap_40_12
XFILLER_36_25 vssd1 vssd1 vccd1 vccd1 sky130_fd_sc_hd__fill_2
XFILLER_54_253 vssd1 vccd1 vssd1 vccd1 sky130_ef_sc_hd__decap_40_12
XTAP_TAPCELL_ROW_52_465 vssd1 vccd1 sky130_fd_sc_hd__tapvpwrvgnd_1
XANTENNA__1221__C1 _1303_/C1 vssd1 vssd1 vccd1 vccd1 sky130_fd_sc_hd__diode_2
XFILLER_10_345 vssd1 vccd1 vssd1 vccd1 sky130_ef_sc_hd__decap_40_12
XFILLER_6_305 vssd1 vssd1 vccd1 vccd1 sky130_fd_sc_hd__fill_2
XANTENNA_fanout94_X _1205_/B vssd1 vssd1 vccd1 vccd1 sky130_fd_sc_hd__diode_2
XTAP_TAPCELL_ROW_9_187 vssd1 vccd1 sky130_fd_sc_hd__tapvpwrvgnd_1
XFILLER_26_80 vssd1 vssd1 vccd1 vccd1 sky130_fd_sc_hd__fill_4
XTAP_TAPCELL_ROW_43_410 vssd1 vccd1 sky130_fd_sc_hd__tapvpwrvgnd_1
XFILLER_9_143 vssd1 vssd1 vccd1 vccd1 sky130_fd_sc_hd__fill_1
X_0930_ _0930_/A _0930_/B vssd1 vssd1 vccd1 vccd1 _0941_/B sky130_fd_sc_hd__xnor2_2
X_0861_ _0862_/A _0862_/B vssd1 vssd1 vccd1 vccd1 _0885_/A sky130_fd_sc_hd__or2_2
X_0792_ _0942_/B _0792_/B vssd1 vssd1 vccd1 vccd1 _0802_/A sky130_fd_sc_hd__xor2_2
X_1413_ _1384_/C _1438_/C _1418_/A vssd1 vssd1 vccd1 vccd1 _1434_/A sky130_fd_sc_hd__nand3b_2
XFILLER_3_51 vssd1 vssd1 vccd1 vccd1 sky130_fd_sc_hd__fill_4
X_1344_ _1344_/A _1471_/D vssd1 vssd1 vccd1 vccd1 _1357_/B sky130_fd_sc_hd__xor2_2
X_1275_ _1059_/A _1309_/B1 _1313_/B1 vssd1 vssd1 vccd1 vccd1 _1275_/X sky130_fd_sc_hd__a21o_2
XANTENNA_fanout141_A input6/X vssd1 vssd1 vccd1 vccd1 sky130_fd_sc_hd__diode_2
XFILLER_51_223 vssd1 vssd1 vccd1 vccd1 sky130_fd_sc_hd__fill_1
Xfanout100 _1124_/X vssd1 vssd1 vccd1 vccd1 _1206_/A2 sky130_fd_sc_hd__clkdlybuf4s25_1
Xfanout111 _1438_/A vssd1 vssd1 vccd1 vccd1 _1435_/A sky130_fd_sc_hd__clkdlybuf4s25_1
Xfanout133 _0687_/Y vssd1 vssd1 vccd1 vccd1 _1542_/A sky130_fd_sc_hd__clkdlybuf4s25_1
XTAP_TAPCELL_ROW_6_168 vssd1 vccd1 sky130_fd_sc_hd__tapvpwrvgnd_1
XTAP_TAPCELL_ROW_57_502 vssd1 vccd1 sky130_fd_sc_hd__tapvpwrvgnd_1
XFILLER_27_231 vssd1 vssd1 vccd1 vccd1 sky130_fd_sc_hd__fill_2
XFILLER_27_242 vssd1 vssd1 vccd1 vccd1 sky130_fd_sc_hd__fill_8
XFILLER_27_297 vssd1 vssd1 vccd1 vccd1 sky130_fd_sc_hd__fill_1
XFILLER_42_201 vssd1 vssd1 vccd1 vccd1 sky130_fd_sc_hd__fill_2
Xteam_00_176 vssd1 vssd1 vccd1 vccd1 team_00_176/HI la_data_out[29] sky130_fd_sc_hd__conb_1
Xteam_00_165 vssd1 vssd1 vccd1 vccd1 team_00_165/HI la_data_out[18] sky130_fd_sc_hd__conb_1
Xteam_00_154 vssd1 vssd1 vccd1 vccd1 team_00_154/HI la_data_out[7] sky130_fd_sc_hd__conb_1
XPHY_EDGE_ROW_29_Right_29 vssd1 vssd1 vccd1 vccd1 sky130_fd_sc_hd__decap_3
XFILLER_10_164 vssd1 vssd1 vccd1 vccd1 sky130_fd_sc_hd__fill_8
XFILLER_8_29 vssd1 vccd1 vssd1 vccd1 sky130_ef_sc_hd__decap_40_12
XPHY_EDGE_ROW_38_Right_38 vssd1 vssd1 vccd1 vccd1 sky130_fd_sc_hd__decap_3
XFILLER_10_197 vssd1 vccd1 vssd1 vccd1 sky130_ef_sc_hd__decap_40_12
XFILLER_2_363 vssd1 vssd1 vccd1 vccd1 sky130_fd_sc_hd__fill_1
XFILLER_18_242 vssd1 vssd1 vccd1 vccd1 sky130_fd_sc_hd__fill_8
X_1060_ _1467_/Q _1048_/X _1049_/X _1057_/Y _1059_/X vssd1 vssd1 vccd1 vccd1 _1070_/B
+ sky130_fd_sc_hd__a311o_2
XPHY_EDGE_ROW_47_Right_47 vssd1 vssd1 vccd1 vccd1 sky130_fd_sc_hd__decap_3
XFILLER_33_289 vssd1 vssd1 vccd1 vccd1 sky130_fd_sc_hd__fill_2
XPHY_EDGE_ROW_56_Right_56 vssd1 vssd1 vccd1 vccd1 sky130_fd_sc_hd__decap_3
X_0913_ _0913_/A _0943_/A vssd1 vssd1 vccd1 vccd1 _0914_/C sky130_fd_sc_hd__or2_2
X_0844_ _0844_/A _0844_/B vssd1 vssd1 vccd1 vccd1 _1364_/A sky130_fd_sc_hd__xnor2_2
X_0775_ _0775_/A _0775_/B vssd1 vssd1 vccd1 vccd1 _0779_/B sky130_fd_sc_hd__xnor2_2
XFILLER_17_16 vssd1 vssd1 vccd1 vccd1 sky130_fd_sc_hd__fill_8
X_1327_ _1447_/Q _1329_/A _1327_/C vssd1 vssd1 vccd1 vccd1 _1327_/X sky130_fd_sc_hd__and3_2
X_1258_ _1307_/A1 _1307_/A2 _1307_/B1 _1256_/X vssd1 vssd1 vccd1 vccd1 _1258_/X sky130_fd_sc_hd__o211a_2
X_1189_ _1455_/Q _1454_/Q _1189_/C vssd1 vssd1 vccd1 vccd1 _1195_/B sky130_fd_sc_hd__and3_2
XTAP_TAPCELL_ROW_3_149 vssd1 vccd1 sky130_fd_sc_hd__tapvpwrvgnd_1
XFILLER_3_105 vssd1 vssd1 vccd1 vccd1 sky130_fd_sc_hd__fill_4
XFILLER_3_149 vssd1 vccd1 vssd1 vccd1 sky130_ef_sc_hd__decap_40_12
XFILLER_47_337 vssd1 vssd1 vccd1 vccd1 sky130_fd_sc_hd__fill_2
XFILLER_59_197 vssd1 vccd1 vssd1 vccd1 sky130_ef_sc_hd__decap_40_12
XPHY_EDGE_ROW_29_Left_89 vssd1 vssd1 vccd1 vccd1 sky130_fd_sc_hd__decap_3
XFILLER_2_193 vssd1 vssd1 vccd1 vccd1 sky130_fd_sc_hd__fill_2
XFILLER_38_304 vssd1 vssd1 vccd1 vccd1 sky130_fd_sc_hd__fill_4
XFILLER_0_41 vssd1 vccd1 vssd1 vccd1 sky130_ef_sc_hd__decap_40_12
XFILLER_0_85 vssd1 vssd1 vccd1 vccd1 sky130_fd_sc_hd__fill_4
XFILLER_38_326 vssd1 vssd1 vccd1 vccd1 sky130_fd_sc_hd__fill_2
XFILLER_53_329 vssd1 vssd1 vccd1 vccd1 sky130_fd_sc_hd__fill_4
X_1112_ _1456_/Q _1345_/A vssd1 vssd1 vccd1 vccd1 _1112_/X sky130_fd_sc_hd__or2_2
X_1043_ _1468_/Q _1346_/A vssd1 vssd1 vccd1 vccd1 _1043_/X sky130_fd_sc_hd__or2_2
XANTENNA__0692__Y _0965_/A vssd1 vssd1 vccd1 vccd1 sky130_fd_sc_hd__diode_2
XFILLER_21_204 vssd1 vssd1 vccd1 vccd1 sky130_fd_sc_hd__fill_4
XFILLER_0_108 vssd1 vssd1 vccd1 vccd1 sky130_fd_sc_hd__fill_4
X_0827_ _0825_/B _0825_/C _0825_/A vssd1 vssd1 vccd1 vccd1 _0832_/B sky130_fd_sc_hd__a21oi_2
X_0758_ _0758_/A _0758_/B vssd1 vssd1 vccd1 vccd1 _0869_/B sky130_fd_sc_hd__xnor2_2
XFILLER_29_337 vssd1 vssd1 vccd1 vccd1 sky130_fd_sc_hd__fill_4
X_0689_ _0919_/A vssd1 vssd1 vccd1 vccd1 _0930_/A sky130_fd_sc_hd__inv_2
XFILLER_56_189 vssd1 vssd1 vccd1 vccd1 sky130_fd_sc_hd__fill_4
XFILLER_20_270 vssd1 vssd1 vccd1 vccd1 sky130_fd_sc_hd__fill_1
XFILLER_8_219 vssd1 vssd1 vccd1 vccd1 sky130_fd_sc_hd__fill_1
XANTENNA__0953__B _0953_/B vssd1 vssd1 vccd1 vccd1 sky130_fd_sc_hd__diode_2
XFILLER_11_281 vssd1 vssd1 vccd1 vccd1 sky130_fd_sc_hd__fill_1
XFILLER_11_292 vssd1 vccd1 vssd1 vccd1 sky130_ef_sc_hd__decap_40_12
XFILLER_7_252 vssd1 vccd1 vssd1 vccd1 sky130_ef_sc_hd__decap_40_12
Xload_slew122 _1214_/A2 vssd1 vssd1 vccd1 vccd1 _1325_/B sky130_fd_sc_hd__clkbuf_4
XFILLER_26_329 vssd1 vccd1 vssd1 vccd1 sky130_ef_sc_hd__decap_40_12
XFILLER_53_137 vssd1 vccd1 vssd1 vccd1 sky130_ef_sc_hd__decap_40_12
X_1026_ _1026_/A _1026_/B _1026_/C vssd1 vssd1 vccd1 vccd1 _1029_/C sky130_fd_sc_hd__nand3_2
XANTENNA_fanout107_X _1332_/A1 vssd1 vssd1 vccd1 vccd1 sky130_fd_sc_hd__diode_2
XFILLER_29_134 vssd1 vccd1 vssd1 vccd1 sky130_ef_sc_hd__decap_40_12
XFILLER_29_167 vssd1 vssd1 vccd1 vccd1 sky130_fd_sc_hd__fill_1
XFILLER_29_189 vssd1 vssd1 vccd1 vccd1 sky130_fd_sc_hd__fill_1
XFILLER_39_69 vssd1 vssd1 vccd1 vccd1 sky130_fd_sc_hd__fill_4
XFILLER_44_104 vssd1 vccd1 vssd1 vccd1 sky130_ef_sc_hd__decap_40_12
XFILLER_55_57 vssd1 vccd1 vssd1 vccd1 sky130_ef_sc_hd__decap_40_12
XTAP_TAPCELL_ROW_27_302 vssd1 vccd1 sky130_fd_sc_hd__tapvpwrvgnd_1
XFILLER_40_332 vssd1 vssd1 vccd1 vccd1 sky130_fd_sc_hd__fill_4
XFILLER_40_365 vssd1 vssd1 vccd1 vccd1 sky130_fd_sc_hd__fill_2
XFILLER_4_233 vssd1 vccd1 vssd1 vccd1 sky130_ef_sc_hd__decap_40_12
XFILLER_4_277 vssd1 vccd1 vssd1 vccd1 sky130_ef_sc_hd__decap_40_12
XFILLER_16_351 vssd1 vssd1 vccd1 vccd1 sky130_fd_sc_hd__fill_1
XTAP_TAPCELL_ROW_41_393 vssd1 vccd1 sky130_fd_sc_hd__tapvpwrvgnd_1
XFILLER_26_104 vssd1 vssd1 vccd1 vccd1 sky130_fd_sc_hd__fill_8
XPHY_EDGE_ROW_16_Left_76 vssd1 vssd1 vccd1 vccd1 sky130_fd_sc_hd__decap_3
XFILLER_22_321 vssd1 vccd1 vssd1 vccd1 sky130_ef_sc_hd__decap_40_12
XFILLER_22_365 vssd1 vssd1 vccd1 vccd1 sky130_fd_sc_hd__fill_2
X_1009_ _1055_/B _1008_/X _0981_/X vssd1 vssd1 vccd1 vccd1 _1041_/A sky130_fd_sc_hd__a21o_2
XFILLER_1_225 vssd1 vccd1 vssd1 vccd1 sky130_ef_sc_hd__decap_40_12
XFILLER_57_273 vssd1 vssd1 vccd1 vccd1 sky130_fd_sc_hd__fill_4
XTAP_TAPCELL_ROW_55_485 vssd1 vccd1 sky130_fd_sc_hd__tapvpwrvgnd_1
XFILLER_13_321 vssd1 vccd1 vssd1 vccd1 sky130_ef_sc_hd__decap_40_12
XFILLER_25_181 vssd1 vssd1 vccd1 vccd1 sky130_fd_sc_hd__fill_1
XFILLER_40_195 vssd1 vssd1 vccd1 vccd1 sky130_fd_sc_hd__fill_1
XFILLER_31_70 vssd1 vssd1 vccd1 vccd1 sky130_fd_sc_hd__fill_1
XFILLER_31_92 vssd1 vssd1 vccd1 vccd1 sky130_fd_sc_hd__fill_1
X_1360_ _1099_/B _1452_/D _1446_/D _1447_/D _1354_/Y vssd1 vssd1 vccd1 vccd1 _1362_/C
+ sky130_fd_sc_hd__a2111o_2
Xoutput70 _1431_/X vssd1 vssd1 vccd1 vccd1 gpio_out[22] sky130_fd_sc_hd__clkdlybuf4s25_1
Xoutput81 _1441_/X vssd1 vssd1 vccd1 vccd1 gpio_out[32] sky130_fd_sc_hd__clkdlybuf4s25_1
X_1291_ _1228_/B _1289_/Y _1290_/Y vssd1 vssd1 vccd1 vccd1 _1468_/D sky130_fd_sc_hd__a21oi_2
XTAP_TAPCELL_ROW_46_430 vssd1 vccd1 sky130_fd_sc_hd__tapvpwrvgnd_1
XFILLER_31_184 vssd1 vccd1 vssd1 vccd1 sky130_ef_sc_hd__decap_40_12
XFILLER_36_48 vssd1 vssd1 vccd1 vccd1 sky130_fd_sc_hd__fill_1
XFILLER_54_221 vssd1 vccd1 vssd1 vccd1 sky130_ef_sc_hd__decap_40_12
XFILLER_54_265 vssd1 vccd1 vssd1 vccd1 sky130_ef_sc_hd__decap_40_12
XANTENNA__1448__RESET_B load_slew137/X vssd1 vssd1 vccd1 vccd1 sky130_fd_sc_hd__diode_2
XFILLER_10_357 vssd1 vssd1 vccd1 vccd1 sky130_fd_sc_hd__fill_4
XFILLER_52_25 vssd1 vssd1 vccd1 vccd1 sky130_fd_sc_hd__fill_2
XTAP_TAPCELL_ROW_52_466 vssd1 vccd1 sky130_fd_sc_hd__tapvpwrvgnd_1
XANTENNA__0779__A input9/X vssd1 vssd1 vccd1 vccd1 sky130_fd_sc_hd__diode_2
XFILLER_7_3 vssd1 vccd1 vssd1 vccd1 sky130_ef_sc_hd__decap_40_12
XTAP_TAPCELL_ROW_9_188 vssd1 vccd1 sky130_fd_sc_hd__tapvpwrvgnd_1
XFILLER_26_92 vssd1 vccd1 vssd1 vccd1 sky130_ef_sc_hd__decap_40_12
XTAP_TAPCELL_ROW_43_411 vssd1 vccd1 sky130_fd_sc_hd__tapvpwrvgnd_1
XFILLER_13_173 vssd1 vssd1 vccd1 vccd1 sky130_fd_sc_hd__fill_2
XFILLER_9_111 vssd1 vssd1 vccd1 vccd1 sky130_fd_sc_hd__fill_1
XFILLER_9_199 vssd1 vssd1 vccd1 vccd1 sky130_fd_sc_hd__fill_4
X_0860_ _0953_/B _0860_/B vssd1 vssd1 vccd1 vccd1 _0862_/B sky130_fd_sc_hd__xnor2_2
X_0791_ _0838_/B _0838_/C _0838_/A vssd1 vssd1 vccd1 vccd1 _0791_/Y sky130_fd_sc_hd__a21oi_2
XFILLER_5_361 vssd1 vccd1 vssd1 vccd1 sky130_ef_sc_hd__decap_40_12
X_1343_ _0771_/A _1448_/D _1457_/D _0854_/B vssd1 vssd1 vccd1 vccd1 _1343_/X sky130_fd_sc_hd__o22a_2
X_1412_ _1435_/A _1422_/D _1441_/D vssd1 vssd1 vccd1 vccd1 _1412_/X sky130_fd_sc_hd__and3_2
XANTENNA__0695__Y _0767_/A vssd1 vssd1 vccd1 vccd1 sky130_fd_sc_hd__diode_2
XANTENNA_wire142_X wire142/X vssd1 vssd1 vccd1 vccd1 sky130_fd_sc_hd__diode_2
X_1274_ _1288_/A _1272_/Y _1273_/X _1303_/C1 vssd1 vssd1 vccd1 vccd1 _1274_/X sky130_fd_sc_hd__a211o_2
XFILLER_36_298 vssd1 vssd1 vccd1 vccd1 sky130_fd_sc_hd__fill_2
XFILLER_51_279 vssd1 vssd1 vccd1 vccd1 sky130_fd_sc_hd__fill_1
X_0989_ _0989_/A _0989_/B _0989_/C vssd1 vssd1 vccd1 vccd1 _0990_/B sky130_fd_sc_hd__nor3_2
XFILLER_47_25 vssd1 vssd1 vccd1 vccd1 sky130_fd_sc_hd__fill_2
XFILLER_59_324 vssd1 vssd1 vccd1 vccd1 sky130_fd_sc_hd__fill_8
Xfanout101 _1045_/X vssd1 vssd1 vccd1 vccd1 _1307_/A1 sky130_fd_sc_hd__clkdlybuf4s25_1
Xfanout112 _1476_/Q vssd1 vssd1 vccd1 vccd1 _1438_/A sky130_fd_sc_hd__clkdlybuf4s25_1
Xfanout123 _1192_/B vssd1 vssd1 vccd1 vccd1 _1252_/A2 sky130_fd_sc_hd__clkdlybuf4s25_1
Xfanout134 input8/X vssd1 vssd1 vccd1 vccd1 _0942_/B sky130_fd_sc_hd__clkdlybuf4s25_1
XTAP_TAPCELL_ROW_6_169 vssd1 vccd1 sky130_fd_sc_hd__tapvpwrvgnd_1
XFILLER_27_276 vssd1 vssd1 vccd1 vccd1 sky130_fd_sc_hd__fill_4
Xteam_00_177 vssd1 vssd1 vccd1 vccd1 team_00_177/HI la_data_out[30] sky130_fd_sc_hd__conb_1
Xteam_00_166 vssd1 vssd1 vccd1 vccd1 team_00_166/HI la_data_out[19] sky130_fd_sc_hd__conb_1
Xteam_00_155 vssd1 vssd1 vccd1 vccd1 team_00_155/HI la_data_out[8] sky130_fd_sc_hd__conb_1
XFILLER_10_121 vssd1 vccd1 vssd1 vccd1 sky130_ef_sc_hd__decap_40_12
XFILLER_33_202 vssd1 vssd1 vccd1 vccd1 sky130_fd_sc_hd__fill_8
XFILLER_18_287 vssd1 vssd1 vccd1 vccd1 sky130_fd_sc_hd__fill_1
X_0912_ _0912_/A _0912_/B vssd1 vssd1 vccd1 vccd1 _0924_/A sky130_fd_sc_hd__nand2_2
X_0843_ _0791_/Y _0998_/A vssd1 vssd1 vccd1 vccd1 _0844_/B sky130_fd_sc_hd__and2b_2
X_0774_ _0775_/A _0788_/A _0774_/C vssd1 vssd1 vccd1 vccd1 _0774_/X sky130_fd_sc_hd__and3_2
XFILLER_56_305 vssd1 vssd1 vccd1 vccd1 sky130_fd_sc_hd__fill_2
X_1326_ _1332_/A1 _1324_/X _1325_/X _0715_/B vssd1 vssd1 vccd1 vccd1 _1446_/D sky130_fd_sc_hd__o211a_2
XFILLER_33_16 vssd1 vccd1 vssd1 vccd1 sky130_ef_sc_hd__decap_40_12
X_1257_ _1464_/Q _1285_/C vssd1 vssd1 vccd1 vccd1 _1257_/Y sky130_fd_sc_hd__nand2_2
X_1188_ _1454_/Q _1189_/C _1455_/Q vssd1 vssd1 vccd1 vccd1 _1190_/B sky130_fd_sc_hd__a21oi_2
XANTENNA__1463__RESET_B wire142/X vssd1 vssd1 vccd1 vccd1 sky130_fd_sc_hd__diode_2
XFILLER_15_202 vssd1 vssd1 vccd1 vccd1 sky130_fd_sc_hd__fill_8
XFILLER_47_305 vssd1 vccd1 vssd1 vccd1 sky130_ef_sc_hd__decap_40_12
XANTENNA__0792__A _0942_/B vssd1 vssd1 vccd1 vccd1 sky130_fd_sc_hd__diode_2
XFILLER_30_205 vssd1 vssd1 vccd1 vccd1 sky130_fd_sc_hd__fill_1
XPHY_EDGE_ROW_4_Left_64 vssd1 vssd1 vccd1 vccd1 sky130_fd_sc_hd__decap_3
XFILLER_31_7 vssd1 vssd1 vccd1 vccd1 sky130_fd_sc_hd__fill_1
XFILLER_0_53 vssd1 vssd1 vccd1 vccd1 sky130_fd_sc_hd__fill_1
XFILLER_46_360 vssd1 vssd1 vccd1 vccd1 sky130_fd_sc_hd__fill_4
X_1111_ _1102_/Y _1109_/X _1110_/X _1101_/B vssd1 vssd1 vccd1 vccd1 _1111_/X sky130_fd_sc_hd__a22o_2
X_1042_ _1468_/Q _1346_/A vssd1 vssd1 vccd1 vccd1 _1042_/Y sky130_fd_sc_hd__nand2_2
XTAP_TAPCELL_ROW_16_230 vssd1 vccd1 sky130_fd_sc_hd__tapvpwrvgnd_1
XFILLER_9_51 vssd1 vssd1 vccd1 vccd1 sky130_fd_sc_hd__fill_4
X_0826_ _0831_/A _0832_/A vssd1 vssd1 vccd1 vccd1 _0848_/B sky130_fd_sc_hd__nand2_2
X_0757_ _0757_/A _0757_/B vssd1 vssd1 vccd1 vccd1 _0758_/B sky130_fd_sc_hd__xnor2_2
X_0688_ _1444_/Q vssd1 vssd1 vccd1 vccd1 _0688_/Y sky130_fd_sc_hd__inv_2
X_1309_ _0902_/Y _1308_/X _1309_/B1 vssd1 vssd1 vccd1 vccd1 _1309_/X sky130_fd_sc_hd__a21o_2
XFILLER_44_15 vssd1 vssd1 vccd1 vccd1 sky130_fd_sc_hd__fill_1
XFILLER_52_363 vssd1 vssd1 vccd1 vccd1 sky130_fd_sc_hd__fill_1
XFILLER_47_113 vssd1 vssd1 vccd1 vccd1 sky130_fd_sc_hd__fill_2
XFILLER_18_82 vssd1 vssd1 vccd1 vccd1 sky130_fd_sc_hd__fill_2
XTAP_TAPCELL_ROW_13_211 vssd1 vccd1 sky130_fd_sc_hd__tapvpwrvgnd_1
XFILLER_7_264 vssd1 vccd1 vssd1 vccd1 sky130_ef_sc_hd__decap_40_12
XFILLER_22_3 vssd1 vssd1 vccd1 vccd1 sky130_fd_sc_hd__fill_4
XFILLER_38_113 vssd1 vccd1 vssd1 vccd1 sky130_ef_sc_hd__decap_40_12
XFILLER_38_146 vssd1 vssd1 vccd1 vccd1 sky130_fd_sc_hd__fill_8
XFILLER_53_105 vssd1 vssd1 vccd1 vccd1 sky130_fd_sc_hd__fill_4
XFILLER_14_29 vssd1 vssd1 vccd1 vccd1 sky130_fd_sc_hd__fill_8
XFILLER_53_149 vssd1 vccd1 vssd1 vccd1 sky130_ef_sc_hd__decap_40_12
X_1025_ _1026_/B _1026_/C _1026_/A vssd1 vssd1 vccd1 vccd1 _1033_/B sky130_fd_sc_hd__a21o_2
X_0809_ _0810_/B _0810_/A vssd1 vssd1 vccd1 vccd1 _0809_/Y sky130_fd_sc_hd__nand2b_2
XFILLER_39_26 vssd1 vssd1 vccd1 vccd1 sky130_fd_sc_hd__fill_1
XFILLER_17_308 vssd1 vccd1 vssd1 vccd1 sky130_ef_sc_hd__decap_40_12
XFILLER_29_113 vssd1 vssd1 vccd1 vccd1 sky130_fd_sc_hd__fill_8
XFILLER_29_146 vssd1 vssd1 vccd1 vccd1 sky130_fd_sc_hd__fill_2
XFILLER_44_116 vssd1 vssd1 vccd1 vccd1 sky130_fd_sc_hd__fill_2
XFILLER_44_138 vssd1 vssd1 vccd1 vccd1 sky130_fd_sc_hd__fill_2
XFILLER_55_69 vssd1 vccd1 vssd1 vccd1 sky130_ef_sc_hd__decap_40_12
XTAP_TAPCELL_ROW_27_303 vssd1 vccd1 sky130_fd_sc_hd__tapvpwrvgnd_1
XFILLER_52_193 vssd1 vssd1 vccd1 vccd1 sky130_fd_sc_hd__fill_2
XFILLER_20_83 vssd1 vssd1 vccd1 vccd1 sky130_fd_sc_hd__fill_1
XFILLER_4_245 vssd1 vssd1 vccd1 vccd1 sky130_fd_sc_hd__fill_4
XFILLER_4_289 vssd1 vccd1 vssd1 vccd1 sky130_ef_sc_hd__decap_40_12
XFILLER_43_171 vssd1 vccd1 vssd1 vccd1 sky130_ef_sc_hd__decap_40_12
XFILLER_45_80 vssd1 vssd1 vccd1 vccd1 sky130_fd_sc_hd__fill_1
XFILLER_6_41 vssd1 vccd1 vssd1 vccd1 sky130_ef_sc_hd__decap_40_12
XTAP_TAPCELL_ROW_41_394 vssd1 vccd1 sky130_fd_sc_hd__tapvpwrvgnd_1
XANTENNA__0698__Y _0771_/A vssd1 vssd1 vccd1 vccd1 sky130_fd_sc_hd__diode_2
XFILLER_6_85 vssd1 vccd1 vssd1 vccd1 sky130_ef_sc_hd__decap_40_12
XFILLER_25_17 vssd1 vssd1 vccd1 vccd1 sky130_fd_sc_hd__fill_4
XFILLER_26_138 vssd1 vssd1 vccd1 vccd1 sky130_fd_sc_hd__fill_2
XTAP_TAPCELL_ROW_49_450 vssd1 vccd1 sky130_fd_sc_hd__tapvpwrvgnd_1
XFILLER_22_333 vssd1 vccd1 vssd1 vccd1 sky130_ef_sc_hd__decap_40_12
XFILLER_34_182 vssd1 vssd1 vccd1 vccd1 sky130_fd_sc_hd__fill_2
X_1008_ _1008_/A _1055_/C vssd1 vssd1 vccd1 vccd1 _1008_/X sky130_fd_sc_hd__and2_2
XFILLER_1_237 vssd1 vccd1 vssd1 vccd1 sky130_ef_sc_hd__decap_40_12
XFILLER_13_333 vssd1 vssd1 vccd1 vccd1 sky130_fd_sc_hd__fill_2
XTAP_TAPCELL_ROW_55_486 vssd1 vccd1 sky130_fd_sc_hd__tapvpwrvgnd_1
XFILLER_15_72 vssd1 vssd1 vccd1 vccd1 sky130_fd_sc_hd__fill_8
XFILLER_15_94 vssd1 vssd1 vccd1 vccd1 sky130_fd_sc_hd__fill_2
XFILLER_40_141 vssd1 vssd1 vccd1 vccd1 sky130_fd_sc_hd__fill_8
XFILLER_9_337 vssd1 vccd1 vssd1 vccd1 sky130_ef_sc_hd__decap_40_12
Xoutput82 _1442_/X vssd1 vssd1 vccd1 vccd1 gpio_out[33] sky130_fd_sc_hd__clkdlybuf4s25_1
Xoutput71 _1432_/Y vssd1 vssd1 vccd1 vccd1 gpio_out[23] sky130_fd_sc_hd__clkdlybuf4s25_1
Xoutput60 _1419_/X vssd1 vssd1 vccd1 vccd1 gpio_out[13] sky130_fd_sc_hd__clkdlybuf4s25_1
XPHY_EDGE_ROW_33_Left_93 vssd1 vssd1 vccd1 vccd1 sky130_fd_sc_hd__decap_3
XFILLER_0_281 vssd1 vccd1 vssd1 vccd1 sky130_ef_sc_hd__decap_40_12
X_1290_ _1468_/Q _1228_/B _1340_/A vssd1 vssd1 vccd1 vccd1 _1290_/Y sky130_fd_sc_hd__o21ai_2
XTAP_TAPCELL_ROW_46_431 vssd1 vccd1 sky130_fd_sc_hd__tapvpwrvgnd_1
XFILLER_16_171 vssd1 vssd1 vccd1 vccd1 sky130_fd_sc_hd__fill_1
XFILLER_36_27 vssd1 vssd1 vccd1 vccd1 sky130_fd_sc_hd__fill_1
XFILLER_36_38 vssd1 vssd1 vccd1 vccd1 sky130_fd_sc_hd__fill_1
XFILLER_39_263 vssd1 vccd1 vssd1 vccd1 sky130_ef_sc_hd__decap_40_12
XFILLER_54_233 vssd1 vccd1 vssd1 vccd1 sky130_ef_sc_hd__decap_40_12
XFILLER_54_277 vssd1 vccd1 vssd1 vccd1 sky130_ef_sc_hd__decap_40_12
XFILLER_22_141 vssd1 vssd1 vccd1 vccd1 sky130_fd_sc_hd__fill_4
XFILLER_22_185 vssd1 vssd1 vccd1 vccd1 sky130_fd_sc_hd__fill_1
XFILLER_6_307 vssd1 vssd1 vccd1 vccd1 sky130_fd_sc_hd__fill_1
XTAP_TAPCELL_ROW_52_467 vssd1 vccd1 sky130_fd_sc_hd__tapvpwrvgnd_1
XTAP_TAPCELL_ROW_9_189 vssd1 vccd1 sky130_fd_sc_hd__tapvpwrvgnd_1
XFILLER_45_277 vssd1 vssd1 vccd1 vccd1 sky130_fd_sc_hd__fill_2
XFILLER_5_373 vssd1 vssd1 vccd1 vccd1 sky130_fd_sc_hd__fill_2
XFILLER_9_167 vssd1 vssd1 vccd1 vccd1 sky130_fd_sc_hd__fill_1
X_0790_ _0853_/D _0790_/B vssd1 vssd1 vccd1 vccd1 _0838_/C sky130_fd_sc_hd__or2_2
XFILLER_47_5 vssd1 vccd1 vssd1 vccd1 sky130_ef_sc_hd__decap_40_12
X_1342_ _1342_/A _1455_/D vssd1 vssd1 vccd1 vccd1 _1357_/A sky130_fd_sc_hd__nor2_2
X_1411_ _1411_/A _1411_/B vssd1 vssd1 vccd1 vccd1 _1441_/D sky130_fd_sc_hd__nor2_2
X_1273_ _1307_/A1 _1307_/A2 _1307_/B1 _1271_/Y vssd1 vssd1 vccd1 vccd1 _1273_/X sky130_fd_sc_hd__o211a_2
XFILLER_51_225 vssd1 vccd1 vssd1 vccd1 sky130_ef_sc_hd__decap_40_12
XFILLER_22_29 vssd1 vssd1 vccd1 vccd1 sky130_fd_sc_hd__fill_4
X_0988_ _0989_/A _0989_/B _0989_/C vssd1 vssd1 vccd1 vccd1 _1003_/B sky130_fd_sc_hd__o21a_2
Xfanout102 _1045_/X vssd1 vssd1 vccd1 vccd1 _1206_/A1 sky130_fd_sc_hd__clkdlybuf4s25_1
Xfanout113 _1476_/Q vssd1 vssd1 vccd1 vccd1 _1418_/A sky130_fd_sc_hd__clkdlybuf4s25_1
XANTENNA_input1_A en vssd1 vssd1 vccd1 vccd1 sky130_fd_sc_hd__diode_2
XFILLER_27_233 vssd1 vssd1 vccd1 vccd1 sky130_fd_sc_hd__fill_1
Xteam_00_167 vssd1 vssd1 vccd1 vccd1 team_00_167/HI la_data_out[20] sky130_fd_sc_hd__conb_1
Xteam_00_156 vssd1 vssd1 vccd1 vccd1 team_00_156/HI la_data_out[9] sky130_fd_sc_hd__conb_1
XFILLER_27_266 vssd1 vssd1 vccd1 vccd1 sky130_fd_sc_hd__fill_2
Xteam_00_178 vssd1 vssd1 vccd1 vccd1 team_00_178/HI la_data_out[31] sky130_fd_sc_hd__conb_1
XFILLER_10_133 vssd1 vssd1 vccd1 vccd1 sky130_fd_sc_hd__fill_4
XFILLER_10_177 vssd1 vssd1 vccd1 vccd1 sky130_fd_sc_hd__fill_1
XFILLER_10_188 vssd1 vssd1 vccd1 vccd1 sky130_fd_sc_hd__fill_2
XFILLER_6_137 vssd1 vssd1 vccd1 vccd1 sky130_fd_sc_hd__fill_2
XFILLER_2_321 vssd1 vccd1 vssd1 vccd1 sky130_ef_sc_hd__decap_40_12
XFILLER_2_365 vssd1 vssd1 vccd1 vccd1 sky130_fd_sc_hd__fill_4
XFILLER_18_255 vssd1 vssd1 vccd1 vccd1 sky130_fd_sc_hd__fill_1
XFILLER_18_277 vssd1 vssd1 vccd1 vccd1 sky130_fd_sc_hd__fill_8
XFILLER_33_225 vssd1 vssd1 vccd1 vccd1 sky130_fd_sc_hd__fill_8
XFILLER_37_92 vssd1 vssd1 vccd1 vccd1 sky130_fd_sc_hd__fill_2
X_0911_ _0919_/A _0942_/B vssd1 vssd1 vccd1 vccd1 _0912_/B sky130_fd_sc_hd__or2_2
X_0842_ _1079_/B vssd1 vssd1 vccd1 vccd1 _1354_/A sky130_fd_sc_hd__inv_2
XFILLER_5_181 vssd1 vccd1 vssd1 vccd1 sky130_ef_sc_hd__decap_40_12
X_0773_ _0788_/A _0774_/C vssd1 vssd1 vccd1 vccd1 _0775_/B sky130_fd_sc_hd__nand2_2
X_1325_ _1446_/Q _1325_/B vssd1 vssd1 vccd1 vccd1 _1325_/X sky130_fd_sc_hd__or2_2
X_1256_ _1256_/A _1263_/B vssd1 vssd1 vccd1 vccd1 _1256_/X sky130_fd_sc_hd__or2_2
X_1187_ _1455_/Q _1329_/A _1205_/B vssd1 vssd1 vccd1 vccd1 _1187_/X sky130_fd_sc_hd__and3_2
XTAP_TAPCELL_ROW_19_250 vssd1 vccd1 sky130_fd_sc_hd__tapvpwrvgnd_1
XPHY_EDGE_ROW_20_Left_80 vssd1 vssd1 vccd1 vccd1 sky130_fd_sc_hd__decap_3
XFILLER_59_111 vssd1 vssd1 vccd1 vccd1 sky130_fd_sc_hd__fill_1
XFILLER_15_225 vssd1 vssd1 vccd1 vccd1 sky130_fd_sc_hd__fill_4
XFILLER_47_317 vssd1 vccd1 vssd1 vccd1 sky130_ef_sc_hd__decap_40_12
XFILLER_47_339 vssd1 vssd1 vccd1 vccd1 sky130_fd_sc_hd__fill_1
XFILLER_55_361 vssd1 vccd1 vssd1 vccd1 sky130_ef_sc_hd__decap_40_12
XTAP_TAPCELL_ROW_2_140 vssd1 vccd1 sky130_fd_sc_hd__tapvpwrvgnd_1
XFILLER_15_258 vssd1 vssd1 vccd1 vccd1 sky130_fd_sc_hd__fill_1
XFILLER_15_269 vssd1 vssd1 vccd1 vccd1 sky130_fd_sc_hd__fill_2
XANTENNA__0926__B1 _0953_/B vssd1 vssd1 vccd1 vccd1 sky130_fd_sc_hd__diode_2
XANTENNA__1179__B1 _1320_/C1 vssd1 vssd1 vccd1 vccd1 sky130_fd_sc_hd__diode_2
XFILLER_2_195 vssd1 vssd1 vccd1 vccd1 sky130_fd_sc_hd__fill_1
XFILLER_38_328 vssd1 vssd1 vccd1 vccd1 sky130_fd_sc_hd__fill_1
XFILLER_48_80 vssd1 vssd1 vccd1 vccd1 sky130_fd_sc_hd__fill_4
X_1110_ _1455_/Q _1342_/A _1095_/Y _1100_/C _1100_/A vssd1 vssd1 vccd1 vccd1 _1110_/X
+ sky130_fd_sc_hd__a221o_2
XFILLER_0_65 vssd1 vccd1 vssd1 vccd1 sky130_ef_sc_hd__decap_40_12
X_1041_ _1041_/A _1041_/B vssd1 vssd1 vccd1 vccd1 _1346_/A sky130_fd_sc_hd__xnor2_2
XTAP_TAPCELL_ROW_16_231 vssd1 vccd1 sky130_fd_sc_hd__tapvpwrvgnd_1
XFILLER_14_291 vssd1 vccd1 vssd1 vccd1 sky130_ef_sc_hd__decap_40_12
X_0825_ _0825_/A _0825_/B _0825_/C vssd1 vssd1 vccd1 vccd1 _0832_/A sky130_fd_sc_hd__and3_2
X_0756_ _0757_/A _0757_/B vssd1 vssd1 vccd1 vccd1 _0756_/Y sky130_fd_sc_hd__nand2_2
X_0687_ input1/X vssd1 vssd1 vccd1 vccd1 _0687_/Y sky130_fd_sc_hd__inv_2
XFILLER_28_39 vssd1 vssd1 vccd1 vccd1 sky130_fd_sc_hd__fill_2
XFILLER_29_317 vssd1 vccd1 vssd1 vccd1 sky130_ef_sc_hd__decap_40_12
XFILLER_44_309 vssd1 vccd1 vssd1 vccd1 sky130_ef_sc_hd__decap_40_12
X_1308_ _1471_/Q _1288_/A _1285_/C _1307_/X vssd1 vssd1 vccd1 vccd1 _1308_/X sky130_fd_sc_hd__a31o_2
X_1239_ _1462_/Q _1240_/B vssd1 vssd1 vccd1 vccd1 _1241_/A sky130_fd_sc_hd__nor2_2
XANTENNA__0908__B1 _0943_/A vssd1 vssd1 vccd1 vccd1 sky130_fd_sc_hd__diode_2
XFILLER_18_50 vssd1 vssd1 vccd1 vccd1 sky130_fd_sc_hd__fill_1
XFILLER_28_350 vssd1 vssd1 vccd1 vccd1 sky130_fd_sc_hd__fill_2
XFILLER_47_169 vssd1 vccd1 vssd1 vccd1 sky130_ef_sc_hd__decap_40_12
XFILLER_34_82 vssd1 vssd1 vccd1 vccd1 sky130_fd_sc_hd__fill_2
XFILLER_7_221 vssd1 vssd1 vccd1 vccd1 sky130_fd_sc_hd__fill_2
XTAP_TAPCELL_ROW_13_212 vssd1 vccd1 sky130_fd_sc_hd__tapvpwrvgnd_1
XFILLER_50_92 vssd1 vssd1 vccd1 vccd1 sky130_fd_sc_hd__fill_1
XFILLER_7_276 vssd1 vssd1 vccd1 vccd1 sky130_fd_sc_hd__fill_4
Xload_slew124 _1252_/A2 vssd1 vssd1 vccd1 vccd1 _1310_/A2 sky130_fd_sc_hd__clkbuf_4
XANTENNA__1324__B1 _1330_/B1 vssd1 vssd1 vccd1 vccd1 sky130_fd_sc_hd__diode_2
XFILLER_38_125 vssd1 vssd1 vccd1 vccd1 sky130_fd_sc_hd__fill_4
XFILLER_38_136 vssd1 vssd1 vccd1 vccd1 sky130_fd_sc_hd__fill_4
X_1024_ _1037_/A _1037_/B _1037_/C vssd1 vssd1 vccd1 vccd1 _1039_/B sky130_fd_sc_hd__a21o_2
XFILLER_34_342 vssd1 vssd1 vccd1 vccd1 sky130_fd_sc_hd__fill_1
X_0808_ _0953_/B _0808_/B vssd1 vssd1 vccd1 vccd1 _0810_/B sky130_fd_sc_hd__xnor2_2
XFILLER_39_38 vssd1 vssd1 vccd1 vccd1 sky130_fd_sc_hd__fill_2
X_0739_ _0750_/B _0739_/B vssd1 vssd1 vccd1 vccd1 _0741_/B sky130_fd_sc_hd__xor2_2
XFILLER_55_15 vssd1 vccd1 vssd1 vccd1 sky130_ef_sc_hd__decap_40_12
XTAP_TAPCELL_ROW_27_304 vssd1 vccd1 sky130_fd_sc_hd__tapvpwrvgnd_1
XFILLER_40_323 vssd1 vssd1 vccd1 vccd1 sky130_fd_sc_hd__fill_4
XPHY_EDGE_ROW_42_Left_102 vssd1 vssd1 vccd1 vccd1 sky130_fd_sc_hd__decap_3
XFILLER_43_183 vssd1 vssd1 vccd1 vccd1 sky130_fd_sc_hd__fill_2
XPHY_EDGE_ROW_51_Left_111 vssd1 vssd1 vccd1 vccd1 sky130_fd_sc_hd__decap_3
XFILLER_6_53 vssd1 vccd1 vssd1 vccd1 sky130_ef_sc_hd__decap_40_12
XTAP_TAPCELL_ROW_41_395 vssd1 vccd1 sky130_fd_sc_hd__tapvpwrvgnd_1
XFILLER_58_209 vssd1 vccd1 vssd1 vccd1 sky130_ef_sc_hd__decap_40_12
XFILLER_6_97 vssd1 vccd1 vssd1 vccd1 sky130_ef_sc_hd__decap_40_12
XANTENNA__1312__A3 _1327_/C vssd1 vssd1 vccd1 vccd1 sky130_fd_sc_hd__diode_2
X_1007_ _1004_/Y _1062_/B _1061_/B vssd1 vssd1 vccd1 vccd1 _1055_/C sky130_fd_sc_hd__o21a_2
XFILLER_22_345 vssd1 vssd1 vccd1 vccd1 sky130_fd_sc_hd__fill_4
XFILLER_41_17 vssd1 vccd1 vssd1 vccd1 sky130_ef_sc_hd__decap_40_12
XTAP_TAPCELL_ROW_32_340 vssd1 vccd1 sky130_fd_sc_hd__tapvpwrvgnd_1
XFILLER_1_205 vssd1 vccd1 vssd1 vccd1 sky130_ef_sc_hd__decap_40_12
XFILLER_1_249 vssd1 vccd1 vssd1 vccd1 sky130_ef_sc_hd__decap_40_12
XANTENNA__1226__B _1327_/C vssd1 vssd1 vccd1 vccd1 sky130_fd_sc_hd__diode_2
XANTENNA__1462__CLK _1463_/CLK vssd1 vssd1 vccd1 vccd1 sky130_fd_sc_hd__diode_2
XFILLER_9_305 vssd1 vccd1 vssd1 vccd1 sky130_ef_sc_hd__decap_40_12
XTAP_TAPCELL_ROW_55_487 vssd1 vccd1 sky130_fd_sc_hd__tapvpwrvgnd_1
XFILLER_9_349 vssd1 vccd1 vssd1 vccd1 sky130_ef_sc_hd__decap_40_12
Xoutput83 _1402_/Y vssd1 vssd1 vccd1 vccd1 gpio_out[3] sky130_fd_sc_hd__clkdlybuf4s25_1
Xoutput72 _1433_/X vssd1 vssd1 vccd1 vccd1 gpio_out[24] sky130_fd_sc_hd__clkdlybuf4s25_1
Xoutput61 _1421_/X vssd1 vssd1 vccd1 vccd1 gpio_out[14] sky130_fd_sc_hd__clkdlybuf4s25_1
Xoutput50 _1515_/X vssd1 vssd1 vccd1 vccd1 gpio_oeb[4] sky130_fd_sc_hd__clkdlybuf4s25_1
XFILLER_0_293 vssd1 vssd1 vccd1 vccd1 sky130_fd_sc_hd__fill_4
XFILLER_48_253 vssd1 vccd1 vssd1 vccd1 sky130_ef_sc_hd__decap_40_12
XFILLER_22_131 vssd1 vssd1 vccd1 vccd1 sky130_fd_sc_hd__fill_2
XFILLER_52_27 vssd1 vssd1 vccd1 vccd1 sky130_fd_sc_hd__fill_1
XFILLER_54_245 vssd1 vssd1 vccd1 vccd1 sky130_fd_sc_hd__fill_4
XFILLER_54_289 vssd1 vccd1 vssd1 vccd1 sky130_ef_sc_hd__decap_40_12
XTAP_TAPCELL_ROW_52_468 vssd1 vccd1 sky130_fd_sc_hd__tapvpwrvgnd_1
XFILLER_22_175 vssd1 vssd1 vccd1 vccd1 sky130_fd_sc_hd__fill_2
XFILLER_45_201 vssd1 vssd1 vccd1 vccd1 sky130_fd_sc_hd__fill_4
XFILLER_45_212 vssd1 vccd1 vssd1 vccd1 sky130_ef_sc_hd__decap_40_12
XFILLER_9_113 vssd1 vccd1 vssd1 vccd1 sky130_ef_sc_hd__decap_40_12
XANTENNA__1212__A2 _1285_/C vssd1 vssd1 vccd1 vccd1 sky130_fd_sc_hd__diode_2
XFILLER_42_93 vssd1 vssd1 vccd1 vccd1 sky130_fd_sc_hd__fill_4
X_1410_ _1417_/A _1432_/A vssd1 vssd1 vccd1 vccd1 _1410_/Y sky130_fd_sc_hd__nor2_2
X_1341_ _1478_/Q _1341_/B _1474_/D _1473_/D vssd1 vssd1 vccd1 vccd1 _1472_/D sky130_fd_sc_hd__and4_2
X_1272_ _1466_/Q _1285_/C vssd1 vssd1 vccd1 vccd1 _1272_/Y sky130_fd_sc_hd__nand2_2
XFILLER_51_237 vssd1 vccd1 vssd1 vccd1 sky130_ef_sc_hd__decap_40_12
X_0987_ _0987_/A _0987_/B vssd1 vssd1 vccd1 vccd1 _0989_/C sky130_fd_sc_hd__xor2_2
XFILLER_59_304 vssd1 vssd1 vccd1 vccd1 sky130_fd_sc_hd__fill_4
XFILLER_59_337 vssd1 vssd1 vccd1 vccd1 sky130_fd_sc_hd__fill_4
X_1539_ _1541_/A vssd1 vssd1 vccd1 vccd1 _1539_/X sky130_fd_sc_hd__buf_2
Xfanout103 _0902_/Y vssd1 vssd1 vccd1 vccd1 _1330_/B1 sky130_fd_sc_hd__clkdlybuf4s25_1
Xfanout114 _1384_/C vssd1 vssd1 vccd1 vccd1 _1438_/B sky130_fd_sc_hd__clkdlybuf4s25_1
Xfanout125 _1192_/B vssd1 vssd1 vccd1 vccd1 _1237_/A2 sky130_fd_sc_hd__clkdlybuf4s25_1
Xfanout136 input6/X vssd1 vssd1 vccd1 vccd1 fanout136/X sky130_fd_sc_hd__clkdlybuf4s25_1
XFILLER_27_201 vssd1 vccd1 vssd1 vccd1 sky130_ef_sc_hd__decap_40_12
XFILLER_27_223 vssd1 vssd1 vccd1 vccd1 sky130_fd_sc_hd__fill_1
Xteam_00_168 vssd1 vssd1 vccd1 vccd1 team_00_168/HI la_data_out[21] sky130_fd_sc_hd__conb_1
Xteam_00_157 vssd1 vssd1 vccd1 vccd1 team_00_157/HI la_data_out[10] sky130_fd_sc_hd__conb_1
XFILLER_42_237 vssd1 vssd1 vccd1 vccd1 sky130_fd_sc_hd__fill_2
XFILLER_12_41 vssd1 vssd1 vccd1 vccd1 sky130_fd_sc_hd__fill_8
XFILLER_18_201 vssd1 vssd1 vccd1 vccd1 sky130_fd_sc_hd__fill_1
XFILLER_2_333 vssd1 vccd1 vssd1 vccd1 sky130_ef_sc_hd__decap_40_12
XTAP_TAPCELL_ROW_5_160 vssd1 vccd1 sky130_fd_sc_hd__tapvpwrvgnd_1
XFILLER_37_71 vssd1 vssd1 vccd1 vccd1 sky130_fd_sc_hd__fill_1
XPHY_EDGE_ROW_16_Right_16 vssd1 vssd1 vccd1 vccd1 sky130_fd_sc_hd__decap_3
XFILLER_41_281 vssd1 vccd1 vssd1 vccd1 sky130_ef_sc_hd__decap_40_12
XFILLER_53_81 vssd1 vccd1 vssd1 vccd1 sky130_ef_sc_hd__decap_40_12
X_0910_ input9/X _0912_/A vssd1 vssd1 vccd1 vccd1 _1010_/B sky130_fd_sc_hd__xor2_2
X_0841_ _0997_/A _0841_/B vssd1 vssd1 vccd1 vccd1 _1079_/B sky130_fd_sc_hd__xor2_2
X_0772_ _0780_/A _0780_/B vssd1 vssd1 vccd1 vccd1 _0774_/C sky130_fd_sc_hd__nor2_2
XPHY_EDGE_ROW_25_Right_25 vssd1 vssd1 vccd1 vccd1 sky130_fd_sc_hd__decap_3
XFILLER_45_3 vssd1 vccd1 vssd1 vccd1 sky130_ef_sc_hd__decap_40_12
XFILLER_5_193 vssd1 vccd1 vssd1 vccd1 sky130_ef_sc_hd__decap_40_12
XFILLER_56_307 vssd1 vssd1 vccd1 vccd1 sky130_fd_sc_hd__fill_1
X_1324_ _1321_/X _1323_/Y _1330_/B1 vssd1 vssd1 vccd1 vccd1 _1324_/X sky130_fd_sc_hd__o21a_2
X_1255_ _1464_/Q _1463_/Q _1255_/C vssd1 vssd1 vccd1 vccd1 _1263_/B sky130_fd_sc_hd__and3_2
X_1186_ _1325_/B _1184_/X _1185_/Y vssd1 vssd1 vccd1 vccd1 _1454_/D sky130_fd_sc_hd__a21oi_2
XPHY_EDGE_ROW_34_Right_34 vssd1 vssd1 vccd1 vccd1 sky130_fd_sc_hd__decap_3
XANTENNA__1340__A _1340_/A vssd1 vssd1 vccd1 vccd1 sky130_fd_sc_hd__diode_2
XFILLER_24_248 vssd1 vssd1 vccd1 vccd1 sky130_fd_sc_hd__fill_4
XTAP_TAPCELL_ROW_19_251 vssd1 vccd1 sky130_fd_sc_hd__tapvpwrvgnd_1
XPHY_EDGE_ROW_43_Right_43 vssd1 vssd1 vccd1 vccd1 sky130_fd_sc_hd__decap_3
XANTENNA__1234__B _1327_/C vssd1 vssd1 vccd1 vccd1 sky130_fd_sc_hd__diode_2
XFILLER_47_329 vssd1 vssd1 vccd1 vccd1 sky130_fd_sc_hd__fill_4
XFILLER_58_26 vssd1 vssd1 vccd1 vccd1 sky130_fd_sc_hd__fill_2
XFILLER_59_156 vssd1 vssd1 vccd1 vccd1 sky130_fd_sc_hd__fill_1
XPHY_EDGE_ROW_52_Right_52 vssd1 vssd1 vccd1 vccd1 sky130_fd_sc_hd__decap_3
XFILLER_55_373 vssd1 vssd1 vccd1 vccd1 sky130_fd_sc_hd__fill_2
XTAP_TAPCELL_ROW_2_141 vssd1 vccd1 sky130_fd_sc_hd__tapvpwrvgnd_1
XFILLER_23_73 vssd1 vccd1 vssd1 vccd1 sky130_ef_sc_hd__decap_40_12
XFILLER_30_229 vssd1 vssd1 vccd1 vccd1 sky130_fd_sc_hd__fill_2
XFILLER_2_141 vssd1 vccd1 vssd1 vccd1 sky130_ef_sc_hd__decap_40_12
XFILLER_38_318 vssd1 vssd1 vccd1 vccd1 sky130_fd_sc_hd__fill_2
X_1040_ _1039_/B _1039_/C _1039_/A vssd1 vssd1 vccd1 vccd1 _1044_/B sky130_fd_sc_hd__a21oi_2
XFILLER_0_77 vssd1 vssd1 vccd1 vccd1 sky130_fd_sc_hd__fill_4
XFILLER_0_99 vssd1 vssd1 vccd1 vccd1 sky130_fd_sc_hd__fill_4
XTAP_TAPCELL_ROW_16_232 vssd1 vccd1 sky130_fd_sc_hd__tapvpwrvgnd_1
X_0824_ _1103_/A _1096_/B vssd1 vssd1 vccd1 vccd1 _0825_/C sky130_fd_sc_hd__nand2_2
X_0755_ _0757_/A _0757_/B vssd1 vssd1 vccd1 vccd1 _0755_/Y sky130_fd_sc_hd__nor2_2
X_0686_ _1478_/Q vssd1 vssd1 vccd1 vccd1 _0711_/A sky130_fd_sc_hd__inv_2
XFILLER_29_329 vssd1 vssd1 vccd1 vccd1 sky130_fd_sc_hd__fill_4
XFILLER_37_362 vssd1 vssd1 vccd1 vccd1 sky130_fd_sc_hd__fill_2
XFILLER_37_373 vssd1 vssd1 vccd1 vccd1 sky130_fd_sc_hd__fill_2
XFILLER_52_321 vssd1 vccd1 vssd1 vccd1 sky130_ef_sc_hd__decap_40_12
XFILLER_56_137 vssd1 vssd1 vccd1 vccd1 sky130_fd_sc_hd__fill_2
X_1307_ _1307_/A1 _1307_/A2 _1307_/B1 _1306_/X vssd1 vssd1 vccd1 vccd1 _1307_/X sky130_fd_sc_hd__o211a_2
X_1238_ _1228_/B _1236_/X _1237_/Y vssd1 vssd1 vccd1 vccd1 _1461_/D sky130_fd_sc_hd__a21oi_2
X_1169_ _1452_/Q _1205_/B vssd1 vssd1 vccd1 vccd1 _1169_/Y sky130_fd_sc_hd__nand2_2
XFILLER_20_240 vssd1 vccd1 vssd1 vccd1 sky130_ef_sc_hd__decap_40_12
XFILLER_52_365 vssd1 vssd1 vccd1 vccd1 sky130_fd_sc_hd__fill_2
XFILLER_47_115 vssd1 vssd1 vccd1 vccd1 sky130_fd_sc_hd__fill_1
XFILLER_43_321 vssd1 vssd1 vccd1 vccd1 sky130_fd_sc_hd__fill_2
XFILLER_55_181 vssd1 vccd1 vssd1 vccd1 sky130_ef_sc_hd__decap_40_12
XTAP_TAPCELL_ROW_13_213 vssd1 vccd1 sky130_fd_sc_hd__tapvpwrvgnd_1
XFILLER_50_82 vssd1 vssd1 vccd1 vccd1 sky130_fd_sc_hd__fill_2
Xwire142 wire142/A vssd1 vssd1 vccd1 vccd1 wire142/X sky130_fd_sc_hd__clkbuf_4
XFILLER_34_321 vssd1 vssd1 vccd1 vccd1 sky130_fd_sc_hd__fill_1
X_1023_ _1023_/A _1023_/B vssd1 vssd1 vccd1 vccd1 _1037_/C sky130_fd_sc_hd__nand2_2
XANTENNA__1321__C _1327_/C vssd1 vssd1 vccd1 vccd1 sky130_fd_sc_hd__diode_2
XANTENNA__1260__B1 _0715_/B vssd1 vssd1 vccd1 vccd1 sky130_fd_sc_hd__diode_2
X_0807_ _0880_/B _0811_/B _0805_/Y vssd1 vssd1 vccd1 vccd1 _0810_/A sky130_fd_sc_hd__a21o_2
X_0738_ _0883_/A _0862_/A _0726_/Y vssd1 vssd1 vccd1 vccd1 _0746_/A sky130_fd_sc_hd__o21ai_2
XFILLER_29_159 vssd1 vssd1 vccd1 vccd1 sky130_fd_sc_hd__fill_8
XPHY_EDGE_ROW_2_Right_2 vssd1 vssd1 vccd1 vccd1 sky130_fd_sc_hd__decap_3
XFILLER_52_195 vssd1 vssd1 vccd1 vccd1 sky130_fd_sc_hd__fill_1
XFILLER_55_27 vssd1 vccd1 vssd1 vccd1 sky130_ef_sc_hd__decap_40_12
XTAP_TAPCELL_ROW_27_305 vssd1 vccd1 sky130_fd_sc_hd__tapvpwrvgnd_1
XANTENNA__1251__B1 _1332_/A1 vssd1 vssd1 vccd1 vccd1 sky130_fd_sc_hd__diode_2
XFILLER_20_85 vssd1 vssd1 vccd1 vccd1 sky130_fd_sc_hd__fill_4
XFILLER_16_321 vssd1 vccd1 vssd1 vccd1 sky130_ef_sc_hd__decap_40_12
XFILLER_16_365 vssd1 vssd1 vccd1 vccd1 sky130_fd_sc_hd__fill_2
XFILLER_31_324 vssd1 vccd1 vssd1 vccd1 sky130_ef_sc_hd__decap_40_12
XFILLER_31_346 vssd1 vssd1 vccd1 vccd1 sky130_fd_sc_hd__fill_1
XFILLER_43_195 vssd1 vssd1 vccd1 vccd1 sky130_fd_sc_hd__fill_8
XFILLER_6_65 vssd1 vccd1 vssd1 vccd1 sky130_ef_sc_hd__decap_40_12
XTAP_TAPCELL_ROW_41_396 vssd1 vccd1 sky130_fd_sc_hd__tapvpwrvgnd_1
XFILLER_19_181 vssd1 vssd1 vccd1 vccd1 sky130_fd_sc_hd__fill_2
XFILLER_22_302 vssd1 vssd1 vccd1 vccd1 sky130_fd_sc_hd__fill_4
XFILLER_34_162 vssd1 vssd1 vccd1 vccd1 sky130_fd_sc_hd__fill_4
X_1006_ _1006_/A _1006_/B _1006_/C vssd1 vssd1 vccd1 vccd1 _1062_/B sky130_fd_sc_hd__or3_2
XFILLER_41_29 vssd1 vssd1 vccd1 vccd1 sky130_fd_sc_hd__fill_8
XANTENNA_fanout105_X _1303_/C1 vssd1 vssd1 vccd1 vccd1 sky130_fd_sc_hd__diode_2
XFILLER_1_217 vssd1 vssd1 vccd1 vccd1 sky130_fd_sc_hd__fill_4
XANTENNA__1242__B _1285_/C vssd1 vssd1 vccd1 vccd1 sky130_fd_sc_hd__diode_2
XFILLER_57_221 vssd1 vssd1 vccd1 vccd1 sky130_fd_sc_hd__fill_2
XFILLER_13_335 vssd1 vssd1 vccd1 vccd1 sky130_fd_sc_hd__fill_1
XFILLER_15_96 vssd1 vssd1 vccd1 vccd1 sky130_fd_sc_hd__fill_1
XFILLER_9_317 vssd1 vccd1 vssd1 vccd1 sky130_ef_sc_hd__decap_40_12
XTAP_TAPCELL_ROW_55_488 vssd1 vccd1 sky130_fd_sc_hd__tapvpwrvgnd_1
XFILLER_31_62 vssd1 vssd1 vccd1 vccd1 sky130_fd_sc_hd__fill_1
XFILLER_31_84 vssd1 vssd1 vccd1 vccd1 sky130_fd_sc_hd__fill_8
Xoutput84 _1405_/Y vssd1 vssd1 vccd1 vccd1 gpio_out[4] sky130_fd_sc_hd__clkdlybuf4s25_1
Xoutput73 _1434_/Y vssd1 vssd1 vccd1 vccd1 gpio_out[25] sky130_fd_sc_hd__clkdlybuf4s25_1
Xoutput62 _1422_/X vssd1 vssd1 vccd1 vccd1 gpio_out[15] sky130_fd_sc_hd__clkdlybuf4s25_1
Xoutput51 _1516_/X vssd1 vssd1 vccd1 vccd1 gpio_oeb[5] sky130_fd_sc_hd__clkdlybuf4s25_1
Xoutput40 _1537_/X vssd1 vssd1 vccd1 vccd1 gpio_oeb[26] sky130_fd_sc_hd__clkdlybuf4s25_1
XFILLER_48_265 vssd1 vccd1 vssd1 vccd1 sky130_ef_sc_hd__decap_40_12
XFILLER_56_81 vssd1 vssd1 vccd1 vccd1 sky130_fd_sc_hd__fill_2
XFILLER_16_195 vssd1 vssd1 vccd1 vccd1 sky130_fd_sc_hd__fill_1
XFILLER_8_361 vssd1 vssd1 vccd1 vccd1 sky130_fd_sc_hd__fill_2
XFILLER_36_29 vssd1 vssd1 vccd1 vccd1 sky130_fd_sc_hd__fill_4
XFILLER_39_221 vssd1 vssd1 vccd1 vccd1 sky130_fd_sc_hd__fill_2
XFILLER_10_305 vssd1 vssd1 vccd1 vccd1 sky130_fd_sc_hd__fill_2
XFILLER_22_110 vssd1 vssd1 vccd1 vccd1 sky130_fd_sc_hd__fill_1
XFILLER_52_17 vssd1 vssd1 vccd1 vccd1 sky130_fd_sc_hd__fill_8
XTAP_TAPCELL_ROW_52_469 vssd1 vccd1 sky130_fd_sc_hd__tapvpwrvgnd_1
XFILLER_6_309 vssd1 vccd1 vssd1 vccd1 sky130_ef_sc_hd__decap_40_12
XFILLER_45_279 vssd1 vssd1 vccd1 vccd1 sky130_fd_sc_hd__fill_1
XFILLER_13_110 vssd1 vssd1 vccd1 vccd1 sky130_fd_sc_hd__fill_2
XFILLER_42_72 vssd1 vccd1 vssd1 vccd1 sky130_ef_sc_hd__decap_40_12
XFILLER_9_125 vssd1 vccd1 vssd1 vccd1 sky130_ef_sc_hd__decap_40_12
XFILLER_9_169 vssd1 vssd1 vccd1 vccd1 sky130_fd_sc_hd__fill_1
X_1340_ _1340_/A _1340_/B _1340_/C vssd1 vssd1 vccd1 vccd1 _1477_/D sky130_fd_sc_hd__and3_2
XFILLER_3_55 vssd1 vssd1 vccd1 vccd1 sky130_fd_sc_hd__fill_1
X_1271_ _1466_/Q _1278_/C vssd1 vssd1 vccd1 vccd1 _1271_/Y sky130_fd_sc_hd__xnor2_2
XTAP_TAPCELL_ROW_8_180 vssd1 vccd1 sky130_fd_sc_hd__tapvpwrvgnd_1
XFILLER_51_205 vssd1 vccd1 vssd1 vccd1 sky130_ef_sc_hd__decap_40_12
XFILLER_51_249 vssd1 vccd1 vssd1 vccd1 sky130_ef_sc_hd__decap_40_12
XFILLER_8_180 vssd1 vssd1 vccd1 vccd1 sky130_fd_sc_hd__fill_4
X_0986_ _0986_/A _0986_/B vssd1 vssd1 vccd1 vccd1 _1006_/B sky130_fd_sc_hd__or2_2
XANTENNA__1452__CLK _1459_/CLK vssd1 vssd1 vccd1 vccd1 sky130_fd_sc_hd__diode_2
XFILLER_47_17 vssd1 vssd1 vccd1 vccd1 sky130_fd_sc_hd__fill_8
XFILLER_59_349 vssd1 vccd1 vssd1 vccd1 sky130_ef_sc_hd__decap_40_12
X_1469_ _1471_/CLK _1469_/D load_slew140/X vssd1 vssd1 vccd1 vccd1 _1469_/Q sky130_fd_sc_hd__dfrtp_2
X_1538_ _1542_/A vssd1 vssd1 vccd1 vccd1 _1538_/X sky130_fd_sc_hd__buf_2
Xfanout104 _0901_/X vssd1 vssd1 vccd1 vccd1 _0902_/A sky130_fd_sc_hd__clkdlybuf4s25_1
Xfanout115 _1475_/Q vssd1 vssd1 vccd1 vccd1 _1384_/C sky130_fd_sc_hd__clkdlybuf4s25_1
XFILLER_27_213 vssd1 vssd1 vccd1 vccd1 sky130_fd_sc_hd__fill_1
XFILLER_42_205 vssd1 vssd1 vccd1 vccd1 sky130_fd_sc_hd__fill_4
XFILLER_47_39 vssd1 vccd1 vssd1 vccd1 sky130_ef_sc_hd__decap_40_12
Xteam_00_169 vssd1 vssd1 vccd1 vccd1 team_00_169/HI la_data_out[22] sky130_fd_sc_hd__conb_1
Xteam_00_158 vssd1 vssd1 vccd1 vccd1 team_00_158/HI la_data_out[11] sky130_fd_sc_hd__conb_1
XFILLER_42_249 vssd1 vssd1 vccd1 vccd1 sky130_fd_sc_hd__fill_2
XFILLER_12_64 vssd1 vssd1 vccd1 vccd1 sky130_fd_sc_hd__fill_4
XFILLER_2_301 vssd1 vssd1 vccd1 vccd1 sky130_fd_sc_hd__fill_4
XFILLER_2_345 vssd1 vccd1 vssd1 vccd1 sky130_ef_sc_hd__decap_40_12
XFILLER_5_3 vssd1 vccd1 vssd1 vccd1 sky130_ef_sc_hd__decap_40_12
XFILLER_6_139 vssd1 vssd1 vccd1 vccd1 sky130_fd_sc_hd__fill_1
XFILLER_18_224 vssd1 vssd1 vccd1 vccd1 sky130_fd_sc_hd__fill_1
XTAP_TAPCELL_ROW_5_161 vssd1 vccd1 sky130_fd_sc_hd__tapvpwrvgnd_1
XFILLER_37_61 vssd1 vssd1 vccd1 vccd1 sky130_fd_sc_hd__fill_2
XFILLER_37_94 vssd1 vssd1 vccd1 vccd1 sky130_fd_sc_hd__fill_1
XFILLER_41_293 vssd1 vssd1 vccd1 vccd1 sky130_fd_sc_hd__fill_8
XFILLER_53_93 vssd1 vccd1 vssd1 vccd1 sky130_ef_sc_hd__decap_40_12
X_0840_ _0998_/A _0998_/B vssd1 vssd1 vccd1 vccd1 _0841_/B sky130_fd_sc_hd__nand2_2
X_0771_ _0771_/A _0771_/B vssd1 vssd1 vccd1 vccd1 _0780_/B sky130_fd_sc_hd__xnor2_2
XFILLER_52_5 vssd1 vccd1 vssd1 vccd1 sky130_ef_sc_hd__decap_40_12
XFILLER_5_161 vssd1 vssd1 vccd1 vccd1 sky130_fd_sc_hd__fill_4
X_1323_ _1329_/A _1328_/B _1323_/C vssd1 vssd1 vccd1 vccd1 _1323_/Y sky130_fd_sc_hd__nor3_2
X_1254_ _1463_/Q _1255_/C _1464_/Q vssd1 vssd1 vccd1 vccd1 _1256_/A sky130_fd_sc_hd__a21oi_2
X_1185_ _1454_/Q _1325_/B _1320_/C1 vssd1 vssd1 vccd1 vccd1 _1185_/Y sky130_fd_sc_hd__o21ai_2
XTAP_TAPCELL_ROW_19_252 vssd1 vccd1 sky130_fd_sc_hd__tapvpwrvgnd_1
XFILLER_3_109 vssd1 vssd1 vccd1 vccd1 sky130_fd_sc_hd__fill_2
X_0969_ _0966_/Y _0969_/B vssd1 vssd1 vccd1 vccd1 _0987_/B sky130_fd_sc_hd__and2b_2
XFILLER_59_113 vssd1 vccd1 vssd1 vccd1 sky130_ef_sc_hd__decap_40_12
XTAP_TAPCELL_ROW_2_142 vssd1 vccd1 sky130_fd_sc_hd__tapvpwrvgnd_1
XFILLER_23_85 vssd1 vssd1 vccd1 vccd1 sky130_fd_sc_hd__fill_4
XFILLER_2_153 vssd1 vccd1 vssd1 vccd1 sky130_ef_sc_hd__decap_40_12
XFILLER_2_197 vssd1 vccd1 vssd1 vccd1 sky130_ef_sc_hd__decap_40_12
XFILLER_46_330 vssd1 vssd1 vccd1 vccd1 sky130_fd_sc_hd__fill_2
XANTENNA__1160__B _1205_/B vssd1 vssd1 vccd1 vccd1 sky130_fd_sc_hd__diode_2
XFILLER_21_208 vssd1 vssd1 vccd1 vccd1 sky130_fd_sc_hd__fill_2
XTAP_TAPCELL_ROW_16_233 vssd1 vccd1 sky130_fd_sc_hd__tapvpwrvgnd_1
X_0823_ _1103_/A input7/X vssd1 vssd1 vccd1 vccd1 _0825_/B sky130_fd_sc_hd__or2_2
X_0754_ _0767_/A _0754_/B vssd1 vssd1 vccd1 vccd1 _0757_/B sky130_fd_sc_hd__xnor2_2
X_1306_ _1471_/Q _1306_/B vssd1 vssd1 vccd1 vccd1 _1306_/X sky130_fd_sc_hd__xor2_2
XFILLER_52_333 vssd1 vccd1 vssd1 vccd1 sky130_ef_sc_hd__decap_40_12
X_1237_ _1461_/Q _1237_/A2 _0715_/B vssd1 vssd1 vccd1 vccd1 _1237_/Y sky130_fd_sc_hd__o21ai_2
X_1168_ _1206_/A1 _1206_/A2 _1206_/B1 _1167_/X vssd1 vssd1 vccd1 vccd1 _1168_/X sky130_fd_sc_hd__o211a_2
X_1099_ _1452_/Q _1099_/B vssd1 vssd1 vccd1 vccd1 _1100_/D sky130_fd_sc_hd__nor2_2
XTAP_TAPCELL_ROW_22_269 vssd1 vccd1 sky130_fd_sc_hd__tapvpwrvgnd_1
XANTENNA__0908__A2 input9/X vssd1 vssd1 vccd1 vccd1 sky130_fd_sc_hd__diode_2
XPHY_EDGE_ROW_8_Left_68 vssd1 vssd1 vccd1 vccd1 sky130_fd_sc_hd__decap_3
XFILLER_18_85 vssd1 vssd1 vccd1 vccd1 sky130_fd_sc_hd__fill_4
XFILLER_28_330 vssd1 vccd1 vssd1 vccd1 sky130_ef_sc_hd__decap_40_12
XFILLER_55_193 vssd1 vccd1 vssd1 vccd1 sky130_ef_sc_hd__decap_40_12
XTAP_TAPCELL_ROW_13_214 vssd1 vccd1 sky130_fd_sc_hd__tapvpwrvgnd_1
XFILLER_7_223 vssd1 vssd1 vccd1 vccd1 sky130_fd_sc_hd__fill_1
XFILLER_59_81 vssd1 vssd1 vccd1 vccd1 sky130_fd_sc_hd__fill_2
Xload_slew126 _1237_/A2 vssd1 vssd1 vccd1 vccd1 _1228_/B sky130_fd_sc_hd__clkbuf_4
Xload_slew137 fanout136/X vssd1 vssd1 vccd1 vccd1 load_slew137/X sky130_fd_sc_hd__buf_4
XFILLER_34_300 vssd1 vssd1 vccd1 vccd1 sky130_fd_sc_hd__fill_8
X_1022_ _1019_/A _1021_/A _1023_/A vssd1 vssd1 vccd1 vccd1 _1026_/C sky130_fd_sc_hd__o21ai_2
X_0806_ _0806_/A _0806_/B vssd1 vssd1 vccd1 vccd1 _0811_/B sky130_fd_sc_hd__xor2_2
X_0737_ _0766_/A _0766_/B _0734_/Y vssd1 vssd1 vccd1 vccd1 _0764_/A sky130_fd_sc_hd__a21o_2
XFILLER_55_39 vssd1 vccd1 vssd1 vccd1 sky130_ef_sc_hd__decap_40_12
XTAP_TAPCELL_ROW_27_306 vssd1 vccd1 sky130_fd_sc_hd__tapvpwrvgnd_1
XFILLER_25_333 vssd1 vssd1 vccd1 vccd1 sky130_fd_sc_hd__fill_2
XFILLER_37_193 vssd1 vssd1 vccd1 vccd1 sky130_fd_sc_hd__fill_2
XFILLER_40_336 vssd1 vssd1 vccd1 vccd1 sky130_fd_sc_hd__fill_2
XFILLER_52_141 vssd1 vccd1 vssd1 vccd1 sky130_ef_sc_hd__decap_40_12
XANTENNA__1251__A1 _1330_/B1 vssd1 vssd1 vccd1 vccd1 sky130_fd_sc_hd__diode_2
XFILLER_20_20 vssd1 vssd1 vccd1 vccd1 sky130_fd_sc_hd__fill_8
XFILLER_20_42 vssd1 vccd1 vssd1 vccd1 sky130_ef_sc_hd__decap_40_12
XFILLER_20_75 vssd1 vssd1 vccd1 vccd1 sky130_fd_sc_hd__fill_8
XFILLER_16_300 vssd1 vssd1 vccd1 vccd1 sky130_fd_sc_hd__fill_1
XFILLER_16_333 vssd1 vccd1 vssd1 vccd1 sky130_ef_sc_hd__decap_40_12
XFILLER_28_160 vssd1 vccd1 vssd1 vccd1 sky130_ef_sc_hd__decap_40_12
XFILLER_29_73 vssd1 vssd1 vccd1 vccd1 sky130_fd_sc_hd__fill_1
XFILLER_45_94 vssd1 vssd1 vccd1 vccd1 sky130_fd_sc_hd__fill_1
XTAP_TAPCELL_ROW_41_397 vssd1 vccd1 sky130_fd_sc_hd__tapvpwrvgnd_1
XFILLER_3_281 vssd1 vccd1 vssd1 vccd1 sky130_ef_sc_hd__decap_40_12
XFILLER_6_77 vssd1 vssd1 vccd1 vccd1 sky130_fd_sc_hd__fill_4
XFILLER_19_171 vssd1 vssd1 vccd1 vccd1 sky130_fd_sc_hd__fill_1
X_1005_ _1005_/A _1005_/B vssd1 vssd1 vccd1 vccd1 _1061_/B sky130_fd_sc_hd__nand2_2
XFILLER_25_130 vssd1 vssd1 vccd1 vccd1 sky130_fd_sc_hd__fill_4
XFILLER_57_277 vssd1 vssd1 vccd1 vccd1 sky130_fd_sc_hd__fill_2
XFILLER_15_86 vssd1 vssd1 vccd1 vccd1 sky130_fd_sc_hd__fill_8
XFILLER_40_155 vssd1 vssd1 vccd1 vccd1 sky130_fd_sc_hd__fill_1
XFILLER_9_329 vssd1 vssd1 vccd1 vccd1 sky130_fd_sc_hd__fill_4
XTAP_TAPCELL_ROW_55_489 vssd1 vccd1 sky130_fd_sc_hd__tapvpwrvgnd_1
XFILLER_31_41 vssd1 vccd1 vssd1 vccd1 sky130_ef_sc_hd__decap_40_12
Xoutput52 _1517_/X vssd1 vssd1 vccd1 vccd1 gpio_oeb[6] sky130_fd_sc_hd__clkdlybuf4s25_1
Xoutput41 _1538_/X vssd1 vssd1 vccd1 vccd1 gpio_oeb[27] sky130_fd_sc_hd__clkdlybuf4s25_1
Xoutput30 _1528_/X vssd1 vssd1 vccd1 vccd1 gpio_oeb[17] sky130_fd_sc_hd__clkdlybuf4s25_1
XFILLER_0_251 vssd1 vssd1 vccd1 vccd1 sky130_fd_sc_hd__fill_1
XFILLER_48_222 vssd1 vccd1 vssd1 vccd1 sky130_ef_sc_hd__decap_40_12
XFILLER_48_277 vssd1 vccd1 vssd1 vccd1 sky130_ef_sc_hd__decap_40_12
Xoutput85 _1407_/Y vssd1 vssd1 vccd1 vccd1 gpio_out[5] sky130_fd_sc_hd__clkdlybuf4s25_1
Xoutput74 _1435_/X vssd1 vssd1 vccd1 vccd1 gpio_out[26] sky130_fd_sc_hd__clkdlybuf4s25_1
Xoutput63 _1423_/X vssd1 vssd1 vccd1 vccd1 gpio_out[16] sky130_fd_sc_hd__clkdlybuf4s25_1
XFILLER_31_111 vssd1 vssd1 vccd1 vccd1 sky130_fd_sc_hd__fill_1
XFILLER_8_373 vssd1 vssd1 vccd1 vccd1 sky130_fd_sc_hd__fill_2
XANTENNA__1327__C _1327_/C vssd1 vssd1 vccd1 vccd1 sky130_fd_sc_hd__diode_2
.ends
