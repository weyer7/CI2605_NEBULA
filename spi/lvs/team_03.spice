* NGSPICE file created from team_03.ext - technology: sky130A

* Black-box entry subcircuit for sky130_fd_sc_hd__fill_1 abstract view
.subckt sky130_fd_sc_hd__fill_1 VGND VNB VPB VPWR
.ends

* Black-box entry subcircuit for sky130_fd_sc_hd__fill_2 abstract view
.subckt sky130_fd_sc_hd__fill_2 VGND VNB VPB VPWR
.ends

* Black-box entry subcircuit for sky130_fd_sc_hd__a22oi_1 abstract view
.subckt sky130_fd_sc_hd__a22oi_1 A1 A2 B1 B2 VGND VNB VPB VPWR Y
.ends

* Black-box entry subcircuit for sky130_fd_sc_hd__nand2_1 abstract view
.subckt sky130_fd_sc_hd__nand2_1 A B VGND VNB VPB VPWR Y
.ends

* Black-box entry subcircuit for sky130_fd_sc_hd__nor2_1 abstract view
.subckt sky130_fd_sc_hd__nor2_1 A B VGND VNB VPB VPWR Y
.ends

* Black-box entry subcircuit for sky130_fd_sc_hd__xnor2_1 abstract view
.subckt sky130_fd_sc_hd__xnor2_1 A B VGND VNB VPB VPWR Y
.ends

* Black-box entry subcircuit for sky130_fd_sc_hd__a21oi_1 abstract view
.subckt sky130_fd_sc_hd__a21oi_1 A1 A2 B1 VGND VNB VPB VPWR Y
.ends

* Black-box entry subcircuit for sky130_fd_sc_hd__o211a_1 abstract view
.subckt sky130_fd_sc_hd__o211a_1 A1 A2 B1 C1 VGND VNB VPB VPWR X
.ends

* Black-box entry subcircuit for sky130_fd_sc_hd__dfrtp_1 abstract view
.subckt sky130_fd_sc_hd__dfrtp_1 CLK D RESET_B VGND VNB VPB VPWR Q
.ends

* Black-box entry subcircuit for sky130_fd_sc_hd__diode_2 abstract view
.subckt sky130_fd_sc_hd__diode_2 DIODE VGND VNB VPB VPWR
.ends

* Black-box entry subcircuit for sky130_fd_sc_hd__nor3_1 abstract view
.subckt sky130_fd_sc_hd__nor3_1 A B C VGND VNB VPB VPWR Y
.ends

* Black-box entry subcircuit for sky130_fd_sc_hd__o21ai_1 abstract view
.subckt sky130_fd_sc_hd__o21ai_1 A1 A2 B1 VGND VNB VPB VPWR Y
.ends

* Black-box entry subcircuit for sky130_fd_sc_hd__xor2_1 abstract view
.subckt sky130_fd_sc_hd__xor2_1 A B VGND VNB VPB VPWR X
.ends

* Black-box entry subcircuit for sky130_ef_sc_hd__decap_40_12 abstract view
.subckt sky130_ef_sc_hd__decap_40_12 VPWR VGND VPB VNB
.ends

* Black-box entry subcircuit for sky130_fd_sc_hd__tapvpwrvgnd_1 abstract view
.subckt sky130_fd_sc_hd__tapvpwrvgnd_1 VGND VPWR
.ends

* Black-box entry subcircuit for sky130_fd_sc_hd__fill_4 abstract view
.subckt sky130_fd_sc_hd__fill_4 VGND VNB VPB VPWR
.ends

* Black-box entry subcircuit for sky130_fd_sc_hd__decap_3 abstract view
.subckt sky130_fd_sc_hd__decap_3 VGND VNB VPB VPWR
.ends

* Black-box entry subcircuit for sky130_fd_sc_hd__fill_8 abstract view
.subckt sky130_fd_sc_hd__fill_8 VGND VNB VPB VPWR
.ends

* Black-box entry subcircuit for sky130_fd_sc_hd__a31o_1 abstract view
.subckt sky130_fd_sc_hd__a31o_1 A1 A2 A3 B1 VGND VNB VPB VPWR X
.ends

* Black-box entry subcircuit for sky130_fd_sc_hd__or2_2 abstract view
.subckt sky130_fd_sc_hd__or2_2 A B VGND VNB VPB VPWR X
.ends

* Black-box entry subcircuit for sky130_fd_sc_hd__or4_1 abstract view
.subckt sky130_fd_sc_hd__or4_1 A B C D VGND VNB VPB VPWR X
.ends

* Black-box entry subcircuit for sky130_fd_sc_hd__and4_1 abstract view
.subckt sky130_fd_sc_hd__and4_1 A B C D VGND VNB VPB VPWR X
.ends

* Black-box entry subcircuit for sky130_fd_sc_hd__o21a_1 abstract view
.subckt sky130_fd_sc_hd__o21a_1 A1 A2 B1 VGND VNB VPB VPWR X
.ends

* Black-box entry subcircuit for sky130_fd_sc_hd__or2_1 abstract view
.subckt sky130_fd_sc_hd__or2_1 A B VGND VNB VPB VPWR X
.ends

* Black-box entry subcircuit for sky130_fd_sc_hd__and2b_1 abstract view
.subckt sky130_fd_sc_hd__and2b_1 A_N B VGND VNB VPB VPWR X
.ends

* Black-box entry subcircuit for sky130_fd_sc_hd__o21ba_1 abstract view
.subckt sky130_fd_sc_hd__o21ba_1 A1 A2 B1_N VGND VNB VPB VPWR X
.ends

* Black-box entry subcircuit for sky130_fd_sc_hd__or3_1 abstract view
.subckt sky130_fd_sc_hd__or3_1 A B C VGND VNB VPB VPWR X
.ends

* Black-box entry subcircuit for sky130_fd_sc_hd__inv_2 abstract view
.subckt sky130_fd_sc_hd__inv_2 A VGND VNB VPB VPWR Y
.ends

* Black-box entry subcircuit for sky130_fd_sc_hd__buf_2 abstract view
.subckt sky130_fd_sc_hd__buf_2 A VGND VNB VPB VPWR X
.ends

* Black-box entry subcircuit for sky130_fd_sc_hd__clkbuf_4 abstract view
.subckt sky130_fd_sc_hd__clkbuf_4 A VGND VNB VPB VPWR X
.ends

* Black-box entry subcircuit for sky130_fd_sc_hd__o21ai_2 abstract view
.subckt sky130_fd_sc_hd__o21ai_2 A1 A2 B1 VGND VNB VPB VPWR Y
.ends

* Black-box entry subcircuit for sky130_fd_sc_hd__and2_1 abstract view
.subckt sky130_fd_sc_hd__and2_1 A B VGND VNB VPB VPWR X
.ends

* Black-box entry subcircuit for sky130_fd_sc_hd__or3b_1 abstract view
.subckt sky130_fd_sc_hd__or3b_1 A B C_N VGND VNB VPB VPWR X
.ends

* Black-box entry subcircuit for sky130_fd_sc_hd__o211ai_2 abstract view
.subckt sky130_fd_sc_hd__o211ai_2 A1 A2 B1 C1 VGND VNB VPB VPWR Y
.ends

* Black-box entry subcircuit for sky130_fd_sc_hd__clkbuf_8 abstract view
.subckt sky130_fd_sc_hd__clkbuf_8 A VGND VNB VPB VPWR X
.ends

* Black-box entry subcircuit for sky130_fd_sc_hd__a21o_1 abstract view
.subckt sky130_fd_sc_hd__a21o_1 A1 A2 B1 VGND VNB VPB VPWR X
.ends

* Black-box entry subcircuit for sky130_fd_sc_hd__o2bb2a_1 abstract view
.subckt sky130_fd_sc_hd__o2bb2a_1 A1_N A2_N B1 B2 VGND VNB VPB VPWR X
.ends

* Black-box entry subcircuit for sky130_fd_sc_hd__a211oi_1 abstract view
.subckt sky130_fd_sc_hd__a211oi_1 A1 A2 B1 C1 VGND VNB VPB VPWR Y
.ends

* Black-box entry subcircuit for sky130_fd_sc_hd__a21bo_1 abstract view
.subckt sky130_fd_sc_hd__a21bo_1 A1 A2 B1_N VGND VNB VPB VPWR X
.ends

* Black-box entry subcircuit for sky130_fd_sc_hd__mux2_1 abstract view
.subckt sky130_fd_sc_hd__mux2_1 A0 A1 S VGND VNB VPB VPWR X
.ends

* Black-box entry subcircuit for sky130_fd_sc_hd__nand2b_1 abstract view
.subckt sky130_fd_sc_hd__nand2b_1 A_N B VGND VNB VPB VPWR Y
.ends

* Black-box entry subcircuit for sky130_fd_sc_hd__o311a_1 abstract view
.subckt sky130_fd_sc_hd__o311a_1 A1 A2 A3 B1 C1 VGND VNB VPB VPWR X
.ends

* Black-box entry subcircuit for sky130_fd_sc_hd__and3_1 abstract view
.subckt sky130_fd_sc_hd__and3_1 A B C VGND VNB VPB VPWR X
.ends

* Black-box entry subcircuit for sky130_fd_sc_hd__nand3_1 abstract view
.subckt sky130_fd_sc_hd__nand3_1 A B C VGND VNB VPB VPWR Y
.ends

* Black-box entry subcircuit for sky130_fd_sc_hd__a22o_1 abstract view
.subckt sky130_fd_sc_hd__a22o_1 A1 A2 B1 B2 VGND VNB VPB VPWR X
.ends

* Black-box entry subcircuit for sky130_fd_sc_hd__dlygate4sd3_1 abstract view
.subckt sky130_fd_sc_hd__dlygate4sd3_1 A VGND VNB VPB VPWR X
.ends

* Black-box entry subcircuit for sky130_fd_sc_hd__o21bai_1 abstract view
.subckt sky130_fd_sc_hd__o21bai_1 A1 A2 B1_N VGND VNB VPB VPWR Y
.ends

* Black-box entry subcircuit for sky130_fd_sc_hd__o2111a_1 abstract view
.subckt sky130_fd_sc_hd__o2111a_1 A1 A2 B1 C1 D1 VGND VNB VPB VPWR X
.ends

* Black-box entry subcircuit for sky130_fd_sc_hd__conb_1 abstract view
.subckt sky130_fd_sc_hd__conb_1 VGND VNB VPB VPWR HI LO
.ends

* Black-box entry subcircuit for sky130_fd_sc_hd__a32oi_4 abstract view
.subckt sky130_fd_sc_hd__a32oi_4 A1 A2 A3 B1 B2 VGND VNB VPB VPWR Y
.ends

* Black-box entry subcircuit for sky130_fd_sc_hd__clkbuf_2 abstract view
.subckt sky130_fd_sc_hd__clkbuf_2 A VGND VNB VPB VPWR X
.ends

* Black-box entry subcircuit for sky130_fd_sc_hd__a211oi_2 abstract view
.subckt sky130_fd_sc_hd__a211oi_2 A1 A2 B1 C1 VGND VNB VPB VPWR Y
.ends

* Black-box entry subcircuit for sky130_fd_sc_hd__dlymetal6s2s_1 abstract view
.subckt sky130_fd_sc_hd__dlymetal6s2s_1 A VGND VNB VPB VPWR X
.ends

* Black-box entry subcircuit for sky130_fd_sc_hd__nor2_2 abstract view
.subckt sky130_fd_sc_hd__nor2_2 A B VGND VNB VPB VPWR Y
.ends

* Black-box entry subcircuit for sky130_fd_sc_hd__a31oi_2 abstract view
.subckt sky130_fd_sc_hd__a31oi_2 A1 A2 A3 B1 VGND VNB VPB VPWR Y
.ends

* Black-box entry subcircuit for sky130_fd_sc_hd__a211o_1 abstract view
.subckt sky130_fd_sc_hd__a211o_1 A1 A2 B1 C1 VGND VNB VPB VPWR X
.ends

* Black-box entry subcircuit for sky130_fd_sc_hd__o211ai_1 abstract view
.subckt sky130_fd_sc_hd__o211ai_1 A1 A2 B1 C1 VGND VNB VPB VPWR Y
.ends

* Black-box entry subcircuit for sky130_fd_sc_hd__nand3b_1 abstract view
.subckt sky130_fd_sc_hd__nand3b_1 A_N B C VGND VNB VPB VPWR Y
.ends

* Black-box entry subcircuit for sky130_fd_sc_hd__a32o_1 abstract view
.subckt sky130_fd_sc_hd__a32o_1 A1 A2 A3 B1 B2 VGND VNB VPB VPWR X
.ends

* Black-box entry subcircuit for sky130_fd_sc_hd__o22a_1 abstract view
.subckt sky130_fd_sc_hd__o22a_1 A1 A2 B1 B2 VGND VNB VPB VPWR X
.ends

* Black-box entry subcircuit for sky130_fd_sc_hd__nand4_1 abstract view
.subckt sky130_fd_sc_hd__nand4_1 A B C D VGND VNB VPB VPWR Y
.ends

* Black-box entry subcircuit for sky130_fd_sc_hd__or4b_1 abstract view
.subckt sky130_fd_sc_hd__or4b_1 A B C D_N VGND VNB VPB VPWR X
.ends

* Black-box entry subcircuit for sky130_fd_sc_hd__and4b_1 abstract view
.subckt sky130_fd_sc_hd__and4b_1 A_N B C D VGND VNB VPB VPWR X
.ends

* Black-box entry subcircuit for sky130_fd_sc_hd__nand3_2 abstract view
.subckt sky130_fd_sc_hd__nand3_2 A B C VGND VNB VPB VPWR Y
.ends

* Black-box entry subcircuit for sky130_fd_sc_hd__o21ai_4 abstract view
.subckt sky130_fd_sc_hd__o21ai_4 A1 A2 B1 VGND VNB VPB VPWR Y
.ends

* Black-box entry subcircuit for sky130_fd_sc_hd__xnor2_2 abstract view
.subckt sky130_fd_sc_hd__xnor2_2 A B VGND VNB VPB VPWR Y
.ends

* Black-box entry subcircuit for sky130_fd_sc_hd__and3b_1 abstract view
.subckt sky130_fd_sc_hd__and3b_1 A_N B C VGND VNB VPB VPWR X
.ends

* Black-box entry subcircuit for sky130_fd_sc_hd__a21boi_1 abstract view
.subckt sky130_fd_sc_hd__a21boi_1 A1 A2 B1_N VGND VNB VPB VPWR Y
.ends

* Black-box entry subcircuit for sky130_fd_sc_hd__a2bb2o_1 abstract view
.subckt sky130_fd_sc_hd__a2bb2o_1 A1_N A2_N B1 B2 VGND VNB VPB VPWR X
.ends

* Black-box entry subcircuit for sky130_fd_sc_hd__o311a_4 abstract view
.subckt sky130_fd_sc_hd__o311a_4 A1 A2 A3 B1 C1 VGND VNB VPB VPWR X
.ends

* Black-box entry subcircuit for sky130_fd_sc_hd__o32ai_4 abstract view
.subckt sky130_fd_sc_hd__o32ai_4 A1 A2 A3 B1 B2 VGND VNB VPB VPWR Y
.ends

* Black-box entry subcircuit for sky130_fd_sc_hd__o31a_1 abstract view
.subckt sky130_fd_sc_hd__o31a_1 A1 A2 A3 B1 VGND VNB VPB VPWR X
.ends

* Black-box entry subcircuit for sky130_fd_sc_hd__o31ai_4 abstract view
.subckt sky130_fd_sc_hd__o31ai_4 A1 A2 A3 B1 VGND VNB VPB VPWR Y
.ends

* Black-box entry subcircuit for sky130_fd_sc_hd__or4bb_1 abstract view
.subckt sky130_fd_sc_hd__or4bb_1 A B C_N D_N VGND VNB VPB VPWR X
.ends

* Black-box entry subcircuit for sky130_fd_sc_hd__inv_6 abstract view
.subckt sky130_fd_sc_hd__inv_6 A VGND VNB VPB VPWR Y
.ends

* Black-box entry subcircuit for sky130_fd_sc_hd__buf_1 abstract view
.subckt sky130_fd_sc_hd__buf_1 A VGND VNB VPB VPWR X
.ends

* Black-box entry subcircuit for sky130_fd_sc_hd__o2bb2ai_1 abstract view
.subckt sky130_fd_sc_hd__o2bb2ai_1 A1_N A2_N B1 B2 VGND VNB VPB VPWR Y
.ends

* Black-box entry subcircuit for sky130_fd_sc_hd__a31oi_1 abstract view
.subckt sky130_fd_sc_hd__a31oi_1 A1 A2 A3 B1 VGND VNB VPB VPWR Y
.ends

* Black-box entry subcircuit for sky130_fd_sc_hd__xor2_2 abstract view
.subckt sky130_fd_sc_hd__xor2_2 A B VGND VNB VPB VPWR X
.ends

* Black-box entry subcircuit for sky130_fd_sc_hd__o211ai_4 abstract view
.subckt sky130_fd_sc_hd__o211ai_4 A1 A2 B1 C1 VGND VNB VPB VPWR Y
.ends

* Black-box entry subcircuit for sky130_fd_sc_hd__and4bb_2 abstract view
.subckt sky130_fd_sc_hd__and4bb_2 A_N B_N C D VGND VNB VPB VPWR X
.ends

* Black-box entry subcircuit for sky130_fd_sc_hd__bufinv_16 abstract view
.subckt sky130_fd_sc_hd__bufinv_16 A VGND VNB VPB VPWR Y
.ends

* Black-box entry subcircuit for sky130_fd_sc_hd__or3_2 abstract view
.subckt sky130_fd_sc_hd__or3_2 A B C VGND VNB VPB VPWR X
.ends

* Black-box entry subcircuit for sky130_fd_sc_hd__a21oi_2 abstract view
.subckt sky130_fd_sc_hd__a21oi_2 A1 A2 B1 VGND VNB VPB VPWR Y
.ends

* Black-box entry subcircuit for sky130_fd_sc_hd__inv_8 abstract view
.subckt sky130_fd_sc_hd__inv_8 A VGND VNB VPB VPWR Y
.ends

* Black-box entry subcircuit for sky130_fd_sc_hd__nor3b_1 abstract view
.subckt sky130_fd_sc_hd__nor3b_1 A B C_N VGND VNB VPB VPWR Y
.ends

* Black-box entry subcircuit for sky130_fd_sc_hd__nand2_2 abstract view
.subckt sky130_fd_sc_hd__nand2_2 A B VGND VNB VPB VPWR Y
.ends

* Black-box entry subcircuit for sky130_fd_sc_hd__and2_2 abstract view
.subckt sky130_fd_sc_hd__and2_2 A B VGND VNB VPB VPWR X
.ends

* Black-box entry subcircuit for sky130_fd_sc_hd__o221a_1 abstract view
.subckt sky130_fd_sc_hd__o221a_1 A1 A2 B1 B2 C1 VGND VNB VPB VPWR X
.ends

* Black-box entry subcircuit for sky130_fd_sc_hd__o31ai_2 abstract view
.subckt sky130_fd_sc_hd__o31ai_2 A1 A2 A3 B1 VGND VNB VPB VPWR Y
.ends

* Black-box entry subcircuit for sky130_fd_sc_hd__o21bai_2 abstract view
.subckt sky130_fd_sc_hd__o21bai_2 A1 A2 B1_N VGND VNB VPB VPWR Y
.ends

* Black-box entry subcircuit for sky130_fd_sc_hd__a221o_1 abstract view
.subckt sky130_fd_sc_hd__a221o_1 A1 A2 B1 B2 C1 VGND VNB VPB VPWR X
.ends

* Black-box entry subcircuit for sky130_fd_sc_hd__clkbuf_16 abstract view
.subckt sky130_fd_sc_hd__clkbuf_16 A VGND VNB VPB VPWR X
.ends

* Black-box entry subcircuit for sky130_fd_sc_hd__dfrtp_2 abstract view
.subckt sky130_fd_sc_hd__dfrtp_2 CLK D RESET_B VGND VNB VPB VPWR Q
.ends

* Black-box entry subcircuit for sky130_fd_sc_hd__clkinv_8 abstract view
.subckt sky130_fd_sc_hd__clkinv_8 A VGND VNB VPB VPWR Y
.ends

* Black-box entry subcircuit for sky130_fd_sc_hd__nand4_2 abstract view
.subckt sky130_fd_sc_hd__nand4_2 A B C D VGND VNB VPB VPWR Y
.ends

* Black-box entry subcircuit for sky130_fd_sc_hd__o22ai_1 abstract view
.subckt sky130_fd_sc_hd__o22ai_1 A1 A2 B1 B2 VGND VNB VPB VPWR Y
.ends

* Black-box entry subcircuit for sky130_fd_sc_hd__clkinvlp_4 abstract view
.subckt sky130_fd_sc_hd__clkinvlp_4 A VGND VNB VPB VPWR Y
.ends

* Black-box entry subcircuit for sky130_fd_sc_hd__clkinv_2 abstract view
.subckt sky130_fd_sc_hd__clkinv_2 A VGND VNB VPB VPWR Y
.ends

* Black-box entry subcircuit for sky130_fd_sc_hd__a41o_1 abstract view
.subckt sky130_fd_sc_hd__a41o_1 A1 A2 A3 A4 B1 VGND VNB VPB VPWR X
.ends

* Black-box entry subcircuit for sky130_fd_sc_hd__a32oi_2 abstract view
.subckt sky130_fd_sc_hd__a32oi_2 A1 A2 A3 B1 B2 VGND VNB VPB VPWR Y
.ends

* Black-box entry subcircuit for sky130_fd_sc_hd__or3b_4 abstract view
.subckt sky130_fd_sc_hd__or3b_4 A B C_N VGND VNB VPB VPWR X
.ends

* Black-box entry subcircuit for sky130_fd_sc_hd__clkbuf_1 abstract view
.subckt sky130_fd_sc_hd__clkbuf_1 A VGND VNB VPB VPWR X
.ends

* Black-box entry subcircuit for sky130_fd_sc_hd__a22oi_2 abstract view
.subckt sky130_fd_sc_hd__a22oi_2 A1 A2 B1 B2 VGND VNB VPB VPWR Y
.ends

* Black-box entry subcircuit for sky130_fd_sc_hd__a2111o_1 abstract view
.subckt sky130_fd_sc_hd__a2111o_1 A1 A2 B1 C1 D1 VGND VNB VPB VPWR X
.ends

* Black-box entry subcircuit for sky130_fd_sc_hd__a21oi_4 abstract view
.subckt sky130_fd_sc_hd__a21oi_4 A1 A2 B1 VGND VNB VPB VPWR Y
.ends

* Black-box entry subcircuit for sky130_fd_sc_hd__nor3_2 abstract view
.subckt sky130_fd_sc_hd__nor3_2 A B C VGND VNB VPB VPWR Y
.ends

* Black-box entry subcircuit for sky130_fd_sc_hd__o311ai_4 abstract view
.subckt sky130_fd_sc_hd__o311ai_4 A1 A2 A3 B1 C1 VGND VNB VPB VPWR Y
.ends

* Black-box entry subcircuit for sky130_fd_sc_hd__xnor2_4 abstract view
.subckt sky130_fd_sc_hd__xnor2_4 A B VGND VNB VPB VPWR Y
.ends

* Black-box entry subcircuit for sky130_fd_sc_hd__o32a_1 abstract view
.subckt sky130_fd_sc_hd__o32a_1 A1 A2 A3 B1 B2 VGND VNB VPB VPWR X
.ends

* Black-box entry subcircuit for sky130_fd_sc_hd__a311o_1 abstract view
.subckt sky130_fd_sc_hd__a311o_1 A1 A2 A3 B1 C1 VGND VNB VPB VPWR X
.ends

* Black-box entry subcircuit for sky130_fd_sc_hd__o2111ai_1 abstract view
.subckt sky130_fd_sc_hd__o2111ai_1 A1 A2 B1 C1 D1 VGND VNB VPB VPWR Y
.ends

* Black-box entry subcircuit for sky130_fd_sc_hd__a2bb2oi_1 abstract view
.subckt sky130_fd_sc_hd__a2bb2oi_1 A1_N A2_N B1 B2 VGND VNB VPB VPWR Y
.ends

* Black-box entry subcircuit for sky130_fd_sc_hd__a311o_2 abstract view
.subckt sky130_fd_sc_hd__a311o_2 A1 A2 A3 B1 C1 VGND VNB VPB VPWR X
.ends

* Black-box entry subcircuit for sky130_fd_sc_hd__buf_4 abstract view
.subckt sky130_fd_sc_hd__buf_4 A VGND VNB VPB VPWR X
.ends

* Black-box entry subcircuit for sky130_fd_sc_hd__nand2_4 abstract view
.subckt sky130_fd_sc_hd__nand2_4 A B VGND VNB VPB VPWR Y
.ends

* Black-box entry subcircuit for sky130_fd_sc_hd__or3_4 abstract view
.subckt sky130_fd_sc_hd__or3_4 A B C VGND VNB VPB VPWR X
.ends

* Black-box entry subcircuit for sky130_fd_sc_hd__nand2b_2 abstract view
.subckt sky130_fd_sc_hd__nand2b_2 A_N B VGND VNB VPB VPWR Y
.ends

* Black-box entry subcircuit for sky130_fd_sc_hd__a311oi_2 abstract view
.subckt sky130_fd_sc_hd__a311oi_2 A1 A2 A3 B1 C1 VGND VNB VPB VPWR Y
.ends

* Black-box entry subcircuit for sky130_fd_sc_hd__and3_4 abstract view
.subckt sky130_fd_sc_hd__and3_4 A B C VGND VNB VPB VPWR X
.ends

* Black-box entry subcircuit for sky130_fd_sc_hd__a21boi_2 abstract view
.subckt sky130_fd_sc_hd__a21boi_2 A1 A2 B1_N VGND VNB VPB VPWR Y
.ends

* Black-box entry subcircuit for sky130_fd_sc_hd__dfrtp_4 abstract view
.subckt sky130_fd_sc_hd__dfrtp_4 CLK D RESET_B VGND VNB VPB VPWR Q
.ends

* Black-box entry subcircuit for sky130_fd_sc_hd__a32oi_1 abstract view
.subckt sky130_fd_sc_hd__a32oi_1 A1 A2 A3 B1 B2 VGND VNB VPB VPWR Y
.ends

* Black-box entry subcircuit for sky130_fd_sc_hd__or3b_2 abstract view
.subckt sky130_fd_sc_hd__or3b_2 A B C_N VGND VNB VPB VPWR X
.ends

.subckt team_03 clk en gpio_in[0] gpio_in[10] gpio_in[11] gpio_in[12] gpio_in[13]
+ gpio_in[14] gpio_in[15] gpio_in[16] gpio_in[17] gpio_in[18] gpio_in[19] gpio_in[1]
+ gpio_in[20] gpio_in[21] gpio_in[22] gpio_in[23] gpio_in[24] gpio_in[25] gpio_in[26]
+ gpio_in[27] gpio_in[28] gpio_in[29] gpio_in[2] gpio_in[30] gpio_in[31] gpio_in[32]
+ gpio_in[33] gpio_in[3] gpio_in[4] gpio_in[5] gpio_in[6] gpio_in[7] gpio_in[8] gpio_in[9]
+ gpio_oeb[0] gpio_oeb[10] gpio_oeb[11] gpio_oeb[12] gpio_oeb[13] gpio_oeb[14] gpio_oeb[15]
+ gpio_oeb[16] gpio_oeb[17] gpio_oeb[18] gpio_oeb[19] gpio_oeb[1] gpio_oeb[20] gpio_oeb[21]
+ gpio_oeb[22] gpio_oeb[23] gpio_oeb[24] gpio_oeb[25] gpio_oeb[26] gpio_oeb[27] gpio_oeb[28]
+ gpio_oeb[29] gpio_oeb[2] gpio_oeb[30] gpio_oeb[31] gpio_oeb[32] gpio_oeb[33] gpio_oeb[3]
+ gpio_oeb[4] gpio_oeb[5] gpio_oeb[6] gpio_oeb[7] gpio_oeb[8] gpio_oeb[9] gpio_out[0]
+ gpio_out[10] gpio_out[11] gpio_out[12] gpio_out[13] gpio_out[14] gpio_out[15] gpio_out[16]
+ gpio_out[17] gpio_out[18] gpio_out[19] gpio_out[1] gpio_out[20] gpio_out[21] gpio_out[22]
+ gpio_out[23] gpio_out[24] gpio_out[25] gpio_out[26] gpio_out[27] gpio_out[28] gpio_out[29]
+ gpio_out[2] gpio_out[30] gpio_out[31] gpio_out[32] gpio_out[33] gpio_out[3] gpio_out[4]
+ gpio_out[5] gpio_out[6] gpio_out[7] gpio_out[8] gpio_out[9] nrst vccd1 vssd1
XFILLER_79_391 vssd1 vssd1 vccd1 vccd1 sky130_fd_sc_hd__fill_1
XFILLER_67_531 vssd1 vssd1 vccd1 vccd1 sky130_fd_sc_hd__fill_1
XFILLER_27_406 vssd1 vssd1 vccd1 vccd1 sky130_fd_sc_hd__fill_1
XFILLER_39_277 vssd1 vssd1 vccd1 vccd1 sky130_fd_sc_hd__fill_2
X_7963_ net276 net191 net190 net281 vssd1 vssd1 vccd1 vccd1 _3218_ sky130_fd_sc_hd__a22oi_1
XFILLER_54_214 vssd1 vssd1 vccd1 vccd1 sky130_fd_sc_hd__fill_1
X_6914_ PID_INST.k3_calc.d1.y\[15\] net76 vssd1 vssd1 vccd1 vccd1 _2124_ sky130_fd_sc_hd__nand2_1
XFILLER_42_409 vssd1 vssd1 vccd1 vccd1 sky130_fd_sc_hd__fill_2
X_7894_ _3147_ _3148_ vssd1 vssd1 vccd1 vccd1 _3149_ sky130_fd_sc_hd__nor2_1
X_6845_ _1989_ _2049_ vssd1 vssd1 vccd1 vccd1 _2052_ sky130_fd_sc_hd__xnor2_1
X_6776_ _1973_ _1974_ _1975_ vssd1 vssd1 vccd1 vccd1 _1978_ sky130_fd_sc_hd__a21oi_1
X_5727_ _0906_ _0912_ net239 net288 vssd1 vssd1 vccd1 vccd1 _0917_ sky130_fd_sc_hd__o211a_1
X_8446_ clknet_4_13_0_clk _0034_ net336 vssd1 vssd1 vccd1 vccd1 PID_INST.k2_calc.sum_reg\[2\]
+ sky130_fd_sc_hd__dfrtp_1
XANTENNA_fanout215_X net215 vssd1 vssd1 vccd1 vccd1 sky130_fd_sc_hd__diode_2
X_5658_ _0711_ _0716_ _0759_ vssd1 vssd1 vccd1 vccd1 _0848_ sky130_fd_sc_hd__nor3_1
X_5589_ _0745_ _0748_ _0778_ vssd1 vssd1 vccd1 vccd1 _0779_ sky130_fd_sc_hd__o21ai_1
X_8377_ clknet_4_13_0_clk _0013_ net335 vssd1 vssd1 vccd1 vccd1 PID_INST.k1_calc.d1.x\[13\]
+ sky130_fd_sc_hd__dfrtp_1
X_4609_ _3867_ _3886_ vssd1 vssd1 vccd1 vccd1 _3887_ sky130_fd_sc_hd__nor2_1
XFILLER_89_111 vssd1 vssd1 vccd1 vccd1 sky130_fd_sc_hd__fill_1
X_7328_ PID_INST.k2_calc.reg_lc\[0\] net182 vssd1 vssd1 vccd1 vccd1 _2562_ sky130_fd_sc_hd__nand2_1
X_7259_ _2487_ _2488_ vssd1 vssd1 vccd1 vccd1 _2489_ sky130_fd_sc_hd__xor2_1
XANTENNA_fanout75_A net77 vssd1 vssd1 vccd1 vccd1 sky130_fd_sc_hd__diode_2
XFILLER_85_361 vssd1 vssd1 vccd1 vccd1 sky130_fd_sc_hd__fill_1
XFILLER_85_350 vssd1 vssd1 vccd1 vccd1 sky130_fd_sc_hd__fill_2
XFILLER_45_225 vssd1 vssd1 vccd1 vccd1 sky130_fd_sc_hd__fill_1
XFILLER_45_203 vccd1 vssd1 vccd1 vssd1 sky130_ef_sc_hd__decap_40_12
XTAP_TAPCELL_ROW_56_765 vssd1 vccd1 sky130_fd_sc_hd__tapvpwrvgnd_1
XANTENNA__8390__RESET_B net328 vssd1 vssd1 vccd1 vccd1 sky130_fd_sc_hd__diode_2
XTAP_TAPCELL_ROW_28_478 vssd1 vccd1 sky130_fd_sc_hd__tapvpwrvgnd_1
XFILLER_13_111 vssd1 vssd1 vccd1 vccd1 sky130_fd_sc_hd__fill_1
XFILLER_13_133 vssd1 vssd1 vccd1 vccd1 sky130_fd_sc_hd__fill_2
XFILLER_41_453 vssd1 vssd1 vccd1 vccd1 sky130_fd_sc_hd__fill_4
XFILLER_41_475 vssd1 vssd1 vccd1 vccd1 sky130_fd_sc_hd__fill_1
XTAP_TAPCELL_ROW_11_312 vssd1 vccd1 sky130_fd_sc_hd__tapvpwrvgnd_1
XANTENNA__5826__D net299 vssd1 vssd1 vccd1 vccd1 sky130_fd_sc_hd__diode_2
XANTENNA__7333__B1 net254 vssd1 vssd1 vccd1 vccd1 sky130_fd_sc_hd__diode_2
XPHY_EDGE_ROW_39_Left_132 vssd1 vssd1 vccd1 vccd1 sky130_fd_sc_hd__decap_3
XANTENNA__6439__A2 net291 vssd1 vssd1 vccd1 vccd1 sky130_fd_sc_hd__diode_2
XFILLER_68_306 vssd1 vssd1 vccd1 vccd1 sky130_fd_sc_hd__fill_2
XFILLER_3_45 vssd1 vssd1 vccd1 vccd1 sky130_fd_sc_hd__fill_2
XFILLER_76_394 vssd1 vssd1 vccd1 vccd1 sky130_fd_sc_hd__fill_4
XPHY_EDGE_ROW_48_Left_141 vssd1 vssd1 vccd1 vccd1 sky130_fd_sc_hd__decap_3
XANTENNA__8478__RESET_B net340 vssd1 vssd1 vccd1 vccd1 sky130_fd_sc_hd__diode_2
XFILLER_36_225 vssd1 vssd1 vccd1 vccd1 sky130_fd_sc_hd__fill_8
XFILLER_64_545 vssd1 vssd1 vccd1 vccd1 sky130_fd_sc_hd__fill_8
XFILLER_24_409 vssd1 vssd1 vccd1 vccd1 sky130_fd_sc_hd__fill_1
XFILLER_51_206 vssd1 vssd1 vccd1 vccd1 sky130_fd_sc_hd__fill_1
X_4960_ net142 _0087_ _0097_ _0096_ vssd1 vssd1 vccd1 vccd1 _0150_ sky130_fd_sc_hd__a31o_1
X_4891_ PID_INST.k1_calc.d1.x\[13\] PID_INST.k3_calc.prev_error\[13\] vssd1 vssd1
+ vccd1 vccd1 _0081_ sky130_fd_sc_hd__or2_2
XFILLER_32_442 vssd1 vssd1 vccd1 vccd1 sky130_fd_sc_hd__fill_1
X_6630_ _1821_ _1822_ vssd1 vssd1 vccd1 vccd1 _1823_ sky130_fd_sc_hd__xnor2_1
X_6561_ _1744_ _1747_ vssd1 vssd1 vccd1 vccd1 _1748_ sky130_fd_sc_hd__xnor2_1
X_8300_ _3564_ _3565_ _3571_ _3572_ vssd1 vssd1 vccd1 vccd1 _3574_ sky130_fd_sc_hd__or4_1
X_5512_ net244 net247 net283 net278 vssd1 vssd1 vccd1 vccd1 _0702_ sky130_fd_sc_hd__and4_1
XANTENNA__7009__C net225 vssd1 vssd1 vccd1 vccd1 sky130_fd_sc_hd__diode_2
XPHY_EDGE_ROW_57_Left_150 vssd1 vssd1 vccd1 vccd1 sky130_fd_sc_hd__decap_3
X_6492_ _1480_ _1482_ _1679_ vssd1 vssd1 vccd1 vccd1 _1680_ sky130_fd_sc_hd__o21a_1
XANTENNA__6127__B2 net114 vssd1 vssd1 vccd1 vccd1 sky130_fd_sc_hd__diode_2
XANTENNA__6127__A1 net116 vssd1 vssd1 vccd1 vccd1 sky130_fd_sc_hd__diode_2
X_8231_ _3498_ _3499_ vssd1 vssd1 vccd1 vccd1 _3500_ sky130_fd_sc_hd__xnor2_1
X_5443_ _0631_ _0632_ vssd1 vssd1 vccd1 vccd1 _0633_ sky130_fd_sc_hd__or2_1
X_8162_ _3425_ _3416_ vssd1 vssd1 vccd1 vccd1 _3426_ sky130_fd_sc_hd__and2b_1
X_5374_ _0559_ _0562_ vssd1 vssd1 vccd1 vccd1 _0564_ sky130_fd_sc_hd__nand2_1
X_7113_ _2234_ _2237_ _2235_ vssd1 vssd1 vccd1 vccd1 _2334_ sky130_fd_sc_hd__o21ba_1
X_4325_ net15 _3397_ _3418_ vssd1 vssd1 vccd1 vccd1 _3461_ sky130_fd_sc_hd__or3_1
XANTENNA__4649__B net84 vssd1 vssd1 vccd1 vccd1 sky130_fd_sc_hd__diode_2
X_8093_ _3351_ vssd1 vssd1 vccd1 vccd1 _3352_ sky130_fd_sc_hd__inv_2
Xfanout138 PID_INST.k3_calc.d1.y\[12\] vssd1 vssd1 vccd1 vccd1 net138 sky130_fd_sc_hd__buf_2
Xfanout116 _2315_ vssd1 vssd1 vccd1 vccd1 net116 sky130_fd_sc_hd__clkbuf_4
Xfanout127 PID_INST.k3_calc.d1.y\[5\] vssd1 vssd1 vccd1 vccd1 net127 sky130_fd_sc_hd__clkbuf_4
Xfanout105 _2516_ vssd1 vssd1 vccd1 vccd1 net105 sky130_fd_sc_hd__clkbuf_4
XFILLER_86_125 vssd1 vssd1 vccd1 vccd1 sky130_fd_sc_hd__fill_1
X_7044_ net221 PID_INST.k2_calc.reg_lc\[13\] vssd1 vssd1 vccd1 vccd1 _2262_ sky130_fd_sc_hd__nand2_1
X_4256_ net92 vssd1 vssd1 vccd1 vccd1 PID_INST.k3_calc.d2.y\[14\] sky130_fd_sc_hd__inv_2
Xfanout149 _1955_ vssd1 vssd1 vccd1 vccd1 net149 sky130_fd_sc_hd__buf_2
X_4187_ net4 net174 _2008_ vssd1 vssd1 vccd1 vccd1 _2019_ sky130_fd_sc_hd__o21ai_2
XANTENNA__4665__A net113 vssd1 vssd1 vccd1 vccd1 sky130_fd_sc_hd__diode_2
XFILLER_27_214 vssd1 vssd1 vccd1 vccd1 sky130_fd_sc_hd__fill_1
XFILLER_27_225 vccd1 vssd1 vccd1 vssd1 sky130_ef_sc_hd__decap_40_12
XFILLER_82_353 vssd1 vssd1 vccd1 vccd1 sky130_fd_sc_hd__fill_2
XFILLER_82_386 vssd1 vssd1 vccd1 vccd1 sky130_fd_sc_hd__fill_4
X_7946_ net293 net186 vssd1 vssd1 vccd1 vccd1 _3201_ sky130_fd_sc_hd__nand2_1
XANTENNA__8143__Y _3406_ vssd1 vssd1 vccd1 vccd1 sky130_fd_sc_hd__diode_2
XANTENNA__7695__B net193 vssd1 vssd1 vccd1 vccd1 sky130_fd_sc_hd__diode_2
XTAP_TAPCELL_ROW_81_1012 vssd1 vccd1 sky130_fd_sc_hd__tapvpwrvgnd_1
XTAP_TAPCELL_ROW_53_735 vssd1 vccd1 sky130_fd_sc_hd__tapvpwrvgnd_1
XFILLER_23_420 vssd1 vssd1 vccd1 vccd1 sky130_fd_sc_hd__fill_1
XTAP_TAPCELL_ROW_25_448 vssd1 vccd1 sky130_fd_sc_hd__tapvpwrvgnd_1
X_7877_ _3066_ _3131_ vssd1 vssd1 vccd1 vccd1 _3132_ sky130_fd_sc_hd__nand2_1
XFILLER_50_250 vssd1 vssd1 vccd1 vccd1 sky130_fd_sc_hd__fill_2
X_6828_ _2030_ _2032_ vssd1 vssd1 vccd1 vccd1 _2033_ sky130_fd_sc_hd__xnor2_1
XFILLER_23_453 vssd1 vssd1 vccd1 vccd1 sky130_fd_sc_hd__fill_2
XFILLER_10_114 vssd1 vssd1 vccd1 vccd1 sky130_fd_sc_hd__fill_2
X_6759_ _1845_ _1869_ vssd1 vssd1 vccd1 vccd1 _1960_ sky130_fd_sc_hd__nor2_1
X_8429_ clknet_4_1_0_clk net406 net327 vssd1 vssd1 vccd1 vccd1 PID_INST.k3_calc.prev_error\[1\]
+ sky130_fd_sc_hd__dfrtp_1
XFILLER_88_25 vssd1 vssd1 vccd1 vccd1 sky130_fd_sc_hd__fill_2
XTAP_TAPCELL_ROW_92_1130 vssd1 vccd1 sky130_fd_sc_hd__tapvpwrvgnd_1
XFILLER_88_47 vssd1 vssd1 vccd1 vccd1 sky130_fd_sc_hd__fill_4
XFILLER_2_335 vssd1 vssd1 vccd1 vccd1 sky130_fd_sc_hd__fill_2
XFILLER_2_346 vssd1 vssd1 vccd1 vccd1 sky130_fd_sc_hd__fill_2
XFILLER_77_125 vssd1 vssd1 vccd1 vccd1 sky130_fd_sc_hd__fill_2
XANTENNA__8291__A1 net294 vssd1 vssd1 vccd1 vccd1 sky130_fd_sc_hd__diode_2
XANTENNA__8291__B2 net305 vssd1 vssd1 vccd1 vccd1 sky130_fd_sc_hd__diode_2
XANTENNA_fanout78_X net78 vssd1 vssd1 vccd1 vccd1 sky130_fd_sc_hd__diode_2
XFILLER_65_309 vssd1 vssd1 vccd1 vccd1 sky130_fd_sc_hd__fill_1
XANTENNA__4301__A0 net282 vssd1 vssd1 vccd1 vccd1 sky130_fd_sc_hd__diode_2
XFILLER_73_320 vssd1 vssd1 vccd1 vccd1 sky130_fd_sc_hd__fill_4
XTAP_TAPCELL_ROW_69_890 vssd1 vccd1 sky130_fd_sc_hd__tapvpwrvgnd_1
XFILLER_18_269 vssd1 vssd1 vccd1 vccd1 sky130_fd_sc_hd__fill_1
XFILLER_33_217 vssd1 vssd1 vccd1 vccd1 sky130_fd_sc_hd__fill_2
XANTENNA__6790__A net135 vssd1 vssd1 vccd1 vccd1 sky130_fd_sc_hd__diode_2
XFILLER_26_291 vssd1 vssd1 vccd1 vccd1 sky130_fd_sc_hd__fill_1
XFILLER_14_475 vssd1 vssd1 vccd1 vccd1 sky130_fd_sc_hd__fill_1
XFILLER_41_294 vssd1 vssd1 vccd1 vccd1 sky130_fd_sc_hd__fill_1
XANTENNA__6949__B net65 vssd1 vssd1 vccd1 vccd1 sky130_fd_sc_hd__diode_2
XANTENNA__4756__Y _4034_ vssd1 vssd1 vccd1 vccd1 sky130_fd_sc_hd__diode_2
X_5090_ _0197_ _0279_ vssd1 vssd1 vccd1 vccd1 _0280_ sky130_fd_sc_hd__or2_1
XFILLER_49_350 vccd1 vssd1 vccd1 vssd1 sky130_ef_sc_hd__decap_40_12
XFILLER_49_383 vssd1 vssd1 vccd1 vccd1 sky130_fd_sc_hd__fill_2
X_7800_ _3054_ _3055_ vssd1 vssd1 vccd1 vccd1 _3056_ sky130_fd_sc_hd__and2_1
X_5992_ _1177_ _1179_ _1181_ vssd1 vssd1 vccd1 vccd1 _1182_ sky130_fd_sc_hd__or3b_1
XFILLER_91_194 vssd1 vssd1 vccd1 vccd1 sky130_fd_sc_hd__fill_8
X_7731_ _2981_ _2986_ vssd1 vssd1 vccd1 vccd1 _2987_ sky130_fd_sc_hd__nand2_1
X_4943_ _0131_ _0132_ vssd1 vssd1 vccd1 vccd1 _0133_ sky130_fd_sc_hd__nor2_1
XFILLER_17_291 vccd1 vssd1 vccd1 vssd1 sky130_ef_sc_hd__decap_40_12
X_7662_ _2914_ _2915_ vssd1 vssd1 vccd1 vccd1 _2916_ sky130_fd_sc_hd__nand2_1
XTAP_TAPCELL_ROW_50_705 vssd1 vccd1 sky130_fd_sc_hd__tapvpwrvgnd_1
XFILLER_32_250 vssd1 vssd1 vccd1 vccd1 sky130_fd_sc_hd__fill_2
X_4874_ _4149_ _4150_ _4042_ _4044_ vssd1 vssd1 vccd1 vccd1 _4152_ sky130_fd_sc_hd__o211ai_2
XTAP_TAPCELL_ROW_22_418 vssd1 vccd1 sky130_fd_sc_hd__tapvpwrvgnd_1
XANTENNA__6205__A net104 vssd1 vssd1 vccd1 vccd1 sky130_fd_sc_hd__diode_2
X_6613_ _1802_ _1803_ vssd1 vssd1 vccd1 vccd1 _1804_ sky130_fd_sc_hd__nor2_1
X_7593_ net110 net40 vssd1 vssd1 vccd1 vccd1 _2843_ sky130_fd_sc_hd__nor2_1
Xclkbuf_4_12_0_clk clknet_0_clk vssd1 vssd1 vccd1 vccd1 clknet_4_12_0_clk sky130_fd_sc_hd__clkbuf_8
X_6544_ _1558_ _1570_ _1557_ vssd1 vssd1 vccd1 vccd1 _1731_ sky130_fd_sc_hd__a21o_1
X_6475_ _1441_ _1444_ _1442_ _0736_ vssd1 vssd1 vccd1 vccd1 _1663_ sky130_fd_sc_hd__o2bb2a_1
X_8214_ _3370_ _3372_ _3480_ _3481_ vssd1 vssd1 vccd1 vccd1 _3482_ sky130_fd_sc_hd__a211oi_1
X_5426_ _0591_ _0615_ vssd1 vssd1 vccd1 vccd1 _0616_ sky130_fd_sc_hd__xnor2_1
X_8145_ _3314_ _3315_ _3406_ vssd1 vssd1 vccd1 vccd1 _3409_ sky130_fd_sc_hd__a21o_1
X_5357_ _0472_ _0474_ _0545_ vssd1 vssd1 vccd1 vccd1 _0547_ sky130_fd_sc_hd__a21bo_1
XANTENNA__6875__A net114 vssd1 vssd1 vccd1 vccd1 sky130_fd_sc_hd__diode_2
XFILLER_87_423 vccd1 vssd1 vccd1 vssd1 sky130_ef_sc_hd__decap_40_12
X_8076_ _3331_ _3333_ vssd1 vssd1 vccd1 vccd1 _3334_ sky130_fd_sc_hd__nand2_1
X_4308_ net252 net10 net171 vssd1 vssd1 vccd1 vccd1 _0031_ sky130_fd_sc_hd__mux2_1
X_5288_ net107 net50 vssd1 vssd1 vccd1 vccd1 _0478_ sky130_fd_sc_hd__nor2_1
XFILLER_87_478 vssd1 vssd1 vccd1 vccd1 sky130_fd_sc_hd__fill_8
X_7027_ _1921_ _1924_ _1920_ vssd1 vssd1 vccd1 vccd1 _2245_ sky130_fd_sc_hd__o21ba_1
XANTENNA_fanout282_X net282 vssd1 vssd1 vccd1 vccd1 sky130_fd_sc_hd__diode_2
X_4239_ PID_INST.k3_calc.timescaling_term\[11\] net169 vssd1 vssd1 vccd1 vccd1 _2569_
+ sky130_fd_sc_hd__or2_1
XFILLER_74_139 vssd1 vssd1 vccd1 vccd1 sky130_fd_sc_hd__fill_1
XFILLER_67_180 vssd1 vssd1 vccd1 vccd1 sky130_fd_sc_hd__fill_4
XFILLER_55_331 vssd1 vssd1 vccd1 vccd1 sky130_fd_sc_hd__fill_4
XFILLER_55_320 vssd1 vssd1 vccd1 vccd1 sky130_fd_sc_hd__fill_8
XFILLER_28_567 vssd1 vssd1 vccd1 vccd1 sky130_fd_sc_hd__fill_2
XTAP_TAPCELL_ROW_66_860 vssd1 vccd1 sky130_fd_sc_hd__tapvpwrvgnd_1
X_7929_ _3183_ _3182_ vssd1 vssd1 vccd1 vccd1 _3184_ sky130_fd_sc_hd__nand2b_1
XTAP_TAPCELL_ROW_38_584 vssd1 vccd1 sky130_fd_sc_hd__tapvpwrvgnd_1
XFILLER_90_26 vssd1 vssd1 vccd1 vccd1 sky130_fd_sc_hd__fill_2
XFILLER_23_250 vssd1 vssd1 vccd1 vccd1 sky130_fd_sc_hd__fill_8
XANTENNA__6339__A1 net163 vssd1 vssd1 vccd1 vccd1 sky130_fd_sc_hd__diode_2
XANTENNA__6339__B2 net162 vssd1 vssd1 vccd1 vccd1 sky130_fd_sc_hd__diode_2
XFILLER_11_412 vssd1 vssd1 vccd1 vccd1 sky130_fd_sc_hd__fill_2
XANTENNA__6115__A net109 vssd1 vssd1 vccd1 vccd1 sky130_fd_sc_hd__diode_2
XANTENNA__4522__B1 net85 vssd1 vssd1 vccd1 vccd1 sky130_fd_sc_hd__diode_2
XFILLER_48_61 vccd1 vssd1 vccd1 vssd1 sky130_ef_sc_hd__decap_40_12
XFILLER_78_489 vssd1 vssd1 vccd1 vccd1 sky130_fd_sc_hd__fill_4
XFILLER_19_501 vssd1 vssd1 vccd1 vccd1 sky130_fd_sc_hd__fill_2
XANTENNA_input10_X net10 vssd1 vssd1 vccd1 vccd1 sky130_fd_sc_hd__diode_2
XFILLER_80_109 vssd1 vssd1 vccd1 vccd1 sky130_fd_sc_hd__fill_2
XFILLER_0_57 vssd1 vssd1 vccd1 vccd1 sky130_fd_sc_hd__fill_8
XFILLER_73_183 vssd1 vssd1 vccd1 vccd1 sky130_fd_sc_hd__fill_1
XFILLER_64_60 vssd1 vssd1 vccd1 vccd1 sky130_fd_sc_hd__fill_1
XFILLER_61_345 vssd1 vssd1 vccd1 vccd1 sky130_fd_sc_hd__fill_2
XFILLER_34_537 vssd1 vssd1 vccd1 vccd1 sky130_fd_sc_hd__fill_1
XFILLER_61_356 vssd1 vssd1 vccd1 vccd1 sky130_fd_sc_hd__fill_2
XFILLER_9_11 vssd1 vssd1 vccd1 vccd1 sky130_fd_sc_hd__fill_2
XFILLER_9_44 vssd1 vssd1 vccd1 vccd1 sky130_fd_sc_hd__fill_1
XFILLER_9_55 vssd1 vssd1 vccd1 vccd1 sky130_fd_sc_hd__fill_1
X_4590_ _3864_ _3867_ vssd1 vssd1 vccd1 vccd1 _3868_ sky130_fd_sc_hd__or2_1
X_6260_ net216 net295 vssd1 vssd1 vccd1 vccd1 _1449_ sky130_fd_sc_hd__nand2_1
X_5211_ _0220_ net57 _0224_ _0300_ _0399_ vssd1 vssd1 vccd1 vccd1 _0401_ sky130_fd_sc_hd__o311a_1
X_6191_ _1378_ _1379_ vssd1 vssd1 vccd1 vccd1 _1380_ sky130_fd_sc_hd__nor2_1
X_5142_ _0248_ _0256_ _0255_ vssd1 vssd1 vccd1 vccd1 _0332_ sky130_fd_sc_hd__a21bo_1
XANTENNA__4816__A1 _4001_ vssd1 vssd1 vccd1 vccd1 sky130_fd_sc_hd__diode_2
X_5073_ _0261_ _0262_ vssd1 vssd1 vccd1 vccd1 _0263_ sky130_fd_sc_hd__xor2_1
XANTENNA__7797__Y _3053_ vssd1 vssd1 vccd1 vccd1 sky130_fd_sc_hd__diode_2
XFILLER_71_109 vssd1 vssd1 vccd1 vccd1 sky130_fd_sc_hd__fill_2
XFILLER_64_183 vccd1 vssd1 vccd1 vssd1 sky130_ef_sc_hd__decap_40_12
XTAP_TAPCELL_ROW_63_830 vssd1 vccd1 sky130_fd_sc_hd__tapvpwrvgnd_1
XFILLER_52_345 vccd1 vssd1 vccd1 vssd1 sky130_ef_sc_hd__decap_40_12
XTAP_TAPCELL_ROW_35_554 vssd1 vccd1 sky130_fd_sc_hd__tapvpwrvgnd_1
X_5975_ _1163_ _1164_ vssd1 vssd1 vccd1 vccd1 _1165_ sky130_fd_sc_hd__xor2_1
XANTENNA_fanout242_A PID_INST.k2_calc.sum_reg\[2\] vssd1 vssd1 vccd1 vccd1 sky130_fd_sc_hd__diode_2
X_7714_ _2816_ _2970_ vssd1 vssd1 vccd1 vccd1 _2971_ sky130_fd_sc_hd__or2_1
X_4926_ net137 net144 _0113_ _0115_ vssd1 vssd1 vccd1 vccd1 _0116_ sky130_fd_sc_hd__and4_1
X_7645_ _2891_ _2896_ vssd1 vssd1 vccd1 vccd1 _2898_ sky130_fd_sc_hd__or2_1
X_4857_ net133 net88 _4064_ vssd1 vssd1 vccd1 vccd1 _4135_ sky130_fd_sc_hd__and3_1
XFILLER_20_253 vccd1 vssd1 vccd1 vssd1 sky130_ef_sc_hd__decap_40_12
XFILLER_20_275 vccd1 vssd1 vccd1 vssd1 sky130_ef_sc_hd__decap_40_12
X_7576_ _2821_ _2822_ vssd1 vssd1 vccd1 vccd1 _2825_ sky130_fd_sc_hd__xnor2_1
X_6527_ _1544_ _1553_ _1712_ vssd1 vssd1 vccd1 vccd1 _1714_ sky130_fd_sc_hd__or3_1
X_4788_ _3974_ _4064_ _4065_ vssd1 vssd1 vccd1 vccd1 _4066_ sky130_fd_sc_hd__a21o_1
X_6458_ net223 net284 net279 net228 vssd1 vssd1 vccd1 vccd1 _1646_ sky130_fd_sc_hd__a22oi_1
XFILLER_69_16 vssd1 vssd1 vccd1 vccd1 sky130_fd_sc_hd__fill_2
X_5409_ _0583_ _0598_ vssd1 vssd1 vccd1 vccd1 _0599_ sky130_fd_sc_hd__or2_1
X_6389_ _1383_ _1386_ vssd1 vssd1 vccd1 vccd1 _1577_ sky130_fd_sc_hd__nand2_1
X_8128_ net286 net186 vssd1 vssd1 vccd1 vccd1 _3390_ sky130_fd_sc_hd__nand2_1
XFILLER_87_242 vssd1 vssd1 vccd1 vccd1 sky130_fd_sc_hd__fill_1
XTAP_TAPCELL_ROW_7_268 vssd1 vccd1 sky130_fd_sc_hd__tapvpwrvgnd_1
XANTENNA_input2_X net2 vssd1 vssd1 vccd1 vccd1 sky130_fd_sc_hd__diode_2
XANTENNA__4837__B _3774_ vssd1 vssd1 vccd1 vccd1 sky130_fd_sc_hd__diode_2
X_8059_ _3169_ _3175_ _3313_ vssd1 vssd1 vccd1 vccd1 _3315_ sky130_fd_sc_hd__nand3_1
XFILLER_18_31 vssd1 vssd1 vccd1 vccd1 sky130_fd_sc_hd__fill_1
XFILLER_18_42 vssd1 vssd1 vccd1 vccd1 sky130_fd_sc_hd__fill_1
XFILLER_90_429 vssd1 vssd1 vccd1 vccd1 sky130_fd_sc_hd__fill_2
XFILLER_55_161 vssd1 vssd1 vccd1 vccd1 sky130_fd_sc_hd__fill_4
XFILLER_55_150 vssd1 vssd1 vccd1 vccd1 sky130_fd_sc_hd__fill_4
XFILLER_28_375 vssd1 vssd1 vccd1 vccd1 sky130_fd_sc_hd__fill_4
XTAP_TAPCELL_ROW_87_1073 vssd1 vccd1 sky130_fd_sc_hd__tapvpwrvgnd_1
XFILLER_83_481 vccd1 vssd1 vccd1 vssd1 sky130_ef_sc_hd__decap_40_12
XFILLER_16_537 vssd1 vssd1 vccd1 vccd1 sky130_fd_sc_hd__fill_2
XFILLER_28_386 vssd1 vssd1 vccd1 vccd1 sky130_fd_sc_hd__fill_2
XFILLER_43_378 vccd1 vssd1 vccd1 vssd1 sky130_ef_sc_hd__decap_40_12
XFILLER_34_74 vssd1 vssd1 vccd1 vccd1 sky130_fd_sc_hd__fill_2
XFILLER_34_85 vssd1 vssd1 vccd1 vccd1 sky130_fd_sc_hd__fill_4
XFILLER_34_96 vssd1 vssd1 vccd1 vccd1 sky130_fd_sc_hd__fill_4
XFILLER_7_202 vssd1 vssd1 vccd1 vccd1 sky130_fd_sc_hd__fill_1
XFILLER_50_40 vssd1 vssd1 vccd1 vccd1 sky130_fd_sc_hd__fill_2
XFILLER_50_73 vssd1 vssd1 vccd1 vccd1 sky130_fd_sc_hd__fill_8
XANTENNA__8237__A1 net322 vssd1 vssd1 vccd1 vccd1 sky130_fd_sc_hd__diode_2
XFILLER_59_71 vssd1 vssd1 vccd1 vccd1 sky130_fd_sc_hd__fill_1
XFILLER_78_286 vssd1 vssd1 vccd1 vccd1 sky130_fd_sc_hd__fill_4
XFILLER_66_404 vssd1 vssd1 vccd1 vccd1 sky130_fd_sc_hd__fill_1
XFILLER_38_117 vssd1 vssd1 vccd1 vccd1 sky130_fd_sc_hd__fill_1
XFILLER_38_128 vssd1 vssd1 vccd1 vccd1 sky130_fd_sc_hd__fill_1
XTAP_TAPCELL_ROW_77_966 vssd1 vccd1 sky130_fd_sc_hd__tapvpwrvgnd_1
XFILLER_19_331 vssd1 vssd1 vccd1 vccd1 sky130_fd_sc_hd__fill_4
XANTENNA__8235__A net322 vssd1 vssd1 vccd1 vccd1 sky130_fd_sc_hd__diode_2
XFILLER_75_81 vssd1 vssd1 vccd1 vccd1 sky130_fd_sc_hd__fill_2
XFILLER_74_492 vssd1 vssd1 vccd1 vccd1 sky130_fd_sc_hd__fill_1
X_5760_ _0938_ _0949_ _0932_ vssd1 vssd1 vccd1 vccd1 _0950_ sky130_fd_sc_hd__a21oi_1
XTAP_TAPCELL_ROW_60_800 vssd1 vccd1 sky130_fd_sc_hd__tapvpwrvgnd_1
XFILLER_34_389 vssd1 vssd1 vccd1 vccd1 sky130_fd_sc_hd__fill_2
X_5691_ _0855_ _0857_ _0875_ _0879_ vssd1 vssd1 vccd1 vccd1 _0881_ sky130_fd_sc_hd__a211oi_1
X_4711_ _3987_ _3988_ vssd1 vssd1 vccd1 vccd1 _3989_ sky130_fd_sc_hd__and2_1
XTAP_TAPCELL_ROW_32_524 vssd1 vccd1 sky130_fd_sc_hd__tapvpwrvgnd_1
X_7430_ _2582_ _2584_ _2581_ vssd1 vssd1 vccd1 vccd1 _2670_ sky130_fd_sc_hd__o21ba_1
X_4642_ net124 net152 net150 net122 vssd1 vssd1 vccd1 vccd1 _3920_ sky130_fd_sc_hd__a22o_1
XANTENNA__6723__A1 net199 vssd1 vssd1 vccd1 vccd1 sky130_fd_sc_hd__diode_2
X_7361_ net225 net213 net275 net262 vssd1 vssd1 vccd1 vccd1 _2597_ sky130_fd_sc_hd__and4_1
X_4573_ _3844_ _3846_ _3850_ vssd1 vssd1 vccd1 vccd1 _3851_ sky130_fd_sc_hd__a21oi_1
X_6312_ net97 net55 vssd1 vssd1 vccd1 vccd1 _1500_ sky130_fd_sc_hd__nor2_1
X_7292_ _2512_ _2522_ vssd1 vssd1 vccd1 vccd1 _2524_ sky130_fd_sc_hd__xnor2_1
X_6243_ _1430_ _1431_ vssd1 vssd1 vccd1 vccd1 _1432_ sky130_fd_sc_hd__xnor2_1
X_6174_ _1361_ _1362_ vssd1 vssd1 vccd1 vccd1 _1363_ sky130_fd_sc_hd__or2_1
XANTENNA_fanout192_A net193 vssd1 vssd1 vccd1 vccd1 sky130_fd_sc_hd__diode_2
XTAP_TAPCELL_ROW_4_238 vssd1 vccd1 sky130_fd_sc_hd__tapvpwrvgnd_1
X_5125_ net116 net61 _0313_ vssd1 vssd1 vccd1 vccd1 _0315_ sky130_fd_sc_hd__or3_1
XFILLER_57_437 vssd1 vssd1 vccd1 vccd1 sky130_fd_sc_hd__fill_2
X_5056_ _0245_ _0232_ vssd1 vssd1 vccd1 vccd1 _0246_ sky130_fd_sc_hd__nand2b_1
XFILLER_65_470 vssd1 vssd1 vccd1 vccd1 sky130_fd_sc_hd__fill_2
XANTENNA__4392__B net9 vssd1 vssd1 vccd1 vccd1 sky130_fd_sc_hd__diode_2
XFILLER_13_507 vssd1 vssd1 vccd1 vccd1 sky130_fd_sc_hd__fill_1
XFILLER_37_194 vssd1 vssd1 vccd1 vccd1 sky130_fd_sc_hd__fill_1
XFILLER_80_495 vssd1 vssd1 vccd1 vccd1 sky130_fd_sc_hd__fill_8
XFILLER_71_17 vssd1 vssd1 vccd1 vccd1 sky130_fd_sc_hd__fill_2
X_5958_ _1987_ net74 vssd1 vssd1 vccd1 vccd1 _1148_ sky130_fd_sc_hd__nor2_1
XFILLER_40_315 vssd1 vssd1 vccd1 vccd1 sky130_fd_sc_hd__fill_4
X_4909_ _0098_ _0080_ vssd1 vssd1 vccd1 vccd1 _0099_ sky130_fd_sc_hd__and2b_1
XFILLER_40_337 vssd1 vssd1 vccd1 vccd1 sky130_fd_sc_hd__fill_1
X_5889_ net241 net325 vssd1 vssd1 vccd1 vccd1 _1079_ sky130_fd_sc_hd__and2b_1
X_7628_ _2879_ vssd1 vssd1 vccd1 vccd1 _2880_ sky130_fd_sc_hd__inv_2
X_7559_ _2805_ _2806_ vssd1 vssd1 vccd1 vccd1 _2807_ sky130_fd_sc_hd__nand2b_1
XFILLER_4_227 vssd1 vssd1 vccd1 vccd1 sky130_fd_sc_hd__fill_2
XANTENNA__8413__CLK clknet_4_0_0_clk vssd1 vssd1 vccd1 vccd1 sky130_fd_sc_hd__diode_2
XFILLER_20_76 vssd1 vssd1 vccd1 vccd1 sky130_fd_sc_hd__fill_8
XANTENNA__7224__A net140 vssd1 vssd1 vccd1 vccd1 sky130_fd_sc_hd__diode_2
Xhold30 net35 vssd1 vssd1 vccd1 vccd1 net423 sky130_fd_sc_hd__dlygate4sd3_1
XFILLER_0_488 vssd1 vssd1 vccd1 vccd1 sky130_fd_sc_hd__fill_1
XPHY_EDGE_ROW_11_Left_104 vssd1 vssd1 vccd1 vccd1 sky130_fd_sc_hd__decap_3
XANTENNA_input18_A gpio_in[8] vssd1 vssd1 vccd1 vccd1 sky130_fd_sc_hd__diode_2
XTAP_TAPCELL_ROW_74_936 vssd1 vccd1 sky130_fd_sc_hd__tapvpwrvgnd_1
XFILLER_56_492 vssd1 vssd1 vccd1 vccd1 sky130_fd_sc_hd__fill_2
XFILLER_56_481 vssd1 vssd1 vccd1 vccd1 sky130_fd_sc_hd__fill_1
XFILLER_16_334 vssd1 vssd1 vccd1 vccd1 sky130_fd_sc_hd__fill_8
XFILLER_71_495 vssd1 vssd1 vccd1 vccd1 sky130_fd_sc_hd__fill_8
XFILLER_31_315 vssd1 vssd1 vccd1 vccd1 sky130_fd_sc_hd__fill_1
XFILLER_43_197 vssd1 vssd1 vccd1 vccd1 sky130_fd_sc_hd__fill_1
XFILLER_77_8 vssd1 vssd1 vccd1 vccd1 sky130_fd_sc_hd__fill_1
XFILLER_8_544 vccd1 vssd1 vccd1 vssd1 sky130_ef_sc_hd__decap_40_12
XFILLER_8_533 vssd1 vssd1 vccd1 vccd1 sky130_fd_sc_hd__fill_4
XPHY_EDGE_ROW_20_Left_113 vssd1 vssd1 vccd1 vccd1 sky130_fd_sc_hd__decap_3
XANTENNA__7134__A net208 vssd1 vssd1 vccd1 vccd1 sky130_fd_sc_hd__diode_2
XFILLER_79_540 vccd1 vssd1 vccd1 vssd1 sky130_ef_sc_hd__decap_40_12
XANTENNA__5580__C net291 vssd1 vssd1 vccd1 vccd1 sky130_fd_sc_hd__diode_2
XFILLER_86_80 vssd1 vssd1 vccd1 vccd1 sky130_fd_sc_hd__fill_4
XANTENNA__7433__A2 net188 vssd1 vssd1 vccd1 vccd1 sky130_fd_sc_hd__diode_2
XFILLER_66_223 vssd1 vssd1 vccd1 vccd1 sky130_fd_sc_hd__fill_4
XFILLER_39_437 vssd1 vssd1 vccd1 vccd1 sky130_fd_sc_hd__fill_8
XFILLER_66_267 vssd1 vssd1 vccd1 vccd1 sky130_fd_sc_hd__fill_4
XFILLER_54_418 vssd1 vssd1 vccd1 vccd1 sky130_fd_sc_hd__fill_2
XTAP_TAPCELL_ROW_1_208 vssd1 vccd1 sky130_fd_sc_hd__tapvpwrvgnd_1
X_6930_ _2139_ _2140_ vssd1 vssd1 vccd1 vccd1 _2141_ sky130_fd_sc_hd__xnor2_1
XFILLER_47_481 vssd1 vssd1 vccd1 vccd1 sky130_fd_sc_hd__fill_2
XFILLER_81_259 vssd1 vssd1 vccd1 vccd1 sky130_fd_sc_hd__fill_2
X_6861_ _2062_ _2067_ vssd1 vssd1 vccd1 vccd1 _2068_ sky130_fd_sc_hd__xnor2_1
X_5812_ _0993_ _0997_ _0995_ vssd1 vssd1 vccd1 vccd1 _1002_ sky130_fd_sc_hd__o21ba_1
X_6792_ _1717_ _1993_ _1994_ vssd1 vssd1 vccd1 vccd1 _1995_ sky130_fd_sc_hd__o21bai_1
X_5743_ net318 net229 vssd1 vssd1 vccd1 vccd1 _0933_ sky130_fd_sc_hd__nand2_1
XTAP_TAPCELL_ROW_17_373 vssd1 vccd1 sky130_fd_sc_hd__tapvpwrvgnd_1
XFILLER_22_326 vssd1 vssd1 vccd1 vccd1 sky130_fd_sc_hd__fill_1
XFILLER_34_197 vccd1 vssd1 vccd1 vssd1 sky130_ef_sc_hd__decap_40_12
X_5674_ _0861_ _0863_ vssd1 vssd1 vccd1 vccd1 _0864_ sky130_fd_sc_hd__or2_1
X_8462_ clknet_4_7_0_clk _0050_ net334 vssd1 vssd1 vccd1 vccd1 PID_INST.k2_calc.sum_reg\[18\]
+ sky130_fd_sc_hd__dfrtp_1
X_7413_ net264 net214 net209 net268 vssd1 vssd1 vccd1 vccd1 _2652_ sky130_fd_sc_hd__a22oi_1
X_8393_ clknet_4_9_0_clk PID_INST.k3_calc.d2.y\[13\] net329 vssd1 vssd1 vccd1 vccd1
+ PID_INST.k3_calc.timescaling_term\[13\] sky130_fd_sc_hd__dfrtp_1
X_4625_ _3880_ _3884_ _3902_ vssd1 vssd1 vccd1 vccd1 _3903_ sky130_fd_sc_hd__and3_1
X_7344_ _2323_ _2326_ _2324_ vssd1 vssd1 vccd1 vccd1 _2579_ sky130_fd_sc_hd__o21ba_1
X_4556_ net121 net81 net78 net113 vssd1 vssd1 vccd1 vccd1 _3834_ sky130_fd_sc_hd__a22o_1
XANTENNA_fanout205_A net206 vssd1 vssd1 vccd1 vccd1 sky130_fd_sc_hd__diode_2
XANTENNA__6867__B net50 vssd1 vssd1 vccd1 vccd1 sky130_fd_sc_hd__diode_2
XFILLER_89_337 vccd1 vssd1 vccd1 vssd1 sky130_ef_sc_hd__decap_40_12
XANTENNA__7044__A net221 vssd1 vssd1 vccd1 vccd1 sky130_fd_sc_hd__diode_2
X_7275_ _2501_ _2504_ vssd1 vssd1 vccd1 vccd1 _2506_ sky130_fd_sc_hd__nor2_1
X_4487_ _3729_ _3730_ _3751_ _3763_ _3716_ vssd1 vssd1 vccd1 vccd1 _3765_ sky130_fd_sc_hd__o2111a_1
X_6226_ net324 net195 vssd1 vssd1 vccd1 vccd1 _1415_ sky130_fd_sc_hd__nand2_1
XANTENNA__4387__B net8 vssd1 vssd1 vccd1 vccd1 sky130_fd_sc_hd__diode_2
X_6157_ _1339_ _1344_ vssd1 vssd1 vccd1 vccd1 _1346_ sky130_fd_sc_hd__nand2_1
XANTENNA_fanout195_X net195 vssd1 vssd1 vccd1 vccd1 sky130_fd_sc_hd__diode_2
XFILLER_57_223 vssd1 vssd1 vccd1 vccd1 sky130_fd_sc_hd__fill_1
Xteam_03_349 vssd1 vssd1 vccd1 vccd1 team_03_349/HI gpio_oeb[25] sky130_fd_sc_hd__conb_1
X_5108_ _0212_ _0213_ _0215_ _0216_ _0149_ vssd1 vssd1 vccd1 vccd1 _0298_ sky130_fd_sc_hd__a32oi_4
X_6088_ _1275_ _1276_ _0853_ _0856_ vssd1 vssd1 vccd1 vccd1 _1278_ sky130_fd_sc_hd__a211oi_1
XFILLER_45_418 vssd1 vssd1 vccd1 vccd1 sky130_fd_sc_hd__fill_1
XFILLER_72_215 vssd1 vssd1 vccd1 vccd1 sky130_fd_sc_hd__fill_1
X_5039_ net114 net54 vssd1 vssd1 vccd1 vccd1 _0229_ sky130_fd_sc_hd__nor2_1
XTAP_TAPCELL_ROW_84_1043 vssd1 vccd1 sky130_fd_sc_hd__tapvpwrvgnd_1
XTAP_TAPCELL_ROW_71_906 vssd1 vccd1 sky130_fd_sc_hd__tapvpwrvgnd_1
XFILLER_25_120 vssd1 vssd1 vccd1 vccd1 sky130_fd_sc_hd__fill_2
XFILLER_40_101 vssd1 vssd1 vccd1 vccd1 sky130_fd_sc_hd__fill_1
XFILLER_13_348 vssd1 vssd1 vccd1 vccd1 sky130_fd_sc_hd__fill_4
XANTENNA__7360__A1 net212 vssd1 vssd1 vccd1 vccd1 sky130_fd_sc_hd__diode_2
XFILLER_5_503 vssd1 vssd1 vccd1 vccd1 sky130_fd_sc_hd__fill_1
XANTENNA__7360__B2 net225 vssd1 vssd1 vccd1 vccd1 sky130_fd_sc_hd__diode_2
XANTENNA__4174__A1 net19 vssd1 vssd1 vccd1 vccd1 sky130_fd_sc_hd__diode_2
XFILLER_5_558 vssd1 vssd1 vccd1 vccd1 sky130_fd_sc_hd__fill_2
Xoutput31 net31 vssd1 vssd1 vccd1 vccd1 gpio_out[28] sky130_fd_sc_hd__buf_2
XANTENNA__6793__A net132 vssd1 vssd1 vccd1 vccd1 sky130_fd_sc_hd__diode_2
XFILLER_48_212 vssd1 vssd1 vccd1 vccd1 sky130_fd_sc_hd__fill_2
XFILLER_91_535 vccd1 vssd1 vccd1 vssd1 sky130_ef_sc_hd__decap_40_12
XFILLER_63_237 vssd1 vssd1 vccd1 vccd1 sky130_fd_sc_hd__fill_4
XFILLER_56_83 vssd1 vssd1 vccd1 vccd1 sky130_fd_sc_hd__fill_1
XFILLER_29_470 vccd1 vssd1 vccd1 vssd1 sky130_ef_sc_hd__decap_40_12
XFILLER_44_440 vccd1 vssd1 vccd1 vssd1 sky130_ef_sc_hd__decap_40_12
XFILLER_16_131 vssd1 vssd1 vccd1 vccd1 sky130_fd_sc_hd__fill_1
XFILLER_16_197 vssd1 vssd1 vccd1 vccd1 sky130_fd_sc_hd__fill_1
XTAP_TAPCELL_ROW_14_343 vssd1 vccd1 sky130_fd_sc_hd__tapvpwrvgnd_1
XANTENNA__4937__B1 net84 vssd1 vssd1 vccd1 vccd1 sky130_fd_sc_hd__diode_2
XFILLER_31_145 vssd1 vssd1 vccd1 vccd1 sky130_fd_sc_hd__fill_1
XFILLER_82_6 vccd1 vssd1 vccd1 vssd1 sky130_ef_sc_hd__decap_40_12
XANTENNA__6968__A net109 vssd1 vssd1 vccd1 vccd1 sky130_fd_sc_hd__diode_2
X_4410_ net187 _3696_ vssd1 vssd1 vccd1 vccd1 _3699_ sky130_fd_sc_hd__nor2_1
X_5390_ _0578_ _0557_ vssd1 vssd1 vccd1 vccd1 _0580_ sky130_fd_sc_hd__xor2_1
X_4341_ net226 net18 vssd1 vssd1 vccd1 vccd1 _3633_ sky130_fd_sc_hd__and2_1
X_7060_ _2278_ _2279_ vssd1 vssd1 vccd1 vccd1 _2280_ sky130_fd_sc_hd__nand2_1
Xfanout309 PID_INST.k2_calc.reg_lc\[3\] vssd1 vssd1 vccd1 vccd1 net309 sky130_fd_sc_hd__clkbuf_2
X_4272_ _1773_ _1838_ net172 vssd1 vssd1 vccd1 vccd1 PID_INST.pid.next_state\[3\]
+ sky130_fd_sc_hd__a21o_1
X_6011_ _0327_ _0556_ _0326_ vssd1 vssd1 vccd1 vccd1 _1201_ sky130_fd_sc_hd__a21oi_1
XANTENNA__7799__A net92 vssd1 vssd1 vccd1 vccd1 sky130_fd_sc_hd__diode_2
XFILLER_39_201 vssd1 vssd1 vccd1 vccd1 sky130_fd_sc_hd__fill_2
XFILLER_67_521 vssd1 vssd1 vccd1 vccd1 sky130_fd_sc_hd__fill_1
XFILLER_82_502 vssd1 vssd1 vccd1 vccd1 sky130_fd_sc_hd__fill_2
XANTENNA__4935__B net84 vssd1 vssd1 vccd1 vccd1 sky130_fd_sc_hd__diode_2
X_7962_ _3215_ _3216_ vssd1 vssd1 vccd1 vccd1 _3217_ sky130_fd_sc_hd__xnor2_1
X_6913_ _1923_ _4101_ vssd1 vssd1 vccd1 vccd1 _2123_ sky130_fd_sc_hd__nor2_1
X_7893_ _3073_ _3084_ _3072_ vssd1 vssd1 vccd1 vccd1 _3148_ sky130_fd_sc_hd__a21oi_1
XFILLER_35_484 vssd1 vssd1 vccd1 vccd1 sky130_fd_sc_hd__fill_2
XANTENNA_fanout155_A net156 vssd1 vssd1 vccd1 vccd1 sky130_fd_sc_hd__diode_2
XFILLER_50_410 vssd1 vssd1 vccd1 vccd1 sky130_fd_sc_hd__fill_1
XFILLER_22_134 vssd1 vssd1 vccd1 vccd1 sky130_fd_sc_hd__fill_2
X_6844_ _2049_ _1989_ vssd1 vssd1 vccd1 vccd1 _2050_ sky130_fd_sc_hd__nand2b_1
X_6775_ _1973_ _1974_ _1975_ vssd1 vssd1 vccd1 vccd1 _1977_ sky130_fd_sc_hd__and3_1
XFILLER_10_307 vssd1 vssd1 vccd1 vccd1 sky130_fd_sc_hd__fill_1
XFILLER_22_145 vssd1 vssd1 vccd1 vccd1 sky130_fd_sc_hd__fill_1
X_5726_ _0903_ _0915_ _0874_ _0885_ vssd1 vssd1 vccd1 vccd1 _0916_ sky130_fd_sc_hd__a211oi_2
XFILLER_10_329 vccd1 vssd1 vccd1 vssd1 sky130_ef_sc_hd__decap_40_12
X_8445_ clknet_4_13_0_clk _0033_ net337 vssd1 vssd1 vccd1 vccd1 PID_INST.k2_calc.sum_reg\[1\]
+ sky130_fd_sc_hd__dfrtp_1
X_5657_ _0838_ _0846_ vssd1 vssd1 vccd1 vccd1 _0847_ sky130_fd_sc_hd__nand2b_1
XANTENNA_fanout110_X net110 vssd1 vssd1 vccd1 vccd1 sky130_fd_sc_hd__diode_2
XANTENNA_fanout208_X net208 vssd1 vssd1 vccd1 vccd1 sky130_fd_sc_hd__diode_2
X_5588_ _0774_ _0777_ vssd1 vssd1 vccd1 vccd1 _0778_ sky130_fd_sc_hd__xnor2_1
X_8376_ clknet_4_4_0_clk _0012_ net331 vssd1 vssd1 vccd1 vccd1 PID_INST.k1_calc.d1.x\[12\]
+ sky130_fd_sc_hd__dfrtp_1
X_4608_ net122 net88 _3864_ _3865_ vssd1 vssd1 vccd1 vccd1 _3886_ sky130_fd_sc_hd__o2bb2a_1
X_7327_ _2559_ _2560_ vssd1 vssd1 vccd1 vccd1 _2561_ sky130_fd_sc_hd__nor2_1
X_4539_ net126 net86 _3737_ _3816_ vssd1 vssd1 vccd1 vccd1 _3817_ sky130_fd_sc_hd__a31o_1
X_7258_ net93 net55 vssd1 vssd1 vccd1 vccd1 _2488_ sky130_fd_sc_hd__nor2_1
XFILLER_89_167 vssd1 vssd1 vccd1 vccd1 sky130_fd_sc_hd__fill_1
X_6209_ _1394_ _1397_ vssd1 vssd1 vccd1 vccd1 _1398_ sky130_fd_sc_hd__xnor2_1
X_7189_ _2402_ _2413_ vssd1 vssd1 vccd1 vccd1 _2415_ sky130_fd_sc_hd__xnor2_1
XFILLER_45_215 vssd1 vssd1 vccd1 vccd1 sky130_fd_sc_hd__fill_8
XANTENNA__6118__A net118 vssd1 vssd1 vccd1 vccd1 sky130_fd_sc_hd__diode_2
XFILLER_26_53 vssd1 vssd1 vccd1 vccd1 sky130_fd_sc_hd__fill_1
XTAP_TAPCELL_ROW_28_479 vssd1 vccd1 sky130_fd_sc_hd__tapvpwrvgnd_1
XANTENNA__7030__B1 net190 vssd1 vssd1 vccd1 vccd1 sky130_fd_sc_hd__diode_2
XFILLER_13_101 vssd1 vssd1 vccd1 vccd1 sky130_fd_sc_hd__fill_2
XFILLER_41_410 vccd1 vssd1 vccd1 vssd1 sky130_ef_sc_hd__decap_40_12
XFILLER_13_167 vssd1 vssd1 vccd1 vccd1 sky130_fd_sc_hd__fill_1
XTAP_TAPCELL_ROW_11_313 vssd1 vccd1 sky130_fd_sc_hd__tapvpwrvgnd_1
XANTENNA__7333__B2 net230 vssd1 vssd1 vccd1 vccd1 sky130_fd_sc_hd__diode_2
XANTENNA__7333__A1 net226 vssd1 vssd1 vccd1 vccd1 sky130_fd_sc_hd__diode_2
XFILLER_5_322 vccd1 vssd1 vccd1 vssd1 sky130_ef_sc_hd__decap_40_12
XFILLER_5_344 vccd1 vssd1 vccd1 vssd1 sky130_ef_sc_hd__decap_40_12
XFILLER_3_24 vccd1 vssd1 vccd1 vssd1 sky130_ef_sc_hd__decap_40_12
XFILLER_1_561 vssd1 vssd1 vccd1 vccd1 sky130_fd_sc_hd__fill_4
XFILLER_3_68 vssd1 vssd1 vccd1 vccd1 sky130_fd_sc_hd__fill_1
XFILLER_83_70 vssd1 vssd1 vccd1 vccd1 sky130_fd_sc_hd__fill_8
XFILLER_17_473 vssd1 vssd1 vccd1 vccd1 sky130_fd_sc_hd__fill_2
XFILLER_44_281 vssd1 vssd1 vccd1 vccd1 sky130_fd_sc_hd__fill_4
X_4890_ _4119_ _4120_ _4122_ vssd1 vssd1 vccd1 vccd1 _0080_ sky130_fd_sc_hd__o21ai_1
XFILLER_32_421 vssd1 vssd1 vccd1 vccd1 sky130_fd_sc_hd__fill_2
XFILLER_32_454 vssd1 vssd1 vccd1 vccd1 sky130_fd_sc_hd__fill_1
X_6560_ _1585_ _1746_ vssd1 vssd1 vccd1 vccd1 _1747_ sky130_fd_sc_hd__xor2_1
X_5511_ net231 net295 vssd1 vssd1 vccd1 vccd1 _0701_ sky130_fd_sc_hd__nand2_1
XANTENNA__7009__D net229 vssd1 vssd1 vccd1 vccd1 sky130_fd_sc_hd__diode_2
X_6491_ _1677_ _1678_ vssd1 vssd1 vccd1 vccd1 _1679_ sky130_fd_sc_hd__nor2_1
XFILLER_8_160 vssd1 vssd1 vccd1 vccd1 sky130_fd_sc_hd__fill_2
XANTENNA__6127__A2 net51 vssd1 vssd1 vccd1 vccd1 sky130_fd_sc_hd__diode_2
X_8230_ net317 net178 vssd1 vssd1 vccd1 vccd1 _3499_ sky130_fd_sc_hd__nand2_1
XFILLER_8_193 vssd1 vssd1 vccd1 vccd1 sky130_fd_sc_hd__fill_2
X_5442_ _0627_ _0630_ vssd1 vssd1 vccd1 vccd1 _0632_ sky130_fd_sc_hd__and2_1
X_8161_ _3417_ _3424_ vssd1 vssd1 vccd1 vccd1 _3425_ sky130_fd_sc_hd__xnor2_1
X_5373_ _0559_ _0562_ vssd1 vssd1 vccd1 vccd1 _0563_ sky130_fd_sc_hd__or2_1
X_8092_ _3335_ _3336_ _3350_ vssd1 vssd1 vccd1 vccd1 _3351_ sky130_fd_sc_hd__nand3_1
X_7112_ _2248_ _2250_ _2247_ vssd1 vssd1 vccd1 vccd1 _2333_ sky130_fd_sc_hd__o21ba_1
X_4324_ _3397_ _3418_ net15 vssd1 vssd1 vccd1 vccd1 _3450_ sky130_fd_sc_hd__o21a_1
X_7043_ _1941_ _1950_ _1949_ vssd1 vssd1 vccd1 vccd1 _2261_ sky130_fd_sc_hd__a21oi_1
Xfanout128 net129 vssd1 vssd1 vccd1 vccd1 net128 sky130_fd_sc_hd__buf_2
Xfanout106 _2516_ vssd1 vssd1 vccd1 vccd1 net106 sky130_fd_sc_hd__dlymetal6s2s_1
Xfanout117 _2315_ vssd1 vssd1 vccd1 vccd1 net117 sky130_fd_sc_hd__clkbuf_4
X_4255_ net9 net167 _2728_ vssd1 vssd1 vccd1 vccd1 _2739_ sky130_fd_sc_hd__o21ai_1
Xfanout139 net140 vssd1 vssd1 vccd1 vccd1 net139 sky130_fd_sc_hd__buf_2
XFILLER_67_351 vccd1 vssd1 vccd1 vssd1 sky130_ef_sc_hd__decap_40_12
X_4186_ PID_INST.k3_calc.kd_term\[9\] _1784_ vssd1 vssd1 vccd1 vccd1 _2008_ sky130_fd_sc_hd__or2_1
XANTENNA_fanout272_A net275 vssd1 vssd1 vccd1 vccd1 sky130_fd_sc_hd__diode_2
XFILLER_55_524 vssd1 vssd1 vccd1 vccd1 sky130_fd_sc_hd__fill_1
XFILLER_27_204 vssd1 vssd1 vccd1 vccd1 sky130_fd_sc_hd__fill_1
XFILLER_55_546 vccd1 vssd1 vccd1 vssd1 sky130_ef_sc_hd__decap_40_12
XFILLER_27_237 vccd1 vssd1 vccd1 vssd1 sky130_ef_sc_hd__decap_40_12
XFILLER_82_365 vssd1 vssd1 vccd1 vccd1 sky130_fd_sc_hd__fill_2
X_7945_ _3198_ _3199_ vssd1 vssd1 vccd1 vccd1 _3200_ sky130_fd_sc_hd__nor2_1
XFILLER_42_218 vssd1 vssd1 vccd1 vccd1 sky130_fd_sc_hd__fill_1
XTAP_TAPCELL_ROW_81_1013 vssd1 vccd1 sky130_fd_sc_hd__tapvpwrvgnd_1
XTAP_TAPCELL_ROW_25_449 vssd1 vccd1 sky130_fd_sc_hd__tapvpwrvgnd_1
X_7876_ net95 net42 vssd1 vssd1 vccd1 vccd1 _3131_ sky130_fd_sc_hd__nor2_2
X_6827_ _1728_ _1729_ _1731_ _1734_ vssd1 vssd1 vccd1 vccd1 _2032_ sky130_fd_sc_hd__a31oi_2
X_6758_ _1934_ _1935_ _1957_ vssd1 vssd1 vccd1 vccd1 _1959_ sky130_fd_sc_hd__o21a_1
X_6689_ _1884_ _1885_ vssd1 vssd1 vccd1 vccd1 _1887_ sky130_fd_sc_hd__xnor2_1
X_5709_ _0897_ _0898_ vssd1 vssd1 vccd1 vccd1 _0899_ sky130_fd_sc_hd__and2_1
XFILLER_12_33 vssd1 vssd1 vccd1 vccd1 sky130_fd_sc_hd__fill_2
XFILLER_12_44 vssd1 vssd1 vccd1 vccd1 sky130_fd_sc_hd__fill_1
X_8428_ clknet_4_0_0_clk net407 net327 vssd1 vssd1 vccd1 vccd1 PID_INST.k3_calc.prev_error\[0\]
+ sky130_fd_sc_hd__dfrtp_1
XTAP_TAPCELL_ROW_92_1120 vssd1 vccd1 sky130_fd_sc_hd__tapvpwrvgnd_1
XFILLER_88_15 vssd1 vssd1 vccd1 vccd1 sky130_fd_sc_hd__fill_2
X_8359_ _3636_ _3637_ vssd1 vssd1 vccd1 vccd1 _3638_ sky130_fd_sc_hd__xnor2_1
XFILLER_2_303 vssd1 vssd1 vccd1 vccd1 sky130_fd_sc_hd__fill_4
XTAP_TAPCELL_ROW_92_1131 vssd1 vccd1 sky130_fd_sc_hd__tapvpwrvgnd_1
XANTENNA__4301__A1 net3 vssd1 vssd1 vccd1 vccd1 sky130_fd_sc_hd__diode_2
XFILLER_58_373 vssd1 vssd1 vccd1 vccd1 sky130_fd_sc_hd__fill_1
XTAP_TAPCELL_ROW_69_891 vssd1 vccd1 sky130_fd_sc_hd__tapvpwrvgnd_1
XFILLER_58_395 vccd1 vssd1 vccd1 vssd1 sky130_ef_sc_hd__decap_40_12
XANTENNA__6790__B _0156_ vssd1 vssd1 vccd1 vccd1 sky130_fd_sc_hd__diode_2
XFILLER_61_538 vssd1 vssd1 vccd1 vccd1 sky130_fd_sc_hd__fill_2
XFILLER_14_421 vssd1 vssd1 vccd1 vccd1 sky130_fd_sc_hd__fill_2
XFILLER_26_281 vssd1 vssd1 vccd1 vccd1 sky130_fd_sc_hd__fill_8
XFILLER_33_229 vssd1 vssd1 vccd1 vccd1 sky130_fd_sc_hd__fill_2
XFILLER_14_454 vssd1 vssd1 vccd1 vccd1 sky130_fd_sc_hd__fill_1
XFILLER_41_240 vssd1 vssd1 vccd1 vccd1 sky130_fd_sc_hd__fill_2
XFILLER_68_137 vssd1 vssd1 vccd1 vccd1 sky130_fd_sc_hd__fill_1
XFILLER_49_362 vssd1 vssd1 vccd1 vccd1 sky130_fd_sc_hd__fill_4
XFILLER_37_502 vssd1 vssd1 vccd1 vccd1 sky130_fd_sc_hd__fill_2
XFILLER_37_546 vssd1 vssd1 vccd1 vccd1 sky130_fd_sc_hd__fill_2
XFILLER_24_207 vssd1 vssd1 vccd1 vccd1 sky130_fd_sc_hd__fill_2
X_5991_ _0531_ _0533_ vssd1 vssd1 vccd1 vccd1 _1181_ sky130_fd_sc_hd__nand2_1
X_7730_ _2984_ _2985_ vssd1 vssd1 vccd1 vccd1 _2986_ sky130_fd_sc_hd__xnor2_1
X_4942_ _4131_ _4139_ _0130_ vssd1 vssd1 vccd1 vccd1 _0132_ sky130_fd_sc_hd__nor3_1
X_7661_ _2900_ _2901_ _2913_ vssd1 vssd1 vccd1 vccd1 _2915_ sky130_fd_sc_hd__a21o_1
XANTENNA__6348__A2 net74 vssd1 vssd1 vccd1 vccd1 sky130_fd_sc_hd__diode_2
X_4873_ _4042_ _4044_ _4149_ _4150_ vssd1 vssd1 vccd1 vccd1 _4151_ sky130_fd_sc_hd__a211o_1
X_6612_ _1491_ _1599_ _1598_ vssd1 vssd1 vccd1 vccd1 _1803_ sky130_fd_sc_hd__a21oi_1
XTAP_TAPCELL_ROW_22_419 vssd1 vccd1 sky130_fd_sc_hd__tapvpwrvgnd_1
XANTENNA__5556__B1 net239 vssd1 vssd1 vccd1 vccd1 sky130_fd_sc_hd__diode_2
X_7592_ _2768_ _2840_ vssd1 vssd1 vccd1 vccd1 _2842_ sky130_fd_sc_hd__xnor2_1
X_6543_ _1728_ _1729_ vssd1 vssd1 vccd1 vccd1 _1730_ sky130_fd_sc_hd__nand2_1
XFILLER_20_479 vssd1 vssd1 vccd1 vccd1 sky130_fd_sc_hd__fill_1
X_6474_ _1659_ _1660_ _1439_ _1460_ vssd1 vssd1 vccd1 vccd1 _1662_ sky130_fd_sc_hd__o211ai_1
XTAP_TAPCELL_ROW_30_496 vssd1 vccd1 sky130_fd_sc_hd__tapvpwrvgnd_1
XANTENNA__5308__B1 _3757_ vssd1 vssd1 vccd1 vccd1 sky130_fd_sc_hd__diode_2
X_8213_ _3347_ _3349_ _3479_ vssd1 vssd1 vccd1 vccd1 _3481_ sky130_fd_sc_hd__nor3_1
X_5425_ net107 net55 vssd1 vssd1 vccd1 vccd1 _0615_ sky130_fd_sc_hd__nor2_1
XANTENNA_fanout118_A _2274_ vssd1 vssd1 vccd1 vccd1 sky130_fd_sc_hd__diode_2
XPHY_EDGE_ROW_12_Right_12 vssd1 vssd1 vccd1 vccd1 sky130_fd_sc_hd__decap_3
X_8144_ _3314_ _3315_ _3406_ vssd1 vssd1 vccd1 vccd1 _3407_ sky130_fd_sc_hd__a21oi_1
XANTENNA__4482__A2_N net81 vssd1 vssd1 vccd1 vccd1 sky130_fd_sc_hd__diode_2
X_5356_ _0545_ _0474_ _0472_ vssd1 vssd1 vccd1 vccd1 _0546_ sky130_fd_sc_hd__nand3b_1
XFILLER_87_435 vssd1 vssd1 vccd1 vccd1 sky130_fd_sc_hd__fill_4
X_8075_ _3325_ _3330_ vssd1 vssd1 vccd1 vccd1 _3333_ sky130_fd_sc_hd__or2_1
X_4307_ net257 net9 net172 vssd1 vssd1 vccd1 vccd1 _0030_ sky130_fd_sc_hd__mux2_1
X_5287_ net107 net47 vssd1 vssd1 vccd1 vccd1 _0477_ sky130_fd_sc_hd__nor2_1
XANTENNA__7052__A net199 vssd1 vssd1 vccd1 vccd1 sky130_fd_sc_hd__diode_2
X_7026_ _1906_ _1914_ _2241_ vssd1 vssd1 vccd1 vccd1 _2244_ sky130_fd_sc_hd__nand3_1
XANTENNA__4295__A0 net316 vssd1 vssd1 vccd1 vccd1 sky130_fd_sc_hd__diode_2
X_4238_ net103 vssd1 vssd1 vccd1 vccd1 PID_INST.k3_calc.d2.y\[0\] sky130_fd_sc_hd__inv_2
XANTENNA_fanout275_X net275 vssd1 vssd1 vccd1 vccd1 sky130_fd_sc_hd__diode_2
X_4169_ _1817_ vssd1 vssd1 vccd1 vccd1 PID_INST.k3_calc.d1.y\[0\] sky130_fd_sc_hd__inv_2
XTAP_TAPCELL_ROW_66_861 vssd1 vccd1 sky130_fd_sc_hd__tapvpwrvgnd_1
XPHY_EDGE_ROW_21_Right_21 vssd1 vssd1 vccd1 vccd1 sky130_fd_sc_hd__decap_3
XFILLER_82_195 vssd1 vssd1 vccd1 vccd1 sky130_fd_sc_hd__fill_1
X_7928_ _2975_ _2977_ _2974_ vssd1 vssd1 vccd1 vccd1 _3183_ sky130_fd_sc_hd__o21ba_1
XTAP_TAPCELL_ROW_38_585 vssd1 vccd1 sky130_fd_sc_hd__tapvpwrvgnd_1
X_7859_ _3053_ _3112_ _3113_ vssd1 vssd1 vccd1 vccd1 _3115_ sky130_fd_sc_hd__and3_1
XFILLER_11_446 vssd1 vssd1 vccd1 vccd1 sky130_fd_sc_hd__fill_2
XANTENNA__7227__A net117 vssd1 vssd1 vccd1 vccd1 sky130_fd_sc_hd__diode_2
XPHY_EDGE_ROW_30_Right_30 vssd1 vssd1 vccd1 vccd1 sky130_fd_sc_hd__decap_3
XFILLER_2_122 vssd1 vssd1 vccd1 vccd1 sky130_fd_sc_hd__fill_4
XFILLER_78_402 vssd1 vssd1 vccd1 vccd1 sky130_fd_sc_hd__fill_1
XPHY_EDGE_ROW_76_Left_169 vssd1 vssd1 vccd1 vccd1 sky130_fd_sc_hd__decap_3
XANTENNA__4522__A1 net127 vssd1 vssd1 vccd1 vccd1 sky130_fd_sc_hd__diode_2
XANTENNA__4522__B2 net125 vssd1 vssd1 vccd1 vccd1 sky130_fd_sc_hd__diode_2
XANTENNA__4286__A0 net4 vssd1 vssd1 vccd1 vccd1 sky130_fd_sc_hd__diode_2
XFILLER_48_51 vssd1 vssd1 vccd1 vccd1 sky130_fd_sc_hd__fill_2
XFILLER_65_129 vssd1 vssd1 vccd1 vccd1 sky130_fd_sc_hd__fill_1
XFILLER_48_73 vssd1 vssd1 vccd1 vccd1 sky130_fd_sc_hd__fill_4
XFILLER_46_343 vccd1 vssd1 vccd1 vssd1 sky130_ef_sc_hd__decap_40_12
XFILLER_46_376 vssd1 vssd1 vccd1 vccd1 sky130_fd_sc_hd__fill_2
XFILLER_0_47 vssd1 vssd1 vccd1 vccd1 sky130_fd_sc_hd__fill_8
XFILLER_64_50 vssd1 vssd1 vccd1 vccd1 sky130_fd_sc_hd__fill_2
XFILLER_46_387 vssd1 vssd1 vccd1 vccd1 sky130_fd_sc_hd__fill_1
XANTENNA__6306__A net100 vssd1 vssd1 vccd1 vccd1 sky130_fd_sc_hd__diode_2
XPHY_EDGE_ROW_85_Left_178 vssd1 vssd1 vccd1 vccd1 sky130_fd_sc_hd__decap_3
XFILLER_9_34 vssd1 vssd1 vccd1 vccd1 sky130_fd_sc_hd__fill_8
XFILLER_14_251 vssd1 vssd1 vccd1 vccd1 sky130_fd_sc_hd__fill_1
XFILLER_80_93 vssd1 vssd1 vccd1 vccd1 sky130_fd_sc_hd__fill_1
XFILLER_80_82 vssd1 vssd1 vccd1 vccd1 sky130_fd_sc_hd__fill_2
XANTENNA__7137__A net296 vssd1 vssd1 vccd1 vccd1 sky130_fd_sc_hd__diode_2
XANTENNA__6041__A net291 vssd1 vssd1 vccd1 vccd1 sky130_fd_sc_hd__diode_2
XANTENNA__4761__A1 _4001_ vssd1 vssd1 vccd1 vccd1 sky130_fd_sc_hd__diode_2
XFILLER_6_472 vssd1 vssd1 vccd1 vccd1 sky130_fd_sc_hd__fill_4
XFILLER_6_483 vssd1 vssd1 vccd1 vccd1 sky130_fd_sc_hd__fill_1
X_5210_ _0299_ _0399_ vssd1 vssd1 vccd1 vccd1 _0400_ sky130_fd_sc_hd__nor2_1
X_6190_ _1167_ _1170_ _1377_ vssd1 vssd1 vccd1 vccd1 _1379_ sky130_fd_sc_hd__and3_1
XFILLER_69_413 vssd1 vssd1 vccd1 vccd1 sky130_fd_sc_hd__fill_1
X_5141_ net142 net68 _0243_ _0242_ _0241_ vssd1 vssd1 vccd1 vccd1 _0331_ sky130_fd_sc_hd__a32o_1
XFILLER_69_446 vssd1 vssd1 vccd1 vccd1 sky130_fd_sc_hd__fill_2
X_5072_ net166 net145 vssd1 vssd1 vccd1 vccd1 _0262_ sky130_fd_sc_hd__nand2_1
XFILLER_25_505 vccd1 vssd1 vccd1 vssd1 sky130_ef_sc_hd__decap_40_12
XFILLER_64_195 vssd1 vssd1 vccd1 vccd1 sky130_fd_sc_hd__fill_1
XTAP_TAPCELL_ROW_63_831 vssd1 vccd1 sky130_fd_sc_hd__tapvpwrvgnd_1
X_7713_ _2882_ _2968_ vssd1 vssd1 vccd1 vccd1 _2970_ sky130_fd_sc_hd__xnor2_1
XANTENNA__5120__A net118 vssd1 vssd1 vccd1 vccd1 sky130_fd_sc_hd__diode_2
XTAP_TAPCELL_ROW_35_555 vssd1 vccd1 sky130_fd_sc_hd__tapvpwrvgnd_1
X_5974_ net127 _0156_ vssd1 vssd1 vccd1 vccd1 _1164_ sky130_fd_sc_hd__nand2_1
X_4925_ _4125_ _0114_ vssd1 vssd1 vccd1 vccd1 _0115_ sky130_fd_sc_hd__or2_1
XANTENNA__8191__A1 net305 vssd1 vssd1 vccd1 vccd1 sky130_fd_sc_hd__diode_2
XANTENNA_fanout235_A net236 vssd1 vssd1 vccd1 vccd1 sky130_fd_sc_hd__diode_2
X_7644_ _2891_ _2896_ vssd1 vssd1 vccd1 vccd1 _2897_ sky130_fd_sc_hd__nand2_1
X_4856_ net133 net88 vssd1 vssd1 vccd1 vccd1 _4134_ sky130_fd_sc_hd__nand2_1
XFILLER_20_232 vssd1 vssd1 vccd1 vccd1 sky130_fd_sc_hd__fill_1
XFILLER_20_265 vssd1 vssd1 vccd1 vccd1 sky130_fd_sc_hd__fill_4
X_7575_ _2822_ _2821_ vssd1 vssd1 vccd1 vccd1 _2824_ sky130_fd_sc_hd__and2b_1
X_6526_ _1544_ _1553_ _1712_ vssd1 vssd1 vccd1 vccd1 _1713_ sky130_fd_sc_hd__o21ai_1
X_4787_ net132 net89 _3734_ _2083_ vssd1 vssd1 vccd1 vccd1 _4065_ sky130_fd_sc_hd__o2bb2a_1
X_6457_ net225 net227 net284 net279 vssd1 vssd1 vccd1 vccd1 _1645_ sky130_fd_sc_hd__and4_1
X_5408_ _0584_ _0589_ _0597_ vssd1 vssd1 vccd1 vccd1 _0598_ sky130_fd_sc_hd__a21oi_1
X_6388_ _1574_ _1575_ vssd1 vssd1 vccd1 vccd1 _1576_ sky130_fd_sc_hd__xnor2_1
X_8127_ _3387_ _3388_ vssd1 vssd1 vccd1 vccd1 _3389_ sky130_fd_sc_hd__nor2_1
X_5339_ net123 net68 _0527_ vssd1 vssd1 vccd1 vccd1 _0529_ sky130_fd_sc_hd__nand3_1
XFILLER_87_232 vssd1 vssd1 vccd1 vccd1 sky130_fd_sc_hd__fill_8
XTAP_TAPCELL_ROW_7_269 vssd1 vccd1 sky130_fd_sc_hd__tapvpwrvgnd_1
XFILLER_75_416 vssd1 vssd1 vccd1 vccd1 sky130_fd_sc_hd__fill_1
XFILLER_75_405 vssd1 vssd1 vccd1 vccd1 sky130_fd_sc_hd__fill_4
X_8058_ _3169_ _3175_ _3313_ vssd1 vssd1 vccd1 vccd1 _3314_ sky130_fd_sc_hd__a21o_1
XFILLER_75_449 vssd1 vssd1 vccd1 vccd1 sky130_fd_sc_hd__fill_4
XFILLER_75_438 vssd1 vssd1 vccd1 vccd1 sky130_fd_sc_hd__fill_1
X_7009_ net271 net266 net225 net229 vssd1 vssd1 vccd1 vccd1 _2225_ sky130_fd_sc_hd__and4_1
XFILLER_90_419 vssd1 vssd1 vccd1 vccd1 sky130_fd_sc_hd__fill_1
XANTENNA__7510__A net101 vssd1 vssd1 vccd1 vccd1 sky130_fd_sc_hd__diode_2
XFILLER_28_365 vssd1 vssd1 vccd1 vccd1 sky130_fd_sc_hd__fill_1
XTAP_TAPCELL_ROW_87_1074 vssd1 vccd1 sky130_fd_sc_hd__tapvpwrvgnd_1
XFILLER_70_110 vssd1 vssd1 vccd1 vccd1 sky130_fd_sc_hd__fill_2
XFILLER_18_98 vssd1 vssd1 vccd1 vccd1 sky130_fd_sc_hd__fill_1
XFILLER_43_335 vssd1 vssd1 vccd1 vccd1 sky130_fd_sc_hd__fill_1
XFILLER_7_225 vssd1 vssd1 vccd1 vccd1 sky130_fd_sc_hd__fill_8
XFILLER_50_63 vssd1 vssd1 vccd1 vccd1 sky130_fd_sc_hd__fill_2
XFILLER_3_431 vssd1 vssd1 vccd1 vccd1 sky130_fd_sc_hd__fill_1
XFILLER_3_464 vssd1 vssd1 vccd1 vccd1 sky130_fd_sc_hd__fill_2
XTAP_TAPCELL_ROW_77_967 vssd1 vccd1 sky130_fd_sc_hd__tapvpwrvgnd_1
XFILLER_19_354 vssd1 vssd1 vccd1 vccd1 sky130_fd_sc_hd__fill_1
Xclkbuf_4_11_0_clk clknet_0_clk vssd1 vssd1 vccd1 vccd1 clknet_4_11_0_clk sky130_fd_sc_hd__clkbuf_8
XTAP_TAPCELL_ROW_60_801 vssd1 vccd1 sky130_fd_sc_hd__tapvpwrvgnd_1
XFILLER_22_519 vssd1 vssd1 vccd1 vccd1 sky130_fd_sc_hd__fill_2
XFILLER_34_379 vssd1 vssd1 vccd1 vccd1 sky130_fd_sc_hd__fill_2
XFILLER_91_92 vssd1 vssd1 vccd1 vccd1 sky130_fd_sc_hd__fill_1
X_5690_ _0875_ _0879_ _0855_ _0857_ vssd1 vssd1 vccd1 vccd1 _0880_ sky130_fd_sc_hd__o211a_1
X_4710_ _3797_ _3805_ _3796_ vssd1 vssd1 vccd1 vccd1 _3988_ sky130_fd_sc_hd__o21ai_1
XTAP_TAPCELL_ROW_32_525 vssd1 vccd1 sky130_fd_sc_hd__tapvpwrvgnd_1
XANTENNA__5594__B net308 vssd1 vssd1 vccd1 vccd1 sky130_fd_sc_hd__diode_2
X_4641_ _3911_ _3913_ vssd1 vssd1 vccd1 vccd1 _3919_ sky130_fd_sc_hd__xor2_1
X_7360_ net212 net275 net262 net225 vssd1 vssd1 vccd1 vccd1 _2596_ sky130_fd_sc_hd__a22oi_1
X_4572_ _3738_ _3848_ _3849_ vssd1 vssd1 vccd1 vccd1 _3850_ sky130_fd_sc_hd__and3_1
X_6311_ _1497_ _1498_ vssd1 vssd1 vccd1 vccd1 _1499_ sky130_fd_sc_hd__nor2_1
X_7291_ _2522_ _2512_ vssd1 vssd1 vccd1 vccd1 _2523_ sky130_fd_sc_hd__nand2b_1
XFILLER_89_508 vssd1 vssd1 vccd1 vccd1 sky130_fd_sc_hd__fill_8
X_6242_ net292 net220 vssd1 vssd1 vccd1 vccd1 _1431_ sky130_fd_sc_hd__nand2_1
XFILLER_69_232 vssd1 vssd1 vccd1 vccd1 sky130_fd_sc_hd__fill_4
X_6173_ _1351_ _1360_ vssd1 vssd1 vccd1 vccd1 _1362_ sky130_fd_sc_hd__nor2_1
XTAP_TAPCELL_ROW_4_239 vssd1 vccd1 sky130_fd_sc_hd__tapvpwrvgnd_1
X_5124_ net116 net61 vssd1 vssd1 vccd1 vccd1 _0314_ sky130_fd_sc_hd__nor2_1
XANTENNA__8365__CLK clknet_4_0_0_clk vssd1 vssd1 vccd1 vccd1 sky130_fd_sc_hd__diode_2
XANTENNA_fanout185_A net186 vssd1 vssd1 vccd1 vccd1 sky130_fd_sc_hd__diode_2
X_5055_ _0233_ _0244_ vssd1 vssd1 vccd1 vccd1 _0245_ sky130_fd_sc_hd__xnor2_1
XFILLER_72_419 vssd1 vssd1 vccd1 vccd1 sky130_fd_sc_hd__fill_1
XTAP_TAPCELL_ROW_48_680 vssd1 vccd1 sky130_fd_sc_hd__tapvpwrvgnd_1
XFILLER_25_346 vssd1 vssd1 vccd1 vccd1 sky130_fd_sc_hd__fill_1
X_5957_ net135 net76 _3999_ net134 vssd1 vssd1 vccd1 vccd1 _1147_ sky130_fd_sc_hd__a22o_1
XANTENNA_fanout140_X net140 vssd1 vssd1 vccd1 vccd1 sky130_fd_sc_hd__diode_2
X_4908_ _0089_ _0097_ vssd1 vssd1 vccd1 vccd1 _0098_ sky130_fd_sc_hd__xnor2_1
XFILLER_21_530 vssd1 vssd1 vccd1 vccd1 sky130_fd_sc_hd__fill_1
XFILLER_40_327 vssd1 vssd1 vccd1 vccd1 sky130_fd_sc_hd__fill_8
XFILLER_40_349 vssd1 vssd1 vccd1 vccd1 sky130_fd_sc_hd__fill_1
X_5888_ net245 net311 _1076_ vssd1 vssd1 vccd1 vccd1 _1078_ sky130_fd_sc_hd__a21o_1
X_7627_ _2875_ _2876_ vssd1 vssd1 vccd1 vccd1 _2879_ sky130_fd_sc_hd__xor2_1
XFILLER_21_552 vssd1 vssd1 vccd1 vccd1 sky130_fd_sc_hd__fill_2
X_4839_ _4048_ _4116_ vssd1 vssd1 vccd1 vccd1 _4117_ sky130_fd_sc_hd__xor2_1
X_7558_ _2546_ _2550_ _2804_ vssd1 vssd1 vccd1 vccd1 _2806_ sky130_fd_sc_hd__a21o_1
X_7489_ _2731_ _2732_ vssd1 vssd1 vccd1 vccd1 _2733_ sky130_fd_sc_hd__or2_1
X_6509_ _1694_ _1695_ vssd1 vssd1 vccd1 vccd1 _1696_ sky130_fd_sc_hd__nor2_1
XANTENNA_fanout98_A _2644_ vssd1 vssd1 vccd1 vccd1 sky130_fd_sc_hd__diode_2
XFILLER_0_412 vssd1 vssd1 vccd1 vccd1 sky130_fd_sc_hd__fill_2
XFILLER_88_530 vssd1 vssd1 vccd1 vccd1 sky130_fd_sc_hd__fill_2
XFILLER_75_202 vccd1 vssd1 vccd1 vssd1 sky130_ef_sc_hd__decap_40_12
Xhold31 PID_INST.k2_calc.sum_reg\[26\] vssd1 vssd1 vccd1 vccd1 net424 sky130_fd_sc_hd__dlygate4sd3_1
XFILLER_48_416 vssd1 vssd1 vccd1 vccd1 sky130_fd_sc_hd__fill_4
Xhold20 net27 vssd1 vssd1 vccd1 vccd1 net413 sky130_fd_sc_hd__dlygate4sd3_1
XANTENNA__8384__RESET_B net328 vssd1 vssd1 vccd1 vccd1 sky130_fd_sc_hd__diode_2
XFILLER_75_279 vssd1 vssd1 vccd1 vccd1 sky130_fd_sc_hd__fill_1
XFILLER_90_227 vssd1 vssd1 vccd1 vccd1 sky130_fd_sc_hd__fill_8
XTAP_TAPCELL_ROW_74_937 vssd1 vccd1 sky130_fd_sc_hd__tapvpwrvgnd_1
XANTENNA_fanout53_X net53 vssd1 vssd1 vccd1 vccd1 sky130_fd_sc_hd__diode_2
XFILLER_71_441 vssd1 vssd1 vccd1 vccd1 sky130_fd_sc_hd__fill_4
XFILLER_28_195 vssd1 vssd1 vccd1 vccd1 sky130_fd_sc_hd__fill_1
XFILLER_71_463 vssd1 vssd1 vccd1 vccd1 sky130_fd_sc_hd__fill_1
XFILLER_8_556 vccd1 vssd1 vccd1 vssd1 sky130_ef_sc_hd__decap_40_12
XANTENNA__7666__B1 net260 vssd1 vssd1 vccd1 vccd1 sky130_fd_sc_hd__diode_2
XANTENNA__7415__A net322 vssd1 vssd1 vccd1 vccd1 sky130_fd_sc_hd__diode_2
XANTENNA__7134__B net212 vssd1 vssd1 vccd1 vccd1 sky130_fd_sc_hd__diode_2
XANTENNA__4758__B net71 vssd1 vssd1 vccd1 vccd1 sky130_fd_sc_hd__diode_2
XFILLER_79_552 vssd1 vssd1 vccd1 vccd1 sky130_fd_sc_hd__fill_8
XANTENNA__5141__A1 net142 vssd1 vssd1 vccd1 vccd1 sky130_fd_sc_hd__diode_2
XFILLER_39_449 vccd1 vssd1 vccd1 vssd1 sky130_ef_sc_hd__decap_40_12
XANTENNA__6641__A1 net291 vssd1 vssd1 vccd1 vccd1 sky130_fd_sc_hd__diode_2
XTAP_TAPCELL_ROW_1_209 vssd1 vccd1 sky130_fd_sc_hd__tapvpwrvgnd_1
XFILLER_62_430 vssd1 vssd1 vccd1 vccd1 sky130_fd_sc_hd__fill_8
X_6860_ _2065_ _2066_ vssd1 vssd1 vccd1 vccd1 _2067_ sky130_fd_sc_hd__nand2_1
X_5811_ _0991_ _1000_ _0961_ _0976_ vssd1 vssd1 vccd1 vccd1 _1001_ sky130_fd_sc_hd__o211a_1
X_6791_ _1987_ _0088_ _0157_ _2019_ vssd1 vssd1 vccd1 vccd1 _1994_ sky130_fd_sc_hd__o22a_1
XTAP_TAPCELL_ROW_45_650 vssd1 vccd1 sky130_fd_sc_hd__tapvpwrvgnd_1
X_5742_ _0902_ _0931_ vssd1 vssd1 vccd1 vccd1 _0932_ sky130_fd_sc_hd__nand2_1
XTAP_TAPCELL_ROW_17_374 vssd1 vccd1 sky130_fd_sc_hd__tapvpwrvgnd_1
X_5673_ net323 net318 net224 net219 vssd1 vssd1 vccd1 vccd1 _0863_ sky130_fd_sc_hd__nand4_1
X_8461_ clknet_4_7_0_clk _0049_ net332 vssd1 vssd1 vccd1 vccd1 PID_INST.k2_calc.sum_reg\[17\]
+ sky130_fd_sc_hd__dfrtp_1
XFILLER_30_382 vssd1 vssd1 vccd1 vccd1 sky130_fd_sc_hd__fill_1
X_7412_ net268 net264 net214 net213 vssd1 vssd1 vccd1 vccd1 _2651_ sky130_fd_sc_hd__and4_1
XPHY_EDGE_ROW_6_Right_6 vssd1 vssd1 vccd1 vccd1 sky130_fd_sc_hd__decap_3
X_4624_ _3885_ _3899_ _3900_ _3901_ vssd1 vssd1 vccd1 vccd1 _3902_ sky130_fd_sc_hd__a22o_1
X_8392_ clknet_4_8_0_clk PID_INST.k3_calc.d2.y\[12\] net328 vssd1 vssd1 vccd1 vccd1
+ PID_INST.k3_calc.timescaling_term\[12\] sky130_fd_sc_hd__dfrtp_1
X_7343_ _2336_ _2338_ _2335_ vssd1 vssd1 vccd1 vccd1 _2578_ sky130_fd_sc_hd__o21ba_1
X_4555_ net148 net147 _3774_ net81 vssd1 vssd1 vccd1 vccd1 _3833_ sky130_fd_sc_hd__or4b_1
XANTENNA__7044__B PID_INST.k2_calc.reg_lc\[13\] vssd1 vssd1 vccd1 vccd1 sky130_fd_sc_hd__diode_2
X_4486_ _3746_ _3749_ _3763_ vssd1 vssd1 vccd1 vccd1 _3764_ sky130_fd_sc_hd__o21a_1
X_7274_ _2502_ _2503_ vssd1 vssd1 vccd1 vccd1 _2504_ sky130_fd_sc_hd__xnor2_1
XFILLER_89_349 vssd1 vssd1 vccd1 vccd1 sky130_fd_sc_hd__fill_4
X_6225_ _1412_ _1413_ vssd1 vssd1 vccd1 vccd1 _1414_ sky130_fd_sc_hd__nor2_1
X_6156_ _1339_ _1344_ vssd1 vssd1 vccd1 vccd1 _1345_ sky130_fd_sc_hd__or2_1
XFILLER_66_29 vssd1 vssd1 vccd1 vccd1 sky130_fd_sc_hd__fill_4
X_5107_ _0231_ _0296_ vssd1 vssd1 vccd1 vccd1 _0297_ sky130_fd_sc_hd__xnor2_1
XANTENNA_fanout188_X net188 vssd1 vssd1 vccd1 vccd1 sky130_fd_sc_hd__diode_2
XFILLER_57_246 vssd1 vssd1 vccd1 vccd1 sky130_fd_sc_hd__fill_4
X_6087_ _0853_ _0856_ _1275_ _1276_ vssd1 vssd1 vccd1 vccd1 _1277_ sky130_fd_sc_hd__o211a_1
X_5038_ net116 net56 vssd1 vssd1 vccd1 vccd1 _0228_ sky130_fd_sc_hd__nor2_1
XFILLER_72_249 vssd1 vssd1 vccd1 vccd1 sky130_fd_sc_hd__fill_1
XTAP_TAPCELL_ROW_71_907 vssd1 vccd1 sky130_fd_sc_hd__tapvpwrvgnd_1
XFILLER_25_110 vssd1 vssd1 vccd1 vccd1 sky130_fd_sc_hd__fill_2
XTAP_TAPCELL_ROW_84_1044 vssd1 vccd1 sky130_fd_sc_hd__tapvpwrvgnd_1
XFILLER_13_327 vssd1 vssd1 vccd1 vccd1 sky130_fd_sc_hd__fill_1
XFILLER_25_198 vssd1 vssd1 vccd1 vccd1 sky130_fd_sc_hd__fill_1
X_6989_ _2196_ _2202_ vssd1 vssd1 vccd1 vccd1 _2204_ sky130_fd_sc_hd__xnor2_1
XFILLER_9_309 vssd1 vssd1 vccd1 vccd1 sky130_fd_sc_hd__fill_4
XFILLER_40_157 vssd1 vssd1 vccd1 vccd1 sky130_fd_sc_hd__fill_4
XFILLER_21_393 vssd1 vssd1 vccd1 vccd1 sky130_fd_sc_hd__fill_2
XANTENNA__7360__A2 net275 vssd1 vssd1 vccd1 vccd1 sky130_fd_sc_hd__diode_2
Xoutput21 net21 vssd1 vssd1 vccd1 vccd1 gpio_out[18] sky130_fd_sc_hd__buf_2
Xoutput32 net32 vssd1 vssd1 vccd1 vccd1 gpio_out[29] sky130_fd_sc_hd__buf_2
XFILLER_0_231 vssd1 vssd1 vccd1 vccd1 sky130_fd_sc_hd__fill_4
XFILLER_88_382 vssd1 vssd1 vccd1 vccd1 sky130_fd_sc_hd__fill_2
XFILLER_76_566 vssd1 vssd1 vccd1 vccd1 sky130_fd_sc_hd__fill_4
XTAP_TAPCELL_ROW_59_786 vssd1 vccd1 sky130_fd_sc_hd__tapvpwrvgnd_1
XFILLER_56_62 vssd1 vssd1 vccd1 vccd1 sky130_fd_sc_hd__fill_2
XANTENNA__4634__B1 _3734_ vssd1 vssd1 vccd1 vccd1 sky130_fd_sc_hd__diode_2
XFILLER_29_482 vssd1 vssd1 vccd1 vccd1 sky130_fd_sc_hd__fill_1
XFILLER_91_569 vssd1 vssd1 vccd1 vccd1 sky130_fd_sc_hd__fill_1
XFILLER_91_547 vccd1 vssd1 vccd1 vssd1 sky130_ef_sc_hd__decap_40_12
XFILLER_44_452 vccd1 vssd1 vccd1 vssd1 sky130_ef_sc_hd__decap_40_12
XFILLER_16_165 vssd1 vssd1 vccd1 vccd1 sky130_fd_sc_hd__fill_2
XFILLER_72_61 vccd1 vssd1 vccd1 vssd1 sky130_ef_sc_hd__decap_40_12
XFILLER_72_50 vssd1 vssd1 vccd1 vccd1 sky130_fd_sc_hd__fill_2
XFILLER_71_271 vssd1 vssd1 vccd1 vccd1 sky130_fd_sc_hd__fill_1
XFILLER_44_485 vssd1 vssd1 vccd1 vccd1 sky130_fd_sc_hd__fill_2
XFILLER_31_113 vccd1 vssd1 vccd1 vssd1 sky130_ef_sc_hd__decap_40_12
XTAP_TAPCELL_ROW_42_620 vssd1 vccd1 sky130_fd_sc_hd__tapvpwrvgnd_1
XTAP_TAPCELL_ROW_14_344 vssd1 vccd1 sky130_fd_sc_hd__tapvpwrvgnd_1
XANTENNA__4937__B2 net132 vssd1 vssd1 vccd1 vccd1 sky130_fd_sc_hd__diode_2
XFILLER_31_135 vssd1 vssd1 vccd1 vccd1 sky130_fd_sc_hd__fill_1
XPHY_EDGE_ROW_59_Right_59 vssd1 vssd1 vccd1 vccd1 sky130_fd_sc_hd__decap_3
XFILLER_12_382 vssd1 vssd1 vccd1 vccd1 sky130_fd_sc_hd__fill_2
XFILLER_12_393 vssd1 vssd1 vccd1 vccd1 sky130_fd_sc_hd__fill_1
XANTENNA__7639__B1 net252 vssd1 vssd1 vccd1 vccd1 sky130_fd_sc_hd__diode_2
X_4340_ net230 _3612_ net161 vssd1 vssd1 vccd1 vccd1 _0037_ sky130_fd_sc_hd__mux2_1
X_4271_ PID_INST.pid.curr_state\[3\] PID_INST.pid.curr_state\[2\] net177 net176 vssd1
+ vssd1 vccd1 vccd1 _2908_ sky130_fd_sc_hd__and4b_1
XANTENNA__6984__A net117 vssd1 vssd1 vccd1 vccd1 sky130_fd_sc_hd__diode_2
X_6010_ _1125_ _1199_ vssd1 vssd1 vccd1 vccd1 _1200_ sky130_fd_sc_hd__xor2_1
XANTENNA__7799__B net51 vssd1 vssd1 vccd1 vccd1 sky130_fd_sc_hd__diode_2
XPHY_EDGE_ROW_68_Right_68 vssd1 vssd1 vccd1 vccd1 sky130_fd_sc_hd__decap_3
X_7961_ net305 net180 vssd1 vssd1 vccd1 vccd1 _3216_ sky130_fd_sc_hd__and2_1
XFILLER_39_279 vssd1 vssd1 vccd1 vccd1 sky130_fd_sc_hd__fill_1
XFILLER_82_569 vssd1 vssd1 vccd1 vccd1 sky130_fd_sc_hd__fill_1
XFILLER_54_249 vssd1 vssd1 vccd1 vccd1 sky130_fd_sc_hd__fill_2
X_6912_ _1998_ _2000_ vssd1 vssd1 vccd1 vccd1 _2122_ sky130_fd_sc_hd__nand2_1
X_7892_ _3141_ _3146_ vssd1 vssd1 vccd1 vccd1 _3147_ sky130_fd_sc_hd__xnor2_1
XFILLER_35_430 vssd1 vssd1 vccd1 vccd1 sky130_fd_sc_hd__fill_1
XFILLER_35_441 vssd1 vssd1 vccd1 vccd1 sky130_fd_sc_hd__fill_4
X_6843_ _1990_ _2048_ vssd1 vssd1 vccd1 vccd1 _2049_ sky130_fd_sc_hd__xnor2_1
X_6774_ net216 net289 _1879_ _1877_ vssd1 vssd1 vccd1 vccd1 _1975_ sky130_fd_sc_hd__a31o_1
XPHY_EDGE_ROW_77_Right_77 vssd1 vssd1 vccd1 vccd1 sky130_fd_sc_hd__decap_3
XFILLER_50_455 vssd1 vssd1 vccd1 vccd1 sky130_fd_sc_hd__fill_4
XANTENNA_fanout148_A _2242_ vssd1 vssd1 vccd1 vccd1 sky130_fd_sc_hd__diode_2
X_5725_ _0903_ _0913_ _0914_ vssd1 vssd1 vccd1 vccd1 _0915_ sky130_fd_sc_hd__nand3_2
XFILLER_50_499 vssd1 vssd1 vccd1 vccd1 sky130_fd_sc_hd__fill_4
XFILLER_50_477 vssd1 vssd1 vccd1 vccd1 sky130_fd_sc_hd__fill_1
XANTENNA_fanout315_A net316 vssd1 vssd1 vccd1 vccd1 sky130_fd_sc_hd__diode_2
X_8444_ clknet_4_13_0_clk _0032_ net338 vssd1 vssd1 vccd1 vccd1 PID_INST.k2_calc.sum_reg\[0\]
+ sky130_fd_sc_hd__dfrtp_1
X_5656_ _0843_ _0844_ _0841_ vssd1 vssd1 vccd1 vccd1 _0846_ sky130_fd_sc_hd__a21bo_1
XANTENNA__7878__B1 net42 vssd1 vssd1 vccd1 vccd1 sky130_fd_sc_hd__diode_2
X_4607_ _3870_ _3875_ vssd1 vssd1 vccd1 vccd1 _3885_ sky130_fd_sc_hd__xor2_1
X_5587_ _0775_ _0776_ vssd1 vssd1 vccd1 vccd1 _0777_ sky130_fd_sc_hd__nor2_1
X_8375_ clknet_4_4_0_clk _0011_ net330 vssd1 vssd1 vccd1 vccd1 PID_INST.k1_calc.d1.x\[11\]
+ sky130_fd_sc_hd__dfrtp_1
XFILLER_89_113 vccd1 vssd1 vccd1 vssd1 sky130_ef_sc_hd__decap_40_12
X_7326_ net268 net217 net218 net264 vssd1 vssd1 vccd1 vccd1 _2560_ sky130_fd_sc_hd__a22oi_1
XFILLER_2_529 vssd1 vssd1 vccd1 vccd1 sky130_fd_sc_hd__fill_2
X_4538_ net125 _3731_ _3732_ net89 net127 vssd1 vssd1 vccd1 vccd1 _3816_ sky130_fd_sc_hd__a32oi_4
XANTENNA_fanout103_X net103 vssd1 vssd1 vccd1 vccd1 sky130_fd_sc_hd__diode_2
X_4469_ PID_INST.k1_calc.d1.x\[5\] PID_INST.k3_calc.prev_error\[5\] vssd1 vssd1 vccd1
+ vccd1 _3747_ sky130_fd_sc_hd__nand2_1
X_7257_ _2418_ _2483_ vssd1 vssd1 vccd1 vccd1 _2487_ sky130_fd_sc_hd__xnor2_1
XPHY_EDGE_ROW_86_Right_86 vssd1 vssd1 vccd1 vccd1 sky130_fd_sc_hd__decap_3
X_6208_ _1194_ _1395_ _1396_ vssd1 vssd1 vccd1 vccd1 _1397_ sky130_fd_sc_hd__a21oi_1
X_7188_ _2413_ _2402_ vssd1 vssd1 vccd1 vccd1 _2414_ sky130_fd_sc_hd__nand2b_1
X_6139_ _0479_ _1193_ _1195_ _1192_ vssd1 vssd1 vccd1 vccd1 _1328_ sky130_fd_sc_hd__a22o_1
XFILLER_85_374 vssd1 vssd1 vccd1 vccd1 sky130_fd_sc_hd__fill_2
XANTENNA__4616__B1 net84 vssd1 vssd1 vccd1 vccd1 sky130_fd_sc_hd__diode_2
XFILLER_73_569 vssd1 vssd1 vccd1 vccd1 sky130_fd_sc_hd__fill_1
XTAP_TAPCELL_ROW_56_756 vssd1 vccd1 sky130_fd_sc_hd__tapvpwrvgnd_1
XFILLER_13_113 vssd1 vssd1 vccd1 vccd1 sky130_fd_sc_hd__fill_8
XFILLER_13_124 vssd1 vssd1 vccd1 vccd1 sky130_fd_sc_hd__fill_2
XFILLER_41_422 vssd1 vssd1 vccd1 vccd1 sky130_fd_sc_hd__fill_1
XFILLER_13_135 vssd1 vssd1 vccd1 vccd1 sky130_fd_sc_hd__fill_1
XTAP_TAPCELL_ROW_11_314 vssd1 vccd1 sky130_fd_sc_hd__tapvpwrvgnd_1
XFILLER_42_64 vssd1 vssd1 vccd1 vccd1 sky130_fd_sc_hd__fill_1
XFILLER_5_356 vccd1 vssd1 vccd1 vssd1 sky130_ef_sc_hd__decap_40_12
XFILLER_5_334 vssd1 vssd1 vccd1 vccd1 sky130_fd_sc_hd__fill_2
XFILLER_49_500 vssd1 vssd1 vccd1 vccd1 sky130_fd_sc_hd__fill_4
XFILLER_3_47 vssd1 vssd1 vccd1 vccd1 sky130_fd_sc_hd__fill_1
XFILLER_3_36 vssd1 vssd1 vccd1 vccd1 sky130_fd_sc_hd__fill_2
XFILLER_76_363 vssd1 vssd1 vccd1 vccd1 sky130_fd_sc_hd__fill_1
XFILLER_64_569 vssd1 vssd1 vccd1 vccd1 sky130_fd_sc_hd__fill_1
XFILLER_36_238 vssd1 vssd1 vccd1 vccd1 sky130_fd_sc_hd__fill_2
XANTENNA__4771__B net125 vssd1 vssd1 vccd1 vccd1 sky130_fd_sc_hd__diode_2
XFILLER_32_477 vssd1 vssd1 vccd1 vccd1 sky130_fd_sc_hd__fill_2
X_5510_ _0693_ _0694_ _0699_ vssd1 vssd1 vccd1 vccd1 _0700_ sky130_fd_sc_hd__or3_1
X_6490_ _1473_ _1477_ _1676_ vssd1 vssd1 vccd1 vccd1 _1678_ sky130_fd_sc_hd__nor3_1
XFILLER_8_150 vssd1 vssd1 vccd1 vccd1 sky130_fd_sc_hd__fill_2
X_5441_ _0627_ _0630_ vssd1 vssd1 vccd1 vccd1 _0631_ sky130_fd_sc_hd__nor2_1
XANTENNA__4499__A PID_INST.k1_calc.d1.x\[0\] vssd1 vssd1 vccd1 vccd1 sky130_fd_sc_hd__diode_2
XANTENNA__8416__RESET_B net328 vssd1 vssd1 vccd1 vccd1 sky130_fd_sc_hd__diode_2
X_8160_ _3422_ _3423_ vssd1 vssd1 vccd1 vccd1 _3424_ sky130_fd_sc_hd__and2_1
X_5372_ _0310_ _0560_ vssd1 vssd1 vccd1 vccd1 _0562_ sky130_fd_sc_hd__nand2_1
X_8091_ _3337_ _3348_ vssd1 vssd1 vccd1 vccd1 _3350_ sky130_fd_sc_hd__xnor2_1
X_7111_ _2232_ _2239_ _2330_ vssd1 vssd1 vccd1 vccd1 _2332_ sky130_fd_sc_hd__nand3_1
X_4323_ net241 net159 _3408_ _3429_ vssd1 vssd1 vccd1 vccd1 _0034_ sky130_fd_sc_hd__a22o_1
X_7042_ _1917_ _1931_ _2258_ vssd1 vssd1 vccd1 vccd1 _2260_ sky130_fd_sc_hd__and3_1
Xfanout107 net108 vssd1 vssd1 vccd1 vccd1 net107 sky130_fd_sc_hd__clkbuf_4
Xfanout118 _2274_ vssd1 vssd1 vccd1 vccd1 net118 sky130_fd_sc_hd__buf_2
Xfanout129 PID_INST.k3_calc.d1.y\[6\] vssd1 vssd1 vccd1 vccd1 net129 sky130_fd_sc_hd__clkbuf_2
X_4254_ PID_INST.k3_calc.timescaling_term\[14\] net169 vssd1 vssd1 vccd1 vccd1 _2728_
+ sky130_fd_sc_hd__or2_1
X_4185_ _1987_ vssd1 vssd1 vccd1 vccd1 PID_INST.k3_calc.d1.y\[10\] sky130_fd_sc_hd__inv_2
XFILLER_82_300 vssd1 vssd1 vccd1 vccd1 sky130_fd_sc_hd__fill_8
XFILLER_67_363 vssd1 vssd1 vccd1 vccd1 sky130_fd_sc_hd__fill_4
X_7944_ net298 net181 net179 net310 vssd1 vssd1 vccd1 vccd1 _3199_ sky130_fd_sc_hd__a22oi_1
XFILLER_55_558 vssd1 vssd1 vccd1 vccd1 sky130_fd_sc_hd__fill_2
XFILLER_55_536 vssd1 vssd1 vccd1 vccd1 sky130_fd_sc_hd__fill_2
XFILLER_27_249 vssd1 vssd1 vccd1 vccd1 sky130_fd_sc_hd__fill_4
XANTENNA_fanout265_A net266 vssd1 vssd1 vccd1 vccd1 sky130_fd_sc_hd__diode_2
XTAP_TAPCELL_ROW_81_1014 vssd1 vccd1 sky130_fd_sc_hd__tapvpwrvgnd_1
XTAP_TAPCELL_ROW_53_726 vssd1 vccd1 sky130_fd_sc_hd__tapvpwrvgnd_1
X_7875_ _3128_ _3129_ vssd1 vssd1 vccd1 vccd1 _3130_ sky130_fd_sc_hd__nor2_1
X_6826_ _2030_ vssd1 vssd1 vccd1 vccd1 _2031_ sky130_fd_sc_hd__inv_2
XFILLER_23_455 vssd1 vssd1 vccd1 vccd1 sky130_fd_sc_hd__fill_1
X_6757_ _1934_ _1935_ _1957_ vssd1 vssd1 vccd1 vccd1 _1958_ sky130_fd_sc_hd__nor3_1
XFILLER_10_116 vssd1 vssd1 vccd1 vccd1 sky130_fd_sc_hd__fill_1
X_5708_ _0698_ _0891_ _0896_ vssd1 vssd1 vccd1 vccd1 _0898_ sky130_fd_sc_hd__o21ai_1
XANTENNA_fanout220_X net220 vssd1 vssd1 vccd1 vccd1 sky130_fd_sc_hd__diode_2
XFILLER_10_149 vssd1 vssd1 vccd1 vccd1 sky130_fd_sc_hd__fill_1
XFILLER_10_127 vssd1 vssd1 vccd1 vccd1 sky130_fd_sc_hd__fill_2
X_6688_ _1884_ _1885_ vssd1 vssd1 vccd1 vccd1 _1886_ sky130_fd_sc_hd__nand2_1
X_5639_ _0819_ _0828_ vssd1 vssd1 vccd1 vccd1 _0829_ sky130_fd_sc_hd__xnor2_1
X_8427_ clknet_4_4_0_clk net162 net331 vssd1 vssd1 vccd1 vccd1 PID_INST.k3_calc.kd_term\[15\]
+ sky130_fd_sc_hd__dfrtp_1
XFILLER_88_27 vssd1 vssd1 vccd1 vccd1 sky130_fd_sc_hd__fill_1
X_8358_ _3552_ _3619_ vssd1 vssd1 vccd1 vccd1 _3637_ sky130_fd_sc_hd__xnor2_1
XFILLER_12_89 vccd1 vssd1 vccd1 vssd1 sky130_ef_sc_hd__decap_40_12
XTAP_TAPCELL_ROW_92_1132 vssd1 vccd1 sky130_fd_sc_hd__tapvpwrvgnd_1
XTAP_TAPCELL_ROW_92_1121 vssd1 vccd1 sky130_fd_sc_hd__tapvpwrvgnd_1
XFILLER_2_315 vccd1 vssd1 vccd1 vssd1 sky130_ef_sc_hd__decap_40_12
XFILLER_2_337 vssd1 vssd1 vccd1 vccd1 sky130_fd_sc_hd__fill_1
XFILLER_2_348 vssd1 vssd1 vccd1 vccd1 sky130_fd_sc_hd__fill_1
X_7309_ _2530_ _2541_ vssd1 vssd1 vccd1 vccd1 _2542_ sky130_fd_sc_hd__xnor2_1
X_8289_ _3560_ _3561_ vssd1 vssd1 vccd1 vccd1 _3562_ sky130_fd_sc_hd__xnor2_1
XANTENNA__7513__A net99 vssd1 vssd1 vccd1 vccd1 sky130_fd_sc_hd__diode_2
XANTENNA_fanout80_A _3756_ vssd1 vssd1 vccd1 vccd1 sky130_fd_sc_hd__diode_2
XANTENNA__4856__B net88 vssd1 vssd1 vccd1 vccd1 sky130_fd_sc_hd__diode_2
XFILLER_37_20 vssd1 vssd1 vccd1 vccd1 sky130_fd_sc_hd__fill_1
XTAP_TAPCELL_ROW_69_892 vssd1 vccd1 sky130_fd_sc_hd__tapvpwrvgnd_1
XANTENNA__5581__A1_N net291 vssd1 vssd1 vccd1 vccd1 sky130_fd_sc_hd__diode_2
XFILLER_14_477 vssd1 vssd1 vccd1 vccd1 sky130_fd_sc_hd__fill_2
XFILLER_5_120 vssd1 vssd1 vccd1 vccd1 sky130_fd_sc_hd__fill_1
XFILLER_5_175 vccd1 vssd1 vccd1 vssd1 sky130_ef_sc_hd__decap_40_12
XANTENNA__7423__A net317 vssd1 vssd1 vccd1 vccd1 sky130_fd_sc_hd__diode_2
XFILLER_78_93 vssd1 vssd1 vccd1 vccd1 sky130_fd_sc_hd__fill_2
X_5990_ _1177_ _1179_ vssd1 vssd1 vccd1 vccd1 _1180_ sky130_fd_sc_hd__or2_1
X_4941_ _4131_ _4139_ _0130_ vssd1 vssd1 vccd1 vccd1 _0131_ sky130_fd_sc_hd__o21a_1
XFILLER_17_271 vssd1 vssd1 vccd1 vccd1 sky130_fd_sc_hd__fill_8
X_7660_ _2900_ _2901_ _2913_ vssd1 vssd1 vccd1 vccd1 _2914_ sky130_fd_sc_hd__nand3_1
X_4872_ _4147_ _4148_ _4076_ _4078_ vssd1 vssd1 vccd1 vccd1 _4150_ sky130_fd_sc_hd__o211a_1
X_6611_ _1688_ _1801_ vssd1 vssd1 vccd1 vccd1 _1802_ sky130_fd_sc_hd__xnor2_1
X_7591_ _2768_ _2840_ vssd1 vssd1 vccd1 vccd1 _2841_ sky130_fd_sc_hd__nand2_1
X_6542_ _1715_ _1727_ vssd1 vssd1 vccd1 vccd1 _1729_ sky130_fd_sc_hd__or2_1
X_6473_ _1439_ _1460_ _1659_ _1660_ vssd1 vssd1 vccd1 vccd1 _1661_ sky130_fd_sc_hd__a211o_1
XTAP_TAPCELL_ROW_30_497 vssd1 vccd1 sky130_fd_sc_hd__tapvpwrvgnd_1
X_8212_ _3347_ _3349_ _3479_ vssd1 vssd1 vccd1 vccd1 _3480_ sky130_fd_sc_hd__o21a_1
X_5424_ _0606_ _0612_ vssd1 vssd1 vccd1 vccd1 _0614_ sky130_fd_sc_hd__xor2_1
X_8143_ _3404_ _3405_ vssd1 vssd1 vccd1 vccd1 _3406_ sky130_fd_sc_hd__nor2_2
X_5355_ _0542_ _0544_ vssd1 vssd1 vccd1 vccd1 _0545_ sky130_fd_sc_hd__or2_1
X_8074_ _3325_ _3330_ vssd1 vssd1 vccd1 vccd1 _3331_ sky130_fd_sc_hd__nand2_1
X_4306_ net260 net8 net172 vssd1 vssd1 vccd1 vccd1 _0029_ sky130_fd_sc_hd__mux2_1
X_5286_ _0474_ _0475_ vssd1 vssd1 vccd1 vccd1 _0476_ sky130_fd_sc_hd__nand2_1
XANTENNA__7052__B net296 vssd1 vssd1 vccd1 vccd1 sky130_fd_sc_hd__diode_2
X_7025_ _1906_ _1914_ _2241_ vssd1 vssd1 vccd1 vccd1 _2243_ sky130_fd_sc_hd__a21o_1
X_4237_ net12 net167 _2537_ vssd1 vssd1 vccd1 vccd1 _2548_ sky130_fd_sc_hd__o21ai_1
XANTENNA__4295__A1 net14 vssd1 vssd1 vccd1 vccd1 sky130_fd_sc_hd__diode_2
XFILLER_28_514 vccd1 vssd1 vccd1 vssd1 sky130_ef_sc_hd__decap_40_12
X_4168_ net12 net174 _1806_ vssd1 vssd1 vccd1 vccd1 _1817_ sky130_fd_sc_hd__o21ai_4
XFILLER_82_152 vssd1 vssd1 vccd1 vccd1 sky130_fd_sc_hd__fill_1
XFILLER_82_141 vssd1 vssd1 vccd1 vccd1 sky130_fd_sc_hd__fill_8
XTAP_TAPCELL_ROW_66_862 vssd1 vccd1 sky130_fd_sc_hd__tapvpwrvgnd_1
XANTENNA__4692__A net132 vssd1 vssd1 vccd1 vccd1 sky130_fd_sc_hd__diode_2
XFILLER_28_569 vssd1 vssd1 vccd1 vccd1 sky130_fd_sc_hd__fill_1
X_7927_ _3180_ _3181_ vssd1 vssd1 vccd1 vccd1 _3182_ sky130_fd_sc_hd__xnor2_1
XFILLER_43_528 vccd1 vssd1 vccd1 vssd1 sky130_ef_sc_hd__decap_40_12
X_7858_ _3112_ _3113_ _3053_ vssd1 vssd1 vccd1 vccd1 _3114_ sky130_fd_sc_hd__a21o_1
X_6809_ _2009_ _2012_ vssd1 vssd1 vccd1 vccd1 _2013_ sky130_fd_sc_hd__xor2_1
XFILLER_11_414 vssd1 vssd1 vccd1 vccd1 sky130_fd_sc_hd__fill_1
XANTENNA__6744__B1 net278 vssd1 vssd1 vccd1 vccd1 sky130_fd_sc_hd__diode_2
X_7789_ _2948_ _2951_ _2947_ vssd1 vssd1 vccd1 vccd1 _3045_ sky130_fd_sc_hd__o21ba_1
XFILLER_23_285 vssd1 vssd1 vccd1 vccd1 sky130_fd_sc_hd__fill_1
XFILLER_23_296 vccd1 vssd1 vccd1 vssd1 sky130_ef_sc_hd__decap_40_12
XFILLER_7_429 vssd1 vssd1 vccd1 vccd1 sky130_fd_sc_hd__fill_1
XANTENNA__5673__D net219 vssd1 vssd1 vccd1 vccd1 sky130_fd_sc_hd__diode_2
XANTENNA__7227__B net40 vssd1 vssd1 vccd1 vccd1 sky130_fd_sc_hd__diode_2
XANTENNA__4522__A2 net86 vssd1 vssd1 vccd1 vccd1 sky130_fd_sc_hd__diode_2
XFILLER_3_3 vssd1 vssd1 vccd1 vccd1 sky130_fd_sc_hd__fill_4
XFILLER_2_145 vssd1 vssd1 vccd1 vccd1 sky130_fd_sc_hd__fill_1
XFILLER_2_156 vssd1 vssd1 vccd1 vccd1 sky130_fd_sc_hd__fill_2
XANTENNA__8339__A net98 vssd1 vssd1 vccd1 vccd1 sky130_fd_sc_hd__diode_2
XANTENNA_fanout83_X net83 vssd1 vssd1 vccd1 vccd1 sky130_fd_sc_hd__diode_2
XFILLER_19_503 vssd1 vssd1 vccd1 vccd1 sky130_fd_sc_hd__fill_1
XFILLER_86_491 vssd1 vssd1 vccd1 vccd1 sky130_fd_sc_hd__fill_1
XFILLER_0_15 vssd1 vssd1 vccd1 vccd1 sky130_fd_sc_hd__fill_8
XFILLER_46_355 vssd1 vssd1 vccd1 vccd1 sky130_fd_sc_hd__fill_4
XFILLER_19_569 vssd1 vssd1 vccd1 vccd1 sky130_fd_sc_hd__fill_1
XFILLER_61_347 vssd1 vssd1 vccd1 vccd1 sky130_fd_sc_hd__fill_1
XANTENNA__7137__B net195 vssd1 vssd1 vccd1 vccd1 sky130_fd_sc_hd__diode_2
XANTENNA__6041__B net223 vssd1 vssd1 vccd1 vccd1 sky130_fd_sc_hd__diode_2
XFILLER_6_451 vccd1 vssd1 vccd1 vssd1 sky130_ef_sc_hd__decap_40_12
X_5140_ _0233_ _0244_ _0246_ vssd1 vssd1 vccd1 vccd1 _0330_ sky130_fd_sc_hd__a21bo_1
X_5071_ _0181_ _0258_ _0260_ vssd1 vssd1 vccd1 vccd1 _0261_ sky130_fd_sc_hd__o21a_1
XANTENNA__4277__A1 net407 vssd1 vssd1 vccd1 vccd1 sky130_fd_sc_hd__diode_2
XFILLER_92_461 vccd1 vssd1 vccd1 vssd1 sky130_ef_sc_hd__decap_40_12
XFILLER_25_517 vssd1 vssd1 vccd1 vccd1 sky130_fd_sc_hd__fill_4
X_5973_ _0521_ _1161_ _1162_ vssd1 vssd1 vccd1 vccd1 _1163_ sky130_fd_sc_hd__a21o_1
XTAP_TAPCELL_ROW_63_832 vssd1 vccd1 sky130_fd_sc_hd__tapvpwrvgnd_1
X_7712_ _2882_ _2968_ vssd1 vssd1 vccd1 vccd1 _2969_ sky130_fd_sc_hd__and2b_1
XANTENNA__5120__B net63 vssd1 vssd1 vccd1 vccd1 sky130_fd_sc_hd__diode_2
X_4924_ net166 net151 vssd1 vssd1 vccd1 vccd1 _0114_ sky130_fd_sc_hd__nand2_1
X_7643_ _2894_ _2895_ vssd1 vssd1 vccd1 vccd1 _2896_ sky130_fd_sc_hd__xnor2_1
X_4855_ _4131_ _4132_ vssd1 vssd1 vccd1 vccd1 _4133_ sky130_fd_sc_hd__or2_1
XANTENNA__6232__A net200 vssd1 vssd1 vccd1 vccd1 sky130_fd_sc_hd__diode_2
XANTENNA_fanout228_A net229 vssd1 vssd1 vccd1 vccd1 sky130_fd_sc_hd__diode_2
X_4786_ _2051_ _3734_ vssd1 vssd1 vccd1 vccd1 _4064_ sky130_fd_sc_hd__nor2_1
XANTENNA_fanout130_A net131 vssd1 vssd1 vccd1 vccd1 sky130_fd_sc_hd__diode_2
X_7574_ _2745_ _2746_ _2749_ vssd1 vssd1 vccd1 vccd1 _2822_ sky130_fd_sc_hd__o21a_1
XANTENNA__7047__B net193 vssd1 vssd1 vccd1 vccd1 sky130_fd_sc_hd__diode_2
X_6525_ _1710_ _1711_ vssd1 vssd1 vccd1 vccd1 _1712_ sky130_fd_sc_hd__nor2_1
X_6456_ _1642_ _1643_ vssd1 vssd1 vccd1 vccd1 _1644_ sky130_fd_sc_hd__xnor2_1
X_5407_ _0590_ _0596_ vssd1 vssd1 vccd1 vccd1 _0597_ sky130_fd_sc_hd__and2b_1
XANTENNA__4687__A net109 vssd1 vssd1 vccd1 vccd1 sky130_fd_sc_hd__diode_2
X_6387_ _1376_ _1378_ vssd1 vssd1 vccd1 vccd1 _1575_ sky130_fd_sc_hd__nor2_1
X_8126_ _3229_ _3232_ _3385_ vssd1 vssd1 vccd1 vccd1 _3388_ sky130_fd_sc_hd__and3_1
X_5338_ net123 net68 vssd1 vssd1 vccd1 vccd1 _0528_ sky130_fd_sc_hd__nand2_1
X_8057_ _3311_ _3312_ vssd1 vssd1 vccd1 vccd1 _3313_ sky130_fd_sc_hd__xnor2_1
X_5269_ _0457_ _0458_ vssd1 vssd1 vccd1 vccd1 _0459_ sky130_fd_sc_hd__xor2_1
X_7008_ _2115_ _2222_ vssd1 vssd1 vccd1 vccd1 _2224_ sky130_fd_sc_hd__xor2_1
XFILLER_87_299 vssd1 vssd1 vccd1 vccd1 sky130_fd_sc_hd__fill_8
XFILLER_18_66 vssd1 vssd1 vccd1 vccd1 sky130_fd_sc_hd__fill_1
XTAP_TAPCELL_ROW_87_1075 vssd1 vccd1 sky130_fd_sc_hd__tapvpwrvgnd_1
XFILLER_28_388 vssd1 vssd1 vccd1 vccd1 sky130_fd_sc_hd__fill_1
XFILLER_43_369 vssd1 vssd1 vccd1 vccd1 sky130_fd_sc_hd__fill_1
XFILLER_51_391 vssd1 vssd1 vccd1 vccd1 sky130_fd_sc_hd__fill_1
XANTENNA__6142__A net163 vssd1 vssd1 vccd1 vccd1 sky130_fd_sc_hd__diode_2
XFILLER_11_277 vssd1 vssd1 vccd1 vccd1 sky130_fd_sc_hd__fill_2
XFILLER_3_443 vssd1 vssd1 vccd1 vccd1 sky130_fd_sc_hd__fill_4
XFILLER_78_233 vccd1 vssd1 vccd1 vssd1 sky130_ef_sc_hd__decap_40_12
Xfanout290 net292 vssd1 vssd1 vccd1 vccd1 net290 sky130_fd_sc_hd__clkbuf_2
XFILLER_81_409 vssd1 vssd1 vccd1 vccd1 sky130_fd_sc_hd__fill_2
XTAP_TAPCELL_ROW_77_968 vssd1 vccd1 sky130_fd_sc_hd__tapvpwrvgnd_1
XFILLER_75_83 vssd1 vssd1 vccd1 vccd1 sky130_fd_sc_hd__fill_1
XTAP_TAPCELL_ROW_60_802 vssd1 vccd1 sky130_fd_sc_hd__tapvpwrvgnd_1
XFILLER_15_561 vssd1 vssd1 vccd1 vccd1 sky130_fd_sc_hd__fill_8
XFILLER_30_531 vssd1 vssd1 vccd1 vccd1 sky130_fd_sc_hd__fill_1
X_4640_ _3906_ _3917_ vssd1 vssd1 vccd1 vccd1 _3918_ sky130_fd_sc_hd__xnor2_1
X_4571_ net122 net86 _3737_ vssd1 vssd1 vccd1 vccd1 _3849_ sky130_fd_sc_hd__a21o_1
X_6310_ _1495_ _1496_ vssd1 vssd1 vccd1 vccd1 _1498_ sky130_fd_sc_hd__and2_1
X_7290_ _2513_ _2520_ vssd1 vssd1 vccd1 vccd1 _2522_ sky130_fd_sc_hd__xor2_1
X_6241_ _1428_ _1429_ vssd1 vssd1 vccd1 vccd1 _1430_ sky130_fd_sc_hd__nor2_1
XFILLER_6_281 vssd1 vssd1 vccd1 vccd1 sky130_fd_sc_hd__fill_1
X_6172_ _1351_ _1360_ vssd1 vssd1 vccd1 vccd1 _1361_ sky130_fd_sc_hd__and2_1
X_5123_ _4160_ _0309_ _0312_ vssd1 vssd1 vccd1 vccd1 _0313_ sky130_fd_sc_hd__a21o_1
XFILLER_57_439 vssd1 vssd1 vccd1 vccd1 sky130_fd_sc_hd__fill_1
X_5054_ _0237_ _0243_ vssd1 vssd1 vccd1 vccd1 _0244_ sky130_fd_sc_hd__xnor2_1
XFILLER_72_409 vssd1 vssd1 vccd1 vccd1 sky130_fd_sc_hd__fill_8
XFILLER_37_130 vssd1 vssd1 vccd1 vccd1 sky130_fd_sc_hd__fill_4
XANTENNA__7739__A2 net183 vssd1 vssd1 vccd1 vccd1 sky130_fd_sc_hd__diode_2
XFILLER_65_472 vssd1 vssd1 vccd1 vccd1 sky130_fd_sc_hd__fill_1
XTAP_TAPCELL_ROW_48_681 vssd1 vccd1 sky130_fd_sc_hd__tapvpwrvgnd_1
XFILLER_25_303 vssd1 vssd1 vccd1 vccd1 sky130_fd_sc_hd__fill_1
XANTENNA__4970__A _2210_ vssd1 vssd1 vccd1 vccd1 sky130_fd_sc_hd__diode_2
X_5956_ _0499_ _0500_ _0497_ vssd1 vssd1 vccd1 vccd1 _1146_ sky130_fd_sc_hd__a21o_1
X_5887_ net245 net311 _1076_ vssd1 vssd1 vccd1 vccd1 _1077_ sky130_fd_sc_hd__nand3_1
X_4907_ _4105_ _0095_ vssd1 vssd1 vccd1 vccd1 _0097_ sky130_fd_sc_hd__xor2_1
XFILLER_33_391 vssd1 vssd1 vccd1 vccd1 sky130_fd_sc_hd__fill_1
X_7626_ _2877_ vssd1 vssd1 vccd1 vccd1 _2878_ sky130_fd_sc_hd__inv_2
XANTENNA_clkbuf_4_0_0_clk_X clknet_4_0_0_clk vssd1 vssd1 vccd1 vccd1 sky130_fd_sc_hd__diode_2
X_4838_ net129 net79 vssd1 vssd1 vccd1 vccd1 _4116_ sky130_fd_sc_hd__nand2_1
X_4769_ net125 net82 _3757_ _2146_ vssd1 vssd1 vccd1 vccd1 _4047_ sky130_fd_sc_hd__o2bb2a_1
X_7557_ _2546_ _2550_ _2804_ vssd1 vssd1 vccd1 vccd1 _2805_ sky130_fd_sc_hd__and3_1
X_7488_ _2729_ _2730_ vssd1 vssd1 vccd1 vccd1 _2732_ sky130_fd_sc_hd__and2_1
X_6508_ net165 net76 _1693_ vssd1 vssd1 vccd1 vccd1 _1695_ sky130_fd_sc_hd__a21oi_1
X_6439_ net216 net291 _1625_ vssd1 vssd1 vccd1 vccd1 _1627_ sky130_fd_sc_hd__a21oi_1
X_8109_ _3218_ _3221_ _3219_ vssd1 vssd1 vccd1 vccd1 _3369_ sky130_fd_sc_hd__o21ba_1
XFILLER_0_446 vssd1 vssd1 vccd1 vccd1 sky130_fd_sc_hd__fill_2
Xhold10 PID_INST.k1_calc.d1.x\[5\] vssd1 vssd1 vccd1 vccd1 net403 sky130_fd_sc_hd__dlygate4sd3_1
XFILLER_48_406 vssd1 vssd1 vccd1 vccd1 sky130_fd_sc_hd__fill_8
Xhold32 PID_INST.k3_calc.timescaling_term\[15\] vssd1 vssd1 vccd1 vccd1 net425 sky130_fd_sc_hd__dlygate4sd3_1
Xhold21 net28 vssd1 vssd1 vccd1 vccd1 net414 sky130_fd_sc_hd__dlygate4sd3_1
XFILLER_75_214 vssd1 vssd1 vccd1 vccd1 sky130_fd_sc_hd__fill_4
XFILLER_75_269 vssd1 vssd1 vccd1 vccd1 sky130_fd_sc_hd__fill_8
XTAP_TAPCELL_ROW_74_938 vssd1 vccd1 sky130_fd_sc_hd__tapvpwrvgnd_1
XFILLER_56_461 vssd1 vssd1 vccd1 vccd1 sky130_fd_sc_hd__fill_4
XFILLER_90_239 vccd1 vssd1 vccd1 vssd1 sky130_ef_sc_hd__decap_40_12
XFILLER_56_494 vssd1 vssd1 vccd1 vccd1 sky130_fd_sc_hd__fill_1
XFILLER_16_325 vssd1 vssd1 vccd1 vccd1 sky130_fd_sc_hd__fill_2
XFILLER_16_347 vccd1 vssd1 vccd1 vssd1 sky130_ef_sc_hd__decap_40_12
XFILLER_71_453 vssd1 vssd1 vccd1 vccd1 sky130_fd_sc_hd__fill_1
XANTENNA__4880__A net118 vssd1 vssd1 vccd1 vccd1 sky130_fd_sc_hd__diode_2
XFILLER_43_144 vssd1 vssd1 vccd1 vccd1 sky130_fd_sc_hd__fill_1
XANTENNA__4277__B1_N _2961_ vssd1 vssd1 vccd1 vccd1 sky130_fd_sc_hd__diode_2
XFILLER_8_502 vssd1 vssd1 vccd1 vccd1 sky130_fd_sc_hd__fill_2
XFILLER_12_531 vssd1 vssd1 vccd1 vccd1 sky130_fd_sc_hd__fill_1
XFILLER_12_564 vssd1 vssd1 vccd1 vccd1 sky130_fd_sc_hd__fill_4
XFILLER_8_568 vssd1 vssd1 vccd1 vccd1 sky130_fd_sc_hd__fill_2
XANTENNA__7115__B1 net188 vssd1 vssd1 vccd1 vccd1 sky130_fd_sc_hd__diode_2
XANTENNA__7666__A1 net202 vssd1 vssd1 vccd1 vccd1 sky130_fd_sc_hd__diode_2
XANTENNA__7666__B2 net214 vssd1 vssd1 vccd1 vccd1 sky130_fd_sc_hd__diode_2
XFILLER_3_251 vssd1 vssd1 vccd1 vccd1 sky130_fd_sc_hd__fill_1
XFILLER_3_240 vssd1 vssd1 vccd1 vccd1 sky130_fd_sc_hd__fill_1
XANTENNA__5216__A net162 vssd1 vssd1 vccd1 vccd1 sky130_fd_sc_hd__diode_2
XANTENNA__7134__C net285 vssd1 vssd1 vccd1 vccd1 sky130_fd_sc_hd__diode_2
XFILLER_20_6 vssd1 vssd1 vccd1 vccd1 sky130_fd_sc_hd__fill_4
XFILLER_39_428 vssd1 vssd1 vccd1 vccd1 sky130_fd_sc_hd__fill_2
XFILLER_34_100 vssd1 vssd1 vccd1 vccd1 sky130_fd_sc_hd__fill_2
XFILLER_81_239 vssd1 vssd1 vccd1 vccd1 sky130_fd_sc_hd__fill_4
XFILLER_62_475 vssd1 vssd1 vccd1 vccd1 sky130_fd_sc_hd__fill_1
X_5810_ _0991_ _0998_ _0999_ vssd1 vssd1 vccd1 vccd1 _1000_ sky130_fd_sc_hd__nor3_1
XTAP_TAPCELL_ROW_45_651 vssd1 vccd1 sky130_fd_sc_hd__tapvpwrvgnd_1
XFILLER_22_306 vssd1 vssd1 vccd1 vccd1 sky130_fd_sc_hd__fill_2
XFILLER_34_166 vssd1 vssd1 vccd1 vccd1 sky130_fd_sc_hd__fill_1
X_6790_ net135 _0156_ vssd1 vssd1 vccd1 vccd1 _1993_ sky130_fd_sc_hd__nand2_1
X_5741_ _0899_ _0901_ vssd1 vssd1 vccd1 vccd1 _0931_ sky130_fd_sc_hd__or2_1
XFILLER_62_486 vccd1 vssd1 vccd1 vssd1 sky130_ef_sc_hd__decap_40_12
XFILLER_15_380 vssd1 vssd1 vccd1 vccd1 sky130_fd_sc_hd__fill_4
XTAP_TAPCELL_ROW_17_375 vssd1 vccd1 sky130_fd_sc_hd__tapvpwrvgnd_1
X_8460_ clknet_4_7_0_clk _0048_ net332 vssd1 vssd1 vccd1 vccd1 PID_INST.k2_calc.sum_reg\[16\]
+ sky130_fd_sc_hd__dfrtp_1
XANTENNA__8412__D net142 vssd1 vssd1 vccd1 vccd1 sky130_fd_sc_hd__diode_2
X_5672_ net324 net224 vssd1 vssd1 vccd1 vccd1 _0862_ sky130_fd_sc_hd__nand2_1
X_7411_ net414 _2650_ net155 vssd1 vssd1 vccd1 vccd1 _0067_ sky130_fd_sc_hd__mux2_1
X_4623_ _3895_ _3896_ vssd1 vssd1 vccd1 vccd1 _3901_ sky130_fd_sc_hd__nand2_1
X_8391_ clknet_4_8_0_clk PID_INST.k3_calc.d2.y\[11\] net340 vssd1 vssd1 vccd1 vccd1
+ PID_INST.k3_calc.timescaling_term\[11\] sky130_fd_sc_hd__dfrtp_1
X_7342_ _2321_ _2328_ _2575_ vssd1 vssd1 vccd1 vccd1 _2577_ sky130_fd_sc_hd__nand3_1
X_4554_ net148 _3774_ vssd1 vssd1 vccd1 vccd1 _3832_ sky130_fd_sc_hd__nor2_1
X_7273_ net97 net46 _2182_ vssd1 vssd1 vccd1 vccd1 _2503_ sky130_fd_sc_hd__or3b_1
X_6224_ net243 net265 net240 net269 vssd1 vssd1 vccd1 vccd1 _1413_ sky130_fd_sc_hd__a22oi_1
X_4485_ _3739_ _3740_ _3744_ vssd1 vssd1 vccd1 vccd1 _3763_ sky130_fd_sc_hd__and3_1
XANTENNA__4340__A0 net230 vssd1 vssd1 vccd1 vccd1 sky130_fd_sc_hd__diode_2
XFILLER_85_501 vssd1 vssd1 vccd1 vccd1 sky130_fd_sc_hd__fill_2
XANTENNA_fanout295_A net296 vssd1 vssd1 vccd1 vccd1 sky130_fd_sc_hd__diode_2
X_6155_ _1148_ _1343_ vssd1 vssd1 vccd1 vccd1 _1344_ sky130_fd_sc_hd__xnor2_1
X_6086_ _1267_ _1268_ _1273_ vssd1 vssd1 vccd1 vccd1 _1276_ sky130_fd_sc_hd__o21ai_1
XFILLER_57_214 vssd1 vssd1 vccd1 vccd1 sky130_fd_sc_hd__fill_1
X_5106_ _0293_ _0294_ vssd1 vssd1 vccd1 vccd1 _0296_ sky130_fd_sc_hd__xor2_1
XANTENNA__4176__S net173 vssd1 vssd1 vccd1 vccd1 sky130_fd_sc_hd__diode_2
X_5037_ net116 net54 vssd1 vssd1 vccd1 vccd1 _0227_ sky130_fd_sc_hd__nor2_1
XANTENNA__5499__C net273 vssd1 vssd1 vccd1 vccd1 sky130_fd_sc_hd__diode_2
XFILLER_82_29 vssd1 vssd1 vccd1 vccd1 sky130_fd_sc_hd__fill_1
XFILLER_82_18 vssd1 vssd1 vccd1 vccd1 sky130_fd_sc_hd__fill_8
XTAP_TAPCELL_ROW_71_908 vssd1 vccd1 sky130_fd_sc_hd__tapvpwrvgnd_1
XTAP_TAPCELL_ROW_84_1045 vssd1 vccd1 sky130_fd_sc_hd__tapvpwrvgnd_1
XFILLER_53_475 vssd1 vssd1 vccd1 vccd1 sky130_fd_sc_hd__fill_4
XFILLER_80_272 vssd1 vssd1 vccd1 vccd1 sky130_fd_sc_hd__fill_4
XFILLER_13_339 vssd1 vssd1 vccd1 vccd1 sky130_fd_sc_hd__fill_4
X_6988_ _2202_ _2196_ vssd1 vssd1 vccd1 vccd1 _2203_ sky130_fd_sc_hd__nand2b_1
X_5939_ _0407_ _0485_ _0483_ vssd1 vssd1 vccd1 vccd1 _1129_ sky130_fd_sc_hd__o21a_1
XFILLER_21_361 vssd1 vssd1 vccd1 vccd1 sky130_fd_sc_hd__fill_8
X_7609_ _2859_ _2860_ vssd1 vssd1 vccd1 vccd1 _2861_ sky130_fd_sc_hd__xor2_1
XFILLER_31_66 vssd1 vssd1 vccd1 vccd1 sky130_fd_sc_hd__fill_1
Xclkbuf_4_10_0_clk clknet_0_clk vssd1 vssd1 vccd1 vccd1 clknet_4_10_0_clk sky130_fd_sc_hd__clkbuf_8
XANTENNA__4859__B net85 vssd1 vssd1 vccd1 vccd1 sky130_fd_sc_hd__diode_2
Xoutput22 net22 vssd1 vssd1 vccd1 vccd1 gpio_out[19] sky130_fd_sc_hd__buf_2
Xoutput33 net33 vssd1 vssd1 vccd1 vccd1 gpio_out[30] sky130_fd_sc_hd__buf_2
XANTENNA__4211__Y _2274_ vssd1 vssd1 vccd1 vccd1 sky130_fd_sc_hd__diode_2
XFILLER_88_361 vssd1 vssd1 vccd1 vccd1 sky130_fd_sc_hd__fill_2
XFILLER_0_243 vssd1 vssd1 vccd1 vccd1 sky130_fd_sc_hd__fill_1
XFILLER_48_214 vssd1 vssd1 vccd1 vccd1 sky130_fd_sc_hd__fill_1
XFILLER_76_545 vssd1 vssd1 vccd1 vccd1 sky130_fd_sc_hd__fill_8
XTAP_TAPCELL_ROW_59_787 vssd1 vccd1 sky130_fd_sc_hd__tapvpwrvgnd_1
XANTENNA__4634__B2 net147 vssd1 vssd1 vccd1 vccd1 sky130_fd_sc_hd__diode_2
XFILLER_91_559 vssd1 vssd1 vccd1 vccd1 sky130_fd_sc_hd__fill_1
XFILLER_56_85 vssd1 vssd1 vccd1 vccd1 sky130_fd_sc_hd__fill_8
XFILLER_44_431 vssd1 vssd1 vccd1 vccd1 sky130_fd_sc_hd__fill_1
XFILLER_44_464 vssd1 vssd1 vccd1 vccd1 sky130_fd_sc_hd__fill_4
XFILLER_31_125 vssd1 vssd1 vccd1 vccd1 sky130_fd_sc_hd__fill_8
XTAP_TAPCELL_ROW_42_621 vssd1 vccd1 sky130_fd_sc_hd__tapvpwrvgnd_1
XFILLER_72_73 vssd1 vssd1 vccd1 vccd1 sky130_fd_sc_hd__fill_2
XTAP_TAPCELL_ROW_14_345 vssd1 vccd1 sky130_fd_sc_hd__tapvpwrvgnd_1
XANTENNA__4937__A2 net86 vssd1 vssd1 vccd1 vccd1 sky130_fd_sc_hd__diode_2
XFILLER_8_332 vssd1 vssd1 vccd1 vccd1 sky130_fd_sc_hd__fill_4
XFILLER_8_365 vssd1 vssd1 vccd1 vccd1 sky130_fd_sc_hd__fill_4
X_4270_ net11 _2823_ _2834_ _2887_ vssd1 vssd1 vccd1 vccd1 PID_INST.pid.next_state\[2\]
+ sky130_fd_sc_hd__a31o_1
XFILLER_39_203 vssd1 vssd1 vccd1 vccd1 sky130_fd_sc_hd__fill_1
X_7960_ _2688_ _3214_ _3213_ vssd1 vssd1 vccd1 vccd1 _3215_ sky130_fd_sc_hd__o21ai_1
X_6911_ _2020_ _2021_ _2023_ vssd1 vssd1 vccd1 vccd1 _2121_ sky130_fd_sc_hd__o21a_1
X_7891_ _3076_ _3144_ vssd1 vssd1 vccd1 vccd1 _3146_ sky130_fd_sc_hd__xor2_1
XANTENNA__6505__A net162 vssd1 vssd1 vccd1 vccd1 sky130_fd_sc_hd__diode_2
X_6842_ _2037_ _2046_ vssd1 vssd1 vccd1 vccd1 _2048_ sky130_fd_sc_hd__xnor2_2
X_6773_ _1873_ _1883_ _1972_ vssd1 vssd1 vccd1 vccd1 _1974_ sky130_fd_sc_hd__nand3_1
X_5724_ _0887_ _0890_ _0902_ vssd1 vssd1 vccd1 vccd1 _0914_ sky130_fd_sc_hd__nand3_1
XFILLER_50_489 vssd1 vssd1 vccd1 vccd1 sky130_fd_sc_hd__fill_2
X_8443_ clknet_4_6_0_clk net394 net337 vssd1 vssd1 vccd1 vccd1 PID_INST.k3_calc.prev_error\[15\]
+ sky130_fd_sc_hd__dfrtp_1
X_5655_ _0841_ _0844_ vssd1 vssd1 vccd1 vccd1 _0845_ sky130_fd_sc_hd__nand2_1
XFILLER_30_191 vssd1 vssd1 vccd1 vccd1 sky130_fd_sc_hd__fill_1
XANTENNA__7878__B2 net101 vssd1 vssd1 vccd1 vccd1 sky130_fd_sc_hd__diode_2
XANTENNA__7336__A net317 vssd1 vssd1 vccd1 vccd1 sky130_fd_sc_hd__diode_2
XANTENNA_fanout210_A net212 vssd1 vssd1 vccd1 vccd1 sky130_fd_sc_hd__diode_2
X_8374_ clknet_4_7_0_clk _0010_ net332 vssd1 vssd1 vccd1 vccd1 PID_INST.k1_calc.d1.x\[10\]
+ sky130_fd_sc_hd__dfrtp_1
X_4606_ _3877_ _3878_ _3879_ vssd1 vssd1 vccd1 vccd1 _3884_ sky130_fd_sc_hd__a21o_1
X_5586_ net283 net235 net240 net278 vssd1 vssd1 vccd1 vccd1 _0776_ sky130_fd_sc_hd__a22oi_1
X_7325_ net268 net264 net214 net218 vssd1 vssd1 vccd1 vccd1 _2559_ sky130_fd_sc_hd__and4_1
XANTENNA_fanout308_A net309 vssd1 vssd1 vccd1 vccd1 sky130_fd_sc_hd__diode_2
X_4537_ _3808_ _3813_ vssd1 vssd1 vccd1 vccd1 _3815_ sky130_fd_sc_hd__xor2_1
XFILLER_89_125 vssd1 vssd1 vccd1 vccd1 sky130_fd_sc_hd__fill_1
X_4468_ PID_INST.k1_calc.d1.x\[5\] PID_INST.k3_calc.prev_error\[5\] vssd1 vssd1 vccd1
+ vccd1 _3746_ sky130_fd_sc_hd__and2_1
X_7256_ _2418_ _2483_ vssd1 vssd1 vccd1 vccd1 _2486_ sky130_fd_sc_hd__nand2_1
XANTENNA__4966__Y _0156_ vssd1 vssd1 vccd1 vccd1 sky130_fd_sc_hd__diode_2
XFILLER_89_169 vssd1 vssd1 vccd1 vccd1 sky130_fd_sc_hd__fill_4
X_6207_ net108 net44 net43 net106 vssd1 vssd1 vccd1 vccd1 _1396_ sky130_fd_sc_hd__o22a_1
X_7187_ _2411_ _2412_ vssd1 vssd1 vccd1 vccd1 _2413_ sky130_fd_sc_hd__xnor2_1
X_4399_ _3685_ _3687_ _3684_ vssd1 vssd1 vccd1 vccd1 _3690_ sky130_fd_sc_hd__a21o_1
X_6138_ _1324_ _1325_ vssd1 vssd1 vccd1 vccd1 _1327_ sky130_fd_sc_hd__xnor2_1
X_6069_ _0801_ _1257_ vssd1 vssd1 vccd1 vccd1 _1259_ sky130_fd_sc_hd__nand2_1
XANTENNA__4616__A1 net120 vssd1 vssd1 vccd1 vccd1 sky130_fd_sc_hd__diode_2
XFILLER_73_559 vssd1 vssd1 vccd1 vccd1 sky130_fd_sc_hd__fill_1
XTAP_TAPCELL_ROW_56_757 vssd1 vccd1 sky130_fd_sc_hd__tapvpwrvgnd_1
XANTENNA__4616__B2 net113 vssd1 vssd1 vccd1 vccd1 sky130_fd_sc_hd__diode_2
XANTENNA__7030__A2 net196 vssd1 vssd1 vccd1 vccd1 sky130_fd_sc_hd__diode_2
XFILLER_13_103 vssd1 vssd1 vccd1 vccd1 sky130_fd_sc_hd__fill_1
XFILLER_13_169 vssd1 vssd1 vccd1 vccd1 sky130_fd_sc_hd__fill_4
XTAP_TAPCELL_ROW_11_315 vssd1 vccd1 sky130_fd_sc_hd__tapvpwrvgnd_1
XFILLER_5_368 vssd1 vssd1 vccd1 vccd1 sky130_fd_sc_hd__fill_2
XFILLER_1_541 vccd1 vssd1 vccd1 vssd1 sky130_ef_sc_hd__decap_40_12
XFILLER_49_523 vssd1 vssd1 vccd1 vccd1 sky130_fd_sc_hd__fill_1
XANTENNA__7412__C net214 vssd1 vssd1 vccd1 vccd1 sky130_fd_sc_hd__diode_2
XANTENNA__5804__B1 net308 vssd1 vssd1 vccd1 vccd1 sky130_fd_sc_hd__diode_2
XFILLER_91_367 vssd1 vssd1 vccd1 vccd1 sky130_fd_sc_hd__fill_1
XANTENNA__4771__C net81 vssd1 vssd1 vccd1 vccd1 sky130_fd_sc_hd__diode_2
XFILLER_17_475 vssd1 vssd1 vccd1 vccd1 sky130_fd_sc_hd__fill_1
XFILLER_17_497 vssd1 vssd1 vccd1 vccd1 sky130_fd_sc_hd__fill_4
XANTENNA__6325__A net118 vssd1 vssd1 vccd1 vccd1 sky130_fd_sc_hd__diode_2
XTAP_TAPCELL_ROW_27_470 vssd1 vccd1 sky130_fd_sc_hd__tapvpwrvgnd_1
XFILLER_32_423 vssd1 vssd1 vccd1 vccd1 sky130_fd_sc_hd__fill_1
XPHY_EDGE_ROW_17_Left_110 vssd1 vssd1 vccd1 vccd1 sky130_fd_sc_hd__decap_3
XFILLER_32_434 vssd1 vssd1 vccd1 vccd1 sky130_fd_sc_hd__fill_8
XFILLER_32_489 vssd1 vssd1 vccd1 vccd1 sky130_fd_sc_hd__fill_1
XANTENNA__6060__A net220 vssd1 vssd1 vccd1 vccd1 sky130_fd_sc_hd__diode_2
X_5440_ _0608_ _0628_ vssd1 vssd1 vccd1 vccd1 _0630_ sky130_fd_sc_hd__nand2_1
XANTENNA__6532__A1 _2051_ vssd1 vssd1 vccd1 vccd1 sky130_fd_sc_hd__diode_2
XFILLER_8_195 vssd1 vssd1 vccd1 vccd1 sky130_fd_sc_hd__fill_1
X_5371_ net116 net64 vssd1 vssd1 vccd1 vccd1 _0561_ sky130_fd_sc_hd__or2_1
X_8090_ _3337_ _3348_ vssd1 vssd1 vccd1 vccd1 _3349_ sky130_fd_sc_hd__and2b_1
XANTENNA__8285__A1 net305 vssd1 vssd1 vccd1 vccd1 sky130_fd_sc_hd__diode_2
X_7110_ _2232_ _2239_ _2330_ vssd1 vssd1 vccd1 vccd1 _2331_ sky130_fd_sc_hd__a21o_1
X_4322_ net159 _3418_ vssd1 vssd1 vccd1 vccd1 _3429_ sky130_fd_sc_hd__nor2_1
X_7041_ _1917_ _1931_ _2258_ vssd1 vssd1 vccd1 vccd1 _2259_ sky130_fd_sc_hd__a21oi_1
X_4253_ _2707_ vssd1 vssd1 vccd1 vccd1 PID_INST.k3_calc.d2.y\[13\] sky130_fd_sc_hd__inv_2
Xfanout108 _2484_ vssd1 vssd1 vccd1 vccd1 net108 sky130_fd_sc_hd__clkbuf_4
Xfanout119 _2274_ vssd1 vssd1 vccd1 vccd1 net119 sky130_fd_sc_hd__clkbuf_4
XFILLER_67_342 vssd1 vssd1 vccd1 vccd1 sky130_fd_sc_hd__fill_2
X_4184_ net5 net173 _1976_ vssd1 vssd1 vccd1 vccd1 _1987_ sky130_fd_sc_hd__o21ai_4
XFILLER_82_345 vssd1 vssd1 vccd1 vccd1 sky130_fd_sc_hd__fill_8
X_7943_ net310 net298 net181 PID_INST.k2_calc.sum_reg\[22\] vssd1 vssd1 vccd1 vccd1
+ _3198_ sky130_fd_sc_hd__and4_1
XFILLER_82_367 vssd1 vssd1 vccd1 vccd1 sky130_fd_sc_hd__fill_1
XTAP_TAPCELL_ROW_81_1015 vssd1 vccd1 sky130_fd_sc_hd__tapvpwrvgnd_1
XANTENNA_fanout258_A net259 vssd1 vssd1 vccd1 vccd1 sky130_fd_sc_hd__diode_2
XTAP_TAPCELL_ROW_53_727 vssd1 vccd1 sky130_fd_sc_hd__tapvpwrvgnd_1
XFILLER_23_412 vssd1 vssd1 vccd1 vccd1 sky130_fd_sc_hd__fill_8
X_7874_ _3056_ _3059_ _3127_ vssd1 vssd1 vccd1 vccd1 _3129_ sky130_fd_sc_hd__nor3_1
XFILLER_35_250 vssd1 vssd1 vccd1 vccd1 sky130_fd_sc_hd__fill_1
X_6825_ _1991_ _2028_ vssd1 vssd1 vccd1 vccd1 _2030_ sky130_fd_sc_hd__xnor2_1
X_6756_ _1936_ _1954_ vssd1 vssd1 vccd1 vccd1 _1957_ sky130_fd_sc_hd__xnor2_1
XFILLER_10_106 vssd1 vssd1 vccd1 vccd1 sky130_fd_sc_hd__fill_8
X_5707_ _0698_ _0891_ _0896_ vssd1 vssd1 vccd1 vccd1 _0897_ sky130_fd_sc_hd__or3_1
X_6687_ _1661_ _1669_ vssd1 vssd1 vccd1 vccd1 _1885_ sky130_fd_sc_hd__nand2_1
XANTENNA_fanout213_X net213 vssd1 vssd1 vccd1 vccd1 sky130_fd_sc_hd__diode_2
X_5638_ _0827_ net210 net318 vssd1 vssd1 vccd1 vccd1 _0828_ sky130_fd_sc_hd__and3b_1
X_8426_ clknet_4_2_0_clk net163 net330 vssd1 vssd1 vccd1 vccd1 PID_INST.k3_calc.kd_term\[14\]
+ sky130_fd_sc_hd__dfrtp_1
XFILLER_12_79 vssd1 vssd1 vccd1 vccd1 sky130_fd_sc_hd__fill_1
XFILLER_88_17 vssd1 vssd1 vccd1 vccd1 sky130_fd_sc_hd__fill_1
X_5569_ _0744_ _0758_ vssd1 vssd1 vccd1 vccd1 _0759_ sky130_fd_sc_hd__xor2_1
X_8357_ _3551_ _3635_ vssd1 vssd1 vccd1 vccd1 _3636_ sky130_fd_sc_hd__xnor2_1
XTAP_TAPCELL_ROW_92_1133 vssd1 vccd1 sky130_fd_sc_hd__tapvpwrvgnd_1
XTAP_TAPCELL_ROW_92_1122 vssd1 vccd1 sky130_fd_sc_hd__tapvpwrvgnd_1
XFILLER_2_327 vssd1 vssd1 vccd1 vccd1 sky130_fd_sc_hd__fill_8
X_7308_ _2539_ _2540_ vssd1 vssd1 vccd1 vccd1 _2541_ sky130_fd_sc_hd__xor2_1
X_8288_ _3475_ _3476_ _3478_ vssd1 vssd1 vccd1 vccd1 _3561_ sky130_fd_sc_hd__a21oi_1
X_7239_ _2159_ _2212_ _2211_ vssd1 vssd1 vccd1 vccd1 _2468_ sky130_fd_sc_hd__a21boi_1
XANTENNA_fanout73_A net74 vssd1 vssd1 vccd1 vccd1 sky130_fd_sc_hd__diode_2
XFILLER_46_515 vssd1 vssd1 vccd1 vccd1 sky130_fd_sc_hd__fill_2
XFILLER_85_194 vssd1 vssd1 vccd1 vccd1 sky130_fd_sc_hd__fill_4
XTAP_TAPCELL_ROW_69_893 vssd1 vccd1 sky130_fd_sc_hd__tapvpwrvgnd_1
XFILLER_18_217 vccd1 vssd1 vccd1 vssd1 sky130_ef_sc_hd__decap_40_12
XFILLER_61_518 vssd1 vssd1 vccd1 vccd1 sky130_fd_sc_hd__fill_1
XFILLER_33_209 vssd1 vssd1 vccd1 vccd1 sky130_fd_sc_hd__fill_1
XFILLER_37_98 vssd1 vssd1 vccd1 vccd1 sky130_fd_sc_hd__fill_1
XANTENNA__8063__C net322 vssd1 vssd1 vccd1 vccd1 sky130_fd_sc_hd__diode_2
XFILLER_14_401 vssd1 vssd1 vccd1 vccd1 sky130_fd_sc_hd__fill_8
XFILLER_14_423 vssd1 vssd1 vccd1 vccd1 sky130_fd_sc_hd__fill_1
XFILLER_14_434 vssd1 vssd1 vccd1 vccd1 sky130_fd_sc_hd__fill_2
XFILLER_14_489 vssd1 vssd1 vccd1 vccd1 sky130_fd_sc_hd__fill_1
XTAP_TAPCELL_ROW_24_440 vssd1 vccd1 sky130_fd_sc_hd__tapvpwrvgnd_1
XFILLER_41_297 vssd1 vssd1 vccd1 vccd1 sky130_fd_sc_hd__fill_1
XFILLER_5_187 vssd1 vssd1 vccd1 vccd1 sky130_fd_sc_hd__fill_2
XFILLER_78_50 vssd1 vssd1 vccd1 vccd1 sky130_fd_sc_hd__fill_4
XANTENNA__7423__B net182 vssd1 vssd1 vccd1 vccd1 sky130_fd_sc_hd__diode_2
XFILLER_78_83 vssd1 vssd1 vccd1 vccd1 sky130_fd_sc_hd__fill_1
XANTENNA__4828__B2 net148 vssd1 vssd1 vccd1 vccd1 sky130_fd_sc_hd__diode_2
XFILLER_76_161 vccd1 vssd1 vccd1 vssd1 sky130_ef_sc_hd__decap_40_12
XFILLER_49_397 vssd1 vssd1 vccd1 vccd1 sky130_fd_sc_hd__fill_1
XFILLER_64_356 vssd1 vssd1 vccd1 vccd1 sky130_fd_sc_hd__fill_4
XANTENNA__6055__A net210 vssd1 vssd1 vccd1 vccd1 sky130_fd_sc_hd__diode_2
X_4940_ _0123_ _0129_ vssd1 vssd1 vccd1 vccd1 _0130_ sky130_fd_sc_hd__xor2_1
XFILLER_17_250 vssd1 vssd1 vccd1 vccd1 sky130_fd_sc_hd__fill_2
X_4871_ _4076_ _4078_ _4147_ _4148_ vssd1 vssd1 vccd1 vccd1 _4149_ sky130_fd_sc_hd__a211oi_2
XANTENNA__4787__A2_N net89 vssd1 vssd1 vccd1 vccd1 sky130_fd_sc_hd__diode_2
X_6610_ _1798_ _1799_ vssd1 vssd1 vccd1 vccd1 _1801_ sky130_fd_sc_hd__xor2_1
X_7590_ net100 net44 vssd1 vssd1 vccd1 vccd1 _2840_ sky130_fd_sc_hd__nor2_1
XFILLER_32_242 vssd1 vssd1 vccd1 vccd1 sky130_fd_sc_hd__fill_8
XANTENNA__5556__A2 net278 vssd1 vssd1 vccd1 vccd1 sky130_fd_sc_hd__diode_2
X_6541_ _1715_ _1727_ vssd1 vssd1 vccd1 vccd1 _1728_ sky130_fd_sc_hd__nand2_1
XFILLER_20_437 vccd1 vssd1 vccd1 vssd1 sky130_ef_sc_hd__decap_40_12
XFILLER_32_286 vccd1 vssd1 vccd1 vssd1 sky130_ef_sc_hd__decap_40_12
XANTENNA__8420__D net132 vssd1 vssd1 vccd1 vccd1 sky130_fd_sc_hd__diode_2
X_6472_ _1638_ _1658_ vssd1 vssd1 vccd1 vccd1 _1660_ sky130_fd_sc_hd__nor2_1
XTAP_TAPCELL_ROW_30_498 vssd1 vccd1 sky130_fd_sc_hd__tapvpwrvgnd_1
X_8211_ _3469_ _3477_ vssd1 vssd1 vccd1 vccd1 _3479_ sky130_fd_sc_hd__xnor2_1
X_5423_ _0588_ _0605_ _0612_ vssd1 vssd1 vccd1 vccd1 _0613_ sky130_fd_sc_hd__and3_1
X_8142_ _3254_ _3257_ _3403_ vssd1 vssd1 vccd1 vccd1 _3405_ sky130_fd_sc_hd__nor3_1
X_5354_ _0467_ _0469_ _0541_ vssd1 vssd1 vccd1 vccd1 _0544_ sky130_fd_sc_hd__and3_1
X_4305_ net264 net7 net171 vssd1 vssd1 vccd1 vccd1 _0028_ sky130_fd_sc_hd__mux2_1
X_8073_ _3328_ _3329_ vssd1 vssd1 vccd1 vccd1 _3330_ sky130_fd_sc_hd__xnor2_1
X_5285_ _0398_ _0401_ _0402_ _0473_ vssd1 vssd1 vccd1 vccd1 _0475_ sky130_fd_sc_hd__or4_1
X_7024_ _2239_ _2240_ vssd1 vssd1 vccd1 vccd1 _2241_ sky130_fd_sc_hd__nand2_1
XFILLER_59_139 vssd1 vssd1 vccd1 vccd1 sky130_fd_sc_hd__fill_1
X_4236_ PID_INST.k3_calc.timescaling_term\[0\] net169 vssd1 vssd1 vccd1 vccd1 _2537_
+ sky130_fd_sc_hd__or2_1
X_4167_ PID_INST.k3_calc.kd_term\[0\] _1784_ vssd1 vssd1 vccd1 vccd1 _1806_ sky130_fd_sc_hd__or2_1
XFILLER_28_526 vssd1 vssd1 vccd1 vccd1 sky130_fd_sc_hd__fill_4
XTAP_TAPCELL_ROW_66_863 vssd1 vccd1 sky130_fd_sc_hd__tapvpwrvgnd_1
XANTENNA__8164__B net40 vssd1 vssd1 vccd1 vccd1 sky130_fd_sc_hd__diode_2
XFILLER_82_175 vssd1 vssd1 vccd1 vccd1 sky130_fd_sc_hd__fill_4
X_7926_ net322 PID_INST.k2_calc.sum_reg\[24\] vssd1 vssd1 vccd1 vccd1 _3181_ sky130_fd_sc_hd__nand2_1
XFILLER_55_378 vssd1 vssd1 vccd1 vccd1 sky130_fd_sc_hd__fill_2
XANTENNA_fanout163_X net163 vssd1 vssd1 vccd1 vccd1 sky130_fd_sc_hd__diode_2
XTAP_TAPCELL_ROW_38_576 vssd1 vccd1 sky130_fd_sc_hd__tapvpwrvgnd_1
XFILLER_90_18 vssd1 vssd1 vccd1 vccd1 sky130_fd_sc_hd__fill_8
XFILLER_82_197 vccd1 vssd1 vccd1 vssd1 sky130_ef_sc_hd__decap_40_12
X_7857_ _2878_ _2881_ _3111_ vssd1 vssd1 vccd1 vccd1 _3113_ sky130_fd_sc_hd__a21o_1
XFILLER_90_29 vssd1 vssd1 vccd1 vccd1 sky130_fd_sc_hd__fill_8
X_6808_ _1692_ _1694_ _2011_ vssd1 vssd1 vccd1 vccd1 _2012_ sky130_fd_sc_hd__o21ai_1
X_7788_ _3042_ _3043_ vssd1 vssd1 vccd1 vccd1 _3044_ sky130_fd_sc_hd__nor2_1
XANTENNA__6744__A1 net215 vssd1 vssd1 vccd1 vccd1 sky130_fd_sc_hd__diode_2
XANTENNA__6744__B2 net219 vssd1 vssd1 vccd1 vccd1 sky130_fd_sc_hd__diode_2
XFILLER_11_426 vssd1 vssd1 vccd1 vccd1 sky130_fd_sc_hd__fill_2
XTAP_TAPCELL_ROW_21_410 vssd1 vccd1 sky130_fd_sc_hd__tapvpwrvgnd_1
X_6739_ net223 net235 net274 net261 vssd1 vssd1 vccd1 vccd1 _1938_ sky130_fd_sc_hd__and4_1
XANTENNA__8416__CLK clknet_4_0_0_clk vssd1 vssd1 vccd1 vccd1 sky130_fd_sc_hd__diode_2
X_8409_ clknet_4_6_0_clk _0029_ net337 vssd1 vssd1 vccd1 vccd1 PID_INST.k2_calc.reg_lc\[13\]
+ sky130_fd_sc_hd__dfrtp_1
XANTENNA__8339__B net37 vssd1 vssd1 vccd1 vccd1 sky130_fd_sc_hd__diode_2
XANTENNA__5979__A net125 vssd1 vssd1 vccd1 vccd1 sky130_fd_sc_hd__diode_2
XFILLER_58_161 vssd1 vssd1 vccd1 vccd1 sky130_fd_sc_hd__fill_1
XFILLER_73_131 vssd1 vssd1 vccd1 vccd1 sky130_fd_sc_hd__fill_2
XFILLER_0_27 vssd1 vssd1 vccd1 vccd1 sky130_fd_sc_hd__fill_1
XFILLER_64_63 vssd1 vssd1 vccd1 vccd1 sky130_fd_sc_hd__fill_1
XFILLER_61_337 vssd1 vssd1 vccd1 vccd1 sky130_fd_sc_hd__fill_4
XFILLER_14_220 vccd1 vssd1 vccd1 vssd1 sky130_ef_sc_hd__decap_40_12
XANTENNA__6025__D net199 vssd1 vssd1 vccd1 vccd1 sky130_fd_sc_hd__diode_2
XFILLER_80_40 vssd1 vssd1 vccd1 vccd1 sky130_fd_sc_hd__fill_1
Xfanout90 _2771_ vssd1 vssd1 vccd1 vccd1 net90 sky130_fd_sc_hd__buf_2
XFILLER_10_481 vssd1 vssd1 vccd1 vccd1 sky130_fd_sc_hd__fill_2
XFILLER_6_463 vssd1 vssd1 vccd1 vccd1 sky130_fd_sc_hd__fill_4
XFILLER_89_82 vssd1 vssd1 vccd1 vccd1 sky130_fd_sc_hd__fill_4
XTAP_TAPCELL_ROW_9_290 vssd1 vccd1 sky130_fd_sc_hd__tapvpwrvgnd_1
X_5070_ net162 net153 _3780_ net163 vssd1 vssd1 vccd1 vccd1 _0260_ sky130_fd_sc_hd__a22o_1
XFILLER_84_407 vssd1 vssd1 vccd1 vccd1 sky130_fd_sc_hd__fill_1
XANTENNA__8265__A _3536_ vssd1 vssd1 vccd1 vccd1 sky130_fd_sc_hd__diode_2
XFILLER_37_334 vssd1 vssd1 vccd1 vccd1 sky130_fd_sc_hd__fill_2
XFILLER_92_473 vssd1 vssd1 vccd1 vccd1 sky130_fd_sc_hd__fill_2
XFILLER_52_304 vssd1 vssd1 vccd1 vccd1 sky130_fd_sc_hd__fill_4
X_5972_ _2083_ net70 _0088_ _2114_ vssd1 vssd1 vccd1 vccd1 _1162_ sky130_fd_sc_hd__o22a_1
X_7711_ _2966_ _2967_ vssd1 vssd1 vccd1 vccd1 _2968_ sky130_fd_sc_hd__nor2_2
XTAP_TAPCELL_ROW_63_833 vssd1 vccd1 sky130_fd_sc_hd__tapvpwrvgnd_1
X_4923_ net166 net153 net151 net138 vssd1 vssd1 vccd1 vccd1 _0113_ sky130_fd_sc_hd__a22o_1
XTAP_TAPCELL_ROW_35_546 vssd1 vccd1 sky130_fd_sc_hd__tapvpwrvgnd_1
X_7642_ net317 net180 vssd1 vssd1 vccd1 vccd1 _2895_ sky130_fd_sc_hd__nand2_1
X_4854_ _4055_ _4058_ _4130_ vssd1 vssd1 vccd1 vccd1 _4132_ sky130_fd_sc_hd__nor3_1
XANTENNA__7328__B net182 vssd1 vssd1 vccd1 vccd1 sky130_fd_sc_hd__diode_2
X_4785_ _4061_ _4062_ vssd1 vssd1 vccd1 vccd1 _4063_ sky130_fd_sc_hd__nand2b_1
X_7573_ _2819_ _2820_ vssd1 vssd1 vccd1 vccd1 _2821_ sky130_fd_sc_hd__xnor2_1
X_6524_ _1703_ _1704_ _1709_ vssd1 vssd1 vccd1 vccd1 _1711_ sky130_fd_sc_hd__a21oi_1
XANTENNA__5129__A net114 vssd1 vssd1 vccd1 vccd1 sky130_fd_sc_hd__diode_2
X_6455_ net203 net307 vssd1 vssd1 vccd1 vccd1 _1643_ sky130_fd_sc_hd__and2_1
XANTENNA__8400__RESET_B net331 vssd1 vssd1 vccd1 vccd1 sky130_fd_sc_hd__diode_2
XANTENNA__4968__A net142 vssd1 vssd1 vccd1 vccd1 sky130_fd_sc_hd__diode_2
X_5406_ _0594_ _0595_ vssd1 vssd1 vccd1 vccd1 _0596_ sky130_fd_sc_hd__xnor2_1
XANTENNA__4687__B net65 vssd1 vssd1 vccd1 vccd1 sky130_fd_sc_hd__diode_2
X_6386_ _1571_ _1572_ vssd1 vssd1 vccd1 vccd1 _1574_ sky130_fd_sc_hd__xor2_1
X_8125_ _3229_ _3232_ _3385_ vssd1 vssd1 vccd1 vccd1 _3387_ sky130_fd_sc_hd__a21oi_1
X_5337_ _0524_ _0525_ vssd1 vssd1 vccd1 vccd1 _0527_ sky130_fd_sc_hd__xnor2_1
X_8056_ _3165_ _3166_ _3164_ vssd1 vssd1 vccd1 vccd1 _3312_ sky130_fd_sc_hd__o21a_1
X_5268_ _0334_ _0336_ _0335_ _0160_ vssd1 vssd1 vccd1 vccd1 _0458_ sky130_fd_sc_hd__a2bb2o_1
XFILLER_87_256 vssd1 vssd1 vccd1 vccd1 sky130_fd_sc_hd__fill_2
XFILLER_85_29 vssd1 vssd1 vccd1 vccd1 sky130_fd_sc_hd__fill_2
X_7007_ _1804_ _1808_ _2103_ _2222_ _2106_ vssd1 vssd1 vccd1 vccd1 _2223_ sky130_fd_sc_hd__o311a_4
X_4219_ net16 net167 _2346_ vssd1 vssd1 vccd1 vccd1 _2357_ sky130_fd_sc_hd__o21ai_1
XANTENNA_fanout280_X net280 vssd1 vssd1 vccd1 vccd1 sky130_fd_sc_hd__diode_2
X_5199_ _0286_ _0288_ vssd1 vssd1 vccd1 vccd1 _0389_ sky130_fd_sc_hd__nand2b_1
XFILLER_28_345 vssd1 vssd1 vccd1 vccd1 sky130_fd_sc_hd__fill_2
XFILLER_16_518 vssd1 vssd1 vccd1 vccd1 sky130_fd_sc_hd__fill_4
XFILLER_16_529 vssd1 vssd1 vccd1 vccd1 sky130_fd_sc_hd__fill_2
XFILLER_70_112 vssd1 vssd1 vccd1 vccd1 sky130_fd_sc_hd__fill_1
X_7909_ _3162_ _3163_ vssd1 vssd1 vccd1 vccd1 _3164_ sky130_fd_sc_hd__or2_1
XFILLER_43_337 vccd1 vssd1 vccd1 vssd1 sky130_ef_sc_hd__decap_40_12
XFILLER_70_178 vssd1 vssd1 vccd1 vccd1 sky130_fd_sc_hd__fill_8
XFILLER_11_212 vssd1 vssd1 vccd1 vccd1 sky130_fd_sc_hd__fill_1
XFILLER_11_223 vssd1 vssd1 vccd1 vccd1 sky130_fd_sc_hd__fill_1
XANTENNA__6142__B net80 vssd1 vssd1 vccd1 vccd1 sky130_fd_sc_hd__diode_2
XFILLER_11_245 vssd1 vssd1 vccd1 vccd1 sky130_fd_sc_hd__fill_4
XANTENNA__5039__A net114 vssd1 vssd1 vccd1 vccd1 sky130_fd_sc_hd__diode_2
XFILLER_3_411 vccd1 vssd1 vccd1 vssd1 sky130_ef_sc_hd__decap_40_12
XFILLER_78_245 vssd1 vssd1 vccd1 vccd1 sky130_fd_sc_hd__fill_1
XFILLER_78_223 vssd1 vssd1 vccd1 vccd1 sky130_fd_sc_hd__fill_2
XFILLER_59_63 vssd1 vssd1 vccd1 vccd1 sky130_fd_sc_hd__fill_8
XFILLER_78_256 vccd1 vssd1 vccd1 vssd1 sky130_ef_sc_hd__decap_40_12
XTAP_TAPCELL_ROW_6_260 vssd1 vccd1 sky130_fd_sc_hd__tapvpwrvgnd_1
XFILLER_38_109 vssd1 vssd1 vccd1 vccd1 sky130_fd_sc_hd__fill_8
Xfanout291 net292 vssd1 vssd1 vccd1 vccd1 net291 sky130_fd_sc_hd__buf_2
Xfanout280 PID_INST.k2_calc.reg_lc\[9\] vssd1 vssd1 vccd1 vccd1 net280 sky130_fd_sc_hd__clkbuf_4
XFILLER_59_481 vssd1 vssd1 vccd1 vccd1 sky130_fd_sc_hd__fill_2
XTAP_TAPCELL_ROW_77_969 vssd1 vccd1 sky130_fd_sc_hd__tapvpwrvgnd_1
XFILLER_75_73 vssd1 vssd1 vccd1 vccd1 sky130_fd_sc_hd__fill_8
XFILLER_46_131 vssd1 vssd1 vccd1 vccd1 sky130_fd_sc_hd__fill_1
XFILLER_75_95 vssd1 vssd1 vccd1 vccd1 sky130_fd_sc_hd__fill_8
XFILLER_46_197 vssd1 vssd1 vccd1 vccd1 sky130_fd_sc_hd__fill_2
XFILLER_61_167 vssd1 vssd1 vccd1 vccd1 sky130_fd_sc_hd__fill_1
XFILLER_61_145 vssd1 vssd1 vccd1 vccd1 sky130_fd_sc_hd__fill_1
XTAP_TAPCELL_ROW_60_803 vssd1 vccd1 sky130_fd_sc_hd__tapvpwrvgnd_1
XFILLER_91_61 vssd1 vssd1 vccd1 vccd1 sky130_fd_sc_hd__fill_2
XTAP_TAPCELL_ROW_32_516 vssd1 vccd1 sky130_fd_sc_hd__tapvpwrvgnd_1
XFILLER_30_565 vssd1 vssd1 vccd1 vccd1 sky130_fd_sc_hd__fill_4
X_4570_ _3844_ _3847_ vssd1 vssd1 vccd1 vccd1 _3848_ sky130_fd_sc_hd__xnor2_1
XFILLER_6_271 vssd1 vssd1 vccd1 vccd1 sky130_fd_sc_hd__fill_2
X_6240_ net203 net315 net303 net211 vssd1 vssd1 vccd1 vccd1 _1429_ sky130_fd_sc_hd__a22oi_1
X_6171_ _1352_ _1358_ vssd1 vssd1 vccd1 vccd1 _1360_ sky130_fd_sc_hd__xnor2_1
X_5122_ net139 net66 net64 net118 vssd1 vssd1 vccd1 vccd1 _0312_ sky130_fd_sc_hd__o22a_1
X_5053_ _0241_ _0242_ vssd1 vssd1 vccd1 vccd1 _0243_ sky130_fd_sc_hd__xor2_1
XFILLER_37_142 vssd1 vssd1 vccd1 vccd1 sky130_fd_sc_hd__fill_1
XPHY_EDGE_ROW_9_Left_102 vssd1 vssd1 vccd1 vccd1 sky130_fd_sc_hd__decap_3
XFILLER_37_164 vssd1 vssd1 vccd1 vccd1 sky130_fd_sc_hd__fill_4
XFILLER_92_281 vssd1 vssd1 vccd1 vccd1 sky130_fd_sc_hd__fill_4
XTAP_TAPCELL_ROW_48_682 vssd1 vccd1 sky130_fd_sc_hd__tapvpwrvgnd_1
XANTENNA__4970__B net70 vssd1 vssd1 vccd1 vccd1 sky130_fd_sc_hd__diode_2
X_5955_ _2083_ net71 _0508_ _0507_ _0435_ vssd1 vssd1 vccd1 vccd1 _1145_ sky130_fd_sc_hd__o32ai_4
XFILLER_40_307 vssd1 vssd1 vccd1 vccd1 sky130_fd_sc_hd__fill_1
XANTENNA_fanout240_A PID_INST.k2_calc.sum_reg\[3\] vssd1 vssd1 vccd1 vccd1 sky130_fd_sc_hd__diode_2
X_5886_ _1073_ _1075_ vssd1 vssd1 vccd1 vccd1 _1076_ sky130_fd_sc_hd__xor2_1
XANTENNA_fanout338_A net339 vssd1 vssd1 vccd1 vccd1 sky130_fd_sc_hd__diode_2
X_4906_ _4105_ _0095_ vssd1 vssd1 vccd1 vccd1 _0096_ sky130_fd_sc_hd__nor2_1
XFILLER_33_370 vssd1 vssd1 vccd1 vccd1 sky130_fd_sc_hd__fill_1
X_7625_ _2875_ _2876_ vssd1 vssd1 vccd1 vccd1 _2877_ sky130_fd_sc_hd__nor2_1
X_4837_ _2178_ _3774_ vssd1 vssd1 vccd1 vccd1 _4115_ sky130_fd_sc_hd__nor2_1
X_4768_ _2210_ _3774_ vssd1 vssd1 vccd1 vccd1 _4046_ sky130_fd_sc_hd__nor2_1
X_7556_ _2802_ _2803_ vssd1 vssd1 vccd1 vccd1 _2804_ sky130_fd_sc_hd__xnor2_1
X_7487_ _2729_ _2730_ vssd1 vssd1 vccd1 vccd1 _2731_ sky130_fd_sc_hd__nor2_1
X_6507_ net165 net76 _1693_ vssd1 vssd1 vccd1 vccd1 _1694_ sky130_fd_sc_hd__and3_1
X_4699_ _3975_ _3976_ vssd1 vssd1 vccd1 vccd1 _3977_ sky130_fd_sc_hd__nor2_1
XFILLER_4_208 vssd1 vssd1 vccd1 vccd1 sky130_fd_sc_hd__fill_2
X_6438_ net215 net291 _1625_ vssd1 vssd1 vccd1 vccd1 _1626_ sky130_fd_sc_hd__and3_1
XFILLER_88_510 vccd1 vssd1 vccd1 vssd1 sky130_ef_sc_hd__decap_40_12
XANTENNA__5306__B net83 vssd1 vssd1 vccd1 vccd1 sky130_fd_sc_hd__diode_2
X_8108_ _3366_ _3367_ vssd1 vssd1 vccd1 vccd1 _3368_ sky130_fd_sc_hd__nor2_1
X_6369_ _1556_ _1555_ vssd1 vssd1 vccd1 vccd1 _1557_ sky130_fd_sc_hd__and2b_1
Xhold22 net22 vssd1 vssd1 vccd1 vccd1 net415 sky130_fd_sc_hd__dlygate4sd3_1
Xhold11 PID_INST.k1_calc.d1.x\[4\] vssd1 vssd1 vccd1 vccd1 net404 sky130_fd_sc_hd__dlygate4sd3_1
X_8039_ net98 _1742_ vssd1 vssd1 vccd1 vccd1 _3293_ sky130_fd_sc_hd__nor2_1
Xhold33 PID_INST.k1_calc.d1.x\[3\] vssd1 vssd1 vccd1 vccd1 net426 sky130_fd_sc_hd__dlygate4sd3_1
XTAP_TAPCELL_ROW_3_230 vssd1 vccd1 sky130_fd_sc_hd__tapvpwrvgnd_1
XTAP_TAPCELL_ROW_74_939 vssd1 vccd1 sky130_fd_sc_hd__tapvpwrvgnd_1
XFILLER_56_484 vssd1 vssd1 vccd1 vccd1 sky130_fd_sc_hd__fill_2
XFILLER_83_281 vccd1 vssd1 vccd1 vssd1 sky130_ef_sc_hd__decap_40_12
XFILLER_83_270 vssd1 vssd1 vccd1 vccd1 sky130_fd_sc_hd__fill_8
XFILLER_71_421 vssd1 vssd1 vccd1 vccd1 sky130_fd_sc_hd__fill_1
XFILLER_28_197 vccd1 vssd1 vccd1 vssd1 sky130_ef_sc_hd__decap_40_12
XANTENNA__4880__B net58 vssd1 vssd1 vccd1 vccd1 sky130_fd_sc_hd__diode_2
XFILLER_16_359 vssd1 vssd1 vccd1 vccd1 sky130_fd_sc_hd__fill_2
XANTENNA__7249__A _2399_ vssd1 vssd1 vccd1 vccd1 sky130_fd_sc_hd__diode_2
XFILLER_24_381 vssd1 vssd1 vccd1 vccd1 sky130_fd_sc_hd__fill_4
XFILLER_61_64 vssd1 vssd1 vccd1 vccd1 sky130_fd_sc_hd__fill_4
XANTENNA__5216__B net89 vssd1 vssd1 vccd1 vccd1 sky130_fd_sc_hd__diode_2
XANTENNA__7134__D net280 vssd1 vssd1 vccd1 vccd1 sky130_fd_sc_hd__diode_2
XFILLER_79_565 vssd1 vssd1 vccd1 vccd1 sky130_fd_sc_hd__fill_4
XANTENNA__6626__B1 net254 vssd1 vssd1 vccd1 vccd1 sky130_fd_sc_hd__diode_2
XANTENNA__6328__A net114 vssd1 vssd1 vccd1 vccd1 sky130_fd_sc_hd__diode_2
XFILLER_13_6 vssd1 vssd1 vccd1 vccd1 sky130_fd_sc_hd__fill_4
XFILLER_19_131 vssd1 vssd1 vccd1 vccd1 sky130_fd_sc_hd__fill_8
XANTENNA__8543__A PID_INST.busy vssd1 vssd1 vccd1 vccd1 sky130_fd_sc_hd__diode_2
XTAP_TAPCELL_ROW_45_652 vssd1 vccd1 sky130_fd_sc_hd__tapvpwrvgnd_1
XFILLER_62_498 vccd1 vssd1 vccd1 vssd1 sky130_ef_sc_hd__decap_40_12
X_5740_ _0903_ _0914_ _0913_ vssd1 vssd1 vccd1 vccd1 _0930_ sky130_fd_sc_hd__a21o_1
XANTENNA__4282__S net157 vssd1 vssd1 vccd1 vccd1 sky130_fd_sc_hd__diode_2
X_5671_ _0830_ _0840_ _0860_ vssd1 vssd1 vccd1 vccd1 _0861_ sky130_fd_sc_hd__o21ai_1
X_7410_ _2647_ _2649_ vssd1 vssd1 vccd1 vccd1 _2650_ sky130_fd_sc_hd__xnor2_1
XANTENNA__4168__A1 net12 vssd1 vssd1 vccd1 vccd1 sky130_fd_sc_hd__diode_2
XFILLER_30_362 vssd1 vssd1 vccd1 vccd1 sky130_fd_sc_hd__fill_2
X_4622_ _3885_ _3899_ vssd1 vssd1 vccd1 vccd1 _3900_ sky130_fd_sc_hd__xor2_1
X_8390_ clknet_4_8_0_clk PID_INST.k3_calc.d2.y\[10\] net328 vssd1 vssd1 vccd1 vccd1
+ PID_INST.k3_calc.timescaling_term\[10\] sky130_fd_sc_hd__dfrtp_1
X_7341_ _2321_ _2328_ _2575_ vssd1 vssd1 vccd1 vccd1 _2576_ sky130_fd_sc_hd__a21o_1
X_4553_ _3829_ _3830_ vssd1 vssd1 vccd1 vccd1 _3831_ sky130_fd_sc_hd__nand2_1
XANTENNA__7325__C net214 vssd1 vssd1 vccd1 vccd1 sky130_fd_sc_hd__diode_2
X_4484_ _3759_ _3760_ _3738_ vssd1 vssd1 vccd1 vccd1 _3762_ sky130_fd_sc_hd__o21ai_1
X_7272_ net99 net51 _2430_ _2429_ vssd1 vssd1 vccd1 vccd1 _2502_ sky130_fd_sc_hd__o31a_1
X_6223_ net269 net243 net265 net240 vssd1 vssd1 vccd1 vccd1 _1412_ sky130_fd_sc_hd__and4_1
XANTENNA__4634__A1_N net120 vssd1 vssd1 vccd1 vccd1 sky130_fd_sc_hd__diode_2
X_6154_ _1340_ _1342_ vssd1 vssd1 vccd1 vccd1 _1343_ sky130_fd_sc_hd__and2_1
XFILLER_85_535 vssd1 vssd1 vccd1 vccd1 sky130_fd_sc_hd__fill_2
XFILLER_85_513 vssd1 vssd1 vccd1 vccd1 sky130_fd_sc_hd__fill_1
XANTENNA_fanout190_A PID_INST.k2_calc.sum_reg\[16\] vssd1 vssd1 vccd1 vccd1 sky130_fd_sc_hd__diode_2
X_6085_ _1267_ _1268_ _1273_ vssd1 vssd1 vccd1 vccd1 _1275_ sky130_fd_sc_hd__or3_1
X_5105_ _0293_ _0294_ vssd1 vssd1 vccd1 vccd1 _0295_ sky130_fd_sc_hd__nor2_1
XFILLER_85_557 vssd1 vssd1 vccd1 vccd1 sky130_fd_sc_hd__fill_2
XFILLER_85_546 vssd1 vssd1 vccd1 vccd1 sky130_fd_sc_hd__fill_1
XANTENNA_fanout288_A net289 vssd1 vssd1 vccd1 vccd1 sky130_fd_sc_hd__diode_2
XFILLER_57_237 vssd1 vssd1 vccd1 vccd1 sky130_fd_sc_hd__fill_1
X_5036_ _0222_ _0225_ vssd1 vssd1 vccd1 vccd1 _0226_ sky130_fd_sc_hd__nand2_1
XANTENNA__5499__D net306 vssd1 vssd1 vccd1 vccd1 sky130_fd_sc_hd__diode_2
XTAP_TAPCELL_ROW_0_200 vssd1 vccd1 sky130_fd_sc_hd__tapvpwrvgnd_1
XFILLER_53_410 vssd1 vssd1 vccd1 vccd1 sky130_fd_sc_hd__fill_2
XTAP_TAPCELL_ROW_71_909 vssd1 vccd1 sky130_fd_sc_hd__tapvpwrvgnd_1
XFILLER_13_307 vssd1 vssd1 vccd1 vccd1 sky130_fd_sc_hd__fill_4
X_6987_ _2200_ _2201_ vssd1 vssd1 vccd1 vccd1 _2202_ sky130_fd_sc_hd__xnor2_1
XFILLER_80_262 vssd1 vssd1 vccd1 vccd1 sky130_fd_sc_hd__fill_2
X_5938_ net164 _3799_ vssd1 vssd1 vccd1 vccd1 _1128_ sky130_fd_sc_hd__nand2_1
XFILLER_40_137 vssd1 vssd1 vccd1 vccd1 sky130_fd_sc_hd__fill_1
X_5869_ net325 net233 _1058_ vssd1 vssd1 vccd1 vccd1 _1059_ sky130_fd_sc_hd__a21o_1
XFILLER_21_384 vssd1 vssd1 vccd1 vccd1 sky130_fd_sc_hd__fill_8
XFILLER_21_395 vssd1 vssd1 vccd1 vccd1 sky130_fd_sc_hd__fill_1
X_7608_ PID_INST.k3_calc.d2.y\[5\] _2034_ _2035_ vssd1 vssd1 vccd1 vccd1 _2860_ sky130_fd_sc_hd__and3_1
X_7539_ _2532_ _2784_ vssd1 vssd1 vccd1 vccd1 _2786_ sky130_fd_sc_hd__nand2_1
Xoutput34 net34 vssd1 vssd1 vccd1 vccd1 gpio_out[31] sky130_fd_sc_hd__buf_2
Xoutput23 net23 vssd1 vssd1 vccd1 vccd1 gpio_out[20] sky130_fd_sc_hd__buf_2
XFILLER_88_395 vssd1 vssd1 vccd1 vccd1 sky130_fd_sc_hd__fill_4
XFILLER_48_204 vssd1 vssd1 vccd1 vccd1 sky130_fd_sc_hd__fill_8
XFILLER_91_505 vssd1 vssd1 vccd1 vccd1 sky130_fd_sc_hd__fill_2
XTAP_TAPCELL_ROW_59_788 vssd1 vccd1 sky130_fd_sc_hd__tapvpwrvgnd_1
XANTENNA_input16_A gpio_in[6] vssd1 vssd1 vccd1 vccd1 sky130_fd_sc_hd__diode_2
XFILLER_44_421 vssd1 vssd1 vccd1 vccd1 sky130_fd_sc_hd__fill_8
XFILLER_72_52 vssd1 vssd1 vccd1 vccd1 sky130_fd_sc_hd__fill_1
XANTENNA__4398__A1 net194 vssd1 vssd1 vccd1 vccd1 sky130_fd_sc_hd__diode_2
XFILLER_16_167 vssd1 vssd1 vccd1 vccd1 sky130_fd_sc_hd__fill_1
XFILLER_16_178 vssd1 vssd1 vccd1 vccd1 sky130_fd_sc_hd__fill_8
XFILLER_31_104 vssd1 vssd1 vccd1 vccd1 sky130_fd_sc_hd__fill_8
XTAP_TAPCELL_ROW_42_622 vssd1 vccd1 sky130_fd_sc_hd__tapvpwrvgnd_1
XFILLER_8_322 vssd1 vssd1 vccd1 vccd1 sky130_fd_sc_hd__fill_1
XANTENNA__5898__A1 _0734_ vssd1 vssd1 vccd1 vccd1 sky130_fd_sc_hd__diode_2
XFILLER_8_388 vccd1 vssd1 vccd1 vssd1 sky130_ef_sc_hd__decap_40_12
XFILLER_67_568 vssd1 vssd1 vccd1 vccd1 sky130_fd_sc_hd__fill_2
XFILLER_11_3 vssd1 vssd1 vccd1 vccd1 sky130_fd_sc_hd__fill_4
X_6910_ _2026_ _2029_ vssd1 vssd1 vccd1 vccd1 _2120_ sky130_fd_sc_hd__nand2_1
X_7890_ _3076_ _3144_ vssd1 vssd1 vccd1 vccd1 _3145_ sky130_fd_sc_hd__nand2_1
X_6841_ _2037_ _2046_ vssd1 vssd1 vccd1 vccd1 _2047_ sky130_fd_sc_hd__and2b_1
XANTENNA__8423__D net137 vssd1 vssd1 vccd1 vccd1 sky130_fd_sc_hd__diode_2
X_6772_ _1873_ _1883_ _1972_ vssd1 vssd1 vccd1 vccd1 _1973_ sky130_fd_sc_hd__a21o_1
XFILLER_22_126 vssd1 vssd1 vccd1 vccd1 sky130_fd_sc_hd__fill_8
X_5723_ _0907_ _0911_ vssd1 vssd1 vccd1 vccd1 _0913_ sky130_fd_sc_hd__xnor2_1
X_5654_ _0830_ _0840_ _0839_ _0831_ vssd1 vssd1 vccd1 vccd1 _0844_ sky130_fd_sc_hd__a2bb2o_1
X_8442_ clknet_4_12_0_clk net398 net335 vssd1 vssd1 vccd1 vccd1 PID_INST.k3_calc.prev_error\[14\]
+ sky130_fd_sc_hd__dfrtp_1
XANTENNA__7878__A2 net44 vssd1 vssd1 vccd1 vccd1 sky130_fd_sc_hd__diode_2
X_8373_ clknet_4_4_0_clk _0009_ net330 vssd1 vssd1 vccd1 vccd1 PID_INST.k1_calc.d1.x\[9\]
+ sky130_fd_sc_hd__dfrtp_1
X_4605_ _3858_ _3859_ _3881_ vssd1 vssd1 vccd1 vccd1 _3883_ sky130_fd_sc_hd__a21o_1
X_5585_ net283 net278 net235 net240 vssd1 vssd1 vccd1 vccd1 _0775_ sky130_fd_sc_hd__and4_1
X_7324_ _2223_ _2475_ _2554_ _2556_ vssd1 vssd1 vccd1 vccd1 _2558_ sky130_fd_sc_hd__a211o_1
XANTENNA_fanout203_A net204 vssd1 vssd1 vccd1 vccd1 sky130_fd_sc_hd__diode_2
X_4536_ _3794_ _3807_ _3813_ vssd1 vssd1 vccd1 vccd1 _3814_ sky130_fd_sc_hd__and3_1
XFILLER_89_137 vssd1 vssd1 vccd1 vccd1 sky130_fd_sc_hd__fill_2
X_4467_ PID_INST.k1_calc.d1.x\[5\] PID_INST.k3_calc.prev_error\[5\] vssd1 vssd1 vccd1
+ vccd1 _3745_ sky130_fd_sc_hd__or2_1
X_7255_ net91 net58 vssd1 vssd1 vccd1 vccd1 _2485_ sky130_fd_sc_hd__or2_1
X_4398_ net194 net158 _3688_ _3689_ vssd1 vssd1 vccd1 vccd1 _0046_ sky130_fd_sc_hd__a22o_1
X_6206_ net108 net43 vssd1 vssd1 vccd1 vccd1 _1395_ sky130_fd_sc_hd__nor2_1
X_7186_ net106 _2147_ vssd1 vssd1 vccd1 vccd1 _2412_ sky130_fd_sc_hd__nor2_1
XANTENNA_input8_A gpio_in[15] vssd1 vssd1 vccd1 vccd1 sky130_fd_sc_hd__diode_2
X_6137_ _1324_ _1325_ vssd1 vssd1 vccd1 vccd1 _1326_ sky130_fd_sc_hd__or2_1
XFILLER_85_343 vssd1 vssd1 vccd1 vccd1 sky130_fd_sc_hd__fill_1
XFILLER_85_321 vccd1 vssd1 vccd1 vssd1 sky130_ef_sc_hd__decap_40_12
XANTENNA_fanout193_X net193 vssd1 vssd1 vccd1 vccd1 sky130_fd_sc_hd__diode_2
XFILLER_85_376 vssd1 vssd1 vccd1 vccd1 sky130_fd_sc_hd__fill_1
XFILLER_73_505 vccd1 vssd1 vccd1 vssd1 sky130_ef_sc_hd__decap_40_12
X_6068_ _0801_ _1257_ vssd1 vssd1 vccd1 vccd1 _1258_ sky130_fd_sc_hd__or2_1
XANTENNA__4616__A2 net86 vssd1 vssd1 vccd1 vccd1 sky130_fd_sc_hd__diode_2
X_5019_ _0180_ _0208_ vssd1 vssd1 vccd1 vccd1 _0209_ sky130_fd_sc_hd__xnor2_1
XFILLER_26_421 vssd1 vssd1 vccd1 vccd1 sky130_fd_sc_hd__fill_4
XTAP_TAPCELL_ROW_56_758 vssd1 vccd1 sky130_fd_sc_hd__tapvpwrvgnd_1
XFILLER_26_487 vccd1 vssd1 vccd1 vssd1 sky130_ef_sc_hd__decap_40_12
XFILLER_41_402 vssd1 vssd1 vccd1 vccd1 sky130_fd_sc_hd__fill_2
XANTENNA__4216__A net117 vssd1 vssd1 vccd1 vccd1 sky130_fd_sc_hd__diode_2
XFILLER_41_446 vssd1 vssd1 vccd1 vccd1 sky130_fd_sc_hd__fill_2
XFILLER_41_457 vssd1 vssd1 vccd1 vccd1 sky130_fd_sc_hd__fill_1
XFILLER_9_108 vssd1 vssd1 vccd1 vccd1 sky130_fd_sc_hd__fill_4
XFILLER_21_181 vssd1 vssd1 vccd1 vccd1 sky130_fd_sc_hd__fill_1
XANTENNA__7869__A2 net51 vssd1 vssd1 vccd1 vccd1 sky130_fd_sc_hd__diode_2
XANTENNA__4222__Y _2389_ vssd1 vssd1 vccd1 vccd1 sky130_fd_sc_hd__diode_2
XANTENNA__4589__C net88 vssd1 vssd1 vccd1 vccd1 sky130_fd_sc_hd__diode_2
XANTENNA__5047__A net142 vssd1 vssd1 vccd1 vccd1 sky130_fd_sc_hd__diode_2
XANTENNA__5501__B1 net232 vssd1 vssd1 vccd1 vccd1 sky130_fd_sc_hd__diode_2
XANTENNA__4304__A1 net6 vssd1 vssd1 vccd1 vccd1 sky130_fd_sc_hd__diode_2
XFILLER_3_16 vssd1 vssd1 vccd1 vccd1 sky130_fd_sc_hd__fill_1
XFILLER_1_553 vssd1 vssd1 vccd1 vccd1 sky130_fd_sc_hd__fill_4
XFILLER_88_181 vccd1 vssd1 vccd1 vssd1 sky130_ef_sc_hd__decap_40_12
XFILLER_76_321 vccd1 vssd1 vccd1 vssd1 sky130_ef_sc_hd__decap_40_12
XANTENNA__7412__D net213 vssd1 vssd1 vccd1 vccd1 sky130_fd_sc_hd__diode_2
XANTENNA_input19_X net19 vssd1 vssd1 vccd1 vccd1 sky130_fd_sc_hd__diode_2
XFILLER_29_281 vssd1 vssd1 vccd1 vccd1 sky130_fd_sc_hd__fill_1
XFILLER_44_240 vssd1 vssd1 vccd1 vccd1 sky130_fd_sc_hd__fill_1
XFILLER_17_432 vssd1 vssd1 vccd1 vccd1 sky130_fd_sc_hd__fill_2
XANTENNA__4771__D net79 vssd1 vssd1 vccd1 vccd1 sky130_fd_sc_hd__diode_2
XTAP_TAPCELL_ROW_27_471 vssd1 vccd1 sky130_fd_sc_hd__tapvpwrvgnd_1
XFILLER_44_295 vccd1 vssd1 vccd1 vssd1 sky130_ef_sc_hd__decap_40_12
XFILLER_32_446 vssd1 vssd1 vccd1 vccd1 sky130_fd_sc_hd__fill_4
XFILLER_80_6 vssd1 vssd1 vccd1 vccd1 sky130_fd_sc_hd__fill_4
XANTENNA__8472__CLK clknet_4_10_0_clk vssd1 vssd1 vccd1 vccd1 sky130_fd_sc_hd__diode_2
XFILLER_8_152 vssd1 vssd1 vccd1 vccd1 sky130_fd_sc_hd__fill_1
XFILLER_12_192 vssd1 vssd1 vccd1 vccd1 sky130_fd_sc_hd__fill_4
XANTENNA__6060__B net295 vssd1 vssd1 vccd1 vccd1 sky130_fd_sc_hd__diode_2
XFILLER_8_185 vssd1 vssd1 vccd1 vccd1 sky130_fd_sc_hd__fill_1
XFILLER_59_3 vssd1 vssd1 vccd1 vccd1 sky130_fd_sc_hd__fill_1
X_5370_ net116 net65 vssd1 vssd1 vccd1 vccd1 _0560_ sky130_fd_sc_hd__nor2_1
X_4321_ _3364_ _3375_ _3386_ vssd1 vssd1 vccd1 vccd1 _3418_ sky130_fd_sc_hd__and3_1
X_7040_ _2256_ _2257_ vssd1 vssd1 vccd1 vccd1 _2258_ sky130_fd_sc_hd__nand2_1
X_4252_ net8 net168 _2696_ vssd1 vssd1 vccd1 vccd1 _2707_ sky130_fd_sc_hd__o21ai_2
Xfanout109 _2453_ vssd1 vssd1 vccd1 vccd1 net109 sky130_fd_sc_hd__clkbuf_4
XANTENNA__8418__D net129 vssd1 vssd1 vccd1 vccd1 sky130_fd_sc_hd__diode_2
XFILLER_67_321 vssd1 vssd1 vccd1 vccd1 sky130_fd_sc_hd__fill_1
X_4183_ PID_INST.k3_calc.kd_term\[10\] net175 vssd1 vssd1 vccd1 vccd1 _1976_ sky130_fd_sc_hd__or2_1
XFILLER_82_313 vssd1 vssd1 vccd1 vccd1 sky130_fd_sc_hd__fill_2
X_7942_ _2982_ _2985_ _2983_ vssd1 vssd1 vccd1 vccd1 _3197_ sky130_fd_sc_hd__o21ba_1
XFILLER_67_387 vssd1 vssd1 vccd1 vccd1 sky130_fd_sc_hd__fill_1
XFILLER_55_538 vssd1 vssd1 vccd1 vccd1 sky130_fd_sc_hd__fill_1
XANTENNA__5420__A net111 vssd1 vssd1 vccd1 vccd1 sky130_fd_sc_hd__diode_2
XTAP_TAPCELL_ROW_53_728 vssd1 vccd1 sky130_fd_sc_hd__tapvpwrvgnd_1
X_7873_ _3056_ _3059_ _3127_ vssd1 vssd1 vccd1 vccd1 _3128_ sky130_fd_sc_hd__o21a_1
XFILLER_35_273 vssd1 vssd1 vccd1 vccd1 sky130_fd_sc_hd__fill_2
XFILLER_90_390 vssd1 vssd1 vccd1 vccd1 sky130_fd_sc_hd__fill_4
X_6824_ _1991_ _2028_ vssd1 vssd1 vccd1 vccd1 _2029_ sky130_fd_sc_hd__nand2b_1
X_6755_ _1936_ _1954_ vssd1 vssd1 vccd1 vccd1 _1956_ sky130_fd_sc_hd__or2_1
XFILLER_23_479 vccd1 vssd1 vccd1 vssd1 sky130_ef_sc_hd__decap_40_12
X_5706_ _0892_ _0895_ vssd1 vssd1 vccd1 vccd1 _0896_ sky130_fd_sc_hd__nor2_1
XANTENNA_fanout320_A net321 vssd1 vssd1 vccd1 vccd1 sky130_fd_sc_hd__diode_2
X_6686_ _1875_ _1881_ vssd1 vssd1 vccd1 vccd1 _1884_ sky130_fd_sc_hd__xnor2_1
X_8425_ clknet_4_4_0_clk net165 net330 vssd1 vssd1 vccd1 vccd1 PID_INST.k3_calc.kd_term\[13\]
+ sky130_fd_sc_hd__dfrtp_1
X_5637_ net323 net215 vssd1 vssd1 vccd1 vccd1 _0827_ sky130_fd_sc_hd__and2_1
XFILLER_12_47 vssd1 vssd1 vccd1 vccd1 sky130_fd_sc_hd__fill_4
XANTENNA_fanout206_X net206 vssd1 vssd1 vccd1 vccd1 sky130_fd_sc_hd__diode_2
X_5568_ _0756_ _0757_ vssd1 vssd1 vccd1 vccd1 _0758_ sky130_fd_sc_hd__nand2_1
X_8356_ _3632_ _3634_ vssd1 vssd1 vccd1 vccd1 _3635_ sky130_fd_sc_hd__xnor2_1
XTAP_TAPCELL_ROW_92_1134 vssd1 vccd1 sky130_fd_sc_hd__tapvpwrvgnd_1
XTAP_TAPCELL_ROW_92_1123 vssd1 vccd1 sky130_fd_sc_hd__tapvpwrvgnd_1
XFILLER_88_29 vssd1 vssd1 vccd1 vccd1 sky130_fd_sc_hd__fill_8
X_8287_ _3486_ _3490_ _3491_ _3494_ _3485_ vssd1 vssd1 vccd1 vccd1 _3560_ sky130_fd_sc_hd__a32o_1
X_4519_ _3795_ _3789_ vssd1 vssd1 vccd1 vccd1 _3797_ sky130_fd_sc_hd__xor2_1
X_7307_ net108 _2147_ vssd1 vssd1 vccd1 vccd1 _2540_ sky130_fd_sc_hd__nor2_1
X_5499_ net249 net224 net273 net306 vssd1 vssd1 vccd1 vccd1 _0689_ sky130_fd_sc_hd__and4_1
XANTENNA__6287__A1 net227 vssd1 vssd1 vccd1 vccd1 sky130_fd_sc_hd__diode_2
XANTENNA__4298__A0 net294 vssd1 vssd1 vccd1 vccd1 sky130_fd_sc_hd__diode_2
X_7238_ _2417_ _2465_ vssd1 vssd1 vccd1 vccd1 _2467_ sky130_fd_sc_hd__xnor2_1
X_7169_ _2391_ _2392_ vssd1 vssd1 vccd1 vccd1 _2394_ sky130_fd_sc_hd__and2_1
XANTENNA__6039__A1 net207 vssd1 vssd1 vccd1 vccd1 sky130_fd_sc_hd__diode_2
XFILLER_58_321 vccd1 vssd1 vccd1 vssd1 sky130_ef_sc_hd__decap_40_12
XANTENNA__7810__A net101 vssd1 vssd1 vccd1 vccd1 sky130_fd_sc_hd__diode_2
XANTENNA__6039__B2 net216 vssd1 vssd1 vccd1 vccd1 sky130_fd_sc_hd__diode_2
XANTENNA_fanout66_A _3964_ vssd1 vssd1 vccd1 vccd1 sky130_fd_sc_hd__diode_2
XFILLER_37_11 vssd1 vssd1 vccd1 vccd1 sky130_fd_sc_hd__fill_1
XFILLER_37_33 vssd1 vssd1 vccd1 vccd1 sky130_fd_sc_hd__fill_1
XTAP_TAPCELL_ROW_69_894 vssd1 vccd1 sky130_fd_sc_hd__tapvpwrvgnd_1
XFILLER_46_527 vssd1 vssd1 vccd1 vccd1 sky130_fd_sc_hd__fill_4
XANTENNA__6145__B net83 vssd1 vssd1 vccd1 vccd1 sky130_fd_sc_hd__diode_2
XFILLER_26_251 vssd1 vssd1 vccd1 vccd1 sky130_fd_sc_hd__fill_1
XFILLER_41_210 vssd1 vssd1 vccd1 vccd1 sky130_fd_sc_hd__fill_2
XFILLER_41_232 vssd1 vssd1 vccd1 vccd1 sky130_fd_sc_hd__fill_8
XTAP_TAPCELL_ROW_24_441 vssd1 vccd1 sky130_fd_sc_hd__tapvpwrvgnd_1
XFILLER_22_490 vssd1 vssd1 vccd1 vccd1 sky130_fd_sc_hd__fill_2
XFILLER_5_166 vssd1 vssd1 vccd1 vccd1 sky130_fd_sc_hd__fill_2
XFILLER_37_505 vccd1 vssd1 vccd1 vssd1 sky130_ef_sc_hd__decap_40_12
XFILLER_91_110 vssd1 vssd1 vccd1 vccd1 sky130_fd_sc_hd__fill_2
XFILLER_76_184 vccd1 vssd1 vccd1 vssd1 sky130_ef_sc_hd__decap_40_12
XFILLER_76_173 vssd1 vssd1 vccd1 vccd1 sky130_fd_sc_hd__fill_4
XFILLER_37_538 vssd1 vssd1 vccd1 vccd1 sky130_fd_sc_hd__fill_8
XANTENNA__6055__B net306 vssd1 vssd1 vccd1 vccd1 sky130_fd_sc_hd__diode_2
XFILLER_60_530 vssd1 vssd1 vccd1 vccd1 sky130_fd_sc_hd__fill_2
X_4870_ _4145_ _4146_ _4114_ vssd1 vssd1 vccd1 vccd1 _4148_ sky130_fd_sc_hd__a21oi_1
XFILLER_32_221 vccd1 vssd1 vccd1 vssd1 sky130_ef_sc_hd__decap_40_12
XANTENNA__4213__A0 net9 vssd1 vssd1 vccd1 vccd1 sky130_fd_sc_hd__diode_2
XFILLER_20_405 vccd1 vssd1 vccd1 vssd1 sky130_ef_sc_hd__decap_40_12
X_6540_ _1716_ _1726_ vssd1 vssd1 vccd1 vccd1 _1727_ sky130_fd_sc_hd__xor2_1
XFILLER_20_449 vssd1 vssd1 vccd1 vccd1 sky130_fd_sc_hd__fill_2
XFILLER_9_461 vssd1 vssd1 vccd1 vccd1 sky130_fd_sc_hd__fill_4
X_6471_ _1638_ _1658_ vssd1 vssd1 vccd1 vccd1 _1659_ sky130_fd_sc_hd__and2_1
X_8210_ _3469_ _3477_ vssd1 vssd1 vccd1 vccd1 _3478_ sky130_fd_sc_hd__and2b_1
X_5422_ _0560_ _0608_ _0611_ vssd1 vssd1 vccd1 vccd1 _0612_ sky130_fd_sc_hd__a21bo_1
XTAP_TAPCELL_ROW_30_499 vssd1 vccd1 sky130_fd_sc_hd__tapvpwrvgnd_1
X_8141_ _3254_ _3257_ _3403_ vssd1 vssd1 vccd1 vccd1 _3404_ sky130_fd_sc_hd__o21a_1
X_5353_ _0542_ vssd1 vssd1 vccd1 vccd1 _0543_ sky130_fd_sc_hd__inv_2
X_4304_ net268 net6 net171 vssd1 vssd1 vccd1 vccd1 _0027_ sky130_fd_sc_hd__mux2_1
XFILLER_87_416 vssd1 vssd1 vccd1 vccd1 sky130_fd_sc_hd__fill_4
XFILLER_87_405 vssd1 vssd1 vccd1 vccd1 sky130_fd_sc_hd__fill_4
X_8072_ net317 PID_INST.k2_calc.sum_reg\[24\] vssd1 vssd1 vccd1 vccd1 _3329_ sky130_fd_sc_hd__nand2_1
X_5284_ _0398_ _0402_ _0401_ _0473_ vssd1 vssd1 vccd1 vccd1 _0474_ sky130_fd_sc_hd__o31ai_4
XANTENNA__8368__CLK clknet_4_1_0_clk vssd1 vssd1 vccd1 vccd1 sky130_fd_sc_hd__diode_2
X_7023_ _2233_ _2238_ vssd1 vssd1 vccd1 vccd1 _2240_ sky130_fd_sc_hd__or2_1
XFILLER_4_92 vssd1 vssd1 vccd1 vccd1 sky130_fd_sc_hd__fill_4
XFILLER_4_81 vssd1 vssd1 vccd1 vccd1 sky130_fd_sc_hd__fill_2
X_4235_ net105 vssd1 vssd1 vccd1 vccd1 PID_INST.k3_calc.d2.y\[1\] sky130_fd_sc_hd__inv_2
X_4166_ net176 PID_INST.pid.curr_state\[2\] PID_INST.pid.curr_state\[3\] net177 vssd1
+ vssd1 vccd1 vccd1 _1795_ sky130_fd_sc_hd__or4bb_1
XFILLER_67_184 vssd1 vssd1 vccd1 vccd1 sky130_fd_sc_hd__fill_2
XFILLER_55_302 vssd1 vssd1 vccd1 vccd1 sky130_fd_sc_hd__fill_1
XFILLER_82_132 vssd1 vssd1 vccd1 vccd1 sky130_fd_sc_hd__fill_8
XTAP_TAPCELL_ROW_66_864 vssd1 vccd1 sky130_fd_sc_hd__tapvpwrvgnd_1
XFILLER_55_368 vssd1 vssd1 vccd1 vccd1 sky130_fd_sc_hd__fill_2
XFILLER_55_335 vssd1 vssd1 vccd1 vccd1 sky130_fd_sc_hd__fill_1
XANTENNA__5150__A net113 vssd1 vssd1 vccd1 vccd1 sky130_fd_sc_hd__diode_2
XANTENNA__5244__A2 net80 vssd1 vssd1 vccd1 vccd1 sky130_fd_sc_hd__diode_2
X_7925_ _3178_ _3179_ vssd1 vssd1 vccd1 vccd1 _3180_ sky130_fd_sc_hd__nor2_1
XTAP_TAPCELL_ROW_38_577 vssd1 vccd1 sky130_fd_sc_hd__tapvpwrvgnd_1
XANTENNA_fanout156_X net156 vssd1 vssd1 vccd1 vccd1 sky130_fd_sc_hd__diode_2
XFILLER_51_530 vssd1 vssd1 vccd1 vccd1 sky130_fd_sc_hd__fill_1
X_7856_ _2878_ _2881_ _3111_ vssd1 vssd1 vccd1 vccd1 _3112_ sky130_fd_sc_hd__nand3_1
X_6807_ _1692_ _2010_ vssd1 vssd1 vccd1 vccd1 _2011_ sky130_fd_sc_hd__nand2_1
X_7787_ _3039_ _3040_ _3041_ vssd1 vssd1 vccd1 vccd1 _3043_ sky130_fd_sc_hd__a21oi_1
XTAP_TAPCELL_ROW_21_411 vssd1 vccd1 sky130_fd_sc_hd__tapvpwrvgnd_1
X_4999_ net135 net87 _0188_ vssd1 vssd1 vccd1 vccd1 _0189_ sky130_fd_sc_hd__a21oi_1
XFILLER_23_13 vssd1 vssd1 vccd1 vccd1 sky130_fd_sc_hd__fill_2
X_6738_ net223 net273 vssd1 vssd1 vccd1 vccd1 _1937_ sky130_fd_sc_hd__nand2_1
XFILLER_7_409 vccd1 vssd1 vccd1 vssd1 sky130_ef_sc_hd__decap_40_12
XFILLER_11_449 vssd1 vssd1 vccd1 vccd1 sky130_fd_sc_hd__fill_2
XFILLER_23_57 vssd1 vssd1 vccd1 vccd1 sky130_fd_sc_hd__fill_2
X_6669_ _1629_ _1632_ _1863_ vssd1 vssd1 vccd1 vccd1 _1865_ sky130_fd_sc_hd__nand3_1
XPHY_EDGE_ROW_36_Left_129 vssd1 vssd1 vccd1 vccd1 sky130_fd_sc_hd__decap_3
X_8408_ clknet_4_6_0_clk _0028_ net333 vssd1 vssd1 vccd1 vccd1 PID_INST.k2_calc.reg_lc\[12\]
+ sky130_fd_sc_hd__dfrtp_1
X_8339_ net98 net37 vssd1 vssd1 vccd1 vccd1 _3617_ sky130_fd_sc_hd__or2_1
XFILLER_2_158 vssd1 vssd1 vccd1 vccd1 sky130_fd_sc_hd__fill_1
XANTENNA__8409__Q PID_INST.k2_calc.reg_lc\[13\] vssd1 vssd1 vccd1 vccd1 sky130_fd_sc_hd__diode_2
XFILLER_48_43 vssd1 vssd1 vccd1 vccd1 sky130_fd_sc_hd__fill_1
XPHY_EDGE_ROW_45_Left_138 vssd1 vssd1 vccd1 vccd1 sky130_fd_sc_hd__decap_3
XFILLER_19_505 vccd1 vssd1 vccd1 vssd1 sky130_ef_sc_hd__decap_40_12
XFILLER_34_508 vccd1 vssd1 vccd1 vssd1 sky130_ef_sc_hd__decap_40_12
XFILLER_14_232 vssd1 vssd1 vccd1 vccd1 sky130_fd_sc_hd__fill_4
XPHY_EDGE_ROW_54_Left_147 vssd1 vssd1 vccd1 vccd1 sky130_fd_sc_hd__decap_3
Xfanout80 _3756_ vssd1 vssd1 vccd1 vccd1 net80 sky130_fd_sc_hd__buf_2
Xfanout91 net92 vssd1 vssd1 vccd1 vccd1 net91 sky130_fd_sc_hd__buf_2
XFILLER_80_85 vssd1 vssd1 vccd1 vccd1 sky130_fd_sc_hd__fill_1
XFILLER_6_497 vssd1 vssd1 vccd1 vccd1 sky130_fd_sc_hd__fill_1
XFILLER_69_449 vssd1 vssd1 vccd1 vccd1 sky130_fd_sc_hd__fill_2
XPHY_EDGE_ROW_63_Left_156 vssd1 vssd1 vccd1 vccd1 sky130_fd_sc_hd__decap_3
XTAP_TAPCELL_ROW_9_291 vssd1 vccd1 sky130_fd_sc_hd__tapvpwrvgnd_1
XANTENNA__7450__A net309 vssd1 vssd1 vccd1 vccd1 sky130_fd_sc_hd__diode_2
XFILLER_1_191 vssd1 vssd1 vccd1 vccd1 sky130_fd_sc_hd__fill_1
XFILLER_49_151 vssd1 vssd1 vccd1 vccd1 sky130_fd_sc_hd__fill_2
X_5971_ _2083_ _0088_ vssd1 vssd1 vccd1 vccd1 _1161_ sky130_fd_sc_hd__nor2_1
X_7710_ _2731_ _2735_ _2965_ vssd1 vssd1 vccd1 vccd1 _2967_ sky130_fd_sc_hd__nor3_1
XTAP_TAPCELL_ROW_63_834 vssd1 vccd1 sky130_fd_sc_hd__tapvpwrvgnd_1
X_4922_ _0102_ _0111_ vssd1 vssd1 vccd1 vccd1 _0112_ sky130_fd_sc_hd__xnor2_1
XANTENNA__4985__A1 net127 vssd1 vssd1 vccd1 vccd1 sky130_fd_sc_hd__diode_2
XTAP_TAPCELL_ROW_35_547 vssd1 vccd1 sky130_fd_sc_hd__tapvpwrvgnd_1
X_7641_ _2892_ _2893_ vssd1 vssd1 vccd1 vccd1 _2894_ sky130_fd_sc_hd__nor2_1
XPHY_EDGE_ROW_72_Left_165 vssd1 vssd1 vccd1 vccd1 sky130_fd_sc_hd__decap_3
X_4853_ _4055_ _4058_ _4130_ vssd1 vssd1 vccd1 vccd1 _4131_ sky130_fd_sc_hd__o21a_1
XANTENNA__4314__A net159 vssd1 vssd1 vccd1 vccd1 sky130_fd_sc_hd__diode_2
X_4784_ _3968_ _3970_ _4060_ vssd1 vssd1 vccd1 vccd1 _4062_ sky130_fd_sc_hd__nand3_1
X_7572_ net91 net53 vssd1 vssd1 vccd1 vccd1 _2820_ sky130_fd_sc_hd__nor2_1
X_6523_ _1703_ _1704_ _1709_ vssd1 vssd1 vccd1 vccd1 _1710_ sky130_fd_sc_hd__and3_1
X_6454_ _0782_ _1641_ _1640_ vssd1 vssd1 vccd1 vccd1 _1642_ sky130_fd_sc_hd__o21ai_1
X_5405_ net104 net49 vssd1 vssd1 vccd1 vccd1 _0595_ sky130_fd_sc_hd__nor2_1
XANTENNA__4968__B _0156_ vssd1 vssd1 vccd1 vccd1 sky130_fd_sc_hd__diode_2
XANTENNA_fanout116_A _2315_ vssd1 vssd1 vccd1 vccd1 sky130_fd_sc_hd__diode_2
X_6385_ _1571_ _1572_ vssd1 vssd1 vccd1 vccd1 _1573_ sky130_fd_sc_hd__and2b_1
XPHY_EDGE_ROW_81_Left_174 vssd1 vssd1 vccd1 vccd1 sky130_fd_sc_hd__decap_3
X_8124_ _3213_ _3216_ _3214_ _2688_ vssd1 vssd1 vccd1 vccd1 _3385_ sky130_fd_sc_hd__o2bb2a_1
XANTENNA__8440__RESET_B net331 vssd1 vssd1 vccd1 vccd1 sky130_fd_sc_hd__diode_2
XANTENNA__5176__D_N net85 vssd1 vssd1 vccd1 vccd1 sky130_fd_sc_hd__diode_2
X_5336_ _0525_ _0524_ vssd1 vssd1 vccd1 vccd1 _0526_ sky130_fd_sc_hd__nand2b_1
XFILLER_87_213 vssd1 vssd1 vccd1 vccd1 sky130_fd_sc_hd__fill_1
X_8055_ _3308_ _3309_ vssd1 vssd1 vccd1 vccd1 _3311_ sky130_fd_sc_hd__nand2_1
XANTENNA__4984__A net127 vssd1 vssd1 vccd1 vccd1 sky130_fd_sc_hd__diode_2
X_5267_ _0455_ _0456_ vssd1 vssd1 vccd1 vccd1 _0457_ sky130_fd_sc_hd__xor2_1
X_7006_ _2218_ _2219_ vssd1 vssd1 vccd1 vccd1 _2222_ sky130_fd_sc_hd__xor2_1
X_4218_ PID_INST.k3_calc.timescaling_term\[4\] net169 vssd1 vssd1 vccd1 vccd1 _2346_
+ sky130_fd_sc_hd__or2_1
XFILLER_68_471 vssd1 vssd1 vccd1 vccd1 sky130_fd_sc_hd__fill_1
X_5198_ _0386_ _0387_ vssd1 vssd1 vccd1 vccd1 _0388_ sky130_fd_sc_hd__nor2_1
XFILLER_68_493 vccd1 vssd1 vccd1 vssd1 sky130_ef_sc_hd__decap_40_12
XANTENNA_fanout273_X net273 vssd1 vssd1 vccd1 vccd1 sky130_fd_sc_hd__diode_2
XFILLER_55_132 vssd1 vssd1 vccd1 vccd1 sky130_fd_sc_hd__fill_2
XFILLER_18_46 vssd1 vssd1 vccd1 vccd1 sky130_fd_sc_hd__fill_1
XTAP_TAPCELL_ROW_87_1066 vssd1 vccd1 sky130_fd_sc_hd__tapvpwrvgnd_1
XFILLER_55_176 vccd1 vssd1 vccd1 vssd1 sky130_ef_sc_hd__decap_40_12
XFILLER_55_165 vssd1 vssd1 vccd1 vccd1 sky130_fd_sc_hd__fill_2
XFILLER_28_368 vssd1 vssd1 vccd1 vccd1 sky130_fd_sc_hd__fill_2
XFILLER_28_379 vssd1 vssd1 vccd1 vccd1 sky130_fd_sc_hd__fill_2
X_7908_ _3088_ _3100_ _3087_ vssd1 vssd1 vccd1 vccd1 _3163_ sky130_fd_sc_hd__a21oi_1
XFILLER_43_349 vccd1 vssd1 vccd1 vssd1 sky130_ef_sc_hd__decap_40_12
XPHY_EDGE_ROW_90_Left_183 vssd1 vssd1 vccd1 vccd1 sky130_fd_sc_hd__decap_3
XFILLER_34_34 vssd1 vssd1 vccd1 vccd1 sky130_fd_sc_hd__fill_4
X_7839_ _3092_ _3093_ vssd1 vssd1 vccd1 vccd1 _3095_ sky130_fd_sc_hd__xor2_1
XFILLER_51_393 vccd1 vssd1 vccd1 vssd1 sky130_ef_sc_hd__decap_40_12
Xclkload0 clknet_4_0_0_clk vssd1 vssd1 vccd1 vccd1 clkload0/Y sky130_fd_sc_hd__inv_6
XFILLER_11_279 vssd1 vssd1 vccd1 vccd1 sky130_fd_sc_hd__fill_1
XFILLER_50_88 vssd1 vssd1 vccd1 vccd1 sky130_fd_sc_hd__fill_4
XANTENNA__7254__B net58 vssd1 vssd1 vccd1 vccd1 sky130_fd_sc_hd__diode_2
XFILLER_3_423 vssd1 vssd1 vccd1 vccd1 sky130_fd_sc_hd__fill_8
XFILLER_3_456 vssd1 vssd1 vccd1 vccd1 sky130_fd_sc_hd__fill_8
XFILLER_78_268 vccd1 vssd1 vccd1 vssd1 sky130_ef_sc_hd__decap_40_12
XTAP_TAPCELL_ROW_6_261 vssd1 vccd1 sky130_fd_sc_hd__tapvpwrvgnd_1
Xfanout281 PID_INST.k2_calc.reg_lc\[8\] vssd1 vssd1 vccd1 vccd1 net281 sky130_fd_sc_hd__buf_2
XANTENNA__8085__B net183 vssd1 vssd1 vccd1 vccd1 sky130_fd_sc_hd__diode_2
Xfanout270 net271 vssd1 vssd1 vccd1 vccd1 net270 sky130_fd_sc_hd__buf_1
Xfanout292 PID_INST.k2_calc.reg_lc\[6\] vssd1 vssd1 vccd1 vccd1 net292 sky130_fd_sc_hd__clkbuf_2
XPHY_EDGE_ROW_3_Left_96 vssd1 vssd1 vccd1 vccd1 sky130_fd_sc_hd__decap_3
XFILLER_19_335 vssd1 vssd1 vccd1 vccd1 sky130_fd_sc_hd__fill_1
XFILLER_34_305 vssd1 vssd1 vccd1 vccd1 sky130_fd_sc_hd__fill_1
XTAP_TAPCELL_ROW_60_804 vssd1 vccd1 sky130_fd_sc_hd__tapvpwrvgnd_1
XTAP_TAPCELL_ROW_32_517 vssd1 vccd1 sky130_fd_sc_hd__tapvpwrvgnd_1
XFILLER_6_250 vssd1 vssd1 vccd1 vccd1 sky130_fd_sc_hd__fill_2
XFILLER_6_294 vssd1 vssd1 vccd1 vccd1 sky130_fd_sc_hd__fill_1
XFILLER_69_202 vssd1 vssd1 vccd1 vccd1 sky130_fd_sc_hd__fill_2
X_6170_ _1358_ _1352_ vssd1 vssd1 vccd1 vccd1 _1359_ sky130_fd_sc_hd__and2b_1
X_5121_ _4160_ _0309_ vssd1 vssd1 vccd1 vccd1 _0311_ sky130_fd_sc_hd__nand2_1
XFILLER_69_257 vssd1 vssd1 vccd1 vccd1 sky130_fd_sc_hd__fill_4
X_5052_ _0092_ _0160_ _0162_ _0159_ vssd1 vssd1 vccd1 vccd1 _0242_ sky130_fd_sc_hd__o2bb2ai_1
XANTENNA__4309__A net251 vssd1 vssd1 vccd1 vccd1 sky130_fd_sc_hd__diode_2
XANTENNA__8426__D net163 vssd1 vssd1 vccd1 vccd1 sky130_fd_sc_hd__diode_2
XFILLER_80_433 vssd1 vssd1 vccd1 vccd1 sky130_fd_sc_hd__fill_4
XFILLER_80_411 vssd1 vssd1 vccd1 vccd1 sky130_fd_sc_hd__fill_8
XANTENNA__4407__B1 net189 vssd1 vssd1 vccd1 vccd1 sky130_fd_sc_hd__diode_2
XFILLER_52_102 vccd1 vssd1 vccd1 vssd1 sky130_ef_sc_hd__decap_40_12
XTAP_TAPCELL_ROW_48_683 vssd1 vccd1 sky130_fd_sc_hd__tapvpwrvgnd_1
XFILLER_52_168 vssd1 vssd1 vccd1 vccd1 sky130_fd_sc_hd__fill_2
X_5954_ _1141_ _1142_ vssd1 vssd1 vccd1 vccd1 _1144_ sky130_fd_sc_hd__xnor2_2
X_5885_ _1060_ _1074_ vssd1 vssd1 vccd1 vccd1 _1075_ sky130_fd_sc_hd__nand2_1
X_4905_ _0090_ _0094_ vssd1 vssd1 vccd1 vccd1 _0095_ sky130_fd_sc_hd__xor2_1
XFILLER_21_522 vssd1 vssd1 vccd1 vccd1 sky130_fd_sc_hd__fill_8
XFILLER_40_319 vssd1 vssd1 vccd1 vccd1 sky130_fd_sc_hd__fill_2
XANTENNA_fanout233_A PID_INST.k2_calc.sum_reg\[4\] vssd1 vssd1 vccd1 vccd1 sky130_fd_sc_hd__diode_2
X_4836_ _4094_ _4112_ vssd1 vssd1 vccd1 vccd1 _4114_ sky130_fd_sc_hd__xnor2_1
X_7624_ _2802_ _2803_ _2800_ vssd1 vssd1 vccd1 vccd1 _2876_ sky130_fd_sc_hd__o21a_1
X_7555_ _2530_ _2541_ _2543_ vssd1 vssd1 vccd1 vccd1 _2803_ sky130_fd_sc_hd__a21boi_1
X_6506_ _1526_ _1691_ vssd1 vssd1 vccd1 vccd1 _1693_ sky130_fd_sc_hd__xor2_1
X_4767_ _4028_ _4043_ vssd1 vssd1 vccd1 vccd1 _4045_ sky130_fd_sc_hd__xnor2_1
X_7486_ _2629_ _2630_ _2632_ _2636_ vssd1 vssd1 vccd1 vccd1 _2730_ sky130_fd_sc_hd__a31oi_1
X_4698_ net128 net86 _3974_ vssd1 vssd1 vccd1 vccd1 _3976_ sky130_fd_sc_hd__and3_1
XANTENNA__4698__B net86 vssd1 vssd1 vccd1 vccd1 sky130_fd_sc_hd__diode_2
XANTENNA_fanout119_X net119 vssd1 vssd1 vccd1 vccd1 sky130_fd_sc_hd__diode_2
X_6437_ _1623_ _1624_ vssd1 vssd1 vccd1 vccd1 _1625_ sky130_fd_sc_hd__nor2_1
X_6368_ _1350_ _1363_ _1349_ vssd1 vssd1 vccd1 vccd1 _1556_ sky130_fd_sc_hd__o21a_1
XFILLER_88_533 vssd1 vssd1 vccd1 vccd1 sky130_fd_sc_hd__fill_2
XFILLER_88_522 vssd1 vssd1 vccd1 vccd1 sky130_fd_sc_hd__fill_8
X_8107_ net294 net181 _3363_ _3365_ vssd1 vssd1 vccd1 vccd1 _3367_ sky130_fd_sc_hd__o2bb2a_1
X_5319_ _2083_ net71 vssd1 vssd1 vccd1 vccd1 _0509_ sky130_fd_sc_hd__nor2_1
Xhold23 net24 vssd1 vssd1 vccd1 vccd1 net416 sky130_fd_sc_hd__dlygate4sd3_1
X_6299_ _1486_ _1487_ vssd1 vssd1 vccd1 vccd1 _1488_ sky130_fd_sc_hd__xor2_1
XFILLER_29_12 vssd1 vssd1 vccd1 vccd1 sky130_fd_sc_hd__fill_2
Xhold12 PID_INST.k1_calc.d1.x\[2\] vssd1 vssd1 vccd1 vccd1 net405 sky130_fd_sc_hd__dlygate4sd3_1
Xhold34 PID_INST.k1_calc.d1.x\[5\] vssd1 vssd1 vccd1 vccd1 net427 sky130_fd_sc_hd__dlygate4sd3_1
X_8038_ _3142_ _3143_ _3145_ vssd1 vssd1 vccd1 vccd1 _3292_ sky130_fd_sc_hd__a21bo_1
XFILLER_29_78 vssd1 vssd1 vccd1 vccd1 sky130_fd_sc_hd__fill_1
XFILLER_56_441 vssd1 vssd1 vccd1 vccd1 sky130_fd_sc_hd__fill_4
XFILLER_56_430 vssd1 vssd1 vccd1 vccd1 sky130_fd_sc_hd__fill_2
XTAP_TAPCELL_ROW_3_231 vssd1 vccd1 sky130_fd_sc_hd__tapvpwrvgnd_1
XFILLER_83_260 vssd1 vssd1 vccd1 vccd1 sky130_fd_sc_hd__fill_2
XFILLER_83_293 vssd1 vssd1 vccd1 vccd1 sky130_fd_sc_hd__fill_1
XANTENNA__6153__B _3774_ vssd1 vssd1 vccd1 vccd1 sky130_fd_sc_hd__diode_2
XFILLER_12_533 vssd1 vssd1 vccd1 vccd1 sky130_fd_sc_hd__fill_8
XANTENNA__7115__A2 net193 vssd1 vssd1 vccd1 vccd1 sky130_fd_sc_hd__diode_2
XFILLER_6_38 vccd1 vssd1 vccd1 vssd1 sky130_ef_sc_hd__decap_40_12
XFILLER_6_27 vssd1 vssd1 vccd1 vccd1 sky130_fd_sc_hd__fill_1
XANTENNA__4401__B net10 vssd1 vssd1 vccd1 vccd1 sky130_fd_sc_hd__diode_2
XANTENNA__7712__B _2968_ vssd1 vssd1 vccd1 vccd1 sky130_fd_sc_hd__diode_2
XFILLER_3_275 vssd1 vssd1 vccd1 vccd1 sky130_fd_sc_hd__fill_2
XANTENNA__8429__CLK clknet_4_1_0_clk vssd1 vssd1 vccd1 vccd1 sky130_fd_sc_hd__diode_2
XANTENNA__6328__B net47 vssd1 vssd1 vccd1 vccd1 sky130_fd_sc_hd__diode_2
XFILLER_86_95 vssd1 vssd1 vccd1 vccd1 sky130_fd_sc_hd__fill_4
XFILLER_47_430 vssd1 vssd1 vccd1 vccd1 sky130_fd_sc_hd__fill_1
XFILLER_81_219 vssd1 vssd1 vccd1 vccd1 sky130_fd_sc_hd__fill_4
XTAP_TAPCELL_ROW_45_653 vssd1 vccd1 sky130_fd_sc_hd__tapvpwrvgnd_1
XTAP_TAPCELL_ROW_17_366 vssd1 vccd1 sky130_fd_sc_hd__tapvpwrvgnd_1
XFILLER_34_179 vssd1 vssd1 vccd1 vccd1 sky130_fd_sc_hd__fill_1
X_5670_ net319 net219 _0827_ vssd1 vssd1 vccd1 vccd1 _0860_ sky130_fd_sc_hd__a21o_1
XFILLER_15_393 vssd1 vssd1 vccd1 vccd1 sky130_fd_sc_hd__fill_2
XANTENNA_clkbuf_0_clk_A clk vssd1 vssd1 vccd1 vccd1 sky130_fd_sc_hd__diode_2
X_4621_ _3887_ _3892_ _3898_ vssd1 vssd1 vccd1 vccd1 _3899_ sky130_fd_sc_hd__a21bo_1
XANTENNA__4168__A2 net174 vssd1 vssd1 vccd1 vccd1 sky130_fd_sc_hd__diode_2
X_7340_ _2573_ _2574_ vssd1 vssd1 vccd1 vccd1 _2575_ sky130_fd_sc_hd__nand2_1
X_4552_ _3769_ _3772_ _3828_ vssd1 vssd1 vccd1 vccd1 _3830_ sky130_fd_sc_hd__o21ai_2
XANTENNA__4311__B net13 vssd1 vssd1 vccd1 vccd1 sky130_fd_sc_hd__diode_2
X_4483_ _3738_ _3759_ _3760_ vssd1 vssd1 vccd1 vccd1 _3761_ sky130_fd_sc_hd__or3_1
XANTENNA__5117__A1 net118 vssd1 vssd1 vccd1 vccd1 sky130_fd_sc_hd__diode_2
X_7271_ _2499_ _2500_ vssd1 vssd1 vccd1 vccd1 _2501_ sky130_fd_sc_hd__xnor2_1
X_6222_ _1409_ _1410_ vssd1 vssd1 vccd1 vccd1 _1411_ sky130_fd_sc_hd__xor2_2
XANTENNA_clkbuf_4_9_0_clk_A clknet_0_clk vssd1 vssd1 vccd1 vccd1 sky130_fd_sc_hd__diode_2
X_6153_ net149 _3774_ _1341_ vssd1 vssd1 vccd1 vccd1 _1342_ sky130_fd_sc_hd__or3_1
XFILLER_85_503 vssd1 vssd1 vccd1 vccd1 sky130_fd_sc_hd__fill_1
X_6084_ _1267_ _1268_ _1273_ vssd1 vssd1 vccd1 vccd1 _1274_ sky130_fd_sc_hd__nor3_1
X_5104_ _0209_ _0210_ _0212_ vssd1 vssd1 vccd1 vccd1 _0294_ sky130_fd_sc_hd__a21boi_1
XFILLER_85_569 vssd1 vssd1 vccd1 vccd1 sky130_fd_sc_hd__fill_1
X_5035_ _0223_ _0224_ vssd1 vssd1 vccd1 vccd1 _0225_ sky130_fd_sc_hd__nor2_1
XTAP_TAPCELL_ROW_0_201 vssd1 vccd1 sky130_fd_sc_hd__tapvpwrvgnd_1
XFILLER_65_271 vssd1 vssd1 vccd1 vccd1 sky130_fd_sc_hd__fill_2
XFILLER_25_102 vssd1 vssd1 vccd1 vccd1 sky130_fd_sc_hd__fill_8
XTAP_TAPCELL_ROW_84_1036 vssd1 vccd1 sky130_fd_sc_hd__tapvpwrvgnd_1
X_6986_ net114 net41 vssd1 vssd1 vccd1 vccd1 _2201_ sky130_fd_sc_hd__nor2_1
XFILLER_53_488 vssd1 vssd1 vccd1 vccd1 sky130_fd_sc_hd__fill_8
X_5937_ _0148_ _0227_ _0230_ _0304_ vssd1 vssd1 vccd1 vccd1 _1127_ sky130_fd_sc_hd__a22o_1
XFILLER_40_149 vssd1 vssd1 vccd1 vccd1 sky130_fd_sc_hd__fill_1
X_5868_ net320 net238 vssd1 vssd1 vccd1 vccd1 _1058_ sky130_fd_sc_hd__and2_1
XANTENNA_fanout236_X net236 vssd1 vssd1 vccd1 vccd1 sky130_fd_sc_hd__diode_2
X_7607_ _2784_ _2857_ vssd1 vssd1 vccd1 vccd1 _2859_ sky130_fd_sc_hd__xnor2_1
X_5799_ _0980_ _0981_ vssd1 vssd1 vccd1 vccd1 _0989_ sky130_fd_sc_hd__xnor2_1
X_4819_ _4095_ _4096_ vssd1 vssd1 vccd1 vccd1 _4097_ sky130_fd_sc_hd__nor2_1
X_7538_ net119 _1583_ vssd1 vssd1 vccd1 vccd1 _2785_ sky130_fd_sc_hd__nor2_1
X_7469_ _2709_ _2710_ _2711_ vssd1 vssd1 vccd1 vccd1 _2712_ sky130_fd_sc_hd__or3_1
XANTENNA__4221__B net175 vssd1 vssd1 vccd1 vccd1 sky130_fd_sc_hd__diode_2
Xoutput24 net24 vssd1 vssd1 vccd1 vccd1 gpio_out[21] sky130_fd_sc_hd__buf_2
Xoutput35 net35 vssd1 vssd1 vccd1 vccd1 gpio_out[32] sky130_fd_sc_hd__buf_2
XFILLER_0_223 vssd1 vssd1 vccd1 vccd1 sky130_fd_sc_hd__fill_1
XANTENNA__5333__A net125 vssd1 vssd1 vccd1 vccd1 sky130_fd_sc_hd__diode_2
XFILLER_88_363 vssd1 vssd1 vccd1 vccd1 sky130_fd_sc_hd__fill_1
XFILLER_76_536 vssd1 vssd1 vccd1 vccd1 sky130_fd_sc_hd__fill_4
XTAP_TAPCELL_ROW_59_789 vssd1 vccd1 sky130_fd_sc_hd__tapvpwrvgnd_1
XANTENNA_fanout51_X net51 vssd1 vssd1 vccd1 vccd1 sky130_fd_sc_hd__diode_2
XFILLER_29_496 vssd1 vssd1 vccd1 vccd1 sky130_fd_sc_hd__fill_8
XPHY_EDGE_ROW_19_Right_19 vssd1 vssd1 vccd1 vccd1 sky130_fd_sc_hd__decap_3
XFILLER_72_31 vssd1 vssd1 vccd1 vccd1 sky130_fd_sc_hd__fill_1
XFILLER_72_20 vssd1 vssd1 vccd1 vccd1 sky130_fd_sc_hd__fill_1
XTAP_TAPCELL_ROW_14_336 vssd1 vccd1 sky130_fd_sc_hd__tapvpwrvgnd_1
XTAP_TAPCELL_ROW_42_623 vssd1 vccd1 sky130_fd_sc_hd__tapvpwrvgnd_1
XFILLER_12_363 vssd1 vssd1 vccd1 vccd1 sky130_fd_sc_hd__fill_1
XPHY_EDGE_ROW_28_Right_28 vssd1 vssd1 vccd1 vccd1 sky130_fd_sc_hd__decap_3
XFILLER_39_216 vssd1 vssd1 vccd1 vccd1 sky130_fd_sc_hd__fill_8
XFILLER_67_558 vssd1 vssd1 vccd1 vccd1 sky130_fd_sc_hd__fill_2
XANTENNA__7272__A1 net99 vssd1 vssd1 vccd1 vccd1 sky130_fd_sc_hd__diode_2
XFILLER_35_422 vssd1 vssd1 vccd1 vccd1 sky130_fd_sc_hd__fill_8
XPHY_EDGE_ROW_37_Right_37 vssd1 vssd1 vccd1 vccd1 sky130_fd_sc_hd__decap_3
X_6840_ _2044_ _2045_ vssd1 vssd1 vccd1 vccd1 _2046_ sky130_fd_sc_hd__xor2_1
X_6771_ _1970_ _1971_ vssd1 vssd1 vccd1 vccd1 _1972_ sky130_fd_sc_hd__or2_1
XFILLER_50_403 vssd1 vssd1 vccd1 vccd1 sky130_fd_sc_hd__fill_2
XFILLER_35_499 vssd1 vssd1 vccd1 vccd1 sky130_fd_sc_hd__fill_4
XANTENNA__5586__B2 net278 vssd1 vssd1 vccd1 vccd1 sky130_fd_sc_hd__diode_2
X_5722_ _0907_ _0911_ vssd1 vssd1 vccd1 vccd1 _0912_ sky130_fd_sc_hd__and2b_1
X_5653_ _0744_ _0842_ vssd1 vssd1 vccd1 vccd1 _0843_ sky130_fd_sc_hd__and2_1
X_8441_ clknet_4_12_0_clk net409 net335 vssd1 vssd1 vccd1 vccd1 PID_INST.k3_calc.prev_error\[13\]
+ sky130_fd_sc_hd__dfrtp_1
X_5584_ net223 net295 vssd1 vssd1 vccd1 vccd1 _0774_ sky130_fd_sc_hd__nand2_1
XANTENNA__4322__A net159 vssd1 vssd1 vccd1 vccd1 sky130_fd_sc_hd__diode_2
X_8372_ clknet_4_4_0_clk _0008_ net331 vssd1 vssd1 vccd1 vccd1 PID_INST.k1_calc.d1.x\[8\]
+ sky130_fd_sc_hd__dfrtp_1
XPHY_EDGE_ROW_46_Right_46 vssd1 vssd1 vccd1 vccd1 sky130_fd_sc_hd__decap_3
X_4604_ _3858_ _3859_ _3881_ vssd1 vssd1 vccd1 vccd1 _3882_ sky130_fd_sc_hd__nand3_2
XANTENNA__5418__A net115 vssd1 vssd1 vccd1 vccd1 sky130_fd_sc_hd__diode_2
X_4535_ net126 net143 _3811_ _3810_ vssd1 vssd1 vccd1 vccd1 _3813_ sky130_fd_sc_hd__a31o_1
X_7323_ _2223_ _2555_ _2554_ _2473_ vssd1 vssd1 vccd1 vccd1 _2557_ sky130_fd_sc_hd__o211ai_4
XFILLER_89_105 vssd1 vssd1 vccd1 vccd1 sky130_fd_sc_hd__fill_4
X_4466_ _3742_ _3743_ vssd1 vssd1 vccd1 vccd1 _3744_ sky130_fd_sc_hd__nor2_1
X_7254_ net91 net58 vssd1 vssd1 vccd1 vccd1 _2483_ sky130_fd_sc_hd__nor2_1
X_4397_ _3686_ _3687_ net160 vssd1 vssd1 vccd1 vccd1 _3689_ sky130_fd_sc_hd__o21a_1
X_6205_ net104 net41 vssd1 vssd1 vccd1 vccd1 _1394_ sky130_fd_sc_hd__nor2_1
X_7185_ _2403_ _2409_ vssd1 vssd1 vccd1 vccd1 _2411_ sky130_fd_sc_hd__xor2_1
X_6136_ _1116_ _1121_ _1115_ vssd1 vssd1 vccd1 vccd1 _1325_ sky130_fd_sc_hd__a21oi_1
XFILLER_85_333 vssd1 vssd1 vccd1 vccd1 sky130_fd_sc_hd__fill_2
XFILLER_73_517 vccd1 vssd1 vccd1 vssd1 sky130_ef_sc_hd__decap_40_12
X_6067_ _1255_ _1256_ vssd1 vssd1 vccd1 vccd1 _1257_ sky130_fd_sc_hd__or2_1
XANTENNA_fanout186_X net186 vssd1 vssd1 vccd1 vccd1 sky130_fd_sc_hd__diode_2
XPHY_EDGE_ROW_55_Right_55 vssd1 vssd1 vccd1 vccd1 sky130_fd_sc_hd__decap_3
XFILLER_73_539 vccd1 vssd1 vccd1 vssd1 sky130_ef_sc_hd__decap_40_12
X_5018_ _0206_ _0207_ vssd1 vssd1 vccd1 vccd1 _0208_ sky130_fd_sc_hd__nor2_1
XTAP_TAPCELL_ROW_56_759 vssd1 vccd1 sky130_fd_sc_hd__tapvpwrvgnd_1
XFILLER_26_433 vccd1 vssd1 vccd1 vssd1 sky130_ef_sc_hd__decap_40_12
XFILLER_26_68 vssd1 vssd1 vccd1 vccd1 sky130_fd_sc_hd__fill_2
XFILLER_26_466 vssd1 vssd1 vccd1 vccd1 sky130_fd_sc_hd__fill_2
XFILLER_26_499 vssd1 vssd1 vccd1 vccd1 sky130_fd_sc_hd__fill_4
X_6969_ _2073_ _2181_ vssd1 vssd1 vccd1 vccd1 _2183_ sky130_fd_sc_hd__nand2_1
XPHY_EDGE_ROW_64_Right_64 vssd1 vssd1 vccd1 vccd1 sky130_fd_sc_hd__decap_3
XTAP_TAPCELL_ROW_11_306 vssd1 vccd1 sky130_fd_sc_hd__tapvpwrvgnd_1
XANTENNA__5329__A1 net121 vssd1 vssd1 vccd1 vccd1 sky130_fd_sc_hd__diode_2
XANTENNA__4232__A net107 vssd1 vssd1 vccd1 vccd1 sky130_fd_sc_hd__diode_2
XANTENNA__8358__B _3619_ vssd1 vssd1 vccd1 vccd1 sky130_fd_sc_hd__diode_2
XANTENNA_fanout99_X net99 vssd1 vssd1 vccd1 vccd1 sky130_fd_sc_hd__diode_2
XANTENNA__5501__A1 net314 vssd1 vssd1 vccd1 vccd1 sky130_fd_sc_hd__diode_2
XFILLER_1_565 vssd1 vssd1 vccd1 vccd1 sky130_fd_sc_hd__fill_2
XFILLER_88_193 vssd1 vssd1 vccd1 vccd1 sky130_fd_sc_hd__fill_2
XPHY_EDGE_ROW_73_Right_73 vssd1 vssd1 vccd1 vccd1 sky130_fd_sc_hd__decap_3
XANTENNA__5804__A2 net296 vssd1 vssd1 vccd1 vccd1 sky130_fd_sc_hd__diode_2
XFILLER_29_260 vssd1 vssd1 vccd1 vccd1 sky130_fd_sc_hd__fill_1
XFILLER_83_52 vssd1 vssd1 vccd1 vccd1 sky130_fd_sc_hd__fill_4
XFILLER_83_96 vccd1 vssd1 vccd1 vssd1 sky130_ef_sc_hd__decap_40_12
XFILLER_44_285 vssd1 vssd1 vccd1 vccd1 sky130_fd_sc_hd__fill_2
XTAP_TAPCELL_ROW_27_472 vssd1 vccd1 sky130_fd_sc_hd__tapvpwrvgnd_1
XPHY_EDGE_ROW_82_Right_82 vssd1 vssd1 vccd1 vccd1 sky130_fd_sc_hd__decap_3
XANTENNA__4240__A1 net6 vssd1 vssd1 vccd1 vccd1 sky130_fd_sc_hd__diode_2
XANTENNA__6341__B net78 vssd1 vssd1 vccd1 vccd1 sky130_fd_sc_hd__diode_2
XFILLER_8_197 vssd1 vssd1 vccd1 vccd1 sky130_fd_sc_hd__fill_4
X_4320_ _3375_ _3386_ _3364_ vssd1 vssd1 vccd1 vccd1 _3408_ sky130_fd_sc_hd__a21o_1
XANTENNA__4288__S net157 vssd1 vssd1 vccd1 vccd1 sky130_fd_sc_hd__diode_2
X_4251_ PID_INST.k3_calc.timescaling_term\[13\] net170 vssd1 vssd1 vccd1 vccd1 _2696_
+ sky130_fd_sc_hd__or2_1
XPHY_EDGE_ROW_91_Right_91 vssd1 vssd1 vccd1 vccd1 sky130_fd_sc_hd__decap_3
XFILLER_67_333 vssd1 vssd1 vccd1 vccd1 sky130_fd_sc_hd__fill_2
X_4182_ net149 vssd1 vssd1 vccd1 vccd1 PID_INST.k3_calc.d1.y\[11\] sky130_fd_sc_hd__inv_2
X_7941_ _2995_ _2997_ _2994_ vssd1 vssd1 vccd1 vccd1 _3196_ sky130_fd_sc_hd__o21ba_1
XFILLER_55_528 vssd1 vssd1 vccd1 vccd1 sky130_fd_sc_hd__fill_8
X_7872_ _3125_ _3126_ vssd1 vssd1 vccd1 vccd1 _3127_ sky130_fd_sc_hd__xnor2_1
XTAP_TAPCELL_ROW_81_1006 vssd1 vccd1 sky130_fd_sc_hd__tapvpwrvgnd_1
XFILLER_63_561 vssd1 vssd1 vccd1 vccd1 sky130_fd_sc_hd__fill_8
XFILLER_63_550 vssd1 vssd1 vccd1 vccd1 sky130_fd_sc_hd__fill_2
XTAP_TAPCELL_ROW_53_729 vssd1 vccd1 sky130_fd_sc_hd__tapvpwrvgnd_1
XANTENNA__5559__A1 net227 vssd1 vssd1 vccd1 vccd1 sky130_fd_sc_hd__diode_2
X_6823_ _2026_ _2027_ vssd1 vssd1 vccd1 vccd1 _2028_ sky130_fd_sc_hd__and2_1
X_6754_ _1952_ _1953_ vssd1 vssd1 vccd1 vccd1 _1954_ sky130_fd_sc_hd__nand2_1
XANTENNA__4231__A1 net14 vssd1 vssd1 vccd1 vccd1 sky130_fd_sc_hd__diode_2
X_6685_ _1875_ _1881_ vssd1 vssd1 vccd1 vccd1 _1883_ sky130_fd_sc_hd__nand2b_1
X_5705_ _0892_ _0893_ net246 net290 vssd1 vssd1 vccd1 vccd1 _0895_ sky130_fd_sc_hd__and4b_1
X_5636_ _0825_ vssd1 vssd1 vccd1 vccd1 _0826_ sky130_fd_sc_hd__inv_2
X_8424_ clknet_4_2_0_clk net138 net330 vssd1 vssd1 vccd1 vccd1 PID_INST.k3_calc.kd_term\[12\]
+ sky130_fd_sc_hd__dfrtp_1
XFILLER_12_15 vccd1 vssd1 vccd1 vssd1 sky130_ef_sc_hd__decap_40_12
XANTENNA_fanout313_A net316 vssd1 vssd1 vccd1 vccd1 sky130_fd_sc_hd__diode_2
XANTENNA__7363__A net308 vssd1 vssd1 vccd1 vccd1 sky130_fd_sc_hd__diode_2
X_5567_ _0753_ _0755_ vssd1 vssd1 vccd1 vccd1 _0757_ sky130_fd_sc_hd__or2_1
X_8355_ _3618_ _3631_ vssd1 vssd1 vccd1 vccd1 _3634_ sky130_fd_sc_hd__xnor2_1
XTAP_TAPCELL_ROW_92_1135 vssd1 vccd1 sky130_fd_sc_hd__tapvpwrvgnd_1
XTAP_TAPCELL_ROW_92_1124 vssd1 vccd1 sky130_fd_sc_hd__tapvpwrvgnd_1
X_8286_ _3557_ _3558_ vssd1 vssd1 vccd1 vccd1 _3559_ sky130_fd_sc_hd__xnor2_1
X_5498_ _0603_ _0687_ vssd1 vssd1 vccd1 vccd1 _0688_ sky130_fd_sc_hd__nand2_1
X_4518_ _3789_ _3795_ vssd1 vssd1 vccd1 vccd1 _3796_ sky130_fd_sc_hd__nand2b_1
XFILLER_2_307 vssd1 vssd1 vccd1 vccd1 sky130_fd_sc_hd__fill_1
XANTENNA_fanout101_X net101 vssd1 vssd1 vccd1 vccd1 sky130_fd_sc_hd__diode_2
X_7306_ _2536_ _2538_ vssd1 vssd1 vccd1 vccd1 _2539_ sky130_fd_sc_hd__xor2_1
XANTENNA__6287__A2 net287 vssd1 vssd1 vccd1 vccd1 sky130_fd_sc_hd__diode_2
X_4449_ _3720_ _3725_ _3726_ _3719_ vssd1 vssd1 vccd1 vccd1 _3727_ sky130_fd_sc_hd__a211o_1
X_7237_ _2417_ _2465_ vssd1 vssd1 vccd1 vccd1 _2466_ sky130_fd_sc_hd__nand2_1
XFILLER_58_300 vssd1 vssd1 vccd1 vccd1 sky130_fd_sc_hd__fill_8
XANTENNA__4298__A1 net17 vssd1 vssd1 vccd1 vccd1 sky130_fd_sc_hd__diode_2
X_7168_ _2391_ _2392_ vssd1 vssd1 vccd1 vccd1 _2393_ sky130_fd_sc_hd__nor2_1
XANTENNA__6039__A2 net314 vssd1 vssd1 vccd1 vccd1 sky130_fd_sc_hd__diode_2
XFILLER_58_333 vssd1 vssd1 vccd1 vccd1 sky130_fd_sc_hd__fill_4
X_7099_ _2226_ _2228_ _2225_ vssd1 vssd1 vccd1 vccd1 _2320_ sky130_fd_sc_hd__o21ba_1
X_6119_ net118 net54 _1306_ vssd1 vssd1 vccd1 vccd1 _1308_ sky130_fd_sc_hd__or3_1
XANTENNA__7810__B net44 vssd1 vssd1 vccd1 vccd1 sky130_fd_sc_hd__diode_2
XFILLER_73_314 vssd1 vssd1 vccd1 vccd1 sky130_fd_sc_hd__fill_2
XTAP_TAPCELL_ROW_69_895 vssd1 vccd1 sky130_fd_sc_hd__tapvpwrvgnd_1
XFILLER_46_517 vssd1 vssd1 vccd1 vccd1 sky130_fd_sc_hd__fill_1
XFILLER_54_561 vssd1 vssd1 vccd1 vccd1 sky130_fd_sc_hd__fill_1
XTAP_TAPCELL_ROW_24_442 vssd1 vccd1 sky130_fd_sc_hd__tapvpwrvgnd_1
XANTENNA__4222__A1 net13 vssd1 vssd1 vccd1 vccd1 sky130_fd_sc_hd__diode_2
XANTENNA__7538__A net119 vssd1 vssd1 vccd1 vccd1 sky130_fd_sc_hd__diode_2
XFILLER_5_101 vssd1 vssd1 vccd1 vccd1 sky130_fd_sc_hd__fill_1
XANTENNA__7273__A net97 vssd1 vssd1 vccd1 vccd1 sky130_fd_sc_hd__diode_2
XFILLER_5_189 vssd1 vssd1 vccd1 vccd1 sky130_fd_sc_hd__fill_1
XFILLER_78_63 vssd1 vssd1 vccd1 vccd1 sky130_fd_sc_hd__fill_2
XANTENNA__4289__A1 net7 vssd1 vssd1 vccd1 vccd1 sky130_fd_sc_hd__diode_2
XFILLER_1_384 vssd1 vssd1 vccd1 vccd1 sky130_fd_sc_hd__fill_1
XFILLER_76_141 vssd1 vssd1 vccd1 vccd1 sky130_fd_sc_hd__fill_2
XFILLER_64_314 vccd1 vssd1 vccd1 vssd1 sky130_ef_sc_hd__decap_40_12
XFILLER_37_517 vccd1 vssd1 vccd1 vssd1 sky130_ef_sc_hd__decap_40_12
XFILLER_64_336 vssd1 vssd1 vccd1 vccd1 sky130_fd_sc_hd__fill_2
XFILLER_45_561 vssd1 vssd1 vccd1 vccd1 sky130_fd_sc_hd__fill_1
XANTENNA__7448__A net206 vssd1 vssd1 vccd1 vccd1 sky130_fd_sc_hd__diode_2
XFILLER_32_233 vssd1 vssd1 vccd1 vccd1 sky130_fd_sc_hd__fill_4
XFILLER_20_417 vssd1 vssd1 vccd1 vccd1 sky130_fd_sc_hd__fill_2
X_6470_ _1639_ _1656_ vssd1 vssd1 vccd1 vccd1 _1658_ sky130_fd_sc_hd__xnor2_1
XFILLER_71_3 vssd1 vssd1 vccd1 vccd1 sky130_fd_sc_hd__fill_4
X_5421_ net111 net60 _0609_ vssd1 vssd1 vccd1 vccd1 _0611_ sky130_fd_sc_hd__or3_1
X_8140_ _3400_ _3401_ vssd1 vssd1 vccd1 vccd1 _3403_ sky130_fd_sc_hd__xnor2_1
X_5352_ _0467_ _0469_ _0541_ vssd1 vssd1 vccd1 vccd1 _0542_ sky130_fd_sc_hd__a21oi_1
X_8071_ _3326_ _3327_ vssd1 vssd1 vccd1 vccd1 _3328_ sky130_fd_sc_hd__nor2_1
X_4303_ net275 net5 net172 vssd1 vssd1 vccd1 vccd1 _0026_ sky130_fd_sc_hd__mux2_1
X_7022_ _2233_ _2238_ vssd1 vssd1 vccd1 vccd1 _2239_ sky130_fd_sc_hd__nand2_1
X_5283_ _0470_ _0471_ vssd1 vssd1 vccd1 vccd1 _0473_ sky130_fd_sc_hd__xor2_1
XFILLER_87_439 vssd1 vssd1 vccd1 vccd1 sky130_fd_sc_hd__fill_2
X_4234_ net13 net167 _2505_ vssd1 vssd1 vccd1 vccd1 _2516_ sky130_fd_sc_hd__o21ai_1
X_4165_ net176 PID_INST.pid.curr_state\[2\] PID_INST.pid.curr_state\[3\] net177 vssd1
+ vssd1 vccd1 vccd1 _1784_ sky130_fd_sc_hd__and4bb_2
XFILLER_82_111 vssd1 vssd1 vccd1 vccd1 sky130_fd_sc_hd__fill_1
XFILLER_28_539 vccd1 vssd1 vccd1 vssd1 sky130_ef_sc_hd__decap_40_12
XFILLER_82_166 vssd1 vssd1 vccd1 vccd1 sky130_fd_sc_hd__fill_2
X_7924_ net267 net197 net201 net263 vssd1 vssd1 vccd1 vccd1 _3179_ sky130_fd_sc_hd__a22oi_1
XTAP_TAPCELL_ROW_66_865 vssd1 vccd1 sky130_fd_sc_hd__tapvpwrvgnd_1
XTAP_TAPCELL_ROW_38_578 vssd1 vccd1 sky130_fd_sc_hd__tapvpwrvgnd_1
X_7855_ _3110_ vssd1 vssd1 vccd1 vccd1 _3111_ sky130_fd_sc_hd__inv_2
XFILLER_23_222 vssd1 vssd1 vccd1 vccd1 sky130_fd_sc_hd__fill_2
X_6806_ net164 _3754_ _1692_ _1694_ vssd1 vssd1 vccd1 vccd1 _2010_ sky130_fd_sc_hd__a31o_1
X_7786_ _3039_ _3040_ _3041_ vssd1 vssd1 vccd1 vccd1 _3042_ sky130_fd_sc_hd__and3_1
XFILLER_11_428 vssd1 vssd1 vccd1 vccd1 sky130_fd_sc_hd__fill_1
XTAP_TAPCELL_ROW_21_412 vssd1 vccd1 sky130_fd_sc_hd__tapvpwrvgnd_1
X_4998_ net137 net89 vssd1 vssd1 vccd1 vccd1 _0188_ sky130_fd_sc_hd__and2_1
X_6737_ _1853_ _1862_ _1861_ vssd1 vssd1 vccd1 vccd1 _1936_ sky130_fd_sc_hd__a21oi_1
X_6668_ _1629_ _1632_ _1863_ vssd1 vssd1 vccd1 vccd1 _1864_ sky130_fd_sc_hd__a21o_1
XANTENNA_fanout316_X net316 vssd1 vssd1 vccd1 vccd1 sky130_fd_sc_hd__diode_2
X_5619_ _0806_ _0807_ net323 net203 vssd1 vssd1 vccd1 vccd1 _0809_ sky130_fd_sc_hd__and4b_1
X_8407_ clknet_4_6_0_clk _0027_ net337 vssd1 vssd1 vccd1 vccd1 PID_INST.k2_calc.reg_lc\[11\]
+ sky130_fd_sc_hd__dfrtp_1
X_6599_ _1787_ _1788_ vssd1 vssd1 vccd1 vccd1 _1789_ sky130_fd_sc_hd__xor2_1
XANTENNA__5606__A net291 vssd1 vssd1 vccd1 vccd1 sky130_fd_sc_hd__diode_2
X_8338_ _3131_ _3428_ _3431_ _3432_ vssd1 vssd1 vccd1 vccd1 _3616_ sky130_fd_sc_hd__o2bb2a_1
XFILLER_2_126 vssd1 vssd1 vccd1 vccd1 sky130_fd_sc_hd__fill_1
X_8269_ _3260_ _3409_ _3410_ vssd1 vssd1 vccd1 vccd1 _3542_ sky130_fd_sc_hd__a21o_1
XANTENNA__7821__A net98 vssd1 vssd1 vccd1 vccd1 sky130_fd_sc_hd__diode_2
XFILLER_86_450 vssd1 vssd1 vccd1 vccd1 sky130_fd_sc_hd__fill_1
XFILLER_86_461 vssd1 vssd1 vccd1 vccd1 sky130_fd_sc_hd__fill_2
XFILLER_48_88 vssd1 vssd1 vccd1 vccd1 sky130_fd_sc_hd__fill_1
XFILLER_48_77 vssd1 vssd1 vccd1 vccd1 sky130_fd_sc_hd__fill_2
XFILLER_19_517 vccd1 vssd1 vccd1 vssd1 sky130_ef_sc_hd__decap_40_12
XFILLER_73_111 vssd1 vssd1 vccd1 vccd1 sky130_fd_sc_hd__fill_1
XFILLER_46_336 vssd1 vssd1 vccd1 vccd1 sky130_fd_sc_hd__fill_4
XFILLER_0_29 vccd1 vssd1 vccd1 vssd1 sky130_ef_sc_hd__decap_40_12
XFILLER_54_380 vssd1 vssd1 vccd1 vccd1 sky130_fd_sc_hd__fill_4
XFILLER_14_266 vccd1 vssd1 vccd1 vssd1 sky130_ef_sc_hd__decap_40_12
XFILLER_14_288 vssd1 vssd1 vccd1 vccd1 sky130_fd_sc_hd__fill_4
Xfanout92 _2739_ vssd1 vssd1 vccd1 vccd1 net92 sky130_fd_sc_hd__clkbuf_2
Xfanout70 _4101_ vssd1 vssd1 vccd1 vccd1 net70 sky130_fd_sc_hd__buf_2
Xfanout81 net83 vssd1 vssd1 vccd1 vccd1 net81 sky130_fd_sc_hd__buf_2
XANTENNA__4898__Y _0088_ vssd1 vssd1 vccd1 vccd1 sky130_fd_sc_hd__diode_2
XANTENNA__8099__A net202 vssd1 vssd1 vccd1 vccd1 sky130_fd_sc_hd__diode_2
XFILLER_6_443 vssd1 vssd1 vccd1 vccd1 sky130_fd_sc_hd__fill_1
XFILLER_89_62 vssd1 vssd1 vccd1 vccd1 sky130_fd_sc_hd__fill_4
XFILLER_89_95 vssd1 vssd1 vccd1 vccd1 sky130_fd_sc_hd__fill_4
XTAP_TAPCELL_ROW_9_292 vssd1 vccd1 sky130_fd_sc_hd__tapvpwrvgnd_1
XANTENNA__7450__B net186 vssd1 vssd1 vccd1 vccd1 sky130_fd_sc_hd__diode_2
XFILLER_77_483 vssd1 vssd1 vccd1 vccd1 sky130_fd_sc_hd__fill_8
XFILLER_92_442 vssd1 vssd1 vccd1 vccd1 sky130_fd_sc_hd__fill_4
XFILLER_77_494 vssd1 vssd1 vccd1 vccd1 sky130_fd_sc_hd__fill_2
XFILLER_92_475 vssd1 vssd1 vccd1 vccd1 sky130_fd_sc_hd__fill_1
X_5970_ _0427_ _0510_ _0512_ vssd1 vssd1 vccd1 vccd1 _1160_ sky130_fd_sc_hd__a21o_1
XTAP_TAPCELL_ROW_63_835 vssd1 vccd1 sky130_fd_sc_hd__tapvpwrvgnd_1
XFILLER_52_328 vccd1 vssd1 vccd1 vssd1 sky130_ef_sc_hd__decap_40_12
X_4921_ _0103_ _0109_ vssd1 vssd1 vccd1 vccd1 _0111_ sky130_fd_sc_hd__xnor2_1
X_7640_ net222 net218 net257 net253 vssd1 vssd1 vccd1 vccd1 _2893_ sky130_fd_sc_hd__and4_1
XANTENNA__6082__A net227 vssd1 vssd1 vccd1 vccd1 sky130_fd_sc_hd__diode_2
X_4852_ _4128_ _4129_ vssd1 vssd1 vccd1 vccd1 _4130_ sky130_fd_sc_hd__and2_1
XTAP_TAPCELL_ROW_35_548 vssd1 vccd1 sky130_fd_sc_hd__tapvpwrvgnd_1
XANTENNA__6232__D net258 vssd1 vssd1 vccd1 vccd1 sky130_fd_sc_hd__diode_2
X_4783_ _3968_ _3970_ _4060_ vssd1 vssd1 vccd1 vccd1 _4061_ sky130_fd_sc_hd__a21oi_1
X_7571_ _2741_ _2744_ _2818_ vssd1 vssd1 vccd1 vccd1 _2819_ sky130_fd_sc_hd__o21ai_2
XFILLER_20_247 vssd1 vssd1 vccd1 vccd1 sky130_fd_sc_hd__fill_2
X_6522_ _1707_ _1708_ vssd1 vssd1 vccd1 vccd1 _1709_ sky130_fd_sc_hd__xnor2_1
XFILLER_20_269 vssd1 vssd1 vccd1 vccd1 sky130_fd_sc_hd__fill_2
X_6453_ net231 net261 vssd1 vssd1 vccd1 vccd1 _1641_ sky130_fd_sc_hd__nand2_1
XFILLER_9_281 vssd1 vssd1 vccd1 vccd1 sky130_fd_sc_hd__fill_1
XANTENNA__5698__B1 net219 vssd1 vssd1 vccd1 vccd1 sky130_fd_sc_hd__diode_2
X_5404_ _0554_ _0591_ _0593_ vssd1 vssd1 vccd1 vccd1 _0594_ sky130_fd_sc_hd__a21o_1
X_8123_ _3381_ _3382_ _3210_ _3234_ vssd1 vssd1 vccd1 vccd1 _3384_ sky130_fd_sc_hd__a211o_1
X_6384_ _1367_ _1380_ _1366_ vssd1 vssd1 vccd1 vccd1 _1572_ sky130_fd_sc_hd__a21bo_1
X_5335_ _0335_ _0454_ _0455_ _0456_ vssd1 vssd1 vccd1 vccd1 _0525_ sky130_fd_sc_hd__o2bb2a_1
XFILLER_87_225 vssd1 vssd1 vccd1 vccd1 sky130_fd_sc_hd__fill_4
XANTENNA__8485__CLK clknet_4_15_0_clk vssd1 vssd1 vccd1 vccd1 sky130_fd_sc_hd__diode_2
X_8054_ _3306_ _3307_ vssd1 vssd1 vccd1 vccd1 _3309_ sky130_fd_sc_hd__nand2_1
X_5266_ net123 _0156_ vssd1 vssd1 vccd1 vccd1 _0456_ sky130_fd_sc_hd__nand2_1
XFILLER_87_258 vssd1 vssd1 vccd1 vccd1 sky130_fd_sc_hd__fill_1
XFILLER_87_247 vssd1 vssd1 vccd1 vccd1 sky130_fd_sc_hd__fill_2
XANTENNA__6257__A net227 vssd1 vssd1 vccd1 vccd1 sky130_fd_sc_hd__diode_2
X_4217_ net10 PID_INST.k3_calc.kd_term\[15\] net174 vssd1 vssd1 vccd1 vccd1 PID_INST.k3_calc.d1.y\[15\]
+ sky130_fd_sc_hd__mux2_1
X_7005_ _2220_ vssd1 vssd1 vccd1 vccd1 _2221_ sky130_fd_sc_hd__inv_2
X_5197_ _0383_ _0385_ _0355_ vssd1 vssd1 vccd1 vccd1 _0387_ sky130_fd_sc_hd__a21oi_1
XANTENNA__8480__RESET_B net340 vssd1 vssd1 vccd1 vccd1 sky130_fd_sc_hd__diode_2
XFILLER_83_431 vccd1 vssd1 vccd1 vssd1 sky130_ef_sc_hd__decap_40_12
XTAP_TAPCELL_ROW_79_990 vssd1 vccd1 sky130_fd_sc_hd__tapvpwrvgnd_1
XFILLER_55_111 vssd1 vssd1 vccd1 vccd1 sky130_fd_sc_hd__fill_1
XFILLER_18_36 vssd1 vssd1 vccd1 vccd1 sky130_fd_sc_hd__fill_4
XTAP_TAPCELL_ROW_87_1067 vssd1 vccd1 sky130_fd_sc_hd__tapvpwrvgnd_1
XFILLER_83_464 vssd1 vssd1 vccd1 vccd1 sky130_fd_sc_hd__fill_2
XANTENNA_fanout266_X net266 vssd1 vssd1 vccd1 vccd1 sky130_fd_sc_hd__diode_2
XFILLER_16_509 vssd1 vssd1 vccd1 vccd1 sky130_fd_sc_hd__fill_2
X_7907_ _3151_ _3161_ vssd1 vssd1 vccd1 vccd1 _3162_ sky130_fd_sc_hd__xnor2_1
XFILLER_24_531 vssd1 vssd1 vccd1 vccd1 sky130_fd_sc_hd__fill_1
X_7838_ net119 _2036_ _3092_ vssd1 vssd1 vccd1 vccd1 _3094_ sky130_fd_sc_hd__or3_1
X_7769_ _3023_ _3024_ vssd1 vssd1 vccd1 vccd1 _3025_ sky130_fd_sc_hd__nand2_1
XFILLER_11_236 vssd1 vssd1 vccd1 vccd1 sky130_fd_sc_hd__fill_2
Xclkload1 clknet_4_1_0_clk vssd1 vssd1 vccd1 vccd1 clkload1/Y sky130_fd_sc_hd__bufinv_16
XFILLER_7_218 vssd1 vssd1 vccd1 vccd1 sky130_fd_sc_hd__fill_4
XFILLER_1_3 vccd1 vssd1 vccd1 vssd1 sky130_ef_sc_hd__decap_40_12
XANTENNA_fanout81_X net81 vssd1 vssd1 vccd1 vccd1 sky130_fd_sc_hd__diode_2
XTAP_TAPCELL_ROW_6_262 vssd1 vccd1 sky130_fd_sc_hd__tapvpwrvgnd_1
XANTENNA__8085__C net293 vssd1 vssd1 vccd1 vccd1 sky130_fd_sc_hd__diode_2
Xfanout271 PID_INST.k2_calc.reg_lc\[11\] vssd1 vssd1 vccd1 vccd1 net271 sky130_fd_sc_hd__dlymetal6s2s_1
Xfanout260 PID_INST.k2_calc.reg_lc\[13\] vssd1 vssd1 vccd1 vccd1 net260 sky130_fd_sc_hd__buf_2
Xfanout282 PID_INST.k2_calc.reg_lc\[8\] vssd1 vssd1 vccd1 vccd1 net282 sky130_fd_sc_hd__dlymetal6s2s_1
XANTENNA__4664__A1 net148 vssd1 vssd1 vccd1 vccd1 sky130_fd_sc_hd__diode_2
XFILLER_86_291 vssd1 vssd1 vccd1 vccd1 sky130_fd_sc_hd__fill_4
XFILLER_75_53 vssd1 vssd1 vccd1 vccd1 sky130_fd_sc_hd__fill_1
Xfanout293 PID_INST.k2_calc.reg_lc\[6\] vssd1 vssd1 vccd1 vccd1 net293 sky130_fd_sc_hd__buf_2
XFILLER_74_464 vssd1 vssd1 vccd1 vccd1 sky130_fd_sc_hd__fill_4
XFILLER_74_453 vssd1 vssd1 vccd1 vccd1 sky130_fd_sc_hd__fill_1
XFILLER_19_369 vssd1 vssd1 vccd1 vccd1 sky130_fd_sc_hd__fill_2
XFILLER_74_486 vssd1 vssd1 vccd1 vccd1 sky130_fd_sc_hd__fill_4
XFILLER_46_199 vssd1 vssd1 vccd1 vccd1 sky130_fd_sc_hd__fill_1
XFILLER_91_41 vssd1 vssd1 vccd1 vccd1 sky130_fd_sc_hd__fill_1
XTAP_TAPCELL_ROW_60_805 vssd1 vccd1 sky130_fd_sc_hd__tapvpwrvgnd_1
XANTENNA__7366__B1 net280 vssd1 vssd1 vccd1 vccd1 sky130_fd_sc_hd__diode_2
XTAP_TAPCELL_ROW_32_518 vssd1 vccd1 sky130_fd_sc_hd__tapvpwrvgnd_1
XFILLER_30_523 vssd1 vssd1 vccd1 vccd1 sky130_fd_sc_hd__fill_1
XFILLER_10_280 vssd1 vssd1 vccd1 vccd1 sky130_fd_sc_hd__fill_1
XFILLER_69_225 vssd1 vssd1 vccd1 vccd1 sky130_fd_sc_hd__fill_4
X_5120_ net118 net63 vssd1 vssd1 vccd1 vccd1 _0310_ sky130_fd_sc_hd__nor2_1
XFILLER_34_3 vccd1 vssd1 vccd1 vssd1 sky130_ef_sc_hd__decap_40_12
XFILLER_69_236 vssd1 vssd1 vccd1 vccd1 sky130_fd_sc_hd__fill_2
X_5051_ _0238_ _0240_ vssd1 vssd1 vccd1 vccd1 _0241_ sky130_fd_sc_hd__xor2_1
XANTENNA__4309__B _2961_ vssd1 vssd1 vccd1 vccd1 sky130_fd_sc_hd__diode_2
XTAP_TAPCELL_ROW_76_960 vssd1 vccd1 sky130_fd_sc_hd__tapvpwrvgnd_1
XANTENNA__8292__A net294 vssd1 vssd1 vccd1 vccd1 sky130_fd_sc_hd__diode_2
XFILLER_52_114 vccd1 vssd1 vccd1 vssd1 sky130_ef_sc_hd__decap_40_12
XTAP_TAPCELL_ROW_48_684 vssd1 vccd1 sky130_fd_sc_hd__tapvpwrvgnd_1
X_5953_ _1141_ _1142_ vssd1 vssd1 vccd1 vccd1 _1143_ sky130_fd_sc_hd__and2b_1
X_5884_ net245 net320 vssd1 vssd1 vccd1 vccd1 _1074_ sky130_fd_sc_hd__and2_1
XANTENNA_clkbuf_4_5_0_clk_A clknet_0_clk vssd1 vssd1 vccd1 vccd1 sky130_fd_sc_hd__diode_2
XANTENNA__4325__A net15 vssd1 vssd1 vccd1 vccd1 sky130_fd_sc_hd__diode_2
X_4904_ _4104_ _0092_ vssd1 vssd1 vccd1 vccd1 _0094_ sky130_fd_sc_hd__xnor2_1
XFILLER_21_512 vssd1 vssd1 vccd1 vccd1 sky130_fd_sc_hd__fill_2
XFILLER_40_309 vssd1 vssd1 vccd1 vccd1 sky130_fd_sc_hd__fill_1
XFILLER_60_180 vssd1 vssd1 vccd1 vccd1 sky130_fd_sc_hd__fill_2
X_7623_ _2873_ _2874_ vssd1 vssd1 vccd1 vccd1 _2875_ sky130_fd_sc_hd__nand2_1
X_4835_ _4112_ _4094_ vssd1 vssd1 vccd1 vccd1 _4113_ sky130_fd_sc_hd__and2b_1
X_4766_ _4028_ _4043_ vssd1 vssd1 vccd1 vccd1 _4044_ sky130_fd_sc_hd__nand2_1
X_7554_ _2800_ _2801_ vssd1 vssd1 vccd1 vccd1 _2802_ sky130_fd_sc_hd__nand2_1
XANTENNA_fanout226_A net229 vssd1 vssd1 vccd1 vccd1 sky130_fd_sc_hd__diode_2
X_6505_ net162 _3773_ vssd1 vssd1 vccd1 vccd1 _1692_ sky130_fd_sc_hd__and2_1
X_7485_ _2726_ _2727_ vssd1 vssd1 vccd1 vccd1 _2729_ sky130_fd_sc_hd__or2_1
X_4697_ net128 net86 _3974_ vssd1 vssd1 vccd1 vccd1 _3975_ sky130_fd_sc_hd__a21oi_1
X_6436_ net199 net315 net302 net208 vssd1 vssd1 vccd1 vccd1 _1624_ sky130_fd_sc_hd__a22oi_1
X_6367_ _1553_ _1554_ vssd1 vssd1 vccd1 vccd1 _1555_ sky130_fd_sc_hd__nor2_1
X_8106_ _3365_ net181 net294 _3362_ vssd1 vssd1 vccd1 vccd1 _3366_ sky130_fd_sc_hd__and4b_1
XANTENNA__4894__A1 _4095_ vssd1 vssd1 vccd1 vccd1 sky130_fd_sc_hd__diode_2
XFILLER_0_416 vssd1 vssd1 vccd1 vccd1 sky130_fd_sc_hd__fill_4
X_5318_ _0435_ _0507_ vssd1 vssd1 vccd1 vccd1 _0508_ sky130_fd_sc_hd__xnor2_2
XFILLER_88_545 vccd1 vssd1 vccd1 vssd1 sky130_ef_sc_hd__decap_40_12
XFILLER_0_449 vccd1 vssd1 vccd1 vssd1 sky130_ef_sc_hd__decap_40_12
X_6298_ _1102_ _1290_ _1289_ vssd1 vssd1 vccd1 vccd1 _1487_ sky130_fd_sc_hd__a21o_1
Xhold13 PID_INST.k1_calc.d1.x\[1\] vssd1 vssd1 vccd1 vccd1 net406 sky130_fd_sc_hd__dlygate4sd3_1
XANTENNA__7090__B _2309_ vssd1 vssd1 vccd1 vccd1 sky130_fd_sc_hd__diode_2
X_8037_ _2855_ _3154_ _3155_ _3157_ vssd1 vssd1 vccd1 vccd1 _3291_ sky130_fd_sc_hd__a22o_1
XFILLER_29_57 vssd1 vssd1 vccd1 vccd1 sky130_fd_sc_hd__fill_1
X_5249_ _2114_ net71 vssd1 vssd1 vccd1 vccd1 _0439_ sky130_fd_sc_hd__nor2_1
Xhold24 net23 vssd1 vssd1 vccd1 vccd1 net417 sky130_fd_sc_hd__dlygate4sd3_1
Xhold35 PID_INST.k1_calc.d1.x\[4\] vssd1 vssd1 vccd1 vccd1 net428 sky130_fd_sc_hd__dlygate4sd3_1
XTAP_TAPCELL_ROW_3_232 vssd1 vccd1 sky130_fd_sc_hd__tapvpwrvgnd_1
XFILLER_83_250 vssd1 vssd1 vccd1 vccd1 sky130_fd_sc_hd__fill_2
XFILLER_56_475 vssd1 vssd1 vccd1 vccd1 sky130_fd_sc_hd__fill_1
XANTENNA__6399__A1 net112 vssd1 vssd1 vccd1 vccd1 sky130_fd_sc_hd__diode_2
XFILLER_45_23 vssd1 vssd1 vccd1 vccd1 sky130_fd_sc_hd__fill_1
XFILLER_16_317 vssd1 vssd1 vccd1 vccd1 sky130_fd_sc_hd__fill_8
XANTENNA__6399__B2 net108 vssd1 vssd1 vccd1 vccd1 sky130_fd_sc_hd__diode_2
XFILLER_71_445 vssd1 vssd1 vccd1 vccd1 sky130_fd_sc_hd__fill_2
XANTENNA__4235__A net105 vssd1 vssd1 vccd1 vccd1 sky130_fd_sc_hd__diode_2
XFILLER_24_350 vssd1 vssd1 vccd1 vccd1 sky130_fd_sc_hd__fill_4
XFILLER_61_55 vssd1 vssd1 vccd1 vccd1 sky130_fd_sc_hd__fill_1
XANTENNA__6571__A1 net95 vssd1 vssd1 vccd1 vccd1 sky130_fd_sc_hd__diode_2
XFILLER_10_92 vssd1 vssd1 vccd1 vccd1 sky130_fd_sc_hd__fill_4
XFILLER_86_41 vssd1 vssd1 vccd1 vccd1 sky130_fd_sc_hd__fill_1
XANTENNA__6626__A2 net259 vssd1 vssd1 vccd1 vccd1 sky130_fd_sc_hd__diode_2
XFILLER_19_111 vssd1 vssd1 vccd1 vccd1 sky130_fd_sc_hd__fill_1
XFILLER_47_442 vssd1 vssd1 vccd1 vccd1 sky130_fd_sc_hd__fill_1
XFILLER_19_144 vssd1 vssd1 vccd1 vccd1 sky130_fd_sc_hd__fill_2
XTAP_TAPCELL_ROW_73_930 vssd1 vccd1 sky130_fd_sc_hd__tapvpwrvgnd_1
XTAP_TAPCELL_ROW_45_654 vssd1 vccd1 sky130_fd_sc_hd__tapvpwrvgnd_1
XFILLER_15_372 vssd1 vssd1 vccd1 vccd1 sky130_fd_sc_hd__fill_4
XTAP_TAPCELL_ROW_17_367 vssd1 vccd1 sky130_fd_sc_hd__tapvpwrvgnd_1
X_4620_ _3893_ _3896_ _3897_ vssd1 vssd1 vccd1 vccd1 _3898_ sky130_fd_sc_hd__nand3_1
XFILLER_30_397 vssd1 vssd1 vccd1 vccd1 sky130_fd_sc_hd__fill_8
X_4551_ _3769_ _3772_ _3828_ vssd1 vssd1 vccd1 vccd1 _3829_ sky130_fd_sc_hd__or3_2
X_4482_ net113 net81 _3757_ net148 vssd1 vssd1 vccd1 vccd1 _3760_ sky130_fd_sc_hd__o2bb2a_1
X_7270_ _2426_ _2432_ _2425_ vssd1 vssd1 vccd1 vccd1 _2500_ sky130_fd_sc_hd__a21oi_1
X_6221_ _1209_ _1210_ _1208_ vssd1 vssd1 vccd1 vccd1 _1410_ sky130_fd_sc_hd__a21oi_2
X_6152_ net138 net76 vssd1 vssd1 vccd1 vccd1 _1341_ sky130_fd_sc_hd__nand2_1
X_5103_ _0247_ _0292_ vssd1 vssd1 vccd1 vccd1 _0293_ sky130_fd_sc_hd__xnor2_1
X_6083_ _1271_ _1272_ vssd1 vssd1 vccd1 vccd1 _1273_ sky130_fd_sc_hd__xor2_1
XFILLER_85_559 vssd1 vssd1 vccd1 vccd1 sky130_fd_sc_hd__fill_1
X_5034_ _4153_ _4155_ _0144_ _0221_ vssd1 vssd1 vccd1 vccd1 _0224_ sky130_fd_sc_hd__a211oi_2
XFILLER_38_431 vccd1 vssd1 vccd1 vssd1 sky130_ef_sc_hd__decap_40_12
XTAP_TAPCELL_ROW_0_202 vssd1 vccd1 sky130_fd_sc_hd__tapvpwrvgnd_1
XFILLER_53_412 vssd1 vssd1 vccd1 vccd1 sky130_fd_sc_hd__fill_1
XFILLER_53_401 vssd1 vssd1 vccd1 vccd1 sky130_fd_sc_hd__fill_2
XFILLER_38_475 vssd1 vssd1 vccd1 vccd1 sky130_fd_sc_hd__fill_1
XTAP_TAPCELL_ROW_84_1037 vssd1 vccd1 sky130_fd_sc_hd__tapvpwrvgnd_1
XFILLER_80_242 vssd1 vssd1 vccd1 vccd1 sky130_fd_sc_hd__fill_1
XFILLER_25_136 vssd1 vssd1 vccd1 vccd1 sky130_fd_sc_hd__fill_2
XFILLER_25_158 vssd1 vssd1 vccd1 vccd1 sky130_fd_sc_hd__fill_2
X_6985_ _2085_ _2198_ vssd1 vssd1 vccd1 vccd1 _2200_ sky130_fd_sc_hd__xnor2_1
XFILLER_80_264 vssd1 vssd1 vccd1 vccd1 sky130_fd_sc_hd__fill_1
X_5936_ _0478_ _0479_ _0480_ _0549_ vssd1 vssd1 vccd1 vccd1 _1126_ sky130_fd_sc_hd__o2bb2ai_1
XFILLER_15_15 vssd1 vssd1 vccd1 vccd1 sky130_fd_sc_hd__fill_4
XFILLER_15_37 vssd1 vssd1 vccd1 vccd1 sky130_fd_sc_hd__fill_4
XFILLER_21_320 vssd1 vssd1 vccd1 vccd1 sky130_fd_sc_hd__fill_4
X_5867_ _1038_ _1056_ vssd1 vssd1 vccd1 vccd1 _1057_ sky130_fd_sc_hd__nand2_1
XANTENNA_fanout131_X net131 vssd1 vssd1 vccd1 vccd1 sky130_fd_sc_hd__diode_2
X_7606_ _2784_ _2857_ vssd1 vssd1 vccd1 vccd1 _2858_ sky130_fd_sc_hd__nand2_1
X_5798_ _0986_ _0987_ vssd1 vssd1 vccd1 vccd1 _0988_ sky130_fd_sc_hd__or2_1
XANTENNA_fanout229_X net229 vssd1 vssd1 vccd1 vccd1 sky130_fd_sc_hd__diode_2
X_4818_ PID_INST.k1_calc.d1.x\[12\] PID_INST.k3_calc.prev_error\[12\] vssd1 vssd1
+ vccd1 vccd1 _4096_ sky130_fd_sc_hd__nor2_1
X_4749_ _3991_ _4005_ _4004_ vssd1 vssd1 vccd1 vccd1 _4027_ sky130_fd_sc_hd__a21oi_1
X_7537_ PID_INST.k3_calc.d2.y\[6\] _1740_ _1741_ vssd1 vssd1 vccd1 vccd1 _2784_ sky130_fd_sc_hd__and3_1
X_7468_ _2593_ _2617_ vssd1 vssd1 vccd1 vccd1 _2711_ sky130_fd_sc_hd__nor2_1
X_6419_ net324 net193 vssd1 vssd1 vccd1 vccd1 _1607_ sky130_fd_sc_hd__nand2_1
Xoutput25 net25 vssd1 vssd1 vccd1 vccd1 gpio_out[22] sky130_fd_sc_hd__buf_2
X_7399_ _2385_ _2386_ _2388_ vssd1 vssd1 vccd1 vccd1 _2638_ sky130_fd_sc_hd__a21oi_1
XFILLER_0_202 vssd1 vssd1 vccd1 vccd1 sky130_fd_sc_hd__fill_2
Xoutput36 net36 vssd1 vssd1 vccd1 vccd1 gpio_out[33] sky130_fd_sc_hd__buf_2
XFILLER_88_342 vssd1 vssd1 vccd1 vccd1 sky130_fd_sc_hd__fill_4
XANTENNA__5333__B _0156_ vssd1 vssd1 vccd1 vccd1 sky130_fd_sc_hd__diode_2
XFILLER_29_464 vssd1 vssd1 vccd1 vccd1 sky130_fd_sc_hd__fill_1
XANTENNA__5292__A1 net163 vssd1 vssd1 vccd1 vccd1 sky130_fd_sc_hd__diode_2
XFILLER_16_114 vssd1 vssd1 vccd1 vccd1 sky130_fd_sc_hd__fill_4
XFILLER_71_242 vssd1 vssd1 vccd1 vccd1 sky130_fd_sc_hd__fill_4
XANTENNA_fanout44_X net44 vssd1 vssd1 vccd1 vccd1 sky130_fd_sc_hd__diode_2
XFILLER_72_43 vssd1 vssd1 vccd1 vccd1 sky130_fd_sc_hd__fill_4
XTAP_TAPCELL_ROW_70_900 vssd1 vccd1 sky130_fd_sc_hd__tapvpwrvgnd_1
XFILLER_71_286 vssd1 vssd1 vccd1 vccd1 sky130_fd_sc_hd__fill_1
XTAP_TAPCELL_ROW_14_337 vssd1 vccd1 sky130_fd_sc_hd__tapvpwrvgnd_1
XFILLER_24_180 vssd1 vssd1 vccd1 vccd1 sky130_fd_sc_hd__fill_8
XTAP_TAPCELL_ROW_42_624 vssd1 vccd1 sky130_fd_sc_hd__tapvpwrvgnd_1
XFILLER_72_98 vssd1 vssd1 vccd1 vccd1 sky130_fd_sc_hd__fill_4
XFILLER_79_375 vssd1 vssd1 vccd1 vccd1 sky130_fd_sc_hd__fill_8
XFILLER_79_353 vssd1 vssd1 vccd1 vccd1 sky130_fd_sc_hd__fill_4
XANTENNA__7272__A2 net51 vssd1 vssd1 vccd1 vccd1 sky130_fd_sc_hd__diode_2
XFILLER_62_231 vssd1 vssd1 vccd1 vccd1 sky130_fd_sc_hd__fill_4
XFILLER_35_456 vssd1 vssd1 vccd1 vccd1 sky130_fd_sc_hd__fill_1
X_6770_ _1961_ _1962_ _1969_ vssd1 vssd1 vccd1 vccd1 _1971_ sky130_fd_sc_hd__a21oi_1
XFILLER_22_106 vssd1 vssd1 vccd1 vccd1 sky130_fd_sc_hd__fill_2
X_5721_ _0908_ _0910_ vssd1 vssd1 vccd1 vccd1 _0911_ sky130_fd_sc_hd__nor2_1
XFILLER_22_139 vssd1 vssd1 vccd1 vccd1 sky130_fd_sc_hd__fill_1
X_5652_ _0741_ _0742_ _0743_ vssd1 vssd1 vccd1 vccd1 _0842_ sky130_fd_sc_hd__o21ai_1
X_8440_ clknet_4_3_0_clk net396 net331 vssd1 vssd1 vccd1 vccd1 PID_INST.k3_calc.prev_error\[12\]
+ sky130_fd_sc_hd__dfrtp_1
XANTENNA__6535__A1 net131 vssd1 vssd1 vccd1 vccd1 sky130_fd_sc_hd__diode_2
X_5583_ _0770_ _0771_ _0772_ vssd1 vssd1 vccd1 vccd1 _0773_ sky130_fd_sc_hd__or3_1
X_8371_ clknet_4_2_0_clk _0007_ net330 vssd1 vssd1 vccd1 vccd1 PID_INST.k1_calc.d1.x\[7\]
+ sky130_fd_sc_hd__dfrtp_1
X_4603_ _3877_ _3880_ vssd1 vssd1 vccd1 vccd1 _3881_ sky130_fd_sc_hd__nand2_1
XANTENNA__5418__B net63 vssd1 vssd1 vccd1 vccd1 sky130_fd_sc_hd__diode_2
X_4534_ net126 net144 vssd1 vssd1 vccd1 vccd1 _3812_ sky130_fd_sc_hd__nand2_1
X_7322_ _2220_ _2472_ _2473_ vssd1 vssd1 vccd1 vccd1 _2556_ sky130_fd_sc_hd__a21boi_1
X_4465_ PID_INST.k1_calc.d1.x\[6\] PID_INST.k3_calc.prev_error\[6\] vssd1 vssd1 vccd1
+ vccd1 _3743_ sky130_fd_sc_hd__nor2_1
X_7253_ _2414_ _2416_ vssd1 vssd1 vccd1 vccd1 _2482_ sky130_fd_sc_hd__nand2_1
XFILLER_89_139 vssd1 vssd1 vccd1 vccd1 sky130_fd_sc_hd__fill_1
X_4396_ _3686_ _3687_ vssd1 vssd1 vccd1 vccd1 _3688_ sky130_fd_sc_hd__nand2_1
X_6204_ _1391_ _1392_ vssd1 vssd1 vccd1 vccd1 _1393_ sky130_fd_sc_hd__nand2_1
X_7184_ _2404_ _2408_ vssd1 vssd1 vccd1 vccd1 _2409_ sky130_fd_sc_hd__xor2_1
XANTENNA_fanout293_A PID_INST.k2_calc.reg_lc\[6\] vssd1 vssd1 vccd1 vccd1 sky130_fd_sc_hd__diode_2
X_6135_ _1313_ _1322_ vssd1 vssd1 vccd1 vccd1 _1324_ sky130_fd_sc_hd__xnor2_1
XTAP_TAPCELL_ROW_90_1096 vssd1 vccd1 sky130_fd_sc_hd__tapvpwrvgnd_1
X_6066_ _1246_ _1254_ vssd1 vssd1 vccd1 vccd1 _1256_ sky130_fd_sc_hd__nor2_1
XFILLER_58_537 vssd1 vssd1 vccd1 vccd1 sky130_fd_sc_hd__fill_8
X_5017_ _0204_ _0205_ vssd1 vssd1 vccd1 vccd1 _0207_ sky130_fd_sc_hd__nor2_1
XFILLER_85_389 vssd1 vssd1 vccd1 vccd1 sky130_fd_sc_hd__fill_2
XFILLER_73_529 vssd1 vssd1 vccd1 vccd1 sky130_fd_sc_hd__fill_4
XFILLER_38_250 vssd1 vssd1 vccd1 vccd1 sky130_fd_sc_hd__fill_2
XFILLER_38_261 vssd1 vssd1 vccd1 vccd1 sky130_fd_sc_hd__fill_4
XFILLER_26_445 vccd1 vssd1 vccd1 vssd1 sky130_ef_sc_hd__decap_40_12
XFILLER_53_275 vssd1 vssd1 vccd1 vccd1 sky130_fd_sc_hd__fill_1
XANTENNA__6774__A1 net216 vssd1 vssd1 vccd1 vccd1 sky130_fd_sc_hd__diode_2
X_6968_ net109 net48 vssd1 vssd1 vccd1 vccd1 _2182_ sky130_fd_sc_hd__or2_1
XFILLER_41_426 vccd1 vssd1 vccd1 vssd1 sky130_ef_sc_hd__decap_40_12
X_5919_ _4021_ _1108_ vssd1 vssd1 vccd1 vccd1 _1109_ sky130_fd_sc_hd__xnor2_1
X_6899_ _2107_ _2108_ vssd1 vssd1 vccd1 vccd1 _2109_ sky130_fd_sc_hd__xor2_1
XTAP_TAPCELL_ROW_11_307 vssd1 vccd1 sky130_fd_sc_hd__tapvpwrvgnd_1
XFILLER_21_161 vssd1 vssd1 vccd1 vccd1 sky130_fd_sc_hd__fill_1
XANTENNA__8419__CLK clknet_4_9_0_clk vssd1 vssd1 vccd1 vccd1 sky130_fd_sc_hd__diode_2
XANTENNA__7824__A net140 vssd1 vssd1 vccd1 vccd1 sky130_fd_sc_hd__diode_2
XFILLER_49_515 vssd1 vssd1 vccd1 vccd1 sky130_fd_sc_hd__fill_2
XANTENNA__5063__B net71 vssd1 vssd1 vccd1 vccd1 sky130_fd_sc_hd__diode_2
XFILLER_91_315 vssd1 vssd1 vccd1 vccd1 sky130_fd_sc_hd__fill_1
XFILLER_64_518 vssd1 vssd1 vccd1 vccd1 sky130_fd_sc_hd__fill_2
XANTENNA_clkbuf_4_13_0_clk_A clknet_0_clk vssd1 vssd1 vccd1 vccd1 sky130_fd_sc_hd__diode_2
XANTENNA__8203__A1 net276 vssd1 vssd1 vccd1 vccd1 sky130_fd_sc_hd__diode_2
XFILLER_83_86 vssd1 vssd1 vccd1 vccd1 sky130_fd_sc_hd__fill_4
XFILLER_17_456 vssd1 vssd1 vccd1 vccd1 sky130_fd_sc_hd__fill_4
XTAP_TAPCELL_ROW_27_473 vssd1 vccd1 sky130_fd_sc_hd__tapvpwrvgnd_1
XFILLER_16_91 vssd1 vssd1 vccd1 vccd1 sky130_fd_sc_hd__fill_1
XFILLER_12_150 vssd1 vssd1 vccd1 vccd1 sky130_fd_sc_hd__fill_2
XFILLER_12_161 vssd1 vssd1 vccd1 vccd1 sky130_fd_sc_hd__fill_1
XFILLER_40_470 vssd1 vssd1 vccd1 vccd1 sky130_fd_sc_hd__fill_4
XFILLER_40_481 vssd1 vssd1 vccd1 vccd1 sky130_fd_sc_hd__fill_4
X_4250_ net95 vssd1 vssd1 vccd1 vccd1 PID_INST.k3_calc.d2.y\[12\] sky130_fd_sc_hd__inv_2
XFILLER_79_150 vssd1 vssd1 vccd1 vccd1 sky130_fd_sc_hd__fill_4
X_4181_ net6 net173 _1944_ vssd1 vssd1 vccd1 vccd1 _1955_ sky130_fd_sc_hd__o21ai_1
XFILLER_67_367 vssd1 vssd1 vccd1 vccd1 sky130_fd_sc_hd__fill_2
XFILLER_82_315 vssd1 vssd1 vccd1 vccd1 sky130_fd_sc_hd__fill_1
X_7940_ _2980_ _2987_ _3193_ vssd1 vssd1 vccd1 vccd1 _3195_ sky130_fd_sc_hd__nand3_1
X_7871_ net93 net46 vssd1 vssd1 vccd1 vccd1 _3126_ sky130_fd_sc_hd__nor2_1
XANTENNA__4317__B net14 vssd1 vssd1 vccd1 vccd1 sky130_fd_sc_hd__diode_2
X_6822_ _1713_ _1728_ _2025_ vssd1 vssd1 vccd1 vccd1 _2027_ sky130_fd_sc_hd__nand3_1
XFILLER_35_253 vssd1 vssd1 vccd1 vccd1 sky130_fd_sc_hd__fill_2
XFILLER_90_370 vccd1 vssd1 vccd1 vssd1 sky130_ef_sc_hd__decap_40_12
XTAP_TAPCELL_ROW_81_1007 vssd1 vccd1 sky130_fd_sc_hd__tapvpwrvgnd_1
XANTENNA__5559__A2 net295 vssd1 vssd1 vccd1 vccd1 sky130_fd_sc_hd__diode_2
X_6753_ _1836_ _1840_ _1951_ vssd1 vssd1 vccd1 vccd1 _1953_ sky130_fd_sc_hd__nand3_1
X_6684_ _1879_ _1880_ vssd1 vssd1 vccd1 vccd1 _1881_ sky130_fd_sc_hd__xnor2_1
X_5704_ _0893_ vssd1 vssd1 vccd1 vccd1 _0894_ sky130_fd_sc_hd__inv_2
X_5635_ _0773_ _0824_ vssd1 vssd1 vccd1 vccd1 _0825_ sky130_fd_sc_hd__and2_1
XFILLER_12_27 vssd1 vssd1 vccd1 vccd1 sky130_fd_sc_hd__fill_1
XANTENNA_fanout139_A net140 vssd1 vssd1 vccd1 vccd1 sky130_fd_sc_hd__diode_2
X_8423_ clknet_4_1_0_clk net137 net326 vssd1 vssd1 vccd1 vccd1 PID_INST.k3_calc.kd_term\[11\]
+ sky130_fd_sc_hd__dfrtp_1
XANTENNA_fanout306_A net308 vssd1 vssd1 vccd1 vccd1 sky130_fd_sc_hd__diode_2
X_5566_ _0753_ _0755_ vssd1 vssd1 vccd1 vccd1 _0756_ sky130_fd_sc_hd__nand2_1
X_8354_ _3615_ _3620_ vssd1 vssd1 vccd1 vccd1 _3632_ sky130_fd_sc_hd__xnor2_1
XTAP_TAPCELL_ROW_92_1125 vssd1 vccd1 sky130_fd_sc_hd__tapvpwrvgnd_1
X_8285_ net305 PID_INST.k2_calc.sum_reg\[23\] _3467_ _3466_ vssd1 vssd1 vccd1 vccd1
+ _3558_ sky130_fd_sc_hd__a31o_1
XANTENNA__7363__B net188 vssd1 vssd1 vccd1 vccd1 sky130_fd_sc_hd__diode_2
X_5497_ _0624_ _0685_ _0686_ vssd1 vssd1 vccd1 vccd1 _0687_ sky130_fd_sc_hd__a21o_1
X_4517_ _3792_ _3794_ vssd1 vssd1 vccd1 vccd1 _3795_ sky130_fd_sc_hd__nand2_1
X_7305_ net108 net38 _2408_ _2407_ vssd1 vssd1 vccd1 vccd1 _2538_ sky130_fd_sc_hd__o31a_1
X_7236_ _2463_ _2464_ vssd1 vssd1 vccd1 vccd1 _2465_ sky130_fd_sc_hd__and2_1
X_4448_ PID_INST.k1_calc.d1.x\[3\] PID_INST.k3_calc.prev_error\[3\] vssd1 vssd1 vccd1
+ vccd1 _3726_ sky130_fd_sc_hd__and2_1
XFILLER_77_109 vssd1 vssd1 vccd1 vccd1 sky130_fd_sc_hd__fill_2
X_7167_ _2298_ _2301_ vssd1 vssd1 vccd1 vccd1 _2392_ sky130_fd_sc_hd__nor2_1
XANTENNA_fanout296_X net296 vssd1 vssd1 vccd1 vccd1 sky130_fd_sc_hd__diode_2
X_4379_ net160 _3671_ _3672_ _3673_ vssd1 vssd1 vccd1 vccd1 _0043_ sky130_fd_sc_hd__a31o_1
X_7098_ _2317_ _2318_ vssd1 vssd1 vccd1 vccd1 _2319_ sky130_fd_sc_hd__xnor2_1
XFILLER_46_507 vssd1 vssd1 vccd1 vccd1 sky130_fd_sc_hd__fill_8
X_6118_ net118 net54 vssd1 vssd1 vccd1 vccd1 _1307_ sky130_fd_sc_hd__nor2_1
XANTENNA__5247__A1 net132 vssd1 vssd1 vccd1 vccd1 sky130_fd_sc_hd__diode_2
X_6049_ _1236_ _1237_ _1238_ vssd1 vssd1 vccd1 vccd1 _1239_ sky130_fd_sc_hd__or3_1
XFILLER_18_209 vssd1 vssd1 vccd1 vccd1 sky130_fd_sc_hd__fill_1
XANTENNA__5247__B2 net131 vssd1 vssd1 vccd1 vccd1 sky130_fd_sc_hd__diode_2
XFILLER_41_223 vssd1 vssd1 vccd1 vccd1 sky130_fd_sc_hd__fill_1
XFILLER_14_448 vssd1 vssd1 vccd1 vccd1 sky130_fd_sc_hd__fill_4
XTAP_TAPCELL_ROW_24_443 vssd1 vccd1 sky130_fd_sc_hd__tapvpwrvgnd_1
XANTENNA__4222__A2 net173 vssd1 vssd1 vccd1 vccd1 sky130_fd_sc_hd__diode_2
XANTENNA__5339__A net123 vssd1 vssd1 vccd1 vccd1 sky130_fd_sc_hd__diode_2
XFILLER_22_481 vssd1 vssd1 vccd1 vccd1 sky130_fd_sc_hd__fill_2
XANTENNA__5505__C net228 vssd1 vssd1 vccd1 vccd1 sky130_fd_sc_hd__diode_2
XFILLER_78_97 vssd1 vssd1 vccd1 vccd1 sky130_fd_sc_hd__fill_2
XFILLER_49_334 vssd1 vssd1 vccd1 vccd1 sky130_fd_sc_hd__fill_2
XANTENNA__5789__A2 PID_INST.k2_calc.sum_reg\[5\] vssd1 vssd1 vccd1 vccd1 sky130_fd_sc_hd__diode_2
XFILLER_64_326 vssd1 vssd1 vccd1 vccd1 sky130_fd_sc_hd__fill_4
XFILLER_37_529 vssd1 vssd1 vccd1 vccd1 sky130_fd_sc_hd__fill_2
XFILLER_76_197 vssd1 vssd1 vccd1 vccd1 sky130_fd_sc_hd__fill_2
XANTENNA__7729__A net317 vssd1 vssd1 vccd1 vccd1 sky130_fd_sc_hd__diode_2
XANTENNA__7448__B net221 vssd1 vssd1 vccd1 vccd1 sky130_fd_sc_hd__diode_2
XFILLER_9_496 vssd1 vssd1 vccd1 vccd1 sky130_fd_sc_hd__fill_1
X_5420_ net111 net60 vssd1 vssd1 vccd1 vccd1 _0610_ sky130_fd_sc_hd__nor2_1
X_5351_ _0539_ _0540_ vssd1 vssd1 vccd1 vccd1 _0541_ sky130_fd_sc_hd__xnor2_1
X_8070_ net205 net209 net256 net252 vssd1 vssd1 vccd1 vccd1 _3327_ sky130_fd_sc_hd__and4_1
X_4302_ net276 net4 net171 vssd1 vssd1 vccd1 vccd1 _0025_ sky130_fd_sc_hd__mux2_1
X_5282_ _0470_ _0471_ vssd1 vssd1 vccd1 vccd1 _0472_ sky130_fd_sc_hd__or2_2
X_7021_ _2236_ _2237_ vssd1 vssd1 vccd1 vccd1 _2238_ sky130_fd_sc_hd__xnor2_1
X_4233_ PID_INST.k3_calc.timescaling_term\[1\] net169 vssd1 vssd1 vccd1 vccd1 _2505_
+ sky130_fd_sc_hd__or2_1
XFILLER_4_83 vssd1 vssd1 vccd1 vccd1 sky130_fd_sc_hd__fill_1
XFILLER_4_72 vssd1 vssd1 vccd1 vccd1 sky130_fd_sc_hd__fill_2
X_4164_ PID_INST.pid.curr_state\[2\] PID_INST.pid.curr_state\[3\] vssd1 vssd1 vccd1
+ vccd1 _1773_ sky130_fd_sc_hd__and2b_1
XFILLER_82_101 vssd1 vssd1 vccd1 vccd1 sky130_fd_sc_hd__fill_4
XFILLER_82_123 vssd1 vssd1 vccd1 vccd1 sky130_fd_sc_hd__fill_2
X_7923_ net267 net263 net197 net201 vssd1 vssd1 vccd1 vccd1 _3178_ sky130_fd_sc_hd__and4_1
XFILLER_55_337 vccd1 vssd1 vccd1 vssd1 sky130_ef_sc_hd__decap_40_12
XTAP_TAPCELL_ROW_38_579 vssd1 vccd1 sky130_fd_sc_hd__tapvpwrvgnd_1
XANTENNA_fanout256_A net259 vssd1 vssd1 vccd1 vccd1 sky130_fd_sc_hd__diode_2
X_7854_ _3107_ _3108_ vssd1 vssd1 vccd1 vccd1 _3110_ sky130_fd_sc_hd__xnor2_1
X_7785_ _2945_ _2952_ _2944_ vssd1 vssd1 vccd1 vccd1 _3041_ sky130_fd_sc_hd__a21bo_1
X_6805_ net164 net76 vssd1 vssd1 vccd1 vccd1 _2009_ sky130_fd_sc_hd__nand2_1
X_6736_ _1827_ _1842_ _1933_ vssd1 vssd1 vccd1 vccd1 _1935_ sky130_fd_sc_hd__and3_1
XFILLER_11_418 vssd1 vssd1 vccd1 vccd1 sky130_fd_sc_hd__fill_8
X_4997_ _0115_ _0186_ vssd1 vssd1 vccd1 vccd1 _0187_ sky130_fd_sc_hd__xor2_1
XTAP_TAPCELL_ROW_21_413 vssd1 vccd1 sky130_fd_sc_hd__tapvpwrvgnd_1
X_6667_ _1853_ _1862_ vssd1 vssd1 vccd1 vccd1 _1863_ sky130_fd_sc_hd__xnor2_1
XANTENNA__4998__A net137 vssd1 vssd1 vccd1 vccd1 sky130_fd_sc_hd__diode_2
X_5618_ _0807_ vssd1 vssd1 vccd1 vccd1 _0808_ sky130_fd_sc_hd__inv_2
X_8406_ clknet_4_6_0_clk _0026_ net337 vssd1 vssd1 vccd1 vccd1 PID_INST.k2_calc.reg_lc\[10\]
+ sky130_fd_sc_hd__dfrtp_1
XANTENNA_fanout309_X net309 vssd1 vssd1 vccd1 vccd1 sky130_fd_sc_hd__diode_2
X_6598_ net114 net45 vssd1 vssd1 vccd1 vccd1 _1788_ sky130_fd_sc_hd__nor2_1
X_5549_ net314 net219 net228 net302 vssd1 vssd1 vccd1 vccd1 _0739_ sky130_fd_sc_hd__a22o_1
XANTENNA__5606__B net227 vssd1 vssd1 vccd1 vccd1 sky130_fd_sc_hd__diode_2
X_8337_ _3553_ _3614_ vssd1 vssd1 vccd1 vccd1 _3615_ sky130_fd_sc_hd__xnor2_1
XANTENNA__4510__B net89 vssd1 vssd1 vccd1 vccd1 sky130_fd_sc_hd__diode_2
XANTENNA__8103__B1 net187 vssd1 vssd1 vccd1 vccd1 sky130_fd_sc_hd__diode_2
XFILLER_3_7 vssd1 vssd1 vccd1 vccd1 sky130_fd_sc_hd__fill_2
X_8268_ _3539_ _3540_ vssd1 vssd1 vccd1 vccd1 _3541_ sky130_fd_sc_hd__nand2b_1
XANTENNA__7821__B net40 vssd1 vssd1 vccd1 vccd1 sky130_fd_sc_hd__diode_2
X_8199_ net198 net272 net260 net189 vssd1 vssd1 vccd1 vccd1 _3466_ sky130_fd_sc_hd__and4_1
X_7219_ _2180_ _2189_ _2179_ vssd1 vssd1 vccd1 vccd1 _2447_ sky130_fd_sc_hd__o21a_1
XFILLER_19_529 vccd1 vssd1 vccd1 vssd1 sky130_ef_sc_hd__decap_40_12
XANTENNA__4238__A net103 vssd1 vssd1 vccd1 vccd1 sky130_fd_sc_hd__diode_2
XFILLER_64_33 vssd1 vssd1 vccd1 vccd1 sky130_fd_sc_hd__fill_1
XANTENNA__4617__D_N net84 vssd1 vssd1 vccd1 vccd1 sky130_fd_sc_hd__diode_2
XFILLER_9_17 vssd1 vssd1 vccd1 vccd1 sky130_fd_sc_hd__fill_4
XFILLER_80_43 vssd1 vssd1 vccd1 vccd1 sky130_fd_sc_hd__fill_4
Xfanout60 net62 vssd1 vssd1 vccd1 vccd1 net60 sky130_fd_sc_hd__clkbuf_4
Xfanout82 net83 vssd1 vssd1 vccd1 vccd1 net82 sky130_fd_sc_hd__clkbuf_2
Xfanout71 _4035_ vssd1 vssd1 vccd1 vccd1 net71 sky130_fd_sc_hd__clkbuf_4
Xfanout93 net94 vssd1 vssd1 vccd1 vccd1 net93 sky130_fd_sc_hd__buf_2
XANTENNA__7284__A net110 vssd1 vssd1 vccd1 vccd1 sky130_fd_sc_hd__diode_2
XFILLER_6_477 vssd1 vssd1 vccd1 vccd1 sky130_fd_sc_hd__fill_4
XANTENNA__5459__A1 net107 vssd1 vssd1 vccd1 vccd1 sky130_fd_sc_hd__diode_2
XTAP_TAPCELL_ROW_9_293 vssd1 vccd1 sky130_fd_sc_hd__tapvpwrvgnd_1
XFILLER_77_451 vssd1 vssd1 vccd1 vccd1 sky130_fd_sc_hd__fill_4
XANTENNA__6347__B net74 vssd1 vssd1 vccd1 vccd1 sky130_fd_sc_hd__diode_2
XFILLER_49_153 vssd1 vssd1 vccd1 vccd1 sky130_fd_sc_hd__fill_1
XFILLER_92_421 vccd1 vssd1 vccd1 vssd1 sky130_ef_sc_hd__decap_40_12
XFILLER_37_337 vccd1 vssd1 vccd1 vssd1 sky130_ef_sc_hd__decap_40_12
XANTENNA__4435__X _3713_ vssd1 vssd1 vccd1 vccd1 sky130_fd_sc_hd__diode_2
X_4920_ _0103_ _0109_ vssd1 vssd1 vccd1 vccd1 _0110_ sky130_fd_sc_hd__nand2_1
XANTENNA__6082__B net287 vssd1 vssd1 vccd1 vccd1 sky130_fd_sc_hd__diode_2
X_4851_ net135 net146 _4126_ _4127_ vssd1 vssd1 vccd1 vccd1 _4129_ sky130_fd_sc_hd__a22o_1
XTAP_TAPCELL_ROW_35_549 vssd1 vccd1 sky130_fd_sc_hd__tapvpwrvgnd_1
XFILLER_20_204 vccd1 vssd1 vccd1 vssd1 sky130_ef_sc_hd__decap_40_12
X_4782_ _4058_ _4059_ vssd1 vssd1 vccd1 vccd1 _4060_ sky130_fd_sc_hd__or2_1
X_7570_ _2485_ _2743_ _2741_ vssd1 vssd1 vccd1 vccd1 _2818_ sky130_fd_sc_hd__a21bo_1
X_6521_ _1987_ _4101_ vssd1 vssd1 vccd1 vccd1 _1708_ sky130_fd_sc_hd__nor2_1
XFILLER_9_260 vssd1 vssd1 vccd1 vccd1 sky130_fd_sc_hd__fill_2
X_6452_ net231 net274 net261 net244 vssd1 vssd1 vccd1 vccd1 _1640_ sky130_fd_sc_hd__a22o_1
X_5403_ net108 net53 net51 net105 vssd1 vssd1 vccd1 vccd1 _0593_ sky130_fd_sc_hd__o22a_1
X_8122_ _3210_ _3234_ _3381_ _3382_ vssd1 vssd1 vccd1 vccd1 _3383_ sky130_fd_sc_hd__o211ai_1
XANTENNA__4330__B net16 vssd1 vssd1 vccd1 vccd1 sky130_fd_sc_hd__diode_2
X_6383_ _1558_ _1570_ vssd1 vssd1 vccd1 vccd1 _1571_ sky130_fd_sc_hd__xnor2_1
X_5334_ _0522_ _0523_ vssd1 vssd1 vccd1 vccd1 _0524_ sky130_fd_sc_hd__xor2_1
X_8053_ _3306_ _3307_ vssd1 vssd1 vccd1 vccd1 _3308_ sky130_fd_sc_hd__or2_1
XANTENNA_clkbuf_4_1_0_clk_A clknet_0_clk vssd1 vssd1 vccd1 vccd1 sky130_fd_sc_hd__diode_2
X_5265_ _0335_ _0454_ vssd1 vssd1 vccd1 vccd1 _0455_ sky130_fd_sc_hd__xnor2_1
X_5196_ _0355_ _0383_ _0385_ vssd1 vssd1 vccd1 vccd1 _0386_ sky130_fd_sc_hd__and3_1
X_7004_ _2218_ _2219_ vssd1 vssd1 vccd1 vccd1 _2220_ sky130_fd_sc_hd__or2_1
X_4216_ net117 vssd1 vssd1 vccd1 vccd1 PID_INST.k3_calc.d2.y\[5\] sky130_fd_sc_hd__inv_2
XFILLER_18_15 vssd1 vssd1 vccd1 vccd1 sky130_fd_sc_hd__fill_2
XANTENNA__5161__B net71 vssd1 vssd1 vccd1 vccd1 sky130_fd_sc_hd__diode_2
XFILLER_28_304 vssd1 vssd1 vccd1 vccd1 sky130_fd_sc_hd__fill_4
XTAP_TAPCELL_ROW_79_991 vssd1 vccd1 sky130_fd_sc_hd__tapvpwrvgnd_1
XFILLER_55_134 vssd1 vssd1 vccd1 vccd1 sky130_fd_sc_hd__fill_1
XTAP_TAPCELL_ROW_87_1068 vssd1 vccd1 sky130_fd_sc_hd__tapvpwrvgnd_1
XFILLER_55_167 vssd1 vssd1 vccd1 vccd1 sky130_fd_sc_hd__fill_1
X_7906_ _3152_ _3159_ vssd1 vssd1 vccd1 vccd1 _3161_ sky130_fd_sc_hd__xnor2_1
XANTENNA_fanout259_X net259 vssd1 vssd1 vccd1 vccd1 sky130_fd_sc_hd__diode_2
XFILLER_70_148 vssd1 vssd1 vccd1 vccd1 sky130_fd_sc_hd__fill_4
X_7837_ net119 net38 vssd1 vssd1 vccd1 vccd1 _3093_ sky130_fd_sc_hd__nor2_1
XFILLER_51_373 vccd1 vssd1 vccd1 vssd1 sky130_ef_sc_hd__decap_40_12
XFILLER_11_204 vssd1 vssd1 vccd1 vccd1 sky130_fd_sc_hd__fill_8
XFILLER_34_47 vssd1 vssd1 vccd1 vccd1 sky130_fd_sc_hd__fill_1
X_7768_ _2910_ _2912_ _3022_ vssd1 vssd1 vccd1 vccd1 _3024_ sky130_fd_sc_hd__nand3_1
X_7699_ _2953_ _2954_ vssd1 vssd1 vccd1 vccd1 _2955_ sky130_fd_sc_hd__or2_1
X_6719_ _1816_ _1824_ _1916_ vssd1 vssd1 vccd1 vccd1 _1917_ sky130_fd_sc_hd__a21o_1
Xclkload2 clknet_4_2_0_clk vssd1 vssd1 vccd1 vccd1 clkload2/Y sky130_fd_sc_hd__inv_8
XFILLER_3_447 vssd1 vssd1 vccd1 vccd1 sky130_fd_sc_hd__fill_1
XANTENNA__6638__B1 net195 vssd1 vssd1 vccd1 vccd1 sky130_fd_sc_hd__diode_2
XFILLER_78_215 vssd1 vssd1 vccd1 vccd1 sky130_fd_sc_hd__fill_8
XFILLER_59_55 vssd1 vssd1 vccd1 vccd1 sky130_fd_sc_hd__fill_1
Xfanout250 PID_INST.k2_calc.sum_reg\[0\] vssd1 vssd1 vccd1 vccd1 net250 sky130_fd_sc_hd__clkbuf_2
Xfanout272 net275 vssd1 vssd1 vccd1 vccd1 net272 sky130_fd_sc_hd__buf_2
Xfanout261 net262 vssd1 vssd1 vccd1 vccd1 net261 sky130_fd_sc_hd__buf_2
Xfanout283 net285 vssd1 vssd1 vccd1 vccd1 net283 sky130_fd_sc_hd__buf_2
XFILLER_59_462 vccd1 vssd1 vccd1 vssd1 sky130_ef_sc_hd__decap_40_12
XANTENNA_fanout74_X net74 vssd1 vssd1 vccd1 vccd1 sky130_fd_sc_hd__diode_2
XTAP_TAPCELL_ROW_6_263 vssd1 vccd1 sky130_fd_sc_hd__tapvpwrvgnd_1
XFILLER_74_421 vssd1 vssd1 vccd1 vccd1 sky130_fd_sc_hd__fill_2
Xfanout294 net297 vssd1 vssd1 vccd1 vccd1 net294 sky130_fd_sc_hd__buf_2
XFILLER_75_65 vssd1 vssd1 vccd1 vccd1 sky130_fd_sc_hd__fill_1
XFILLER_46_189 vssd1 vssd1 vccd1 vccd1 sky130_fd_sc_hd__fill_2
XFILLER_34_329 vssd1 vssd1 vccd1 vccd1 sky130_fd_sc_hd__fill_1
XANTENNA__7366__A1 net204 vssd1 vssd1 vccd1 vccd1 sky130_fd_sc_hd__diode_2
XANTENNA__7366__B2 net208 vssd1 vssd1 vccd1 vccd1 sky130_fd_sc_hd__diode_2
XTAP_TAPCELL_ROW_32_519 vssd1 vccd1 sky130_fd_sc_hd__tapvpwrvgnd_1
XFILLER_42_362 vssd1 vssd1 vccd1 vccd1 sky130_fd_sc_hd__fill_2
XTAP_TAPCELL_ROW_40_596 vssd1 vccd1 sky130_fd_sc_hd__tapvpwrvgnd_1
XFILLER_6_263 vssd1 vssd1 vccd1 vccd1 sky130_fd_sc_hd__fill_2
X_5050_ _0160_ _0239_ vssd1 vssd1 vccd1 vccd1 _0240_ sky130_fd_sc_hd__xnor2_1
XFILLER_77_281 vssd1 vssd1 vccd1 vccd1 sky130_fd_sc_hd__fill_8
XFILLER_92_251 vssd1 vssd1 vccd1 vccd1 sky130_fd_sc_hd__fill_1
XTAP_TAPCELL_ROW_76_961 vssd1 vccd1 sky130_fd_sc_hd__tapvpwrvgnd_1
XANTENNA__8292__B net305 vssd1 vssd1 vccd1 vccd1 sky130_fd_sc_hd__diode_2
XFILLER_37_134 vssd1 vssd1 vccd1 vccd1 sky130_fd_sc_hd__fill_2
XANTENNA__4165__X _1784_ vssd1 vssd1 vccd1 vccd1 sky130_fd_sc_hd__diode_2
XTAP_TAPCELL_ROW_48_685 vssd1 vccd1 sky130_fd_sc_hd__tapvpwrvgnd_1
X_5952_ _0495_ _0502_ _0494_ vssd1 vssd1 vccd1 vccd1 _1142_ sky130_fd_sc_hd__a21bo_1
XFILLER_37_178 vccd1 vssd1 vccd1 vssd1 sky130_ef_sc_hd__decap_40_12
XFILLER_52_126 vccd1 vssd1 vccd1 vssd1 sky130_ef_sc_hd__decap_40_12
X_4903_ _4037_ _0091_ vssd1 vssd1 vccd1 vccd1 _0093_ sky130_fd_sc_hd__nand2_1
X_5883_ net320 net237 _1060_ _1072_ vssd1 vssd1 vccd1 vccd1 _1073_ sky130_fd_sc_hd__a31o_1
X_4834_ _4110_ _4111_ vssd1 vssd1 vccd1 vccd1 _4112_ sky130_fd_sc_hd__xnor2_1
X_7622_ _2871_ _2872_ vssd1 vssd1 vccd1 vccd1 _2874_ sky130_fd_sc_hd__nand2_1
X_4765_ _4040_ _4041_ vssd1 vssd1 vccd1 vccd1 _4043_ sky130_fd_sc_hd__xor2_1
XFILLER_21_568 vssd1 vssd1 vccd1 vccd1 sky130_fd_sc_hd__fill_2
X_7553_ _2798_ _2799_ vssd1 vssd1 vccd1 vccd1 _2801_ sky130_fd_sc_hd__nand2_1
XANTENNA__4341__A net226 vssd1 vssd1 vccd1 vccd1 sky130_fd_sc_hd__diode_2
X_6504_ net163 net78 vssd1 vssd1 vccd1 vccd1 _1691_ sky130_fd_sc_hd__nand2_1
X_7484_ _2623_ _2626_ _2725_ vssd1 vssd1 vccd1 vccd1 _2727_ sky130_fd_sc_hd__nor3b_1
XANTENNA_fanout219_A net221 vssd1 vssd1 vccd1 vccd1 sky130_fd_sc_hd__diode_2
X_4696_ net130 net88 vssd1 vssd1 vccd1 vccd1 _3974_ sky130_fd_sc_hd__and2_1
X_6435_ net199 net207 net314 net302 vssd1 vssd1 vccd1 vccd1 _1623_ sky130_fd_sc_hd__and4_1
XFILLER_20_49 vssd1 vssd1 vccd1 vccd1 sky130_fd_sc_hd__fill_1
X_6366_ _1546_ _1552_ vssd1 vssd1 vccd1 vccd1 _1554_ sky130_fd_sc_hd__and2_1
X_8105_ net281 net276 net189 net187 vssd1 vssd1 vccd1 vccd1 _3365_ sky130_fd_sc_hd__and4_1
XANTENNA__4894__A2 _4099_ vssd1 vssd1 vccd1 vccd1 sky130_fd_sc_hd__diode_2
X_5317_ net134 net76 vssd1 vssd1 vccd1 vccd1 _0507_ sky130_fd_sc_hd__nand2_2
XFILLER_88_557 vccd1 vssd1 vccd1 vssd1 sky130_ef_sc_hd__decap_40_12
X_8036_ _3288_ _3289_ vssd1 vssd1 vccd1 vccd1 _3290_ sky130_fd_sc_hd__xor2_1
X_6297_ _1411_ _1484_ vssd1 vssd1 vccd1 vccd1 _1486_ sky130_fd_sc_hd__xor2_1
Xhold14 PID_INST.k1_calc.d1.x\[0\] vssd1 vssd1 vccd1 vccd1 net407 sky130_fd_sc_hd__dlygate4sd3_1
XFILLER_75_218 vssd1 vssd1 vccd1 vccd1 sky130_fd_sc_hd__fill_2
Xhold25 net31 vssd1 vssd1 vccd1 vccd1 net418 sky130_fd_sc_hd__dlygate4sd3_1
X_5248_ _0436_ _0437_ vssd1 vssd1 vccd1 vccd1 _0438_ sky130_fd_sc_hd__nand2_1
XFILLER_56_432 vssd1 vssd1 vccd1 vccd1 sky130_fd_sc_hd__fill_1
XTAP_TAPCELL_ROW_3_233 vssd1 vccd1 sky130_fd_sc_hd__tapvpwrvgnd_1
X_5179_ net136 net80 _0366_ _0367_ vssd1 vssd1 vccd1 vccd1 _0369_ sky130_fd_sc_hd__a22o_1
XANTENNA__6399__A2 net44 vssd1 vssd1 vccd1 vccd1 sky130_fd_sc_hd__diode_2
XFILLER_83_262 vssd1 vssd1 vccd1 vccd1 sky130_fd_sc_hd__fill_1
XFILLER_45_68 vssd1 vssd1 vccd1 vccd1 sky130_fd_sc_hd__fill_8
XFILLER_51_181 vssd1 vssd1 vccd1 vccd1 sky130_fd_sc_hd__fill_4
XANTENNA__5359__B1 net103 vssd1 vssd1 vccd1 vccd1 sky130_fd_sc_hd__diode_2
XFILLER_8_506 vccd1 vssd1 vccd1 vssd1 sky130_ef_sc_hd__decap_40_12
XFILLER_12_568 vssd1 vssd1 vccd1 vccd1 sky130_fd_sc_hd__fill_2
XANTENNA__7562__A _2737_ vssd1 vssd1 vccd1 vccd1 sky130_fd_sc_hd__diode_2
XFILLER_79_513 vssd1 vssd1 vccd1 vccd1 sky130_fd_sc_hd__fill_2
XFILLER_3_277 vssd1 vssd1 vccd1 vccd1 sky130_fd_sc_hd__fill_1
XFILLER_86_64 vssd1 vssd1 vccd1 vccd1 sky130_fd_sc_hd__fill_2
XFILLER_59_270 vssd1 vssd1 vccd1 vccd1 sky130_fd_sc_hd__fill_8
XFILLER_47_465 vssd1 vssd1 vccd1 vccd1 sky130_fd_sc_hd__fill_4
XFILLER_19_80 vssd1 vssd1 vccd1 vccd1 sky130_fd_sc_hd__fill_8
XFILLER_34_115 vssd1 vssd1 vccd1 vccd1 sky130_fd_sc_hd__fill_2
XTAP_TAPCELL_ROW_73_931 vssd1 vccd1 sky130_fd_sc_hd__tapvpwrvgnd_1
XTAP_TAPCELL_ROW_45_655 vssd1 vccd1 sky130_fd_sc_hd__tapvpwrvgnd_1
XTAP_TAPCELL_ROW_17_368 vssd1 vccd1 sky130_fd_sc_hd__tapvpwrvgnd_1
XFILLER_15_384 vssd1 vssd1 vccd1 vccd1 sky130_fd_sc_hd__fill_1
XFILLER_15_395 vssd1 vssd1 vccd1 vccd1 sky130_fd_sc_hd__fill_1
XFILLER_30_365 vssd1 vssd1 vccd1 vccd1 sky130_fd_sc_hd__fill_2
X_4550_ _3825_ _3827_ vssd1 vssd1 vccd1 vccd1 _3828_ sky130_fd_sc_hd__nand2_1
XFILLER_7_561 vssd1 vssd1 vccd1 vccd1 sky130_fd_sc_hd__fill_8
X_4481_ net120 net113 net81 net79 vssd1 vssd1 vccd1 vccd1 _3759_ sky130_fd_sc_hd__and4_1
X_6220_ _1406_ _1407_ vssd1 vssd1 vccd1 vccd1 _1409_ sky130_fd_sc_hd__xnor2_1
X_6151_ PID_INST.k3_calc.d1.y\[12\] net78 net76 net137 vssd1 vssd1 vccd1 vccd1 _1340_
+ sky130_fd_sc_hd__a22o_1
X_5102_ _0290_ _0291_ vssd1 vssd1 vccd1 vccd1 _0292_ sky130_fd_sc_hd__xnor2_1
XFILLER_85_505 vssd1 vssd1 vccd1 vccd1 sky130_fd_sc_hd__fill_8
X_6082_ net227 net287 vssd1 vssd1 vccd1 vccd1 _1272_ sky130_fd_sc_hd__nand2_1
X_5033_ _0142_ _0143_ _0221_ vssd1 vssd1 vccd1 vccd1 _0223_ sky130_fd_sc_hd__nor3_1
XTAP_TAPCELL_ROW_0_203 vssd1 vccd1 sky130_fd_sc_hd__tapvpwrvgnd_1
XFILLER_38_443 vccd1 vssd1 vccd1 vssd1 sky130_ef_sc_hd__decap_40_12
XPHY_EDGE_ROW_69_Left_162 vssd1 vssd1 vccd1 vccd1 sky130_fd_sc_hd__decap_3
XFILLER_65_251 vssd1 vssd1 vccd1 vccd1 sky130_fd_sc_hd__fill_1
XFILLER_38_498 vssd1 vssd1 vccd1 vccd1 sky130_fd_sc_hd__fill_1
XTAP_TAPCELL_ROW_84_1038 vssd1 vccd1 sky130_fd_sc_hd__tapvpwrvgnd_1
XFILLER_80_232 vssd1 vssd1 vccd1 vccd1 sky130_fd_sc_hd__fill_2
XFILLER_65_295 vccd1 vssd1 vccd1 vssd1 sky130_ef_sc_hd__decap_40_12
XANTENNA__4336__A net230 vssd1 vssd1 vccd1 vccd1 sky130_fd_sc_hd__diode_2
X_6984_ net117 net43 vssd1 vssd1 vccd1 vccd1 _2198_ sky130_fd_sc_hd__or2_1
XFILLER_53_479 vssd1 vssd1 vccd1 vccd1 sky130_fd_sc_hd__fill_2
X_5935_ _1122_ _1123_ vssd1 vssd1 vccd1 vccd1 _1125_ sky130_fd_sc_hd__xor2_1
XFILLER_15_27 vssd1 vssd1 vccd1 vccd1 sky130_fd_sc_hd__fill_1
X_5866_ _1035_ _1037_ vssd1 vssd1 vccd1 vccd1 _1056_ sky130_fd_sc_hd__nand2_1
X_4817_ PID_INST.k1_calc.d1.x\[12\] PID_INST.k3_calc.prev_error\[12\] vssd1 vssd1
+ vccd1 vccd1 _4095_ sky130_fd_sc_hd__and2_2
XFILLER_21_332 vssd1 vssd1 vccd1 vccd1 sky130_fd_sc_hd__fill_4
X_7605_ net140 net39 vssd1 vssd1 vccd1 vccd1 _2857_ sky130_fd_sc_hd__nor2_1
X_5797_ _0983_ _0985_ vssd1 vssd1 vccd1 vccd1 _0987_ sky130_fd_sc_hd__nor2_1
XPHY_EDGE_ROW_78_Left_171 vssd1 vssd1 vccd1 vccd1 sky130_fd_sc_hd__decap_3
X_4748_ _4023_ _4024_ vssd1 vssd1 vccd1 vccd1 _4026_ sky130_fd_sc_hd__xnor2_1
X_7536_ _2521_ _2523_ vssd1 vssd1 vccd1 vccd1 _2783_ sky130_fd_sc_hd__nand2_1
X_7467_ _2685_ _2686_ _2708_ vssd1 vssd1 vccd1 vccd1 _2710_ sky130_fd_sc_hd__o21a_1
X_4679_ _3906_ _3916_ _3915_ vssd1 vssd1 vccd1 vccd1 _3957_ sky130_fd_sc_hd__a21bo_1
X_6418_ _1604_ _1605_ vssd1 vssd1 vccd1 vccd1 _1606_ sky130_fd_sc_hd__nor2_1
XANTENNA__5513__B1 net278 vssd1 vssd1 vccd1 vccd1 sky130_fd_sc_hd__diode_2
XPHY_EDGE_ROW_1_Right_1 vssd1 vssd1 vccd1 vccd1 sky130_fd_sc_hd__decap_3
X_7398_ _2634_ _2635_ vssd1 vssd1 vccd1 vccd1 _2637_ sky130_fd_sc_hd__xnor2_1
Xoutput26 net26 vssd1 vssd1 vccd1 vccd1 gpio_out[23] sky130_fd_sc_hd__buf_2
X_6349_ net149 net74 _1341_ vssd1 vssd1 vccd1 vccd1 _1537_ sky130_fd_sc_hd__or3_1
XANTENNA__4619__A2 net79 vssd1 vssd1 vccd1 vccd1 sky130_fd_sc_hd__diode_2
XPHY_EDGE_ROW_87_Left_180 vssd1 vssd1 vccd1 vccd1 sky130_fd_sc_hd__decap_3
XFILLER_48_218 vssd1 vssd1 vccd1 vccd1 sky130_fd_sc_hd__fill_4
X_8019_ _3271_ _3272_ vssd1 vssd1 vccd1 vccd1 _3273_ sky130_fd_sc_hd__or2_1
XFILLER_29_432 vssd1 vssd1 vccd1 vccd1 sky130_fd_sc_hd__fill_2
XANTENNA__5292__A2 net87 vssd1 vssd1 vccd1 vccd1 sky130_fd_sc_hd__diode_2
XFILLER_16_104 vssd1 vssd1 vccd1 vccd1 sky130_fd_sc_hd__fill_2
XFILLER_29_487 vssd1 vssd1 vccd1 vccd1 sky130_fd_sc_hd__fill_2
XFILLER_71_210 vssd1 vssd1 vccd1 vccd1 sky130_fd_sc_hd__fill_1
XFILLER_16_148 vssd1 vssd1 vccd1 vccd1 sky130_fd_sc_hd__fill_1
XTAP_TAPCELL_ROW_70_901 vssd1 vccd1 sky130_fd_sc_hd__tapvpwrvgnd_1
XFILLER_44_468 vssd1 vssd1 vccd1 vccd1 sky130_fd_sc_hd__fill_1
XFILLER_16_159 vssd1 vssd1 vccd1 vccd1 sky130_fd_sc_hd__fill_2
XANTENNA_fanout37_X net37 vssd1 vssd1 vccd1 vccd1 sky130_fd_sc_hd__diode_2
XFILLER_72_55 vssd1 vssd1 vccd1 vccd1 sky130_fd_sc_hd__fill_1
XFILLER_24_170 vssd1 vssd1 vccd1 vccd1 sky130_fd_sc_hd__fill_2
XTAP_TAPCELL_ROW_42_625 vssd1 vccd1 sky130_fd_sc_hd__tapvpwrvgnd_1
XFILLER_12_343 vccd1 vssd1 vccd1 vssd1 sky130_ef_sc_hd__decap_40_12
XTAP_TAPCELL_ROW_14_338 vssd1 vccd1 sky130_fd_sc_hd__tapvpwrvgnd_1
XFILLER_8_325 vssd1 vssd1 vccd1 vccd1 sky130_fd_sc_hd__fill_4
XFILLER_12_365 vssd1 vssd1 vccd1 vccd1 sky130_fd_sc_hd__fill_4
XFILLER_8_369 vssd1 vssd1 vccd1 vccd1 sky130_fd_sc_hd__fill_1
XANTENNA__4307__A1 net9 vssd1 vssd1 vccd1 vccd1 sky130_fd_sc_hd__diode_2
XFILLER_4_531 vssd1 vssd1 vccd1 vccd1 sky130_fd_sc_hd__fill_1
XFILLER_79_310 vssd1 vssd1 vccd1 vccd1 sky130_fd_sc_hd__fill_1
XFILLER_67_505 vssd1 vssd1 vccd1 vccd1 sky130_fd_sc_hd__fill_4
XTAP_TAPCELL_ROW_58_780 vssd1 vccd1 sky130_fd_sc_hd__tapvpwrvgnd_1
XFILLER_50_405 vssd1 vssd1 vccd1 vccd1 sky130_fd_sc_hd__fill_1
X_5720_ _0724_ _0909_ vssd1 vssd1 vccd1 vccd1 _0910_ sky130_fd_sc_hd__or2_1
XFILLER_50_438 vssd1 vssd1 vccd1 vccd1 sky130_fd_sc_hd__fill_1
XANTENNA__6371__A _2051_ vssd1 vssd1 vccd1 vccd1 sky130_fd_sc_hd__diode_2
XANTENNA__7186__B _2147_ vssd1 vssd1 vccd1 vccd1 sky130_fd_sc_hd__diode_2
X_5651_ net323 net210 _0830_ _0840_ vssd1 vssd1 vccd1 vccd1 _0841_ sky130_fd_sc_hd__a211o_1
X_5582_ _0738_ _0741_ vssd1 vssd1 vccd1 vccd1 _0772_ sky130_fd_sc_hd__nor2_1
X_8370_ clknet_4_4_0_clk _0006_ net330 vssd1 vssd1 vccd1 vccd1 PID_INST.k1_calc.d1.x\[6\]
+ sky130_fd_sc_hd__dfrtp_1
X_4602_ _3877_ _3878_ _3879_ vssd1 vssd1 vccd1 vccd1 _3880_ sky130_fd_sc_hd__nand3_1
X_4533_ _3790_ _3809_ vssd1 vssd1 vccd1 vccd1 _3811_ sky130_fd_sc_hd__xor2_1
X_7321_ _2220_ _2472_ vssd1 vssd1 vccd1 vccd1 _2555_ sky130_fd_sc_hd__nand2_1
X_7252_ net413 _2481_ net155 vssd1 vssd1 vccd1 vccd1 _0066_ sky130_fd_sc_hd__mux2_1
XFILLER_7_391 vssd1 vssd1 vccd1 vccd1 sky130_fd_sc_hd__fill_1
XFILLER_7_380 vssd1 vssd1 vccd1 vccd1 sky130_fd_sc_hd__fill_1
X_4464_ PID_INST.k1_calc.d1.x\[6\] PID_INST.k3_calc.prev_error\[6\] vssd1 vssd1 vccd1
+ vccd1 _3742_ sky130_fd_sc_hd__and2_1
X_6203_ _1186_ _1189_ _1390_ vssd1 vssd1 vccd1 vccd1 _1392_ sky130_fd_sc_hd__o21ai_1
XFILLER_89_129 vssd1 vssd1 vccd1 vccd1 sky130_fd_sc_hd__fill_8
X_4395_ _3679_ _3680_ _3681_ vssd1 vssd1 vccd1 vccd1 _3687_ sky130_fd_sc_hd__o21ai_1
X_7183_ _2150_ _2406_ vssd1 vssd1 vccd1 vccd1 _2408_ sky130_fd_sc_hd__xnor2_1
X_6134_ _1313_ _1322_ vssd1 vssd1 vccd1 vccd1 _1323_ sky130_fd_sc_hd__nor2_1
XTAP_TAPCELL_ROW_90_1097 vssd1 vccd1 sky130_fd_sc_hd__tapvpwrvgnd_1
XFILLER_85_335 vssd1 vssd1 vccd1 vccd1 sky130_fd_sc_hd__fill_1
X_6065_ _1246_ _1254_ vssd1 vssd1 vccd1 vccd1 _1255_ sky130_fd_sc_hd__and2_1
XFILLER_85_346 vssd1 vssd1 vccd1 vccd1 sky130_fd_sc_hd__fill_4
XANTENNA_fanout286_A net289 vssd1 vssd1 vccd1 vccd1 sky130_fd_sc_hd__diode_2
X_5016_ _0204_ _0205_ vssd1 vssd1 vccd1 vccd1 _0206_ sky130_fd_sc_hd__and2_1
XANTENNA__4482__B1 _3757_ vssd1 vssd1 vccd1 vccd1 sky130_fd_sc_hd__diode_2
XFILLER_26_402 vssd1 vssd1 vccd1 vccd1 sky130_fd_sc_hd__fill_1
X_6967_ net97 net48 vssd1 vssd1 vccd1 vccd1 _2181_ sky130_fd_sc_hd__nor2_2
XFILLER_26_457 vssd1 vssd1 vccd1 vccd1 sky130_fd_sc_hd__fill_2
XFILLER_26_468 vssd1 vssd1 vccd1 vccd1 sky130_fd_sc_hd__fill_1
XANTENNA__6774__A2 net289 vssd1 vssd1 vccd1 vccd1 sky130_fd_sc_hd__diode_2
X_5918_ net100 net66 vssd1 vssd1 vccd1 vccd1 _1108_ sky130_fd_sc_hd__nor2_1
XFILLER_13_129 vssd1 vssd1 vccd1 vccd1 sky130_fd_sc_hd__fill_4
XFILLER_41_438 vssd1 vssd1 vccd1 vccd1 sky130_fd_sc_hd__fill_8
XANTENNA__6712__C net258 vssd1 vssd1 vccd1 vccd1 sky130_fd_sc_hd__diode_2
XANTENNA_fanout339_X net339 vssd1 vssd1 vccd1 vccd1 sky130_fd_sc_hd__diode_2
X_6898_ _1805_ _1807_ _1804_ vssd1 vssd1 vccd1 vccd1 _2108_ sky130_fd_sc_hd__o21bai_1
X_5849_ _1034_ _1038_ _1029_ vssd1 vssd1 vccd1 vccd1 _1039_ sky130_fd_sc_hd__a21oi_1
XTAP_TAPCELL_ROW_11_308 vssd1 vccd1 sky130_fd_sc_hd__tapvpwrvgnd_1
X_7519_ _2762_ _2763_ vssd1 vssd1 vccd1 vccd1 _2765_ sky130_fd_sc_hd__xnor2_1
XANTENNA__5912__X _1102_ vssd1 vssd1 vccd1 vccd1 sky130_fd_sc_hd__diode_2
XFILLER_49_505 vssd1 vssd1 vccd1 vccd1 sky130_fd_sc_hd__fill_2
XANTENNA__7840__A net117 vssd1 vssd1 vccd1 vccd1 sky130_fd_sc_hd__diode_2
XFILLER_88_195 vssd1 vssd1 vccd1 vccd1 sky130_fd_sc_hd__fill_1
XFILLER_17_402 vssd1 vssd1 vccd1 vccd1 sky130_fd_sc_hd__fill_4
XANTENNA__8203__A2 net187 vssd1 vssd1 vccd1 vccd1 sky130_fd_sc_hd__diode_2
XANTENNA_input14_A gpio_in[4] vssd1 vssd1 vccd1 vccd1 sky130_fd_sc_hd__diode_2
XTAP_TAPCELL_ROW_55_750 vssd1 vccd1 sky130_fd_sc_hd__tapvpwrvgnd_1
XFILLER_44_265 vssd1 vssd1 vccd1 vccd1 sky130_fd_sc_hd__fill_2
XFILLER_44_287 vssd1 vssd1 vccd1 vccd1 sky130_fd_sc_hd__fill_1
XTAP_TAPCELL_ROW_27_474 vssd1 vccd1 sky130_fd_sc_hd__tapvpwrvgnd_1
XANTENNA__7287__A net119 vssd1 vssd1 vccd1 vccd1 sky130_fd_sc_hd__diode_2
XANTENNA__7718__C net201 vssd1 vssd1 vccd1 vccd1 sky130_fd_sc_hd__diode_2
XFILLER_16_81 vssd1 vssd1 vccd1 vccd1 sky130_fd_sc_hd__fill_2
XFILLER_8_122 vssd1 vssd1 vccd1 vccd1 sky130_fd_sc_hd__fill_1
XFILLER_12_173 vssd1 vssd1 vccd1 vccd1 sky130_fd_sc_hd__fill_4
XFILLER_8_177 vssd1 vssd1 vccd1 vccd1 sky130_fd_sc_hd__fill_8
X_4180_ PID_INST.k3_calc.kd_term\[11\] net175 vssd1 vssd1 vccd1 vccd1 _1944_ sky130_fd_sc_hd__or2_1
XFILLER_79_173 vssd1 vssd1 vccd1 vccd1 sky130_fd_sc_hd__fill_2
XFILLER_67_335 vssd1 vssd1 vccd1 vccd1 sky130_fd_sc_hd__fill_1
XANTENNA__5270__A net121 vssd1 vssd1 vccd1 vccd1 sky130_fd_sc_hd__diode_2
X_7870_ _3055_ _3121_ _3124_ vssd1 vssd1 vccd1 vccd1 _3125_ sky130_fd_sc_hd__a21o_1
X_6821_ _1713_ _1728_ _2025_ vssd1 vssd1 vccd1 vccd1 _2026_ sky130_fd_sc_hd__a21o_1
XFILLER_35_232 vccd1 vssd1 vccd1 vssd1 sky130_ef_sc_hd__decap_40_12
XFILLER_90_382 vssd1 vssd1 vccd1 vccd1 sky130_fd_sc_hd__fill_2
XTAP_TAPCELL_ROW_81_1008 vssd1 vccd1 sky130_fd_sc_hd__tapvpwrvgnd_1
X_6752_ _1836_ _1840_ _1951_ vssd1 vssd1 vccd1 vccd1 _1952_ sky130_fd_sc_hd__a21o_1
XFILLER_16_490 vssd1 vssd1 vccd1 vccd1 sky130_fd_sc_hd__fill_2
XFILLER_23_449 vssd1 vssd1 vccd1 vccd1 sky130_fd_sc_hd__fill_4
X_6683_ net216 net289 vssd1 vssd1 vccd1 vccd1 _1880_ sky130_fd_sc_hd__nand2_1
X_5703_ net312 net232 net237 net301 vssd1 vssd1 vccd1 vccd1 _0893_ sky130_fd_sc_hd__a22o_1
X_5634_ _0770_ _0771_ _0772_ vssd1 vssd1 vccd1 vccd1 _0824_ sky130_fd_sc_hd__o21ai_1
X_8422_ clknet_4_1_0_clk net136 net326 vssd1 vssd1 vccd1 vccd1 PID_INST.k3_calc.kd_term\[10\]
+ sky130_fd_sc_hd__dfrtp_1
X_8353_ _3622_ _3630_ vssd1 vssd1 vccd1 vccd1 _3631_ sky130_fd_sc_hd__xnor2_1
X_5565_ _0736_ _0754_ _0737_ vssd1 vssd1 vccd1 vccd1 _0755_ sky130_fd_sc_hd__a21oi_1
XANTENNA__8474__RESET_B net341 vssd1 vssd1 vccd1 vccd1 sky130_fd_sc_hd__diode_2
X_7304_ _2534_ _2535_ vssd1 vssd1 vccd1 vccd1 _2536_ sky130_fd_sc_hd__xor2_1
XTAP_TAPCELL_ROW_92_1126 vssd1 vccd1 sky130_fd_sc_hd__tapvpwrvgnd_1
X_8284_ _3480_ _3482_ vssd1 vssd1 vccd1 vccd1 _3557_ sky130_fd_sc_hd__or2_1
XANTENNA_fanout201_A net202 vssd1 vssd1 vccd1 vccd1 sky130_fd_sc_hd__diode_2
X_4516_ net128 net143 _3792_ _3793_ vssd1 vssd1 vccd1 vccd1 _3794_ sky130_fd_sc_hd__nand4_1
X_5496_ _0642_ _0683_ _0685_ _0624_ _0684_ vssd1 vssd1 vccd1 vccd1 _0686_ sky130_fd_sc_hd__o221a_1
XFILLER_2_309 vssd1 vssd1 vccd1 vccd1 sky130_fd_sc_hd__fill_1
X_4447_ PID_INST.k1_calc.d1.x\[0\] PID_INST.k3_calc.prev_error\[0\] _3723_ _3722_
+ vssd1 vssd1 vccd1 vccd1 _3725_ sky130_fd_sc_hd__a31o_1
X_7235_ _2192_ _2206_ _2462_ vssd1 vssd1 vccd1 vccd1 _2464_ sky130_fd_sc_hd__or3_1
X_7166_ _2388_ _2390_ vssd1 vssd1 vccd1 vccd1 _2391_ sky130_fd_sc_hd__or2_1
X_4378_ net205 net158 vssd1 vssd1 vccd1 vccd1 _3673_ sky130_fd_sc_hd__and2_1
XFILLER_58_313 vssd1 vssd1 vccd1 vccd1 sky130_fd_sc_hd__fill_2
XANTENNA_input6_A gpio_in[13] vssd1 vssd1 vccd1 vccd1 sky130_fd_sc_hd__diode_2
X_6117_ _1103_ _1305_ vssd1 vssd1 vccd1 vccd1 _1306_ sky130_fd_sc_hd__xnor2_1
XFILLER_85_143 vssd1 vssd1 vccd1 vccd1 sky130_fd_sc_hd__fill_2
X_7097_ net325 net183 vssd1 vssd1 vccd1 vccd1 _2318_ sky130_fd_sc_hd__nand2_1
XANTENNA_fanout289_X net289 vssd1 vssd1 vccd1 vccd1 sky130_fd_sc_hd__diode_2
XTAP_TAPCELL_ROW_69_886 vssd1 vccd1 sky130_fd_sc_hd__tapvpwrvgnd_1
X_6048_ _0817_ _0820_ _0822_ vssd1 vssd1 vccd1 vccd1 _1238_ sky130_fd_sc_hd__a21oi_1
XFILLER_85_198 vssd1 vssd1 vccd1 vccd1 sky130_fd_sc_hd__fill_2
XFILLER_26_243 vssd1 vssd1 vccd1 vccd1 sky130_fd_sc_hd__fill_1
X_7999_ _3042_ _3046_ _3253_ vssd1 vssd1 vccd1 vccd1 _3254_ sky130_fd_sc_hd__o21a_1
XTAP_TAPCELL_ROW_52_720 vssd1 vccd1 sky130_fd_sc_hd__tapvpwrvgnd_1
XFILLER_41_202 vssd1 vssd1 vccd1 vccd1 sky130_fd_sc_hd__fill_1
XFILLER_81_393 vssd1 vssd1 vccd1 vccd1 sky130_fd_sc_hd__fill_4
XTAP_TAPCELL_ROW_24_444 vssd1 vccd1 sky130_fd_sc_hd__tapvpwrvgnd_1
XFILLER_41_279 vssd1 vssd1 vccd1 vccd1 sky130_fd_sc_hd__fill_1
XFILLER_78_10 vccd1 vssd1 vccd1 vssd1 sky130_ef_sc_hd__decap_40_12
XFILLER_78_65 vssd1 vssd1 vccd1 vccd1 sky130_fd_sc_hd__fill_1
XFILLER_78_54 vssd1 vssd1 vccd1 vccd1 sky130_fd_sc_hd__fill_2
XANTENNA__5802__B net296 vssd1 vssd1 vccd1 vccd1 sky130_fd_sc_hd__diode_2
XFILLER_76_132 vssd1 vssd1 vccd1 vccd1 sky130_fd_sc_hd__fill_1
XFILLER_76_154 vssd1 vssd1 vccd1 vccd1 sky130_fd_sc_hd__fill_2
XANTENNA__7632__B1 net209 vssd1 vssd1 vccd1 vccd1 sky130_fd_sc_hd__diode_2
XFILLER_91_113 vssd1 vssd1 vccd1 vccd1 sky130_fd_sc_hd__fill_1
XANTENNA_input17_X net17 vssd1 vssd1 vccd1 vccd1 sky130_fd_sc_hd__diode_2
XFILLER_45_530 vssd1 vssd1 vccd1 vccd1 sky130_fd_sc_hd__fill_2
XANTENNA__7448__C net275 vssd1 vssd1 vccd1 vccd1 sky130_fd_sc_hd__diode_2
XFILLER_72_393 vssd1 vssd1 vccd1 vccd1 sky130_fd_sc_hd__fill_1
XFILLER_60_566 vssd1 vssd1 vccd1 vccd1 sky130_fd_sc_hd__fill_4
XFILLER_60_533 vccd1 vssd1 vccd1 vssd1 sky130_ef_sc_hd__decap_40_12
XFILLER_13_460 vssd1 vssd1 vccd1 vccd1 sky130_fd_sc_hd__fill_8
XFILLER_20_419 vssd1 vssd1 vccd1 vccd1 sky130_fd_sc_hd__fill_1
XANTENNA__5249__B net71 vssd1 vssd1 vccd1 vccd1 sky130_fd_sc_hd__diode_2
X_5350_ _0451_ _0463_ _0462_ vssd1 vssd1 vccd1 vccd1 _0540_ sky130_fd_sc_hd__a21oi_1
X_4301_ net282 net3 net172 vssd1 vssd1 vccd1 vccd1 _0024_ sky130_fd_sc_hd__mux2_1
X_5281_ _0330_ _0395_ _0394_ vssd1 vssd1 vccd1 vccd1 _0471_ sky130_fd_sc_hd__a21oi_1
X_7020_ net320 net188 vssd1 vssd1 vccd1 vccd1 _2237_ sky130_fd_sc_hd__nand2_1
X_4232_ net107 vssd1 vssd1 vccd1 vccd1 PID_INST.k3_calc.d2.y\[2\] sky130_fd_sc_hd__inv_2
X_4163_ net177 vssd1 vssd1 vccd1 vccd1 _1762_ sky130_fd_sc_hd__inv_2
XFILLER_28_508 vssd1 vssd1 vccd1 vccd1 sky130_fd_sc_hd__fill_1
XANTENNA__5229__A2 net83 vssd1 vssd1 vccd1 vccd1 sky130_fd_sc_hd__diode_2
XFILLER_55_349 vssd1 vssd1 vccd1 vccd1 sky130_fd_sc_hd__fill_1
X_7922_ _3175_ _3176_ vssd1 vssd1 vccd1 vccd1 _3177_ sky130_fd_sc_hd__and2_1
XFILLER_36_530 vssd1 vssd1 vccd1 vccd1 sky130_fd_sc_hd__fill_2
XTAP_TAPCELL_ROW_66_856 vssd1 vccd1 sky130_fd_sc_hd__tapvpwrvgnd_1
XFILLER_82_179 vssd1 vssd1 vccd1 vccd1 sky130_fd_sc_hd__fill_2
X_7853_ _3107_ _3108_ vssd1 vssd1 vccd1 vccd1 _3109_ sky130_fd_sc_hd__and2b_1
X_7784_ _3031_ _3032_ _3038_ vssd1 vssd1 vccd1 vccd1 _3040_ sky130_fd_sc_hd__a21o_1
X_6804_ _2005_ _2006_ vssd1 vssd1 vccd1 vccd1 _2007_ sky130_fd_sc_hd__xor2_1
XFILLER_51_555 vssd1 vssd1 vccd1 vccd1 sky130_fd_sc_hd__fill_1
X_4996_ _0184_ _0185_ vssd1 vssd1 vccd1 vccd1 _0186_ sky130_fd_sc_hd__nand2_1
X_6735_ _1827_ _1842_ _1933_ vssd1 vssd1 vccd1 vccd1 _1934_ sky130_fd_sc_hd__a21oi_1
XTAP_TAPCELL_ROW_21_414 vssd1 vccd1 sky130_fd_sc_hd__tapvpwrvgnd_1
X_6666_ _1858_ _1859_ vssd1 vssd1 vccd1 vccd1 _1862_ sky130_fd_sc_hd__xnor2_1
XANTENNA__4998__B net89 vssd1 vssd1 vccd1 vccd1 sky130_fd_sc_hd__diode_2
X_5617_ net269 net247 net250 net265 vssd1 vssd1 vccd1 vccd1 _0807_ sky130_fd_sc_hd__a22o_1
X_8405_ clknet_4_6_0_clk _0025_ net333 vssd1 vssd1 vccd1 vccd1 PID_INST.k2_calc.reg_lc\[9\]
+ sky130_fd_sc_hd__dfrtp_1
X_6597_ _1512_ _1786_ vssd1 vssd1 vccd1 vccd1 _1787_ sky130_fd_sc_hd__xnor2_1
X_8336_ _3554_ _3613_ vssd1 vssd1 vccd1 vccd1 _3614_ sky130_fd_sc_hd__xnor2_2
XANTENNA_fanout204_X net204 vssd1 vssd1 vccd1 vccd1 sky130_fd_sc_hd__diode_2
XANTENNA__8103__A1 net276 vssd1 vssd1 vccd1 vccd1 sky130_fd_sc_hd__diode_2
X_5548_ net314 net302 net220 net227 vssd1 vssd1 vccd1 vccd1 _0738_ sky130_fd_sc_hd__and4_1
X_8267_ _3455_ _3538_ vssd1 vssd1 vccd1 vccd1 _3540_ sky130_fd_sc_hd__nand2_1
X_5479_ _0648_ _0668_ vssd1 vssd1 vccd1 vccd1 _0669_ sky130_fd_sc_hd__xnor2_1
XFILLER_2_139 vssd1 vssd1 vccd1 vccd1 sky130_fd_sc_hd__fill_1
X_7218_ _2444_ _2445_ vssd1 vssd1 vccd1 vccd1 _2446_ sky130_fd_sc_hd__nor2_1
X_8198_ net197 net260 net189 net272 vssd1 vssd1 vccd1 vccd1 _3465_ sky130_fd_sc_hd__a22oi_1
X_7149_ _2348_ _2349_ _2370_ vssd1 vssd1 vccd1 vccd1 _2372_ sky130_fd_sc_hd__o21a_1
XFILLER_58_121 vssd1 vssd1 vccd1 vccd1 sky130_fd_sc_hd__fill_2
XANTENNA_input9_X net9 vssd1 vssd1 vccd1 vccd1 sky130_fd_sc_hd__diode_2
XFILLER_86_474 vssd1 vssd1 vccd1 vccd1 sky130_fd_sc_hd__fill_2
XFILLER_86_463 vssd1 vssd1 vccd1 vccd1 sky130_fd_sc_hd__fill_1
XANTENNA__6417__B2 net266 vssd1 vssd1 vccd1 vccd1 sky130_fd_sc_hd__diode_2
XFILLER_48_79 vssd1 vssd1 vccd1 vccd1 sky130_fd_sc_hd__fill_1
XFILLER_64_45 vssd1 vssd1 vccd1 vccd1 sky130_fd_sc_hd__fill_2
XPHY_EDGE_ROW_14_Left_107 vssd1 vssd1 vccd1 vccd1 sky130_fd_sc_hd__decap_3
XFILLER_42_533 vssd1 vssd1 vccd1 vccd1 sky130_fd_sc_hd__fill_1
XFILLER_80_22 vssd1 vssd1 vccd1 vccd1 sky130_fd_sc_hd__fill_4
XFILLER_9_29 vssd1 vssd1 vccd1 vccd1 sky130_fd_sc_hd__fill_2
Xfanout83 _3754_ vssd1 vssd1 vccd1 vccd1 net83 sky130_fd_sc_hd__buf_2
Xfanout72 _4035_ vssd1 vssd1 vccd1 vccd1 net72 sky130_fd_sc_hd__buf_1
Xfanout61 net62 vssd1 vssd1 vccd1 vccd1 net61 sky130_fd_sc_hd__buf_2
Xfanout50 _0403_ vssd1 vssd1 vccd1 vccd1 net50 sky130_fd_sc_hd__clkbuf_4
Xfanout94 _2707_ vssd1 vssd1 vccd1 vccd1 net94 sky130_fd_sc_hd__buf_1
XFILLER_89_31 vccd1 vssd1 vccd1 vssd1 sky130_ef_sc_hd__decap_40_12
XANTENNA__8099__C net260 vssd1 vssd1 vccd1 vccd1 sky130_fd_sc_hd__diode_2
XANTENNA__5516__C net285 vssd1 vssd1 vccd1 vccd1 sky130_fd_sc_hd__diode_2
XPHY_EDGE_ROW_23_Left_116 vssd1 vssd1 vccd1 vccd1 sky130_fd_sc_hd__decap_3
XFILLER_6_489 vssd1 vssd1 vccd1 vccd1 sky130_fd_sc_hd__fill_8
XFILLER_89_86 vssd1 vssd1 vccd1 vccd1 sky130_fd_sc_hd__fill_2
XANTENNA__5459__A2 net63 vssd1 vssd1 vccd1 vccd1 sky130_fd_sc_hd__diode_2
XTAP_TAPCELL_ROW_9_294 vssd1 vccd1 sky130_fd_sc_hd__tapvpwrvgnd_1
XFILLER_92_433 vssd1 vssd1 vccd1 vccd1 sky130_fd_sc_hd__fill_4
XFILLER_77_496 vssd1 vssd1 vccd1 vccd1 sky130_fd_sc_hd__fill_1
XFILLER_49_176 vccd1 vssd1 vccd1 vssd1 sky130_ef_sc_hd__decap_40_12
XFILLER_37_349 vssd1 vssd1 vccd1 vccd1 sky130_fd_sc_hd__fill_2
XFILLER_92_477 vccd1 vssd1 vccd1 vssd1 sky130_ef_sc_hd__decap_40_12
XFILLER_18_530 vssd1 vssd1 vccd1 vccd1 sky130_fd_sc_hd__fill_2
XPHY_EDGE_ROW_32_Left_125 vssd1 vssd1 vccd1 vccd1 sky130_fd_sc_hd__decap_3
XTAP_TAPCELL_ROW_63_826 vssd1 vccd1 sky130_fd_sc_hd__tapvpwrvgnd_1
XFILLER_52_319 vssd1 vssd1 vccd1 vccd1 sky130_fd_sc_hd__fill_2
X_4850_ net135 net143 _4126_ _4127_ vssd1 vssd1 vccd1 vccd1 _4128_ sky130_fd_sc_hd__nand4_1
XANTENNA__4769__A1_N net125 vssd1 vssd1 vccd1 vccd1 sky130_fd_sc_hd__diode_2
X_6520_ _1535_ _1705_ _1706_ vssd1 vssd1 vccd1 vccd1 _1707_ sky130_fd_sc_hd__a21bo_1
X_4781_ net133 net143 _4057_ vssd1 vssd1 vccd1 vccd1 _4059_ sky130_fd_sc_hd__a21oi_1
XFILLER_20_216 vssd1 vssd1 vccd1 vccd1 sky130_fd_sc_hd__fill_1
XFILLER_13_290 vssd1 vssd1 vccd1 vccd1 sky130_fd_sc_hd__fill_2
X_6451_ _1445_ _1453_ _1452_ vssd1 vssd1 vccd1 vccd1 _1639_ sky130_fd_sc_hd__a21oi_1
XPHY_EDGE_ROW_41_Left_134 vssd1 vssd1 vccd1 vccd1 sky130_fd_sc_hd__decap_3
X_5402_ _0554_ _0591_ vssd1 vssd1 vccd1 vccd1 _0592_ sky130_fd_sc_hd__nand2_1
X_6382_ _1568_ _1569_ vssd1 vssd1 vccd1 vccd1 _1570_ sky130_fd_sc_hd__and2_1
X_8121_ _3355_ _3356_ _3379_ _3380_ vssd1 vssd1 vccd1 vccd1 _3382_ sky130_fd_sc_hd__a22o_1
X_5333_ net125 _0156_ vssd1 vssd1 vccd1 vccd1 _0523_ sky130_fd_sc_hd__nand2_1
X_8052_ _3153_ _3158_ _3160_ vssd1 vssd1 vccd1 vccd1 _3307_ sky130_fd_sc_hd__a21boi_1
X_5264_ _2146_ net70 vssd1 vssd1 vccd1 vccd1 _0454_ sky130_fd_sc_hd__nor2_1
XFILLER_68_430 vssd1 vssd1 vccd1 vccd1 sky130_fd_sc_hd__fill_1
X_5195_ _0381_ _0382_ _0275_ _0284_ vssd1 vssd1 vccd1 vccd1 _0385_ sky130_fd_sc_hd__a211o_1
X_7003_ _1988_ _2100_ _2099_ vssd1 vssd1 vccd1 vccd1 _2219_ sky130_fd_sc_hd__a21oi_1
X_4215_ net17 net167 _2305_ vssd1 vssd1 vccd1 vccd1 _2315_ sky130_fd_sc_hd__o21ai_2
XANTENNA_fanout199_A net200 vssd1 vssd1 vccd1 vccd1 sky130_fd_sc_hd__diode_2
XFILLER_68_474 vssd1 vssd1 vccd1 vccd1 sky130_fd_sc_hd__fill_2
XPHY_EDGE_ROW_50_Left_143 vssd1 vssd1 vccd1 vccd1 sky130_fd_sc_hd__decap_3
XTAP_TAPCELL_ROW_79_992 vssd1 vccd1 sky130_fd_sc_hd__tapvpwrvgnd_1
XFILLER_68_485 vssd1 vssd1 vccd1 vccd1 sky130_fd_sc_hd__fill_1
XFILLER_28_327 vssd1 vssd1 vccd1 vccd1 sky130_fd_sc_hd__fill_2
XANTENNA__8381__CLK clknet_4_10_0_clk vssd1 vssd1 vccd1 vccd1 sky130_fd_sc_hd__diode_2
XFILLER_43_308 vssd1 vssd1 vccd1 vccd1 sky130_fd_sc_hd__fill_4
XTAP_TAPCELL_ROW_87_1069 vssd1 vccd1 sky130_fd_sc_hd__tapvpwrvgnd_1
X_7905_ _3159_ _3152_ vssd1 vssd1 vccd1 vccd1 _3160_ sky130_fd_sc_hd__nand2b_1
XFILLER_51_330 vssd1 vssd1 vccd1 vccd1 sky130_fd_sc_hd__fill_4
XFILLER_24_533 vssd1 vssd1 vccd1 vccd1 sky130_fd_sc_hd__fill_4
XFILLER_34_15 vssd1 vssd1 vccd1 vccd1 sky130_fd_sc_hd__fill_4
X_7836_ net117 net38 _2859_ _2858_ vssd1 vssd1 vccd1 vccd1 _3092_ sky130_fd_sc_hd__o31a_1
X_7767_ _2910_ _2912_ _3022_ vssd1 vssd1 vccd1 vccd1 _3023_ sky130_fd_sc_hd__a21o_1
XFILLER_51_385 vssd1 vssd1 vccd1 vccd1 sky130_fd_sc_hd__fill_4
XFILLER_11_227 vssd1 vssd1 vccd1 vccd1 sky130_fd_sc_hd__fill_2
X_4979_ _0168_ _0150_ vssd1 vssd1 vccd1 vccd1 _0169_ sky130_fd_sc_hd__nand2b_1
X_7698_ _2944_ _2945_ _2952_ vssd1 vssd1 vccd1 vccd1 _2954_ sky130_fd_sc_hd__a21oi_1
XANTENNA__8324__A1 net317 vssd1 vssd1 vccd1 vccd1 sky130_fd_sc_hd__diode_2
X_6718_ _1914_ _1915_ vssd1 vssd1 vccd1 vccd1 _1916_ sky130_fd_sc_hd__nand2_1
XANTENNA_fanout321_X net321 vssd1 vssd1 vccd1 vccd1 sky130_fd_sc_hd__diode_2
Xclkload3 clknet_4_3_0_clk vssd1 vssd1 vccd1 vccd1 clkload3/Y sky130_fd_sc_hd__inv_6
XFILLER_11_249 vssd1 vssd1 vccd1 vccd1 sky130_fd_sc_hd__fill_1
X_6649_ _1827_ _1828_ _1841_ vssd1 vssd1 vccd1 vccd1 _1843_ sky130_fd_sc_hd__a21o_1
XFILLER_50_69 vssd1 vssd1 vccd1 vccd1 sky130_fd_sc_hd__fill_1
XANTENNA__6638__A1 net204 vssd1 vssd1 vccd1 vccd1 sky130_fd_sc_hd__diode_2
X_8319_ net293 net180 vssd1 vssd1 vccd1 vccd1 _3595_ sky130_fd_sc_hd__nand2_1
XFILLER_78_205 vssd1 vssd1 vccd1 vccd1 sky130_fd_sc_hd__fill_1
Xfanout240 PID_INST.k2_calc.sum_reg\[3\] vssd1 vssd1 vccd1 vccd1 net240 sky130_fd_sc_hd__clkbuf_2
Xfanout262 PID_INST.k2_calc.reg_lc\[13\] vssd1 vssd1 vccd1 vccd1 net262 sky130_fd_sc_hd__clkbuf_2
XFILLER_75_11 vssd1 vssd1 vccd1 vccd1 sky130_fd_sc_hd__fill_4
Xfanout251 PID_INST.k2_calc.sum_reg\[0\] vssd1 vssd1 vccd1 vccd1 net251 sky130_fd_sc_hd__buf_2
XFILLER_59_474 vssd1 vssd1 vccd1 vccd1 sky130_fd_sc_hd__fill_4
Xfanout273 net275 vssd1 vssd1 vccd1 vccd1 net273 sky130_fd_sc_hd__buf_2
XTAP_TAPCELL_ROW_6_264 vssd1 vccd1 sky130_fd_sc_hd__tapvpwrvgnd_1
Xfanout284 net285 vssd1 vssd1 vccd1 vccd1 net284 sky130_fd_sc_hd__clkbuf_2
XFILLER_74_411 vssd1 vssd1 vccd1 vccd1 sky130_fd_sc_hd__fill_8
Xfanout295 net296 vssd1 vssd1 vccd1 vccd1 net295 sky130_fd_sc_hd__clkbuf_4
XFILLER_46_113 vccd1 vssd1 vccd1 vssd1 sky130_ef_sc_hd__decap_40_12
XFILLER_46_179 vssd1 vssd1 vccd1 vccd1 sky130_fd_sc_hd__fill_2
XFILLER_91_21 vccd1 vssd1 vccd1 vssd1 sky130_ef_sc_hd__decap_40_12
XFILLER_15_544 vssd1 vssd1 vccd1 vccd1 sky130_fd_sc_hd__fill_2
XANTENNA__7366__A2 net285 vssd1 vssd1 vccd1 vccd1 sky130_fd_sc_hd__diode_2
XFILLER_30_536 vccd1 vssd1 vccd1 vssd1 sky130_ef_sc_hd__decap_40_12
XFILLER_30_569 vssd1 vssd1 vccd1 vccd1 sky130_fd_sc_hd__fill_1
XFILLER_10_260 vccd1 vssd1 vccd1 vssd1 sky130_ef_sc_hd__decap_40_12
XFILLER_10_293 vssd1 vssd1 vccd1 vccd1 sky130_fd_sc_hd__fill_4
XFILLER_6_231 vssd1 vssd1 vccd1 vccd1 sky130_fd_sc_hd__fill_4
XTAP_TAPCELL_ROW_40_597 vssd1 vccd1 sky130_fd_sc_hd__tapvpwrvgnd_1
XFILLER_6_275 vssd1 vssd1 vccd1 vccd1 sky130_fd_sc_hd__fill_4
XFILLER_69_216 vssd1 vssd1 vccd1 vccd1 sky130_fd_sc_hd__fill_8
XFILLER_2_470 vssd1 vssd1 vccd1 vccd1 sky130_fd_sc_hd__fill_4
XFILLER_37_113 vssd1 vssd1 vccd1 vccd1 sky130_fd_sc_hd__fill_4
XTAP_TAPCELL_ROW_76_962 vssd1 vccd1 sky130_fd_sc_hd__tapvpwrvgnd_1
XFILLER_65_499 vssd1 vssd1 vccd1 vccd1 sky130_fd_sc_hd__fill_4
XFILLER_18_371 vssd1 vssd1 vccd1 vccd1 sky130_fd_sc_hd__fill_1
X_5951_ _1134_ _1140_ vssd1 vssd1 vccd1 vccd1 _1141_ sky130_fd_sc_hd__xnor2_2
XFILLER_52_138 vssd1 vssd1 vccd1 vccd1 sky130_fd_sc_hd__fill_2
XFILLER_52_149 vssd1 vssd1 vccd1 vccd1 sky130_fd_sc_hd__fill_2
X_4902_ net121 _4033_ _4034_ vssd1 vssd1 vccd1 vccd1 _0092_ sky130_fd_sc_hd__and3_1
X_5882_ net241 net320 _1031_ vssd1 vssd1 vccd1 vccd1 _1072_ sky130_fd_sc_hd__a21oi_1
XFILLER_33_363 vssd1 vssd1 vccd1 vccd1 sky130_fd_sc_hd__fill_1
X_4833_ _4046_ _4052_ _4051_ vssd1 vssd1 vccd1 vccd1 _4111_ sky130_fd_sc_hd__a21bo_1
XFILLER_21_536 vccd1 vssd1 vccd1 vssd1 sky130_ef_sc_hd__decap_40_12
X_7621_ _2871_ _2872_ vssd1 vssd1 vccd1 vccd1 _2873_ sky130_fd_sc_hd__or2_1
XANTENNA__5718__A net232 vssd1 vssd1 vccd1 vccd1 sky130_fd_sc_hd__diode_2
XFILLER_60_193 vssd1 vssd1 vccd1 vccd1 sky130_fd_sc_hd__fill_2
X_4764_ _4040_ _4041_ vssd1 vssd1 vccd1 vccd1 _4042_ sky130_fd_sc_hd__or2_1
X_7552_ _2798_ _2799_ vssd1 vssd1 vccd1 vccd1 _2800_ sky130_fd_sc_hd__or2_1
X_7483_ _2623_ _2626_ _2725_ vssd1 vssd1 vccd1 vccd1 _2726_ sky130_fd_sc_hd__o21ba_1
XANTENNA__4341__B net18 vssd1 vssd1 vccd1 vccd1 sky130_fd_sc_hd__diode_2
X_6503_ _1117_ _1314_ _1518_ _1517_ _1511_ vssd1 vssd1 vccd1 vccd1 _1690_ sky130_fd_sc_hd__a32o_1
X_6434_ net292 net220 _1430_ _1428_ vssd1 vssd1 vccd1 vccd1 _1622_ sky130_fd_sc_hd__a31o_1
X_4695_ _3782_ _3972_ vssd1 vssd1 vccd1 vccd1 _3973_ sky130_fd_sc_hd__xor2_1
XANTENNA__6868__A1 net139 vssd1 vssd1 vccd1 vccd1 sky130_fd_sc_hd__diode_2
XANTENNA_fanout114_A net115 vssd1 vssd1 vccd1 vccd1 sky130_fd_sc_hd__diode_2
X_6365_ _1546_ _1552_ vssd1 vssd1 vccd1 vccd1 _1553_ sky130_fd_sc_hd__nor2_1
XANTENNA__5453__A net107 vssd1 vssd1 vccd1 vccd1 sky130_fd_sc_hd__diode_2
X_8104_ _3362_ vssd1 vssd1 vccd1 vccd1 _3363_ sky130_fd_sc_hd__inv_2
X_6296_ _1411_ _1484_ vssd1 vssd1 vccd1 vccd1 _1485_ sky130_fd_sc_hd__and2_1
X_5316_ net134 net77 vssd1 vssd1 vccd1 vccd1 _0506_ sky130_fd_sc_hd__and2_1
X_8035_ _3141_ _3146_ _3139_ vssd1 vssd1 vccd1 vccd1 _3289_ sky130_fd_sc_hd__a21oi_1
X_5247_ net132 net76 _3999_ net131 vssd1 vssd1 vccd1 vccd1 _0437_ sky130_fd_sc_hd__a22o_1
XFILLER_88_569 vssd1 vssd1 vccd1 vccd1 sky130_fd_sc_hd__fill_1
Xhold15 PID_INST.k1_calc.d1.x\[10\] vssd1 vssd1 vccd1 vccd1 net408 sky130_fd_sc_hd__dlygate4sd3_1
Xhold26 net32 vssd1 vssd1 vccd1 vccd1 net419 sky130_fd_sc_hd__dlygate4sd3_1
XTAP_TAPCELL_ROW_3_234 vssd1 vccd1 sky130_fd_sc_hd__tapvpwrvgnd_1
X_5178_ net136 net80 _0366_ _0367_ vssd1 vssd1 vccd1 vccd1 _0368_ sky130_fd_sc_hd__nand4_1
XFILLER_56_488 vssd1 vssd1 vccd1 vccd1 sky130_fd_sc_hd__fill_4
XFILLER_71_447 vssd1 vssd1 vccd1 vccd1 sky130_fd_sc_hd__fill_1
XFILLER_24_363 vssd1 vssd1 vccd1 vccd1 sky130_fd_sc_hd__fill_1
XFILLER_24_385 vssd1 vssd1 vccd1 vccd1 sky130_fd_sc_hd__fill_2
X_7819_ net102 net47 _2828_ _2827_ vssd1 vssd1 vccd1 vccd1 _3075_ sky130_fd_sc_hd__o31ai_2
XFILLER_61_68 vssd1 vssd1 vccd1 vccd1 sky130_fd_sc_hd__fill_2
XFILLER_8_518 vssd1 vssd1 vccd1 vccd1 sky130_fd_sc_hd__fill_1
XFILLER_3_223 vssd1 vssd1 vccd1 vccd1 sky130_fd_sc_hd__fill_1
XANTENNA__5363__A net105 vssd1 vssd1 vccd1 vccd1 sky130_fd_sc_hd__diode_2
XANTENNA__8447__Q PID_INST.k2_calc.sum_reg\[3\] vssd1 vssd1 vccd1 vccd1 sky130_fd_sc_hd__diode_2
XFILLER_10_83 vssd1 vssd1 vccd1 vccd1 sky130_fd_sc_hd__fill_1
XFILLER_79_569 vssd1 vssd1 vccd1 vccd1 sky130_fd_sc_hd__fill_1
XFILLER_86_87 vssd1 vssd1 vccd1 vccd1 sky130_fd_sc_hd__fill_1
XFILLER_19_146 vssd1 vssd1 vccd1 vccd1 sky130_fd_sc_hd__fill_1
XFILLER_74_274 vssd1 vssd1 vccd1 vccd1 sky130_fd_sc_hd__fill_2
XTAP_TAPCELL_ROW_73_932 vssd1 vccd1 sky130_fd_sc_hd__tapvpwrvgnd_1
XANTENNA__4270__A1 net11 vssd1 vssd1 vccd1 vccd1 sky130_fd_sc_hd__diode_2
XTAP_TAPCELL_ROW_17_369 vssd1 vccd1 sky130_fd_sc_hd__tapvpwrvgnd_1
XFILLER_30_311 vssd1 vssd1 vccd1 vccd1 sky130_fd_sc_hd__fill_1
XFILLER_89_6 vccd1 vssd1 vccd1 vssd1 sky130_ef_sc_hd__decap_40_12
X_4480_ net113 net79 vssd1 vssd1 vccd1 vccd1 _3758_ sky130_fd_sc_hd__nand2_1
XANTENNA__5544__Y _0734_ vssd1 vssd1 vccd1 vccd1 sky130_fd_sc_hd__diode_2
X_6150_ _1336_ _1337_ vssd1 vssd1 vccd1 vccd1 _1339_ sky130_fd_sc_hd__xnor2_1
X_5101_ _0180_ _0207_ _0206_ vssd1 vssd1 vccd1 vccd1 _0291_ sky130_fd_sc_hd__o21bai_2
X_6081_ _1269_ _1270_ vssd1 vssd1 vccd1 vccd1 _1271_ sky130_fd_sc_hd__nor2_1
X_5032_ _0142_ _0143_ _0145_ _0221_ vssd1 vssd1 vccd1 vccd1 _0222_ sky130_fd_sc_hd__o211ai_2
XANTENNA__4617__A net148 vssd1 vssd1 vccd1 vccd1 sky130_fd_sc_hd__diode_2
XFILLER_38_455 vssd1 vssd1 vccd1 vccd1 sky130_fd_sc_hd__fill_1
XTAP_TAPCELL_ROW_0_204 vssd1 vccd1 sky130_fd_sc_hd__tapvpwrvgnd_1
XANTENNA__8428__RESET_B net327 vssd1 vssd1 vccd1 vccd1 sky130_fd_sc_hd__diode_2
XFILLER_38_477 vssd1 vssd1 vccd1 vccd1 sky130_fd_sc_hd__fill_2
XTAP_TAPCELL_ROW_84_1039 vssd1 vccd1 sky130_fd_sc_hd__tapvpwrvgnd_1
XFILLER_65_285 vssd1 vssd1 vccd1 vccd1 sky130_fd_sc_hd__fill_8
XANTENNA__4336__B net17 vssd1 vssd1 vccd1 vccd1 sky130_fd_sc_hd__diode_2
XFILLER_53_447 vssd1 vssd1 vccd1 vccd1 sky130_fd_sc_hd__fill_1
X_6983_ net119 net42 vssd1 vssd1 vccd1 vccd1 _2197_ sky130_fd_sc_hd__nor2_1
X_5934_ _1122_ _1123_ vssd1 vssd1 vccd1 vccd1 _1124_ sky130_fd_sc_hd__nand2b_1
XANTENNA__6832__A net104 vssd1 vssd1 vccd1 vccd1 sky130_fd_sc_hd__diode_2
X_5865_ _1044_ _1054_ vssd1 vssd1 vccd1 vccd1 _1055_ sky130_fd_sc_hd__nor2_1
XANTENNA_fanout231_A net232 vssd1 vssd1 vccd1 vccd1 sky130_fd_sc_hd__diode_2
X_7604_ net140 _1742_ vssd1 vssd1 vccd1 vccd1 _2855_ sky130_fd_sc_hd__nor2_1
X_4816_ _4001_ _4037_ _4038_ _4036_ vssd1 vssd1 vccd1 vccd1 _4094_ sky130_fd_sc_hd__a22o_1
X_5796_ _0983_ _0985_ vssd1 vssd1 vccd1 vccd1 _0986_ sky130_fd_sc_hd__and2_1
XANTENNA_fanout329_A net339 vssd1 vssd1 vccd1 vccd1 sky130_fd_sc_hd__diode_2
X_4747_ _3965_ _4022_ vssd1 vssd1 vccd1 vccd1 _4025_ sky130_fd_sc_hd__nand2_1
XFILLER_21_399 vssd1 vssd1 vccd1 vccd1 sky130_fd_sc_hd__fill_2
XFILLER_31_38 vssd1 vssd1 vccd1 vccd1 sky130_fd_sc_hd__fill_1
X_7535_ _2536_ _2538_ _2539_ _2540_ vssd1 vssd1 vccd1 vccd1 _2782_ sky130_fd_sc_hd__a2bb2o_1
X_7466_ _2685_ _2686_ _2708_ vssd1 vssd1 vccd1 vccd1 _2709_ sky130_fd_sc_hd__nor3_1
X_4678_ _3918_ _3928_ _3935_ _3953_ _3955_ vssd1 vssd1 vccd1 vccd1 _3956_ sky130_fd_sc_hd__a221o_1
XANTENNA_fanout117_X net117 vssd1 vssd1 vccd1 vccd1 sky130_fd_sc_hd__diode_2
X_7397_ _2635_ _2634_ vssd1 vssd1 vccd1 vccd1 _2636_ sky130_fd_sc_hd__and2b_1
X_6417_ net269 net235 net240 net266 vssd1 vssd1 vccd1 vccd1 _1605_ sky130_fd_sc_hd__a22oi_1
XANTENNA__4316__A2 net13 vssd1 vssd1 vccd1 vccd1 sky130_fd_sc_hd__diode_2
Xoutput27 net27 vssd1 vssd1 vccd1 vccd1 gpio_out[24] sky130_fd_sc_hd__buf_2
X_6348_ net149 net74 _1341_ vssd1 vssd1 vccd1 vccd1 _1536_ sky130_fd_sc_hd__o21ai_1
X_6279_ _1466_ _1467_ vssd1 vssd1 vccd1 vccd1 _1468_ sky130_fd_sc_hd__nor2_1
XFILLER_88_399 vssd1 vssd1 vccd1 vccd1 sky130_fd_sc_hd__fill_1
X_8018_ net94 net46 _3124_ _3123_ vssd1 vssd1 vccd1 vccd1 _3272_ sky130_fd_sc_hd__o31a_1
XANTENNA__5630__B net210 vssd1 vssd1 vccd1 vccd1 sky130_fd_sc_hd__diode_2
XFILLER_84_550 vccd1 vssd1 vccd1 vssd1 sky130_ef_sc_hd__decap_40_12
XFILLER_71_222 vssd1 vssd1 vccd1 vccd1 sky130_fd_sc_hd__fill_2
XANTENNA__7838__A net119 vssd1 vssd1 vccd1 vccd1 sky130_fd_sc_hd__diode_2
XFILLER_71_255 vssd1 vssd1 vccd1 vccd1 sky130_fd_sc_hd__fill_2
XTAP_TAPCELL_ROW_70_902 vssd1 vccd1 sky130_fd_sc_hd__tapvpwrvgnd_1
XANTENNA__4252__A1 net8 vssd1 vssd1 vccd1 vccd1 sky130_fd_sc_hd__diode_2
XTAP_TAPCELL_ROW_14_339 vssd1 vccd1 sky130_fd_sc_hd__tapvpwrvgnd_1
XFILLER_12_355 vssd1 vssd1 vccd1 vccd1 sky130_fd_sc_hd__fill_8
XFILLER_8_348 vccd1 vssd1 vccd1 vssd1 sky130_ef_sc_hd__decap_40_12
XFILLER_4_565 vssd1 vssd1 vccd1 vccd1 sky130_fd_sc_hd__fill_2
XFILLER_67_517 vssd1 vssd1 vccd1 vccd1 sky130_fd_sc_hd__fill_4
XFILLER_11_7 vssd1 vssd1 vccd1 vccd1 sky130_fd_sc_hd__fill_2
XFILLER_75_561 vssd1 vssd1 vccd1 vccd1 sky130_fd_sc_hd__fill_8
XFILLER_90_531 vssd1 vssd1 vccd1 vccd1 sky130_fd_sc_hd__fill_1
XTAP_TAPCELL_ROW_58_781 vssd1 vccd1 sky130_fd_sc_hd__tapvpwrvgnd_1
XFILLER_62_255 vssd1 vssd1 vccd1 vccd1 sky130_fd_sc_hd__fill_1
XFILLER_35_469 vssd1 vssd1 vccd1 vccd1 sky130_fd_sc_hd__fill_8
XANTENNA__4243__A1 net5 vssd1 vssd1 vccd1 vccd1 sky130_fd_sc_hd__diode_2
XFILLER_22_108 vssd1 vssd1 vccd1 vccd1 sky130_fd_sc_hd__fill_1
XANTENNA__6371__B _0088_ vssd1 vssd1 vccd1 vccd1 sky130_fd_sc_hd__diode_2
X_5650_ net323 net219 vssd1 vssd1 vccd1 vccd1 _0840_ sky130_fd_sc_hd__nand2_1
Xclkbuf_0_clk clk vssd1 vssd1 vccd1 vccd1 clknet_0_clk sky130_fd_sc_hd__clkbuf_16
X_4601_ net141 net81 _3873_ _3872_ vssd1 vssd1 vccd1 vccd1 _3879_ sky130_fd_sc_hd__a31o_1
XFILLER_30_141 vssd1 vssd1 vccd1 vccd1 sky130_fd_sc_hd__fill_4
X_5581_ net291 net231 _0767_ _0769_ vssd1 vssd1 vccd1 vccd1 _0771_ sky130_fd_sc_hd__o2bb2a_1
XANTENNA__4546__A2 net87 vssd1 vssd1 vccd1 vccd1 sky130_fd_sc_hd__diode_2
X_4532_ _3790_ _3809_ vssd1 vssd1 vccd1 vccd1 _3810_ sky130_fd_sc_hd__nor2_1
XANTENNA__4900__A net147 vssd1 vssd1 vccd1 vccd1 sky130_fd_sc_hd__diode_2
X_7320_ _2551_ _2552_ vssd1 vssd1 vccd1 vccd1 _2554_ sky130_fd_sc_hd__xor2_2
X_4463_ _3739_ _3740_ vssd1 vssd1 vccd1 vccd1 _3741_ sky130_fd_sc_hd__nand2_1
X_7251_ _2479_ _2480_ vssd1 vssd1 vccd1 vccd1 _2481_ sky130_fd_sc_hd__xor2_1
XFILLER_7_95 vssd1 vssd1 vccd1 vccd1 sky130_fd_sc_hd__fill_2
X_6202_ _1186_ _1189_ _1390_ vssd1 vssd1 vccd1 vccd1 _1391_ sky130_fd_sc_hd__or3_1
X_4394_ _3684_ _3685_ vssd1 vssd1 vccd1 vccd1 _3686_ sky130_fd_sc_hd__and2b_1
XPHY_EDGE_ROW_15_Right_15 vssd1 vssd1 vccd1 vccd1 sky130_fd_sc_hd__decap_3
X_7182_ _2039_ _2405_ vssd1 vssd1 vccd1 vccd1 _2407_ sky130_fd_sc_hd__nand2_1
X_6133_ _1320_ _1321_ vssd1 vssd1 vccd1 vccd1 _1322_ sky130_fd_sc_hd__xnor2_1
XTAP_TAPCELL_ROW_90_1098 vssd1 vccd1 sky130_fd_sc_hd__tapvpwrvgnd_1
X_6064_ _1251_ _1252_ vssd1 vssd1 vccd1 vccd1 _1254_ sky130_fd_sc_hd__xnor2_1
X_5015_ _0123_ _0129_ _0122_ vssd1 vssd1 vccd1 vccd1 _0205_ sky130_fd_sc_hd__o21ai_1
XANTENNA_fanout279_A net280 vssd1 vssd1 vccd1 vccd1 sky130_fd_sc_hd__diode_2
XANTENNA_fanout181_A net182 vssd1 vssd1 vccd1 vccd1 sky130_fd_sc_hd__diode_2
XANTENNA__4482__B2 net148 vssd1 vssd1 vccd1 vccd1 sky130_fd_sc_hd__diode_2
XFILLER_26_425 vssd1 vssd1 vccd1 vccd1 sky130_fd_sc_hd__fill_1
XFILLER_38_296 vssd1 vssd1 vccd1 vccd1 sky130_fd_sc_hd__fill_8
XANTENNA__7420__B2 net226 vssd1 vssd1 vccd1 vccd1 sky130_fd_sc_hd__diode_2
XFILLER_53_233 vssd1 vssd1 vccd1 vccd1 sky130_fd_sc_hd__fill_4
X_6966_ _2176_ _2177_ vssd1 vssd1 vccd1 vccd1 _2180_ sky130_fd_sc_hd__xnor2_1
XPHY_EDGE_ROW_24_Right_24 vssd1 vssd1 vccd1 vccd1 sky130_fd_sc_hd__decap_3
XANTENNA__4234__A1 net13 vssd1 vssd1 vccd1 vccd1 sky130_fd_sc_hd__diode_2
X_5917_ net109 net61 vssd1 vssd1 vccd1 vccd1 _1107_ sky130_fd_sc_hd__nor2_1
XANTENNA__6712__D net255 vssd1 vssd1 vccd1 vccd1 sky130_fd_sc_hd__diode_2
X_6897_ _2103_ _2105_ vssd1 vssd1 vccd1 vccd1 _2107_ sky130_fd_sc_hd__nor2_1
X_5848_ _1035_ _1037_ vssd1 vssd1 vccd1 vccd1 _1038_ sky130_fd_sc_hd__or2_1
XTAP_TAPCELL_ROW_11_309 vssd1 vccd1 sky130_fd_sc_hd__tapvpwrvgnd_1
X_5779_ _0963_ _0968_ _0922_ _0929_ vssd1 vssd1 vccd1 vccd1 _0969_ sky130_fd_sc_hd__o211a_1
X_7518_ _2763_ _2762_ vssd1 vssd1 vccd1 vccd1 _2764_ sky130_fd_sc_hd__nand2b_1
X_7449_ _2262_ _2688_ _2689_ vssd1 vssd1 vccd1 vccd1 _2690_ sky130_fd_sc_hd__a21oi_1
XPHY_EDGE_ROW_33_Right_33 vssd1 vssd1 vccd1 vccd1 sky130_fd_sc_hd__decap_3
XANTENNA__7840__B net37 vssd1 vssd1 vccd1 vccd1 sky130_fd_sc_hd__diode_2
XFILLER_1_557 vssd1 vssd1 vccd1 vccd1 sky130_fd_sc_hd__fill_2
XFILLER_88_174 vssd1 vssd1 vccd1 vccd1 sky130_fd_sc_hd__fill_1
XFILLER_88_152 vssd1 vssd1 vccd1 vccd1 sky130_fd_sc_hd__fill_2
XFILLER_64_509 vssd1 vssd1 vccd1 vccd1 sky130_fd_sc_hd__fill_4
XFILLER_29_274 vssd1 vssd1 vccd1 vccd1 sky130_fd_sc_hd__fill_4
XPHY_EDGE_ROW_42_Right_42 vssd1 vssd1 vccd1 vccd1 sky130_fd_sc_hd__decap_3
XTAP_TAPCELL_ROW_55_751 vssd1 vccd1 sky130_fd_sc_hd__tapvpwrvgnd_1
XFILLER_17_447 vssd1 vssd1 vccd1 vccd1 sky130_fd_sc_hd__fill_1
XANTENNA__4225__A1 net15 vssd1 vssd1 vccd1 vccd1 sky130_fd_sc_hd__diode_2
XTAP_TAPCELL_ROW_27_475 vssd1 vccd1 sky130_fd_sc_hd__tapvpwrvgnd_1
XANTENNA__7718__D net205 vssd1 vssd1 vccd1 vccd1 sky130_fd_sc_hd__diode_2
XANTENNA__8460__Q PID_INST.k2_calc.sum_reg\[16\] vssd1 vssd1 vccd1 vccd1 sky130_fd_sc_hd__diode_2
XANTENNA__4704__B net79 vssd1 vssd1 vccd1 vccd1 sky130_fd_sc_hd__diode_2
XFILLER_25_491 vccd1 vssd1 vccd1 vssd1 sky130_ef_sc_hd__decap_40_12
XPHY_EDGE_ROW_51_Right_51 vssd1 vssd1 vccd1 vccd1 sky130_fd_sc_hd__decap_3
XFILLER_67_325 vssd1 vssd1 vccd1 vccd1 sky130_fd_sc_hd__fill_1
XFILLER_67_369 vssd1 vssd1 vccd1 vccd1 sky130_fd_sc_hd__fill_1
XPHY_EDGE_ROW_60_Right_60 vssd1 vssd1 vccd1 vccd1 sky130_fd_sc_hd__decap_3
XFILLER_75_391 vssd1 vssd1 vccd1 vccd1 sky130_fd_sc_hd__fill_1
XFILLER_35_222 vssd1 vssd1 vccd1 vccd1 sky130_fd_sc_hd__fill_2
XFILLER_63_542 vssd1 vssd1 vccd1 vccd1 sky130_fd_sc_hd__fill_8
X_6820_ _2023_ _2024_ vssd1 vssd1 vccd1 vccd1 _2025_ sky130_fd_sc_hd__nand2_1
XFILLER_35_244 vssd1 vssd1 vccd1 vccd1 sky130_fd_sc_hd__fill_4
XFILLER_35_255 vssd1 vssd1 vccd1 vccd1 sky130_fd_sc_hd__fill_1
XTAP_TAPCELL_ROW_81_1009 vssd1 vccd1 sky130_fd_sc_hd__tapvpwrvgnd_1
X_6751_ _1941_ _1950_ vssd1 vssd1 vccd1 vccd1 _1951_ sky130_fd_sc_hd__xnor2_1
XFILLER_50_225 vssd1 vssd1 vccd1 vccd1 sky130_fd_sc_hd__fill_2
X_6682_ _1877_ _1878_ vssd1 vssd1 vccd1 vccd1 _1879_ sky130_fd_sc_hd__nor2_1
XANTENNA__5620__A2_N net203 vssd1 vssd1 vccd1 vccd1 sky130_fd_sc_hd__diode_2
X_5702_ net312 net301 net232 net237 vssd1 vssd1 vccd1 vccd1 _0892_ sky130_fd_sc_hd__and4_1
X_5633_ _0804_ _0821_ vssd1 vssd1 vccd1 vccd1 _0823_ sky130_fd_sc_hd__and2_1
X_8421_ clknet_4_3_0_clk net134 net339 vssd1 vssd1 vccd1 vccd1 PID_INST.k3_calc.kd_term\[9\]
+ sky130_fd_sc_hd__dfrtp_1
X_5564_ net220 net306 vssd1 vssd1 vccd1 vccd1 _0754_ sky130_fd_sc_hd__nand2_1
XFILLER_12_29 vssd1 vssd1 vccd1 vccd1 sky130_fd_sc_hd__fill_4
X_8352_ _3626_ _3629_ vssd1 vssd1 vccd1 vccd1 _3630_ sky130_fd_sc_hd__xnor2_1
X_4515_ _3779_ _3791_ vssd1 vssd1 vccd1 vccd1 _3793_ sky130_fd_sc_hd__nand2_1
X_7303_ PID_INST.k3_calc.d2.y\[3\] _2034_ _2035_ vssd1 vssd1 vccd1 vccd1 _2535_ sky130_fd_sc_hd__and3_1
XTAP_TAPCELL_ROW_92_1116 vssd1 vccd1 sky130_fd_sc_hd__tapvpwrvgnd_1
X_8283_ _3495_ _3513_ _3512_ vssd1 vssd1 vccd1 vccd1 _3556_ sky130_fd_sc_hd__a21bo_1
XANTENNA__8488__CLK clknet_4_15_0_clk vssd1 vssd1 vccd1 vccd1 sky130_fd_sc_hd__diode_2
X_5495_ _0600_ _0601_ vssd1 vssd1 vccd1 vccd1 _0685_ sky130_fd_sc_hd__xor2_1
XTAP_TAPCELL_ROW_92_1127 vssd1 vccd1 sky130_fd_sc_hd__tapvpwrvgnd_1
X_4446_ PID_INST.k1_calc.d1.x\[0\] PID_INST.k3_calc.prev_error\[0\] vssd1 vssd1 vccd1
+ vccd1 _3724_ sky130_fd_sc_hd__nand2_1
X_7234_ _2192_ _2206_ _2462_ vssd1 vssd1 vccd1 vccd1 _2463_ sky130_fd_sc_hd__o21ai_1
X_7165_ _2289_ _2292_ _2387_ vssd1 vssd1 vccd1 vccd1 _2390_ sky130_fd_sc_hd__nor3b_1
X_4377_ _3668_ _3669_ _3670_ vssd1 vssd1 vccd1 vccd1 _3672_ sky130_fd_sc_hd__or3_1
XANTENNA__5461__A net105 vssd1 vssd1 vccd1 vccd1 sky130_fd_sc_hd__diode_2
X_6116_ net109 net59 vssd1 vssd1 vccd1 vccd1 _1305_ sky130_fd_sc_hd__nor2_1
X_7096_ _2314_ _2316_ vssd1 vssd1 vccd1 vccd1 _2317_ sky130_fd_sc_hd__nor2_1
XTAP_TAPCELL_ROW_69_887 vssd1 vccd1 sky130_fd_sc_hd__tapvpwrvgnd_1
X_6047_ _1227_ _1235_ vssd1 vssd1 vccd1 vccd1 _1237_ sky130_fd_sc_hd__nor2_1
XFILLER_58_369 vssd1 vssd1 vccd1 vccd1 sky130_fd_sc_hd__fill_4
XFILLER_39_550 vssd1 vssd1 vccd1 vccd1 sky130_fd_sc_hd__fill_8
XFILLER_39_561 vssd1 vssd1 vccd1 vccd1 sky130_fd_sc_hd__fill_1
XFILLER_54_531 vssd1 vssd1 vccd1 vccd1 sky130_fd_sc_hd__fill_1
XFILLER_26_211 vssd1 vssd1 vccd1 vccd1 sky130_fd_sc_hd__fill_1
XANTENNA__7388__A net199 vssd1 vssd1 vccd1 vccd1 sky130_fd_sc_hd__diode_2
XFILLER_54_542 vssd1 vssd1 vccd1 vccd1 sky130_fd_sc_hd__fill_1
X_7998_ _3250_ _3251_ vssd1 vssd1 vccd1 vccd1 _3253_ sky130_fd_sc_hd__xnor2_1
XFILLER_81_372 vssd1 vssd1 vccd1 vccd1 sky130_fd_sc_hd__fill_2
XFILLER_53_25 vssd1 vssd1 vccd1 vccd1 sky130_fd_sc_hd__fill_1
XTAP_TAPCELL_ROW_52_721 vssd1 vccd1 sky130_fd_sc_hd__tapvpwrvgnd_1
X_6949_ net90 net65 vssd1 vssd1 vccd1 vccd1 _2161_ sky130_fd_sc_hd__nor2_1
XTAP_TAPCELL_ROW_24_445 vssd1 vccd1 sky130_fd_sc_hd__tapvpwrvgnd_1
XFILLER_41_225 vssd1 vssd1 vccd1 vccd1 sky130_fd_sc_hd__fill_4
XFILLER_22_483 vssd1 vssd1 vccd1 vccd1 sky130_fd_sc_hd__fill_1
XFILLER_78_22 vssd1 vssd1 vccd1 vccd1 sky130_fd_sc_hd__fill_1
XFILLER_78_44 vssd1 vssd1 vccd1 vccd1 sky130_fd_sc_hd__fill_4
XANTENNA_fanout97_X net97 vssd1 vssd1 vccd1 vccd1 sky130_fd_sc_hd__diode_2
XFILLER_89_472 vssd1 vssd1 vccd1 vccd1 sky130_fd_sc_hd__fill_4
XFILLER_78_99 vssd1 vssd1 vccd1 vccd1 sky130_fd_sc_hd__fill_1
XFILLER_76_100 vssd1 vssd1 vccd1 vccd1 sky130_fd_sc_hd__fill_2
XANTENNA__5371__A net116 vssd1 vssd1 vccd1 vccd1 sky130_fd_sc_hd__diode_2
XFILLER_76_111 vssd1 vssd1 vccd1 vccd1 sky130_fd_sc_hd__fill_1
XANTENNA__5802__C net237 vssd1 vssd1 vccd1 vccd1 sky130_fd_sc_hd__diode_2
XANTENNA__8455__Q PID_INST.k2_calc.sum_reg\[11\] vssd1 vssd1 vccd1 vccd1 sky130_fd_sc_hd__diode_2
XFILLER_1_398 vssd1 vssd1 vccd1 vccd1 sky130_fd_sc_hd__fill_1
XFILLER_76_199 vssd1 vssd1 vccd1 vccd1 sky130_fd_sc_hd__fill_1
XFILLER_76_177 vssd1 vssd1 vccd1 vccd1 sky130_fd_sc_hd__fill_2
XFILLER_57_391 vssd1 vssd1 vccd1 vccd1 sky130_fd_sc_hd__fill_1
XFILLER_17_222 vssd1 vssd1 vccd1 vccd1 sky130_fd_sc_hd__fill_2
XFILLER_60_523 vssd1 vssd1 vccd1 vccd1 sky130_fd_sc_hd__fill_2
XFILLER_60_501 vssd1 vssd1 vccd1 vccd1 sky130_fd_sc_hd__fill_2
XANTENNA__7448__D net260 vssd1 vssd1 vccd1 vccd1 sky130_fd_sc_hd__diode_2
XFILLER_60_545 vccd1 vssd1 vccd1 vssd1 sky130_ef_sc_hd__decap_40_12
XFILLER_32_258 vccd1 vssd1 vccd1 vssd1 sky130_ef_sc_hd__decap_40_12
XFILLER_9_421 vssd1 vssd1 vccd1 vccd1 sky130_fd_sc_hd__fill_4
XFILLER_9_465 vssd1 vssd1 vccd1 vccd1 sky130_fd_sc_hd__fill_1
XANTENNA__7761__A net294 vssd1 vssd1 vccd1 vccd1 sky130_fd_sc_hd__diode_2
X_4300_ net286 net19 net172 vssd1 vssd1 vccd1 vccd1 _0023_ sky130_fd_sc_hd__mux2_1
X_5280_ _0405_ _0468_ vssd1 vssd1 vccd1 vccd1 _0470_ sky130_fd_sc_hd__xnor2_1
X_4231_ net14 net167 _2474_ vssd1 vssd1 vccd1 vccd1 _2484_ sky130_fd_sc_hd__o21ai_1
XFILLER_4_74 vssd1 vssd1 vccd1 vccd1 sky130_fd_sc_hd__fill_1
XFILLER_55_306 vssd1 vssd1 vccd1 vccd1 sky130_fd_sc_hd__fill_8
XFILLER_82_125 vssd1 vssd1 vccd1 vccd1 sky130_fd_sc_hd__fill_1
X_7921_ _3171_ _3173_ _3174_ vssd1 vssd1 vccd1 vccd1 _3176_ sky130_fd_sc_hd__nand3_1
XFILLER_82_158 vssd1 vssd1 vccd1 vccd1 sky130_fd_sc_hd__fill_8
XTAP_TAPCELL_ROW_66_857 vssd1 vccd1 sky130_fd_sc_hd__tapvpwrvgnd_1
X_7852_ _2869_ _2870_ _2873_ vssd1 vssd1 vccd1 vccd1 _3108_ sky130_fd_sc_hd__o21ai_1
X_7783_ _3031_ _3032_ _3038_ vssd1 vssd1 vccd1 vccd1 _3039_ sky130_fd_sc_hd__nand3_1
X_6803_ _1955_ _4101_ vssd1 vssd1 vccd1 vccd1 _2006_ sky130_fd_sc_hd__or2_1
X_4995_ net138 net145 _0183_ vssd1 vssd1 vccd1 vccd1 _0185_ sky130_fd_sc_hd__a21o_1
XFILLER_23_225 vssd1 vssd1 vccd1 vccd1 sky130_fd_sc_hd__fill_1
X_6734_ _1931_ _1932_ vssd1 vssd1 vccd1 vccd1 _1933_ sky130_fd_sc_hd__nand2_1
XTAP_TAPCELL_ROW_21_415 vssd1 vccd1 sky130_fd_sc_hd__tapvpwrvgnd_1
X_6665_ _1859_ _1858_ vssd1 vssd1 vccd1 vccd1 _1861_ sky130_fd_sc_hd__and2b_1
X_8404_ clknet_4_6_0_clk _0024_ net337 vssd1 vssd1 vccd1 vccd1 PID_INST.k2_calc.reg_lc\[8\]
+ sky130_fd_sc_hd__dfrtp_2
XANTENNA__5456__A PID_INST.k3_calc.d2.y\[2\] vssd1 vssd1 vccd1 vccd1 sky130_fd_sc_hd__diode_2
XANTENNA_fanout311_A net316 vssd1 vssd1 vccd1 vccd1 sky130_fd_sc_hd__diode_2
X_5616_ net269 net265 net247 net250 vssd1 vssd1 vccd1 vccd1 _0806_ sky130_fd_sc_hd__and4_1
X_6596_ net116 net47 vssd1 vssd1 vccd1 vccd1 _1786_ sky130_fd_sc_hd__nor2_1
X_8335_ _3555_ _3611_ vssd1 vssd1 vccd1 vccd1 _3613_ sky130_fd_sc_hd__xnor2_1
X_5547_ _0734_ _0735_ vssd1 vssd1 vccd1 vccd1 _0737_ sky130_fd_sc_hd__nor2_1
XANTENNA__5175__B net85 vssd1 vssd1 vccd1 vccd1 sky130_fd_sc_hd__diode_2
XANTENNA__8103__A2 net189 vssd1 vssd1 vccd1 vccd1 sky130_fd_sc_hd__diode_2
X_8266_ _3455_ _3538_ vssd1 vssd1 vccd1 vccd1 _3539_ sky130_fd_sc_hd__nor2_1
X_5478_ _0666_ _0667_ vssd1 vssd1 vccd1 vccd1 _0668_ sky130_fd_sc_hd__nand2_1
XFILLER_2_107 vssd1 vssd1 vccd1 vccd1 sky130_fd_sc_hd__fill_2
XFILLER_2_118 vssd1 vssd1 vccd1 vccd1 sky130_fd_sc_hd__fill_1
X_4429_ _3708_ _3709_ vssd1 vssd1 vccd1 vccd1 _0057_ sky130_fd_sc_hd__and2_1
X_7217_ _2436_ _2443_ vssd1 vssd1 vccd1 vccd1 _2445_ sky130_fd_sc_hd__nor2_1
X_8197_ _3463_ vssd1 vssd1 vccd1 vccd1 _3464_ sky130_fd_sc_hd__inv_2
X_7148_ _2348_ _2349_ _2370_ vssd1 vssd1 vccd1 vccd1 _2371_ sky130_fd_sc_hd__nor3_1
XFILLER_86_431 vssd1 vssd1 vccd1 vccd1 sky130_fd_sc_hd__fill_1
X_7079_ _2295_ _2296_ _2297_ vssd1 vssd1 vccd1 vccd1 _2299_ sky130_fd_sc_hd__a21oi_1
XFILLER_86_497 vccd1 vssd1 vccd1 vssd1 sky130_ef_sc_hd__decap_40_12
XFILLER_46_317 vssd1 vssd1 vccd1 vccd1 sky130_fd_sc_hd__fill_2
XFILLER_39_380 vccd1 vssd1 vccd1 vssd1 sky130_ef_sc_hd__decap_40_12
XFILLER_27_531 vssd1 vssd1 vccd1 vccd1 sky130_fd_sc_hd__fill_2
XFILLER_42_512 vssd1 vssd1 vccd1 vccd1 sky130_fd_sc_hd__fill_2
XFILLER_14_236 vssd1 vssd1 vccd1 vccd1 sky130_fd_sc_hd__fill_1
XTAP_TAPCELL_ROW_37_570 vssd1 vccd1 sky130_fd_sc_hd__tapvpwrvgnd_1
XANTENNA__4822__X _4100_ vssd1 vssd1 vccd1 vccd1 sky130_fd_sc_hd__diode_2
Xfanout40 _1393_ vssd1 vssd1 vccd1 vccd1 net40 sky130_fd_sc_hd__clkbuf_4
Xfanout51 _0303_ vssd1 vssd1 vccd1 vccd1 net51 sky130_fd_sc_hd__clkbuf_4
Xfanout62 _4089_ vssd1 vssd1 vccd1 vccd1 net62 sky130_fd_sc_hd__clkbuf_2
Xfanout73 net74 vssd1 vssd1 vccd1 vccd1 net73 sky130_fd_sc_hd__clkbuf_2
XFILLER_80_67 vssd1 vssd1 vccd1 vccd1 sky130_fd_sc_hd__fill_2
Xfanout84 net85 vssd1 vssd1 vccd1 vccd1 net84 sky130_fd_sc_hd__clkbuf_4
Xfanout95 _2675_ vssd1 vssd1 vccd1 vccd1 net95 sky130_fd_sc_hd__clkbuf_4
XFILLER_6_435 vssd1 vssd1 vccd1 vccd1 sky130_fd_sc_hd__fill_8
XFILLER_6_413 vssd1 vssd1 vccd1 vccd1 sky130_fd_sc_hd__fill_1
XFILLER_89_43 vssd1 vssd1 vccd1 vccd1 sky130_fd_sc_hd__fill_4
XANTENNA__5516__D net280 vssd1 vssd1 vccd1 vccd1 sky130_fd_sc_hd__diode_2
XFILLER_89_76 vssd1 vssd1 vccd1 vccd1 sky130_fd_sc_hd__fill_1
XANTENNA__7581__A net101 vssd1 vssd1 vccd1 vccd1 sky130_fd_sc_hd__diode_2
XANTENNA__8365__RESET_B net327 vssd1 vssd1 vccd1 vccd1 sky130_fd_sc_hd__diode_2
XANTENNA__5813__B net289 vssd1 vssd1 vccd1 vccd1 sky130_fd_sc_hd__diode_2
XANTENNA__4667__B2 net121 vssd1 vssd1 vccd1 vccd1 sky130_fd_sc_hd__diode_2
XFILLER_77_431 vssd1 vssd1 vccd1 vccd1 sky130_fd_sc_hd__fill_8
XTAP_TAPCELL_ROW_9_295 vssd1 vccd1 sky130_fd_sc_hd__tapvpwrvgnd_1
XFILLER_29_8 vssd1 vssd1 vccd1 vccd1 sky130_fd_sc_hd__fill_4
XFILLER_77_442 vssd1 vssd1 vccd1 vccd1 sky130_fd_sc_hd__fill_1
XFILLER_49_188 vssd1 vssd1 vccd1 vccd1 sky130_fd_sc_hd__fill_8
XFILLER_92_489 vccd1 vssd1 vccd1 vssd1 sky130_ef_sc_hd__decap_40_12
XTAP_TAPCELL_ROW_63_827 vssd1 vccd1 sky130_fd_sc_hd__tapvpwrvgnd_1
XFILLER_52_309 vssd1 vssd1 vccd1 vccd1 sky130_fd_sc_hd__fill_2
XANTENNA__7756__A net305 vssd1 vssd1 vccd1 vccd1 sky130_fd_sc_hd__diode_2
X_4780_ net133 net146 _4057_ vssd1 vssd1 vccd1 vccd1 _4058_ sky130_fd_sc_hd__and3_1
X_6450_ _1636_ _1637_ vssd1 vssd1 vccd1 vccd1 _1638_ sky130_fd_sc_hd__xnor2_1
XFILLER_9_262 vssd1 vssd1 vccd1 vccd1 sky130_fd_sc_hd__fill_1
Xclkload10 clknet_4_11_0_clk vssd1 vssd1 vccd1 vccd1 clkload10/Y sky130_fd_sc_hd__clkinv_8
X_5401_ PID_INST.k3_calc.d2.y\[1\] _0222_ _0225_ vssd1 vssd1 vccd1 vccd1 _0591_ sky130_fd_sc_hd__and3_1
X_6381_ _1371_ _1374_ _1567_ vssd1 vssd1 vccd1 vccd1 _1569_ sky130_fd_sc_hd__or3_1
X_8120_ _3355_ _3356_ _3379_ _3380_ vssd1 vssd1 vccd1 vccd1 _3381_ sky130_fd_sc_hd__nand4_2
X_5332_ _0453_ _0521_ vssd1 vssd1 vccd1 vccd1 _0522_ sky130_fd_sc_hd__xnor2_1
X_8051_ _3304_ _3305_ vssd1 vssd1 vccd1 vccd1 _3306_ sky130_fd_sc_hd__xnor2_1
XANTENNA__4658__B2 net121 vssd1 vssd1 vccd1 vccd1 sky130_fd_sc_hd__diode_2
XANTENNA__4658__A1 net123 vssd1 vssd1 vccd1 vccd1 sky130_fd_sc_hd__diode_2
X_5263_ _2146_ _0088_ vssd1 vssd1 vccd1 vccd1 _0453_ sky130_fd_sc_hd__nor2_1
X_5194_ _0383_ vssd1 vssd1 vccd1 vccd1 _0384_ sky130_fd_sc_hd__inv_2
X_7002_ _2116_ _2216_ vssd1 vssd1 vccd1 vccd1 _2218_ sky130_fd_sc_hd__xnor2_1
X_4214_ PID_INST.k3_calc.timescaling_term\[5\] net169 vssd1 vssd1 vccd1 vccd1 _2305_
+ sky130_fd_sc_hd__or2_1
XFILLER_68_442 vssd1 vssd1 vccd1 vccd1 sky130_fd_sc_hd__fill_1
XANTENNA__6835__A PID_INST.k3_calc.d2.y\[2\] vssd1 vssd1 vccd1 vccd1 sky130_fd_sc_hd__diode_2
XFILLER_83_401 vssd1 vssd1 vccd1 vccd1 sky130_fd_sc_hd__fill_2
XTAP_TAPCELL_ROW_79_993 vssd1 vccd1 sky130_fd_sc_hd__tapvpwrvgnd_1
XFILLER_70_106 vssd1 vssd1 vccd1 vccd1 sky130_fd_sc_hd__fill_4
XANTENNA_fanout261_A net262 vssd1 vssd1 vccd1 vccd1 sky130_fd_sc_hd__diode_2
X_7904_ _3153_ _3158_ vssd1 vssd1 vccd1 vccd1 _3159_ sky130_fd_sc_hd__xnor2_1
XFILLER_36_361 vssd1 vssd1 vccd1 vccd1 sky130_fd_sc_hd__fill_2
X_7835_ _3090_ vssd1 vssd1 vccd1 vccd1 _3091_ sky130_fd_sc_hd__inv_2
XFILLER_24_523 vssd1 vssd1 vccd1 vccd1 sky130_fd_sc_hd__fill_8
XFILLER_34_27 vssd1 vssd1 vccd1 vccd1 sky130_fd_sc_hd__fill_1
XFILLER_34_38 vssd1 vssd1 vccd1 vccd1 sky130_fd_sc_hd__fill_2
XTAP_TAPCELL_ROW_34_540 vssd1 vccd1 sky130_fd_sc_hd__tapvpwrvgnd_1
X_7766_ _3013_ _3021_ vssd1 vssd1 vccd1 vccd1 _3022_ sky130_fd_sc_hd__xnor2_1
X_4978_ _0151_ _0167_ vssd1 vssd1 vccd1 vccd1 _0168_ sky130_fd_sc_hd__xnor2_1
XANTENNA_fanout147_X net147 vssd1 vssd1 vccd1 vccd1 sky130_fd_sc_hd__diode_2
X_7697_ _2944_ _2945_ _2952_ vssd1 vssd1 vccd1 vccd1 _2953_ sky130_fd_sc_hd__and3_1
X_6717_ _1907_ _1913_ vssd1 vssd1 vccd1 vccd1 _1915_ sky130_fd_sc_hd__or2_1
Xclkload4 clknet_4_4_0_clk vssd1 vssd1 vccd1 vccd1 clkload4/Y sky130_fd_sc_hd__bufinv_16
X_6648_ _1827_ _1828_ _1841_ vssd1 vssd1 vccd1 vccd1 _1842_ sky130_fd_sc_hd__nand3_1
XANTENNA_fanout314_X net314 vssd1 vssd1 vccd1 vccd1 sky130_fd_sc_hd__diode_2
X_8318_ _3488_ _3490_ vssd1 vssd1 vccd1 vccd1 _3594_ sky130_fd_sc_hd__nand2b_1
X_6579_ _1295_ _1492_ _1493_ _1494_ vssd1 vssd1 vccd1 vccd1 _1767_ sky130_fd_sc_hd__a22oi_1
X_8249_ _3518_ _3519_ vssd1 vssd1 vccd1 vccd1 _3520_ sky130_fd_sc_hd__nor2_1
XFILLER_59_46 vssd1 vssd1 vccd1 vccd1 sky130_fd_sc_hd__fill_1
Xfanout241 PID_INST.k2_calc.sum_reg\[2\] vssd1 vssd1 vccd1 vccd1 net241 sky130_fd_sc_hd__buf_2
Xfanout230 PID_INST.k2_calc.sum_reg\[5\] vssd1 vssd1 vccd1 vccd1 net230 sky130_fd_sc_hd__buf_2
Xfanout274 net275 vssd1 vssd1 vccd1 vccd1 net274 sky130_fd_sc_hd__buf_1
Xfanout263 net264 vssd1 vssd1 vccd1 vccd1 net263 sky130_fd_sc_hd__clkbuf_2
Xfanout252 net255 vssd1 vssd1 vccd1 vccd1 net252 sky130_fd_sc_hd__buf_2
XANTENNA__4817__X _4095_ vssd1 vssd1 vccd1 vccd1 sky130_fd_sc_hd__diode_2
XTAP_TAPCELL_ROW_6_265 vssd1 vccd1 sky130_fd_sc_hd__tapvpwrvgnd_1
XFILLER_86_261 vssd1 vssd1 vccd1 vccd1 sky130_fd_sc_hd__fill_1
XFILLER_75_45 vssd1 vssd1 vccd1 vccd1 sky130_fd_sc_hd__fill_8
XFILLER_74_423 vssd1 vssd1 vccd1 vccd1 sky130_fd_sc_hd__fill_1
Xfanout296 net297 vssd1 vssd1 vccd1 vccd1 net296 sky130_fd_sc_hd__clkbuf_4
Xfanout285 PID_INST.k2_calc.reg_lc\[8\] vssd1 vssd1 vccd1 vccd1 net285 sky130_fd_sc_hd__buf_2
XFILLER_46_103 vssd1 vssd1 vccd1 vccd1 sky130_fd_sc_hd__fill_1
XFILLER_74_445 vssd1 vssd1 vccd1 vccd1 sky130_fd_sc_hd__fill_8
XFILLER_46_125 vssd1 vssd1 vccd1 vccd1 sky130_fd_sc_hd__fill_4
XANTENNA__8382__D PID_INST.k3_calc.d2.y\[2\] vssd1 vssd1 vccd1 vccd1 sky130_fd_sc_hd__diode_2
XFILLER_91_33 vssd1 vssd1 vccd1 vccd1 sky130_fd_sc_hd__fill_1
XFILLER_30_515 vssd1 vssd1 vccd1 vccd1 sky130_fd_sc_hd__fill_1
XFILLER_24_93 vccd1 vssd1 vccd1 vssd1 sky130_ef_sc_hd__decap_40_12
XFILLER_30_548 vssd1 vssd1 vccd1 vccd1 sky130_fd_sc_hd__fill_2
XFILLER_10_272 vssd1 vssd1 vccd1 vccd1 sky130_fd_sc_hd__fill_8
XTAP_TAPCELL_ROW_40_598 vssd1 vccd1 sky130_fd_sc_hd__tapvpwrvgnd_1
XFILLER_40_81 vssd1 vssd1 vccd1 vccd1 sky130_fd_sc_hd__fill_1
XANTENNA__6655__A net227 vssd1 vssd1 vccd1 vccd1 sky130_fd_sc_hd__diode_2
XFILLER_1_64 vssd1 vssd1 vccd1 vccd1 sky130_fd_sc_hd__fill_1
XFILLER_92_253 vccd1 vssd1 vccd1 vssd1 sky130_ef_sc_hd__decap_40_12
XTAP_TAPCELL_ROW_76_963 vssd1 vccd1 sky130_fd_sc_hd__tapvpwrvgnd_1
XTAP_TAPCELL_ROW_48_676 vssd1 vccd1 sky130_fd_sc_hd__tapvpwrvgnd_1
XFILLER_18_361 vssd1 vssd1 vccd1 vccd1 sky130_fd_sc_hd__fill_2
XFILLER_37_169 vssd1 vssd1 vccd1 vccd1 sky130_fd_sc_hd__fill_4
X_5950_ _1139_ vssd1 vssd1 vccd1 vccd1 _1140_ sky130_fd_sc_hd__inv_2
XANTENNA__4175__A net140 vssd1 vssd1 vccd1 vccd1 sky130_fd_sc_hd__diode_2
XFILLER_80_437 vssd1 vssd1 vccd1 vccd1 sky130_fd_sc_hd__fill_1
X_4901_ net123 _4033_ _4034_ vssd1 vssd1 vccd1 vccd1 _0091_ sky130_fd_sc_hd__and3_1
X_5881_ _1038_ _1056_ _1066_ _1070_ vssd1 vssd1 vccd1 vccd1 _1071_ sky130_fd_sc_hd__a31o_1
XFILLER_33_353 vssd1 vssd1 vccd1 vccd1 sky130_fd_sc_hd__fill_2
X_7620_ _2783_ _2794_ _2796_ vssd1 vssd1 vccd1 vccd1 _2872_ sky130_fd_sc_hd__a21boi_1
XFILLER_60_150 vssd1 vssd1 vccd1 vccd1 sky130_fd_sc_hd__fill_1
X_4832_ _4102_ _4108_ vssd1 vssd1 vccd1 vccd1 _4110_ sky130_fd_sc_hd__xnor2_1
XTAP_TAPCELL_ROW_31_510 vssd1 vccd1 sky130_fd_sc_hd__tapvpwrvgnd_1
XANTENNA__5718__B net306 vssd1 vssd1 vccd1 vccd1 sky130_fd_sc_hd__diode_2
X_4763_ _3801_ _3982_ _3985_ vssd1 vssd1 vccd1 vccd1 _4041_ sky130_fd_sc_hd__o21a_1
XANTENNA__4576__B1 net78 vssd1 vssd1 vccd1 vccd1 sky130_fd_sc_hd__diode_2
XFILLER_21_548 vssd1 vssd1 vccd1 vccd1 sky130_fd_sc_hd__fill_4
X_7551_ _2528_ _2544_ _2527_ vssd1 vssd1 vccd1 vccd1 _2799_ sky130_fd_sc_hd__a21oi_1
X_7482_ _2723_ _2724_ vssd1 vssd1 vccd1 vccd1 _2725_ sky130_fd_sc_hd__xnor2_1
X_4694_ _3970_ _3971_ vssd1 vssd1 vccd1 vccd1 _3972_ sky130_fd_sc_hd__nand2_1
X_6502_ _1584_ _1591_ _1590_ vssd1 vssd1 vccd1 vccd1 _1689_ sky130_fd_sc_hd__a21bo_1
X_6433_ _1417_ _1423_ _1619_ vssd1 vssd1 vccd1 vccd1 _1621_ sky130_fd_sc_hd__nand3_1
XANTENNA__6868__A2 net50 vssd1 vssd1 vccd1 vccd1 sky130_fd_sc_hd__diode_2
XFILLER_20_29 vssd1 vssd1 vccd1 vccd1 sky130_fd_sc_hd__fill_1
X_6364_ _1354_ _1550_ vssd1 vssd1 vccd1 vccd1 _1552_ sky130_fd_sc_hd__xnor2_1
XANTENNA_fanout107_A net108 vssd1 vssd1 vccd1 vccd1 sky130_fd_sc_hd__diode_2
X_8103_ net276 net189 net187 net281 vssd1 vssd1 vccd1 vccd1 _3362_ sky130_fd_sc_hd__a22o_1
X_6295_ _1482_ _1483_ vssd1 vssd1 vccd1 vccd1 _1484_ sky130_fd_sc_hd__nor2_1
XANTENNA__5453__B net65 vssd1 vssd1 vccd1 vccd1 sky130_fd_sc_hd__diode_2
X_5315_ _0503_ _0504_ vssd1 vssd1 vccd1 vccd1 _0505_ sky130_fd_sc_hd__xnor2_1
XANTENNA__5828__B1 net237 vssd1 vssd1 vccd1 vccd1 sky130_fd_sc_hd__diode_2
X_8034_ _3286_ _3287_ vssd1 vssd1 vccd1 vccd1 _3288_ sky130_fd_sc_hd__nand2_1
X_5246_ _2083_ _0435_ net76 vssd1 vssd1 vccd1 vccd1 _0436_ sky130_fd_sc_hd__or3b_1
XPHY_EDGE_ROW_89_Right_89 vssd1 vssd1 vccd1 vccd1 sky130_fd_sc_hd__decap_3
Xhold27 net33 vssd1 vssd1 vccd1 vccd1 net420 sky130_fd_sc_hd__dlygate4sd3_1
Xhold16 PID_INST.k1_calc.d1.x\[13\] vssd1 vssd1 vccd1 vccd1 net409 sky130_fd_sc_hd__dlygate4sd3_1
XFILLER_56_412 vssd1 vssd1 vccd1 vccd1 sky130_fd_sc_hd__fill_4
XTAP_TAPCELL_ROW_3_235 vssd1 vccd1 sky130_fd_sc_hd__tapvpwrvgnd_1
X_5177_ net138 net87 net85 net137 vssd1 vssd1 vccd1 vccd1 _0367_ sky130_fd_sc_hd__a22o_1
XFILLER_56_445 vssd1 vssd1 vccd1 vccd1 sky130_fd_sc_hd__fill_1
XFILLER_16_309 vssd1 vssd1 vccd1 vccd1 sky130_fd_sc_hd__fill_1
XFILLER_71_459 vssd1 vssd1 vccd1 vccd1 sky130_fd_sc_hd__fill_4
XFILLER_36_191 vssd1 vssd1 vccd1 vccd1 sky130_fd_sc_hd__fill_4
XANTENNA__7753__B1 net260 vssd1 vssd1 vccd1 vccd1 sky130_fd_sc_hd__diode_2
X_7818_ net110 net40 _2842_ _2841_ vssd1 vssd1 vccd1 vccd1 _3074_ sky130_fd_sc_hd__o31ai_2
X_7749_ _3003_ _3004_ vssd1 vssd1 vccd1 vccd1 _3005_ sky130_fd_sc_hd__nand2_1
XFILLER_3_202 vssd1 vssd1 vccd1 vccd1 sky130_fd_sc_hd__fill_4
XFILLER_86_66 vssd1 vssd1 vccd1 vccd1 sky130_fd_sc_hd__fill_1
XFILLER_47_423 vssd1 vssd1 vccd1 vccd1 sky130_fd_sc_hd__fill_2
XFILLER_86_99 vssd1 vssd1 vccd1 vccd1 sky130_fd_sc_hd__fill_2
XFILLER_62_404 vssd1 vssd1 vccd1 vccd1 sky130_fd_sc_hd__fill_2
XFILLER_19_169 vssd1 vssd1 vccd1 vccd1 sky130_fd_sc_hd__fill_4
XTAP_TAPCELL_ROW_73_933 vssd1 vccd1 sky130_fd_sc_hd__tapvpwrvgnd_1
XFILLER_62_448 vssd1 vssd1 vccd1 vccd1 sky130_fd_sc_hd__fill_1
XFILLER_34_117 vssd1 vssd1 vccd1 vccd1 sky130_fd_sc_hd__fill_1
XFILLER_34_128 vssd1 vssd1 vccd1 vccd1 sky130_fd_sc_hd__fill_1
XFILLER_34_139 vssd1 vssd1 vccd1 vccd1 sky130_fd_sc_hd__fill_1
XTAP_TAPCELL_ROW_45_646 vssd1 vccd1 sky130_fd_sc_hd__tapvpwrvgnd_1
XFILLER_42_194 vssd1 vssd1 vccd1 vccd1 sky130_fd_sc_hd__fill_2
XANTENNA__8380__RESET_B net328 vssd1 vssd1 vccd1 vccd1 sky130_fd_sc_hd__diode_2
X_6080_ _0786_ _0791_ _0794_ vssd1 vssd1 vccd1 vccd1 _1270_ sky130_fd_sc_hd__nor3_1
X_5100_ _0288_ _0289_ vssd1 vssd1 vccd1 vccd1 _0290_ sky130_fd_sc_hd__nand2_1
XFILLER_32_3 vssd1 vssd1 vccd1 vccd1 sky130_fd_sc_hd__fill_1
X_5031_ _0217_ _0218_ vssd1 vssd1 vccd1 vccd1 _0221_ sky130_fd_sc_hd__xnor2_2
XFILLER_85_518 vssd1 vssd1 vccd1 vccd1 sky130_fd_sc_hd__fill_2
XANTENNA__4617__B net147 vssd1 vssd1 vccd1 vccd1 sky130_fd_sc_hd__diode_2
XTAP_TAPCELL_ROW_0_205 vssd1 vccd1 sky130_fd_sc_hd__tapvpwrvgnd_1
XFILLER_38_467 vssd1 vssd1 vccd1 vccd1 sky130_fd_sc_hd__fill_8
XFILLER_38_489 vssd1 vssd1 vccd1 vccd1 sky130_fd_sc_hd__fill_2
XFILLER_80_234 vssd1 vssd1 vccd1 vccd1 sky130_fd_sc_hd__fill_1
XFILLER_53_426 vssd1 vssd1 vccd1 vccd1 sky130_fd_sc_hd__fill_2
X_6982_ _1771_ _2073_ _2075_ vssd1 vssd1 vccd1 vccd1 _2196_ sky130_fd_sc_hd__a21bo_1
X_5933_ _0077_ _0305_ _0076_ vssd1 vssd1 vccd1 vccd1 _1123_ sky130_fd_sc_hd__a21bo_1
XFILLER_18_180 vssd1 vssd1 vccd1 vccd1 sky130_fd_sc_hd__fill_1
X_5864_ _1041_ _1043_ vssd1 vssd1 vccd1 vccd1 _1054_ sky130_fd_sc_hd__nor2_1
XANTENNA__4352__B net3 vssd1 vssd1 vccd1 vccd1 sky130_fd_sc_hd__diode_2
X_4815_ _4091_ _4092_ vssd1 vssd1 vccd1 vccd1 _4093_ sky130_fd_sc_hd__nand2_1
X_7603_ _2767_ _2774_ _2776_ vssd1 vssd1 vccd1 vccd1 _2854_ sky130_fd_sc_hd__a21bo_1
X_5795_ _0943_ _0984_ vssd1 vssd1 vccd1 vccd1 _0985_ sky130_fd_sc_hd__nor2_1
X_7534_ _2778_ _2779_ vssd1 vssd1 vccd1 vccd1 _2781_ sky130_fd_sc_hd__xor2_1
XANTENNA_fanout224_A net225 vssd1 vssd1 vccd1 vccd1 sky130_fd_sc_hd__diode_2
X_4746_ net97 net65 vssd1 vssd1 vccd1 vccd1 _4024_ sky130_fd_sc_hd__nor2_1
X_7465_ _2687_ _2705_ vssd1 vssd1 vccd1 vccd1 _2708_ sky130_fd_sc_hd__xnor2_1
X_4677_ _3935_ _3953_ _3954_ vssd1 vssd1 vccd1 vccd1 _3955_ sky130_fd_sc_hd__o21a_1
X_7396_ _2379_ _2381_ _2377_ vssd1 vssd1 vccd1 vccd1 _2635_ sky130_fd_sc_hd__o21ba_1
X_6416_ net269 net265 net235 net240 vssd1 vssd1 vccd1 vccd1 _1604_ sky130_fd_sc_hd__and4_1
X_6347_ net149 net74 vssd1 vssd1 vccd1 vccd1 _1535_ sky130_fd_sc_hd__nor2_1
Xoutput28 net28 vssd1 vssd1 vccd1 vccd1 gpio_out[25] sky130_fd_sc_hd__buf_2
XFILLER_88_367 vssd1 vssd1 vccd1 vccd1 sky130_fd_sc_hd__fill_1
XFILLER_88_356 vssd1 vssd1 vccd1 vccd1 sky130_fd_sc_hd__fill_2
XFILLER_76_507 vssd1 vssd1 vccd1 vccd1 sky130_fd_sc_hd__fill_4
X_6278_ _1258_ _1261_ _1465_ vssd1 vssd1 vccd1 vccd1 _1467_ sky130_fd_sc_hd__and3_1
XFILLER_88_378 vssd1 vssd1 vccd1 vccd1 sky130_fd_sc_hd__fill_4
XFILLER_76_518 vccd1 vssd1 vccd1 vssd1 sky130_ef_sc_hd__decap_40_12
X_8017_ _3266_ _3269_ vssd1 vssd1 vccd1 vccd1 _3271_ sky130_fd_sc_hd__xnor2_1
X_5229_ net136 net83 _0417_ vssd1 vssd1 vccd1 vccd1 _0419_ sky130_fd_sc_hd__a21oi_1
XFILLER_84_562 vssd1 vssd1 vccd1 vccd1 sky130_fd_sc_hd__fill_8
XFILLER_56_253 vssd1 vssd1 vccd1 vccd1 sky130_fd_sc_hd__fill_1
XFILLER_29_489 vssd1 vssd1 vccd1 vccd1 sky130_fd_sc_hd__fill_1
XFILLER_16_106 vssd1 vssd1 vccd1 vccd1 sky130_fd_sc_hd__fill_1
XFILLER_16_139 vssd1 vssd1 vccd1 vccd1 sky130_fd_sc_hd__fill_1
XTAP_TAPCELL_ROW_70_903 vssd1 vccd1 sky130_fd_sc_hd__tapvpwrvgnd_1
XFILLER_24_172 vssd1 vssd1 vccd1 vccd1 sky130_fd_sc_hd__fill_1
XTAP_TAPCELL_ROW_42_616 vssd1 vccd1 sky130_fd_sc_hd__tapvpwrvgnd_1
XFILLER_8_338 vssd1 vssd1 vccd1 vccd1 sky130_fd_sc_hd__fill_4
XFILLER_4_500 vssd1 vssd1 vccd1 vccd1 sky130_fd_sc_hd__fill_2
XFILLER_4_533 vccd1 vssd1 vccd1 vssd1 sky130_ef_sc_hd__decap_40_12
XFILLER_79_323 vssd1 vssd1 vccd1 vccd1 sky130_fd_sc_hd__fill_2
XFILLER_67_529 vssd1 vssd1 vccd1 vccd1 sky130_fd_sc_hd__fill_2
XTAP_TAPCELL_ROW_58_782 vssd1 vccd1 sky130_fd_sc_hd__tapvpwrvgnd_1
XFILLER_47_286 vssd1 vssd1 vccd1 vccd1 sky130_fd_sc_hd__fill_2
XFILLER_90_565 vssd1 vssd1 vccd1 vccd1 sky130_fd_sc_hd__fill_2
XANTENNA__6026__A2_N net199 vssd1 vssd1 vccd1 vccd1 sky130_fd_sc_hd__diode_2
XFILLER_62_289 vccd1 vssd1 vccd1 vssd1 sky130_ef_sc_hd__decap_40_12
XFILLER_30_120 vssd1 vssd1 vccd1 vccd1 sky130_fd_sc_hd__fill_1
X_4600_ _3855_ _3860_ _3869_ _3876_ vssd1 vssd1 vccd1 vccd1 _3878_ sky130_fd_sc_hd__o211ai_1
X_5580_ _0767_ _0768_ net291 net231 vssd1 vssd1 vccd1 vccd1 _0770_ sky130_fd_sc_hd__and4b_1
X_4531_ net128 net151 vssd1 vssd1 vccd1 vccd1 _3809_ sky130_fd_sc_hd__nand2_1
XANTENNA__4900__B net70 vssd1 vssd1 vccd1 vccd1 sky130_fd_sc_hd__diode_2
X_4462_ PID_INST.k1_calc.d1.x\[7\] PID_INST.k3_calc.prev_error\[7\] vssd1 vssd1 vccd1
+ vccd1 _3740_ sky130_fd_sc_hd__or2_1
X_7250_ _2311_ _2312_ _2310_ vssd1 vssd1 vccd1 vccd1 _2480_ sky130_fd_sc_hd__a21o_1
XFILLER_7_393 vssd1 vssd1 vccd1 vccd1 sky130_fd_sc_hd__fill_2
XFILLER_89_109 vssd1 vssd1 vccd1 vccd1 sky130_fd_sc_hd__fill_2
X_6201_ _1388_ _1389_ vssd1 vssd1 vccd1 vccd1 _1390_ sky130_fd_sc_hd__and2b_1
X_4393_ net194 net9 vssd1 vssd1 vccd1 vccd1 _3685_ sky130_fd_sc_hd__or2_1
X_7181_ net115 _1583_ vssd1 vssd1 vccd1 vccd1 _2406_ sky130_fd_sc_hd__nor2_1
X_6132_ net112 net47 vssd1 vssd1 vccd1 vccd1 _1321_ sky130_fd_sc_hd__nor2_1
XTAP_TAPCELL_ROW_90_1099 vssd1 vccd1 sky130_fd_sc_hd__tapvpwrvgnd_1
X_6063_ _1252_ _1251_ vssd1 vssd1 vccd1 vccd1 _1253_ sky130_fd_sc_hd__and2b_1
XANTENNA__4628__A net120 vssd1 vssd1 vccd1 vccd1 sky130_fd_sc_hd__diode_2
X_5014_ _0196_ _0202_ vssd1 vssd1 vccd1 vccd1 _0204_ sky130_fd_sc_hd__xor2_1
XFILLER_81_521 vccd1 vssd1 vccd1 vssd1 sky130_ef_sc_hd__decap_40_12
XFILLER_38_275 vssd1 vssd1 vccd1 vccd1 sky130_fd_sc_hd__fill_1
XFILLER_81_554 vssd1 vssd1 vccd1 vccd1 sky130_fd_sc_hd__fill_1
X_6965_ _2176_ _2177_ vssd1 vssd1 vccd1 vccd1 _2179_ sky130_fd_sc_hd__or2_1
X_5916_ _1104_ _1105_ vssd1 vssd1 vccd1 vccd1 _1106_ sky130_fd_sc_hd__nand2_1
XFILLER_13_109 vssd1 vssd1 vccd1 vccd1 sky130_fd_sc_hd__fill_2
XANTENNA_fanout341_A PID_INST.add_three.n_rst vssd1 vssd1 vccd1 vccd1 sky130_fd_sc_hd__diode_2
XFILLER_34_470 vssd1 vssd1 vccd1 vccd1 sky130_fd_sc_hd__fill_4
XANTENNA__5178__B net80 vssd1 vssd1 vccd1 vccd1 sky130_fd_sc_hd__diode_2
X_6896_ _2105_ vssd1 vssd1 vccd1 vccd1 _2106_ sky130_fd_sc_hd__inv_2
X_5847_ _1034_ _1036_ vssd1 vssd1 vccd1 vccd1 _1037_ sky130_fd_sc_hd__nand2_1
XANTENNA_fanout227_X net227 vssd1 vssd1 vccd1 vccd1 sky130_fd_sc_hd__diode_2
X_5778_ _0963_ _0966_ _0967_ vssd1 vssd1 vccd1 vccd1 _0968_ sky130_fd_sc_hd__nor3_1
XFILLER_21_164 vssd1 vssd1 vccd1 vccd1 sky130_fd_sc_hd__fill_4
X_4729_ _3990_ _4006_ vssd1 vssd1 vccd1 vccd1 _4007_ sky130_fd_sc_hd__and2_1
X_7517_ _2499_ _2500_ _2506_ vssd1 vssd1 vccd1 vccd1 _2763_ sky130_fd_sc_hd__o21ba_1
X_7448_ net206 net221 net275 net260 vssd1 vssd1 vccd1 vccd1 _2689_ sky130_fd_sc_hd__and4_1
X_7379_ _2593_ _2594_ _2616_ vssd1 vssd1 vccd1 vccd1 _2617_ sky130_fd_sc_hd__nor3_1
XFILLER_1_503 vssd1 vssd1 vccd1 vccd1 sky130_fd_sc_hd__fill_1
XFILLER_76_304 vssd1 vssd1 vccd1 vccd1 sky130_fd_sc_hd__fill_4
XANTENNA__5641__B net210 vssd1 vssd1 vccd1 vccd1 sky130_fd_sc_hd__diode_2
XFILLER_49_507 vssd1 vssd1 vccd1 vccd1 sky130_fd_sc_hd__fill_1
XFILLER_76_359 vssd1 vssd1 vccd1 vccd1 sky130_fd_sc_hd__fill_4
XFILLER_67_79 vssd1 vssd1 vccd1 vccd1 sky130_fd_sc_hd__fill_1
XFILLER_84_381 vssd1 vssd1 vccd1 vccd1 sky130_fd_sc_hd__fill_1
XFILLER_83_78 vssd1 vssd1 vccd1 vccd1 sky130_fd_sc_hd__fill_1
XFILLER_72_554 vssd1 vssd1 vccd1 vccd1 sky130_fd_sc_hd__fill_2
XTAP_TAPCELL_ROW_55_752 vssd1 vccd1 sky130_fd_sc_hd__tapvpwrvgnd_1
XANTENNA_fanout42_X net42 vssd1 vssd1 vccd1 vccd1 sky130_fd_sc_hd__diode_2
XFILLER_32_407 vccd1 vssd1 vccd1 vssd1 sky130_ef_sc_hd__decap_40_12
XFILLER_16_83 vssd1 vssd1 vccd1 vccd1 sky130_fd_sc_hd__fill_1
XANTENNA__5088__B net83 vssd1 vssd1 vccd1 vccd1 sky130_fd_sc_hd__diode_2
XFILLER_40_440 vssd1 vssd1 vccd1 vccd1 sky130_fd_sc_hd__fill_2
XFILLER_12_186 vssd1 vssd1 vccd1 vccd1 sky130_fd_sc_hd__fill_1
XFILLER_66_9 vssd1 vssd1 vccd1 vccd1 sky130_fd_sc_hd__fill_1
XFILLER_4_330 vssd1 vssd1 vccd1 vccd1 sky130_fd_sc_hd__fill_1
XFILLER_4_363 vssd1 vssd1 vccd1 vccd1 sky130_fd_sc_hd__fill_1
XFILLER_67_315 vssd1 vssd1 vccd1 vccd1 sky130_fd_sc_hd__fill_1
XFILLER_79_197 vssd1 vssd1 vccd1 vccd1 sky130_fd_sc_hd__fill_1
XANTENNA__4167__B _1784_ vssd1 vssd1 vccd1 vccd1 sky130_fd_sc_hd__diode_2
XFILLER_63_510 vssd1 vssd1 vccd1 vccd1 sky130_fd_sc_hd__fill_1
XFILLER_90_384 vssd1 vssd1 vccd1 vccd1 sky130_fd_sc_hd__fill_1
X_6750_ _1947_ _1948_ vssd1 vssd1 vccd1 vccd1 _1950_ sky130_fd_sc_hd__xnor2_1
X_5701_ net243 net290 _0695_ _0697_ vssd1 vssd1 vccd1 vccd1 _0891_ sky130_fd_sc_hd__o2bb2a_1
XFILLER_16_481 vssd1 vssd1 vccd1 vccd1 sky130_fd_sc_hd__fill_2
XFILLER_16_492 vssd1 vssd1 vccd1 vccd1 sky130_fd_sc_hd__fill_1
X_6681_ _1654_ _1657_ _1876_ vssd1 vssd1 vccd1 vccd1 _1878_ sky130_fd_sc_hd__and3_1
XFILLER_31_451 vccd1 vssd1 vccd1 vssd1 sky130_ef_sc_hd__decap_40_12
X_5632_ _0804_ _0821_ vssd1 vssd1 vccd1 vccd1 _0822_ sky130_fd_sc_hd__nor2_1
XANTENNA__5177__B1 net85 vssd1 vssd1 vccd1 vccd1 sky130_fd_sc_hd__diode_2
X_8420_ clknet_4_2_0_clk net132 net326 vssd1 vssd1 vccd1 vccd1 PID_INST.k3_calc.kd_term\[8\]
+ sky130_fd_sc_hd__dfrtp_1
X_5563_ _0750_ _0751_ vssd1 vssd1 vccd1 vccd1 _0753_ sky130_fd_sc_hd__xnor2_1
X_8351_ _3627_ _3628_ vssd1 vssd1 vccd1 vccd1 _3629_ sky130_fd_sc_hd__nand2_1
X_4514_ _3779_ _3791_ vssd1 vssd1 vccd1 vccd1 _3792_ sky130_fd_sc_hd__or2_1
X_7302_ _2405_ _2532_ vssd1 vssd1 vccd1 vccd1 _2534_ sky130_fd_sc_hd__xnor2_1
XTAP_TAPCELL_ROW_92_1117 vssd1 vccd1 sky130_fd_sc_hd__tapvpwrvgnd_1
X_8282_ _3464_ _3524_ _3522_ vssd1 vssd1 vccd1 vccd1 _3555_ sky130_fd_sc_hd__o21a_1
X_5494_ _0625_ _0641_ vssd1 vssd1 vccd1 vccd1 _0684_ sky130_fd_sc_hd__nand2_1
XTAP_TAPCELL_ROW_92_1128 vssd1 vccd1 sky130_fd_sc_hd__tapvpwrvgnd_1
X_7233_ _2448_ _2460_ vssd1 vssd1 vccd1 vccd1 _2462_ sky130_fd_sc_hd__xnor2_1
X_4445_ PID_INST.k1_calc.d1.x\[1\] PID_INST.k3_calc.prev_error\[1\] vssd1 vssd1 vccd1
+ vccd1 _3723_ sky130_fd_sc_hd__xor2_1
X_7164_ _2289_ _2292_ _2387_ vssd1 vssd1 vccd1 vccd1 _2388_ sky130_fd_sc_hd__o21ba_1
X_4376_ _3669_ _3670_ _3668_ vssd1 vssd1 vccd1 vccd1 _3671_ sky130_fd_sc_hd__o21ai_1
XFILLER_58_315 vssd1 vssd1 vccd1 vccd1 sky130_fd_sc_hd__fill_1
X_6115_ net109 net56 vssd1 vssd1 vccd1 vccd1 _1304_ sky130_fd_sc_hd__nor2_1
XANTENNA_fanout291_A net292 vssd1 vssd1 vccd1 vccd1 sky130_fd_sc_hd__diode_2
X_7095_ net266 net222 net221 net271 vssd1 vssd1 vccd1 vccd1 _2316_ sky130_fd_sc_hd__a22oi_1
XFILLER_58_337 vssd1 vssd1 vccd1 vccd1 sky130_fd_sc_hd__fill_1
XFILLER_85_145 vssd1 vssd1 vccd1 vccd1 sky130_fd_sc_hd__fill_1
XTAP_TAPCELL_ROW_69_888 vssd1 vccd1 sky130_fd_sc_hd__tapvpwrvgnd_1
X_6046_ _1227_ _1235_ vssd1 vssd1 vccd1 vccd1 _1236_ sky130_fd_sc_hd__and2_1
XFILLER_54_521 vssd1 vssd1 vccd1 vccd1 sky130_fd_sc_hd__fill_1
XANTENNA__8483__RESET_B net341 vssd1 vssd1 vccd1 vccd1 sky130_fd_sc_hd__diode_2
XANTENNA__6573__A net101 vssd1 vssd1 vccd1 vccd1 sky130_fd_sc_hd__diode_2
XANTENNA__7388__B net288 vssd1 vssd1 vccd1 vccd1 sky130_fd_sc_hd__diode_2
XANTENNA__8412__RESET_B net328 vssd1 vssd1 vccd1 vccd1 sky130_fd_sc_hd__diode_2
X_7997_ _3251_ _3250_ vssd1 vssd1 vccd1 vccd1 _3252_ sky130_fd_sc_hd__and2b_1
XFILLER_26_289 vssd1 vssd1 vccd1 vccd1 sky130_fd_sc_hd__fill_2
XFILLER_81_384 vssd1 vssd1 vccd1 vccd1 sky130_fd_sc_hd__fill_8
XTAP_TAPCELL_ROW_52_722 vssd1 vccd1 sky130_fd_sc_hd__tapvpwrvgnd_1
X_6948_ net90 net63 vssd1 vssd1 vccd1 vccd1 _2160_ sky130_fd_sc_hd__nor2_1
XANTENNA__4524__C _3734_ vssd1 vssd1 vccd1 vccd1 sky130_fd_sc_hd__diode_2
XANTENNA__5955__A2 net71 vssd1 vssd1 vccd1 vccd1 sky130_fd_sc_hd__diode_2
X_6879_ _2084_ _2087_ vssd1 vssd1 vccd1 vccd1 _2088_ sky130_fd_sc_hd__xor2_1
XANTENNA__5917__A net109 vssd1 vssd1 vccd1 vccd1 sky130_fd_sc_hd__diode_2
XANTENNA__4540__B net84 vssd1 vssd1 vccd1 vccd1 sky130_fd_sc_hd__diode_2
XANTENNA__8012__B net44 vssd1 vssd1 vccd1 vccd1 sky130_fd_sc_hd__diode_2
XANTENNA__8432__CLK clknet_4_1_0_clk vssd1 vssd1 vccd1 vccd1 sky130_fd_sc_hd__diode_2
XFILLER_78_89 vssd1 vssd1 vccd1 vccd1 sky130_fd_sc_hd__fill_4
XANTENNA__5891__B2 net305 vssd1 vssd1 vccd1 vccd1 sky130_fd_sc_hd__diode_2
XFILLER_49_315 vccd1 vssd1 vccd1 vssd1 sky130_ef_sc_hd__decap_40_12
XFILLER_76_123 vssd1 vssd1 vccd1 vccd1 sky130_fd_sc_hd__fill_1
XANTENNA__5802__D net308 vssd1 vssd1 vccd1 vccd1 sky130_fd_sc_hd__diode_2
XFILLER_49_337 vssd1 vssd1 vccd1 vccd1 sky130_fd_sc_hd__fill_8
XANTENNA__7632__A2 net205 vssd1 vssd1 vccd1 vccd1 sky130_fd_sc_hd__diode_2
XFILLER_45_510 vccd1 vssd1 vccd1 vssd1 sky130_ef_sc_hd__decap_40_12
XFILLER_17_201 vssd1 vssd1 vccd1 vccd1 sky130_fd_sc_hd__fill_1
XFILLER_91_159 vssd1 vssd1 vccd1 vccd1 sky130_fd_sc_hd__fill_2
XFILLER_72_373 vssd1 vssd1 vccd1 vccd1 sky130_fd_sc_hd__fill_4
XFILLER_72_384 vssd1 vssd1 vccd1 vccd1 sky130_fd_sc_hd__fill_1
XFILLER_60_557 vssd1 vssd1 vccd1 vccd1 sky130_fd_sc_hd__fill_4
XFILLER_32_237 vssd1 vssd1 vccd1 vccd1 sky130_fd_sc_hd__fill_2
XANTENNA__5946__A2 net80 vssd1 vssd1 vccd1 vccd1 sky130_fd_sc_hd__diode_2
XFILLER_13_473 vccd1 vssd1 vccd1 vssd1 sky130_ef_sc_hd__decap_40_12
XANTENNA__5159__B1 net77 vssd1 vssd1 vccd1 vccd1 sky130_fd_sc_hd__diode_2
XFILLER_71_7 vssd1 vssd1 vccd1 vccd1 sky130_fd_sc_hd__fill_2
XANTENNA__5546__B net273 vssd1 vssd1 vccd1 vccd1 sky130_fd_sc_hd__diode_2
XFILLER_4_160 vssd1 vssd1 vccd1 vccd1 sky130_fd_sc_hd__fill_2
XFILLER_4_193 vssd1 vssd1 vccd1 vccd1 sky130_fd_sc_hd__fill_2
X_4230_ PID_INST.k3_calc.timescaling_term\[2\] net169 vssd1 vssd1 vccd1 vccd1 _2474_
+ sky130_fd_sc_hd__or2_1
X_7920_ _3173_ _3174_ _3171_ vssd1 vssd1 vccd1 vccd1 _3175_ sky130_fd_sc_hd__a21o_1
XFILLER_36_521 vssd1 vssd1 vccd1 vccd1 sky130_fd_sc_hd__fill_2
XTAP_TAPCELL_ROW_89_1090 vssd1 vccd1 sky130_fd_sc_hd__tapvpwrvgnd_1
XTAP_TAPCELL_ROW_66_858 vssd1 vccd1 sky130_fd_sc_hd__tapvpwrvgnd_1
X_7851_ _3105_ _3106_ vssd1 vssd1 vccd1 vccd1 _3107_ sky130_fd_sc_hd__xnor2_1
X_6802_ _1705_ _2004_ vssd1 vssd1 vccd1 vccd1 _2005_ sky130_fd_sc_hd__xnor2_1
X_7782_ _3036_ _3037_ vssd1 vssd1 vccd1 vccd1 _3038_ sky130_fd_sc_hd__xnor2_1
X_4994_ net138 net145 _0183_ vssd1 vssd1 vccd1 vccd1 _0184_ sky130_fd_sc_hd__nand3_1
X_6733_ _1917_ _1918_ _1930_ vssd1 vssd1 vccd1 vccd1 _1932_ sky130_fd_sc_hd__a21o_1
X_6664_ _1646_ _1648_ _1645_ vssd1 vssd1 vccd1 vccd1 _1859_ sky130_fd_sc_hd__o21ba_1
X_5615_ net318 net207 vssd1 vssd1 vccd1 vccd1 _0805_ sky130_fd_sc_hd__nand2_1
X_8403_ clknet_4_13_0_clk _0023_ net335 vssd1 vssd1 vccd1 vccd1 PID_INST.k2_calc.reg_lc\[7\]
+ sky130_fd_sc_hd__dfrtp_1
XANTENNA__5456__B net65 vssd1 vssd1 vccd1 vccd1 sky130_fd_sc_hd__diode_2
XFILLER_31_281 vssd1 vssd1 vccd1 vccd1 sky130_fd_sc_hd__fill_4
X_6595_ net119 net47 vssd1 vssd1 vccd1 vccd1 _1785_ sky130_fd_sc_hd__nor2_1
X_8334_ _3607_ _3610_ vssd1 vssd1 vccd1 vccd1 _3611_ sky130_fd_sc_hd__xnor2_1
X_5546_ net246 net273 vssd1 vssd1 vccd1 vccd1 _0736_ sky130_fd_sc_hd__nand2_1
X_8265_ _3536_ vssd1 vssd1 vccd1 vccd1 _3538_ sky130_fd_sc_hd__inv_2
X_5477_ _0634_ _0665_ vssd1 vssd1 vccd1 vccd1 _0667_ sky130_fd_sc_hd__or2_1
X_4428_ net178 _3707_ vssd1 vssd1 vccd1 vccd1 _3709_ sky130_fd_sc_hd__nand2_1
X_7216_ _2436_ _2443_ vssd1 vssd1 vccd1 vccd1 _2444_ sky130_fd_sc_hd__and2_1
X_8196_ _3460_ _3462_ vssd1 vssd1 vccd1 vccd1 _3463_ sky130_fd_sc_hd__xnor2_1
X_7147_ _2350_ _2368_ vssd1 vssd1 vccd1 vccd1 _2370_ sky130_fd_sc_hd__xnor2_1
XANTENNA__5622__D net207 vssd1 vssd1 vccd1 vccd1 sky130_fd_sc_hd__diode_2
X_4359_ net161 _3654_ _3655_ _3656_ vssd1 vssd1 vccd1 vccd1 _0040_ sky130_fd_sc_hd__a31o_1
XFILLER_58_123 vssd1 vssd1 vccd1 vccd1 sky130_fd_sc_hd__fill_1
XANTENNA_fanout294_X net294 vssd1 vssd1 vccd1 vccd1 sky130_fd_sc_hd__diode_2
X_7078_ _2295_ _2296_ _2297_ vssd1 vssd1 vccd1 vccd1 _2298_ sky130_fd_sc_hd__and3_1
XFILLER_46_307 vssd1 vssd1 vccd1 vccd1 sky130_fd_sc_hd__fill_1
XFILLER_86_487 vssd1 vssd1 vccd1 vccd1 sky130_fd_sc_hd__fill_4
X_6029_ _1217_ _1218_ vssd1 vssd1 vccd1 vccd1 _1219_ sky130_fd_sc_hd__nand2_1
XFILLER_46_329 vssd1 vssd1 vccd1 vccd1 sky130_fd_sc_hd__fill_2
XFILLER_27_521 vssd1 vssd1 vccd1 vccd1 sky130_fd_sc_hd__fill_2
XFILLER_27_543 vssd1 vssd1 vccd1 vccd1 sky130_fd_sc_hd__fill_4
XFILLER_54_395 vssd1 vssd1 vccd1 vccd1 sky130_fd_sc_hd__fill_1
XFILLER_54_384 vssd1 vssd1 vccd1 vccd1 sky130_fd_sc_hd__fill_1
XTAP_TAPCELL_ROW_37_571 vssd1 vccd1 sky130_fd_sc_hd__tapvpwrvgnd_1
Xfanout74 _3998_ vssd1 vssd1 vccd1 vccd1 net74 sky130_fd_sc_hd__buf_2
Xfanout63 _4020_ vssd1 vssd1 vccd1 vccd1 net63 sky130_fd_sc_hd__clkbuf_4
Xfanout52 _0303_ vssd1 vssd1 vccd1 vccd1 net52 sky130_fd_sc_hd__buf_2
Xfanout41 _1393_ vssd1 vssd1 vccd1 vccd1 net41 sky130_fd_sc_hd__buf_1
XFILLER_10_432 vssd1 vssd1 vccd1 vccd1 sky130_fd_sc_hd__fill_2
Xfanout96 _2675_ vssd1 vssd1 vccd1 vccd1 net96 sky130_fd_sc_hd__dlymetal6s2s_1
Xfanout85 _3799_ vssd1 vssd1 vccd1 vccd1 net85 sky130_fd_sc_hd__buf_2
XFILLER_89_22 vssd1 vssd1 vccd1 vccd1 sky130_fd_sc_hd__fill_2
XFILLER_13_95 vssd1 vssd1 vccd1 vccd1 sky130_fd_sc_hd__fill_2
XFILLER_89_66 vssd1 vssd1 vccd1 vccd1 sky130_fd_sc_hd__fill_2
XFILLER_89_88 vssd1 vssd1 vccd1 vccd1 sky130_fd_sc_hd__fill_1
XFILLER_89_281 vssd1 vssd1 vccd1 vccd1 sky130_fd_sc_hd__fill_1
XFILLER_77_421 vssd1 vssd1 vccd1 vccd1 sky130_fd_sc_hd__fill_4
XFILLER_49_156 vccd1 vssd1 vccd1 vssd1 sky130_ef_sc_hd__decap_40_12
XFILLER_92_446 vssd1 vssd1 vccd1 vccd1 sky130_fd_sc_hd__fill_2
XTAP_TAPCELL_ROW_63_828 vssd1 vccd1 sky130_fd_sc_hd__tapvpwrvgnd_1
XFILLER_45_384 vssd1 vssd1 vccd1 vccd1 sky130_fd_sc_hd__fill_8
XANTENNA__7756__B net182 vssd1 vssd1 vccd1 vccd1 sky130_fd_sc_hd__diode_2
XFILLER_9_252 vssd1 vssd1 vccd1 vccd1 sky130_fd_sc_hd__fill_8
XFILLER_13_292 vssd1 vssd1 vccd1 vccd1 sky130_fd_sc_hd__fill_1
XANTENNA__4180__B net175 vssd1 vssd1 vccd1 vccd1 sky130_fd_sc_hd__diode_2
Xclkload11 clknet_4_12_0_clk vssd1 vssd1 vccd1 vccd1 clkload11/Y sky130_fd_sc_hd__inv_6
X_5400_ _0584_ _0589_ vssd1 vssd1 vccd1 vccd1 _0590_ sky130_fd_sc_hd__xnor2_1
X_6380_ _1371_ _1374_ _1567_ vssd1 vssd1 vccd1 vccd1 _1568_ sky130_fd_sc_hd__o21ai_1
X_5331_ _2114_ net70 vssd1 vssd1 vccd1 vccd1 _0521_ sky130_fd_sc_hd__nor2_1
X_8050_ _3151_ _3161_ _3149_ vssd1 vssd1 vccd1 vccd1 _3305_ sky130_fd_sc_hd__a21oi_1
X_5262_ _0347_ _0352_ _0354_ vssd1 vssd1 vccd1 vccd1 _0452_ sky130_fd_sc_hd__a21bo_1
X_7001_ _2116_ _2216_ vssd1 vssd1 vccd1 vccd1 _2217_ sky130_fd_sc_hd__nand2_1
X_4213_ net9 PID_INST.k3_calc.kd_term\[14\] net173 vssd1 vssd1 vccd1 vccd1 PID_INST.k3_calc.d1.y\[14\]
+ sky130_fd_sc_hd__mux2_1
X_5193_ _0275_ _0284_ _0381_ _0382_ vssd1 vssd1 vccd1 vccd1 _0383_ sky130_fd_sc_hd__o211ai_2
XTAP_TAPCELL_ROW_79_994 vssd1 vccd1 sky130_fd_sc_hd__tapvpwrvgnd_1
XFILLER_18_29 vssd1 vssd1 vccd1 vccd1 sky130_fd_sc_hd__fill_2
X_7903_ _3156_ _3157_ vssd1 vssd1 vccd1 vccd1 _3158_ sky130_fd_sc_hd__xnor2_1
XANTENNA_fanout254_A net255 vssd1 vssd1 vccd1 vccd1 sky130_fd_sc_hd__diode_2
X_7834_ _2838_ _2844_ _2847_ vssd1 vssd1 vccd1 vccd1 _3090_ sky130_fd_sc_hd__a21bo_1
X_7765_ _3018_ _3019_ vssd1 vssd1 vccd1 vccd1 _3021_ sky130_fd_sc_hd__xnor2_1
XANTENNA__6032__A1 net203 vssd1 vssd1 vccd1 vccd1 sky130_fd_sc_hd__diode_2
XTAP_TAPCELL_ROW_34_541 vssd1 vccd1 sky130_fd_sc_hd__tapvpwrvgnd_1
X_6716_ _1907_ _1913_ vssd1 vssd1 vccd1 vccd1 _1914_ sky130_fd_sc_hd__nand2_1
XANTENNA__8309__B1 net252 vssd1 vssd1 vccd1 vccd1 sky130_fd_sc_hd__diode_2
XFILLER_11_229 vssd1 vssd1 vccd1 vccd1 sky130_fd_sc_hd__fill_1
X_4977_ _0158_ _0166_ vssd1 vssd1 vccd1 vccd1 _0167_ sky130_fd_sc_hd__xor2_1
X_7696_ _2949_ _2951_ vssd1 vssd1 vccd1 vccd1 _2952_ sky130_fd_sc_hd__xnor2_1
Xclkload5 clknet_4_5_0_clk vssd1 vssd1 vccd1 vccd1 clkload5/Y sky130_fd_sc_hd__inv_6
XANTENNA__5186__B net78 vssd1 vssd1 vccd1 vccd1 sky130_fd_sc_hd__diode_2
X_6647_ _1839_ _1840_ vssd1 vssd1 vccd1 vccd1 _1841_ sky130_fd_sc_hd__and2_1
XANTENNA__8086__A1_N net293 vssd1 vssd1 vccd1 vccd1 sky130_fd_sc_hd__diode_2
X_6578_ _1764_ _1765_ vssd1 vssd1 vccd1 vccd1 _1766_ sky130_fd_sc_hd__xor2_1
X_8317_ _3582_ _3592_ vssd1 vssd1 vccd1 vccd1 _3593_ sky130_fd_sc_hd__xnor2_1
X_5529_ _0700_ _0718_ vssd1 vssd1 vccd1 vccd1 _0719_ sky130_fd_sc_hd__nor2_1
X_8248_ _3335_ _3351_ _3517_ vssd1 vssd1 vccd1 vccd1 _3519_ sky130_fd_sc_hd__and3_1
Xfanout220 net221 vssd1 vssd1 vccd1 vccd1 net220 sky130_fd_sc_hd__buf_2
XFILLER_59_421 vssd1 vssd1 vccd1 vccd1 sky130_fd_sc_hd__fill_4
Xfanout231 net232 vssd1 vssd1 vccd1 vccd1 net231 sky130_fd_sc_hd__buf_2
X_8179_ _3442_ _3443_ vssd1 vssd1 vccd1 vccd1 _3444_ sky130_fd_sc_hd__nor2_1
Xfanout253 net255 vssd1 vssd1 vccd1 vccd1 net253 sky130_fd_sc_hd__buf_1
Xfanout264 PID_INST.k2_calc.reg_lc\[12\] vssd1 vssd1 vccd1 vccd1 net264 sky130_fd_sc_hd__clkbuf_2
Xfanout242 PID_INST.k2_calc.sum_reg\[2\] vssd1 vssd1 vccd1 vccd1 net242 sky130_fd_sc_hd__dlymetal6s2s_1
XFILLER_74_402 vssd1 vssd1 vccd1 vccd1 sky130_fd_sc_hd__fill_2
Xfanout275 PID_INST.k2_calc.reg_lc\[10\] vssd1 vssd1 vccd1 vccd1 net275 sky130_fd_sc_hd__buf_2
Xfanout297 PID_INST.k2_calc.reg_lc\[5\] vssd1 vssd1 vccd1 vccd1 net297 sky130_fd_sc_hd__buf_2
Xfanout286 net289 vssd1 vssd1 vccd1 vccd1 net286 sky130_fd_sc_hd__clkbuf_4
XFILLER_19_318 vssd1 vssd1 vccd1 vccd1 sky130_fd_sc_hd__fill_1
XFILLER_75_57 vssd1 vssd1 vccd1 vccd1 sky130_fd_sc_hd__fill_8
XFILLER_74_468 vssd1 vssd1 vccd1 vccd1 sky130_fd_sc_hd__fill_2
XANTENNA__4282__A0 net17 vssd1 vssd1 vccd1 vccd1 sky130_fd_sc_hd__diode_2
XFILLER_15_524 vccd1 vssd1 vccd1 vssd1 sky130_ef_sc_hd__decap_40_12
XFILLER_42_321 vssd1 vssd1 vccd1 vccd1 sky130_fd_sc_hd__fill_1
XFILLER_15_546 vssd1 vssd1 vccd1 vccd1 sky130_fd_sc_hd__fill_1
XFILLER_30_505 vssd1 vssd1 vccd1 vccd1 sky130_fd_sc_hd__fill_2
XFILLER_24_61 vssd1 vssd1 vccd1 vccd1 sky130_fd_sc_hd__fill_2
XFILLER_10_251 vssd1 vssd1 vccd1 vccd1 sky130_fd_sc_hd__fill_1
XTAP_TAPCELL_ROW_40_599 vssd1 vccd1 sky130_fd_sc_hd__tapvpwrvgnd_1
XFILLER_69_229 vssd1 vssd1 vccd1 vccd1 sky130_fd_sc_hd__fill_1
XANTENNA__6936__A net104 vssd1 vssd1 vccd1 vccd1 sky130_fd_sc_hd__diode_2
XFILLER_77_240 vssd1 vssd1 vccd1 vccd1 sky130_fd_sc_hd__fill_2
XANTENNA__6655__B net239 vssd1 vssd1 vccd1 vccd1 sky130_fd_sc_hd__diode_2
XFILLER_77_262 vssd1 vssd1 vccd1 vccd1 sky130_fd_sc_hd__fill_2
XFILLER_92_221 vssd1 vssd1 vccd1 vccd1 sky130_fd_sc_hd__fill_2
XFILLER_92_265 vccd1 vssd1 vccd1 vssd1 sky130_ef_sc_hd__decap_40_12
XTAP_TAPCELL_ROW_76_964 vssd1 vccd1 sky130_fd_sc_hd__tapvpwrvgnd_1
XTAP_TAPCELL_ROW_48_677 vssd1 vccd1 sky130_fd_sc_hd__tapvpwrvgnd_1
XTAP_TAPCELL_ROW_86_1060 vssd1 vccd1 sky130_fd_sc_hd__tapvpwrvgnd_1
X_5880_ _1021_ _1067_ _1069_ vssd1 vssd1 vccd1 vccd1 _1070_ sky130_fd_sc_hd__and3_1
X_4900_ net147 net70 vssd1 vssd1 vccd1 vccd1 _0090_ sky130_fd_sc_hd__nor2_1
X_4831_ _1817_ net70 _4108_ vssd1 vssd1 vccd1 vccd1 _4109_ sky130_fd_sc_hd__or3_1
XANTENNA__5287__A net107 vssd1 vssd1 vccd1 vccd1 sky130_fd_sc_hd__diode_2
XFILLER_60_195 vssd1 vssd1 vccd1 vccd1 sky130_fd_sc_hd__fill_1
XFILLER_60_184 vssd1 vssd1 vccd1 vccd1 sky130_fd_sc_hd__fill_1
X_4762_ _4036_ _4039_ vssd1 vssd1 vccd1 vccd1 _4040_ sky130_fd_sc_hd__xnor2_1
XANTENNA__4191__A _2051_ vssd1 vssd1 vccd1 vccd1 sky130_fd_sc_hd__diode_2
XTAP_TAPCELL_ROW_31_511 vssd1 vccd1 sky130_fd_sc_hd__tapvpwrvgnd_1
X_7550_ _2781_ _2797_ vssd1 vssd1 vccd1 vccd1 _2798_ sky130_fd_sc_hd__xnor2_1
X_7481_ _2620_ _2629_ vssd1 vssd1 vccd1 vccd1 _2724_ sky130_fd_sc_hd__nand2_1
X_4693_ net132 net143 _3968_ _3969_ vssd1 vssd1 vccd1 vccd1 _3971_ sky130_fd_sc_hd__a22o_1
X_6501_ _1525_ _1592_ _1594_ vssd1 vssd1 vccd1 vccd1 _1688_ sky130_fd_sc_hd__a21bo_1
X_6432_ _1417_ _1423_ _1619_ vssd1 vssd1 vccd1 vccd1 _1620_ sky130_fd_sc_hd__a21o_1
XANTENNA__4328__A1 net237 vssd1 vssd1 vccd1 vccd1 sky130_fd_sc_hd__diode_2
X_8102_ _3359_ _3360_ vssd1 vssd1 vccd1 vccd1 _3361_ sky130_fd_sc_hd__xnor2_1
X_6363_ _1354_ _1550_ vssd1 vssd1 vccd1 vccd1 _1551_ sky130_fd_sc_hd__nand2_1
X_6294_ _1282_ _1286_ _1481_ vssd1 vssd1 vccd1 vccd1 _1483_ sky130_fd_sc_hd__and3_1
X_5314_ _0424_ _0428_ _0423_ vssd1 vssd1 vccd1 vccd1 _0504_ sky130_fd_sc_hd__a21boi_1
XANTENNA__5828__B2 net308 vssd1 vssd1 vccd1 vccd1 sky130_fd_sc_hd__diode_2
X_8033_ _3281_ _3285_ vssd1 vssd1 vccd1 vccd1 _3287_ sky130_fd_sc_hd__or2_1
X_5245_ _2051_ net74 vssd1 vssd1 vccd1 vccd1 _0435_ sky130_fd_sc_hd__or2_2
Xhold28 PID_INST.k2_calc.sum_reg\[27\] vssd1 vssd1 vccd1 vccd1 net421 sky130_fd_sc_hd__dlygate4sd3_1
Xhold17 net25 vssd1 vssd1 vccd1 vccd1 net410 sky130_fd_sc_hd__dlygate4sd3_1
XFILLER_68_251 vssd1 vssd1 vccd1 vccd1 sky130_fd_sc_hd__fill_1
XFILLER_56_402 vssd1 vssd1 vccd1 vccd1 sky130_fd_sc_hd__fill_4
X_5176_ _1923_ net149 _3734_ net85 vssd1 vssd1 vccd1 vccd1 _0366_ sky130_fd_sc_hd__or4b_1
XFILLER_83_221 vssd1 vssd1 vccd1 vccd1 sky130_fd_sc_hd__fill_2
XFILLER_28_137 vssd1 vssd1 vccd1 vccd1 sky130_fd_sc_hd__fill_2
XFILLER_56_479 vssd1 vssd1 vccd1 vccd1 sky130_fd_sc_hd__fill_2
XFILLER_71_449 vssd1 vssd1 vccd1 vccd1 sky130_fd_sc_hd__fill_4
XFILLER_45_49 vssd1 vssd1 vccd1 vccd1 sky130_fd_sc_hd__fill_1
XFILLER_43_118 vssd1 vssd1 vccd1 vccd1 sky130_fd_sc_hd__fill_1
XTAP_TAPCELL_ROW_19_390 vssd1 vccd1 sky130_fd_sc_hd__tapvpwrvgnd_1
XFILLER_24_354 vssd1 vssd1 vccd1 vccd1 sky130_fd_sc_hd__fill_2
XANTENNA__7753__B2 net213 vssd1 vssd1 vccd1 vccd1 sky130_fd_sc_hd__diode_2
XANTENNA__7753__A1 net198 vssd1 vssd1 vccd1 vccd1 sky130_fd_sc_hd__diode_2
XFILLER_51_173 vssd1 vssd1 vccd1 vccd1 sky130_fd_sc_hd__fill_1
XFILLER_12_516 vssd1 vssd1 vccd1 vccd1 sky130_fd_sc_hd__fill_8
X_7817_ _3070_ _3071_ vssd1 vssd1 vccd1 vccd1 _3073_ sky130_fd_sc_hd__xor2_1
X_7748_ _2990_ _2991_ _3002_ vssd1 vssd1 vccd1 vccd1 _3004_ sky130_fd_sc_hd__a21o_1
X_7679_ _2930_ _2931_ vssd1 vssd1 vccd1 vccd1 _2933_ sky130_fd_sc_hd__xnor2_1
XFILLER_3_225 vssd1 vssd1 vccd1 vccd1 sky130_fd_sc_hd__fill_1
XFILLER_79_505 vssd1 vssd1 vccd1 vccd1 sky130_fd_sc_hd__fill_8
XFILLER_10_96 vssd1 vssd1 vccd1 vccd1 sky130_fd_sc_hd__fill_2
XFILLER_86_45 vssd1 vssd1 vccd1 vccd1 sky130_fd_sc_hd__fill_4
XANTENNA__4276__A net12 vssd1 vssd1 vccd1 vccd1 sky130_fd_sc_hd__diode_2
XFILLER_19_61 vssd1 vssd1 vccd1 vccd1 sky130_fd_sc_hd__fill_2
XTAP_TAPCELL_ROW_73_934 vssd1 vccd1 sky130_fd_sc_hd__tapvpwrvgnd_1
XFILLER_34_107 vssd1 vssd1 vccd1 vccd1 sky130_fd_sc_hd__fill_8
XTAP_TAPCELL_ROW_45_647 vssd1 vccd1 sky130_fd_sc_hd__tapvpwrvgnd_1
XFILLER_15_321 vssd1 vssd1 vccd1 vccd1 sky130_fd_sc_hd__fill_4
XFILLER_35_82 vssd1 vssd1 vccd1 vccd1 sky130_fd_sc_hd__fill_2
XFILLER_35_93 vssd1 vssd1 vccd1 vccd1 sky130_fd_sc_hd__fill_1
XFILLER_30_335 vssd1 vssd1 vccd1 vccd1 sky130_fd_sc_hd__fill_4
XANTENNA__5835__A net251 vssd1 vssd1 vccd1 vccd1 sky130_fd_sc_hd__diode_2
XFILLER_51_70 vssd1 vssd1 vccd1 vccd1 sky130_fd_sc_hd__fill_2
XPHY_EDGE_ROW_29_Left_122 vssd1 vssd1 vccd1 vccd1 sky130_fd_sc_hd__decap_3
X_5030_ _0219_ vssd1 vssd1 vccd1 vccd1 _0220_ sky130_fd_sc_hd__inv_2
XFILLER_65_221 vssd1 vssd1 vccd1 vccd1 sky130_fd_sc_hd__fill_2
XANTENNA__4617__C _3734_ vssd1 vssd1 vccd1 vccd1 sky130_fd_sc_hd__diode_2
X_6981_ _1786_ _2085_ _2087_ _2084_ vssd1 vssd1 vccd1 vccd1 _2195_ sky130_fd_sc_hd__a22o_1
X_5932_ _1116_ _1121_ vssd1 vssd1 vccd1 vccd1 _1122_ sky130_fd_sc_hd__xnor2_1
XFILLER_53_449 vccd1 vssd1 vccd1 vssd1 sky130_ef_sc_hd__decap_40_12
XFILLER_15_19 vssd1 vssd1 vccd1 vccd1 sky130_fd_sc_hd__fill_1
XANTENNA__8105__B net276 vssd1 vssd1 vccd1 vccd1 sky130_fd_sc_hd__diode_2
X_5863_ _1047_ _1048_ vssd1 vssd1 vccd1 vccd1 _1053_ sky130_fd_sc_hd__or2_1
XPHY_EDGE_ROW_38_Left_131 vssd1 vssd1 vccd1 vccd1 sky130_fd_sc_hd__decap_3
X_5794_ net251 net290 _0940_ _0942_ vssd1 vssd1 vccd1 vccd1 _0984_ sky130_fd_sc_hd__o2bb2a_1
X_4814_ _4026_ _4090_ vssd1 vssd1 vccd1 vccd1 _4092_ sky130_fd_sc_hd__or2_1
XTAP_TAPCELL_ROW_16_360 vssd1 vccd1 sky130_fd_sc_hd__tapvpwrvgnd_1
X_7602_ _2789_ _2790_ _2791_ _2793_ vssd1 vssd1 vccd1 vccd1 _2853_ sky130_fd_sc_hd__a2bb2o_1
X_4745_ net109 net64 vssd1 vssd1 vccd1 vccd1 _4023_ sky130_fd_sc_hd__or2_1
X_7533_ _2778_ _2779_ vssd1 vssd1 vccd1 vccd1 _2780_ sky130_fd_sc_hd__nor2_1
XANTENNA__4828__A1_N net123 vssd1 vssd1 vccd1 vccd1 sky130_fd_sc_hd__diode_2
X_7464_ _2687_ _2705_ vssd1 vssd1 vccd1 vccd1 _2706_ sky130_fd_sc_hd__or2_1
X_4676_ _3926_ _3927_ vssd1 vssd1 vccd1 vccd1 _3954_ sky130_fd_sc_hd__xor2_1
X_7395_ _2631_ _2632_ vssd1 vssd1 vccd1 vccd1 _2634_ sky130_fd_sc_hd__xnor2_1
X_6415_ _1489_ _1602_ vssd1 vssd1 vccd1 vccd1 _1603_ sky130_fd_sc_hd__xor2_1
X_6346_ _1532_ _1533_ vssd1 vssd1 vccd1 vccd1 _1534_ sky130_fd_sc_hd__nand2_1
XPHY_EDGE_ROW_47_Left_140 vssd1 vssd1 vccd1 vccd1 sky130_fd_sc_hd__decap_3
Xoutput29 net29 vssd1 vssd1 vccd1 vccd1 gpio_out[26] sky130_fd_sc_hd__buf_2
X_6277_ _1258_ _1261_ _1465_ vssd1 vssd1 vccd1 vccd1 _1466_ sky130_fd_sc_hd__a21oi_1
XANTENNA__5480__A net103 vssd1 vssd1 vccd1 vccd1 sky130_fd_sc_hd__diode_2
X_8016_ _3266_ _3269_ vssd1 vssd1 vccd1 vccd1 _3270_ sky130_fd_sc_hd__nor2_1
X_5228_ net136 net83 _0417_ vssd1 vssd1 vccd1 vccd1 _0418_ sky130_fd_sc_hd__and3_1
X_5159_ _2114_ net74 net77 net131 vssd1 vssd1 vccd1 vccd1 _0349_ sky130_fd_sc_hd__a2bb2o_1
XFILLER_44_405 vssd1 vssd1 vccd1 vccd1 sky130_fd_sc_hd__fill_1
XFILLER_44_416 vssd1 vssd1 vccd1 vccd1 sky130_fd_sc_hd__fill_4
XFILLER_16_118 vssd1 vssd1 vccd1 vccd1 sky130_fd_sc_hd__fill_1
XFILLER_71_246 vssd1 vssd1 vccd1 vccd1 sky130_fd_sc_hd__fill_1
XTAP_TAPCELL_ROW_70_904 vssd1 vccd1 sky130_fd_sc_hd__tapvpwrvgnd_1
XFILLER_72_47 vssd1 vssd1 vccd1 vccd1 sky130_fd_sc_hd__fill_1
XFILLER_71_279 vssd1 vssd1 vccd1 vccd1 sky130_fd_sc_hd__fill_1
XANTENNA__7726__A1 net214 vssd1 vssd1 vccd1 vccd1 sky130_fd_sc_hd__diode_2
XTAP_TAPCELL_ROW_42_617 vssd1 vccd1 sky130_fd_sc_hd__tapvpwrvgnd_1
XFILLER_12_313 vssd1 vssd1 vccd1 vccd1 sky130_fd_sc_hd__fill_1
XFILLER_8_306 vssd1 vssd1 vccd1 vccd1 sky130_fd_sc_hd__fill_2
XANTENNA__4960__A1 net142 vssd1 vssd1 vccd1 vccd1 sky130_fd_sc_hd__diode_2
XFILLER_21_40 vssd1 vssd1 vccd1 vccd1 sky130_fd_sc_hd__fill_4
XFILLER_4_545 vccd1 vssd1 vccd1 vssd1 sky130_ef_sc_hd__decap_40_12
XFILLER_79_357 vssd1 vssd1 vccd1 vccd1 sky130_fd_sc_hd__fill_2
XFILLER_11_9 vssd1 vssd1 vccd1 vccd1 sky130_fd_sc_hd__fill_1
XFILLER_90_533 vccd1 vssd1 vccd1 vssd1 sky130_ef_sc_hd__decap_40_12
XTAP_TAPCELL_ROW_58_783 vssd1 vccd1 sky130_fd_sc_hd__tapvpwrvgnd_1
XANTENNA__8206__A net294 vssd1 vssd1 vccd1 vccd1 sky130_fd_sc_hd__diode_2
XFILLER_62_235 vssd1 vssd1 vccd1 vccd1 sky130_fd_sc_hd__fill_1
XTAP_TAPCELL_ROW_83_1030 vssd1 vccd1 sky130_fd_sc_hd__tapvpwrvgnd_1
XFILLER_15_173 vssd1 vssd1 vccd1 vccd1 sky130_fd_sc_hd__fill_1
XFILLER_15_195 vssd1 vssd1 vccd1 vccd1 sky130_fd_sc_hd__fill_4
XTAP_TAPCELL_ROW_13_330 vssd1 vccd1 sky130_fd_sc_hd__tapvpwrvgnd_1
XFILLER_30_187 vssd1 vssd1 vccd1 vccd1 sky130_fd_sc_hd__fill_4
X_4530_ _3794_ _3807_ vssd1 vssd1 vccd1 vccd1 _3808_ sky130_fd_sc_hd__nand2_1
XFILLER_7_64 vssd1 vssd1 vccd1 vccd1 sky130_fd_sc_hd__fill_2
XFILLER_7_42 vssd1 vssd1 vccd1 vccd1 sky130_fd_sc_hd__fill_1
X_4461_ PID_INST.k1_calc.d1.x\[7\] PID_INST.k3_calc.prev_error\[7\] vssd1 vssd1 vccd1
+ vccd1 _3739_ sky130_fd_sc_hd__nand2_1
X_6200_ _1178_ _1182_ _1387_ vssd1 vssd1 vccd1 vccd1 _1389_ sky130_fd_sc_hd__a21o_1
X_7180_ PID_INST.k3_calc.d2.y\[4\] _1740_ _1741_ vssd1 vssd1 vccd1 vccd1 _2405_ sky130_fd_sc_hd__and3_1
X_4392_ net194 net9 vssd1 vssd1 vccd1 vccd1 _3684_ sky130_fd_sc_hd__and2_1
XANTENNA__5900__B1 _0734_ vssd1 vssd1 vccd1 vccd1 sky130_fd_sc_hd__diode_2
X_6131_ _1318_ _1319_ vssd1 vssd1 vccd1 vccd1 _1320_ sky130_fd_sc_hd__nor2_1
XANTENNA__6396__A net104 vssd1 vssd1 vccd1 vccd1 sky130_fd_sc_hd__diode_2
X_6062_ _0774_ _0776_ _0775_ vssd1 vssd1 vccd1 vccd1 _1252_ sky130_fd_sc_hd__o21ba_1
XANTENNA__4628__B net86 vssd1 vssd1 vccd1 vccd1 sky130_fd_sc_hd__diode_2
X_5013_ _0196_ _0202_ vssd1 vssd1 vccd1 vccd1 _0203_ sky130_fd_sc_hd__or2_1
XFILLER_38_210 vssd1 vssd1 vccd1 vccd1 sky130_fd_sc_hd__fill_2
XFILLER_66_552 vssd1 vssd1 vccd1 vccd1 sky130_fd_sc_hd__fill_2
XFILLER_81_533 vccd1 vssd1 vccd1 vssd1 sky130_ef_sc_hd__decap_40_12
XPHY_EDGE_ROW_5_Right_5 vssd1 vssd1 vccd1 vccd1 sky130_fd_sc_hd__decap_3
X_6964_ _2062_ _2067_ _2060_ vssd1 vssd1 vccd1 vccd1 _2177_ sky130_fd_sc_hd__o21a_1
XFILLER_19_490 vssd1 vssd1 vccd1 vccd1 sky130_fd_sc_hd__fill_1
X_5915_ net139 net59 net56 net118 vssd1 vssd1 vccd1 vccd1 _1105_ sky130_fd_sc_hd__o22ai_1
X_6895_ _2101_ _2102_ vssd1 vssd1 vccd1 vccd1 _2105_ sky130_fd_sc_hd__and2_1
X_5846_ _0981_ _1030_ _1033_ vssd1 vssd1 vccd1 vccd1 _1036_ sky130_fd_sc_hd__o21ai_1
XANTENNA__5719__B1 net295 vssd1 vssd1 vccd1 vccd1 sky130_fd_sc_hd__diode_2
XANTENNA_fanout334_A net339 vssd1 vssd1 vccd1 vccd1 sky130_fd_sc_hd__diode_2
X_5777_ _0915_ _0930_ _0950_ _0962_ vssd1 vssd1 vccd1 vccd1 _0967_ sky130_fd_sc_hd__a211oi_1
XFILLER_5_309 vssd1 vssd1 vccd1 vccd1 sky130_fd_sc_hd__fill_2
X_4728_ _3991_ _4005_ vssd1 vssd1 vccd1 vccd1 _4006_ sky130_fd_sc_hd__xor2_1
X_7516_ _2754_ _2759_ vssd1 vssd1 vccd1 vccd1 _2762_ sky130_fd_sc_hd__xnor2_1
X_7447_ net206 net275 vssd1 vssd1 vccd1 vccd1 _2688_ sky130_fd_sc_hd__nand2_1
X_4659_ net113 net145 _3930_ _3936_ vssd1 vssd1 vccd1 vccd1 _3937_ sky130_fd_sc_hd__and4_1
X_7378_ _2595_ _2614_ vssd1 vssd1 vccd1 vccd1 _2616_ sky130_fd_sc_hd__xnor2_1
XANTENNA__4819__A _4095_ vssd1 vssd1 vccd1 vccd1 sky130_fd_sc_hd__diode_2
XFILLER_1_559 vssd1 vssd1 vccd1 vccd1 sky130_fd_sc_hd__fill_1
X_6329_ _1515_ _1516_ vssd1 vssd1 vccd1 vccd1 _1517_ sky130_fd_sc_hd__xnor2_1
XFILLER_69_390 vssd1 vssd1 vccd1 vccd1 sky130_fd_sc_hd__fill_2
XFILLER_29_210 vssd1 vssd1 vccd1 vccd1 sky130_fd_sc_hd__fill_1
XFILLER_29_221 vssd1 vssd1 vccd1 vccd1 sky130_fd_sc_hd__fill_1
XANTENNA__5670__A2 net219 vssd1 vssd1 vccd1 vccd1 sky130_fd_sc_hd__diode_2
XFILLER_29_254 vssd1 vssd1 vccd1 vccd1 sky130_fd_sc_hd__fill_4
XTAP_TAPCELL_ROW_55_753 vssd1 vccd1 sky130_fd_sc_hd__tapvpwrvgnd_1
XANTENNA__4554__A net148 vssd1 vssd1 vccd1 vccd1 sky130_fd_sc_hd__diode_2
XTAP_TAPCELL_ROW_27_466 vssd1 vccd1 sky130_fd_sc_hd__tapvpwrvgnd_1
XFILLER_32_419 vssd1 vssd1 vccd1 vccd1 sky130_fd_sc_hd__fill_1
XFILLER_16_73 vssd1 vssd1 vccd1 vccd1 sky130_fd_sc_hd__fill_8
XFILLER_25_471 vssd1 vssd1 vccd1 vccd1 sky130_fd_sc_hd__fill_1
XTAP_TAPCELL_ROW_10_300 vssd1 vccd1 sky130_fd_sc_hd__tapvpwrvgnd_1
XANTENNA__5385__A net103 vssd1 vssd1 vccd1 vccd1 sky130_fd_sc_hd__diode_2
XFILLER_40_474 vssd1 vssd1 vccd1 vccd1 sky130_fd_sc_hd__fill_2
XFILLER_32_61 vssd1 vssd1 vccd1 vccd1 sky130_fd_sc_hd__fill_1
XFILLER_32_83 vssd1 vssd1 vccd1 vccd1 sky130_fd_sc_hd__fill_1
XFILLER_4_397 vssd1 vssd1 vccd1 vccd1 sky130_fd_sc_hd__fill_2
XFILLER_79_165 vssd1 vssd1 vccd1 vccd1 sky130_fd_sc_hd__fill_2
XFILLER_79_154 vssd1 vssd1 vccd1 vccd1 sky130_fd_sc_hd__fill_1
XANTENNA__5551__C net291 vssd1 vssd1 vccd1 vccd1 sky130_fd_sc_hd__diode_2
XFILLER_48_530 vssd1 vssd1 vccd1 vccd1 sky130_fd_sc_hd__fill_2
XFILLER_82_319 vssd1 vssd1 vccd1 vccd1 sky130_fd_sc_hd__fill_8
XFILLER_35_202 vccd1 vssd1 vccd1 vssd1 sky130_ef_sc_hd__decap_40_12
XANTENNA__8060__B1 net194 vssd1 vssd1 vccd1 vccd1 sky130_fd_sc_hd__diode_2
XFILLER_75_393 vccd1 vssd1 vccd1 vssd1 sky130_ef_sc_hd__decap_40_12
XFILLER_90_352 vssd1 vssd1 vccd1 vccd1 sky130_fd_sc_hd__fill_4
XANTENNA__4183__B net175 vssd1 vssd1 vccd1 vccd1 sky130_fd_sc_hd__diode_2
X_5700_ net318 net224 _0840_ _0889_ vssd1 vssd1 vccd1 vccd1 _0890_ sky130_fd_sc_hd__nand4_1
X_6680_ _1654_ _1657_ _1876_ vssd1 vssd1 vccd1 vccd1 _1877_ sky130_fd_sc_hd__a21oi_1
X_5631_ _0817_ _0820_ vssd1 vssd1 vccd1 vccd1 _0821_ sky130_fd_sc_hd__xnor2_1
XANTENNA__7494__B net53 vssd1 vssd1 vccd1 vccd1 sky130_fd_sc_hd__diode_2
XANTENNA__5177__B2 net137 vssd1 vssd1 vccd1 vccd1 sky130_fd_sc_hd__diode_2
XANTENNA__5177__A1 net138 vssd1 vssd1 vccd1 vccd1 sky130_fd_sc_hd__diode_2
XFILLER_31_463 vssd1 vssd1 vccd1 vccd1 sky130_fd_sc_hd__fill_4
X_5562_ _0748_ _0749_ _0751_ vssd1 vssd1 vccd1 vccd1 _0752_ sky130_fd_sc_hd__or3_1
X_8350_ net95 net39 _1742_ net102 vssd1 vssd1 vccd1 vccd1 _3628_ sky130_fd_sc_hd__o22ai_1
X_8281_ net286 net184 _3460_ _3458_ vssd1 vssd1 vccd1 vccd1 _3554_ sky130_fd_sc_hd__a31o_1
X_4513_ net130 net151 vssd1 vssd1 vccd1 vccd1 _3791_ sky130_fd_sc_hd__nand2_1
X_7301_ _2406_ _2531_ vssd1 vssd1 vccd1 vccd1 _2533_ sky130_fd_sc_hd__nand2_1
X_5493_ _0680_ _0681_ _0682_ vssd1 vssd1 vccd1 vccd1 _0683_ sky130_fd_sc_hd__o21a_1
X_7232_ _2448_ _2460_ vssd1 vssd1 vccd1 vccd1 _2461_ sky130_fd_sc_hd__nand2b_1
XTAP_TAPCELL_ROW_92_1129 vssd1 vccd1 sky130_fd_sc_hd__tapvpwrvgnd_1
XTAP_TAPCELL_ROW_92_1118 vssd1 vccd1 sky130_fd_sc_hd__tapvpwrvgnd_1
X_4444_ PID_INST.k1_calc.d1.x\[1\] PID_INST.k3_calc.prev_error\[1\] vssd1 vssd1 vccd1
+ vccd1 _3722_ sky130_fd_sc_hd__and2_1
X_7163_ _2385_ _2386_ vssd1 vssd1 vccd1 vccd1 _2387_ sky130_fd_sc_hd__xnor2_1
X_4375_ net205 net6 vssd1 vssd1 vccd1 vccd1 _3670_ sky130_fd_sc_hd__and2_1
X_7094_ net271 net266 net222 net218 vssd1 vssd1 vccd1 vccd1 _2314_ sky130_fd_sc_hd__and4_1
X_6114_ _1301_ _1302_ vssd1 vssd1 vccd1 vccd1 _1303_ sky130_fd_sc_hd__nand2b_1
XFILLER_85_113 vssd1 vssd1 vccd1 vccd1 sky130_fd_sc_hd__fill_2
X_6045_ _1232_ _1233_ vssd1 vssd1 vccd1 vccd1 _1235_ sky130_fd_sc_hd__xnor2_1
XANTENNA__4358__B net159 vssd1 vssd1 vccd1 vccd1 sky130_fd_sc_hd__diode_2
XANTENNA__8384__CLK clknet_4_9_0_clk vssd1 vssd1 vccd1 vccd1 sky130_fd_sc_hd__diode_2
XANTENNA_fanout284_A net285 vssd1 vssd1 vccd1 vccd1 sky130_fd_sc_hd__diode_2
XFILLER_85_135 vssd1 vssd1 vccd1 vccd1 sky130_fd_sc_hd__fill_8
XFILLER_39_530 vssd1 vssd1 vccd1 vccd1 sky130_fd_sc_hd__fill_8
XTAP_TAPCELL_ROW_69_889 vssd1 vccd1 sky130_fd_sc_hd__tapvpwrvgnd_1
XFILLER_66_393 vssd1 vssd1 vccd1 vccd1 sky130_fd_sc_hd__fill_2
XANTENNA__4374__A net205 vssd1 vssd1 vccd1 vccd1 sky130_fd_sc_hd__diode_2
X_7996_ _3035_ _3037_ _3034_ vssd1 vssd1 vccd1 vccd1 _3251_ sky130_fd_sc_hd__o21ba_1
XFILLER_26_257 vccd1 vssd1 vccd1 vssd1 sky130_ef_sc_hd__decap_40_12
XTAP_TAPCELL_ROW_52_723 vssd1 vccd1 sky130_fd_sc_hd__tapvpwrvgnd_1
XTAP_TAPCELL_ROW_24_436 vssd1 vccd1 sky130_fd_sc_hd__tapvpwrvgnd_1
X_6947_ _2117_ _2157_ vssd1 vssd1 vccd1 vccd1 _2159_ sky130_fd_sc_hd__xnor2_1
XFILLER_22_452 vccd1 vssd1 vccd1 vssd1 sky130_ef_sc_hd__decap_40_12
X_6878_ _1785_ _2086_ vssd1 vssd1 vccd1 vccd1 _2087_ sky130_fd_sc_hd__xor2_1
X_5829_ _0993_ _1018_ vssd1 vssd1 vccd1 vccd1 _1019_ sky130_fd_sc_hd__and2_1
X_8479_ clknet_4_11_0_clk _0067_ net340 vssd1 vssd1 vccd1 vccd1 net28 sky130_fd_sc_hd__dfrtp_1
XFILLER_1_301 vssd1 vssd1 vccd1 vccd1 sky130_fd_sc_hd__fill_1
XFILLER_49_327 vssd1 vssd1 vccd1 vccd1 sky130_fd_sc_hd__fill_4
XFILLER_76_146 vssd1 vssd1 vccd1 vccd1 sky130_fd_sc_hd__fill_8
XFILLER_91_138 vssd1 vssd1 vccd1 vccd1 sky130_fd_sc_hd__fill_1
XFILLER_57_393 vssd1 vssd1 vccd1 vccd1 sky130_fd_sc_hd__fill_1
XFILLER_45_555 vssd1 vssd1 vccd1 vccd1 sky130_fd_sc_hd__fill_1
XFILLER_45_522 vssd1 vssd1 vccd1 vccd1 sky130_fd_sc_hd__fill_8
XANTENNA_input12_A gpio_in[2] vssd1 vssd1 vccd1 vccd1 sky130_fd_sc_hd__diode_2
XFILLER_17_213 vssd1 vssd1 vccd1 vccd1 sky130_fd_sc_hd__fill_2
XFILLER_72_363 vssd1 vssd1 vccd1 vccd1 sky130_fd_sc_hd__fill_1
XFILLER_72_352 vssd1 vssd1 vccd1 vccd1 sky130_fd_sc_hd__fill_2
XFILLER_17_279 vssd1 vssd1 vccd1 vccd1 sky130_fd_sc_hd__fill_1
XTAP_TAPCELL_ROW_80_1000 vssd1 vccd1 sky130_fd_sc_hd__tapvpwrvgnd_1
XFILLER_13_441 vssd1 vssd1 vccd1 vccd1 sky130_fd_sc_hd__fill_4
XFILLER_13_485 vccd1 vssd1 vccd1 vssd1 sky130_ef_sc_hd__decap_40_12
XANTENNA__5159__B2 net131 vssd1 vssd1 vccd1 vccd1 sky130_fd_sc_hd__diode_2
XFILLER_9_478 vssd1 vssd1 vccd1 vccd1 sky130_fd_sc_hd__fill_4
XANTENNA__6939__A PID_INST.k3_calc.d2.y\[2\] vssd1 vssd1 vccd1 vccd1 sky130_fd_sc_hd__diode_2
XTAP_TAPCELL_ROW_89_1091 vssd1 vccd1 sky130_fd_sc_hd__tapvpwrvgnd_1
XTAP_TAPCELL_ROW_66_859 vssd1 vccd1 sky130_fd_sc_hd__tapvpwrvgnd_1
XFILLER_48_382 vccd1 vssd1 vccd1 vssd1 sky130_ef_sc_hd__decap_40_12
X_7850_ _2854_ _2865_ _2867_ vssd1 vssd1 vccd1 vccd1 _3106_ sky130_fd_sc_hd__a21boi_1
XFILLER_63_352 vssd1 vssd1 vccd1 vccd1 sky130_fd_sc_hd__fill_1
X_6801_ net165 _3999_ vssd1 vssd1 vccd1 vccd1 _2004_ sky130_fd_sc_hd__and2_1
XFILLER_90_171 vssd1 vssd1 vccd1 vccd1 sky130_fd_sc_hd__fill_8
X_7781_ net286 PID_INST.k2_calc.sum_reg\[16\] vssd1 vssd1 vccd1 vccd1 _3037_ sky130_fd_sc_hd__nand2_1
X_4993_ _0114_ _0181_ vssd1 vssd1 vccd1 vccd1 _0183_ sky130_fd_sc_hd__xor2_1
XFILLER_23_238 vccd1 vssd1 vccd1 vssd1 sky130_ef_sc_hd__decap_40_12
X_6732_ _1917_ _1918_ _1930_ vssd1 vssd1 vccd1 vccd1 _1931_ sky130_fd_sc_hd__nand3_1
X_6663_ _1856_ _1857_ vssd1 vssd1 vccd1 vccd1 _1858_ sky130_fd_sc_hd__xnor2_1
XTAP_TAPCELL_ROW_21_406 vssd1 vccd1 sky130_fd_sc_hd__tapvpwrvgnd_1
X_5614_ _0803_ vssd1 vssd1 vccd1 vccd1 _0804_ sky130_fd_sc_hd__inv_2
X_8402_ clknet_4_3_0_clk _0022_ net335 vssd1 vssd1 vccd1 vccd1 PID_INST.k2_calc.reg_lc\[6\]
+ sky130_fd_sc_hd__dfrtp_1
X_6594_ _1305_ _1500_ _1504_ vssd1 vssd1 vccd1 vccd1 _1783_ sky130_fd_sc_hd__a21bo_1
X_8333_ _3608_ _3609_ vssd1 vssd1 vccd1 vccd1 _3610_ sky130_fd_sc_hd__xnor2_1
X_5545_ net219 net273 vssd1 vssd1 vccd1 vccd1 _0735_ sky130_fd_sc_hd__nand2_1
X_8264_ _3534_ _3535_ vssd1 vssd1 vccd1 vccd1 _3536_ sky130_fd_sc_hd__nor2_2
X_5476_ _0634_ _0665_ vssd1 vssd1 vccd1 vccd1 _0666_ sky130_fd_sc_hd__nand2_1
XFILLER_2_109 vssd1 vssd1 vccd1 vccd1 sky130_fd_sc_hd__fill_1
X_8195_ net286 net184 vssd1 vssd1 vccd1 vccd1 _3462_ sky130_fd_sc_hd__nand2_1
X_4427_ net178 _3707_ vssd1 vssd1 vccd1 vccd1 _3708_ sky130_fd_sc_hd__or2_1
X_7215_ _2183_ _2441_ vssd1 vssd1 vccd1 vccd1 _2443_ sky130_fd_sc_hd__xor2_1
X_7146_ _2350_ _2368_ vssd1 vssd1 vccd1 vccd1 _2369_ sky130_fd_sc_hd__or2_1
XANTENNA_input4_A gpio_in[11] vssd1 vssd1 vccd1 vccd1 sky130_fd_sc_hd__diode_2
X_4358_ net218 net159 vssd1 vssd1 vccd1 vccd1 _3656_ sky130_fd_sc_hd__and2_1
X_7077_ _1962_ _1969_ _1961_ vssd1 vssd1 vccd1 vccd1 _2297_ sky130_fd_sc_hd__a21bo_1
XFILLER_86_466 vssd1 vssd1 vccd1 vccd1 sky130_fd_sc_hd__fill_8
XFILLER_86_444 vssd1 vssd1 vccd1 vccd1 sky130_fd_sc_hd__fill_4
X_4289_ net396 net7 net160 vssd1 vssd1 vccd1 vccd1 _0012_ sky130_fd_sc_hd__mux2_1
XANTENNA_fanout287_X net287 vssd1 vssd1 vccd1 vccd1 sky130_fd_sc_hd__diode_2
X_6028_ _0806_ _0809_ vssd1 vssd1 vccd1 vccd1 _1218_ sky130_fd_sc_hd__or2_1
XFILLER_46_319 vssd1 vssd1 vccd1 vccd1 sky130_fd_sc_hd__fill_1
XFILLER_39_393 vssd1 vssd1 vccd1 vccd1 sky130_fd_sc_hd__fill_4
X_7979_ _3210_ _3211_ _3233_ vssd1 vssd1 vccd1 vccd1 _3234_ sky130_fd_sc_hd__nor3_1
XFILLER_14_205 vssd1 vssd1 vccd1 vccd1 sky130_fd_sc_hd__fill_1
XTAP_TAPCELL_ROW_37_572 vssd1 vccd1 sky130_fd_sc_hd__tapvpwrvgnd_1
XFILLER_42_514 vssd1 vssd1 vccd1 vccd1 sky130_fd_sc_hd__fill_1
XFILLER_14_249 vssd1 vssd1 vccd1 vccd1 sky130_fd_sc_hd__fill_2
XFILLER_80_47 vssd1 vssd1 vccd1 vccd1 sky130_fd_sc_hd__fill_2
Xfanout64 _4020_ vssd1 vssd1 vccd1 vccd1 net64 sky130_fd_sc_hd__clkbuf_2
Xfanout53 _0226_ vssd1 vssd1 vccd1 vccd1 net53 sky130_fd_sc_hd__clkbuf_4
Xfanout42 _1191_ vssd1 vssd1 vccd1 vccd1 net42 sky130_fd_sc_hd__clkbuf_4
XFILLER_80_69 vssd1 vssd1 vccd1 vccd1 sky130_fd_sc_hd__fill_1
Xfanout86 net87 vssd1 vssd1 vccd1 vccd1 net86 sky130_fd_sc_hd__buf_2
Xfanout97 _2644_ vssd1 vssd1 vccd1 vccd1 net97 sky130_fd_sc_hd__clkbuf_4
Xfanout75 net77 vssd1 vssd1 vccd1 vccd1 net75 sky130_fd_sc_hd__buf_2
XFILLER_1_131 vssd1 vssd1 vccd1 vccd1 sky130_fd_sc_hd__fill_2
XFILLER_49_113 vssd1 vssd1 vccd1 vccd1 sky130_fd_sc_hd__fill_1
XTAP_TAPCELL_ROW_9_286 vssd1 vccd1 sky130_fd_sc_hd__tapvpwrvgnd_1
XFILLER_77_455 vssd1 vssd1 vccd1 vccd1 sky130_fd_sc_hd__fill_1
XFILLER_49_135 vssd1 vssd1 vccd1 vccd1 sky130_fd_sc_hd__fill_8
XANTENNA__5077__B1 _3734_ vssd1 vssd1 vccd1 vccd1 sky130_fd_sc_hd__diode_2
XANTENNA_input15_X net15 vssd1 vssd1 vccd1 vccd1 sky130_fd_sc_hd__diode_2
XFILLER_18_533 vssd1 vssd1 vccd1 vccd1 sky130_fd_sc_hd__fill_4
XFILLER_18_544 vccd1 vssd1 vccd1 vssd1 sky130_ef_sc_hd__decap_40_12
XTAP_TAPCELL_ROW_63_829 vssd1 vccd1 sky130_fd_sc_hd__tapvpwrvgnd_1
XFILLER_60_311 vccd1 vssd1 vccd1 vssd1 sky130_ef_sc_hd__decap_40_12
XFILLER_60_355 vssd1 vssd1 vccd1 vccd1 sky130_fd_sc_hd__fill_1
XFILLER_9_231 vccd1 vssd1 vccd1 vssd1 sky130_ef_sc_hd__decap_40_12
XANTENNA__4355__A2 net19 vssd1 vssd1 vccd1 vccd1 sky130_fd_sc_hd__diode_2
Xclkload12 clknet_4_13_0_clk vssd1 vssd1 vccd1 vccd1 clkload12/Y sky130_fd_sc_hd__clkinvlp_4
X_5330_ _0434_ _0441_ _0443_ vssd1 vssd1 vccd1 vccd1 _0520_ sky130_fd_sc_hd__a21bo_1
XPHY_EDGE_ROW_10_Left_103 vssd1 vssd1 vccd1 vccd1 sky130_fd_sc_hd__decap_3
X_5261_ _0339_ _0340_ _0333_ _0338_ vssd1 vssd1 vccd1 vccd1 _0451_ sky130_fd_sc_hd__a2bb2o_1
X_7000_ _2213_ _2214_ vssd1 vssd1 vccd1 vccd1 _2216_ sky130_fd_sc_hd__xor2_1
X_4212_ net119 vssd1 vssd1 vccd1 vccd1 PID_INST.k3_calc.d2.y\[6\] sky130_fd_sc_hd__inv_2
XFILLER_68_400 vssd1 vssd1 vccd1 vccd1 sky130_fd_sc_hd__fill_2
X_5192_ _0372_ _0373_ _0380_ vssd1 vssd1 vccd1 vccd1 _0382_ sky130_fd_sc_hd__a21o_1
XFILLER_83_403 vssd1 vssd1 vccd1 vccd1 sky130_fd_sc_hd__fill_1
XTAP_TAPCELL_ROW_79_995 vssd1 vccd1 sky130_fd_sc_hd__tapvpwrvgnd_1
XFILLER_68_477 vssd1 vssd1 vccd1 vccd1 sky130_fd_sc_hd__fill_8
XFILLER_28_319 vssd1 vssd1 vccd1 vccd1 sky130_fd_sc_hd__fill_1
XFILLER_83_447 vssd1 vssd1 vccd1 vccd1 sky130_fd_sc_hd__fill_1
XANTENNA__7012__B net186 vssd1 vssd1 vccd1 vccd1 sky130_fd_sc_hd__diode_2
XFILLER_55_138 vccd1 vssd1 vccd1 vssd1 sky130_ef_sc_hd__decap_40_12
X_7902_ net119 _2147_ vssd1 vssd1 vccd1 vccd1 _3157_ sky130_fd_sc_hd__nor2_1
XFILLER_83_469 vccd1 vssd1 vccd1 vssd1 sky130_ef_sc_hd__decap_40_12
XANTENNA__4291__A1 net9 vssd1 vssd1 vccd1 vccd1 sky130_fd_sc_hd__diode_2
XANTENNA__8422__CLK clknet_4_1_0_clk vssd1 vssd1 vccd1 vccd1 sky130_fd_sc_hd__diode_2
XFILLER_36_363 vssd1 vssd1 vccd1 vccd1 sky130_fd_sc_hd__fill_1
X_7833_ _2861_ _2862_ _2863_ _2864_ vssd1 vssd1 vccd1 vccd1 _3089_ sky130_fd_sc_hd__a2bb2o_1
X_7764_ _3019_ _3018_ vssd1 vssd1 vccd1 vccd1 _3020_ sky130_fd_sc_hd__and2b_1
XANTENNA__6032__A2 net321 vssd1 vssd1 vccd1 vccd1 sky130_fd_sc_hd__diode_2
XANTENNA__4652__A net123 vssd1 vssd1 vccd1 vccd1 sky130_fd_sc_hd__diode_2
XTAP_TAPCELL_ROW_34_542 vssd1 vccd1 sky130_fd_sc_hd__tapvpwrvgnd_1
X_6715_ _1910_ _1911_ vssd1 vssd1 vccd1 vccd1 _1913_ sky130_fd_sc_hd__xnor2_1
XANTENNA__8309__B2 net201 vssd1 vssd1 vccd1 vccd1 sky130_fd_sc_hd__diode_2
X_4976_ _0163_ _0164_ vssd1 vssd1 vccd1 vccd1 _0166_ sky130_fd_sc_hd__xnor2_1
X_7695_ net286 net193 vssd1 vssd1 vccd1 vccd1 _2951_ sky130_fd_sc_hd__nand2_1
X_6646_ _1623_ _1626_ _1837_ vssd1 vssd1 vccd1 vccd1 _1840_ sky130_fd_sc_hd__o21ai_1
Xclkload6 clknet_4_6_0_clk vssd1 vssd1 vccd1 vccd1 clkload6/Y sky130_fd_sc_hd__clkinv_2
XANTENNA__5543__A1 net236 vssd1 vssd1 vccd1 vccd1 sky130_fd_sc_hd__diode_2
X_6577_ net100 net59 vssd1 vssd1 vccd1 vccd1 _1765_ sky130_fd_sc_hd__nor2_1
X_8316_ _3583_ _3591_ vssd1 vssd1 vccd1 vccd1 _3592_ sky130_fd_sc_hd__xnor2_1
XANTENNA_fanout202_X net202 vssd1 vssd1 vccd1 vccd1 sky130_fd_sc_hd__diode_2
X_5528_ _0716_ _0717_ vssd1 vssd1 vccd1 vccd1 _0718_ sky130_fd_sc_hd__or2_1
X_8247_ _3335_ _3351_ _3517_ vssd1 vssd1 vccd1 vccd1 _3518_ sky130_fd_sc_hd__a21oi_1
XFILLER_59_59 vssd1 vssd1 vccd1 vccd1 sky130_fd_sc_hd__fill_1
X_5459_ net107 net63 _0628_ vssd1 vssd1 vccd1 vccd1 _0649_ sky130_fd_sc_hd__o21ba_1
Xfanout221 PID_INST.k2_calc.sum_reg\[8\] vssd1 vssd1 vccd1 vccd1 net221 sky130_fd_sc_hd__buf_2
Xfanout210 net212 vssd1 vssd1 vccd1 vccd1 net210 sky130_fd_sc_hd__buf_2
Xfanout232 PID_INST.k2_calc.sum_reg\[5\] vssd1 vssd1 vccd1 vccd1 net232 sky130_fd_sc_hd__buf_2
X_8178_ _3279_ _3286_ _3441_ vssd1 vssd1 vccd1 vccd1 _3443_ sky130_fd_sc_hd__and3_1
X_7129_ net229 net262 _0785_ vssd1 vssd1 vccd1 vccd1 _2351_ sky130_fd_sc_hd__a21oi_1
Xfanout265 net266 vssd1 vssd1 vccd1 vccd1 net265 sky130_fd_sc_hd__clkbuf_2
Xfanout254 net255 vssd1 vssd1 vccd1 vccd1 net254 sky130_fd_sc_hd__buf_2
Xfanout243 PID_INST.k2_calc.sum_reg\[2\] vssd1 vssd1 vccd1 vccd1 net243 sky130_fd_sc_hd__clkbuf_2
XFILLER_59_444 vssd1 vssd1 vccd1 vccd1 sky130_fd_sc_hd__fill_4
XANTENNA_input7_X net7 vssd1 vssd1 vccd1 vccd1 sky130_fd_sc_hd__diode_2
XTAP_TAPCELL_ROW_6_256 vssd1 vccd1 sky130_fd_sc_hd__tapvpwrvgnd_1
XANTENNA__4827__A _2210_ vssd1 vssd1 vccd1 vccd1 sky130_fd_sc_hd__diode_2
Xfanout298 net299 vssd1 vssd1 vccd1 vccd1 net298 sky130_fd_sc_hd__buf_2
Xfanout276 net277 vssd1 vssd1 vccd1 vccd1 net276 sky130_fd_sc_hd__buf_2
XFILLER_59_488 vccd1 vssd1 vccd1 vssd1 sky130_ef_sc_hd__decap_40_12
Xfanout287 net288 vssd1 vssd1 vccd1 vccd1 net287 sky130_fd_sc_hd__buf_2
XFILLER_15_503 vssd1 vssd1 vccd1 vccd1 sky130_fd_sc_hd__fill_1
XFILLER_15_536 vssd1 vssd1 vccd1 vccd1 sky130_fd_sc_hd__fill_8
XFILLER_91_57 vssd1 vssd1 vccd1 vccd1 sky130_fd_sc_hd__fill_4
XFILLER_15_569 vssd1 vssd1 vccd1 vccd1 sky130_fd_sc_hd__fill_1
XANTENNA_clkbuf_4_15_0_clk_X clknet_4_15_0_clk vssd1 vssd1 vccd1 vccd1 sky130_fd_sc_hd__diode_2
XANTENNA__6936__B net37 vssd1 vssd1 vccd1 vccd1 sky130_fd_sc_hd__diode_2
XFILLER_80_406 vssd1 vssd1 vccd1 vccd1 sky130_fd_sc_hd__fill_2
XTAP_TAPCELL_ROW_76_965 vssd1 vccd1 sky130_fd_sc_hd__tapvpwrvgnd_1
XTAP_TAPCELL_ROW_48_678 vssd1 vccd1 sky130_fd_sc_hd__tapvpwrvgnd_1
XFILLER_92_277 vssd1 vssd1 vccd1 vccd1 sky130_fd_sc_hd__fill_2
XTAP_TAPCELL_ROW_86_1061 vssd1 vccd1 sky130_fd_sc_hd__tapvpwrvgnd_1
XFILLER_65_91 vssd1 vssd1 vccd1 vccd1 sky130_fd_sc_hd__fill_1
XFILLER_18_363 vssd1 vssd1 vccd1 vccd1 sky130_fd_sc_hd__fill_1
X_4830_ _4103_ _4107_ vssd1 vssd1 vccd1 vccd1 _4108_ sky130_fd_sc_hd__xor2_1
XFILLER_33_344 vssd1 vssd1 vccd1 vccd1 sky130_fd_sc_hd__fill_2
XFILLER_33_355 vssd1 vssd1 vccd1 vccd1 sky130_fd_sc_hd__fill_1
XFILLER_60_141 vssd1 vssd1 vccd1 vccd1 sky130_fd_sc_hd__fill_1
XANTENNA__5287__B net47 vssd1 vssd1 vccd1 vccd1 sky130_fd_sc_hd__diode_2
X_4761_ _4001_ _4037_ _4038_ vssd1 vssd1 vccd1 vccd1 _4039_ sky130_fd_sc_hd__a21boi_1
XANTENNA__6970__B1 net50 vssd1 vssd1 vccd1 vccd1 sky130_fd_sc_hd__diode_2
XTAP_TAPCELL_ROW_31_512 vssd1 vccd1 sky130_fd_sc_hd__tapvpwrvgnd_1
XFILLER_33_399 vssd1 vssd1 vccd1 vccd1 sky130_fd_sc_hd__fill_8
X_7480_ _2714_ _2721_ vssd1 vssd1 vccd1 vccd1 _2723_ sky130_fd_sc_hd__xnor2_1
X_6500_ net416 net154 vssd1 vssd1 vccd1 vccd1 _1687_ sky130_fd_sc_hd__nor2_1
X_4692_ net132 net143 _3968_ _3969_ vssd1 vssd1 vccd1 vccd1 _3970_ sky130_fd_sc_hd__nand4_1
X_6431_ _1617_ _1618_ vssd1 vssd1 vccd1 vccd1 _1619_ sky130_fd_sc_hd__nand2_1
X_6362_ _1547_ _1548_ vssd1 vssd1 vccd1 vccd1 _1550_ sky130_fd_sc_hd__xnor2_1
X_8101_ net305 net179 vssd1 vssd1 vccd1 vccd1 _3360_ sky130_fd_sc_hd__nand2_1
X_5313_ _0495_ _0502_ vssd1 vssd1 vccd1 vccd1 _0503_ sky130_fd_sc_hd__xnor2_1
X_6293_ _1282_ _1286_ _1481_ vssd1 vssd1 vccd1 vccd1 _1482_ sky130_fd_sc_hd__a21oi_1
XANTENNA__5828__A2 net296 vssd1 vssd1 vccd1 vccd1 sky130_fd_sc_hd__diode_2
X_8032_ _3281_ _3285_ vssd1 vssd1 vccd1 vccd1 _3286_ sky130_fd_sc_hd__nand2_1
X_5244_ net134 net80 _0278_ _0379_ _0378_ vssd1 vssd1 vccd1 vccd1 _0434_ sky130_fd_sc_hd__a41o_1
XANTENNA__8227__B1 net252 vssd1 vssd1 vccd1 vccd1 sky130_fd_sc_hd__diode_2
Xhold29 net34 vssd1 vssd1 vccd1 vccd1 net422 sky130_fd_sc_hd__dlygate4sd3_1
XANTENNA__6846__B net63 vssd1 vssd1 vccd1 vccd1 sky130_fd_sc_hd__diode_2
XFILLER_29_29 vssd1 vssd1 vccd1 vccd1 sky130_fd_sc_hd__fill_2
X_5175_ PID_INST.k3_calc.d1.y\[12\] net85 vssd1 vssd1 vccd1 vccd1 _0365_ sky130_fd_sc_hd__nand2_1
Xhold18 net29 vssd1 vssd1 vccd1 vccd1 net411 sky130_fd_sc_hd__dlygate4sd3_1
XANTENNA_fanout197_A net198 vssd1 vssd1 vccd1 vccd1 sky130_fd_sc_hd__diode_2
XTAP_TAPCELL_ROW_3_226 vssd1 vccd1 sky130_fd_sc_hd__tapvpwrvgnd_1
XFILLER_68_285 vssd1 vssd1 vccd1 vccd1 sky130_fd_sc_hd__fill_4
XFILLER_28_127 vssd1 vssd1 vccd1 vccd1 sky130_fd_sc_hd__fill_2
XFILLER_71_417 vssd1 vssd1 vccd1 vccd1 sky130_fd_sc_hd__fill_4
XFILLER_36_171 vssd1 vssd1 vccd1 vccd1 sky130_fd_sc_hd__fill_1
XFILLER_51_130 vssd1 vssd1 vccd1 vccd1 sky130_fd_sc_hd__fill_1
XTAP_TAPCELL_ROW_19_391 vssd1 vccd1 sky130_fd_sc_hd__tapvpwrvgnd_1
X_7816_ _3070_ _3071_ vssd1 vssd1 vccd1 vccd1 _3072_ sky130_fd_sc_hd__nor2_1
X_7747_ _2990_ _2991_ _3002_ vssd1 vssd1 vccd1 vccd1 _3003_ sky130_fd_sc_hd__nand3_1
XFILLER_51_185 vssd1 vssd1 vccd1 vccd1 sky130_fd_sc_hd__fill_1
X_4959_ _0079_ _0100_ _0099_ vssd1 vssd1 vccd1 vccd1 _0149_ sky130_fd_sc_hd__a21o_1
X_7678_ _2931_ _2930_ vssd1 vssd1 vccd1 vccd1 _2932_ sky130_fd_sc_hd__and2b_1
X_6629_ net319 net193 vssd1 vssd1 vccd1 vccd1 _1822_ sky130_fd_sc_hd__nand2_1
XFILLER_3_215 vssd1 vssd1 vccd1 vccd1 sky130_fd_sc_hd__fill_8
XANTENNA__6102__A _1102_ vssd1 vssd1 vccd1 vccd1 sky130_fd_sc_hd__diode_2
XFILLER_10_64 vssd1 vssd1 vccd1 vccd1 sky130_fd_sc_hd__fill_1
XFILLER_10_31 vssd1 vssd1 vccd1 vccd1 sky130_fd_sc_hd__fill_1
XFILLER_3_259 vssd1 vssd1 vccd1 vccd1 sky130_fd_sc_hd__fill_8
XFILLER_10_75 vssd1 vssd1 vccd1 vccd1 sky130_fd_sc_hd__fill_8
XFILLER_87_561 vssd1 vssd1 vccd1 vccd1 sky130_fd_sc_hd__fill_4
XANTENNA__4557__A net142 vssd1 vssd1 vccd1 vccd1 sky130_fd_sc_hd__diode_2
XANTENNA_fanout65_X net65 vssd1 vssd1 vccd1 vccd1 sky130_fd_sc_hd__diode_2
XFILLER_74_266 vssd1 vssd1 vccd1 vccd1 sky130_fd_sc_hd__fill_8
XFILLER_74_255 vssd1 vssd1 vccd1 vccd1 sky130_fd_sc_hd__fill_8
XANTENNA__4255__A1 net9 vssd1 vssd1 vccd1 vccd1 sky130_fd_sc_hd__diode_2
XFILLER_19_95 vssd1 vssd1 vccd1 vccd1 sky130_fd_sc_hd__fill_1
XTAP_TAPCELL_ROW_73_935 vssd1 vccd1 sky130_fd_sc_hd__tapvpwrvgnd_1
XFILLER_15_311 vssd1 vssd1 vccd1 vccd1 sky130_fd_sc_hd__fill_1
XTAP_TAPCELL_ROW_45_648 vssd1 vccd1 sky130_fd_sc_hd__tapvpwrvgnd_1
XFILLER_15_344 vccd1 vssd1 vccd1 vssd1 sky130_ef_sc_hd__decap_40_12
XFILLER_35_61 vccd1 vssd1 vccd1 vssd1 sky130_ef_sc_hd__decap_40_12
XFILLER_30_347 vssd1 vssd1 vccd1 vccd1 sky130_fd_sc_hd__fill_8
XANTENNA__5835__B net289 vssd1 vssd1 vccd1 vccd1 sky130_fd_sc_hd__diode_2
XFILLER_51_82 vssd1 vssd1 vccd1 vccd1 sky130_fd_sc_hd__fill_2
XANTENNA__6704__B1 PID_INST.k2_calc.sum_reg\[5\] vssd1 vssd1 vccd1 vccd1 sky130_fd_sc_hd__diode_2
XANTENNA__5912__D1 _1101_ vssd1 vssd1 vccd1 vccd1 sky130_fd_sc_hd__diode_2
XANTENNA__4186__B _1784_ vssd1 vssd1 vccd1 vccd1 sky130_fd_sc_hd__diode_2
XFILLER_18_3 vssd1 vssd1 vccd1 vccd1 sky130_fd_sc_hd__fill_2
XFILLER_53_406 vssd1 vssd1 vccd1 vccd1 sky130_fd_sc_hd__fill_4
XANTENNA__4246__A1 net4 vssd1 vssd1 vccd1 vccd1 sky130_fd_sc_hd__diode_2
X_6980_ _2192_ _2193_ vssd1 vssd1 vccd1 vccd1 _2194_ sky130_fd_sc_hd__or2_1
XFILLER_53_439 vssd1 vssd1 vccd1 vccd1 sky130_fd_sc_hd__fill_8
X_5931_ _1119_ _1120_ vssd1 vssd1 vccd1 vccd1 _1121_ sky130_fd_sc_hd__and2_1
XANTENNA__8105__C net189 vssd1 vssd1 vccd1 vccd1 sky130_fd_sc_hd__diode_2
X_5862_ _1050_ _1051_ vssd1 vssd1 vccd1 vccd1 _1052_ sky130_fd_sc_hd__nor2_1
XFILLER_21_303 vssd1 vssd1 vccd1 vccd1 sky130_fd_sc_hd__fill_2
X_5793_ net248 net312 net300 net238 vssd1 vssd1 vccd1 vccd1 _0983_ sky130_fd_sc_hd__and4_1
X_4813_ _4026_ _4090_ vssd1 vssd1 vccd1 vccd1 _4091_ sky130_fd_sc_hd__nand2_1
XTAP_TAPCELL_ROW_16_361 vssd1 vccd1 sky130_fd_sc_hd__tapvpwrvgnd_1
XFILLER_33_174 vssd1 vssd1 vccd1 vccd1 sky130_fd_sc_hd__fill_2
X_7601_ _2849_ _2850_ vssd1 vssd1 vccd1 vccd1 _2852_ sky130_fd_sc_hd__xor2_1
X_4744_ _4021_ vssd1 vssd1 vccd1 vccd1 _4022_ sky130_fd_sc_hd__inv_2
XFILLER_21_369 vssd1 vssd1 vccd1 vccd1 sky130_fd_sc_hd__fill_2
X_7532_ _2510_ _2524_ _2509_ vssd1 vssd1 vccd1 vccd1 _2779_ sky130_fd_sc_hd__a21boi_1
XANTENNA__5745__B net230 vssd1 vssd1 vccd1 vccd1 sky130_fd_sc_hd__diode_2
X_7463_ _2703_ _2704_ vssd1 vssd1 vccd1 vccd1 _2705_ sky130_fd_sc_hd__nand2_1
X_4675_ _3934_ _3950_ _3952_ _3951_ vssd1 vssd1 vccd1 vccd1 _3953_ sky130_fd_sc_hd__a31o_1
X_7394_ _2375_ _2382_ _2374_ vssd1 vssd1 vccd1 vccd1 _2632_ sky130_fd_sc_hd__a21bo_1
X_6414_ _1490_ _1600_ vssd1 vssd1 vccd1 vccd1 _1602_ sky130_fd_sc_hd__xnor2_1
XANTENNA__8477__RESET_B net341 vssd1 vssd1 vccd1 vccd1 sky130_fd_sc_hd__diode_2
X_6345_ _1332_ _1334_ _1531_ vssd1 vssd1 vccd1 vccd1 _1533_ sky130_fd_sc_hd__or3_1
XANTENNA__6857__A net101 vssd1 vssd1 vccd1 vccd1 sky130_fd_sc_hd__diode_2
XFILLER_88_325 vssd1 vssd1 vccd1 vccd1 sky130_fd_sc_hd__fill_4
X_6276_ net210 net306 _1242_ _1243_ net261 vssd1 vssd1 vccd1 vccd1 _1465_ sky130_fd_sc_hd__a32oi_2
XFILLER_0_207 vccd1 vssd1 vccd1 vssd1 sky130_ef_sc_hd__decap_40_12
X_8015_ _3122_ _3268_ _3267_ vssd1 vssd1 vccd1 vccd1 _3269_ sky130_fd_sc_hd__a21o_1
X_5227_ _0365_ _0416_ vssd1 vssd1 vccd1 vccd1 _0417_ sky130_fd_sc_hd__xor2_1
XFILLER_56_27 vssd1 vssd1 vccd1 vccd1 sky130_fd_sc_hd__fill_1
X_5158_ _2083_ _2114_ net73 net75 vssd1 vssd1 vccd1 vccd1 _0348_ sky130_fd_sc_hd__or4b_1
XFILLER_56_244 vssd1 vssd1 vccd1 vccd1 sky130_fd_sc_hd__fill_2
X_5089_ PID_INST.k3_calc.d1.y\[8\] net82 vssd1 vssd1 vccd1 vccd1 _0279_ sky130_fd_sc_hd__nand2_1
XANTENNA__4237__A1 net12 vssd1 vssd1 vccd1 vccd1 sky130_fd_sc_hd__diode_2
XANTENNA__4824__B net70 vssd1 vssd1 vccd1 vccd1 sky130_fd_sc_hd__diode_2
XFILLER_72_26 vssd1 vssd1 vccd1 vccd1 sky130_fd_sc_hd__fill_2
XTAP_TAPCELL_ROW_70_905 vssd1 vccd1 sky130_fd_sc_hd__tapvpwrvgnd_1
XFILLER_52_450 vccd1 vssd1 vccd1 vssd1 sky130_ef_sc_hd__decap_40_12
XTAP_TAPCELL_ROW_42_618 vssd1 vccd1 sky130_fd_sc_hd__tapvpwrvgnd_1
XFILLER_12_369 vssd1 vssd1 vccd1 vccd1 sky130_fd_sc_hd__fill_2
XANTENNA__4840__A net78 vssd1 vssd1 vccd1 vccd1 sky130_fd_sc_hd__diode_2
XFILLER_8_329 vssd1 vssd1 vccd1 vccd1 sky130_fd_sc_hd__fill_1
XANTENNA__4960__A2 _0087_ vssd1 vssd1 vccd1 vccd1 sky130_fd_sc_hd__diode_2
XFILLER_4_557 vssd1 vssd1 vccd1 vccd1 sky130_fd_sc_hd__fill_8
XFILLER_21_85 vccd1 vssd1 vccd1 vssd1 sky130_ef_sc_hd__decap_40_12
XFILLER_87_391 vssd1 vssd1 vccd1 vccd1 sky130_fd_sc_hd__fill_1
XFILLER_47_211 vssd1 vssd1 vccd1 vccd1 sky130_fd_sc_hd__fill_2
XTAP_TAPCELL_ROW_58_784 vssd1 vccd1 sky130_fd_sc_hd__tapvpwrvgnd_1
XFILLER_47_288 vssd1 vssd1 vccd1 vccd1 sky130_fd_sc_hd__fill_1
XFILLER_47_266 vssd1 vssd1 vccd1 vccd1 sky130_fd_sc_hd__fill_1
XANTENNA__4228__A1 net3 vssd1 vssd1 vccd1 vccd1 sky130_fd_sc_hd__diode_2
XFILLER_90_545 vccd1 vssd1 vccd1 vssd1 sky130_ef_sc_hd__decap_40_12
XTAP_TAPCELL_ROW_83_1031 vssd1 vccd1 sky130_fd_sc_hd__tapvpwrvgnd_1
XANTENNA__5728__A1 net239 vssd1 vssd1 vccd1 vccd1 sky130_fd_sc_hd__diode_2
XFILLER_87_6 vccd1 vssd1 vccd1 vssd1 sky130_ef_sc_hd__decap_40_12
XFILLER_70_291 vssd1 vssd1 vccd1 vccd1 sky130_fd_sc_hd__fill_1
XTAP_TAPCELL_ROW_13_331 vssd1 vccd1 sky130_fd_sc_hd__tapvpwrvgnd_1
X_4460_ _2210_ _3734_ _3737_ vssd1 vssd1 vccd1 vccd1 _3738_ sky130_fd_sc_hd__or3b_4
XFILLER_7_87 vssd1 vssd1 vccd1 vccd1 sky130_fd_sc_hd__fill_8
X_4391_ net197 _3683_ net160 vssd1 vssd1 vccd1 vccd1 _0045_ sky130_fd_sc_hd__mux2_1
X_6130_ _1104_ _1317_ vssd1 vssd1 vccd1 vccd1 _1319_ sky130_fd_sc_hd__and2_1
XANTENNA__7102__B1 net254 vssd1 vssd1 vccd1 vccd1 sky130_fd_sc_hd__diode_2
X_6061_ _1249_ _1250_ vssd1 vssd1 vccd1 vccd1 _1251_ sky130_fd_sc_hd__xnor2_1
X_5012_ _0200_ _0201_ vssd1 vssd1 vccd1 vccd1 _0202_ sky130_fd_sc_hd__xor2_1
XFILLER_66_531 vssd1 vssd1 vccd1 vccd1 sky130_fd_sc_hd__fill_1
XANTENNA__4219__A1 net16 vssd1 vssd1 vccd1 vccd1 sky130_fd_sc_hd__diode_2
XFILLER_81_545 vssd1 vssd1 vccd1 vccd1 sky130_fd_sc_hd__fill_4
X_6963_ _2169_ _2175_ vssd1 vssd1 vccd1 vccd1 _2176_ sky130_fd_sc_hd__xnor2_1
XANTENNA__7020__B net188 vssd1 vssd1 vccd1 vccd1 sky130_fd_sc_hd__diode_2
X_5914_ _4158_ _1103_ vssd1 vssd1 vccd1 vccd1 _1104_ sky130_fd_sc_hd__nand2_1
X_6894_ _2101_ _2102_ vssd1 vssd1 vccd1 vccd1 _2103_ sky130_fd_sc_hd__nor2_1
X_5845_ _1015_ _1016_ vssd1 vssd1 vccd1 vccd1 _1035_ sky130_fd_sc_hd__xor2_1
XANTENNA__5719__B2 net239 vssd1 vssd1 vccd1 vccd1 sky130_fd_sc_hd__diode_2
X_5776_ _0964_ _0965_ vssd1 vssd1 vccd1 vccd1 _0966_ sky130_fd_sc_hd__or2_1
XANTENNA_fanout327_A net339 vssd1 vssd1 vccd1 vccd1 sky130_fd_sc_hd__diode_2
X_4727_ _3992_ _4003_ vssd1 vssd1 vccd1 vccd1 _4005_ sky130_fd_sc_hd__xnor2_1
X_7515_ _2759_ vssd1 vssd1 vccd1 vccd1 _2761_ sky130_fd_sc_hd__inv_2
X_7446_ _2600_ _2609_ _2608_ vssd1 vssd1 vccd1 vccd1 _2687_ sky130_fd_sc_hd__a21oi_1
X_4658_ net123 net153 net151 net121 vssd1 vssd1 vccd1 vccd1 _3936_ sky130_fd_sc_hd__a22o_1
XANTENNA_fanout115_X net115 vssd1 vssd1 vccd1 vccd1 sky130_fd_sc_hd__diode_2
XFILLER_88_100 vssd1 vssd1 vccd1 vccd1 sky130_fd_sc_hd__fill_1
X_7377_ _2595_ _2614_ vssd1 vssd1 vccd1 vccd1 _2615_ sky130_fd_sc_hd__or2_1
X_4589_ _3864_ net122 net88 _3866_ vssd1 vssd1 vccd1 vccd1 _3867_ sky130_fd_sc_hd__and4b_1
XFILLER_1_505 vccd1 vssd1 vccd1 vssd1 sky130_ef_sc_hd__decap_40_12
X_6328_ net114 net47 vssd1 vssd1 vccd1 vccd1 _1516_ sky130_fd_sc_hd__nor2_1
X_6259_ _1446_ _1447_ vssd1 vssd1 vccd1 vccd1 _1448_ sky130_fd_sc_hd__nor2_1
XFILLER_57_564 vssd1 vssd1 vccd1 vccd1 sky130_fd_sc_hd__fill_4
XFILLER_17_406 vssd1 vssd1 vccd1 vccd1 sky130_fd_sc_hd__fill_2
XFILLER_84_394 vssd1 vssd1 vccd1 vccd1 sky130_fd_sc_hd__fill_8
XFILLER_72_556 vssd1 vssd1 vccd1 vccd1 sky130_fd_sc_hd__fill_1
XANTENNA__4554__B _3774_ vssd1 vssd1 vccd1 vccd1 sky130_fd_sc_hd__diode_2
XFILLER_72_567 vssd1 vssd1 vccd1 vccd1 sky130_fd_sc_hd__fill_2
XTAP_TAPCELL_ROW_55_754 vssd1 vccd1 sky130_fd_sc_hd__tapvpwrvgnd_1
XFILLER_25_461 vssd1 vssd1 vccd1 vccd1 sky130_fd_sc_hd__fill_8
XTAP_TAPCELL_ROW_27_467 vssd1 vccd1 sky130_fd_sc_hd__tapvpwrvgnd_1
XPHY_EDGE_ROW_11_Right_11 vssd1 vssd1 vccd1 vccd1 sky130_fd_sc_hd__decap_3
XFILLER_16_63 vssd1 vssd1 vccd1 vccd1 sky130_fd_sc_hd__fill_1
XFILLER_16_85 vssd1 vssd1 vccd1 vccd1 sky130_fd_sc_hd__fill_4
XFILLER_25_483 vssd1 vssd1 vccd1 vccd1 sky130_fd_sc_hd__fill_1
XFILLER_12_122 vccd1 vssd1 vccd1 vssd1 sky130_ef_sc_hd__decap_40_12
XFILLER_40_442 vssd1 vssd1 vccd1 vccd1 sky130_fd_sc_hd__fill_1
XFILLER_12_177 vssd1 vssd1 vccd1 vccd1 sky130_fd_sc_hd__fill_2
XTAP_TAPCELL_ROW_10_301 vssd1 vccd1 sky130_fd_sc_hd__tapvpwrvgnd_1
XFILLER_8_137 vssd1 vssd1 vccd1 vccd1 sky130_fd_sc_hd__fill_2
XANTENNA__5385__B net47 vssd1 vssd1 vccd1 vccd1 sky130_fd_sc_hd__diode_2
XFILLER_79_133 vssd1 vssd1 vccd1 vccd1 sky130_fd_sc_hd__fill_4
XPHY_EDGE_ROW_20_Right_20 vssd1 vssd1 vccd1 vccd1 sky130_fd_sc_hd__decap_3
XANTENNA__7105__B net186 vssd1 vssd1 vccd1 vccd1 sky130_fd_sc_hd__diode_2
XANTENNA__5551__D net236 vssd1 vssd1 vccd1 vccd1 sky130_fd_sc_hd__diode_2
XFILLER_82_309 vssd1 vssd1 vccd1 vccd1 sky130_fd_sc_hd__fill_4
XPHY_EDGE_ROW_66_Left_159 vssd1 vssd1 vccd1 vccd1 sky130_fd_sc_hd__decap_3
XFILLER_48_542 vssd1 vssd1 vccd1 vccd1 sky130_fd_sc_hd__fill_2
XANTENNA__4745__A net109 vssd1 vssd1 vccd1 vccd1 sky130_fd_sc_hd__diode_2
XFILLER_90_331 vssd1 vssd1 vccd1 vccd1 sky130_fd_sc_hd__fill_4
XFILLER_35_214 vssd1 vssd1 vccd1 vccd1 sky130_fd_sc_hd__fill_8
XFILLER_90_342 vssd1 vssd1 vccd1 vccd1 sky130_fd_sc_hd__fill_1
XFILLER_35_269 vssd1 vssd1 vccd1 vccd1 sky130_fd_sc_hd__fill_4
XFILLER_50_239 vssd1 vssd1 vccd1 vccd1 sky130_fd_sc_hd__fill_4
XFILLER_50_217 vssd1 vssd1 vccd1 vccd1 sky130_fd_sc_hd__fill_8
XFILLER_31_431 vssd1 vssd1 vccd1 vccd1 sky130_fd_sc_hd__fill_1
XPHY_EDGE_ROW_75_Left_168 vssd1 vssd1 vccd1 vccd1 sky130_fd_sc_hd__decap_3
X_5630_ net318 net210 _0819_ vssd1 vssd1 vccd1 vccd1 _0820_ sky130_fd_sc_hd__and3_1
XANTENNA__4385__A0 net201 vssd1 vssd1 vccd1 vccd1 sky130_fd_sc_hd__diode_2
XANTENNA__4480__A net113 vssd1 vssd1 vccd1 vccd1 sky130_fd_sc_hd__diode_2
XANTENNA__5177__A2 net87 vssd1 vssd1 vccd1 vccd1 sky130_fd_sc_hd__diode_2
XFILLER_31_475 vccd1 vssd1 vccd1 vssd1 sky130_ef_sc_hd__decap_40_12
X_5561_ _0701_ _0703_ _0702_ vssd1 vssd1 vccd1 vccd1 _0751_ sky130_fd_sc_hd__o21ba_1
XANTENNA__5295__B net85 vssd1 vssd1 vccd1 vccd1 sky130_fd_sc_hd__diode_2
X_8280_ _3437_ _3438_ _3440_ vssd1 vssd1 vccd1 vccd1 _3553_ sky130_fd_sc_hd__o21ai_1
X_5492_ _0672_ _0673_ _0680_ _0681_ _0679_ vssd1 vssd1 vccd1 vccd1 _0682_ sky130_fd_sc_hd__a221o_1
X_4512_ net130 net152 vssd1 vssd1 vccd1 vccd1 _3790_ sky130_fd_sc_hd__nand2_1
X_7300_ net117 net39 vssd1 vssd1 vccd1 vccd1 _2532_ sky130_fd_sc_hd__nor2_1
X_7231_ _2449_ _2458_ vssd1 vssd1 vccd1 vccd1 _2460_ sky130_fd_sc_hd__xnor2_1
XTAP_TAPCELL_ROW_92_1119 vssd1 vccd1 sky130_fd_sc_hd__tapvpwrvgnd_1
XANTENNA__4479__X _3757_ vssd1 vssd1 vccd1 vccd1 sky130_fd_sc_hd__diode_2
X_4443_ _3719_ _3720_ vssd1 vssd1 vccd1 vccd1 _3721_ sky130_fd_sc_hd__and2b_1
X_7162_ _2286_ _2295_ vssd1 vssd1 vccd1 vccd1 _2386_ sky130_fd_sc_hd__nand2_1
X_4374_ net205 net6 vssd1 vssd1 vccd1 vccd1 _3669_ sky130_fd_sc_hd__nor2_1
X_7093_ net412 _2313_ net154 vssd1 vssd1 vccd1 vccd1 _0065_ sky130_fd_sc_hd__mux2_1
XANTENNA_clkload14_A clknet_4_15_0_clk vssd1 vssd1 vccd1 vccd1 sky130_fd_sc_hd__diode_2
X_6113_ _1299_ _1300_ vssd1 vssd1 vccd1 vccd1 _1302_ sky130_fd_sc_hd__nand2_1
XPHY_EDGE_ROW_84_Left_177 vssd1 vssd1 vccd1 vccd1 sky130_fd_sc_hd__decap_3
X_6044_ _1233_ _1232_ vssd1 vssd1 vccd1 vccd1 _1234_ sky130_fd_sc_hd__nand2b_1
XFILLER_66_372 vssd1 vssd1 vccd1 vccd1 sky130_fd_sc_hd__fill_1
XANTENNA_fanout277_A PID_INST.k2_calc.reg_lc\[9\] vssd1 vssd1 vccd1 vccd1 sky130_fd_sc_hd__diode_2
X_7995_ _3248_ _3249_ vssd1 vssd1 vccd1 vccd1 _3250_ sky130_fd_sc_hd__xor2_1
XANTENNA__4374__B net6 vssd1 vssd1 vccd1 vccd1 sky130_fd_sc_hd__diode_2
XANTENNA__7966__A net294 vssd1 vssd1 vccd1 vccd1 sky130_fd_sc_hd__diode_2
XFILLER_81_364 vssd1 vssd1 vccd1 vccd1 sky130_fd_sc_hd__fill_8
XFILLER_81_353 vssd1 vssd1 vccd1 vccd1 sky130_fd_sc_hd__fill_4
XFILLER_26_269 vccd1 vssd1 vccd1 vssd1 sky130_ef_sc_hd__decap_40_12
X_6946_ _2157_ _2117_ vssd1 vssd1 vccd1 vccd1 _2158_ sky130_fd_sc_hd__and2b_1
XFILLER_81_397 vssd1 vssd1 vccd1 vccd1 sky130_fd_sc_hd__fill_2
XTAP_TAPCELL_ROW_52_724 vssd1 vccd1 sky130_fd_sc_hd__tapvpwrvgnd_1
XTAP_TAPCELL_ROW_24_437 vssd1 vccd1 sky130_fd_sc_hd__tapvpwrvgnd_1
X_6877_ net117 net45 vssd1 vssd1 vccd1 vccd1 _2086_ sky130_fd_sc_hd__nor2_1
XANTENNA_fanout232_X net232 vssd1 vssd1 vccd1 vccd1 sky130_fd_sc_hd__diode_2
X_5828_ net248 net296 net237 net308 vssd1 vssd1 vccd1 vccd1 _1018_ sky130_fd_sc_hd__a22o_1
XFILLER_22_464 vssd1 vssd1 vccd1 vccd1 sky130_fd_sc_hd__fill_4
XFILLER_22_486 vssd1 vssd1 vccd1 vccd1 sky130_fd_sc_hd__fill_4
X_5759_ _0947_ _0948_ vssd1 vssd1 vccd1 vccd1 _0949_ sky130_fd_sc_hd__nand2_1
XANTENNA__8421__RESET_B net339 vssd1 vssd1 vccd1 vccd1 sky130_fd_sc_hd__diode_2
X_8478_ clknet_4_14_0_clk _0066_ net340 vssd1 vssd1 vccd1 vccd1 net27 sky130_fd_sc_hd__dfrtp_1
X_7429_ _2565_ _2573_ _2667_ vssd1 vssd1 vccd1 vccd1 _2669_ sky130_fd_sc_hd__nand3_1
XFILLER_78_25 vssd1 vssd1 vccd1 vccd1 sky130_fd_sc_hd__fill_2
XFILLER_1_313 vssd1 vssd1 vccd1 vccd1 sky130_fd_sc_hd__fill_1
XANTENNA__5628__B1 net207 vssd1 vssd1 vccd1 vccd1 sky130_fd_sc_hd__diode_2
XANTENNA__4300__A0 net286 vssd1 vssd1 vccd1 vccd1 sky130_fd_sc_hd__diode_2
XFILLER_64_309 vssd1 vssd1 vccd1 vccd1 sky130_fd_sc_hd__fill_2
XFILLER_57_361 vssd1 vssd1 vccd1 vccd1 sky130_fd_sc_hd__fill_2
XANTENNA__4851__A1 net135 vssd1 vssd1 vccd1 vccd1 sky130_fd_sc_hd__diode_2
XFILLER_57_383 vssd1 vssd1 vccd1 vccd1 sky130_fd_sc_hd__fill_8
XFILLER_17_236 vssd1 vssd1 vccd1 vccd1 sky130_fd_sc_hd__fill_2
XANTENNA__7876__A net95 vssd1 vssd1 vccd1 vccd1 sky130_fd_sc_hd__diode_2
XTAP_TAPCELL_ROW_80_1001 vssd1 vccd1 sky130_fd_sc_hd__tapvpwrvgnd_1
XANTENNA__5396__A net115 vssd1 vssd1 vccd1 vccd1 sky130_fd_sc_hd__diode_2
XFILLER_40_250 vssd1 vssd1 vccd1 vccd1 sky130_fd_sc_hd__fill_2
XFILLER_9_446 vssd1 vssd1 vccd1 vccd1 sky130_fd_sc_hd__fill_2
XFILLER_13_497 vssd1 vssd1 vccd1 vccd1 sky130_fd_sc_hd__fill_4
XFILLER_71_9 vssd1 vssd1 vccd1 vccd1 sky130_fd_sc_hd__fill_1
XANTENNA__4459__B net88 vssd1 vssd1 vccd1 vccd1 sky130_fd_sc_hd__diode_2
XFILLER_4_162 vssd1 vssd1 vccd1 vccd1 sky130_fd_sc_hd__fill_1
XFILLER_4_195 vssd1 vssd1 vccd1 vccd1 sky130_fd_sc_hd__fill_1
XANTENNA__8281__A1 net286 vssd1 vssd1 vccd1 vccd1 sky130_fd_sc_hd__diode_2
XFILLER_67_169 vssd1 vssd1 vccd1 vccd1 sky130_fd_sc_hd__fill_1
XFILLER_63_320 vssd1 vssd1 vccd1 vccd1 sky130_fd_sc_hd__fill_2
XFILLER_48_394 vccd1 vssd1 vccd1 vssd1 sky130_ef_sc_hd__decap_40_12
XFILLER_48_372 vssd1 vssd1 vccd1 vccd1 sky130_fd_sc_hd__fill_8
XTAP_TAPCELL_ROW_89_1092 vssd1 vccd1 sky130_fd_sc_hd__tapvpwrvgnd_1
X_6800_ net165 _4033_ _4034_ vssd1 vssd1 vccd1 vccd1 _2003_ sky130_fd_sc_hd__and3_1
X_7780_ _3034_ _3035_ vssd1 vssd1 vccd1 vccd1 _3036_ sky130_fd_sc_hd__nor2_1
X_4992_ _0114_ _0181_ vssd1 vssd1 vccd1 vccd1 _0182_ sky130_fd_sc_hd__or2_1
XFILLER_23_206 vccd1 vssd1 vccd1 vssd1 sky130_ef_sc_hd__decap_40_12
X_6731_ _1928_ _1929_ vssd1 vssd1 vccd1 vccd1 _1930_ sky130_fd_sc_hd__and2_1
XFILLER_16_280 vssd1 vssd1 vccd1 vccd1 sky130_fd_sc_hd__fill_2
X_6662_ net207 net295 vssd1 vssd1 vccd1 vccd1 _1857_ sky130_fd_sc_hd__nand2_1
XTAP_TAPCELL_ROW_21_407 vssd1 vccd1 sky130_fd_sc_hd__tapvpwrvgnd_1
X_5613_ _0801_ _0802_ vssd1 vssd1 vccd1 vccd1 _0803_ sky130_fd_sc_hd__and2_1
X_8401_ clknet_4_13_0_clk _0021_ net335 vssd1 vssd1 vccd1 vccd1 PID_INST.k2_calc.reg_lc\[5\]
+ sky130_fd_sc_hd__dfrtp_1
X_8332_ net286 net182 vssd1 vssd1 vccd1 vccd1 _3609_ sky130_fd_sc_hd__nand2_1
X_6593_ net114 net47 _1515_ _1514_ vssd1 vssd1 vccd1 vccd1 _1782_ sky130_fd_sc_hd__o31ai_2
X_5544_ net245 net308 vssd1 vssd1 vccd1 vccd1 _0734_ sky130_fd_sc_hd__nand2_2
XFILLER_8_490 vccd1 vssd1 vccd1 vssd1 sky130_ef_sc_hd__decap_40_12
X_8263_ _3402_ _3404_ _3533_ vssd1 vssd1 vccd1 vccd1 _3535_ sky130_fd_sc_hd__nor3_1
X_5475_ _0663_ _0664_ vssd1 vssd1 vccd1 vccd1 _0665_ sky130_fd_sc_hd__xnor2_1
X_8194_ _3458_ _3459_ vssd1 vssd1 vccd1 vccd1 _3460_ sky130_fd_sc_hd__and2b_1
X_4426_ _3706_ _3707_ vssd1 vssd1 vccd1 vccd1 _0056_ sky130_fd_sc_hd__nor2_1
X_7214_ _2437_ _2439_ vssd1 vssd1 vccd1 vccd1 _2441_ sky130_fd_sc_hd__xnor2_1
X_7145_ _2366_ _2367_ vssd1 vssd1 vccd1 vccd1 _2368_ sky130_fd_sc_hd__nand2_1
XFILLER_86_401 vssd1 vssd1 vccd1 vccd1 sky130_fd_sc_hd__fill_2
X_4357_ _3650_ _3651_ _3653_ vssd1 vssd1 vccd1 vccd1 _3655_ sky130_fd_sc_hd__or3_1
XANTENNA__6865__A net109 vssd1 vssd1 vccd1 vccd1 sky130_fd_sc_hd__diode_2
X_7076_ _2286_ _2287_ _2294_ vssd1 vssd1 vccd1 vccd1 _2296_ sky130_fd_sc_hd__a21o_1
X_4288_ net6 net400 net157 vssd1 vssd1 vccd1 vccd1 _0011_ sky130_fd_sc_hd__mux2_1
X_6027_ _1215_ _1216_ vssd1 vssd1 vccd1 vccd1 _1217_ sky130_fd_sc_hd__nor2_1
XANTENNA_fanout182_X net182 vssd1 vssd1 vccd1 vccd1 sky130_fd_sc_hd__diode_2
XFILLER_46_309 vssd1 vssd1 vccd1 vccd1 sky130_fd_sc_hd__fill_8
XFILLER_27_523 vssd1 vssd1 vccd1 vccd1 sky130_fd_sc_hd__fill_1
XFILLER_66_191 vssd1 vssd1 vccd1 vccd1 sky130_fd_sc_hd__fill_2
X_7978_ _3212_ _3231_ vssd1 vssd1 vccd1 vccd1 _3233_ sky130_fd_sc_hd__xnor2_1
XTAP_TAPCELL_ROW_37_573 vssd1 vccd1 sky130_fd_sc_hd__tapvpwrvgnd_1
XFILLER_81_194 vssd1 vssd1 vccd1 vccd1 sky130_fd_sc_hd__fill_1
X_6929_ _1717_ _1993_ _1995_ _1996_ vssd1 vssd1 vccd1 vccd1 _2140_ sky130_fd_sc_hd__o22ai_1
XFILLER_80_26 vssd1 vssd1 vccd1 vccd1 sky130_fd_sc_hd__fill_2
XFILLER_80_15 vssd1 vssd1 vccd1 vccd1 sky130_fd_sc_hd__fill_4
XFILLER_10_401 vccd1 vssd1 vccd1 vssd1 sky130_ef_sc_hd__decap_40_12
Xfanout54 _0226_ vssd1 vssd1 vccd1 vccd1 net54 sky130_fd_sc_hd__clkbuf_2
Xfanout65 _3964_ vssd1 vssd1 vccd1 vccd1 net65 sky130_fd_sc_hd__clkbuf_4
Xfanout43 _1191_ vssd1 vssd1 vccd1 vccd1 net43 sky130_fd_sc_hd__clkbuf_2
XFILLER_80_59 vssd1 vssd1 vccd1 vccd1 sky130_fd_sc_hd__fill_8
Xfanout76 net77 vssd1 vssd1 vccd1 vccd1 net76 sky130_fd_sc_hd__buf_2
Xfanout98 _2644_ vssd1 vssd1 vccd1 vccd1 net98 sky130_fd_sc_hd__buf_2
XFILLER_10_434 vssd1 vssd1 vccd1 vccd1 sky130_fd_sc_hd__fill_1
XFILLER_22_272 vssd1 vssd1 vccd1 vccd1 sky130_fd_sc_hd__fill_1
Xfanout87 _3733_ vssd1 vssd1 vccd1 vccd1 net87 sky130_fd_sc_hd__buf_2
XFILLER_6_405 vssd1 vssd1 vccd1 vccd1 sky130_fd_sc_hd__fill_8
XFILLER_10_489 vssd1 vssd1 vccd1 vccd1 sky130_fd_sc_hd__fill_8
XFILLER_89_68 vssd1 vssd1 vccd1 vccd1 sky130_fd_sc_hd__fill_1
XANTENNA_fanout95_X net95 vssd1 vssd1 vccd1 vccd1 sky130_fd_sc_hd__diode_2
XTAP_TAPCELL_ROW_9_287 vssd1 vccd1 sky130_fd_sc_hd__tapvpwrvgnd_1
XFILLER_77_445 vssd1 vssd1 vccd1 vccd1 sky130_fd_sc_hd__fill_2
XFILLER_92_437 vssd1 vssd1 vccd1 vccd1 sky130_fd_sc_hd__fill_1
XFILLER_72_150 vssd1 vssd1 vccd1 vccd1 sky130_fd_sc_hd__fill_4
XFILLER_60_323 vccd1 vssd1 vccd1 vssd1 sky130_ef_sc_hd__decap_40_12
XFILLER_45_364 vccd1 vssd1 vccd1 vssd1 sky130_ef_sc_hd__decap_40_12
XFILLER_72_183 vssd1 vssd1 vccd1 vccd1 sky130_fd_sc_hd__fill_4
XFILLER_54_60 vssd1 vssd1 vccd1 vccd1 sky130_fd_sc_hd__fill_2
XANTENNA_clkbuf_4_11_0_clk_X clknet_4_11_0_clk vssd1 vssd1 vccd1 vccd1 sky130_fd_sc_hd__diode_2
XFILLER_9_243 vssd1 vssd1 vccd1 vccd1 sky130_fd_sc_hd__fill_2
XANTENNA__8230__A net317 vssd1 vssd1 vccd1 vccd1 sky130_fd_sc_hd__diode_2
XFILLER_70_92 vssd1 vssd1 vccd1 vccd1 sky130_fd_sc_hd__fill_4
Xclkload13 clknet_4_14_0_clk vssd1 vssd1 vccd1 vccd1 clkload13/Y sky130_fd_sc_hd__inv_8
XFILLER_9_298 vssd1 vssd1 vccd1 vccd1 sky130_fd_sc_hd__fill_4
X_5260_ _0448_ _0449_ vssd1 vssd1 vccd1 vccd1 _0450_ sky130_fd_sc_hd__nand2b_1
XANTENNA__4189__B net175 vssd1 vssd1 vccd1 vccd1 sky130_fd_sc_hd__diode_2
X_4211_ net18 net168 _2263_ vssd1 vssd1 vccd1 vccd1 _2274_ sky130_fd_sc_hd__o21ai_2
X_5191_ _0372_ _0373_ _0380_ vssd1 vssd1 vccd1 vccd1 _0381_ sky130_fd_sc_hd__nand3_1
XFILLER_28_309 vssd1 vssd1 vccd1 vccd1 sky130_fd_sc_hd__fill_2
XFILLER_55_128 vssd1 vssd1 vccd1 vccd1 sky130_fd_sc_hd__fill_4
XFILLER_55_117 vssd1 vssd1 vccd1 vccd1 sky130_fd_sc_hd__fill_4
X_7901_ _2855_ _3154_ _3155_ vssd1 vssd1 vccd1 vccd1 _3156_ sky130_fd_sc_hd__a21bo_1
XFILLER_36_353 vssd1 vssd1 vccd1 vccd1 sky130_fd_sc_hd__fill_1
X_7832_ _3085_ _3086_ vssd1 vssd1 vccd1 vccd1 _3088_ sky130_fd_sc_hd__xor2_1
XFILLER_24_537 vssd1 vssd1 vccd1 vccd1 sky130_fd_sc_hd__fill_2
X_7763_ _2927_ _2929_ _2926_ vssd1 vssd1 vccd1 vccd1 _3019_ sky130_fd_sc_hd__o21ba_1
XFILLER_63_183 vssd1 vssd1 vccd1 vccd1 sky130_fd_sc_hd__fill_1
XFILLER_51_334 vssd1 vssd1 vccd1 vccd1 sky130_fd_sc_hd__fill_2
X_4975_ _0163_ _0164_ vssd1 vssd1 vccd1 vccd1 _0165_ sky130_fd_sc_hd__or2_1
XANTENNA__4652__B net120 vssd1 vssd1 vccd1 vccd1 sky130_fd_sc_hd__diode_2
XTAP_TAPCELL_ROW_34_543 vssd1 vccd1 sky130_fd_sc_hd__tapvpwrvgnd_1
X_6714_ net319 net190 vssd1 vssd1 vccd1 vccd1 _1911_ sky130_fd_sc_hd__nand2_1
XANTENNA__8309__A2 net256 vssd1 vssd1 vccd1 vccd1 sky130_fd_sc_hd__diode_2
XFILLER_51_389 vssd1 vssd1 vccd1 vccd1 sky130_fd_sc_hd__fill_2
X_7694_ _2947_ _2948_ vssd1 vssd1 vccd1 vccd1 _2949_ sky130_fd_sc_hd__nor2_1
X_6645_ _1623_ _1626_ _1837_ vssd1 vssd1 vccd1 vccd1 _1839_ sky130_fd_sc_hd__or3_1
Xclkload7 clknet_4_8_0_clk vssd1 vssd1 vccd1 vccd1 clkload7/Y sky130_fd_sc_hd__inv_8
XANTENNA__5543__A2 net288 vssd1 vssd1 vccd1 vccd1 sky130_fd_sc_hd__diode_2
X_6576_ _1761_ _1763_ vssd1 vssd1 vccd1 vccd1 _1764_ sky130_fd_sc_hd__nand2_1
X_8315_ _3588_ _3589_ vssd1 vssd1 vccd1 vccd1 _3591_ sky130_fd_sc_hd__nand2b_1
X_5527_ _0713_ _0715_ vssd1 vssd1 vccd1 vccd1 _0717_ sky130_fd_sc_hd__nor2_1
X_8246_ _3514_ _3516_ vssd1 vssd1 vccd1 vccd1 _3517_ sky130_fd_sc_hd__or2_1
X_5458_ _0629_ _0643_ vssd1 vssd1 vccd1 vccd1 _0648_ sky130_fd_sc_hd__nand2_1
Xfanout211 net212 vssd1 vssd1 vccd1 vccd1 net211 sky130_fd_sc_hd__clkbuf_2
Xfanout200 PID_INST.k2_calc.sum_reg\[13\] vssd1 vssd1 vccd1 vccd1 net200 sky130_fd_sc_hd__buf_2
X_4409_ net187 _3696_ vssd1 vssd1 vccd1 vccd1 _3698_ sky130_fd_sc_hd__and2_1
Xfanout222 net225 vssd1 vssd1 vccd1 vccd1 net222 sky130_fd_sc_hd__buf_2
XFILLER_59_412 vssd1 vssd1 vccd1 vccd1 sky130_fd_sc_hd__fill_1
XFILLER_59_401 vssd1 vssd1 vccd1 vccd1 sky130_fd_sc_hd__fill_4
X_8177_ _3279_ _3286_ _3441_ vssd1 vssd1 vccd1 vccd1 _3442_ sky130_fd_sc_hd__a21oi_1
X_5389_ _0578_ _0557_ vssd1 vssd1 vccd1 vccd1 _0579_ sky130_fd_sc_hd__nand2b_1
XANTENNA__6595__A net119 vssd1 vssd1 vccd1 vccd1 sky130_fd_sc_hd__diode_2
X_7128_ _2267_ _2276_ _2275_ vssd1 vssd1 vccd1 vccd1 _2350_ sky130_fd_sc_hd__a21oi_1
XFILLER_86_220 vssd1 vssd1 vccd1 vccd1 sky130_fd_sc_hd__fill_4
Xfanout255 PID_INST.k2_calc.reg_lc\[15\] vssd1 vssd1 vccd1 vccd1 net255 sky130_fd_sc_hd__clkbuf_2
Xfanout244 PID_INST.k2_calc.sum_reg\[2\] vssd1 vssd1 vccd1 vccd1 net244 sky130_fd_sc_hd__dlymetal6s2s_1
Xfanout233 PID_INST.k2_calc.sum_reg\[4\] vssd1 vssd1 vccd1 vccd1 net233 sky130_fd_sc_hd__buf_2
XTAP_TAPCELL_ROW_6_257 vssd1 vccd1 sky130_fd_sc_hd__tapvpwrvgnd_1
XANTENNA__4827__B net148 vssd1 vssd1 vccd1 vccd1 sky130_fd_sc_hd__diode_2
X_7059_ _1926_ _1929_ _2277_ vssd1 vssd1 vccd1 vccd1 _2279_ sky130_fd_sc_hd__nand3_1
XFILLER_86_275 vssd1 vssd1 vccd1 vccd1 sky130_fd_sc_hd__fill_1
XFILLER_75_37 vssd1 vssd1 vccd1 vccd1 sky130_fd_sc_hd__fill_1
XFILLER_75_15 vssd1 vssd1 vccd1 vccd1 sky130_fd_sc_hd__fill_2
XFILLER_74_404 vssd1 vssd1 vccd1 vccd1 sky130_fd_sc_hd__fill_1
Xfanout266 PID_INST.k2_calc.reg_lc\[12\] vssd1 vssd1 vccd1 vccd1 net266 sky130_fd_sc_hd__clkbuf_2
Xfanout277 PID_INST.k2_calc.reg_lc\[9\] vssd1 vssd1 vccd1 vccd1 net277 sky130_fd_sc_hd__clkbuf_2
Xfanout288 net289 vssd1 vssd1 vccd1 vccd1 net288 sky130_fd_sc_hd__clkbuf_4
Xfanout299 net304 vssd1 vssd1 vccd1 vccd1 net299 sky130_fd_sc_hd__buf_2
XFILLER_86_286 vssd1 vssd1 vccd1 vccd1 sky130_fd_sc_hd__fill_1
XFILLER_27_353 vssd1 vssd1 vccd1 vccd1 sky130_fd_sc_hd__fill_2
XFILLER_54_161 vccd1 vssd1 vccd1 vssd1 sky130_ef_sc_hd__decap_40_12
XFILLER_30_507 vssd1 vssd1 vccd1 vccd1 sky130_fd_sc_hd__fill_1
XFILLER_42_356 vssd1 vssd1 vccd1 vccd1 sky130_fd_sc_hd__fill_1
XFILLER_24_63 vssd1 vssd1 vccd1 vccd1 sky130_fd_sc_hd__fill_1
XFILLER_10_286 vssd1 vssd1 vccd1 vccd1 sky130_fd_sc_hd__fill_2
XFILLER_6_235 vssd1 vssd1 vccd1 vccd1 sky130_fd_sc_hd__fill_1
XFILLER_6_213 vssd1 vssd1 vccd1 vccd1 sky130_fd_sc_hd__fill_1
XFILLER_6_246 vssd1 vssd1 vccd1 vccd1 sky130_fd_sc_hd__fill_4
XFILLER_6_279 vssd1 vssd1 vccd1 vccd1 sky130_fd_sc_hd__fill_2
XFILLER_40_95 vssd1 vssd1 vccd1 vccd1 sky130_fd_sc_hd__fill_4
XFILLER_2_474 vssd1 vssd1 vccd1 vccd1 sky130_fd_sc_hd__fill_2
XFILLER_27_8 vssd1 vssd1 vccd1 vccd1 sky130_fd_sc_hd__fill_1
XFILLER_77_242 vssd1 vssd1 vccd1 vccd1 sky130_fd_sc_hd__fill_1
XFILLER_92_223 vssd1 vssd1 vccd1 vccd1 sky130_fd_sc_hd__fill_1
XFILLER_1_34 vssd1 vssd1 vccd1 vccd1 sky130_fd_sc_hd__fill_4
XFILLER_92_289 vccd1 vssd1 vccd1 vssd1 sky130_ef_sc_hd__decap_40_12
XTAP_TAPCELL_ROW_86_1062 vssd1 vccd1 sky130_fd_sc_hd__tapvpwrvgnd_1
XFILLER_73_470 vssd1 vssd1 vccd1 vccd1 sky130_fd_sc_hd__fill_4
XTAP_TAPCELL_ROW_48_679 vssd1 vccd1 sky130_fd_sc_hd__tapvpwrvgnd_1
X_4760_ net147 net73 net75 PID_INST.k3_calc.d1.y\[2\] vssd1 vssd1 vccd1 vccd1 _4038_
+ sky130_fd_sc_hd__a2bb2o_1
XANTENNA__6970__A1 net97 vssd1 vssd1 vccd1 vccd1 sky130_fd_sc_hd__diode_2
XANTENNA__6970__B2 net109 vssd1 vssd1 vccd1 vccd1 sky130_fd_sc_hd__diode_2
XTAP_TAPCELL_ROW_31_513 vssd1 vccd1 sky130_fd_sc_hd__tapvpwrvgnd_1
XANTENNA__5584__A net223 vssd1 vssd1 vccd1 vccd1 sky130_fd_sc_hd__diode_2
X_4691_ _3781_ _3967_ vssd1 vssd1 vccd1 vccd1 _3969_ sky130_fd_sc_hd__nand2_1
X_6430_ _1611_ _1616_ vssd1 vssd1 vccd1 vccd1 _1618_ sky130_fd_sc_hd__or2_1
X_6361_ _1355_ _1357_ _1547_ vssd1 vssd1 vccd1 vccd1 _1549_ sky130_fd_sc_hd__a21o_1
X_8100_ net191 _3358_ _3357_ vssd1 vssd1 vccd1 vccd1 _3359_ sky130_fd_sc_hd__a21bo_1
XPHY_EDGE_ROW_49_Right_49 vssd1 vssd1 vccd1 vccd1 sky130_fd_sc_hd__decap_3
X_5312_ _0501_ vssd1 vssd1 vccd1 vccd1 _0502_ sky130_fd_sc_hd__inv_2
X_6292_ _1478_ _1479_ vssd1 vssd1 vccd1 vccd1 _1481_ sky130_fd_sc_hd__xor2_1
XFILLER_5_290 vssd1 vssd1 vccd1 vccd1 sky130_fd_sc_hd__fill_1
X_5243_ _0349_ _0351_ _0348_ vssd1 vssd1 vccd1 vccd1 _0433_ sky130_fd_sc_hd__a21bo_1
X_8031_ _3283_ _3284_ vssd1 vssd1 vccd1 vccd1 _3285_ sky130_fd_sc_hd__xor2_1
XANTENNA__8227__B2 net205 vssd1 vssd1 vccd1 vccd1 sky130_fd_sc_hd__diode_2
XANTENNA__8227__A1 net201 vssd1 vssd1 vccd1 vccd1 sky130_fd_sc_hd__diode_2
XFILLER_68_231 vssd1 vssd1 vccd1 vccd1 sky130_fd_sc_hd__fill_1
Xhold19 net26 vssd1 vssd1 vccd1 vccd1 net412 sky130_fd_sc_hd__dlygate4sd3_1
X_5174_ _0362_ _0363_ vssd1 vssd1 vccd1 vccd1 _0364_ sky130_fd_sc_hd__nor2_1
XFILLER_68_253 vssd1 vssd1 vccd1 vccd1 sky130_fd_sc_hd__fill_8
XFILLER_83_223 vssd1 vssd1 vccd1 vccd1 sky130_fd_sc_hd__fill_1
XTAP_TAPCELL_ROW_3_227 vssd1 vccd1 sky130_fd_sc_hd__tapvpwrvgnd_1
XFILLER_28_139 vssd1 vssd1 vccd1 vccd1 sky130_fd_sc_hd__fill_1
XFILLER_83_256 vssd1 vssd1 vccd1 vccd1 sky130_fd_sc_hd__fill_4
XPHY_EDGE_ROW_58_Right_58 vssd1 vssd1 vccd1 vccd1 sky130_fd_sc_hd__decap_3
XFILLER_83_278 vssd1 vssd1 vccd1 vccd1 sky130_fd_sc_hd__fill_2
XFILLER_64_470 vssd1 vssd1 vccd1 vccd1 sky130_fd_sc_hd__fill_1
XFILLER_64_481 vssd1 vssd1 vccd1 vccd1 sky130_fd_sc_hd__fill_1
XTAP_TAPCELL_ROW_19_392 vssd1 vccd1 sky130_fd_sc_hd__tapvpwrvgnd_1
X_7815_ _2825_ _2831_ _2824_ vssd1 vssd1 vccd1 vccd1 _3071_ sky130_fd_sc_hd__a21oi_2
XFILLER_24_356 vssd1 vssd1 vccd1 vccd1 sky130_fd_sc_hd__fill_1
X_7746_ _2992_ _3000_ vssd1 vssd1 vccd1 vccd1 _3002_ sky130_fd_sc_hd__xnor2_1
X_4958_ net114 net56 vssd1 vssd1 vccd1 vccd1 _0148_ sky130_fd_sc_hd__nor2_2
XFILLER_24_389 vccd1 vssd1 vccd1 vssd1 sky130_ef_sc_hd__decap_40_12
X_7677_ _2694_ _2697_ _2693_ vssd1 vssd1 vccd1 vccd1 _2931_ sky130_fd_sc_hd__o21ba_1
X_4889_ _2389_ net71 _4107_ _4109_ vssd1 vssd1 vccd1 vccd1 _0079_ sky130_fd_sc_hd__o31ai_2
X_6628_ _1819_ _1820_ vssd1 vssd1 vccd1 vccd1 _1821_ sky130_fd_sc_hd__nor2_1
XFILLER_20_562 vssd1 vssd1 vccd1 vccd1 sky130_fd_sc_hd__fill_8
XPHY_EDGE_ROW_67_Right_67 vssd1 vssd1 vccd1 vccd1 sky130_fd_sc_hd__decap_3
X_6559_ PID_INST.k3_calc.d2.y\[2\] _1391_ _1392_ vssd1 vssd1 vccd1 vccd1 _1746_ sky130_fd_sc_hd__and3_1
X_8229_ _3496_ _3497_ vssd1 vssd1 vccd1 vccd1 _3498_ sky130_fd_sc_hd__nor2_1
XFILLER_79_529 vssd1 vssd1 vccd1 vccd1 sky130_fd_sc_hd__fill_4
XANTENNA__4838__A net129 vssd1 vssd1 vccd1 vccd1 sky130_fd_sc_hd__diode_2
XFILLER_86_14 vssd1 vssd1 vccd1 vccd1 sky130_fd_sc_hd__fill_1
XANTENNA__8218__A1 net317 vssd1 vssd1 vccd1 vccd1 sky130_fd_sc_hd__diode_2
XPHY_EDGE_ROW_76_Right_76 vssd1 vssd1 vccd1 vccd1 sky130_fd_sc_hd__decap_3
XFILLER_19_41 vssd1 vssd1 vccd1 vccd1 sky130_fd_sc_hd__fill_1
XANTENNA_fanout58_X net58 vssd1 vssd1 vccd1 vccd1 sky130_fd_sc_hd__diode_2
XFILLER_74_289 vccd1 vssd1 vccd1 vssd1 sky130_ef_sc_hd__decap_40_12
XFILLER_62_418 vssd1 vssd1 vccd1 vccd1 sky130_fd_sc_hd__fill_2
XFILLER_15_301 vssd1 vssd1 vccd1 vccd1 sky130_fd_sc_hd__fill_2
XTAP_TAPCELL_ROW_45_649 vssd1 vccd1 sky130_fd_sc_hd__tapvpwrvgnd_1
XFILLER_15_334 vssd1 vssd1 vccd1 vccd1 sky130_fd_sc_hd__fill_2
XFILLER_70_451 vssd1 vssd1 vccd1 vccd1 sky130_fd_sc_hd__fill_1
XFILLER_15_356 vccd1 vssd1 vccd1 vssd1 sky130_ef_sc_hd__decap_40_12
XFILLER_35_73 vssd1 vssd1 vccd1 vccd1 sky130_fd_sc_hd__fill_4
XFILLER_35_84 vssd1 vssd1 vccd1 vccd1 sky130_fd_sc_hd__fill_1
XFILLER_42_175 vssd1 vssd1 vccd1 vccd1 sky130_fd_sc_hd__fill_4
XFILLER_42_186 vssd1 vssd1 vccd1 vccd1 sky130_fd_sc_hd__fill_8
XPHY_EDGE_ROW_85_Right_85 vssd1 vssd1 vccd1 vccd1 sky130_fd_sc_hd__decap_3
XANTENNA__5912__C1 _1100_ vssd1 vssd1 vccd1 vccd1 sky130_fd_sc_hd__diode_2
XFILLER_65_223 vssd1 vssd1 vccd1 vccd1 sky130_fd_sc_hd__fill_1
XFILLER_65_267 vssd1 vssd1 vccd1 vccd1 sky130_fd_sc_hd__fill_4
XFILLER_53_418 vssd1 vssd1 vccd1 vccd1 sky130_fd_sc_hd__fill_8
X_5930_ net111 net50 _1118_ vssd1 vssd1 vccd1 vccd1 _1120_ sky130_fd_sc_hd__o21ai_1
XFILLER_18_194 vssd1 vssd1 vccd1 vccd1 sky130_fd_sc_hd__fill_2
X_5861_ _1007_ _1026_ _1046_ _1049_ vssd1 vssd1 vccd1 vccd1 _1051_ sky130_fd_sc_hd__o211a_1
X_7600_ _2849_ _2850_ vssd1 vssd1 vccd1 vccd1 _2851_ sky130_fd_sc_hd__nor2_1
XANTENNA__8105__D net187 vssd1 vssd1 vccd1 vccd1 sky130_fd_sc_hd__diode_2
X_5792_ _0980_ _0981_ vssd1 vssd1 vccd1 vccd1 _0982_ sky130_fd_sc_hd__nand2b_1
XFILLER_61_484 vssd1 vssd1 vccd1 vccd1 sky130_fd_sc_hd__fill_1
X_4812_ net139 net61 vssd1 vssd1 vccd1 vccd1 _4090_ sky130_fd_sc_hd__nor2_1
XTAP_TAPCELL_ROW_16_362 vssd1 vccd1 sky130_fd_sc_hd__tapvpwrvgnd_1
XFILLER_21_337 vccd1 vssd1 vccd1 vssd1 sky130_ef_sc_hd__decap_40_12
XFILLER_33_164 vssd1 vssd1 vccd1 vccd1 sky130_fd_sc_hd__fill_2
XANTENNA__8145__B1 _3406_ vssd1 vssd1 vccd1 vccd1 sky130_fd_sc_hd__diode_2
X_4743_ net97 net63 vssd1 vssd1 vccd1 vccd1 _4021_ sky130_fd_sc_hd__or2_1
X_7531_ _2765_ _2777_ vssd1 vssd1 vccd1 vccd1 _2778_ sky130_fd_sc_hd__xnor2_1
X_7462_ _2586_ _2588_ _2702_ vssd1 vssd1 vccd1 vccd1 _2704_ sky130_fd_sc_hd__nand3_1
X_4674_ net142 net86 _3932_ _3933_ vssd1 vssd1 vccd1 vccd1 _3952_ sky130_fd_sc_hd__a22o_1
X_6413_ _1600_ _1490_ vssd1 vssd1 vccd1 vccd1 _1601_ sky130_fd_sc_hd__and2b_1
X_7393_ _2629_ _2630_ vssd1 vssd1 vccd1 vccd1 _2631_ sky130_fd_sc_hd__nand2_1
X_6344_ _1332_ _1334_ _1531_ vssd1 vssd1 vccd1 vccd1 _1532_ sky130_fd_sc_hd__o21ai_1
XANTENNA__6857__B net58 vssd1 vssd1 vccd1 vccd1 sky130_fd_sc_hd__diode_2
X_6275_ _1239_ _1265_ _1462_ vssd1 vssd1 vccd1 vccd1 _1464_ sky130_fd_sc_hd__nand3_1
XFILLER_0_219 vssd1 vssd1 vccd1 vccd1 sky130_fd_sc_hd__fill_4
X_5226_ net149 _3752_ _3755_ vssd1 vssd1 vccd1 vccd1 _0416_ sky130_fd_sc_hd__or3_1
X_8014_ net90 net46 vssd1 vssd1 vccd1 vccd1 _3268_ sky130_fd_sc_hd__nor2_1
XFILLER_56_212 vssd1 vssd1 vccd1 vccd1 sky130_fd_sc_hd__fill_1
X_5157_ _0190_ _0281_ _0282_ _0277_ vssd1 vssd1 vccd1 vccd1 _0347_ sky130_fd_sc_hd__a22o_1
X_5088_ PID_INST.k3_calc.d1.y\[8\] net83 vssd1 vssd1 vccd1 vccd1 _0278_ sky130_fd_sc_hd__and2_1
XANTENNA_fanout262_X net262 vssd1 vssd1 vccd1 vccd1 sky130_fd_sc_hd__diode_2
XFILLER_71_204 vssd1 vssd1 vccd1 vccd1 sky130_fd_sc_hd__fill_4
XANTENNA__4393__A net194 vssd1 vssd1 vccd1 vccd1 sky130_fd_sc_hd__diode_2
XFILLER_44_429 vssd1 vssd1 vccd1 vccd1 sky130_fd_sc_hd__fill_2
XFILLER_37_492 vssd1 vssd1 vccd1 vccd1 sky130_fd_sc_hd__fill_2
XFILLER_52_462 vssd1 vssd1 vccd1 vccd1 sky130_fd_sc_hd__fill_2
XFILLER_24_131 vssd1 vssd1 vccd1 vccd1 sky130_fd_sc_hd__fill_4
XTAP_TAPCELL_ROW_42_619 vssd1 vccd1 sky130_fd_sc_hd__tapvpwrvgnd_1
X_7729_ net317 net179 vssd1 vssd1 vccd1 vccd1 _2985_ sky130_fd_sc_hd__nand2_1
XFILLER_8_319 vssd1 vssd1 vccd1 vccd1 sky130_fd_sc_hd__fill_1
XFILLER_24_197 vssd1 vssd1 vccd1 vccd1 sky130_fd_sc_hd__fill_2
XANTENNA__4917__A2_N net81 vssd1 vssd1 vccd1 vccd1 sky130_fd_sc_hd__diode_2
XTAP_TAPCELL_ROW_50_696 vssd1 vccd1 sky130_fd_sc_hd__tapvpwrvgnd_1
XFILLER_21_97 vssd1 vssd1 vccd1 vccd1 sky130_fd_sc_hd__fill_2
XFILLER_79_337 vssd1 vssd1 vccd1 vccd1 sky130_fd_sc_hd__fill_1
XFILLER_79_359 vssd1 vssd1 vccd1 vccd1 sky130_fd_sc_hd__fill_1
XFILLER_87_370 vssd1 vssd1 vccd1 vccd1 sky130_fd_sc_hd__fill_8
XFILLER_47_245 vssd1 vssd1 vccd1 vccd1 sky130_fd_sc_hd__fill_1
XTAP_TAPCELL_ROW_58_785 vssd1 vccd1 sky130_fd_sc_hd__tapvpwrvgnd_1
XFILLER_90_557 vssd1 vssd1 vccd1 vccd1 sky130_fd_sc_hd__fill_8
XTAP_TAPCELL_ROW_83_1032 vssd1 vccd1 sky130_fd_sc_hd__tapvpwrvgnd_1
XANTENNA__5728__A2 net288 vssd1 vssd1 vccd1 vccd1 sky130_fd_sc_hd__diode_2
XFILLER_43_473 vssd1 vssd1 vccd1 vccd1 sky130_fd_sc_hd__fill_2
XTAP_TAPCELL_ROW_13_332 vssd1 vccd1 sky130_fd_sc_hd__tapvpwrvgnd_1
XFILLER_30_145 vssd1 vssd1 vccd1 vccd1 sky130_fd_sc_hd__fill_1
XFILLER_7_11 vssd1 vssd1 vccd1 vccd1 sky130_fd_sc_hd__fill_2
XFILLER_7_55 vssd1 vssd1 vccd1 vccd1 sky130_fd_sc_hd__fill_1
XFILLER_7_22 vccd1 vssd1 vccd1 vssd1 sky130_ef_sc_hd__decap_40_12
XFILLER_7_374 vssd1 vssd1 vccd1 vccd1 sky130_fd_sc_hd__fill_4
XFILLER_7_352 vssd1 vssd1 vccd1 vccd1 sky130_fd_sc_hd__fill_4
XANTENNA__6958__A net95 vssd1 vssd1 vccd1 vccd1 sky130_fd_sc_hd__diode_2
X_4390_ _3679_ _3682_ vssd1 vssd1 vccd1 vccd1 _3683_ sky130_fd_sc_hd__xnor2_1
XANTENNA__7102__A1 net230 vssd1 vssd1 vccd1 vccd1 sky130_fd_sc_hd__diode_2
X_6060_ net220 net295 vssd1 vssd1 vccd1 vccd1 _1250_ sky130_fd_sc_hd__nand2_1
X_5011_ net130 net82 vssd1 vssd1 vccd1 vccd1 _0201_ sky130_fd_sc_hd__nand2_1
XFILLER_66_554 vssd1 vssd1 vccd1 vccd1 sky130_fd_sc_hd__fill_1
XFILLER_38_267 vssd1 vssd1 vccd1 vccd1 sky130_fd_sc_hd__fill_8
XFILLER_53_237 vssd1 vssd1 vccd1 vccd1 sky130_fd_sc_hd__fill_1
X_6962_ _2173_ _2174_ vssd1 vssd1 vccd1 vccd1 _2175_ sky130_fd_sc_hd__xnor2_1
XFILLER_81_568 vssd1 vssd1 vccd1 vccd1 sky130_fd_sc_hd__fill_2
XANTENNA__5596__X _0786_ vssd1 vssd1 vccd1 vccd1 sky130_fd_sc_hd__diode_2
XFILLER_53_259 vssd1 vssd1 vccd1 vccd1 sky130_fd_sc_hd__fill_1
X_5913_ net139 net56 vssd1 vssd1 vccd1 vccd1 _1103_ sky130_fd_sc_hd__nor2_1
X_6893_ _1688_ _1801_ _1800_ vssd1 vssd1 vccd1 vccd1 _2102_ sky130_fd_sc_hd__a21oi_1
X_5844_ _0981_ _1030_ _1033_ vssd1 vssd1 vccd1 vccd1 _1034_ sky130_fd_sc_hd__or3_1
XFILLER_34_484 vccd1 vssd1 vccd1 vssd1 sky130_ef_sc_hd__decap_40_12
XFILLER_61_281 vssd1 vssd1 vccd1 vccd1 sky130_fd_sc_hd__fill_8
XFILLER_21_134 vssd1 vssd1 vccd1 vccd1 sky130_fd_sc_hd__fill_2
X_5775_ net242 net288 _0955_ _0957_ vssd1 vssd1 vccd1 vccd1 _0965_ sky130_fd_sc_hd__a211oi_1
X_7514_ _2756_ _2757_ vssd1 vssd1 vccd1 vccd1 _2759_ sky130_fd_sc_hd__xnor2_1
XANTENNA_fanout222_A net225 vssd1 vssd1 vccd1 vccd1 sky130_fd_sc_hd__diode_2
X_4726_ _4003_ _3992_ vssd1 vssd1 vccd1 vccd1 _4004_ sky130_fd_sc_hd__and2b_1
X_7445_ _2576_ _2590_ _2684_ vssd1 vssd1 vccd1 vccd1 _2686_ sky130_fd_sc_hd__and3_1
X_4657_ _3932_ _3934_ vssd1 vssd1 vccd1 vccd1 _3935_ sky130_fd_sc_hd__nand2_1
X_7376_ _2611_ _2613_ vssd1 vssd1 vccd1 vccd1 _2614_ sky130_fd_sc_hd__nand2_1
X_4588_ net124 net144 _3847_ _3863_ vssd1 vssd1 vccd1 vccd1 _3866_ sky130_fd_sc_hd__a22o_1
XFILLER_1_517 vccd1 vssd1 vccd1 vssd1 sky130_ef_sc_hd__decap_40_12
X_6327_ _1314_ _1513_ vssd1 vssd1 vccd1 vccd1 _1515_ sky130_fd_sc_hd__xnor2_1
XANTENNA_fanout108_X net108 vssd1 vssd1 vccd1 vccd1 sky130_fd_sc_hd__diode_2
X_6258_ net228 net284 net279 net231 vssd1 vssd1 vccd1 vccd1 _1447_ sky130_fd_sc_hd__a22oi_1
XFILLER_69_370 vssd1 vssd1 vccd1 vccd1 sky130_fd_sc_hd__fill_2
X_5209_ _0396_ _0397_ vssd1 vssd1 vccd1 vccd1 _0399_ sky130_fd_sc_hd__xor2_1
X_6189_ _1167_ _1170_ _1377_ vssd1 vssd1 vccd1 vccd1 _1378_ sky130_fd_sc_hd__a21oi_1
XFILLER_57_554 vssd1 vssd1 vccd1 vccd1 sky130_fd_sc_hd__fill_2
XFILLER_29_278 vssd1 vssd1 vccd1 vccd1 sky130_fd_sc_hd__fill_2
XFILLER_83_37 vssd1 vssd1 vccd1 vccd1 sky130_fd_sc_hd__fill_8
XFILLER_72_524 vssd1 vssd1 vccd1 vccd1 sky130_fd_sc_hd__fill_8
XTAP_TAPCELL_ROW_55_755 vssd1 vccd1 sky130_fd_sc_hd__tapvpwrvgnd_1
XTAP_TAPCELL_ROW_27_468 vssd1 vccd1 sky130_fd_sc_hd__tapvpwrvgnd_1
XFILLER_12_101 vccd1 vssd1 vccd1 vssd1 sky130_ef_sc_hd__decap_40_12
XFILLER_12_134 vssd1 vssd1 vccd1 vccd1 sky130_fd_sc_hd__fill_4
XFILLER_40_421 vssd1 vssd1 vccd1 vccd1 sky130_fd_sc_hd__fill_2
XFILLER_40_454 vssd1 vssd1 vccd1 vccd1 sky130_fd_sc_hd__fill_4
XFILLER_8_105 vssd1 vssd1 vccd1 vccd1 sky130_fd_sc_hd__fill_4
XTAP_TAPCELL_ROW_10_302 vssd1 vccd1 sky130_fd_sc_hd__tapvpwrvgnd_1
XANTENNA__4697__A2 net86 vssd1 vssd1 vccd1 vccd1 sky130_fd_sc_hd__diode_2
XFILLER_79_189 vssd1 vssd1 vccd1 vccd1 sky130_fd_sc_hd__fill_8
XFILLER_79_167 vssd1 vssd1 vccd1 vccd1 sky130_fd_sc_hd__fill_1
XFILLER_57_82 vssd1 vssd1 vccd1 vccd1 sky130_fd_sc_hd__fill_2
XANTENNA_clkload0_A clknet_4_0_0_clk vssd1 vssd1 vccd1 vccd1 sky130_fd_sc_hd__diode_2
XFILLER_35_248 vssd1 vssd1 vccd1 vccd1 sky130_fd_sc_hd__fill_2
XFILLER_16_473 vssd1 vssd1 vccd1 vccd1 sky130_fd_sc_hd__fill_2
XFILLER_43_270 vssd1 vssd1 vccd1 vccd1 sky130_fd_sc_hd__fill_8
XANTENNA__4480__B net79 vssd1 vssd1 vccd1 vccd1 sky130_fd_sc_hd__diode_2
XFILLER_31_487 vccd1 vssd1 vccd1 vssd1 sky130_ef_sc_hd__decap_40_12
X_5560_ _0748_ _0749_ vssd1 vssd1 vccd1 vccd1 _0750_ sky130_fd_sc_hd__nor2_1
X_4511_ _3787_ _3788_ vssd1 vssd1 vccd1 vccd1 _3789_ sky130_fd_sc_hd__xnor2_2
X_5491_ _0635_ _0640_ vssd1 vssd1 vccd1 vccd1 _0681_ sky130_fd_sc_hd__xnor2_1
X_7230_ _2458_ _2449_ vssd1 vssd1 vccd1 vccd1 _2459_ sky130_fd_sc_hd__nand2b_1
X_4442_ PID_INST.k1_calc.d1.x\[2\] PID_INST.k3_calc.prev_error\[2\] vssd1 vssd1 vccd1
+ vccd1 _3720_ sky130_fd_sc_hd__or2_1
X_7161_ _2383_ _2384_ vssd1 vssd1 vccd1 vccd1 _2385_ sky130_fd_sc_hd__nor2_1
X_4373_ _3665_ _3666_ _3663_ vssd1 vssd1 vccd1 vccd1 _3668_ sky130_fd_sc_hd__o21a_1
X_6112_ _1299_ _1300_ vssd1 vssd1 vccd1 vccd1 _1301_ sky130_fd_sc_hd__nor2_1
X_7092_ _2311_ _2312_ vssd1 vssd1 vccd1 vccd1 _2313_ sky130_fd_sc_hd__xor2_1
XFILLER_85_115 vssd1 vssd1 vccd1 vccd1 sky130_fd_sc_hd__fill_1
X_6043_ _0796_ _0798_ _0797_ vssd1 vssd1 vccd1 vccd1 _1233_ sky130_fd_sc_hd__o21ba_1
XANTENNA__4936__A _2051_ vssd1 vssd1 vccd1 vccd1 sky130_fd_sc_hd__diode_2
XFILLER_85_159 vssd1 vssd1 vccd1 vccd1 sky130_fd_sc_hd__fill_1
XFILLER_85_126 vssd1 vssd1 vccd1 vccd1 sky130_fd_sc_hd__fill_4
X_7994_ _3031_ _3039_ vssd1 vssd1 vccd1 vccd1 _3249_ sky130_fd_sc_hd__nand2_1
XFILLER_81_332 vssd1 vssd1 vccd1 vccd1 sky130_fd_sc_hd__fill_1
XFILLER_66_395 vssd1 vssd1 vccd1 vccd1 sky130_fd_sc_hd__fill_1
XANTENNA__7966__B net183 vssd1 vssd1 vccd1 vccd1 sky130_fd_sc_hd__diode_2
XFILLER_81_343 vssd1 vssd1 vccd1 vccd1 sky130_fd_sc_hd__fill_2
X_6945_ _2118_ _2156_ vssd1 vssd1 vccd1 vccd1 _2157_ sky130_fd_sc_hd__xnor2_1
XTAP_TAPCELL_ROW_52_725 vssd1 vccd1 sky130_fd_sc_hd__tapvpwrvgnd_1
XFILLER_41_229 vssd1 vssd1 vccd1 vccd1 sky130_fd_sc_hd__fill_1
XTAP_TAPCELL_ROW_24_438 vssd1 vccd1 sky130_fd_sc_hd__tapvpwrvgnd_1
X_6876_ net119 net45 vssd1 vssd1 vccd1 vccd1 _2085_ sky130_fd_sc_hd__nor2_1
XFILLER_34_281 vssd1 vssd1 vccd1 vccd1 sky130_fd_sc_hd__fill_4
X_5827_ _1015_ _1016_ vssd1 vssd1 vccd1 vccd1 _1017_ sky130_fd_sc_hd__and2b_1
X_5758_ _0934_ _0937_ vssd1 vssd1 vccd1 vccd1 _0948_ sky130_fd_sc_hd__xnor2_1
XANTENNA_fanout225_X net225 vssd1 vssd1 vccd1 vccd1 sky130_fd_sc_hd__diode_2
X_8477_ clknet_4_15_0_clk _0065_ net341 vssd1 vssd1 vccd1 vccd1 net26 sky130_fd_sc_hd__dfrtp_1
X_4709_ _3981_ _3986_ vssd1 vssd1 vccd1 vccd1 _3987_ sky130_fd_sc_hd__xor2_1
XANTENNA__6598__A net114 vssd1 vssd1 vccd1 vccd1 sky130_fd_sc_hd__diode_2
X_7428_ _2565_ _2573_ _2667_ vssd1 vssd1 vccd1 vccd1 _2668_ sky130_fd_sc_hd__a21o_1
X_5689_ _0878_ vssd1 vssd1 vccd1 vccd1 _0879_ sky130_fd_sc_hd__inv_2
X_7359_ _2355_ _2364_ _2363_ vssd1 vssd1 vccd1 vccd1 _2595_ sky130_fd_sc_hd__a21oi_1
XFILLER_78_59 vssd1 vssd1 vccd1 vccd1 sky130_fd_sc_hd__fill_4
XANTENNA__4300__A1 net19 vssd1 vssd1 vccd1 vccd1 sky130_fd_sc_hd__diode_2
XTAP_TAPCELL_ROW_68_880 vssd1 vccd1 sky130_fd_sc_hd__tapvpwrvgnd_1
XANTENNA__8042__A2 net37 vssd1 vssd1 vccd1 vccd1 sky130_fd_sc_hd__diode_2
XFILLER_27_41 vssd1 vssd1 vccd1 vccd1 sky130_fd_sc_hd__fill_2
XFILLER_27_52 vssd1 vssd1 vccd1 vccd1 sky130_fd_sc_hd__fill_1
XFILLER_72_343 vssd1 vssd1 vccd1 vccd1 sky130_fd_sc_hd__fill_4
XFILLER_17_259 vccd1 vssd1 vccd1 vssd1 sky130_ef_sc_hd__decap_40_12
XFILLER_27_74 vssd1 vssd1 vccd1 vccd1 sky130_fd_sc_hd__fill_2
XANTENNA__7876__B net42 vssd1 vssd1 vccd1 vccd1 sky130_fd_sc_hd__diode_2
XANTENNA_fanout40_X net40 vssd1 vssd1 vccd1 vccd1 sky130_fd_sc_hd__diode_2
XTAP_TAPCELL_ROW_80_1002 vssd1 vccd1 sky130_fd_sc_hd__tapvpwrvgnd_1
XFILLER_60_516 vssd1 vssd1 vccd1 vccd1 sky130_fd_sc_hd__fill_4
XFILLER_25_281 vssd1 vssd1 vccd1 vccd1 sky130_fd_sc_hd__fill_2
XFILLER_9_425 vssd1 vssd1 vccd1 vccd1 sky130_fd_sc_hd__fill_2
XFILLER_40_295 vccd1 vssd1 vccd1 vssd1 sky130_ef_sc_hd__decap_40_12
XANTENNA__7305__A1 net108 vssd1 vssd1 vccd1 vccd1 sky130_fd_sc_hd__diode_2
XFILLER_4_185 vssd1 vssd1 vccd1 vccd1 sky130_fd_sc_hd__fill_8
XFILLER_4_45 vccd1 vssd1 vccd1 vssd1 sky130_ef_sc_hd__decap_40_12
XFILLER_67_115 vssd1 vssd1 vccd1 vccd1 sky130_fd_sc_hd__fill_4
XANTENNA__8228__A net202 vssd1 vssd1 vccd1 vccd1 sky130_fd_sc_hd__diode_2
XANTENNA__7132__A net308 vssd1 vssd1 vccd1 vccd1 sky130_fd_sc_hd__diode_2
XFILLER_0_391 vssd1 vssd1 vccd1 vccd1 sky130_fd_sc_hd__fill_1
XFILLER_82_107 vssd1 vssd1 vccd1 vccd1 sky130_fd_sc_hd__fill_4
XTAP_TAPCELL_ROW_89_1093 vssd1 vccd1 sky130_fd_sc_hd__tapvpwrvgnd_1
XFILLER_63_332 vssd1 vssd1 vccd1 vccd1 sky130_fd_sc_hd__fill_4
XFILLER_51_505 vssd1 vssd1 vccd1 vccd1 sky130_fd_sc_hd__fill_1
XFILLER_36_557 vssd1 vssd1 vccd1 vccd1 sky130_fd_sc_hd__fill_1
X_6730_ _1830_ _1833_ _1927_ vssd1 vssd1 vccd1 vccd1 _1929_ sky130_fd_sc_hd__o21ai_1
XFILLER_23_218 vssd1 vssd1 vccd1 vccd1 sky130_fd_sc_hd__fill_4
X_4991_ net163 net153 vssd1 vssd1 vccd1 vccd1 _0181_ sky130_fd_sc_hd__nand2_1
X_6661_ _1854_ _1855_ vssd1 vssd1 vccd1 vccd1 _1856_ sky130_fd_sc_hd__nor2_1
XTAP_TAPCELL_ROW_21_408 vssd1 vccd1 sky130_fd_sc_hd__tapvpwrvgnd_1
X_5612_ _0767_ _0770_ _0800_ vssd1 vssd1 vccd1 vccd1 _0802_ sky130_fd_sc_hd__or3_1
X_8400_ clknet_4_3_0_clk _0020_ net331 vssd1 vssd1 vccd1 vccd1 PID_INST.k2_calc.reg_lc\[4\]
+ sky130_fd_sc_hd__dfrtp_1
X_6592_ _1779_ _1780_ vssd1 vssd1 vccd1 vccd1 _1781_ sky130_fd_sc_hd__nor2_1
X_8331_ _3484_ _3520_ _3518_ vssd1 vssd1 vccd1 vccd1 _3608_ sky130_fd_sc_hd__a21oi_1
X_5543_ net236 net288 _0731_ _0729_ vssd1 vssd1 vccd1 vccd1 _0733_ sky130_fd_sc_hd__a31o_1
XANTENNA__7307__A net108 vssd1 vssd1 vccd1 vccd1 sky130_fd_sc_hd__diode_2
X_8262_ _3402_ _3404_ _3533_ vssd1 vssd1 vccd1 vccd1 _3534_ sky130_fd_sc_hd__o21a_1
X_5474_ net107 net60 vssd1 vssd1 vccd1 vccd1 _0664_ sky130_fd_sc_hd__nor2_1
X_8193_ _3374_ _3378_ _3457_ vssd1 vssd1 vccd1 vccd1 _3459_ sky130_fd_sc_hd__or3b_1
X_4425_ PID_INST.k2_calc.sum_reg\[23\] PID_INST.k2_calc.sum_reg\[24\] _3705_ vssd1
+ vssd1 vccd1 vccd1 _3707_ sky130_fd_sc_hd__and3_1
X_7213_ _2437_ _2439_ vssd1 vssd1 vccd1 vccd1 _2440_ sky130_fd_sc_hd__nand2_1
X_7144_ _2252_ _2254_ _2365_ vssd1 vssd1 vccd1 vccd1 _2367_ sky130_fd_sc_hd__nand3_1
X_4356_ _3650_ _3651_ _3653_ vssd1 vssd1 vccd1 vccd1 _3654_ sky130_fd_sc_hd__o21ai_1
X_7075_ _2286_ _2287_ _2294_ vssd1 vssd1 vccd1 vccd1 _2295_ sky130_fd_sc_hd__nand3_1
X_4287_ net5 PID_INST.k1_calc.d1.x\[10\] net158 vssd1 vssd1 vccd1 vccd1 _0010_ sky130_fd_sc_hd__mux2_1
X_6026_ net324 net199 _1212_ _1214_ vssd1 vssd1 vccd1 vccd1 _1216_ sky130_fd_sc_hd__o2bb2a_1
XANTENNA__4294__A0 net321 vssd1 vssd1 vccd1 vccd1 sky130_fd_sc_hd__diode_2
XFILLER_27_502 vssd1 vssd1 vccd1 vccd1 sky130_fd_sc_hd__fill_2
XFILLER_54_321 vccd1 vssd1 vccd1 vssd1 sky130_ef_sc_hd__decap_40_12
XANTENNA_fanout175_X net175 vssd1 vssd1 vccd1 vccd1 sky130_fd_sc_hd__diode_2
XTAP_TAPCELL_ROW_65_850 vssd1 vccd1 sky130_fd_sc_hd__tapvpwrvgnd_1
XFILLER_27_568 vssd1 vssd1 vccd1 vccd1 sky130_fd_sc_hd__fill_2
X_7977_ _3212_ _3231_ vssd1 vssd1 vccd1 vccd1 _3232_ sky130_fd_sc_hd__or2_1
XFILLER_54_365 vssd1 vssd1 vccd1 vccd1 sky130_fd_sc_hd__fill_4
XTAP_TAPCELL_ROW_37_574 vssd1 vccd1 sky130_fd_sc_hd__tapvpwrvgnd_1
X_6928_ _2007_ _2018_ _2015_ vssd1 vssd1 vccd1 vccd1 _2139_ sky130_fd_sc_hd__a21oi_1
Xfanout55 _0147_ vssd1 vssd1 vccd1 vccd1 net55 sky130_fd_sc_hd__buf_2
X_6859_ PID_INST.k3_calc.d2.y\[10\] _0145_ _0146_ _2064_ vssd1 vssd1 vccd1 vccd1 _2066_
+ sky130_fd_sc_hd__a31o_1
Xfanout44 _0548_ vssd1 vssd1 vccd1 vccd1 net44 sky130_fd_sc_hd__buf_2
Xfanout77 _3831_ vssd1 vssd1 vccd1 vccd1 net77 sky130_fd_sc_hd__clkbuf_2
XFILLER_10_413 vssd1 vssd1 vccd1 vccd1 sky130_fd_sc_hd__fill_2
Xfanout66 _3964_ vssd1 vssd1 vccd1 vccd1 net66 sky130_fd_sc_hd__clkbuf_2
XFILLER_13_10 vssd1 vssd1 vccd1 vccd1 sky130_fd_sc_hd__fill_1
Xfanout88 net89 vssd1 vssd1 vccd1 vccd1 net88 sky130_fd_sc_hd__buf_2
Xfanout99 net100 vssd1 vssd1 vccd1 vccd1 net99 sky130_fd_sc_hd__clkbuf_4
XFILLER_13_54 vssd1 vssd1 vccd1 vccd1 sky130_fd_sc_hd__fill_2
XFILLER_6_428 vssd1 vssd1 vccd1 vccd1 sky130_fd_sc_hd__fill_2
XFILLER_89_47 vssd1 vssd1 vccd1 vccd1 sky130_fd_sc_hd__fill_1
XFILLER_8_3 vssd1 vssd1 vccd1 vccd1 sky130_fd_sc_hd__fill_4
XFILLER_1_133 vssd1 vssd1 vccd1 vccd1 sky130_fd_sc_hd__fill_1
XANTENNA__5960__A _2051_ vssd1 vssd1 vccd1 vccd1 sky130_fd_sc_hd__diode_2
XFILLER_49_104 vssd1 vssd1 vccd1 vccd1 sky130_fd_sc_hd__fill_8
XTAP_TAPCELL_ROW_9_288 vssd1 vccd1 sky130_fd_sc_hd__tapvpwrvgnd_1
XANTENNA_fanout88_X net88 vssd1 vssd1 vccd1 vccd1 sky130_fd_sc_hd__diode_2
XFILLER_89_295 vccd1 vssd1 vccd1 vssd1 sky130_ef_sc_hd__decap_40_12
XFILLER_1_199 vssd1 vssd1 vccd1 vccd1 sky130_fd_sc_hd__fill_1
XFILLER_92_405 vccd1 vssd1 vccd1 vssd1 sky130_ef_sc_hd__decap_40_12
XANTENNA__4285__A0 net3 vssd1 vssd1 vccd1 vccd1 sky130_fd_sc_hd__diode_2
XFILLER_92_449 vccd1 vssd1 vccd1 vssd1 sky130_ef_sc_hd__decap_40_12
XFILLER_45_310 vssd1 vssd1 vccd1 vccd1 sky130_fd_sc_hd__fill_1
XFILLER_60_302 vssd1 vssd1 vccd1 vccd1 sky130_fd_sc_hd__fill_2
XFILLER_45_376 vssd1 vssd1 vccd1 vccd1 sky130_fd_sc_hd__fill_2
XFILLER_33_505 vssd1 vssd1 vccd1 vccd1 sky130_fd_sc_hd__fill_1
XFILLER_60_335 vccd1 vssd1 vccd1 vssd1 sky130_ef_sc_hd__decap_40_12
XFILLER_33_538 vssd1 vssd1 vccd1 vccd1 sky130_fd_sc_hd__fill_1
XFILLER_9_200 vssd1 vssd1 vccd1 vccd1 sky130_fd_sc_hd__fill_1
XFILLER_13_262 vccd1 vssd1 vccd1 vssd1 sky130_ef_sc_hd__decap_40_12
Xclkload14 clknet_4_15_0_clk vssd1 vssd1 vccd1 vccd1 clkload14/Y sky130_fd_sc_hd__inv_8
XANTENNA__8383__RESET_B net340 vssd1 vssd1 vccd1 vccd1 sky130_fd_sc_hd__diode_2
XANTENNA__6031__A net203 vssd1 vssd1 vccd1 vccd1 sky130_fd_sc_hd__diode_2
X_4210_ PID_INST.k3_calc.timescaling_term\[6\] net170 vssd1 vssd1 vccd1 vccd1 _2263_
+ sky130_fd_sc_hd__or2_1
X_5190_ _0280_ _0379_ vssd1 vssd1 vccd1 vccd1 _0380_ sky130_fd_sc_hd__xnor2_1
XTAP_TAPCELL_ROW_79_986 vssd1 vccd1 sky130_fd_sc_hd__tapvpwrvgnd_1
X_7900_ net110 _1742_ net38 net140 vssd1 vssd1 vccd1 vccd1 _3155_ sky130_fd_sc_hd__o22ai_1
X_7831_ _3085_ _3086_ vssd1 vssd1 vccd1 vccd1 _3087_ sky130_fd_sc_hd__nor2_1
X_7762_ _3016_ _3017_ vssd1 vssd1 vccd1 vccd1 _3018_ sky130_fd_sc_hd__xnor2_1
XTAP_TAPCELL_ROW_62_820 vssd1 vccd1 sky130_fd_sc_hd__tapvpwrvgnd_1
XFILLER_51_346 vccd1 vssd1 vccd1 vssd1 sky130_ef_sc_hd__decap_40_12
X_4974_ _2389_ net70 _0094_ _0093_ vssd1 vssd1 vccd1 vccd1 _0164_ sky130_fd_sc_hd__o31a_1
XFILLER_24_549 vssd1 vssd1 vccd1 vccd1 sky130_fd_sc_hd__fill_1
XANTENNA__6206__A net108 vssd1 vssd1 vccd1 vccd1 sky130_fd_sc_hd__diode_2
XFILLER_36_398 vssd1 vssd1 vccd1 vccd1 sky130_fd_sc_hd__fill_2
X_7693_ _2703_ _2706_ _2946_ vssd1 vssd1 vccd1 vccd1 _2948_ sky130_fd_sc_hd__and3_1
X_6713_ _1908_ _1909_ vssd1 vssd1 vccd1 vccd1 _1910_ sky130_fd_sc_hd__nor2_1
XTAP_TAPCELL_ROW_34_544 vssd1 vccd1 sky130_fd_sc_hd__tapvpwrvgnd_1
X_6644_ _1829_ _1835_ vssd1 vssd1 vccd1 vccd1 _1837_ sky130_fd_sc_hd__xnor2_1
Xclkload8 clknet_4_9_0_clk vssd1 vssd1 vccd1 vccd1 clkload8/Y sky130_fd_sc_hd__inv_6
X_6575_ _1759_ _1760_ vssd1 vssd1 vccd1 vccd1 _1763_ sky130_fd_sc_hd__or2_1
X_8314_ _3584_ _3585_ _3586_ _3587_ vssd1 vssd1 vccd1 vccd1 _3589_ sky130_fd_sc_hd__a22o_1
XANTENNA_fanout302_A net304 vssd1 vssd1 vccd1 vccd1 sky130_fd_sc_hd__diode_2
X_5526_ _0713_ _0715_ vssd1 vssd1 vccd1 vccd1 _0716_ sky130_fd_sc_hd__and2_1
X_8245_ _3495_ _3512_ _3513_ vssd1 vssd1 vccd1 vccd1 _3516_ sky130_fd_sc_hd__and3_1
X_5457_ net60 _0646_ net103 vssd1 vssd1 vccd1 vccd1 _0647_ sky130_fd_sc_hd__a21o_1
XANTENNA__6876__A net119 vssd1 vssd1 vccd1 vccd1 sky130_fd_sc_hd__diode_2
X_4408_ _3696_ _3697_ vssd1 vssd1 vccd1 vccd1 _0048_ sky130_fd_sc_hd__and2b_1
Xfanout212 net213 vssd1 vssd1 vccd1 vccd1 net212 sky130_fd_sc_hd__clkbuf_2
Xfanout223 net225 vssd1 vssd1 vccd1 vccd1 net223 sky130_fd_sc_hd__buf_2
Xfanout201 net202 vssd1 vssd1 vccd1 vccd1 net201 sky130_fd_sc_hd__buf_2
X_8176_ _3433_ _3439_ vssd1 vssd1 vccd1 vccd1 _3441_ sky130_fd_sc_hd__xor2_1
X_5388_ _0558_ _0570_ _0577_ vssd1 vssd1 vccd1 vccd1 _0578_ sky130_fd_sc_hd__o21a_1
XANTENNA__6595__B net47 vssd1 vssd1 vccd1 vccd1 sky130_fd_sc_hd__diode_2
XFILLER_86_232 vccd1 vssd1 vccd1 vssd1 sky130_ef_sc_hd__decap_40_12
X_7127_ _2243_ _2256_ _2347_ vssd1 vssd1 vccd1 vccd1 _2349_ sky130_fd_sc_hd__and3_1
Xfanout256 net259 vssd1 vssd1 vccd1 vccd1 net256 sky130_fd_sc_hd__buf_2
XANTENNA_fanout292_X net292 vssd1 vssd1 vccd1 vccd1 sky130_fd_sc_hd__diode_2
Xfanout234 PID_INST.k2_calc.sum_reg\[4\] vssd1 vssd1 vccd1 vccd1 net234 sky130_fd_sc_hd__clkbuf_2
Xfanout245 net248 vssd1 vssd1 vccd1 vccd1 net245 sky130_fd_sc_hd__buf_2
X_4339_ _3590_ _3601_ vssd1 vssd1 vccd1 vccd1 _3612_ sky130_fd_sc_hd__xnor2_1
XTAP_TAPCELL_ROW_6_258 vssd1 vccd1 sky130_fd_sc_hd__tapvpwrvgnd_1
X_7058_ _1926_ _1929_ _2277_ vssd1 vssd1 vccd1 vccd1 _2278_ sky130_fd_sc_hd__a21o_1
XANTENNA__7453__B1 net277 vssd1 vssd1 vccd1 vccd1 sky130_fd_sc_hd__diode_2
Xfanout267 net268 vssd1 vssd1 vccd1 vccd1 net267 sky130_fd_sc_hd__clkbuf_2
Xfanout278 net280 vssd1 vssd1 vccd1 vccd1 net278 sky130_fd_sc_hd__buf_2
Xfanout289 PID_INST.k2_calc.reg_lc\[7\] vssd1 vssd1 vccd1 vccd1 net289 sky130_fd_sc_hd__buf_2
XFILLER_46_129 vssd1 vssd1 vccd1 vccd1 sky130_fd_sc_hd__fill_2
X_6009_ _1126_ _1197_ vssd1 vssd1 vccd1 vccd1 _1199_ sky130_fd_sc_hd__xor2_1
XFILLER_67_490 vssd1 vssd1 vccd1 vccd1 sky130_fd_sc_hd__fill_1
XFILLER_27_332 vssd1 vssd1 vccd1 vccd1 sky130_fd_sc_hd__fill_1
XFILLER_15_505 vssd1 vssd1 vccd1 vccd1 sky130_fd_sc_hd__fill_1
XFILLER_54_173 vssd1 vssd1 vccd1 vccd1 sky130_fd_sc_hd__fill_2
XANTENNA__6116__A net109 vssd1 vssd1 vccd1 vccd1 sky130_fd_sc_hd__diode_2
XFILLER_40_85 vssd1 vssd1 vccd1 vccd1 sky130_fd_sc_hd__fill_1
XFILLER_49_94 vssd1 vssd1 vccd1 vccd1 sky130_fd_sc_hd__fill_1
XTAP_TAPCELL_ROW_76_956 vssd1 vccd1 sky130_fd_sc_hd__tapvpwrvgnd_1
XFILLER_1_79 vssd1 vssd1 vccd1 vccd1 sky130_fd_sc_hd__fill_1
XFILLER_92_279 vssd1 vssd1 vccd1 vccd1 sky130_fd_sc_hd__fill_1
XTAP_TAPCELL_ROW_86_1063 vssd1 vccd1 sky130_fd_sc_hd__tapvpwrvgnd_1
XFILLER_80_419 vssd1 vssd1 vccd1 vccd1 sky130_fd_sc_hd__fill_1
XFILLER_45_162 vssd1 vssd1 vccd1 vccd1 sky130_fd_sc_hd__fill_1
XFILLER_45_173 vssd1 vssd1 vccd1 vccd1 sky130_fd_sc_hd__fill_1
XFILLER_33_335 vssd1 vssd1 vccd1 vccd1 sky130_fd_sc_hd__fill_1
XFILLER_33_346 vssd1 vssd1 vccd1 vccd1 sky130_fd_sc_hd__fill_1
XTAP_TAPCELL_ROW_31_514 vssd1 vccd1 sky130_fd_sc_hd__tapvpwrvgnd_1
X_4690_ _3781_ _3967_ vssd1 vssd1 vccd1 vccd1 _3968_ sky130_fd_sc_hd__or2_1
XANTENNA__4981__A1 net125 vssd1 vssd1 vccd1 vccd1 sky130_fd_sc_hd__diode_2
XANTENNA__5584__B net295 vssd1 vssd1 vccd1 vccd1 sky130_fd_sc_hd__diode_2
X_6360_ _1355_ _1357_ vssd1 vssd1 vccd1 vccd1 _1548_ sky130_fd_sc_hd__nand2_1
X_5311_ _0499_ _0500_ vssd1 vssd1 vccd1 vccd1 _0501_ sky130_fd_sc_hd__xnor2_1
X_6291_ _1479_ _1478_ vssd1 vssd1 vccd1 vccd1 _1480_ sky130_fd_sc_hd__and2b_1
X_8030_ net100 net39 vssd1 vssd1 vccd1 vccd1 _3284_ sky130_fd_sc_hd__or2_1
X_5242_ _0429_ _0430_ vssd1 vssd1 vccd1 vccd1 _0432_ sky130_fd_sc_hd__xor2_1
XANTENNA__8227__A2 net256 vssd1 vssd1 vccd1 vccd1 sky130_fd_sc_hd__diode_2
X_5173_ _0361_ _0360_ vssd1 vssd1 vccd1 vccd1 _0363_ sky130_fd_sc_hd__and2b_1
XFILLER_56_416 vssd1 vssd1 vccd1 vccd1 sky130_fd_sc_hd__fill_1
XTAP_TAPCELL_ROW_3_228 vssd1 vccd1 sky130_fd_sc_hd__tapvpwrvgnd_1
Xinput1 en vssd1 vssd1 vccd1 vccd1 net1 sky130_fd_sc_hd__clkbuf_1
XFILLER_83_235 vssd1 vssd1 vccd1 vccd1 sky130_fd_sc_hd__fill_2
XFILLER_56_449 vccd1 vssd1 vccd1 vssd1 sky130_ef_sc_hd__decap_40_12
XANTENNA__5308__A2_N net83 vssd1 vssd1 vccd1 vccd1 sky130_fd_sc_hd__diode_2
XFILLER_64_460 vssd1 vssd1 vccd1 vccd1 sky130_fd_sc_hd__fill_8
XFILLER_24_302 vssd1 vssd1 vccd1 vccd1 sky130_fd_sc_hd__fill_1
XANTENNA_fanout252_A net255 vssd1 vssd1 vccd1 vccd1 sky130_fd_sc_hd__diode_2
X_7814_ _3064_ _3069_ vssd1 vssd1 vccd1 vccd1 _3070_ sky130_fd_sc_hd__xnor2_1
XFILLER_36_195 vssd1 vssd1 vccd1 vccd1 sky130_fd_sc_hd__fill_1
XTAP_TAPCELL_ROW_19_393 vssd1 vccd1 sky130_fd_sc_hd__tapvpwrvgnd_1
X_7745_ _2992_ _3000_ vssd1 vssd1 vccd1 vccd1 _3001_ sky130_fd_sc_hd__nand2b_1
X_4957_ _0145_ _0146_ vssd1 vssd1 vccd1 vccd1 _0147_ sky130_fd_sc_hd__nand2_1
X_7676_ _2928_ _2929_ vssd1 vssd1 vccd1 vccd1 _2930_ sky130_fd_sc_hd__xnor2_1
XANTENNA_fanout138_X net138 vssd1 vssd1 vccd1 vccd1 sky130_fd_sc_hd__diode_2
X_4888_ _4110_ _4111_ _4113_ vssd1 vssd1 vccd1 vccd1 _0078_ sky130_fd_sc_hd__a21o_1
X_6627_ net243 net246 net259 net254 vssd1 vssd1 vccd1 vccd1 _1820_ sky130_fd_sc_hd__and4_1
XANTENNA_fanout305_X net305 vssd1 vssd1 vccd1 vccd1 sky130_fd_sc_hd__diode_2
X_6558_ PID_INST.k3_calc.d2.y\[3\] _1391_ _1392_ vssd1 vssd1 vccd1 vccd1 _1745_ sky130_fd_sc_hd__and3_1
XFILLER_3_206 vssd1 vssd1 vccd1 vccd1 sky130_fd_sc_hd__fill_2
X_5509_ _0695_ _0698_ vssd1 vssd1 vccd1 vccd1 _0699_ sky130_fd_sc_hd__nor2_1
X_6489_ _1473_ _1477_ _1676_ vssd1 vssd1 vccd1 vccd1 _1677_ sky130_fd_sc_hd__o21a_1
X_8228_ net202 net206 net256 net252 vssd1 vssd1 vccd1 vccd1 _3497_ sky130_fd_sc_hd__and4_1
XANTENNA__4838__B net79 vssd1 vssd1 vccd1 vccd1 sky130_fd_sc_hd__diode_2
XFILLER_86_26 vssd1 vssd1 vccd1 vccd1 sky130_fd_sc_hd__fill_2
X_8159_ net110 net37 _3421_ vssd1 vssd1 vccd1 vccd1 _3423_ sky130_fd_sc_hd__o21ai_1
XFILLER_59_254 vssd1 vssd1 vccd1 vccd1 sky130_fd_sc_hd__fill_1
XFILLER_47_438 vssd1 vssd1 vccd1 vccd1 sky130_fd_sc_hd__fill_4
XFILLER_19_118 vssd1 vssd1 vccd1 vccd1 sky130_fd_sc_hd__fill_2
XTAP_TAPCELL_ROW_73_926 vssd1 vccd1 sky130_fd_sc_hd__tapvpwrvgnd_1
XFILLER_27_140 vssd1 vssd1 vccd1 vccd1 sky130_fd_sc_hd__fill_4
XFILLER_27_151 vssd1 vssd1 vccd1 vccd1 sky130_fd_sc_hd__fill_4
XFILLER_35_52 vssd1 vssd1 vccd1 vccd1 sky130_fd_sc_hd__fill_4
XFILLER_70_485 vccd1 vssd1 vccd1 vssd1 sky130_ef_sc_hd__decap_40_12
XFILLER_70_474 vssd1 vssd1 vccd1 vccd1 sky130_fd_sc_hd__fill_2
XANTENNA__6952__A2 net62 vssd1 vssd1 vccd1 vccd1 sky130_fd_sc_hd__diode_2
XFILLER_30_327 vssd1 vssd1 vccd1 vccd1 sky130_fd_sc_hd__fill_2
XANTENNA__6704__A2 net226 vssd1 vssd1 vccd1 vccd1 sky130_fd_sc_hd__diode_2
XFILLER_7_556 vssd1 vssd1 vccd1 vccd1 sky130_fd_sc_hd__fill_4
XPHY_EDGE_ROW_2_Left_95 vssd1 vssd1 vccd1 vccd1 sky130_fd_sc_hd__decap_3
XFILLER_78_541 vssd1 vssd1 vccd1 vccd1 sky130_fd_sc_hd__fill_2
XFILLER_18_5 vssd1 vssd1 vccd1 vccd1 sky130_fd_sc_hd__fill_1
XFILLER_65_279 vssd1 vssd1 vccd1 vccd1 sky130_fd_sc_hd__fill_1
X_5860_ _1046_ _1049_ _1007_ _1026_ vssd1 vssd1 vccd1 vccd1 _1050_ sky130_fd_sc_hd__a211oi_1
XFILLER_18_162 vccd1 vssd1 vccd1 vssd1 sky130_ef_sc_hd__decap_40_12
X_4811_ _4087_ _4088_ vssd1 vssd1 vccd1 vccd1 _4089_ sky130_fd_sc_hd__nand2b_1
XANTENNA__5595__A net215 vssd1 vssd1 vccd1 vccd1 sky130_fd_sc_hd__diode_2
X_5791_ net320 net233 _0936_ vssd1 vssd1 vccd1 vccd1 _0981_ sky130_fd_sc_hd__and3_1
XTAP_TAPCELL_ROW_16_363 vssd1 vccd1 sky130_fd_sc_hd__tapvpwrvgnd_1
XFILLER_21_305 vssd1 vssd1 vccd1 vccd1 sky130_fd_sc_hd__fill_1
XFILLER_33_187 vssd1 vssd1 vccd1 vccd1 sky130_fd_sc_hd__fill_2
X_4742_ _3882_ _4019_ _4017_ vssd1 vssd1 vccd1 vccd1 _4020_ sky130_fd_sc_hd__a21o_1
XFILLER_21_349 vccd1 vssd1 vccd1 vssd1 sky130_ef_sc_hd__decap_40_12
X_7530_ _2766_ _2775_ vssd1 vssd1 vccd1 vccd1 _2777_ sky130_fd_sc_hd__xnor2_1
X_7461_ _2586_ _2588_ _2702_ vssd1 vssd1 vccd1 vccd1 _2703_ sky130_fd_sc_hd__a21o_1
X_4673_ _3948_ _3949_ vssd1 vssd1 vccd1 vccd1 _3951_ sky130_fd_sc_hd__nor2_1
X_6412_ _1491_ _1599_ vssd1 vssd1 vccd1 vccd1 _1600_ sky130_fd_sc_hd__xnor2_1
X_7392_ _2620_ _2621_ _2628_ vssd1 vssd1 vccd1 vccd1 _2630_ sky130_fd_sc_hd__a21o_1
XANTENNA__7018__C net258 vssd1 vssd1 vccd1 vccd1 sky130_fd_sc_hd__diode_2
X_6343_ _1528_ _1529_ vssd1 vssd1 vccd1 vccd1 _1531_ sky130_fd_sc_hd__xnor2_1
X_6274_ _1239_ _1265_ _1462_ vssd1 vssd1 vccd1 vccd1 _1463_ sky130_fd_sc_hd__a21o_1
XANTENNA__8387__CLK clknet_4_9_0_clk vssd1 vssd1 vccd1 vccd1 sky130_fd_sc_hd__diode_2
X_8013_ net91 net46 _3121_ vssd1 vssd1 vccd1 vccd1 _3267_ sky130_fd_sc_hd__o21ba_1
X_5225_ _0412_ _0413_ vssd1 vssd1 vccd1 vccd1 _0415_ sky130_fd_sc_hd__xor2_1
XFILLER_69_541 vssd1 vssd1 vccd1 vccd1 sky130_fd_sc_hd__fill_2
XFILLER_84_500 vssd1 vssd1 vccd1 vccd1 sky130_fd_sc_hd__fill_2
X_5156_ _0251_ _0253_ _0250_ vssd1 vssd1 vccd1 vccd1 _0346_ sky130_fd_sc_hd__a21bo_1
XFILLER_84_533 vccd1 vssd1 vccd1 vssd1 sky130_ef_sc_hd__decap_40_12
X_5087_ _2083_ _3774_ vssd1 vssd1 vccd1 vccd1 _0277_ sky130_fd_sc_hd__nor2_1
XANTENNA__4393__B net9 vssd1 vssd1 vccd1 vccd1 sky130_fd_sc_hd__diode_2
XANTENNA__8486__RESET_B net341 vssd1 vssd1 vccd1 vccd1 sky130_fd_sc_hd__diode_2
XANTENNA_fanout255_X net255 vssd1 vssd1 vccd1 vccd1 sky130_fd_sc_hd__diode_2
XFILLER_52_430 vssd1 vssd1 vccd1 vccd1 sky130_fd_sc_hd__fill_8
XANTENNA__8415__RESET_B net327 vssd1 vssd1 vccd1 vccd1 sky130_fd_sc_hd__diode_2
XFILLER_12_305 vssd1 vssd1 vccd1 vccd1 sky130_fd_sc_hd__fill_2
XFILLER_24_154 vccd1 vssd1 vccd1 vssd1 sky130_ef_sc_hd__decap_40_12
X_5989_ _0516_ _0535_ _1176_ vssd1 vssd1 vccd1 vccd1 _1179_ sky130_fd_sc_hd__and3_1
X_7728_ _2982_ _2983_ vssd1 vssd1 vccd1 vccd1 _2984_ sky130_fd_sc_hd__nor2_1
XFILLER_8_309 vssd1 vssd1 vccd1 vccd1 sky130_fd_sc_hd__fill_8
X_7659_ _2902_ _2911_ vssd1 vssd1 vccd1 vccd1 _2913_ sky130_fd_sc_hd__xnor2_1
XTAP_TAPCELL_ROW_50_697 vssd1 vccd1 sky130_fd_sc_hd__tapvpwrvgnd_1
XFILLER_21_21 vccd1 vssd1 vccd1 vssd1 sky130_ef_sc_hd__decap_40_12
XFILLER_4_515 vssd1 vssd1 vccd1 vccd1 sky130_fd_sc_hd__fill_4
XFILLER_21_54 vssd1 vssd1 vccd1 vccd1 sky130_fd_sc_hd__fill_2
XANTENNA__5122__A1 net139 vssd1 vssd1 vccd1 vccd1 sky130_fd_sc_hd__diode_2
XANTENNA__5122__B2 net118 vssd1 vssd1 vccd1 vccd1 sky130_fd_sc_hd__diode_2
XFILLER_47_213 vssd1 vssd1 vccd1 vccd1 sky130_fd_sc_hd__fill_1
XANTENNA_fanout70_X net70 vssd1 vssd1 vccd1 vccd1 sky130_fd_sc_hd__diode_2
XFILLER_46_40 vssd1 vssd1 vccd1 vccd1 sky130_fd_sc_hd__fill_1
XFILLER_35_419 vssd1 vssd1 vccd1 vccd1 sky130_fd_sc_hd__fill_1
XFILLER_15_110 vssd1 vssd1 vccd1 vccd1 sky130_fd_sc_hd__fill_2
XTAP_TAPCELL_ROW_83_1033 vssd1 vccd1 sky130_fd_sc_hd__tapvpwrvgnd_1
XFILLER_15_165 vssd1 vssd1 vccd1 vccd1 sky130_fd_sc_hd__fill_2
XANTENNA__6304__A net95 vssd1 vssd1 vccd1 vccd1 sky130_fd_sc_hd__diode_2
XTAP_TAPCELL_ROW_13_333 vssd1 vccd1 sky130_fd_sc_hd__tapvpwrvgnd_1
XFILLER_7_34 vssd1 vssd1 vccd1 vccd1 sky130_fd_sc_hd__fill_4
XANTENNA__4759__A net148 vssd1 vssd1 vccd1 vccd1 sky130_fd_sc_hd__diode_2
XANTENNA__7102__A2 net258 vssd1 vssd1 vccd1 vccd1 sky130_fd_sc_hd__diode_2
XANTENNA__6974__A net139 vssd1 vssd1 vccd1 vccd1 sky130_fd_sc_hd__diode_2
X_5010_ _0125_ _0198_ vssd1 vssd1 vccd1 vccd1 _0200_ sky130_fd_sc_hd__xor2_1
XFILLER_87_91 vssd1 vssd1 vccd1 vccd1 sky130_fd_sc_hd__fill_1
XFILLER_66_500 vssd1 vssd1 vccd1 vccd1 sky130_fd_sc_hd__fill_1
XFILLER_23_3 vssd1 vssd1 vccd1 vccd1 sky130_fd_sc_hd__fill_4
XFILLER_66_544 vssd1 vssd1 vccd1 vccd1 sky130_fd_sc_hd__fill_8
XFILLER_66_533 vssd1 vssd1 vccd1 vccd1 sky130_fd_sc_hd__fill_2
XFILLER_38_246 vssd1 vssd1 vccd1 vccd1 sky130_fd_sc_hd__fill_4
XFILLER_26_408 vccd1 vssd1 vccd1 vssd1 sky130_ef_sc_hd__decap_40_12
X_6961_ net100 net53 vssd1 vssd1 vccd1 vccd1 _2174_ sky130_fd_sc_hd__nor2_1
XFILLER_19_493 vssd1 vssd1 vccd1 vccd1 sky130_fd_sc_hd__fill_8
X_5912_ _0603_ _0687_ _0688_ _1100_ _1101_ vssd1 vssd1 vccd1 vccd1 _1102_ sky130_fd_sc_hd__o2111a_1
X_6892_ _1988_ _2100_ vssd1 vssd1 vccd1 vccd1 _2101_ sky130_fd_sc_hd__xnor2_1
X_5843_ _1032_ vssd1 vssd1 vccd1 vccd1 _1033_ sky130_fd_sc_hd__inv_2
XFILLER_61_260 vssd1 vssd1 vccd1 vccd1 sky130_fd_sc_hd__fill_1
XFILLER_34_474 vssd1 vssd1 vccd1 vccd1 sky130_fd_sc_hd__fill_2
XANTENNA__4927__A1 net137 vssd1 vssd1 vccd1 vccd1 sky130_fd_sc_hd__diode_2
XFILLER_21_113 vccd1 vssd1 vccd1 vssd1 sky130_ef_sc_hd__decap_40_12
XFILLER_34_496 vccd1 vssd1 vccd1 vssd1 sky130_ef_sc_hd__decap_40_12
X_5774_ _0955_ _0957_ net243 net288 vssd1 vssd1 vccd1 vccd1 _0964_ sky130_fd_sc_hd__o211a_1
X_7513_ net99 net46 _2756_ vssd1 vssd1 vccd1 vccd1 _2758_ sky130_fd_sc_hd__or3_1
X_4725_ _4000_ _4002_ vssd1 vssd1 vccd1 vccd1 _4003_ sky130_fd_sc_hd__xnor2_1
X_7444_ _2576_ _2590_ _2684_ vssd1 vssd1 vccd1 vccd1 _2685_ sky130_fd_sc_hd__a21oi_1
XANTENNA_fanout215_A net217 vssd1 vssd1 vccd1 vccd1 sky130_fd_sc_hd__diode_2
X_4656_ net142 net86 _3932_ _3933_ vssd1 vssd1 vccd1 vccd1 _3934_ sky130_fd_sc_hd__nand4_1
X_7375_ _2340_ _2342_ _2610_ vssd1 vssd1 vccd1 vccd1 _2613_ sky130_fd_sc_hd__nand3_1
X_4587_ net124 net144 _3847_ _3863_ vssd1 vssd1 vccd1 vccd1 _3865_ sky130_fd_sc_hd__a22oi_1
XANTENNA__7045__A net219 vssd1 vssd1 vccd1 vccd1 sky130_fd_sc_hd__diode_2
X_6326_ _1314_ _1513_ vssd1 vssd1 vccd1 vccd1 _1514_ sky130_fd_sc_hd__nand2_1
XANTENNA__4388__B net8 vssd1 vssd1 vccd1 vccd1 sky130_fd_sc_hd__diode_2
XFILLER_1_529 vccd1 vssd1 vccd1 vssd1 sky130_ef_sc_hd__decap_40_12
X_6257_ net227 net231 net284 net279 vssd1 vssd1 vccd1 vccd1 _1446_ sky130_fd_sc_hd__and4_1
X_5208_ _0396_ _0397_ vssd1 vssd1 vccd1 vccd1 _0398_ sky130_fd_sc_hd__nor2_1
XFILLER_29_202 vssd1 vssd1 vccd1 vccd1 sky130_fd_sc_hd__fill_8
X_6188_ _1368_ _1375_ vssd1 vssd1 vccd1 vccd1 _1377_ sky130_fd_sc_hd__xor2_1
XFILLER_57_522 vssd1 vssd1 vccd1 vccd1 sky130_fd_sc_hd__fill_2
X_5139_ _0228_ _0319_ _0321_ _0323_ vssd1 vssd1 vccd1 vccd1 _0329_ sky130_fd_sc_hd__a22o_1
XFILLER_84_363 vssd1 vssd1 vccd1 vccd1 sky130_fd_sc_hd__fill_1
XFILLER_83_16 vccd1 vssd1 vccd1 vssd1 sky130_ef_sc_hd__decap_40_12
XFILLER_17_408 vssd1 vssd1 vccd1 vccd1 sky130_fd_sc_hd__fill_1
XFILLER_16_10 vssd1 vssd1 vccd1 vccd1 sky130_fd_sc_hd__fill_2
XFILLER_72_569 vssd1 vssd1 vccd1 vccd1 sky130_fd_sc_hd__fill_1
XFILLER_25_430 vssd1 vssd1 vccd1 vccd1 sky130_fd_sc_hd__fill_8
XFILLER_16_54 vssd1 vssd1 vccd1 vccd1 sky130_fd_sc_hd__fill_1
XTAP_TAPCELL_ROW_27_469 vssd1 vccd1 sky130_fd_sc_hd__tapvpwrvgnd_1
XFILLER_12_113 vssd1 vssd1 vccd1 vccd1 sky130_fd_sc_hd__fill_4
XFILLER_12_157 vssd1 vssd1 vccd1 vccd1 sky130_fd_sc_hd__fill_4
XFILLER_40_477 vssd1 vssd1 vccd1 vccd1 sky130_fd_sc_hd__fill_1
XTAP_TAPCELL_ROW_10_303 vssd1 vccd1 sky130_fd_sc_hd__tapvpwrvgnd_1
XFILLER_8_139 vssd1 vssd1 vccd1 vccd1 sky130_fd_sc_hd__fill_1
XFILLER_32_75 vssd1 vssd1 vccd1 vccd1 sky130_fd_sc_hd__fill_1
XANTENNA__8293__B1 net183 vssd1 vssd1 vccd1 vccd1 sky130_fd_sc_hd__diode_2
XFILLER_57_61 vssd1 vssd1 vccd1 vccd1 sky130_fd_sc_hd__fill_1
XFILLER_48_533 vssd1 vssd1 vccd1 vccd1 sky130_fd_sc_hd__fill_2
XFILLER_63_503 vssd1 vssd1 vccd1 vccd1 sky130_fd_sc_hd__fill_1
XFILLER_63_514 vssd1 vssd1 vccd1 vccd1 sky130_fd_sc_hd__fill_1
XFILLER_63_569 vssd1 vssd1 vccd1 vccd1 sky130_fd_sc_hd__fill_1
XFILLER_31_411 vssd1 vssd1 vccd1 vccd1 sky130_fd_sc_hd__fill_1
XFILLER_31_499 vssd1 vssd1 vccd1 vccd1 sky130_fd_sc_hd__fill_4
X_4510_ net128 net89 vssd1 vssd1 vccd1 vccd1 _3788_ sky130_fd_sc_hd__nand2_1
X_5490_ _0674_ _0675_ _0677_ vssd1 vssd1 vccd1 vccd1 _0680_ sky130_fd_sc_hd__o21ai_1
X_4441_ PID_INST.k1_calc.d1.x\[2\] PID_INST.k3_calc.prev_error\[2\] vssd1 vssd1 vccd1
+ vccd1 _3719_ sky130_fd_sc_hd__and2_1
X_7160_ _2374_ _2375_ _2382_ vssd1 vssd1 vccd1 vccd1 _2384_ sky130_fd_sc_hd__a21oi_1
XPHY_EDGE_ROW_9_Right_9 vssd1 vssd1 vccd1 vccd1 sky130_fd_sc_hd__decap_3
X_4372_ net209 _3667_ net160 vssd1 vssd1 vccd1 vccd1 _0042_ sky130_fd_sc_hd__mux2_1
XANTENNA__4823__A_N _4099_ vssd1 vssd1 vccd1 vccd1 sky130_fd_sc_hd__diode_2
X_6111_ _4022_ _1108_ _1109_ _1107_ vssd1 vssd1 vccd1 vccd1 _1300_ sky130_fd_sc_hd__a22oi_2
X_7091_ _2111_ _2112_ _2110_ vssd1 vssd1 vccd1 vccd1 _2312_ sky130_fd_sc_hd__a21o_1
X_6042_ _1230_ _1231_ vssd1 vssd1 vccd1 vccd1 _1232_ sky130_fd_sc_hd__xnor2_1
XFILLER_39_500 vssd1 vssd1 vccd1 vccd1 sky130_fd_sc_hd__fill_4
XANTENNA__4936__B _3734_ vssd1 vssd1 vccd1 vccd1 sky130_fd_sc_hd__diode_2
XFILLER_66_363 vssd1 vssd1 vccd1 vccd1 sky130_fd_sc_hd__fill_1
X_7993_ _3245_ _3247_ vssd1 vssd1 vccd1 vccd1 _3248_ sky130_fd_sc_hd__nor2_1
XFILLER_54_547 vccd1 vssd1 vccd1 vssd1 sky130_ef_sc_hd__decap_40_12
X_6944_ _2148_ _2155_ vssd1 vssd1 vccd1 vccd1 _2156_ sky130_fd_sc_hd__xnor2_2
XFILLER_34_260 vssd1 vssd1 vccd1 vccd1 sky130_fd_sc_hd__fill_1
XFILLER_41_219 vssd1 vssd1 vccd1 vccd1 sky130_fd_sc_hd__fill_4
XFILLER_22_411 vssd1 vssd1 vccd1 vccd1 sky130_fd_sc_hd__fill_4
XFILLER_22_444 vssd1 vssd1 vccd1 vccd1 sky130_fd_sc_hd__fill_1
XTAP_TAPCELL_ROW_24_439 vssd1 vccd1 sky130_fd_sc_hd__tapvpwrvgnd_1
X_6875_ net114 net43 vssd1 vssd1 vccd1 vccd1 _2084_ sky130_fd_sc_hd__nor2_1
X_5826_ net241 net251 net311 net299 vssd1 vssd1 vccd1 vccd1 _1016_ sky130_fd_sc_hd__and4_1
XFILLER_22_477 vssd1 vssd1 vccd1 vccd1 sky130_fd_sc_hd__fill_4
X_5757_ _0945_ _0946_ vssd1 vssd1 vccd1 vccd1 _0947_ sky130_fd_sc_hd__and2_1
X_8476_ clknet_4_14_0_clk _0064_ net341 vssd1 vssd1 vccd1 vccd1 net25 sky130_fd_sc_hd__dfrtp_1
X_4708_ _3983_ _3984_ vssd1 vssd1 vccd1 vccd1 _3986_ sky130_fd_sc_hd__xnor2_1
XANTENNA_fanout120_X net120 vssd1 vssd1 vccd1 vccd1 sky130_fd_sc_hd__diode_2
X_7427_ _2665_ _2666_ vssd1 vssd1 vccd1 vccd1 _2667_ sky130_fd_sc_hd__nand2_1
X_5688_ _0875_ _0876_ _0877_ vssd1 vssd1 vccd1 vccd1 _0878_ sky130_fd_sc_hd__or3_1
X_4639_ _3915_ _3916_ vssd1 vssd1 vccd1 vccd1 _3917_ sky130_fd_sc_hd__nand2_1
X_7358_ _2331_ _2344_ _2592_ vssd1 vssd1 vccd1 vccd1 _2594_ sky130_fd_sc_hd__and3_1
XFILLER_78_27 vssd1 vssd1 vccd1 vccd1 sky130_fd_sc_hd__fill_1
XANTENNA__4686__X _3964_ vssd1 vssd1 vccd1 vccd1 sky130_fd_sc_hd__diode_2
X_6309_ _1495_ _1496_ vssd1 vssd1 vccd1 vccd1 _1497_ sky130_fd_sc_hd__nor2_1
XANTENNA__5007__B net80 vssd1 vssd1 vccd1 vccd1 sky130_fd_sc_hd__diode_2
X_7289_ _2513_ _2520_ vssd1 vssd1 vccd1 vccd1 _2521_ sky130_fd_sc_hd__nand2b_1
XFILLER_89_488 vssd1 vssd1 vccd1 vccd1 sky130_fd_sc_hd__fill_1
XFILLER_76_138 vssd1 vssd1 vccd1 vccd1 sky130_fd_sc_hd__fill_2
XFILLER_57_341 vccd1 vssd1 vccd1 vssd1 sky130_ef_sc_hd__decap_40_12
XFILLER_45_503 vssd1 vssd1 vccd1 vccd1 sky130_fd_sc_hd__fill_1
XANTENNA__6119__A net118 vssd1 vssd1 vccd1 vccd1 sky130_fd_sc_hd__diode_2
XANTENNA__8430__RESET_B net327 vssd1 vssd1 vccd1 vccd1 sky130_fd_sc_hd__diode_2
XTAP_TAPCELL_ROW_68_881 vssd1 vccd1 sky130_fd_sc_hd__tapvpwrvgnd_1
XFILLER_17_205 vssd1 vssd1 vccd1 vccd1 sky130_fd_sc_hd__fill_8
XFILLER_72_377 vssd1 vssd1 vccd1 vccd1 sky130_fd_sc_hd__fill_2
XTAP_TAPCELL_ROW_80_1003 vssd1 vccd1 sky130_fd_sc_hd__tapvpwrvgnd_1
XFILLER_25_271 vssd1 vssd1 vccd1 vccd1 sky130_fd_sc_hd__fill_8
XFILLER_40_263 vssd1 vssd1 vccd1 vccd1 sky130_fd_sc_hd__fill_2
XFILLER_40_285 vssd1 vssd1 vccd1 vccd1 sky130_fd_sc_hd__fill_2
XTAP_TAPCELL_ROW_91_1110 vssd1 vccd1 sky130_fd_sc_hd__tapvpwrvgnd_1
XFILLER_4_57 vssd1 vssd1 vccd1 vccd1 sky130_fd_sc_hd__fill_8
XANTENNA__8228__B net206 vssd1 vssd1 vccd1 vccd1 sky130_fd_sc_hd__diode_2
XANTENNA__7132__B net190 vssd1 vssd1 vccd1 vccd1 sky130_fd_sc_hd__diode_2
XFILLER_82_119 vssd1 vssd1 vccd1 vccd1 sky130_fd_sc_hd__fill_4
XFILLER_75_171 vccd1 vssd1 vccd1 vssd1 sky130_ef_sc_hd__decap_40_12
XFILLER_63_322 vssd1 vssd1 vccd1 vccd1 sky130_fd_sc_hd__fill_1
XFILLER_48_363 vssd1 vssd1 vccd1 vccd1 sky130_fd_sc_hd__fill_1
XFILLER_90_141 vccd1 vssd1 vccd1 vssd1 sky130_ef_sc_hd__decap_40_12
XTAP_TAPCELL_ROW_89_1094 vssd1 vccd1 sky130_fd_sc_hd__tapvpwrvgnd_1
XFILLER_63_344 vssd1 vssd1 vccd1 vccd1 sky130_fd_sc_hd__fill_8
X_4990_ _0171_ _0179_ vssd1 vssd1 vccd1 vccd1 _0180_ sky130_fd_sc_hd__xnor2_1
XFILLER_16_282 vssd1 vssd1 vccd1 vccd1 sky130_fd_sc_hd__fill_1
X_6660_ net219 net284 net279 net223 vssd1 vssd1 vccd1 vccd1 _1855_ sky130_fd_sc_hd__a22oi_1
XTAP_TAPCELL_ROW_21_409 vssd1 vccd1 sky130_fd_sc_hd__tapvpwrvgnd_1
XFILLER_31_241 vssd1 vssd1 vccd1 vccd1 sky130_fd_sc_hd__fill_2
X_5611_ _0767_ _0770_ _0800_ vssd1 vssd1 vccd1 vccd1 _0801_ sky130_fd_sc_hd__o21ai_1
X_6591_ _1777_ _1778_ vssd1 vssd1 vccd1 vccd1 _1780_ sky130_fd_sc_hd__and2_1
XFILLER_31_274 vssd1 vssd1 vccd1 vccd1 sky130_fd_sc_hd__fill_4
XFILLER_31_285 vssd1 vssd1 vccd1 vccd1 sky130_fd_sc_hd__fill_2
X_8330_ _3556_ _3606_ vssd1 vssd1 vccd1 vccd1 _3607_ sky130_fd_sc_hd__xnor2_1
X_5542_ net236 net288 vssd1 vssd1 vccd1 vccd1 _0732_ sky130_fd_sc_hd__nand2_1
XFILLER_8_481 vssd1 vssd1 vccd1 vccd1 sky130_fd_sc_hd__fill_2
XANTENNA__7307__B _2147_ vssd1 vssd1 vccd1 vccd1 sky130_fd_sc_hd__diode_2
X_8261_ _3531_ _3532_ vssd1 vssd1 vccd1 vccd1 _3533_ sky130_fd_sc_hd__nor2_1
X_5473_ _0607_ _0629_ vssd1 vssd1 vccd1 vccd1 _0663_ sky130_fd_sc_hd__xnor2_1
X_8192_ _3376_ _3379_ _3457_ vssd1 vssd1 vccd1 vccd1 _3458_ sky130_fd_sc_hd__a21oi_1
X_4424_ PID_INST.k2_calc.sum_reg\[23\] _3705_ PID_INST.k2_calc.sum_reg\[24\] vssd1
+ vssd1 vccd1 vccd1 _3706_ sky130_fd_sc_hd__a21oi_1
X_7212_ _2181_ _2438_ vssd1 vssd1 vccd1 vccd1 _2439_ sky130_fd_sc_hd__xor2_1
X_7143_ _2252_ _2254_ _2365_ vssd1 vssd1 vccd1 vccd1 _2366_ sky130_fd_sc_hd__a21o_1
X_4355_ net222 net19 _3652_ vssd1 vssd1 vccd1 vccd1 _3653_ sky130_fd_sc_hd__a21oi_1
X_7074_ _2292_ _2293_ vssd1 vssd1 vccd1 vccd1 _2294_ sky130_fd_sc_hd__nor2_1
XFILLER_86_403 vssd1 vssd1 vccd1 vccd1 sky130_fd_sc_hd__fill_1
X_4286_ net4 net401 net157 vssd1 vssd1 vccd1 vccd1 _0009_ sky130_fd_sc_hd__mux2_1
X_6025_ _1212_ _1213_ net323 net199 vssd1 vssd1 vccd1 vccd1 _1215_ sky130_fd_sc_hd__and4b_1
XANTENNA_fanout282_A PID_INST.k2_calc.reg_lc\[8\] vssd1 vssd1 vccd1 vccd1 sky130_fd_sc_hd__diode_2
XANTENNA__4294__A1 net13 vssd1 vssd1 vccd1 vccd1 sky130_fd_sc_hd__diode_2
XFILLER_39_352 vssd1 vssd1 vccd1 vccd1 sky130_fd_sc_hd__fill_2
XFILLER_66_193 vssd1 vssd1 vccd1 vccd1 sky130_fd_sc_hd__fill_1
XTAP_TAPCELL_ROW_65_851 vssd1 vccd1 sky130_fd_sc_hd__tapvpwrvgnd_1
XFILLER_54_333 vccd1 vssd1 vccd1 vssd1 sky130_ef_sc_hd__decap_40_12
XFILLER_27_547 vssd1 vssd1 vccd1 vccd1 sky130_fd_sc_hd__fill_1
XFILLER_81_174 vccd1 vssd1 vccd1 vssd1 sky130_ef_sc_hd__decap_40_12
X_7976_ _3229_ _3230_ vssd1 vssd1 vccd1 vccd1 _3231_ sky130_fd_sc_hd__nand2_1
XFILLER_14_208 vccd1 vssd1 vccd1 vssd1 sky130_ef_sc_hd__decap_40_12
XTAP_TAPCELL_ROW_37_575 vssd1 vccd1 sky130_fd_sc_hd__tapvpwrvgnd_1
XFILLER_42_528 vssd1 vssd1 vccd1 vccd1 sky130_fd_sc_hd__fill_4
X_6927_ _2133_ _2137_ vssd1 vssd1 vccd1 vccd1 _2138_ sky130_fd_sc_hd__xnor2_1
X_6858_ _1765_ _2063_ vssd1 vssd1 vccd1 vccd1 _2065_ sky130_fd_sc_hd__nand2_1
Xfanout56 _0147_ vssd1 vssd1 vccd1 vccd1 net56 sky130_fd_sc_hd__clkbuf_2
Xfanout45 _0548_ vssd1 vssd1 vccd1 vccd1 net45 sky130_fd_sc_hd__dlymetal6s2s_1
X_5809_ _0978_ _0982_ _0990_ vssd1 vssd1 vccd1 vccd1 _0999_ sky130_fd_sc_hd__and3_1
Xfanout78 _3773_ vssd1 vssd1 vccd1 vccd1 net78 sky130_fd_sc_hd__clkbuf_4
XFILLER_22_285 vssd1 vssd1 vccd1 vccd1 sky130_fd_sc_hd__fill_1
Xfanout89 _3736_ vssd1 vssd1 vccd1 vccd1 net89 sky130_fd_sc_hd__clkbuf_4
X_6789_ _1535_ _1705_ _1706_ _1708_ vssd1 vssd1 vccd1 vccd1 _1992_ sky130_fd_sc_hd__a22o_1
XFILLER_13_66 vssd1 vssd1 vccd1 vccd1 sky130_fd_sc_hd__fill_1
X_8459_ clknet_4_5_0_clk _0047_ net332 vssd1 vssd1 vccd1 vccd1 PID_INST.k2_calc.sum_reg\[15\]
+ sky130_fd_sc_hd__dfrtp_2
XPHY_EDGE_ROW_8_Left_101 vssd1 vssd1 vccd1 vccd1 sky130_fd_sc_hd__decap_3
XANTENNA__5960__B net71 vssd1 vssd1 vccd1 vccd1 sky130_fd_sc_hd__diode_2
XFILLER_77_414 vssd1 vssd1 vccd1 vccd1 sky130_fd_sc_hd__fill_2
XTAP_TAPCELL_ROW_9_289 vssd1 vccd1 sky130_fd_sc_hd__tapvpwrvgnd_1
XFILLER_1_145 vssd1 vssd1 vccd1 vccd1 sky130_fd_sc_hd__fill_2
XFILLER_89_285 vssd1 vssd1 vccd1 vccd1 sky130_fd_sc_hd__fill_1
XFILLER_77_447 vssd1 vssd1 vccd1 vccd1 sky130_fd_sc_hd__fill_1
XFILLER_77_425 vssd1 vssd1 vccd1 vccd1 sky130_fd_sc_hd__fill_2
XFILLER_1_189 vssd1 vssd1 vccd1 vccd1 sky130_fd_sc_hd__fill_2
XFILLER_1_178 vssd1 vssd1 vccd1 vccd1 sky130_fd_sc_hd__fill_4
XFILLER_38_63 vssd1 vssd1 vccd1 vccd1 sky130_fd_sc_hd__fill_1
XFILLER_92_417 vssd1 vssd1 vccd1 vccd1 sky130_fd_sc_hd__fill_2
XANTENNA_input10_A gpio_in[17] vssd1 vssd1 vccd1 vccd1 sky130_fd_sc_hd__diode_2
XFILLER_18_569 vssd1 vssd1 vccd1 vccd1 sky130_fd_sc_hd__fill_1
XFILLER_33_528 vssd1 vssd1 vccd1 vccd1 sky130_fd_sc_hd__fill_2
XFILLER_60_347 vssd1 vssd1 vccd1 vccd1 sky130_fd_sc_hd__fill_2
XFILLER_41_550 vssd1 vssd1 vccd1 vccd1 sky130_fd_sc_hd__fill_8
XFILLER_13_274 vssd1 vssd1 vccd1 vccd1 sky130_fd_sc_hd__fill_4
XANTENNA__6312__A net97 vssd1 vssd1 vccd1 vccd1 sky130_fd_sc_hd__diode_2
XANTENNA__6031__B net321 vssd1 vssd1 vccd1 vccd1 sky130_fd_sc_hd__diode_2
XFILLER_5_473 vccd1 vssd1 vccd1 vssd1 sky130_ef_sc_hd__decap_40_12
XFILLER_68_414 vssd1 vssd1 vccd1 vccd1 sky130_fd_sc_hd__fill_1
XTAP_TAPCELL_ROW_79_987 vssd1 vccd1 sky130_fd_sc_hd__tapvpwrvgnd_1
XFILLER_48_193 vssd1 vssd1 vccd1 vccd1 sky130_fd_sc_hd__fill_2
X_7830_ _2836_ _2848_ _2835_ vssd1 vssd1 vccd1 vccd1 _3086_ sky130_fd_sc_hd__a21oi_1
XFILLER_36_333 vssd1 vssd1 vccd1 vccd1 sky130_fd_sc_hd__fill_2
XFILLER_91_461 vssd1 vssd1 vccd1 vccd1 sky130_fd_sc_hd__fill_1
X_7761_ net294 net185 vssd1 vssd1 vccd1 vccd1 _3017_ sky130_fd_sc_hd__nand2_1
XTAP_TAPCELL_ROW_62_821 vssd1 vccd1 sky130_fd_sc_hd__tapvpwrvgnd_1
X_4973_ _0159_ _0162_ vssd1 vssd1 vccd1 vccd1 _0163_ sky130_fd_sc_hd__xnor2_1
X_7692_ _2703_ _2706_ _2946_ vssd1 vssd1 vccd1 vccd1 _2947_ sky130_fd_sc_hd__a21oi_1
X_6712_ net242 net238 net258 net255 vssd1 vssd1 vccd1 vccd1 _1909_ sky130_fd_sc_hd__and4_1
XFILLER_51_358 vccd1 vssd1 vccd1 vssd1 sky130_ef_sc_hd__decap_40_12
XTAP_TAPCELL_ROW_34_545 vssd1 vccd1 sky130_fd_sc_hd__tapvpwrvgnd_1
X_6643_ _1829_ _1833_ _1834_ vssd1 vssd1 vccd1 vccd1 _1836_ sky130_fd_sc_hd__or3_1
Xclkload9 clknet_4_10_0_clk vssd1 vssd1 vccd1 vccd1 clkload9/Y sky130_fd_sc_hd__clkinv_8
X_6574_ _1759_ _1760_ vssd1 vssd1 vccd1 vccd1 _1761_ sky130_fd_sc_hd__nand2_1
XANTENNA_fanout128_A net129 vssd1 vssd1 vccd1 vccd1 sky130_fd_sc_hd__diode_2
X_8313_ _3584_ _3585_ _3586_ _3587_ vssd1 vssd1 vccd1 vccd1 _3588_ sky130_fd_sc_hd__and4_1
X_5525_ _0689_ _0714_ vssd1 vssd1 vccd1 vccd1 _0715_ sky130_fd_sc_hd__nor2_1
X_8244_ _3512_ _3513_ _3495_ vssd1 vssd1 vccd1 vccd1 _3514_ sky130_fd_sc_hd__a21oi_1
X_5456_ PID_INST.k3_calc.d2.y\[2\] net65 vssd1 vssd1 vccd1 vccd1 _0646_ sky130_fd_sc_hd__or2_1
X_4407_ net160 _3692_ _3695_ net189 vssd1 vssd1 vccd1 vccd1 _3697_ sky130_fd_sc_hd__a31o_1
Xfanout213 PID_INST.k2_calc.sum_reg\[10\] vssd1 vssd1 vccd1 vccd1 net213 sky130_fd_sc_hd__clkbuf_2
Xfanout202 PID_INST.k2_calc.sum_reg\[12\] vssd1 vssd1 vccd1 vccd1 net202 sky130_fd_sc_hd__buf_2
X_8175_ _3433_ _3439_ vssd1 vssd1 vccd1 vccd1 _3440_ sky130_fd_sc_hd__nand2b_1
X_5387_ _0571_ _0576_ vssd1 vssd1 vccd1 vccd1 _0577_ sky130_fd_sc_hd__or2_1
X_7126_ _2243_ _2256_ _2347_ vssd1 vssd1 vccd1 vccd1 _2348_ sky130_fd_sc_hd__a21oi_1
Xfanout235 net236 vssd1 vssd1 vccd1 vccd1 net235 sky130_fd_sc_hd__buf_2
Xfanout246 net247 vssd1 vssd1 vccd1 vccd1 net246 sky130_fd_sc_hd__buf_2
Xfanout224 net225 vssd1 vssd1 vccd1 vccd1 net224 sky130_fd_sc_hd__buf_2
XFILLER_59_425 vssd1 vssd1 vccd1 vccd1 sky130_fd_sc_hd__fill_2
X_4338_ net233 net16 _3526_ vssd1 vssd1 vccd1 vccd1 _3601_ sky130_fd_sc_hd__a21o_1
XTAP_TAPCELL_ROW_6_259 vssd1 vccd1 sky130_fd_sc_hd__tapvpwrvgnd_1
XANTENNA__7988__A net286 vssd1 vssd1 vccd1 vccd1 sky130_fd_sc_hd__diode_2
X_7057_ _2267_ _2276_ vssd1 vssd1 vccd1 vccd1 _2277_ sky130_fd_sc_hd__xnor2_1
XFILLER_86_266 vssd1 vssd1 vccd1 vccd1 sky130_fd_sc_hd__fill_4
XFILLER_86_244 vssd1 vssd1 vccd1 vccd1 sky130_fd_sc_hd__fill_4
XANTENNA__7453__B2 net202 vssd1 vssd1 vccd1 vccd1 sky130_fd_sc_hd__diode_2
XANTENNA__7453__A1 net198 vssd1 vssd1 vccd1 vccd1 sky130_fd_sc_hd__diode_2
Xfanout279 net280 vssd1 vssd1 vccd1 vccd1 net279 sky130_fd_sc_hd__dlymetal6s2s_1
Xfanout257 net259 vssd1 vssd1 vccd1 vccd1 net257 sky130_fd_sc_hd__clkbuf_2
Xfanout268 PID_INST.k2_calc.reg_lc\[11\] vssd1 vssd1 vccd1 vccd1 net268 sky130_fd_sc_hd__clkbuf_2
XANTENNA_fanout285_X net285 vssd1 vssd1 vccd1 vccd1 sky130_fd_sc_hd__diode_2
X_4269_ PID_INST.pid.curr_state\[3\] PID_INST.pid.curr_state\[2\] _1838_ _2845_ vssd1
+ vssd1 vccd1 vccd1 _2887_ sky130_fd_sc_hd__and4b_1
XANTENNA_input2_A gpio_in[0] vssd1 vssd1 vccd1 vccd1 sky130_fd_sc_hd__diode_2
X_6008_ _1197_ _1126_ vssd1 vssd1 vccd1 vccd1 _1198_ sky130_fd_sc_hd__nand2b_1
XFILLER_54_141 vssd1 vssd1 vccd1 vccd1 sky130_fd_sc_hd__fill_1
X_7959_ net260 net194 vssd1 vssd1 vccd1 vccd1 _3214_ sky130_fd_sc_hd__nand2_1
XFILLER_27_388 vssd1 vssd1 vccd1 vccd1 sky130_fd_sc_hd__fill_4
XFILLER_23_561 vssd1 vssd1 vccd1 vccd1 sky130_fd_sc_hd__fill_8
XFILLER_24_43 vssd1 vssd1 vccd1 vccd1 sky130_fd_sc_hd__fill_1
XANTENNA__6132__A net112 vssd1 vssd1 vccd1 vccd1 sky130_fd_sc_hd__diode_2
XFILLER_10_288 vssd1 vssd1 vccd1 vccd1 sky130_fd_sc_hd__fill_1
XFILLER_77_211 vssd1 vssd1 vccd1 vccd1 sky130_fd_sc_hd__fill_2
XANTENNA__4258__A1 net10 vssd1 vssd1 vccd1 vccd1 sky130_fd_sc_hd__diode_2
XFILLER_92_225 vccd1 vssd1 vccd1 vssd1 sky130_ef_sc_hd__decap_40_12
XTAP_TAPCELL_ROW_76_957 vssd1 vccd1 sky130_fd_sc_hd__tapvpwrvgnd_1
XANTENNA_input13_X net13 vssd1 vssd1 vccd1 vccd1 sky130_fd_sc_hd__diode_2
XFILLER_65_83 vssd1 vssd1 vccd1 vccd1 sky130_fd_sc_hd__fill_8
XTAP_TAPCELL_ROW_86_1064 vssd1 vccd1 sky130_fd_sc_hd__tapvpwrvgnd_1
XFILLER_45_196 vssd1 vssd1 vccd1 vccd1 sky130_fd_sc_hd__fill_2
XTAP_TAPCELL_ROW_31_515 vssd1 vccd1 sky130_fd_sc_hd__tapvpwrvgnd_1
XANTENNA__4981__A2 net77 vssd1 vssd1 vccd1 vccd1 sky130_fd_sc_hd__diode_2
XFILLER_41_380 vssd1 vssd1 vccd1 vccd1 sky130_fd_sc_hd__fill_8
XFILLER_41_391 vssd1 vssd1 vccd1 vccd1 sky130_fd_sc_hd__fill_1
XANTENNA__5930__A1 net111 vssd1 vssd1 vccd1 vccd1 sky130_fd_sc_hd__diode_2
X_6290_ _1277_ _1279_ vssd1 vssd1 vccd1 vccd1 _1479_ sky130_fd_sc_hd__nor2_1
X_5310_ _1987_ _3774_ vssd1 vssd1 vccd1 vccd1 _0500_ sky130_fd_sc_hd__nor2_1
X_5241_ _0429_ _0430_ vssd1 vssd1 vccd1 vccd1 _0431_ sky130_fd_sc_hd__and2_1
X_5172_ _0360_ _0361_ vssd1 vssd1 vccd1 vccd1 _0362_ sky130_fd_sc_hd__and2b_1
XTAP_TAPCELL_ROW_3_229 vssd1 vccd1 sky130_fd_sc_hd__tapvpwrvgnd_1
Xinput2 gpio_in[0] vssd1 vssd1 vccd1 vccd1 net2 sky130_fd_sc_hd__buf_1
XFILLER_28_119 vssd1 vssd1 vccd1 vccd1 sky130_fd_sc_hd__fill_8
XANTENNA__4249__A1 net7 vssd1 vssd1 vccd1 vccd1 sky130_fd_sc_hd__diode_2
XFILLER_83_225 vssd1 vssd1 vccd1 vccd1 sky130_fd_sc_hd__fill_1
XFILLER_71_409 vssd1 vssd1 vccd1 vccd1 sky130_fd_sc_hd__fill_1
XFILLER_36_141 vssd1 vssd1 vccd1 vccd1 sky130_fd_sc_hd__fill_8
XTAP_TAPCELL_ROW_47_670 vssd1 vccd1 sky130_fd_sc_hd__tapvpwrvgnd_1
X_7813_ _2839_ _3067_ vssd1 vssd1 vccd1 vccd1 _3069_ sky130_fd_sc_hd__xnor2_1
X_7744_ _2993_ _2998_ vssd1 vssd1 vccd1 vccd1 _3000_ sky130_fd_sc_hd__xnor2_1
XTAP_TAPCELL_ROW_19_394 vssd1 vccd1 sky130_fd_sc_hd__tapvpwrvgnd_1
XFILLER_24_369 vccd1 vssd1 vccd1 vssd1 sky130_ef_sc_hd__decap_40_12
XFILLER_51_177 vssd1 vssd1 vccd1 vccd1 sky130_fd_sc_hd__fill_1
X_4956_ _4153_ _4155_ _0144_ vssd1 vssd1 vccd1 vccd1 _0146_ sky130_fd_sc_hd__nand3_1
X_7675_ net297 net188 vssd1 vssd1 vccd1 vccd1 _2929_ sky130_fd_sc_hd__nand2_1
X_4887_ _4159_ _0075_ vssd1 vssd1 vccd1 vccd1 _0077_ sky130_fd_sc_hd__xnor2_1
XFILLER_32_391 vssd1 vssd1 vccd1 vccd1 sky130_fd_sc_hd__fill_1
X_6626_ net243 net259 net254 net246 vssd1 vssd1 vccd1 vccd1 _1819_ sky130_fd_sc_hd__a22oi_1
XFILLER_20_553 vssd1 vssd1 vccd1 vccd1 sky130_fd_sc_hd__fill_2
X_6557_ net106 net39 vssd1 vssd1 vccd1 vccd1 _1744_ sky130_fd_sc_hd__nor2_1
X_5508_ _0695_ _0696_ net243 net290 vssd1 vssd1 vccd1 vccd1 _0698_ sky130_fd_sc_hd__and4b_1
XANTENNA_fanout200_X net200 vssd1 vssd1 vccd1 vccd1 sky130_fd_sc_hd__diode_2
X_6488_ _1673_ _1674_ vssd1 vssd1 vccd1 vccd1 _1676_ sky130_fd_sc_hd__xnor2_1
XFILLER_10_34 vssd1 vssd1 vccd1 vccd1 sky130_fd_sc_hd__fill_4
X_8227_ net201 net256 net252 net205 vssd1 vssd1 vccd1 vccd1 _3496_ sky130_fd_sc_hd__a22oi_1
XFILLER_10_56 vssd1 vssd1 vccd1 vccd1 sky130_fd_sc_hd__fill_8
X_5439_ net111 net63 vssd1 vssd1 vccd1 vccd1 _0629_ sky130_fd_sc_hd__nor2_1
XFILLER_87_520 vssd1 vssd1 vccd1 vccd1 sky130_fd_sc_hd__fill_2
X_8158_ net110 net37 _3421_ vssd1 vssd1 vccd1 vccd1 _3422_ sky130_fd_sc_hd__or3_1
X_7109_ _2328_ _2329_ vssd1 vssd1 vccd1 vccd1 _2330_ sky130_fd_sc_hd__nand2_1
XANTENNA_input5_X net5 vssd1 vssd1 vccd1 vccd1 sky130_fd_sc_hd__diode_2
X_8089_ _3338_ _3346_ vssd1 vssd1 vccd1 vccd1 _3348_ sky130_fd_sc_hd__xnor2_1
XFILLER_19_65 vssd1 vssd1 vccd1 vccd1 sky130_fd_sc_hd__fill_1
XANTENNA_fanout60_A net62 vssd1 vssd1 vccd1 vccd1 sky130_fd_sc_hd__diode_2
XTAP_TAPCELL_ROW_73_927 vssd1 vccd1 sky130_fd_sc_hd__tapvpwrvgnd_1
XFILLER_82_280 vssd1 vssd1 vccd1 vccd1 sky130_fd_sc_hd__fill_1
XFILLER_15_303 vssd1 vssd1 vccd1 vccd1 sky130_fd_sc_hd__fill_1
XFILLER_15_325 vssd1 vssd1 vccd1 vccd1 sky130_fd_sc_hd__fill_1
XFILLER_27_174 vssd1 vssd1 vccd1 vccd1 sky130_fd_sc_hd__fill_4
XFILLER_82_291 vssd1 vssd1 vccd1 vccd1 sky130_fd_sc_hd__fill_4
XFILLER_70_431 vssd1 vssd1 vccd1 vccd1 sky130_fd_sc_hd__fill_1
XFILLER_70_497 vssd1 vssd1 vccd1 vccd1 sky130_fd_sc_hd__fill_1
XFILLER_70_464 vssd1 vssd1 vccd1 vccd1 sky130_fd_sc_hd__fill_4
XFILLER_35_97 vssd1 vssd1 vccd1 vccd1 sky130_fd_sc_hd__fill_2
XFILLER_7_524 vccd1 vssd1 vccd1 vssd1 sky130_ef_sc_hd__decap_40_12
XFILLER_11_553 vssd1 vssd1 vccd1 vccd1 sky130_fd_sc_hd__fill_4
XANTENNA__4176__A0 net8 vssd1 vssd1 vccd1 vccd1 sky130_fd_sc_hd__diode_2
XFILLER_2_251 vssd1 vssd1 vccd1 vccd1 sky130_fd_sc_hd__fill_1
XFILLER_65_247 vssd1 vssd1 vccd1 vccd1 sky130_fd_sc_hd__fill_4
XFILLER_46_483 vssd1 vssd1 vccd1 vccd1 sky130_fd_sc_hd__fill_4
XFILLER_18_174 vssd1 vssd1 vccd1 vccd1 sky130_fd_sc_hd__fill_4
XFILLER_33_111 vssd1 vssd1 vccd1 vccd1 sky130_fd_sc_hd__fill_1
XFILLER_92_81 vssd1 vssd1 vccd1 vccd1 sky130_fd_sc_hd__fill_2
XTAP_TAPCELL_ROW_44_640 vssd1 vccd1 sky130_fd_sc_hd__tapvpwrvgnd_1
X_4810_ _4085_ _4086_ _4015_ _4017_ _4018_ vssd1 vssd1 vccd1 vccd1 _4088_ sky130_fd_sc_hd__a2111o_1
X_5790_ _0937_ _0979_ vssd1 vssd1 vccd1 vccd1 _0980_ sky130_fd_sc_hd__or2_1
XTAP_TAPCELL_ROW_16_364 vssd1 vccd1 sky130_fd_sc_hd__tapvpwrvgnd_1
XANTENNA__5595__B net273 vssd1 vssd1 vccd1 vccd1 sky130_fd_sc_hd__diode_2
X_4741_ _3962_ _4016_ vssd1 vssd1 vccd1 vccd1 _4019_ sky130_fd_sc_hd__xnor2_1
X_7460_ _2692_ _2701_ vssd1 vssd1 vccd1 vccd1 _2702_ sky130_fd_sc_hd__xnor2_1
X_4672_ _3948_ _3949_ vssd1 vssd1 vccd1 vccd1 _3950_ sky130_fd_sc_hd__nand2_1
X_6411_ _1596_ _1597_ vssd1 vssd1 vccd1 vccd1 _1599_ sky130_fd_sc_hd__xnor2_1
X_7391_ _2620_ _2621_ _2628_ vssd1 vssd1 vccd1 vccd1 _2629_ sky130_fd_sc_hd__nand3_1
XANTENNA__7018__D net254 vssd1 vssd1 vccd1 vccd1 sky130_fd_sc_hd__diode_2
X_6342_ net165 net78 _1528_ vssd1 vssd1 vccd1 vccd1 _1530_ sky130_fd_sc_hd__and3_1
XFILLER_88_306 vssd1 vssd1 vccd1 vccd1 sky130_fd_sc_hd__fill_2
X_6273_ _1460_ _1461_ vssd1 vssd1 vccd1 vccd1 _1462_ sky130_fd_sc_hd__nand2_1
X_8012_ net94 net44 vssd1 vssd1 vccd1 vccd1 _3266_ sky130_fd_sc_hd__or2_1
X_5224_ _0412_ _0413_ vssd1 vssd1 vccd1 vccd1 _0414_ sky130_fd_sc_hd__and2b_1
XFILLER_84_512 vssd1 vssd1 vccd1 vccd1 sky130_fd_sc_hd__fill_2
XANTENNA_fanout195_A net196 vssd1 vssd1 vccd1 vccd1 sky130_fd_sc_hd__diode_2
X_5155_ _0331_ _0343_ vssd1 vssd1 vccd1 vccd1 _0345_ sky130_fd_sc_hd__xor2_1
XFILLER_84_545 vssd1 vssd1 vccd1 vccd1 sky130_fd_sc_hd__fill_1
X_5086_ _0273_ _0274_ vssd1 vssd1 vccd1 vccd1 _0276_ sky130_fd_sc_hd__xor2_1
XFILLER_37_472 vccd1 vssd1 vccd1 vssd1 sky130_ef_sc_hd__decap_40_12
XFILLER_37_494 vssd1 vssd1 vccd1 vccd1 sky130_fd_sc_hd__fill_1
XFILLER_72_18 vssd1 vssd1 vccd1 vccd1 sky130_fd_sc_hd__fill_2
XFILLER_52_475 vssd1 vssd1 vccd1 vccd1 sky130_fd_sc_hd__fill_1
XFILLER_52_464 vssd1 vssd1 vccd1 vccd1 sky130_fd_sc_hd__fill_1
XFILLER_24_166 vssd1 vssd1 vccd1 vccd1 sky130_fd_sc_hd__fill_4
X_5988_ _0516_ _0535_ _1176_ vssd1 vssd1 vccd1 vccd1 _1178_ sky130_fd_sc_hd__a21o_1
X_7727_ net214 net218 net256 net253 vssd1 vssd1 vccd1 vccd1 _2983_ sky130_fd_sc_hd__and4_1
X_4939_ _0124_ _0128_ vssd1 vssd1 vccd1 vccd1 _0129_ sky130_fd_sc_hd__xnor2_1
XFILLER_24_188 vssd1 vssd1 vccd1 vccd1 sky130_fd_sc_hd__fill_2
X_7658_ _2902_ _2911_ vssd1 vssd1 vccd1 vccd1 _2912_ sky130_fd_sc_hd__nand2b_1
XANTENNA__8312__D net189 vssd1 vssd1 vccd1 vccd1 sky130_fd_sc_hd__diode_2
XTAP_TAPCELL_ROW_50_698 vssd1 vccd1 sky130_fd_sc_hd__tapvpwrvgnd_1
XFILLER_20_372 vssd1 vssd1 vccd1 vccd1 sky130_fd_sc_hd__fill_8
X_6609_ _1798_ _1799_ vssd1 vssd1 vccd1 vccd1 _1800_ sky130_fd_sc_hd__nor2_1
XFILLER_21_33 vssd1 vssd1 vccd1 vccd1 sky130_fd_sc_hd__fill_4
X_7589_ _2612_ net42 vssd1 vssd1 vccd1 vccd1 _2839_ sky130_fd_sc_hd__nor2_1
XFILLER_75_512 vssd1 vssd1 vccd1 vccd1 sky130_fd_sc_hd__fill_1
XANTENNA_fanout63_X net63 vssd1 vssd1 vccd1 vccd1 sky130_fd_sc_hd__diode_2
XTAP_TAPCELL_ROW_58_776 vssd1 vccd1 sky130_fd_sc_hd__tapvpwrvgnd_1
XTAP_TAPCELL_ROW_83_1034 vssd1 vccd1 sky130_fd_sc_hd__tapvpwrvgnd_1
XFILLER_43_453 vssd1 vssd1 vccd1 vccd1 sky130_fd_sc_hd__fill_2
XFILLER_15_144 vssd1 vssd1 vccd1 vccd1 sky130_fd_sc_hd__fill_1
XANTENNA__8072__A net317 vssd1 vssd1 vccd1 vccd1 sky130_fd_sc_hd__diode_2
XFILLER_43_475 vssd1 vssd1 vccd1 vccd1 sky130_fd_sc_hd__fill_1
XTAP_TAPCELL_ROW_41_610 vssd1 vccd1 sky130_fd_sc_hd__tapvpwrvgnd_1
XTAP_TAPCELL_ROW_13_334 vssd1 vccd1 sky130_fd_sc_hd__tapvpwrvgnd_1
XFILLER_30_158 vssd1 vssd1 vccd1 vccd1 sky130_fd_sc_hd__fill_1
XFILLER_30_169 vssd1 vssd1 vccd1 vccd1 sky130_fd_sc_hd__fill_1
XFILLER_7_387 vssd1 vssd1 vccd1 vccd1 sky130_fd_sc_hd__fill_4
XANTENNA__5649__B1 net210 vssd1 vssd1 vccd1 vccd1 sky130_fd_sc_hd__diode_2
XANTENNA__6974__B net47 vssd1 vssd1 vccd1 vccd1 sky130_fd_sc_hd__diode_2
X_6960_ _2063_ _2171_ vssd1 vssd1 vccd1 vccd1 _2173_ sky130_fd_sc_hd__xnor2_1
X_5911_ _0927_ _1099_ vssd1 vssd1 vccd1 vccd1 _1101_ sky130_fd_sc_hd__or2_1
X_6891_ _2097_ _2098_ vssd1 vssd1 vccd1 vccd1 _2100_ sky130_fd_sc_hd__xor2_1
X_5842_ net320 net233 _1031_ vssd1 vssd1 vccd1 vccd1 _1032_ sky130_fd_sc_hd__and3_1
X_5773_ _0950_ _0962_ _0915_ _0930_ vssd1 vssd1 vccd1 vccd1 _0963_ sky130_fd_sc_hd__o211a_1
XFILLER_21_125 vssd1 vssd1 vccd1 vccd1 sky130_fd_sc_hd__fill_2
X_4724_ _3832_ _4001_ vssd1 vssd1 vccd1 vccd1 _4002_ sky130_fd_sc_hd__xor2_1
XFILLER_21_169 vccd1 vssd1 vccd1 vssd1 sky130_ef_sc_hd__decap_40_12
X_7512_ net99 net46 vssd1 vssd1 vccd1 vccd1 _2757_ sky130_fd_sc_hd__nor2_1
XANTENNA_clkbuf_4_8_0_clk_A clknet_0_clk vssd1 vssd1 vccd1 vccd1 sky130_fd_sc_hd__diode_2
XANTENNA__7029__C net195 vssd1 vssd1 vccd1 vccd1 sky130_fd_sc_hd__diode_2
X_7443_ _2682_ _2683_ vssd1 vssd1 vccd1 vccd1 _2684_ sky130_fd_sc_hd__nand2_1
X_4655_ _3924_ _3931_ _3930_ vssd1 vssd1 vccd1 vccd1 _3933_ sky130_fd_sc_hd__a21bo_1
XANTENNA_fanout208_A PID_INST.k2_calc.sum_reg\[11\] vssd1 vssd1 vccd1 vccd1 sky130_fd_sc_hd__diode_2
X_7374_ _2340_ _2342_ _2610_ vssd1 vssd1 vccd1 vccd1 _2611_ sky130_fd_sc_hd__a21o_1
X_4586_ net124 net144 _3847_ _3863_ vssd1 vssd1 vccd1 vccd1 _3864_ sky130_fd_sc_hd__and4_1
XANTENNA__7045__B net232 vssd1 vssd1 vccd1 vccd1 sky130_fd_sc_hd__diode_2
X_6325_ net118 net52 vssd1 vssd1 vccd1 vccd1 _1513_ sky130_fd_sc_hd__nor2_1
XFILLER_88_125 vssd1 vssd1 vccd1 vccd1 sky130_fd_sc_hd__fill_2
X_6256_ _1443_ _1444_ vssd1 vssd1 vccd1 vccd1 _1445_ sky130_fd_sc_hd__xnor2_1
XFILLER_67_29 vssd1 vssd1 vccd1 vccd1 sky130_fd_sc_hd__fill_4
XFILLER_76_309 vccd1 vssd1 vccd1 vssd1 sky130_ef_sc_hd__decap_40_12
XFILLER_69_350 vssd1 vssd1 vccd1 vccd1 sky130_fd_sc_hd__fill_2
XANTENNA_fanout198_X net198 vssd1 vssd1 vccd1 vccd1 sky130_fd_sc_hd__diode_2
X_5207_ _0231_ _0296_ _0295_ vssd1 vssd1 vccd1 vccd1 _0397_ sky130_fd_sc_hd__a21oi_1
X_6187_ _1375_ _1368_ vssd1 vssd1 vccd1 vccd1 _1376_ sky130_fd_sc_hd__and2b_1
X_5138_ _0306_ _0325_ vssd1 vssd1 vccd1 vccd1 _0328_ sky130_fd_sc_hd__xnor2_1
XFILLER_29_225 vssd1 vssd1 vccd1 vccd1 sky130_fd_sc_hd__fill_1
XFILLER_57_556 vssd1 vssd1 vccd1 vccd1 sky130_fd_sc_hd__fill_1
XFILLER_29_258 vssd1 vssd1 vccd1 vccd1 sky130_fd_sc_hd__fill_2
XFILLER_83_28 vssd1 vssd1 vccd1 vccd1 sky130_fd_sc_hd__fill_2
X_5069_ _0181_ _0258_ vssd1 vssd1 vccd1 vccd1 _0259_ sky130_fd_sc_hd__nor2_1
XTAP_TAPCELL_ROW_55_746 vssd1 vccd1 sky130_fd_sc_hd__tapvpwrvgnd_1
XFILLER_52_250 vssd1 vssd1 vccd1 vccd1 sky130_fd_sc_hd__fill_2
XTAP_TAPCELL_ROW_10_304 vssd1 vccd1 sky130_fd_sc_hd__tapvpwrvgnd_1
XPHY_EDGE_ROW_26_Left_119 vssd1 vssd1 vccd1 vccd1 sky130_fd_sc_hd__decap_3
XFILLER_4_379 vssd1 vssd1 vccd1 vccd1 sky130_fd_sc_hd__fill_2
XANTENNA__8293__A1 net276 vssd1 vssd1 vccd1 vccd1 sky130_fd_sc_hd__diode_2
XANTENNA__4303__A0 net275 vssd1 vssd1 vccd1 vccd1 sky130_fd_sc_hd__diode_2
XFILLER_79_169 vssd1 vssd1 vccd1 vccd1 sky130_fd_sc_hd__fill_4
XFILLER_0_552 vssd1 vssd1 vccd1 vccd1 sky130_fd_sc_hd__fill_8
XFILLER_57_73 vssd1 vssd1 vccd1 vccd1 sky130_fd_sc_hd__fill_2
XFILLER_90_356 vssd1 vssd1 vccd1 vccd1 sky130_fd_sc_hd__fill_2
XFILLER_63_559 vssd1 vssd1 vccd1 vccd1 sky130_fd_sc_hd__fill_1
XPHY_EDGE_ROW_35_Left_128 vssd1 vssd1 vccd1 vccd1 sky130_fd_sc_hd__decap_3
XANTENNA__6315__A net140 vssd1 vssd1 vccd1 vccd1 sky130_fd_sc_hd__diode_2
XFILLER_16_475 vssd1 vssd1 vccd1 vccd1 sky130_fd_sc_hd__fill_1
XFILLER_43_261 vssd1 vssd1 vccd1 vccd1 sky130_fd_sc_hd__fill_4
XANTENNA__8233__C net194 vssd1 vssd1 vccd1 vccd1 sky130_fd_sc_hd__diode_2
XFILLER_16_486 vssd1 vssd1 vccd1 vccd1 sky130_fd_sc_hd__fill_4
XFILLER_85_6 vccd1 vssd1 vccd1 vssd1 sky130_ef_sc_hd__decap_40_12
XFILLER_31_467 vssd1 vssd1 vccd1 vccd1 sky130_fd_sc_hd__fill_1
XPHY_EDGE_ROW_44_Left_137 vssd1 vssd1 vccd1 vccd1 sky130_fd_sc_hd__decap_3
X_4440_ PID_INST.k1_calc.d1.x\[3\] PID_INST.k3_calc.prev_error\[3\] vssd1 vssd1 vccd1
+ vccd1 _3718_ sky130_fd_sc_hd__or2_1
X_4371_ _3665_ _3666_ vssd1 vssd1 vccd1 vccd1 _3667_ sky130_fd_sc_hd__xor2_1
X_6110_ _1297_ _1298_ vssd1 vssd1 vccd1 vccd1 _1299_ sky130_fd_sc_hd__xnor2_1
X_7090_ _2224_ _2309_ vssd1 vssd1 vccd1 vccd1 _2311_ sky130_fd_sc_hd__xor2_1
X_6041_ net291 net223 vssd1 vssd1 vccd1 vccd1 _1231_ sky130_fd_sc_hd__nand2_1
XFILLER_58_309 vssd1 vssd1 vccd1 vccd1 sky130_fd_sc_hd__fill_4
X_7992_ _3237_ _3238_ _3244_ vssd1 vssd1 vccd1 vccd1 _3247_ sky130_fd_sc_hd__a21oi_1
XPHY_EDGE_ROW_53_Left_146 vssd1 vssd1 vccd1 vccd1 sky130_fd_sc_hd__decap_3
XFILLER_81_345 vssd1 vssd1 vccd1 vccd1 sky130_fd_sc_hd__fill_1
XFILLER_54_559 vssd1 vssd1 vccd1 vccd1 sky130_fd_sc_hd__fill_2
X_6943_ _2154_ _2153_ vssd1 vssd1 vccd1 vccd1 _2155_ sky130_fd_sc_hd__xor2_2
XTAP_TAPCELL_ROW_52_716 vssd1 vccd1 sky130_fd_sc_hd__tapvpwrvgnd_1
X_6874_ _1304_ _1771_ _1772_ _1775_ vssd1 vssd1 vccd1 vccd1 _2082_ sky130_fd_sc_hd__a22o_1
XFILLER_34_250 vssd1 vssd1 vccd1 vccd1 sky130_fd_sc_hd__fill_2
X_5825_ _0983_ _1014_ vssd1 vssd1 vccd1 vccd1 _1015_ sky130_fd_sc_hd__or2_1
XANTENNA_fanout158_A net159 vssd1 vssd1 vccd1 vccd1 sky130_fd_sc_hd__diode_2
XFILLER_22_434 vssd1 vssd1 vccd1 vccd1 sky130_fd_sc_hd__fill_1
XFILLER_34_294 vssd1 vssd1 vccd1 vccd1 sky130_fd_sc_hd__fill_1
X_5756_ _0895_ _0939_ _0944_ vssd1 vssd1 vccd1 vccd1 _0946_ sky130_fd_sc_hd__o21ai_1
XPHY_EDGE_ROW_62_Left_155 vssd1 vssd1 vccd1 vccd1 sky130_fd_sc_hd__decap_3
X_5687_ _0851_ _0858_ _0870_ _0874_ vssd1 vssd1 vccd1 vccd1 _0877_ sky130_fd_sc_hd__a211oi_1
X_8475_ clknet_4_14_0_clk _0063_ net340 vssd1 vssd1 vccd1 vccd1 net24 sky130_fd_sc_hd__dfrtp_1
X_4707_ _3983_ _3984_ vssd1 vssd1 vccd1 vccd1 _3985_ sky130_fd_sc_hd__or2_1
X_7426_ _2658_ _2663_ vssd1 vssd1 vccd1 vccd1 _2666_ sky130_fd_sc_hd__or2_1
X_4638_ _3898_ _3907_ _3914_ vssd1 vssd1 vccd1 vccd1 _3916_ sky130_fd_sc_hd__a21o_1
XANTENNA_fanout113_X net113 vssd1 vssd1 vccd1 vccd1 sky130_fd_sc_hd__diode_2
X_7357_ _2331_ _2344_ _2592_ vssd1 vssd1 vccd1 vccd1 _2593_ sky130_fd_sc_hd__a21oi_1
X_4569_ net128 net126 net152 net150 vssd1 vssd1 vccd1 vccd1 _3847_ sky130_fd_sc_hd__nand4_2
XFILLER_89_445 vssd1 vssd1 vccd1 vccd1 sky130_fd_sc_hd__fill_2
X_6308_ _1108_ _1295_ _1297_ _1298_ vssd1 vssd1 vccd1 vccd1 _1496_ sky130_fd_sc_hd__a22oi_1
X_7288_ _2518_ _2519_ vssd1 vssd1 vccd1 vccd1 _2520_ sky130_fd_sc_hd__xnor2_1
X_6239_ net203 net315 net303 net211 vssd1 vssd1 vccd1 vccd1 _1428_ sky130_fd_sc_hd__and4_1
XFILLER_49_309 vssd1 vssd1 vccd1 vccd1 sky130_fd_sc_hd__fill_1
XPHY_EDGE_ROW_71_Left_164 vssd1 vssd1 vccd1 vccd1 sky130_fd_sc_hd__decap_3
XFILLER_57_353 vssd1 vssd1 vccd1 vccd1 sky130_fd_sc_hd__fill_8
XFILLER_72_301 vssd1 vssd1 vccd1 vccd1 sky130_fd_sc_hd__fill_4
XTAP_TAPCELL_ROW_68_882 vssd1 vccd1 sky130_fd_sc_hd__tapvpwrvgnd_1
XANTENNA__5958__B net74 vssd1 vssd1 vccd1 vccd1 sky130_fd_sc_hd__diode_2
XFILLER_27_76 vssd1 vssd1 vccd1 vccd1 sky130_fd_sc_hd__fill_1
XFILLER_72_367 vssd1 vssd1 vccd1 vccd1 sky130_fd_sc_hd__fill_2
XFILLER_13_401 vssd1 vssd1 vccd1 vccd1 sky130_fd_sc_hd__fill_2
XFILLER_25_250 vssd1 vssd1 vccd1 vccd1 sky130_fd_sc_hd__fill_1
XTAP_TAPCELL_ROW_80_1004 vssd1 vccd1 sky130_fd_sc_hd__tapvpwrvgnd_1
XFILLER_43_31 vssd1 vssd1 vccd1 vccd1 sky130_fd_sc_hd__fill_1
XFILLER_9_405 vccd1 vssd1 vccd1 vssd1 sky130_ef_sc_hd__decap_40_12
XFILLER_13_445 vssd1 vssd1 vccd1 vccd1 sky130_fd_sc_hd__fill_1
XANTENNA__5974__A net127 vssd1 vssd1 vccd1 vccd1 sky130_fd_sc_hd__diode_2
XFILLER_43_53 vssd1 vssd1 vccd1 vccd1 sky130_fd_sc_hd__fill_2
XPHY_EDGE_ROW_80_Left_173 vssd1 vssd1 vccd1 vccd1 sky130_fd_sc_hd__decap_3
XFILLER_9_449 vccd1 vssd1 vccd1 vssd1 sky130_ef_sc_hd__decap_40_12
XFILLER_9_438 vssd1 vssd1 vccd1 vccd1 sky130_fd_sc_hd__fill_8
XFILLER_9_427 vssd1 vssd1 vccd1 vccd1 sky130_fd_sc_hd__fill_1
XTAP_TAPCELL_ROW_91_1111 vssd1 vccd1 sky130_fd_sc_hd__tapvpwrvgnd_1
XANTENNA__8228__C net256 vssd1 vssd1 vccd1 vccd1 sky130_fd_sc_hd__diode_2
XFILLER_67_139 vssd1 vssd1 vccd1 vccd1 sky130_fd_sc_hd__fill_1
XANTENNA__5214__A net105 vssd1 vssd1 vccd1 vccd1 sky130_fd_sc_hd__diode_2
XFILLER_0_382 vssd1 vssd1 vccd1 vccd1 sky130_fd_sc_hd__fill_1
XFILLER_48_342 vssd1 vssd1 vccd1 vccd1 sky130_fd_sc_hd__fill_2
XTAP_TAPCELL_ROW_89_1095 vssd1 vccd1 sky130_fd_sc_hd__tapvpwrvgnd_1
XFILLER_75_183 vssd1 vssd1 vccd1 vccd1 sky130_fd_sc_hd__fill_4
XFILLER_90_197 vssd1 vssd1 vccd1 vccd1 sky130_fd_sc_hd__fill_1
XFILLER_83_3 vssd1 vssd1 vccd1 vccd1 sky130_fd_sc_hd__fill_4
X_5610_ _0796_ _0799_ vssd1 vssd1 vccd1 vccd1 _0800_ sky130_fd_sc_hd__xnor2_1
X_6590_ _1777_ _1778_ vssd1 vssd1 vccd1 vccd1 _1779_ sky130_fd_sc_hd__nor2_1
X_5541_ _0729_ _0730_ vssd1 vssd1 vccd1 vccd1 _0731_ sky130_fd_sc_hd__nor2_1
X_8260_ _3394_ _3399_ _3530_ vssd1 vssd1 vccd1 vccd1 _3532_ sky130_fd_sc_hd__nor3_1
X_5472_ _0659_ _0660_ vssd1 vssd1 vccd1 vccd1 _0662_ sky130_fd_sc_hd__nand2_1
X_7211_ PID_INST.k3_calc.d2.y\[8\] _0474_ _0475_ vssd1 vssd1 vccd1 vccd1 _2438_ sky130_fd_sc_hd__and3_1
X_8191_ net305 PID_INST.k2_calc.sum_reg\[22\] _3357_ _3358_ net191 vssd1 vssd1 vccd1
+ vccd1 _3457_ sky130_fd_sc_hd__a32oi_2
X_4423_ PID_INST.k2_calc.sum_reg\[23\] _3705_ vssd1 vssd1 vccd1 vccd1 _0055_ sky130_fd_sc_hd__xor2_1
X_7142_ _2355_ _2364_ vssd1 vssd1 vccd1 vccd1 _2365_ sky130_fd_sc_hd__xnor2_1
X_4354_ net222 net19 _3648_ vssd1 vssd1 vccd1 vccd1 _3652_ sky130_fd_sc_hd__o21a_1
XANTENNA__7604__A net140 vssd1 vssd1 vccd1 vccd1 sky130_fd_sc_hd__diode_2
X_7073_ net207 net287 _2291_ vssd1 vssd1 vccd1 vccd1 _2293_ sky130_fd_sc_hd__a21oi_1
XFILLER_86_415 vssd1 vssd1 vccd1 vccd1 sky130_fd_sc_hd__fill_1
XFILLER_86_448 vssd1 vssd1 vccd1 vccd1 sky130_fd_sc_hd__fill_2
X_6024_ _1213_ vssd1 vssd1 vccd1 vccd1 _1214_ sky130_fd_sc_hd__inv_2
X_4285_ net3 net395 net158 vssd1 vssd1 vccd1 vccd1 _0008_ sky130_fd_sc_hd__mux2_1
XANTENNA__5124__A net116 vssd1 vssd1 vccd1 vccd1 sky130_fd_sc_hd__diode_2
XFILLER_39_331 vssd1 vssd1 vccd1 vccd1 sky130_fd_sc_hd__fill_4
X_7975_ _2999_ _3001_ _3228_ vssd1 vssd1 vccd1 vccd1 _3230_ sky130_fd_sc_hd__nand3_1
XFILLER_66_183 vssd1 vssd1 vccd1 vccd1 sky130_fd_sc_hd__fill_8
XFILLER_54_345 vssd1 vssd1 vccd1 vccd1 sky130_fd_sc_hd__fill_4
XFILLER_39_397 vssd1 vssd1 vccd1 vccd1 sky130_fd_sc_hd__fill_1
XTAP_TAPCELL_ROW_65_852 vssd1 vccd1 sky130_fd_sc_hd__tapvpwrvgnd_1
X_6926_ _2134_ _2136_ vssd1 vssd1 vccd1 vccd1 _2137_ sky130_fd_sc_hd__xor2_1
XFILLER_54_356 vssd1 vssd1 vccd1 vccd1 sky130_fd_sc_hd__fill_8
XFILLER_81_186 vssd1 vssd1 vccd1 vccd1 sky130_fd_sc_hd__fill_8
X_6857_ net101 net58 vssd1 vssd1 vccd1 vccd1 _2064_ sky130_fd_sc_hd__nor2_1
Xfanout46 net47 vssd1 vssd1 vccd1 vccd1 net46 sky130_fd_sc_hd__buf_2
X_5808_ _0993_ _0997_ vssd1 vssd1 vccd1 vccd1 _0998_ sky130_fd_sc_hd__xnor2_1
XANTENNA_fanout230_X net230 vssd1 vssd1 vccd1 vccd1 sky130_fd_sc_hd__diode_2
X_6788_ _1716_ _1726_ _1724_ vssd1 vssd1 vccd1 vccd1 _1991_ sky130_fd_sc_hd__a21oi_1
Xfanout79 _3756_ vssd1 vssd1 vccd1 vccd1 net79 sky130_fd_sc_hd__buf_2
XANTENNA_fanout328_X net328 vssd1 vssd1 vccd1 vccd1 sky130_fd_sc_hd__diode_2
Xfanout68 _0236_ vssd1 vssd1 vccd1 vccd1 net68 sky130_fd_sc_hd__buf_2
X_5739_ _0916_ _0920_ _0919_ vssd1 vssd1 vccd1 vccd1 _0929_ sky130_fd_sc_hd__o21ai_1
XFILLER_10_448 vssd1 vssd1 vccd1 vccd1 sky130_fd_sc_hd__fill_1
XFILLER_13_34 vccd1 vssd1 vccd1 vssd1 sky130_ef_sc_hd__decap_40_12
X_8458_ clknet_4_7_0_clk _0046_ net332 vssd1 vssd1 vccd1 vccd1 PID_INST.k2_calc.sum_reg\[14\]
+ sky130_fd_sc_hd__dfrtp_1
X_8389_ clknet_4_12_0_clk PID_INST.k3_calc.d2.y\[9\] net329 vssd1 vssd1 vccd1 vccd1
+ PID_INST.k3_calc.timescaling_term\[9\] sky130_fd_sc_hd__dfrtp_1
X_7409_ _2479_ _2480_ _2478_ vssd1 vssd1 vccd1 vccd1 _2649_ sky130_fd_sc_hd__a21oi_2
XANTENNA__4857__B net88 vssd1 vssd1 vccd1 vccd1 sky130_fd_sc_hd__diode_2
XFILLER_49_117 vssd1 vssd1 vccd1 vccd1 sky130_fd_sc_hd__fill_8
XANTENNA__7759__B1 net192 vssd1 vssd1 vccd1 vccd1 sky130_fd_sc_hd__diode_2
XFILLER_18_537 vssd1 vssd1 vccd1 vccd1 sky130_fd_sc_hd__fill_2
XFILLER_60_304 vssd1 vssd1 vccd1 vccd1 sky130_fd_sc_hd__fill_1
XTAP_TAPCELL_ROW_0_190 vssd1 vccd1 sky130_fd_sc_hd__tapvpwrvgnd_1
XFILLER_54_85 vssd1 vssd1 vccd1 vccd1 sky130_fd_sc_hd__fill_2
XANTENNA__7931__B1 net252 vssd1 vssd1 vccd1 vccd1 sky130_fd_sc_hd__diode_2
XFILLER_13_286 vssd1 vssd1 vccd1 vccd1 sky130_fd_sc_hd__fill_4
XANTENNA__8415__CLK clknet_4_1_0_clk vssd1 vssd1 vccd1 vccd1 sky130_fd_sc_hd__diode_2
XFILLER_79_71 vssd1 vssd1 vccd1 vccd1 sky130_fd_sc_hd__fill_2
XFILLER_5_485 vccd1 vssd1 vccd1 vssd1 sky130_ef_sc_hd__decap_40_12
XANTENNA__8392__RESET_B net328 vssd1 vssd1 vccd1 vccd1 sky130_fd_sc_hd__diode_2
XTAP_TAPCELL_ROW_79_988 vssd1 vccd1 sky130_fd_sc_hd__tapvpwrvgnd_1
XFILLER_36_301 vssd1 vssd1 vccd1 vccd1 sky130_fd_sc_hd__fill_1
XFILLER_91_451 vssd1 vssd1 vccd1 vccd1 sky130_fd_sc_hd__fill_8
X_7760_ _3014_ _3015_ vssd1 vssd1 vccd1 vccd1 _3016_ sky130_fd_sc_hd__nor2_1
XTAP_TAPCELL_ROW_62_822 vssd1 vccd1 sky130_fd_sc_hd__tapvpwrvgnd_1
XFILLER_51_337 vssd1 vssd1 vccd1 vccd1 sky130_fd_sc_hd__fill_1
X_4972_ _0091_ _0161_ vssd1 vssd1 vccd1 vccd1 _0162_ sky130_fd_sc_hd__xor2_1
X_7691_ net305 net186 _2690_ _2689_ vssd1 vssd1 vccd1 vccd1 _2946_ sky130_fd_sc_hd__a31oi_1
X_6711_ net238 net258 net255 net242 vssd1 vssd1 vccd1 vccd1 _1908_ sky130_fd_sc_hd__a22oi_1
XFILLER_32_540 vssd1 vssd1 vccd1 vccd1 sky130_fd_sc_hd__fill_4
X_6642_ _1833_ _1834_ vssd1 vssd1 vccd1 vccd1 _1835_ sky130_fd_sc_hd__nor2_1
X_8312_ net267 net263 net191 net189 vssd1 vssd1 vccd1 vccd1 _3587_ sky130_fd_sc_hd__nand4_1
XANTENNA__5119__A net118 vssd1 vssd1 vccd1 vccd1 sky130_fd_sc_hd__diode_2
X_6573_ net101 net61 vssd1 vssd1 vccd1 vccd1 _1760_ sky130_fd_sc_hd__nor2_1
X_5524_ net249 net273 net306 net224 vssd1 vssd1 vccd1 vccd1 _0714_ sky130_fd_sc_hd__a22oi_1
XFILLER_8_290 vssd1 vssd1 vccd1 vccd1 sky130_fd_sc_hd__fill_1
X_8243_ _3324_ _3331_ _3511_ vssd1 vssd1 vccd1 vccd1 _3513_ sky130_fd_sc_hd__nand3_1
X_5455_ _0643_ _0644_ vssd1 vssd1 vccd1 vccd1 _0645_ sky130_fd_sc_hd__nand2_1
XANTENNA__4958__A net114 vssd1 vssd1 vccd1 vccd1 sky130_fd_sc_hd__diode_2
XANTENNA__7334__A net226 vssd1 vssd1 vccd1 vccd1 sky130_fd_sc_hd__diode_2
X_4406_ net189 net160 _3692_ _3695_ vssd1 vssd1 vccd1 vccd1 _3696_ sky130_fd_sc_hd__and4_1
X_8174_ _3437_ _3438_ vssd1 vssd1 vccd1 vccd1 _3439_ sky130_fd_sc_hd__xor2_1
X_7125_ _2344_ _2345_ vssd1 vssd1 vccd1 vccd1 _2347_ sky130_fd_sc_hd__nand2_1
Xfanout203 net204 vssd1 vssd1 vccd1 vccd1 net203 sky130_fd_sc_hd__buf_2
Xfanout214 net217 vssd1 vssd1 vccd1 vccd1 net214 sky130_fd_sc_hd__buf_2
X_5386_ _0574_ _0575_ vssd1 vssd1 vccd1 vccd1 _0576_ sky130_fd_sc_hd__xnor2_1
XFILLER_5_90 vssd1 vssd1 vccd1 vccd1 sky130_fd_sc_hd__fill_2
Xfanout225 PID_INST.k2_calc.sum_reg\[7\] vssd1 vssd1 vccd1 vccd1 net225 sky130_fd_sc_hd__buf_2
Xfanout236 PID_INST.k2_calc.sum_reg\[4\] vssd1 vssd1 vccd1 vccd1 net236 sky130_fd_sc_hd__clkbuf_2
Xfanout247 net248 vssd1 vssd1 vccd1 vccd1 net247 sky130_fd_sc_hd__clkbuf_2
X_4337_ _3568_ _3579_ vssd1 vssd1 vccd1 vccd1 _3590_ sky130_fd_sc_hd__nand2_1
XANTENNA__7988__B net188 vssd1 vssd1 vccd1 vccd1 sky130_fd_sc_hd__diode_2
X_7056_ _2272_ _2273_ vssd1 vssd1 vccd1 vccd1 _2276_ sky130_fd_sc_hd__xnor2_1
XANTENNA__7453__A2 net282 vssd1 vssd1 vccd1 vccd1 sky130_fd_sc_hd__diode_2
Xfanout269 net270 vssd1 vssd1 vccd1 vccd1 net269 sky130_fd_sc_hd__clkbuf_2
Xfanout258 net259 vssd1 vssd1 vccd1 vccd1 net258 sky130_fd_sc_hd__buf_2
X_4268_ _1838_ _2792_ _2845_ vssd1 vssd1 vccd1 vccd1 PID_INST.pid.next_state\[1\]
+ sky130_fd_sc_hd__and3_1
XFILLER_75_29 vssd1 vssd1 vccd1 vccd1 sky130_fd_sc_hd__fill_8
X_6007_ _1127_ _1196_ vssd1 vssd1 vccd1 vccd1 _1197_ sky130_fd_sc_hd__xnor2_1
XANTENNA__5077__A2_N net89 vssd1 vssd1 vccd1 vccd1 sky130_fd_sc_hd__diode_2
XANTENNA_fanout278_X net278 vssd1 vssd1 vccd1 vccd1 sky130_fd_sc_hd__diode_2
X_4199_ net17 net174 _2135_ vssd1 vssd1 vccd1 vccd1 _2146_ sky130_fd_sc_hd__o21ai_4
XFILLER_27_345 vssd1 vssd1 vccd1 vccd1 sky130_fd_sc_hd__fill_8
XFILLER_27_367 vssd1 vssd1 vccd1 vccd1 sky130_fd_sc_hd__fill_1
XFILLER_82_484 vssd1 vssd1 vccd1 vccd1 sky130_fd_sc_hd__fill_2
X_7958_ net206 net260 net196 net272 vssd1 vssd1 vccd1 vccd1 _3213_ sky130_fd_sc_hd__a22o_1
XFILLER_54_175 vssd1 vssd1 vccd1 vccd1 sky130_fd_sc_hd__fill_1
X_7889_ _3142_ _3143_ vssd1 vssd1 vccd1 vccd1 _3144_ sky130_fd_sc_hd__xor2_1
X_6909_ _2031_ _2032_ _2034_ vssd1 vssd1 vccd1 vccd1 _2119_ sky130_fd_sc_hd__o21ai_1
XFILLER_24_66 vssd1 vssd1 vccd1 vccd1 sky130_fd_sc_hd__fill_4
XFILLER_10_245 vssd1 vssd1 vccd1 vccd1 sky130_fd_sc_hd__fill_4
XANTENNA__6132__B net47 vssd1 vssd1 vccd1 vccd1 sky130_fd_sc_hd__diode_2
XFILLER_40_54 vssd1 vssd1 vccd1 vccd1 sky130_fd_sc_hd__fill_1
XANTENNA__5971__B _0088_ vssd1 vssd1 vccd1 vccd1 sky130_fd_sc_hd__diode_2
XFILLER_77_223 vssd1 vssd1 vccd1 vccd1 sky130_fd_sc_hd__fill_1
XFILLER_2_477 vccd1 vssd1 vccd1 vssd1 sky130_ef_sc_hd__decap_40_12
XFILLER_1_15 vccd1 vssd1 vccd1 vssd1 sky130_ef_sc_hd__decap_40_12
XFILLER_92_237 vccd1 vssd1 vccd1 vssd1 sky130_ef_sc_hd__decap_40_12
XTAP_TAPCELL_ROW_76_958 vssd1 vccd1 sky130_fd_sc_hd__tapvpwrvgnd_1
XFILLER_18_312 vssd1 vssd1 vccd1 vccd1 sky130_fd_sc_hd__fill_1
XFILLER_18_367 vssd1 vssd1 vccd1 vccd1 sky130_fd_sc_hd__fill_4
XTAP_TAPCELL_ROW_86_1065 vssd1 vccd1 sky130_fd_sc_hd__tapvpwrvgnd_1
XFILLER_60_112 vssd1 vssd1 vccd1 vccd1 sky130_fd_sc_hd__fill_1
XFILLER_14_540 vssd1 vssd1 vccd1 vccd1 sky130_fd_sc_hd__fill_1
XANTENNA__5930__A2 net50 vssd1 vssd1 vccd1 vccd1 sky130_fd_sc_hd__diode_2
XFILLER_5_260 vssd1 vssd1 vccd1 vccd1 sky130_fd_sc_hd__fill_4
X_5240_ _0372_ _0381_ vssd1 vssd1 vccd1 vccd1 _0430_ sky130_fd_sc_hd__nand2_1
XFILLER_46_3 vssd1 vssd1 vccd1 vccd1 sky130_fd_sc_hd__fill_1
XPHY_EDGE_ROW_18_Right_18 vssd1 vssd1 vccd1 vccd1 sky130_fd_sc_hd__decap_3
X_5171_ net166 net146 _0261_ _0259_ vssd1 vssd1 vccd1 vccd1 _0361_ sky130_fd_sc_hd__a31o_1
XANTENNA__5446__B2 net105 vssd1 vssd1 vccd1 vccd1 sky130_fd_sc_hd__diode_2
XANTENNA__5446__A1 net107 vssd1 vssd1 vccd1 vccd1 sky130_fd_sc_hd__diode_2
XFILLER_83_237 vssd1 vssd1 vccd1 vccd1 sky130_fd_sc_hd__fill_1
Xinput3 gpio_in[10] vssd1 vssd1 vccd1 vccd1 net3 sky130_fd_sc_hd__clkbuf_4
XFILLER_91_281 vssd1 vssd1 vccd1 vccd1 sky130_fd_sc_hd__fill_2
XFILLER_51_101 vssd1 vssd1 vccd1 vccd1 sky130_fd_sc_hd__fill_2
XTAP_TAPCELL_ROW_47_671 vssd1 vccd1 sky130_fd_sc_hd__tapvpwrvgnd_1
X_7812_ _3067_ vssd1 vssd1 vccd1 vccd1 _3068_ sky130_fd_sc_hd__inv_2
X_7743_ _2993_ _2998_ vssd1 vssd1 vccd1 vccd1 _2999_ sky130_fd_sc_hd__nand2b_1
XFILLER_51_145 vssd1 vssd1 vccd1 vccd1 sky130_fd_sc_hd__fill_4
X_4955_ _4153_ _4155_ _0144_ vssd1 vssd1 vccd1 vccd1 _0145_ sky130_fd_sc_hd__a21o_1
XTAP_TAPCELL_ROW_19_395 vssd1 vccd1 sky130_fd_sc_hd__tapvpwrvgnd_1
XFILLER_24_359 vssd1 vssd1 vccd1 vccd1 sky130_fd_sc_hd__fill_4
XPHY_EDGE_ROW_27_Right_27 vssd1 vssd1 vccd1 vccd1 sky130_fd_sc_hd__decap_3
XFILLER_36_197 vssd1 vssd1 vccd1 vccd1 sky130_fd_sc_hd__fill_8
X_7674_ _2926_ _2927_ vssd1 vssd1 vccd1 vccd1 _2928_ sky130_fd_sc_hd__nor2_1
XANTENNA_fanout238_A PID_INST.k2_calc.sum_reg\[3\] vssd1 vssd1 vccd1 vccd1 sky130_fd_sc_hd__diode_2
X_4886_ _4159_ _0075_ vssd1 vssd1 vccd1 vccd1 _0076_ sky130_fd_sc_hd__nand2b_1
X_6625_ _1814_ _1815_ vssd1 vssd1 vccd1 vccd1 _1818_ sky130_fd_sc_hd__xnor2_1
X_6556_ net104 _1742_ vssd1 vssd1 vccd1 vccd1 _1743_ sky130_fd_sc_hd__or2_1
X_5507_ _0696_ vssd1 vssd1 vccd1 vccd1 _0697_ sky130_fd_sc_hd__inv_2
X_8226_ _3485_ _3494_ vssd1 vssd1 vccd1 vccd1 _3495_ sky130_fd_sc_hd__xor2_1
X_6487_ _1674_ _1673_ vssd1 vssd1 vccd1 vccd1 _1675_ sky130_fd_sc_hd__and2b_1
XFILLER_10_24 vssd1 vssd1 vccd1 vccd1 sky130_fd_sc_hd__fill_4
X_5438_ net111 net65 vssd1 vssd1 vccd1 vccd1 _0628_ sky130_fd_sc_hd__nor2_1
XPHY_EDGE_ROW_36_Right_36 vssd1 vssd1 vccd1 vccd1 sky130_fd_sc_hd__decap_3
X_8157_ _3293_ _3419_ _3420_ vssd1 vssd1 vccd1 vccd1 _3421_ sky130_fd_sc_hd__a21o_1
X_5369_ _0313_ _0314_ vssd1 vssd1 vccd1 vccd1 _0559_ sky130_fd_sc_hd__xor2_1
X_8088_ _3338_ _3346_ vssd1 vssd1 vccd1 vccd1 _3347_ sky130_fd_sc_hd__and2b_1
X_7108_ _2322_ _2327_ vssd1 vssd1 vccd1 vccd1 _2329_ sky130_fd_sc_hd__or2_1
XFILLER_59_223 vssd1 vssd1 vccd1 vccd1 sky130_fd_sc_hd__fill_1
XFILLER_87_565 vssd1 vssd1 vccd1 vccd1 sky130_fd_sc_hd__fill_2
X_7039_ _2243_ _2244_ _2255_ vssd1 vssd1 vccd1 vccd1 _2257_ sky130_fd_sc_hd__a21o_1
XFILLER_59_278 vssd1 vssd1 vccd1 vccd1 sky130_fd_sc_hd__fill_2
XFILLER_47_407 vssd1 vssd1 vccd1 vccd1 sky130_fd_sc_hd__fill_1
XFILLER_19_55 vssd1 vssd1 vccd1 vccd1 sky130_fd_sc_hd__fill_1
XTAP_TAPCELL_ROW_73_928 vssd1 vccd1 sky130_fd_sc_hd__tapvpwrvgnd_1
XPHY_EDGE_ROW_45_Right_45 vssd1 vssd1 vccd1 vccd1 sky130_fd_sc_hd__decap_3
XFILLER_15_315 vssd1 vssd1 vccd1 vccd1 sky130_fd_sc_hd__fill_1
XFILLER_27_186 vssd1 vssd1 vccd1 vccd1 sky130_fd_sc_hd__fill_4
XFILLER_30_307 vssd1 vssd1 vccd1 vccd1 sky130_fd_sc_hd__fill_1
XFILLER_42_167 vssd1 vssd1 vccd1 vccd1 sky130_fd_sc_hd__fill_2
XFILLER_23_381 vssd1 vssd1 vccd1 vccd1 sky130_fd_sc_hd__fill_8
XFILLER_51_97 vssd1 vssd1 vccd1 vccd1 sky130_fd_sc_hd__fill_4
XFILLER_51_64 vssd1 vssd1 vccd1 vccd1 sky130_fd_sc_hd__fill_1
XFILLER_7_536 vssd1 vssd1 vccd1 vccd1 sky130_fd_sc_hd__fill_2
XFILLER_7_569 vssd1 vssd1 vccd1 vccd1 sky130_fd_sc_hd__fill_1
XANTENNA__8311__B1 net189 vssd1 vssd1 vccd1 vccd1 sky130_fd_sc_hd__diode_2
XPHY_EDGE_ROW_54_Right_54 vssd1 vssd1 vccd1 vccd1 sky130_fd_sc_hd__decap_3
XANTENNA__7405__C _2643_ vssd1 vssd1 vccd1 vccd1 sky130_fd_sc_hd__diode_2
XANTENNA__7421__B net226 vssd1 vssd1 vccd1 vccd1 sky130_fd_sc_hd__diode_2
XFILLER_80_207 vccd1 vssd1 vccd1 vssd1 sky130_ef_sc_hd__decap_40_12
XPHY_EDGE_ROW_63_Right_63 vssd1 vssd1 vccd1 vccd1 sky130_fd_sc_hd__decap_3
XFILLER_61_410 vssd1 vssd1 vccd1 vccd1 sky130_fd_sc_hd__fill_8
XFILLER_46_495 vccd1 vssd1 vccd1 vssd1 sky130_ef_sc_hd__decap_40_12
XFILLER_46_473 vssd1 vssd1 vccd1 vccd1 sky130_fd_sc_hd__fill_2
XANTENNA__7050__B1 net280 vssd1 vssd1 vccd1 vccd1 sky130_fd_sc_hd__diode_2
XTAP_TAPCELL_ROW_44_641 vssd1 vccd1 sky130_fd_sc_hd__tapvpwrvgnd_1
XTAP_TAPCELL_ROW_16_365 vssd1 vccd1 sky130_fd_sc_hd__tapvpwrvgnd_1
X_4740_ _3962_ _4016_ vssd1 vssd1 vccd1 vccd1 _4018_ sky130_fd_sc_hd__and2_1
XFILLER_14_381 vssd1 vssd1 vccd1 vccd1 sky130_fd_sc_hd__fill_2
XFILLER_33_189 vssd1 vssd1 vccd1 vccd1 sky130_fd_sc_hd__fill_1
X_4671_ net141 net88 _3938_ _3937_ vssd1 vssd1 vccd1 vccd1 _3949_ sky130_fd_sc_hd__a31oi_1
X_7390_ _2626_ _2627_ vssd1 vssd1 vccd1 vccd1 _2628_ sky130_fd_sc_hd__nor2_1
XANTENNA__5892__A net251 vssd1 vssd1 vccd1 vccd1 sky130_fd_sc_hd__diode_2
X_6410_ _1597_ _1596_ vssd1 vssd1 vccd1 vccd1 _1598_ sky130_fd_sc_hd__and2b_1
XPHY_EDGE_ROW_72_Right_72 vssd1 vssd1 vccd1 vccd1 sky130_fd_sc_hd__decap_3
X_6341_ PID_INST.k3_calc.d1.y\[13\] net78 vssd1 vssd1 vccd1 vccd1 _1529_ sky130_fd_sc_hd__nand2_1
X_6272_ _1439_ _1440_ _1458_ _1459_ vssd1 vssd1 vccd1 vccd1 _1461_ sky130_fd_sc_hd__a22o_1
X_8011_ net154 _3265_ _3120_ vssd1 vssd1 vccd1 vccd1 _0071_ sky130_fd_sc_hd__a21oi_1
X_5223_ net166 _3736_ _0358_ _0357_ vssd1 vssd1 vccd1 vccd1 _0413_ sky130_fd_sc_hd__a31o_1
X_5154_ _0343_ _0331_ vssd1 vssd1 vccd1 vccd1 _0344_ sky130_fd_sc_hd__and2b_1
XANTENNA__7612__A net115 vssd1 vssd1 vccd1 vccd1 sky130_fd_sc_hd__diode_2
XANTENNA_clkbuf_4_4_0_clk_A clknet_0_clk vssd1 vssd1 vccd1 vccd1 sky130_fd_sc_hd__diode_2
XANTENNA_hold14_X net407 vssd1 vssd1 vccd1 vccd1 sky130_fd_sc_hd__diode_2
XFILLER_84_524 vssd1 vssd1 vccd1 vccd1 sky130_fd_sc_hd__fill_8
XPHY_EDGE_ROW_81_Right_81 vssd1 vssd1 vccd1 vccd1 sky130_fd_sc_hd__decap_3
XANTENNA__8146__C _3406_ vssd1 vssd1 vccd1 vccd1 sky130_fd_sc_hd__diode_2
X_5085_ _0274_ _0273_ vssd1 vssd1 vccd1 vccd1 _0275_ sky130_fd_sc_hd__and2b_1
XFILLER_71_218 vssd1 vssd1 vccd1 vccd1 sky130_fd_sc_hd__fill_4
XANTENNA__4971__A net148 vssd1 vssd1 vccd1 vccd1 sky130_fd_sc_hd__diode_2
XFILLER_37_484 vssd1 vssd1 vccd1 vccd1 sky130_fd_sc_hd__fill_8
XFILLER_24_123 vssd1 vssd1 vccd1 vccd1 sky130_fd_sc_hd__fill_2
XFILLER_12_307 vssd1 vssd1 vccd1 vccd1 sky130_fd_sc_hd__fill_1
X_5987_ _0516_ _0535_ _1176_ vssd1 vssd1 vccd1 vccd1 _1177_ sky130_fd_sc_hd__a21oi_1
X_7726_ net214 net257 net253 net218 vssd1 vssd1 vccd1 vccd1 _2982_ sky130_fd_sc_hd__a22oi_1
X_4938_ _0126_ _0127_ vssd1 vssd1 vccd1 vccd1 _0128_ sky130_fd_sc_hd__nand2_1
X_7657_ _2903_ _2909_ vssd1 vssd1 vccd1 vccd1 _2911_ sky130_fd_sc_hd__xnor2_1
X_4869_ _4114_ _4145_ _4146_ vssd1 vssd1 vccd1 vccd1 _4147_ sky130_fd_sc_hd__and3_1
XFILLER_20_351 vssd1 vssd1 vccd1 vccd1 sky130_fd_sc_hd__fill_4
XPHY_EDGE_ROW_90_Right_90 vssd1 vssd1 vccd1 vccd1 sky130_fd_sc_hd__decap_3
XTAP_TAPCELL_ROW_50_699 vssd1 vccd1 sky130_fd_sc_hd__tapvpwrvgnd_1
X_6608_ _1522_ _1595_ _1521_ vssd1 vssd1 vccd1 vccd1 _1799_ sky130_fd_sc_hd__a21oi_1
X_7588_ _2493_ _2755_ _2758_ vssd1 vssd1 vccd1 vccd1 _2838_ sky130_fd_sc_hd__a21bo_1
X_6539_ _1724_ _1725_ vssd1 vssd1 vccd1 vccd1 _1726_ sky130_fd_sc_hd__nor2_1
XANTENNA__5307__A net137 vssd1 vssd1 vccd1 vccd1 sky130_fd_sc_hd__diode_2
X_8209_ _3475_ _3476_ vssd1 vssd1 vccd1 vccd1 _3477_ sky130_fd_sc_hd__xor2_1
XANTENNA__7522__A net98 vssd1 vssd1 vccd1 vccd1 sky130_fd_sc_hd__diode_2
XANTENNA__8337__B _3614_ vssd1 vssd1 vccd1 vccd1 sky130_fd_sc_hd__diode_2
XFILLER_62_218 vssd1 vssd1 vccd1 vccd1 sky130_fd_sc_hd__fill_2
XTAP_TAPCELL_ROW_58_777 vssd1 vccd1 sky130_fd_sc_hd__tapvpwrvgnd_1
XFILLER_55_270 vssd1 vssd1 vccd1 vccd1 sky130_fd_sc_hd__fill_8
XFILLER_15_101 vssd1 vssd1 vccd1 vccd1 sky130_fd_sc_hd__fill_1
XFILLER_28_484 vccd1 vssd1 vccd1 vssd1 sky130_ef_sc_hd__decap_40_12
XTAP_TAPCELL_ROW_83_1035 vssd1 vccd1 sky130_fd_sc_hd__tapvpwrvgnd_1
XFILLER_55_281 vssd1 vssd1 vccd1 vccd1 sky130_fd_sc_hd__fill_2
XFILLER_70_240 vccd1 vssd1 vccd1 vssd1 sky130_ef_sc_hd__decap_40_12
XFILLER_15_167 vssd1 vssd1 vccd1 vccd1 sky130_fd_sc_hd__fill_1
XTAP_TAPCELL_ROW_41_611 vssd1 vccd1 sky130_fd_sc_hd__tapvpwrvgnd_1
XTAP_TAPCELL_ROW_13_335 vssd1 vccd1 sky130_fd_sc_hd__tapvpwrvgnd_1
XFILLER_7_311 vssd1 vssd1 vccd1 vccd1 sky130_fd_sc_hd__fill_1
XANTENNA__5897__A1 net308 vssd1 vssd1 vccd1 vccd1 sky130_fd_sc_hd__diode_2
XFILLER_7_366 vssd1 vssd1 vccd1 vccd1 sky130_fd_sc_hd__fill_1
XFILLER_11_395 vssd1 vssd1 vccd1 vccd1 sky130_fd_sc_hd__fill_2
XANTENNA__5217__A net163 vssd1 vssd1 vccd1 vccd1 sky130_fd_sc_hd__diode_2
XFILLER_3_561 vssd1 vssd1 vccd1 vccd1 sky130_fd_sc_hd__fill_8
XANTENNA__7432__A net311 vssd1 vssd1 vccd1 vccd1 sky130_fd_sc_hd__diode_2
XFILLER_78_362 vssd1 vssd1 vccd1 vccd1 sky130_fd_sc_hd__fill_2
XFILLER_78_373 vssd1 vssd1 vccd1 vccd1 sky130_fd_sc_hd__fill_2
XFILLER_19_440 vssd1 vssd1 vccd1 vccd1 sky130_fd_sc_hd__fill_1
X_5910_ _0927_ _1099_ vssd1 vssd1 vccd1 vccd1 _1100_ sky130_fd_sc_hd__nand2_1
XFILLER_81_549 vssd1 vssd1 vccd1 vccd1 sky130_fd_sc_hd__fill_2
XFILLER_46_292 vssd1 vssd1 vccd1 vccd1 sky130_fd_sc_hd__fill_1
XTAP_TAPCELL_ROW_29_490 vssd1 vccd1 sky130_fd_sc_hd__tapvpwrvgnd_1
X_6890_ _2097_ _2098_ vssd1 vssd1 vccd1 vccd1 _2099_ sky130_fd_sc_hd__nor2_1
X_5841_ net325 net237 vssd1 vssd1 vccd1 vccd1 _1031_ sky130_fd_sc_hd__and2_1
X_5772_ _0961_ vssd1 vssd1 vccd1 vccd1 _0962_ sky130_fd_sc_hd__inv_2
XANTENNA__8413__D net113 vssd1 vssd1 vccd1 vccd1 sky130_fd_sc_hd__diode_2
XFILLER_21_159 vssd1 vssd1 vccd1 vccd1 sky130_fd_sc_hd__fill_2
X_7511_ _2493_ _2755_ vssd1 vssd1 vccd1 vccd1 _2756_ sky130_fd_sc_hd__xnor2_1
X_4723_ _3829_ _3830_ net147 vssd1 vssd1 vccd1 vccd1 _4001_ sky130_fd_sc_hd__a21oi_4
XANTENNA__7029__D net190 vssd1 vssd1 vccd1 vccd1 sky130_fd_sc_hd__diode_2
X_7442_ _2668_ _2669_ _2681_ vssd1 vssd1 vccd1 vccd1 _2683_ sky130_fd_sc_hd__a21o_1
X_4654_ _3930_ _3931_ _3924_ vssd1 vssd1 vccd1 vccd1 _3932_ sky130_fd_sc_hd__nand3b_1
X_7373_ _2600_ _2609_ vssd1 vssd1 vccd1 vccd1 _2610_ sky130_fd_sc_hd__xnor2_1
X_4585_ net128 net152 net150 net126 vssd1 vssd1 vccd1 vccd1 _3863_ sky130_fd_sc_hd__a22o_1
X_6324_ net119 net50 vssd1 vssd1 vccd1 vccd1 _1512_ sky130_fd_sc_hd__or2_1
X_6255_ net207 net307 vssd1 vssd1 vccd1 vccd1 _1444_ sky130_fd_sc_hd__and2_1
XFILLER_88_148 vssd1 vssd1 vccd1 vccd1 sky130_fd_sc_hd__fill_4
XANTENNA__4312__A1 net251 vssd1 vssd1 vccd1 vccd1 sky130_fd_sc_hd__diode_2
X_5206_ _0330_ _0395_ vssd1 vssd1 vccd1 vccd1 _0396_ sky130_fd_sc_hd__xnor2_1
XFILLER_69_362 vssd1 vssd1 vccd1 vccd1 sky130_fd_sc_hd__fill_4
XFILLER_57_502 vssd1 vssd1 vccd1 vccd1 sky130_fd_sc_hd__fill_2
X_6186_ _1372_ _1373_ vssd1 vssd1 vccd1 vccd1 _1375_ sky130_fd_sc_hd__xor2_1
XFILLER_69_384 vssd1 vssd1 vccd1 vccd1 sky130_fd_sc_hd__fill_2
XFILLER_57_524 vssd1 vssd1 vccd1 vccd1 sky130_fd_sc_hd__fill_1
X_5137_ _0306_ _0325_ vssd1 vssd1 vccd1 vccd1 _0327_ sky130_fd_sc_hd__nand2_1
XFILLER_57_568 vssd1 vssd1 vccd1 vccd1 sky130_fd_sc_hd__fill_2
XFILLER_57_546 vssd1 vssd1 vccd1 vccd1 sky130_fd_sc_hd__fill_8
X_5068_ net162 net151 vssd1 vssd1 vccd1 vccd1 _0258_ sky130_fd_sc_hd__nand2_1
XFILLER_84_365 vccd1 vssd1 vccd1 vssd1 sky130_ef_sc_hd__decap_40_12
XFILLER_44_207 vssd1 vssd1 vccd1 vccd1 sky130_fd_sc_hd__fill_4
XANTENNA_fanout260_X net260 vssd1 vssd1 vccd1 vccd1 sky130_fd_sc_hd__diode_2
XTAP_TAPCELL_ROW_55_747 vssd1 vccd1 sky130_fd_sc_hd__tapvpwrvgnd_1
XFILLER_37_270 vssd1 vssd1 vccd1 vccd1 sky130_fd_sc_hd__fill_1
XPHY_EDGE_ROW_0_Right_0 vssd1 vssd1 vccd1 vccd1 sky130_fd_sc_hd__decap_3
XANTENNA__4206__A _2210_ vssd1 vssd1 vccd1 vccd1 sky130_fd_sc_hd__diode_2
XFILLER_16_89 vssd1 vssd1 vccd1 vccd1 sky130_fd_sc_hd__fill_2
X_7709_ _2731_ _2735_ _2965_ vssd1 vssd1 vccd1 vccd1 _2966_ sky130_fd_sc_hd__o21a_1
XTAP_TAPCELL_ROW_10_305 vssd1 vccd1 sky130_fd_sc_hd__tapvpwrvgnd_1
XFILLER_32_44 vssd1 vssd1 vccd1 vccd1 sky130_fd_sc_hd__fill_1
XFILLER_20_181 vccd1 vssd1 vccd1 vssd1 sky130_ef_sc_hd__decap_40_12
XANTENNA__5037__A net116 vssd1 vssd1 vccd1 vccd1 sky130_fd_sc_hd__diode_2
XANTENNA__4303__A1 net5 vssd1 vssd1 vccd1 vccd1 sky130_fd_sc_hd__diode_2
XFILLER_0_531 vssd1 vssd1 vccd1 vccd1 sky130_fd_sc_hd__fill_1
XFILLER_75_310 vssd1 vssd1 vccd1 vccd1 sky130_fd_sc_hd__fill_8
XFILLER_75_354 vccd1 vssd1 vccd1 vssd1 sky130_ef_sc_hd__decap_40_12
XFILLER_90_313 vssd1 vssd1 vccd1 vccd1 sky130_fd_sc_hd__fill_2
XFILLER_75_387 vssd1 vssd1 vccd1 vccd1 sky130_fd_sc_hd__fill_4
XFILLER_90_335 vssd1 vssd1 vccd1 vccd1 sky130_fd_sc_hd__fill_2
XFILLER_73_40 vssd1 vssd1 vccd1 vccd1 sky130_fd_sc_hd__fill_1
XFILLER_16_443 vssd1 vssd1 vccd1 vccd1 sky130_fd_sc_hd__fill_1
XFILLER_43_251 vssd1 vssd1 vccd1 vccd1 sky130_fd_sc_hd__fill_1
XTAP_TAPCELL_ROW_26_460 vssd1 vccd1 sky130_fd_sc_hd__tapvpwrvgnd_1
X_4370_ _3657_ _3658_ _3659_ vssd1 vssd1 vccd1 vccd1 _3666_ sky130_fd_sc_hd__o21ba_1
XANTENNA__4786__A _2051_ vssd1 vssd1 vccd1 vccd1 sky130_fd_sc_hd__diode_2
X_6040_ _1228_ _1229_ vssd1 vssd1 vccd1 vccd1 _1230_ sky130_fd_sc_hd__nor2_1
XFILLER_3_391 vssd1 vssd1 vccd1 vccd1 sky130_fd_sc_hd__fill_1
X_7991_ _3245_ vssd1 vssd1 vccd1 vccd1 _3246_ sky130_fd_sc_hd__inv_2
XANTENNA__8264__Y _3536_ vssd1 vssd1 vccd1 vccd1 sky130_fd_sc_hd__diode_2
XFILLER_54_538 vssd1 vssd1 vccd1 vccd1 sky130_fd_sc_hd__fill_4
XFILLER_19_281 vssd1 vssd1 vccd1 vccd1 sky130_fd_sc_hd__fill_2
X_6942_ _1746_ _2039_ _2043_ vssd1 vssd1 vccd1 vccd1 _2154_ sky130_fd_sc_hd__a21bo_1
XTAP_TAPCELL_ROW_52_717 vssd1 vccd1 sky130_fd_sc_hd__tapvpwrvgnd_1
X_6873_ _1314_ _1785_ _1787_ _1788_ vssd1 vssd1 vccd1 vccd1 _2081_ sky130_fd_sc_hd__a22o_1
X_5824_ net248 net300 net237 net312 vssd1 vssd1 vccd1 vccd1 _1014_ sky130_fd_sc_hd__a22oi_1
XFILLER_34_273 vssd1 vssd1 vccd1 vccd1 sky130_fd_sc_hd__fill_4
X_5755_ _0895_ _0939_ _0944_ vssd1 vssd1 vccd1 vccd1 _0945_ sky130_fd_sc_hd__or3_1
X_8543_ PID_INST.busy vssd1 vssd1 vccd1 vccd1 net36 sky130_fd_sc_hd__clkbuf_1
XANTENNA_fanout220_A net221 vssd1 vssd1 vccd1 vccd1 sky130_fd_sc_hd__diode_2
X_5686_ _0731_ _0732_ vssd1 vssd1 vccd1 vccd1 _0876_ sky130_fd_sc_hd__xor2_1
X_4706_ net123 net81 vssd1 vssd1 vccd1 vccd1 _3984_ sky130_fd_sc_hd__nand2_1
X_8474_ clknet_4_10_0_clk _0062_ net341 vssd1 vssd1 vccd1 vccd1 net23 sky130_fd_sc_hd__dfrtp_1
X_7425_ _2658_ _2663_ vssd1 vssd1 vccd1 vccd1 _2665_ sky130_fd_sc_hd__nand2_1
X_4637_ _3898_ _3907_ _3914_ vssd1 vssd1 vccd1 vccd1 _3915_ sky130_fd_sc_hd__nand3_1
XFILLER_89_413 vccd1 vssd1 vccd1 vssd1 sky130_ef_sc_hd__decap_40_12
XFILLER_89_402 vssd1 vssd1 vccd1 vccd1 sky130_fd_sc_hd__fill_4
XFILLER_78_29 vccd1 vssd1 vccd1 vssd1 sky130_ef_sc_hd__decap_40_12
X_7356_ _2590_ _2591_ vssd1 vssd1 vccd1 vccd1 _2592_ sky130_fd_sc_hd__nand2_1
X_4568_ _3809_ _3845_ vssd1 vssd1 vccd1 vccd1 _3846_ sky130_fd_sc_hd__nor2_1
XANTENNA__7072__A net207 vssd1 vssd1 vccd1 vccd1 sky130_fd_sc_hd__diode_2
X_6307_ _1493_ _1494_ vssd1 vssd1 vccd1 vccd1 _1495_ sky130_fd_sc_hd__xnor2_1
X_4499_ PID_INST.k1_calc.d1.x\[0\] PID_INST.k3_calc.prev_error\[0\] vssd1 vssd1 vccd1
+ vccd1 _3777_ sky130_fd_sc_hd__or2_1
X_7287_ net119 net41 vssd1 vssd1 vccd1 vccd1 _2519_ sky130_fd_sc_hd__nor2_1
XFILLER_89_457 vssd1 vssd1 vccd1 vccd1 sky130_fd_sc_hd__fill_2
X_6238_ _1219_ _1221_ _1425_ vssd1 vssd1 vccd1 vccd1 _1427_ sky130_fd_sc_hd__nand3_1
XANTENNA__4297__A0 net299 vssd1 vssd1 vccd1 vccd1 sky130_fd_sc_hd__diode_2
X_6169_ _1161_ _1356_ vssd1 vssd1 vccd1 vccd1 _1358_ sky130_fd_sc_hd__xor2_1
XFILLER_69_192 vssd1 vssd1 vccd1 vccd1 sky130_fd_sc_hd__fill_2
XFILLER_57_321 vssd1 vssd1 vccd1 vccd1 sky130_fd_sc_hd__fill_2
XFILLER_27_11 vssd1 vssd1 vccd1 vccd1 sky130_fd_sc_hd__fill_4
XTAP_TAPCELL_ROW_68_883 vssd1 vccd1 sky130_fd_sc_hd__tapvpwrvgnd_1
XFILLER_27_33 vssd1 vssd1 vccd1 vccd1 sky130_fd_sc_hd__fill_8
XFILLER_72_335 vssd1 vssd1 vccd1 vccd1 sky130_fd_sc_hd__fill_4
XFILLER_27_66 vssd1 vssd1 vccd1 vccd1 sky130_fd_sc_hd__fill_8
XFILLER_72_379 vssd1 vssd1 vccd1 vccd1 sky130_fd_sc_hd__fill_1
XFILLER_25_240 vssd1 vssd1 vccd1 vccd1 sky130_fd_sc_hd__fill_8
XFILLER_27_88 vccd1 vssd1 vccd1 vssd1 sky130_ef_sc_hd__decap_40_12
XTAP_TAPCELL_ROW_80_1005 vssd1 vccd1 sky130_fd_sc_hd__tapvpwrvgnd_1
XANTENNA__5549__B1 net228 vssd1 vssd1 vccd1 vccd1 sky130_fd_sc_hd__diode_2
XANTENNA__8404__Q PID_INST.k2_calc.reg_lc\[8\] vssd1 vssd1 vccd1 vccd1 sky130_fd_sc_hd__diode_2
XFILLER_9_417 vssd1 vssd1 vccd1 vccd1 sky130_fd_sc_hd__fill_2
XTAP_TAPCELL_ROW_23_430 vssd1 vccd1 sky130_fd_sc_hd__tapvpwrvgnd_1
XANTENNA__5974__B _0156_ vssd1 vssd1 vccd1 vccd1 sky130_fd_sc_hd__diode_2
XFILLER_40_232 vssd1 vssd1 vccd1 vccd1 sky130_fd_sc_hd__fill_1
XFILLER_40_265 vssd1 vssd1 vccd1 vccd1 sky130_fd_sc_hd__fill_1
XFILLER_40_287 vssd1 vssd1 vccd1 vccd1 sky130_fd_sc_hd__fill_1
XFILLER_4_111 vssd1 vssd1 vccd1 vccd1 sky130_fd_sc_hd__fill_1
XTAP_TAPCELL_ROW_91_1112 vssd1 vccd1 sky130_fd_sc_hd__tapvpwrvgnd_1
XANTENNA_clkbuf_4_12_0_clk_A clknet_0_clk vssd1 vssd1 vccd1 vccd1 sky130_fd_sc_hd__diode_2
XFILLER_4_144 vssd1 vssd1 vccd1 vccd1 sky130_fd_sc_hd__fill_2
XFILLER_4_15 vssd1 vssd1 vccd1 vccd1 sky130_fd_sc_hd__fill_4
XFILLER_4_26 vssd1 vssd1 vccd1 vccd1 sky130_fd_sc_hd__fill_2
XANTENNA__4288__A0 net6 vssd1 vssd1 vccd1 vccd1 sky130_fd_sc_hd__diode_2
XANTENNA__8228__D net252 vssd1 vssd1 vccd1 vccd1 sky130_fd_sc_hd__diode_2
XFILLER_0_361 vssd1 vssd1 vccd1 vccd1 sky130_fd_sc_hd__fill_1
XFILLER_36_505 vssd1 vssd1 vccd1 vccd1 sky130_fd_sc_hd__fill_2
XFILLER_84_83 vssd1 vssd1 vccd1 vccd1 sky130_fd_sc_hd__fill_1
XFILLER_31_265 vssd1 vssd1 vccd1 vccd1 sky130_fd_sc_hd__fill_4
XANTENNA__7157__A net203 vssd1 vssd1 vccd1 vccd1 sky130_fd_sc_hd__diode_2
X_5540_ _0689_ _0719_ _0728_ vssd1 vssd1 vccd1 vccd1 _0730_ sky130_fd_sc_hd__nor3_1
XANTENNA__4280__S net157 vssd1 vssd1 vccd1 vccd1 sky130_fd_sc_hd__diode_2
X_5471_ _0659_ _0660_ vssd1 vssd1 vccd1 vccd1 _0661_ sky130_fd_sc_hd__nor2_1
X_4422_ _3704_ _3705_ vssd1 vssd1 vccd1 vccd1 _0054_ sky130_fd_sc_hd__nor2_1
X_7210_ net99 net53 _2173_ _2172_ vssd1 vssd1 vccd1 vccd1 _2437_ sky130_fd_sc_hd__o31ai_2
X_8190_ _3388_ _3390_ _3387_ vssd1 vssd1 vccd1 vccd1 _3456_ sky130_fd_sc_hd__o21ba_1
X_7141_ _2361_ _2362_ vssd1 vssd1 vccd1 vccd1 _2364_ sky130_fd_sc_hd__xnor2_1
X_4353_ net218 net3 vssd1 vssd1 vccd1 vccd1 _3651_ sky130_fd_sc_hd__nor2_1
X_7072_ net207 net287 _2291_ vssd1 vssd1 vccd1 vccd1 _2292_ sky130_fd_sc_hd__and3_1
X_4284_ net19 net397 net157 vssd1 vssd1 vccd1 vccd1 _0007_ sky130_fd_sc_hd__mux2_1
XANTENNA__5405__A net104 vssd1 vssd1 vccd1 vccd1 sky130_fd_sc_hd__diode_2
XANTENNA__4279__A0 net14 vssd1 vssd1 vccd1 vccd1 sky130_fd_sc_hd__diode_2
XFILLER_86_427 vssd1 vssd1 vccd1 vccd1 sky130_fd_sc_hd__fill_4
X_6023_ net270 net243 net265 net246 vssd1 vssd1 vccd1 vccd1 _1213_ sky130_fd_sc_hd__a22o_1
XFILLER_27_505 vssd1 vssd1 vccd1 vccd1 sky130_fd_sc_hd__fill_1
XFILLER_39_354 vssd1 vssd1 vccd1 vccd1 sky130_fd_sc_hd__fill_1
X_7974_ _2999_ _3001_ _3228_ vssd1 vssd1 vccd1 vccd1 _3229_ sky130_fd_sc_hd__a21o_1
XTAP_TAPCELL_ROW_65_853 vssd1 vccd1 sky130_fd_sc_hd__tapvpwrvgnd_1
X_6925_ net134 net69 vssd1 vssd1 vccd1 vccd1 _2136_ sky130_fd_sc_hd__nand2_1
XTAP_TAPCELL_ROW_37_566 vssd1 vccd1 sky130_fd_sc_hd__tapvpwrvgnd_1
XFILLER_42_508 vssd1 vssd1 vccd1 vccd1 sky130_fd_sc_hd__fill_4
XFILLER_80_19 vssd1 vssd1 vccd1 vccd1 sky130_fd_sc_hd__fill_1
XFILLER_50_530 vssd1 vssd1 vccd1 vccd1 sky130_fd_sc_hd__fill_2
X_6856_ net101 net56 vssd1 vssd1 vccd1 vccd1 _2063_ sky130_fd_sc_hd__nor2_1
XFILLER_22_221 vccd1 vssd1 vccd1 vssd1 sky130_ef_sc_hd__decap_40_12
Xfanout47 _0476_ vssd1 vssd1 vccd1 vccd1 net47 sky130_fd_sc_hd__clkbuf_4
X_5807_ _0995_ _0996_ vssd1 vssd1 vccd1 vccd1 _0997_ sky130_fd_sc_hd__or2_1
Xfanout69 _0236_ vssd1 vssd1 vccd1 vccd1 net69 sky130_fd_sc_hd__clkbuf_2
Xfanout58 _4157_ vssd1 vssd1 vccd1 vccd1 net58 sky130_fd_sc_hd__clkbuf_4
XFILLER_13_24 vssd1 vssd1 vccd1 vccd1 sky130_fd_sc_hd__fill_2
X_6787_ _1783_ _1789_ _1791_ vssd1 vssd1 vccd1 vccd1 _1990_ sky130_fd_sc_hd__a21bo_1
XANTENNA_fanout223_X net223 vssd1 vssd1 vccd1 vccd1 sky130_fd_sc_hd__diode_2
X_5738_ _0917_ _0925_ vssd1 vssd1 vccd1 vccd1 _0928_ sky130_fd_sc_hd__xor2_1
XFILLER_13_46 vssd1 vssd1 vccd1 vccd1 sky130_fd_sc_hd__fill_1
XTAP_TAPCELL_ROW_20_400 vssd1 vccd1 sky130_fd_sc_hd__tapvpwrvgnd_1
X_8457_ clknet_4_7_0_clk _0045_ net332 vssd1 vssd1 vccd1 vccd1 PID_INST.k2_calc.sum_reg\[13\]
+ sky130_fd_sc_hd__dfrtp_1
X_5669_ _0843_ _0845_ vssd1 vssd1 vccd1 vccd1 _0859_ sky130_fd_sc_hd__xor2_1
XANTENNA__5703__B1 net237 vssd1 vssd1 vccd1 vccd1 sky130_fd_sc_hd__diode_2
X_7408_ _2647_ vssd1 vssd1 vccd1 vccd1 _2648_ sky130_fd_sc_hd__inv_2
X_8388_ clknet_4_8_0_clk PID_INST.k3_calc.d2.y\[8\] net328 vssd1 vssd1 vccd1 vccd1
+ PID_INST.k3_calc.timescaling_term\[8\] sky130_fd_sc_hd__dfrtp_1
X_7339_ _2566_ _2572_ vssd1 vssd1 vccd1 vccd1 _2574_ sky130_fd_sc_hd__or2_1
XFILLER_77_427 vssd1 vssd1 vccd1 vccd1 sky130_fd_sc_hd__fill_1
XFILLER_77_416 vssd1 vssd1 vccd1 vccd1 sky130_fd_sc_hd__fill_1
XFILLER_1_169 vssd1 vssd1 vccd1 vccd1 sky130_fd_sc_hd__fill_2
XANTENNA__8367__CLK clknet_4_1_0_clk vssd1 vssd1 vccd1 vccd1 sky130_fd_sc_hd__diode_2
XFILLER_92_419 vssd1 vssd1 vccd1 vccd1 sky130_fd_sc_hd__fill_1
XANTENNA__7759__A1 net276 vssd1 vssd1 vccd1 vccd1 sky130_fd_sc_hd__diode_2
XFILLER_57_151 vssd1 vssd1 vccd1 vccd1 sky130_fd_sc_hd__fill_4
XANTENNA__8345__B net44 vssd1 vssd1 vccd1 vccd1 sky130_fd_sc_hd__diode_2
XFILLER_45_335 vssd1 vssd1 vccd1 vccd1 sky130_fd_sc_hd__fill_1
XFILLER_72_154 vssd1 vssd1 vccd1 vccd1 sky130_fd_sc_hd__fill_2
XFILLER_72_187 vssd1 vssd1 vccd1 vccd1 sky130_fd_sc_hd__fill_2
XFILLER_60_349 vssd1 vssd1 vccd1 vccd1 sky130_fd_sc_hd__fill_1
XFILLER_53_390 vssd1 vssd1 vccd1 vccd1 sky130_fd_sc_hd__fill_2
XTAP_TAPCELL_ROW_0_191 vssd1 vccd1 sky130_fd_sc_hd__tapvpwrvgnd_1
XFILLER_13_232 vccd1 vssd1 vccd1 vssd1 sky130_ef_sc_hd__decap_40_12
XFILLER_9_214 vssd1 vssd1 vccd1 vccd1 sky130_fd_sc_hd__fill_2
XANTENNA__7931__A1 net209 vssd1 vssd1 vccd1 vccd1 sky130_fd_sc_hd__diode_2
XANTENNA__7931__B2 net214 vssd1 vssd1 vccd1 vccd1 sky130_fd_sc_hd__diode_2
XFILLER_70_96 vssd1 vssd1 vccd1 vccd1 sky130_fd_sc_hd__fill_2
XFILLER_5_497 vssd1 vssd1 vccd1 vccd1 sky130_fd_sc_hd__fill_4
XFILLER_79_83 vssd1 vssd1 vccd1 vccd1 sky130_fd_sc_hd__fill_2
XANTENNA__7711__Y _2968_ vssd1 vssd1 vccd1 vccd1 sky130_fd_sc_hd__diode_2
XFILLER_68_427 vssd1 vssd1 vccd1 vccd1 sky130_fd_sc_hd__fill_1
XTAP_TAPCELL_ROW_8_280 vssd1 vccd1 sky130_fd_sc_hd__tapvpwrvgnd_1
XTAP_TAPCELL_ROW_79_989 vssd1 vccd1 sky130_fd_sc_hd__tapvpwrvgnd_1
XFILLER_0_191 vssd1 vssd1 vccd1 vccd1 sky130_fd_sc_hd__fill_4
XFILLER_91_430 vssd1 vssd1 vccd1 vccd1 sky130_fd_sc_hd__fill_1
XFILLER_48_195 vssd1 vssd1 vccd1 vccd1 sky130_fd_sc_hd__fill_1
XFILLER_36_357 vssd1 vssd1 vccd1 vccd1 sky130_fd_sc_hd__fill_4
XTAP_TAPCELL_ROW_62_823 vssd1 vccd1 sky130_fd_sc_hd__tapvpwrvgnd_1
X_4971_ net148 _4099_ _4100_ vssd1 vssd1 vccd1 vccd1 _0161_ sky130_fd_sc_hd__or3b_1
X_7690_ _2941_ _2942_ _2943_ vssd1 vssd1 vccd1 vccd1 _2945_ sky130_fd_sc_hd__o21ai_1
X_6710_ _1904_ _1905_ vssd1 vssd1 vccd1 vccd1 _1907_ sky130_fd_sc_hd__xnor2_1
XTAP_TAPCELL_ROW_34_536 vssd1 vccd1 sky130_fd_sc_hd__tapvpwrvgnd_1
X_6641_ net291 net211 _1832_ vssd1 vssd1 vccd1 vccd1 _1834_ sky130_fd_sc_hd__a21oi_1
X_8311_ net263 net191 net189 net267 vssd1 vssd1 vccd1 vccd1 _3586_ sky130_fd_sc_hd__a22o_1
XANTENNA__5119__B net65 vssd1 vssd1 vccd1 vccd1 sky130_fd_sc_hd__diode_2
X_6572_ _1492_ _1755_ _1758_ vssd1 vssd1 vccd1 vccd1 _1759_ sky130_fd_sc_hd__a21oi_1
X_5523_ _0711_ _0712_ vssd1 vssd1 vccd1 vccd1 _0713_ sky130_fd_sc_hd__nor2_1
X_8242_ _3324_ _3331_ _3511_ vssd1 vssd1 vccd1 vccd1 _3512_ sky130_fd_sc_hd__a21o_1
X_5454_ net105 net63 vssd1 vssd1 vccd1 vccd1 _0644_ sky130_fd_sc_hd__nor2_1
XANTENNA__7334__B net230 vssd1 vssd1 vccd1 vccd1 sky130_fd_sc_hd__diode_2
X_4405_ _3690_ _3691_ vssd1 vssd1 vccd1 vccd1 _3695_ sky130_fd_sc_hd__nand2b_1
X_5385_ net103 net47 vssd1 vssd1 vccd1 vccd1 _0575_ sky130_fd_sc_hd__nor2_1
X_8173_ _3275_ _3276_ _3273_ vssd1 vssd1 vccd1 vccd1 _3438_ sky130_fd_sc_hd__o21a_1
Xfanout204 PID_INST.k2_calc.sum_reg\[12\] vssd1 vssd1 vccd1 vccd1 net204 sky130_fd_sc_hd__clkbuf_2
X_7124_ _2331_ _2332_ _2343_ vssd1 vssd1 vccd1 vccd1 _2345_ sky130_fd_sc_hd__a21o_1
X_4336_ net230 net17 vssd1 vssd1 vccd1 vccd1 _3579_ sky130_fd_sc_hd__or2_1
XFILLER_5_80 vssd1 vssd1 vccd1 vccd1 sky130_fd_sc_hd__fill_2
XFILLER_86_202 vssd1 vssd1 vccd1 vccd1 sky130_fd_sc_hd__fill_2
Xfanout215 net217 vssd1 vssd1 vccd1 vccd1 net215 sky130_fd_sc_hd__buf_2
XFILLER_59_427 vssd1 vssd1 vccd1 vccd1 sky130_fd_sc_hd__fill_1
XFILLER_59_405 vssd1 vssd1 vccd1 vccd1 sky130_fd_sc_hd__fill_2
Xfanout226 net229 vssd1 vssd1 vccd1 vccd1 net226 sky130_fd_sc_hd__buf_2
Xfanout237 PID_INST.k2_calc.sum_reg\[3\] vssd1 vssd1 vccd1 vccd1 net237 sky130_fd_sc_hd__buf_2
X_7055_ _2273_ _2272_ vssd1 vssd1 vccd1 vccd1 _2275_ sky130_fd_sc_hd__and2b_1
XFILLER_86_224 vssd1 vssd1 vccd1 vccd1 sky130_fd_sc_hd__fill_1
Xfanout259 PID_INST.k2_calc.reg_lc\[14\] vssd1 vssd1 vccd1 vccd1 net259 sky130_fd_sc_hd__clkbuf_2
Xfanout248 PID_INST.k2_calc.sum_reg\[1\] vssd1 vssd1 vccd1 vccd1 net248 sky130_fd_sc_hd__dlymetal6s2s_1
XFILLER_59_449 vssd1 vssd1 vccd1 vccd1 sky130_fd_sc_hd__fill_8
X_4267_ _1762_ _2792_ _2813_ _2856_ vssd1 vssd1 vccd1 vccd1 PID_INST.pid.next_state\[0\]
+ sky130_fd_sc_hd__a31o_1
XFILLER_74_419 vssd1 vssd1 vccd1 vccd1 sky130_fd_sc_hd__fill_1
X_6006_ _1192_ _1195_ vssd1 vssd1 vccd1 vccd1 _1196_ sky130_fd_sc_hd__xor2_1
X_4198_ PID_INST.k3_calc.kd_term\[5\] _1784_ vssd1 vssd1 vccd1 vccd1 _2135_ sky130_fd_sc_hd__or2_1
XFILLER_54_132 vssd1 vssd1 vccd1 vccd1 sky130_fd_sc_hd__fill_1
XANTENNA_fanout173_X net173 vssd1 vssd1 vccd1 vccd1 sky130_fd_sc_hd__diode_2
X_7957_ _3013_ _3021_ _3020_ vssd1 vssd1 vccd1 vccd1 _3212_ sky130_fd_sc_hd__a21oi_1
XFILLER_23_541 vssd1 vssd1 vccd1 vccd1 sky130_fd_sc_hd__fill_4
XANTENNA_fanout340_X net340 vssd1 vssd1 vccd1 vccd1 sky130_fd_sc_hd__diode_2
X_6908_ _2082_ _2088_ _2090_ vssd1 vssd1 vccd1 vccd1 _2118_ sky130_fd_sc_hd__a21oi_1
X_7888_ _3077_ _3078_ _3080_ vssd1 vssd1 vccd1 vccd1 _3143_ sky130_fd_sc_hd__a21bo_1
X_6839_ _1395_ _1745_ _1747_ _1744_ vssd1 vssd1 vccd1 vccd1 _2045_ sky130_fd_sc_hd__a22o_1
XFILLER_10_213 vccd1 vssd1 vccd1 vssd1 sky130_ef_sc_hd__decap_40_12
XFILLER_2_401 vssd1 vssd1 vccd1 vccd1 sky130_fd_sc_hd__fill_1
XFILLER_40_99 vssd1 vssd1 vccd1 vccd1 sky130_fd_sc_hd__fill_2
XFILLER_6_3 vssd1 vssd1 vccd1 vccd1 sky130_fd_sc_hd__fill_4
XFILLER_2_434 vccd1 vssd1 vccd1 vssd1 sky130_ef_sc_hd__decap_40_12
XFILLER_77_213 vssd1 vssd1 vccd1 vccd1 sky130_fd_sc_hd__fill_1
XFILLER_2_489 vccd1 vssd1 vccd1 vssd1 sky130_ef_sc_hd__decap_40_12
XANTENNA_fanout86_X net86 vssd1 vssd1 vccd1 vccd1 sky130_fd_sc_hd__diode_2
XANTENNA__4884__A net118 vssd1 vssd1 vccd1 vccd1 sky130_fd_sc_hd__diode_2
XANTENNA__5699__B net228 vssd1 vssd1 vccd1 vccd1 sky130_fd_sc_hd__diode_2
XTAP_TAPCELL_ROW_5_250 vssd1 vccd1 sky130_fd_sc_hd__tapvpwrvgnd_1
XFILLER_1_38 vssd1 vssd1 vccd1 vccd1 sky130_fd_sc_hd__fill_1
XFILLER_1_27 vssd1 vssd1 vccd1 vccd1 sky130_fd_sc_hd__fill_1
XFILLER_92_249 vssd1 vssd1 vccd1 vccd1 sky130_fd_sc_hd__fill_2
XTAP_TAPCELL_ROW_76_959 vssd1 vccd1 sky130_fd_sc_hd__tapvpwrvgnd_1
XFILLER_1_49 vssd1 vssd1 vccd1 vccd1 sky130_fd_sc_hd__fill_1
XFILLER_18_302 vssd1 vssd1 vccd1 vccd1 sky130_fd_sc_hd__fill_4
XFILLER_73_496 vssd1 vssd1 vccd1 vccd1 sky130_fd_sc_hd__fill_8
XFILLER_73_474 vssd1 vssd1 vccd1 vccd1 sky130_fd_sc_hd__fill_1
XFILLER_18_379 vssd1 vssd1 vccd1 vccd1 sky130_fd_sc_hd__fill_1
XFILLER_14_530 vssd1 vssd1 vccd1 vccd1 sky130_fd_sc_hd__fill_2
XFILLER_33_349 vssd1 vssd1 vccd1 vccd1 sky130_fd_sc_hd__fill_4
XTAP_TAPCELL_ROW_31_506 vssd1 vccd1 sky130_fd_sc_hd__tapvpwrvgnd_1
XFILLER_41_360 vssd1 vssd1 vccd1 vccd1 sky130_fd_sc_hd__fill_2
XFILLER_81_73 vssd1 vssd1 vccd1 vccd1 sky130_fd_sc_hd__fill_4
XANTENNA__7435__A net293 vssd1 vssd1 vccd1 vccd1 sky130_fd_sc_hd__diode_2
X_5170_ _0358_ _0359_ vssd1 vssd1 vccd1 vccd1 _0360_ sky130_fd_sc_hd__xor2_1
XFILLER_68_235 vssd1 vssd1 vccd1 vccd1 sky130_fd_sc_hd__fill_1
XFILLER_83_205 vccd1 vssd1 vccd1 vssd1 sky130_ef_sc_hd__decap_40_12
XFILLER_56_419 vssd1 vssd1 vccd1 vccd1 sky130_fd_sc_hd__fill_1
XANTENNA__5446__A2 net58 vssd1 vssd1 vccd1 vccd1 sky130_fd_sc_hd__diode_2
Xinput4 gpio_in[11] vssd1 vssd1 vccd1 vccd1 net4 sky130_fd_sc_hd__buf_2
XANTENNA__8416__D net125 vssd1 vssd1 vccd1 vccd1 sky130_fd_sc_hd__diode_2
XTAP_TAPCELL_ROW_47_672 vssd1 vccd1 sky130_fd_sc_hd__tapvpwrvgnd_1
X_7811_ _3065_ _3066_ vssd1 vssd1 vccd1 vccd1 _3067_ sky130_fd_sc_hd__xnor2_1
X_7742_ _2996_ _2997_ vssd1 vssd1 vccd1 vccd1 _2998_ sky130_fd_sc_hd__xnor2_1
X_4954_ _0142_ _0143_ vssd1 vssd1 vccd1 vccd1 _0144_ sky130_fd_sc_hd__xnor2_1
XFILLER_24_338 vccd1 vssd1 vccd1 vssd1 sky130_ef_sc_hd__decap_40_12
X_7673_ net198 net277 net196 net282 vssd1 vssd1 vccd1 vccd1 _2927_ sky130_fd_sc_hd__a22oi_1
X_4885_ _3965_ _4160_ _4162_ vssd1 vssd1 vccd1 vccd1 _0075_ sky130_fd_sc_hd__a21bo_1
X_6624_ _1815_ _1814_ vssd1 vssd1 vccd1 vccd1 _1816_ sky130_fd_sc_hd__nand2b_1
XANTENNA_clkbuf_4_0_0_clk_A clknet_0_clk vssd1 vssd1 vccd1 vccd1 sky130_fd_sc_hd__diode_2
XANTENNA__4969__A net147 vssd1 vssd1 vccd1 vccd1 sky130_fd_sc_hd__diode_2
X_6555_ _1740_ _1741_ vssd1 vssd1 vccd1 vccd1 _1742_ sky130_fd_sc_hd__nand2_2
XANTENNA__7345__A net311 vssd1 vssd1 vccd1 vccd1 sky130_fd_sc_hd__diode_2
X_5506_ net312 net228 net235 net301 vssd1 vssd1 vccd1 vccd1 _0696_ sky130_fd_sc_hd__a22o_1
XANTENNA_fanout300_A net304 vssd1 vssd1 vccd1 vccd1 sky130_fd_sc_hd__diode_2
X_8225_ _3486_ _3492_ vssd1 vssd1 vccd1 vccd1 _3494_ sky130_fd_sc_hd__xnor2_1
X_6486_ _1467_ _1469_ _1466_ vssd1 vssd1 vccd1 vccd1 _1674_ sky130_fd_sc_hd__o21ba_1
X_5437_ _0609_ _0610_ vssd1 vssd1 vccd1 vccd1 _0627_ sky130_fd_sc_hd__xor2_1
XFILLER_86_29 vccd1 vssd1 vccd1 vssd1 sky130_ef_sc_hd__decap_40_12
X_8156_ net100 _1742_ net38 net98 vssd1 vssd1 vccd1 vccd1 _3420_ sky130_fd_sc_hd__o22a_1
X_5368_ _0318_ _0324_ vssd1 vssd1 vccd1 vccd1 _0558_ sky130_fd_sc_hd__xnor2_1
X_8087_ _3344_ _3345_ vssd1 vssd1 vccd1 vccd1 _3346_ sky130_fd_sc_hd__nor2_1
X_7107_ _2322_ _2327_ vssd1 vssd1 vccd1 vccd1 _2328_ sky130_fd_sc_hd__nand2_1
X_4319_ _3386_ vssd1 vssd1 vccd1 vccd1 _3397_ sky130_fd_sc_hd__inv_2
X_5299_ _0486_ _0487_ vssd1 vssd1 vccd1 vccd1 _0489_ sky130_fd_sc_hd__xnor2_1
X_7038_ _2243_ _2244_ _2255_ vssd1 vssd1 vccd1 vccd1 _2256_ sky130_fd_sc_hd__nand3_1
XFILLER_74_205 vssd1 vssd1 vccd1 vccd1 sky130_fd_sc_hd__fill_2
XTAP_TAPCELL_ROW_2_220 vssd1 vccd1 sky130_fd_sc_hd__tapvpwrvgnd_1
XFILLER_55_441 vssd1 vssd1 vccd1 vccd1 sky130_fd_sc_hd__fill_4
XANTENNA__4209__A net148 vssd1 vssd1 vccd1 vccd1 sky130_fd_sc_hd__diode_2
XTAP_TAPCELL_ROW_73_929 vssd1 vccd1 sky130_fd_sc_hd__tapvpwrvgnd_1
XANTENNA_fanout46_A net47 vssd1 vssd1 vccd1 vccd1 sky130_fd_sc_hd__diode_2
XFILLER_27_165 vssd1 vssd1 vccd1 vccd1 sky130_fd_sc_hd__fill_2
XFILLER_35_11 vssd1 vssd1 vccd1 vccd1 sky130_fd_sc_hd__fill_2
XFILLER_30_319 vssd1 vssd1 vccd1 vccd1 sky130_fd_sc_hd__fill_2
XFILLER_42_179 vssd1 vssd1 vccd1 vccd1 sky130_fd_sc_hd__fill_2
XFILLER_11_533 vssd1 vssd1 vccd1 vccd1 sky130_fd_sc_hd__fill_8
XANTENNA__4215__Y _2315_ vssd1 vssd1 vccd1 vccd1 sky130_fd_sc_hd__diode_2
XFILLER_78_533 vssd1 vssd1 vccd1 vccd1 sky130_fd_sc_hd__fill_8
XFILLER_76_40 vssd1 vssd1 vccd1 vccd1 sky130_fd_sc_hd__fill_1
XFILLER_80_219 vssd1 vssd1 vccd1 vccd1 sky130_fd_sc_hd__fill_8
XANTENNA_clkload9_A clknet_4_10_0_clk vssd1 vssd1 vccd1 vccd1 sky130_fd_sc_hd__diode_2
XANTENNA__7050__B2 net215 vssd1 vssd1 vccd1 vccd1 sky130_fd_sc_hd__diode_2
XANTENNA__7050__A1 net212 vssd1 vssd1 vccd1 vccd1 sky130_fd_sc_hd__diode_2
XFILLER_33_113 vccd1 vssd1 vccd1 vssd1 sky130_ef_sc_hd__decap_40_12
XFILLER_92_83 vssd1 vssd1 vccd1 vccd1 sky130_fd_sc_hd__fill_1
XTAP_TAPCELL_ROW_44_642 vssd1 vccd1 sky130_fd_sc_hd__tapvpwrvgnd_1
XANTENNA__5061__B1 net77 vssd1 vssd1 vccd1 vccd1 sky130_fd_sc_hd__diode_2
XANTENNA__6053__B net239 vssd1 vssd1 vccd1 vccd1 sky130_fd_sc_hd__diode_2
X_4670_ _3944_ _3945_ _3947_ vssd1 vssd1 vccd1 vccd1 _3948_ sky130_fd_sc_hd__nand3_1
XANTENNA__4789__A net129 vssd1 vssd1 vccd1 vccd1 sky130_fd_sc_hd__diode_2
X_6340_ _1331_ _1526_ _1527_ vssd1 vssd1 vccd1 vccd1 _1528_ sky130_fd_sc_hd__o21a_1
X_6271_ _1439_ _1440_ _1458_ _1459_ vssd1 vssd1 vccd1 vccd1 _1460_ sky130_fd_sc_hd__nand4_1
X_8010_ _3262_ _3264_ vssd1 vssd1 vccd1 vccd1 _3265_ sky130_fd_sc_hd__xnor2_1
X_5222_ _0410_ _0411_ vssd1 vssd1 vccd1 vccd1 _0412_ sky130_fd_sc_hd__or2_1
X_5153_ _0332_ _0341_ vssd1 vssd1 vccd1 vccd1 _0343_ sky130_fd_sc_hd__xor2_1
XANTENNA__7612__B net37 vssd1 vssd1 vccd1 vccd1 sky130_fd_sc_hd__diode_2
XANTENNA__8428__CLK clknet_4_0_0_clk vssd1 vssd1 vccd1 vccd1 sky130_fd_sc_hd__diode_2
X_5084_ _0115_ _0186_ _0192_ vssd1 vssd1 vccd1 vccd1 _0274_ sky130_fd_sc_hd__o21a_1
XFILLER_71_208 vssd1 vssd1 vccd1 vccd1 sky130_fd_sc_hd__fill_2
XANTENNA__4971__B _4099_ vssd1 vssd1 vccd1 vccd1 sky130_fd_sc_hd__diode_2
XFILLER_24_113 vssd1 vssd1 vccd1 vccd1 sky130_fd_sc_hd__fill_2
X_5986_ _1158_ _1175_ vssd1 vssd1 vccd1 vccd1 _1176_ sky130_fd_sc_hd__xnor2_1
X_7725_ _2978_ _2979_ vssd1 vssd1 vccd1 vccd1 _2981_ sky130_fd_sc_hd__xnor2_1
XFILLER_52_488 vssd1 vssd1 vccd1 vccd1 sky130_fd_sc_hd__fill_2
X_4937_ net133 net86 net84 net132 vssd1 vssd1 vccd1 vccd1 _0127_ sky130_fd_sc_hd__a22o_1
X_7656_ _2903_ _2909_ vssd1 vssd1 vccd1 vccd1 _2910_ sky130_fd_sc_hd__nand2b_1
X_4868_ _4143_ _4144_ _4071_ _4073_ vssd1 vssd1 vccd1 vccd1 _4146_ sky130_fd_sc_hd__o211ai_2
X_6607_ _1754_ _1797_ vssd1 vssd1 vccd1 vccd1 _1798_ sky130_fd_sc_hd__xnor2_1
X_4799_ _4074_ _4075_ vssd1 vssd1 vccd1 vccd1 _4077_ sky130_fd_sc_hd__xor2_1
X_7587_ _2515_ _2768_ _2770_ _2773_ vssd1 vssd1 vccd1 vccd1 _2837_ sky130_fd_sc_hd__a22o_1
X_6538_ _1549_ _1551_ _1723_ vssd1 vssd1 vccd1 vccd1 _1725_ sky130_fd_sc_hd__and3_1
XFILLER_21_57 vccd1 vssd1 vccd1 vssd1 sky130_ef_sc_hd__decap_40_12
X_6469_ _1639_ _1656_ vssd1 vssd1 vccd1 vccd1 _1657_ sky130_fd_sc_hd__nand2b_1
XANTENNA__5307__B net80 vssd1 vssd1 vccd1 vccd1 sky130_fd_sc_hd__diode_2
X_8208_ net294 net181 _3362_ _3365_ vssd1 vssd1 vccd1 vccd1 _3476_ sky130_fd_sc_hd__a31o_1
XFILLER_79_308 vssd1 vssd1 vccd1 vccd1 sky130_fd_sc_hd__fill_2
X_8139_ _3401_ _3400_ vssd1 vssd1 vccd1 vccd1 _3402_ sky130_fd_sc_hd__and2b_1
XFILLER_75_503 vssd1 vssd1 vccd1 vccd1 sky130_fd_sc_hd__fill_1
XFILLER_75_569 vssd1 vssd1 vccd1 vccd1 sky130_fd_sc_hd__fill_1
XFILLER_75_547 vccd1 vssd1 vccd1 vssd1 sky130_ef_sc_hd__decap_40_12
XFILLER_62_208 vssd1 vssd1 vccd1 vccd1 sky130_fd_sc_hd__fill_1
XTAP_TAPCELL_ROW_58_778 vssd1 vccd1 sky130_fd_sc_hd__tapvpwrvgnd_1
XPHY_EDGE_ROW_6_Left_99 vssd1 vssd1 vccd1 vccd1 sky130_fd_sc_hd__decap_3
XFILLER_15_113 vccd1 vssd1 vccd1 vssd1 sky130_ef_sc_hd__decap_40_12
XFILLER_28_496 vccd1 vssd1 vccd1 vssd1 sky130_ef_sc_hd__decap_40_12
XFILLER_43_455 vssd1 vssd1 vccd1 vccd1 sky130_fd_sc_hd__fill_1
XFILLER_30_116 vssd1 vssd1 vccd1 vccd1 sky130_fd_sc_hd__fill_4
XTAP_TAPCELL_ROW_41_612 vssd1 vccd1 sky130_fd_sc_hd__tapvpwrvgnd_1
XFILLER_30_138 vssd1 vssd1 vccd1 vccd1 sky130_fd_sc_hd__fill_2
XFILLER_7_356 vssd1 vssd1 vccd1 vccd1 sky130_fd_sc_hd__fill_1
XFILLER_7_378 vssd1 vssd1 vccd1 vccd1 sky130_fd_sc_hd__fill_2
XANTENNA__5217__B net89 vssd1 vssd1 vccd1 vccd1 sky130_fd_sc_hd__diode_2
XANTENNA__5649__A2 net215 vssd1 vssd1 vccd1 vccd1 sky130_fd_sc_hd__diode_2
XANTENNA__7432__B net299 vssd1 vssd1 vccd1 vccd1 sky130_fd_sc_hd__diode_2
XFILLER_87_83 vssd1 vssd1 vccd1 vccd1 sky130_fd_sc_hd__fill_8
XFILLER_38_227 vccd1 vssd1 vccd1 vssd1 sky130_ef_sc_hd__decap_40_12
XFILLER_66_558 vccd1 vssd1 vccd1 vssd1 sky130_ef_sc_hd__decap_40_12
XANTENNA__5887__B net311 vssd1 vssd1 vccd1 vccd1 sky130_fd_sc_hd__diode_2
XANTENNA__4283__S net157 vssd1 vssd1 vccd1 vccd1 sky130_fd_sc_hd__diode_2
XFILLER_46_282 vssd1 vssd1 vccd1 vccd1 sky130_fd_sc_hd__fill_2
XFILLER_46_271 vssd1 vssd1 vccd1 vccd1 sky130_fd_sc_hd__fill_1
X_5840_ net320 net233 _0936_ vssd1 vssd1 vccd1 vccd1 _1030_ sky130_fd_sc_hd__a21oi_1
XTAP_TAPCELL_ROW_29_491 vssd1 vccd1 sky130_fd_sc_hd__tapvpwrvgnd_1
XFILLER_34_477 vssd1 vssd1 vccd1 vccd1 sky130_fd_sc_hd__fill_1
X_5771_ _0950_ _0959_ _0960_ vssd1 vssd1 vccd1 vccd1 _0961_ sky130_fd_sc_hd__or3_1
X_8490_ clknet_4_12_0_clk PID_INST.pid.next_state\[3\] net336 vssd1 vssd1 vccd1 vccd1
+ PID_INST.pid.curr_state\[3\] sky130_fd_sc_hd__dfrtp_2
X_4722_ _1817_ net73 vssd1 vssd1 vccd1 vccd1 _4000_ sky130_fd_sc_hd__nor2_1
X_7510_ net101 net48 vssd1 vssd1 vccd1 vccd1 _2755_ sky130_fd_sc_hd__nor2_1
X_7441_ _2668_ _2669_ _2681_ vssd1 vssd1 vccd1 vccd1 _2682_ sky130_fd_sc_hd__nand3_1
XANTENNA__7326__A2 net217 vssd1 vssd1 vccd1 vccd1 sky130_fd_sc_hd__diode_2
X_4653_ _3922_ _3923_ _3905_ vssd1 vssd1 vccd1 vccd1 _3931_ sky130_fd_sc_hd__a21o_1
X_7372_ _2606_ _2607_ vssd1 vssd1 vccd1 vccd1 _2609_ sky130_fd_sc_hd__xnor2_1
XANTENNA__5888__A2 net311 vssd1 vssd1 vccd1 vccd1 sky130_fd_sc_hd__diode_2
X_4584_ _3850_ _3861_ vssd1 vssd1 vccd1 vccd1 _3862_ sky130_fd_sc_hd__nor2_1
XANTENNA__7045__D net262 vssd1 vssd1 vccd1 vccd1 sky130_fd_sc_hd__diode_2
X_6323_ _1103_ _1305_ _1308_ vssd1 vssd1 vccd1 vccd1 _1511_ sky130_fd_sc_hd__a21bo_1
X_6254_ _0736_ _1442_ _1441_ vssd1 vssd1 vccd1 vccd1 _1443_ sky130_fd_sc_hd__o21ai_1
XFILLER_88_116 vssd1 vssd1 vccd1 vccd1 sky130_fd_sc_hd__fill_1
X_5205_ _0392_ _0393_ vssd1 vssd1 vccd1 vccd1 _0395_ sky130_fd_sc_hd__xnor2_1
XANTENNA__6239__A net203 vssd1 vssd1 vccd1 vccd1 sky130_fd_sc_hd__diode_2
XANTENNA_fanout298_A net299 vssd1 vssd1 vccd1 vccd1 sky130_fd_sc_hd__diode_2
XFILLER_69_352 vssd1 vssd1 vccd1 vccd1 sky130_fd_sc_hd__fill_1
XANTENNA__4312__A2 net12 vssd1 vssd1 vccd1 vccd1 sky130_fd_sc_hd__diode_2
X_6185_ net127 net69 _1372_ vssd1 vssd1 vccd1 vccd1 _1374_ sky130_fd_sc_hd__and3_1
XFILLER_57_514 vssd1 vssd1 vccd1 vccd1 sky130_fd_sc_hd__fill_8
X_5136_ _0306_ _0325_ vssd1 vssd1 vccd1 vccd1 _0326_ sky130_fd_sc_hd__nor2_1
X_5067_ _0248_ _0256_ vssd1 vssd1 vccd1 vccd1 _0257_ sky130_fd_sc_hd__xnor2_1
XFILLER_84_377 vssd1 vssd1 vccd1 vccd1 sky130_fd_sc_hd__fill_4
XFILLER_25_400 vssd1 vssd1 vccd1 vccd1 sky130_fd_sc_hd__fill_4
XTAP_TAPCELL_ROW_55_748 vssd1 vccd1 sky130_fd_sc_hd__tapvpwrvgnd_1
XFILLER_16_24 vssd1 vssd1 vccd1 vccd1 sky130_fd_sc_hd__fill_4
XFILLER_16_35 vssd1 vssd1 vccd1 vccd1 sky130_fd_sc_hd__fill_4
X_5969_ _0526_ _0529_ vssd1 vssd1 vccd1 vccd1 _1159_ sky130_fd_sc_hd__nand2_1
X_7708_ _2963_ _2964_ vssd1 vssd1 vccd1 vccd1 _2965_ sky130_fd_sc_hd__nor2_1
XFILLER_12_138 vssd1 vssd1 vccd1 vccd1 sky130_fd_sc_hd__fill_2
XFILLER_40_458 vssd1 vssd1 vccd1 vccd1 sky130_fd_sc_hd__fill_1
X_7639_ net218 net257 net252 net222 vssd1 vssd1 vccd1 vccd1 _2892_ sky130_fd_sc_hd__a22oi_1
XFILLER_20_193 vssd1 vssd1 vccd1 vccd1 sky130_fd_sc_hd__fill_2
XFILLER_4_326 vssd1 vssd1 vccd1 vccd1 sky130_fd_sc_hd__fill_4
XFILLER_4_359 vssd1 vssd1 vccd1 vccd1 sky130_fd_sc_hd__fill_4
XFILLER_48_514 vccd1 vssd1 vccd1 vssd1 sky130_ef_sc_hd__decap_40_12
XFILLER_75_366 vccd1 vssd1 vccd1 vssd1 sky130_ef_sc_hd__decap_40_12
XFILLER_90_325 vssd1 vssd1 vccd1 vccd1 sky130_fd_sc_hd__fill_2
XFILLER_28_260 vssd1 vssd1 vccd1 vccd1 sky130_fd_sc_hd__fill_8
XFILLER_90_358 vssd1 vssd1 vccd1 vccd1 sky130_fd_sc_hd__fill_1
XFILLER_71_561 vssd1 vssd1 vccd1 vccd1 sky130_fd_sc_hd__fill_8
XFILLER_16_477 vssd1 vssd1 vccd1 vccd1 sky130_fd_sc_hd__fill_4
XTAP_TAPCELL_ROW_26_461 vssd1 vccd1 sky130_fd_sc_hd__tapvpwrvgnd_1
XFILLER_43_296 vccd1 vssd1 vccd1 vssd1 sky130_ef_sc_hd__decap_40_12
XFILLER_7_164 vssd1 vssd1 vccd1 vccd1 sky130_fd_sc_hd__fill_4
XANTENNA__4786__B _3734_ vssd1 vssd1 vccd1 vccd1 sky130_fd_sc_hd__diode_2
XANTENNA__4278__S net157 vssd1 vssd1 vccd1 vccd1 sky130_fd_sc_hd__diode_2
XFILLER_85_108 vssd1 vssd1 vccd1 vccd1 sky130_fd_sc_hd__fill_4
XFILLER_39_558 vssd1 vssd1 vccd1 vccd1 sky130_fd_sc_hd__fill_2
X_7990_ _3237_ _3238_ _3244_ vssd1 vssd1 vccd1 vccd1 _3245_ sky130_fd_sc_hd__and3_1
X_6941_ _2149_ _2152_ vssd1 vssd1 vccd1 vccd1 _2153_ sky130_fd_sc_hd__xor2_2
XFILLER_62_561 vssd1 vssd1 vccd1 vccd1 sky130_fd_sc_hd__fill_2
XANTENNA__8424__D net138 vssd1 vssd1 vccd1 vccd1 sky130_fd_sc_hd__diode_2
X_6872_ _2078_ _2079_ vssd1 vssd1 vccd1 vccd1 _2080_ sky130_fd_sc_hd__xor2_1
X_5823_ _1004_ _1012_ vssd1 vssd1 vccd1 vccd1 _1013_ sky130_fd_sc_hd__and2_1
XTAP_TAPCELL_ROW_52_718 vssd1 vccd1 sky130_fd_sc_hd__tapvpwrvgnd_1
X_5754_ _0940_ _0943_ vssd1 vssd1 vccd1 vccd1 _0944_ sky130_fd_sc_hd__nor2_1
X_5685_ _0870_ _0874_ _0851_ _0858_ vssd1 vssd1 vccd1 vccd1 _0875_ sky130_fd_sc_hd__o211a_1
X_4705_ _3801_ _3982_ vssd1 vssd1 vccd1 vccd1 _3983_ sky130_fd_sc_hd__xnor2_1
X_8473_ clknet_4_10_0_clk _0061_ net340 vssd1 vssd1 vccd1 vccd1 net22 sky130_fd_sc_hd__dfrtp_1
X_7424_ _2661_ _2662_ vssd1 vssd1 vccd1 vccd1 _2663_ sky130_fd_sc_hd__xnor2_1
X_4636_ _3908_ _3909_ _3911_ _3913_ vssd1 vssd1 vccd1 vccd1 _3914_ sky130_fd_sc_hd__a22o_1
X_7355_ _2576_ _2577_ _2589_ vssd1 vssd1 vccd1 vccd1 _2591_ sky130_fd_sc_hd__a21o_1
X_4567_ net126 net152 vssd1 vssd1 vccd1 vccd1 _3845_ sky130_fd_sc_hd__nand2_1
X_6306_ net100 net61 vssd1 vssd1 vccd1 vccd1 _1494_ sky130_fd_sc_hd__nor2_1
XFILLER_89_447 vssd1 vssd1 vccd1 vccd1 sky130_fd_sc_hd__fill_1
XFILLER_89_425 vccd1 vssd1 vccd1 vssd1 sky130_ef_sc_hd__decap_40_12
XANTENNA__4696__B net88 vssd1 vssd1 vccd1 vccd1 sky130_fd_sc_hd__diode_2
X_4498_ _3761_ _3775_ vssd1 vssd1 vccd1 vccd1 _3776_ sky130_fd_sc_hd__nand2_1
X_7286_ _2451_ _2515_ vssd1 vssd1 vccd1 vccd1 _2518_ sky130_fd_sc_hd__xnor2_1
XANTENNA__7072__B net287 vssd1 vssd1 vccd1 vccd1 sky130_fd_sc_hd__diode_2
X_6237_ _1219_ _1221_ _1425_ vssd1 vssd1 vccd1 vccd1 _1426_ sky130_fd_sc_hd__a21o_1
XANTENNA__4297__A1 net16 vssd1 vssd1 vccd1 vccd1 sky130_fd_sc_hd__diode_2
XFILLER_69_171 vssd1 vssd1 vccd1 vccd1 sky130_fd_sc_hd__fill_2
X_6168_ _2083_ _0088_ _1356_ vssd1 vssd1 vccd1 vccd1 _1357_ sky130_fd_sc_hd__or3_1
XFILLER_57_333 vssd1 vssd1 vccd1 vccd1 sky130_fd_sc_hd__fill_2
X_5119_ net118 net65 vssd1 vssd1 vccd1 vccd1 _0309_ sky130_fd_sc_hd__nor2_1
XTAP_TAPCELL_ROW_68_884 vssd1 vccd1 sky130_fd_sc_hd__tapvpwrvgnd_1
X_6099_ _1211_ _1288_ vssd1 vssd1 vccd1 vccd1 _1289_ sky130_fd_sc_hd__and2b_1
XFILLER_84_174 vssd1 vssd1 vccd1 vccd1 sky130_fd_sc_hd__fill_1
XFILLER_72_347 vssd1 vssd1 vccd1 vccd1 sky130_fd_sc_hd__fill_2
XFILLER_72_369 vssd1 vssd1 vccd1 vccd1 sky130_fd_sc_hd__fill_1
XANTENNA__5549__A1 net314 vssd1 vssd1 vccd1 vccd1 sky130_fd_sc_hd__diode_2
XFILLER_13_403 vssd1 vssd1 vccd1 vccd1 sky130_fd_sc_hd__fill_1
XFILLER_40_211 vssd1 vssd1 vccd1 vccd1 sky130_fd_sc_hd__fill_2
XFILLER_43_22 vssd1 vssd1 vccd1 vccd1 sky130_fd_sc_hd__fill_1
XTAP_TAPCELL_ROW_23_431 vssd1 vccd1 sky130_fd_sc_hd__tapvpwrvgnd_1
XFILLER_43_55 vssd1 vssd1 vccd1 vccd1 sky130_fd_sc_hd__fill_1
XANTENNA__5048__A net147 vssd1 vssd1 vccd1 vccd1 sky130_fd_sc_hd__diode_2
XTAP_TAPCELL_ROW_91_1113 vssd1 vccd1 sky130_fd_sc_hd__tapvpwrvgnd_1
XFILLER_4_156 vssd1 vssd1 vccd1 vccd1 sky130_fd_sc_hd__fill_4
XFILLER_48_344 vssd1 vssd1 vccd1 vccd1 sky130_fd_sc_hd__fill_1
XFILLER_0_395 vssd1 vssd1 vccd1 vccd1 sky130_fd_sc_hd__fill_4
XTAP_TAPCELL_ROW_89_1086 vssd1 vccd1 sky130_fd_sc_hd__tapvpwrvgnd_1
XFILLER_75_196 vssd1 vssd1 vccd1 vccd1 sky130_fd_sc_hd__fill_1
XFILLER_90_6 vccd1 vssd1 vccd1 vssd1 sky130_ef_sc_hd__decap_40_12
XANTENNA__7157__B net288 vssd1 vssd1 vccd1 vccd1 sky130_fd_sc_hd__diode_2
XFILLER_31_299 vccd1 vssd1 vccd1 vssd1 sky130_ef_sc_hd__decap_40_12
X_5470_ _0654_ _0655_ _0652_ vssd1 vssd1 vccd1 vccd1 _0660_ sky130_fd_sc_hd__o21a_1
X_4421_ net181 net180 net179 _3700_ vssd1 vssd1 vccd1 vccd1 _3705_ sky130_fd_sc_hd__and4_1
XFILLER_69_3 vssd1 vssd1 vccd1 vccd1 sky130_fd_sc_hd__fill_4
X_7140_ _2362_ _2361_ vssd1 vssd1 vccd1 vccd1 _2363_ sky130_fd_sc_hd__and2b_1
X_4352_ net218 net3 vssd1 vssd1 vccd1 vccd1 _3650_ sky130_fd_sc_hd__and2_1
X_7071_ _2289_ _2290_ vssd1 vssd1 vccd1 vccd1 _2291_ sky130_fd_sc_hd__nor2_1
X_4283_ net18 net399 net157 vssd1 vssd1 vccd1 vccd1 _0006_ sky130_fd_sc_hd__mux2_1
XANTENNA__8419__D net131 vssd1 vssd1 vccd1 vccd1 sky130_fd_sc_hd__diode_2
X_6022_ net269 net243 net265 net246 vssd1 vssd1 vccd1 vccd1 _1212_ sky130_fd_sc_hd__and4_1
XFILLER_79_480 vssd1 vssd1 vccd1 vccd1 sky130_fd_sc_hd__fill_1
XFILLER_54_303 vssd1 vssd1 vccd1 vccd1 sky130_fd_sc_hd__fill_4
XANTENNA__5421__A net111 vssd1 vssd1 vccd1 vccd1 sky130_fd_sc_hd__diode_2
X_7973_ _3226_ _3227_ vssd1 vssd1 vccd1 vccd1 _3228_ sky130_fd_sc_hd__or2_1
XTAP_TAPCELL_ROW_65_854 vssd1 vccd1 sky130_fd_sc_hd__tapvpwrvgnd_1
XFILLER_54_369 vssd1 vssd1 vccd1 vccd1 sky130_fd_sc_hd__fill_2
X_6924_ _1705_ _2004_ _2005_ _2006_ vssd1 vssd1 vccd1 vccd1 _2134_ sky130_fd_sc_hd__o2bb2a_1
XTAP_TAPCELL_ROW_37_567 vssd1 vccd1 sky130_fd_sc_hd__tapvpwrvgnd_1
XANTENNA__7348__A net293 vssd1 vssd1 vccd1 vccd1 sky130_fd_sc_hd__diode_2
X_6855_ _2060_ _2061_ vssd1 vssd1 vccd1 vccd1 _2062_ sky130_fd_sc_hd__nand2_1
XFILLER_22_233 vssd1 vssd1 vccd1 vccd1 sky130_fd_sc_hd__fill_4
Xfanout37 _2147_ vssd1 vssd1 vccd1 vccd1 net37 sky130_fd_sc_hd__buf_2
X_5806_ _0952_ _0994_ _0986_ vssd1 vssd1 vccd1 vccd1 _0996_ sky130_fd_sc_hd__a21oi_1
XANTENNA_fanout330_A net331 vssd1 vssd1 vccd1 vccd1 sky130_fd_sc_hd__diode_2
Xfanout59 _4157_ vssd1 vssd1 vccd1 vccd1 net59 sky130_fd_sc_hd__buf_2
Xfanout48 net49 vssd1 vssd1 vccd1 vccd1 net48 sky130_fd_sc_hd__buf_2
X_6786_ _1586_ _1748_ _1750_ vssd1 vssd1 vccd1 vccd1 _1989_ sky130_fd_sc_hd__o21ai_1
X_5737_ _0883_ _0926_ vssd1 vssd1 vccd1 vccd1 _0927_ sky130_fd_sc_hd__xnor2_1
XTAP_TAPCELL_ROW_20_401 vssd1 vccd1 sky130_fd_sc_hd__tapvpwrvgnd_1
X_8456_ clknet_4_7_0_clk _0044_ net332 vssd1 vssd1 vccd1 vccd1 PID_INST.k2_calc.sum_reg\[12\]
+ sky130_fd_sc_hd__dfrtp_2
XFILLER_89_18 vssd1 vssd1 vccd1 vccd1 sky130_fd_sc_hd__fill_4
XANTENNA_fanout216_X net216 vssd1 vssd1 vccd1 vccd1 sky130_fd_sc_hd__diode_2
X_5668_ _0760_ _0848_ _0850_ vssd1 vssd1 vccd1 vccd1 _0858_ sky130_fd_sc_hd__o21ai_1
X_7407_ _2645_ _2646_ vssd1 vssd1 vccd1 vccd1 _2647_ sky130_fd_sc_hd__nor2_1
X_5599_ _0781_ _0787_ vssd1 vssd1 vccd1 vccd1 _0789_ sky130_fd_sc_hd__or2_1
X_8387_ clknet_4_9_0_clk PID_INST.k3_calc.d2.y\[7\] net329 vssd1 vssd1 vccd1 vccd1
+ PID_INST.k3_calc.timescaling_term\[7\] sky130_fd_sc_hd__dfrtp_1
X_4619_ net141 net79 _3894_ _3895_ vssd1 vssd1 vccd1 vccd1 _3897_ sky130_fd_sc_hd__a22o_1
XFILLER_89_222 vssd1 vssd1 vccd1 vccd1 sky130_fd_sc_hd__fill_2
X_7338_ _2566_ _2572_ vssd1 vssd1 vccd1 vccd1 _2573_ sky130_fd_sc_hd__nand2_1
XFILLER_8_7 vssd1 vssd1 vccd1 vccd1 sky130_fd_sc_hd__fill_1
X_7269_ _2492_ _2498_ vssd1 vssd1 vccd1 vccd1 _2499_ sky130_fd_sc_hd__xnor2_1
XFILLER_77_439 vssd1 vssd1 vccd1 vccd1 sky130_fd_sc_hd__fill_1
XANTENNA_fanout76_A net77 vssd1 vssd1 vccd1 vccd1 sky130_fd_sc_hd__diode_2
XANTENNA__7759__A2 net194 vssd1 vssd1 vccd1 vccd1 sky130_fd_sc_hd__diode_2
XFILLER_38_55 vssd1 vssd1 vccd1 vccd1 sky130_fd_sc_hd__fill_8
XFILLER_18_539 vssd1 vssd1 vccd1 vccd1 sky130_fd_sc_hd__fill_1
XFILLER_72_166 vccd1 vssd1 vccd1 vssd1 sky130_ef_sc_hd__decap_40_12
XFILLER_54_54 vssd1 vssd1 vccd1 vccd1 sky130_fd_sc_hd__fill_2
XFILLER_26_561 vssd1 vssd1 vccd1 vccd1 sky130_fd_sc_hd__fill_8
XTAP_TAPCELL_ROW_0_192 vssd1 vccd1 sky130_fd_sc_hd__tapvpwrvgnd_1
XFILLER_13_222 vssd1 vssd1 vccd1 vccd1 sky130_fd_sc_hd__fill_2
XFILLER_13_244 vccd1 vssd1 vccd1 vssd1 sky130_ef_sc_hd__decap_40_12
XANTENNA__7931__A2 net256 vssd1 vssd1 vccd1 vccd1 sky130_fd_sc_hd__diode_2
XFILLER_5_465 vssd1 vssd1 vccd1 vccd1 sky130_fd_sc_hd__fill_1
XANTENNA__4410__A net187 vssd1 vssd1 vccd1 vccd1 sky130_fd_sc_hd__diode_2
XANTENNA__7721__A net322 vssd1 vssd1 vccd1 vccd1 sky130_fd_sc_hd__diode_2
XTAP_TAPCELL_ROW_8_281 vssd1 vccd1 sky130_fd_sc_hd__tapvpwrvgnd_1
XFILLER_83_409 vssd1 vssd1 vccd1 vccd1 sky130_fd_sc_hd__fill_1
XFILLER_48_130 vssd1 vssd1 vccd1 vccd1 sky130_fd_sc_hd__fill_4
XFILLER_48_174 vssd1 vssd1 vccd1 vccd1 sky130_fd_sc_hd__fill_2
XTAP_TAPCELL_ROW_62_824 vssd1 vccd1 sky130_fd_sc_hd__tapvpwrvgnd_1
XFILLER_17_561 vssd1 vssd1 vccd1 vccd1 sky130_fd_sc_hd__fill_8
X_4970_ _2210_ net70 vssd1 vssd1 vccd1 vccd1 _0160_ sky130_fd_sc_hd__nor2_1
XFILLER_32_520 vssd1 vssd1 vccd1 vccd1 sky130_fd_sc_hd__fill_2
XFILLER_32_531 vssd1 vssd1 vccd1 vccd1 sky130_fd_sc_hd__fill_1
XTAP_TAPCELL_ROW_34_537 vssd1 vccd1 sky130_fd_sc_hd__tapvpwrvgnd_1
X_6640_ net291 net211 _1832_ vssd1 vssd1 vccd1 vccd1 _1833_ sky130_fd_sc_hd__and3_1
X_6571_ net95 net64 _1756_ vssd1 vssd1 vccd1 vccd1 _1758_ sky130_fd_sc_hd__o21ba_1
X_8310_ net197 net201 net256 net252 vssd1 vssd1 vccd1 vccd1 _3585_ sky130_fd_sc_hd__nand4_1
X_5522_ _0705_ _0710_ vssd1 vssd1 vccd1 vccd1 _0712_ sky130_fd_sc_hd__nor2_1
XANTENNA__7174__Y _2399_ vssd1 vssd1 vccd1 vccd1 sky130_fd_sc_hd__diode_2
XANTENNA__7135__B1 net280 vssd1 vssd1 vccd1 vccd1 sky130_fd_sc_hd__diode_2
X_8241_ _3509_ _3510_ vssd1 vssd1 vccd1 vccd1 _3511_ sky130_fd_sc_hd__or2_1
X_5453_ net107 net65 vssd1 vssd1 vccd1 vccd1 _0643_ sky130_fd_sc_hd__nor2_1
XANTENNA__7334__C net256 vssd1 vssd1 vccd1 vccd1 sky130_fd_sc_hd__diode_2
X_4404_ net191 _3694_ net160 vssd1 vssd1 vccd1 vccd1 _0047_ sky130_fd_sc_hd__mux2_1
X_5384_ _0567_ _0572_ vssd1 vssd1 vccd1 vccd1 _0574_ sky130_fd_sc_hd__xor2_1
X_8172_ _3435_ _3436_ vssd1 vssd1 vccd1 vccd1 _3437_ sky130_fd_sc_hd__xnor2_1
X_7123_ _2331_ _2332_ _2343_ vssd1 vssd1 vccd1 vccd1 _2344_ sky130_fd_sc_hd__nand3_1
Xfanout205 net206 vssd1 vssd1 vccd1 vccd1 net205 sky130_fd_sc_hd__buf_2
X_4335_ net230 net17 vssd1 vssd1 vccd1 vccd1 _3568_ sky130_fd_sc_hd__nand2_1
Xfanout238 PID_INST.k2_calc.sum_reg\[3\] vssd1 vssd1 vccd1 vccd1 net238 sky130_fd_sc_hd__dlymetal6s2s_1
Xfanout216 net217 vssd1 vssd1 vccd1 vccd1 net216 sky130_fd_sc_hd__buf_2
Xfanout227 net228 vssd1 vssd1 vccd1 vccd1 net227 sky130_fd_sc_hd__buf_2
X_7054_ _1943_ _1946_ _1942_ vssd1 vssd1 vccd1 vccd1 _2273_ sky130_fd_sc_hd__o21ba_1
Xfanout249 PID_INST.k2_calc.sum_reg\[0\] vssd1 vssd1 vccd1 vccd1 net249 sky130_fd_sc_hd__buf_2
X_4266_ net11 net2 _2823_ _2834_ vssd1 vssd1 vccd1 vccd1 _2856_ sky130_fd_sc_hd__o211a_1
XANTENNA_fanout280_A PID_INST.k2_calc.reg_lc\[9\] vssd1 vssd1 vccd1 vccd1 sky130_fd_sc_hd__diode_2
X_6005_ _0477_ _1194_ vssd1 vssd1 vccd1 vccd1 _1195_ sky130_fd_sc_hd__xor2_1
X_4197_ _2114_ vssd1 vssd1 vccd1 vccd1 PID_INST.k3_calc.d1.y\[6\] sky130_fd_sc_hd__inv_2
XFILLER_67_472 vssd1 vssd1 vccd1 vccd1 sky130_fd_sc_hd__fill_1
XFILLER_27_314 vssd1 vssd1 vccd1 vccd1 sky130_fd_sc_hd__fill_2
XANTENNA__7610__A1 net115 vssd1 vssd1 vccd1 vccd1 sky130_fd_sc_hd__diode_2
X_7956_ _2990_ _3003_ _3209_ vssd1 vssd1 vccd1 vccd1 _3211_ sky130_fd_sc_hd__and3_1
XPHY_EDGE_ROW_59_Left_152 vssd1 vssd1 vccd1 vccd1 sky130_fd_sc_hd__decap_3
XFILLER_24_13 vssd1 vssd1 vccd1 vccd1 sky130_fd_sc_hd__fill_2
XFILLER_24_24 vssd1 vssd1 vccd1 vccd1 sky130_fd_sc_hd__fill_1
X_7887_ _3065_ _3066_ _3068_ _2839_ vssd1 vssd1 vccd1 vccd1 _3142_ sky130_fd_sc_hd__a22o_1
X_6907_ _2044_ _2045_ _2047_ vssd1 vssd1 vccd1 vccd1 _2117_ sky130_fd_sc_hd__a21o_1
XFILLER_35_391 vssd1 vssd1 vccd1 vccd1 sky130_fd_sc_hd__fill_1
XFILLER_24_35 vssd1 vssd1 vccd1 vccd1 sky130_fd_sc_hd__fill_8
XFILLER_24_57 vssd1 vssd1 vccd1 vccd1 sky130_fd_sc_hd__fill_4
X_6838_ _2038_ _2042_ vssd1 vssd1 vccd1 vccd1 _2044_ sky130_fd_sc_hd__xnor2_1
XANTENNA__8418__RESET_B net327 vssd1 vssd1 vccd1 vccd1 sky130_fd_sc_hd__diode_2
XFILLER_10_225 vssd1 vssd1 vccd1 vccd1 sky130_fd_sc_hd__fill_8
X_6769_ _1961_ _1962_ _1969_ vssd1 vssd1 vccd1 vccd1 _1970_ sky130_fd_sc_hd__and3_1
X_8439_ clknet_4_4_0_clk net400 net331 vssd1 vssd1 vccd1 vccd1 PID_INST.k3_calc.prev_error\[11\]
+ sky130_fd_sc_hd__dfrtp_1
XPHY_EDGE_ROW_68_Left_161 vssd1 vssd1 vccd1 vccd1 sky130_fd_sc_hd__decap_3
XFILLER_2_446 vccd1 vssd1 vccd1 vssd1 sky130_ef_sc_hd__decap_40_12
XANTENNA__8484__CLK clknet_4_15_0_clk vssd1 vssd1 vccd1 vccd1 sky130_fd_sc_hd__diode_2
XFILLER_49_54 vssd1 vssd1 vccd1 vccd1 sky130_fd_sc_hd__fill_2
XFILLER_49_43 vssd1 vssd1 vccd1 vccd1 sky130_fd_sc_hd__fill_4
XANTENNA_fanout79_X net79 vssd1 vssd1 vccd1 vccd1 sky130_fd_sc_hd__diode_2
XFILLER_77_269 vssd1 vssd1 vccd1 vccd1 sky130_fd_sc_hd__fill_8
XFILLER_77_258 vssd1 vssd1 vccd1 vccd1 sky130_fd_sc_hd__fill_4
XFILLER_65_409 vssd1 vssd1 vccd1 vccd1 sky130_fd_sc_hd__fill_2
XTAP_TAPCELL_ROW_5_251 vssd1 vccd1 sky130_fd_sc_hd__tapvpwrvgnd_1
XTAP_TAPCELL_ROW_86_1056 vssd1 vccd1 sky130_fd_sc_hd__tapvpwrvgnd_1
XPHY_EDGE_ROW_77_Left_170 vssd1 vssd1 vccd1 vccd1 sky130_fd_sc_hd__decap_3
XFILLER_73_464 vssd1 vssd1 vccd1 vccd1 sky130_fd_sc_hd__fill_2
XFILLER_45_177 vccd1 vssd1 vccd1 vssd1 sky130_ef_sc_hd__decap_40_12
XFILLER_60_125 vssd1 vssd1 vccd1 vccd1 sky130_fd_sc_hd__fill_1
XFILLER_26_391 vssd1 vssd1 vccd1 vccd1 sky130_fd_sc_hd__fill_2
XFILLER_14_553 vccd1 vssd1 vccd1 vssd1 sky130_ef_sc_hd__decap_40_12
XTAP_TAPCELL_ROW_31_507 vssd1 vccd1 sky130_fd_sc_hd__tapvpwrvgnd_1
XFILLER_41_372 vssd1 vssd1 vccd1 vccd1 sky130_fd_sc_hd__fill_1
XANTENNA__5915__B2 net118 vssd1 vssd1 vccd1 vccd1 sky130_fd_sc_hd__diode_2
XANTENNA__5915__A1 net139 vssd1 vssd1 vccd1 vccd1 sky130_fd_sc_hd__diode_2
XANTENNA__7435__B net192 vssd1 vssd1 vccd1 vccd1 sky130_fd_sc_hd__diode_2
XANTENNA__4497__D net78 vssd1 vssd1 vccd1 vccd1 sky130_fd_sc_hd__diode_2
XANTENNA__4286__S net157 vssd1 vssd1 vccd1 vccd1 sky130_fd_sc_hd__diode_2
Xinput5 gpio_in[12] vssd1 vssd1 vccd1 vccd1 net5 sky130_fd_sc_hd__clkbuf_4
X_7810_ net101 net44 vssd1 vssd1 vccd1 vccd1 _3066_ sky130_fd_sc_hd__nor2_1
XFILLER_64_486 vssd1 vssd1 vccd1 vccd1 sky130_fd_sc_hd__fill_1
XFILLER_51_103 vssd1 vssd1 vccd1 vccd1 sky130_fd_sc_hd__fill_1
XTAP_TAPCELL_ROW_47_673 vssd1 vccd1 sky130_fd_sc_hd__tapvpwrvgnd_1
XFILLER_91_283 vssd1 vssd1 vccd1 vccd1 sky130_fd_sc_hd__fill_1
X_7741_ net293 net187 vssd1 vssd1 vccd1 vccd1 _2997_ sky130_fd_sc_hd__nand2_1
X_4953_ _4149_ _4151_ vssd1 vssd1 vccd1 vccd1 _0143_ sky130_fd_sc_hd__and2b_1
XFILLER_17_380 vccd1 vssd1 vccd1 vssd1 sky130_ef_sc_hd__decap_40_12
XTAP_TAPCELL_ROW_19_386 vssd1 vccd1 sky130_fd_sc_hd__tapvpwrvgnd_1
X_7672_ net198 net282 net277 net194 vssd1 vssd1 vccd1 vccd1 _2926_ sky130_fd_sc_hd__and4_1
XFILLER_51_158 vssd1 vssd1 vccd1 vccd1 sky130_fd_sc_hd__fill_4
X_6623_ _1605_ _1607_ _1604_ vssd1 vssd1 vccd1 vccd1 _1815_ sky130_fd_sc_hd__o21ba_1
X_4884_ net118 net61 _4161_ vssd1 vssd1 vccd1 vccd1 _4162_ sky130_fd_sc_hd__or3_1
XANTENNA_fanout126_A net127 vssd1 vssd1 vccd1 vccd1 sky130_fd_sc_hd__diode_2
X_6554_ _1578_ _1581_ _1738_ vssd1 vssd1 vccd1 vccd1 _1741_ sky130_fd_sc_hd__nand3_2
XANTENNA__7345__B net299 vssd1 vssd1 vccd1 vccd1 sky130_fd_sc_hd__diode_2
X_5505_ net312 net301 net228 net235 vssd1 vssd1 vccd1 vccd1 _0695_ sky130_fd_sc_hd__and4_1
X_6485_ _1671_ _1672_ vssd1 vssd1 vccd1 vccd1 _1673_ sky130_fd_sc_hd__xnor2_1
X_8224_ _3490_ _3491_ vssd1 vssd1 vccd1 vccd1 _3492_ sky130_fd_sc_hd__nand2_1
X_5436_ _0614_ _0619_ vssd1 vssd1 vccd1 vccd1 _0626_ sky130_fd_sc_hd__xor2_1
XANTENNA__7361__A net225 vssd1 vssd1 vccd1 vccd1 sky130_fd_sc_hd__diode_2
X_8155_ net100 net38 vssd1 vssd1 vccd1 vccd1 _3419_ sky130_fd_sc_hd__nor2_1
X_5367_ _0328_ _0556_ vssd1 vssd1 vccd1 vccd1 _0557_ sky130_fd_sc_hd__xnor2_1
XANTENNA__4893__A1 _4095_ vssd1 vssd1 vccd1 vccd1 sky130_fd_sc_hd__diode_2
X_8086_ net293 net183 _3340_ _3342_ vssd1 vssd1 vccd1 vccd1 _3345_ sky130_fd_sc_hd__o2bb2a_1
X_7106_ _2325_ _2326_ vssd1 vssd1 vccd1 vccd1 _2327_ sky130_fd_sc_hd__xnor2_1
X_4318_ net241 net14 vssd1 vssd1 vccd1 vccd1 _3386_ sky130_fd_sc_hd__nand2_1
X_5298_ _0487_ _0486_ vssd1 vssd1 vccd1 vccd1 _0488_ sky130_fd_sc_hd__and2b_1
X_7037_ _2245_ _2253_ vssd1 vssd1 vccd1 vccd1 _2255_ sky130_fd_sc_hd__xnor2_1
XANTENNA__6095__B1 _1101_ vssd1 vssd1 vccd1 vccd1 sky130_fd_sc_hd__diode_2
X_4249_ net7 net167 _2664_ vssd1 vssd1 vccd1 vccd1 _2675_ sky130_fd_sc_hd__o21ai_1
XTAP_TAPCELL_ROW_2_221 vssd1 vccd1 sky130_fd_sc_hd__tapvpwrvgnd_1
XANTENNA__4645__A1 net120 vssd1 vssd1 vccd1 vccd1 sky130_fd_sc_hd__diode_2
XFILLER_19_57 vssd1 vssd1 vccd1 vccd1 sky130_fd_sc_hd__fill_2
XFILLER_19_68 vccd1 vssd1 vccd1 vssd1 sky130_ef_sc_hd__decap_40_12
XFILLER_27_100 vssd1 vssd1 vccd1 vccd1 sky130_fd_sc_hd__fill_2
XFILLER_55_453 vssd1 vssd1 vccd1 vccd1 sky130_fd_sc_hd__fill_2
XFILLER_27_144 vssd1 vssd1 vccd1 vccd1 sky130_fd_sc_hd__fill_1
XFILLER_55_475 vssd1 vssd1 vccd1 vccd1 sky130_fd_sc_hd__fill_1
XFILLER_55_464 vssd1 vssd1 vccd1 vccd1 sky130_fd_sc_hd__fill_4
X_7939_ _2980_ _2987_ _3193_ vssd1 vssd1 vccd1 vccd1 _3194_ sky130_fd_sc_hd__a21o_1
XFILLER_42_114 vssd1 vssd1 vccd1 vccd1 sky130_fd_sc_hd__fill_1
XFILLER_42_125 vssd1 vssd1 vccd1 vccd1 sky130_fd_sc_hd__fill_1
XANTENNA__5070__A1 net162 vssd1 vssd1 vccd1 vccd1 sky130_fd_sc_hd__diode_2
XANTENNA__5070__B2 net163 vssd1 vssd1 vccd1 vccd1 sky130_fd_sc_hd__diode_2
XFILLER_30_309 vssd1 vssd1 vccd1 vccd1 sky130_fd_sc_hd__fill_2
XFILLER_42_147 vssd1 vssd1 vccd1 vccd1 sky130_fd_sc_hd__fill_1
XFILLER_42_169 vssd1 vssd1 vccd1 vccd1 sky130_fd_sc_hd__fill_1
XFILLER_7_505 vssd1 vssd1 vccd1 vccd1 sky130_fd_sc_hd__fill_1
XFILLER_7_538 vssd1 vssd1 vccd1 vccd1 sky130_fd_sc_hd__fill_1
XANTENNA__7255__B net58 vssd1 vssd1 vccd1 vccd1 sky130_fd_sc_hd__diode_2
XFILLER_78_501 vssd1 vssd1 vccd1 vccd1 sky130_fd_sc_hd__fill_4
XFILLER_76_85 vssd1 vssd1 vccd1 vccd1 sky130_fd_sc_hd__fill_2
XFILLER_65_217 vssd1 vssd1 vccd1 vccd1 sky130_fd_sc_hd__fill_4
XANTENNA_input11_X net11 vssd1 vssd1 vccd1 vccd1 sky130_fd_sc_hd__diode_2
XFILLER_46_475 vssd1 vssd1 vccd1 vccd1 sky130_fd_sc_hd__fill_1
XFILLER_18_155 vssd1 vssd1 vccd1 vccd1 sky130_fd_sc_hd__fill_2
XANTENNA__7050__A2 net285 vssd1 vssd1 vccd1 vccd1 sky130_fd_sc_hd__diode_2
XFILLER_61_445 vssd1 vssd1 vccd1 vccd1 sky130_fd_sc_hd__fill_2
XFILLER_33_125 vssd1 vssd1 vccd1 vccd1 sky130_fd_sc_hd__fill_8
XTAP_TAPCELL_ROW_44_643 vssd1 vccd1 sky130_fd_sc_hd__tapvpwrvgnd_1
XTAP_TAPCELL_ROW_16_356 vssd1 vccd1 sky130_fd_sc_hd__tapvpwrvgnd_1
XANTENNA__6053__C net273 vssd1 vssd1 vccd1 vccd1 sky130_fd_sc_hd__diode_2
XFILLER_14_383 vssd1 vssd1 vccd1 vccd1 sky130_fd_sc_hd__fill_1
XANTENNA__4789__B net85 vssd1 vssd1 vccd1 vccd1 sky130_fd_sc_hd__diode_2
X_6270_ _1253_ _1255_ _1457_ vssd1 vssd1 vccd1 vccd1 _1459_ sky130_fd_sc_hd__or3_1
XANTENNA__6313__A1 net97 vssd1 vssd1 vccd1 vccd1 sky130_fd_sc_hd__diode_2
XANTENNA__6313__B2 net109 vssd1 vssd1 vccd1 vccd1 sky130_fd_sc_hd__diode_2
XANTENNA__4324__B1 net15 vssd1 vssd1 vccd1 vccd1 sky130_fd_sc_hd__diode_2
X_5221_ net166 net87 _0409_ vssd1 vssd1 vccd1 vccd1 _0411_ sky130_fd_sc_hd__a21oi_1
XANTENNA__7181__A net115 vssd1 vssd1 vccd1 vccd1 sky130_fd_sc_hd__diode_2
X_5152_ _0341_ _0332_ vssd1 vssd1 vccd1 vccd1 _0342_ sky130_fd_sc_hd__and2b_1
XANTENNA__8427__D net162 vssd1 vssd1 vccd1 vccd1 sky130_fd_sc_hd__diode_2
XANTENNA__5824__B1 net237 vssd1 vssd1 vccd1 vccd1 sky130_fd_sc_hd__diode_2
XFILLER_56_228 vssd1 vssd1 vccd1 vccd1 sky130_fd_sc_hd__fill_1
X_5083_ _0266_ _0271_ vssd1 vssd1 vccd1 vccd1 _0273_ sky130_fd_sc_hd__xor2_1
XFILLER_37_464 vssd1 vssd1 vccd1 vccd1 sky130_fd_sc_hd__fill_1
XFILLER_64_283 vssd1 vssd1 vccd1 vccd1 sky130_fd_sc_hd__fill_2
XFILLER_24_125 vssd1 vssd1 vccd1 vccd1 sky130_fd_sc_hd__fill_1
X_7724_ _2979_ _2978_ vssd1 vssd1 vccd1 vccd1 _2980_ sky130_fd_sc_hd__nand2b_1
XFILLER_52_467 vssd1 vssd1 vccd1 vccd1 sky130_fd_sc_hd__fill_8
XFILLER_12_309 vssd1 vssd1 vccd1 vccd1 sky130_fd_sc_hd__fill_4
X_5985_ _1159_ _1173_ vssd1 vssd1 vccd1 vccd1 _1175_ sky130_fd_sc_hd__xnor2_1
XANTENNA_fanout243_A PID_INST.k2_calc.sum_reg\[2\] vssd1 vssd1 vccd1 vccd1 sky130_fd_sc_hd__diode_2
X_4936_ _2051_ _3734_ _0125_ vssd1 vssd1 vccd1 vccd1 _0126_ sky130_fd_sc_hd__or3_1
X_7655_ _2906_ _2907_ vssd1 vssd1 vccd1 vccd1 _2909_ sky130_fd_sc_hd__xnor2_1
X_4867_ _4071_ _4073_ _4143_ _4144_ vssd1 vssd1 vccd1 vccd1 _4145_ sky130_fd_sc_hd__a211o_1
XANTENNA__6260__A net216 vssd1 vssd1 vccd1 vccd1 sky130_fd_sc_hd__diode_2
X_7586_ _2832_ _2833_ vssd1 vssd1 vccd1 vccd1 _2836_ sky130_fd_sc_hd__xor2_1
X_6606_ _1793_ _1794_ vssd1 vssd1 vccd1 vccd1 _1797_ sky130_fd_sc_hd__xnor2_1
X_6537_ _1549_ _1551_ _1723_ vssd1 vssd1 vccd1 vccd1 _1724_ sky130_fd_sc_hd__a21oi_1
X_4798_ _4074_ _4075_ vssd1 vssd1 vccd1 vccd1 _4076_ sky130_fd_sc_hd__nand2b_1
XANTENNA_fanout129_X net129 vssd1 vssd1 vccd1 vccd1 sky130_fd_sc_hd__diode_2
XFILLER_4_519 vssd1 vssd1 vccd1 vccd1 sky130_fd_sc_hd__fill_1
XFILLER_21_69 vssd1 vssd1 vccd1 vccd1 sky130_fd_sc_hd__fill_4
X_6468_ _1654_ _1655_ vssd1 vssd1 vccd1 vccd1 _1656_ sky130_fd_sc_hd__and2_1
X_8207_ _3473_ _3474_ vssd1 vssd1 vccd1 vccd1 _3475_ sky130_fd_sc_hd__xnor2_1
X_5419_ _0560_ _0608_ vssd1 vssd1 vccd1 vccd1 _0609_ sky130_fd_sc_hd__xnor2_1
X_6399_ net112 net44 net43 net108 vssd1 vssd1 vccd1 vccd1 _1587_ sky130_fd_sc_hd__o22a_1
X_8138_ _3248_ _3249_ _3252_ vssd1 vssd1 vccd1 vccd1 _3401_ sky130_fd_sc_hd__a21oi_1
XANTENNA__6419__B net193 vssd1 vssd1 vccd1 vccd1 sky130_fd_sc_hd__diode_2
XANTENNA_input3_X net3 vssd1 vssd1 vccd1 vccd1 sky130_fd_sc_hd__diode_2
X_8069_ net205 net256 net252 net209 vssd1 vssd1 vccd1 vccd1 _3326_ sky130_fd_sc_hd__a22oi_1
XFILLER_75_537 vssd1 vssd1 vccd1 vccd1 sky130_fd_sc_hd__fill_2
XFILLER_75_559 vssd1 vssd1 vccd1 vccd1 sky130_fd_sc_hd__fill_1
XANTENNA__6435__A net199 vssd1 vssd1 vccd1 vccd1 sky130_fd_sc_hd__diode_2
XTAP_TAPCELL_ROW_58_779 vssd1 vccd1 sky130_fd_sc_hd__tapvpwrvgnd_1
XFILLER_28_475 vssd1 vssd1 vccd1 vccd1 sky130_fd_sc_hd__fill_1
XTAP_TAPCELL_ROW_83_1026 vssd1 vccd1 sky130_fd_sc_hd__tapvpwrvgnd_1
XFILLER_55_294 vssd1 vssd1 vccd1 vccd1 sky130_fd_sc_hd__fill_8
Xmax_cap67 _4082_ vssd1 vssd1 vccd1 vccd1 net67 sky130_fd_sc_hd__clkbuf_2
XFILLER_15_125 vssd1 vssd1 vccd1 vccd1 sky130_fd_sc_hd__fill_4
XFILLER_43_412 vccd1 vssd1 vccd1 vssd1 sky130_ef_sc_hd__decap_40_12
XFILLER_70_253 vssd1 vssd1 vccd1 vccd1 sky130_fd_sc_hd__fill_2
XFILLER_15_169 vssd1 vssd1 vccd1 vccd1 sky130_fd_sc_hd__fill_4
XTAP_TAPCELL_ROW_41_613 vssd1 vccd1 sky130_fd_sc_hd__tapvpwrvgnd_1
XTAP_TAPCELL_ROW_13_326 vssd1 vccd1 sky130_fd_sc_hd__tapvpwrvgnd_1
XFILLER_11_364 vssd1 vssd1 vccd1 vccd1 sky130_fd_sc_hd__fill_1
XFILLER_7_38 vssd1 vssd1 vccd1 vccd1 sky130_fd_sc_hd__fill_2
XANTENNA__8296__A1 net294 vssd1 vssd1 vccd1 vccd1 sky130_fd_sc_hd__diode_2
XANTENNA__4306__A0 net260 vssd1 vssd1 vccd1 vccd1 sky130_fd_sc_hd__diode_2
XANTENNA__7713__B _2968_ vssd1 vssd1 vccd1 vccd1 sky130_fd_sc_hd__diode_2
XFILLER_87_40 vccd1 vssd1 vccd1 vssd1 sky130_ef_sc_hd__decap_40_12
XANTENNA__7432__C net188 vssd1 vssd1 vccd1 vccd1 sky130_fd_sc_hd__diode_2
Xclkbuf_4_9_0_clk clknet_0_clk vssd1 vssd1 vccd1 vccd1 clknet_4_9_0_clk sky130_fd_sc_hd__clkbuf_8
XFILLER_23_7 vssd1 vssd1 vccd1 vccd1 sky130_fd_sc_hd__fill_2
XFILLER_38_206 vssd1 vssd1 vccd1 vccd1 sky130_fd_sc_hd__fill_4
XFILLER_16_6 vssd1 vssd1 vccd1 vccd1 sky130_fd_sc_hd__fill_4
XFILLER_38_239 vssd1 vssd1 vccd1 vccd1 sky130_fd_sc_hd__fill_4
XFILLER_61_220 vssd1 vssd1 vccd1 vccd1 sky130_fd_sc_hd__fill_4
XFILLER_34_434 vccd1 vssd1 vccd1 vssd1 sky130_ef_sc_hd__decap_40_12
XANTENNA__6231__B1 net258 vssd1 vssd1 vccd1 vccd1 sky130_fd_sc_hd__diode_2
XTAP_TAPCELL_ROW_29_492 vssd1 vccd1 sky130_fd_sc_hd__tapvpwrvgnd_1
X_5770_ _0932_ _0938_ _0949_ vssd1 vssd1 vccd1 vccd1 _0960_ sky130_fd_sc_hd__and3_1
X_4721_ net74 vssd1 vssd1 vccd1 vccd1 _3999_ sky130_fd_sc_hd__inv_2
X_7440_ _2670_ _2679_ vssd1 vssd1 vccd1 vccd1 _2681_ sky130_fd_sc_hd__xnor2_1
XANTENNA__6080__A _0786_ vssd1 vssd1 vccd1 vccd1 sky130_fd_sc_hd__diode_2
X_4652_ net123 net120 net153 net151 vssd1 vssd1 vccd1 vccd1 _3930_ sky130_fd_sc_hd__nand4_1
X_7371_ _2607_ _2606_ vssd1 vssd1 vccd1 vccd1 _2608_ sky130_fd_sc_hd__and2b_1
X_4583_ _3738_ _3849_ _3848_ vssd1 vssd1 vccd1 vccd1 _3861_ sky130_fd_sc_hd__a21oi_1
X_6322_ _1508_ _1509_ vssd1 vssd1 vccd1 vccd1 _1510_ sky130_fd_sc_hd__nand2b_1
X_6253_ net235 net261 vssd1 vssd1 vccd1 vccd1 _1442_ sky130_fd_sc_hd__nand2_1
XFILLER_6_390 vssd1 vssd1 vccd1 vccd1 sky130_fd_sc_hd__fill_8
X_5204_ _0393_ _0392_ vssd1 vssd1 vccd1 vccd1 _0394_ sky130_fd_sc_hd__and2b_1
X_6184_ net127 net68 vssd1 vssd1 vccd1 vccd1 _1373_ sky130_fd_sc_hd__nand2_1
XANTENNA_fanout193_A PID_INST.k2_calc.sum_reg\[15\] vssd1 vssd1 vccd1 vccd1 sky130_fd_sc_hd__diode_2
XFILLER_69_386 vssd1 vssd1 vccd1 vccd1 sky130_fd_sc_hd__fill_1
X_5135_ _0318_ _0324_ _0316_ vssd1 vssd1 vccd1 vccd1 _0325_ sky130_fd_sc_hd__a21oi_1
X_5066_ _0249_ _0254_ vssd1 vssd1 vccd1 vccd1 _0256_ sky130_fd_sc_hd__xor2_1
XANTENNA__6255__A net207 vssd1 vssd1 vccd1 vccd1 sky130_fd_sc_hd__diode_2
XTAP_TAPCELL_ROW_55_749 vssd1 vccd1 sky130_fd_sc_hd__tapvpwrvgnd_1
XFILLER_25_412 vccd1 vssd1 vccd1 vssd1 sky130_ef_sc_hd__decap_40_12
XFILLER_80_562 vssd1 vssd1 vccd1 vccd1 sky130_fd_sc_hd__fill_8
XFILLER_52_253 vssd1 vssd1 vccd1 vccd1 sky130_fd_sc_hd__fill_4
XFILLER_52_264 vssd1 vssd1 vccd1 vccd1 sky130_fd_sc_hd__fill_1
XANTENNA__4555__D_N net81 vssd1 vssd1 vccd1 vccd1 sky130_fd_sc_hd__diode_2
XFILLER_12_117 vssd1 vssd1 vccd1 vccd1 sky130_fd_sc_hd__fill_2
X_5968_ _1155_ _1156_ vssd1 vssd1 vccd1 vccd1 _1158_ sky130_fd_sc_hd__xnor2_1
XFILLER_40_404 vccd1 vssd1 vccd1 vssd1 sky130_ef_sc_hd__decap_40_12
X_7707_ _2959_ _2960_ _2962_ vssd1 vssd1 vccd1 vccd1 _2964_ sky130_fd_sc_hd__o21a_1
X_4919_ _0104_ _0108_ vssd1 vssd1 vccd1 vccd1 _0109_ sky130_fd_sc_hd__xnor2_1
X_5899_ _1085_ _1088_ _1086_ vssd1 vssd1 vccd1 vccd1 _1089_ sky130_fd_sc_hd__a21oi_1
XFILLER_20_150 vssd1 vssd1 vccd1 vccd1 sky130_fd_sc_hd__fill_1
X_7638_ _2888_ _2889_ vssd1 vssd1 vccd1 vccd1 _2891_ sky130_fd_sc_hd__xnor2_1
X_7569_ _2553_ _2557_ _2806_ _2805_ vssd1 vssd1 vccd1 vccd1 _2817_ sky130_fd_sc_hd__a31o_1
XFILLER_4_316 vssd1 vssd1 vccd1 vccd1 sky130_fd_sc_hd__fill_2
XFILLER_0_533 vccd1 vssd1 vccd1 vssd1 sky130_ef_sc_hd__decap_40_12
XFILLER_90_304 vssd1 vssd1 vccd1 vccd1 sky130_fd_sc_hd__fill_4
XANTENNA_input19_A gpio_in[9] vssd1 vssd1 vccd1 vccd1 sky130_fd_sc_hd__diode_2
XFILLER_16_401 vccd1 vssd1 vccd1 vssd1 sky130_ef_sc_hd__decap_40_12
XFILLER_43_231 vssd1 vssd1 vccd1 vccd1 sky130_fd_sc_hd__fill_4
XTAP_TAPCELL_ROW_26_462 vssd1 vccd1 sky130_fd_sc_hd__tapvpwrvgnd_1
XANTENNA__8418__CLK clknet_4_0_0_clk vssd1 vssd1 vccd1 vccd1 sky130_fd_sc_hd__diode_2
XFILLER_7_121 vccd1 vssd1 vccd1 vssd1 sky130_ef_sc_hd__decap_40_12
XFILLER_7_143 vssd1 vssd1 vccd1 vccd1 sky130_fd_sc_hd__fill_1
XFILLER_11_194 vssd1 vssd1 vccd1 vccd1 sky130_fd_sc_hd__fill_1
XANTENNA__5228__B net83 vssd1 vssd1 vccd1 vccd1 sky130_fd_sc_hd__diode_2
XFILLER_7_198 vssd1 vssd1 vccd1 vccd1 sky130_fd_sc_hd__fill_4
XFILLER_3_393 vssd1 vssd1 vccd1 vccd1 sky130_fd_sc_hd__fill_4
XPHY_EDGE_ROW_13_Left_106 vssd1 vssd1 vccd1 vccd1 sky130_fd_sc_hd__decap_3
XFILLER_78_161 vccd1 vssd1 vccd1 vssd1 sky130_ef_sc_hd__decap_40_12
XFILLER_26_209 vssd1 vssd1 vccd1 vccd1 sky130_fd_sc_hd__fill_2
X_6940_ _2039_ _2151_ vssd1 vssd1 vccd1 vccd1 _2152_ sky130_fd_sc_hd__xor2_1
XFILLER_66_389 vssd1 vssd1 vccd1 vccd1 sky130_fd_sc_hd__fill_4
XFILLER_19_283 vssd1 vssd1 vccd1 vccd1 sky130_fd_sc_hd__fill_1
X_6871_ _1770_ _1776_ _1768_ vssd1 vssd1 vccd1 vccd1 _2079_ sky130_fd_sc_hd__a21oi_1
X_5822_ _0975_ _1008_ vssd1 vssd1 vccd1 vccd1 _1012_ sky130_fd_sc_hd__xnor2_1
XTAP_TAPCELL_ROW_52_719 vssd1 vccd1 sky130_fd_sc_hd__tapvpwrvgnd_1
XPHY_EDGE_ROW_22_Left_115 vssd1 vssd1 vccd1 vccd1 sky130_fd_sc_hd__decap_3
XFILLER_22_426 vssd1 vssd1 vccd1 vccd1 sky130_fd_sc_hd__fill_8
XFILLER_34_253 vssd1 vssd1 vccd1 vccd1 sky130_fd_sc_hd__fill_1
X_5753_ _0940_ _0941_ net250 net290 vssd1 vssd1 vccd1 vccd1 _0943_ sky130_fd_sc_hd__and4b_1
X_4704_ net124 net79 vssd1 vssd1 vccd1 vccd1 _3982_ sky130_fd_sc_hd__nand2_1
XTAP_TAPCELL_ROW_60_796 vssd1 vccd1 sky130_fd_sc_hd__tapvpwrvgnd_1
X_5684_ _0870_ _0872_ _0873_ vssd1 vssd1 vccd1 vccd1 _0874_ sky130_fd_sc_hd__nor3_2
X_8472_ clknet_4_10_0_clk _0060_ net340 vssd1 vssd1 vccd1 vccd1 net21 sky130_fd_sc_hd__dfrtp_1
XFILLER_30_470 vssd1 vssd1 vccd1 vccd1 sky130_fd_sc_hd__fill_4
X_7423_ net317 net182 vssd1 vssd1 vccd1 vccd1 _2662_ sky130_fd_sc_hd__nand2_1
XFILLER_8_92 vssd1 vssd1 vccd1 vccd1 sky130_fd_sc_hd__fill_1
X_4635_ _3906_ _3912_ vssd1 vssd1 vccd1 vccd1 _3913_ sky130_fd_sc_hd__nor2_1
X_7354_ _2576_ _2577_ _2589_ vssd1 vssd1 vccd1 vccd1 _2590_ sky130_fd_sc_hd__nand3_1
XANTENNA__7634__A net322 vssd1 vssd1 vccd1 vccd1 sky130_fd_sc_hd__diode_2
XANTENNA_fanout206_A PID_INST.k2_calc.sum_reg\[11\] vssd1 vssd1 vccd1 vccd1 sky130_fd_sc_hd__diode_2
X_4566_ _3811_ _3812_ vssd1 vssd1 vccd1 vccd1 _3844_ sky130_fd_sc_hd__xnor2_1
X_6305_ _1295_ _1492_ vssd1 vssd1 vccd1 vccd1 _1493_ sky130_fd_sc_hd__xor2_1
XPHY_EDGE_ROW_31_Left_124 vssd1 vssd1 vccd1 vccd1 sky130_fd_sc_hd__decap_3
XFILLER_89_437 vssd1 vssd1 vccd1 vccd1 sky130_fd_sc_hd__fill_1
X_4497_ net141 _3761_ _3762_ net78 vssd1 vssd1 vccd1 vccd1 _3775_ sky130_fd_sc_hd__nand4_1
X_7285_ _2451_ _2515_ vssd1 vssd1 vccd1 vccd1 _2517_ sky130_fd_sc_hd__or2_1
X_6236_ _1423_ _1424_ vssd1 vssd1 vccd1 vccd1 _1425_ sky130_fd_sc_hd__nand2_1
XFILLER_76_109 vssd1 vssd1 vccd1 vccd1 sky130_fd_sc_hd__fill_2
XANTENNA_fanout196_X net196 vssd1 vssd1 vccd1 vccd1 sky130_fd_sc_hd__diode_2
X_6167_ _1150_ _1354_ _1353_ vssd1 vssd1 vccd1 vccd1 _1356_ sky130_fd_sc_hd__a21o_1
XFILLER_69_194 vssd1 vssd1 vccd1 vccd1 sky130_fd_sc_hd__fill_1
XFILLER_57_323 vssd1 vssd1 vccd1 vccd1 sky130_fd_sc_hd__fill_1
XFILLER_57_312 vssd1 vssd1 vccd1 vccd1 sky130_fd_sc_hd__fill_2
X_5118_ _4162_ _0307_ vssd1 vssd1 vccd1 vccd1 _0308_ sky130_fd_sc_hd__nand2_1
X_6098_ _1286_ _1287_ vssd1 vssd1 vccd1 vccd1 _1288_ sky130_fd_sc_hd__and2_1
XTAP_TAPCELL_ROW_68_885 vssd1 vccd1 sky130_fd_sc_hd__tapvpwrvgnd_1
X_5049_ net121 _0084_ _0086_ vssd1 vssd1 vccd1 vccd1 _0239_ sky130_fd_sc_hd__and3_1
XPHY_EDGE_ROW_40_Left_133 vssd1 vssd1 vccd1 vccd1 sky130_fd_sc_hd__decap_3
XANTENNA__5549__A2 net219 vssd1 vssd1 vccd1 vccd1 sky130_fd_sc_hd__diode_2
XANTENNA__7809__A net95 vssd1 vssd1 vccd1 vccd1 sky130_fd_sc_hd__diode_2
XFILLER_43_45 vssd1 vssd1 vccd1 vccd1 sky130_fd_sc_hd__fill_2
XTAP_TAPCELL_ROW_23_432 vssd1 vccd1 sky130_fd_sc_hd__tapvpwrvgnd_1
XANTENNA__7263__B net51 vssd1 vssd1 vccd1 vccd1 sky130_fd_sc_hd__diode_2
XTAP_TAPCELL_ROW_91_1114 vssd1 vccd1 sky130_fd_sc_hd__tapvpwrvgnd_1
XFILLER_4_168 vssd1 vssd1 vccd1 vccd1 sky130_fd_sc_hd__fill_4
XANTENNA__5485__A1 net107 vssd1 vssd1 vccd1 vccd1 sky130_fd_sc_hd__diode_2
XFILLER_84_41 vssd1 vssd1 vccd1 vccd1 sky130_fd_sc_hd__fill_8
XANTENNA__5511__B net295 vssd1 vssd1 vccd1 vccd1 sky130_fd_sc_hd__diode_2
XTAP_TAPCELL_ROW_89_1087 vssd1 vccd1 sky130_fd_sc_hd__tapvpwrvgnd_1
XFILLER_84_74 vssd1 vssd1 vccd1 vccd1 sky130_fd_sc_hd__fill_4
XFILLER_84_85 vssd1 vssd1 vccd1 vccd1 sky130_fd_sc_hd__fill_1
XFILLER_16_253 vssd1 vssd1 vccd1 vccd1 sky130_fd_sc_hd__fill_4
XANTENNA__6342__B net78 vssd1 vssd1 vccd1 vccd1 sky130_fd_sc_hd__diode_2
XFILLER_31_278 vssd1 vssd1 vccd1 vccd1 sky130_fd_sc_hd__fill_2
X_4420_ net181 net180 _3700_ net179 vssd1 vssd1 vccd1 vccd1 _3704_ sky130_fd_sc_hd__a31oi_1
XFILLER_8_485 vssd1 vssd1 vccd1 vccd1 sky130_fd_sc_hd__fill_2
X_4351_ net222 _3649_ net161 vssd1 vssd1 vccd1 vccd1 _0039_ sky130_fd_sc_hd__mux2_1
X_7070_ _1952_ _1956_ _2288_ vssd1 vssd1 vccd1 vccd1 _2290_ sky130_fd_sc_hd__and3_1
X_4282_ net17 net427 net157 vssd1 vssd1 vccd1 vccd1 _0005_ sky130_fd_sc_hd__mux2_1
XFILLER_3_190 vccd1 vssd1 vccd1 vssd1 sky130_ef_sc_hd__decap_40_12
XFILLER_86_407 vssd1 vssd1 vccd1 vccd1 sky130_fd_sc_hd__fill_8
X_6021_ _1209_ _1210_ vssd1 vssd1 vccd1 vccd1 _1211_ sky130_fd_sc_hd__xnor2_2
X_7972_ _3217_ _3225_ vssd1 vssd1 vccd1 vccd1 _3227_ sky130_fd_sc_hd__nor2_1
XFILLER_81_156 vccd1 vssd1 vccd1 vssd1 sky130_ef_sc_hd__decap_40_12
XFILLER_81_134 vssd1 vssd1 vccd1 vccd1 sky130_fd_sc_hd__fill_8
XTAP_TAPCELL_ROW_65_855 vssd1 vccd1 sky130_fd_sc_hd__tapvpwrvgnd_1
X_6923_ _2130_ _2132_ vssd1 vssd1 vccd1 vccd1 _2133_ sky130_fd_sc_hd__xnor2_1
XTAP_TAPCELL_ROW_37_568 vssd1 vccd1 sky130_fd_sc_hd__tapvpwrvgnd_1
XANTENNA_fanout156_A _3713_ vssd1 vssd1 vccd1 vccd1 sky130_fd_sc_hd__diode_2
X_6854_ _1757_ _2059_ vssd1 vssd1 vccd1 vccd1 _2061_ sky130_fd_sc_hd__nand2_1
Xfanout38 _2036_ vssd1 vssd1 vccd1 vccd1 net38 sky130_fd_sc_hd__buf_2
XANTENNA__7348__B net195 vssd1 vssd1 vccd1 vccd1 sky130_fd_sc_hd__diode_2
X_5805_ _0952_ _0986_ _0994_ vssd1 vssd1 vccd1 vccd1 _0995_ sky130_fd_sc_hd__and3_1
Xfanout49 net50 vssd1 vssd1 vccd1 vccd1 net49 sky130_fd_sc_hd__clkbuf_2
X_6785_ _1690_ _1751_ _1753_ vssd1 vssd1 vccd1 vccd1 _1988_ sky130_fd_sc_hd__a21bo_1
X_5736_ _0917_ _0925_ _0923_ vssd1 vssd1 vccd1 vccd1 _0926_ sky130_fd_sc_hd__a21oi_1
XFILLER_13_26 vssd1 vssd1 vccd1 vccd1 sky130_fd_sc_hd__fill_1
XTAP_TAPCELL_ROW_20_402 vssd1 vccd1 sky130_fd_sc_hd__tapvpwrvgnd_1
X_8455_ clknet_4_5_0_clk _0043_ net332 vssd1 vssd1 vccd1 vccd1 PID_INST.k2_calc.sum_reg\[11\]
+ sky130_fd_sc_hd__dfrtp_2
X_5667_ _0853_ _0854_ _0766_ vssd1 vssd1 vccd1 vccd1 _0857_ sky130_fd_sc_hd__o21ai_1
X_4618_ net141 net79 _3894_ _3895_ vssd1 vssd1 vccd1 vccd1 _3896_ sky130_fd_sc_hd__nand4_1
XANTENNA_fanout111_X net111 vssd1 vssd1 vccd1 vccd1 sky130_fd_sc_hd__diode_2
X_7406_ _2557_ _2558_ _2643_ vssd1 vssd1 vccd1 vccd1 _2646_ sky130_fd_sc_hd__a21oi_1
XANTENNA__5703__A2 net232 vssd1 vssd1 vccd1 vccd1 sky130_fd_sc_hd__diode_2
XANTENNA_fanout209_X net209 vssd1 vssd1 vccd1 vccd1 sky130_fd_sc_hd__diode_2
X_5598_ _0781_ _0787_ vssd1 vssd1 vccd1 vccd1 _0788_ sky130_fd_sc_hd__nand2_1
X_8386_ clknet_4_9_0_clk PID_INST.k3_calc.d2.y\[6\] net329 vssd1 vssd1 vccd1 vccd1
+ PID_INST.k3_calc.timescaling_term\[6\] sky130_fd_sc_hd__dfrtp_1
X_7337_ _2570_ _2571_ vssd1 vssd1 vccd1 vccd1 _2572_ sky130_fd_sc_hd__xnor2_1
X_4549_ PID_INST.k1_calc.d1.x\[9\] PID_INST.k3_calc.prev_error\[9\] vssd1 vssd1 vccd1
+ vccd1 _3827_ sky130_fd_sc_hd__nand2_1
X_7268_ _2496_ _2497_ vssd1 vssd1 vccd1 vccd1 _2498_ sky130_fd_sc_hd__xnor2_1
XANTENNA__8195__A net286 vssd1 vssd1 vccd1 vccd1 sky130_fd_sc_hd__diode_2
XFILLER_77_407 vssd1 vssd1 vccd1 vccd1 sky130_fd_sc_hd__fill_1
X_6219_ _1406_ _1407_ vssd1 vssd1 vccd1 vccd1 _1408_ sky130_fd_sc_hd__or2_1
X_7199_ _2423_ _2424_ vssd1 vssd1 vccd1 vccd1 _2426_ sky130_fd_sc_hd__xnor2_1
XANTENNA__6427__B net195 vssd1 vssd1 vccd1 vccd1 sky130_fd_sc_hd__diode_2
XFILLER_45_326 vssd1 vssd1 vccd1 vccd1 sky130_fd_sc_hd__fill_1
XANTENNA__5331__B net70 vssd1 vssd1 vccd1 vccd1 sky130_fd_sc_hd__diode_2
XFILLER_72_134 vssd1 vssd1 vccd1 vccd1 sky130_fd_sc_hd__fill_4
XFILLER_45_337 vssd1 vssd1 vccd1 vccd1 sky130_fd_sc_hd__fill_2
XFILLER_72_189 vssd1 vssd1 vccd1 vccd1 sky130_fd_sc_hd__fill_1
XFILLER_72_178 vssd1 vssd1 vccd1 vccd1 sky130_fd_sc_hd__fill_1
XFILLER_60_307 vssd1 vssd1 vccd1 vccd1 sky130_fd_sc_hd__fill_1
XFILLER_54_77 vssd1 vssd1 vccd1 vccd1 sky130_fd_sc_hd__fill_4
XTAP_TAPCELL_ROW_0_193 vssd1 vccd1 sky130_fd_sc_hd__tapvpwrvgnd_1
XFILLER_41_532 vssd1 vssd1 vccd1 vccd1 sky130_fd_sc_hd__fill_4
XFILLER_9_216 vssd1 vssd1 vccd1 vccd1 sky130_fd_sc_hd__fill_1
XFILLER_13_256 vssd1 vssd1 vccd1 vccd1 sky130_fd_sc_hd__fill_2
XFILLER_13_278 vssd1 vssd1 vccd1 vccd1 sky130_fd_sc_hd__fill_2
XFILLER_70_98 vssd1 vssd1 vccd1 vccd1 sky130_fd_sc_hd__fill_1
XTAP_TAPCELL_ROW_8_282 vssd1 vccd1 sky130_fd_sc_hd__tapvpwrvgnd_1
XFILLER_76_473 vssd1 vssd1 vccd1 vccd1 sky130_fd_sc_hd__fill_1
XFILLER_63_167 vssd1 vssd1 vccd1 vccd1 sky130_fd_sc_hd__fill_1
XTAP_TAPCELL_ROW_62_825 vssd1 vccd1 sky130_fd_sc_hd__tapvpwrvgnd_1
XFILLER_51_307 vssd1 vssd1 vccd1 vccd1 sky130_fd_sc_hd__fill_2
XTAP_TAPCELL_ROW_34_538 vssd1 vccd1 sky130_fd_sc_hd__tapvpwrvgnd_1
X_6570_ _1492_ _1755_ vssd1 vssd1 vccd1 vccd1 _1757_ sky130_fd_sc_hd__nand2_1
X_5521_ _0705_ _0710_ vssd1 vssd1 vccd1 vccd1 _0711_ sky130_fd_sc_hd__and2_1
XANTENNA__6499__S net156 vssd1 vssd1 vccd1 vccd1 sky130_fd_sc_hd__diode_2
X_8240_ _3500_ _3508_ vssd1 vssd1 vccd1 vccd1 _3510_ sky130_fd_sc_hd__nor2_1
XANTENNA__7135__A1 net208 vssd1 vssd1 vccd1 vccd1 sky130_fd_sc_hd__diode_2
XANTENNA__7135__B2 net212 vssd1 vssd1 vccd1 vccd1 sky130_fd_sc_hd__diode_2
XANTENNA__6800__B _4033_ vssd1 vssd1 vccd1 vccd1 sky130_fd_sc_hd__diode_2
X_5452_ _0625_ _0641_ vssd1 vssd1 vccd1 vccd1 _0642_ sky130_fd_sc_hd__nor2_1
XANTENNA__5146__B1 net70 vssd1 vssd1 vccd1 vccd1 sky130_fd_sc_hd__diode_2
XANTENNA__7334__D net254 vssd1 vssd1 vccd1 vccd1 sky130_fd_sc_hd__diode_2
X_4403_ _3690_ _3693_ vssd1 vssd1 vccd1 vccd1 _3694_ sky130_fd_sc_hd__xnor2_1
X_5383_ _0567_ _0572_ vssd1 vssd1 vccd1 vccd1 _0573_ sky130_fd_sc_hd__nor2_1
X_8171_ net92 net44 vssd1 vssd1 vccd1 vccd1 _3436_ sky130_fd_sc_hd__nor2_1
X_7122_ _2333_ _2341_ vssd1 vssd1 vccd1 vccd1 _2343_ sky130_fd_sc_hd__xnor2_1
X_4334_ net233 _3547_ net161 vssd1 vssd1 vccd1 vccd1 _0036_ sky130_fd_sc_hd__mux2_1
XFILLER_5_60 vssd1 vssd1 vccd1 vccd1 sky130_fd_sc_hd__fill_8
X_7053_ _2270_ _2271_ vssd1 vssd1 vccd1 vccd1 _2272_ sky130_fd_sc_hd__xnor2_1
XFILLER_86_204 vssd1 vssd1 vccd1 vccd1 sky130_fd_sc_hd__fill_1
Xfanout217 PID_INST.k2_calc.sum_reg\[9\] vssd1 vssd1 vccd1 vccd1 net217 sky130_fd_sc_hd__buf_2
Xfanout206 PID_INST.k2_calc.sum_reg\[11\] vssd1 vssd1 vccd1 vccd1 net206 sky130_fd_sc_hd__clkbuf_2
Xfanout228 net229 vssd1 vssd1 vccd1 vccd1 net228 sky130_fd_sc_hd__buf_2
Xfanout239 PID_INST.k2_calc.sum_reg\[3\] vssd1 vssd1 vccd1 vccd1 net239 sky130_fd_sc_hd__buf_2
X_4265_ PID_INST.pid.curr_state\[0\] PID_INST.pid.curr_state\[1\] vssd1 vssd1 vccd1
+ vccd1 _2845_ sky130_fd_sc_hd__or2_1
X_6004_ _0546_ _0547_ net105 vssd1 vssd1 vccd1 vccd1 _1194_ sky130_fd_sc_hd__a21oi_1
XANTENNA_clkload10_A clknet_4_11_0_clk vssd1 vssd1 vccd1 vccd1 sky130_fd_sc_hd__diode_2
XFILLER_86_259 vssd1 vssd1 vccd1 vccd1 sky130_fd_sc_hd__fill_2
X_4196_ net18 net174 _2104_ vssd1 vssd1 vccd1 vccd1 _2114_ sky130_fd_sc_hd__o21ai_4
XFILLER_82_410 vssd1 vssd1 vccd1 vccd1 sky130_fd_sc_hd__fill_1
XTAP_TAPCELL_ROW_78_980 vssd1 vccd1 sky130_fd_sc_hd__tapvpwrvgnd_1
XANTENNA_fanout273_A net275 vssd1 vssd1 vccd1 vccd1 sky130_fd_sc_hd__diode_2
XFILLER_82_421 vccd1 vssd1 vccd1 vssd1 sky130_ef_sc_hd__decap_40_12
XFILLER_27_337 vssd1 vssd1 vccd1 vccd1 sky130_fd_sc_hd__fill_4
XFILLER_39_197 vssd1 vssd1 vccd1 vccd1 sky130_fd_sc_hd__fill_1
X_7955_ _2990_ _3003_ _3209_ vssd1 vssd1 vccd1 vccd1 _3210_ sky130_fd_sc_hd__a21oi_2
XFILLER_82_498 vssd1 vssd1 vccd1 vccd1 sky130_fd_sc_hd__fill_4
XANTENNA_fanout159_X net159 vssd1 vssd1 vccd1 vccd1 sky130_fd_sc_hd__diode_2
X_7886_ _3139_ _3140_ vssd1 vssd1 vccd1 vccd1 _3141_ sky130_fd_sc_hd__nor2_1
XFILLER_23_510 vssd1 vssd1 vccd1 vccd1 sky130_fd_sc_hd__fill_2
X_6906_ _1990_ _2048_ _2050_ vssd1 vssd1 vccd1 vccd1 _2116_ sky130_fd_sc_hd__a21bo_1
XFILLER_42_329 vssd1 vssd1 vccd1 vccd1 sky130_fd_sc_hd__fill_2
X_6837_ net105 _1742_ _2042_ vssd1 vssd1 vccd1 vccd1 _2043_ sky130_fd_sc_hd__or3_1
XFILLER_50_362 vssd1 vssd1 vccd1 vccd1 sky130_fd_sc_hd__fill_2
X_6768_ _1967_ _1968_ vssd1 vssd1 vccd1 vccd1 _1969_ sky130_fd_sc_hd__nor2_1
XFILLER_50_395 vssd1 vssd1 vccd1 vccd1 sky130_fd_sc_hd__fill_8
XANTENNA__5607__A net314 vssd1 vssd1 vccd1 vccd1 sky130_fd_sc_hd__diode_2
X_5719_ net249 net283 net295 net239 vssd1 vssd1 vccd1 vccd1 _0909_ sky130_fd_sc_hd__a22oi_1
XFILLER_6_219 vccd1 vssd1 vccd1 vssd1 sky130_ef_sc_hd__decap_40_12
X_6699_ _1809_ _1895_ vssd1 vssd1 vccd1 vccd1 _1897_ sky130_fd_sc_hd__xor2_1
X_8438_ clknet_4_5_0_clk net408 net333 vssd1 vssd1 vccd1 vccd1 PID_INST.k3_calc.prev_error\[10\]
+ sky130_fd_sc_hd__dfrtp_1
X_8369_ clknet_4_1_0_clk _0005_ net326 vssd1 vssd1 vccd1 vccd1 PID_INST.k1_calc.d1.x\[5\]
+ sky130_fd_sc_hd__dfrtp_1
XANTENNA__4896__C1 _4099_ vssd1 vssd1 vccd1 vccd1 sky130_fd_sc_hd__diode_2
XANTENNA__7822__A net110 vssd1 vssd1 vccd1 vccd1 sky130_fd_sc_hd__diode_2
XFILLER_2_458 vccd1 vssd1 vccd1 vssd1 sky130_ef_sc_hd__decap_40_12
XANTENNA__6438__A net215 vssd1 vssd1 vccd1 vccd1 sky130_fd_sc_hd__diode_2
XTAP_TAPCELL_ROW_5_252 vssd1 vccd1 sky130_fd_sc_hd__tapvpwrvgnd_1
XFILLER_18_337 vccd1 vssd1 vccd1 vssd1 sky130_ef_sc_hd__decap_40_12
XTAP_TAPCELL_ROW_86_1057 vssd1 vccd1 sky130_fd_sc_hd__tapvpwrvgnd_1
XFILLER_14_565 vssd1 vssd1 vccd1 vccd1 sky130_fd_sc_hd__fill_4
XTAP_TAPCELL_ROW_31_508 vssd1 vccd1 sky130_fd_sc_hd__tapvpwrvgnd_1
XFILLER_41_362 vssd1 vssd1 vccd1 vccd1 sky130_fd_sc_hd__fill_1
XFILLER_81_97 vssd1 vssd1 vccd1 vccd1 sky130_fd_sc_hd__fill_1
XFILLER_5_252 vssd1 vssd1 vccd1 vccd1 sky130_fd_sc_hd__fill_2
XANTENNA__5552__A1_N net291 vssd1 vssd1 vccd1 vccd1 sky130_fd_sc_hd__diode_2
XFILLER_64_410 vssd1 vssd1 vccd1 vccd1 sky130_fd_sc_hd__fill_8
Xinput6 gpio_in[13] vssd1 vssd1 vccd1 vccd1 net6 sky130_fd_sc_hd__buf_2
XFILLER_36_101 vssd1 vssd1 vccd1 vccd1 sky130_fd_sc_hd__fill_2
XFILLER_36_112 vssd1 vssd1 vccd1 vccd1 sky130_fd_sc_hd__fill_1
XFILLER_36_134 vssd1 vssd1 vccd1 vccd1 sky130_fd_sc_hd__fill_1
XTAP_TAPCELL_ROW_75_950 vssd1 vccd1 sky130_fd_sc_hd__tapvpwrvgnd_1
XTAP_TAPCELL_ROW_47_674 vssd1 vccd1 sky130_fd_sc_hd__tapvpwrvgnd_1
XANTENNA__7179__A PID_INST.k3_calc.d2.y\[2\] vssd1 vssd1 vccd1 vccd1 sky130_fd_sc_hd__diode_2
X_7740_ _2994_ _2995_ vssd1 vssd1 vccd1 vccd1 _2996_ sky130_fd_sc_hd__nor2_1
X_4952_ _0078_ _0141_ vssd1 vssd1 vccd1 vccd1 _0142_ sky130_fd_sc_hd__xnor2_2
XTAP_TAPCELL_ROW_19_387 vssd1 vccd1 sky130_fd_sc_hd__tapvpwrvgnd_1
X_7671_ _2923_ _2924_ vssd1 vssd1 vccd1 vccd1 _2925_ sky130_fd_sc_hd__xor2_1
X_4883_ _3965_ _4160_ vssd1 vssd1 vccd1 vccd1 _4161_ sky130_fd_sc_hd__xnor2_1
X_6622_ _1812_ _1813_ vssd1 vssd1 vccd1 vccd1 _1814_ sky130_fd_sc_hd__xnor2_1
XANTENNA__6530__B _0087_ vssd1 vssd1 vccd1 vccd1 sky130_fd_sc_hd__diode_2
X_6553_ _1578_ _1581_ _1738_ vssd1 vssd1 vccd1 vccd1 _1740_ sky130_fd_sc_hd__a21o_1
XANTENNA__7345__C net190 vssd1 vssd1 vccd1 vccd1 sky130_fd_sc_hd__diode_2
X_5504_ net290 net239 _0690_ _0692_ vssd1 vssd1 vccd1 vccd1 _0694_ sky130_fd_sc_hd__o2bb2a_1
X_6484_ _1463_ _1471_ vssd1 vssd1 vccd1 vccd1 _1672_ sky130_fd_sc_hd__nand2_1
XANTENNA__5427__A net103 vssd1 vssd1 vccd1 vccd1 sky130_fd_sc_hd__diode_2
X_8223_ _3487_ _3488_ _3489_ vssd1 vssd1 vccd1 vccd1 _3491_ sky130_fd_sc_hd__o21ai_1
X_5435_ _0622_ _0623_ vssd1 vssd1 vccd1 vccd1 _0625_ sky130_fd_sc_hd__xnor2_1
XANTENNA_fanout119_A _2274_ vssd1 vssd1 vccd1 vccd1 sky130_fd_sc_hd__diode_2
XANTENNA__7642__A net317 vssd1 vssd1 vccd1 vccd1 sky130_fd_sc_hd__diode_2
XFILLER_10_38 vssd1 vssd1 vccd1 vccd1 sky130_fd_sc_hd__fill_2
XANTENNA__7361__B net213 vssd1 vssd1 vccd1 vccd1 sky130_fd_sc_hd__diode_2
X_5366_ _0552_ _0555_ vssd1 vssd1 vccd1 vccd1 _0556_ sky130_fd_sc_hd__xnor2_1
XANTENNA__4893__A2 _4099_ vssd1 vssd1 vccd1 vccd1 sky130_fd_sc_hd__diode_2
X_8154_ _3131_ _3282_ _3283_ _3284_ vssd1 vssd1 vccd1 vccd1 _3417_ sky130_fd_sc_hd__o2bb2ai_1
XFILLER_87_535 vccd1 vssd1 vccd1 vssd1 sky130_ef_sc_hd__decap_40_12
X_8085_ _3342_ net183 net293 _3339_ vssd1 vssd1 vccd1 vccd1 _3344_ sky130_fd_sc_hd__and4b_1
X_7105_ net320 net186 vssd1 vssd1 vccd1 vccd1 _2326_ sky130_fd_sc_hd__nand2_1
X_4317_ net241 net14 vssd1 vssd1 vccd1 vccd1 _3375_ sky130_fd_sc_hd__or2_1
X_5297_ _0356_ _0406_ _0410_ vssd1 vssd1 vccd1 vccd1 _0487_ sky130_fd_sc_hd__o21ba_1
X_7036_ _2245_ _2253_ vssd1 vssd1 vccd1 vccd1 _2254_ sky130_fd_sc_hd__nand2b_1
XFILLER_19_14 vssd1 vssd1 vccd1 vccd1 sky130_fd_sc_hd__fill_2
XFILLER_19_47 vssd1 vssd1 vccd1 vccd1 sky130_fd_sc_hd__fill_4
X_4248_ PID_INST.k3_calc.timescaling_term\[12\] net169 vssd1 vssd1 vccd1 vccd1 _2664_
+ sky130_fd_sc_hd__or2_1
XTAP_TAPCELL_ROW_2_222 vssd1 vccd1 sky130_fd_sc_hd__tapvpwrvgnd_1
XFILLER_67_281 vccd1 vssd1 vccd1 vssd1 sky130_ef_sc_hd__decap_40_12
XANTENNA_fanout276_X net276 vssd1 vssd1 vccd1 vccd1 sky130_fd_sc_hd__diode_2
XFILLER_27_134 vssd1 vssd1 vccd1 vccd1 sky130_fd_sc_hd__fill_1
X_4179_ _1923_ vssd1 vssd1 vccd1 vccd1 PID_INST.k3_calc.d1.y\[12\] sky130_fd_sc_hd__inv_2
XFILLER_82_262 vccd1 vssd1 vccd1 vssd1 sky130_ef_sc_hd__decap_40_12
XFILLER_82_251 vssd1 vssd1 vccd1 vccd1 sky130_fd_sc_hd__fill_1
XFILLER_27_167 vssd1 vssd1 vccd1 vccd1 sky130_fd_sc_hd__fill_1
XFILLER_35_13 vssd1 vssd1 vccd1 vccd1 sky130_fd_sc_hd__fill_1
XFILLER_82_295 vssd1 vssd1 vccd1 vccd1 sky130_fd_sc_hd__fill_1
X_7938_ _3191_ _3192_ vssd1 vssd1 vccd1 vccd1 _3193_ sky130_fd_sc_hd__nand2_1
XFILLER_27_178 vssd1 vssd1 vccd1 vccd1 sky130_fd_sc_hd__fill_1
XFILLER_35_57 vssd1 vssd1 vccd1 vccd1 sky130_fd_sc_hd__fill_1
XFILLER_70_468 vssd1 vssd1 vccd1 vccd1 sky130_fd_sc_hd__fill_1
XFILLER_42_159 vssd1 vssd1 vccd1 vccd1 sky130_fd_sc_hd__fill_8
X_7869_ net90 net51 net48 net91 vssd1 vssd1 vccd1 vccd1 _3124_ sky130_fd_sc_hd__o22a_1
XFILLER_11_557 vssd1 vssd1 vccd1 vccd1 sky130_fd_sc_hd__fill_2
XPHY_EDGE_ROW_14_Right_14 vssd1 vssd1 vccd1 vccd1 sky130_fd_sc_hd__decap_3
XFILLER_11_568 vssd1 vssd1 vccd1 vccd1 sky130_fd_sc_hd__fill_2
XANTENNA__4241__A net101 vssd1 vssd1 vccd1 vccd1 sky130_fd_sc_hd__diode_2
XFILLER_2_222 vssd1 vssd1 vccd1 vccd1 sky130_fd_sc_hd__fill_2
XFILLER_2_255 vssd1 vssd1 vccd1 vccd1 sky130_fd_sc_hd__fill_2
XPHY_EDGE_ROW_23_Right_23 vssd1 vssd1 vccd1 vccd1 sky130_fd_sc_hd__decap_3
XFILLER_46_421 vccd1 vssd1 vccd1 vssd1 sky130_ef_sc_hd__decap_40_12
XFILLER_18_123 vssd1 vssd1 vccd1 vccd1 sky130_fd_sc_hd__fill_2
XFILLER_73_251 vssd1 vssd1 vccd1 vccd1 sky130_fd_sc_hd__fill_1
XFILLER_46_465 vssd1 vssd1 vccd1 vccd1 sky130_fd_sc_hd__fill_2
XFILLER_92_41 vccd1 vssd1 vccd1 vssd1 sky130_ef_sc_hd__decap_40_12
XANTENNA__5597__B1 _0786_ vssd1 vssd1 vccd1 vccd1 sky130_fd_sc_hd__diode_2
XTAP_TAPCELL_ROW_72_920 vssd1 vccd1 sky130_fd_sc_hd__tapvpwrvgnd_1
XFILLER_46_487 vssd1 vssd1 vccd1 vccd1 sky130_fd_sc_hd__fill_2
XFILLER_18_178 vssd1 vssd1 vccd1 vccd1 sky130_fd_sc_hd__fill_2
XFILLER_92_85 vccd1 vssd1 vccd1 vssd1 sky130_ef_sc_hd__decap_40_12
XTAP_TAPCELL_ROW_44_644 vssd1 vccd1 sky130_fd_sc_hd__tapvpwrvgnd_1
XTAP_TAPCELL_ROW_16_357 vssd1 vccd1 sky130_fd_sc_hd__tapvpwrvgnd_1
XPHY_EDGE_ROW_32_Right_32 vssd1 vssd1 vccd1 vccd1 sky130_fd_sc_hd__decap_3
XANTENNA__7727__A net214 vssd1 vssd1 vccd1 vccd1 sky130_fd_sc_hd__diode_2
X_5220_ net166 net87 _0409_ vssd1 vssd1 vccd1 vccd1 _0410_ sky130_fd_sc_hd__and3_1
XPHY_EDGE_ROW_41_Right_41 vssd1 vssd1 vccd1 vccd1 sky130_fd_sc_hd__decap_3
X_5151_ _0339_ _0340_ vssd1 vssd1 vccd1 vccd1 _0341_ sky130_fd_sc_hd__xnor2_1
XFILLER_69_568 vssd1 vssd1 vccd1 vccd1 sky130_fd_sc_hd__fill_2
X_5082_ _0266_ _0271_ vssd1 vssd1 vccd1 vccd1 _0272_ sky130_fd_sc_hd__nor2_1
XFILLER_2_83 vssd1 vssd1 vccd1 vccd1 sky130_fd_sc_hd__fill_1
XFILLER_64_251 vssd1 vssd1 vccd1 vccd1 sky130_fd_sc_hd__fill_1
XANTENNA__4326__A net159 vssd1 vssd1 vccd1 vccd1 sky130_fd_sc_hd__diode_2
XPHY_EDGE_ROW_50_Right_50 vssd1 vssd1 vccd1 vccd1 sky130_fd_sc_hd__decap_3
XFILLER_24_115 vssd1 vssd1 vccd1 vccd1 sky130_fd_sc_hd__fill_1
XFILLER_37_498 vssd1 vssd1 vccd1 vccd1 sky130_fd_sc_hd__fill_4
X_7723_ _2884_ _2886_ _2883_ vssd1 vssd1 vccd1 vccd1 _2979_ sky130_fd_sc_hd__o21ba_1
XFILLER_24_137 vssd1 vssd1 vccd1 vccd1 sky130_fd_sc_hd__fill_2
X_5984_ _1173_ _1159_ vssd1 vssd1 vccd1 vccd1 _1174_ sky130_fd_sc_hd__nand2b_1
X_4935_ net133 net84 vssd1 vssd1 vccd1 vccd1 _0125_ sky130_fd_sc_hd__nand2_1
X_7654_ net293 net189 vssd1 vssd1 vccd1 vccd1 _2907_ sky130_fd_sc_hd__nand2_1
XANTENNA_fanout236_A PID_INST.k2_calc.sum_reg\[4\] vssd1 vssd1 vccd1 vccd1 sky130_fd_sc_hd__diode_2
X_4866_ _4123_ _4142_ vssd1 vssd1 vccd1 vccd1 _4144_ sky130_fd_sc_hd__and2_1
XANTENNA__8474__CLK clknet_4_10_0_clk vssd1 vssd1 vccd1 vccd1 sky130_fd_sc_hd__diode_2
XANTENNA__6260__B net295 vssd1 vssd1 vccd1 vccd1 sky130_fd_sc_hd__diode_2
X_4797_ _3981_ _3986_ _3980_ vssd1 vssd1 vccd1 vccd1 _4075_ sky130_fd_sc_hd__o21ai_1
X_7585_ _2832_ _2833_ vssd1 vssd1 vccd1 vccd1 _2835_ sky130_fd_sc_hd__nor2_1
X_6605_ _1793_ _1794_ vssd1 vssd1 vccd1 vccd1 _1796_ sky130_fd_sc_hd__and2b_1
X_6536_ _1721_ _1722_ vssd1 vssd1 vccd1 vccd1 _1723_ sky130_fd_sc_hd__nand2_1
XFILLER_20_387 vssd1 vssd1 vccd1 vccd1 sky130_fd_sc_hd__fill_2
XFILLER_21_37 vssd1 vssd1 vccd1 vccd1 sky130_fd_sc_hd__fill_1
XFILLER_21_48 vssd1 vssd1 vccd1 vccd1 sky130_fd_sc_hd__fill_1
X_6467_ _1434_ _1653_ vssd1 vssd1 vccd1 vccd1 _1655_ sky130_fd_sc_hd__nand2_1
X_8206_ net294 net180 vssd1 vssd1 vccd1 vccd1 _3474_ sky130_fd_sc_hd__nand2_1
X_5418_ net115 net63 vssd1 vssd1 vccd1 vccd1 _0608_ sky130_fd_sc_hd__nor2_1
X_6398_ _1193_ _1585_ vssd1 vssd1 vccd1 vccd1 _1586_ sky130_fd_sc_hd__nand2_1
X_8137_ _3396_ _3398_ vssd1 vssd1 vccd1 vccd1 _3400_ sky130_fd_sc_hd__xnor2_1
XFILLER_87_310 vssd1 vssd1 vccd1 vccd1 sky130_fd_sc_hd__fill_4
X_5349_ _0536_ _0537_ vssd1 vssd1 vccd1 vccd1 _0539_ sky130_fd_sc_hd__xnor2_1
X_8068_ _3322_ _3323_ vssd1 vssd1 vccd1 vccd1 _3325_ sky130_fd_sc_hd__xnor2_1
X_7019_ _2234_ _2235_ vssd1 vssd1 vccd1 vccd1 _2236_ sky130_fd_sc_hd__nor2_1
XANTENNA__7017__B1 net254 vssd1 vssd1 vccd1 vccd1 sky130_fd_sc_hd__diode_2
XANTENNA__6435__B net207 vssd1 vssd1 vccd1 vccd1 sky130_fd_sc_hd__diode_2
XTAP_TAPCELL_ROW_83_1027 vssd1 vccd1 sky130_fd_sc_hd__tapvpwrvgnd_1
XFILLER_43_424 vccd1 vssd1 vccd1 vssd1 sky130_ef_sc_hd__decap_40_12
Xmax_cap57 _0223_ vssd1 vssd1 vccd1 vccd1 net57 sky130_fd_sc_hd__buf_1
XANTENNA__6240__A1 net203 vssd1 vssd1 vccd1 vccd1 sky130_fd_sc_hd__diode_2
XANTENNA__8473__RESET_B net340 vssd1 vssd1 vccd1 vccd1 sky130_fd_sc_hd__diode_2
XANTENNA__6791__A2 _0088_ vssd1 vssd1 vccd1 vccd1 sky130_fd_sc_hd__diode_2
XTAP_TAPCELL_ROW_41_614 vssd1 vccd1 sky130_fd_sc_hd__tapvpwrvgnd_1
XFILLER_62_77 vssd1 vssd1 vccd1 vccd1 sky130_fd_sc_hd__fill_2
XTAP_TAPCELL_ROW_13_327 vssd1 vccd1 sky130_fd_sc_hd__tapvpwrvgnd_1
XFILLER_23_181 vssd1 vssd1 vccd1 vccd1 sky130_fd_sc_hd__fill_2
XANTENNA__4306__A1 net8 vssd1 vssd1 vccd1 vccd1 sky130_fd_sc_hd__diode_2
XFILLER_11_70 vssd1 vssd1 vccd1 vccd1 sky130_fd_sc_hd__fill_1
XFILLER_11_92 vssd1 vssd1 vccd1 vccd1 sky130_fd_sc_hd__fill_2
XFILLER_87_52 vssd1 vssd1 vccd1 vccd1 sky130_fd_sc_hd__fill_4
XFILLER_78_354 vssd1 vssd1 vccd1 vccd1 sky130_fd_sc_hd__fill_8
XFILLER_78_321 vssd1 vssd1 vccd1 vccd1 sky130_fd_sc_hd__fill_2
XFILLER_66_527 vssd1 vssd1 vccd1 vccd1 sky130_fd_sc_hd__fill_4
XFILLER_19_465 vccd1 vssd1 vccd1 vssd1 sky130_ef_sc_hd__decap_40_12
XFILLER_46_284 vssd1 vssd1 vccd1 vccd1 sky130_fd_sc_hd__fill_1
XANTENNA__6231__A1 net200 vssd1 vssd1 vccd1 vccd1 sky130_fd_sc_hd__diode_2
XFILLER_46_295 vccd1 vssd1 vccd1 vssd1 sky130_ef_sc_hd__decap_40_12
XTAP_TAPCELL_ROW_29_493 vssd1 vccd1 sky130_fd_sc_hd__tapvpwrvgnd_1
XFILLER_34_446 vccd1 vssd1 vccd1 vssd1 sky130_ef_sc_hd__decap_40_12
X_4720_ _3995_ _3996_ vssd1 vssd1 vccd1 vccd1 _3998_ sky130_fd_sc_hd__xnor2_1
XFILLER_42_490 vssd1 vssd1 vccd1 vccd1 sky130_fd_sc_hd__fill_2
X_4651_ _3918_ _3928_ vssd1 vssd1 vccd1 vccd1 _3929_ sky130_fd_sc_hd__or2_1
Xinput20 nrst vssd1 vssd1 vccd1 vccd1 net20 sky130_fd_sc_hd__clkbuf_1
X_7370_ _2358_ _2360_ _2356_ vssd1 vssd1 vccd1 vccd1 _2607_ sky130_fd_sc_hd__o21ba_1
X_4582_ _3775_ _3854_ _3853_ vssd1 vssd1 vccd1 vccd1 _3860_ sky130_fd_sc_hd__a21oi_1
X_6321_ _1506_ _1507_ vssd1 vssd1 vccd1 vccd1 _1509_ sky130_fd_sc_hd__nand2_1
X_6252_ net235 net273 net261 net246 vssd1 vssd1 vccd1 vccd1 _1441_ sky130_fd_sc_hd__a22o_1
XANTENNA__6298__A1 _1102_ vssd1 vssd1 vccd1 vccd1 sky130_fd_sc_hd__diode_2
XANTENNA__6300__S net156 vssd1 vssd1 vccd1 vccd1 sky130_fd_sc_hd__diode_2
X_5203_ _0288_ _0289_ _0291_ _0292_ _0247_ vssd1 vssd1 vccd1 vccd1 _0393_ sky130_fd_sc_hd__a32oi_2
X_6183_ _1369_ _1370_ vssd1 vssd1 vccd1 vccd1 _1372_ sky130_fd_sc_hd__xnor2_1
XFILLER_69_332 vssd1 vssd1 vccd1 vccd1 sky130_fd_sc_hd__fill_4
X_5134_ _0322_ _0323_ vssd1 vssd1 vccd1 vccd1 _0324_ sky130_fd_sc_hd__xnor2_1
XFILLER_69_376 vssd1 vssd1 vccd1 vccd1 sky130_fd_sc_hd__fill_8
XFILLER_57_527 vssd1 vssd1 vccd1 vccd1 sky130_fd_sc_hd__fill_2
XFILLER_57_538 vssd1 vssd1 vccd1 vccd1 sky130_fd_sc_hd__fill_1
X_5065_ _0249_ _0254_ vssd1 vssd1 vccd1 vccd1 _0255_ sky130_fd_sc_hd__nand2_1
XFILLER_25_424 vssd1 vssd1 vccd1 vccd1 sky130_fd_sc_hd__fill_1
XFILLER_25_446 vssd1 vssd1 vccd1 vccd1 sky130_fd_sc_hd__fill_2
XFILLER_25_479 vssd1 vssd1 vccd1 vccd1 sky130_fd_sc_hd__fill_4
X_5967_ _1156_ _1155_ vssd1 vssd1 vccd1 vccd1 _1157_ sky130_fd_sc_hd__nand2b_1
XFILLER_40_416 vssd1 vssd1 vccd1 vccd1 sky130_fd_sc_hd__fill_4
X_7706_ _2959_ _2960_ _2962_ vssd1 vssd1 vccd1 vccd1 _2963_ sky130_fd_sc_hd__nor3_1
XANTENNA_fanout239_X net239 vssd1 vssd1 vccd1 vccd1 sky130_fd_sc_hd__diode_2
X_4918_ _0106_ _0107_ vssd1 vssd1 vccd1 vccd1 _0108_ sky130_fd_sc_hd__nor2_1
X_7637_ _2889_ _2888_ vssd1 vssd1 vccd1 vccd1 _2890_ sky130_fd_sc_hd__nand2b_1
X_5898_ _0734_ _1082_ _1087_ vssd1 vssd1 vccd1 vccd1 _1088_ sky130_fd_sc_hd__a21bo_1
XFILLER_32_25 vssd1 vssd1 vccd1 vccd1 sky130_fd_sc_hd__fill_1
X_4849_ _4054_ _4125_ vssd1 vssd1 vccd1 vccd1 _4127_ sky130_fd_sc_hd__nand2_1
X_7568_ _2648_ _2649_ _2811_ _2815_ _2810_ vssd1 vssd1 vccd1 vccd1 _2816_ sky130_fd_sc_hd__o311ai_4
XFILLER_20_195 vssd1 vssd1 vccd1 vccd1 sky130_fd_sc_hd__fill_1
X_6519_ net149 net72 _3999_ net138 vssd1 vssd1 vccd1 vccd1 _1706_ sky130_fd_sc_hd__a2bb2o_1
XFILLER_4_339 vssd1 vssd1 vccd1 vccd1 sky130_fd_sc_hd__fill_8
X_7499_ _2743_ vssd1 vssd1 vccd1 vccd1 _2744_ sky130_fd_sc_hd__inv_2
XFILLER_0_501 vssd1 vssd1 vccd1 vccd1 sky130_fd_sc_hd__fill_2
XANTENNA_fanout99_A net100 vssd1 vssd1 vccd1 vccd1 sky130_fd_sc_hd__diode_2
XFILLER_0_545 vssd1 vssd1 vccd1 vccd1 sky130_fd_sc_hd__fill_4
XFILLER_87_151 vssd1 vssd1 vccd1 vccd1 sky130_fd_sc_hd__fill_1
XFILLER_75_335 vssd1 vssd1 vccd1 vccd1 sky130_fd_sc_hd__fill_1
XFILLER_57_55 vssd1 vssd1 vccd1 vccd1 sky130_fd_sc_hd__fill_1
XFILLER_48_538 vssd1 vssd1 vccd1 vccd1 sky130_fd_sc_hd__fill_4
XFILLER_16_413 vssd1 vssd1 vccd1 vccd1 sky130_fd_sc_hd__fill_4
XFILLER_71_552 vssd1 vssd1 vccd1 vccd1 sky130_fd_sc_hd__fill_8
XFILLER_71_541 vssd1 vssd1 vccd1 vccd1 sky130_fd_sc_hd__fill_1
XFILLER_71_530 vssd1 vssd1 vccd1 vccd1 sky130_fd_sc_hd__fill_2
XANTENNA__5500__D net232 vssd1 vssd1 vccd1 vccd1 sky130_fd_sc_hd__diode_2
XFILLER_16_435 vssd1 vssd1 vccd1 vccd1 sky130_fd_sc_hd__fill_8
XFILLER_16_457 vccd1 vssd1 vccd1 vssd1 sky130_ef_sc_hd__decap_40_12
XTAP_TAPCELL_ROW_26_463 vssd1 vccd1 sky130_fd_sc_hd__tapvpwrvgnd_1
XFILLER_31_405 vssd1 vssd1 vccd1 vccd1 sky130_fd_sc_hd__fill_4
XFILLER_43_265 vssd1 vssd1 vccd1 vccd1 sky130_fd_sc_hd__fill_2
XANTENNA__5972__B1 _0088_ vssd1 vssd1 vccd1 vccd1 sky130_fd_sc_hd__diode_2
XANTENNA__6181__A net129 vssd1 vssd1 vccd1 vccd1 sky130_fd_sc_hd__diode_2
XANTENNA__4413__B net183 vssd1 vssd1 vccd1 vccd1 sky130_fd_sc_hd__diode_2
XFILLER_7_100 vccd1 vssd1 vccd1 vssd1 sky130_ef_sc_hd__decap_40_12
XFILLER_7_155 vssd1 vssd1 vccd1 vccd1 sky130_fd_sc_hd__fill_1
XFILLER_7_133 vssd1 vssd1 vccd1 vccd1 sky130_fd_sc_hd__fill_1
XFILLER_22_80 vssd1 vssd1 vccd1 vccd1 sky130_fd_sc_hd__fill_1
XFILLER_39_505 vccd1 vssd1 vccd1 vssd1 sky130_ef_sc_hd__decap_40_12
XFILLER_78_173 vssd1 vssd1 vccd1 vccd1 sky130_fd_sc_hd__fill_4
XFILLER_81_305 vssd1 vssd1 vccd1 vccd1 sky130_fd_sc_hd__fill_4
XFILLER_66_379 vssd1 vssd1 vccd1 vccd1 sky130_fd_sc_hd__fill_8
XFILLER_66_368 vssd1 vssd1 vccd1 vccd1 sky130_fd_sc_hd__fill_4
XFILLER_66_357 vssd1 vssd1 vccd1 vccd1 sky130_fd_sc_hd__fill_1
XFILLER_54_519 vssd1 vssd1 vccd1 vccd1 sky130_fd_sc_hd__fill_2
XFILLER_19_240 vssd1 vssd1 vccd1 vccd1 sky130_fd_sc_hd__fill_4
X_6870_ _2071_ _2077_ vssd1 vssd1 vccd1 vccd1 _2078_ sky130_fd_sc_hd__xnor2_1
XFILLER_34_221 vssd1 vssd1 vccd1 vccd1 sky130_fd_sc_hd__fill_4
XFILLER_62_563 vssd1 vssd1 vccd1 vccd1 sky130_fd_sc_hd__fill_1
X_5821_ _1009_ _1010_ vssd1 vssd1 vccd1 vccd1 _1011_ sky130_fd_sc_hd__nor2_1
X_5752_ _0941_ vssd1 vssd1 vccd1 vccd1 _0942_ sky130_fd_sc_hd__inv_2
X_4703_ _3978_ _3979_ vssd1 vssd1 vccd1 vccd1 _3981_ sky130_fd_sc_hd__xnor2_1
X_8471_ clknet_4_7_0_clk _0059_ net334 vssd1 vssd1 vccd1 vccd1 PID_INST.k2_calc.sum_reg\[27\]
+ sky130_fd_sc_hd__dfrtp_1
X_5683_ _0859_ _0864_ _0869_ vssd1 vssd1 vccd1 vccd1 _0873_ sky130_fd_sc_hd__and3_1
XTAP_TAPCELL_ROW_60_797 vssd1 vccd1 sky130_fd_sc_hd__tapvpwrvgnd_1
X_7422_ _2659_ _2660_ vssd1 vssd1 vccd1 vccd1 _2661_ sky130_fd_sc_hd__nor2_1
XFILLER_8_71 vssd1 vssd1 vccd1 vccd1 sky130_fd_sc_hd__fill_1
X_4634_ net120 net88 _3734_ net147 vssd1 vssd1 vccd1 vccd1 _3912_ sky130_fd_sc_hd__o2bb2a_1
X_7353_ _2578_ _2587_ vssd1 vssd1 vccd1 vccd1 _2589_ sky130_fd_sc_hd__xnor2_1
X_4565_ _3815_ _3820_ vssd1 vssd1 vccd1 vccd1 _3843_ sky130_fd_sc_hd__xor2_1
X_6304_ net95 net66 vssd1 vssd1 vccd1 vccd1 _1492_ sky130_fd_sc_hd__nor2_1
X_4496_ _3767_ _3771_ vssd1 vssd1 vccd1 vccd1 _3774_ sky130_fd_sc_hd__xnor2_4
XPHY_EDGE_ROW_4_Right_4 vssd1 vssd1 vccd1 vccd1 sky130_fd_sc_hd__decap_3
X_7284_ net110 net45 vssd1 vssd1 vccd1 vccd1 _2515_ sky130_fd_sc_hd__nor2_1
XFILLER_89_449 vssd1 vssd1 vccd1 vccd1 sky130_fd_sc_hd__fill_8
X_6235_ _1419_ _1422_ vssd1 vssd1 vccd1 vccd1 _1424_ sky130_fd_sc_hd__or2_1
X_6166_ _1150_ _1354_ vssd1 vssd1 vccd1 vccd1 _1355_ sky130_fd_sc_hd__nand2_1
XFILLER_57_335 vssd1 vssd1 vccd1 vccd1 sky130_fd_sc_hd__fill_1
X_6097_ _1284_ _1285_ vssd1 vssd1 vccd1 vccd1 _1287_ sky130_fd_sc_hd__or2_1
X_5117_ net118 net61 _4161_ vssd1 vssd1 vccd1 vccd1 _0307_ sky130_fd_sc_hd__o21ai_1
XFILLER_84_154 vssd1 vssd1 vccd1 vccd1 sky130_fd_sc_hd__fill_1
XANTENNA_fanout189_X net189 vssd1 vssd1 vccd1 vccd1 sky130_fd_sc_hd__diode_2
X_5048_ net147 _0154_ _0155_ vssd1 vssd1 vccd1 vccd1 _0238_ sky130_fd_sc_hd__or3_1
XFILLER_72_305 vssd1 vssd1 vccd1 vccd1 sky130_fd_sc_hd__fill_1
XFILLER_72_349 vssd1 vssd1 vccd1 vccd1 sky130_fd_sc_hd__fill_1
XFILLER_43_13 vssd1 vssd1 vccd1 vccd1 sky130_fd_sc_hd__fill_1
XFILLER_80_371 vccd1 vssd1 vccd1 vssd1 sky130_ef_sc_hd__decap_40_12
Xclkbuf_4_8_0_clk clknet_0_clk vssd1 vssd1 vccd1 vccd1 clknet_4_8_0_clk sky130_fd_sc_hd__clkbuf_8
X_6999_ _2213_ _2214_ vssd1 vssd1 vccd1 vccd1 _2215_ sky130_fd_sc_hd__or2_1
XFILLER_40_213 vssd1 vssd1 vccd1 vccd1 sky130_fd_sc_hd__fill_1
XTAP_TAPCELL_ROW_23_433 vssd1 vccd1 sky130_fd_sc_hd__tapvpwrvgnd_1
XFILLER_40_246 vssd1 vssd1 vccd1 vccd1 sky130_fd_sc_hd__fill_4
XTAP_TAPCELL_ROW_91_1115 vssd1 vccd1 sky130_fd_sc_hd__tapvpwrvgnd_1
XFILLER_4_29 vssd1 vssd1 vccd1 vccd1 sky130_fd_sc_hd__fill_4
XFILLER_88_493 vssd1 vssd1 vccd1 vccd1 sky130_fd_sc_hd__fill_2
XFILLER_75_121 vssd1 vssd1 vccd1 vccd1 sky130_fd_sc_hd__fill_1
XFILLER_68_98 vssd1 vssd1 vccd1 vccd1 sky130_fd_sc_hd__fill_1
XFILLER_0_386 vssd1 vssd1 vccd1 vccd1 sky130_fd_sc_hd__fill_2
XANTENNA__6434__A1 net292 vssd1 vssd1 vccd1 vccd1 sky130_fd_sc_hd__diode_2
XANTENNA__5080__A net135 vssd1 vssd1 vccd1 vccd1 sky130_fd_sc_hd__diode_2
XTAP_TAPCELL_ROW_89_1088 vssd1 vccd1 sky130_fd_sc_hd__tapvpwrvgnd_1
XFILLER_75_187 vssd1 vssd1 vccd1 vccd1 sky130_fd_sc_hd__fill_2
XFILLER_16_210 vssd1 vssd1 vccd1 vccd1 sky130_fd_sc_hd__fill_8
XFILLER_17_80 vssd1 vssd1 vccd1 vccd1 sky130_fd_sc_hd__fill_1
XFILLER_16_276 vssd1 vssd1 vccd1 vccd1 sky130_fd_sc_hd__fill_4
XFILLER_31_202 vccd1 vssd1 vccd1 vssd1 sky130_ef_sc_hd__decap_40_12
XFILLER_83_7 vssd1 vssd1 vccd1 vccd1 sky130_fd_sc_hd__fill_2
X_4350_ _3647_ _3648_ vssd1 vssd1 vccd1 vccd1 _3649_ sky130_fd_sc_hd__xnor2_1
X_4281_ net16 net428 net157 vssd1 vssd1 vccd1 vccd1 _0004_ sky130_fd_sc_hd__mux2_1
X_6020_ _0582_ _0602_ _0603_ _0687_ vssd1 vssd1 vccd1 vccd1 _1210_ sky130_fd_sc_hd__a2bb2o_1
XFILLER_39_335 vssd1 vssd1 vccd1 vccd1 sky130_fd_sc_hd__fill_1
XFILLER_39_357 vssd1 vssd1 vccd1 vccd1 sky130_fd_sc_hd__fill_2
X_7971_ _3217_ _3225_ vssd1 vssd1 vccd1 vccd1 _3226_ sky130_fd_sc_hd__and2_1
XANTENNA__4318__B net14 vssd1 vssd1 vccd1 vccd1 sky130_fd_sc_hd__diode_2
X_6922_ _1993_ _2131_ vssd1 vssd1 vccd1 vccd1 _2132_ sky130_fd_sc_hd__xnor2_1
XFILLER_54_349 vssd1 vssd1 vccd1 vccd1 sky130_fd_sc_hd__fill_2
XFILLER_62_360 vssd1 vssd1 vccd1 vccd1 sky130_fd_sc_hd__fill_2
X_6853_ _1757_ _2059_ vssd1 vssd1 vccd1 vccd1 _2060_ sky130_fd_sc_hd__or2_1
XTAP_TAPCELL_ROW_37_569 vssd1 vccd1 sky130_fd_sc_hd__tapvpwrvgnd_1
X_5804_ net241 net296 net308 net233 vssd1 vssd1 vccd1 vccd1 _0994_ sky130_fd_sc_hd__a22o_1
XFILLER_50_533 vssd1 vssd1 vccd1 vccd1 sky130_fd_sc_hd__fill_4
X_6784_ _1984_ _1985_ vssd1 vssd1 vccd1 vccd1 _1986_ sky130_fd_sc_hd__and2_1
Xfanout39 _1583_ vssd1 vssd1 vccd1 vccd1 net39 sky130_fd_sc_hd__buf_2
X_5735_ _0923_ _0924_ vssd1 vssd1 vccd1 vccd1 _0925_ sky130_fd_sc_hd__nor2_1
XTAP_TAPCELL_ROW_20_403 vssd1 vccd1 sky130_fd_sc_hd__tapvpwrvgnd_1
X_8454_ clknet_4_7_0_clk _0042_ net333 vssd1 vssd1 vccd1 vccd1 PID_INST.k2_calc.sum_reg\[10\]
+ sky130_fd_sc_hd__dfrtp_1
X_5666_ _0855_ vssd1 vssd1 vccd1 vccd1 _0856_ sky130_fd_sc_hd__inv_2
XANTENNA__7153__A2 PID_INST.k2_calc.sum_reg\[15\] vssd1 vssd1 vccd1 vccd1 sky130_fd_sc_hd__diode_2
X_4617_ net148 net147 _3734_ net84 vssd1 vssd1 vccd1 vccd1 _3895_ sky130_fd_sc_hd__or4b_1
XANTENNA__8350__A1 net95 vssd1 vssd1 vccd1 vccd1 sky130_fd_sc_hd__diode_2
X_7405_ _2557_ _2558_ _2643_ vssd1 vssd1 vccd1 vccd1 _2645_ sky130_fd_sc_hd__and3_1
X_5597_ _0782_ _0783_ _0786_ vssd1 vssd1 vccd1 vccd1 _0787_ sky130_fd_sc_hd__a21oi_1
X_8385_ clknet_4_9_0_clk PID_INST.k3_calc.d2.y\[5\] net328 vssd1 vssd1 vccd1 vccd1
+ PID_INST.k3_calc.timescaling_term\[5\] sky130_fd_sc_hd__dfrtp_1
XFILLER_89_202 vssd1 vssd1 vccd1 vccd1 sky130_fd_sc_hd__fill_2
X_7336_ net317 net184 vssd1 vssd1 vccd1 vccd1 _2571_ sky130_fd_sc_hd__nand2_1
X_4548_ PID_INST.k1_calc.d1.x\[9\] PID_INST.k3_calc.prev_error\[9\] vssd1 vssd1 vccd1
+ vccd1 _3826_ sky130_fd_sc_hd__and2_1
XANTENNA_fanout104_X net104 vssd1 vssd1 vccd1 vccd1 sky130_fd_sc_hd__diode_2
X_4479_ _3752_ _3755_ vssd1 vssd1 vccd1 vccd1 _3757_ sky130_fd_sc_hd__or2_2
X_7267_ net99 net48 vssd1 vssd1 vccd1 vccd1 _2497_ sky130_fd_sc_hd__nor2_1
XFILLER_89_268 vccd1 vssd1 vccd1 vssd1 sky130_ef_sc_hd__decap_40_12
X_6218_ _1202_ _1205_ vssd1 vssd1 vccd1 vccd1 _1407_ sky130_fd_sc_hd__and2_1
X_7198_ _2423_ _2424_ vssd1 vssd1 vccd1 vccd1 _2425_ sky130_fd_sc_hd__and2b_1
X_6149_ _1336_ _1337_ vssd1 vssd1 vccd1 vccd1 _1338_ sky130_fd_sc_hd__nand2_1
XPHY_EDGE_ROW_79_Right_79 vssd1 vssd1 vccd1 vccd1 sky130_fd_sc_hd__decap_3
XFILLER_72_102 vssd1 vssd1 vccd1 vccd1 sky130_fd_sc_hd__fill_2
XFILLER_53_393 vssd1 vssd1 vccd1 vccd1 sky130_fd_sc_hd__fill_8
XTAP_TAPCELL_ROW_0_194 vssd1 vccd1 sky130_fd_sc_hd__tapvpwrvgnd_1
XFILLER_9_206 vssd1 vssd1 vccd1 vccd1 sky130_fd_sc_hd__fill_8
XANTENNA__4244__A net99 vssd1 vssd1 vccd1 vccd1 sky130_fd_sc_hd__diode_2
XFILLER_70_77 vssd1 vssd1 vccd1 vccd1 sky130_fd_sc_hd__fill_2
XPHY_EDGE_ROW_88_Right_88 vssd1 vssd1 vccd1 vccd1 sky130_fd_sc_hd__decap_3
XFILLER_79_75 vssd1 vssd1 vccd1 vccd1 sky130_fd_sc_hd__fill_8
XTAP_TAPCELL_ROW_8_283 vssd1 vccd1 sky130_fd_sc_hd__tapvpwrvgnd_1
XFILLER_48_176 vssd1 vssd1 vccd1 vccd1 sky130_fd_sc_hd__fill_1
XFILLER_48_154 vssd1 vssd1 vccd1 vccd1 sky130_fd_sc_hd__fill_1
XFILLER_63_124 vssd1 vssd1 vccd1 vccd1 sky130_fd_sc_hd__fill_1
XFILLER_91_477 vccd1 vssd1 vccd1 vssd1 sky130_ef_sc_hd__decap_40_12
XFILLER_32_522 vssd1 vssd1 vccd1 vccd1 sky130_fd_sc_hd__fill_1
XFILLER_32_533 vssd1 vssd1 vccd1 vccd1 sky130_fd_sc_hd__fill_4
XTAP_TAPCELL_ROW_34_539 vssd1 vccd1 sky130_fd_sc_hd__tapvpwrvgnd_1
XFILLER_71_190 vssd1 vssd1 vccd1 vccd1 sky130_fd_sc_hd__fill_4
XFILLER_32_544 vssd1 vssd1 vccd1 vccd1 sky130_fd_sc_hd__fill_2
X_5520_ net236 net296 _0708_ _0706_ vssd1 vssd1 vccd1 vccd1 _0710_ sky130_fd_sc_hd__a31o_1
XANTENNA__7135__A2 net285 vssd1 vssd1 vccd1 vccd1 sky130_fd_sc_hd__diode_2
XANTENNA__6800__C _4034_ vssd1 vssd1 vccd1 vccd1 sky130_fd_sc_hd__diode_2
XANTENNA__5146__A1 _2210_ vssd1 vssd1 vccd1 vccd1 sky130_fd_sc_hd__diode_2
X_5451_ _0615_ _0634_ _0640_ _0639_ vssd1 vssd1 vccd1 vccd1 _0641_ sky130_fd_sc_hd__a31oi_1
X_4402_ _3691_ _3692_ vssd1 vssd1 vccd1 vccd1 _3693_ sky130_fd_sc_hd__nand2_1
X_5382_ _0404_ _0554_ vssd1 vssd1 vccd1 vccd1 _0572_ sky130_fd_sc_hd__xnor2_1
X_8170_ _3268_ _3270_ _3434_ vssd1 vssd1 vccd1 vccd1 _3435_ sky130_fd_sc_hd__o21a_1
X_7121_ _2333_ _2341_ vssd1 vssd1 vccd1 vccd1 _2342_ sky130_fd_sc_hd__nand2b_1
X_4333_ _3504_ _3526_ _3537_ vssd1 vssd1 vccd1 vccd1 _3547_ sky130_fd_sc_hd__a21oi_1
XFILLER_5_72 vssd1 vssd1 vccd1 vccd1 sky130_fd_sc_hd__fill_8
X_7052_ net199 net296 vssd1 vssd1 vccd1 vccd1 _2271_ sky130_fd_sc_hd__nand2_1
XANTENNA__7631__C net205 vssd1 vssd1 vccd1 vccd1 sky130_fd_sc_hd__diode_2
Xfanout207 net208 vssd1 vssd1 vccd1 vccd1 net207 sky130_fd_sc_hd__buf_2
Xfanout218 net221 vssd1 vssd1 vccd1 vccd1 net218 sky130_fd_sc_hd__clkbuf_2
Xfanout229 PID_INST.k2_calc.sum_reg\[6\] vssd1 vssd1 vccd1 vccd1 net229 sky130_fd_sc_hd__clkbuf_2
X_4264_ net177 net176 vssd1 vssd1 vccd1 vccd1 _2834_ sky130_fd_sc_hd__nor2_1
X_6003_ net108 net44 vssd1 vssd1 vccd1 vccd1 _1193_ sky130_fd_sc_hd__nor2_1
X_4195_ PID_INST.k3_calc.kd_term\[6\] net175 vssd1 vssd1 vccd1 vccd1 _2104_ sky130_fd_sc_hd__or2_1
XTAP_TAPCELL_ROW_78_981 vssd1 vccd1 sky130_fd_sc_hd__tapvpwrvgnd_1
XFILLER_82_433 vssd1 vssd1 vccd1 vccd1 sky130_fd_sc_hd__fill_4
X_7954_ _3207_ _3208_ vssd1 vssd1 vccd1 vccd1 _3209_ sky130_fd_sc_hd__or2_1
XFILLER_82_477 vssd1 vssd1 vccd1 vccd1 sky130_fd_sc_hd__fill_1
X_6905_ _1804_ _1808_ _2103_ _2106_ vssd1 vssd1 vccd1 vccd1 _2115_ sky130_fd_sc_hd__o31a_1
X_7885_ _3137_ _3138_ vssd1 vssd1 vccd1 vccd1 _3140_ sky130_fd_sc_hd__and2_1
X_6836_ _1745_ _2041_ vssd1 vssd1 vccd1 vccd1 _2042_ sky130_fd_sc_hd__xnor2_1
XFILLER_35_393 vssd1 vssd1 vccd1 vccd1 sky130_fd_sc_hd__fill_8
X_6767_ net210 net287 _1966_ vssd1 vssd1 vccd1 vccd1 _1968_ sky130_fd_sc_hd__a21oi_1
XANTENNA_fanout221_X net221 vssd1 vssd1 vccd1 vccd1 sky130_fd_sc_hd__diode_2
X_5718_ net232 net306 vssd1 vssd1 vccd1 vccd1 _0908_ sky130_fd_sc_hd__nand2_1
XFILLER_10_249 vssd1 vssd1 vccd1 vccd1 sky130_fd_sc_hd__fill_2
XANTENNA__7094__B net266 vssd1 vssd1 vccd1 vccd1 sky130_fd_sc_hd__diode_2
XFILLER_6_209 vssd1 vssd1 vccd1 vccd1 sky130_fd_sc_hd__fill_4
X_6698_ _1809_ _1895_ vssd1 vssd1 vccd1 vccd1 _1896_ sky130_fd_sc_hd__and2_1
X_5649_ net319 net215 net210 net323 vssd1 vssd1 vccd1 vccd1 _0839_ sky130_fd_sc_hd__a22o_1
X_8437_ clknet_4_4_0_clk net401 net330 vssd1 vssd1 vccd1 vccd1 PID_INST.k3_calc.prev_error\[9\]
+ sky130_fd_sc_hd__dfrtp_1
X_8368_ clknet_4_1_0_clk _0004_ net326 vssd1 vssd1 vccd1 vccd1 PID_INST.k1_calc.d1.x\[4\]
+ sky130_fd_sc_hd__dfrtp_1
XANTENNA__8427__RESET_B net331 vssd1 vssd1 vccd1 vccd1 sky130_fd_sc_hd__diode_2
XANTENNA__4896__B1 _4095_ vssd1 vssd1 vccd1 vccd1 sky130_fd_sc_hd__diode_2
X_7319_ _2551_ _2552_ vssd1 vssd1 vccd1 vccd1 _2553_ sky130_fd_sc_hd__or2_1
X_8299_ _3564_ _3565_ _3571_ _3572_ vssd1 vssd1 vccd1 vccd1 _3573_ sky130_fd_sc_hd__o22a_1
XANTENNA__6438__B net291 vssd1 vssd1 vccd1 vccd1 sky130_fd_sc_hd__diode_2
XANTENNA_fanout81_A net83 vssd1 vssd1 vccd1 vccd1 sky130_fd_sc_hd__diode_2
XFILLER_58_452 vccd1 vssd1 vccd1 vssd1 sky130_ef_sc_hd__decap_40_12
XFILLER_58_441 vssd1 vssd1 vccd1 vccd1 sky130_fd_sc_hd__fill_1
XTAP_TAPCELL_ROW_5_253 vssd1 vccd1 sky130_fd_sc_hd__tapvpwrvgnd_1
XFILLER_85_260 vccd1 vssd1 vccd1 vssd1 sky130_ef_sc_hd__decap_40_12
XFILLER_73_433 vssd1 vssd1 vccd1 vccd1 sky130_fd_sc_hd__fill_4
XFILLER_65_55 vssd1 vssd1 vccd1 vccd1 sky130_fd_sc_hd__fill_1
XFILLER_18_349 vccd1 vssd1 vccd1 vssd1 sky130_ef_sc_hd__decap_40_12
XANTENNA__8380__CLK clknet_4_9_0_clk vssd1 vssd1 vccd1 vccd1 sky130_fd_sc_hd__diode_2
XTAP_TAPCELL_ROW_86_1058 vssd1 vccd1 sky130_fd_sc_hd__tapvpwrvgnd_1
XFILLER_14_522 vssd1 vssd1 vccd1 vccd1 sky130_fd_sc_hd__fill_2
XFILLER_26_371 vccd1 vssd1 vccd1 vssd1 sky130_ef_sc_hd__decap_40_12
XFILLER_26_393 vssd1 vssd1 vccd1 vccd1 sky130_fd_sc_hd__fill_1
XTAP_TAPCELL_ROW_31_509 vssd1 vccd1 sky130_fd_sc_hd__tapvpwrvgnd_1
XANTENNA__4261__X PID_INST.busy vssd1 vssd1 vccd1 vccd1 sky130_fd_sc_hd__diode_2
XFILLER_14_81 vssd1 vssd1 vccd1 vccd1 sky130_fd_sc_hd__fill_1
XANTENNA__5517__B net296 vssd1 vssd1 vccd1 vccd1 sky130_fd_sc_hd__diode_2
XFILLER_5_297 vccd1 vssd1 vccd1 vssd1 sky130_ef_sc_hd__decap_40_12
XANTENNA__5533__A net251 vssd1 vssd1 vccd1 vccd1 sky130_fd_sc_hd__diode_2
XFILLER_68_205 vssd1 vssd1 vccd1 vccd1 sky130_fd_sc_hd__fill_2
XFILLER_68_249 vssd1 vssd1 vccd1 vccd1 sky130_fd_sc_hd__fill_2
Xinput7 gpio_in[14] vssd1 vssd1 vccd1 vccd1 net7 sky130_fd_sc_hd__clkbuf_4
XFILLER_49_463 vssd1 vssd1 vccd1 vccd1 sky130_fd_sc_hd__fill_1
XFILLER_91_263 vssd1 vssd1 vccd1 vccd1 sky130_fd_sc_hd__fill_2
XTAP_TAPCELL_ROW_75_951 vssd1 vccd1 sky130_fd_sc_hd__tapvpwrvgnd_1
XTAP_TAPCELL_ROW_47_675 vssd1 vccd1 sky130_fd_sc_hd__tapvpwrvgnd_1
X_4951_ _0138_ _0139_ vssd1 vssd1 vccd1 vccd1 _0141_ sky130_fd_sc_hd__xnor2_2
XTAP_TAPCELL_ROW_19_388 vssd1 vccd1 sky130_fd_sc_hd__tapvpwrvgnd_1
XFILLER_36_179 vccd1 vssd1 vccd1 vssd1 sky130_ef_sc_hd__decap_40_12
X_7670_ net309 net184 vssd1 vssd1 vccd1 vccd1 _2924_ sky130_fd_sc_hd__nand2_1
XFILLER_51_149 vssd1 vssd1 vccd1 vccd1 sky130_fd_sc_hd__fill_2
X_4882_ net139 net64 vssd1 vssd1 vccd1 vccd1 _4160_ sky130_fd_sc_hd__nor2_1
XFILLER_17_393 vssd1 vssd1 vccd1 vccd1 sky130_fd_sc_hd__fill_2
X_6621_ net324 net190 vssd1 vssd1 vccd1 vccd1 _1813_ sky130_fd_sc_hd__nand2_1
XANTENNA__8305__A1 net322 vssd1 vssd1 vccd1 vccd1 sky130_fd_sc_hd__diode_2
X_6552_ _1578_ _1581_ _1738_ vssd1 vssd1 vccd1 vccd1 _1739_ sky130_fd_sc_hd__a21oi_1
XANTENNA__7345__D net186 vssd1 vssd1 vccd1 vccd1 sky130_fd_sc_hd__diode_2
X_5503_ _0690_ _0691_ net290 net240 vssd1 vssd1 vccd1 vccd1 _0693_ sky130_fd_sc_hd__and4b_1
X_6483_ _1669_ _1670_ vssd1 vssd1 vccd1 vccd1 _1671_ sky130_fd_sc_hd__nand2_1
XANTENNA__5427__B net51 vssd1 vssd1 vccd1 vccd1 sky130_fd_sc_hd__diode_2
X_8222_ _3487_ _3488_ _3489_ vssd1 vssd1 vccd1 vccd1 _3490_ sky130_fd_sc_hd__or3_1
X_5434_ _0622_ _0623_ _0621_ vssd1 vssd1 vccd1 vccd1 _0624_ sky130_fd_sc_hd__a21bo_1
XANTENNA__8069__B1 net252 vssd1 vssd1 vccd1 vccd1 sky130_fd_sc_hd__diode_2
X_8153_ _3154_ _3293_ _3295_ vssd1 vssd1 vccd1 vccd1 _3416_ sky130_fd_sc_hd__a21o_1
X_7104_ _2323_ _2324_ vssd1 vssd1 vccd1 vccd1 _2325_ sky130_fd_sc_hd__nor2_1
X_5365_ _0478_ _0553_ vssd1 vssd1 vccd1 vccd1 _0555_ sky130_fd_sc_hd__nand2_1
X_8084_ net310 net298 net180 PID_INST.k2_calc.sum_reg\[23\] vssd1 vssd1 vccd1 vccd1
+ _3342_ sky130_fd_sc_hd__and4_1
XANTENNA__7361__C net275 vssd1 vssd1 vccd1 vccd1 sky130_fd_sc_hd__diode_2
XANTENNA__6619__B2 net266 vssd1 vssd1 vccd1 vccd1 sky130_fd_sc_hd__diode_2
X_4316_ net245 net13 _3332_ vssd1 vssd1 vccd1 vccd1 _3364_ sky130_fd_sc_hd__a21o_1
X_5296_ _0481_ _0484_ vssd1 vssd1 vccd1 vccd1 _0486_ sky130_fd_sc_hd__xnor2_1
XFILLER_87_547 vccd1 vssd1 vccd1 vssd1 sky130_ef_sc_hd__decap_40_12
X_7035_ _2246_ _2251_ vssd1 vssd1 vccd1 vccd1 _2253_ sky130_fd_sc_hd__xnor2_1
X_4247_ net98 vssd1 vssd1 vccd1 vccd1 PID_INST.k3_calc.d2.y\[9\] sky130_fd_sc_hd__inv_2
X_4178_ net7 net173 _1912_ vssd1 vssd1 vccd1 vccd1 _1923_ sky130_fd_sc_hd__o21ai_2
XFILLER_67_293 vssd1 vssd1 vccd1 vccd1 sky130_fd_sc_hd__fill_4
XTAP_TAPCELL_ROW_2_223 vssd1 vccd1 sky130_fd_sc_hd__tapvpwrvgnd_1
XFILLER_55_455 vssd1 vssd1 vccd1 vccd1 sky130_fd_sc_hd__fill_1
XFILLER_27_157 vssd1 vssd1 vccd1 vccd1 sky130_fd_sc_hd__fill_8
XFILLER_82_274 vssd1 vssd1 vccd1 vccd1 sky130_fd_sc_hd__fill_4
X_7937_ _3185_ _3190_ vssd1 vssd1 vccd1 vccd1 _3192_ sky130_fd_sc_hd__or2_1
XANTENNA__7089__B _2309_ vssd1 vssd1 vccd1 vccd1 sky130_fd_sc_hd__diode_2
XFILLER_70_447 vssd1 vssd1 vccd1 vccd1 sky130_fd_sc_hd__fill_4
XFILLER_23_341 vssd1 vssd1 vccd1 vccd1 sky130_fd_sc_hd__fill_1
X_7868_ _3055_ _3121_ vssd1 vssd1 vccd1 vccd1 _3123_ sky130_fd_sc_hd__nand2_1
X_6819_ _2002_ _2022_ vssd1 vssd1 vccd1 vccd1 _2024_ sky130_fd_sc_hd__nand2_1
XFILLER_11_503 vssd1 vssd1 vccd1 vccd1 sky130_fd_sc_hd__fill_1
XFILLER_51_24 vssd1 vssd1 vccd1 vccd1 sky130_fd_sc_hd__fill_1
XFILLER_11_525 vssd1 vssd1 vccd1 vccd1 sky130_fd_sc_hd__fill_2
X_7799_ net92 net51 vssd1 vssd1 vccd1 vccd1 _3055_ sky130_fd_sc_hd__nor2_1
XFILLER_4_3 vccd1 vssd1 vccd1 vssd1 sky130_ef_sc_hd__decap_40_12
XANTENNA__6168__B _0088_ vssd1 vssd1 vccd1 vccd1 sky130_fd_sc_hd__diode_2
XFILLER_2_278 vssd1 vssd1 vccd1 vccd1 sky130_fd_sc_hd__fill_1
XANTENNA_fanout84_X net84 vssd1 vssd1 vccd1 vccd1 sky130_fd_sc_hd__diode_2
XFILLER_76_21 vssd1 vssd1 vccd1 vccd1 sky130_fd_sc_hd__fill_4
XFILLER_76_76 vssd1 vssd1 vccd1 vccd1 sky130_fd_sc_hd__fill_8
XFILLER_58_282 vssd1 vssd1 vccd1 vccd1 sky130_fd_sc_hd__fill_1
XFILLER_46_433 vccd1 vssd1 vccd1 vssd1 sky130_ef_sc_hd__decap_40_12
XFILLER_18_135 vssd1 vssd1 vccd1 vccd1 sky130_fd_sc_hd__fill_4
XANTENNA__6184__A net127 vssd1 vssd1 vccd1 vccd1 sky130_fd_sc_hd__diode_2
XFILLER_92_53 vssd1 vssd1 vccd1 vccd1 sky130_fd_sc_hd__fill_2
XTAP_TAPCELL_ROW_72_921 vssd1 vccd1 sky130_fd_sc_hd__tapvpwrvgnd_1
XFILLER_61_447 vssd1 vssd1 vccd1 vccd1 sky130_fd_sc_hd__fill_1
XTAP_TAPCELL_ROW_44_645 vssd1 vccd1 sky130_fd_sc_hd__tapvpwrvgnd_1
XFILLER_26_190 vssd1 vssd1 vccd1 vccd1 sky130_fd_sc_hd__fill_4
XTAP_TAPCELL_ROW_16_358 vssd1 vccd1 sky130_fd_sc_hd__tapvpwrvgnd_1
XFILLER_41_182 vssd1 vssd1 vccd1 vccd1 sky130_fd_sc_hd__fill_8
XFILLER_69_503 vssd1 vssd1 vccd1 vccd1 sky130_fd_sc_hd__fill_1
X_5150_ net113 net68 vssd1 vssd1 vccd1 vccd1 _0340_ sky130_fd_sc_hd__nand2_1
XFILLER_37_3 vssd1 vssd1 vccd1 vccd1 sky130_fd_sc_hd__fill_8
XFILLER_69_558 vssd1 vssd1 vccd1 vccd1 sky130_fd_sc_hd__fill_2
X_5081_ _0269_ _0270_ vssd1 vssd1 vccd1 vccd1 _0271_ sky130_fd_sc_hd__xnor2_1
XFILLER_2_95 vccd1 vssd1 vccd1 vssd1 sky130_ef_sc_hd__decap_40_12
XFILLER_92_561 vssd1 vssd1 vccd1 vccd1 sky130_fd_sc_hd__fill_4
XFILLER_52_403 vssd1 vssd1 vccd1 vccd1 sky130_fd_sc_hd__fill_2
XFILLER_24_105 vssd1 vssd1 vccd1 vccd1 sky130_fd_sc_hd__fill_8
X_5983_ _1160_ _1171_ vssd1 vssd1 vccd1 vccd1 _1173_ sky130_fd_sc_hd__xor2_1
X_7722_ _2976_ _2977_ vssd1 vssd1 vccd1 vccd1 _2978_ sky130_fd_sc_hd__xnor2_1
X_4934_ net130 net79 vssd1 vssd1 vccd1 vccd1 _0124_ sky130_fd_sc_hd__nand2_1
X_7653_ _2904_ _2905_ vssd1 vssd1 vccd1 vccd1 _2906_ sky130_fd_sc_hd__nor2_1
XFILLER_60_491 vssd1 vssd1 vccd1 vccd1 sky130_fd_sc_hd__fill_2
X_4865_ _4123_ _4142_ vssd1 vssd1 vccd1 vccd1 _4143_ sky130_fd_sc_hd__nor2_1
XANTENNA__5438__A net111 vssd1 vssd1 vccd1 vccd1 sky130_fd_sc_hd__diode_2
XANTENNA__4342__A net226 vssd1 vssd1 vccd1 vccd1 sky130_fd_sc_hd__diode_2
X_4796_ _4053_ _4072_ vssd1 vssd1 vccd1 vccd1 _4074_ sky130_fd_sc_hd__xnor2_1
X_6604_ _1509_ _1519_ _1508_ vssd1 vssd1 vccd1 vccd1 _1794_ sky130_fd_sc_hd__a21o_1
XFILLER_20_355 vssd1 vssd1 vccd1 vccd1 sky130_fd_sc_hd__fill_1
X_7584_ _2753_ _2761_ _2752_ vssd1 vssd1 vccd1 vccd1 _2833_ sky130_fd_sc_hd__o21ba_1
X_6535_ net131 net69 _1720_ vssd1 vssd1 vccd1 vccd1 _1722_ sky130_fd_sc_hd__a21o_1
X_8205_ _3470_ _3471_ vssd1 vssd1 vccd1 vccd1 _3473_ sky130_fd_sc_hd__nor2_1
X_6466_ _1434_ _1653_ vssd1 vssd1 vccd1 vccd1 _1654_ sky130_fd_sc_hd__or2_1
XANTENNA__4315__A2 net159 vssd1 vssd1 vccd1 vccd1 sky130_fd_sc_hd__diode_2
X_5417_ net115 net65 vssd1 vssd1 vccd1 vccd1 _0607_ sky130_fd_sc_hd__nor2_1
X_6397_ net112 net42 vssd1 vssd1 vccd1 vccd1 _1585_ sky130_fd_sc_hd__nor2_1
X_8136_ _3398_ _3396_ vssd1 vssd1 vccd1 vccd1 _3399_ sky130_fd_sc_hd__and2b_1
X_5348_ _0536_ _0537_ vssd1 vssd1 vccd1 vccd1 _0538_ sky130_fd_sc_hd__nor2_1
X_8067_ _3323_ _3322_ vssd1 vssd1 vccd1 vccd1 _3324_ sky130_fd_sc_hd__nand2b_1
XFILLER_75_528 vssd1 vssd1 vccd1 vccd1 sky130_fd_sc_hd__fill_1
X_7018_ net234 net238 net258 net254 vssd1 vssd1 vccd1 vccd1 _2235_ sky130_fd_sc_hd__and4_1
X_5279_ _0405_ _0468_ vssd1 vssd1 vccd1 vccd1 _0469_ sky130_fd_sc_hd__nand2_1
XFILLER_75_539 vssd1 vssd1 vccd1 vccd1 sky130_fd_sc_hd__fill_1
XFILLER_83_561 vssd1 vssd1 vccd1 vccd1 sky130_fd_sc_hd__fill_8
XFILLER_28_444 vssd1 vssd1 vccd1 vccd1 sky130_fd_sc_hd__fill_4
XANTENNA__6435__C net314 vssd1 vssd1 vccd1 vccd1 sky130_fd_sc_hd__diode_2
XTAP_TAPCELL_ROW_83_1028 vssd1 vccd1 sky130_fd_sc_hd__tapvpwrvgnd_1
XFILLER_43_436 vccd1 vssd1 vccd1 vssd1 sky130_ef_sc_hd__decap_40_12
XFILLER_15_149 vssd1 vssd1 vccd1 vccd1 sky130_fd_sc_hd__fill_1
XFILLER_70_277 vssd1 vssd1 vccd1 vccd1 sky130_fd_sc_hd__fill_1
XFILLER_70_255 vssd1 vssd1 vccd1 vccd1 sky130_fd_sc_hd__fill_1
XFILLER_43_469 vssd1 vssd1 vccd1 vccd1 sky130_fd_sc_hd__fill_4
XTAP_TAPCELL_ROW_41_615 vssd1 vccd1 sky130_fd_sc_hd__tapvpwrvgnd_1
XTAP_TAPCELL_ROW_13_328 vssd1 vccd1 sky130_fd_sc_hd__tapvpwrvgnd_1
XFILLER_11_388 vssd1 vssd1 vccd1 vccd1 sky130_fd_sc_hd__fill_4
XANTENNA__7563__A _2737_ vssd1 vssd1 vccd1 vccd1 sky130_fd_sc_hd__diode_2
XFILLER_87_97 vccd1 vssd1 vccd1 vssd1 sky130_ef_sc_hd__decap_40_12
XFILLER_23_9 vssd1 vssd1 vccd1 vccd1 sky130_fd_sc_hd__fill_1
XFILLER_19_411 vssd1 vssd1 vccd1 vccd1 sky130_fd_sc_hd__fill_1
XFILLER_61_200 vssd1 vssd1 vccd1 vccd1 sky130_fd_sc_hd__fill_1
XTAP_TAPCELL_ROW_57_770 vssd1 vccd1 sky130_fd_sc_hd__tapvpwrvgnd_1
XANTENNA__4760__A1_N net147 vssd1 vssd1 vccd1 vccd1 sky130_fd_sc_hd__diode_2
XFILLER_19_477 vssd1 vssd1 vccd1 vccd1 sky130_fd_sc_hd__fill_1
XTAP_TAPCELL_ROW_29_494 vssd1 vccd1 sky130_fd_sc_hd__tapvpwrvgnd_1
XFILLER_34_458 vccd1 vssd1 vccd1 vssd1 sky130_ef_sc_hd__decap_40_12
XFILLER_61_277 vssd1 vssd1 vccd1 vccd1 sky130_fd_sc_hd__fill_2
XFILLER_14_182 vssd1 vssd1 vccd1 vccd1 sky130_fd_sc_hd__fill_1
X_4650_ _3926_ _3927_ _3919_ _3925_ vssd1 vssd1 vccd1 vccd1 _3928_ sky130_fd_sc_hd__a2bb2o_1
XFILLER_14_193 vssd1 vssd1 vccd1 vccd1 sky130_fd_sc_hd__fill_2
Xinput10 gpio_in[17] vssd1 vssd1 vccd1 vccd1 net10 sky130_fd_sc_hd__buf_2
X_4581_ _3856_ _3857_ _3776_ vssd1 vssd1 vccd1 vccd1 _3859_ sky130_fd_sc_hd__a21o_1
X_6320_ _1506_ _1507_ vssd1 vssd1 vccd1 vccd1 _1508_ sky130_fd_sc_hd__nor2_1
X_6251_ _1224_ _1236_ _1438_ vssd1 vssd1 vccd1 vccd1 _1440_ sky130_fd_sc_hd__or3_1
XFILLER_88_108 vssd1 vssd1 vccd1 vccd1 sky130_fd_sc_hd__fill_8
X_5202_ _0345_ _0390_ vssd1 vssd1 vccd1 vccd1 _0392_ sky130_fd_sc_hd__xor2_1
X_6182_ net129 _0156_ _1369_ vssd1 vssd1 vccd1 vccd1 _1371_ sky130_fd_sc_hd__and3_1
XFILLER_69_344 vssd1 vssd1 vccd1 vccd1 sky130_fd_sc_hd__fill_1
X_5133_ net111 net54 vssd1 vssd1 vccd1 vccd1 _0323_ sky130_fd_sc_hd__nor2_1
XFILLER_69_366 vssd1 vssd1 vccd1 vccd1 sky130_fd_sc_hd__fill_1
X_5064_ _0252_ _0253_ vssd1 vssd1 vccd1 vccd1 _0254_ sky130_fd_sc_hd__xnor2_1
XFILLER_65_561 vssd1 vssd1 vccd1 vccd1 sky130_fd_sc_hd__fill_8
XFILLER_37_263 vssd1 vssd1 vccd1 vccd1 sky130_fd_sc_hd__fill_1
XFILLER_92_391 vssd1 vssd1 vccd1 vccd1 sky130_fd_sc_hd__fill_1
XFILLER_80_520 vssd1 vssd1 vccd1 vccd1 sky130_fd_sc_hd__fill_2
XFILLER_25_469 vssd1 vssd1 vccd1 vccd1 sky130_fd_sc_hd__fill_2
X_5966_ _0505_ _0512_ _0513_ _0504_ _0503_ vssd1 vssd1 vccd1 vccd1 _1156_ sky130_fd_sc_hd__o32a_1
X_7705_ _2723_ _2724_ _2726_ vssd1 vssd1 vccd1 vccd1 _2962_ sky130_fd_sc_hd__a21oi_1
X_5897_ net308 _1080_ _1083_ _1084_ vssd1 vssd1 vccd1 vccd1 _1087_ sky130_fd_sc_hd__o22a_1
X_4917_ net128 net81 _3774_ _2146_ vssd1 vssd1 vccd1 vccd1 _0107_ sky130_fd_sc_hd__o2bb2a_1
XFILLER_40_428 vccd1 vssd1 vccd1 vssd1 sky130_ef_sc_hd__decap_40_12
X_7636_ _2652_ _2654_ _2651_ vssd1 vssd1 vccd1 vccd1 _2889_ sky130_fd_sc_hd__o21ba_1
X_4848_ _4054_ _4125_ vssd1 vssd1 vccd1 vccd1 _4126_ sky130_fd_sc_hd__or2_1
X_7567_ _2737_ _2809_ _2645_ vssd1 vssd1 vccd1 vccd1 _2815_ sky130_fd_sc_hd__o21ai_1
XFILLER_4_307 vssd1 vssd1 vccd1 vccd1 sky130_fd_sc_hd__fill_1
X_4779_ _3967_ _4054_ _4056_ vssd1 vssd1 vccd1 vccd1 _4057_ sky130_fd_sc_hd__o21a_1
X_6518_ _1923_ net72 vssd1 vssd1 vccd1 vccd1 _1705_ sky130_fd_sc_hd__nor2_1
X_7498_ _2738_ _2742_ vssd1 vssd1 vccd1 vccd1 _2743_ sky130_fd_sc_hd__nand2_1
X_6449_ _1427_ _1435_ _1426_ vssd1 vssd1 vccd1 vccd1 _1637_ sky130_fd_sc_hd__a21bo_1
XANTENNA__5615__B net207 vssd1 vssd1 vccd1 vccd1 sky130_fd_sc_hd__diode_2
X_8119_ _3376_ _3377_ _3224_ _3226_ vssd1 vssd1 vccd1 vccd1 _3380_ sky130_fd_sc_hd__a211o_1
XFILLER_56_550 vssd1 vssd1 vccd1 vccd1 sky130_fd_sc_hd__fill_4
XANTENNA__4247__A net98 vssd1 vssd1 vccd1 vccd1 sky130_fd_sc_hd__diode_2
XFILLER_28_241 vssd1 vssd1 vccd1 vccd1 sky130_fd_sc_hd__fill_4
XFILLER_90_317 vssd1 vssd1 vccd1 vccd1 sky130_fd_sc_hd__fill_8
XFILLER_83_391 vssd1 vssd1 vccd1 vccd1 sky130_fd_sc_hd__fill_1
XTAP_TAPCELL_ROW_54_740 vssd1 vccd1 sky130_fd_sc_hd__tapvpwrvgnd_1
XANTENNA_fanout47_X net47 vssd1 vssd1 vccd1 vccd1 sky130_fd_sc_hd__diode_2
XFILLER_43_211 vccd1 vssd1 vccd1 vssd1 sky130_ef_sc_hd__decap_40_12
XFILLER_16_469 vssd1 vssd1 vccd1 vccd1 sky130_fd_sc_hd__fill_4
XTAP_TAPCELL_ROW_26_464 vssd1 vccd1 sky130_fd_sc_hd__tapvpwrvgnd_1
XFILLER_73_99 vssd1 vssd1 vccd1 vccd1 sky130_fd_sc_hd__fill_1
XANTENNA__6181__B _0156_ vssd1 vssd1 vccd1 vccd1 sky130_fd_sc_hd__diode_2
XFILLER_11_141 vssd1 vssd1 vccd1 vccd1 sky130_fd_sc_hd__fill_4
XANTENNA__5078__A net138 vssd1 vssd1 vccd1 vccd1 sky130_fd_sc_hd__diode_2
XFILLER_11_152 vccd1 vssd1 vccd1 vssd1 sky130_ef_sc_hd__decap_40_12
XFILLER_11_174 vccd1 vssd1 vccd1 vssd1 sky130_ef_sc_hd__decap_40_12
XANTENNA__7477__A1 net286 vssd1 vssd1 vccd1 vccd1 sky130_fd_sc_hd__diode_2
XANTENNA__6637__A net203 vssd1 vssd1 vccd1 vccd1 sky130_fd_sc_hd__diode_2
XFILLER_78_141 vssd1 vssd1 vccd1 vccd1 sky130_fd_sc_hd__fill_1
XFILLER_21_6 vssd1 vssd1 vccd1 vccd1 sky130_fd_sc_hd__fill_2
XFILLER_39_517 vssd1 vssd1 vccd1 vccd1 sky130_fd_sc_hd__fill_1
XFILLER_66_314 vccd1 vssd1 vccd1 vssd1 sky130_ef_sc_hd__decap_40_12
XFILLER_47_561 vssd1 vssd1 vccd1 vccd1 sky130_fd_sc_hd__fill_1
XFILLER_81_339 vssd1 vssd1 vccd1 vccd1 sky130_fd_sc_hd__fill_4
XFILLER_62_553 vssd1 vssd1 vccd1 vccd1 sky130_fd_sc_hd__fill_8
X_5820_ _0964_ _0971_ vssd1 vssd1 vccd1 vccd1 _1010_ sky130_fd_sc_hd__xor2_1
XANTENNA__6372__A _2051_ vssd1 vssd1 vccd1 vccd1 sky130_fd_sc_hd__diode_2
XANTENNA__4215__A1 net17 vssd1 vssd1 vccd1 vccd1 sky130_fd_sc_hd__diode_2
X_5751_ net242 net300 net234 net312 vssd1 vssd1 vccd1 vccd1 _0941_ sky130_fd_sc_hd__a22o_1
XFILLER_34_277 vssd1 vssd1 vccd1 vccd1 sky130_fd_sc_hd__fill_2
X_8470_ clknet_4_7_0_clk _0058_ net334 vssd1 vssd1 vccd1 vccd1 PID_INST.k2_calc.sum_reg\[26\]
+ sky130_fd_sc_hd__dfrtp_2
X_4702_ _3978_ _3979_ vssd1 vssd1 vccd1 vccd1 _3980_ sky130_fd_sc_hd__nand2_1
X_7421_ net222 net226 net257 net253 vssd1 vssd1 vccd1 vccd1 _2660_ sky130_fd_sc_hd__and4_1
XTAP_TAPCELL_ROW_60_798 vssd1 vccd1 sky130_fd_sc_hd__tapvpwrvgnd_1
X_5682_ _0728_ _0871_ vssd1 vssd1 vccd1 vccd1 _0872_ sky130_fd_sc_hd__or2_1
XFILLER_8_83 vssd1 vssd1 vccd1 vccd1 sky130_fd_sc_hd__fill_1
X_4633_ _3908_ _3910_ vssd1 vssd1 vccd1 vccd1 _3911_ sky130_fd_sc_hd__xnor2_1
X_7352_ _2578_ _2587_ vssd1 vssd1 vccd1 vccd1 _2588_ sky130_fd_sc_hd__nand2b_1
X_4564_ _3839_ _3840_ _3823_ vssd1 vssd1 vccd1 vccd1 _3842_ sky130_fd_sc_hd__a21o_1
X_6303_ _1328_ _1400_ _1399_ vssd1 vssd1 vccd1 vccd1 _1491_ sky130_fd_sc_hd__a21bo_1
X_7283_ net110 net42 vssd1 vssd1 vccd1 vccd1 _2514_ sky130_fd_sc_hd__nor2_1
X_6234_ _1419_ _1422_ vssd1 vssd1 vccd1 vccd1 _1423_ sky130_fd_sc_hd__nand2_1
X_4495_ _3767_ _3770_ vssd1 vssd1 vccd1 vccd1 _3773_ sky130_fd_sc_hd__xnor2_1
XANTENNA_fanout296_A net297 vssd1 vssd1 vccd1 vccd1 sky130_fd_sc_hd__diode_2
X_6165_ _2019_ _4101_ vssd1 vssd1 vccd1 vccd1 _1354_ sky130_fd_sc_hd__nor2_1
X_6096_ _1284_ _1285_ vssd1 vssd1 vccd1 vccd1 _1286_ sky130_fd_sc_hd__nand2_1
X_5116_ _0077_ _0305_ vssd1 vssd1 vccd1 vccd1 _0306_ sky130_fd_sc_hd__xnor2_1
X_5047_ net142 net68 vssd1 vssd1 vccd1 vccd1 _0237_ sky130_fd_sc_hd__nand2_1
XFILLER_27_26 vssd1 vssd1 vccd1 vccd1 sky130_fd_sc_hd__fill_1
XFILLER_84_166 vssd1 vssd1 vccd1 vccd1 sky130_fd_sc_hd__fill_8
XTAP_TAPCELL_ROW_68_876 vssd1 vccd1 sky130_fd_sc_hd__tapvpwrvgnd_1
XFILLER_72_339 vssd1 vssd1 vccd1 vccd1 sky130_fd_sc_hd__fill_2
XFILLER_53_531 vssd1 vssd1 vccd1 vccd1 sky130_fd_sc_hd__fill_1
XFILLER_25_222 vssd1 vssd1 vccd1 vccd1 sky130_fd_sc_hd__fill_2
XFILLER_25_233 vssd1 vssd1 vccd1 vccd1 sky130_fd_sc_hd__fill_1
XANTENNA_fanout251_X net251 vssd1 vssd1 vccd1 vccd1 sky130_fd_sc_hd__diode_2
X_6998_ _2052_ _2096_ _2095_ vssd1 vssd1 vccd1 vccd1 _2214_ sky130_fd_sc_hd__a21oi_1
XFILLER_80_383 vccd1 vssd1 vccd1 vssd1 sky130_ef_sc_hd__decap_40_12
XANTENNA__7097__B net183 vssd1 vssd1 vccd1 vccd1 sky130_fd_sc_hd__diode_2
XTAP_TAPCELL_ROW_51_710 vssd1 vccd1 sky130_fd_sc_hd__tapvpwrvgnd_1
XANTENNA__5403__B1 net51 vssd1 vssd1 vccd1 vccd1 sky130_fd_sc_hd__diode_2
X_5949_ _1137_ _1138_ vssd1 vssd1 vccd1 vccd1 _1139_ sky130_fd_sc_hd__xnor2_1
XTAP_TAPCELL_ROW_23_434 vssd1 vccd1 sky130_fd_sc_hd__tapvpwrvgnd_1
X_7619_ _2869_ _2870_ vssd1 vssd1 vccd1 vccd1 _2871_ sky130_fd_sc_hd__xnor2_1
XFILLER_4_148 vssd1 vssd1 vccd1 vccd1 sky130_fd_sc_hd__fill_2
XFILLER_4_137 vssd1 vssd1 vccd1 vccd1 sky130_fd_sc_hd__fill_2
XFILLER_4_19 vssd1 vssd1 vccd1 vccd1 sky130_fd_sc_hd__fill_2
XANTENNA__6457__A net225 vssd1 vssd1 vccd1 vccd1 sky130_fd_sc_hd__diode_2
XANTENNA__4693__A1 net132 vssd1 vssd1 vccd1 vccd1 sky130_fd_sc_hd__diode_2
XFILLER_75_111 vssd1 vssd1 vccd1 vccd1 sky130_fd_sc_hd__fill_1
XFILLER_0_365 vssd1 vssd1 vccd1 vccd1 sky130_fd_sc_hd__fill_8
XANTENNA__6434__A2 net220 vssd1 vssd1 vccd1 vccd1 sky130_fd_sc_hd__diode_2
XFILLER_48_336 vssd1 vssd1 vccd1 vccd1 sky130_fd_sc_hd__fill_1
XANTENNA__5080__B net84 vssd1 vssd1 vccd1 vccd1 sky130_fd_sc_hd__diode_2
XFILLER_90_103 vccd1 vssd1 vccd1 vssd1 sky130_ef_sc_hd__decap_40_12
XTAP_TAPCELL_ROW_89_1089 vssd1 vccd1 sky130_fd_sc_hd__tapvpwrvgnd_1
XFILLER_75_155 vssd1 vssd1 vccd1 vccd1 sky130_fd_sc_hd__fill_8
XFILLER_90_125 vssd1 vssd1 vccd1 vccd1 sky130_fd_sc_hd__fill_4
XFILLER_44_542 vssd1 vssd1 vccd1 vccd1 sky130_fd_sc_hd__fill_2
XFILLER_44_531 vssd1 vssd1 vccd1 vccd1 sky130_fd_sc_hd__fill_1
XFILLER_31_214 vssd1 vssd1 vccd1 vccd1 sky130_fd_sc_hd__fill_2
XFILLER_12_472 vssd1 vssd1 vccd1 vccd1 sky130_fd_sc_hd__fill_4
XFILLER_33_80 vccd1 vssd1 vccd1 vssd1 sky130_ef_sc_hd__decap_40_12
XANTENNA__5536__A net228 vssd1 vssd1 vccd1 vccd1 sky130_fd_sc_hd__diode_2
XFILLER_8_487 vssd1 vssd1 vccd1 vccd1 sky130_fd_sc_hd__fill_1
X_4280_ net15 net426 net157 vssd1 vssd1 vccd1 vccd1 _0003_ sky130_fd_sc_hd__mux2_1
XFILLER_79_461 vssd1 vssd1 vccd1 vccd1 sky130_fd_sc_hd__fill_8
XANTENNA__5702__C net232 vssd1 vssd1 vccd1 vccd1 sky130_fd_sc_hd__diode_2
XFILLER_66_111 vssd1 vssd1 vccd1 vccd1 sky130_fd_sc_hd__fill_1
XFILLER_66_133 vssd1 vssd1 vccd1 vccd1 sky130_fd_sc_hd__fill_1
X_7970_ _3222_ _3223_ vssd1 vssd1 vccd1 vccd1 _3225_ sky130_fd_sc_hd__xnor2_1
XTAP_TAPCELL_ROW_65_846 vssd1 vccd1 sky130_fd_sc_hd__tapvpwrvgnd_1
X_6921_ _2009_ _2012_ _2011_ vssd1 vssd1 vccd1 vccd1 _2131_ sky130_fd_sc_hd__o21a_1
XFILLER_35_531 vccd1 vssd1 vccd1 vssd1 sky130_ef_sc_hd__decap_40_12
X_6852_ _2057_ _2058_ vssd1 vssd1 vccd1 vccd1 _2059_ sky130_fd_sc_hd__nand2_1
XFILLER_35_553 vssd1 vssd1 vccd1 vccd1 sky130_fd_sc_hd__fill_4
X_5803_ _0992_ vssd1 vssd1 vccd1 vccd1 _0993_ sky130_fd_sc_hd__inv_2
XANTENNA__7926__A net322 vssd1 vssd1 vccd1 vccd1 sky130_fd_sc_hd__diode_2
X_6783_ _1982_ _1983_ vssd1 vssd1 vccd1 vccd1 _1985_ sky130_fd_sc_hd__nand2_1
X_5734_ _0878_ _0884_ _0916_ _0921_ vssd1 vssd1 vccd1 vccd1 _0924_ sky130_fd_sc_hd__a211oi_1
XTAP_TAPCELL_ROW_20_404 vssd1 vccd1 sky130_fd_sc_hd__tapvpwrvgnd_1
X_8453_ clknet_4_7_0_clk _0041_ net333 vssd1 vssd1 vccd1 vccd1 PID_INST.k2_calc.sum_reg\[9\]
+ sky130_fd_sc_hd__dfrtp_1
X_5665_ _0766_ _0853_ _0854_ vssd1 vssd1 vccd1 vccd1 _0855_ sky130_fd_sc_hd__or3_1
XFILLER_30_291 vssd1 vssd1 vccd1 vccd1 sky130_fd_sc_hd__fill_1
X_7404_ _2641_ _2642_ vssd1 vssd1 vccd1 vccd1 _2643_ sky130_fd_sc_hd__nor2_1
XANTENNA_fanout211_A net212 vssd1 vssd1 vccd1 vccd1 sky130_fd_sc_hd__diode_2
X_4616_ net120 net86 net84 net113 vssd1 vssd1 vccd1 vccd1 _3894_ sky130_fd_sc_hd__a22o_1
X_8384_ clknet_4_9_0_clk PID_INST.k3_calc.d2.y\[4\] net328 vssd1 vssd1 vccd1 vccd1
+ PID_INST.k3_calc.timescaling_term\[4\] sky130_fd_sc_hd__dfrtp_1
X_5596_ net243 net306 _0785_ vssd1 vssd1 vccd1 vccd1 _0786_ sky130_fd_sc_hd__and3_1
X_7335_ _2567_ _2568_ vssd1 vssd1 vccd1 vccd1 _2570_ sky130_fd_sc_hd__nor2_1
XANTENNA__4372__A0 net209 vssd1 vssd1 vccd1 vccd1 sky130_fd_sc_hd__diode_2
X_4547_ PID_INST.k1_calc.d1.x\[9\] PID_INST.k3_calc.prev_error\[9\] vssd1 vssd1 vccd1
+ vccd1 _3825_ sky130_fd_sc_hd__or2_1
XFILLER_89_225 vccd1 vssd1 vccd1 vssd1 sky130_ef_sc_hd__decap_40_12
XFILLER_89_214 vssd1 vssd1 vccd1 vccd1 sky130_fd_sc_hd__fill_8
X_4478_ _3752_ _3755_ vssd1 vssd1 vccd1 vccd1 _3756_ sky130_fd_sc_hd__nor2_1
X_7266_ _2427_ _2494_ vssd1 vssd1 vccd1 vccd1 _2496_ sky130_fd_sc_hd__xnor2_1
XFILLER_89_258 vssd1 vssd1 vccd1 vccd1 sky130_fd_sc_hd__fill_1
X_6217_ _1294_ _1405_ vssd1 vssd1 vccd1 vccd1 _1406_ sky130_fd_sc_hd__xnor2_1
X_7197_ _2054_ _2160_ _2163_ vssd1 vssd1 vccd1 vccd1 _2424_ sky130_fd_sc_hd__a21bo_1
XANTENNA__5872__B1 net299 vssd1 vssd1 vccd1 vccd1 sky130_fd_sc_hd__diode_2
XANTENNA_fanout299_X net299 vssd1 vssd1 vccd1 vccd1 sky130_fd_sc_hd__diode_2
X_6148_ net164 _3799_ _1130_ _1129_ vssd1 vssd1 vccd1 vccd1 _1337_ sky130_fd_sc_hd__a31o_1
XFILLER_85_453 vssd1 vssd1 vccd1 vccd1 sky130_fd_sc_hd__fill_2
X_6079_ _0791_ _0794_ _0786_ vssd1 vssd1 vccd1 vccd1 _1269_ sky130_fd_sc_hd__o21a_1
XFILLER_57_155 vssd1 vssd1 vccd1 vccd1 sky130_fd_sc_hd__fill_1
XFILLER_57_199 vssd1 vssd1 vccd1 vccd1 sky130_fd_sc_hd__fill_1
XFILLER_26_531 vssd1 vssd1 vccd1 vccd1 sky130_fd_sc_hd__fill_1
XFILLER_38_380 vssd1 vssd1 vccd1 vccd1 sky130_fd_sc_hd__fill_2
XFILLER_54_46 vssd1 vssd1 vccd1 vccd1 sky130_fd_sc_hd__fill_8
XFILLER_26_553 vssd1 vssd1 vccd1 vccd1 sky130_fd_sc_hd__fill_2
XTAP_TAPCELL_ROW_0_195 vssd1 vccd1 sky130_fd_sc_hd__tapvpwrvgnd_1
XFILLER_80_180 vssd1 vssd1 vccd1 vccd1 sky130_fd_sc_hd__fill_1
XFILLER_13_258 vssd1 vssd1 vccd1 vccd1 sky130_fd_sc_hd__fill_1
XFILLER_41_545 vssd1 vssd1 vccd1 vccd1 sky130_fd_sc_hd__fill_1
XFILLER_70_34 vssd1 vssd1 vccd1 vccd1 sky130_fd_sc_hd__fill_2
XFILLER_21_291 vssd1 vssd1 vccd1 vccd1 sky130_fd_sc_hd__fill_1
XFILLER_5_457 vssd1 vssd1 vccd1 vccd1 sky130_fd_sc_hd__fill_8
XANTENNA__6104__A1 net156 vssd1 vssd1 vccd1 vccd1 sky130_fd_sc_hd__diode_2
XANTENNA__6618__C net232 vssd1 vssd1 vccd1 vccd1 sky130_fd_sc_hd__diode_2
XTAP_TAPCELL_ROW_8_284 vssd1 vccd1 sky130_fd_sc_hd__tapvpwrvgnd_1
XFILLER_88_280 vssd1 vssd1 vccd1 vccd1 sky130_fd_sc_hd__fill_2
XFILLER_0_195 vssd1 vssd1 vccd1 vccd1 sky130_fd_sc_hd__fill_1
XFILLER_63_169 vssd1 vssd1 vccd1 vccd1 sky130_fd_sc_hd__fill_1
XTAP_TAPCELL_ROW_62_816 vssd1 vccd1 sky130_fd_sc_hd__tapvpwrvgnd_1
XFILLER_51_309 vssd1 vssd1 vccd1 vccd1 sky130_fd_sc_hd__fill_1
XFILLER_17_542 vssd1 vssd1 vccd1 vccd1 sky130_fd_sc_hd__fill_2
XFILLER_44_361 vssd1 vssd1 vccd1 vccd1 sky130_fd_sc_hd__fill_2
XFILLER_32_512 vssd1 vssd1 vccd1 vccd1 sky130_fd_sc_hd__fill_8
XFILLER_8_251 vssd1 vssd1 vccd1 vccd1 sky130_fd_sc_hd__fill_1
X_5450_ _0626_ _0638_ vssd1 vssd1 vccd1 vccd1 _0640_ sky130_fd_sc_hd__xnor2_1
XFILLER_12_291 vssd1 vssd1 vccd1 vccd1 sky130_fd_sc_hd__fill_8
XANTENNA__5266__A net123 vssd1 vssd1 vccd1 vccd1 sky130_fd_sc_hd__diode_2
X_4401_ net191 net10 vssd1 vssd1 vccd1 vccd1 _3692_ sky130_fd_sc_hd__or2_1
X_5381_ _0558_ _0570_ vssd1 vssd1 vccd1 vccd1 _0571_ sky130_fd_sc_hd__xnor2_1
X_7120_ _2334_ _2339_ vssd1 vssd1 vccd1 vccd1 _2341_ sky130_fd_sc_hd__xnor2_1
X_4332_ _3504_ _3515_ _3493_ vssd1 vssd1 vccd1 vccd1 _3537_ sky130_fd_sc_hd__a21oi_1
X_7051_ _2268_ _2269_ vssd1 vssd1 vccd1 vccd1 _2270_ sky130_fd_sc_hd__nor2_1
Xfanout208 PID_INST.k2_calc.sum_reg\[11\] vssd1 vssd1 vccd1 vccd1 net208 sky130_fd_sc_hd__clkbuf_2
Xfanout219 net221 vssd1 vssd1 vccd1 vccd1 net219 sky130_fd_sc_hd__buf_2
X_4263_ PID_INST.pid.curr_state\[3\] PID_INST.pid.curr_state\[2\] vssd1 vssd1 vccd1
+ vccd1 _2823_ sky130_fd_sc_hd__nor2_1
XANTENNA__7631__D net209 vssd1 vssd1 vccd1 vccd1 sky130_fd_sc_hd__diode_2
Xclkbuf_4_7_0_clk clknet_0_clk vssd1 vssd1 vccd1 vccd1 clknet_4_7_0_clk sky130_fd_sc_hd__clkbuf_8
X_6002_ net104 net42 vssd1 vssd1 vccd1 vccd1 _1192_ sky130_fd_sc_hd__nor2_1
XANTENNA__4329__B net16 vssd1 vssd1 vccd1 vccd1 sky130_fd_sc_hd__diode_2
X_4194_ _2083_ vssd1 vssd1 vccd1 vccd1 PID_INST.k3_calc.d1.y\[7\] sky130_fd_sc_hd__inv_2
XFILLER_39_111 vssd1 vssd1 vccd1 vccd1 sky130_fd_sc_hd__fill_1
XTAP_TAPCELL_ROW_78_982 vssd1 vccd1 sky130_fd_sc_hd__tapvpwrvgnd_1
XPHY_EDGE_ROW_19_Left_112 vssd1 vssd1 vccd1 vccd1 sky130_fd_sc_hd__decap_3
XFILLER_39_177 vccd1 vssd1 vccd1 vssd1 sky130_ef_sc_hd__decap_40_12
X_7953_ _3194_ _3195_ _3206_ vssd1 vssd1 vccd1 vccd1 _3208_ sky130_fd_sc_hd__a21oi_1
XFILLER_27_328 vssd1 vssd1 vccd1 vccd1 sky130_fd_sc_hd__fill_4
X_6904_ net410 _2113_ net155 vssd1 vssd1 vccd1 vccd1 _0064_ sky130_fd_sc_hd__mux2_1
XFILLER_35_350 vssd1 vssd1 vccd1 vccd1 sky130_fd_sc_hd__fill_1
XFILLER_42_309 vccd1 vssd1 vccd1 vssd1 sky130_ef_sc_hd__decap_40_12
XFILLER_23_512 vssd1 vssd1 vccd1 vccd1 sky130_fd_sc_hd__fill_1
X_7884_ _3137_ _3138_ vssd1 vssd1 vccd1 vccd1 _3139_ sky130_fd_sc_hd__nor2_1
XFILLER_23_545 vssd1 vssd1 vccd1 vccd1 sky130_fd_sc_hd__fill_1
XFILLER_23_556 vssd1 vssd1 vccd1 vccd1 sky130_fd_sc_hd__fill_4
XFILLER_24_27 vssd1 vssd1 vccd1 vccd1 sky130_fd_sc_hd__fill_1
X_6835_ PID_INST.k3_calc.d2.y\[2\] _1581_ _1582_ vssd1 vssd1 vccd1 vccd1 _2041_ sky130_fd_sc_hd__and3_1
X_6766_ net211 net287 _1966_ vssd1 vssd1 vccd1 vccd1 _1967_ sky130_fd_sc_hd__and3_1
X_5717_ _0897_ _0905_ vssd1 vssd1 vccd1 vccd1 _0907_ sky130_fd_sc_hd__xor2_1
XPHY_EDGE_ROW_28_Left_121 vssd1 vssd1 vccd1 vccd1 sky130_fd_sc_hd__decap_3
X_6697_ _1893_ _1894_ vssd1 vssd1 vccd1 vccd1 _1895_ sky130_fd_sc_hd__xor2_2
XANTENNA__5607__C net210 vssd1 vssd1 vccd1 vccd1 sky130_fd_sc_hd__diode_2
XANTENNA_fanout214_X net214 vssd1 vssd1 vccd1 vccd1 sky130_fd_sc_hd__diode_2
X_5648_ _0825_ _0829_ vssd1 vssd1 vccd1 vccd1 _0838_ sky130_fd_sc_hd__xor2_1
X_8436_ clknet_4_4_0_clk net395 net331 vssd1 vssd1 vccd1 vccd1 PID_INST.k3_calc.prev_error\[8\]
+ sky130_fd_sc_hd__dfrtp_1
X_5579_ _0768_ vssd1 vssd1 vccd1 vccd1 _0769_ sky130_fd_sc_hd__inv_2
X_8367_ clknet_4_1_0_clk _0003_ net326 vssd1 vssd1 vccd1 vccd1 PID_INST.k1_calc.d1.x\[3\]
+ sky130_fd_sc_hd__dfrtp_1
X_8298_ net272 net187 _3214_ vssd1 vssd1 vccd1 vccd1 _3572_ sky130_fd_sc_hd__a21oi_1
XFILLER_6_7 vssd1 vssd1 vccd1 vccd1 sky130_fd_sc_hd__fill_1
X_7318_ _2400_ _2470_ _2469_ vssd1 vssd1 vccd1 vccd1 _2552_ sky130_fd_sc_hd__a21oi_1
X_7249_ _2399_ _2477_ vssd1 vssd1 vccd1 vccd1 _2479_ sky130_fd_sc_hd__xor2_1
XFILLER_49_57 vssd1 vssd1 vccd1 vccd1 sky130_fd_sc_hd__fill_2
XFILLER_58_431 vssd1 vssd1 vccd1 vccd1 sky130_fd_sc_hd__fill_8
XTAP_TAPCELL_ROW_5_254 vssd1 vccd1 sky130_fd_sc_hd__tapvpwrvgnd_1
XPHY_EDGE_ROW_37_Left_130 vssd1 vssd1 vccd1 vccd1 sky130_fd_sc_hd__decap_3
XFILLER_92_209 vccd1 vssd1 vccd1 vssd1 sky130_ef_sc_hd__decap_40_12
XFILLER_58_475 vssd1 vssd1 vccd1 vccd1 sky130_fd_sc_hd__fill_1
XANTENNA__5910__Y _1100_ vssd1 vssd1 vccd1 vccd1 sky130_fd_sc_hd__diode_2
XFILLER_18_306 vssd1 vssd1 vccd1 vccd1 sky130_fd_sc_hd__fill_2
XFILLER_85_272 vssd1 vssd1 vccd1 vccd1 sky130_fd_sc_hd__fill_1
XFILLER_58_497 vssd1 vssd1 vccd1 vccd1 sky130_fd_sc_hd__fill_2
XTAP_TAPCELL_ROW_86_1059 vssd1 vccd1 sky130_fd_sc_hd__tapvpwrvgnd_1
XFILLER_45_169 vssd1 vssd1 vccd1 vccd1 sky130_fd_sc_hd__fill_4
XFILLER_26_383 vssd1 vssd1 vccd1 vccd1 sky130_fd_sc_hd__fill_8
XFILLER_60_139 vssd1 vssd1 vccd1 vccd1 sky130_fd_sc_hd__fill_1
XFILLER_81_77 vssd1 vssd1 vccd1 vccd1 sky130_fd_sc_hd__fill_2
XFILLER_81_55 vssd1 vssd1 vccd1 vccd1 sky130_fd_sc_hd__fill_1
XFILLER_41_353 vssd1 vssd1 vccd1 vccd1 sky130_fd_sc_hd__fill_4
XFILLER_14_71 vssd1 vssd1 vccd1 vccd1 sky130_fd_sc_hd__fill_4
XFILLER_5_210 vssd1 vssd1 vccd1 vccd1 sky130_fd_sc_hd__fill_1
XFILLER_53_9 vssd1 vssd1 vccd1 vccd1 sky130_fd_sc_hd__fill_1
XANTENNA__6629__B net193 vssd1 vssd1 vccd1 vccd1 sky130_fd_sc_hd__diode_2
XANTENNA__5533__B net296 vssd1 vssd1 vccd1 vccd1 sky130_fd_sc_hd__diode_2
XANTENNA__8107__A1_N net294 vssd1 vssd1 vccd1 vccd1 sky130_fd_sc_hd__diode_2
XFILLER_49_442 vssd1 vssd1 vccd1 vccd1 sky130_fd_sc_hd__fill_4
Xinput8 gpio_in[15] vssd1 vssd1 vccd1 vccd1 net8 sky130_fd_sc_hd__buf_2
XFILLER_76_272 vssd1 vssd1 vccd1 vccd1 sky130_fd_sc_hd__fill_2
XTAP_TAPCELL_ROW_75_952 vssd1 vccd1 sky130_fd_sc_hd__tapvpwrvgnd_1
XFILLER_64_445 vssd1 vssd1 vccd1 vccd1 sky130_fd_sc_hd__fill_4
XFILLER_36_169 vssd1 vssd1 vccd1 vccd1 sky130_fd_sc_hd__fill_2
XFILLER_91_297 vssd1 vssd1 vccd1 vccd1 sky130_fd_sc_hd__fill_1
XFILLER_51_128 vssd1 vssd1 vccd1 vccd1 sky130_fd_sc_hd__fill_2
X_4950_ _0138_ _0139_ vssd1 vssd1 vccd1 vccd1 _0140_ sky130_fd_sc_hd__and2b_1
XTAP_TAPCELL_ROW_19_389 vssd1 vccd1 sky130_fd_sc_hd__tapvpwrvgnd_1
X_4881_ _4093_ _4158_ vssd1 vssd1 vccd1 vccd1 _4159_ sky130_fd_sc_hd__xor2_1
XANTENNA__7476__A net286 vssd1 vssd1 vccd1 vccd1 sky130_fd_sc_hd__diode_2
X_6620_ _1810_ _1811_ vssd1 vssd1 vccd1 vccd1 _1812_ sky130_fd_sc_hd__nor2_1
XANTENNA__7195__B net58 vssd1 vssd1 vccd1 vccd1 sky130_fd_sc_hd__diode_2
X_6551_ _1735_ _1736_ vssd1 vssd1 vccd1 vccd1 _1738_ sky130_fd_sc_hd__xnor2_2
X_5502_ _0691_ vssd1 vssd1 vccd1 vccd1 _0692_ sky130_fd_sc_hd__inv_2
X_6482_ _1661_ _1662_ _1668_ vssd1 vssd1 vccd1 vccd1 _1670_ sky130_fd_sc_hd__a21o_1
X_8221_ net293 net181 vssd1 vssd1 vccd1 vccd1 _3489_ sky130_fd_sc_hd__nand2_1
X_5433_ _0591_ _0615_ _0618_ vssd1 vssd1 vccd1 vccd1 _0623_ sky130_fd_sc_hd__a21o_1
XANTENNA__8069__A1 net205 vssd1 vssd1 vccd1 vccd1 sky130_fd_sc_hd__diode_2
XANTENNA__8069__B2 net209 vssd1 vssd1 vccd1 vccd1 sky130_fd_sc_hd__diode_2
X_8152_ _3292_ _3297_ _3300_ vssd1 vssd1 vccd1 vccd1 _3415_ sky130_fd_sc_hd__a21bo_1
XFILLER_10_29 vssd1 vssd1 vccd1 vccd1 sky130_fd_sc_hd__fill_2
X_5364_ net107 net51 vssd1 vssd1 vccd1 vccd1 _0554_ sky130_fd_sc_hd__nor2_1
XANTENNA__6619__A2 net232 vssd1 vssd1 vccd1 vccd1 sky130_fd_sc_hd__diode_2
X_7103_ net230 net234 net258 net254 vssd1 vssd1 vccd1 vccd1 _2324_ sky130_fd_sc_hd__and4_1
X_4315_ net245 net159 _3321_ _3343_ vssd1 vssd1 vccd1 vccd1 _0033_ sky130_fd_sc_hd__a22o_1
XANTENNA__7361__D net262 vssd1 vssd1 vccd1 vccd1 sky130_fd_sc_hd__diode_2
X_8083_ net298 PID_INST.k2_calc.sum_reg\[23\] vssd1 vssd1 vccd1 vccd1 _3341_ sky130_fd_sc_hd__nand2_1
X_5295_ net166 net85 _0484_ vssd1 vssd1 vccd1 vccd1 _0485_ sky130_fd_sc_hd__and3_1
XFILLER_87_559 vssd1 vssd1 vccd1 vccd1 sky130_fd_sc_hd__fill_1
X_7034_ _2246_ _2251_ vssd1 vssd1 vccd1 vccd1 _2252_ sky130_fd_sc_hd__nand2b_1
X_4246_ net4 net168 _2633_ vssd1 vssd1 vccd1 vccd1 _2644_ sky130_fd_sc_hd__o21ai_2
X_4177_ PID_INST.k3_calc.kd_term\[12\] net175 vssd1 vssd1 vccd1 vccd1 _1912_ sky130_fd_sc_hd__or2_1
XTAP_TAPCELL_ROW_2_224 vssd1 vccd1 sky130_fd_sc_hd__tapvpwrvgnd_1
XFILLER_27_125 vssd1 vssd1 vccd1 vccd1 sky130_fd_sc_hd__fill_2
XFILLER_82_253 vssd1 vssd1 vccd1 vccd1 sky130_fd_sc_hd__fill_2
X_7936_ _3185_ _3190_ vssd1 vssd1 vccd1 vccd1 _3191_ sky130_fd_sc_hd__nand2_1
XFILLER_70_404 vssd1 vssd1 vccd1 vccd1 sky130_fd_sc_hd__fill_1
XFILLER_15_309 vssd1 vssd1 vccd1 vccd1 sky130_fd_sc_hd__fill_2
XFILLER_23_320 vssd1 vssd1 vccd1 vccd1 sky130_fd_sc_hd__fill_4
X_7867_ net92 net48 vssd1 vssd1 vccd1 vccd1 _3122_ sky130_fd_sc_hd__nor2_1
X_6818_ _2002_ _2022_ vssd1 vssd1 vccd1 vccd1 _2023_ sky130_fd_sc_hd__or2_1
XANTENNA_fanout331_X net331 vssd1 vssd1 vccd1 vccd1 sky130_fd_sc_hd__diode_2
XANTENNA__6004__B1 net105 vssd1 vssd1 vccd1 vccd1 sky130_fd_sc_hd__diode_2
X_7798_ net90 net53 vssd1 vssd1 vccd1 vccd1 _3054_ sky130_fd_sc_hd__nor2_1
X_6749_ _1948_ _1947_ vssd1 vssd1 vccd1 vccd1 _1949_ sky130_fd_sc_hd__and2b_1
XFILLER_11_559 vssd1 vssd1 vccd1 vccd1 sky130_fd_sc_hd__fill_1
X_8419_ clknet_4_9_0_clk net131 net326 vssd1 vssd1 vccd1 vccd1 PID_INST.k3_calc.kd_term\[7\]
+ sky130_fd_sc_hd__dfrtp_1
XFILLER_2_235 vccd1 vssd1 vccd1 vssd1 sky130_ef_sc_hd__decap_40_12
XFILLER_2_257 vssd1 vssd1 vccd1 vccd1 sky130_fd_sc_hd__fill_1
XANTENNA_fanout77_X net77 vssd1 vssd1 vccd1 vccd1 sky130_fd_sc_hd__diode_2
XFILLER_58_261 vssd1 vssd1 vccd1 vccd1 sky130_fd_sc_hd__fill_1
XFILLER_46_445 vccd1 vssd1 vccd1 vssd1 sky130_ef_sc_hd__decap_40_12
XTAP_TAPCELL_ROW_72_922 vssd1 vccd1 sky130_fd_sc_hd__tapvpwrvgnd_1
XFILLER_73_275 vssd1 vssd1 vccd1 vccd1 sky130_fd_sc_hd__fill_4
XFILLER_46_489 vssd1 vssd1 vccd1 vccd1 sky130_fd_sc_hd__fill_1
XFILLER_14_320 vssd1 vssd1 vccd1 vccd1 sky130_fd_sc_hd__fill_2
XFILLER_33_139 vssd1 vssd1 vccd1 vccd1 sky130_fd_sc_hd__fill_1
XTAP_TAPCELL_ROW_16_359 vssd1 vccd1 sky130_fd_sc_hd__tapvpwrvgnd_1
XANTENNA__7727__C net256 vssd1 vssd1 vccd1 vccd1 sky130_fd_sc_hd__diode_2
XANTENNA__5263__B _0088_ vssd1 vssd1 vccd1 vccd1 sky130_fd_sc_hd__diode_2
X_5080_ net135 net84 vssd1 vssd1 vccd1 vccd1 _0270_ sky130_fd_sc_hd__nand2_1
XFILLER_2_41 vccd1 vssd1 vccd1 vssd1 sky130_ef_sc_hd__decap_40_12
XANTENNA__6375__A net129 vssd1 vssd1 vccd1 vccd1 sky130_fd_sc_hd__diode_2
XFILLER_2_85 vssd1 vssd1 vccd1 vccd1 sky130_fd_sc_hd__fill_4
XFILLER_64_220 vssd1 vssd1 vccd1 vccd1 sky130_fd_sc_hd__fill_4
XFILLER_37_456 vssd1 vssd1 vccd1 vccd1 sky130_fd_sc_hd__fill_8
XFILLER_64_253 vssd1 vssd1 vccd1 vccd1 sky130_fd_sc_hd__fill_4
X_5982_ _1171_ _1160_ vssd1 vssd1 vccd1 vccd1 _1172_ sky130_fd_sc_hd__nand2b_1
X_7721_ net322 PID_INST.k2_calc.sum_reg\[23\] vssd1 vssd1 vccd1 vccd1 _2977_ sky130_fd_sc_hd__nand2_1
X_4933_ _0120_ _0121_ vssd1 vssd1 vccd1 vccd1 _0123_ sky130_fd_sc_hd__xor2_1
XFILLER_24_139 vssd1 vssd1 vccd1 vccd1 sky130_fd_sc_hd__fill_1
X_7652_ net298 net185 net182 net310 vssd1 vssd1 vccd1 vccd1 _2905_ sky130_fd_sc_hd__a22oi_1
X_4864_ _4124_ _4141_ vssd1 vssd1 vccd1 vccd1 _4142_ sky130_fd_sc_hd__xnor2_1
XANTENNA__4342__B net18 vssd1 vssd1 vccd1 vccd1 sky130_fd_sc_hd__diode_2
X_4795_ _4053_ _4072_ vssd1 vssd1 vccd1 vccd1 _4073_ sky130_fd_sc_hd__or2_1
XANTENNA__5438__B net65 vssd1 vssd1 vccd1 vccd1 sky130_fd_sc_hd__diode_2
X_7583_ _2825_ _2831_ vssd1 vssd1 vccd1 vccd1 _2832_ sky130_fd_sc_hd__xnor2_1
X_6603_ _1781_ _1792_ vssd1 vssd1 vccd1 vccd1 _1793_ sky130_fd_sc_hd__xnor2_1
XANTENNA__7934__A net317 vssd1 vssd1 vccd1 vccd1 sky130_fd_sc_hd__diode_2
X_6534_ net131 net69 _1720_ vssd1 vssd1 vccd1 vccd1 _1721_ sky130_fd_sc_hd__nand3_1
XANTENNA_fanout124_A net125 vssd1 vssd1 vccd1 vccd1 sky130_fd_sc_hd__diode_2
XFILLER_21_17 vssd1 vssd1 vccd1 vccd1 sky130_fd_sc_hd__fill_2
X_6465_ _1644_ _1652_ vssd1 vssd1 vccd1 vccd1 _1653_ sky130_fd_sc_hd__xnor2_1
X_8204_ net281 net276 net187 net185 vssd1 vssd1 vccd1 vccd1 _3471_ sky130_fd_sc_hd__and4_1
XANTENNA__5454__A net105 vssd1 vssd1 vccd1 vccd1 sky130_fd_sc_hd__diode_2
X_5416_ _0588_ _0605_ vssd1 vssd1 vccd1 vccd1 _0606_ sky130_fd_sc_hd__nand2_1
X_6396_ net104 net39 vssd1 vssd1 vccd1 vccd1 _1584_ sky130_fd_sc_hd__nor2_1
X_8135_ _3241_ _3243_ _3240_ vssd1 vssd1 vccd1 vccd1 _3398_ sky130_fd_sc_hd__o21ba_1
X_5347_ _0450_ _0464_ _0448_ vssd1 vssd1 vccd1 vccd1 _0537_ sky130_fd_sc_hd__o21ba_1
XFILLER_87_334 vssd1 vssd1 vccd1 vccd1 sky130_fd_sc_hd__fill_2
X_8066_ _3179_ _3181_ _3178_ vssd1 vssd1 vccd1 vccd1 _3323_ sky130_fd_sc_hd__o21ba_1
X_5278_ _0465_ _0466_ vssd1 vssd1 vccd1 vccd1 _0468_ sky130_fd_sc_hd__xnor2_1
XFILLER_87_378 vssd1 vssd1 vccd1 vccd1 sky130_fd_sc_hd__fill_2
X_7017_ net234 net258 net254 net238 vssd1 vssd1 vccd1 vccd1 _2234_ sky130_fd_sc_hd__a22oi_1
X_4229_ net109 vssd1 vssd1 vccd1 vccd1 PID_INST.k3_calc.d2.y\[8\] sky130_fd_sc_hd__inv_2
XANTENNA__7017__A2 net258 vssd1 vssd1 vccd1 vccd1 sky130_fd_sc_hd__diode_2
XFILLER_55_242 vssd1 vssd1 vccd1 vccd1 sky130_fd_sc_hd__fill_8
XFILLER_46_58 vssd1 vssd1 vccd1 vccd1 sky130_fd_sc_hd__fill_1
XFILLER_28_456 vccd1 vssd1 vccd1 vssd1 sky130_ef_sc_hd__decap_40_12
XFILLER_15_106 vssd1 vssd1 vccd1 vccd1 sky130_fd_sc_hd__fill_4
XTAP_TAPCELL_ROW_83_1029 vssd1 vccd1 sky130_fd_sc_hd__tapvpwrvgnd_1
X_7919_ _2877_ _3110_ _3109_ vssd1 vssd1 vccd1 vccd1 _3174_ sky130_fd_sc_hd__a21oi_1
XANTENNA__4787__B1 _3734_ vssd1 vssd1 vccd1 vccd1 sky130_fd_sc_hd__diode_2
XANTENNA_fanout37_A _2147_ vssd1 vssd1 vccd1 vccd1 sky130_fd_sc_hd__diode_2
XFILLER_51_492 vssd1 vssd1 vccd1 vccd1 sky130_fd_sc_hd__fill_2
XTAP_TAPCELL_ROW_13_329 vssd1 vccd1 sky130_fd_sc_hd__tapvpwrvgnd_1
XFILLER_23_183 vssd1 vssd1 vccd1 vccd1 sky130_fd_sc_hd__fill_1
XANTENNA__5364__A net107 vssd1 vssd1 vccd1 vccd1 sky130_fd_sc_hd__diode_2
XANTENNA__8482__RESET_B net340 vssd1 vssd1 vccd1 vccd1 sky130_fd_sc_hd__diode_2
XFILLER_11_94 vssd1 vssd1 vccd1 vccd1 sky130_fd_sc_hd__fill_1
XFILLER_87_32 vssd1 vssd1 vccd1 vccd1 sky130_fd_sc_hd__fill_2
XFILLER_78_301 vssd1 vssd1 vccd1 vccd1 sky130_fd_sc_hd__fill_4
XANTENNA__8448__Q PID_INST.k2_calc.sum_reg\[4\] vssd1 vssd1 vccd1 vccd1 sky130_fd_sc_hd__diode_2
XFILLER_19_456 vssd1 vssd1 vccd1 vccd1 sky130_fd_sc_hd__fill_2
XANTENNA__6767__A1 net210 vssd1 vssd1 vccd1 vccd1 sky130_fd_sc_hd__diode_2
XTAP_TAPCELL_ROW_57_771 vssd1 vccd1 sky130_fd_sc_hd__tapvpwrvgnd_1
XFILLER_46_264 vssd1 vssd1 vccd1 vccd1 sky130_fd_sc_hd__fill_1
XFILLER_34_415 vssd1 vssd1 vccd1 vccd1 sky130_fd_sc_hd__fill_2
XFILLER_61_212 vssd1 vssd1 vccd1 vccd1 sky130_fd_sc_hd__fill_2
XTAP_TAPCELL_ROW_29_495 vssd1 vccd1 sky130_fd_sc_hd__tapvpwrvgnd_1
XFILLER_61_267 vssd1 vssd1 vccd1 vccd1 sky130_fd_sc_hd__fill_1
XANTENNA__6519__B2 net138 vssd1 vssd1 vccd1 vccd1 sky130_fd_sc_hd__diode_2
XANTENNA__5727__C1 net288 vssd1 vssd1 vccd1 vccd1 sky130_fd_sc_hd__diode_2
XANTENNA__8393__CLK clknet_4_9_0_clk vssd1 vssd1 vccd1 vccd1 sky130_fd_sc_hd__diode_2
XFILLER_42_492 vssd1 vssd1 vccd1 vccd1 sky130_fd_sc_hd__fill_1
XANTENNA__7754__A net198 vssd1 vssd1 vccd1 vccd1 sky130_fd_sc_hd__diode_2
Xinput11 gpio_in[1] vssd1 vssd1 vccd1 vccd1 net11 sky130_fd_sc_hd__dlymetal6s2s_1
X_4580_ _3776_ _3856_ _3857_ vssd1 vssd1 vccd1 vccd1 _3858_ sky130_fd_sc_hd__nand3_1
XFILLER_6_371 vssd1 vssd1 vccd1 vccd1 sky130_fd_sc_hd__fill_4
X_6250_ _1224_ _1236_ _1438_ vssd1 vssd1 vccd1 vccd1 _1439_ sky130_fd_sc_hd__o21ai_2
XANTENNA__7495__A2 net58 vssd1 vssd1 vccd1 vccd1 sky130_fd_sc_hd__diode_2
X_5201_ _0345_ _0390_ vssd1 vssd1 vccd1 vccd1 _0391_ sky130_fd_sc_hd__nor2_1
X_6181_ net129 _0156_ vssd1 vssd1 vccd1 vccd1 _1370_ sky130_fd_sc_hd__nand2_1
X_5132_ _0148_ _0320_ vssd1 vssd1 vccd1 vccd1 _0322_ sky130_fd_sc_hd__xnor2_1
X_5063_ _2178_ net71 vssd1 vssd1 vccd1 vccd1 _0253_ sky130_fd_sc_hd__nor2_1
XFILLER_84_359 vssd1 vssd1 vccd1 vccd1 sky130_fd_sc_hd__fill_4
XFILLER_84_348 vssd1 vssd1 vccd1 vccd1 sky130_fd_sc_hd__fill_2
XFILLER_16_17 vssd1 vssd1 vccd1 vccd1 sky130_fd_sc_hd__fill_2
XFILLER_25_404 vssd1 vssd1 vccd1 vccd1 sky130_fd_sc_hd__fill_1
XFILLER_80_543 vssd1 vssd1 vccd1 vccd1 sky130_fd_sc_hd__fill_4
XANTENNA__4769__B1 _3757_ vssd1 vssd1 vccd1 vccd1 sky130_fd_sc_hd__diode_2
XFILLER_16_39 vssd1 vssd1 vccd1 vccd1 sky130_fd_sc_hd__fill_2
X_5965_ _1144_ _1154_ vssd1 vssd1 vccd1 vccd1 _1155_ sky130_fd_sc_hd__xor2_2
X_7704_ _2716_ _2719_ _2958_ vssd1 vssd1 vccd1 vccd1 _2960_ sky130_fd_sc_hd__nor3b_1
X_5896_ _1068_ _1069_ vssd1 vssd1 vccd1 vccd1 _1086_ sky130_fd_sc_hd__xor2_1
XANTENNA_fanout241_A PID_INST.k2_calc.sum_reg\[2\] vssd1 vssd1 vccd1 vccd1 sky130_fd_sc_hd__diode_2
X_4916_ net127 net82 _0105_ vssd1 vssd1 vccd1 vccd1 _0106_ sky130_fd_sc_hd__and3_1
XANTENNA_fanout339_A PID_INST.add_three.n_rst vssd1 vssd1 vccd1 vccd1 sky130_fd_sc_hd__diode_2
X_7635_ _2885_ _2886_ vssd1 vssd1 vccd1 vccd1 _2888_ sky130_fd_sc_hd__xnor2_1
X_4847_ net138 net153 vssd1 vssd1 vccd1 vccd1 _4125_ sky130_fd_sc_hd__nand2_1
X_4778_ net137 net152 net150 net135 vssd1 vssd1 vccd1 vccd1 _4056_ sky130_fd_sc_hd__a22o_1
XANTENNA_fanout127_X net127 vssd1 vssd1 vccd1 vccd1 sky130_fd_sc_hd__diode_2
X_7566_ net411 _2814_ net155 vssd1 vssd1 vccd1 vccd1 _0068_ sky130_fd_sc_hd__mux2_1
X_6517_ _1532_ _1541_ _1702_ vssd1 vssd1 vccd1 vccd1 _1704_ sky130_fd_sc_hd__nand3_1
X_7497_ _2483_ _2741_ _2740_ vssd1 vssd1 vccd1 vccd1 _2742_ sky130_fd_sc_hd__a21oi_1
X_6448_ _1634_ _1635_ vssd1 vssd1 vccd1 vccd1 _1636_ sky130_fd_sc_hd__nand2_1
XFILLER_0_503 vssd1 vssd1 vccd1 vccd1 sky130_fd_sc_hd__fill_1
X_6379_ _1565_ _1566_ vssd1 vssd1 vccd1 vccd1 _1567_ sky130_fd_sc_hd__and2_1
X_8118_ _3378_ vssd1 vssd1 vccd1 vccd1 _3379_ sky130_fd_sc_hd__inv_2
XFILLER_57_57 vssd1 vssd1 vccd1 vccd1 sky130_fd_sc_hd__fill_4
X_8049_ _3302_ _3303_ vssd1 vssd1 vccd1 vccd1 _3304_ sky130_fd_sc_hd__nand2_1
XFILLER_75_348 vssd1 vssd1 vccd1 vccd1 sky130_fd_sc_hd__fill_1
XANTENNA__6743__A net215 vssd1 vssd1 vccd1 vccd1 sky130_fd_sc_hd__diode_2
XFILLER_28_253 vssd1 vssd1 vccd1 vccd1 sky130_fd_sc_hd__fill_4
XFILLER_43_223 vssd1 vssd1 vccd1 vccd1 sky130_fd_sc_hd__fill_1
XTAP_TAPCELL_ROW_54_741 vssd1 vccd1 sky130_fd_sc_hd__tapvpwrvgnd_1
XFILLER_43_256 vssd1 vssd1 vccd1 vccd1 sky130_fd_sc_hd__fill_2
XFILLER_43_267 vssd1 vssd1 vccd1 vccd1 sky130_fd_sc_hd__fill_1
XTAP_TAPCELL_ROW_26_465 vssd1 vccd1 sky130_fd_sc_hd__tapvpwrvgnd_1
XFILLER_31_429 vssd1 vssd1 vccd1 vccd1 sky130_fd_sc_hd__fill_2
XANTENNA__5972__A2 net70 vssd1 vssd1 vccd1 vccd1 sky130_fd_sc_hd__diode_2
XANTENNA__5078__B net87 vssd1 vssd1 vccd1 vccd1 sky130_fd_sc_hd__diode_2
XFILLER_7_113 vssd1 vssd1 vccd1 vccd1 sky130_fd_sc_hd__fill_2
XFILLER_11_164 vssd1 vssd1 vccd1 vccd1 sky130_fd_sc_hd__fill_4
XANTENNA__5185__B1 net78 vssd1 vssd1 vccd1 vccd1 sky130_fd_sc_hd__diode_2
XFILLER_11_186 vssd1 vssd1 vccd1 vccd1 sky130_fd_sc_hd__fill_8
XFILLER_11_197 vssd1 vssd1 vccd1 vccd1 sky130_fd_sc_hd__fill_2
XANTENNA__7477__A2 net195 vssd1 vssd1 vccd1 vccd1 sky130_fd_sc_hd__diode_2
XANTENNA__5488__A1 net103 vssd1 vssd1 vccd1 vccd1 sky130_fd_sc_hd__diode_2
XANTENNA__6918__A net137 vssd1 vssd1 vccd1 vccd1 sky130_fd_sc_hd__diode_2
XFILLER_66_326 vssd1 vssd1 vccd1 vccd1 sky130_fd_sc_hd__fill_8
XFILLER_66_304 vssd1 vssd1 vccd1 vccd1 sky130_fd_sc_hd__fill_4
XFILLER_74_392 vssd1 vssd1 vccd1 vccd1 sky130_fd_sc_hd__fill_1
XFILLER_62_521 vssd1 vssd1 vccd1 vccd1 sky130_fd_sc_hd__fill_1
XFILLER_62_510 vssd1 vssd1 vccd1 vccd1 sky130_fd_sc_hd__fill_2
XFILLER_34_256 vssd1 vssd1 vccd1 vccd1 sky130_fd_sc_hd__fill_4
XFILLER_34_267 vssd1 vssd1 vccd1 vccd1 sky130_fd_sc_hd__fill_1
X_5750_ net242 net312 net300 net234 vssd1 vssd1 vccd1 vccd1 _0940_ sky130_fd_sc_hd__and4_1
X_5681_ _0721_ _0727_ vssd1 vssd1 vccd1 vccd1 _0871_ sky130_fd_sc_hd__and2_1
X_4701_ _3786_ _3788_ _3785_ vssd1 vssd1 vccd1 vccd1 _3979_ sky130_fd_sc_hd__o21bai_1
X_7420_ net222 net257 net253 net226 vssd1 vssd1 vccd1 vccd1 _2659_ sky130_fd_sc_hd__a22oi_1
XTAP_TAPCELL_ROW_60_799 vssd1 vccd1 sky130_fd_sc_hd__tapvpwrvgnd_1
X_4632_ net124 net122 net152 net150 vssd1 vssd1 vccd1 vccd1 _3910_ sky130_fd_sc_hd__nand4_2
XANTENNA__4901__A net123 vssd1 vssd1 vccd1 vccd1 sky130_fd_sc_hd__diode_2
X_7351_ _2579_ _2585_ vssd1 vssd1 vccd1 vccd1 _2587_ sky130_fd_sc_hd__xnor2_1
X_4563_ _3823_ _3839_ _3840_ vssd1 vssd1 vccd1 vccd1 _3841_ sky130_fd_sc_hd__nand3_2
X_4494_ _3764_ _3765_ _3766_ _3771_ vssd1 vssd1 vccd1 vccd1 _3772_ sky130_fd_sc_hd__o31a_1
X_6302_ _1294_ _1405_ _1404_ vssd1 vssd1 vccd1 vccd1 _1490_ sky130_fd_sc_hd__a21o_1
X_7282_ _2183_ _2441_ _2440_ vssd1 vssd1 vccd1 vccd1 _2513_ sky130_fd_sc_hd__o21a_1
X_6233_ _1420_ _1421_ vssd1 vssd1 vccd1 vccd1 _1422_ sky130_fd_sc_hd__nor2_1
XFILLER_6_190 vssd1 vssd1 vccd1 vccd1 sky130_fd_sc_hd__fill_4
XANTENNA__4634__A2_N net88 vssd1 vssd1 vccd1 vccd1 sky130_fd_sc_hd__diode_2
X_6164_ _2019_ net72 net70 _2051_ vssd1 vssd1 vccd1 vccd1 _1353_ sky130_fd_sc_hd__o22a_1
XANTENNA_fanout191_A net192 vssd1 vssd1 vccd1 vccd1 sky130_fd_sc_hd__diode_2
X_6095_ _0883_ _0926_ _1101_ vssd1 vssd1 vccd1 vccd1 _1285_ sky130_fd_sc_hd__o21ai_1
X_5115_ _0230_ _0304_ vssd1 vssd1 vccd1 vccd1 _0305_ sky130_fd_sc_hd__xor2_1
X_5046_ _0234_ _0235_ vssd1 vssd1 vccd1 vccd1 _0236_ sky130_fd_sc_hd__xnor2_1
XTAP_TAPCELL_ROW_68_877 vssd1 vccd1 sky130_fd_sc_hd__tapvpwrvgnd_1
XFILLER_38_551 vssd1 vssd1 vccd1 vccd1 sky130_fd_sc_hd__fill_1
XANTENNA__5403__A1 net108 vssd1 vssd1 vccd1 vccd1 sky130_fd_sc_hd__diode_2
XFILLER_13_407 vccd1 vssd1 vccd1 vssd1 sky130_ef_sc_hd__decap_40_12
X_6997_ _2159_ _2212_ vssd1 vssd1 vccd1 vccd1 _2213_ sky130_fd_sc_hd__xnor2_1
XFILLER_80_395 vssd1 vssd1 vccd1 vccd1 sky130_fd_sc_hd__fill_4
XTAP_TAPCELL_ROW_51_711 vssd1 vccd1 sky130_fd_sc_hd__tapvpwrvgnd_1
XANTENNA__5403__B2 net105 vssd1 vssd1 vccd1 vccd1 sky130_fd_sc_hd__diode_2
XFILLER_13_429 vccd1 vssd1 vccd1 vssd1 sky130_ef_sc_hd__decap_40_12
X_5948_ net149 _3774_ vssd1 vssd1 vccd1 vccd1 _1138_ sky130_fd_sc_hd__nor2_1
XTAP_TAPCELL_ROW_23_435 vssd1 vccd1 sky130_fd_sc_hd__tapvpwrvgnd_1
X_5879_ _1057_ _1066_ vssd1 vssd1 vccd1 vccd1 _1069_ sky130_fd_sc_hd__xnor2_1
X_7618_ _2781_ _2797_ _2780_ vssd1 vssd1 vccd1 vccd1 _2870_ sky130_fd_sc_hd__a21oi_1
X_7549_ _2782_ _2795_ vssd1 vssd1 vccd1 vccd1 _2797_ sky130_fd_sc_hd__xnor2_1
XTAP_TAPCELL_ROW_91_1106 vssd1 vccd1 sky130_fd_sc_hd__tapvpwrvgnd_1
XANTENNA__6738__A net223 vssd1 vssd1 vccd1 vccd1 sky130_fd_sc_hd__diode_2
XANTENNA__6457__B net227 vssd1 vssd1 vccd1 vccd1 sky130_fd_sc_hd__diode_2
XFILLER_68_78 vssd1 vssd1 vccd1 vccd1 sky130_fd_sc_hd__fill_1
XFILLER_88_495 vssd1 vssd1 vccd1 vccd1 sky130_fd_sc_hd__fill_1
XFILLER_88_473 vssd1 vssd1 vccd1 vccd1 sky130_fd_sc_hd__fill_2
XANTENNA__5890__B2 net311 vssd1 vssd1 vccd1 vccd1 sky130_fd_sc_hd__diode_2
XFILLER_84_22 vssd1 vssd1 vccd1 vccd1 sky130_fd_sc_hd__fill_4
XFILLER_0_399 vssd1 vssd1 vccd1 vccd1 sky130_fd_sc_hd__fill_2
XFILLER_84_55 vssd1 vssd1 vccd1 vccd1 sky130_fd_sc_hd__fill_4
XANTENNA_input17_A gpio_in[7] vssd1 vssd1 vccd1 vccd1 sky130_fd_sc_hd__diode_2
XFILLER_90_115 vssd1 vssd1 vccd1 vccd1 sky130_fd_sc_hd__fill_1
XFILLER_90_159 vccd1 vssd1 vccd1 vssd1 sky130_ef_sc_hd__decap_40_12
XTAP_TAPCELL_ROW_39_590 vssd1 vccd1 sky130_fd_sc_hd__tapvpwrvgnd_1
XFILLER_16_267 vssd1 vssd1 vccd1 vccd1 sky130_fd_sc_hd__fill_2
XFILLER_8_400 vccd1 vssd1 vccd1 vssd1 sky130_ef_sc_hd__decap_40_12
XANTENNA__4721__A net74 vssd1 vssd1 vccd1 vccd1 sky130_fd_sc_hd__diode_2
XFILLER_12_484 vssd1 vssd1 vccd1 vccd1 sky130_fd_sc_hd__fill_1
XFILLER_33_92 vssd1 vssd1 vccd1 vccd1 sky130_fd_sc_hd__fill_2
XFILLER_69_7 vssd1 vssd1 vccd1 vccd1 sky130_fd_sc_hd__fill_2
XANTENNA__5536__B net306 vssd1 vssd1 vccd1 vccd1 sky130_fd_sc_hd__diode_2
XFILLER_8_477 vssd1 vssd1 vccd1 vccd1 sky130_fd_sc_hd__fill_4
XANTENNA__8431__CLK clknet_4_1_0_clk vssd1 vssd1 vccd1 vccd1 sky130_fd_sc_hd__diode_2
XANTENNA__5702__D net237 vssd1 vssd1 vccd1 vccd1 sky130_fd_sc_hd__diode_2
XFILLER_66_101 vssd1 vssd1 vccd1 vccd1 sky130_fd_sc_hd__fill_1
XFILLER_39_315 vssd1 vssd1 vccd1 vccd1 sky130_fd_sc_hd__fill_1
XFILLER_12_3 vccd1 vssd1 vccd1 vssd1 sky130_ef_sc_hd__decap_40_12
XFILLER_66_178 vssd1 vssd1 vccd1 vccd1 sky130_fd_sc_hd__fill_1
XFILLER_54_307 vssd1 vssd1 vccd1 vccd1 sky130_fd_sc_hd__fill_1
XTAP_TAPCELL_ROW_65_847 vssd1 vccd1 sky130_fd_sc_hd__tapvpwrvgnd_1
X_6920_ _2127_ _2129_ vssd1 vssd1 vccd1 vccd1 _2130_ sky130_fd_sc_hd__xnor2_1
X_6851_ net95 net61 _2056_ vssd1 vssd1 vccd1 vccd1 _2058_ sky130_fd_sc_hd__o21ai_1
X_5802_ net245 net296 net237 net308 vssd1 vssd1 vccd1 vccd1 _0992_ sky130_fd_sc_hd__and4_1
X_6782_ _1982_ _1983_ vssd1 vssd1 vccd1 vccd1 _1984_ sky130_fd_sc_hd__or2_1
XFILLER_22_237 vssd1 vssd1 vccd1 vccd1 sky130_fd_sc_hd__fill_1
X_5733_ _0916_ _0921_ _0878_ _0884_ vssd1 vssd1 vccd1 vccd1 _0923_ sky130_fd_sc_hd__o211a_1
XTAP_TAPCELL_ROW_20_405 vssd1 vccd1 sky130_fd_sc_hd__tapvpwrvgnd_1
X_8452_ clknet_4_6_0_clk _0040_ net337 vssd1 vssd1 vccd1 vccd1 PID_INST.k2_calc.sum_reg\[8\]
+ sky130_fd_sc_hd__dfrtp_1
X_5664_ _0836_ _0837_ _0852_ vssd1 vssd1 vccd1 vccd1 _0854_ sky130_fd_sc_hd__a21oi_1
X_7403_ _2393_ _2397_ _2640_ vssd1 vssd1 vccd1 vccd1 _2642_ sky130_fd_sc_hd__nor3_1
X_5595_ net215 net273 vssd1 vssd1 vccd1 vccd1 _0785_ sky130_fd_sc_hd__and2_1
X_4615_ _3887_ _3892_ vssd1 vssd1 vccd1 vccd1 _3893_ sky130_fd_sc_hd__xor2_1
X_8383_ clknet_4_11_0_clk PID_INST.k3_calc.d2.y\[3\] net340 vssd1 vssd1 vccd1 vccd1
+ PID_INST.k3_calc.timescaling_term\[3\] sky130_fd_sc_hd__dfrtp_1
X_7334_ net226 net230 net256 net254 vssd1 vssd1 vccd1 vccd1 _2568_ sky130_fd_sc_hd__and4_1
X_4546_ net126 net87 _3737_ _3819_ vssd1 vssd1 vccd1 vccd1 _3824_ sky130_fd_sc_hd__a31o_1
XFILLER_89_204 vssd1 vssd1 vccd1 vccd1 sky130_fd_sc_hd__fill_1
XANTENNA_fanout204_A PID_INST.k2_calc.sum_reg\[12\] vssd1 vssd1 vccd1 vccd1 sky130_fd_sc_hd__diode_2
XFILLER_89_237 vssd1 vssd1 vccd1 vccd1 sky130_fd_sc_hd__fill_8
X_4477_ _3745_ _3748_ _3744_ vssd1 vssd1 vccd1 vccd1 _3755_ sky130_fd_sc_hd__a21oi_1
X_7265_ _2427_ _2494_ vssd1 vssd1 vccd1 vccd1 _2495_ sky130_fd_sc_hd__nand2_1
X_7196_ _2420_ _2422_ vssd1 vssd1 vccd1 vccd1 _2423_ sky130_fd_sc_hd__xnor2_1
X_6216_ _1402_ _1403_ vssd1 vssd1 vccd1 vccd1 _1405_ sky130_fd_sc_hd__xor2_1
XFILLER_85_410 vssd1 vssd1 vccd1 vccd1 sky130_fd_sc_hd__fill_8
XANTENNA__5872__B2 net251 vssd1 vssd1 vccd1 vccd1 sky130_fd_sc_hd__diode_2
XANTENNA_input9_A gpio_in[16] vssd1 vssd1 vccd1 vccd1 sky130_fd_sc_hd__diode_2
X_6147_ _1334_ _1335_ vssd1 vssd1 vccd1 vccd1 _1336_ sky130_fd_sc_hd__nor2_1
XFILLER_85_443 vssd1 vssd1 vccd1 vccd1 sky130_fd_sc_hd__fill_4
XFILLER_85_432 vssd1 vssd1 vccd1 vccd1 sky130_fd_sc_hd__fill_4
XANTENNA_fanout194_X net194 vssd1 vssd1 vccd1 vccd1 sky130_fd_sc_hd__diode_2
XFILLER_85_487 vssd1 vssd1 vccd1 vccd1 sky130_fd_sc_hd__fill_1
X_6078_ _0833_ _0836_ _1266_ vssd1 vssd1 vccd1 vccd1 _1268_ sky130_fd_sc_hd__and3_1
XFILLER_57_178 vssd1 vssd1 vccd1 vccd1 sky130_fd_sc_hd__fill_1
XFILLER_45_318 vssd1 vssd1 vccd1 vccd1 sky130_fd_sc_hd__fill_8
XFILLER_72_104 vssd1 vssd1 vccd1 vccd1 sky130_fd_sc_hd__fill_1
X_5029_ _0217_ _0218_ vssd1 vssd1 vccd1 vccd1 _0219_ sky130_fd_sc_hd__or2_1
XTAP_TAPCELL_ROW_0_196 vssd1 vccd1 sky130_fd_sc_hd__tapvpwrvgnd_1
XTAP_TAPCELL_ROW_36_560 vssd1 vccd1 sky130_fd_sc_hd__tapvpwrvgnd_1
XFILLER_41_513 vssd1 vssd1 vccd1 vccd1 sky130_fd_sc_hd__fill_2
XANTENNA__7129__A1 net229 vssd1 vssd1 vccd1 vccd1 sky130_fd_sc_hd__diode_2
XFILLER_21_281 vssd1 vssd1 vccd1 vccd1 sky130_fd_sc_hd__fill_8
XFILLER_5_447 vssd1 vssd1 vccd1 vccd1 sky130_fd_sc_hd__fill_1
XFILLER_79_55 vssd1 vssd1 vccd1 vccd1 sky130_fd_sc_hd__fill_1
XANTENNA__8456__Q PID_INST.k2_calc.sum_reg\[12\] vssd1 vssd1 vccd1 vccd1 sky130_fd_sc_hd__diode_2
XTAP_TAPCELL_ROW_8_285 vssd1 vccd1 sky130_fd_sc_hd__tapvpwrvgnd_1
XFILLER_0_141 vccd1 vssd1 vccd1 vssd1 sky130_ef_sc_hd__decap_40_12
XANTENNA__4666__A2 net120 vssd1 vssd1 vccd1 vccd1 sky130_fd_sc_hd__diode_2
XFILLER_48_134 vssd1 vssd1 vccd1 vccd1 sky130_fd_sc_hd__fill_2
XFILLER_36_307 vssd1 vssd1 vccd1 vccd1 sky130_fd_sc_hd__fill_1
XTAP_TAPCELL_ROW_62_817 vssd1 vccd1 sky130_fd_sc_hd__tapvpwrvgnd_1
XANTENNA__5547__A _0734_ vssd1 vssd1 vccd1 vccd1 sky130_fd_sc_hd__diode_2
XANTENNA__5266__B _0156_ vssd1 vssd1 vccd1 vccd1 sky130_fd_sc_hd__diode_2
X_4400_ net191 net10 vssd1 vssd1 vccd1 vccd1 _3691_ sky130_fd_sc_hd__nand2_1
XFILLER_8_296 vssd1 vssd1 vccd1 vccd1 sky130_fd_sc_hd__fill_8
X_5380_ _0565_ _0569_ _0563_ vssd1 vssd1 vccd1 vccd1 _0570_ sky130_fd_sc_hd__o21a_1
X_4331_ _3493_ _3515_ vssd1 vssd1 vccd1 vccd1 _3526_ sky130_fd_sc_hd__and2_1
X_7050_ net212 net285 net280 net215 vssd1 vssd1 vccd1 vccd1 _2269_ sky130_fd_sc_hd__a22oi_1
Xfanout209 net213 vssd1 vssd1 vccd1 vccd1 net209 sky130_fd_sc_hd__buf_2
X_4262_ net176 PID_INST.pid.curr_state\[3\] vssd1 vssd1 vccd1 vccd1 _2813_ sky130_fd_sc_hd__or2_1
X_6001_ _1187_ _1188_ vssd1 vssd1 vccd1 vccd1 _1191_ sky130_fd_sc_hd__xnor2_1
X_4193_ net19 net173 _2072_ vssd1 vssd1 vccd1 vccd1 _2083_ sky130_fd_sc_hd__o21ai_4
XFILLER_39_156 vssd1 vssd1 vccd1 vccd1 sky130_fd_sc_hd__fill_1
XFILLER_39_167 vssd1 vssd1 vccd1 vccd1 sky130_fd_sc_hd__fill_1
XFILLER_82_413 vssd1 vssd1 vccd1 vccd1 sky130_fd_sc_hd__fill_2
XTAP_TAPCELL_ROW_78_983 vssd1 vccd1 sky130_fd_sc_hd__tapvpwrvgnd_1
X_7952_ _3194_ _3195_ _3206_ vssd1 vssd1 vccd1 vccd1 _3207_ sky130_fd_sc_hd__and3_1
XFILLER_39_189 vssd1 vssd1 vccd1 vccd1 sky130_fd_sc_hd__fill_8
X_6903_ _2111_ _2112_ vssd1 vssd1 vccd1 vccd1 _2113_ sky130_fd_sc_hd__xor2_1
X_7883_ _3064_ _3069_ _3063_ vssd1 vssd1 vccd1 vccd1 _3138_ sky130_fd_sc_hd__a21oi_1
XFILLER_62_192 vssd1 vssd1 vccd1 vccd1 sky130_fd_sc_hd__fill_2
XANTENNA__8477__CLK clknet_4_15_0_clk vssd1 vssd1 vccd1 vccd1 sky130_fd_sc_hd__diode_2
XTAP_TAPCELL_ROW_33_530 vssd1 vccd1 sky130_fd_sc_hd__tapvpwrvgnd_1
X_6834_ net112 net39 vssd1 vssd1 vccd1 vccd1 _2039_ sky130_fd_sc_hd__nor2_1
X_6765_ _1964_ _1965_ vssd1 vssd1 vccd1 vccd1 _1966_ sky130_fd_sc_hd__nor2_1
XANTENNA__4361__A net214 vssd1 vssd1 vccd1 vccd1 sky130_fd_sc_hd__diode_2
X_5716_ _0897_ _0905_ vssd1 vssd1 vccd1 vccd1 _0906_ sky130_fd_sc_hd__and2b_1
X_6696_ _1677_ _1680_ vssd1 vssd1 vccd1 vccd1 _1894_ sky130_fd_sc_hd__nor2_1
X_8435_ clknet_4_2_0_clk net397 net330 vssd1 vssd1 vccd1 vccd1 PID_INST.k3_calc.prev_error\[7\]
+ sky130_fd_sc_hd__dfrtp_1
XANTENNA__7672__A net198 vssd1 vssd1 vccd1 vccd1 sky130_fd_sc_hd__diode_2
XANTENNA__5607__D net220 vssd1 vssd1 vccd1 vccd1 sky130_fd_sc_hd__diode_2
X_5647_ _0794_ _0795_ _0835_ vssd1 vssd1 vccd1 vccd1 _0837_ sky130_fd_sc_hd__o21ai_1
XANTENNA_fanout207_X net207 vssd1 vssd1 vccd1 vccd1 sky130_fd_sc_hd__diode_2
X_5578_ net314 net215 net223 net302 vssd1 vssd1 vccd1 vccd1 _0768_ sky130_fd_sc_hd__a22o_1
X_8366_ clknet_4_0_0_clk _0002_ net327 vssd1 vssd1 vccd1 vccd1 PID_INST.k1_calc.d1.x\[2\]
+ sky130_fd_sc_hd__dfrtp_1
X_8297_ net272 net187 _3214_ vssd1 vssd1 vccd1 vccd1 _3571_ sky130_fd_sc_hd__and3_1
X_4529_ net128 net143 _3792_ _3793_ vssd1 vssd1 vccd1 vccd1 _3807_ sky130_fd_sc_hd__a22o_1
XFILLER_2_406 vccd1 vssd1 vccd1 vssd1 sky130_ef_sc_hd__decap_40_12
X_7317_ _2482_ _2549_ vssd1 vssd1 vccd1 vccd1 _2551_ sky130_fd_sc_hd__xor2_2
X_7248_ _2399_ _2477_ vssd1 vssd1 vccd1 vccd1 _2478_ sky130_fd_sc_hd__and2_1
XFILLER_77_207 vssd1 vssd1 vccd1 vccd1 sky130_fd_sc_hd__fill_4
XTAP_TAPCELL_ROW_5_255 vssd1 vccd1 sky130_fd_sc_hd__tapvpwrvgnd_1
X_7179_ PID_INST.k3_calc.d2.y\[2\] _2034_ _2035_ vssd1 vssd1 vccd1 vccd1 _2404_ sky130_fd_sc_hd__and3_1
XFILLER_85_240 vssd1 vssd1 vccd1 vccd1 sky130_fd_sc_hd__fill_4
XFILLER_58_487 vssd1 vssd1 vccd1 vccd1 sky130_fd_sc_hd__fill_1
XANTENNA__8436__RESET_B net331 vssd1 vssd1 vccd1 vccd1 sky130_fd_sc_hd__diode_2
XANTENNA__4281__A0 net16 vssd1 vssd1 vccd1 vccd1 sky130_fd_sc_hd__diode_2
XFILLER_81_490 vssd1 vssd1 vccd1 vccd1 sky130_fd_sc_hd__fill_2
XFILLER_14_61 vssd1 vssd1 vccd1 vccd1 sky130_fd_sc_hd__fill_2
XFILLER_41_398 vssd1 vssd1 vccd1 vccd1 sky130_fd_sc_hd__fill_4
XFILLER_5_222 vssd1 vssd1 vccd1 vccd1 sky130_fd_sc_hd__fill_2
XFILLER_68_207 vssd1 vssd1 vccd1 vccd1 sky130_fd_sc_hd__fill_1
XFILLER_76_251 vssd1 vssd1 vccd1 vccd1 sky130_fd_sc_hd__fill_1
XFILLER_49_476 vccd1 vssd1 vccd1 vssd1 sky130_ef_sc_hd__decap_40_12
XANTENNA_clkbuf_4_10_0_clk_X clknet_4_10_0_clk vssd1 vssd1 vccd1 vccd1 sky130_fd_sc_hd__diode_2
XFILLER_76_284 vssd1 vssd1 vccd1 vccd1 sky130_fd_sc_hd__fill_1
Xinput9 gpio_in[16] vssd1 vssd1 vccd1 vccd1 net9 sky130_fd_sc_hd__buf_2
XANTENNA__4446__A PID_INST.k1_calc.d1.x\[0\] vssd1 vssd1 vccd1 vccd1 sky130_fd_sc_hd__diode_2
XTAP_TAPCELL_ROW_75_953 vssd1 vccd1 sky130_fd_sc_hd__tapvpwrvgnd_1
XFILLER_64_468 vssd1 vssd1 vccd1 vccd1 sky130_fd_sc_hd__fill_2
XFILLER_36_137 vssd1 vssd1 vccd1 vccd1 sky130_fd_sc_hd__fill_2
XTAP_TAPCELL_ROW_47_666 vssd1 vccd1 sky130_fd_sc_hd__tapvpwrvgnd_1
X_4880_ net118 net58 vssd1 vssd1 vccd1 vccd1 _4158_ sky130_fd_sc_hd__nor2_1
XANTENNA__7476__B net195 vssd1 vssd1 vccd1 vccd1 sky130_fd_sc_hd__diode_2
XFILLER_20_505 vccd1 vssd1 vccd1 vssd1 sky130_ef_sc_hd__decap_40_12
XFILLER_32_365 vccd1 vssd1 vccd1 vssd1 sky130_ef_sc_hd__decap_40_12
XTAP_TAPCELL_ROW_30_500 vssd1 vccd1 sky130_fd_sc_hd__tapvpwrvgnd_1
X_6550_ _1735_ _1736_ vssd1 vssd1 vccd1 vccd1 _1737_ sky130_fd_sc_hd__nor2_1
X_5501_ net314 net224 net232 net303 vssd1 vssd1 vccd1 vccd1 _0691_ sky130_fd_sc_hd__a22o_1
X_6481_ _1661_ _1662_ _1668_ vssd1 vssd1 vccd1 vccd1 _1669_ sky130_fd_sc_hd__nand3_1
X_8220_ net310 net298 net179 PID_INST.k2_calc.sum_reg\[24\] vssd1 vssd1 vccd1 vccd1
+ _3488_ sky130_fd_sc_hd__and4_1
XANTENNA__5524__B1 net306 vssd1 vssd1 vccd1 vccd1 sky130_fd_sc_hd__diode_2
X_5432_ _0604_ _0620_ vssd1 vssd1 vccd1 vccd1 _0622_ sky130_fd_sc_hd__xnor2_1
XANTENNA__8069__A2 net256 vssd1 vssd1 vccd1 vccd1 sky130_fd_sc_hd__diode_2
X_8151_ _3311_ _3312_ _3314_ vssd1 vssd1 vccd1 vccd1 _3414_ sky130_fd_sc_hd__o21a_1
X_5363_ net105 net52 vssd1 vssd1 vccd1 vccd1 _0553_ sky130_fd_sc_hd__nor2_1
X_7102_ net230 net258 net254 net234 vssd1 vssd1 vccd1 vccd1 _2323_ sky130_fd_sc_hd__a22oi_1
X_4314_ net159 _3332_ vssd1 vssd1 vccd1 vccd1 _3343_ sky130_fd_sc_hd__nor2_1
X_8082_ _3339_ vssd1 vssd1 vccd1 vccd1 _3340_ sky130_fd_sc_hd__inv_2
X_5294_ _0407_ _0483_ _0482_ vssd1 vssd1 vccd1 vccd1 _0484_ sky130_fd_sc_hd__a21oi_1
X_7033_ _2249_ _2250_ vssd1 vssd1 vccd1 vccd1 _2251_ sky130_fd_sc_hd__xnor2_1
X_4245_ PID_INST.k3_calc.timescaling_term\[9\] net170 vssd1 vssd1 vccd1 vccd1 _2633_
+ sky130_fd_sc_hd__or2_1
XFILLER_67_251 vssd1 vssd1 vccd1 vccd1 sky130_fd_sc_hd__fill_4
X_4176_ net8 PID_INST.k3_calc.kd_term\[13\] net173 vssd1 vssd1 vccd1 vccd1 PID_INST.k3_calc.d1.y\[13\]
+ sky130_fd_sc_hd__mux2_1
XFILLER_55_424 vssd1 vssd1 vccd1 vccd1 sky130_fd_sc_hd__fill_2
XTAP_TAPCELL_ROW_2_225 vssd1 vccd1 sky130_fd_sc_hd__tapvpwrvgnd_1
X_7935_ _3188_ _3189_ vssd1 vssd1 vccd1 vccd1 _3190_ sky130_fd_sc_hd__xnor2_1
XANTENNA_fanout157_X net157 vssd1 vssd1 vccd1 vccd1 sky130_fd_sc_hd__diode_2
XFILLER_63_490 vssd1 vssd1 vccd1 vccd1 sky130_fd_sc_hd__fill_1
X_7866_ net90 net48 vssd1 vssd1 vccd1 vccd1 _3121_ sky130_fd_sc_hd__nor2_1
X_6817_ _2020_ _2021_ vssd1 vssd1 vccd1 vccd1 _2022_ sky130_fd_sc_hd__xnor2_1
XFILLER_11_505 vccd1 vssd1 vccd1 vssd1 sky130_ef_sc_hd__decap_40_12
XFILLER_23_354 vssd1 vssd1 vccd1 vccd1 sky130_fd_sc_hd__fill_1
X_7797_ _3051_ _3052_ vssd1 vssd1 vccd1 vccd1 _3053_ sky130_fd_sc_hd__nor2_2
XFILLER_50_173 vssd1 vssd1 vccd1 vccd1 sky130_fd_sc_hd__fill_2
X_6748_ _1855_ _1857_ _1854_ vssd1 vssd1 vccd1 vccd1 _1948_ sky130_fd_sc_hd__o21ba_1
X_6679_ _1640_ _1643_ _1641_ _0782_ vssd1 vssd1 vccd1 vccd1 _1876_ sky130_fd_sc_hd__o2bb2a_1
X_8418_ clknet_4_0_0_clk net129 net327 vssd1 vssd1 vccd1 vccd1 PID_INST.k3_calc.kd_term\[6\]
+ sky130_fd_sc_hd__dfrtp_1
XFILLER_2_214 vssd1 vssd1 vccd1 vccd1 sky130_fd_sc_hd__fill_8
X_8349_ net102 net96 net39 _1742_ vssd1 vssd1 vccd1 vccd1 _3627_ sky130_fd_sc_hd__or4_1
XFILLER_2_247 vssd1 vssd1 vccd1 vccd1 sky130_fd_sc_hd__fill_4
XFILLER_78_516 vccd1 vssd1 vccd1 vssd1 sky130_ef_sc_hd__decap_40_12
XANTENNA__6746__A net203 vssd1 vssd1 vccd1 vccd1 sky130_fd_sc_hd__diode_2
XANTENNA__8232__A2 net194 vssd1 vssd1 vccd1 vccd1 sky130_fd_sc_hd__diode_2
XFILLER_46_413 vssd1 vssd1 vccd1 vccd1 sky130_fd_sc_hd__fill_4
XFILLER_18_115 vssd1 vssd1 vccd1 vccd1 sky130_fd_sc_hd__fill_8
XFILLER_46_457 vssd1 vssd1 vccd1 vccd1 sky130_fd_sc_hd__fill_8
XTAP_TAPCELL_ROW_72_923 vssd1 vccd1 sky130_fd_sc_hd__tapvpwrvgnd_1
XFILLER_73_254 vssd1 vssd1 vccd1 vccd1 sky130_fd_sc_hd__fill_4
XFILLER_92_55 vssd1 vssd1 vccd1 vccd1 sky130_fd_sc_hd__fill_1
XFILLER_61_438 vssd1 vssd1 vccd1 vccd1 sky130_fd_sc_hd__fill_4
XTAP_TAPCELL_ROW_44_636 vssd1 vccd1 sky130_fd_sc_hd__tapvpwrvgnd_1
XFILLER_14_365 vssd1 vssd1 vccd1 vccd1 sky130_fd_sc_hd__fill_2
Xclkbuf_4_6_0_clk clknet_0_clk vssd1 vssd1 vccd1 vccd1 clknet_4_6_0_clk sky130_fd_sc_hd__clkbuf_8
XANTENNA__8201__A net305 vssd1 vssd1 vccd1 vccd1 sky130_fd_sc_hd__diode_2
XFILLER_6_531 vssd1 vssd1 vccd1 vccd1 sky130_fd_sc_hd__fill_1
XANTENNA__5544__B net308 vssd1 vssd1 vccd1 vccd1 sky130_fd_sc_hd__diode_2
XFILLER_2_53 vccd1 vssd1 vccd1 vssd1 sky130_ef_sc_hd__decap_40_12
XPHY_EDGE_ROW_10_Right_10 vssd1 vssd1 vccd1 vccd1 sky130_fd_sc_hd__decap_3
XFILLER_2_75 vssd1 vssd1 vccd1 vccd1 sky130_fd_sc_hd__fill_8
XFILLER_92_552 vssd1 vssd1 vccd1 vccd1 sky130_fd_sc_hd__fill_8
XPHY_EDGE_ROW_56_Left_149 vssd1 vssd1 vccd1 vccd1 sky130_fd_sc_hd__decap_3
XFILLER_52_405 vssd1 vssd1 vccd1 vccd1 sky130_fd_sc_hd__fill_1
X_5981_ _1168_ _1169_ vssd1 vssd1 vccd1 vccd1 _1171_ sky130_fd_sc_hd__xor2_1
X_7720_ _2974_ _2975_ vssd1 vssd1 vccd1 vccd1 _2976_ sky130_fd_sc_hd__nor2_1
X_4932_ _0120_ _0121_ vssd1 vssd1 vccd1 vccd1 _0122_ sky130_fd_sc_hd__nand2b_1
XFILLER_17_181 vssd1 vssd1 vccd1 vccd1 sky130_fd_sc_hd__fill_2
X_7651_ net311 net299 net185 net182 vssd1 vssd1 vccd1 vccd1 _2904_ sky130_fd_sc_hd__and4_1
X_4863_ _4139_ _4140_ vssd1 vssd1 vccd1 vccd1 _4141_ sky130_fd_sc_hd__nor2_1
X_6602_ _1782_ _1790_ vssd1 vssd1 vccd1 vccd1 _1792_ sky130_fd_sc_hd__xnor2_1
XFILLER_60_493 vssd1 vssd1 vccd1 vccd1 sky130_fd_sc_hd__fill_1
X_4794_ _4069_ _4070_ vssd1 vssd1 vccd1 vccd1 _4072_ sky130_fd_sc_hd__xor2_1
XFILLER_20_335 vssd1 vssd1 vccd1 vccd1 sky130_fd_sc_hd__fill_4
X_7582_ _2829_ _2830_ vssd1 vssd1 vccd1 vccd1 _2831_ sky130_fd_sc_hd__xnor2_1
XFILLER_32_195 vssd1 vssd1 vccd1 vccd1 sky130_fd_sc_hd__fill_1
XANTENNA__7493__Y _2737_ vssd1 vssd1 vccd1 vccd1 sky130_fd_sc_hd__diode_2
X_6533_ _1718_ _1719_ vssd1 vssd1 vccd1 vccd1 _1720_ sky130_fd_sc_hd__and2_1
X_6464_ _1649_ _1650_ vssd1 vssd1 vccd1 vccd1 _1652_ sky130_fd_sc_hd__xnor2_1
XFILLER_9_391 vssd1 vssd1 vccd1 vccd1 sky130_fd_sc_hd__fill_1
X_8203_ net276 net187 net185 net281 vssd1 vssd1 vccd1 vccd1 _3470_ sky130_fd_sc_hd__a22oi_1
XPHY_EDGE_ROW_65_Left_158 vssd1 vssd1 vccd1 vccd1 sky130_fd_sc_hd__decap_3
XANTENNA__5454__B net63 vssd1 vssd1 vccd1 vccd1 sky130_fd_sc_hd__diode_2
X_5415_ _0566_ _0587_ vssd1 vssd1 vccd1 vccd1 _0605_ sky130_fd_sc_hd__or2_1
XANTENNA_fanout117_A _2315_ vssd1 vssd1 vccd1 vccd1 sky130_fd_sc_hd__diode_2
X_6395_ _1581_ _1582_ vssd1 vssd1 vccd1 vccd1 _1583_ sky130_fd_sc_hd__nand2_1
X_8134_ _3394_ _3395_ vssd1 vssd1 vccd1 vccd1 _3396_ sky130_fd_sc_hd__nor2_1
XANTENNA__4482__A1_N net113 vssd1 vssd1 vccd1 vccd1 sky130_fd_sc_hd__diode_2
X_5346_ _0518_ _0534_ vssd1 vssd1 vccd1 vccd1 _0536_ sky130_fd_sc_hd__xnor2_1
X_8065_ _3319_ _3320_ vssd1 vssd1 vccd1 vccd1 _3322_ sky130_fd_sc_hd__nor2_1
X_5277_ _0466_ _0465_ vssd1 vssd1 vccd1 vccd1 _0467_ sky130_fd_sc_hd__nand2b_1
X_7016_ _2229_ _2230_ vssd1 vssd1 vccd1 vccd1 _2233_ sky130_fd_sc_hd__xnor2_1
X_4228_ net3 net168 _2442_ vssd1 vssd1 vccd1 vccd1 _2453_ sky130_fd_sc_hd__o21ai_2
XFILLER_68_560 vssd1 vssd1 vccd1 vccd1 sky130_fd_sc_hd__fill_2
XPHY_EDGE_ROW_74_Left_167 vssd1 vssd1 vccd1 vccd1 sky130_fd_sc_hd__decap_3
XFILLER_28_435 vssd1 vssd1 vccd1 vccd1 sky130_fd_sc_hd__fill_4
XFILLER_43_405 vssd1 vssd1 vccd1 vccd1 sky130_fd_sc_hd__fill_2
X_7918_ _2553_ _2557_ _2806_ _3172_ _2805_ vssd1 vssd1 vccd1 vccd1 _3173_ sky130_fd_sc_hd__a311o_1
XFILLER_43_449 vssd1 vssd1 vccd1 vccd1 sky130_fd_sc_hd__fill_4
XFILLER_15_129 vssd1 vssd1 vccd1 vccd1 sky130_fd_sc_hd__fill_1
XTAP_TAPCELL_ROW_41_606 vssd1 vccd1 sky130_fd_sc_hd__tapvpwrvgnd_1
XANTENNA__8005__B _3259_ vssd1 vssd1 vccd1 vccd1 sky130_fd_sc_hd__diode_2
X_7849_ _3103_ _3104_ vssd1 vssd1 vccd1 vccd1 _3105_ sky130_fd_sc_hd__nand2_1
XFILLER_11_335 vssd1 vssd1 vccd1 vccd1 sky130_fd_sc_hd__fill_1
XPHY_EDGE_ROW_83_Left_176 vssd1 vssd1 vccd1 vccd1 sky130_fd_sc_hd__decap_3
XFILLER_11_379 vssd1 vssd1 vccd1 vccd1 sky130_fd_sc_hd__fill_2
XANTENNA__5364__B net51 vssd1 vssd1 vccd1 vccd1 sky130_fd_sc_hd__diode_2
XFILLER_3_501 vssd1 vssd1 vccd1 vccd1 sky130_fd_sc_hd__fill_2
XFILLER_11_73 vssd1 vssd1 vccd1 vccd1 sky130_fd_sc_hd__fill_4
XFILLER_87_22 vssd1 vssd1 vccd1 vccd1 sky130_fd_sc_hd__fill_1
XFILLER_78_335 vssd1 vssd1 vccd1 vccd1 sky130_fd_sc_hd__fill_2
XPHY_EDGE_ROW_92_Left_185 vssd1 vssd1 vccd1 vccd1 sky130_fd_sc_hd__decap_3
XANTENNA__7413__B1 net209 vssd1 vssd1 vccd1 vccd1 sky130_fd_sc_hd__diode_2
XTAP_TAPCELL_ROW_57_772 vssd1 vccd1 sky130_fd_sc_hd__tapvpwrvgnd_1
XFILLER_34_405 vssd1 vssd1 vccd1 vccd1 sky130_fd_sc_hd__fill_1
XANTENNA__6767__A2 net287 vssd1 vssd1 vccd1 vccd1 sky130_fd_sc_hd__diode_2
XANTENNA__7738__C net183 vssd1 vssd1 vccd1 vccd1 sky130_fd_sc_hd__diode_2
XANTENNA__4778__A1 net137 vssd1 vssd1 vccd1 vccd1 sky130_fd_sc_hd__diode_2
XANTENNA__4778__B2 net135 vssd1 vssd1 vccd1 vccd1 sky130_fd_sc_hd__diode_2
XFILLER_36_81 vssd1 vssd1 vccd1 vccd1 sky130_fd_sc_hd__fill_2
XPHY_EDGE_ROW_1_Left_94 vssd1 vssd1 vccd1 vccd1 sky130_fd_sc_hd__decap_3
XFILLER_61_279 vssd1 vssd1 vccd1 vccd1 sky130_fd_sc_hd__fill_1
XFILLER_42_471 vssd1 vssd1 vccd1 vccd1 sky130_fd_sc_hd__fill_4
XANTENNA__5727__B1 net239 vssd1 vssd1 vccd1 vccd1 sky130_fd_sc_hd__diode_2
XFILLER_14_195 vssd1 vssd1 vccd1 vccd1 sky130_fd_sc_hd__fill_1
XANTENNA__7754__B net213 vssd1 vssd1 vccd1 vccd1 sky130_fd_sc_hd__diode_2
Xinput12 gpio_in[2] vssd1 vssd1 vccd1 vccd1 net12 sky130_fd_sc_hd__clkbuf_4
XFILLER_10_390 vssd1 vssd1 vccd1 vccd1 sky130_fd_sc_hd__fill_4
XFILLER_6_361 vssd1 vssd1 vccd1 vccd1 sky130_fd_sc_hd__fill_2
X_5200_ _0388_ _0389_ vssd1 vssd1 vccd1 vccd1 _0390_ sky130_fd_sc_hd__xnor2_1
X_6180_ _1162_ _1164_ _0521_ _1161_ vssd1 vssd1 vccd1 vccd1 _1369_ sky130_fd_sc_hd__a2bb2o_1
XFILLER_69_313 vssd1 vssd1 vccd1 vccd1 sky130_fd_sc_hd__fill_4
X_5131_ _0148_ _0320_ vssd1 vssd1 vccd1 vccd1 _0321_ sky130_fd_sc_hd__or2_1
XANTENNA__7652__B1 net182 vssd1 vssd1 vccd1 vccd1 sky130_fd_sc_hd__diode_2
X_5062_ _0250_ _0251_ vssd1 vssd1 vccd1 vccd1 _0252_ sky130_fd_sc_hd__nand2_1
XANTENNA__4618__B net79 vssd1 vssd1 vccd1 vccd1 sky130_fd_sc_hd__diode_2
XFILLER_77_390 vssd1 vssd1 vccd1 vccd1 sky130_fd_sc_hd__fill_2
XANTENNA__6207__A1 net108 vssd1 vssd1 vccd1 vccd1 sky130_fd_sc_hd__diode_2
XFILLER_92_393 vccd1 vssd1 vccd1 vssd1 sky130_ef_sc_hd__decap_40_12
XFILLER_80_533 vssd1 vssd1 vccd1 vccd1 sky130_fd_sc_hd__fill_2
XFILLER_25_449 vccd1 vssd1 vccd1 vssd1 sky130_ef_sc_hd__decap_40_12
X_7703_ _2716_ _2719_ _2958_ vssd1 vssd1 vccd1 vccd1 _2959_ sky130_fd_sc_hd__o21ba_1
XFILLER_52_246 vssd1 vssd1 vccd1 vccd1 sky130_fd_sc_hd__fill_1
X_5964_ _1145_ _1152_ vssd1 vssd1 vccd1 vccd1 _1154_ sky130_fd_sc_hd__xnor2_2
X_5895_ _1083_ _1084_ vssd1 vssd1 vccd1 vccd1 _1085_ sky130_fd_sc_hd__nand2_1
XANTENNA__4353__B net3 vssd1 vssd1 vccd1 vccd1 sky130_fd_sc_hd__diode_2
X_4915_ _2114_ _3774_ vssd1 vssd1 vccd1 vccd1 _0105_ sky130_fd_sc_hd__nor2_1
XANTENNA_fanout234_A PID_INST.k2_calc.sum_reg\[4\] vssd1 vssd1 vccd1 vccd1 sky130_fd_sc_hd__diode_2
X_7634_ net322 net179 vssd1 vssd1 vccd1 vccd1 _2886_ sky130_fd_sc_hd__nand2_1
X_4846_ _4062_ _4068_ _4061_ vssd1 vssd1 vccd1 vccd1 _4124_ sky130_fd_sc_hd__a21o_1
XFILLER_32_17 vssd1 vssd1 vccd1 vccd1 sky130_fd_sc_hd__fill_2
X_7565_ _2811_ _2812_ vssd1 vssd1 vccd1 vccd1 _2814_ sky130_fd_sc_hd__xor2_1
X_6516_ _1532_ _1541_ _1702_ vssd1 vssd1 vccd1 vccd1 _1703_ sky130_fd_sc_hd__a21o_1
XANTENNA__5465__A net103 vssd1 vssd1 vccd1 vccd1 sky130_fd_sc_hd__diode_2
X_4777_ _3967_ _4054_ vssd1 vssd1 vccd1 vccd1 _4055_ sky130_fd_sc_hd__nor2_1
X_7496_ net90 net55 vssd1 vssd1 vccd1 vccd1 _2741_ sky130_fd_sc_hd__nor2_1
X_6447_ _1620_ _1621_ _1633_ vssd1 vssd1 vccd1 vccd1 _1635_ sky130_fd_sc_hd__a21o_1
X_6378_ _1359_ _1361_ _1564_ vssd1 vssd1 vccd1 vccd1 _1566_ sky130_fd_sc_hd__or3_1
X_8117_ _3224_ _3226_ _3376_ _3377_ vssd1 vssd1 vccd1 vccd1 _3378_ sky130_fd_sc_hd__o211a_1
X_5329_ net121 net68 _0459_ _0458_ _0457_ vssd1 vssd1 vccd1 vccd1 _0519_ sky130_fd_sc_hd__a32o_1
X_8048_ _3290_ _3301_ vssd1 vssd1 vccd1 vccd1 _3303_ sky130_fd_sc_hd__or2_1
XFILLER_68_390 vssd1 vssd1 vccd1 vccd1 sky130_fd_sc_hd__fill_1
XFILLER_56_541 vssd1 vssd1 vccd1 vccd1 sky130_fd_sc_hd__fill_2
XANTENNA__6743__B net219 vssd1 vssd1 vccd1 vccd1 sky130_fd_sc_hd__diode_2
XFILLER_83_393 vssd1 vssd1 vccd1 vccd1 sky130_fd_sc_hd__fill_8
XTAP_TAPCELL_ROW_54_742 vssd1 vccd1 sky130_fd_sc_hd__tapvpwrvgnd_1
XFILLER_24_493 vssd1 vssd1 vccd1 vccd1 sky130_fd_sc_hd__fill_1
XANTENNA__8459__Q PID_INST.k2_calc.sum_reg\[15\] vssd1 vssd1 vccd1 vccd1 sky130_fd_sc_hd__diode_2
XFILLER_7_169 vssd1 vssd1 vccd1 vccd1 sky130_fd_sc_hd__fill_2
XFILLER_22_83 vssd1 vssd1 vccd1 vccd1 sky130_fd_sc_hd__fill_1
XFILLER_22_94 vccd1 vssd1 vccd1 vssd1 sky130_ef_sc_hd__decap_40_12
XANTENNA__5488__A2 net53 vssd1 vssd1 vccd1 vccd1 sky130_fd_sc_hd__diode_2
XANTENNA__7590__A net100 vssd1 vssd1 vccd1 vccd1 sky130_fd_sc_hd__diode_2
XFILLER_3_397 vssd1 vssd1 vccd1 vccd1 sky130_fd_sc_hd__fill_1
XFILLER_3_375 vssd1 vssd1 vccd1 vccd1 sky130_fd_sc_hd__fill_8
XANTENNA__6918__B _0087_ vssd1 vssd1 vccd1 vccd1 sky130_fd_sc_hd__diode_2
XFILLER_21_8 vssd1 vssd1 vccd1 vccd1 sky130_fd_sc_hd__fill_1
XFILLER_19_221 vssd1 vssd1 vccd1 vccd1 sky130_fd_sc_hd__fill_2
XANTENNA__4999__A1 net135 vssd1 vssd1 vccd1 vccd1 sky130_fd_sc_hd__diode_2
XFILLER_74_371 vssd1 vssd1 vccd1 vccd1 sky130_fd_sc_hd__fill_1
XFILLER_62_533 vssd1 vssd1 vccd1 vccd1 sky130_fd_sc_hd__fill_4
XFILLER_22_419 vssd1 vssd1 vccd1 vccd1 sky130_fd_sc_hd__fill_1
X_5680_ _0864_ _0869_ _0859_ vssd1 vssd1 vccd1 vccd1 _0870_ sky130_fd_sc_hd__a21oi_2
X_4700_ _3973_ _3977_ vssd1 vssd1 vccd1 vccd1 _3978_ sky130_fd_sc_hd__xor2_1
X_4631_ net124 net122 net152 net150 vssd1 vssd1 vccd1 vccd1 _3909_ sky130_fd_sc_hd__and4_1
XFILLER_30_474 vssd1 vssd1 vccd1 vccd1 sky130_fd_sc_hd__fill_2
XANTENNA__4901__B _4033_ vssd1 vssd1 vccd1 vccd1 sky130_fd_sc_hd__diode_2
X_7350_ _2579_ _2585_ vssd1 vssd1 vccd1 vccd1 _2586_ sky130_fd_sc_hd__nand2b_1
X_4562_ _3837_ _3838_ _3759_ vssd1 vssd1 vccd1 vccd1 _3840_ sky130_fd_sc_hd__a21o_1
XANTENNA__4923__B2 net138 vssd1 vssd1 vccd1 vccd1 sky130_fd_sc_hd__diode_2
X_4493_ _3770_ vssd1 vssd1 vccd1 vccd1 _3771_ sky130_fd_sc_hd__inv_2
X_6301_ _1409_ _1410_ _1408_ vssd1 vssd1 vccd1 vccd1 _1489_ sky130_fd_sc_hd__o21ai_2
X_7281_ _2085_ _2451_ _2454_ _2456_ vssd1 vssd1 vccd1 vccd1 _2512_ sky130_fd_sc_hd__a22o_1
X_6232_ net200 net250 net319 net258 vssd1 vssd1 vccd1 vccd1 _1421_ sky130_fd_sc_hd__and4_1
X_6163_ _1137_ _1138_ _1135_ vssd1 vssd1 vccd1 vccd1 _1352_ sky130_fd_sc_hd__a21o_1
XFILLER_69_176 vccd1 vssd1 vccd1 vssd1 sky130_ef_sc_hd__decap_40_12
XANTENNA__4348__B net19 vssd1 vssd1 vccd1 vccd1 sky130_fd_sc_hd__diode_2
X_6094_ _1282_ _1283_ vssd1 vssd1 vccd1 vccd1 _1284_ sky130_fd_sc_hd__and2_1
X_5114_ net111 net52 vssd1 vssd1 vccd1 vccd1 _0304_ sky130_fd_sc_hd__nor2_1
XFILLER_84_124 vssd1 vssd1 vccd1 vccd1 sky130_fd_sc_hd__fill_2
X_5045_ PID_INST.k1_calc.d1.x\[15\] PID_INST.k3_calc.prev_error\[15\] vssd1 vssd1
+ vccd1 vccd1 _0235_ sky130_fd_sc_hd__xor2_1
XFILLER_72_319 vssd1 vssd1 vccd1 vccd1 sky130_fd_sc_hd__fill_1
XTAP_TAPCELL_ROW_68_878 vssd1 vccd1 sky130_fd_sc_hd__tapvpwrvgnd_1
XANTENNA__5651__A2 net210 vssd1 vssd1 vccd1 vccd1 sky130_fd_sc_hd__diode_2
XFILLER_80_352 vccd1 vssd1 vccd1 vssd1 sky130_ef_sc_hd__decap_40_12
X_6996_ _2208_ _2209_ vssd1 vssd1 vccd1 vccd1 _2212_ sky130_fd_sc_hd__xnor2_1
XTAP_TAPCELL_ROW_51_712 vssd1 vccd1 sky130_fd_sc_hd__tapvpwrvgnd_1
XANTENNA__5403__A2 net53 vssd1 vssd1 vccd1 vccd1 sky130_fd_sc_hd__diode_2
XFILLER_13_419 vssd1 vssd1 vccd1 vccd1 sky130_fd_sc_hd__fill_4
XFILLER_25_279 vssd1 vssd1 vccd1 vccd1 sky130_fd_sc_hd__fill_1
X_5947_ _1135_ _1136_ vssd1 vssd1 vccd1 vccd1 _1137_ sky130_fd_sc_hd__nor2_1
XANTENNA__7675__A net297 vssd1 vssd1 vccd1 vccd1 sky130_fd_sc_hd__diode_2
XFILLER_43_49 vssd1 vssd1 vccd1 vccd1 sky130_fd_sc_hd__fill_4
X_5878_ _1021_ _1067_ vssd1 vssd1 vccd1 vccd1 _1068_ sky130_fd_sc_hd__nand2_1
XANTENNA_fanout237_X net237 vssd1 vssd1 vccd1 vccd1 sky130_fd_sc_hd__diode_2
X_7617_ _2852_ _2868_ vssd1 vssd1 vccd1 vccd1 _2869_ sky130_fd_sc_hd__xnor2_1
X_4829_ net121 net75 _4104_ _4106_ vssd1 vssd1 vccd1 vccd1 _4107_ sky130_fd_sc_hd__a31o_1
XFILLER_21_485 vssd1 vssd1 vccd1 vccd1 sky130_fd_sc_hd__fill_1
X_7548_ _2795_ _2782_ vssd1 vssd1 vccd1 vccd1 _2796_ sky130_fd_sc_hd__nand2b_1
X_7479_ _2714_ _2721_ vssd1 vssd1 vccd1 vccd1 _2722_ sky130_fd_sc_hd__nand2b_1
XFILLER_4_139 vssd1 vssd1 vccd1 vccd1 sky130_fd_sc_hd__fill_1
XTAP_TAPCELL_ROW_91_1107 vssd1 vccd1 sky130_fd_sc_hd__tapvpwrvgnd_1
XANTENNA__6738__B net273 vssd1 vssd1 vccd1 vccd1 sky130_fd_sc_hd__diode_2
XANTENNA_fanout97_A _2644_ vssd1 vssd1 vccd1 vccd1 sky130_fd_sc_hd__diode_2
XFILLER_88_452 vssd1 vssd1 vccd1 vccd1 sky130_fd_sc_hd__fill_2
XFILLER_0_378 vssd1 vssd1 vccd1 vccd1 sky130_fd_sc_hd__fill_4
XFILLER_75_113 vssd1 vssd1 vccd1 vccd1 sky130_fd_sc_hd__fill_8
XANTENNA__8383__CLK clknet_4_11_0_clk vssd1 vssd1 vccd1 vccd1 sky130_fd_sc_hd__diode_2
XFILLER_90_138 vssd1 vssd1 vccd1 vccd1 sky130_fd_sc_hd__fill_2
XFILLER_16_224 vccd1 vssd1 vccd1 vssd1 sky130_ef_sc_hd__decap_40_12
XFILLER_16_257 vssd1 vssd1 vccd1 vccd1 sky130_fd_sc_hd__fill_2
XTAP_TAPCELL_ROW_39_591 vssd1 vccd1 sky130_fd_sc_hd__tapvpwrvgnd_1
XFILLER_31_216 vssd1 vssd1 vccd1 vccd1 sky130_fd_sc_hd__fill_1
XFILLER_12_463 vssd1 vssd1 vccd1 vccd1 sky130_fd_sc_hd__fill_2
XFILLER_76_9 vccd1 vssd1 vccd1 vssd1 sky130_ef_sc_hd__decap_40_12
XANTENNA__4213__S net173 vssd1 vssd1 vccd1 vccd1 sky130_fd_sc_hd__diode_2
XANTENNA__6107__B1 net63 vssd1 vssd1 vccd1 vccd1 sky130_fd_sc_hd__diode_2
XFILLER_79_452 vssd1 vssd1 vccd1 vccd1 sky130_fd_sc_hd__fill_4
XANTENNA__6935__Y _2147_ vssd1 vssd1 vccd1 vccd1 sky130_fd_sc_hd__diode_2
XFILLER_79_496 vssd1 vssd1 vccd1 vccd1 sky130_fd_sc_hd__fill_8
Xhold1 PID_INST.k1_calc.d1.x\[15\] vssd1 vssd1 vccd1 vccd1 net394 sky130_fd_sc_hd__dlygate4sd3_1
XTAP_TAPCELL_ROW_65_848 vssd1 vccd1 sky130_fd_sc_hd__tapvpwrvgnd_1
XFILLER_47_360 vssd1 vssd1 vccd1 vccd1 sky130_fd_sc_hd__fill_8
X_6850_ net95 net61 _2056_ vssd1 vssd1 vccd1 vccd1 _2057_ sky130_fd_sc_hd__or3_1
X_5801_ _0982_ _0990_ _0978_ vssd1 vssd1 vccd1 vccd1 _0991_ sky130_fd_sc_hd__a21oi_2
X_6781_ _1893_ _1894_ _1891_ vssd1 vssd1 vccd1 vccd1 _1983_ sky130_fd_sc_hd__o21a_1
XFILLER_50_503 vssd1 vssd1 vccd1 vccd1 sky130_fd_sc_hd__fill_1
XPHY_EDGE_ROW_8_Right_8 vssd1 vssd1 vccd1 vccd1 sky130_fd_sc_hd__decap_3
X_5732_ _0916_ _0919_ _0920_ vssd1 vssd1 vccd1 vccd1 _0922_ sky130_fd_sc_hd__or3_1
X_8451_ clknet_4_6_0_clk _0039_ net337 vssd1 vssd1 vccd1 vccd1 PID_INST.k2_calc.sum_reg\[7\]
+ sky130_fd_sc_hd__dfrtp_1
X_5663_ _0836_ _0837_ _0852_ vssd1 vssd1 vccd1 vccd1 _0853_ sky130_fd_sc_hd__and3_1
XANTENNA__4190__Y _2051_ vssd1 vssd1 vccd1 vccd1 sky130_fd_sc_hd__diode_2
X_7402_ _2393_ _2397_ _2640_ vssd1 vssd1 vccd1 vccd1 _2641_ sky130_fd_sc_hd__o21a_1
X_5594_ net241 net308 vssd1 vssd1 vccd1 vccd1 _0784_ sky130_fd_sc_hd__nand2_1
X_4614_ net122 net144 _3890_ _3889_ vssd1 vssd1 vccd1 vccd1 _3892_ sky130_fd_sc_hd__a31o_1
X_8382_ clknet_4_11_0_clk PID_INST.k3_calc.d2.y\[2\] net340 vssd1 vssd1 vccd1 vccd1
+ PID_INST.k3_calc.timescaling_term\[2\] sky130_fd_sc_hd__dfrtp_1
X_7333_ net226 net257 net254 net230 vssd1 vssd1 vccd1 vccd1 _2567_ sky130_fd_sc_hd__a22oi_1
X_4545_ _3806_ _3821_ vssd1 vssd1 vccd1 vccd1 _3823_ sky130_fd_sc_hd__xnor2_1
X_4476_ _3741_ _3753_ vssd1 vssd1 vccd1 vccd1 _3754_ sky130_fd_sc_hd__xnor2_1
X_7264_ PID_INST.k3_calc.d2.y\[11\] _0301_ _0302_ vssd1 vssd1 vccd1 vccd1 _2494_ sky130_fd_sc_hd__and3_1
X_6215_ _1402_ _1403_ vssd1 vssd1 vccd1 vccd1 _1404_ sky130_fd_sc_hd__nor2_1
X_7195_ net93 net58 vssd1 vssd1 vccd1 vccd1 _2422_ sky130_fd_sc_hd__nor2_1
XPHY_EDGE_ROW_39_Right_39 vssd1 vssd1 vccd1 vccd1 sky130_fd_sc_hd__decap_3
XANTENNA__5872__A2 net316 vssd1 vssd1 vccd1 vccd1 sky130_fd_sc_hd__diode_2
X_6146_ net165 net83 _1333_ vssd1 vssd1 vccd1 vccd1 _1335_ sky130_fd_sc_hd__a21oi_1
XFILLER_85_455 vssd1 vssd1 vccd1 vccd1 sky130_fd_sc_hd__fill_1
XANTENNA_fanout187_X net187 vssd1 vssd1 vccd1 vccd1 sky130_fd_sc_hd__diode_2
X_6077_ _0833_ _0836_ _1266_ vssd1 vssd1 vccd1 vccd1 _1267_ sky130_fd_sc_hd__a21oi_2
XFILLER_72_116 vccd1 vssd1 vccd1 vssd1 sky130_ef_sc_hd__decap_40_12
X_5028_ _0078_ _0141_ _0140_ vssd1 vssd1 vccd1 vccd1 _0218_ sky130_fd_sc_hd__a21oi_1
XFILLER_26_511 vccd1 vssd1 vccd1 vssd1 sky130_ef_sc_hd__decap_40_12
XTAP_TAPCELL_ROW_88_1080 vssd1 vccd1 sky130_fd_sc_hd__tapvpwrvgnd_1
XFILLER_26_533 vccd1 vssd1 vccd1 vssd1 sky130_ef_sc_hd__decap_40_12
XTAP_TAPCELL_ROW_0_186 vssd1 vccd1 sky130_fd_sc_hd__tapvpwrvgnd_1
XTAP_TAPCELL_ROW_0_197 vssd1 vccd1 sky130_fd_sc_hd__tapvpwrvgnd_1
XFILLER_13_216 vssd1 vssd1 vccd1 vccd1 sky130_fd_sc_hd__fill_1
XTAP_TAPCELL_ROW_36_561 vssd1 vccd1 sky130_fd_sc_hd__tapvpwrvgnd_1
XFILLER_41_503 vssd1 vssd1 vccd1 vccd1 sky130_fd_sc_hd__fill_1
XPHY_EDGE_ROW_48_Right_48 vssd1 vssd1 vccd1 vccd1 sky130_fd_sc_hd__decap_3
XANTENNA__5918__A net100 vssd1 vssd1 vccd1 vccd1 sky130_fd_sc_hd__diode_2
X_6979_ _2190_ _2191_ vssd1 vssd1 vccd1 vccd1 _2193_ sky130_fd_sc_hd__and2_1
XFILLER_41_536 vssd1 vssd1 vccd1 vccd1 sky130_fd_sc_hd__fill_2
XFILLER_41_558 vssd1 vssd1 vccd1 vccd1 sky130_fd_sc_hd__fill_2
XANTENNA__7129__A2 net262 vssd1 vssd1 vccd1 vccd1 sky130_fd_sc_hd__diode_2
XFILLER_70_69 vssd1 vssd1 vccd1 vccd1 sky130_fd_sc_hd__fill_8
XANTENNA__5637__B net215 vssd1 vssd1 vccd1 vccd1 sky130_fd_sc_hd__diode_2
XFILLER_21_271 vssd1 vssd1 vccd1 vccd1 sky130_fd_sc_hd__fill_1
XFILLER_5_404 vccd1 vssd1 vccd1 vssd1 sky130_ef_sc_hd__decap_40_12
XFILLER_79_67 vssd1 vssd1 vccd1 vccd1 sky130_fd_sc_hd__fill_4
XPHY_EDGE_ROW_57_Right_57 vssd1 vssd1 vccd1 vccd1 sky130_fd_sc_hd__decap_3
XFILLER_0_153 vccd1 vssd1 vccd1 vssd1 sky130_ef_sc_hd__decap_40_12
XFILLER_76_444 vssd1 vssd1 vccd1 vccd1 sky130_fd_sc_hd__fill_1
XFILLER_17_511 vssd1 vssd1 vccd1 vccd1 sky130_fd_sc_hd__fill_4
XFILLER_91_447 vssd1 vssd1 vccd1 vccd1 sky130_fd_sc_hd__fill_1
XFILLER_17_533 vssd1 vssd1 vccd1 vccd1 sky130_fd_sc_hd__fill_2
XFILLER_17_544 vssd1 vssd1 vccd1 vccd1 sky130_fd_sc_hd__fill_1
XPHY_EDGE_ROW_66_Right_66 vssd1 vssd1 vccd1 vccd1 sky130_fd_sc_hd__decap_3
XTAP_TAPCELL_ROW_62_818 vssd1 vccd1 sky130_fd_sc_hd__tapvpwrvgnd_1
XFILLER_44_363 vssd1 vssd1 vccd1 vccd1 sky130_fd_sc_hd__fill_1
XFILLER_74_6 vccd1 vssd1 vccd1 vssd1 sky130_ef_sc_hd__decap_40_12
XFILLER_8_253 vssd1 vssd1 vccd1 vccd1 sky130_fd_sc_hd__fill_2
XANTENNA__6659__A net223 vssd1 vssd1 vccd1 vccd1 sky130_fd_sc_hd__diode_2
XPHY_EDGE_ROW_75_Right_75 vssd1 vssd1 vccd1 vccd1 sky130_fd_sc_hd__decap_3
XANTENNA__4354__A2 net19 vssd1 vssd1 vccd1 vccd1 sky130_fd_sc_hd__diode_2
X_4330_ net233 net16 vssd1 vssd1 vccd1 vccd1 _3515_ sky130_fd_sc_hd__or2_1
X_4261_ net177 _2792_ vssd1 vssd1 vccd1 vccd1 PID_INST.busy sky130_fd_sc_hd__and2_1
XFILLER_67_400 vssd1 vssd1 vccd1 vccd1 sky130_fd_sc_hd__fill_4
X_6000_ _0474_ _0472_ _0543_ _0544_ _1187_ vssd1 vssd1 vccd1 vccd1 _1190_ sky130_fd_sc_hd__a311o_1
XFILLER_79_293 vssd1 vssd1 vccd1 vccd1 sky130_fd_sc_hd__fill_1
X_4192_ PID_INST.k3_calc.kd_term\[7\] net175 vssd1 vssd1 vccd1 vccd1 _2072_ sky130_fd_sc_hd__or2_1
XPHY_EDGE_ROW_84_Right_84 vssd1 vssd1 vccd1 vccd1 sky130_fd_sc_hd__decap_3
XTAP_TAPCELL_ROW_78_984 vssd1 vccd1 sky130_fd_sc_hd__tapvpwrvgnd_1
X_7951_ _3196_ _3204_ vssd1 vssd1 vccd1 vccd1 _3206_ sky130_fd_sc_hd__xnor2_1
XFILLER_67_488 vssd1 vssd1 vccd1 vccd1 sky130_fd_sc_hd__fill_2
XFILLER_54_105 vssd1 vssd1 vccd1 vccd1 sky130_fd_sc_hd__fill_1
XFILLER_54_149 vccd1 vssd1 vccd1 vssd1 sky130_ef_sc_hd__decap_40_12
X_7882_ _3130_ _3136_ vssd1 vssd1 vccd1 vccd1 _3137_ sky130_fd_sc_hd__xnor2_1
X_6902_ _1897_ _1898_ _1896_ vssd1 vssd1 vccd1 vccd1 _2112_ sky130_fd_sc_hd__a21o_1
XANTENNA__4290__A1 net8 vssd1 vssd1 vccd1 vccd1 sky130_fd_sc_hd__diode_2
XFILLER_50_300 vssd1 vssd1 vccd1 vccd1 sky130_fd_sc_hd__fill_1
XFILLER_23_503 vssd1 vssd1 vccd1 vccd1 sky130_fd_sc_hd__fill_1
X_6833_ PID_INST.k3_calc.d2.y\[1\] _1740_ _1741_ vssd1 vssd1 vccd1 vccd1 _2038_ sky130_fd_sc_hd__and3_1
X_6764_ _1864_ _1867_ _1963_ vssd1 vssd1 vccd1 vccd1 _1965_ sky130_fd_sc_hd__and3_1
XFILLER_50_355 vssd1 vssd1 vccd1 vccd1 sky130_fd_sc_hd__fill_1
XFILLER_23_569 vssd1 vssd1 vccd1 vccd1 sky130_fd_sc_hd__fill_1
XANTENNA_fanout147_A _2389_ vssd1 vssd1 vccd1 vccd1 sky130_fd_sc_hd__diode_2
XTAP_TAPCELL_ROW_33_531 vssd1 vccd1 sky130_fd_sc_hd__tapvpwrvgnd_1
X_6695_ _1891_ _1892_ vssd1 vssd1 vccd1 vccd1 _1893_ sky130_fd_sc_hd__nand2_1
XANTENNA__4361__B net4 vssd1 vssd1 vccd1 vccd1 sky130_fd_sc_hd__diode_2
X_5715_ _0726_ _0904_ vssd1 vssd1 vccd1 vccd1 _0905_ sky130_fd_sc_hd__nor2_1
XANTENNA_fanout314_A net316 vssd1 vssd1 vccd1 vccd1 sky130_fd_sc_hd__diode_2
X_5646_ _0794_ _0795_ _0835_ vssd1 vssd1 vccd1 vccd1 _0836_ sky130_fd_sc_hd__or3_2
X_8434_ clknet_4_4_0_clk net399 net330 vssd1 vssd1 vccd1 vccd1 PID_INST.k3_calc.prev_error\[6\]
+ sky130_fd_sc_hd__dfrtp_1
XANTENNA__5176__C _3734_ vssd1 vssd1 vccd1 vccd1 sky130_fd_sc_hd__diode_2
XANTENNA__7672__B net282 vssd1 vssd1 vccd1 vccd1 sky130_fd_sc_hd__diode_2
X_5577_ net314 net302 net216 net223 vssd1 vssd1 vccd1 vccd1 _0767_ sky130_fd_sc_hd__and4_1
X_8365_ clknet_4_0_0_clk _0001_ net327 vssd1 vssd1 vccd1 vccd1 PID_INST.k1_calc.d1.x\[1\]
+ sky130_fd_sc_hd__dfrtp_1
X_8296_ net294 net180 _3473_ _3471_ vssd1 vssd1 vccd1 vccd1 _3570_ sky130_fd_sc_hd__a31o_1
XFILLER_2_429 vssd1 vssd1 vccd1 vccd1 sky130_fd_sc_hd__fill_2
X_4528_ _3797_ _3805_ vssd1 vssd1 vccd1 vccd1 _3806_ sky130_fd_sc_hd__xor2_1
X_7316_ _2549_ _2482_ vssd1 vssd1 vccd1 vccd1 _2550_ sky130_fd_sc_hd__nand2b_1
X_4459_ net124 net88 vssd1 vssd1 vccd1 vccd1 _3737_ sky130_fd_sc_hd__and2_1
X_7247_ _2475_ _2476_ vssd1 vssd1 vccd1 vccd1 _2477_ sky130_fd_sc_hd__xnor2_1
XFILLER_49_59 vssd1 vssd1 vccd1 vccd1 sky130_fd_sc_hd__fill_1
X_7178_ _2041_ _2150_ _2152_ _2149_ vssd1 vssd1 vccd1 vccd1 _2403_ sky130_fd_sc_hd__a22oi_2
X_6129_ _1104_ _1317_ vssd1 vssd1 vccd1 vccd1 _1318_ sky130_fd_sc_hd__nor2_1
XFILLER_73_447 vssd1 vssd1 vccd1 vccd1 sky130_fd_sc_hd__fill_1
XFILLER_26_330 vssd1 vssd1 vccd1 vccd1 sky130_fd_sc_hd__fill_1
XFILLER_14_514 vssd1 vssd1 vccd1 vccd1 sky130_fd_sc_hd__fill_8
XFILLER_26_341 vssd1 vssd1 vccd1 vccd1 sky130_fd_sc_hd__fill_2
XFILLER_41_311 vssd1 vssd1 vccd1 vccd1 sky130_fd_sc_hd__fill_2
XANTENNA__8476__RESET_B net341 vssd1 vssd1 vccd1 vccd1 sky130_fd_sc_hd__diode_2
XFILLER_14_569 vssd1 vssd1 vccd1 vccd1 sky130_fd_sc_hd__fill_1
XFILLER_81_79 vssd1 vssd1 vccd1 vccd1 sky130_fd_sc_hd__fill_1
XFILLER_41_388 vssd1 vssd1 vccd1 vccd1 sky130_fd_sc_hd__fill_1
XANTENNA__6479__A net220 vssd1 vssd1 vccd1 vccd1 sky130_fd_sc_hd__diode_2
XFILLER_49_433 vssd1 vssd1 vccd1 vccd1 sky130_fd_sc_hd__fill_1
XFILLER_39_92 vssd1 vssd1 vccd1 vccd1 sky130_fd_sc_hd__fill_2
XFILLER_76_263 vssd1 vssd1 vccd1 vccd1 sky130_fd_sc_hd__fill_2
XANTENNA__7103__A net230 vssd1 vssd1 vccd1 vccd1 sky130_fd_sc_hd__diode_2
XFILLER_64_403 vssd1 vssd1 vccd1 vccd1 sky130_fd_sc_hd__fill_1
XFILLER_49_488 vccd1 vssd1 vccd1 vssd1 sky130_ef_sc_hd__decap_40_12
XTAP_TAPCELL_ROW_75_954 vssd1 vccd1 sky130_fd_sc_hd__tapvpwrvgnd_1
XTAP_TAPCELL_ROW_47_667 vssd1 vccd1 sky130_fd_sc_hd__tapvpwrvgnd_1
XANTENNA__5558__A net227 vssd1 vssd1 vccd1 vccd1 sky130_fd_sc_hd__diode_2
XFILLER_44_193 vssd1 vssd1 vccd1 vccd1 sky130_fd_sc_hd__fill_2
XANTENNA__7210__A1 net99 vssd1 vssd1 vccd1 vccd1 sky130_fd_sc_hd__diode_2
XFILLER_20_517 vssd1 vssd1 vccd1 vccd1 sky130_fd_sc_hd__fill_8
XTAP_TAPCELL_ROW_30_501 vssd1 vccd1 sky130_fd_sc_hd__tapvpwrvgnd_1
XFILLER_32_377 vccd1 vssd1 vccd1 vssd1 sky130_ef_sc_hd__decap_40_12
X_5500_ net312 net300 net224 net232 vssd1 vssd1 vccd1 vccd1 _0690_ sky130_fd_sc_hd__and4_1
X_6480_ _1666_ _1667_ vssd1 vssd1 vccd1 vccd1 _1668_ sky130_fd_sc_hd__xnor2_1
XANTENNA__7923__D net201 vssd1 vssd1 vccd1 vccd1 sky130_fd_sc_hd__diode_2
X_5431_ _0620_ _0604_ vssd1 vssd1 vccd1 vccd1 _0621_ sky130_fd_sc_hd__nand2b_1
XANTENNA__5293__A net162 vssd1 vssd1 vccd1 vccd1 sky130_fd_sc_hd__diode_2
X_8150_ net420 _3413_ net155 vssd1 vssd1 vccd1 vccd1 _0072_ sky130_fd_sc_hd__mux2_1
X_5362_ _0329_ _0550_ vssd1 vssd1 vccd1 vccd1 _0552_ sky130_fd_sc_hd__xnor2_2
X_8081_ net298 net180 PID_INST.k2_calc.sum_reg\[23\] net310 vssd1 vssd1 vccd1 vccd1
+ _3339_ sky130_fd_sc_hd__a22o_1
X_7101_ _2319_ _2320_ vssd1 vssd1 vccd1 vccd1 _2322_ sky130_fd_sc_hd__xnor2_1
X_4313_ net251 net12 _3299_ _3310_ vssd1 vssd1 vccd1 vccd1 _3332_ sky130_fd_sc_hd__and4_1
X_7032_ net204 net292 vssd1 vssd1 vccd1 vccd1 _2250_ sky130_fd_sc_hd__nand2_1
X_5293_ net162 _3731_ _3732_ vssd1 vssd1 vccd1 vccd1 _0483_ sky130_fd_sc_hd__and3_1
X_4244_ net99 vssd1 vssd1 vccd1 vccd1 PID_INST.k3_calc.d2.y\[10\] sky130_fd_sc_hd__inv_2
XFILLER_19_29 vssd1 vssd1 vccd1 vccd1 sky130_fd_sc_hd__fill_8
X_4175_ net140 vssd1 vssd1 vccd1 vccd1 PID_INST.k3_calc.d2.y\[7\] sky130_fd_sc_hd__inv_2
XANTENNA__6252__A2 net273 vssd1 vssd1 vccd1 vccd1 sky130_fd_sc_hd__diode_2
XTAP_TAPCELL_ROW_85_1050 vssd1 vccd1 sky130_fd_sc_hd__tapvpwrvgnd_1
X_7934_ net317 PID_INST.k2_calc.sum_reg\[23\] vssd1 vssd1 vccd1 vccd1 _3189_ sky130_fd_sc_hd__nand2_1
X_7865_ net419 net154 vssd1 vssd1 vccd1 vccd1 _3120_ sky130_fd_sc_hd__nor2_1
X_7796_ _2963_ _2966_ _3050_ vssd1 vssd1 vccd1 vccd1 _3052_ sky130_fd_sc_hd__nor3_1
X_6816_ _1704_ _1709_ _1703_ vssd1 vssd1 vccd1 vccd1 _2021_ sky130_fd_sc_hd__a21boi_1
XFILLER_50_141 vssd1 vssd1 vccd1 vccd1 sky130_fd_sc_hd__fill_1
XTAP_TAPCELL_ROW_18_380 vssd1 vccd1 sky130_fd_sc_hd__tapvpwrvgnd_1
X_6747_ _1945_ _1946_ vssd1 vssd1 vccd1 vccd1 _1947_ sky130_fd_sc_hd__xnor2_1
XFILLER_11_517 vssd1 vssd1 vccd1 vccd1 sky130_fd_sc_hd__fill_8
X_6678_ _1873_ _1874_ vssd1 vssd1 vccd1 vccd1 _1875_ sky130_fd_sc_hd__nand2_1
XANTENNA_fanout317_X net317 vssd1 vssd1 vccd1 vccd1 sky130_fd_sc_hd__diode_2
X_5629_ _0812_ _0818_ vssd1 vssd1 vccd1 vccd1 _0819_ sky130_fd_sc_hd__nor2_1
X_8417_ clknet_4_0_0_clk net127 net328 vssd1 vssd1 vccd1 vccd1 PID_INST.k3_calc.kd_term\[5\]
+ sky130_fd_sc_hd__dfrtp_1
X_8348_ _3428_ _3625_ vssd1 vssd1 vccd1 vccd1 _3626_ sky130_fd_sc_hd__xnor2_1
XFILLER_78_528 vssd1 vssd1 vccd1 vccd1 sky130_fd_sc_hd__fill_4
X_8279_ _3427_ _3444_ _3442_ vssd1 vssd1 vccd1 vccd1 _3552_ sky130_fd_sc_hd__a21o_1
XANTENNA__6746__B net295 vssd1 vssd1 vccd1 vccd1 sky130_fd_sc_hd__diode_2
XANTENNA__5650__B net219 vssd1 vssd1 vccd1 vccd1 sky130_fd_sc_hd__diode_2
XFILLER_86_561 vssd1 vssd1 vccd1 vccd1 sky130_fd_sc_hd__fill_4
XFILLER_92_12 vccd1 vssd1 vccd1 vssd1 sky130_ef_sc_hd__decap_40_12
XTAP_TAPCELL_ROW_72_924 vssd1 vccd1 sky130_fd_sc_hd__tapvpwrvgnd_1
XTAP_TAPCELL_ROW_44_637 vssd1 vccd1 sky130_fd_sc_hd__tapvpwrvgnd_1
XFILLER_14_322 vssd1 vssd1 vccd1 vccd1 sky130_fd_sc_hd__fill_1
XANTENNA__7593__A net110 vssd1 vssd1 vccd1 vccd1 sky130_fd_sc_hd__diode_2
XFILLER_41_71 vssd1 vssd1 vccd1 vccd1 sky130_fd_sc_hd__fill_2
XANTENNA__6002__A net104 vssd1 vssd1 vccd1 vccd1 sky130_fd_sc_hd__diode_2
XFILLER_2_65 vssd1 vssd1 vccd1 vccd1 sky130_fd_sc_hd__fill_2
XFILLER_92_531 vssd1 vssd1 vccd1 vccd1 sky130_fd_sc_hd__fill_1
XFILLER_64_266 vssd1 vssd1 vccd1 vccd1 sky130_fd_sc_hd__fill_1
X_5980_ net125 net68 _1168_ vssd1 vssd1 vccd1 vccd1 _1170_ sky130_fd_sc_hd__nand3_1
X_4931_ _4126_ _4128_ vssd1 vssd1 vccd1 vccd1 _0121_ sky130_fd_sc_hd__nand2_1
XFILLER_24_119 vssd1 vssd1 vccd1 vccd1 sky130_fd_sc_hd__fill_4
X_7650_ _2659_ _2662_ _2660_ vssd1 vssd1 vccd1 vccd1 _2903_ sky130_fd_sc_hd__o21ba_1
XFILLER_60_450 vssd1 vssd1 vccd1 vccd1 sky130_fd_sc_hd__fill_2
XANTENNA__5288__A net107 vssd1 vssd1 vccd1 vccd1 sky130_fd_sc_hd__diode_2
X_4862_ _4133_ _4138_ vssd1 vssd1 vccd1 vccd1 _4140_ sky130_fd_sc_hd__and2_1
XFILLER_60_472 vssd1 vssd1 vccd1 vccd1 sky130_fd_sc_hd__fill_2
XTAP_TAPCELL_ROW_15_350 vssd1 vccd1 sky130_fd_sc_hd__tapvpwrvgnd_1
XFILLER_20_303 vssd1 vssd1 vccd1 vccd1 sky130_fd_sc_hd__fill_4
X_6601_ _1790_ _1782_ vssd1 vssd1 vccd1 vccd1 _1791_ sky130_fd_sc_hd__nand2b_1
X_4793_ _4070_ _4069_ vssd1 vssd1 vccd1 vccd1 _4071_ sky130_fd_sc_hd__nand2b_1
X_7581_ net101 net46 vssd1 vssd1 vccd1 vccd1 _2830_ sky130_fd_sc_hd__nor2_1
X_6532_ _2051_ _0157_ _1717_ vssd1 vssd1 vccd1 vccd1 _1719_ sky130_fd_sc_hd__o21ai_1
X_6463_ _1650_ _1649_ vssd1 vssd1 vccd1 vccd1 _1651_ sky130_fd_sc_hd__and2b_1
X_8202_ _3467_ _3468_ vssd1 vssd1 vccd1 vccd1 _3469_ sky130_fd_sc_hd__xor2_1
X_5414_ _0590_ _0596_ vssd1 vssd1 vccd1 vccd1 _0604_ sky130_fd_sc_hd__xnor2_1
X_8133_ _3392_ _3393_ _3237_ _3246_ vssd1 vssd1 vccd1 vccd1 _3395_ sky130_fd_sc_hd__o211a_1
X_6394_ _1190_ _1388_ _1389_ _1579_ _1580_ vssd1 vssd1 vccd1 vccd1 _1582_ sky130_fd_sc_hd__o2111ai_1
X_5345_ _0518_ _0534_ vssd1 vssd1 vccd1 vccd1 _0535_ sky130_fd_sc_hd__nand2_1
X_8064_ net322 net178 _3317_ _3318_ vssd1 vssd1 vccd1 vccd1 _3320_ sky130_fd_sc_hd__o2bb2a_1
X_5276_ _0388_ _0389_ _0391_ vssd1 vssd1 vccd1 vccd1 _0466_ sky130_fd_sc_hd__a21oi_1
XFILLER_87_358 vccd1 vssd1 vccd1 vssd1 sky130_ef_sc_hd__decap_40_12
X_7015_ _2230_ _2229_ vssd1 vssd1 vccd1 vccd1 _2232_ sky130_fd_sc_hd__nand2b_1
XANTENNA__4367__A net209 vssd1 vssd1 vccd1 vccd1 sky130_fd_sc_hd__diode_2
X_4227_ PID_INST.k3_calc.timescaling_term\[8\] net170 vssd1 vssd1 vccd1 vccd1 _2442_
+ sky130_fd_sc_hd__or2_1
XFILLER_28_403 vssd1 vssd1 vccd1 vccd1 sky130_fd_sc_hd__fill_1
XFILLER_28_414 vssd1 vssd1 vccd1 vccd1 sky130_fd_sc_hd__fill_4
XFILLER_55_266 vssd1 vssd1 vccd1 vccd1 sky130_fd_sc_hd__fill_2
X_7917_ _2879_ _3110_ vssd1 vssd1 vccd1 vccd1 _3172_ sky130_fd_sc_hd__nand2_1
XFILLER_36_491 vssd1 vssd1 vccd1 vccd1 sky130_fd_sc_hd__fill_1
X_7848_ _3101_ _3102_ vssd1 vssd1 vccd1 vccd1 _3104_ sky130_fd_sc_hd__nand2_1
XTAP_TAPCELL_ROW_41_607 vssd1 vccd1 sky130_fd_sc_hd__tapvpwrvgnd_1
X_7779_ _2935_ _2938_ _3033_ vssd1 vssd1 vccd1 vccd1 _3035_ sky130_fd_sc_hd__and3_1
XFILLER_51_494 vssd1 vssd1 vccd1 vccd1 sky130_fd_sc_hd__fill_1
XANTENNA__4539__A2 net86 vssd1 vssd1 vccd1 vccd1 sky130_fd_sc_hd__diode_2
XFILLER_23_196 vssd1 vssd1 vccd1 vccd1 sky130_fd_sc_hd__fill_2
XFILLER_3_513 vccd1 vssd1 vccd1 vssd1 sky130_ef_sc_hd__decap_40_12
XFILLER_87_34 vssd1 vssd1 vccd1 vccd1 sky130_fd_sc_hd__fill_1
XFILLER_3_557 vssd1 vssd1 vccd1 vccd1 sky130_fd_sc_hd__fill_2
XFILLER_2_3 vssd1 vssd1 vccd1 vccd1 sky130_fd_sc_hd__fill_8
XFILLER_78_369 vssd1 vssd1 vccd1 vccd1 sky130_fd_sc_hd__fill_4
XFILLER_66_509 vssd1 vssd1 vccd1 vccd1 sky130_fd_sc_hd__fill_1
XFILLER_59_561 vssd1 vssd1 vccd1 vccd1 sky130_fd_sc_hd__fill_8
XFILLER_74_542 vssd1 vssd1 vccd1 vccd1 sky130_fd_sc_hd__fill_4
XFILLER_19_436 vssd1 vssd1 vccd1 vccd1 sky130_fd_sc_hd__fill_4
XTAP_TAPCELL_ROW_57_773 vssd1 vccd1 sky130_fd_sc_hd__tapvpwrvgnd_1
XTAP_TAPCELL_ROW_29_486 vssd1 vccd1 sky130_fd_sc_hd__tapvpwrvgnd_1
XANTENNA__4724__B _4001_ vssd1 vssd1 vccd1 vccd1 sky130_fd_sc_hd__diode_2
XFILLER_36_93 vssd1 vssd1 vccd1 vccd1 sky130_fd_sc_hd__fill_8
XFILLER_14_141 vssd1 vssd1 vccd1 vccd1 sky130_fd_sc_hd__fill_4
XFILLER_42_450 vssd1 vssd1 vccd1 vccd1 sky130_fd_sc_hd__fill_1
XTAP_TAPCELL_ROW_12_320 vssd1 vccd1 sky130_fd_sc_hd__tapvpwrvgnd_1
XANTENNA__7754__C PID_INST.k2_calc.reg_lc\[13\] vssd1 vssd1 vccd1 vccd1 sky130_fd_sc_hd__diode_2
Xinput13 gpio_in[3] vssd1 vssd1 vccd1 vccd1 net13 sky130_fd_sc_hd__clkbuf_4
XFILLER_6_340 vssd1 vssd1 vccd1 vccd1 sky130_fd_sc_hd__fill_4
X_5130_ net116 net58 vssd1 vssd1 vccd1 vccd1 _0320_ sky130_fd_sc_hd__nor2_1
XFILLER_35_3 vssd1 vssd1 vccd1 vccd1 sky130_fd_sc_hd__fill_8
X_5061_ _2146_ net73 net77 net128 vssd1 vssd1 vccd1 vccd1 _0251_ sky130_fd_sc_hd__a2bb2o_1
XFILLER_65_542 vssd1 vssd1 vccd1 vccd1 sky130_fd_sc_hd__fill_2
XANTENNA__6207__A2 net44 vssd1 vssd1 vccd1 vccd1 sky130_fd_sc_hd__diode_2
XFILLER_52_203 vssd1 vssd1 vccd1 vccd1 sky130_fd_sc_hd__fill_2
XFILLER_16_19 vssd1 vssd1 vccd1 vccd1 sky130_fd_sc_hd__fill_1
X_5963_ _1152_ _1145_ vssd1 vssd1 vccd1 vccd1 _1153_ sky130_fd_sc_hd__nand2b_1
X_7702_ _2956_ _2957_ vssd1 vssd1 vccd1 vccd1 _2958_ sky130_fd_sc_hd__or2_1
XTAP_TAPCELL_ROW_82_1020 vssd1 vccd1 sky130_fd_sc_hd__tapvpwrvgnd_1
X_4914_ net124 net75 vssd1 vssd1 vccd1 vccd1 _0104_ sky130_fd_sc_hd__nand2_1
X_5894_ _1073_ _1075_ _1077_ vssd1 vssd1 vccd1 vccd1 _1084_ sky130_fd_sc_hd__o21ai_1
X_7633_ _2883_ _2884_ vssd1 vssd1 vccd1 vccd1 _2885_ sky130_fd_sc_hd__nor2_1
XFILLER_60_291 vssd1 vssd1 vccd1 vccd1 sky130_fd_sc_hd__fill_4
XFILLER_60_280 vssd1 vssd1 vccd1 vccd1 sky130_fd_sc_hd__fill_8
X_4845_ _4049_ _4121_ vssd1 vssd1 vccd1 vccd1 _4123_ sky130_fd_sc_hd__xor2_1
XFILLER_32_29 vssd1 vssd1 vccd1 vccd1 sky130_fd_sc_hd__fill_1
X_7564_ _2648_ _2649_ _2645_ vssd1 vssd1 vccd1 vccd1 _2812_ sky130_fd_sc_hd__o21ba_1
X_4776_ net137 net150 vssd1 vssd1 vccd1 vccd1 _4054_ sky130_fd_sc_hd__nand2_1
XANTENNA_fanout227_A net228 vssd1 vssd1 vccd1 vccd1 sky130_fd_sc_hd__diode_2
X_6515_ _1700_ _1701_ vssd1 vssd1 vccd1 vccd1 _1702_ sky130_fd_sc_hd__xnor2_1
XANTENNA__5465__B net58 vssd1 vssd1 vccd1 vccd1 sky130_fd_sc_hd__diode_2
XANTENNA__7961__A net305 vssd1 vssd1 vccd1 vccd1 sky130_fd_sc_hd__diode_2
X_7495_ net90 net58 net55 net91 vssd1 vssd1 vccd1 vccd1 _2740_ sky130_fd_sc_hd__o22a_1
X_6446_ _1620_ _1621_ _1633_ vssd1 vssd1 vccd1 vccd1 _1634_ sky130_fd_sc_hd__nand3_1
XANTENNA__6577__A net100 vssd1 vssd1 vccd1 vccd1 sky130_fd_sc_hd__diode_2
X_6377_ _1359_ _1361_ _1564_ vssd1 vssd1 vccd1 vccd1 _1565_ sky130_fd_sc_hd__o21ai_1
XFILLER_87_111 vssd1 vssd1 vccd1 vccd1 sky130_fd_sc_hd__fill_1
X_8116_ _3203_ _3205_ _3373_ vssd1 vssd1 vccd1 vccd1 _3377_ sky130_fd_sc_hd__or3_1
XFILLER_0_505 vccd1 vssd1 vccd1 vssd1 sky130_ef_sc_hd__decap_40_12
X_5328_ _0516_ _0517_ vssd1 vssd1 vccd1 vccd1 _0518_ sky130_fd_sc_hd__and2_1
X_8047_ _3290_ _3301_ vssd1 vssd1 vccd1 vccd1 _3302_ sky130_fd_sc_hd__nand2_1
XFILLER_87_177 vssd1 vssd1 vccd1 vccd1 sky130_fd_sc_hd__fill_2
Xclkbuf_4_5_0_clk clknet_0_clk vssd1 vssd1 vccd1 vccd1 clknet_4_5_0_clk sky130_fd_sc_hd__clkbuf_8
X_5259_ _0446_ _0447_ vssd1 vssd1 vccd1 vccd1 _0449_ sky130_fd_sc_hd__nand2_1
XFILLER_28_211 vssd1 vssd1 vccd1 vccd1 sky130_fd_sc_hd__fill_1
XANTENNA__4825__A net147 vssd1 vssd1 vccd1 vccd1 sky130_fd_sc_hd__diode_2
XFILLER_16_417 vssd1 vssd1 vccd1 vccd1 sky130_fd_sc_hd__fill_2
XFILLER_71_545 vssd1 vssd1 vccd1 vccd1 sky130_fd_sc_hd__fill_1
XTAP_TAPCELL_ROW_54_743 vssd1 vccd1 sky130_fd_sc_hd__tapvpwrvgnd_1
XANTENNA__5957__A1 net135 vssd1 vssd1 vccd1 vccd1 sky130_fd_sc_hd__diode_2
XFILLER_43_258 vssd1 vssd1 vccd1 vccd1 sky130_fd_sc_hd__fill_1
XTAP_TAPCELL_ROW_26_456 vssd1 vccd1 sky130_fd_sc_hd__tapvpwrvgnd_1
XFILLER_31_409 vssd1 vssd1 vccd1 vccd1 sky130_fd_sc_hd__fill_2
XFILLER_11_199 vssd1 vssd1 vccd1 vccd1 sky130_fd_sc_hd__fill_1
XFILLER_3_343 vccd1 vssd1 vccd1 vssd1 sky130_ef_sc_hd__decap_40_12
XANTENNA__7590__B net44 vssd1 vssd1 vccd1 vccd1 sky130_fd_sc_hd__diode_2
XFILLER_78_111 vssd1 vssd1 vccd1 vccd1 sky130_fd_sc_hd__fill_1
XANTENNA__6637__D net195 vssd1 vssd1 vccd1 vccd1 sky130_fd_sc_hd__diode_2
XFILLER_78_122 vssd1 vssd1 vccd1 vccd1 sky130_fd_sc_hd__fill_2
XFILLER_78_177 vssd1 vssd1 vccd1 vccd1 sky130_fd_sc_hd__fill_1
Xfanout190 PID_INST.k2_calc.sum_reg\[16\] vssd1 vssd1 vccd1 vccd1 net190 sky130_fd_sc_hd__clkbuf_4
XANTENNA__4999__A2 net87 vssd1 vssd1 vccd1 vccd1 sky130_fd_sc_hd__diode_2
XFILLER_81_309 vssd1 vssd1 vccd1 vccd1 sky130_fd_sc_hd__fill_2
XFILLER_19_244 vssd1 vssd1 vccd1 vccd1 sky130_fd_sc_hd__fill_1
XFILLER_62_512 vssd1 vssd1 vccd1 vccd1 sky130_fd_sc_hd__fill_1
XFILLER_34_225 vssd1 vssd1 vccd1 vccd1 sky130_fd_sc_hd__fill_2
XFILLER_62_567 vssd1 vssd1 vccd1 vccd1 sky130_fd_sc_hd__fill_2
XFILLER_15_472 vssd1 vssd1 vccd1 vccd1 sky130_fd_sc_hd__fill_1
XFILLER_8_31 vssd1 vssd1 vccd1 vccd1 sky130_fd_sc_hd__fill_1
X_4630_ _3890_ _3891_ vssd1 vssd1 vccd1 vccd1 _3908_ sky130_fd_sc_hd__xnor2_1
XFILLER_30_453 vssd1 vssd1 vccd1 vccd1 sky130_fd_sc_hd__fill_2
XANTENNA__6373__A1 net131 vssd1 vssd1 vccd1 vccd1 sky130_fd_sc_hd__diode_2
XANTENNA__4901__C _4034_ vssd1 vssd1 vccd1 vccd1 sky130_fd_sc_hd__diode_2
XFILLER_30_497 vssd1 vssd1 vccd1 vccd1 sky130_fd_sc_hd__fill_1
XANTENNA__7781__A net286 vssd1 vssd1 vccd1 vccd1 sky130_fd_sc_hd__diode_2
X_4561_ _3759_ _3837_ _3838_ vssd1 vssd1 vccd1 vccd1 _3839_ sky130_fd_sc_hd__nand3_1
X_6300_ net415 _1488_ net156 vssd1 vssd1 vccd1 vccd1 _0061_ sky130_fd_sc_hd__mux2_1
X_4492_ _3768_ _3769_ vssd1 vssd1 vccd1 vccd1 _3770_ sky130_fd_sc_hd__or2_1
X_7280_ _2509_ _2510_ vssd1 vssd1 vccd1 vccd1 _2511_ sky130_fd_sc_hd__nand2_1
X_6231_ net200 net319 net258 net250 vssd1 vssd1 vccd1 vccd1 _1420_ sky130_fd_sc_hd__a22oi_1
XANTENNA__6397__A net112 vssd1 vssd1 vccd1 vccd1 sky130_fd_sc_hd__diode_2
XFILLER_69_100 vssd1 vssd1 vccd1 vccd1 sky130_fd_sc_hd__fill_1
X_6162_ _0506_ _1148_ _1150_ _1147_ vssd1 vssd1 vccd1 vccd1 _1351_ sky130_fd_sc_hd__a22o_1
X_5113_ _0301_ _0302_ vssd1 vssd1 vccd1 vccd1 _0303_ sky130_fd_sc_hd__nand2_1
XFILLER_57_317 vssd1 vssd1 vccd1 vccd1 sky130_fd_sc_hd__fill_4
X_6093_ _1279_ _1280_ _1281_ vssd1 vssd1 vccd1 vccd1 _1283_ sky130_fd_sc_hd__o21ai_1
XFILLER_69_188 vssd1 vssd1 vccd1 vccd1 sky130_fd_sc_hd__fill_4
X_5044_ _0153_ _0155_ vssd1 vssd1 vccd1 vccd1 _0234_ sky130_fd_sc_hd__nor2_1
XFILLER_38_531 vssd1 vssd1 vccd1 vccd1 sky130_fd_sc_hd__fill_1
XTAP_TAPCELL_ROW_68_879 vssd1 vccd1 sky130_fd_sc_hd__tapvpwrvgnd_1
XFILLER_53_545 vssd1 vssd1 vccd1 vccd1 sky130_fd_sc_hd__fill_4
XFILLER_25_225 vssd1 vssd1 vccd1 vccd1 sky130_fd_sc_hd__fill_8
X_6995_ _2208_ _2209_ vssd1 vssd1 vccd1 vccd1 _2211_ sky130_fd_sc_hd__nand2b_1
XTAP_TAPCELL_ROW_51_713 vssd1 vccd1 sky130_fd_sc_hd__tapvpwrvgnd_1
X_5946_ net165 net80 _0496_ vssd1 vssd1 vccd1 vccd1 _1136_ sky130_fd_sc_hd__a21oi_1
XANTENNA__7675__B net188 vssd1 vssd1 vccd1 vccd1 sky130_fd_sc_hd__diode_2
X_5877_ _0723_ _0784_ vssd1 vssd1 vccd1 vccd1 _1067_ sky130_fd_sc_hd__nand2_1
XFILLER_21_431 vssd1 vssd1 vccd1 vccd1 sky130_fd_sc_hd__fill_1
XTAP_TAPCELL_ROW_23_426 vssd1 vccd1 sky130_fd_sc_hd__tapvpwrvgnd_1
XFILLER_40_228 vssd1 vssd1 vccd1 vccd1 sky130_fd_sc_hd__fill_4
XANTENNA__4380__A net201 vssd1 vssd1 vccd1 vccd1 sky130_fd_sc_hd__diode_2
X_4828_ net123 net75 net73 net148 vssd1 vssd1 vccd1 vccd1 _4106_ sky130_fd_sc_hd__o2bb2a_1
XANTENNA_fanout132_X net132 vssd1 vssd1 vccd1 vccd1 sky130_fd_sc_hd__diode_2
X_7616_ _2853_ _2866_ vssd1 vssd1 vccd1 vccd1 _2868_ sky130_fd_sc_hd__xnor2_1
XFILLER_21_475 vssd1 vssd1 vccd1 vccd1 sky130_fd_sc_hd__fill_1
X_4759_ net148 net73 vssd1 vssd1 vccd1 vccd1 _4037_ sky130_fd_sc_hd__nor2_1
X_7547_ _2783_ _2794_ vssd1 vssd1 vccd1 vccd1 _2795_ sky130_fd_sc_hd__xnor2_1
X_7478_ _2719_ _2720_ vssd1 vssd1 vccd1 vccd1 _2721_ sky130_fd_sc_hd__nor2_1
XFILLER_4_129 vssd1 vssd1 vccd1 vccd1 sky130_fd_sc_hd__fill_8
XFILLER_4_118 vssd1 vssd1 vccd1 vccd1 sky130_fd_sc_hd__fill_1
XTAP_TAPCELL_ROW_91_1108 vssd1 vccd1 sky130_fd_sc_hd__tapvpwrvgnd_1
X_6429_ _1611_ _1616_ vssd1 vssd1 vccd1 vccd1 _1617_ sky130_fd_sc_hd__nand2_1
XFILLER_88_475 vssd1 vssd1 vccd1 vccd1 sky130_fd_sc_hd__fill_1
XFILLER_75_103 vssd1 vssd1 vccd1 vccd1 sky130_fd_sc_hd__fill_1
XANTENNA__4555__A net148 vssd1 vssd1 vccd1 vccd1 sky130_fd_sc_hd__diode_2
XFILLER_29_542 vccd1 vssd1 vccd1 vssd1 sky130_ef_sc_hd__decap_40_12
XFILLER_84_68 vssd1 vssd1 vccd1 vccd1 sky130_fd_sc_hd__fill_1
XFILLER_71_331 vssd1 vssd1 vccd1 vccd1 sky130_fd_sc_hd__fill_4
XFILLER_71_320 vssd1 vssd1 vccd1 vccd1 sky130_fd_sc_hd__fill_8
XFILLER_16_236 vccd1 vssd1 vccd1 vssd1 sky130_ef_sc_hd__decap_40_12
XFILLER_17_73 vssd1 vssd1 vccd1 vccd1 sky130_fd_sc_hd__fill_1
XTAP_TAPCELL_ROW_39_592 vssd1 vccd1 sky130_fd_sc_hd__tapvpwrvgnd_1
XFILLER_17_95 vccd1 vssd1 vccd1 vssd1 sky130_ef_sc_hd__decap_40_12
XFILLER_31_228 vssd1 vssd1 vccd1 vccd1 sky130_fd_sc_hd__fill_1
XFILLER_8_468 vssd1 vssd1 vccd1 vccd1 sky130_fd_sc_hd__fill_8
XFILLER_69_9 vssd1 vssd1 vccd1 vccd1 sky130_fd_sc_hd__fill_1
XANTENNA__6107__B2 net99 vssd1 vssd1 vccd1 vccd1 sky130_fd_sc_hd__diode_2
XANTENNA__6107__A1 net101 vssd1 vssd1 vccd1 vccd1 sky130_fd_sc_hd__diode_2
XANTENNA__4669__A1 net121 vssd1 vssd1 vccd1 vccd1 sky130_fd_sc_hd__diode_2
Xhold2 PID_INST.k1_calc.d1.x\[8\] vssd1 vssd1 vccd1 vccd1 net395 sky130_fd_sc_hd__dlygate4sd3_1
XFILLER_66_147 vssd1 vssd1 vccd1 vccd1 sky130_fd_sc_hd__fill_1
XFILLER_54_309 vccd1 vssd1 vccd1 vssd1 sky130_ef_sc_hd__decap_40_12
XTAP_TAPCELL_ROW_65_849 vssd1 vccd1 sky130_fd_sc_hd__tapvpwrvgnd_1
XFILLER_35_523 vssd1 vssd1 vccd1 vccd1 sky130_fd_sc_hd__fill_2
XANTENNA__5794__A1_N net251 vssd1 vssd1 vccd1 vccd1 sky130_fd_sc_hd__diode_2
X_6780_ _1979_ _1980_ vssd1 vssd1 vccd1 vccd1 _1982_ sky130_fd_sc_hd__xnor2_1
X_5800_ _0988_ _0989_ vssd1 vssd1 vccd1 vccd1 _0990_ sky130_fd_sc_hd__nand2b_1
XFILLER_62_353 vssd1 vssd1 vccd1 vccd1 sky130_fd_sc_hd__fill_1
X_5731_ _0916_ _0919_ _0920_ vssd1 vssd1 vccd1 vccd1 _0921_ sky130_fd_sc_hd__nor3_1
XFILLER_50_537 vssd1 vssd1 vccd1 vccd1 sky130_fd_sc_hd__fill_1
XFILLER_50_526 vssd1 vssd1 vccd1 vccd1 sky130_fd_sc_hd__fill_4
X_8450_ clknet_4_13_0_clk _0038_ net335 vssd1 vssd1 vccd1 vccd1 PID_INST.k2_calc.sum_reg\[6\]
+ sky130_fd_sc_hd__dfrtp_1
X_5662_ _0847_ _0851_ vssd1 vssd1 vccd1 vccd1 _0852_ sky130_fd_sc_hd__nand2_1
X_7401_ _2637_ _2638_ vssd1 vssd1 vccd1 vccd1 _2640_ sky130_fd_sc_hd__xnor2_1
X_5593_ net216 net306 vssd1 vssd1 vccd1 vccd1 _0783_ sky130_fd_sc_hd__nand2_1
X_4613_ net122 net144 vssd1 vssd1 vccd1 vccd1 _3891_ sky130_fd_sc_hd__nand2_1
X_8381_ clknet_4_10_0_clk PID_INST.k3_calc.d2.y\[1\] net328 vssd1 vssd1 vccd1 vccd1
+ PID_INST.k3_calc.timescaling_term\[1\] sky130_fd_sc_hd__dfrtp_1
X_7332_ _2563_ _2564_ vssd1 vssd1 vccd1 vccd1 _2566_ sky130_fd_sc_hd__xnor2_1
X_4544_ _3821_ _3806_ vssd1 vssd1 vccd1 vccd1 _3822_ sky130_fd_sc_hd__nand2b_1
XANTENNA__5743__B net229 vssd1 vssd1 vccd1 vccd1 sky130_fd_sc_hd__diode_2
X_7263_ net96 net51 vssd1 vssd1 vccd1 vccd1 _2493_ sky130_fd_sc_hd__nor2_1
X_4475_ _3744_ _3745_ _3748_ _3742_ vssd1 vssd1 vccd1 vccd1 _3753_ sky130_fd_sc_hd__a31o_1
X_6214_ _1125_ _1199_ _1124_ vssd1 vssd1 vccd1 vccd1 _1403_ sky130_fd_sc_hd__o21a_1
X_7194_ _2053_ _2418_ _2419_ vssd1 vssd1 vccd1 vccd1 _2420_ sky130_fd_sc_hd__a21boi_1
XANTENNA_fanout294_A net297 vssd1 vssd1 vccd1 vccd1 sky130_fd_sc_hd__diode_2
X_6145_ net165 net83 _1333_ vssd1 vssd1 vccd1 vccd1 _1334_ sky130_fd_sc_hd__and3_1
X_6076_ _1241_ _1264_ vssd1 vssd1 vccd1 vccd1 _1266_ sky130_fd_sc_hd__xnor2_1
XFILLER_57_125 vccd1 vssd1 vccd1 vssd1 sky130_ef_sc_hd__decap_40_12
XFILLER_85_467 vccd1 vssd1 vccd1 vssd1 sky130_ef_sc_hd__decap_40_12
X_5027_ _0149_ _0216_ vssd1 vssd1 vccd1 vccd1 _0217_ sky130_fd_sc_hd__xnor2_1
XFILLER_72_128 vssd1 vssd1 vccd1 vccd1 sky130_fd_sc_hd__fill_1
XANTENNA__4375__A net205 vssd1 vssd1 vccd1 vccd1 sky130_fd_sc_hd__diode_2
XFILLER_26_523 vssd1 vssd1 vccd1 vccd1 sky130_fd_sc_hd__fill_2
XTAP_TAPCELL_ROW_88_1081 vssd1 vccd1 sky130_fd_sc_hd__tapvpwrvgnd_1
XFILLER_65_191 vssd1 vssd1 vccd1 vccd1 sky130_fd_sc_hd__fill_4
XFILLER_26_545 vssd1 vssd1 vccd1 vccd1 sky130_fd_sc_hd__fill_2
XFILLER_80_161 vssd1 vssd1 vccd1 vccd1 sky130_fd_sc_hd__fill_2
XTAP_TAPCELL_ROW_0_187 vssd1 vccd1 sky130_fd_sc_hd__tapvpwrvgnd_1
XTAP_TAPCELL_ROW_36_562 vssd1 vccd1 sky130_fd_sc_hd__tapvpwrvgnd_1
XFILLER_53_386 vssd1 vssd1 vccd1 vccd1 sky130_fd_sc_hd__fill_4
XTAP_TAPCELL_ROW_0_198 vssd1 vccd1 sky130_fd_sc_hd__tapvpwrvgnd_1
X_6978_ _2190_ _2191_ vssd1 vssd1 vccd1 vccd1 _2192_ sky130_fd_sc_hd__nor2_1
X_5929_ net111 net50 _1118_ vssd1 vssd1 vccd1 vccd1 _1119_ sky130_fd_sc_hd__or3_1
XFILLER_21_261 vssd1 vssd1 vccd1 vccd1 sky130_fd_sc_hd__fill_8
XFILLER_5_416 vssd1 vssd1 vccd1 vccd1 sky130_fd_sc_hd__fill_2
XFILLER_5_449 vssd1 vssd1 vccd1 vccd1 sky130_fd_sc_hd__fill_4
XTAP_TAPCELL_ROW_8_276 vssd1 vccd1 sky130_fd_sc_hd__tapvpwrvgnd_1
XFILLER_88_272 vssd1 vssd1 vccd1 vccd1 sky130_fd_sc_hd__fill_8
XFILLER_0_165 vssd1 vssd1 vccd1 vccd1 sky130_fd_sc_hd__fill_2
XFILLER_91_415 vssd1 vssd1 vccd1 vccd1 sky130_fd_sc_hd__fill_2
XFILLER_91_404 vssd1 vssd1 vccd1 vccd1 sky130_fd_sc_hd__fill_4
XFILLER_17_501 vssd1 vssd1 vccd1 vccd1 sky130_fd_sc_hd__fill_2
XFILLER_28_61 vssd1 vssd1 vccd1 vccd1 sky130_fd_sc_hd__fill_1
XFILLER_28_83 vssd1 vssd1 vccd1 vccd1 sky130_fd_sc_hd__fill_1
XFILLER_91_459 vssd1 vssd1 vccd1 vccd1 sky130_fd_sc_hd__fill_2
XTAP_TAPCELL_ROW_62_819 vssd1 vccd1 sky130_fd_sc_hd__tapvpwrvgnd_1
XFILLER_44_353 vssd1 vssd1 vccd1 vccd1 sky130_fd_sc_hd__fill_1
XFILLER_44_397 vssd1 vssd1 vccd1 vccd1 sky130_fd_sc_hd__fill_8
XANTENNA__8204__B net276 vssd1 vssd1 vccd1 vccd1 sky130_fd_sc_hd__diode_2
XTAP_TAPCELL_ROW_70_896 vssd1 vccd1 sky130_fd_sc_hd__tapvpwrvgnd_1
XFILLER_8_243 vssd1 vssd1 vccd1 vccd1 sky130_fd_sc_hd__fill_8
XFILLER_8_232 vssd1 vssd1 vccd1 vccd1 sky130_fd_sc_hd__fill_2
XANTENNA__6659__B net220 vssd1 vssd1 vccd1 vccd1 sky130_fd_sc_hd__diode_2
X_4260_ PID_INST.pid.curr_state\[3\] PID_INST.pid.curr_state\[2\] vssd1 vssd1 vccd1
+ vccd1 _2792_ sky130_fd_sc_hd__nand2_1
X_4191_ _2051_ vssd1 vssd1 vccd1 vccd1 PID_INST.k3_calc.d1.y\[8\] sky130_fd_sc_hd__inv_2
XFILLER_79_272 vssd1 vssd1 vccd1 vccd1 sky130_fd_sc_hd__fill_2
XFILLER_82_415 vssd1 vssd1 vccd1 vccd1 sky130_fd_sc_hd__fill_1
XFILLER_82_404 vssd1 vssd1 vccd1 vccd1 sky130_fd_sc_hd__fill_1
XTAP_TAPCELL_ROW_78_985 vssd1 vccd1 sky130_fd_sc_hd__tapvpwrvgnd_1
X_7950_ _3196_ _3204_ vssd1 vssd1 vccd1 vccd1 _3205_ sky130_fd_sc_hd__and2b_1
XFILLER_39_169 vssd1 vssd1 vccd1 vccd1 sky130_fd_sc_hd__fill_1
XFILLER_82_437 vssd1 vssd1 vccd1 vccd1 sky130_fd_sc_hd__fill_1
X_7881_ _3134_ _3135_ vssd1 vssd1 vccd1 vccd1 _3136_ sky130_fd_sc_hd__xnor2_1
X_6901_ _1986_ _2109_ vssd1 vssd1 vccd1 vccd1 _2111_ sky130_fd_sc_hd__xor2_1
X_6832_ net104 net38 vssd1 vssd1 vccd1 vccd1 _2037_ sky130_fd_sc_hd__or2_1
XFILLER_50_323 vssd1 vssd1 vccd1 vccd1 sky130_fd_sc_hd__fill_2
XFILLER_23_548 vssd1 vssd1 vccd1 vccd1 sky130_fd_sc_hd__fill_1
X_6763_ _1864_ _1867_ _1963_ vssd1 vssd1 vccd1 vccd1 _1964_ sky130_fd_sc_hd__a21oi_1
XFILLER_50_345 vssd1 vssd1 vccd1 vccd1 sky130_fd_sc_hd__fill_2
XTAP_TAPCELL_ROW_33_532 vssd1 vccd1 sky130_fd_sc_hd__tapvpwrvgnd_1
X_6694_ _1889_ _1890_ vssd1 vssd1 vccd1 vccd1 _1892_ sky130_fd_sc_hd__nand2_1
X_5714_ net228 net306 _0725_ vssd1 vssd1 vccd1 vccd1 _0904_ sky130_fd_sc_hd__a21oi_1
X_5645_ _0833_ _0834_ vssd1 vssd1 vccd1 vccd1 _0835_ sky130_fd_sc_hd__nand2_1
X_8433_ clknet_4_1_0_clk net403 net326 vssd1 vssd1 vccd1 vccd1 PID_INST.k3_calc.prev_error\[5\]
+ sky130_fd_sc_hd__dfrtp_1
XANTENNA__7672__C net277 vssd1 vssd1 vccd1 vccd1 sky130_fd_sc_hd__diode_2
XANTENNA_fanout307_A net308 vssd1 vssd1 vccd1 vccd1 sky130_fd_sc_hd__diode_2
X_8364_ clknet_4_5_0_clk _0000_ net332 vssd1 vssd1 vccd1 vccd1 PID_INST.k1_calc.d1.x\[0\]
+ sky130_fd_sc_hd__dfrtp_2
X_5576_ _0764_ _0765_ vssd1 vssd1 vccd1 vccd1 _0766_ sky130_fd_sc_hd__nand2_1
X_8295_ _3566_ _3567_ vssd1 vssd1 vccd1 vccd1 _3569_ sky130_fd_sc_hd__nand2_1
X_4527_ _3803_ _3804_ vssd1 vssd1 vccd1 vccd1 _3805_ sky130_fd_sc_hd__xnor2_1
X_7315_ _2546_ _2547_ vssd1 vssd1 vccd1 vccd1 _2549_ sky130_fd_sc_hd__nand2_1
X_4458_ _3728_ _3735_ vssd1 vssd1 vccd1 vccd1 _3736_ sky130_fd_sc_hd__xnor2_2
X_7246_ _2221_ _2223_ vssd1 vssd1 vccd1 vccd1 _2476_ sky130_fd_sc_hd__nor2_1
X_7177_ _2195_ _2204_ _2203_ vssd1 vssd1 vccd1 vccd1 _2402_ sky130_fd_sc_hd__a21bo_1
X_4389_ _3680_ _3681_ vssd1 vssd1 vccd1 vccd1 _3682_ sky130_fd_sc_hd__and2b_1
XANTENNA_fanout297_X net297 vssd1 vssd1 vccd1 vccd1 sky130_fd_sc_hd__diode_2
XTAP_TAPCELL_ROW_5_246 vssd1 vccd1 sky130_fd_sc_hd__tapvpwrvgnd_1
X_6128_ _1117_ _1314_ _1316_ vssd1 vssd1 vccd1 vccd1 _1317_ sky130_fd_sc_hd__a21o_1
XFILLER_73_426 vssd1 vssd1 vccd1 vccd1 sky130_fd_sc_hd__fill_4
X_6059_ _1247_ _1248_ vssd1 vssd1 vccd1 vccd1 _1249_ sky130_fd_sc_hd__nor2_1
XFILLER_73_437 vssd1 vssd1 vccd1 vccd1 sky130_fd_sc_hd__fill_2
XFILLER_45_128 vssd1 vssd1 vccd1 vccd1 sky130_fd_sc_hd__fill_1
XFILLER_38_191 vssd1 vssd1 vccd1 vccd1 sky130_fd_sc_hd__fill_4
XANTENNA__5929__A net111 vssd1 vssd1 vccd1 vccd1 sky130_fd_sc_hd__diode_2
XFILLER_14_504 vssd1 vssd1 vccd1 vccd1 sky130_fd_sc_hd__fill_2
XFILLER_81_492 vssd1 vssd1 vccd1 vccd1 sky130_fd_sc_hd__fill_1
XFILLER_81_36 vssd1 vssd1 vccd1 vccd1 sky130_fd_sc_hd__fill_1
XFILLER_53_161 vssd1 vssd1 vccd1 vccd1 sky130_fd_sc_hd__fill_1
XFILLER_41_334 vssd1 vssd1 vccd1 vccd1 sky130_fd_sc_hd__fill_2
XANTENNA__6479__B net287 vssd1 vssd1 vccd1 vccd1 sky130_fd_sc_hd__diode_2
XFILLER_5_235 vssd1 vssd1 vccd1 vccd1 sky130_fd_sc_hd__fill_2
XFILLER_5_279 vssd1 vssd1 vccd1 vccd1 sky130_fd_sc_hd__fill_1
XFILLER_39_71 vccd1 vssd1 vccd1 vssd1 sky130_ef_sc_hd__decap_40_12
XTAP_TAPCELL_ROW_75_955 vssd1 vccd1 sky130_fd_sc_hd__tapvpwrvgnd_1
XFILLER_36_139 vssd1 vssd1 vccd1 vccd1 sky130_fd_sc_hd__fill_1
XFILLER_91_278 vssd1 vssd1 vccd1 vccd1 sky130_fd_sc_hd__fill_2
XTAP_TAPCELL_ROW_47_668 vssd1 vccd1 sky130_fd_sc_hd__tapvpwrvgnd_1
XANTENNA__4743__A net97 vssd1 vssd1 vccd1 vccd1 sky130_fd_sc_hd__diode_2
XFILLER_32_323 vssd1 vssd1 vccd1 vccd1 sky130_fd_sc_hd__fill_1
XANTENNA__5558__B net295 vssd1 vssd1 vccd1 vccd1 sky130_fd_sc_hd__diode_2
XANTENNA__7210__A2 net53 vssd1 vssd1 vccd1 vccd1 sky130_fd_sc_hd__diode_2
XTAP_TAPCELL_ROW_30_502 vssd1 vccd1 sky130_fd_sc_hd__tapvpwrvgnd_1
XFILLER_32_389 vssd1 vssd1 vccd1 vccd1 sky130_fd_sc_hd__fill_2
XFILLER_9_530 vssd1 vssd1 vccd1 vccd1 sky130_fd_sc_hd__fill_2
X_5430_ _0614_ _0619_ _0613_ vssd1 vssd1 vccd1 vccd1 _0620_ sky130_fd_sc_hd__o21ba_1
XFILLER_65_3 vssd1 vssd1 vccd1 vccd1 sky130_fd_sc_hd__fill_1
XANTENNA__5524__A2 net273 vssd1 vssd1 vccd1 vccd1 sky130_fd_sc_hd__diode_2
X_5361_ _0550_ _0329_ vssd1 vssd1 vccd1 vccd1 _0551_ sky130_fd_sc_hd__and2b_1
X_8080_ _3186_ _3189_ _3187_ vssd1 vssd1 vccd1 vccd1 _3338_ sky130_fd_sc_hd__o21ba_1
X_7100_ _2320_ _2319_ vssd1 vssd1 vccd1 vccd1 _2321_ sky130_fd_sc_hd__nand2b_1
X_4312_ net251 net12 _3299_ _3310_ vssd1 vssd1 vccd1 vccd1 _3321_ sky130_fd_sc_hd__a22o_1
X_5292_ net163 net87 _0406_ vssd1 vssd1 vccd1 vccd1 _0482_ sky130_fd_sc_hd__a21boi_1
X_7031_ _2247_ _2248_ vssd1 vssd1 vccd1 vccd1 _2249_ sky130_fd_sc_hd__nor2_1
X_4243_ net5 net168 _2601_ vssd1 vssd1 vccd1 vccd1 _2612_ sky130_fd_sc_hd__o21ai_2
XFILLER_19_19 vssd1 vssd1 vccd1 vccd1 sky130_fd_sc_hd__fill_1
X_4174_ net19 net167 _1871_ vssd1 vssd1 vccd1 vccd1 _1882_ sky130_fd_sc_hd__o21ai_2
XTAP_TAPCELL_ROW_2_216 vssd1 vccd1 sky130_fd_sc_hd__tapvpwrvgnd_1
X_7933_ _3186_ _3187_ vssd1 vssd1 vccd1 vccd1 _3188_ sky130_fd_sc_hd__nor2_1
XFILLER_67_297 vssd1 vssd1 vccd1 vccd1 sky130_fd_sc_hd__fill_1
XFILLER_82_278 vssd1 vssd1 vccd1 vccd1 sky130_fd_sc_hd__fill_2
XTAP_TAPCELL_ROW_85_1051 vssd1 vccd1 sky130_fd_sc_hd__tapvpwrvgnd_1
XANTENNA_fanout257_A net259 vssd1 vssd1 vccd1 vccd1 sky130_fd_sc_hd__diode_2
X_7864_ net418 _3119_ net154 vssd1 vssd1 vccd1 vccd1 _0070_ sky130_fd_sc_hd__mux2_1
X_7795_ _2963_ _2966_ _3050_ vssd1 vssd1 vccd1 vccd1 _3051_ sky130_fd_sc_hd__o21a_1
X_6815_ _2007_ _2017_ vssd1 vssd1 vccd1 vccd1 _2020_ sky130_fd_sc_hd__xor2_1
XTAP_TAPCELL_ROW_18_381 vssd1 vccd1 sky130_fd_sc_hd__tapvpwrvgnd_1
XFILLER_35_194 vssd1 vssd1 vccd1 vccd1 sky130_fd_sc_hd__fill_1
X_6746_ net203 net295 vssd1 vssd1 vccd1 vccd1 _1946_ sky130_fd_sc_hd__nand2_1
X_6677_ _1869_ _1870_ _1872_ vssd1 vssd1 vccd1 vccd1 _1874_ sky130_fd_sc_hd__o21ai_1
XANTENNA_fanout212_X net212 vssd1 vssd1 vccd1 vccd1 sky130_fd_sc_hd__diode_2
X_5628_ net269 net249 net207 net323 vssd1 vssd1 vccd1 vccd1 _0818_ sky130_fd_sc_hd__a22oi_1
X_8416_ clknet_4_0_0_clk net125 net328 vssd1 vssd1 vccd1 vccd1 PID_INST.k3_calc.kd_term\[4\]
+ sky130_fd_sc_hd__dfrtp_1
X_5559_ net227 net295 _0747_ vssd1 vssd1 vccd1 vccd1 _0749_ sky130_fd_sc_hd__a21oi_1
X_8347_ _3623_ _3624_ vssd1 vssd1 vccd1 vccd1 _3625_ sky130_fd_sc_hd__xnor2_1
XANTENNA__4723__B1 net147 vssd1 vssd1 vccd1 vccd1 sky130_fd_sc_hd__diode_2
X_8278_ _3549_ _3550_ vssd1 vssd1 vccd1 vccd1 _3551_ sky130_fd_sc_hd__xor2_1
XANTENNA__7204__A net99 vssd1 vssd1 vccd1 vccd1 sky130_fd_sc_hd__diode_2
X_7229_ _2450_ _2457_ vssd1 vssd1 vccd1 vccd1 _2458_ sky130_fd_sc_hd__xnor2_1
XFILLER_76_25 vssd1 vssd1 vccd1 vccd1 sky130_fd_sc_hd__fill_2
XFILLER_58_242 vssd1 vssd1 vccd1 vccd1 sky130_fd_sc_hd__fill_2
XFILLER_73_212 vssd1 vssd1 vccd1 vccd1 sky130_fd_sc_hd__fill_2
XFILLER_18_139 vssd1 vssd1 vccd1 vccd1 sky130_fd_sc_hd__fill_1
XFILLER_61_407 vssd1 vssd1 vccd1 vccd1 sky130_fd_sc_hd__fill_1
XFILLER_92_57 vccd1 vssd1 vccd1 vssd1 sky130_ef_sc_hd__decap_40_12
XTAP_TAPCELL_ROW_72_925 vssd1 vccd1 sky130_fd_sc_hd__tapvpwrvgnd_1
XFILLER_73_289 vssd1 vssd1 vccd1 vccd1 sky130_fd_sc_hd__fill_1
XFILLER_61_429 vssd1 vssd1 vccd1 vccd1 sky130_fd_sc_hd__fill_1
XTAP_TAPCELL_ROW_44_638 vssd1 vccd1 sky130_fd_sc_hd__tapvpwrvgnd_1
XFILLER_14_312 vssd1 vssd1 vccd1 vccd1 sky130_fd_sc_hd__fill_8
XFILLER_26_194 vssd1 vssd1 vccd1 vccd1 sky130_fd_sc_hd__fill_2
XFILLER_14_367 vssd1 vssd1 vccd1 vccd1 sky130_fd_sc_hd__fill_1
XFILLER_14_389 vccd1 vssd1 vccd1 vssd1 sky130_ef_sc_hd__decap_40_12
XANTENNA__7593__B net40 vssd1 vssd1 vccd1 vccd1 sky130_fd_sc_hd__diode_2
XANTENNA__5506__A2 net228 vssd1 vssd1 vccd1 vccd1 sky130_fd_sc_hd__diode_2
XFILLER_6_533 vssd1 vssd1 vccd1 vccd1 sky130_fd_sc_hd__fill_2
XANTENNA__6002__B net42 vssd1 vssd1 vccd1 vccd1 sky130_fd_sc_hd__diode_2
XANTENNA__4190__A1 net3 vssd1 vssd1 vccd1 vccd1 sky130_fd_sc_hd__diode_2
XFILLER_69_518 vssd1 vssd1 vccd1 vccd1 sky130_fd_sc_hd__fill_1
XANTENNA__5841__B net237 vssd1 vssd1 vccd1 vccd1 sky130_fd_sc_hd__diode_2
XANTENNA__8208__A1 net294 vssd1 vssd1 vccd1 vccd1 sky130_fd_sc_hd__diode_2
XFILLER_49_242 vssd1 vssd1 vccd1 vccd1 sky130_fd_sc_hd__fill_1
XFILLER_2_11 vssd1 vssd1 vccd1 vccd1 sky130_fd_sc_hd__fill_1
Xteam_03_390 vssd1 vssd1 vccd1 vccd1 gpio_oeb[14] team_03_390/LO sky130_fd_sc_hd__conb_1
XFILLER_92_565 vssd1 vssd1 vccd1 vccd1 sky130_fd_sc_hd__fill_2
XFILLER_64_245 vssd1 vssd1 vccd1 vccd1 sky130_fd_sc_hd__fill_4
XANTENNA__7719__B1 net205 vssd1 vssd1 vccd1 vccd1 sky130_fd_sc_hd__diode_2
X_4930_ _0118_ _0119_ vssd1 vssd1 vccd1 vccd1 _0120_ sky130_fd_sc_hd__xnor2_1
XANTENNA__4192__B net175 vssd1 vssd1 vccd1 vccd1 sky130_fd_sc_hd__diode_2
XANTENNA__5288__B net50 vssd1 vssd1 vccd1 vccd1 sky130_fd_sc_hd__diode_2
X_4861_ _4133_ _4138_ vssd1 vssd1 vccd1 vccd1 _4139_ sky130_fd_sc_hd__nor2_1
XANTENNA__4787__A1_N net132 vssd1 vssd1 vccd1 vccd1 sky130_fd_sc_hd__diode_2
XTAP_TAPCELL_ROW_15_351 vssd1 vccd1 sky130_fd_sc_hd__tapvpwrvgnd_1
X_6600_ _1783_ _1789_ vssd1 vssd1 vccd1 vccd1 _1790_ sky130_fd_sc_hd__xnor2_1
X_4792_ _3782_ _3972_ _3973_ _3977_ vssd1 vssd1 vccd1 vccd1 _4070_ sky130_fd_sc_hd__a2bb2oi_1
X_7580_ _2493_ _2826_ _2828_ vssd1 vssd1 vccd1 vccd1 _2829_ sky130_fd_sc_hd__a21o_1
XFILLER_32_197 vssd1 vssd1 vccd1 vccd1 sky130_fd_sc_hd__fill_4
XANTENNA__8144__B1 _3406_ vssd1 vssd1 vccd1 vccd1 sky130_fd_sc_hd__diode_2
X_6531_ _2051_ _0157_ _1717_ vssd1 vssd1 vccd1 vccd1 _1718_ sky130_fd_sc_hd__or3_1
X_6462_ _1447_ _1449_ _1446_ vssd1 vssd1 vccd1 vccd1 _1650_ sky130_fd_sc_hd__o21ba_1
XFILLER_9_371 vssd1 vssd1 vccd1 vccd1 sky130_fd_sc_hd__fill_1
X_8201_ net305 PID_INST.k2_calc.sum_reg\[23\] vssd1 vssd1 vccd1 vccd1 _3468_ sky130_fd_sc_hd__nand2_1
X_5413_ _0582_ _0602_ vssd1 vssd1 vccd1 vccd1 _0603_ sky130_fd_sc_hd__xor2_1
X_6393_ _1185_ _1190_ _1389_ _1579_ _1388_ vssd1 vssd1 vccd1 vccd1 _1581_ sky130_fd_sc_hd__a311o_2
X_8132_ _3237_ _3246_ _3392_ _3393_ vssd1 vssd1 vccd1 vccd1 _3394_ sky130_fd_sc_hd__a211oi_1
X_5344_ _0519_ _0532_ vssd1 vssd1 vccd1 vccd1 _0534_ sky130_fd_sc_hd__xnor2_1
XANTENNA__4181__A1 net6 vssd1 vssd1 vccd1 vccd1 sky130_fd_sc_hd__diode_2
XANTENNA__6847__B net65 vssd1 vssd1 vccd1 vccd1 sky130_fd_sc_hd__diode_2
XFILLER_87_326 vssd1 vssd1 vccd1 vccd1 sky130_fd_sc_hd__fill_8
X_8063_ _3318_ net178 net322 _3316_ vssd1 vssd1 vccd1 vccd1 _3319_ sky130_fd_sc_hd__and4b_1
X_5275_ _0450_ _0464_ vssd1 vssd1 vccd1 vccd1 _0465_ sky130_fd_sc_hd__xor2_1
XFILLER_87_337 vssd1 vssd1 vccd1 vccd1 sky130_fd_sc_hd__fill_4
X_7014_ _1901_ _1903_ _1900_ vssd1 vssd1 vccd1 vccd1 _2230_ sky130_fd_sc_hd__o21ba_1
XANTENNA__4367__B net5 vssd1 vssd1 vccd1 vccd1 sky130_fd_sc_hd__diode_2
X_4226_ net111 vssd1 vssd1 vccd1 vccd1 PID_INST.k3_calc.d2.y\[3\] sky130_fd_sc_hd__inv_2
XANTENNA__7959__A net260 vssd1 vssd1 vccd1 vccd1 sky130_fd_sc_hd__diode_2
XFILLER_83_543 vccd1 vssd1 vccd1 vssd1 sky130_ef_sc_hd__decap_40_12
XANTENNA__7958__B1 net196 vssd1 vssd1 vccd1 vccd1 sky130_fd_sc_hd__diode_2
XFILLER_28_448 vssd1 vssd1 vccd1 vccd1 sky130_fd_sc_hd__fill_1
XANTENNA_fanout162_X net162 vssd1 vssd1 vccd1 vccd1 sky130_fd_sc_hd__diode_2
XFILLER_55_278 vssd1 vssd1 vccd1 vccd1 sky130_fd_sc_hd__fill_2
X_7916_ _3169_ _3170_ vssd1 vssd1 vccd1 vccd1 _3171_ sky130_fd_sc_hd__nand2_1
XFILLER_62_27 vssd1 vssd1 vccd1 vccd1 sky130_fd_sc_hd__fill_1
X_7847_ _3101_ _3102_ vssd1 vssd1 vccd1 vccd1 _3103_ sky130_fd_sc_hd__or2_1
XTAP_TAPCELL_ROW_41_608 vssd1 vccd1 sky130_fd_sc_hd__tapvpwrvgnd_1
X_7778_ _2935_ _2938_ _3033_ vssd1 vssd1 vccd1 vccd1 _3034_ sky130_fd_sc_hd__a21oi_1
XFILLER_51_484 vssd1 vssd1 vccd1 vccd1 sky130_fd_sc_hd__fill_8
XFILLER_11_326 vssd1 vssd1 vccd1 vccd1 sky130_fd_sc_hd__fill_1
X_6729_ _1830_ _1833_ _1927_ vssd1 vssd1 vccd1 vccd1 _1928_ sky130_fd_sc_hd__or3_1
XFILLER_3_503 vssd1 vssd1 vccd1 vccd1 sky130_fd_sc_hd__fill_1
XFILLER_11_20 vssd1 vssd1 vccd1 vccd1 sky130_fd_sc_hd__fill_4
XFILLER_3_525 vccd1 vssd1 vccd1 vssd1 sky130_ef_sc_hd__decap_40_12
XFILLER_3_569 vssd1 vssd1 vccd1 vccd1 sky130_fd_sc_hd__fill_1
XANTENNA__7413__A2 net214 vssd1 vssd1 vccd1 vccd1 sky130_fd_sc_hd__diode_2
XFILLER_46_256 vssd1 vssd1 vccd1 vccd1 sky130_fd_sc_hd__fill_2
XTAP_TAPCELL_ROW_57_774 vssd1 vccd1 sky130_fd_sc_hd__tapvpwrvgnd_1
XFILLER_46_278 vssd1 vssd1 vccd1 vccd1 sky130_fd_sc_hd__fill_4
XTAP_TAPCELL_ROW_29_487 vssd1 vccd1 sky130_fd_sc_hd__tapvpwrvgnd_1
XFILLER_36_83 vssd1 vssd1 vccd1 vccd1 sky130_fd_sc_hd__fill_1
XFILLER_14_197 vssd1 vssd1 vccd1 vccd1 sky130_fd_sc_hd__fill_8
XFILLER_52_82 vssd1 vssd1 vccd1 vccd1 sky130_fd_sc_hd__fill_2
XTAP_TAPCELL_ROW_12_321 vssd1 vccd1 sky130_fd_sc_hd__tapvpwrvgnd_1
XANTENNA__5555__C net278 vssd1 vssd1 vccd1 vccd1 sky130_fd_sc_hd__diode_2
Xinput14 gpio_in[4] vssd1 vssd1 vccd1 vccd1 net14 sky130_fd_sc_hd__clkbuf_4
XFILLER_6_363 vssd1 vssd1 vccd1 vccd1 sky130_fd_sc_hd__fill_1
XFILLER_69_304 vssd1 vssd1 vccd1 vccd1 sky130_fd_sc_hd__fill_4
X_5060_ _2114_ _2146_ net73 net77 vssd1 vssd1 vccd1 vccd1 _0250_ sky130_fd_sc_hd__or4b_1
XFILLER_84_307 vssd1 vssd1 vccd1 vccd1 sky130_fd_sc_hd__fill_1
XFILLER_84_329 vssd1 vssd1 vccd1 vccd1 sky130_fd_sc_hd__fill_8
XANTENNA__6683__A net216 vssd1 vssd1 vccd1 vccd1 sky130_fd_sc_hd__diode_2
XANTENNA__4755__X _4033_ vssd1 vssd1 vccd1 vccd1 sky130_fd_sc_hd__diode_2
XFILLER_92_340 vccd1 vssd1 vccd1 vssd1 sky130_ef_sc_hd__decap_40_12
XANTENNA__4915__B _3774_ vssd1 vssd1 vccd1 vccd1 sky130_fd_sc_hd__diode_2
XFILLER_37_245 vccd1 vssd1 vccd1 vssd1 sky130_ef_sc_hd__decap_40_12
XFILLER_52_226 vssd1 vssd1 vccd1 vccd1 sky130_fd_sc_hd__fill_4
X_5962_ _1146_ _1151_ vssd1 vssd1 vccd1 vccd1 _1152_ sky130_fd_sc_hd__xnor2_1
X_7701_ _2712_ _2722_ _2955_ vssd1 vssd1 vccd1 vccd1 _2957_ sky130_fd_sc_hd__and3_1
XANTENNA__8106__C net294 vssd1 vssd1 vccd1 vccd1 sky130_fd_sc_hd__diode_2
XTAP_TAPCELL_ROW_82_1021 vssd1 vccd1 sky130_fd_sc_hd__tapvpwrvgnd_1
X_4913_ net130 net85 _4136_ _4135_ vssd1 vssd1 vccd1 vccd1 _0103_ sky130_fd_sc_hd__a31o_1
X_5893_ _1063_ _1065_ vssd1 vssd1 vccd1 vccd1 _1083_ sky130_fd_sc_hd__xor2_1
X_7632_ net268 net205 net209 net264 vssd1 vssd1 vccd1 vccd1 _2884_ sky130_fd_sc_hd__a22oi_1
X_4844_ _3982_ _4048_ _4121_ vssd1 vssd1 vccd1 vccd1 _4122_ sky130_fd_sc_hd__or3_1
X_7563_ _2737_ _2809_ vssd1 vssd1 vccd1 vccd1 _2811_ sky130_fd_sc_hd__xnor2_2
X_4775_ _4046_ _4052_ vssd1 vssd1 vccd1 vccd1 _4053_ sky130_fd_sc_hd__xnor2_1
X_6514_ _1987_ net72 _1538_ _1537_ vssd1 vssd1 vccd1 vccd1 _1701_ sky130_fd_sc_hd__o31a_1
XANTENNA_fanout122_A net123 vssd1 vssd1 vccd1 vccd1 sky130_fd_sc_hd__diode_2
X_7494_ net93 net53 vssd1 vssd1 vccd1 vccd1 _2738_ sky130_fd_sc_hd__nor2_1
X_6445_ _1622_ _1631_ vssd1 vssd1 vccd1 vccd1 _1633_ sky130_fd_sc_hd__xnor2_1
X_6376_ _1562_ _1563_ vssd1 vssd1 vccd1 vccd1 _1564_ sky130_fd_sc_hd__xor2_1
X_8115_ _3374_ vssd1 vssd1 vccd1 vccd1 _3376_ sky130_fd_sc_hd__inv_2
XANTENNA__4378__A net205 vssd1 vssd1 vccd1 vccd1 sky130_fd_sc_hd__diode_2
XFILLER_0_517 vccd1 vssd1 vccd1 vssd1 sky130_ef_sc_hd__decap_40_12
X_5327_ _0431_ _0445_ _0515_ vssd1 vssd1 vccd1 vccd1 _0517_ sky130_fd_sc_hd__or3_1
XFILLER_87_123 vccd1 vssd1 vccd1 vssd1 sky130_ef_sc_hd__decap_40_12
X_8046_ _3291_ _3298_ vssd1 vssd1 vccd1 vccd1 _3301_ sky130_fd_sc_hd__xnor2_1
XFILLER_87_167 vssd1 vssd1 vccd1 vccd1 sky130_fd_sc_hd__fill_1
XFILLER_75_318 vssd1 vssd1 vccd1 vccd1 sky130_fd_sc_hd__fill_2
X_5258_ _0446_ _0447_ vssd1 vssd1 vccd1 vccd1 _0448_ sky130_fd_sc_hd__nor2_1
XFILLER_87_189 vssd1 vssd1 vccd1 vccd1 sky130_fd_sc_hd__fill_2
X_4209_ net148 vssd1 vssd1 vccd1 vccd1 PID_INST.k3_calc.d1.y\[2\] sky130_fd_sc_hd__inv_2
X_5189_ _0374_ _0377_ vssd1 vssd1 vccd1 vccd1 _0379_ sky130_fd_sc_hd__xnor2_1
XFILLER_56_554 vssd1 vssd1 vccd1 vccd1 sky130_fd_sc_hd__fill_2
XFILLER_56_543 vssd1 vssd1 vccd1 vccd1 sky130_fd_sc_hd__fill_1
XANTENNA__4825__B net71 vssd1 vssd1 vccd1 vccd1 sky130_fd_sc_hd__diode_2
XANTENNA__6743__D net278 vssd1 vssd1 vccd1 vccd1 sky130_fd_sc_hd__diode_2
XTAP_TAPCELL_ROW_54_744 vssd1 vccd1 sky130_fd_sc_hd__tapvpwrvgnd_1
XFILLER_43_237 vssd1 vssd1 vccd1 vccd1 sky130_fd_sc_hd__fill_1
XTAP_TAPCELL_ROW_26_457 vssd1 vccd1 sky130_fd_sc_hd__tapvpwrvgnd_1
XANTENNA__4917__B1 _3774_ vssd1 vssd1 vccd1 vccd1 sky130_fd_sc_hd__diode_2
XFILLER_3_311 vssd1 vssd1 vccd1 vccd1 sky130_fd_sc_hd__fill_2
XFILLER_3_355 vccd1 vssd1 vccd1 vssd1 sky130_ef_sc_hd__decap_40_12
XANTENNA__7095__B1 net221 vssd1 vssd1 vccd1 vccd1 sky130_fd_sc_hd__diode_2
Xfanout180 PID_INST.k2_calc.sum_reg\[21\] vssd1 vssd1 vccd1 vccd1 net180 sky130_fd_sc_hd__buf_2
Xfanout191 net192 vssd1 vssd1 vccd1 vccd1 net191 sky130_fd_sc_hd__buf_2
XFILLER_19_223 vssd1 vssd1 vccd1 vccd1 sky130_fd_sc_hd__fill_1
XFILLER_74_384 vssd1 vssd1 vccd1 vccd1 sky130_fd_sc_hd__fill_8
XFILLER_62_524 vssd1 vssd1 vccd1 vccd1 sky130_fd_sc_hd__fill_4
XFILLER_19_278 vssd1 vssd1 vccd1 vccd1 sky130_fd_sc_hd__fill_2
XFILLER_30_421 vccd1 vssd1 vccd1 vssd1 sky130_ef_sc_hd__decap_40_12
XPHY_EDGE_ROW_7_Left_100 vssd1 vssd1 vccd1 vccd1 sky130_fd_sc_hd__decap_3
X_4560_ _3835_ _3836_ _3824_ vssd1 vssd1 vccd1 vccd1 _3838_ sky130_fd_sc_hd__a21o_1
XANTENNA__6373__A2 _0156_ vssd1 vssd1 vccd1 vccd1 sky130_fd_sc_hd__diode_2
XANTENNA__7781__B PID_INST.k2_calc.sum_reg\[16\] vssd1 vssd1 vccd1 vccd1 sky130_fd_sc_hd__diode_2
X_4491_ PID_INST.k1_calc.d1.x\[8\] PID_INST.k3_calc.prev_error\[8\] vssd1 vssd1 vccd1
+ vccd1 _3769_ sky130_fd_sc_hd__and2_1
XFILLER_6_171 vccd1 vssd1 vccd1 vssd1 sky130_ef_sc_hd__decap_40_12
X_6230_ _1417_ _1418_ vssd1 vssd1 vccd1 vccd1 _1419_ sky130_fd_sc_hd__and2_1
XANTENNA__6397__B net42 vssd1 vssd1 vccd1 vccd1 sky130_fd_sc_hd__diode_2
X_6161_ _1347_ _1348_ vssd1 vssd1 vccd1 vccd1 _1350_ sky130_fd_sc_hd__xor2_1
X_5112_ _0220_ net57 _0224_ _0300_ vssd1 vssd1 vccd1 vccd1 _0302_ sky130_fd_sc_hd__or4_1
XFILLER_69_167 vssd1 vssd1 vccd1 vccd1 sky130_fd_sc_hd__fill_1
X_6092_ _1279_ _1280_ _1281_ vssd1 vssd1 vccd1 vccd1 _1282_ sky130_fd_sc_hd__or3_1
XFILLER_57_329 vssd1 vssd1 vccd1 vccd1 sky130_fd_sc_hd__fill_4
XANTENNA__4926__A net137 vssd1 vssd1 vccd1 vccd1 sky130_fd_sc_hd__diode_2
X_5043_ _0171_ _0179_ _0178_ vssd1 vssd1 vccd1 vccd1 _0233_ sky130_fd_sc_hd__a21o_1
XFILLER_38_510 vssd1 vssd1 vccd1 vccd1 sky130_fd_sc_hd__fill_2
XANTENNA__7389__A1 net199 vssd1 vssd1 vccd1 vccd1 sky130_fd_sc_hd__diode_2
XANTENNA_clkbuf_4_7_0_clk_A clknet_0_clk vssd1 vssd1 vccd1 vccd1 sky130_fd_sc_hd__diode_2
XFILLER_38_565 vssd1 vssd1 vccd1 vccd1 sky130_fd_sc_hd__fill_1
XFILLER_25_248 vssd1 vssd1 vccd1 vccd1 sky130_fd_sc_hd__fill_2
X_6994_ _2078_ _2079_ _2092_ vssd1 vssd1 vccd1 vccd1 _2209_ sky130_fd_sc_hd__o21ai_1
XANTENNA__8382__RESET_B net340 vssd1 vssd1 vccd1 vccd1 sky130_fd_sc_hd__diode_2
XFILLER_80_365 vssd1 vssd1 vccd1 vccd1 sky130_fd_sc_hd__fill_2
XFILLER_25_259 vccd1 vssd1 vccd1 vssd1 sky130_ef_sc_hd__decap_40_12
XFILLER_40_207 vssd1 vssd1 vccd1 vccd1 sky130_fd_sc_hd__fill_4
X_5945_ net165 net80 _0496_ vssd1 vssd1 vccd1 vccd1 _1135_ sky130_fd_sc_hd__and3_1
X_5876_ _1063_ _1064_ _1061_ vssd1 vssd1 vccd1 vccd1 _1066_ sky130_fd_sc_hd__a21o_1
XTAP_TAPCELL_ROW_51_714 vssd1 vccd1 sky130_fd_sc_hd__tapvpwrvgnd_1
XTAP_TAPCELL_ROW_23_427 vssd1 vccd1 sky130_fd_sc_hd__tapvpwrvgnd_1
XANTENNA__7010__B1 net226 vssd1 vssd1 vccd1 vccd1 sky130_fd_sc_hd__diode_2
XANTENNA__4380__B net7 vssd1 vssd1 vccd1 vccd1 sky130_fd_sc_hd__diode_2
X_7615_ _2866_ _2853_ vssd1 vssd1 vccd1 vccd1 _2867_ sky130_fd_sc_hd__nand2b_1
X_4827_ _2210_ net148 net73 net75 vssd1 vssd1 vccd1 vccd1 _4105_ sky130_fd_sc_hd__or4b_1
XFILLER_21_443 vssd1 vssd1 vccd1 vccd1 sky130_fd_sc_hd__fill_2
X_4758_ _1817_ net71 vssd1 vssd1 vccd1 vccd1 _4036_ sky130_fd_sc_hd__nor2_1
XANTENNA_fanout125_X net125 vssd1 vssd1 vccd1 vccd1 sky130_fd_sc_hd__diode_2
X_7546_ _2791_ _2793_ vssd1 vssd1 vccd1 vccd1 _2794_ sky130_fd_sc_hd__xor2_1
X_7477_ net286 net195 _2718_ vssd1 vssd1 vccd1 vccd1 _2720_ sky130_fd_sc_hd__a21oi_1
X_4689_ net135 net152 vssd1 vssd1 vccd1 vccd1 _3967_ sky130_fd_sc_hd__nand2_1
XTAP_TAPCELL_ROW_91_1109 vssd1 vccd1 sky130_fd_sc_hd__tapvpwrvgnd_1
X_6428_ _1614_ _1615_ vssd1 vssd1 vccd1 vccd1 _1616_ sky130_fd_sc_hd__xnor2_1
XFILLER_68_15 vssd1 vssd1 vccd1 vccd1 sky130_fd_sc_hd__fill_2
X_6359_ _1148_ _1340_ _1342_ vssd1 vssd1 vccd1 vccd1 _1547_ sky130_fd_sc_hd__a21boi_1
XFILLER_48_307 vssd1 vssd1 vccd1 vccd1 sky130_fd_sc_hd__fill_1
XFILLER_0_347 vccd1 vssd1 vccd1 vssd1 sky130_ef_sc_hd__decap_40_12
XFILLER_88_498 vccd1 vssd1 vccd1 vssd1 sky130_ef_sc_hd__decap_40_12
XANTENNA__8308__A net322 vssd1 vssd1 vccd1 vccd1 sky130_fd_sc_hd__diode_2
X_8029_ _3131_ _3282_ vssd1 vssd1 vccd1 vccd1 _3283_ sky130_fd_sc_hd__xnor2_1
XFILLER_84_14 vssd1 vssd1 vccd1 vccd1 sky130_fd_sc_hd__fill_1
XFILLER_75_137 vssd1 vssd1 vccd1 vccd1 sky130_fd_sc_hd__fill_1
XFILLER_29_532 vssd1 vssd1 vccd1 vccd1 sky130_fd_sc_hd__fill_2
XFILLER_29_554 vssd1 vssd1 vccd1 vccd1 sky130_fd_sc_hd__fill_1
XFILLER_90_129 vssd1 vssd1 vccd1 vccd1 sky130_fd_sc_hd__fill_2
XANTENNA__4555__B net147 vssd1 vssd1 vccd1 vccd1 sky130_fd_sc_hd__diode_2
XFILLER_83_192 vssd1 vssd1 vccd1 vccd1 sky130_fd_sc_hd__fill_2
XFILLER_71_343 vssd1 vssd1 vccd1 vccd1 sky130_fd_sc_hd__fill_1
XFILLER_71_310 vssd1 vssd1 vccd1 vccd1 sky130_fd_sc_hd__fill_4
XANTENNA__6052__A1 net239 vssd1 vssd1 vccd1 vccd1 sky130_fd_sc_hd__diode_2
XFILLER_16_248 vssd1 vssd1 vccd1 vccd1 sky130_fd_sc_hd__fill_4
XTAP_TAPCELL_ROW_39_593 vssd1 vccd1 sky130_fd_sc_hd__tapvpwrvgnd_1
XFILLER_71_376 vssd1 vssd1 vccd1 vccd1 sky130_fd_sc_hd__fill_2
XFILLER_16_259 vssd1 vssd1 vccd1 vccd1 sky130_fd_sc_hd__fill_1
XFILLER_12_443 vccd1 vssd1 vccd1 vssd1 sky130_ef_sc_hd__decap_40_12
XPHY_EDGE_ROW_89_Left_182 vssd1 vssd1 vccd1 vccd1 sky130_fd_sc_hd__decap_3
XFILLER_3_141 vccd1 vssd1 vccd1 vssd1 sky130_ef_sc_hd__decap_40_12
XFILLER_79_443 vssd1 vssd1 vccd1 vccd1 sky130_fd_sc_hd__fill_4
Xhold3 PID_INST.k1_calc.d1.x\[12\] vssd1 vssd1 vccd1 vccd1 net396 sky130_fd_sc_hd__dlygate4sd3_1
XANTENNA__4746__A net97 vssd1 vssd1 vccd1 vccd1 sky130_fd_sc_hd__diode_2
XANTENNA__6961__A net100 vssd1 vssd1 vccd1 vccd1 sky130_fd_sc_hd__diode_2
XFILLER_35_557 vssd1 vssd1 vccd1 vccd1 sky130_fd_sc_hd__fill_1
XANTENNA__5577__A net314 vssd1 vssd1 vccd1 vccd1 sky130_fd_sc_hd__diode_2
X_5730_ _0874_ _0885_ _0903_ _0915_ vssd1 vssd1 vccd1 vccd1 _0920_ sky130_fd_sc_hd__o211a_1
XANTENNA__4481__A net120 vssd1 vssd1 vccd1 vccd1 sky130_fd_sc_hd__diode_2
XFILLER_15_281 vccd1 vssd1 vccd1 vssd1 sky130_ef_sc_hd__decap_40_12
XFILLER_30_240 vccd1 vssd1 vccd1 vssd1 sky130_ef_sc_hd__decap_40_12
X_7400_ _2638_ _2637_ vssd1 vssd1 vccd1 vccd1 _2639_ sky130_fd_sc_hd__and2b_1
X_5661_ _0760_ _0848_ _0850_ vssd1 vssd1 vccd1 vccd1 _0851_ sky130_fd_sc_hd__or3_1
XANTENNA__7543__A1 net112 vssd1 vssd1 vccd1 vccd1 sky130_fd_sc_hd__diode_2
X_5592_ net244 net274 vssd1 vssd1 vccd1 vccd1 _0782_ sky130_fd_sc_hd__nand2_1
Xclkbuf_4_4_0_clk clknet_0_clk vssd1 vssd1 vccd1 vccd1 clknet_4_4_0_clk sky130_fd_sc_hd__clkbuf_8
X_4612_ _3845_ _3888_ vssd1 vssd1 vccd1 vccd1 _3890_ sky130_fd_sc_hd__xor2_1
X_8380_ clknet_4_9_0_clk PID_INST.k3_calc.d2.y\[0\] net328 vssd1 vssd1 vccd1 vccd1
+ PID_INST.k3_calc.timescaling_term\[0\] sky130_fd_sc_hd__dfrtp_1
X_7331_ _2564_ _2563_ vssd1 vssd1 vccd1 vccd1 _2565_ sky130_fd_sc_hd__nand2b_1
X_4543_ _3815_ _3820_ _3814_ vssd1 vssd1 vccd1 vccd1 _3821_ sky130_fd_sc_hd__o21ba_1
X_7262_ _2489_ _2490_ vssd1 vssd1 vccd1 vccd1 _2492_ sky130_fd_sc_hd__xnor2_1
X_4474_ _3744_ _3745_ _3748_ vssd1 vssd1 vccd1 vccd1 _3752_ sky130_fd_sc_hd__and3_1
X_6213_ _1327_ _1401_ vssd1 vssd1 vccd1 vccd1 _1402_ sky130_fd_sc_hd__xnor2_1
X_7193_ net91 net60 _2160_ vssd1 vssd1 vccd1 vccd1 _2419_ sky130_fd_sc_hd__o21bai_1
X_6144_ _1330_ _1331_ vssd1 vssd1 vccd1 vccd1 _1333_ sky130_fd_sc_hd__xor2_1
XANTENNA__8128__A net286 vssd1 vssd1 vccd1 vccd1 sky130_fd_sc_hd__diode_2
X_6075_ _1241_ _1264_ vssd1 vssd1 vccd1 vccd1 _1265_ sky130_fd_sc_hd__or2_1
XANTENNA__4656__A net142 vssd1 vssd1 vccd1 vccd1 sky130_fd_sc_hd__diode_2
XANTENNA__7032__A net204 vssd1 vssd1 vccd1 vccd1 sky130_fd_sc_hd__diode_2
XFILLER_57_137 vssd1 vssd1 vccd1 vccd1 sky130_fd_sc_hd__fill_1
XANTENNA_fanout287_A net288 vssd1 vssd1 vccd1 vccd1 sky130_fd_sc_hd__diode_2
X_5026_ _0214_ _0215_ vssd1 vssd1 vccd1 vccd1 _0216_ sky130_fd_sc_hd__xnor2_2
XFILLER_85_479 vssd1 vssd1 vccd1 vccd1 sky130_fd_sc_hd__fill_8
XANTENNA__4375__B net6 vssd1 vssd1 vccd1 vccd1 sky130_fd_sc_hd__diode_2
XTAP_TAPCELL_ROW_88_1082 vssd1 vccd1 sky130_fd_sc_hd__tapvpwrvgnd_1
XFILLER_53_354 vssd1 vssd1 vccd1 vccd1 sky130_fd_sc_hd__fill_2
XTAP_TAPCELL_ROW_0_188 vssd1 vccd1 sky130_fd_sc_hd__tapvpwrvgnd_1
X_6977_ _2071_ _2077_ _2070_ vssd1 vssd1 vccd1 vccd1 _2191_ sky130_fd_sc_hd__a21oi_1
XTAP_TAPCELL_ROW_36_563 vssd1 vccd1 sky130_fd_sc_hd__tapvpwrvgnd_1
XFILLER_41_505 vssd1 vssd1 vccd1 vccd1 sky130_fd_sc_hd__fill_8
X_5928_ _0227_ _1117_ vssd1 vssd1 vccd1 vccd1 _1118_ sky130_fd_sc_hd__xnor2_1
XANTENNA__5487__A net103 vssd1 vssd1 vccd1 vccd1 sky130_fd_sc_hd__diode_2
XTAP_TAPCELL_ROW_0_199 vssd1 vccd1 sky130_fd_sc_hd__tapvpwrvgnd_1
X_5859_ _1047_ _1048_ vssd1 vssd1 vccd1 vccd1 _1049_ sky130_fd_sc_hd__nand2_1
XANTENNA__8310__B net201 vssd1 vssd1 vccd1 vccd1 sky130_fd_sc_hd__diode_2
X_7529_ _2775_ _2766_ vssd1 vssd1 vccd1 vccd1 _2776_ sky130_fd_sc_hd__nand2b_1
XFILLER_5_439 vssd1 vssd1 vccd1 vccd1 sky130_fd_sc_hd__fill_8
XFILLER_0_100 vssd1 vssd1 vccd1 vccd1 sky130_fd_sc_hd__fill_2
XFILLER_0_111 vssd1 vssd1 vccd1 vccd1 sky130_fd_sc_hd__fill_1
XFILLER_88_251 vssd1 vssd1 vccd1 vccd1 sky130_fd_sc_hd__fill_1
XTAP_TAPCELL_ROW_8_277 vssd1 vccd1 sky130_fd_sc_hd__tapvpwrvgnd_1
XFILLER_88_284 vssd1 vssd1 vccd1 vccd1 sky130_fd_sc_hd__fill_2
XFILLER_48_115 vssd1 vssd1 vccd1 vccd1 sky130_fd_sc_hd__fill_4
XFILLER_88_295 vssd1 vssd1 vccd1 vccd1 sky130_fd_sc_hd__fill_2
XANTENNA_input15_A gpio_in[5] vssd1 vssd1 vccd1 vccd1 sky130_fd_sc_hd__diode_2
XANTENNA__4284__A0 net19 vssd1 vssd1 vccd1 vccd1 sky130_fd_sc_hd__diode_2
XFILLER_17_535 vssd1 vssd1 vccd1 vccd1 sky130_fd_sc_hd__fill_1
XFILLER_44_365 vssd1 vssd1 vccd1 vccd1 sky130_fd_sc_hd__fill_4
XFILLER_17_557 vssd1 vssd1 vccd1 vccd1 sky130_fd_sc_hd__fill_2
XFILLER_32_527 vssd1 vssd1 vccd1 vccd1 sky130_fd_sc_hd__fill_4
XANTENNA__8204__C net187 vssd1 vssd1 vccd1 vccd1 sky130_fd_sc_hd__diode_2
XTAP_TAPCELL_ROW_70_897 vssd1 vccd1 sky130_fd_sc_hd__tapvpwrvgnd_1
XFILLER_8_211 vssd1 vssd1 vccd1 vccd1 sky130_fd_sc_hd__fill_8
XFILLER_12_251 vssd1 vssd1 vccd1 vccd1 sky130_fd_sc_hd__fill_1
XFILLER_12_284 vssd1 vssd1 vccd1 vccd1 sky130_fd_sc_hd__fill_4
XFILLER_8_288 vssd1 vssd1 vccd1 vccd1 sky130_fd_sc_hd__fill_2
XFILLER_8_277 vssd1 vssd1 vccd1 vccd1 sky130_fd_sc_hd__fill_2
XANTENNA__7117__A net200 vssd1 vssd1 vccd1 vccd1 sky130_fd_sc_hd__diode_2
XFILLER_69_80 vssd1 vssd1 vccd1 vccd1 sky130_fd_sc_hd__fill_4
XFILLER_5_99 vssd1 vssd1 vccd1 vccd1 sky130_fd_sc_hd__fill_2
X_4190_ net3 net173 _2040_ vssd1 vssd1 vccd1 vccd1 _2051_ sky130_fd_sc_hd__o21ai_4
XFILLER_39_115 vssd1 vssd1 vccd1 vccd1 sky130_fd_sc_hd__fill_4
XFILLER_10_3 vssd1 vssd1 vccd1 vccd1 sky130_fd_sc_hd__fill_4
XANTENNA__4195__B net175 vssd1 vssd1 vccd1 vccd1 sky130_fd_sc_hd__diode_2
XFILLER_82_449 vssd1 vssd1 vccd1 vccd1 sky130_fd_sc_hd__fill_2
XFILLER_75_490 vssd1 vssd1 vccd1 vccd1 sky130_fd_sc_hd__fill_1
XFILLER_47_181 vccd1 vssd1 vccd1 vssd1 sky130_ef_sc_hd__decap_40_12
X_7880_ net99 net40 vssd1 vssd1 vccd1 vccd1 _3135_ sky130_fd_sc_hd__nor2_1
X_6900_ _1986_ _2109_ vssd1 vssd1 vccd1 vccd1 _2110_ sky130_fd_sc_hd__and2_1
X_6831_ _2034_ _2035_ vssd1 vssd1 vccd1 vccd1 _2036_ sky130_fd_sc_hd__nand2_1
X_6762_ _1848_ _1852_ _1850_ vssd1 vssd1 vccd1 vccd1 _1963_ sky130_fd_sc_hd__o21ba_1
XTAP_TAPCELL_ROW_33_533 vssd1 vccd1 sky130_fd_sc_hd__tapvpwrvgnd_1
X_5713_ _0890_ _0902_ _0887_ vssd1 vssd1 vccd1 vccd1 _0903_ sky130_fd_sc_hd__a21o_1
X_6693_ _1889_ _1890_ vssd1 vssd1 vccd1 vccd1 _1891_ sky130_fd_sc_hd__or2_1
X_5644_ _0822_ _0823_ _0832_ vssd1 vssd1 vccd1 vccd1 _0834_ sky130_fd_sc_hd__o21ai_1
X_8432_ clknet_4_1_0_clk net404 net326 vssd1 vssd1 vccd1 vccd1 PID_INST.k3_calc.prev_error\[4\]
+ sky130_fd_sc_hd__dfrtp_1
X_8363_ net423 _3641_ net154 vssd1 vssd1 vccd1 vccd1 _0074_ sky130_fd_sc_hd__mux2_1
XANTENNA__7672__D net194 vssd1 vssd1 vccd1 vccd1 sky130_fd_sc_hd__diode_2
X_5575_ net231 net287 _0763_ vssd1 vssd1 vccd1 vccd1 _0765_ sky130_fd_sc_hd__a21o_1
X_7314_ _2463_ _2466_ _2545_ vssd1 vssd1 vccd1 vccd1 _2547_ sky130_fd_sc_hd__nand3_1
X_8294_ net281 net276 net185 net183 vssd1 vssd1 vccd1 vccd1 _3567_ sky130_fd_sc_hd__nand4_1
XANTENNA_fanout202_A PID_INST.k2_calc.sum_reg\[12\] vssd1 vssd1 vccd1 vccd1 sky130_fd_sc_hd__diode_2
X_4526_ net123 net79 vssd1 vssd1 vccd1 vccd1 _3804_ sky130_fd_sc_hd__nand2_1
XANTENNA__7819__A2 net47 vssd1 vssd1 vccd1 vccd1 sky130_fd_sc_hd__diode_2
X_4457_ _3720_ _3725_ _3719_ vssd1 vssd1 vccd1 vccd1 _3735_ sky130_fd_sc_hd__a21oi_1
X_7245_ _2472_ _2473_ vssd1 vssd1 vccd1 vccd1 _2475_ sky130_fd_sc_hd__and2_1
X_7176_ _2153_ _2154_ _2155_ _2148_ vssd1 vssd1 vccd1 vccd1 _2401_ sky130_fd_sc_hd__a22oi_2
X_4388_ net197 net8 vssd1 vssd1 vccd1 vccd1 _3681_ sky130_fd_sc_hd__nand2_1
XANTENNA_input7_A gpio_in[14] vssd1 vssd1 vccd1 vccd1 sky130_fd_sc_hd__diode_2
X_6127_ net116 net51 net50 net114 vssd1 vssd1 vccd1 vccd1 _1316_ sky130_fd_sc_hd__o22a_1
XANTENNA_fanout192_X net192 vssd1 vssd1 vccd1 vccd1 sky130_fd_sc_hd__diode_2
XTAP_TAPCELL_ROW_5_247 vssd1 vccd1 sky130_fd_sc_hd__tapvpwrvgnd_1
X_6058_ net231 net283 net278 net236 vssd1 vssd1 vccd1 vccd1 _1248_ sky130_fd_sc_hd__a22oi_1
XFILLER_85_298 vssd1 vssd1 vccd1 vccd1 sky130_fd_sc_hd__fill_1
X_5009_ _0125_ _0198_ vssd1 vssd1 vccd1 vccd1 _0199_ sky130_fd_sc_hd__nor2_1
XANTENNA__5929__B net50 vssd1 vssd1 vccd1 vccd1 sky130_fd_sc_hd__diode_2
XFILLER_26_343 vssd1 vssd1 vccd1 vccd1 sky130_fd_sc_hd__fill_1
XFILLER_81_482 vssd1 vssd1 vccd1 vccd1 sky130_fd_sc_hd__fill_8
XFILLER_81_471 vssd1 vssd1 vccd1 vccd1 sky130_fd_sc_hd__fill_1
XANTENNA__7755__A1 net275 vssd1 vssd1 vccd1 vccd1 sky130_fd_sc_hd__diode_2
XANTENNA__6106__A net101 vssd1 vssd1 vccd1 vccd1 sky130_fd_sc_hd__diode_2
XFILLER_14_42 vssd1 vssd1 vccd1 vccd1 sky130_fd_sc_hd__fill_8
XFILLER_14_53 vssd1 vssd1 vccd1 vccd1 sky130_fd_sc_hd__fill_8
XFILLER_41_368 vssd1 vssd1 vccd1 vccd1 sky130_fd_sc_hd__fill_1
XANTENNA__5518__B1 net280 vssd1 vssd1 vccd1 vccd1 sky130_fd_sc_hd__diode_2
XFILLER_14_75 vssd1 vssd1 vccd1 vccd1 sky130_fd_sc_hd__fill_1
XANTENNA__8485__RESET_B net341 vssd1 vssd1 vccd1 vccd1 sky130_fd_sc_hd__diode_2
XANTENNA_clkbuf_4_15_0_clk_A clknet_0_clk vssd1 vssd1 vccd1 vccd1 sky130_fd_sc_hd__diode_2
XFILLER_1_486 vssd1 vssd1 vccd1 vccd1 sky130_fd_sc_hd__fill_1
XANTENNA__8414__RESET_B net327 vssd1 vssd1 vccd1 vccd1 sky130_fd_sc_hd__diode_2
XFILLER_49_446 vssd1 vssd1 vccd1 vccd1 sky130_fd_sc_hd__fill_2
XFILLER_39_83 vssd1 vssd1 vccd1 vccd1 sky130_fd_sc_hd__fill_1
XFILLER_91_202 vssd1 vssd1 vccd1 vccd1 sky130_fd_sc_hd__fill_1
XANTENNA__7103__C net258 vssd1 vssd1 vccd1 vccd1 sky130_fd_sc_hd__diode_2
XFILLER_64_449 vssd1 vssd1 vccd1 vccd1 sky130_fd_sc_hd__fill_1
XFILLER_64_427 vssd1 vssd1 vccd1 vccd1 sky130_fd_sc_hd__fill_1
XANTENNA_input18_X net18 vssd1 vssd1 vccd1 vccd1 sky130_fd_sc_hd__diode_2
XTAP_TAPCELL_ROW_47_669 vssd1 vccd1 sky130_fd_sc_hd__tapvpwrvgnd_1
XFILLER_55_93 vssd1 vssd1 vccd1 vccd1 sky130_fd_sc_hd__fill_2
XFILLER_44_173 vccd1 vssd1 vccd1 vssd1 sky130_ef_sc_hd__decap_40_12
XANTENNA__4743__B net63 vssd1 vssd1 vccd1 vccd1 sky130_fd_sc_hd__diode_2
XFILLER_17_365 vssd1 vssd1 vccd1 vccd1 sky130_fd_sc_hd__fill_1
XFILLER_17_376 vssd1 vssd1 vccd1 vccd1 sky130_fd_sc_hd__fill_2
XFILLER_32_313 vssd1 vssd1 vccd1 vccd1 sky130_fd_sc_hd__fill_2
XFILLER_44_195 vssd1 vssd1 vccd1 vccd1 sky130_fd_sc_hd__fill_1
XANTENNA__5221__A2 net87 vssd1 vssd1 vccd1 vccd1 sky130_fd_sc_hd__diode_2
XFILLER_32_335 vccd1 vssd1 vccd1 vssd1 sky130_ef_sc_hd__decap_40_12
XTAP_TAPCELL_ROW_30_503 vssd1 vccd1 sky130_fd_sc_hd__tapvpwrvgnd_1
XANTENNA__5574__B net287 vssd1 vssd1 vccd1 vccd1 sky130_fd_sc_hd__diode_2
XFILLER_9_564 vssd1 vssd1 vccd1 vccd1 sky130_fd_sc_hd__fill_4
X_5360_ _0480_ _0549_ vssd1 vssd1 vccd1 vccd1 _0550_ sky130_fd_sc_hd__xnor2_2
X_4311_ net245 net13 vssd1 vssd1 vccd1 vccd1 _3310_ sky130_fd_sc_hd__or2_1
X_5291_ net166 net85 vssd1 vssd1 vccd1 vccd1 _0481_ sky130_fd_sc_hd__nand2_1
X_7030_ net300 net196 net190 net313 vssd1 vssd1 vccd1 vccd1 _2248_ sky130_fd_sc_hd__a22oi_1
X_4242_ PID_INST.k3_calc.timescaling_term\[10\] net169 vssd1 vssd1 vccd1 vccd1 _2601_
+ sky130_fd_sc_hd__or2_1
X_4173_ PID_INST.k3_calc.timescaling_term\[7\] net170 vssd1 vssd1 vccd1 vccd1 _1871_
+ sky130_fd_sc_hd__or2_1
XTAP_TAPCELL_ROW_2_217 vssd1 vccd1 sky130_fd_sc_hd__tapvpwrvgnd_1
XFILLER_82_224 vssd1 vssd1 vccd1 vccd1 sky130_fd_sc_hd__fill_2
X_7932_ net217 net209 net256 net252 vssd1 vssd1 vccd1 vccd1 _3187_ sky130_fd_sc_hd__and4_1
XFILLER_55_449 vssd1 vssd1 vccd1 vccd1 sky130_fd_sc_hd__fill_4
XFILLER_27_118 vssd1 vssd1 vccd1 vccd1 sky130_fd_sc_hd__fill_1
XTAP_TAPCELL_ROW_85_1052 vssd1 vccd1 sky130_fd_sc_hd__tapvpwrvgnd_1
XFILLER_70_419 vssd1 vssd1 vccd1 vccd1 sky130_fd_sc_hd__fill_1
X_7863_ _3117_ _3118_ vssd1 vssd1 vccd1 vccd1 _3119_ sky130_fd_sc_hd__xnor2_1
X_7794_ _3048_ _3049_ vssd1 vssd1 vccd1 vccd1 _3050_ sky130_fd_sc_hd__nor2_1
X_6814_ _2017_ vssd1 vssd1 vccd1 vccd1 _2018_ sky130_fd_sc_hd__inv_2
XFILLER_50_121 vssd1 vssd1 vccd1 vccd1 sky130_fd_sc_hd__fill_8
XTAP_TAPCELL_ROW_18_382 vssd1 vccd1 sky130_fd_sc_hd__tapvpwrvgnd_1
XFILLER_23_324 vssd1 vssd1 vccd1 vccd1 sky130_fd_sc_hd__fill_2
X_6745_ _1942_ _1943_ vssd1 vssd1 vccd1 vccd1 _1945_ sky130_fd_sc_hd__nor2_1
XANTENNA__7964__B net277 vssd1 vssd1 vccd1 vccd1 sky130_fd_sc_hd__diode_2
XFILLER_50_165 vssd1 vssd1 vccd1 vccd1 sky130_fd_sc_hd__fill_4
XFILLER_50_154 vssd1 vssd1 vccd1 vccd1 sky130_fd_sc_hd__fill_4
X_6676_ _1869_ _1870_ _1872_ vssd1 vssd1 vccd1 vccd1 _1873_ sky130_fd_sc_hd__or3_1
X_8415_ clknet_4_1_0_clk net122 net327 vssd1 vssd1 vccd1 vccd1 PID_INST.k3_calc.kd_term\[3\]
+ sky130_fd_sc_hd__dfrtp_1
XFILLER_31_390 vssd1 vssd1 vccd1 vccd1 sky130_fd_sc_hd__fill_2
X_5627_ _0805_ _0815_ vssd1 vssd1 vccd1 vccd1 _0817_ sky130_fd_sc_hd__xnor2_1
XANTENNA_fanout205_X net205 vssd1 vssd1 vccd1 vccd1 sky130_fd_sc_hd__diode_2
X_5558_ net227 net295 _0747_ vssd1 vssd1 vccd1 vccd1 _0748_ sky130_fd_sc_hd__and3_1
X_8346_ net92 net42 vssd1 vssd1 vccd1 vccd1 _3624_ sky130_fd_sc_hd__nor2_1
X_8277_ _3417_ _3424_ _3426_ vssd1 vssd1 vccd1 vccd1 _3550_ sky130_fd_sc_hd__a21o_1
X_4509_ _3785_ _3786_ vssd1 vssd1 vccd1 vccd1 _3787_ sky130_fd_sc_hd__or2_1
XANTENNA__6596__A net116 vssd1 vssd1 vccd1 vccd1 sky130_fd_sc_hd__diode_2
XANTENNA__7673__B1 net196 vssd1 vssd1 vccd1 vccd1 sky130_fd_sc_hd__diode_2
X_5489_ _0672_ _0673_ _0677_ _0678_ vssd1 vssd1 vccd1 vccd1 _0679_ sky130_fd_sc_hd__o211a_1
X_7228_ _2455_ _2456_ vssd1 vssd1 vccd1 vccd1 _2457_ sky130_fd_sc_hd__xnor2_1
X_7159_ _2374_ _2375_ _2382_ vssd1 vssd1 vccd1 vccd1 _2383_ sky130_fd_sc_hd__and3_1
XANTENNA__7204__B net51 vssd1 vssd1 vccd1 vccd1 sky130_fd_sc_hd__diode_2
XANTENNA_fanout65_A _3964_ vssd1 vssd1 vccd1 vccd1 sky130_fd_sc_hd__diode_2
XFILLER_92_69 vccd1 vssd1 vccd1 vssd1 sky130_ef_sc_hd__decap_40_12
XFILLER_73_279 vssd1 vssd1 vccd1 vccd1 sky130_fd_sc_hd__fill_1
XTAP_TAPCELL_ROW_44_639 vssd1 vccd1 sky130_fd_sc_hd__tapvpwrvgnd_1
XFILLER_26_173 vssd1 vssd1 vccd1 vccd1 sky130_fd_sc_hd__fill_2
XFILLER_25_63 vssd1 vssd1 vccd1 vccd1 sky130_fd_sc_hd__fill_1
XFILLER_25_85 vssd1 vssd1 vccd1 vccd1 sky130_fd_sc_hd__fill_8
XFILLER_41_198 vssd1 vssd1 vccd1 vccd1 sky130_fd_sc_hd__fill_4
XFILLER_6_501 vssd1 vssd1 vccd1 vccd1 sky130_fd_sc_hd__fill_1
XANTENNA__7900__A1 net110 vssd1 vssd1 vccd1 vccd1 sky130_fd_sc_hd__diode_2
XFILLER_6_512 vssd1 vssd1 vccd1 vccd1 sky130_fd_sc_hd__fill_4
XANTENNA__6164__B1 net70 vssd1 vssd1 vccd1 vccd1 sky130_fd_sc_hd__diode_2
XANTENNA__7900__B2 net140 vssd1 vssd1 vccd1 vccd1 sky130_fd_sc_hd__diode_2
XFILLER_6_567 vssd1 vssd1 vccd1 vccd1 sky130_fd_sc_hd__fill_2
XANTENNA__4190__A2 net173 vssd1 vssd1 vccd1 vccd1 sky130_fd_sc_hd__diode_2
XPHY_EDGE_ROW_16_Left_109 vssd1 vssd1 vccd1 vccd1 sky130_fd_sc_hd__decap_3
XFILLER_49_254 vssd1 vssd1 vccd1 vccd1 sky130_fd_sc_hd__fill_1
XFILLER_2_67 vssd1 vssd1 vccd1 vccd1 sky130_fd_sc_hd__fill_1
XFILLER_92_533 vssd1 vssd1 vccd1 vccd1 sky130_fd_sc_hd__fill_2
Xteam_03_391 vssd1 vssd1 vccd1 vccd1 gpio_oeb[15] team_03_391/LO sky130_fd_sc_hd__conb_1
XFILLER_64_224 vssd1 vssd1 vccd1 vccd1 sky130_fd_sc_hd__fill_1
Xteam_03_380 vssd1 vssd1 vccd1 vccd1 gpio_oeb[4] team_03_380/LO sky130_fd_sc_hd__conb_1
XFILLER_2_89 vssd1 vssd1 vccd1 vccd1 sky130_fd_sc_hd__fill_2
XANTENNA__7130__A net229 vssd1 vssd1 vccd1 vccd1 sky130_fd_sc_hd__diode_2
X_4860_ _4136_ _4137_ vssd1 vssd1 vccd1 vccd1 _4138_ sky130_fd_sc_hd__xor2_1
XTAP_TAPCELL_ROW_15_352 vssd1 vccd1 sky130_fd_sc_hd__tapvpwrvgnd_1
XPHY_EDGE_ROW_25_Left_118 vssd1 vssd1 vccd1 vccd1 sky130_fd_sc_hd__decap_3
X_6530_ net134 _0087_ vssd1 vssd1 vccd1 vccd1 _1717_ sky130_fd_sc_hd__nand2_1
X_4791_ _4063_ _4068_ vssd1 vssd1 vccd1 vccd1 _4069_ sky130_fd_sc_hd__xnor2_1
X_6461_ _1647_ _1648_ vssd1 vssd1 vccd1 vccd1 _1649_ sky130_fd_sc_hd__xnor2_1
X_8200_ _3465_ _3466_ vssd1 vssd1 vccd1 vccd1 _3467_ sky130_fd_sc_hd__nor2_1
X_5412_ _0600_ _0601_ _0599_ vssd1 vssd1 vccd1 vccd1 _0602_ sky130_fd_sc_hd__o21a_1
X_6392_ _1185_ _1388_ vssd1 vssd1 vccd1 vccd1 _1580_ sky130_fd_sc_hd__or2_1
X_8131_ _3383_ _3384_ _3391_ vssd1 vssd1 vccd1 vccd1 _3393_ sky130_fd_sc_hd__a21oi_1
X_5343_ _0532_ _0519_ vssd1 vssd1 vccd1 vccd1 _0533_ sky130_fd_sc_hd__nand2b_1
XANTENNA__4181__A2 net173 vssd1 vssd1 vccd1 vccd1 sky130_fd_sc_hd__diode_2
XANTENNA__6458__A1 net223 vssd1 vssd1 vccd1 vccd1 sky130_fd_sc_hd__diode_2
XANTENNA__6458__B2 net228 vssd1 vssd1 vccd1 vccd1 sky130_fd_sc_hd__diode_2
XANTENNA__4929__A net135 vssd1 vssd1 vccd1 vccd1 sky130_fd_sc_hd__diode_2
X_8062_ net267 net263 net197 net194 vssd1 vssd1 vccd1 vccd1 _3318_ sky130_fd_sc_hd__and4_1
X_5274_ _0451_ _0463_ vssd1 vssd1 vccd1 vccd1 _0464_ sky130_fd_sc_hd__xnor2_1
XPHY_EDGE_ROW_34_Left_127 vssd1 vssd1 vccd1 vccd1 sky130_fd_sc_hd__decap_3
XFILLER_87_349 vssd1 vssd1 vccd1 vccd1 sky130_fd_sc_hd__fill_2
X_7013_ _2227_ _2228_ vssd1 vssd1 vccd1 vccd1 _2229_ sky130_fd_sc_hd__xnor2_1
X_4225_ net15 net167 _2410_ vssd1 vssd1 vccd1 vccd1 _2421_ sky130_fd_sc_hd__o21ai_1
XANTENNA__7959__B net194 vssd1 vssd1 vccd1 vccd1 sky130_fd_sc_hd__diode_2
XANTENNA__7958__A1 net206 vssd1 vssd1 vccd1 vccd1 sky130_fd_sc_hd__diode_2
XFILLER_83_555 vssd1 vssd1 vccd1 vccd1 sky130_fd_sc_hd__fill_4
XFILLER_70_205 vssd1 vssd1 vccd1 vccd1 sky130_fd_sc_hd__fill_4
X_7915_ _3167_ _3168_ vssd1 vssd1 vccd1 vccd1 _3170_ sky130_fd_sc_hd__nand2_1
XFILLER_36_471 vssd1 vssd1 vccd1 vccd1 sky130_fd_sc_hd__fill_4
X_7846_ _2852_ _2868_ _2851_ vssd1 vssd1 vccd1 vccd1 _3102_ sky130_fd_sc_hd__a21oi_1
XPHY_EDGE_ROW_43_Left_136 vssd1 vssd1 vccd1 vccd1 sky130_fd_sc_hd__decap_3
XTAP_TAPCELL_ROW_41_609 vssd1 vccd1 sky130_fd_sc_hd__tapvpwrvgnd_1
X_7777_ _2921_ _2924_ _2922_ vssd1 vssd1 vccd1 vccd1 _3033_ sky130_fd_sc_hd__o21ba_1
X_4989_ _0172_ _0177_ vssd1 vssd1 vccd1 vccd1 _0179_ sky130_fd_sc_hd__xnor2_1
XFILLER_23_198 vssd1 vssd1 vccd1 vccd1 sky130_fd_sc_hd__fill_1
X_6728_ _1919_ _1925_ vssd1 vssd1 vccd1 vccd1 _1927_ sky130_fd_sc_hd__xnor2_1
XANTENNA_fanout322_X net322 vssd1 vssd1 vccd1 vccd1 sky130_fd_sc_hd__diode_2
X_6659_ net223 net220 net284 net279 vssd1 vssd1 vccd1 vccd1 _1854_ sky130_fd_sc_hd__and4_1
X_8329_ _3559_ _3605_ vssd1 vssd1 vccd1 vccd1 _3606_ sky130_fd_sc_hd__xnor2_1
XFILLER_3_537 vccd1 vssd1 vccd1 vssd1 sky130_ef_sc_hd__decap_40_12
XPHY_EDGE_ROW_52_Left_145 vssd1 vssd1 vccd1 vccd1 sky130_fd_sc_hd__decap_3
XFILLER_3_559 vssd1 vssd1 vccd1 vccd1 sky130_fd_sc_hd__fill_1
XFILLER_78_305 vssd1 vssd1 vccd1 vccd1 sky130_fd_sc_hd__fill_2
XANTENNA__8386__CLK clknet_4_9_0_clk vssd1 vssd1 vccd1 vccd1 sky130_fd_sc_hd__diode_2
Xfanout340 net341 vssd1 vssd1 vccd1 vccd1 net340 sky130_fd_sc_hd__buf_4
XFILLER_19_405 vssd1 vssd1 vccd1 vccd1 sky130_fd_sc_hd__fill_4
XFILLER_86_393 vssd1 vssd1 vccd1 vccd1 sky130_fd_sc_hd__fill_8
XFILLER_86_371 vssd1 vssd1 vccd1 vccd1 sky130_fd_sc_hd__fill_1
XFILLER_74_511 vssd1 vssd1 vccd1 vccd1 sky130_fd_sc_hd__fill_2
XFILLER_74_555 vssd1 vssd1 vccd1 vccd1 sky130_fd_sc_hd__fill_1
XPHY_EDGE_ROW_61_Left_154 vssd1 vssd1 vccd1 vccd1 sky130_fd_sc_hd__decap_3
XTAP_TAPCELL_ROW_57_775 vssd1 vccd1 sky130_fd_sc_hd__tapvpwrvgnd_1
XFILLER_27_471 vssd1 vssd1 vccd1 vccd1 sky130_fd_sc_hd__fill_1
XTAP_TAPCELL_ROW_29_488 vssd1 vccd1 sky130_fd_sc_hd__tapvpwrvgnd_1
XFILLER_14_187 vssd1 vssd1 vccd1 vccd1 sky130_fd_sc_hd__fill_2
XFILLER_42_496 vccd1 vssd1 vccd1 vssd1 sky130_ef_sc_hd__decap_40_12
XTAP_TAPCELL_ROW_12_322 vssd1 vccd1 sky130_fd_sc_hd__tapvpwrvgnd_1
XANTENNA__5555__D net239 vssd1 vssd1 vccd1 vccd1 sky130_fd_sc_hd__diode_2
Xinput15 gpio_in[5] vssd1 vssd1 vccd1 vccd1 net15 sky130_fd_sc_hd__clkbuf_4
XFILLER_10_371 vssd1 vssd1 vccd1 vccd1 sky130_fd_sc_hd__fill_1
XFILLER_6_331 vssd1 vssd1 vccd1 vccd1 sky130_fd_sc_hd__fill_1
XPHY_EDGE_ROW_70_Left_163 vssd1 vssd1 vccd1 vccd1 sky130_fd_sc_hd__decap_3
XFILLER_6_375 vssd1 vssd1 vccd1 vccd1 sky130_fd_sc_hd__fill_2
XANTENNA__6948__B net63 vssd1 vssd1 vccd1 vccd1 sky130_fd_sc_hd__diode_2
XANTENNA__6683__B net289 vssd1 vssd1 vccd1 vccd1 sky130_fd_sc_hd__diode_2
XFILLER_77_393 vssd1 vssd1 vccd1 vccd1 sky130_fd_sc_hd__fill_1
XFILLER_77_382 vssd1 vssd1 vccd1 vccd1 sky130_fd_sc_hd__fill_8
XFILLER_65_533 vssd1 vssd1 vccd1 vccd1 sky130_fd_sc_hd__fill_2
XFILLER_92_352 vccd1 vssd1 vccd1 vssd1 sky130_ef_sc_hd__decap_40_12
XFILLER_65_544 vssd1 vssd1 vccd1 vccd1 sky130_fd_sc_hd__fill_1
XFILLER_52_205 vssd1 vssd1 vccd1 vccd1 sky130_fd_sc_hd__fill_1
XFILLER_18_471 vssd1 vssd1 vccd1 vccd1 sky130_fd_sc_hd__fill_4
X_5961_ _1149_ _1150_ vssd1 vssd1 vccd1 vccd1 _1151_ sky130_fd_sc_hd__xnor2_1
X_7700_ _2712_ _2722_ _2955_ vssd1 vssd1 vccd1 vccd1 _2956_ sky130_fd_sc_hd__a21oi_1
XTAP_TAPCELL_ROW_82_1022 vssd1 vccd1 sky130_fd_sc_hd__tapvpwrvgnd_1
XFILLER_80_547 vssd1 vssd1 vccd1 vccd1 sky130_fd_sc_hd__fill_1
XFILLER_52_238 vssd1 vssd1 vccd1 vccd1 sky130_fd_sc_hd__fill_2
X_4912_ _4048_ _4116_ _4118_ _2178_ vssd1 vssd1 vccd1 vccd1 _0102_ sky130_fd_sc_hd__o22a_1
X_7631_ net268 net264 net205 net209 vssd1 vssd1 vccd1 vccd1 _2883_ sky130_fd_sc_hd__and4_1
X_5892_ net251 _1081_ vssd1 vssd1 vccd1 vccd1 _1082_ sky130_fd_sc_hd__nand2_1
XFILLER_60_260 vssd1 vssd1 vccd1 vccd1 sky130_fd_sc_hd__fill_4
X_4843_ _4119_ _4120_ vssd1 vssd1 vccd1 vccd1 _4121_ sky130_fd_sc_hd__xnor2_1
XFILLER_33_474 vssd1 vssd1 vccd1 vccd1 sky130_fd_sc_hd__fill_1
XFILLER_33_496 vssd1 vssd1 vccd1 vccd1 sky130_fd_sc_hd__fill_1
XFILLER_33_485 vssd1 vssd1 vccd1 vccd1 sky130_fd_sc_hd__fill_4
X_7562_ _2737_ _2809_ vssd1 vssd1 vccd1 vccd1 _2810_ sky130_fd_sc_hd__nand2_1
X_4774_ _3976_ _4050_ vssd1 vssd1 vccd1 vccd1 _4052_ sky130_fd_sc_hd__xor2_1
XFILLER_20_146 vssd1 vssd1 vccd1 vccd1 sky130_fd_sc_hd__fill_4
X_7493_ _2735_ _2736_ vssd1 vssd1 vccd1 vccd1 _2737_ sky130_fd_sc_hd__nor2_2
X_6513_ _1698_ _1699_ vssd1 vssd1 vccd1 vccd1 _1700_ sky130_fd_sc_hd__nand2_1
X_6444_ _1631_ _1622_ vssd1 vssd1 vccd1 vccd1 _1632_ sky130_fd_sc_hd__nand2b_1
XANTENNA_clkbuf_4_3_0_clk_A clknet_0_clk vssd1 vssd1 vccd1 vccd1 sky130_fd_sc_hd__diode_2
XANTENNA__4659__A net113 vssd1 vssd1 vccd1 vccd1 sky130_fd_sc_hd__diode_2
X_6375_ net129 net69 vssd1 vssd1 vccd1 vccd1 _1563_ sky130_fd_sc_hd__nand2_1
X_8114_ _3203_ _3205_ _3373_ vssd1 vssd1 vccd1 vccd1 _3374_ sky130_fd_sc_hd__o21a_1
XFILLER_0_529 vssd1 vssd1 vccd1 vccd1 sky130_fd_sc_hd__fill_2
X_5326_ _0431_ _0445_ _0515_ vssd1 vssd1 vccd1 vccd1 _0516_ sky130_fd_sc_hd__o21ai_2
XFILLER_87_135 vssd1 vssd1 vccd1 vccd1 sky130_fd_sc_hd__fill_2
X_8045_ _3298_ _3291_ vssd1 vssd1 vccd1 vccd1 _3300_ sky130_fd_sc_hd__nand2b_1
X_5257_ _0384_ _0386_ vssd1 vssd1 vccd1 vccd1 _0447_ sky130_fd_sc_hd__nor2_1
XANTENNA__6851__A1 net95 vssd1 vssd1 vccd1 vccd1 sky130_fd_sc_hd__diode_2
X_4208_ net14 net173 _2231_ vssd1 vssd1 vccd1 vccd1 _2242_ sky130_fd_sc_hd__o21ai_2
XFILLER_68_360 vssd1 vssd1 vccd1 vccd1 sky130_fd_sc_hd__fill_4
X_5188_ _0374_ _0377_ vssd1 vssd1 vccd1 vccd1 _0378_ sky130_fd_sc_hd__and2b_1
XFILLER_56_533 vssd1 vssd1 vccd1 vccd1 sky130_fd_sc_hd__fill_8
XFILLER_28_235 vssd1 vssd1 vccd1 vccd1 sky130_fd_sc_hd__fill_4
XFILLER_83_363 vssd1 vssd1 vccd1 vccd1 sky130_fd_sc_hd__fill_2
XFILLER_71_514 vccd1 vssd1 vccd1 vssd1 sky130_ef_sc_hd__decap_40_12
XFILLER_71_503 vssd1 vssd1 vccd1 vccd1 sky130_fd_sc_hd__fill_1
XFILLER_16_419 vssd1 vssd1 vccd1 vccd1 sky130_fd_sc_hd__fill_1
XFILLER_28_268 vssd1 vssd1 vccd1 vccd1 sky130_fd_sc_hd__fill_1
XTAP_TAPCELL_ROW_54_745 vssd1 vccd1 sky130_fd_sc_hd__tapvpwrvgnd_1
XFILLER_43_249 vssd1 vssd1 vccd1 vccd1 sky130_fd_sc_hd__fill_2
XFILLER_71_569 vssd1 vssd1 vccd1 vccd1 sky130_fd_sc_hd__fill_1
XTAP_TAPCELL_ROW_26_458 vssd1 vccd1 sky130_fd_sc_hd__tapvpwrvgnd_1
X_7829_ _3073_ _3084_ vssd1 vssd1 vccd1 vccd1 _3085_ sky130_fd_sc_hd__xnor2_1
XFILLER_22_75 vssd1 vssd1 vccd1 vccd1 sky130_fd_sc_hd__fill_1
XPHY_EDGE_ROW_5_Left_98 vssd1 vssd1 vccd1 vccd1 sky130_fd_sc_hd__decap_3
XFILLER_3_367 vssd1 vssd1 vccd1 vccd1 sky130_fd_sc_hd__fill_2
XANTENNA__7095__A1 net266 vssd1 vssd1 vccd1 vccd1 sky130_fd_sc_hd__diode_2
XFILLER_3_389 vssd1 vssd1 vccd1 vccd1 sky130_fd_sc_hd__fill_2
Xfanout192 net193 vssd1 vssd1 vccd1 vccd1 net192 sky130_fd_sc_hd__clkbuf_2
Xfanout181 net182 vssd1 vssd1 vccd1 vccd1 net181 sky130_fd_sc_hd__buf_2
Xfanout170 _1849_ vssd1 vssd1 vccd1 vccd1 net170 sky130_fd_sc_hd__buf_1
XFILLER_34_216 vssd1 vssd1 vccd1 vccd1 sky130_fd_sc_hd__fill_2
XFILLER_34_227 vssd1 vssd1 vccd1 vccd1 sky130_fd_sc_hd__fill_1
XFILLER_62_569 vssd1 vssd1 vccd1 vccd1 sky130_fd_sc_hd__fill_1
XFILLER_15_441 vssd1 vssd1 vccd1 vccd1 sky130_fd_sc_hd__fill_4
XFILLER_30_411 vssd1 vssd1 vccd1 vccd1 sky130_fd_sc_hd__fill_8
XFILLER_30_433 vssd1 vssd1 vccd1 vccd1 sky130_fd_sc_hd__fill_4
XFILLER_30_477 vssd1 vssd1 vccd1 vccd1 sky130_fd_sc_hd__fill_4
XFILLER_30_488 vssd1 vssd1 vccd1 vccd1 sky130_fd_sc_hd__fill_2
XANTENNA__7858__B1 _3053_ vssd1 vssd1 vccd1 vccd1 sky130_fd_sc_hd__diode_2
X_4490_ PID_INST.k1_calc.d1.x\[8\] PID_INST.k3_calc.prev_error\[8\] vssd1 vssd1 vccd1
+ vccd1 _3768_ sky130_fd_sc_hd__nor2_1
XFILLER_6_194 vssd1 vssd1 vccd1 vccd1 sky130_fd_sc_hd__fill_2
XFILLER_40_3 vssd1 vssd1 vccd1 vccd1 sky130_fd_sc_hd__fill_1
X_6160_ _1347_ _1348_ vssd1 vssd1 vccd1 vccd1 _1349_ sky130_fd_sc_hd__nand2b_1
X_5111_ _0220_ net57 _0224_ _0300_ vssd1 vssd1 vccd1 vccd1 _0301_ sky130_fd_sc_hd__o31ai_2
XANTENNA__4198__B _1784_ vssd1 vssd1 vccd1 vccd1 sky130_fd_sc_hd__diode_2
XFILLER_57_308 vssd1 vssd1 vccd1 vccd1 sky130_fd_sc_hd__fill_4
X_6091_ _0733_ _0882_ _0880_ vssd1 vssd1 vccd1 vccd1 _1281_ sky130_fd_sc_hd__a21oi_1
X_5042_ _0158_ _0166_ _0165_ vssd1 vssd1 vccd1 vccd1 _0232_ sky130_fd_sc_hd__o21ai_1
XFILLER_38_533 vccd1 vssd1 vccd1 vssd1 sky130_ef_sc_hd__decap_40_12
XANTENNA__7389__A2 net288 vssd1 vssd1 vccd1 vccd1 sky130_fd_sc_hd__diode_2
XFILLER_92_182 vccd1 vssd1 vccd1 vssd1 sky130_ef_sc_hd__decap_40_12
X_6993_ _2206_ _2207_ vssd1 vssd1 vccd1 vccd1 _2208_ sky130_fd_sc_hd__or2_1
X_5944_ _1131_ _1132_ vssd1 vssd1 vccd1 vccd1 _1134_ sky130_fd_sc_hd__xnor2_2
XFILLER_80_399 vssd1 vssd1 vccd1 vccd1 sky130_fd_sc_hd__fill_1
X_5875_ _1061_ _1064_ vssd1 vssd1 vccd1 vccd1 _1065_ sky130_fd_sc_hd__and2b_1
XTAP_TAPCELL_ROW_51_715 vssd1 vccd1 sky130_fd_sc_hd__tapvpwrvgnd_1
XTAP_TAPCELL_ROW_23_428 vssd1 vccd1 sky130_fd_sc_hd__tapvpwrvgnd_1
XANTENNA__7010__B2 net266 vssd1 vssd1 vccd1 vccd1 sky130_fd_sc_hd__diode_2
XANTENNA_fanout232_A PID_INST.k2_calc.sum_reg\[5\] vssd1 vssd1 vccd1 vccd1 sky130_fd_sc_hd__diode_2
X_4826_ _2210_ net73 vssd1 vssd1 vccd1 vccd1 _4104_ sky130_fd_sc_hd__nor2_1
X_7614_ _2854_ _2865_ vssd1 vssd1 vccd1 vccd1 _2866_ sky130_fd_sc_hd__xnor2_1
X_7545_ net112 net37 vssd1 vssd1 vccd1 vccd1 _2793_ sky130_fd_sc_hd__nor2_1
X_4757_ _4033_ _4034_ vssd1 vssd1 vccd1 vccd1 _4035_ sky130_fd_sc_hd__nand2_1
X_7476_ net286 net195 _2718_ vssd1 vssd1 vccd1 vccd1 _2719_ sky130_fd_sc_hd__and3_1
X_4688_ _3837_ _3839_ vssd1 vssd1 vccd1 vccd1 _3966_ sky130_fd_sc_hd__nand2_1
XANTENNA_fanout118_X net118 vssd1 vssd1 vccd1 vccd1 sky130_fd_sc_hd__diode_2
X_6427_ net319 net195 vssd1 vssd1 vccd1 vccd1 _1615_ sky130_fd_sc_hd__nand2_1
X_6358_ _1544_ _1545_ vssd1 vssd1 vccd1 vccd1 _1546_ sky130_fd_sc_hd__or2_1
XFILLER_68_27 vssd1 vssd1 vccd1 vccd1 sky130_fd_sc_hd__fill_1
XFILLER_0_304 vssd1 vssd1 vccd1 vccd1 sky130_fd_sc_hd__fill_4
XFILLER_0_337 vssd1 vssd1 vccd1 vccd1 sky130_fd_sc_hd__fill_1
X_5309_ _0497_ _0498_ vssd1 vssd1 vccd1 vccd1 _0499_ sky130_fd_sc_hd__nor2_1
XFILLER_88_477 vccd1 vssd1 vccd1 vssd1 sky130_ef_sc_hd__decap_40_12
XFILLER_88_444 vssd1 vssd1 vccd1 vccd1 sky130_fd_sc_hd__fill_4
X_6289_ _1475_ _1476_ vssd1 vssd1 vccd1 vccd1 _1478_ sky130_fd_sc_hd__xnor2_1
XFILLER_29_511 vssd1 vssd1 vccd1 vccd1 sky130_fd_sc_hd__fill_1
X_8028_ net102 net40 vssd1 vssd1 vccd1 vccd1 _3282_ sky130_fd_sc_hd__nor2_1
XFILLER_84_26 vssd1 vssd1 vccd1 vccd1 sky130_fd_sc_hd__fill_2
XANTENNA__6109__A net97 vssd1 vssd1 vccd1 vccd1 sky130_fd_sc_hd__diode_2
XTAP_TAPCELL_ROW_67_870 vssd1 vccd1 sky130_fd_sc_hd__tapvpwrvgnd_1
XANTENNA__4555__C _3774_ vssd1 vssd1 vccd1 vccd1 sky130_fd_sc_hd__diode_2
XANTENNA__6052__A2 net273 vssd1 vssd1 vccd1 vccd1 sky130_fd_sc_hd__diode_2
XTAP_TAPCELL_ROW_39_594 vssd1 vccd1 sky130_fd_sc_hd__tapvpwrvgnd_1
XANTENNA__8439__RESET_B net331 vssd1 vssd1 vccd1 vccd1 sky130_fd_sc_hd__diode_2
XFILLER_12_433 vssd1 vssd1 vccd1 vccd1 sky130_fd_sc_hd__fill_2
XFILLER_12_455 vssd1 vssd1 vccd1 vccd1 sky130_fd_sc_hd__fill_8
XFILLER_24_293 vssd1 vssd1 vccd1 vccd1 sky130_fd_sc_hd__fill_1
XFILLER_33_63 vssd1 vssd1 vccd1 vccd1 sky130_fd_sc_hd__fill_2
XFILLER_3_153 vccd1 vssd1 vccd1 vssd1 sky130_ef_sc_hd__decap_40_12
XFILLER_39_308 vssd1 vssd1 vccd1 vccd1 sky130_fd_sc_hd__fill_2
XFILLER_58_71 vssd1 vssd1 vccd1 vccd1 sky130_fd_sc_hd__fill_4
Xhold4 PID_INST.k1_calc.d1.x\[7\] vssd1 vssd1 vccd1 vccd1 net397 sky130_fd_sc_hd__dlygate4sd3_1
XANTENNA__4746__B net65 vssd1 vssd1 vccd1 vccd1 sky130_fd_sc_hd__diode_2
XANTENNA__6103__A_N net156 vssd1 vssd1 vccd1 vccd1 sky130_fd_sc_hd__diode_2
XFILLER_35_503 vssd1 vssd1 vccd1 vccd1 sky130_fd_sc_hd__fill_1
XANTENNA__6961__B net53 vssd1 vssd1 vccd1 vccd1 sky130_fd_sc_hd__diode_2
XFILLER_35_525 vssd1 vssd1 vccd1 vccd1 sky130_fd_sc_hd__fill_1
XANTENNA__4481__B net113 vssd1 vssd1 vccd1 vccd1 sky130_fd_sc_hd__diode_2
X_5660_ _0847_ _0849_ vssd1 vssd1 vccd1 vccd1 _0850_ sky130_fd_sc_hd__nand2_1
XFILLER_15_293 vssd1 vssd1 vccd1 vccd1 sky130_fd_sc_hd__fill_8
XFILLER_88_3 vccd1 vssd1 vccd1 vssd1 sky130_ef_sc_hd__decap_40_12
X_4611_ _3845_ _3888_ vssd1 vssd1 vccd1 vccd1 _3889_ sky130_fd_sc_hd__nor2_1
XANTENNA__5593__A net216 vssd1 vssd1 vccd1 vccd1 sky130_fd_sc_hd__diode_2
X_5591_ _0779_ _0780_ vssd1 vssd1 vccd1 vccd1 _0781_ sky130_fd_sc_hd__and2_1
X_7330_ _2316_ _2318_ _2314_ vssd1 vssd1 vccd1 vccd1 _2564_ sky130_fd_sc_hd__o21ba_1
X_4542_ _3817_ _3818_ vssd1 vssd1 vccd1 vccd1 _3820_ sky130_fd_sc_hd__xnor2_1
X_7261_ _2489_ _2490_ vssd1 vssd1 vccd1 vccd1 _2491_ sky130_fd_sc_hd__nand2b_1
X_4473_ _3750_ vssd1 vssd1 vccd1 vccd1 _3751_ sky130_fd_sc_hd__inv_2
X_6212_ _1328_ _1400_ vssd1 vssd1 vccd1 vccd1 _1401_ sky130_fd_sc_hd__xnor2_1
X_7192_ net90 net60 vssd1 vssd1 vccd1 vccd1 _2418_ sky130_fd_sc_hd__nor2_1
X_6143_ _1330_ _1331_ vssd1 vssd1 vccd1 vccd1 _1332_ sky130_fd_sc_hd__nor2_1
X_6074_ _1261_ _1263_ vssd1 vssd1 vccd1 vccd1 _1264_ sky130_fd_sc_hd__nand2_1
XANTENNA__4656__B net86 vssd1 vssd1 vccd1 vccd1 sky130_fd_sc_hd__diode_2
XFILLER_85_458 vssd1 vssd1 vccd1 vccd1 sky130_fd_sc_hd__fill_1
XFILLER_85_447 vssd1 vssd1 vccd1 vccd1 sky130_fd_sc_hd__fill_1
XANTENNA__8128__B net186 vssd1 vssd1 vccd1 vccd1 sky130_fd_sc_hd__diode_2
XANTENNA__7032__B net292 vssd1 vssd1 vccd1 vccd1 sky130_fd_sc_hd__diode_2
X_5025_ _0101_ _0137_ _0136_ vssd1 vssd1 vccd1 vccd1 _0215_ sky130_fd_sc_hd__o21ai_2
XANTENNA__4293__A1 net12 vssd1 vssd1 vccd1 vccd1 sky130_fd_sc_hd__diode_2
XFILLER_26_503 vssd1 vssd1 vccd1 vccd1 sky130_fd_sc_hd__fill_1
XFILLER_38_363 vssd1 vssd1 vccd1 vccd1 sky130_fd_sc_hd__fill_1
XTAP_TAPCELL_ROW_88_1083 vssd1 vccd1 sky130_fd_sc_hd__tapvpwrvgnd_1
XFILLER_80_141 vssd1 vssd1 vccd1 vccd1 sky130_fd_sc_hd__fill_4
XFILLER_80_130 vssd1 vssd1 vccd1 vccd1 sky130_fd_sc_hd__fill_8
XTAP_TAPCELL_ROW_64_840 vssd1 vccd1 sky130_fd_sc_hd__tapvpwrvgnd_1
X_6976_ _2180_ _2189_ vssd1 vssd1 vccd1 vccd1 _2190_ sky130_fd_sc_hd__xnor2_1
XFILLER_26_569 vssd1 vssd1 vccd1 vccd1 sky130_fd_sc_hd__fill_1
X_5927_ net114 net52 vssd1 vssd1 vccd1 vccd1 _1117_ sky130_fd_sc_hd__nor2_2
XANTENNA__5487__B net53 vssd1 vssd1 vccd1 vccd1 sky130_fd_sc_hd__diode_2
XTAP_TAPCELL_ROW_0_189 vssd1 vccd1 sky130_fd_sc_hd__tapvpwrvgnd_1
XFILLER_13_208 vssd1 vssd1 vccd1 vccd1 sky130_fd_sc_hd__fill_8
XTAP_TAPCELL_ROW_36_564 vssd1 vccd1 sky130_fd_sc_hd__tapvpwrvgnd_1
X_5858_ _1028_ _1045_ vssd1 vssd1 vccd1 vccd1 _1048_ sky130_fd_sc_hd__xnor2_1
X_5789_ net318 PID_INST.k2_calc.sum_reg\[5\] _0889_ vssd1 vssd1 vccd1 vccd1 _0979_
+ sky130_fd_sc_hd__a21oi_1
X_4809_ _4015_ _4017_ _4018_ _4085_ _4086_ vssd1 vssd1 vccd1 vccd1 _4087_ sky130_fd_sc_hd__o311a_1
XPHY_EDGE_ROW_17_Right_17 vssd1 vssd1 vccd1 vccd1 sky130_fd_sc_hd__decap_3
X_7528_ _2767_ _2774_ vssd1 vssd1 vccd1 vccd1 _2775_ sky130_fd_sc_hd__xnor2_1
X_7459_ _2698_ _2699_ vssd1 vssd1 vccd1 vccd1 _2701_ sky130_fd_sc_hd__xnor2_1
XFILLER_79_15 vssd1 vssd1 vccd1 vccd1 sky130_fd_sc_hd__fill_1
XANTENNA__8310__C net256 vssd1 vssd1 vccd1 vccd1 sky130_fd_sc_hd__diode_2
XANTENNA__5008__A net132 vssd1 vssd1 vccd1 vccd1 sky130_fd_sc_hd__diode_2
XANTENNA__8319__A net293 vssd1 vssd1 vccd1 vccd1 sky130_fd_sc_hd__diode_2
XTAP_TAPCELL_ROW_8_278 vssd1 vccd1 sky130_fd_sc_hd__tapvpwrvgnd_1
XFILLER_0_123 vccd1 vssd1 vccd1 vssd1 sky130_ef_sc_hd__decap_40_12
XANTENNA__4847__A net138 vssd1 vssd1 vccd1 vccd1 sky130_fd_sc_hd__diode_2
XFILLER_76_414 vssd1 vssd1 vccd1 vccd1 sky130_fd_sc_hd__fill_1
XFILLER_0_178 vssd1 vssd1 vccd1 vccd1 sky130_fd_sc_hd__fill_8
XFILLER_0_167 vssd1 vssd1 vccd1 vccd1 sky130_fd_sc_hd__fill_1
XPHY_EDGE_ROW_26_Right_26 vssd1 vssd1 vccd1 vccd1 sky130_fd_sc_hd__decap_3
XANTENNA__7223__A net140 vssd1 vssd1 vccd1 vccd1 sky130_fd_sc_hd__diode_2
XFILLER_76_458 vssd1 vssd1 vccd1 vccd1 sky130_fd_sc_hd__fill_4
XFILLER_76_436 vssd1 vssd1 vccd1 vccd1 sky130_fd_sc_hd__fill_8
XFILLER_76_469 vssd1 vssd1 vccd1 vccd1 sky130_fd_sc_hd__fill_4
XFILLER_17_503 vssd1 vssd1 vccd1 vccd1 sky130_fd_sc_hd__fill_1
XANTENNA_fanout50_X net50 vssd1 vssd1 vccd1 vccd1 sky130_fd_sc_hd__diode_2
XFILLER_28_85 vssd1 vssd1 vccd1 vccd1 sky130_fd_sc_hd__fill_1
XFILLER_17_569 vssd1 vssd1 vccd1 vccd1 sky130_fd_sc_hd__fill_1
XFILLER_44_51 vssd1 vssd1 vccd1 vccd1 sky130_fd_sc_hd__fill_1
XANTENNA_clkbuf_4_11_0_clk_A clknet_0_clk vssd1 vssd1 vccd1 vccd1 sky130_fd_sc_hd__diode_2
XFILLER_8_201 vssd1 vssd1 vccd1 vccd1 sky130_fd_sc_hd__fill_1
XFILLER_12_241 vssd1 vssd1 vccd1 vccd1 sky130_fd_sc_hd__fill_8
XPHY_EDGE_ROW_35_Right_35 vssd1 vssd1 vccd1 vccd1 sky130_fd_sc_hd__decap_3
XTAP_TAPCELL_ROW_70_898 vssd1 vccd1 sky130_fd_sc_hd__tapvpwrvgnd_1
XFILLER_8_234 vssd1 vssd1 vccd1 vccd1 sky130_fd_sc_hd__fill_1
XFILLER_4_440 vssd1 vssd1 vccd1 vccd1 sky130_fd_sc_hd__fill_8
XANTENNA__7404__Y _2643_ vssd1 vssd1 vccd1 vccd1 sky130_fd_sc_hd__diode_2
XANTENNA__4757__A _4033_ vssd1 vssd1 vccd1 vccd1 sky130_fd_sc_hd__diode_2
XPHY_EDGE_ROW_44_Right_44 vssd1 vssd1 vccd1 vccd1 sky130_fd_sc_hd__decap_3
XFILLER_79_274 vssd1 vssd1 vccd1 vccd1 sky130_fd_sc_hd__fill_1
XFILLER_67_458 vssd1 vssd1 vccd1 vccd1 sky130_fd_sc_hd__fill_1
XFILLER_67_447 vssd1 vssd1 vccd1 vccd1 sky130_fd_sc_hd__fill_1
XTAP_TAPCELL_ROW_78_976 vssd1 vccd1 sky130_fd_sc_hd__tapvpwrvgnd_1
XFILLER_75_480 vssd1 vssd1 vccd1 vccd1 sky130_fd_sc_hd__fill_1
XFILLER_47_193 vssd1 vssd1 vccd1 vccd1 sky130_fd_sc_hd__fill_8
X_6830_ _1737_ _1739_ _2033_ vssd1 vssd1 vccd1 vccd1 _2035_ sky130_fd_sc_hd__or3_2
X_6761_ _1958_ _1959_ _1960_ vssd1 vssd1 vccd1 vccd1 _1962_ sky130_fd_sc_hd__o21ai_1
XTAP_TAPCELL_ROW_61_810 vssd1 vccd1 sky130_fd_sc_hd__tapvpwrvgnd_1
XFILLER_23_517 vccd1 vssd1 vccd1 vssd1 sky130_ef_sc_hd__decap_40_12
X_5712_ _0899_ _0901_ vssd1 vssd1 vccd1 vccd1 _0902_ sky130_fd_sc_hd__nand2_1
XPHY_EDGE_ROW_53_Right_53 vssd1 vssd1 vccd1 vccd1 sky130_fd_sc_hd__decap_3
XFILLER_50_347 vssd1 vssd1 vccd1 vccd1 sky130_fd_sc_hd__fill_1
XFILLER_50_336 vssd1 vssd1 vccd1 vccd1 sky130_fd_sc_hd__fill_2
XTAP_TAPCELL_ROW_33_534 vssd1 vccd1 sky130_fd_sc_hd__tapvpwrvgnd_1
X_6692_ _1669_ _1670_ _1672_ _1675_ vssd1 vssd1 vccd1 vccd1 _1890_ sky130_fd_sc_hd__a31oi_1
X_5643_ _0822_ _0823_ _0832_ vssd1 vssd1 vccd1 vccd1 _0833_ sky130_fd_sc_hd__or3_1
X_8431_ clknet_4_1_0_clk net402 net326 vssd1 vssd1 vccd1 vccd1 PID_INST.k3_calc.prev_error\[3\]
+ sky130_fd_sc_hd__dfrtp_1
X_5574_ net231 net287 _0763_ vssd1 vssd1 vccd1 vccd1 _0764_ sky130_fd_sc_hd__nand3_1
X_8362_ _3545_ _3640_ vssd1 vssd1 vccd1 vccd1 _3641_ sky130_fd_sc_hd__xnor2_1
X_4525_ _3800_ _3802_ vssd1 vssd1 vccd1 vccd1 _3803_ sky130_fd_sc_hd__nand2_1
X_7313_ _2463_ _2466_ _2545_ vssd1 vssd1 vccd1 vccd1 _2546_ sky130_fd_sc_hd__a21o_1
X_8293_ net276 net185 net183 net281 vssd1 vssd1 vccd1 vccd1 _3566_ sky130_fd_sc_hd__a22o_1
XANTENNA__4750__A2 _4001_ vssd1 vssd1 vccd1 vccd1 sky130_fd_sc_hd__diode_2
XPHY_EDGE_ROW_62_Right_62 vssd1 vssd1 vccd1 vccd1 sky130_fd_sc_hd__decap_3
X_4456_ _3731_ _3732_ vssd1 vssd1 vccd1 vccd1 _3734_ sky130_fd_sc_hd__nand2_4
X_7244_ _2215_ _2217_ _2471_ vssd1 vssd1 vccd1 vccd1 _2473_ sky130_fd_sc_hd__nand3_2
X_4387_ net197 net8 vssd1 vssd1 vccd1 vccd1 _3680_ sky130_fd_sc_hd__nor2_1
X_7175_ _2118_ _2156_ _2158_ vssd1 vssd1 vccd1 vccd1 _2400_ sky130_fd_sc_hd__o21bai_1
XFILLER_85_200 vssd1 vssd1 vccd1 vccd1 sky130_fd_sc_hd__fill_1
XFILLER_58_414 vssd1 vssd1 vccd1 vccd1 sky130_fd_sc_hd__fill_4
X_6126_ _1117_ _1314_ vssd1 vssd1 vccd1 vccd1 _1315_ sky130_fd_sc_hd__nand2_1
XFILLER_85_244 vssd1 vssd1 vccd1 vccd1 sky130_fd_sc_hd__fill_2
XTAP_TAPCELL_ROW_5_248 vssd1 vccd1 sky130_fd_sc_hd__tapvpwrvgnd_1
X_6057_ net232 net283 net278 net236 vssd1 vssd1 vccd1 vccd1 _1247_ sky130_fd_sc_hd__and4_1
XANTENNA__4266__A1 net11 vssd1 vssd1 vccd1 vccd1 sky130_fd_sc_hd__diode_2
XFILLER_73_439 vssd1 vssd1 vccd1 vccd1 sky130_fd_sc_hd__fill_1
X_5008_ net132 net79 vssd1 vssd1 vccd1 vccd1 _0198_ sky130_fd_sc_hd__nand2_1
XFILLER_26_355 vssd1 vssd1 vccd1 vccd1 sky130_fd_sc_hd__fill_4
XPHY_EDGE_ROW_71_Right_71 vssd1 vssd1 vccd1 vccd1 sky130_fd_sc_hd__decap_3
XFILLER_14_506 vssd1 vssd1 vccd1 vccd1 sky130_fd_sc_hd__fill_1
XANTENNA__6106__B net63 vssd1 vssd1 vccd1 vccd1 sky130_fd_sc_hd__diode_2
X_6959_ _2064_ _2170_ vssd1 vssd1 vccd1 vccd1 _2172_ sky130_fd_sc_hd__nand2_1
XANTENNA__5945__B net80 vssd1 vssd1 vccd1 vccd1 sky130_fd_sc_hd__diode_2
XPHY_EDGE_ROW_80_Right_80 vssd1 vssd1 vccd1 vccd1 sky130_fd_sc_hd__decap_3
XANTENNA_fanout98_X net98 vssd1 vssd1 vccd1 vccd1 sky130_fd_sc_hd__diode_2
XANTENNA__7691__A1 net305 vssd1 vssd1 vccd1 vccd1 sky130_fd_sc_hd__diode_2
XFILLER_89_561 vssd1 vssd1 vccd1 vccd1 sky130_fd_sc_hd__fill_4
XFILLER_76_222 vccd1 vssd1 vccd1 vssd1 sky130_ef_sc_hd__decap_40_12
XFILLER_76_211 vssd1 vssd1 vccd1 vccd1 sky130_fd_sc_hd__fill_1
XFILLER_39_62 vssd1 vssd1 vccd1 vccd1 sky130_fd_sc_hd__fill_1
XFILLER_76_255 vssd1 vssd1 vccd1 vccd1 sky130_fd_sc_hd__fill_8
XFILLER_76_244 vssd1 vssd1 vccd1 vccd1 sky130_fd_sc_hd__fill_1
XANTENNA__7103__D net254 vssd1 vssd1 vccd1 vccd1 sky130_fd_sc_hd__diode_2
Xclkbuf_4_3_0_clk clknet_0_clk vssd1 vssd1 vccd1 vccd1 clknet_4_3_0_clk sky130_fd_sc_hd__clkbuf_8
XFILLER_36_108 vssd1 vssd1 vccd1 vccd1 sky130_fd_sc_hd__fill_4
XFILLER_91_236 vssd1 vssd1 vccd1 vccd1 sky130_fd_sc_hd__fill_1
XTAP_TAPCELL_ROW_75_946 vssd1 vccd1 sky130_fd_sc_hd__tapvpwrvgnd_1
XFILLER_72_450 vssd1 vssd1 vccd1 vccd1 sky130_fd_sc_hd__fill_1
XFILLER_44_185 vssd1 vssd1 vccd1 vccd1 sky130_fd_sc_hd__fill_8
XFILLER_32_347 vssd1 vssd1 vccd1 vccd1 sky130_fd_sc_hd__fill_8
XTAP_TAPCELL_ROW_30_504 vssd1 vccd1 sky130_fd_sc_hd__tapvpwrvgnd_1
XFILLER_40_380 vccd1 vssd1 vccd1 vssd1 sky130_ef_sc_hd__decap_40_12
XFILLER_72_6 vccd1 vssd1 vccd1 vssd1 sky130_ef_sc_hd__decap_40_12
XANTENNA__6967__A net97 vssd1 vssd1 vccd1 vccd1 sky130_fd_sc_hd__diode_2
X_4310_ net245 net13 vssd1 vssd1 vccd1 vccd1 _3299_ sky130_fd_sc_hd__nand2_1
X_5290_ _0478_ _0479_ vssd1 vssd1 vccd1 vccd1 _0480_ sky130_fd_sc_hd__xnor2_2
X_4241_ net101 vssd1 vssd1 vccd1 vccd1 PID_INST.k3_calc.d2.y\[11\] sky130_fd_sc_hd__inv_2
XFILLER_67_233 vssd1 vssd1 vccd1 vccd1 sky130_fd_sc_hd__fill_1
XFILLER_67_222 vssd1 vssd1 vccd1 vccd1 sky130_fd_sc_hd__fill_2
X_4172_ PID_INST.pid.curr_state\[2\] _1838_ PID_INST.pid.curr_state\[3\] vssd1 vssd1
+ vccd1 vccd1 _1860_ sky130_fd_sc_hd__or3b_1
XTAP_TAPCELL_ROW_2_218 vssd1 vccd1 sky130_fd_sc_hd__tapvpwrvgnd_1
X_7931_ net209 net256 net252 net214 vssd1 vssd1 vccd1 vccd1 _3186_ sky130_fd_sc_hd__a22oi_1
XFILLER_67_277 vssd1 vssd1 vccd1 vccd1 sky130_fd_sc_hd__fill_2
XANTENNA__4934__B net79 vssd1 vssd1 vccd1 vccd1 sky130_fd_sc_hd__diode_2
XFILLER_27_108 vssd1 vssd1 vccd1 vccd1 sky130_fd_sc_hd__fill_1
XTAP_TAPCELL_ROW_85_1053 vssd1 vccd1 sky130_fd_sc_hd__tapvpwrvgnd_1
XFILLER_63_461 vssd1 vssd1 vccd1 vccd1 sky130_fd_sc_hd__fill_8
X_7862_ _2816_ _2970_ _2969_ vssd1 vssd1 vccd1 vccd1 _3118_ sky130_fd_sc_hd__a21oi_1
XFILLER_35_163 vssd1 vssd1 vccd1 vccd1 sky130_fd_sc_hd__fill_4
X_7793_ _2956_ _2959_ _3047_ vssd1 vssd1 vccd1 vccd1 _3049_ sky130_fd_sc_hd__nor3_1
XFILLER_90_291 vssd1 vssd1 vccd1 vccd1 sky130_fd_sc_hd__fill_8
X_6813_ _2015_ _2016_ vssd1 vssd1 vccd1 vccd1 _2017_ sky130_fd_sc_hd__or2_1
XTAP_TAPCELL_ROW_18_383 vssd1 vccd1 sky130_fd_sc_hd__tapvpwrvgnd_1
X_6744_ net215 net284 net278 net219 vssd1 vssd1 vccd1 vccd1 _1943_ sky130_fd_sc_hd__a22oi_1
XANTENNA__7964__C net192 vssd1 vssd1 vccd1 vccd1 sky130_fd_sc_hd__diode_2
X_6675_ _1634_ _1635_ _1637_ _1659_ vssd1 vssd1 vccd1 vccd1 _1872_ sky130_fd_sc_hd__a31oi_1
X_5626_ _0805_ _0815_ vssd1 vssd1 vccd1 vccd1 _0816_ sky130_fd_sc_hd__nand2b_1
X_8414_ clknet_4_1_0_clk net120 net327 vssd1 vssd1 vccd1 vccd1 PID_INST.k3_calc.kd_term\[2\]
+ sky130_fd_sc_hd__dfrtp_1
XANTENNA_fanout312_A net316 vssd1 vssd1 vccd1 vccd1 sky130_fd_sc_hd__diode_2
X_5557_ _0745_ _0746_ vssd1 vssd1 vccd1 vccd1 _0747_ sky130_fd_sc_hd__nor2_1
XANTENNA__6877__A net117 vssd1 vssd1 vccd1 vccd1 sky130_fd_sc_hd__diode_2
X_8345_ net90 net44 vssd1 vssd1 vccd1 vccd1 _3623_ sky130_fd_sc_hd__nor2_1
X_8276_ _3525_ _3527_ _3529_ vssd1 vssd1 vccd1 vccd1 _3549_ sky130_fd_sc_hd__a21bo_1
XANTENNA_fanout100_X net100 vssd1 vssd1 vccd1 vccd1 sky130_fd_sc_hd__diode_2
X_4508_ _3782_ _3783_ net143 net130 vssd1 vssd1 vccd1 vccd1 _3786_ sky130_fd_sc_hd__a22oi_1
X_5488_ net103 net53 _0676_ vssd1 vssd1 vccd1 vccd1 _0678_ sky130_fd_sc_hd__o21ai_1
XANTENNA__6596__B net47 vssd1 vssd1 vccd1 vccd1 sky130_fd_sc_hd__diode_2
XANTENNA__7673__B2 net282 vssd1 vssd1 vccd1 vccd1 sky130_fd_sc_hd__diode_2
XANTENNA__7673__A1 net198 vssd1 vssd1 vccd1 vccd1 sky130_fd_sc_hd__diode_2
X_7227_ net117 net40 vssd1 vssd1 vccd1 vccd1 _2456_ sky130_fd_sc_hd__nor2_1
X_4439_ PID_INST.k1_calc.d1.x\[3\] PID_INST.k3_calc.prev_error\[3\] vssd1 vssd1 vccd1
+ vccd1 _3717_ sky130_fd_sc_hd__nor2_1
X_7158_ _2380_ _2381_ vssd1 vssd1 vccd1 vccd1 _2382_ sky130_fd_sc_hd__xnor2_1
XFILLER_86_531 vssd1 vssd1 vccd1 vccd1 sky130_fd_sc_hd__fill_1
XFILLER_76_27 vssd1 vssd1 vccd1 vccd1 sky130_fd_sc_hd__fill_1
XFILLER_58_244 vssd1 vssd1 vccd1 vccd1 sky130_fd_sc_hd__fill_1
X_6109_ net97 net62 vssd1 vssd1 vccd1 vccd1 _1298_ sky130_fd_sc_hd__nor2_1
X_7089_ _2224_ _2309_ vssd1 vssd1 vccd1 vccd1 _2310_ sky130_fd_sc_hd__and2_1
XFILLER_73_225 vccd1 vssd1 vccd1 vssd1 sky130_ef_sc_hd__decap_40_12
XFILLER_46_417 vssd1 vssd1 vccd1 vccd1 sky130_fd_sc_hd__fill_2
XFILLER_73_258 vssd1 vssd1 vccd1 vccd1 sky130_fd_sc_hd__fill_2
XTAP_TAPCELL_ROW_72_916 vssd1 vccd1 sky130_fd_sc_hd__tapvpwrvgnd_1
XFILLER_14_303 vssd1 vssd1 vccd1 vccd1 sky130_fd_sc_hd__fill_4
XFILLER_26_152 vssd1 vssd1 vccd1 vccd1 sky130_fd_sc_hd__fill_1
XFILLER_14_336 vssd1 vssd1 vccd1 vccd1 sky130_fd_sc_hd__fill_1
XFILLER_14_347 vssd1 vssd1 vccd1 vccd1 sky130_fd_sc_hd__fill_1
XFILLER_41_111 vssd1 vssd1 vccd1 vccd1 sky130_fd_sc_hd__fill_1
XANTENNA__8332__A net286 vssd1 vssd1 vccd1 vccd1 sky130_fd_sc_hd__diode_2
XFILLER_41_166 vssd1 vssd1 vccd1 vccd1 sky130_fd_sc_hd__fill_2
XANTENNA__6164__B2 _2051_ vssd1 vssd1 vccd1 vccd1 sky130_fd_sc_hd__diode_2
XANTENNA__7114__C net193 vssd1 vssd1 vccd1 vccd1 sky130_fd_sc_hd__diode_2
XFILLER_49_233 vssd1 vssd1 vccd1 vccd1 sky130_fd_sc_hd__fill_2
XFILLER_92_501 vssd1 vssd1 vccd1 vccd1 sky130_fd_sc_hd__fill_2
XFILLER_77_553 vssd1 vssd1 vccd1 vccd1 sky130_fd_sc_hd__fill_4
Xteam_03_370 vssd1 vssd1 vccd1 vccd1 team_03_370/HI gpio_out[12] sky130_fd_sc_hd__conb_1
XFILLER_64_203 vssd1 vssd1 vccd1 vccd1 sky130_fd_sc_hd__fill_4
Xteam_03_392 vssd1 vssd1 vccd1 vccd1 gpio_oeb[16] team_03_392/LO sky130_fd_sc_hd__conb_1
Xteam_03_381 vssd1 vssd1 vccd1 vccd1 gpio_oeb[5] team_03_381/LO sky130_fd_sc_hd__conb_1
XFILLER_92_545 vssd1 vssd1 vccd1 vccd1 sky130_fd_sc_hd__fill_4
XANTENNA__7130__B net262 vssd1 vssd1 vccd1 vccd1 sky130_fd_sc_hd__diode_2
XANTENNA__7719__A2 net201 vssd1 vssd1 vccd1 vccd1 sky130_fd_sc_hd__diode_2
XFILLER_17_141 vssd1 vssd1 vccd1 vccd1 sky130_fd_sc_hd__fill_4
XFILLER_32_100 vssd1 vssd1 vccd1 vccd1 sky130_fd_sc_hd__fill_2
X_4790_ _4066_ _4067_ vssd1 vssd1 vccd1 vccd1 _4068_ sky130_fd_sc_hd__xor2_1
XTAP_TAPCELL_ROW_15_353 vssd1 vccd1 sky130_fd_sc_hd__tapvpwrvgnd_1
XFILLER_32_144 vssd1 vssd1 vccd1 vccd1 sky130_fd_sc_hd__fill_4
XANTENNA__5585__B net278 vssd1 vssd1 vccd1 vccd1 sky130_fd_sc_hd__diode_2
XFILLER_60_497 vssd1 vssd1 vccd1 vccd1 sky130_fd_sc_hd__fill_4
XFILLER_13_391 vssd1 vssd1 vccd1 vccd1 sky130_fd_sc_hd__fill_1
X_6460_ net211 net297 vssd1 vssd1 vccd1 vccd1 _1648_ sky130_fd_sc_hd__nand2_1
X_5411_ net104 net49 _0594_ _0592_ vssd1 vssd1 vccd1 vccd1 _0601_ sky130_fd_sc_hd__o31a_1
X_6391_ _1576_ _1577_ vssd1 vssd1 vccd1 vccd1 _1579_ sky130_fd_sc_hd__xor2_1
X_8130_ _3383_ _3384_ _3391_ vssd1 vssd1 vccd1 vccd1 _3392_ sky130_fd_sc_hd__and3_1
X_5342_ _0520_ _0530_ vssd1 vssd1 vccd1 vccd1 _0532_ sky130_fd_sc_hd__xor2_1
X_8061_ _3316_ vssd1 vssd1 vccd1 vccd1 _3317_ sky130_fd_sc_hd__inv_2
XANTENNA__4929__B net88 vssd1 vssd1 vccd1 vccd1 sky130_fd_sc_hd__diode_2
X_7012_ net325 net186 vssd1 vssd1 vccd1 vccd1 _2228_ sky130_fd_sc_hd__nand2_1
XANTENNA__8376__RESET_B net331 vssd1 vssd1 vccd1 vccd1 sky130_fd_sc_hd__diode_2
X_5273_ _0452_ _0461_ vssd1 vssd1 vccd1 vccd1 _0463_ sky130_fd_sc_hd__xnor2_1
X_4224_ PID_INST.k3_calc.timescaling_term\[3\] net169 vssd1 vssd1 vccd1 vccd1 _2410_
+ sky130_fd_sc_hd__or2_1
XFILLER_83_512 vssd1 vssd1 vccd1 vccd1 sky130_fd_sc_hd__fill_4
XANTENNA__7958__A2 net260 vssd1 vssd1 vccd1 vccd1 sky130_fd_sc_hd__diode_2
XFILLER_55_258 vssd1 vssd1 vccd1 vccd1 sky130_fd_sc_hd__fill_2
XANTENNA_fanout262_A PID_INST.k2_calc.reg_lc\[13\] vssd1 vssd1 vccd1 vccd1 sky130_fd_sc_hd__diode_2
X_7914_ _3167_ _3168_ vssd1 vssd1 vccd1 vccd1 _3169_ sky130_fd_sc_hd__or2_1
X_7845_ _3088_ _3100_ vssd1 vssd1 vccd1 vccd1 _3101_ sky130_fd_sc_hd__xnor2_1
X_7776_ _3028_ _3029_ _3030_ vssd1 vssd1 vccd1 vccd1 _3032_ sky130_fd_sc_hd__o21ai_1
XFILLER_11_306 vccd1 vssd1 vccd1 vssd1 sky130_ef_sc_hd__decap_40_12
XFILLER_11_339 vssd1 vssd1 vccd1 vccd1 sky130_fd_sc_hd__fill_4
X_4988_ _0177_ _0172_ vssd1 vssd1 vccd1 vccd1 _0178_ sky130_fd_sc_hd__and2b_1
XANTENNA_fanout148_X net148 vssd1 vssd1 vccd1 vccd1 sky130_fd_sc_hd__diode_2
XFILLER_23_177 vssd1 vssd1 vccd1 vccd1 sky130_fd_sc_hd__fill_4
X_6727_ _1919_ _1925_ vssd1 vssd1 vccd1 vccd1 _1926_ sky130_fd_sc_hd__nand2b_1
X_6658_ _1851_ _1852_ vssd1 vssd1 vccd1 vccd1 _1853_ sky130_fd_sc_hd__xnor2_1
X_5609_ _0797_ _0798_ vssd1 vssd1 vccd1 vccd1 _0799_ sky130_fd_sc_hd__nor2_1
X_8328_ _3562_ _3604_ vssd1 vssd1 vccd1 vccd1 _3605_ sky130_fd_sc_hd__xnor2_1
XFILLER_3_505 vssd1 vssd1 vccd1 vccd1 sky130_fd_sc_hd__fill_1
XFILLER_11_66 vssd1 vssd1 vccd1 vccd1 sky130_fd_sc_hd__fill_4
X_6589_ _1499_ _1505_ _1497_ vssd1 vssd1 vccd1 vccd1 _1778_ sky130_fd_sc_hd__a21oi_1
XFILLER_3_549 vssd1 vssd1 vccd1 vccd1 sky130_fd_sc_hd__fill_8
XFILLER_11_77 vssd1 vssd1 vccd1 vccd1 sky130_fd_sc_hd__fill_1
XFILLER_11_88 vssd1 vssd1 vccd1 vccd1 sky130_fd_sc_hd__fill_4
X_8259_ _3394_ _3399_ _3530_ vssd1 vssd1 vccd1 vccd1 _3531_ sky130_fd_sc_hd__o21a_1
XFILLER_59_531 vssd1 vssd1 vccd1 vccd1 sky130_fd_sc_hd__fill_2
Xfanout330 net331 vssd1 vssd1 vccd1 vccd1 net330 sky130_fd_sc_hd__clkbuf_4
Xfanout341 PID_INST.add_three.n_rst vssd1 vssd1 vccd1 vccd1 net341 sky130_fd_sc_hd__buf_4
XFILLER_59_553 vssd1 vssd1 vccd1 vccd1 sky130_fd_sc_hd__fill_1
XFILLER_19_428 vssd1 vssd1 vccd1 vccd1 sky130_fd_sc_hd__fill_1
XFILLER_46_258 vssd1 vssd1 vccd1 vccd1 sky130_fd_sc_hd__fill_1
XFILLER_46_269 vssd1 vssd1 vccd1 vccd1 sky130_fd_sc_hd__fill_2
XFILLER_36_52 vssd1 vssd1 vccd1 vccd1 sky130_fd_sc_hd__fill_2
XFILLER_61_228 vssd1 vssd1 vccd1 vccd1 sky130_fd_sc_hd__fill_1
XTAP_TAPCELL_ROW_29_489 vssd1 vccd1 sky130_fd_sc_hd__tapvpwrvgnd_1
XFILLER_36_85 vssd1 vssd1 vccd1 vccd1 sky130_fd_sc_hd__fill_2
XFILLER_14_133 vssd1 vssd1 vccd1 vccd1 sky130_fd_sc_hd__fill_4
XFILLER_14_166 vccd1 vssd1 vccd1 vssd1 sky130_ef_sc_hd__decap_40_12
XFILLER_42_475 vssd1 vssd1 vccd1 vccd1 sky130_fd_sc_hd__fill_1
XTAP_TAPCELL_ROW_12_323 vssd1 vccd1 sky130_fd_sc_hd__tapvpwrvgnd_1
Xinput16 gpio_in[6] vssd1 vssd1 vccd1 vccd1 net16 sky130_fd_sc_hd__clkbuf_4
XFILLER_10_361 vssd1 vssd1 vccd1 vccd1 sky130_fd_sc_hd__fill_2
XFILLER_10_394 vssd1 vssd1 vccd1 vccd1 sky130_fd_sc_hd__fill_1
XFILLER_69_317 vssd1 vssd1 vccd1 vccd1 sky130_fd_sc_hd__fill_2
XFILLER_84_309 vssd1 vssd1 vccd1 vccd1 sky130_fd_sc_hd__fill_8
XFILLER_77_372 vssd1 vssd1 vccd1 vccd1 sky130_fd_sc_hd__fill_4
XFILLER_77_361 vssd1 vssd1 vccd1 vccd1 sky130_fd_sc_hd__fill_1
XANTENNA__8480__CLK clknet_4_11_0_clk vssd1 vssd1 vccd1 vccd1 sky130_fd_sc_hd__diode_2
XFILLER_37_225 vssd1 vssd1 vccd1 vccd1 sky130_fd_sc_hd__fill_4
X_5960_ _2051_ net71 vssd1 vssd1 vccd1 vccd1 _1150_ sky130_fd_sc_hd__nor2_1
X_5891_ _1077_ _1078_ _1080_ net305 vssd1 vssd1 vccd1 vccd1 _1081_ sky130_fd_sc_hd__a22o_1
X_4911_ _0079_ _0100_ vssd1 vssd1 vccd1 vccd1 _0101_ sky130_fd_sc_hd__xnor2_1
XTAP_TAPCELL_ROW_82_1023 vssd1 vccd1 sky130_fd_sc_hd__tapvpwrvgnd_1
X_7630_ _2817_ _2880_ vssd1 vssd1 vccd1 vccd1 _2882_ sky130_fd_sc_hd__xnor2_1
X_4842_ _3974_ _4064_ _4065_ _4067_ vssd1 vssd1 vccd1 vccd1 _4120_ sky130_fd_sc_hd__o2bb2a_1
XFILLER_20_103 vssd1 vssd1 vccd1 vccd1 sky130_fd_sc_hd__fill_2
XANTENNA__5179__A2 net80 vssd1 vssd1 vccd1 vccd1 sky130_fd_sc_hd__diode_2
X_7561_ _2807_ _2808_ vssd1 vssd1 vccd1 vccd1 _2809_ sky130_fd_sc_hd__xnor2_2
X_4773_ _3976_ _4050_ vssd1 vssd1 vccd1 vccd1 _4051_ sky130_fd_sc_hd__nand2_1
X_7492_ _2733_ _2734_ vssd1 vssd1 vccd1 vccd1 _2736_ sky130_fd_sc_hd__and2_1
X_6512_ _1696_ _1697_ vssd1 vssd1 vccd1 vccd1 _1699_ sky130_fd_sc_hd__nand2b_1
X_6443_ _1629_ _1630_ vssd1 vssd1 vccd1 vccd1 _1631_ sky130_fd_sc_hd__nand2_1
X_6374_ _1560_ _1561_ vssd1 vssd1 vccd1 vccd1 _1562_ sky130_fd_sc_hd__nand2_1
X_8113_ _3361_ _3371_ vssd1 vssd1 vccd1 vccd1 _3373_ sky130_fd_sc_hd__xnor2_1
X_5325_ _0505_ _0514_ vssd1 vssd1 vccd1 vccd1 _0515_ sky130_fd_sc_hd__xnor2_1
X_8044_ _3292_ _3297_ vssd1 vssd1 vccd1 vccd1 _3298_ sky130_fd_sc_hd__xnor2_1
X_5256_ _0432_ _0444_ vssd1 vssd1 vccd1 vccd1 _0446_ sky130_fd_sc_hd__xnor2_1
XFILLER_87_169 vssd1 vssd1 vccd1 vccd1 sky130_fd_sc_hd__fill_8
X_4207_ PID_INST.k3_calc.kd_term\[2\] net175 vssd1 vssd1 vccd1 vccd1 _2231_ sky130_fd_sc_hd__or2_1
XFILLER_68_372 vssd1 vssd1 vccd1 vccd1 sky130_fd_sc_hd__fill_2
X_5187_ _0279_ _0376_ _0375_ vssd1 vssd1 vccd1 vccd1 _0377_ sky130_fd_sc_hd__o21a_1
XFILLER_56_556 vssd1 vssd1 vccd1 vccd1 sky130_fd_sc_hd__fill_1
XFILLER_73_28 vssd1 vssd1 vccd1 vccd1 sky130_fd_sc_hd__fill_1
XFILLER_56_567 vssd1 vssd1 vccd1 vccd1 sky130_fd_sc_hd__fill_2
XFILLER_71_537 vssd1 vssd1 vccd1 vccd1 sky130_fd_sc_hd__fill_4
XFILLER_71_526 vssd1 vssd1 vccd1 vccd1 sky130_fd_sc_hd__fill_4
XFILLER_36_280 vssd1 vssd1 vccd1 vccd1 sky130_fd_sc_hd__fill_1
XTAP_TAPCELL_ROW_26_459 vssd1 vccd1 sky130_fd_sc_hd__tapvpwrvgnd_1
X_7828_ _3074_ _3083_ vssd1 vssd1 vccd1 vccd1 _3084_ sky130_fd_sc_hd__xor2_1
X_7759_ net276 net194 net192 net281 vssd1 vssd1 vccd1 vccd1 _3015_ sky130_fd_sc_hd__a22oi_1
XFILLER_0_3 vccd1 vssd1 vccd1 vssd1 sky130_ef_sc_hd__decap_40_12
XANTENNA_fanout80_X net80 vssd1 vssd1 vccd1 vccd1 sky130_fd_sc_hd__diode_2
XFILLER_66_309 vssd1 vssd1 vccd1 vccd1 sky130_fd_sc_hd__fill_1
XANTENNA__4302__A0 net276 vssd1 vssd1 vccd1 vccd1 sky130_fd_sc_hd__diode_2
Xfanout182 PID_INST.k2_calc.sum_reg\[20\] vssd1 vssd1 vccd1 vccd1 net182 sky130_fd_sc_hd__buf_2
Xfanout160 _2939_ vssd1 vssd1 vccd1 vccd1 net160 sky130_fd_sc_hd__clkbuf_4
Xfanout171 net172 vssd1 vssd1 vccd1 vccd1 net171 sky130_fd_sc_hd__clkbuf_4
XFILLER_47_512 vssd1 vssd1 vccd1 vccd1 sky130_fd_sc_hd__fill_1
XFILLER_74_331 vssd1 vssd1 vccd1 vccd1 sky130_fd_sc_hd__fill_2
Xfanout193 PID_INST.k2_calc.sum_reg\[15\] vssd1 vssd1 vccd1 vccd1 net193 sky130_fd_sc_hd__clkbuf_4
XFILLER_62_537 vssd1 vssd1 vccd1 vccd1 sky130_fd_sc_hd__fill_2
XFILLER_63_50 vssd1 vssd1 vccd1 vccd1 sky130_fd_sc_hd__fill_4
XFILLER_30_445 vssd1 vssd1 vccd1 vccd1 sky130_fd_sc_hd__fill_1
XFILLER_6_151 vssd1 vssd1 vccd1 vccd1 sky130_fd_sc_hd__fill_2
X_6090_ _1277_ _1278_ _0762_ _0764_ vssd1 vssd1 vccd1 vccd1 _1280_ sky130_fd_sc_hd__o211a_1
X_5110_ _0297_ _0298_ vssd1 vssd1 vccd1 vccd1 _0300_ sky130_fd_sc_hd__xor2_1
X_5041_ _0151_ _0167_ _0169_ vssd1 vssd1 vccd1 vccd1 _0231_ sky130_fd_sc_hd__a21bo_1
XFILLER_38_512 vssd1 vssd1 vccd1 vccd1 sky130_fd_sc_hd__fill_1
XFILLER_77_191 vssd1 vssd1 vccd1 vccd1 sky130_fd_sc_hd__fill_2
XFILLER_38_545 vssd1 vssd1 vccd1 vccd1 sky130_fd_sc_hd__fill_4
XFILLER_53_515 vccd1 vssd1 vccd1 vssd1 sky130_ef_sc_hd__decap_40_12
XFILLER_25_206 vccd1 vssd1 vccd1 vssd1 sky130_ef_sc_hd__decap_40_12
XFILLER_92_194 vssd1 vssd1 vccd1 vccd1 sky130_fd_sc_hd__fill_2
XFILLER_80_334 vssd1 vssd1 vccd1 vccd1 sky130_fd_sc_hd__fill_8
X_6992_ _2194_ _2205_ vssd1 vssd1 vccd1 vccd1 _2207_ sky130_fd_sc_hd__and2_1
XFILLER_80_367 vssd1 vssd1 vccd1 vccd1 sky130_fd_sc_hd__fill_1
XFILLER_80_345 vssd1 vssd1 vccd1 vccd1 sky130_fd_sc_hd__fill_2
X_5943_ _1132_ _1131_ vssd1 vssd1 vccd1 vccd1 _1133_ sky130_fd_sc_hd__nand2b_1
X_5874_ net320 net237 _1060_ _1059_ _1033_ vssd1 vssd1 vccd1 vccd1 _1064_ sky130_fd_sc_hd__a32o_1
XTAP_TAPCELL_ROW_23_429 vssd1 vccd1 sky130_fd_sc_hd__tapvpwrvgnd_1
XANTENNA__7010__A2 net225 vssd1 vssd1 vccd1 vccd1 sky130_fd_sc_hd__diode_2
X_4825_ net147 net71 vssd1 vssd1 vccd1 vccd1 _4103_ sky130_fd_sc_hd__nor2_1
X_7613_ _2863_ _2864_ vssd1 vssd1 vccd1 vccd1 _2865_ sky130_fd_sc_hd__xor2_1
XFILLER_21_456 vssd1 vssd1 vccd1 vccd1 sky130_fd_sc_hd__fill_4
X_7544_ _2789_ _2790_ vssd1 vssd1 vccd1 vccd1 _2791_ sky130_fd_sc_hd__xor2_1
X_4756_ _3994_ _3997_ _4032_ vssd1 vssd1 vccd1 vccd1 _4034_ sky130_fd_sc_hd__o21ai_2
X_7475_ _2716_ _2717_ vssd1 vssd1 vccd1 vccd1 _2718_ sky130_fd_sc_hd__nor2_1
X_4687_ net109 net65 vssd1 vssd1 vccd1 vccd1 _3965_ sky130_fd_sc_hd__nor2_1
XANTENNA__8391__RESET_B net340 vssd1 vssd1 vccd1 vccd1 sky130_fd_sc_hd__diode_2
X_6426_ _1612_ _1613_ vssd1 vssd1 vccd1 vccd1 _1614_ sky130_fd_sc_hd__nor2_1
XFILLER_68_17 vssd1 vssd1 vccd1 vccd1 sky130_fd_sc_hd__fill_1
X_6357_ _1338_ _1345_ _1543_ vssd1 vssd1 vccd1 vccd1 _1545_ sky130_fd_sc_hd__and3_1
XFILLER_0_316 vccd1 vssd1 vccd1 vssd1 sky130_ef_sc_hd__decap_40_12
X_5308_ PID_INST.k3_calc.d1.y\[11\] net83 _3757_ _1923_ vssd1 vssd1 vccd1 vccd1 _0498_
+ sky130_fd_sc_hd__o2bb2a_1
X_6288_ _1475_ _1476_ vssd1 vssd1 vccd1 vccd1 _1477_ sky130_fd_sc_hd__and2b_1
XFILLER_88_489 vssd1 vssd1 vccd1 vccd1 sky130_fd_sc_hd__fill_4
X_8027_ _3279_ _3280_ vssd1 vssd1 vccd1 vccd1 _3281_ sky130_fd_sc_hd__and2_1
X_5239_ _0424_ _0428_ vssd1 vssd1 vccd1 vccd1 _0429_ sky130_fd_sc_hd__xor2_1
XFILLER_29_534 vssd1 vssd1 vccd1 vccd1 sky130_fd_sc_hd__fill_1
XFILLER_84_49 vssd1 vssd1 vccd1 vccd1 sky130_fd_sc_hd__fill_1
XTAP_TAPCELL_ROW_67_871 vssd1 vccd1 sky130_fd_sc_hd__tapvpwrvgnd_1
XANTENNA__6109__B net62 vssd1 vssd1 vccd1 vccd1 sky130_fd_sc_hd__diode_2
XFILLER_29_567 vssd1 vssd1 vccd1 vccd1 sky130_fd_sc_hd__fill_2
XFILLER_56_397 vssd1 vssd1 vccd1 vccd1 sky130_fd_sc_hd__fill_1
XTAP_TAPCELL_ROW_39_595 vssd1 vccd1 sky130_fd_sc_hd__tapvpwrvgnd_1
XANTENNA__5948__B _3774_ vssd1 vssd1 vccd1 vccd1 sky130_fd_sc_hd__diode_2
XFILLER_83_194 vssd1 vssd1 vccd1 vccd1 sky130_fd_sc_hd__fill_1
XANTENNA__6125__A net116 vssd1 vssd1 vccd1 vccd1 sky130_fd_sc_hd__diode_2
XFILLER_24_261 vssd1 vssd1 vccd1 vccd1 sky130_fd_sc_hd__fill_4
XANTENNA__8479__RESET_B net340 vssd1 vssd1 vccd1 vccd1 sky130_fd_sc_hd__diode_2
XFILLER_3_110 vssd1 vssd1 vccd1 vccd1 sky130_fd_sc_hd__fill_2
XANTENNA__7068__A2 net195 vssd1 vssd1 vccd1 vccd1 sky130_fd_sc_hd__diode_2
XFILLER_3_165 vssd1 vssd1 vccd1 vccd1 sky130_fd_sc_hd__fill_2
XFILLER_79_456 vssd1 vssd1 vccd1 vccd1 sky130_fd_sc_hd__fill_2
Xhold5 PID_INST.k1_calc.d1.x\[14\] vssd1 vssd1 vccd1 vccd1 net398 sky130_fd_sc_hd__dlygate4sd3_1
XFILLER_47_353 vssd1 vssd1 vccd1 vccd1 sky130_fd_sc_hd__fill_2
XFILLER_47_342 vssd1 vssd1 vccd1 vccd1 sky130_fd_sc_hd__fill_1
XFILLER_62_323 vssd1 vssd1 vccd1 vccd1 sky130_fd_sc_hd__fill_2
XFILLER_35_515 vssd1 vssd1 vccd1 vccd1 sky130_fd_sc_hd__fill_1
XANTENNA__5577__C net216 vssd1 vssd1 vccd1 vccd1 sky130_fd_sc_hd__diode_2
XANTENNA__4481__C net81 vssd1 vssd1 vccd1 vccd1 sky130_fd_sc_hd__diode_2
XFILLER_15_261 vssd1 vssd1 vccd1 vccd1 sky130_fd_sc_hd__fill_4
XFILLER_22_209 vccd1 vssd1 vccd1 vssd1 sky130_ef_sc_hd__decap_40_12
XFILLER_30_220 vssd1 vssd1 vccd1 vccd1 sky130_fd_sc_hd__fill_2
XFILLER_90_81 vssd1 vssd1 vccd1 vccd1 sky130_fd_sc_hd__fill_2
X_4610_ net124 net150 vssd1 vssd1 vccd1 vccd1 _3888_ sky130_fd_sc_hd__nand2_1
XANTENNA__5593__B net306 vssd1 vssd1 vccd1 vccd1 sky130_fd_sc_hd__diode_2
X_5590_ _0745_ _0748_ _0778_ vssd1 vssd1 vccd1 vccd1 _0780_ sky130_fd_sc_hd__or3_1
X_4541_ _3817_ _3818_ vssd1 vssd1 vccd1 vccd1 _3819_ sky130_fd_sc_hd__nor2_1
X_4472_ _3745_ _3747_ vssd1 vssd1 vccd1 vccd1 _3750_ sky130_fd_sc_hd__nand2_1
XFILLER_7_493 vssd1 vssd1 vccd1 vccd1 sky130_fd_sc_hd__fill_1
X_7260_ _2053_ _2418_ _2419_ _2422_ vssd1 vssd1 vccd1 vccd1 _2490_ sky130_fd_sc_hd__a22o_1
X_6211_ _1329_ _1398_ vssd1 vssd1 vccd1 vccd1 _1400_ sky130_fd_sc_hd__xnor2_1
X_7191_ _2401_ _2415_ vssd1 vssd1 vccd1 vccd1 _2417_ sky130_fd_sc_hd__xnor2_1
XTAP_TAPCELL_ROW_90_1100 vssd1 vccd1 sky130_fd_sc_hd__tapvpwrvgnd_1
X_6142_ net163 net80 vssd1 vssd1 vccd1 vccd1 _1331_ sky130_fd_sc_hd__nand2_1
XANTENNA__4496__Y _3774_ vssd1 vssd1 vccd1 vccd1 sky130_fd_sc_hd__diode_2
XFILLER_85_426 vssd1 vssd1 vccd1 vccd1 sky130_fd_sc_hd__fill_1
X_6073_ _1262_ vssd1 vssd1 vccd1 vccd1 _1263_ sky130_fd_sc_hd__inv_2
XANTENNA__5114__A net111 vssd1 vssd1 vccd1 vccd1 sky130_fd_sc_hd__diode_2
X_5024_ _0170_ _0211_ vssd1 vssd1 vccd1 vccd1 _0214_ sky130_fd_sc_hd__xnor2_1
XFILLER_38_320 vssd1 vssd1 vccd1 vccd1 sky130_fd_sc_hd__fill_1
XTAP_TAPCELL_ROW_88_1084 vssd1 vccd1 sky130_fd_sc_hd__tapvpwrvgnd_1
XANTENNA_fanout175_A _1784_ vssd1 vssd1 vccd1 vccd1 sky130_fd_sc_hd__diode_2
XTAP_TAPCELL_ROW_64_841 vssd1 vccd1 sky130_fd_sc_hd__tapvpwrvgnd_1
XFILLER_53_356 vssd1 vssd1 vccd1 vccd1 sky130_fd_sc_hd__fill_1
X_6975_ _2187_ _2188_ vssd1 vssd1 vccd1 vccd1 _2189_ sky130_fd_sc_hd__xnor2_1
XFILLER_53_378 vssd1 vssd1 vccd1 vccd1 sky130_fd_sc_hd__fill_1
X_5926_ _1113_ _1114_ vssd1 vssd1 vccd1 vccd1 _1116_ sky130_fd_sc_hd__xnor2_1
XTAP_TAPCELL_ROW_36_565 vssd1 vccd1 sky130_fd_sc_hd__tapvpwrvgnd_1
X_5857_ _1023_ _1024_ vssd1 vssd1 vccd1 vccd1 _1047_ sky130_fd_sc_hd__xnor2_1
X_5788_ _0949_ _0977_ vssd1 vssd1 vccd1 vccd1 _0978_ sky130_fd_sc_hd__nand2_1
XANTENNA_fanout228_X net228 vssd1 vssd1 vccd1 vccd1 sky130_fd_sc_hd__diode_2
X_4808_ _4082_ _4083_ _4010_ _4012_ vssd1 vssd1 vccd1 vccd1 _4086_ sky130_fd_sc_hd__o211ai_1
X_4739_ _3882_ _4016_ vssd1 vssd1 vccd1 vccd1 _4017_ sky130_fd_sc_hd__and2b_1
X_7527_ _2772_ _2773_ vssd1 vssd1 vccd1 vccd1 _2774_ sky130_fd_sc_hd__xnor2_1
X_7458_ _2699_ _2698_ vssd1 vssd1 vccd1 vccd1 _2700_ sky130_fd_sc_hd__and2b_1
XANTENNA__8310__D net252 vssd1 vssd1 vccd1 vccd1 sky130_fd_sc_hd__diode_2
X_6409_ _1327_ _1401_ _1326_ vssd1 vssd1 vccd1 vccd1 _1597_ sky130_fd_sc_hd__o21a_1
XANTENNA__5008__B net79 vssd1 vssd1 vccd1 vccd1 sky130_fd_sc_hd__diode_2
X_7389_ net199 net288 _2625_ vssd1 vssd1 vccd1 vccd1 _2627_ sky130_fd_sc_hd__a21oi_1
XFILLER_88_220 vssd1 vssd1 vccd1 vccd1 sky130_fd_sc_hd__fill_1
XTAP_TAPCELL_ROW_8_279 vssd1 vccd1 sky130_fd_sc_hd__tapvpwrvgnd_1
XFILLER_0_135 vssd1 vssd1 vccd1 vccd1 sky130_fd_sc_hd__fill_4
XFILLER_0_113 vssd1 vssd1 vccd1 vccd1 sky130_fd_sc_hd__fill_4
XANTENNA_fanout88_A net89 vssd1 vssd1 vccd1 vccd1 sky130_fd_sc_hd__diode_2
XFILLER_88_253 vccd1 vssd1 vccd1 vssd1 sky130_ef_sc_hd__decap_40_12
XANTENNA__7223__B net42 vssd1 vssd1 vccd1 vccd1 sky130_fd_sc_hd__diode_2
XANTENNA__5481__A1 net103 vssd1 vssd1 vccd1 vccd1 sky130_fd_sc_hd__diode_2
XFILLER_29_353 vssd1 vssd1 vccd1 vccd1 sky130_fd_sc_hd__fill_2
XFILLER_17_559 vssd1 vssd1 vccd1 vccd1 sky130_fd_sc_hd__fill_1
XFILLER_44_389 vssd1 vssd1 vccd1 vccd1 sky130_fd_sc_hd__fill_4
XFILLER_44_378 vssd1 vssd1 vccd1 vccd1 sky130_fd_sc_hd__fill_4
XFILLER_44_85 vssd1 vssd1 vccd1 vccd1 sky130_fd_sc_hd__fill_1
XANTENNA__8341__Y _3619_ vssd1 vssd1 vccd1 vccd1 sky130_fd_sc_hd__diode_2
XFILLER_12_253 vssd1 vssd1 vccd1 vccd1 sky130_fd_sc_hd__fill_4
XANTENNA__8070__A net205 vssd1 vssd1 vccd1 vccd1 sky130_fd_sc_hd__diode_2
XTAP_TAPCELL_ROW_70_899 vssd1 vccd1 sky130_fd_sc_hd__tapvpwrvgnd_1
XFILLER_8_279 vssd1 vssd1 vccd1 vccd1 sky130_fd_sc_hd__fill_1
XFILLER_5_46 vssd1 vssd1 vccd1 vccd1 sky130_fd_sc_hd__fill_1
XFILLER_4_474 vssd1 vssd1 vccd1 vccd1 sky130_fd_sc_hd__fill_2
XFILLER_4_463 vssd1 vssd1 vccd1 vccd1 sky130_fd_sc_hd__fill_2
XFILLER_79_242 vssd1 vssd1 vccd1 vccd1 sky130_fd_sc_hd__fill_1
XFILLER_69_71 vssd1 vssd1 vccd1 vccd1 sky130_fd_sc_hd__fill_1
XANTENNA__4757__B _4034_ vssd1 vssd1 vccd1 vccd1 sky130_fd_sc_hd__diode_2
XTAP_TAPCELL_ROW_78_977 vssd1 vccd1 sky130_fd_sc_hd__tapvpwrvgnd_1
XFILLER_75_470 vssd1 vssd1 vccd1 vccd1 sky130_fd_sc_hd__fill_8
X_6760_ _1958_ _1959_ _1960_ vssd1 vssd1 vccd1 vccd1 _1961_ sky130_fd_sc_hd__or3_1
XTAP_TAPCELL_ROW_61_811 vssd1 vccd1 sky130_fd_sc_hd__tapvpwrvgnd_1
XFILLER_50_315 vssd1 vssd1 vccd1 vccd1 sky130_fd_sc_hd__fill_8
XFILLER_23_529 vccd1 vssd1 vccd1 vssd1 sky130_ef_sc_hd__decap_40_12
X_5711_ _0890_ _0900_ vssd1 vssd1 vccd1 vccd1 _0901_ sky130_fd_sc_hd__and2_1
XANTENNA__5775__A2 net288 vssd1 vssd1 vccd1 vccd1 sky130_fd_sc_hd__diode_2
XTAP_TAPCELL_ROW_33_535 vssd1 vccd1 sky130_fd_sc_hd__tapvpwrvgnd_1
X_6691_ _1887_ _1888_ vssd1 vssd1 vccd1 vccd1 _1889_ sky130_fd_sc_hd__xnor2_1
X_5642_ _0826_ _0829_ _0831_ _0819_ vssd1 vssd1 vccd1 vccd1 _0832_ sky130_fd_sc_hd__o22a_1
X_8430_ clknet_4_0_0_clk net405 net327 vssd1 vssd1 vccd1 vccd1 PID_INST.k3_calc.prev_error\[2\]
+ sky130_fd_sc_hd__dfrtp_1
X_5573_ _0737_ _0761_ vssd1 vssd1 vccd1 vccd1 _0763_ sky130_fd_sc_hd__xnor2_1
X_8361_ _3546_ _3639_ vssd1 vssd1 vccd1 vccd1 _3640_ sky130_fd_sc_hd__xor2_1
X_4524_ _2146_ _2178_ _3734_ net84 vssd1 vssd1 vccd1 vccd1 _3802_ sky130_fd_sc_hd__or4b_1
XANTENNA__8414__CLK clknet_4_1_0_clk vssd1 vssd1 vccd1 vccd1 sky130_fd_sc_hd__diode_2
X_7312_ _2528_ _2544_ vssd1 vssd1 vccd1 vccd1 _2545_ sky130_fd_sc_hd__xnor2_1
X_8292_ net294 net305 net179 PID_INST.k2_calc.sum_reg\[24\] vssd1 vssd1 vccd1 vccd1
+ _3565_ sky130_fd_sc_hd__and4_1
X_4455_ _3731_ _3732_ vssd1 vssd1 vccd1 vccd1 _3733_ sky130_fd_sc_hd__and2_1
X_7243_ _2215_ _2217_ _2471_ vssd1 vssd1 vccd1 vccd1 _2472_ sky130_fd_sc_hd__a21o_1
X_7174_ _2397_ _2398_ vssd1 vssd1 vccd1 vccd1 _2399_ sky130_fd_sc_hd__nor2_1
X_4386_ _3675_ _3677_ _3674_ vssd1 vssd1 vccd1 vccd1 _3679_ sky130_fd_sc_hd__o21ba_1
X_6125_ net116 net50 vssd1 vssd1 vccd1 vccd1 _1314_ sky130_fd_sc_hd__nor2_2
XANTENNA_fanout292_A PID_INST.k2_calc.reg_lc\[6\] vssd1 vssd1 vccd1 vccd1 sky130_fd_sc_hd__diode_2
XTAP_TAPCELL_ROW_5_249 vssd1 vccd1 sky130_fd_sc_hd__tapvpwrvgnd_1
X_6056_ _1244_ _1245_ vssd1 vssd1 vccd1 vccd1 _1246_ sky130_fd_sc_hd__xor2_1
XANTENNA__4266__A2 net2 vssd1 vssd1 vccd1 vccd1 sky130_fd_sc_hd__diode_2
XANTENNA__8155__A net100 vssd1 vssd1 vccd1 vccd1 sky130_fd_sc_hd__diode_2
X_5007_ net133 net80 vssd1 vssd1 vccd1 vccd1 _0197_ sky130_fd_sc_hd__nand2_1
XFILLER_53_131 vssd1 vssd1 vccd1 vccd1 sky130_fd_sc_hd__fill_1
XTAP_TAPCELL_ROW_49_690 vssd1 vccd1 sky130_fd_sc_hd__tapvpwrvgnd_1
XFILLER_38_183 vssd1 vssd1 vccd1 vccd1 sky130_fd_sc_hd__fill_1
XFILLER_81_451 vssd1 vssd1 vccd1 vccd1 sky130_fd_sc_hd__fill_4
XFILLER_26_367 vssd1 vssd1 vccd1 vccd1 sky130_fd_sc_hd__fill_2
X_6958_ net95 net59 vssd1 vssd1 vccd1 vccd1 _2171_ sky130_fd_sc_hd__nor2_1
XFILLER_41_337 vssd1 vssd1 vccd1 vccd1 sky130_fd_sc_hd__fill_2
X_5909_ _1096_ _1097_ _1098_ _0973_ vssd1 vssd1 vccd1 vccd1 _1099_ sky130_fd_sc_hd__a31o_1
XFILLER_22_562 vssd1 vssd1 vccd1 vccd1 sky130_fd_sc_hd__fill_8
X_6889_ _1754_ _1797_ _1796_ vssd1 vssd1 vccd1 vccd1 _2098_ sky130_fd_sc_hd__a21oi_1
XANTENNA__8165__B1 net40 vssd1 vssd1 vccd1 vccd1 sky130_fd_sc_hd__diode_2
XANTENNA__5518__A2 net285 vssd1 vssd1 vccd1 vccd1 sky130_fd_sc_hd__diode_2
XFILLER_14_66 vssd1 vssd1 vccd1 vccd1 sky130_fd_sc_hd__fill_2
XANTENNA__7691__A2 net186 vssd1 vssd1 vccd1 vccd1 sky130_fd_sc_hd__diode_2
XFILLER_76_234 vssd1 vssd1 vccd1 vccd1 sky130_fd_sc_hd__fill_4
XANTENNA__8336__Y _3614_ vssd1 vssd1 vccd1 vccd1 sky130_fd_sc_hd__diode_2
XFILLER_49_459 vssd1 vssd1 vccd1 vccd1 sky130_fd_sc_hd__fill_4
XANTENNA_input20_A nrst vssd1 vssd1 vccd1 vccd1 sky130_fd_sc_hd__diode_2
XFILLER_39_96 vccd1 vssd1 vccd1 vssd1 sky130_ef_sc_hd__decap_40_12
XTAP_TAPCELL_ROW_75_947 vssd1 vccd1 sky130_fd_sc_hd__tapvpwrvgnd_1
XFILLER_57_470 vssd1 vssd1 vccd1 vccd1 sky130_fd_sc_hd__fill_4
XANTENNA__4593__A net120 vssd1 vssd1 vccd1 vccd1 sky130_fd_sc_hd__diode_2
XFILLER_57_492 vssd1 vssd1 vccd1 vccd1 sky130_fd_sc_hd__fill_2
XFILLER_44_120 vssd1 vssd1 vccd1 vccd1 sky130_fd_sc_hd__fill_1
XFILLER_72_473 vssd1 vssd1 vccd1 vccd1 sky130_fd_sc_hd__fill_2
XFILLER_55_95 vssd1 vssd1 vccd1 vccd1 sky130_fd_sc_hd__fill_1
XFILLER_44_164 vssd1 vssd1 vccd1 vccd1 sky130_fd_sc_hd__fill_4
XFILLER_44_197 vssd1 vssd1 vccd1 vccd1 sky130_fd_sc_hd__fill_4
XFILLER_32_315 vssd1 vssd1 vccd1 vccd1 sky130_fd_sc_hd__fill_1
XFILLER_9_511 vssd1 vssd1 vccd1 vccd1 sky130_fd_sc_hd__fill_1
XTAP_TAPCELL_ROW_30_505 vssd1 vccd1 sky130_fd_sc_hd__tapvpwrvgnd_1
XFILLER_40_392 vccd1 vssd1 vccd1 vssd1 sky130_ef_sc_hd__decap_40_12
XANTENNA__4193__A1 net19 vssd1 vssd1 vccd1 vccd1 sky130_fd_sc_hd__diode_2
XANTENNA__4768__A _2210_ vssd1 vssd1 vccd1 vccd1 sky130_fd_sc_hd__diode_2
X_4240_ net6 net167 _2569_ vssd1 vssd1 vccd1 vccd1 _2580_ sky130_fd_sc_hd__o21ai_1
X_4171_ net177 net176 _1773_ vssd1 vssd1 vccd1 vccd1 _1849_ sky130_fd_sc_hd__and3_1
XANTENNA__6983__A net119 vssd1 vssd1 vccd1 vccd1 sky130_fd_sc_hd__diode_2
XTAP_TAPCELL_ROW_2_219 vssd1 vccd1 sky130_fd_sc_hd__tapvpwrvgnd_1
XANTENNA__7798__B net53 vssd1 vssd1 vccd1 vccd1 sky130_fd_sc_hd__diode_2
X_7930_ _3182_ _3183_ vssd1 vssd1 vccd1 vccd1 _3185_ sky130_fd_sc_hd__xnor2_1
X_7861_ _3114_ _3116_ vssd1 vssd1 vccd1 vccd1 _3117_ sky130_fd_sc_hd__and2_1
XTAP_TAPCELL_ROW_85_1054 vssd1 vccd1 sky130_fd_sc_hd__tapvpwrvgnd_1
XFILLER_63_451 vssd1 vssd1 vccd1 vccd1 sky130_fd_sc_hd__fill_1
X_6812_ _2013_ _2014_ vssd1 vssd1 vccd1 vccd1 _2016_ sky130_fd_sc_hd__and2b_1
XTAP_TAPCELL_ROW_46_660 vssd1 vccd1 sky130_fd_sc_hd__tapvpwrvgnd_1
X_7792_ _2956_ _2959_ _3047_ vssd1 vssd1 vccd1 vccd1 _3048_ sky130_fd_sc_hd__o21a_1
XTAP_TAPCELL_ROW_18_384 vssd1 vccd1 sky130_fd_sc_hd__tapvpwrvgnd_1
X_6743_ net215 net219 net284 net278 vssd1 vssd1 vccd1 vccd1 _1942_ sky130_fd_sc_hd__and4_1
XANTENNA__7964__D net189 vssd1 vssd1 vccd1 vccd1 sky130_fd_sc_hd__diode_2
X_6674_ _1845_ _1846_ _1868_ vssd1 vssd1 vccd1 vccd1 _1870_ sky130_fd_sc_hd__o21a_1
X_5625_ _0813_ _0814_ vssd1 vssd1 vccd1 vccd1 _0815_ sky130_fd_sc_hd__and2_1
X_8413_ clknet_4_0_0_clk net113 net327 vssd1 vssd1 vccd1 vccd1 PID_INST.k3_calc.kd_term\[1\]
+ sky130_fd_sc_hd__dfrtp_1
XANTENNA__4184__A1 net5 vssd1 vssd1 vccd1 vccd1 sky130_fd_sc_hd__diode_2
XANTENNA_fanout305_A net309 vssd1 vssd1 vccd1 vccd1 sky130_fd_sc_hd__diode_2
X_5556_ net244 net278 net239 net283 vssd1 vssd1 vccd1 vccd1 _0746_ sky130_fd_sc_hd__a22oi_1
X_8344_ _3419_ _3621_ vssd1 vssd1 vccd1 vccd1 _3622_ sky130_fd_sc_hd__xnor2_1
X_8275_ _3445_ _3446_ _3448_ vssd1 vssd1 vccd1 vccd1 _3548_ sky130_fd_sc_hd__o21ba_1
X_4507_ net130 _3782_ _3783_ net143 vssd1 vssd1 vccd1 vccd1 _3785_ sky130_fd_sc_hd__and4_1
X_5487_ net103 net53 _0676_ vssd1 vssd1 vccd1 vccd1 _0677_ sky130_fd_sc_hd__or3_1
XANTENNA__7673__A2 net277 vssd1 vssd1 vccd1 vccd1 sky130_fd_sc_hd__diode_2
X_7226_ _2197_ _2452_ vssd1 vssd1 vccd1 vccd1 _2455_ sky130_fd_sc_hd__xnor2_1
X_4438_ _3714_ _3715_ vssd1 vssd1 vccd1 vccd1 _3716_ sky130_fd_sc_hd__and2b_1
X_7157_ net203 net288 vssd1 vssd1 vccd1 vccd1 _2381_ sky130_fd_sc_hd__nand2_1
XFILLER_86_521 vssd1 vssd1 vccd1 vccd1 sky130_fd_sc_hd__fill_2
X_4369_ _3663_ _3664_ vssd1 vssd1 vccd1 vccd1 _3665_ sky130_fd_sc_hd__nand2_1
XANTENNA_fanout295_X net295 vssd1 vssd1 vccd1 vccd1 sky130_fd_sc_hd__diode_2
XFILLER_58_223 vssd1 vssd1 vccd1 vccd1 sky130_fd_sc_hd__fill_4
XFILLER_86_565 vssd1 vssd1 vccd1 vccd1 sky130_fd_sc_hd__fill_2
X_7088_ _2307_ _2308_ vssd1 vssd1 vccd1 vccd1 _2309_ sky130_fd_sc_hd__nor2_1
X_6108_ _1108_ _1295_ _1296_ vssd1 vssd1 vccd1 vccd1 _1297_ sky130_fd_sc_hd__a21oi_1
X_6039_ net207 net314 net302 net216 vssd1 vssd1 vccd1 vccd1 _1229_ sky130_fd_sc_hd__a22oi_1
XFILLER_92_27 vssd1 vssd1 vccd1 vccd1 sky130_fd_sc_hd__fill_1
XFILLER_73_237 vssd1 vssd1 vccd1 vccd1 sky130_fd_sc_hd__fill_8
XTAP_TAPCELL_ROW_72_917 vssd1 vccd1 sky130_fd_sc_hd__tapvpwrvgnd_1
XFILLER_54_473 vssd1 vssd1 vccd1 vccd1 sky130_fd_sc_hd__fill_2
XFILLER_81_281 vssd1 vssd1 vccd1 vccd1 sky130_fd_sc_hd__fill_4
XFILLER_26_175 vssd1 vssd1 vccd1 vccd1 sky130_fd_sc_hd__fill_1
XFILLER_26_197 vccd1 vssd1 vccd1 vssd1 sky130_ef_sc_hd__decap_40_12
XANTENNA__8332__B net182 vssd1 vssd1 vccd1 vccd1 sky130_fd_sc_hd__diode_2
XFILLER_10_565 vssd1 vssd1 vccd1 vccd1 sky130_fd_sc_hd__fill_2
XFILLER_6_547 vccd1 vssd1 vccd1 vssd1 sky130_ef_sc_hd__decap_40_12
XFILLER_6_569 vssd1 vssd1 vccd1 vccd1 sky130_fd_sc_hd__fill_1
XANTENNA__7899__A net110 vssd1 vssd1 vccd1 vccd1 sky130_fd_sc_hd__diode_2
XANTENNA__7114__D net188 vssd1 vssd1 vccd1 vccd1 sky130_fd_sc_hd__diode_2
XFILLER_49_223 vssd1 vssd1 vccd1 vccd1 sky130_fd_sc_hd__fill_1
XFILLER_77_565 vssd1 vssd1 vccd1 vccd1 sky130_fd_sc_hd__fill_4
XFILLER_77_543 vssd1 vssd1 vccd1 vccd1 sky130_fd_sc_hd__fill_1
Xteam_03_360 vssd1 vssd1 vccd1 vccd1 team_03_360/HI gpio_out[2] sky130_fd_sc_hd__conb_1
XFILLER_92_524 vssd1 vssd1 vccd1 vccd1 sky130_fd_sc_hd__fill_4
Xteam_03_393 vssd1 vssd1 vccd1 vccd1 gpio_oeb[17] team_03_393/LO sky130_fd_sc_hd__conb_1
Xteam_03_371 vssd1 vssd1 vccd1 vccd1 team_03_371/HI gpio_out[13] sky130_fd_sc_hd__conb_1
Xteam_03_382 vssd1 vssd1 vccd1 vccd1 gpio_oeb[6] team_03_382/LO sky130_fd_sc_hd__conb_1
XFILLER_66_61 vssd1 vssd1 vccd1 vccd1 sky130_fd_sc_hd__fill_1
XFILLER_72_270 vccd1 vssd1 vccd1 vssd1 sky130_ef_sc_hd__decap_40_12
XFILLER_60_421 vssd1 vssd1 vccd1 vccd1 sky130_fd_sc_hd__fill_1
XANTENNA__4770__B net81 vssd1 vssd1 vccd1 vccd1 sky130_fd_sc_hd__diode_2
XTAP_TAPCELL_ROW_43_630 vssd1 vccd1 sky130_fd_sc_hd__tapvpwrvgnd_1
XTAP_TAPCELL_ROW_15_354 vssd1 vccd1 sky130_fd_sc_hd__tapvpwrvgnd_1
XFILLER_20_307 vssd1 vssd1 vccd1 vccd1 sky130_fd_sc_hd__fill_1
X_5410_ _0583_ _0598_ vssd1 vssd1 vccd1 vccd1 _0600_ sky130_fd_sc_hd__xnor2_1
X_6390_ _1576_ _1577_ vssd1 vssd1 vccd1 vccd1 _1578_ sky130_fd_sc_hd__nand2b_1
X_5341_ _0530_ _0520_ vssd1 vssd1 vccd1 vccd1 _0531_ sky130_fd_sc_hd__nand2b_1
X_8060_ net263 net197 net194 net267 vssd1 vssd1 vccd1 vccd1 _3316_ sky130_fd_sc_hd__a22o_1
XFILLER_87_307 vssd1 vssd1 vccd1 vccd1 sky130_fd_sc_hd__fill_1
X_7011_ _2225_ _2226_ vssd1 vssd1 vccd1 vccd1 _2227_ sky130_fd_sc_hd__nor2_1
X_5272_ _0461_ _0452_ vssd1 vssd1 vccd1 vccd1 _0462_ sky130_fd_sc_hd__and2b_1
X_4223_ net147 vssd1 vssd1 vccd1 vccd1 PID_INST.k3_calc.d1.y\[1\] sky130_fd_sc_hd__inv_2
XFILLER_68_565 vssd1 vssd1 vccd1 vccd1 sky130_fd_sc_hd__fill_4
XFILLER_83_524 vccd1 vssd1 vccd1 vssd1 sky130_ef_sc_hd__decap_40_12
XFILLER_28_418 vssd1 vssd1 vccd1 vccd1 sky130_fd_sc_hd__fill_2
X_7913_ _3105_ _3106_ _3103_ vssd1 vssd1 vccd1 vccd1 _3168_ sky130_fd_sc_hd__o21a_1
X_7844_ _3089_ _3098_ vssd1 vssd1 vccd1 vccd1 _3100_ sky130_fd_sc_hd__xnor2_1
X_7775_ _3028_ _3029_ _3030_ vssd1 vssd1 vccd1 vccd1 _3031_ sky130_fd_sc_hd__or3_1
XANTENNA__7049__A net215 vssd1 vssd1 vccd1 vccd1 sky130_fd_sc_hd__diode_2
X_6726_ _1922_ _1924_ vssd1 vssd1 vccd1 vccd1 _1925_ sky130_fd_sc_hd__xnor2_1
X_4987_ _0173_ _0176_ vssd1 vssd1 vccd1 vccd1 _0177_ sky130_fd_sc_hd__xnor2_1
X_6657_ net199 net307 vssd1 vssd1 vccd1 vccd1 _1852_ sky130_fd_sc_hd__nand2_1
XANTENNA__6146__A2 net83 vssd1 vssd1 vccd1 vccd1 sky130_fd_sc_hd__diode_2
XANTENNA__5159__A2_N net74 vssd1 vssd1 vccd1 vccd1 sky130_fd_sc_hd__diode_2
XANTENNA__8086__A2_N net183 vssd1 vssd1 vccd1 vccd1 sky130_fd_sc_hd__diode_2
X_5608_ net314 net210 net220 net302 vssd1 vssd1 vccd1 vccd1 _0798_ sky130_fd_sc_hd__a22oi_1
XANTENNA_fanout210_X net210 vssd1 vssd1 vccd1 vccd1 sky130_fd_sc_hd__diode_2
XANTENNA_fanout308_X net308 vssd1 vssd1 vccd1 vccd1 sky130_fd_sc_hd__diode_2
Xclkbuf_4_2_0_clk clknet_0_clk vssd1 vssd1 vccd1 vccd1 clknet_4_2_0_clk sky130_fd_sc_hd__clkbuf_8
X_6588_ _1770_ _1776_ vssd1 vssd1 vccd1 vccd1 _1777_ sky130_fd_sc_hd__xnor2_1
X_8327_ _3578_ _3603_ vssd1 vssd1 vccd1 vccd1 _3604_ sky130_fd_sc_hd__xnor2_1
X_5539_ _0719_ _0728_ _0689_ vssd1 vssd1 vccd1 vccd1 _0729_ sky130_fd_sc_hd__o21a_1
X_8258_ _3456_ _3528_ vssd1 vssd1 vccd1 vccd1 _3530_ sky130_fd_sc_hd__xnor2_1
XFILLER_78_307 vssd1 vssd1 vccd1 vccd1 sky130_fd_sc_hd__fill_1
Xfanout320 net321 vssd1 vssd1 vccd1 vccd1 net320 sky130_fd_sc_hd__buf_2
XFILLER_59_521 vssd1 vssd1 vccd1 vccd1 sky130_fd_sc_hd__fill_2
X_8189_ _3414_ _3453_ vssd1 vssd1 vccd1 vccd1 _3455_ sky130_fd_sc_hd__xor2_1
Xfanout331 net339 vssd1 vssd1 vccd1 vccd1 net331 sky130_fd_sc_hd__clkbuf_4
X_7209_ _2433_ _2434_ vssd1 vssd1 vccd1 vccd1 _2436_ sky130_fd_sc_hd__xor2_1
XANTENNA__7512__A net99 vssd1 vssd1 vccd1 vccd1 sky130_fd_sc_hd__diode_2
XFILLER_46_215 vssd1 vssd1 vccd1 vccd1 sky130_fd_sc_hd__fill_8
XFILLER_74_546 vssd1 vssd1 vccd1 vccd1 sky130_fd_sc_hd__fill_1
XTAP_TAPCELL_ROW_57_766 vssd1 vccd1 sky130_fd_sc_hd__tapvpwrvgnd_1
XFILLER_14_178 vssd1 vssd1 vccd1 vccd1 sky130_fd_sc_hd__fill_4
XTAP_TAPCELL_ROW_40_600 vssd1 vccd1 sky130_fd_sc_hd__tapvpwrvgnd_1
XFILLER_52_85 vssd1 vssd1 vccd1 vccd1 sky130_fd_sc_hd__fill_4
XFILLER_52_74 vssd1 vssd1 vccd1 vccd1 sky130_fd_sc_hd__fill_1
XTAP_TAPCELL_ROW_12_324 vssd1 vccd1 sky130_fd_sc_hd__tapvpwrvgnd_1
XFILLER_52_96 vssd1 vssd1 vccd1 vccd1 sky130_fd_sc_hd__fill_4
Xinput17 gpio_in[7] vssd1 vssd1 vccd1 vccd1 net17 sky130_fd_sc_hd__clkbuf_4
XFILLER_6_344 vssd1 vssd1 vccd1 vccd1 sky130_fd_sc_hd__fill_2
XFILLER_6_322 vssd1 vssd1 vccd1 vccd1 sky130_fd_sc_hd__fill_1
XFILLER_6_377 vssd1 vssd1 vccd1 vccd1 sky130_fd_sc_hd__fill_1
XFILLER_77_71 vssd1 vssd1 vccd1 vccd1 sky130_fd_sc_hd__fill_1
XFILLER_37_204 vccd1 vssd1 vccd1 vssd1 sky130_ef_sc_hd__decap_40_12
XANTENNA__6038__A net207 vssd1 vssd1 vccd1 vccd1 sky130_fd_sc_hd__diode_2
XFILLER_37_237 vssd1 vssd1 vccd1 vccd1 sky130_fd_sc_hd__fill_2
XFILLER_92_365 vccd1 vssd1 vccd1 vssd1 sky130_ef_sc_hd__decap_40_12
XFILLER_80_516 vssd1 vssd1 vccd1 vccd1 sky130_fd_sc_hd__fill_4
XFILLER_80_505 vssd1 vssd1 vccd1 vccd1 sky130_fd_sc_hd__fill_4
XFILLER_18_451 vssd1 vssd1 vccd1 vccd1 sky130_fd_sc_hd__fill_2
X_5890_ _1060_ _1074_ _1079_ net311 vssd1 vssd1 vccd1 vccd1 _1080_ sky130_fd_sc_hd__o22a_1
X_4910_ _0080_ _0098_ vssd1 vssd1 vccd1 vccd1 _0100_ sky130_fd_sc_hd__xnor2_1
XTAP_TAPCELL_ROW_82_1024 vssd1 vccd1 sky130_fd_sc_hd__tapvpwrvgnd_1
XANTENNA__5596__B net306 vssd1 vssd1 vccd1 vccd1 sky130_fd_sc_hd__diode_2
X_4841_ _4115_ _4117_ vssd1 vssd1 vccd1 vccd1 _4119_ sky130_fd_sc_hd__xnor2_1
XFILLER_60_251 vssd1 vssd1 vccd1 vccd1 sky130_fd_sc_hd__fill_1
XFILLER_60_295 vssd1 vssd1 vccd1 vccd1 sky130_fd_sc_hd__fill_1
X_4772_ _4047_ _4049_ vssd1 vssd1 vccd1 vccd1 _4050_ sky130_fd_sc_hd__nor2_1
X_7560_ _2553_ _2557_ vssd1 vssd1 vccd1 vccd1 _2808_ sky130_fd_sc_hd__nand2_1
X_7491_ _2733_ _2734_ vssd1 vssd1 vccd1 vccd1 _2735_ sky130_fd_sc_hd__nor2_1
X_6511_ _1697_ _1696_ vssd1 vssd1 vccd1 vccd1 _1698_ sky130_fd_sc_hd__nand2b_1
X_6442_ _1421_ _1628_ vssd1 vssd1 vccd1 vccd1 _1630_ sky130_fd_sc_hd__or2_1
X_8112_ _3361_ _3371_ vssd1 vssd1 vccd1 vccd1 _3372_ sky130_fd_sc_hd__nand2b_1
X_6373_ net131 _0156_ _1559_ vssd1 vssd1 vccd1 vccd1 _1561_ sky130_fd_sc_hd__a21o_1
X_5324_ _0512_ _0513_ vssd1 vssd1 vccd1 vccd1 _0514_ sky130_fd_sc_hd__nor2_1
X_8043_ _3295_ _3296_ vssd1 vssd1 vccd1 vccd1 _3297_ sky130_fd_sc_hd__nor2_1
X_5255_ _0432_ _0444_ vssd1 vssd1 vccd1 vccd1 _0445_ sky130_fd_sc_hd__and2_1
XFILLER_68_340 vssd1 vssd1 vccd1 vccd1 sky130_fd_sc_hd__fill_2
X_4206_ _2210_ vssd1 vssd1 vccd1 vccd1 PID_INST.k3_calc.d1.y\[3\] sky130_fd_sc_hd__inv_2
X_5186_ net134 net78 vssd1 vssd1 vccd1 vccd1 _0376_ sky130_fd_sc_hd__nand2_1
XFILLER_71_505 vssd1 vssd1 vccd1 vccd1 sky130_fd_sc_hd__fill_2
XTAP_TAPCELL_ROW_54_736 vssd1 vccd1 sky130_fd_sc_hd__tapvpwrvgnd_1
XANTENNA_fanout258_X net258 vssd1 vssd1 vccd1 vccd1 sky130_fd_sc_hd__diode_2
XFILLER_51_240 vssd1 vssd1 vccd1 vccd1 sky130_fd_sc_hd__fill_1
X_7827_ _3075_ _3081_ vssd1 vssd1 vccd1 vccd1 _3083_ sky130_fd_sc_hd__xnor2_1
XFILLER_24_465 vssd1 vssd1 vccd1 vccd1 sky130_fd_sc_hd__fill_2
X_7758_ net281 net276 net196 net192 vssd1 vssd1 vccd1 vccd1 _3014_ sky130_fd_sc_hd__and4_1
X_7689_ _2941_ _2942_ _2943_ vssd1 vssd1 vccd1 vccd1 _2944_ sky130_fd_sc_hd__or3_1
X_6709_ _1905_ _1904_ vssd1 vssd1 vccd1 vccd1 _1906_ sky130_fd_sc_hd__nand2b_1
XFILLER_22_66 vssd1 vssd1 vccd1 vccd1 sky130_fd_sc_hd__fill_1
XFILLER_78_137 vssd1 vssd1 vccd1 vccd1 sky130_fd_sc_hd__fill_2
XANTENNA__4302__A1 net4 vssd1 vssd1 vccd1 vccd1 sky130_fd_sc_hd__diode_2
Xfanout183 PID_INST.k2_calc.sum_reg\[19\] vssd1 vssd1 vccd1 vccd1 net183 sky130_fd_sc_hd__clkbuf_4
Xfanout161 _2939_ vssd1 vssd1 vccd1 vccd1 net161 sky130_fd_sc_hd__clkbuf_4
Xfanout172 _2908_ vssd1 vssd1 vccd1 vccd1 net172 sky130_fd_sc_hd__buf_2
XFILLER_47_502 vssd1 vssd1 vccd1 vccd1 sky130_fd_sc_hd__fill_2
Xfanout150 net151 vssd1 vssd1 vccd1 vccd1 net150 sky130_fd_sc_hd__buf_2
XFILLER_19_204 vssd1 vssd1 vccd1 vccd1 sky130_fd_sc_hd__fill_1
XFILLER_74_321 vssd1 vssd1 vccd1 vccd1 sky130_fd_sc_hd__fill_1
Xfanout194 net196 vssd1 vssd1 vccd1 vccd1 net194 sky130_fd_sc_hd__buf_2
XFILLER_47_535 vssd1 vssd1 vccd1 vccd1 sky130_fd_sc_hd__fill_2
XFILLER_47_74 vssd1 vssd1 vccd1 vccd1 sky130_fd_sc_hd__fill_1
XFILLER_74_398 vssd1 vssd1 vccd1 vccd1 sky130_fd_sc_hd__fill_4
XFILLER_27_281 vssd1 vssd1 vccd1 vccd1 sky130_fd_sc_hd__fill_8
XFILLER_8_57 vccd1 vssd1 vccd1 vssd1 sky130_ef_sc_hd__decap_40_12
XFILLER_6_141 vssd1 vssd1 vccd1 vccd1 sky130_fd_sc_hd__fill_1
XFILLER_88_70 vssd1 vssd1 vccd1 vccd1 sky130_fd_sc_hd__fill_1
XANTENNA__4776__A net137 vssd1 vssd1 vccd1 vccd1 sky130_fd_sc_hd__diode_2
X_5040_ _0228_ _0229_ vssd1 vssd1 vccd1 vccd1 _0230_ sky130_fd_sc_hd__xor2_1
X_6991_ _2194_ _2205_ vssd1 vssd1 vccd1 vccd1 _2206_ sky130_fd_sc_hd__nor2_1
XFILLER_92_173 vssd1 vssd1 vccd1 vccd1 sky130_fd_sc_hd__fill_2
XFILLER_80_313 vssd1 vssd1 vccd1 vccd1 sky130_fd_sc_hd__fill_2
XFILLER_65_398 vssd1 vssd1 vccd1 vccd1 sky130_fd_sc_hd__fill_1
XFILLER_53_527 vssd1 vssd1 vccd1 vccd1 sky130_fd_sc_hd__fill_4
XFILLER_25_218 vssd1 vssd1 vccd1 vccd1 sky130_fd_sc_hd__fill_4
X_5942_ _0488_ _0491_ vssd1 vssd1 vccd1 vccd1 _1132_ sky130_fd_sc_hd__nor2_1
XFILLER_18_281 vssd1 vssd1 vccd1 vccd1 sky130_fd_sc_hd__fill_1
X_5873_ _1016_ _1062_ vssd1 vssd1 vccd1 vccd1 _1063_ sky130_fd_sc_hd__nor2_1
XTAP_TAPCELL_ROW_51_706 vssd1 vccd1 sky130_fd_sc_hd__tapvpwrvgnd_1
X_4824_ _1817_ net70 vssd1 vssd1 vccd1 vccd1 _4102_ sky130_fd_sc_hd__nor2_1
X_7612_ net115 net37 vssd1 vssd1 vccd1 vccd1 _2864_ sky130_fd_sc_hd__nor2_1
X_4755_ _3994_ _3997_ _4032_ vssd1 vssd1 vccd1 vccd1 _4033_ sky130_fd_sc_hd__or3_2
X_7543_ net112 net38 _2534_ _2533_ vssd1 vssd1 vccd1 vccd1 _2790_ sky130_fd_sc_hd__o31a_1
XANTENNA_fanout120_A net121 vssd1 vssd1 vccd1 vccd1 sky130_fd_sc_hd__diode_2
X_7474_ _2611_ _2615_ _2715_ vssd1 vssd1 vccd1 vccd1 _2717_ sky130_fd_sc_hd__and3_1
XANTENNA_fanout218_A net221 vssd1 vssd1 vccd1 vccd1 sky130_fd_sc_hd__diode_2
X_4686_ _3962_ _3963_ vssd1 vssd1 vccd1 vccd1 _3964_ sky130_fd_sc_hd__or2_1
X_6425_ net246 net250 net258 net254 vssd1 vssd1 vccd1 vccd1 _1613_ sky130_fd_sc_hd__and4_1
X_6356_ _1338_ _1345_ _1543_ vssd1 vssd1 vccd1 vccd1 _1544_ sky130_fd_sc_hd__a21oi_1
XFILLER_0_328 vssd1 vssd1 vccd1 vccd1 sky130_fd_sc_hd__fill_8
X_5307_ net137 net80 _0496_ vssd1 vssd1 vccd1 vccd1 _0497_ sky130_fd_sc_hd__and3_1
XFILLER_88_457 vccd1 vssd1 vccd1 vssd1 sky130_ef_sc_hd__decap_40_12
X_6287_ net227 net287 _1271_ _1269_ vssd1 vssd1 vccd1 vccd1 _1476_ sky130_fd_sc_hd__a31o_1
XANTENNA__8158__A net110 vssd1 vssd1 vccd1 vccd1 sky130_fd_sc_hd__diode_2
X_8026_ _3277_ _3278_ vssd1 vssd1 vccd1 vccd1 _3280_ sky130_fd_sc_hd__nand2_1
XANTENNA__4296__A0 net309 vssd1 vssd1 vccd1 vccd1 sky130_fd_sc_hd__diode_2
X_5238_ _0425_ _0426_ vssd1 vssd1 vccd1 vccd1 _0428_ sky130_fd_sc_hd__xor2_1
XFILLER_56_332 vssd1 vssd1 vccd1 vccd1 sky130_fd_sc_hd__fill_1
X_5169_ net166 net89 vssd1 vssd1 vccd1 vccd1 _0359_ sky130_fd_sc_hd__nand2_1
XFILLER_56_343 vssd1 vssd1 vccd1 vccd1 sky130_fd_sc_hd__fill_1
XFILLER_83_184 vssd1 vssd1 vccd1 vccd1 sky130_fd_sc_hd__fill_8
XFILLER_71_302 vssd1 vssd1 vccd1 vccd1 sky130_fd_sc_hd__fill_2
XTAP_TAPCELL_ROW_67_872 vssd1 vccd1 sky130_fd_sc_hd__tapvpwrvgnd_1
XFILLER_56_376 vccd1 vssd1 vccd1 vssd1 sky130_ef_sc_hd__decap_40_12
XFILLER_16_218 vssd1 vssd1 vccd1 vccd1 sky130_fd_sc_hd__fill_1
XFILLER_17_55 vssd1 vssd1 vccd1 vccd1 sky130_fd_sc_hd__fill_1
XFILLER_71_335 vssd1 vssd1 vccd1 vccd1 sky130_fd_sc_hd__fill_1
XANTENNA__6125__B net50 vssd1 vssd1 vccd1 vccd1 sky130_fd_sc_hd__diode_2
XFILLER_12_435 vssd1 vssd1 vccd1 vccd1 sky130_fd_sc_hd__fill_1
XPHY_EDGE_ROW_49_Left_142 vssd1 vssd1 vccd1 vccd1 sky130_fd_sc_hd__decap_3
XFILLER_33_65 vssd1 vssd1 vccd1 vccd1 sky130_fd_sc_hd__fill_1
XANTENNA__6141__A net162 vssd1 vssd1 vccd1 vccd1 sky130_fd_sc_hd__diode_2
XANTENNA__5980__A net125 vssd1 vssd1 vccd1 vccd1 sky130_fd_sc_hd__diode_2
XFILLER_79_413 vccd1 vssd1 vccd1 vssd1 sky130_ef_sc_hd__decap_40_12
XFILLER_3_177 vssd1 vssd1 vccd1 vccd1 sky130_fd_sc_hd__fill_2
XANTENNA__6276__A1 net210 vssd1 vssd1 vccd1 vccd1 sky130_fd_sc_hd__diode_2
XANTENNA__4287__A0 net5 vssd1 vssd1 vccd1 vccd1 sky130_fd_sc_hd__diode_2
XPHY_EDGE_ROW_58_Left_151 vssd1 vssd1 vccd1 vccd1 sky130_fd_sc_hd__decap_3
Xhold6 PID_INST.k1_calc.d1.x\[6\] vssd1 vssd1 vccd1 vccd1 net399 sky130_fd_sc_hd__dlygate4sd3_1
XFILLER_35_505 vssd1 vssd1 vccd1 vccd1 sky130_fd_sc_hd__fill_4
XFILLER_74_151 vssd1 vssd1 vccd1 vccd1 sky130_fd_sc_hd__fill_1
XFILLER_74_61 vccd1 vssd1 vccd1 vssd1 sky130_ef_sc_hd__decap_40_12
XFILLER_74_195 vssd1 vssd1 vccd1 vccd1 sky130_fd_sc_hd__fill_1
XFILLER_74_83 vssd1 vssd1 vccd1 vccd1 sky130_fd_sc_hd__fill_1
XANTENNA__6316__A net139 vssd1 vssd1 vccd1 vccd1 sky130_fd_sc_hd__diode_2
XANTENNA__5577__D net223 vssd1 vssd1 vccd1 vccd1 sky130_fd_sc_hd__diode_2
XPHY_EDGE_ROW_67_Left_160 vssd1 vssd1 vccd1 vccd1 sky130_fd_sc_hd__decap_3
XANTENNA__4481__D net79 vssd1 vssd1 vccd1 vccd1 sky130_fd_sc_hd__diode_2
X_4540_ net122 net84 vssd1 vssd1 vccd1 vccd1 _3818_ sky130_fd_sc_hd__nand2_1
X_4471_ PID_INST.k1_calc.d1.x\[4\] PID_INST.k3_calc.prev_error\[4\] _3745_ vssd1 vssd1
+ vccd1 vccd1 _3749_ sky130_fd_sc_hd__and3_1
XANTENNA__6986__A net114 vssd1 vssd1 vccd1 vccd1 sky130_fd_sc_hd__diode_2
X_6210_ _1398_ _1329_ vssd1 vssd1 vccd1 vccd1 _1399_ sky130_fd_sc_hd__nand2b_1
X_7190_ _2401_ _2415_ vssd1 vssd1 vccd1 vccd1 _2416_ sky130_fd_sc_hd__nand2b_1
XTAP_TAPCELL_ROW_90_1101 vssd1 vccd1 sky130_fd_sc_hd__tapvpwrvgnd_1
X_6141_ net162 _3799_ vssd1 vssd1 vccd1 vccd1 _1330_ sky130_fd_sc_hd__nand2_1
X_6072_ _0779_ _0788_ _1260_ vssd1 vssd1 vccd1 vccd1 _1262_ sky130_fd_sc_hd__and3_1
XANTENNA__4278__A0 net13 vssd1 vssd1 vccd1 vccd1 sky130_fd_sc_hd__diode_2
XFILLER_85_449 vssd1 vssd1 vccd1 vccd1 sky130_fd_sc_hd__fill_4
X_5023_ _0170_ _0211_ vssd1 vssd1 vccd1 vccd1 _0213_ sky130_fd_sc_hd__or2_1
XFILLER_53_324 vssd1 vssd1 vccd1 vccd1 sky130_fd_sc_hd__fill_4
XFILLER_38_365 vssd1 vssd1 vccd1 vccd1 sky130_fd_sc_hd__fill_8
XTAP_TAPCELL_ROW_88_1085 vssd1 vccd1 sky130_fd_sc_hd__tapvpwrvgnd_1
XFILLER_65_195 vssd1 vssd1 vccd1 vccd1 sky130_fd_sc_hd__fill_2
XTAP_TAPCELL_ROW_64_842 vssd1 vccd1 sky130_fd_sc_hd__tapvpwrvgnd_1
XANTENNA__5130__A net116 vssd1 vssd1 vccd1 vccd1 sky130_fd_sc_hd__diode_2
X_6974_ net139 net47 vssd1 vssd1 vccd1 vccd1 _2188_ sky130_fd_sc_hd__nor2_1
XFILLER_26_549 vssd1 vssd1 vccd1 vccd1 sky130_fd_sc_hd__fill_2
XFILLER_80_176 vssd1 vssd1 vccd1 vccd1 sky130_fd_sc_hd__fill_4
X_5925_ _1113_ _1114_ vssd1 vssd1 vccd1 vccd1 _1115_ sky130_fd_sc_hd__and2b_1
X_5856_ _1028_ _1045_ vssd1 vssd1 vccd1 vccd1 _1046_ sky130_fd_sc_hd__nand2b_1
XPHY_EDGE_ROW_3_Right_3 vssd1 vssd1 vccd1 vccd1 sky130_fd_sc_hd__decap_3
X_4807_ _4010_ _4012_ _4082_ _4083_ vssd1 vssd1 vccd1 vccd1 _4085_ sky130_fd_sc_hd__a211o_1
X_5787_ _0947_ _0948_ vssd1 vssd1 vccd1 vccd1 _0977_ sky130_fd_sc_hd__or2_1
X_4738_ _4013_ _4014_ vssd1 vssd1 vccd1 vccd1 _4016_ sky130_fd_sc_hd__xor2_1
XANTENNA_fanout123_X net123 vssd1 vssd1 vccd1 vccd1 sky130_fd_sc_hd__diode_2
X_7526_ net140 net40 vssd1 vssd1 vccd1 vccd1 _2773_ sky130_fd_sc_hd__nor2_1
X_7457_ _2603_ _2605_ _2602_ vssd1 vssd1 vccd1 vccd1 _2699_ sky130_fd_sc_hd__o21ba_1
X_4669_ net121 net153 net145 _3946_ vssd1 vssd1 vccd1 vccd1 _3947_ sky130_fd_sc_hd__a31o_1
XANTENNA__4505__B2 net132 vssd1 vssd1 vccd1 vccd1 sky130_fd_sc_hd__diode_2
X_6408_ _1523_ _1595_ vssd1 vssd1 vccd1 vccd1 _1596_ sky130_fd_sc_hd__xnor2_1
X_7388_ net199 net288 _2625_ vssd1 vssd1 vccd1 vccd1 _2626_ sky130_fd_sc_hd__and3_1
XFILLER_88_243 vssd1 vssd1 vccd1 vccd1 sky130_fd_sc_hd__fill_1
XANTENNA__6258__A1 net228 vssd1 vssd1 vccd1 vccd1 sky130_fd_sc_hd__diode_2
X_6339_ net163 _3754_ net80 net162 vssd1 vssd1 vccd1 vccd1 _1527_ sky130_fd_sc_hd__a22o_1
XFILLER_88_265 vssd1 vssd1 vccd1 vccd1 sky130_fd_sc_hd__fill_2
XFILLER_0_169 vssd1 vssd1 vccd1 vccd1 sky130_fd_sc_hd__fill_4
X_8009_ _2816_ _2970_ _3114_ _3115_ _3263_ vssd1 vssd1 vccd1 vccd1 _3264_ sky130_fd_sc_hd__a311o_1
XFILLER_29_332 vssd1 vssd1 vccd1 vccd1 sky130_fd_sc_hd__fill_4
XFILLER_29_376 vccd1 vssd1 vccd1 vssd1 sky130_ef_sc_hd__decap_40_12
XFILLER_44_64 vssd1 vssd1 vccd1 vccd1 sky130_fd_sc_hd__fill_4
XFILLER_12_221 vssd1 vssd1 vccd1 vccd1 sky130_fd_sc_hd__fill_4
XANTENNA__8070__B net209 vssd1 vssd1 vccd1 vccd1 sky130_fd_sc_hd__diode_2
XFILLER_67_438 vssd1 vssd1 vccd1 vccd1 sky130_fd_sc_hd__fill_1
XANTENNA__8366__CLK clknet_4_0_0_clk vssd1 vssd1 vccd1 vccd1 sky130_fd_sc_hd__diode_2
XFILLER_85_60 vssd1 vssd1 vccd1 vccd1 sky130_fd_sc_hd__fill_8
XTAP_TAPCELL_ROW_78_978 vssd1 vccd1 sky130_fd_sc_hd__tapvpwrvgnd_1
XTAP_TAPCELL_ROW_61_812 vssd1 vccd1 sky130_fd_sc_hd__tapvpwrvgnd_1
X_5710_ net318 net224 _0889_ _0888_ _0863_ vssd1 vssd1 vccd1 vccd1 _0900_ sky130_fd_sc_hd__a32o_1
X_6690_ _1665_ _1667_ _1664_ vssd1 vssd1 vccd1 vccd1 _1888_ sky130_fd_sc_hd__o21ba_1
XFILLER_31_563 vssd1 vssd1 vccd1 vccd1 sky130_fd_sc_hd__fill_4
XFILLER_43_390 vssd1 vssd1 vccd1 vccd1 sky130_fd_sc_hd__fill_2
X_5641_ net319 net210 _0827_ vssd1 vssd1 vccd1 vccd1 _0831_ sky130_fd_sc_hd__nand3_1
X_5572_ _0734_ _0735_ _0761_ vssd1 vssd1 vccd1 vccd1 _0762_ sky130_fd_sc_hd__or3_1
X_8360_ _3548_ _3638_ vssd1 vssd1 vccd1 vccd1 _3639_ sky130_fd_sc_hd__xnor2_1
X_8291_ net294 net179 PID_INST.k2_calc.sum_reg\[24\] net305 vssd1 vssd1 vccd1 vccd1
+ _3564_ sky130_fd_sc_hd__a22oi_1
X_4523_ net126 net84 vssd1 vssd1 vccd1 vccd1 _3801_ sky130_fd_sc_hd__nand2_1
X_7311_ _2529_ _2542_ vssd1 vssd1 vccd1 vccd1 _2544_ sky130_fd_sc_hd__xnor2_1
X_7242_ _2400_ _2470_ vssd1 vssd1 vccd1 vccd1 _2471_ sky130_fd_sc_hd__xnor2_1
XANTENNA__7605__A net140 vssd1 vssd1 vccd1 vccd1 sky130_fd_sc_hd__diode_2
X_4454_ _3716_ _3729_ _3730_ vssd1 vssd1 vccd1 vccd1 _3732_ sky130_fd_sc_hd__or3_4
X_7173_ _2395_ _2396_ vssd1 vssd1 vccd1 vccd1 _2398_ sky130_fd_sc_hd__and2_1
X_4385_ net201 _3678_ net160 vssd1 vssd1 vccd1 vccd1 _0044_ sky130_fd_sc_hd__mux2_1
XANTENNA__5125__A net116 vssd1 vssd1 vccd1 vccd1 sky130_fd_sc_hd__diode_2
X_6124_ _1310_ _1311_ vssd1 vssd1 vccd1 vccd1 _1313_ sky130_fd_sc_hd__xor2_1
X_6055_ net210 net306 vssd1 vssd1 vccd1 vccd1 _1245_ sky130_fd_sc_hd__nand2_1
XANTENNA__6660__A1 net219 vssd1 vssd1 vccd1 vccd1 sky130_fd_sc_hd__diode_2
XFILLER_85_246 vssd1 vssd1 vccd1 vccd1 sky130_fd_sc_hd__fill_1
XFILLER_73_408 vssd1 vssd1 vccd1 vccd1 sky130_fd_sc_hd__fill_4
XANTENNA_fanout285_A PID_INST.k2_calc.reg_lc\[8\] vssd1 vssd1 vccd1 vccd1 sky130_fd_sc_hd__diode_2
X_5006_ _0193_ _0194_ vssd1 vssd1 vccd1 vccd1 _0196_ sky130_fd_sc_hd__xnor2_1
XANTENNA__6660__B2 net223 vssd1 vssd1 vccd1 vccd1 sky130_fd_sc_hd__diode_2
XTAP_TAPCELL_ROW_49_691 vssd1 vccd1 sky130_fd_sc_hd__tapvpwrvgnd_1
XFILLER_38_195 vssd1 vssd1 vccd1 vccd1 sky130_fd_sc_hd__fill_1
XFILLER_81_474 vssd1 vssd1 vccd1 vccd1 sky130_fd_sc_hd__fill_4
X_6957_ net95 net55 vssd1 vssd1 vccd1 vccd1 _2170_ sky130_fd_sc_hd__nor2_1
XFILLER_53_176 vssd1 vssd1 vccd1 vccd1 sky130_fd_sc_hd__fill_2
X_5908_ _1009_ _1013_ _1010_ vssd1 vssd1 vccd1 vccd1 _1098_ sky130_fd_sc_hd__o21ai_1
XFILLER_14_34 vssd1 vssd1 vccd1 vccd1 sky130_fd_sc_hd__fill_1
XANTENNA__4974__A1 _2389_ vssd1 vssd1 vccd1 vccd1 sky130_fd_sc_hd__diode_2
XANTENNA__8171__A net92 vssd1 vssd1 vccd1 vccd1 sky130_fd_sc_hd__diode_2
X_6888_ _2052_ _2096_ vssd1 vssd1 vccd1 vccd1 _2097_ sky130_fd_sc_hd__xnor2_1
X_5839_ _0988_ _0989_ vssd1 vssd1 vccd1 vccd1 _1029_ sky130_fd_sc_hd__xor2_1
XFILLER_14_78 vssd1 vssd1 vccd1 vccd1 sky130_fd_sc_hd__fill_1
X_7509_ _2752_ _2753_ vssd1 vssd1 vccd1 vccd1 _2754_ sky130_fd_sc_hd__or2_1
X_8489_ clknet_4_15_0_clk PID_INST.pid.next_state\[2\] net336 vssd1 vssd1 vccd1 vccd1
+ PID_INST.pid.curr_state\[2\] sky130_fd_sc_hd__dfrtp_1
XFILLER_1_434 vssd1 vssd1 vccd1 vccd1 sky130_fd_sc_hd__fill_1
XFILLER_49_427 vssd1 vssd1 vccd1 vccd1 sky130_fd_sc_hd__fill_1
XANTENNA__8346__A net92 vssd1 vssd1 vccd1 vccd1 sky130_fd_sc_hd__diode_2
XANTENNA__4593__B net84 vssd1 vssd1 vccd1 vccd1 sky130_fd_sc_hd__diode_2
XFILLER_29_162 vssd1 vssd1 vccd1 vccd1 sky130_fd_sc_hd__fill_2
XTAP_TAPCELL_ROW_75_948 vssd1 vccd1 sky130_fd_sc_hd__tapvpwrvgnd_1
XANTENNA_input13_A gpio_in[3] vssd1 vssd1 vccd1 vccd1 sky130_fd_sc_hd__diode_2
XANTENNA__4414__B1 net183 vssd1 vssd1 vccd1 vccd1 sky130_fd_sc_hd__diode_2
XANTENNA__8156__A1 net100 vssd1 vssd1 vccd1 vccd1 sky130_fd_sc_hd__diode_2
XANTENNA__8156__B2 net98 vssd1 vssd1 vccd1 vccd1 sky130_fd_sc_hd__diode_2
XFILLER_71_84 vssd1 vssd1 vccd1 vccd1 sky130_fd_sc_hd__fill_1
XANTENNA__4193__A2 net173 vssd1 vssd1 vccd1 vccd1 sky130_fd_sc_hd__diode_2
XTAP_TAPCELL_ROW_10_296 vssd1 vccd1 sky130_fd_sc_hd__tapvpwrvgnd_1
XANTENNA__4768__B _3774_ vssd1 vssd1 vccd1 vccd1 sky130_fd_sc_hd__diode_2
XFILLER_4_294 vssd1 vssd1 vccd1 vccd1 sky130_fd_sc_hd__fill_4
X_4170_ net177 net176 vssd1 vssd1 vccd1 vccd1 _1838_ sky130_fd_sc_hd__nand2_1
XANTENNA__6983__B net42 vssd1 vssd1 vccd1 vccd1 sky130_fd_sc_hd__diode_2
XFILLER_67_279 vssd1 vssd1 vccd1 vccd1 sky130_fd_sc_hd__fill_1
X_7860_ _3115_ vssd1 vssd1 vccd1 vccd1 _3116_ sky130_fd_sc_hd__inv_2
XTAP_TAPCELL_ROW_85_1055 vssd1 vccd1 sky130_fd_sc_hd__tapvpwrvgnd_1
XFILLER_63_474 vssd1 vssd1 vccd1 vccd1 sky130_fd_sc_hd__fill_2
X_6811_ _2014_ _2013_ vssd1 vssd1 vccd1 vccd1 _2015_ sky130_fd_sc_hd__and2b_1
XTAP_TAPCELL_ROW_46_661 vssd1 vccd1 sky130_fd_sc_hd__tapvpwrvgnd_1
X_7791_ _3044_ _3045_ vssd1 vssd1 vccd1 vccd1 _3047_ sky130_fd_sc_hd__xnor2_1
XFILLER_50_113 vssd1 vssd1 vccd1 vccd1 sky130_fd_sc_hd__fill_1
XTAP_TAPCELL_ROW_18_385 vssd1 vccd1 sky130_fd_sc_hd__tapvpwrvgnd_1
X_6742_ _1939_ _1940_ vssd1 vssd1 vccd1 vccd1 _1941_ sky130_fd_sc_hd__xnor2_1
XANTENNA__6504__A net163 vssd1 vssd1 vccd1 vccd1 sky130_fd_sc_hd__diode_2
XFILLER_50_135 vssd1 vssd1 vccd1 vccd1 sky130_fd_sc_hd__fill_4
X_6673_ _1845_ _1846_ _1868_ vssd1 vssd1 vccd1 vccd1 _1869_ sky130_fd_sc_hd__nor3_1
X_5624_ _0811_ _0812_ vssd1 vssd1 vccd1 vccd1 _0814_ sky130_fd_sc_hd__or2_1
X_8412_ clknet_4_8_0_clk net142 net328 vssd1 vssd1 vccd1 vccd1 PID_INST.k3_calc.kd_term\[0\]
+ sky130_fd_sc_hd__dfrtp_1
XFILLER_31_382 vssd1 vssd1 vccd1 vccd1 sky130_fd_sc_hd__fill_8
X_8343_ _3435_ _3436_ _3434_ vssd1 vssd1 vccd1 vccd1 _3621_ sky130_fd_sc_hd__a21bo_1
X_5555_ net244 net283 net278 net239 vssd1 vssd1 vccd1 vccd1 _0745_ sky130_fd_sc_hd__and4_1
XANTENNA__4184__A2 net173 vssd1 vssd1 vccd1 vccd1 sky130_fd_sc_hd__diode_2
X_8274_ _3451_ _3452_ _3454_ vssd1 vssd1 vccd1 vccd1 _3546_ sky130_fd_sc_hd__o21ai_1
X_5486_ _0674_ _0675_ vssd1 vssd1 vccd1 vccd1 _0676_ sky130_fd_sc_hd__xnor2_1
XFILLER_2_209 vssd1 vssd1 vccd1 vccd1 sky130_fd_sc_hd__fill_2
X_4506_ _3721_ _3725_ vssd1 vssd1 vccd1 vccd1 _3784_ sky130_fd_sc_hd__xor2_1
X_7225_ _2197_ _2452_ vssd1 vssd1 vccd1 vccd1 _2454_ sky130_fd_sc_hd__or2_1
X_4437_ PID_INST.k1_calc.d1.x\[4\] PID_INST.k3_calc.prev_error\[4\] vssd1 vssd1 vccd1
+ vccd1 _3715_ sky130_fd_sc_hd__or2_1
X_7156_ _2377_ _2379_ vssd1 vssd1 vccd1 vccd1 _2380_ sky130_fd_sc_hd__nor2_1
XFILLER_86_533 vssd1 vssd1 vccd1 vccd1 sky130_fd_sc_hd__fill_8
XANTENNA_input5_A gpio_in[12] vssd1 vssd1 vccd1 vccd1 sky130_fd_sc_hd__diode_2
X_4368_ net209 net5 vssd1 vssd1 vccd1 vccd1 _3664_ sky130_fd_sc_hd__or2_1
XFILLER_58_213 vssd1 vssd1 vccd1 vccd1 sky130_fd_sc_hd__fill_1
X_6107_ net101 net66 net63 net99 vssd1 vssd1 vccd1 vccd1 _1296_ sky130_fd_sc_hd__o22a_1
X_7087_ _1981_ _1984_ _2306_ vssd1 vssd1 vccd1 vccd1 _2308_ sky130_fd_sc_hd__and3_1
XANTENNA_fanout190_X net190 vssd1 vssd1 vccd1 vccd1 sky130_fd_sc_hd__diode_2
XANTENNA_fanout288_X net288 vssd1 vssd1 vccd1 vccd1 sky130_fd_sc_hd__diode_2
X_4299_ net293 net18 net171 vssd1 vssd1 vccd1 vccd1 _0022_ sky130_fd_sc_hd__mux2_1
X_6038_ net207 net314 net302 net216 vssd1 vssd1 vccd1 vccd1 _1228_ sky130_fd_sc_hd__and4_1
XFILLER_73_216 vssd1 vssd1 vccd1 vccd1 sky130_fd_sc_hd__fill_8
XFILLER_46_419 vssd1 vssd1 vccd1 vccd1 sky130_fd_sc_hd__fill_1
XFILLER_73_249 vssd1 vssd1 vccd1 vccd1 sky130_fd_sc_hd__fill_2
XFILLER_26_110 vssd1 vssd1 vccd1 vccd1 sky130_fd_sc_hd__fill_4
XTAP_TAPCELL_ROW_72_918 vssd1 vccd1 sky130_fd_sc_hd__tapvpwrvgnd_1
XFILLER_26_132 vssd1 vssd1 vccd1 vccd1 sky130_fd_sc_hd__fill_2
X_7989_ _3242_ _3243_ vssd1 vssd1 vccd1 vccd1 _3244_ sky130_fd_sc_hd__xnor2_1
XFILLER_54_496 vssd1 vssd1 vccd1 vccd1 sky130_fd_sc_hd__fill_2
XFILLER_26_165 vssd1 vssd1 vccd1 vccd1 sky130_fd_sc_hd__fill_8
XFILLER_41_113 vssd1 vssd1 vccd1 vccd1 sky130_fd_sc_hd__fill_4
XFILLER_10_511 vssd1 vssd1 vccd1 vccd1 sky130_fd_sc_hd__fill_1
XANTENNA__4205__Y _2210_ vssd1 vssd1 vccd1 vccd1 sky130_fd_sc_hd__diode_2
XANTENNA__8402__Q PID_INST.k2_calc.reg_lc\[6\] vssd1 vssd1 vccd1 vccd1 sky130_fd_sc_hd__diode_2
XFILLER_10_533 vccd1 vssd1 vccd1 vssd1 sky130_ef_sc_hd__decap_40_12
XFILLER_41_54 vssd1 vssd1 vccd1 vccd1 sky130_fd_sc_hd__fill_2
XFILLER_41_65 vssd1 vssd1 vccd1 vccd1 sky130_fd_sc_hd__fill_2
XFILLER_6_559 vssd1 vssd1 vccd1 vccd1 sky130_fd_sc_hd__fill_8
XFILLER_89_382 vssd1 vssd1 vccd1 vccd1 sky130_fd_sc_hd__fill_4
Xteam_03_350 vssd1 vssd1 vccd1 vccd1 team_03_350/HI gpio_oeb[26] sky130_fd_sc_hd__conb_1
XFILLER_49_235 vssd1 vssd1 vccd1 vccd1 sky130_fd_sc_hd__fill_1
XFILLER_92_503 vssd1 vssd1 vccd1 vccd1 sky130_fd_sc_hd__fill_1
Xteam_03_361 vssd1 vssd1 vccd1 vccd1 team_03_361/HI gpio_out[3] sky130_fd_sc_hd__conb_1
Xteam_03_383 vssd1 vssd1 vccd1 vccd1 gpio_oeb[7] team_03_383/LO sky130_fd_sc_hd__conb_1
Xteam_03_372 vssd1 vssd1 vccd1 vccd1 team_03_372/HI gpio_out[14] sky130_fd_sc_hd__conb_1
XFILLER_64_249 vssd1 vssd1 vccd1 vccd1 sky130_fd_sc_hd__fill_2
XANTENNA_input16_X net16 vssd1 vssd1 vccd1 vccd1 sky130_fd_sc_hd__diode_2
XFILLER_45_430 vssd1 vssd1 vccd1 vccd1 sky130_fd_sc_hd__fill_1
XFILLER_82_50 vssd1 vssd1 vccd1 vccd1 sky130_fd_sc_hd__fill_4
XFILLER_72_282 vssd1 vssd1 vccd1 vccd1 sky130_fd_sc_hd__fill_8
XFILLER_32_102 vssd1 vssd1 vccd1 vccd1 sky130_fd_sc_hd__fill_1
XFILLER_82_83 vssd1 vssd1 vccd1 vccd1 sky130_fd_sc_hd__fill_1
XANTENNA__6324__A net119 vssd1 vssd1 vccd1 vccd1 sky130_fd_sc_hd__diode_2
XTAP_TAPCELL_ROW_43_631 vssd1 vccd1 sky130_fd_sc_hd__tapvpwrvgnd_1
XTAP_TAPCELL_ROW_15_355 vssd1 vccd1 sky130_fd_sc_hd__tapvpwrvgnd_1
XFILLER_13_393 vssd1 vssd1 vccd1 vccd1 sky130_fd_sc_hd__fill_4
X_5340_ _0527_ _0528_ vssd1 vssd1 vccd1 vccd1 _0530_ sky130_fd_sc_hd__xor2_1
X_5271_ _0459_ _0460_ vssd1 vssd1 vccd1 vccd1 _0461_ sky130_fd_sc_hd__xor2_1
X_7010_ net271 net225 net226 net266 vssd1 vssd1 vccd1 vccd1 _2226_ sky130_fd_sc_hd__a22oi_1
X_4222_ net13 net173 _2378_ vssd1 vssd1 vccd1 vccd1 _2389_ sky130_fd_sc_hd__o21ai_4
XFILLER_68_544 vssd1 vssd1 vccd1 vccd1 sky130_fd_sc_hd__fill_1
XFILLER_68_533 vssd1 vssd1 vccd1 vccd1 sky130_fd_sc_hd__fill_4
X_7912_ _3165_ _3166_ vssd1 vssd1 vccd1 vccd1 _3167_ sky130_fd_sc_hd__xnor2_1
XFILLER_83_569 vssd1 vssd1 vccd1 vccd1 sky130_fd_sc_hd__fill_1
XFILLER_36_430 vccd1 vssd1 vccd1 vssd1 sky130_ef_sc_hd__decap_40_12
XFILLER_70_219 vssd1 vssd1 vccd1 vccd1 sky130_fd_sc_hd__fill_1
X_7843_ _3098_ _3089_ vssd1 vssd1 vccd1 vccd1 _3099_ sky130_fd_sc_hd__nand2b_1
X_7774_ _2917_ _2941_ vssd1 vssd1 vccd1 vccd1 _3030_ sky130_fd_sc_hd__nor2_1
X_4986_ _0174_ _0175_ vssd1 vssd1 vccd1 vccd1 _0176_ sky130_fd_sc_hd__nor2_1
XANTENNA__8385__RESET_B net328 vssd1 vssd1 vccd1 vccd1 sky130_fd_sc_hd__diode_2
XANTENNA__7049__B net212 vssd1 vssd1 vccd1 vccd1 sky130_fd_sc_hd__diode_2
X_6725_ net208 net290 vssd1 vssd1 vccd1 vccd1 _1924_ sky130_fd_sc_hd__nand2_1
XPHY_EDGE_ROW_12_Left_105 vssd1 vssd1 vccd1 vccd1 sky130_fd_sc_hd__decap_3
X_6656_ _1848_ _1850_ vssd1 vssd1 vccd1 vccd1 _1851_ sky130_fd_sc_hd__nor2_1
X_5607_ net314 net302 net210 net220 vssd1 vssd1 vccd1 vccd1 _0797_ sky130_fd_sc_hd__and4_1
XFILLER_11_24 vssd1 vssd1 vccd1 vccd1 sky130_fd_sc_hd__fill_1
XANTENNA__4689__A net135 vssd1 vssd1 vccd1 vccd1 sky130_fd_sc_hd__diode_2
X_6587_ _1774_ _1775_ vssd1 vssd1 vccd1 vccd1 _1776_ sky130_fd_sc_hd__xnor2_1
X_8326_ _3593_ _3602_ vssd1 vssd1 vccd1 vccd1 _3603_ sky130_fd_sc_hd__xnor2_1
XANTENNA_fanout203_X net203 vssd1 vssd1 vccd1 vccd1 sky130_fd_sc_hd__diode_2
X_5538_ _0721_ _0727_ vssd1 vssd1 vccd1 vccd1 _0728_ sky130_fd_sc_hd__nor2_1
X_8257_ _3456_ _3528_ vssd1 vssd1 vccd1 vccd1 _3529_ sky130_fd_sc_hd__nand2b_1
XFILLER_87_28 vssd1 vssd1 vccd1 vccd1 sky130_fd_sc_hd__fill_4
X_5469_ _0645_ _0647_ _0657_ _0658_ vssd1 vssd1 vccd1 vccd1 _0659_ sky130_fd_sc_hd__o22a_1
X_7208_ _2433_ _2434_ vssd1 vssd1 vccd1 vccd1 _2435_ sky130_fd_sc_hd__nor2_1
XANTENNA__4201__B net175 vssd1 vssd1 vccd1 vccd1 sky130_fd_sc_hd__diode_2
Xfanout310 net311 vssd1 vssd1 vccd1 vccd1 net310 sky130_fd_sc_hd__buf_2
Xfanout332 net334 vssd1 vssd1 vccd1 vccd1 net332 sky130_fd_sc_hd__clkbuf_4
XFILLER_59_500 vssd1 vssd1 vccd1 vccd1 sky130_fd_sc_hd__fill_4
Xfanout321 PID_INST.k2_calc.reg_lc\[1\] vssd1 vssd1 vccd1 vccd1 net321 sky130_fd_sc_hd__buf_2
X_8188_ _3414_ _3453_ vssd1 vssd1 vccd1 vccd1 _3454_ sky130_fd_sc_hd__nand2b_1
X_7139_ _2269_ _2271_ _2268_ vssd1 vssd1 vccd1 vccd1 _2362_ sky130_fd_sc_hd__o21ba_1
XFILLER_59_533 vssd1 vssd1 vccd1 vccd1 sky130_fd_sc_hd__fill_1
XANTENNA_input8_X net8 vssd1 vssd1 vccd1 vccd1 sky130_fd_sc_hd__diode_2
XPHY_EDGE_ROW_21_Left_114 vssd1 vssd1 vccd1 vccd1 sky130_fd_sc_hd__decap_3
XFILLER_46_205 vssd1 vssd1 vccd1 vccd1 sky130_fd_sc_hd__fill_2
XFILLER_61_208 vssd1 vssd1 vccd1 vccd1 sky130_fd_sc_hd__fill_4
XTAP_TAPCELL_ROW_57_767 vssd1 vccd1 sky130_fd_sc_hd__tapvpwrvgnd_1
XFILLER_27_430 vssd1 vssd1 vccd1 vccd1 sky130_fd_sc_hd__fill_1
XFILLER_42_411 vssd1 vssd1 vccd1 vccd1 sky130_fd_sc_hd__fill_1
XFILLER_52_42 vssd1 vssd1 vccd1 vccd1 sky130_fd_sc_hd__fill_4
XFILLER_14_157 vssd1 vssd1 vccd1 vccd1 sky130_fd_sc_hd__fill_2
XPHY_EDGE_ROW_30_Left_123 vssd1 vssd1 vccd1 vccd1 sky130_fd_sc_hd__decap_3
XTAP_TAPCELL_ROW_40_601 vssd1 vccd1 sky130_fd_sc_hd__tapvpwrvgnd_1
XFILLER_42_477 vssd1 vssd1 vccd1 vccd1 sky130_fd_sc_hd__fill_8
XTAP_TAPCELL_ROW_12_325 vssd1 vccd1 sky130_fd_sc_hd__tapvpwrvgnd_1
Xinput18 gpio_in[8] vssd1 vssd1 vccd1 vccd1 net18 sky130_fd_sc_hd__clkbuf_4
XFILLER_10_363 vssd1 vssd1 vccd1 vccd1 sky130_fd_sc_hd__fill_1
XFILLER_77_330 vssd1 vssd1 vccd1 vccd1 sky130_fd_sc_hd__fill_4
XFILLER_65_503 vssd1 vssd1 vccd1 vccd1 sky130_fd_sc_hd__fill_1
XANTENNA__6038__B net314 vssd1 vssd1 vccd1 vccd1 sky130_fd_sc_hd__diode_2
XFILLER_37_216 vssd1 vssd1 vccd1 vccd1 sky130_fd_sc_hd__fill_8
XFILLER_65_569 vssd1 vssd1 vccd1 vccd1 sky130_fd_sc_hd__fill_1
XFILLER_18_430 vssd1 vssd1 vccd1 vccd1 sky130_fd_sc_hd__fill_1
XFILLER_92_377 vccd1 vssd1 vccd1 vssd1 sky130_ef_sc_hd__decap_40_12
XFILLER_33_411 vccd1 vssd1 vccd1 vssd1 sky130_ef_sc_hd__decap_40_12
XTAP_TAPCELL_ROW_82_1025 vssd1 vccd1 sky130_fd_sc_hd__tapvpwrvgnd_1
X_4840_ net78 _4117_ vssd1 vssd1 vccd1 vccd1 _4118_ sky130_fd_sc_hd__nand2_1
XTAP_TAPCELL_ROW_28_480 vssd1 vccd1 sky130_fd_sc_hd__tapvpwrvgnd_1
XFILLER_60_274 vssd1 vssd1 vccd1 vccd1 sky130_fd_sc_hd__fill_1
XFILLER_33_466 vssd1 vssd1 vccd1 vccd1 sky130_fd_sc_hd__fill_4
X_6510_ _1331_ _1526_ _1530_ vssd1 vssd1 vccd1 vccd1 _1697_ sky130_fd_sc_hd__o21ba_1
X_4771_ net126 net125 net81 net79 vssd1 vssd1 vccd1 vccd1 _4049_ sky130_fd_sc_hd__and4_1
X_7490_ _2639_ _2641_ vssd1 vssd1 vccd1 vccd1 _2734_ sky130_fd_sc_hd__nor2_1
XFILLER_9_150 vccd1 vssd1 vccd1 vssd1 sky130_ef_sc_hd__decap_40_12
X_6441_ _1421_ _1628_ vssd1 vssd1 vccd1 vccd1 _1629_ sky130_fd_sc_hd__nand2_1
X_6372_ _2051_ _0157_ _1161_ vssd1 vssd1 vccd1 vccd1 _1560_ sky130_fd_sc_hd__or3b_1
X_8111_ _3368_ _3369_ vssd1 vssd1 vccd1 vccd1 _3371_ sky130_fd_sc_hd__xnor2_1
X_5323_ _0436_ _0440_ _0511_ vssd1 vssd1 vccd1 vccd1 _0513_ sky130_fd_sc_hd__and3_1
X_8042_ _1882_ net37 _3294_ vssd1 vssd1 vccd1 vccd1 _3296_ sky130_fd_sc_hd__o21a_1
X_5254_ _0433_ _0442_ vssd1 vssd1 vccd1 vccd1 _0444_ sky130_fd_sc_hd__xnor2_1
X_5185_ net133 net82 net78 PID_INST.k3_calc.d1.y\[8\] vssd1 vssd1 vccd1 vccd1 _0375_
+ sky130_fd_sc_hd__a22o_1
X_4205_ net15 net173 _2199_ vssd1 vssd1 vccd1 vccd1 _2210_ sky130_fd_sc_hd__o21ai_4
XANTENNA_fanout198_A net200 vssd1 vssd1 vccd1 vccd1 sky130_fd_sc_hd__diode_2
XFILLER_68_352 vssd1 vssd1 vccd1 vccd1 sky130_fd_sc_hd__fill_2
XANTENNA__5133__A net111 vssd1 vssd1 vccd1 vccd1 sky130_fd_sc_hd__diode_2
XFILLER_83_333 vssd1 vssd1 vccd1 vccd1 sky130_fd_sc_hd__fill_2
XFILLER_28_227 vssd1 vssd1 vccd1 vccd1 sky130_fd_sc_hd__fill_1
XFILLER_83_355 vssd1 vssd1 vccd1 vccd1 sky130_fd_sc_hd__fill_8
XFILLER_56_569 vssd1 vssd1 vccd1 vccd1 sky130_fd_sc_hd__fill_1
XTAP_TAPCELL_ROW_54_737 vssd1 vccd1 sky130_fd_sc_hd__tapvpwrvgnd_1
X_7826_ _3081_ _3075_ vssd1 vssd1 vccd1 vccd1 _3082_ sky130_fd_sc_hd__and2b_1
XFILLER_51_252 vssd1 vssd1 vccd1 vccd1 sky130_fd_sc_hd__fill_4
X_7757_ _3011_ _3012_ vssd1 vssd1 vccd1 vccd1 _3013_ sky130_fd_sc_hd__xor2_1
X_4969_ net147 _0083_ _0085_ vssd1 vssd1 vccd1 vccd1 _0159_ sky130_fd_sc_hd__or3_1
X_7688_ _2685_ _2709_ vssd1 vssd1 vccd1 vccd1 _2943_ sky130_fd_sc_hd__nor2_1
X_6708_ _1811_ _1813_ _1810_ vssd1 vssd1 vccd1 vccd1 _1905_ sky130_fd_sc_hd__o21ba_1
X_6639_ _1830_ _1831_ vssd1 vssd1 vccd1 vccd1 _1832_ sky130_fd_sc_hd__nor2_1
XANTENNA__4212__A net119 vssd1 vssd1 vccd1 vccd1 sky130_fd_sc_hd__diode_2
X_8309_ net197 net256 net252 net201 vssd1 vssd1 vccd1 vccd1 _3584_ sky130_fd_sc_hd__a22o_1
XANTENNA__7523__A net98 vssd1 vssd1 vccd1 vccd1 sky130_fd_sc_hd__diode_2
XFILLER_78_149 vccd1 vssd1 vccd1 vssd1 sky130_ef_sc_hd__decap_40_12
Xfanout140 _1882_ vssd1 vssd1 vccd1 vccd1 net140 sky130_fd_sc_hd__clkbuf_4
XFILLER_59_352 vssd1 vssd1 vccd1 vccd1 sky130_fd_sc_hd__fill_4
Xfanout162 PID_INST.k3_calc.d1.y\[15\] vssd1 vssd1 vccd1 vccd1 net162 sky130_fd_sc_hd__buf_2
Xfanout173 net174 vssd1 vssd1 vccd1 vccd1 net173 sky130_fd_sc_hd__clkbuf_8
Xfanout151 _3780_ vssd1 vssd1 vccd1 vccd1 net151 sky130_fd_sc_hd__buf_2
XFILLER_86_160 vssd1 vssd1 vccd1 vccd1 sky130_fd_sc_hd__fill_1
Xfanout195 net196 vssd1 vssd1 vccd1 vccd1 net195 sky130_fd_sc_hd__clkbuf_4
Xfanout184 PID_INST.k2_calc.sum_reg\[19\] vssd1 vssd1 vccd1 vccd1 net184 sky130_fd_sc_hd__clkbuf_2
XFILLER_59_396 vssd1 vssd1 vccd1 vccd1 sky130_fd_sc_hd__fill_1
XFILLER_59_385 vssd1 vssd1 vccd1 vccd1 sky130_fd_sc_hd__fill_1
XFILLER_47_42 vssd1 vssd1 vccd1 vccd1 sky130_fd_sc_hd__fill_2
XFILLER_86_193 vssd1 vssd1 vccd1 vccd1 sky130_fd_sc_hd__fill_2
XFILLER_74_344 vccd1 vssd1 vccd1 vssd1 sky130_ef_sc_hd__decap_40_12
XANTENNA__4882__A net139 vssd1 vssd1 vccd1 vccd1 sky130_fd_sc_hd__diode_2
XFILLER_62_539 vssd1 vssd1 vccd1 vccd1 sky130_fd_sc_hd__fill_1
XFILLER_62_528 vssd1 vssd1 vccd1 vccd1 sky130_fd_sc_hd__fill_1
XTAP_TAPCELL_ROW_25_450 vssd1 vccd1 sky130_fd_sc_hd__tapvpwrvgnd_1
XFILLER_8_69 vssd1 vssd1 vccd1 vccd1 sky130_fd_sc_hd__fill_2
XFILLER_6_153 vssd1 vssd1 vccd1 vccd1 sky130_fd_sc_hd__fill_1
XFILLER_6_131 vssd1 vssd1 vccd1 vccd1 sky130_fd_sc_hd__fill_8
XFILLER_6_197 vccd1 vssd1 vccd1 vssd1 sky130_ef_sc_hd__decap_40_12
XFILLER_2_381 vssd1 vssd1 vccd1 vccd1 sky130_fd_sc_hd__fill_2
XFILLER_92_141 vccd1 vssd1 vccd1 vssd1 sky130_ef_sc_hd__decap_40_12
XFILLER_77_193 vssd1 vssd1 vccd1 vccd1 sky130_fd_sc_hd__fill_1
XFILLER_65_344 vssd1 vssd1 vccd1 vccd1 sky130_fd_sc_hd__fill_1
XFILLER_65_333 vssd1 vssd1 vccd1 vccd1 sky130_fd_sc_hd__fill_2
Xclkbuf_4_1_0_clk clknet_0_clk vssd1 vssd1 vccd1 vccd1 clknet_4_1_0_clk sky130_fd_sc_hd__clkbuf_8
X_6990_ _2195_ _2204_ vssd1 vssd1 vccd1 vccd1 _2205_ sky130_fd_sc_hd__xnor2_1
XFILLER_80_325 vssd1 vssd1 vccd1 vccd1 sky130_fd_sc_hd__fill_1
X_5941_ _1128_ _1130_ vssd1 vssd1 vccd1 vccd1 _1131_ sky130_fd_sc_hd__xnor2_2
XANTENNA__8414__D net120 vssd1 vssd1 vccd1 vccd1 sky130_fd_sc_hd__diode_2
X_5872_ net241 net316 net299 net251 vssd1 vssd1 vccd1 vccd1 _1062_ sky130_fd_sc_hd__a22oi_1
XTAP_TAPCELL_ROW_51_707 vssd1 vccd1 sky130_fd_sc_hd__tapvpwrvgnd_1
X_4823_ _4099_ _4100_ vssd1 vssd1 vccd1 vccd1 _4101_ sky130_fd_sc_hd__nand2b_2
X_7611_ _2861_ _2862_ vssd1 vssd1 vccd1 vccd1 _2863_ sky130_fd_sc_hd__xor2_1
X_4754_ _4030_ _4031_ vssd1 vssd1 vccd1 vccd1 _4032_ sky130_fd_sc_hd__nor2_1
X_7542_ _2787_ _2788_ vssd1 vssd1 vccd1 vccd1 _2789_ sky130_fd_sc_hd__xor2_1
X_7473_ _2611_ _2615_ _2715_ vssd1 vssd1 vccd1 vccd1 _2716_ sky130_fd_sc_hd__a21oi_1
X_4685_ _3882_ _3883_ _3961_ vssd1 vssd1 vccd1 vccd1 _3963_ sky130_fd_sc_hd__a21oi_1
X_6424_ net246 net258 net254 net250 vssd1 vssd1 vccd1 vccd1 _1612_ sky130_fd_sc_hd__a22oi_1
X_6355_ _1541_ _1542_ vssd1 vssd1 vccd1 vccd1 _1543_ sky130_fd_sc_hd__nand2_1
XFILLER_88_414 vssd1 vssd1 vccd1 vccd1 sky130_fd_sc_hd__fill_2
X_6286_ _1473_ _1474_ vssd1 vssd1 vccd1 vccd1 _1475_ sky130_fd_sc_hd__or2_1
X_5306_ PID_INST.k3_calc.d1.y\[12\] net83 vssd1 vssd1 vccd1 vccd1 _0496_ sky130_fd_sc_hd__and2_1
XANTENNA__8158__B net37 vssd1 vssd1 vccd1 vccd1 sky130_fd_sc_hd__diode_2
X_5237_ _0278_ _0425_ _0376_ vssd1 vssd1 vccd1 vccd1 _0427_ sky130_fd_sc_hd__o21ba_1
X_8025_ _3277_ _3278_ vssd1 vssd1 vccd1 vccd1 _3279_ sky130_fd_sc_hd__or2_1
XFILLER_88_469 vssd1 vssd1 vccd1 vccd1 sky130_fd_sc_hd__fill_4
XANTENNA__4296__A1 net15 vssd1 vssd1 vccd1 vccd1 sky130_fd_sc_hd__diode_2
XFILLER_84_29 vccd1 vssd1 vccd1 vssd1 sky130_ef_sc_hd__decap_40_12
X_5168_ _0258_ _0356_ vssd1 vssd1 vccd1 vccd1 _0358_ sky130_fd_sc_hd__xor2_1
XFILLER_68_193 vssd1 vssd1 vccd1 vccd1 sky130_fd_sc_hd__fill_2
X_5099_ _0286_ _0287_ _0257_ vssd1 vssd1 vccd1 vccd1 _0289_ sky130_fd_sc_hd__o21ai_1
XFILLER_29_569 vssd1 vssd1 vccd1 vccd1 sky130_fd_sc_hd__fill_1
XFILLER_83_174 vssd1 vssd1 vccd1 vccd1 sky130_fd_sc_hd__fill_2
XFILLER_71_314 vssd1 vssd1 vccd1 vccd1 sky130_fd_sc_hd__fill_1
XTAP_TAPCELL_ROW_67_873 vssd1 vccd1 sky130_fd_sc_hd__tapvpwrvgnd_1
XFILLER_56_388 vssd1 vssd1 vccd1 vccd1 sky130_fd_sc_hd__fill_1
XTAP_TAPCELL_ROW_39_586 vssd1 vccd1 sky130_fd_sc_hd__tapvpwrvgnd_1
XANTENNA__5310__B _3774_ vssd1 vssd1 vccd1 vccd1 sky130_fd_sc_hd__diode_2
XFILLER_17_78 vssd1 vssd1 vccd1 vccd1 sky130_fd_sc_hd__fill_2
X_7809_ net95 net46 vssd1 vssd1 vccd1 vccd1 _3065_ sky130_fd_sc_hd__nor2_1
XTAP_TAPCELL_ROW_22_420 vssd1 vccd1 sky130_fd_sc_hd__tapvpwrvgnd_1
XFILLER_33_99 vccd1 vssd1 vccd1 vssd1 sky130_ef_sc_hd__decap_40_12
XANTENNA__5038__A net116 vssd1 vssd1 vccd1 vccd1 sky130_fd_sc_hd__diode_2
XFILLER_79_425 vccd1 vssd1 vccd1 vssd1 sky130_ef_sc_hd__decap_40_12
XFILLER_3_167 vssd1 vssd1 vccd1 vccd1 sky130_fd_sc_hd__fill_1
XFILLER_79_447 vssd1 vssd1 vccd1 vccd1 sky130_fd_sc_hd__fill_1
XANTENNA__6276__A2 net306 vssd1 vssd1 vccd1 vccd1 sky130_fd_sc_hd__diode_2
XANTENNA__4596__B net81 vssd1 vssd1 vccd1 vccd1 sky130_fd_sc_hd__diode_2
XFILLER_66_108 vssd1 vssd1 vccd1 vccd1 sky130_fd_sc_hd__fill_1
Xhold7 PID_INST.k1_calc.d1.x\[11\] vssd1 vssd1 vccd1 vccd1 net400 sky130_fd_sc_hd__dlygate4sd3_1
XFILLER_47_300 vssd1 vssd1 vccd1 vccd1 sky130_fd_sc_hd__fill_1
XANTENNA__8417__RESET_B net328 vssd1 vssd1 vccd1 vccd1 sky130_fd_sc_hd__diode_2
XFILLER_47_355 vssd1 vssd1 vccd1 vccd1 sky130_fd_sc_hd__fill_1
XFILLER_47_333 vssd1 vssd1 vccd1 vccd1 sky130_fd_sc_hd__fill_2
XFILLER_74_51 vssd1 vssd1 vccd1 vccd1 sky130_fd_sc_hd__fill_4
XFILLER_74_73 vssd1 vssd1 vccd1 vccd1 sky130_fd_sc_hd__fill_2
XANTENNA__6316__B net53 vssd1 vssd1 vccd1 vccd1 sky130_fd_sc_hd__diode_2
XANTENNA__5220__B net87 vssd1 vssd1 vccd1 vccd1 sky130_fd_sc_hd__diode_2
XFILLER_43_550 vssd1 vssd1 vccd1 vccd1 sky130_fd_sc_hd__fill_2
XFILLER_30_222 vssd1 vssd1 vccd1 vccd1 sky130_fd_sc_hd__fill_1
XFILLER_30_233 vssd1 vssd1 vccd1 vccd1 sky130_fd_sc_hd__fill_2
XFILLER_90_83 vssd1 vssd1 vccd1 vccd1 sky130_fd_sc_hd__fill_1
XFILLER_30_266 vssd1 vssd1 vccd1 vccd1 sky130_fd_sc_hd__fill_2
XANTENNA__4211__A1 net18 vssd1 vssd1 vccd1 vccd1 sky130_fd_sc_hd__diode_2
XFILLER_11_480 vssd1 vssd1 vccd1 vccd1 sky130_fd_sc_hd__fill_2
X_4470_ _3715_ _3718_ _3727_ _3746_ _3714_ vssd1 vssd1 vccd1 vccd1 _3748_ sky130_fd_sc_hd__a311o_1
XTAP_TAPCELL_ROW_90_1102 vssd1 vccd1 sky130_fd_sc_hd__tapvpwrvgnd_1
X_6140_ _0227_ _1117_ _1119_ vssd1 vssd1 vccd1 vccd1 _1329_ sky130_fd_sc_hd__a21bo_1
X_6071_ _0779_ _0788_ _1260_ vssd1 vssd1 vccd1 vccd1 _1261_ sky130_fd_sc_hd__a21o_1
X_5022_ _0170_ _0211_ vssd1 vssd1 vccd1 vccd1 _0212_ sky130_fd_sc_hd__nand2_1
XFILLER_65_152 vssd1 vssd1 vccd1 vccd1 sky130_fd_sc_hd__fill_1
XANTENNA__6226__B net195 vssd1 vssd1 vccd1 vccd1 sky130_fd_sc_hd__diode_2
XTAP_TAPCELL_ROW_64_843 vssd1 vccd1 sky130_fd_sc_hd__tapvpwrvgnd_1
XANTENNA__5130__B net58 vssd1 vssd1 vccd1 vccd1 sky130_fd_sc_hd__diode_2
X_6973_ _2065_ _2185_ vssd1 vssd1 vccd1 vccd1 _2187_ sky130_fd_sc_hd__xor2_1
XFILLER_38_399 vssd1 vssd1 vccd1 vccd1 sky130_fd_sc_hd__fill_8
XFILLER_80_166 vssd1 vssd1 vccd1 vccd1 sky130_fd_sc_hd__fill_1
XFILLER_0_81 vssd1 vssd1 vccd1 vccd1 sky130_fd_sc_hd__fill_2
X_5924_ _4092_ _4158_ _4091_ vssd1 vssd1 vccd1 vccd1 _1114_ sky130_fd_sc_hd__a21bo_1
XTAP_TAPCELL_ROW_36_556 vssd1 vccd1 sky130_fd_sc_hd__tapvpwrvgnd_1
XFILLER_80_188 vssd1 vssd1 vccd1 vccd1 sky130_fd_sc_hd__fill_8
X_5855_ _1039_ _1044_ vssd1 vssd1 vccd1 vccd1 _1045_ sky130_fd_sc_hd__or2_1
XFILLER_21_200 vssd1 vssd1 vccd1 vccd1 sky130_fd_sc_hd__fill_4
XANTENNA__6242__A net292 vssd1 vssd1 vccd1 vccd1 sky130_fd_sc_hd__diode_2
XFILLER_61_391 vssd1 vssd1 vccd1 vccd1 sky130_fd_sc_hd__fill_1
XANTENNA_fanout230_A PID_INST.k2_calc.sum_reg\[5\] vssd1 vssd1 vccd1 vccd1 sky130_fd_sc_hd__diode_2
X_4806_ _4010_ _4012_ _4082_ _4083_ vssd1 vssd1 vccd1 vccd1 _4084_ sky130_fd_sc_hd__a211oi_2
X_5786_ _0950_ _0960_ _0959_ vssd1 vssd1 vccd1 vccd1 _0976_ sky130_fd_sc_hd__o21ai_1
XANTENNA__4202__A1 net16 vssd1 vssd1 vccd1 vccd1 sky130_fd_sc_hd__diode_2
XANTENNA_fanout328_A net339 vssd1 vssd1 vccd1 vccd1 sky130_fd_sc_hd__diode_2
X_4737_ _4013_ _4014_ vssd1 vssd1 vccd1 vccd1 _4015_ sky130_fd_sc_hd__nor2_1
XFILLER_21_299 vssd1 vssd1 vccd1 vccd1 sky130_fd_sc_hd__fill_4
X_7525_ _2514_ _2769_ vssd1 vssd1 vccd1 vccd1 _2772_ sky130_fd_sc_hd__xnor2_1
X_7456_ _2695_ _2697_ vssd1 vssd1 vccd1 vccd1 _2698_ sky130_fd_sc_hd__xnor2_1
X_4668_ PID_INST.k3_calc.d1.y\[1\] net151 net145 _3943_ vssd1 vssd1 vccd1 vccd1 _3946_
+ sky130_fd_sc_hd__a31o_1
XANTENNA_fanout116_X net116 vssd1 vssd1 vccd1 vccd1 sky130_fd_sc_hd__diode_2
X_6407_ _1524_ _1593_ vssd1 vssd1 vccd1 vccd1 _1595_ sky130_fd_sc_hd__xnor2_1
X_7387_ _2623_ _2624_ vssd1 vssd1 vccd1 vccd1 _2625_ sky130_fd_sc_hd__nor2_1
X_4599_ _3869_ _3876_ _3855_ _3860_ vssd1 vssd1 vccd1 vccd1 _3877_ sky130_fd_sc_hd__a211o_1
X_6338_ net162 net83 vssd1 vssd1 vccd1 vccd1 _1526_ sky130_fd_sc_hd__nand2_1
XFILLER_76_406 vssd1 vssd1 vccd1 vccd1 sky130_fd_sc_hd__fill_8
X_6269_ _1253_ _1255_ _1457_ vssd1 vssd1 vccd1 vccd1 _1458_ sky130_fd_sc_hd__o21ai_1
X_8008_ _2969_ _3114_ vssd1 vssd1 vccd1 vccd1 _3263_ sky130_fd_sc_hd__and2_1
XFILLER_56_141 vssd1 vssd1 vccd1 vccd1 sky130_fd_sc_hd__fill_4
XFILLER_44_314 vccd1 vssd1 vccd1 vssd1 sky130_ef_sc_hd__decap_40_12
XFILLER_29_388 vssd1 vssd1 vccd1 vccd1 sky130_fd_sc_hd__fill_2
XFILLER_71_133 vssd1 vssd1 vccd1 vccd1 sky130_fd_sc_hd__fill_4
XFILLER_71_111 vssd1 vssd1 vccd1 vccd1 sky130_fd_sc_hd__fill_1
XANTENNA__8405__Q PID_INST.k2_calc.reg_lc\[9\] vssd1 vssd1 vccd1 vccd1 sky130_fd_sc_hd__diode_2
XANTENNA__4208__Y _2242_ vssd1 vssd1 vccd1 vccd1 sky130_fd_sc_hd__diode_2
XFILLER_71_166 vssd1 vssd1 vccd1 vccd1 sky130_fd_sc_hd__fill_2
XFILLER_44_369 vssd1 vssd1 vccd1 vccd1 sky130_fd_sc_hd__fill_2
XFILLER_71_177 vssd1 vssd1 vccd1 vccd1 sky130_fd_sc_hd__fill_2
XANTENNA__6152__A net138 vssd1 vssd1 vccd1 vccd1 sky130_fd_sc_hd__diode_2
XANTENNA__7248__A _2399_ vssd1 vssd1 vccd1 vccd1 sky130_fd_sc_hd__diode_2
XANTENNA__8070__C net256 vssd1 vssd1 vccd1 vccd1 sky130_fd_sc_hd__diode_2
XFILLER_60_53 vssd1 vssd1 vccd1 vccd1 sky130_fd_sc_hd__fill_1
XFILLER_5_15 vssd1 vssd1 vccd1 vccd1 sky130_fd_sc_hd__fill_2
XFILLER_4_465 vssd1 vssd1 vccd1 vccd1 sky130_fd_sc_hd__fill_1
XFILLER_79_222 vssd1 vssd1 vccd1 vccd1 sky130_fd_sc_hd__fill_2
XFILLER_67_417 vssd1 vssd1 vccd1 vccd1 sky130_fd_sc_hd__fill_2
XANTENNA__5457__B1 net103 vssd1 vssd1 vccd1 vccd1 sky130_fd_sc_hd__diode_2
XTAP_TAPCELL_ROW_7_270 vssd1 vccd1 sky130_fd_sc_hd__tapvpwrvgnd_1
XFILLER_39_108 vssd1 vssd1 vccd1 vccd1 sky130_fd_sc_hd__fill_1
XTAP_TAPCELL_ROW_78_979 vssd1 vccd1 sky130_fd_sc_hd__tapvpwrvgnd_1
XFILLER_10_7 vssd1 vssd1 vccd1 vccd1 sky130_fd_sc_hd__fill_2
XPHY_EDGE_ROW_13_Right_13 vssd1 vssd1 vccd1 vccd1 sky130_fd_sc_hd__decap_3
XTAP_TAPCELL_ROW_61_813 vssd1 vccd1 sky130_fd_sc_hd__tapvpwrvgnd_1
XFILLER_50_328 vssd1 vssd1 vccd1 vccd1 sky130_fd_sc_hd__fill_8
XTAP_TAPCELL_ROW_33_526 vssd1 vccd1 sky130_fd_sc_hd__tapvpwrvgnd_1
XANTENNA__4281__S net157 vssd1 vssd1 vccd1 vccd1 sky130_fd_sc_hd__diode_2
X_5640_ net319 net215 vssd1 vssd1 vccd1 vccd1 _0830_ sky130_fd_sc_hd__nand2_1
X_5571_ _0744_ _0758_ _0760_ vssd1 vssd1 vccd1 vccd1 _0761_ sky130_fd_sc_hd__o21ba_1
XPHY_EDGE_ROW_22_Right_22 vssd1 vssd1 vccd1 vccd1 sky130_fd_sc_hd__decap_3
X_8290_ _3506_ _3507_ _3509_ vssd1 vssd1 vccd1 vccd1 _3563_ sky130_fd_sc_hd__a21o_1
X_4522_ net127 net86 net85 net125 vssd1 vssd1 vccd1 vccd1 _3800_ sky130_fd_sc_hd__a22o_1
X_7310_ _2542_ _2529_ vssd1 vssd1 vccd1 vccd1 _2543_ sky130_fd_sc_hd__nand2b_1
X_7241_ _2467_ _2468_ vssd1 vssd1 vccd1 vccd1 _2470_ sky130_fd_sc_hd__xor2_1
X_4453_ _3729_ _3730_ _3716_ vssd1 vssd1 vccd1 vccd1 _3731_ sky130_fd_sc_hd__o21ai_4
X_7172_ _2395_ _2396_ vssd1 vssd1 vccd1 vccd1 _2397_ sky130_fd_sc_hd__nor2_1
X_4384_ _3676_ _3677_ vssd1 vssd1 vccd1 vccd1 _3678_ sky130_fd_sc_hd__xnor2_1
XANTENNA__8276__X _3549_ vssd1 vssd1 vccd1 vccd1 sky130_fd_sc_hd__diode_2
X_6123_ _1311_ _1310_ vssd1 vssd1 vccd1 vccd1 _1312_ sky130_fd_sc_hd__and2b_1
X_6054_ net261 _1243_ _1242_ vssd1 vssd1 vccd1 vccd1 _1244_ sky130_fd_sc_hd__a21bo_1
XFILLER_58_439 vssd1 vssd1 vccd1 vccd1 sky130_fd_sc_hd__fill_2
XPHY_EDGE_ROW_31_Right_31 vssd1 vssd1 vccd1 vccd1 sky130_fd_sc_hd__decap_3
X_5005_ _0193_ _0194_ vssd1 vssd1 vccd1 vccd1 _0195_ sky130_fd_sc_hd__nand2_1
XANTENNA_fanout278_A net280 vssd1 vssd1 vccd1 vccd1 sky130_fd_sc_hd__diode_2
XFILLER_81_420 vssd1 vssd1 vccd1 vccd1 sky130_fd_sc_hd__fill_8
XTAP_TAPCELL_ROW_49_692 vssd1 vccd1 sky130_fd_sc_hd__tapvpwrvgnd_1
X_6956_ _2166_ _2168_ vssd1 vssd1 vccd1 vccd1 _2169_ sky130_fd_sc_hd__nor2_1
X_5907_ _0928_ _0972_ vssd1 vssd1 vccd1 vccd1 _1097_ sky130_fd_sc_hd__nand2_1
XANTENNA__4974__A2 net70 vssd1 vssd1 vccd1 vccd1 sky130_fd_sc_hd__diode_2
XANTENNA__8171__B net44 vssd1 vssd1 vccd1 vccd1 sky130_fd_sc_hd__diode_2
X_6887_ _2093_ _2094_ vssd1 vssd1 vccd1 vccd1 _2096_ sky130_fd_sc_hd__xor2_1
XANTENNA__8165__A2 net42 vssd1 vssd1 vccd1 vccd1 sky130_fd_sc_hd__diode_2
XFILLER_34_391 vssd1 vssd1 vccd1 vccd1 sky130_fd_sc_hd__fill_1
X_5838_ _1000_ _1027_ vssd1 vssd1 vccd1 vccd1 _1028_ sky130_fd_sc_hd__or2_1
XFILLER_14_68 vssd1 vssd1 vccd1 vccd1 sky130_fd_sc_hd__fill_1
XPHY_EDGE_ROW_40_Right_40 vssd1 vssd1 vccd1 vccd1 sky130_fd_sc_hd__decap_3
X_5769_ _0957_ _0958_ vssd1 vssd1 vccd1 vccd1 _0959_ sky130_fd_sc_hd__or2_1
XANTENNA__4204__B net175 vssd1 vssd1 vccd1 vccd1 sky130_fd_sc_hd__diode_2
XFILLER_5_218 vssd1 vssd1 vccd1 vccd1 sky130_fd_sc_hd__fill_4
X_7508_ _2750_ _2751_ vssd1 vssd1 vccd1 vccd1 _2753_ sky130_fd_sc_hd__and2_1
XPHY_EDGE_ROW_86_Left_179 vssd1 vssd1 vccd1 vccd1 sky130_fd_sc_hd__decap_3
X_8488_ clknet_4_15_0_clk PID_INST.pid.next_state\[1\] net336 vssd1 vssd1 vccd1 vccd1
+ PID_INST.pid.curr_state\[1\] sky130_fd_sc_hd__dfrtp_1
X_7439_ _2670_ _2679_ vssd1 vssd1 vccd1 vccd1 _2680_ sky130_fd_sc_hd__nand2b_1
XFILLER_89_531 vssd1 vssd1 vccd1 vccd1 sky130_fd_sc_hd__fill_2
XANTENNA__4220__A net115 vssd1 vssd1 vccd1 vccd1 sky130_fd_sc_hd__diode_2
XFILLER_39_43 vccd1 vssd1 vccd1 vssd1 sky130_ef_sc_hd__decap_40_12
XTAP_TAPCELL_ROW_4_240 vssd1 vccd1 sky130_fd_sc_hd__tapvpwrvgnd_1
XANTENNA__8346__B net42 vssd1 vssd1 vccd1 vccd1 sky130_fd_sc_hd__diode_2
XFILLER_91_217 vssd1 vssd1 vccd1 vccd1 sky130_fd_sc_hd__fill_1
XFILLER_29_152 vssd1 vssd1 vccd1 vccd1 sky130_fd_sc_hd__fill_4
XTAP_TAPCELL_ROW_75_949 vssd1 vccd1 sky130_fd_sc_hd__tapvpwrvgnd_1
XFILLER_55_53 vssd1 vssd1 vccd1 vccd1 sky130_fd_sc_hd__fill_1
XFILLER_17_325 vssd1 vssd1 vccd1 vccd1 sky130_fd_sc_hd__fill_1
XFILLER_72_453 vssd1 vssd1 vccd1 vccd1 sky130_fd_sc_hd__fill_2
XFILLER_72_475 vssd1 vssd1 vccd1 vccd1 sky130_fd_sc_hd__fill_1
XFILLER_13_553 vssd1 vssd1 vccd1 vccd1 sky130_fd_sc_hd__fill_1
XFILLER_9_568 vssd1 vssd1 vccd1 vccd1 sky130_fd_sc_hd__fill_2
XTAP_TAPCELL_ROW_10_297 vssd1 vccd1 sky130_fd_sc_hd__tapvpwrvgnd_1
XANTENNA__6057__A net232 vssd1 vssd1 vccd1 vccd1 sky130_fd_sc_hd__diode_2
X_6810_ _1700_ _1701_ _1698_ vssd1 vssd1 vccd1 vccd1 _2014_ sky130_fd_sc_hd__o21a_1
X_7790_ _3045_ _3044_ vssd1 vssd1 vccd1 vccd1 _3046_ sky130_fd_sc_hd__and2b_1
XFILLER_90_261 vssd1 vssd1 vccd1 vccd1 sky130_fd_sc_hd__fill_2
XTAP_TAPCELL_ROW_46_662 vssd1 vccd1 sky130_fd_sc_hd__tapvpwrvgnd_1
XFILLER_23_339 vssd1 vssd1 vccd1 vccd1 sky130_fd_sc_hd__fill_2
X_6741_ net307 net196 vssd1 vssd1 vccd1 vccd1 _1940_ sky130_fd_sc_hd__nand2_1
XANTENNA__6504__B net78 vssd1 vssd1 vccd1 vccd1 sky130_fd_sc_hd__diode_2
X_6672_ _1847_ _1866_ vssd1 vssd1 vccd1 vccd1 _1868_ sky130_fd_sc_hd__xnor2_1
XFILLER_50_169 vssd1 vssd1 vccd1 vccd1 sky130_fd_sc_hd__fill_1
XANTENNA_clkbuf_0_clk_X clknet_0_clk vssd1 vssd1 vccd1 vccd1 sky130_fd_sc_hd__diode_2
X_5623_ _0811_ _0812_ vssd1 vssd1 vccd1 vccd1 _0813_ sky130_fd_sc_hd__nand2_1
X_8411_ clknet_4_7_0_clk _0031_ net333 vssd1 vssd1 vccd1 vccd1 PID_INST.k2_calc.reg_lc\[15\]
+ sky130_fd_sc_hd__dfrtp_1
X_8342_ _3293_ _3419_ _3422_ vssd1 vssd1 vccd1 vccd1 _3620_ sky130_fd_sc_hd__a21bo_1
X_5554_ _0741_ _0742_ _0743_ vssd1 vssd1 vccd1 vccd1 _0744_ sky130_fd_sc_hd__or3_1
X_8273_ _3540_ _3543_ _3539_ vssd1 vssd1 vccd1 vccd1 _3545_ sky130_fd_sc_hd__a21oi_1
X_5485_ net107 net60 _0663_ _0666_ vssd1 vssd1 vccd1 vccd1 _0675_ sky130_fd_sc_hd__o31a_1
X_4505_ net133 net153 net150 net132 vssd1 vssd1 vccd1 vccd1 _3783_ sky130_fd_sc_hd__a22o_1
X_7224_ net140 net45 vssd1 vssd1 vccd1 vccd1 _2452_ sky130_fd_sc_hd__nor2_1
X_4436_ PID_INST.k1_calc.d1.x\[4\] PID_INST.k3_calc.prev_error\[4\] vssd1 vssd1 vccd1
+ vccd1 _3714_ sky130_fd_sc_hd__and2_1
X_7155_ _2278_ _2281_ _2376_ vssd1 vssd1 vccd1 vccd1 _2379_ sky130_fd_sc_hd__and3_1
X_4367_ net209 net5 vssd1 vssd1 vccd1 vccd1 _3663_ sky130_fd_sc_hd__nand2_1
XANTENNA_clkbuf_4_9_0_clk_X clknet_4_9_0_clk vssd1 vssd1 vccd1 vccd1 sky130_fd_sc_hd__diode_2
XFILLER_86_523 vssd1 vssd1 vccd1 vccd1 sky130_fd_sc_hd__fill_1
X_6106_ net101 net63 vssd1 vssd1 vccd1 vccd1 _1295_ sky130_fd_sc_hd__nor2_1
X_7086_ _1981_ _1984_ _2306_ vssd1 vssd1 vccd1 vccd1 _2307_ sky130_fd_sc_hd__a21oi_1
XFILLER_58_247 vssd1 vssd1 vccd1 vccd1 sky130_fd_sc_hd__fill_1
X_4298_ net294 net17 net171 vssd1 vssd1 vccd1 vccd1 _0021_ sky130_fd_sc_hd__mux2_1
XANTENNA_fanout183_X net183 vssd1 vssd1 vccd1 vccd1 sky130_fd_sc_hd__diode_2
X_6037_ _1226_ vssd1 vssd1 vccd1 vccd1 _1227_ sky130_fd_sc_hd__inv_2
XFILLER_39_461 vccd1 vssd1 vccd1 vssd1 sky130_ef_sc_hd__decap_40_12
XTAP_TAPCELL_ROW_1_210 vssd1 vccd1 sky130_fd_sc_hd__tapvpwrvgnd_1
XFILLER_39_483 vccd1 vssd1 vccd1 vssd1 sky130_ef_sc_hd__decap_40_12
XFILLER_92_29 vccd1 vssd1 vccd1 vssd1 sky130_ef_sc_hd__decap_40_12
XTAP_TAPCELL_ROW_72_919 vssd1 vccd1 sky130_fd_sc_hd__tapvpwrvgnd_1
X_7988_ net286 net188 vssd1 vssd1 vccd1 vccd1 _3243_ sky130_fd_sc_hd__nand2_1
XFILLER_81_261 vssd1 vssd1 vccd1 vccd1 sky130_fd_sc_hd__fill_1
XFILLER_54_475 vssd1 vssd1 vccd1 vccd1 sky130_fd_sc_hd__fill_1
XFILLER_81_294 vssd1 vssd1 vccd1 vccd1 sky130_fd_sc_hd__fill_4
X_6939_ PID_INST.k3_calc.d2.y\[2\] _1740_ _1741_ vssd1 vssd1 vccd1 vccd1 _2151_ sky130_fd_sc_hd__and3_1
XFILLER_41_136 vssd1 vssd1 vccd1 vccd1 sky130_fd_sc_hd__fill_1
XTAP_TAPCELL_ROW_80_996 vssd1 vccd1 sky130_fd_sc_hd__tapvpwrvgnd_1
XANTENNA__7346__B1 net186 vssd1 vssd1 vccd1 vccd1 sky130_fd_sc_hd__diode_2
XFILLER_41_169 vssd1 vssd1 vccd1 vccd1 sky130_fd_sc_hd__fill_4
XANTENNA__7897__A1 net117 vssd1 vssd1 vccd1 vccd1 sky130_fd_sc_hd__diode_2
XFILLER_6_516 vssd1 vssd1 vccd1 vccd1 sky130_fd_sc_hd__fill_2
XFILLER_10_545 vccd1 vssd1 vccd1 vssd1 sky130_ef_sc_hd__decap_40_12
XANTENNA__7526__A net140 vssd1 vssd1 vccd1 vccd1 sky130_fd_sc_hd__diode_2
XFILLER_1_232 vssd1 vssd1 vccd1 vccd1 sky130_fd_sc_hd__fill_2
Xteam_03_351 vssd1 vssd1 vccd1 vccd1 team_03_351/HI gpio_oeb[27] sky130_fd_sc_hd__conb_1
XFILLER_49_225 vssd1 vssd1 vccd1 vccd1 sky130_fd_sc_hd__fill_8
XFILLER_2_27 vssd1 vssd1 vccd1 vccd1 sky130_fd_sc_hd__fill_1
Xteam_03_362 vssd1 vssd1 vccd1 vccd1 team_03_362/HI gpio_out[4] sky130_fd_sc_hd__conb_1
Xteam_03_373 vssd1 vssd1 vccd1 vccd1 team_03_373/HI gpio_out[15] sky130_fd_sc_hd__conb_1
Xteam_03_384 vssd1 vssd1 vccd1 vccd1 gpio_oeb[8] team_03_384/LO sky130_fd_sc_hd__conb_1
XFILLER_66_85 vssd1 vssd1 vccd1 vccd1 sky130_fd_sc_hd__fill_2
XFILLER_17_177 vssd1 vssd1 vccd1 vccd1 sky130_fd_sc_hd__fill_4
XFILLER_60_434 vssd1 vssd1 vccd1 vccd1 sky130_fd_sc_hd__fill_8
XANTENNA__6324__B net50 vssd1 vssd1 vccd1 vccd1 sky130_fd_sc_hd__diode_2
XFILLER_32_125 vssd1 vssd1 vccd1 vccd1 sky130_fd_sc_hd__fill_4
XTAP_TAPCELL_ROW_43_632 vssd1 vccd1 sky130_fd_sc_hd__tapvpwrvgnd_1
XFILLER_13_361 vccd1 vssd1 vccd1 vssd1 sky130_ef_sc_hd__decap_40_12
XFILLER_20_309 vssd1 vssd1 vccd1 vccd1 sky130_fd_sc_hd__fill_4
XFILLER_9_354 vssd1 vssd1 vccd1 vccd1 sky130_fd_sc_hd__fill_4
X_5270_ net121 net68 vssd1 vssd1 vccd1 vccd1 _0460_ sky130_fd_sc_hd__nand2_1
X_4221_ PID_INST.k3_calc.kd_term\[1\] net175 vssd1 vssd1 vccd1 vccd1 _2378_ sky130_fd_sc_hd__or2_1
XANTENNA__8417__D net127 vssd1 vssd1 vccd1 vccd1 sky130_fd_sc_hd__diode_2
XANTENNA_hold14_A PID_INST.k1_calc.d1.x\[0\] vssd1 vssd1 vccd1 vccd1 sky130_fd_sc_hd__diode_2
XFILLER_55_217 vssd1 vssd1 vccd1 vccd1 sky130_fd_sc_hd__fill_1
X_7911_ _3091_ _3097_ _3099_ vssd1 vssd1 vccd1 vccd1 _3166_ sky130_fd_sc_hd__o21a_1
XFILLER_83_559 vssd1 vssd1 vccd1 vccd1 sky130_fd_sc_hd__fill_1
XFILLER_70_209 vssd1 vssd1 vccd1 vccd1 sky130_fd_sc_hd__fill_2
X_7842_ _3090_ _3097_ vssd1 vssd1 vccd1 vccd1 _3098_ sky130_fd_sc_hd__xor2_1
XFILLER_36_475 vssd1 vssd1 vccd1 vccd1 sky130_fd_sc_hd__fill_1
X_7773_ _3006_ _3007_ _3027_ vssd1 vssd1 vccd1 vccd1 _3029_ sky130_fd_sc_hd__o21a_1
XFILLER_51_434 vccd1 vssd1 vccd1 vssd1 sky130_ef_sc_hd__decap_40_12
X_4985_ net127 net75 _0105_ vssd1 vssd1 vccd1 vccd1 _0175_ sky130_fd_sc_hd__a21oi_1
XFILLER_23_147 vssd1 vssd1 vccd1 vccd1 sky130_fd_sc_hd__fill_1
XANTENNA__7049__C net285 vssd1 vssd1 vccd1 vccd1 sky130_fd_sc_hd__diode_2
X_6724_ _1920_ _1921_ vssd1 vssd1 vccd1 vccd1 _1922_ sky130_fd_sc_hd__nor2_1
X_6655_ net227 net239 net274 net261 vssd1 vssd1 vccd1 vccd1 _1850_ sky130_fd_sc_hd__and4_1
XANTENNA_fanout310_A net311 vssd1 vssd1 vccd1 vccd1 sky130_fd_sc_hd__diode_2
X_5606_ net291 net227 vssd1 vssd1 vccd1 vccd1 _0796_ sky130_fd_sc_hd__nand2_1
X_6586_ net139 net52 vssd1 vssd1 vccd1 vccd1 _1775_ sky130_fd_sc_hd__nor2_1
X_8325_ _3599_ _3600_ vssd1 vssd1 vccd1 vccd1 _3602_ sky130_fd_sc_hd__xnor2_1
X_5537_ _0722_ _0724_ _0726_ vssd1 vssd1 vccd1 vccd1 _0727_ sky130_fd_sc_hd__a21oi_1
X_8256_ _3525_ _3527_ vssd1 vssd1 vccd1 vccd1 _3528_ sky130_fd_sc_hd__xor2_1
XFILLER_87_18 vssd1 vssd1 vccd1 vccd1 sky130_fd_sc_hd__fill_1
XFILLER_78_309 vccd1 vssd1 vccd1 vssd1 sky130_ef_sc_hd__decap_40_12
X_5468_ _0654_ _0655_ vssd1 vssd1 vccd1 vccd1 _0658_ sky130_fd_sc_hd__xnor2_1
X_7207_ _2169_ _2175_ _2166_ vssd1 vssd1 vccd1 vccd1 _2434_ sky130_fd_sc_hd__a21oi_1
Xfanout311 net316 vssd1 vssd1 vccd1 vccd1 net311 sky130_fd_sc_hd__buf_2
Xfanout300 net304 vssd1 vssd1 vccd1 vccd1 net300 sky130_fd_sc_hd__buf_2
X_4419_ net180 _3702_ vssd1 vssd1 vccd1 vccd1 _0053_ sky130_fd_sc_hd__xnor2_1
Xfanout322 PID_INST.k2_calc.reg_lc\[0\] vssd1 vssd1 vccd1 vccd1 net322 sky130_fd_sc_hd__buf_2
X_8187_ _3451_ _3452_ vssd1 vssd1 vccd1 vccd1 _3453_ sky130_fd_sc_hd__xor2_1
X_5399_ net115 net60 _0585_ _0588_ vssd1 vssd1 vccd1 vccd1 _0589_ sky130_fd_sc_hd__o31ai_2
X_7138_ _2359_ _2360_ vssd1 vssd1 vccd1 vccd1 _2361_ sky130_fd_sc_hd__xnor2_1
Xfanout333 net334 vssd1 vssd1 vccd1 vccd1 net333 sky130_fd_sc_hd__clkbuf_4
XFILLER_59_523 vssd1 vssd1 vccd1 vccd1 sky130_fd_sc_hd__fill_1
X_7069_ _1952_ _1956_ _2288_ vssd1 vssd1 vccd1 vccd1 _2289_ sky130_fd_sc_hd__a21oi_1
XFILLER_19_409 vssd1 vssd1 vccd1 vccd1 sky130_fd_sc_hd__fill_2
XTAP_TAPCELL_ROW_57_768 vssd1 vccd1 sky130_fd_sc_hd__tapvpwrvgnd_1
XFILLER_36_77 vssd1 vssd1 vccd1 vccd1 sky130_fd_sc_hd__fill_4
XFILLER_42_401 vssd1 vssd1 vccd1 vccd1 sky130_fd_sc_hd__fill_1
XANTENNA__8062__D net194 vssd1 vssd1 vccd1 vccd1 sky130_fd_sc_hd__diode_2
XTAP_TAPCELL_ROW_40_602 vssd1 vccd1 sky130_fd_sc_hd__tapvpwrvgnd_1
Xinput19 gpio_in[9] vssd1 vssd1 vccd1 vccd1 net19 sky130_fd_sc_hd__clkbuf_4
XFILLER_6_346 vssd1 vssd1 vccd1 vccd1 sky130_fd_sc_hd__fill_1
XANTENNA__6058__B1 net278 vssd1 vssd1 vccd1 vccd1 sky130_fd_sc_hd__diode_2
XFILLER_92_312 vccd1 vssd1 vccd1 vssd1 sky130_ef_sc_hd__decap_40_12
XFILLER_92_301 vssd1 vssd1 vccd1 vccd1 sky130_fd_sc_hd__fill_4
XFILLER_37_239 vssd1 vssd1 vccd1 vccd1 sky130_fd_sc_hd__fill_1
XFILLER_18_453 vssd1 vssd1 vccd1 vccd1 sky130_fd_sc_hd__fill_1
XFILLER_92_389 vssd1 vssd1 vccd1 vccd1 sky130_fd_sc_hd__fill_2
XFILLER_18_475 vssd1 vssd1 vccd1 vccd1 sky130_fd_sc_hd__fill_1
XFILLER_45_294 vssd1 vssd1 vccd1 vccd1 sky130_fd_sc_hd__fill_4
XFILLER_45_283 vssd1 vssd1 vccd1 vccd1 sky130_fd_sc_hd__fill_4
XTAP_TAPCELL_ROW_28_481 vssd1 vccd1 sky130_fd_sc_hd__tapvpwrvgnd_1
XFILLER_33_423 vccd1 vssd1 vccd1 vssd1 sky130_ef_sc_hd__decap_40_12
XFILLER_60_264 vssd1 vssd1 vccd1 vccd1 sky130_fd_sc_hd__fill_2
XFILLER_33_456 vssd1 vssd1 vccd1 vccd1 sky130_fd_sc_hd__fill_2
X_4770_ net126 net81 vssd1 vssd1 vccd1 vccd1 _4048_ sky130_fd_sc_hd__nand2_1
XFILLER_20_139 vssd1 vssd1 vccd1 vccd1 sky130_fd_sc_hd__fill_1
X_6440_ _1626_ _1627_ vssd1 vssd1 vccd1 vccd1 _1628_ sky130_fd_sc_hd__nor2_1
XFILLER_9_162 vssd1 vssd1 vccd1 vccd1 sky130_fd_sc_hd__fill_2
X_6371_ _2051_ _0088_ vssd1 vssd1 vccd1 vccd1 _1559_ sky130_fd_sc_hd__nor2_1
X_8110_ _3369_ _3368_ vssd1 vssd1 vccd1 vccd1 _3370_ sky130_fd_sc_hd__nand2b_1
X_5322_ _0436_ _0440_ _0511_ vssd1 vssd1 vccd1 vccd1 _0512_ sky130_fd_sc_hd__a21oi_1
XFILLER_5_390 vssd1 vssd1 vccd1 vccd1 sky130_fd_sc_hd__fill_2
X_8041_ _1882_ net37 _3294_ vssd1 vssd1 vccd1 vccd1 _3295_ sky130_fd_sc_hd__nor3_1
X_5253_ _0442_ _0433_ vssd1 vssd1 vccd1 vccd1 _0443_ sky130_fd_sc_hd__nand2b_1
X_5184_ _0267_ _0270_ _0268_ vssd1 vssd1 vccd1 vccd1 _0374_ sky130_fd_sc_hd__o21ba_1
X_4204_ PID_INST.k3_calc.kd_term\[3\] net175 vssd1 vssd1 vccd1 vccd1 _2199_ sky130_fd_sc_hd__or2_1
XFILLER_56_504 vccd1 vssd1 vccd1 vssd1 sky130_ef_sc_hd__decap_40_12
XFILLER_71_507 vssd1 vssd1 vccd1 vccd1 sky130_fd_sc_hd__fill_1
XFILLER_83_389 vssd1 vssd1 vccd1 vccd1 sky130_fd_sc_hd__fill_2
XANTENNA_fanout260_A PID_INST.k2_calc.reg_lc\[13\] vssd1 vssd1 vccd1 vccd1 sky130_fd_sc_hd__diode_2
XFILLER_24_401 vssd1 vssd1 vccd1 vccd1 sky130_fd_sc_hd__fill_8
XTAP_TAPCELL_ROW_54_738 vssd1 vccd1 sky130_fd_sc_hd__tapvpwrvgnd_1
X_7825_ _2855_ _3079_ vssd1 vssd1 vccd1 vccd1 _3081_ sky130_fd_sc_hd__xor2_1
X_7756_ net305 net182 vssd1 vssd1 vccd1 vccd1 _3012_ sky130_fd_sc_hd__nand2_1
XANTENNA__5575__A2 net287 vssd1 vssd1 vccd1 vccd1 sky130_fd_sc_hd__diode_2
X_4968_ net142 _0156_ vssd1 vssd1 vccd1 vccd1 _0158_ sky130_fd_sc_hd__nand2_1
XFILLER_24_489 vssd1 vssd1 vccd1 vccd1 sky130_fd_sc_hd__fill_4
X_7687_ _2917_ _2918_ _2940_ vssd1 vssd1 vccd1 vccd1 _2942_ sky130_fd_sc_hd__o21a_1
X_6707_ _1902_ _1903_ vssd1 vssd1 vccd1 vccd1 _1904_ sky130_fd_sc_hd__xnor2_1
X_4899_ _1817_ _0088_ vssd1 vssd1 vccd1 vccd1 _0089_ sky130_fd_sc_hd__nor2_1
X_6638_ net204 net303 net195 net315 vssd1 vssd1 vccd1 vccd1 _1831_ sky130_fd_sc_hd__a22oi_1
X_8308_ net322 PID_INST.k2_calc.sum_reg\[27\] vssd1 vssd1 vccd1 vccd1 _3583_ sky130_fd_sc_hd__nand2_1
X_6569_ net93 net66 vssd1 vssd1 vccd1 vccd1 _1756_ sky130_fd_sc_hd__nor2_1
X_8239_ _3500_ _3508_ vssd1 vssd1 vccd1 vccd1 _3509_ sky130_fd_sc_hd__and2_1
XANTENNA__7523__B net44 vssd1 vssd1 vccd1 vccd1 sky130_fd_sc_hd__diode_2
XFILLER_78_139 vssd1 vssd1 vccd1 vccd1 sky130_fd_sc_hd__fill_1
Xfanout130 net131 vssd1 vssd1 vccd1 vccd1 net130 sky130_fd_sc_hd__buf_2
XFILLER_59_342 vssd1 vssd1 vccd1 vccd1 sky130_fd_sc_hd__fill_4
Xfanout163 PID_INST.k3_calc.d1.y\[14\] vssd1 vssd1 vccd1 vccd1 net163 sky130_fd_sc_hd__buf_2
Xfanout174 _1795_ vssd1 vssd1 vccd1 vccd1 net174 sky130_fd_sc_hd__buf_4
Xfanout152 net153 vssd1 vssd1 vccd1 vccd1 net152 sky130_fd_sc_hd__buf_2
Xfanout141 net142 vssd1 vssd1 vccd1 vccd1 net141 sky130_fd_sc_hd__buf_2
XFILLER_74_301 vssd1 vssd1 vccd1 vccd1 sky130_fd_sc_hd__fill_2
Xfanout185 net186 vssd1 vssd1 vccd1 vccd1 net185 sky130_fd_sc_hd__buf_2
Xfanout196 PID_INST.k2_calc.sum_reg\[14\] vssd1 vssd1 vccd1 vccd1 net196 sky130_fd_sc_hd__clkbuf_4
XFILLER_19_217 vssd1 vssd1 vccd1 vccd1 sky130_fd_sc_hd__fill_4
XFILLER_19_228 vccd1 vssd1 vccd1 vssd1 sky130_ef_sc_hd__decap_40_12
XFILLER_74_356 vssd1 vssd1 vccd1 vccd1 sky130_fd_sc_hd__fill_1
XFILLER_47_559 vssd1 vssd1 vccd1 vccd1 sky130_fd_sc_hd__fill_1
XFILLER_74_367 vssd1 vssd1 vccd1 vccd1 sky130_fd_sc_hd__fill_2
XFILLER_34_209 vssd1 vssd1 vccd1 vccd1 sky130_fd_sc_hd__fill_2
XFILLER_15_423 vssd1 vssd1 vccd1 vccd1 sky130_fd_sc_hd__fill_2
XFILLER_15_445 vssd1 vssd1 vccd1 vccd1 sky130_fd_sc_hd__fill_2
XFILLER_27_294 vssd1 vssd1 vccd1 vccd1 sky130_fd_sc_hd__fill_1
XPHY_EDGE_ROW_69_Right_69 vssd1 vssd1 vccd1 vccd1 sky130_fd_sc_hd__decap_3
XTAP_TAPCELL_ROW_25_451 vssd1 vccd1 sky130_fd_sc_hd__tapvpwrvgnd_1
XFILLER_30_437 vssd1 vssd1 vccd1 vccd1 sky130_fd_sc_hd__fill_2
XPHY_EDGE_ROW_78_Right_78 vssd1 vssd1 vccd1 vccd1 sky130_fd_sc_hd__decap_3
XFILLER_88_61 vssd1 vssd1 vccd1 vccd1 sky130_fd_sc_hd__fill_1
XANTENNA__4829__A1 net121 vssd1 vssd1 vccd1 vccd1 sky130_fd_sc_hd__diode_2
XFILLER_88_94 vssd1 vssd1 vccd1 vccd1 sky130_fd_sc_hd__fill_4
XFILLER_69_139 vccd1 vssd1 vccd1 vssd1 sky130_ef_sc_hd__decap_40_12
XFILLER_2_393 vssd1 vssd1 vccd1 vccd1 sky130_fd_sc_hd__fill_8
XFILLER_77_161 vssd1 vssd1 vccd1 vccd1 sky130_fd_sc_hd__fill_1
XFILLER_92_120 vccd1 vssd1 vccd1 vssd1 sky130_ef_sc_hd__decap_40_12
XFILLER_92_153 vccd1 vssd1 vccd1 vssd1 sky130_ef_sc_hd__decap_40_12
XFILLER_80_315 vssd1 vssd1 vccd1 vccd1 sky130_fd_sc_hd__fill_1
XFILLER_65_378 vssd1 vssd1 vccd1 vccd1 sky130_fd_sc_hd__fill_1
XANTENNA__4284__S net157 vssd1 vssd1 vccd1 vccd1 sky130_fd_sc_hd__diode_2
X_5940_ _0483_ _0485_ _1129_ vssd1 vssd1 vccd1 vccd1 _1130_ sky130_fd_sc_hd__o21ba_1
XFILLER_92_197 vccd1 vssd1 vccd1 vssd1 sky130_ef_sc_hd__decap_40_12
XPHY_EDGE_ROW_87_Right_87 vssd1 vssd1 vccd1 vccd1 sky130_fd_sc_hd__decap_3
X_5871_ _1033_ _1058_ _1060_ vssd1 vssd1 vccd1 vccd1 _1061_ sky130_fd_sc_hd__and3_1
XFILLER_61_551 vssd1 vssd1 vccd1 vccd1 sky130_fd_sc_hd__fill_4
XFILLER_61_540 vssd1 vssd1 vccd1 vccd1 sky130_fd_sc_hd__fill_1
XTAP_TAPCELL_ROW_51_708 vssd1 vccd1 sky130_fd_sc_hd__tapvpwrvgnd_1
X_7610_ net115 net38 _2787_ _2786_ vssd1 vssd1 vccd1 vccd1 _2862_ sky130_fd_sc_hd__o31a_1
X_4822_ _3995_ _3996_ _4032_ _4097_ _4098_ vssd1 vssd1 vccd1 vccd1 _4100_ sky130_fd_sc_hd__a311o_1
XFILLER_21_415 vccd1 vssd1 vccd1 vssd1 sky130_ef_sc_hd__decap_40_12
X_4753_ PID_INST.k1_calc.d1.x\[11\] PID_INST.k3_calc.prev_error\[11\] vssd1 vssd1
+ vccd1 vccd1 _4031_ sky130_fd_sc_hd__and2_1
X_7541_ PID_INST.k3_calc.d2.y\[4\] _2034_ _2035_ vssd1 vssd1 vccd1 vccd1 _2788_ sky130_fd_sc_hd__and3_1
X_7472_ _2596_ _2599_ _2597_ vssd1 vssd1 vccd1 vccd1 _2715_ sky130_fd_sc_hd__o21ba_1
XANTENNA__4313__A net251 vssd1 vssd1 vccd1 vccd1 sky130_fd_sc_hd__diode_2
XANTENNA__8417__CLK clknet_4_0_0_clk vssd1 vssd1 vccd1 vccd1 sky130_fd_sc_hd__diode_2
X_6423_ _1608_ _1609_ vssd1 vssd1 vccd1 vccd1 _1611_ sky130_fd_sc_hd__xnor2_1
X_4684_ _3882_ _3883_ _3961_ vssd1 vssd1 vccd1 vccd1 _3962_ sky130_fd_sc_hd__and3_1
X_6354_ _1534_ _1540_ vssd1 vssd1 vccd1 vccd1 _1542_ sky130_fd_sc_hd__nand2_1
X_6285_ _1471_ _1472_ _1267_ _1274_ vssd1 vssd1 vccd1 vccd1 _1474_ sky130_fd_sc_hd__a211oi_1
X_5305_ _0492_ _0493_ vssd1 vssd1 vccd1 vccd1 _0495_ sky130_fd_sc_hd__xnor2_1
XFILLER_88_448 vssd1 vssd1 vccd1 vccd1 sky130_fd_sc_hd__fill_2
XFILLER_88_426 vssd1 vssd1 vccd1 vccd1 sky130_fd_sc_hd__fill_1
X_8024_ _3130_ _3136_ _3128_ vssd1 vssd1 vccd1 vccd1 _3278_ sky130_fd_sc_hd__a21oi_1
X_5236_ _0278_ _0376_ vssd1 vssd1 vccd1 vccd1 _0426_ sky130_fd_sc_hd__nor2_1
XANTENNA__5144__A _2242_ vssd1 vssd1 vccd1 vccd1 sky130_fd_sc_hd__diode_2
XFILLER_75_109 vssd1 vssd1 vccd1 vccd1 sky130_fd_sc_hd__fill_2
X_5167_ _0258_ _0356_ vssd1 vssd1 vccd1 vccd1 _0357_ sky130_fd_sc_hd__nor2_1
XFILLER_83_120 vssd1 vssd1 vccd1 vccd1 sky130_fd_sc_hd__fill_1
XFILLER_56_356 vssd1 vssd1 vccd1 vccd1 sky130_fd_sc_hd__fill_4
X_5098_ _0257_ _0286_ _0287_ vssd1 vssd1 vccd1 vccd1 _0288_ sky130_fd_sc_hd__or3_1
XTAP_TAPCELL_ROW_67_874 vssd1 vccd1 sky130_fd_sc_hd__tapvpwrvgnd_1
XTAP_TAPCELL_ROW_39_587 vssd1 vccd1 sky130_fd_sc_hd__tapvpwrvgnd_1
XFILLER_24_253 vssd1 vssd1 vccd1 vccd1 sky130_fd_sc_hd__fill_1
XANTENNA__4207__B net175 vssd1 vssd1 vccd1 vccd1 sky130_fd_sc_hd__diode_2
XFILLER_12_415 vssd1 vssd1 vccd1 vccd1 sky130_fd_sc_hd__fill_2
X_7808_ _3061_ _3062_ vssd1 vssd1 vccd1 vccd1 _3064_ sky130_fd_sc_hd__xnor2_1
X_7739_ net298 net183 PID_INST.k2_calc.sum_reg\[21\] net310 vssd1 vssd1 vccd1 vccd1
+ _2995_ sky130_fd_sc_hd__a22oi_1
XFILLER_8_419 vssd1 vssd1 vccd1 vccd1 sky130_fd_sc_hd__fill_1
XTAP_TAPCELL_ROW_22_421 vssd1 vccd1 sky130_fd_sc_hd__tapvpwrvgnd_1
XFILLER_33_45 vssd1 vssd1 vccd1 vccd1 sky130_fd_sc_hd__fill_2
XANTENNA__4223__A net147 vssd1 vssd1 vccd1 vccd1 sky130_fd_sc_hd__diode_2
XFILLER_79_437 vssd1 vssd1 vccd1 vccd1 sky130_fd_sc_hd__fill_4
Xhold8 PID_INST.k1_calc.d1.x\[9\] vssd1 vssd1 vccd1 vccd1 net401 sky130_fd_sc_hd__dlygate4sd3_1
XFILLER_58_75 vssd1 vssd1 vccd1 vccd1 sky130_fd_sc_hd__fill_1
XFILLER_74_85 vssd1 vssd1 vccd1 vccd1 sky130_fd_sc_hd__fill_2
XFILLER_15_275 vssd1 vssd1 vccd1 vccd1 sky130_fd_sc_hd__fill_4
XFILLER_30_212 vssd1 vssd1 vccd1 vccd1 sky130_fd_sc_hd__fill_8
XTAP_TAPCELL_ROW_90_1103 vssd1 vccd1 sky130_fd_sc_hd__tapvpwrvgnd_1
XANTENNA__4279__S net157 vssd1 vssd1 vccd1 vccd1 sky130_fd_sc_hd__diode_2
X_6070_ _1258_ _1259_ vssd1 vssd1 vccd1 vccd1 _1260_ sky130_fd_sc_hd__nand2_1
XFILLER_85_418 vssd1 vssd1 vccd1 vccd1 sky130_fd_sc_hd__fill_2
X_5021_ _0209_ _0210_ vssd1 vssd1 vccd1 vccd1 _0211_ sky130_fd_sc_hd__xor2_1
XANTENNA__6424__B1 net254 vssd1 vssd1 vccd1 vccd1 sky130_fd_sc_hd__diode_2
XFILLER_26_529 vssd1 vssd1 vccd1 vccd1 sky130_fd_sc_hd__fill_2
XTAP_TAPCELL_ROW_88_1076 vssd1 vccd1 sky130_fd_sc_hd__tapvpwrvgnd_1
XTAP_TAPCELL_ROW_64_844 vssd1 vccd1 sky130_fd_sc_hd__tapvpwrvgnd_1
X_6972_ _2065_ _2185_ vssd1 vssd1 vccd1 vccd1 _2186_ sky130_fd_sc_hd__nor2_1
X_5923_ _1106_ _1111_ vssd1 vssd1 vccd1 vccd1 _1113_ sky130_fd_sc_hd__xor2_1
XTAP_TAPCELL_ROW_36_557 vssd1 vccd1 sky130_fd_sc_hd__tapvpwrvgnd_1
XANTENNA__7924__B1 net201 vssd1 vssd1 vccd1 vccd1 sky130_fd_sc_hd__diode_2
XFILLER_61_381 vssd1 vssd1 vccd1 vccd1 sky130_fd_sc_hd__fill_1
X_5854_ _1041_ _1043_ vssd1 vssd1 vccd1 vccd1 _1044_ sky130_fd_sc_hd__and2_1
X_4805_ _4080_ _4081_ _4027_ vssd1 vssd1 vccd1 vccd1 _4083_ sky130_fd_sc_hd__o21a_1
XANTENNA__6242__B net220 vssd1 vssd1 vccd1 vccd1 sky130_fd_sc_hd__diode_2
X_5785_ _0968_ _0974_ vssd1 vssd1 vccd1 vccd1 _0975_ sky130_fd_sc_hd__or2_1
X_7524_ _2514_ _2769_ vssd1 vssd1 vccd1 vccd1 _2770_ sky130_fd_sc_hd__or2_1
XANTENNA__4202__A2 net174 vssd1 vssd1 vccd1 vccd1 sky130_fd_sc_hd__diode_2
XANTENNA_fanout223_A net225 vssd1 vssd1 vccd1 vccd1 sky130_fd_sc_hd__diode_2
X_4736_ _3856_ _3858_ vssd1 vssd1 vccd1 vccd1 _4014_ sky130_fd_sc_hd__and2_1
XFILLER_21_289 vssd1 vssd1 vccd1 vccd1 sky130_fd_sc_hd__fill_2
X_7455_ net297 net190 vssd1 vssd1 vccd1 vccd1 _2697_ sky130_fd_sc_hd__nand2_1
X_4667_ net141 _3942_ _3943_ net121 vssd1 vssd1 vccd1 vccd1 _3945_ sky130_fd_sc_hd__a22o_1
X_7386_ _2366_ _2369_ _2622_ vssd1 vssd1 vccd1 vccd1 _2624_ sky130_fd_sc_hd__and3_1
XANTENNA_fanout109_X net109 vssd1 vssd1 vccd1 vccd1 sky130_fd_sc_hd__diode_2
X_6406_ _1593_ _1524_ vssd1 vssd1 vccd1 vccd1 _1594_ sky130_fd_sc_hd__nand2b_1
X_4598_ _3870_ _3875_ vssd1 vssd1 vccd1 vccd1 _3876_ sky130_fd_sc_hd__or2_1
X_6337_ _1320_ _1321_ _1318_ vssd1 vssd1 vccd1 vccd1 _1525_ sky130_fd_sc_hd__a21o_1
XFILLER_88_267 vssd1 vssd1 vccd1 vccd1 sky130_fd_sc_hd__fill_1
X_6268_ _1455_ _1456_ vssd1 vssd1 vccd1 vccd1 _1457_ sky130_fd_sc_hd__and2_1
X_8007_ _3260_ _3261_ vssd1 vssd1 vccd1 vccd1 _3262_ sky130_fd_sc_hd__nor2_1
X_5219_ _0356_ _0406_ _0408_ vssd1 vssd1 vccd1 vccd1 _0409_ sky130_fd_sc_hd__o21a_1
X_6199_ _1178_ _1182_ _1387_ vssd1 vssd1 vccd1 vccd1 _1388_ sky130_fd_sc_hd__and3_1
XFILLER_56_153 vssd1 vssd1 vccd1 vccd1 sky130_fd_sc_hd__fill_4
XFILLER_17_518 vssd1 vssd1 vccd1 vccd1 sky130_fd_sc_hd__fill_2
XFILLER_29_367 vssd1 vssd1 vccd1 vccd1 sky130_fd_sc_hd__fill_2
XANTENNA__5218__A1 net163 vssd1 vssd1 vccd1 vccd1 sky130_fd_sc_hd__diode_2
XANTENNA__5218__B2 net162 vssd1 vssd1 vccd1 vccd1 sky130_fd_sc_hd__diode_2
XFILLER_84_484 vccd1 vssd1 vccd1 vssd1 sky130_ef_sc_hd__decap_40_12
XFILLER_44_326 vccd1 vssd1 vccd1 vssd1 sky130_ef_sc_hd__decap_40_12
XFILLER_44_33 vccd1 vssd1 vccd1 vssd1 sky130_ef_sc_hd__decap_40_12
XFILLER_52_381 vssd1 vssd1 vccd1 vccd1 sky130_fd_sc_hd__fill_1
XFILLER_12_234 vssd1 vssd1 vccd1 vccd1 sky130_fd_sc_hd__fill_1
XANTENNA__8070__D net252 vssd1 vssd1 vccd1 vccd1 sky130_fd_sc_hd__diode_2
XANTENNA__5049__A net121 vssd1 vssd1 vccd1 vccd1 sky130_fd_sc_hd__diode_2
Xclkbuf_4_0_0_clk clknet_0_clk vssd1 vssd1 vccd1 vccd1 clknet_4_0_0_clk sky130_fd_sc_hd__clkbuf_8
XFILLER_4_411 vssd1 vssd1 vccd1 vccd1 sky130_fd_sc_hd__fill_4
XFILLER_69_41 vssd1 vssd1 vccd1 vccd1 sky130_fd_sc_hd__fill_1
XANTENNA__4400__B net10 vssd1 vssd1 vccd1 vccd1 sky130_fd_sc_hd__diode_2
XFILLER_67_429 vssd1 vssd1 vccd1 vccd1 sky130_fd_sc_hd__fill_1
XTAP_TAPCELL_ROW_7_271 vssd1 vccd1 sky130_fd_sc_hd__tapvpwrvgnd_1
XANTENNA_clkload1_A clknet_4_1_0_clk vssd1 vssd1 vccd1 vccd1 sky130_fd_sc_hd__diode_2
XFILLER_35_359 vssd1 vssd1 vccd1 vccd1 sky130_fd_sc_hd__fill_8
XTAP_TAPCELL_ROW_61_814 vssd1 vccd1 sky130_fd_sc_hd__tapvpwrvgnd_1
XTAP_TAPCELL_ROW_33_527 vssd1 vccd1 sky130_fd_sc_hd__tapvpwrvgnd_1
XANTENNA__4196__A1 net18 vssd1 vssd1 vccd1 vccd1 sky130_fd_sc_hd__diode_2
X_5570_ _0711_ _0716_ _0759_ vssd1 vssd1 vccd1 vccd1 _0760_ sky130_fd_sc_hd__o21a_1
X_4521_ _3750_ _3798_ vssd1 vssd1 vccd1 vccd1 _3799_ sky130_fd_sc_hd__xnor2_2
X_4452_ _3721_ _3725_ _3728_ vssd1 vssd1 vccd1 vccd1 _3730_ sky130_fd_sc_hd__and3_1
X_7240_ _2467_ _2468_ vssd1 vssd1 vccd1 vccd1 _2469_ sky130_fd_sc_hd__nor2_1
X_7171_ _2303_ _2304_ _2307_ vssd1 vssd1 vccd1 vccd1 _2396_ sky130_fd_sc_hd__a21oi_1
X_4383_ _3668_ _3669_ _3670_ vssd1 vssd1 vccd1 vccd1 _3677_ sky130_fd_sc_hd__o21ba_1
XANTENNA__4310__B net13 vssd1 vssd1 vccd1 vccd1 sky130_fd_sc_hd__diode_2
XANTENNA__7902__A net119 vssd1 vssd1 vccd1 vccd1 sky130_fd_sc_hd__diode_2
XFILLER_58_407 vssd1 vssd1 vccd1 vccd1 sky130_fd_sc_hd__fill_2
X_6122_ _4025_ _1110_ _1112_ vssd1 vssd1 vccd1 vccd1 _1311_ sky130_fd_sc_hd__o21a_1
X_6053_ net249 net239 net273 vssd1 vssd1 vccd1 vccd1 _1243_ sky130_fd_sc_hd__and3_1
XFILLER_58_418 vssd1 vssd1 vccd1 vccd1 sky130_fd_sc_hd__fill_2
X_5004_ _0117_ _0119_ _0116_ vssd1 vssd1 vccd1 vccd1 _0194_ sky130_fd_sc_hd__o21bai_1
XANTENNA__4671__A2 net88 vssd1 vssd1 vccd1 vccd1 sky130_fd_sc_hd__diode_2
XFILLER_38_131 vssd1 vssd1 vccd1 vccd1 sky130_fd_sc_hd__fill_2
XFILLER_53_123 vssd1 vssd1 vccd1 vccd1 sky130_fd_sc_hd__fill_1
XTAP_TAPCELL_ROW_49_693 vssd1 vccd1 sky130_fd_sc_hd__tapvpwrvgnd_1
XANTENNA_fanout173_A net174 vssd1 vssd1 vccd1 vccd1 sky130_fd_sc_hd__diode_2
XFILLER_53_134 vssd1 vssd1 vccd1 vccd1 sky130_fd_sc_hd__fill_1
X_6955_ _2055_ _2057_ _2165_ vssd1 vssd1 vccd1 vccd1 _2168_ sky130_fd_sc_hd__and3_1
XFILLER_26_359 vssd1 vssd1 vccd1 vccd1 sky130_fd_sc_hd__fill_2
X_5906_ _1011_ _1013_ _1095_ vssd1 vssd1 vccd1 vccd1 _1096_ sky130_fd_sc_hd__or3_1
XANTENNA_fanout340_A net341 vssd1 vssd1 vccd1 vccd1 sky130_fd_sc_hd__diode_2
XFILLER_41_318 vssd1 vssd1 vccd1 vccd1 sky130_fd_sc_hd__fill_8
X_6886_ _2093_ _2094_ vssd1 vssd1 vccd1 vccd1 _2095_ sky130_fd_sc_hd__nor2_1
XFILLER_34_381 vssd1 vssd1 vccd1 vccd1 sky130_fd_sc_hd__fill_1
X_5837_ _0991_ _0999_ _0998_ vssd1 vssd1 vccd1 vccd1 _1027_ sky130_fd_sc_hd__o21a_1
X_5768_ _0951_ _0956_ vssd1 vssd1 vccd1 vccd1 _0958_ sky130_fd_sc_hd__nor2_1
XANTENNA_fanout226_X net226 vssd1 vssd1 vccd1 vccd1 sky130_fd_sc_hd__diode_2
XANTENNA__4187__A1 net4 vssd1 vssd1 vccd1 vccd1 sky130_fd_sc_hd__diode_2
X_4719_ _3769_ _3772_ _3826_ _3995_ _3825_ vssd1 vssd1 vccd1 vccd1 _3997_ sky130_fd_sc_hd__o311a_1
X_8487_ clknet_4_12_0_clk PID_INST.pid.next_state\[0\] net336 vssd1 vssd1 vccd1 vccd1
+ PID_INST.pid.curr_state\[0\] sky130_fd_sc_hd__dfrtp_1
XFILLER_5_208 vssd1 vssd1 vccd1 vccd1 sky130_fd_sc_hd__fill_2
X_7507_ _2750_ _2751_ vssd1 vssd1 vccd1 vccd1 _2752_ sky130_fd_sc_hd__nor2_1
X_7438_ _2671_ _2677_ vssd1 vssd1 vccd1 vccd1 _2679_ sky130_fd_sc_hd__xnor2_1
X_5699_ net324 net228 vssd1 vssd1 vccd1 vccd1 _0889_ sky130_fd_sc_hd__and2_1
XANTENNA__4501__A net132 vssd1 vssd1 vccd1 vccd1 sky130_fd_sc_hd__diode_2
XFILLER_30_79 vssd1 vssd1 vccd1 vccd1 sky130_fd_sc_hd__fill_1
XANTENNA__5316__B net77 vssd1 vssd1 vccd1 vccd1 sky130_fd_sc_hd__diode_2
X_7369_ _2604_ _2605_ vssd1 vssd1 vccd1 vccd1 _2606_ sky130_fd_sc_hd__xnor2_1
XANTENNA__4895__C1 _4099_ vssd1 vssd1 vccd1 vccd1 sky130_fd_sc_hd__diode_2
XFILLER_89_565 vssd1 vssd1 vccd1 vccd1 sky130_fd_sc_hd__fill_2
XANTENNA_fanout86_A net87 vssd1 vssd1 vccd1 vccd1 sky130_fd_sc_hd__diode_2
XFILLER_39_55 vssd1 vssd1 vccd1 vccd1 sky130_fd_sc_hd__fill_1
XTAP_TAPCELL_ROW_4_241 vssd1 vccd1 sky130_fd_sc_hd__tapvpwrvgnd_1
XFILLER_72_421 vssd1 vssd1 vccd1 vccd1 sky130_fd_sc_hd__fill_4
XFILLER_57_484 vssd1 vssd1 vccd1 vccd1 sky130_fd_sc_hd__fill_8
XFILLER_29_164 vssd1 vssd1 vccd1 vccd1 sky130_fd_sc_hd__fill_1
XFILLER_32_307 vssd1 vssd1 vccd1 vccd1 sky130_fd_sc_hd__fill_1
XANTENNA__4178__A1 net7 vssd1 vssd1 vccd1 vccd1 sky130_fd_sc_hd__diode_2
XFILLER_9_558 vssd1 vssd1 vccd1 vccd1 sky130_fd_sc_hd__fill_2
XTAP_TAPCELL_ROW_10_298 vssd1 vccd1 sky130_fd_sc_hd__tapvpwrvgnd_1
XANTENNA__8472__RESET_B net340 vssd1 vssd1 vccd1 vccd1 sky130_fd_sc_hd__diode_2
XANTENNA__6338__A net162 vssd1 vssd1 vccd1 vccd1 sky130_fd_sc_hd__diode_2
XFILLER_48_484 vssd1 vssd1 vccd1 vccd1 sky130_fd_sc_hd__fill_4
XTAP_TAPCELL_ROW_85_1046 vssd1 vccd1 sky130_fd_sc_hd__tapvpwrvgnd_1
XFILLER_90_251 vssd1 vssd1 vccd1 vccd1 sky130_fd_sc_hd__fill_1
X_6740_ _1442_ _1937_ _1938_ vssd1 vssd1 vccd1 vccd1 _1939_ sky130_fd_sc_hd__a21oi_1
XFILLER_63_498 vssd1 vssd1 vccd1 vccd1 sky130_fd_sc_hd__fill_1
XFILLER_63_476 vssd1 vssd1 vccd1 vccd1 sky130_fd_sc_hd__fill_1
XTAP_TAPCELL_ROW_46_663 vssd1 vccd1 sky130_fd_sc_hd__tapvpwrvgnd_1
XTAP_TAPCELL_ROW_18_376 vssd1 vccd1 sky130_fd_sc_hd__tapvpwrvgnd_1
XFILLER_35_167 vssd1 vssd1 vccd1 vccd1 sky130_fd_sc_hd__fill_1
X_6671_ _1847_ _1866_ vssd1 vssd1 vccd1 vccd1 _1867_ sky130_fd_sc_hd__or2_1
X_5622_ net269 net323 net249 net207 vssd1 vssd1 vccd1 vccd1 _0812_ sky130_fd_sc_hd__and4_1
X_8410_ clknet_4_6_0_clk _0030_ net337 vssd1 vssd1 vccd1 vccd1 PID_INST.k2_calc.reg_lc\[14\]
+ sky130_fd_sc_hd__dfrtp_1
X_8341_ _3531_ _3534_ vssd1 vssd1 vccd1 vccd1 _3619_ sky130_fd_sc_hd__nor2_1
X_5553_ _0690_ _0693_ vssd1 vssd1 vccd1 vccd1 _0743_ sky130_fd_sc_hd__nor2_1
X_4504_ _3779_ _3781_ vssd1 vssd1 vccd1 vccd1 _3782_ sky130_fd_sc_hd__or2_1
XANTENNA__5417__A net115 vssd1 vssd1 vccd1 vccd1 sky130_fd_sc_hd__diode_2
X_8272_ net422 _3544_ net154 vssd1 vssd1 vccd1 vccd1 _0073_ sky130_fd_sc_hd__mux2_1
X_5484_ _0633_ _0637_ vssd1 vssd1 vccd1 vccd1 _0674_ sky130_fd_sc_hd__xnor2_1
X_4435_ net177 net176 _2823_ vssd1 vssd1 vccd1 vccd1 _3713_ sky130_fd_sc_hd__and3_1
X_7223_ net140 net42 vssd1 vssd1 vccd1 vccd1 _2451_ sky130_fd_sc_hd__nor2_1
X_7154_ _2278_ _2281_ _2376_ vssd1 vssd1 vccd1 vccd1 _2377_ sky130_fd_sc_hd__a21oi_1
X_4366_ net160 _3660_ _3661_ _3662_ vssd1 vssd1 vccd1 vccd1 _0041_ sky130_fd_sc_hd__a31o_1
XFILLER_86_513 vssd1 vssd1 vccd1 vccd1 sky130_fd_sc_hd__fill_2
X_6105_ _1127_ _1196_ _1198_ vssd1 vssd1 vccd1 vccd1 _1294_ sky130_fd_sc_hd__a21bo_1
X_7085_ _2303_ _2304_ vssd1 vssd1 vccd1 vccd1 _2306_ sky130_fd_sc_hd__xnor2_1
XANTENNA_fanout290_A net292 vssd1 vssd1 vccd1 vccd1 sky130_fd_sc_hd__diode_2
X_4297_ net299 net16 net171 vssd1 vssd1 vccd1 vccd1 _0020_ sky130_fd_sc_hd__mux2_1
X_6036_ _1224_ _1225_ vssd1 vssd1 vccd1 vccd1 _1226_ sky130_fd_sc_hd__or2_1
XFILLER_54_421 vccd1 vssd1 vccd1 vssd1 sky130_ef_sc_hd__decap_40_12
XFILLER_54_410 vssd1 vssd1 vccd1 vccd1 sky130_fd_sc_hd__fill_2
XTAP_TAPCELL_ROW_1_211 vssd1 vccd1 sky130_fd_sc_hd__tapvpwrvgnd_1
XANTENNA__4991__A net163 vssd1 vssd1 vccd1 vccd1 sky130_fd_sc_hd__diode_2
XFILLER_39_495 vssd1 vssd1 vccd1 vccd1 sky130_fd_sc_hd__fill_1
X_7987_ _3240_ _3241_ vssd1 vssd1 vccd1 vccd1 _3242_ sky130_fd_sc_hd__nor2_1
XFILLER_54_498 vssd1 vssd1 vccd1 vccd1 sky130_fd_sc_hd__fill_1
XFILLER_14_307 vssd1 vssd1 vccd1 vccd1 sky130_fd_sc_hd__fill_1
XFILLER_25_35 vssd1 vssd1 vccd1 vccd1 sky130_fd_sc_hd__fill_1
XFILLER_25_79 vssd1 vssd1 vccd1 vccd1 sky130_fd_sc_hd__fill_1
X_6938_ PID_INST.k3_calc.d2.y\[3\] _1740_ _1741_ vssd1 vssd1 vccd1 vccd1 _2150_ sky130_fd_sc_hd__and3_1
XANTENNA__7346__B2 net311 vssd1 vssd1 vccd1 vccd1 sky130_fd_sc_hd__diode_2
XANTENNA__7346__A1 net299 vssd1 vssd1 vccd1 vccd1 sky130_fd_sc_hd__diode_2
X_6869_ _2075_ _2076_ vssd1 vssd1 vccd1 vccd1 _2077_ sky130_fd_sc_hd__and2_1
XTAP_TAPCELL_ROW_80_997 vssd1 vccd1 sky130_fd_sc_hd__tapvpwrvgnd_1
XANTENNA__7897__A2 net37 vssd1 vssd1 vccd1 vccd1 sky130_fd_sc_hd__diode_2
XFILLER_10_557 vssd1 vssd1 vccd1 vccd1 sky130_fd_sc_hd__fill_8
XANTENNA__7526__B net40 vssd1 vssd1 vccd1 vccd1 sky130_fd_sc_hd__diode_2
XFILLER_41_67 vssd1 vssd1 vccd1 vccd1 sky130_fd_sc_hd__fill_1
XFILLER_9_3 vssd1 vssd1 vccd1 vccd1 sky130_fd_sc_hd__fill_8
XFILLER_49_204 vccd1 vssd1 vccd1 vssd1 sky130_ef_sc_hd__decap_40_12
XANTENNA_fanout89_X net89 vssd1 vssd1 vccd1 vccd1 sky130_fd_sc_hd__diode_2
XFILLER_77_557 vssd1 vssd1 vccd1 vccd1 sky130_fd_sc_hd__fill_2
XFILLER_49_248 vssd1 vssd1 vccd1 vccd1 sky130_fd_sc_hd__fill_4
XFILLER_92_505 vccd1 vssd1 vccd1 vssd1 sky130_ef_sc_hd__decap_40_12
Xteam_03_374 vssd1 vssd1 vccd1 vccd1 team_03_374/HI gpio_out[16] sky130_fd_sc_hd__conb_1
Xteam_03_352 vssd1 vssd1 vccd1 vccd1 team_03_352/HI gpio_oeb[28] sky130_fd_sc_hd__conb_1
Xteam_03_363 vssd1 vssd1 vccd1 vccd1 team_03_363/HI gpio_out[5] sky130_fd_sc_hd__conb_1
Xteam_03_385 vssd1 vssd1 vccd1 vccd1 gpio_oeb[9] team_03_385/LO sky130_fd_sc_hd__conb_1
XFILLER_66_42 vssd1 vssd1 vccd1 vccd1 sky130_fd_sc_hd__fill_4
XFILLER_92_538 vssd1 vssd1 vccd1 vccd1 sky130_fd_sc_hd__fill_4
XFILLER_66_97 vssd1 vssd1 vccd1 vccd1 sky130_fd_sc_hd__fill_2
XFILLER_57_281 vssd1 vssd1 vccd1 vccd1 sky130_fd_sc_hd__fill_1
XFILLER_17_145 vssd1 vssd1 vccd1 vccd1 sky130_fd_sc_hd__fill_2
XFILLER_45_487 vccd1 vssd1 vccd1 vssd1 sky130_ef_sc_hd__decap_40_12
XFILLER_82_63 vssd1 vssd1 vccd1 vccd1 sky130_fd_sc_hd__fill_2
XFILLER_72_295 vssd1 vssd1 vccd1 vccd1 sky130_fd_sc_hd__fill_4
XANTENNA__4406__A net189 vssd1 vssd1 vccd1 vccd1 sky130_fd_sc_hd__diode_2
XTAP_TAPCELL_ROW_43_633 vssd1 vccd1 sky130_fd_sc_hd__tapvpwrvgnd_1
XFILLER_17_189 vccd1 vssd1 vccd1 vssd1 sky130_ef_sc_hd__decap_40_12
XTAP_TAPCELL_ROW_15_346 vssd1 vccd1 sky130_fd_sc_hd__tapvpwrvgnd_1
XFILLER_32_148 vssd1 vssd1 vccd1 vccd1 sky130_fd_sc_hd__fill_1
XFILLER_32_159 vssd1 vssd1 vccd1 vccd1 sky130_fd_sc_hd__fill_1
XFILLER_13_373 vccd1 vssd1 vccd1 vssd1 sky130_ef_sc_hd__decap_40_12
XFILLER_40_192 vssd1 vssd1 vccd1 vccd1 sky130_fd_sc_hd__fill_4
XFILLER_5_561 vssd1 vssd1 vccd1 vccd1 sky130_fd_sc_hd__fill_4
XANTENNA__7452__A net198 vssd1 vssd1 vccd1 vccd1 sky130_fd_sc_hd__diode_2
X_4220_ net115 vssd1 vssd1 vccd1 vccd1 PID_INST.k3_calc.d2.y\[4\] sky130_fd_sc_hd__inv_2
XFILLER_68_524 vssd1 vssd1 vccd1 vccd1 sky130_fd_sc_hd__fill_4
XFILLER_83_516 vssd1 vssd1 vccd1 vccd1 sky130_fd_sc_hd__fill_1
XFILLER_83_505 vssd1 vssd1 vccd1 vccd1 sky130_fd_sc_hd__fill_4
X_7910_ _3162_ _3163_ vssd1 vssd1 vccd1 vccd1 _3165_ sky130_fd_sc_hd__xnor2_1
X_7841_ _3095_ _3096_ vssd1 vssd1 vccd1 vccd1 _3097_ sky130_fd_sc_hd__xor2_1
X_7772_ _3006_ _3007_ _3027_ vssd1 vssd1 vccd1 vccd1 _3028_ sky130_fd_sc_hd__nor3_1
XFILLER_51_446 vssd1 vssd1 vccd1 vccd1 sky130_fd_sc_hd__fill_2
X_4984_ net127 net75 _0105_ vssd1 vssd1 vccd1 vccd1 _0174_ sky130_fd_sc_hd__and3_1
XANTENNA__7049__D net280 vssd1 vssd1 vccd1 vccd1 sky130_fd_sc_hd__diode_2
X_6723_ net199 net301 net193 net313 vssd1 vssd1 vccd1 vccd1 _1921_ sky130_fd_sc_hd__a22oi_1
X_6654_ net227 net273 net261 net240 vssd1 vssd1 vccd1 vccd1 _1848_ sky130_fd_sc_hd__a22oi_1
XANTENNA__6531__A _2051_ vssd1 vssd1 vccd1 vccd1 sky130_fd_sc_hd__diode_2
X_5605_ _0752_ _0756_ _0793_ vssd1 vssd1 vccd1 vccd1 _0795_ sky130_fd_sc_hd__and3_1
XFILLER_31_192 vssd1 vssd1 vccd1 vccd1 sky130_fd_sc_hd__fill_2
X_6585_ _1304_ _1771_ _1772_ vssd1 vssd1 vccd1 vccd1 _1774_ sky130_fd_sc_hd__a21bo_1
X_8324_ net317 PID_INST.k2_calc.sum_reg\[25\] _3498_ _3497_ vssd1 vssd1 vccd1 vccd1
+ _3600_ sky130_fd_sc_hd__a31o_1
XANTENNA_fanout303_A net304 vssd1 vssd1 vccd1 vccd1 sky130_fd_sc_hd__diode_2
X_5536_ net228 net306 _0725_ vssd1 vssd1 vccd1 vccd1 _0726_ sky130_fd_sc_hd__and3_1
X_8255_ _3384_ _3391_ _3383_ vssd1 vssd1 vccd1 vccd1 _3527_ sky130_fd_sc_hd__a21bo_1
X_5467_ _0647_ _0656_ _0645_ vssd1 vssd1 vccd1 vccd1 _0657_ sky130_fd_sc_hd__o21a_1
X_4418_ _3702_ _3703_ vssd1 vssd1 vccd1 vccd1 _0052_ sky130_fd_sc_hd__and2_1
X_7206_ _2426_ _2432_ vssd1 vssd1 vccd1 vccd1 _2433_ sky130_fd_sc_hd__xnor2_1
Xfanout301 net304 vssd1 vssd1 vccd1 vccd1 net301 sky130_fd_sc_hd__buf_1
Xfanout312 net316 vssd1 vssd1 vccd1 vccd1 net312 sky130_fd_sc_hd__clkbuf_2
Xfanout323 net324 vssd1 vssd1 vccd1 vccd1 net323 sky130_fd_sc_hd__clkbuf_2
XFILLER_59_513 vssd1 vssd1 vccd1 vccd1 sky130_fd_sc_hd__fill_8
X_8186_ _3304_ _3305_ _3308_ vssd1 vssd1 vccd1 vccd1 _3452_ sky130_fd_sc_hd__o21a_1
X_5398_ _0566_ _0587_ vssd1 vssd1 vccd1 vccd1 _0588_ sky130_fd_sc_hd__nand2_1
XFILLER_86_321 vssd1 vssd1 vccd1 vccd1 sky130_fd_sc_hd__fill_8
X_7137_ net296 net195 vssd1 vssd1 vccd1 vccd1 _2360_ sky130_fd_sc_hd__nand2_1
Xfanout334 net339 vssd1 vssd1 vccd1 vccd1 net334 sky130_fd_sc_hd__buf_2
X_4349_ _3579_ _3643_ _3644_ _3633_ vssd1 vssd1 vccd1 vccd1 _3648_ sky130_fd_sc_hd__a31o_1
XANTENNA_fanout293_X net293 vssd1 vssd1 vccd1 vccd1 sky130_fd_sc_hd__diode_2
X_7068_ net307 net195 _1939_ _1938_ vssd1 vssd1 vccd1 vccd1 _2288_ sky130_fd_sc_hd__a31oi_1
XFILLER_86_365 vssd1 vssd1 vccd1 vccd1 sky130_fd_sc_hd__fill_4
XFILLER_74_516 vccd1 vssd1 vccd1 vssd1 sky130_ef_sc_hd__decap_40_12
X_6019_ _1206_ _1207_ vssd1 vssd1 vccd1 vccd1 _1209_ sky130_fd_sc_hd__xor2_2
XTAP_TAPCELL_ROW_57_769 vssd1 vccd1 sky130_fd_sc_hd__tapvpwrvgnd_1
XFILLER_54_251 vssd1 vssd1 vccd1 vccd1 sky130_fd_sc_hd__fill_1
XANTENNA__7567__A1 _2737_ vssd1 vssd1 vccd1 vccd1 sky130_fd_sc_hd__diode_2
XANTENNA_fanout49_A net50 vssd1 vssd1 vccd1 vccd1 sky130_fd_sc_hd__diode_2
XFILLER_36_67 vssd1 vssd1 vccd1 vccd1 sky130_fd_sc_hd__fill_2
XANTENNA__5578__B1 net223 vssd1 vssd1 vccd1 vccd1 sky130_fd_sc_hd__diode_2
XANTENNA__4226__A net111 vssd1 vssd1 vccd1 vccd1 sky130_fd_sc_hd__diode_2
XFILLER_14_115 vssd1 vssd1 vccd1 vccd1 sky130_fd_sc_hd__fill_2
XFILLER_14_137 vssd1 vssd1 vccd1 vccd1 sky130_fd_sc_hd__fill_2
XFILLER_52_55 vssd1 vssd1 vccd1 vccd1 sky130_fd_sc_hd__fill_1
XTAP_TAPCELL_ROW_12_316 vssd1 vccd1 sky130_fd_sc_hd__tapvpwrvgnd_1
XTAP_TAPCELL_ROW_40_603 vssd1 vccd1 sky130_fd_sc_hd__tapvpwrvgnd_1
XFILLER_22_181 vccd1 vssd1 vccd1 vssd1 sky130_ef_sc_hd__decap_40_12
XANTENNA__8473__CLK clknet_4_10_0_clk vssd1 vssd1 vccd1 vccd1 sky130_fd_sc_hd__diode_2
XANTENNA__4232__Y PID_INST.k3_calc.d2.y\[2\] vssd1 vssd1 vccd1 vccd1 sky130_fd_sc_hd__diode_2
XFILLER_6_325 vssd1 vssd1 vccd1 vccd1 sky130_fd_sc_hd__fill_4
XANTENNA__4305__A1 net7 vssd1 vssd1 vccd1 vccd1 sky130_fd_sc_hd__diode_2
XFILLER_2_531 vssd1 vssd1 vccd1 vccd1 sky130_fd_sc_hd__fill_1
XANTENNA__6058__B2 net236 vssd1 vssd1 vccd1 vccd1 sky130_fd_sc_hd__diode_2
XFILLER_65_505 vccd1 vssd1 vccd1 vssd1 sky130_ef_sc_hd__decap_40_12
XFILLER_92_324 vccd1 vssd1 vccd1 vssd1 sky130_ef_sc_hd__decap_40_12
XFILLER_77_376 vssd1 vssd1 vccd1 vccd1 sky130_fd_sc_hd__fill_2
XANTENNA__6038__D net216 vssd1 vssd1 vccd1 vccd1 sky130_fd_sc_hd__diode_2
XFILLER_65_538 vssd1 vssd1 vccd1 vccd1 sky130_fd_sc_hd__fill_4
XFILLER_37_229 vssd1 vssd1 vccd1 vccd1 sky130_fd_sc_hd__fill_1
XFILLER_18_421 vssd1 vssd1 vccd1 vccd1 sky130_fd_sc_hd__fill_2
XTAP_TAPCELL_ROW_82_1016 vssd1 vccd1 sky130_fd_sc_hd__tapvpwrvgnd_1
XFILLER_60_221 vssd1 vssd1 vccd1 vccd1 sky130_fd_sc_hd__fill_4
XTAP_TAPCELL_ROW_28_482 vssd1 vccd1 sky130_fd_sc_hd__tapvpwrvgnd_1
XFILLER_33_435 vccd1 vssd1 vccd1 vssd1 sky130_ef_sc_hd__decap_40_12
XANTENNA__7447__A net206 vssd1 vssd1 vccd1 vccd1 sky130_fd_sc_hd__diode_2
XFILLER_9_130 vssd1 vssd1 vccd1 vccd1 sky130_fd_sc_hd__fill_2
XFILLER_9_174 vccd1 vssd1 vccd1 vssd1 sky130_ef_sc_hd__decap_40_12
XFILLER_9_196 vssd1 vssd1 vccd1 vccd1 sky130_fd_sc_hd__fill_1
X_6370_ _1555_ _1556_ vssd1 vssd1 vccd1 vccd1 _1558_ sky130_fd_sc_hd__xnor2_1
X_5321_ _0427_ _0510_ vssd1 vssd1 vccd1 vccd1 _0511_ sky130_fd_sc_hd__xnor2_1
XANTENNA__8278__A _3549_ vssd1 vssd1 vccd1 vccd1 sky130_fd_sc_hd__diode_2
X_8040_ _3154_ _3293_ vssd1 vssd1 vccd1 vccd1 _3294_ sky130_fd_sc_hd__xnor2_1
X_5252_ _0434_ _0441_ vssd1 vssd1 vccd1 vccd1 _0442_ sky130_fd_sc_hd__xnor2_1
X_5183_ _0264_ _0272_ _0371_ vssd1 vssd1 vccd1 vccd1 _0373_ sky130_fd_sc_hd__or3_1
XANTENNA__8428__D net407 vssd1 vssd1 vccd1 vccd1 sky130_fd_sc_hd__diode_2
X_4203_ _2178_ vssd1 vssd1 vccd1 vccd1 PID_INST.k3_calc.d1.y\[4\] sky130_fd_sc_hd__inv_2
XFILLER_68_354 vssd1 vssd1 vccd1 vccd1 sky130_fd_sc_hd__fill_1
XFILLER_56_516 vccd1 vssd1 vccd1 vssd1 sky130_ef_sc_hd__decap_40_12
XFILLER_83_335 vssd1 vssd1 vccd1 vccd1 sky130_fd_sc_hd__fill_1
XFILLER_64_560 vssd1 vssd1 vccd1 vccd1 sky130_fd_sc_hd__fill_1
XANTENNA_fanout253_A net255 vssd1 vssd1 vccd1 vccd1 sky130_fd_sc_hd__diode_2
XTAP_TAPCELL_ROW_54_739 vssd1 vccd1 sky130_fd_sc_hd__tapvpwrvgnd_1
X_7824_ net140 _1742_ _3079_ vssd1 vssd1 vccd1 vccd1 _3080_ sky130_fd_sc_hd__or3_1
X_7755_ net275 _3010_ _3009_ vssd1 vssd1 vccd1 vccd1 _3011_ sky130_fd_sc_hd__a21bo_1
X_4967_ _0154_ _0155_ vssd1 vssd1 vccd1 vccd1 _0157_ sky130_fd_sc_hd__or2_1
XFILLER_11_129 vssd1 vssd1 vccd1 vccd1 sky130_fd_sc_hd__fill_1
X_7686_ _2917_ _2918_ _2940_ vssd1 vssd1 vccd1 vccd1 _2941_ sky130_fd_sc_hd__nor3_1
X_6706_ net325 net187 vssd1 vssd1 vccd1 vccd1 _1903_ sky130_fd_sc_hd__nand2_1
XANTENNA_fanout139_X net139 vssd1 vssd1 vccd1 vccd1 sky130_fd_sc_hd__diode_2
X_4898_ _0084_ _0086_ vssd1 vssd1 vccd1 vccd1 _0088_ sky130_fd_sc_hd__nand2_2
X_6637_ net203 net315 net303 net195 vssd1 vssd1 vccd1 vccd1 _1830_ sky130_fd_sc_hd__and4_1
XANTENNA_fanout306_X net306 vssd1 vssd1 vccd1 vccd1 sky130_fd_sc_hd__diode_2
X_6568_ net93 net64 vssd1 vssd1 vccd1 vccd1 _1755_ sky130_fd_sc_hd__nor2_1
X_8307_ _3580_ _3581_ vssd1 vssd1 vccd1 vccd1 _3582_ sky130_fd_sc_hd__xor2_1
X_5519_ _0706_ _0708_ vssd1 vssd1 vccd1 vccd1 _0709_ sky130_fd_sc_hd__and2b_1
XFILLER_3_328 vssd1 vssd1 vccd1 vccd1 sky130_fd_sc_hd__fill_1
X_6499_ net417 _1686_ net156 vssd1 vssd1 vccd1 vccd1 _0062_ sky130_fd_sc_hd__mux2_1
X_8238_ _3506_ _3507_ vssd1 vssd1 vccd1 vccd1 _3508_ sky130_fd_sc_hd__xor2_1
XFILLER_78_107 vssd1 vssd1 vccd1 vccd1 sky130_fd_sc_hd__fill_4
XANTENNA__4299__A0 net293 vssd1 vssd1 vccd1 vccd1 sky130_fd_sc_hd__diode_2
XFILLER_78_118 vssd1 vssd1 vccd1 vccd1 sky130_fd_sc_hd__fill_4
Xfanout120 net121 vssd1 vssd1 vccd1 vccd1 net120 sky130_fd_sc_hd__buf_2
X_8169_ _3122_ _3270_ _3268_ vssd1 vssd1 vccd1 vccd1 _3434_ sky130_fd_sc_hd__o21ai_1
Xfanout131 PID_INST.k3_calc.d1.y\[7\] vssd1 vssd1 vccd1 vccd1 net131 sky130_fd_sc_hd__clkbuf_2
Xfanout164 PID_INST.k3_calc.d1.y\[14\] vssd1 vssd1 vccd1 vccd1 net164 sky130_fd_sc_hd__dlymetal6s2s_1
Xfanout142 PID_INST.k3_calc.d1.y\[0\] vssd1 vssd1 vccd1 vccd1 net142 sky130_fd_sc_hd__clkbuf_4
Xfanout153 _3778_ vssd1 vssd1 vccd1 vccd1 net153 sky130_fd_sc_hd__buf_2
XANTENNA__7820__A net98 vssd1 vssd1 vccd1 vccd1 sky130_fd_sc_hd__diode_2
Xfanout186 PID_INST.k2_calc.sum_reg\[18\] vssd1 vssd1 vccd1 vccd1 net186 sky130_fd_sc_hd__buf_2
Xfanout197 net198 vssd1 vssd1 vccd1 vccd1 net197 sky130_fd_sc_hd__buf_2
XFILLER_47_55 vssd1 vssd1 vccd1 vccd1 sky130_fd_sc_hd__fill_1
XFILLER_47_44 vssd1 vssd1 vccd1 vccd1 sky130_fd_sc_hd__fill_1
Xfanout175 _1784_ vssd1 vssd1 vccd1 vccd1 net175 sky130_fd_sc_hd__buf_2
XFILLER_86_195 vssd1 vssd1 vccd1 vccd1 sky130_fd_sc_hd__fill_1
XFILLER_74_335 vssd1 vssd1 vccd1 vccd1 sky130_fd_sc_hd__fill_4
XFILLER_47_66 vssd1 vssd1 vccd1 vccd1 sky130_fd_sc_hd__fill_8
XFILLER_74_379 vssd1 vssd1 vccd1 vccd1 sky130_fd_sc_hd__fill_1
XFILLER_27_262 vssd1 vssd1 vccd1 vccd1 sky130_fd_sc_hd__fill_1
XFILLER_82_390 vssd1 vssd1 vccd1 vccd1 sky130_fd_sc_hd__fill_2
XFILLER_70_563 vssd1 vssd1 vccd1 vccd1 sky130_fd_sc_hd__fill_4
XFILLER_63_43 vssd1 vssd1 vccd1 vccd1 sky130_fd_sc_hd__fill_1
XFILLER_15_468 vssd1 vssd1 vccd1 vccd1 sky130_fd_sc_hd__fill_4
XANTENNA__7267__A net99 vssd1 vssd1 vccd1 vccd1 sky130_fd_sc_hd__diode_2
XTAP_TAPCELL_ROW_25_452 vssd1 vccd1 sky130_fd_sc_hd__tapvpwrvgnd_1
XFILLER_30_405 vssd1 vssd1 vccd1 vccd1 sky130_fd_sc_hd__fill_2
XFILLER_8_27 vssd1 vssd1 vccd1 vccd1 sky130_fd_sc_hd__fill_1
XFILLER_10_173 vssd1 vssd1 vccd1 vccd1 sky130_fd_sc_hd__fill_4
XFILLER_6_144 vssd1 vssd1 vccd1 vccd1 sky130_fd_sc_hd__fill_4
XFILLER_6_111 vssd1 vssd1 vccd1 vccd1 sky130_fd_sc_hd__fill_2
XANTENNA__4897__Y _0087_ vssd1 vssd1 vccd1 vccd1 sky130_fd_sc_hd__diode_2
XFILLER_88_51 vssd1 vssd1 vccd1 vccd1 sky130_fd_sc_hd__fill_1
XANTENNA__8369__CLK clknet_4_1_0_clk vssd1 vssd1 vccd1 vccd1 sky130_fd_sc_hd__diode_2
XFILLER_2_383 vssd1 vssd1 vccd1 vccd1 sky130_fd_sc_hd__fill_1
XPHY_EDGE_ROW_0_Left_93 vssd1 vssd1 vccd1 vccd1 sky130_fd_sc_hd__decap_3
XFILLER_38_527 vssd1 vssd1 vccd1 vccd1 sky130_fd_sc_hd__fill_4
XFILLER_92_132 vssd1 vssd1 vccd1 vccd1 sky130_fd_sc_hd__fill_8
XFILLER_92_110 vssd1 vssd1 vccd1 vccd1 sky130_fd_sc_hd__fill_2
XFILLER_65_335 vssd1 vssd1 vccd1 vccd1 sky130_fd_sc_hd__fill_1
XFILLER_38_549 vssd1 vssd1 vccd1 vccd1 sky130_fd_sc_hd__fill_2
XFILLER_92_165 vssd1 vssd1 vccd1 vccd1 sky130_fd_sc_hd__fill_2
X_5870_ net241 net325 vssd1 vssd1 vccd1 vccd1 _1060_ sky130_fd_sc_hd__and2_1
XFILLER_18_295 vssd1 vssd1 vccd1 vccd1 sky130_fd_sc_hd__fill_1
X_4821_ _3994_ _3997_ _4031_ _4097_ _4029_ vssd1 vssd1 vccd1 vccd1 _4099_ sky130_fd_sc_hd__o311a_4
XTAP_TAPCELL_ROW_51_709 vssd1 vccd1 sky130_fd_sc_hd__tapvpwrvgnd_1
XFILLER_21_427 vssd1 vssd1 vccd1 vccd1 sky130_fd_sc_hd__fill_4
X_4752_ _4029_ vssd1 vssd1 vccd1 vccd1 _4030_ sky130_fd_sc_hd__inv_2
X_7540_ _2531_ _2785_ vssd1 vssd1 vccd1 vccd1 _2787_ sky130_fd_sc_hd__xnor2_1
X_7471_ _2712_ _2713_ vssd1 vssd1 vccd1 vccd1 _2714_ sky130_fd_sc_hd__nand2_1
XANTENNA__4313__B net12 vssd1 vssd1 vccd1 vccd1 sky130_fd_sc_hd__diode_2
X_4683_ _3904_ _3959_ _3960_ _3903_ vssd1 vssd1 vccd1 vccd1 _3961_ sky130_fd_sc_hd__a31o_1
X_6422_ _1609_ _1608_ vssd1 vssd1 vccd1 vccd1 _1610_ sky130_fd_sc_hd__nand2b_1
X_6353_ _1534_ _1540_ vssd1 vssd1 vccd1 vccd1 _1541_ sky130_fd_sc_hd__or2_1
XANTENNA__5425__A net107 vssd1 vssd1 vccd1 vccd1 sky130_fd_sc_hd__diode_2
X_6284_ _1267_ _1274_ _1471_ _1472_ vssd1 vssd1 vccd1 vccd1 _1473_ sky130_fd_sc_hd__o211a_1
X_5304_ _0493_ _0492_ vssd1 vssd1 vccd1 vccd1 _0494_ sky130_fd_sc_hd__nand2b_1
X_5235_ _0366_ _0368_ vssd1 vssd1 vccd1 vccd1 _0425_ sky130_fd_sc_hd__nand2_1
X_8023_ _3275_ _3276_ vssd1 vssd1 vccd1 vccd1 _3277_ sky130_fd_sc_hd__xnor2_1
XFILLER_68_151 vssd1 vssd1 vccd1 vccd1 sky130_fd_sc_hd__fill_1
X_5166_ net163 net145 vssd1 vssd1 vccd1 vccd1 _0356_ sky130_fd_sc_hd__nand2_1
XFILLER_29_505 vssd1 vssd1 vccd1 vccd1 sky130_fd_sc_hd__fill_4
XFILLER_29_516 vccd1 vssd1 vccd1 vssd1 sky130_ef_sc_hd__decap_40_12
XFILLER_68_195 vssd1 vssd1 vccd1 vccd1 sky130_fd_sc_hd__fill_1
X_5097_ _0284_ _0285_ _0195_ _0203_ vssd1 vssd1 vccd1 vccd1 _0287_ sky130_fd_sc_hd__o211a_1
XFILLER_83_154 vssd1 vssd1 vccd1 vccd1 sky130_fd_sc_hd__fill_4
XTAP_TAPCELL_ROW_67_875 vssd1 vccd1 sky130_fd_sc_hd__tapvpwrvgnd_1
XFILLER_83_176 vssd1 vssd1 vccd1 vccd1 sky130_fd_sc_hd__fill_1
XTAP_TAPCELL_ROW_39_588 vssd1 vccd1 sky130_fd_sc_hd__tapvpwrvgnd_1
XANTENNA_fanout256_X net256 vssd1 vssd1 vccd1 vccd1 sky130_fd_sc_hd__diode_2
X_5999_ _0472_ _0474_ _0543_ _0544_ _1187_ vssd1 vssd1 vccd1 vccd1 _1189_ sky130_fd_sc_hd__a311oi_2
XFILLER_24_265 vssd1 vssd1 vccd1 vccd1 sky130_fd_sc_hd__fill_2
X_7807_ _3061_ _3062_ vssd1 vssd1 vccd1 vccd1 _3063_ sky130_fd_sc_hd__and2b_1
X_7738_ net310 net298 net183 PID_INST.k2_calc.sum_reg\[21\] vssd1 vssd1 vccd1 vccd1
+ _2994_ sky130_fd_sc_hd__and4_1
XTAP_TAPCELL_ROW_22_422 vssd1 vccd1 sky130_fd_sc_hd__tapvpwrvgnd_1
XFILLER_33_68 vssd1 vssd1 vccd1 vccd1 sky130_fd_sc_hd__fill_4
XANTENNA__5319__B net71 vssd1 vssd1 vccd1 vccd1 sky130_fd_sc_hd__diode_2
X_7669_ _2921_ _2922_ vssd1 vssd1 vccd1 vccd1 _2923_ sky130_fd_sc_hd__or2_1
XFILLER_20_493 vssd1 vssd1 vccd1 vccd1 sky130_fd_sc_hd__fill_2
XPHY_EDGE_ROW_18_Left_111 vssd1 vssd1 vccd1 vccd1 sky130_fd_sc_hd__decap_3
XFILLER_3_169 vssd1 vssd1 vccd1 vccd1 sky130_fd_sc_hd__fill_8
XFILLER_79_449 vssd1 vssd1 vccd1 vccd1 sky130_fd_sc_hd__fill_1
Xhold9 PID_INST.k1_calc.d1.x\[3\] vssd1 vssd1 vccd1 vccd1 net402 sky130_fd_sc_hd__dlygate4sd3_1
XANTENNA_fanout71_X net71 vssd1 vssd1 vccd1 vccd1 sky130_fd_sc_hd__diode_2
XFILLER_87_493 vssd1 vssd1 vccd1 vccd1 sky130_fd_sc_hd__fill_4
XFILLER_47_335 vssd1 vssd1 vccd1 vccd1 sky130_fd_sc_hd__fill_1
XPHY_EDGE_ROW_27_Left_120 vssd1 vssd1 vccd1 vccd1 sky130_fd_sc_hd__decap_3
XFILLER_35_519 vssd1 vssd1 vccd1 vccd1 sky130_fd_sc_hd__fill_4
XFILLER_74_75 vssd1 vssd1 vccd1 vccd1 sky130_fd_sc_hd__fill_1
XANTENNA__4995__A1 net138 vssd1 vssd1 vccd1 vccd1 sky130_fd_sc_hd__diode_2
XFILLER_15_265 vssd1 vssd1 vccd1 vccd1 sky130_fd_sc_hd__fill_2
XFILLER_90_85 vssd1 vssd1 vccd1 vccd1 sky130_fd_sc_hd__fill_8
XFILLER_7_442 vssd1 vssd1 vccd1 vccd1 sky130_fd_sc_hd__fill_1
XFILLER_11_482 vssd1 vssd1 vccd1 vccd1 sky130_fd_sc_hd__fill_1
XFILLER_23_90 vssd1 vssd1 vccd1 vccd1 sky130_fd_sc_hd__fill_1
XTAP_TAPCELL_ROW_90_1104 vssd1 vccd1 sky130_fd_sc_hd__tapvpwrvgnd_1
XANTENNA__5245__A _2051_ vssd1 vssd1 vccd1 vccd1 sky130_fd_sc_hd__diode_2
X_5020_ _0112_ _0132_ _0131_ vssd1 vssd1 vccd1 vccd1 _0210_ sky130_fd_sc_hd__o21bai_2
XFILLER_78_471 vssd1 vssd1 vccd1 vccd1 sky130_fd_sc_hd__fill_4
XFILLER_78_493 vssd1 vssd1 vccd1 vccd1 sky130_fd_sc_hd__fill_1
XTAP_TAPCELL_ROW_88_1077 vssd1 vccd1 sky130_fd_sc_hd__tapvpwrvgnd_1
XFILLER_80_113 vssd1 vssd1 vccd1 vccd1 sky130_fd_sc_hd__fill_2
X_6971_ _2073_ _2181_ _2184_ vssd1 vssd1 vccd1 vccd1 _2185_ sky130_fd_sc_hd__a21o_1
XFILLER_80_157 vssd1 vssd1 vccd1 vccd1 sky130_fd_sc_hd__fill_4
XTAP_TAPCELL_ROW_64_845 vssd1 vccd1 sky130_fd_sc_hd__tapvpwrvgnd_1
X_5922_ _1106_ _1111_ vssd1 vssd1 vccd1 vccd1 _1112_ sky130_fd_sc_hd__nand2b_1
XFILLER_0_83 vssd1 vssd1 vccd1 vccd1 sky130_fd_sc_hd__fill_1
XFILLER_34_541 vssd1 vssd1 vccd1 vccd1 sky130_fd_sc_hd__fill_4
XTAP_TAPCELL_ROW_36_558 vssd1 vccd1 sky130_fd_sc_hd__tapvpwrvgnd_1
X_5853_ _1039_ _1042_ vssd1 vssd1 vccd1 vccd1 _1043_ sky130_fd_sc_hd__nor2_1
X_5784_ _0963_ _0967_ _0966_ vssd1 vssd1 vccd1 vccd1 _0974_ sky130_fd_sc_hd__o21a_1
X_4804_ _4027_ _4080_ _4081_ vssd1 vssd1 vccd1 vccd1 _4082_ sky130_fd_sc_hd__nor3_1
X_4735_ _3966_ _4011_ vssd1 vssd1 vccd1 vccd1 _4013_ sky130_fd_sc_hd__xnor2_1
XFILLER_21_279 vssd1 vssd1 vccd1 vccd1 sky130_fd_sc_hd__fill_1
X_7523_ net98 net44 vssd1 vssd1 vccd1 vccd1 _2769_ sky130_fd_sc_hd__nor2_1
XFILLER_9_92 vssd1 vssd1 vccd1 vccd1 sky130_fd_sc_hd__fill_2
X_7454_ _2693_ _2694_ vssd1 vssd1 vccd1 vccd1 _2695_ sky130_fd_sc_hd__nor2_1
XANTENNA_fanout216_A net217 vssd1 vssd1 vccd1 vccd1 sky130_fd_sc_hd__diode_2
X_4666_ net141 net120 net145 _3943_ _3941_ vssd1 vssd1 vccd1 vccd1 _3944_ sky130_fd_sc_hd__a41o_1
X_7385_ _2366_ _2369_ _2622_ vssd1 vssd1 vccd1 vccd1 _2623_ sky130_fd_sc_hd__a21oi_1
X_4597_ _3873_ _3874_ vssd1 vssd1 vccd1 vccd1 _3875_ sky130_fd_sc_hd__xor2_1
X_6405_ _1525_ _1592_ vssd1 vssd1 vccd1 vccd1 _1593_ sky130_fd_sc_hd__xnor2_1
X_6336_ _1194_ _1395_ _1397_ _1394_ vssd1 vssd1 vccd1 vccd1 _1524_ sky130_fd_sc_hd__a22o_1
XANTENNA_clkbuf_4_1_0_clk_X clknet_4_1_0_clk vssd1 vssd1 vccd1 vccd1 sky130_fd_sc_hd__diode_2
XFILLER_0_117 vssd1 vssd1 vccd1 vccd1 sky130_fd_sc_hd__fill_2
X_6267_ _1234_ _1454_ vssd1 vssd1 vccd1 vccd1 _1456_ sky130_fd_sc_hd__nand2_1
XFILLER_0_139 vssd1 vssd1 vccd1 vccd1 sky130_fd_sc_hd__fill_1
XANTENNA__4994__A net138 vssd1 vssd1 vccd1 vccd1 sky130_fd_sc_hd__diode_2
X_8006_ _3177_ _3259_ vssd1 vssd1 vccd1 vccd1 _3261_ sky130_fd_sc_hd__nor2_1
X_5218_ net163 net89 net146 net162 vssd1 vssd1 vccd1 vccd1 _0408_ sky130_fd_sc_hd__a22o_1
X_6198_ _1384_ _1385_ vssd1 vssd1 vccd1 vccd1 _1387_ sky130_fd_sc_hd__xor2_1
X_5149_ _0333_ _0338_ vssd1 vssd1 vccd1 vccd1 _0339_ sky130_fd_sc_hd__xnor2_1
XANTENNA__5218__A2 net89 vssd1 vssd1 vccd1 vccd1 sky130_fd_sc_hd__diode_2
XFILLER_84_496 vssd1 vssd1 vccd1 vccd1 sky130_fd_sc_hd__fill_4
XFILLER_44_338 vssd1 vssd1 vccd1 vccd1 sky130_fd_sc_hd__fill_8
XFILLER_44_349 vssd1 vssd1 vccd1 vccd1 sky130_fd_sc_hd__fill_4
XFILLER_25_552 vssd1 vssd1 vccd1 vccd1 sky130_fd_sc_hd__fill_1
XANTENNA__7088__Y _2309_ vssd1 vssd1 vccd1 vccd1 sky130_fd_sc_hd__diode_2
XFILLER_44_45 vssd1 vssd1 vccd1 vccd1 sky130_fd_sc_hd__fill_4
XFILLER_40_511 vssd1 vssd1 vccd1 vccd1 sky130_fd_sc_hd__fill_1
XFILLER_40_544 vssd1 vssd1 vccd1 vccd1 sky130_fd_sc_hd__fill_1
XANTENNA__7545__A net112 vssd1 vssd1 vccd1 vccd1 sky130_fd_sc_hd__diode_2
XFILLER_5_17 vssd1 vssd1 vccd1 vccd1 sky130_fd_sc_hd__fill_1
XANTENNA__6654__A1 net227 vssd1 vssd1 vccd1 vccd1 sky130_fd_sc_hd__diode_2
XFILLER_79_279 vssd1 vssd1 vccd1 vccd1 sky130_fd_sc_hd__fill_1
XFILLER_67_419 vssd1 vssd1 vccd1 vccd1 sky130_fd_sc_hd__fill_1
XTAP_TAPCELL_ROW_7_272 vssd1 vccd1 sky130_fd_sc_hd__tapvpwrvgnd_1
XANTENNA__4409__A net187 vssd1 vssd1 vccd1 vccd1 sky130_fd_sc_hd__diode_2
XFILLER_47_110 vssd1 vssd1 vccd1 vccd1 sky130_fd_sc_hd__fill_2
XFILLER_10_9 vssd1 vssd1 vccd1 vccd1 sky130_fd_sc_hd__fill_1
XFILLER_90_400 vssd1 vssd1 vccd1 vccd1 sky130_fd_sc_hd__fill_2
XFILLER_85_96 vccd1 vssd1 vccd1 vssd1 sky130_ef_sc_hd__decap_40_12
XFILLER_90_444 vccd1 vssd1 vccd1 vssd1 sky130_ef_sc_hd__decap_40_12
XANTENNA__8159__A1 net110 vssd1 vssd1 vccd1 vccd1 sky130_fd_sc_hd__diode_2
XFILLER_18_90 vssd1 vssd1 vccd1 vccd1 sky130_fd_sc_hd__fill_8
XFILLER_62_168 vssd1 vssd1 vccd1 vccd1 sky130_fd_sc_hd__fill_1
XTAP_TAPCELL_ROW_61_815 vssd1 vccd1 sky130_fd_sc_hd__tapvpwrvgnd_1
XTAP_TAPCELL_ROW_33_528 vssd1 vccd1 sky130_fd_sc_hd__tapvpwrvgnd_1
XFILLER_43_393 vccd1 vssd1 vccd1 vssd1 sky130_ef_sc_hd__decap_40_12
XANTENNA__7455__A net297 vssd1 vssd1 vccd1 vccd1 sky130_fd_sc_hd__diode_2
XANTENNA__4196__A2 net174 vssd1 vssd1 vccd1 vccd1 sky130_fd_sc_hd__diode_2
X_4520_ _3715_ _3718_ _3727_ _3714_ vssd1 vssd1 vccd1 vccd1 _3798_ sky130_fd_sc_hd__a31o_1
X_4451_ PID_INST.k1_calc.d1.x\[2\] PID_INST.k3_calc.prev_error\[2\] _3718_ _3726_
+ vssd1 vssd1 vccd1 vccd1 _3729_ sky130_fd_sc_hd__a31o_1
X_7170_ _2393_ _2394_ vssd1 vssd1 vccd1 vccd1 _2395_ sky130_fd_sc_hd__or2_1
XFILLER_7_294 vssd1 vssd1 vccd1 vccd1 sky130_fd_sc_hd__fill_1
X_4382_ _3674_ _3675_ vssd1 vssd1 vccd1 vccd1 _3676_ sky130_fd_sc_hd__nor2_1
X_6121_ _1303_ _1309_ vssd1 vssd1 vccd1 vccd1 _1310_ sky130_fd_sc_hd__xnor2_1
XANTENNA__7902__B _2147_ vssd1 vssd1 vccd1 vccd1 sky130_fd_sc_hd__diode_2
XFILLER_85_205 vccd1 vssd1 vccd1 vssd1 sky130_ef_sc_hd__decap_40_12
X_6052_ net239 net273 net261 net249 vssd1 vssd1 vccd1 vccd1 _1242_ sky130_fd_sc_hd__a22o_1
XPHY_EDGE_ROW_7_Right_7 vssd1 vssd1 vccd1 vccd1 sky130_fd_sc_hd__decap_3
X_5003_ _0187_ _0191_ vssd1 vssd1 vccd1 vccd1 _0193_ sky130_fd_sc_hd__xnor2_1
XTAP_TAPCELL_ROW_77_970 vssd1 vccd1 sky130_fd_sc_hd__tapvpwrvgnd_1
XFILLER_53_113 vssd1 vssd1 vccd1 vccd1 sky130_fd_sc_hd__fill_1
XTAP_TAPCELL_ROW_49_694 vssd1 vccd1 sky130_fd_sc_hd__tapvpwrvgnd_1
XFILLER_26_316 vssd1 vssd1 vccd1 vccd1 sky130_fd_sc_hd__fill_1
XFILLER_81_455 vssd1 vssd1 vccd1 vccd1 sky130_fd_sc_hd__fill_2
XANTENNA__6534__A net131 vssd1 vssd1 vccd1 vccd1 sky130_fd_sc_hd__diode_2
X_6954_ _2055_ _2057_ _2165_ vssd1 vssd1 vccd1 vccd1 _2166_ sky130_fd_sc_hd__a21oi_1
X_5905_ _1004_ _1012_ _1094_ vssd1 vssd1 vccd1 vccd1 _1095_ sky130_fd_sc_hd__o21ai_1
X_6885_ _1781_ _1792_ _1779_ vssd1 vssd1 vccd1 vccd1 _2094_ sky130_fd_sc_hd__a21oi_1
X_5836_ _1001_ _1006_ _1005_ vssd1 vssd1 vccd1 vccd1 _1026_ sky130_fd_sc_hd__o21a_1
XANTENNA__7365__A net204 vssd1 vssd1 vccd1 vccd1 sky130_fd_sc_hd__diode_2
X_5767_ _0951_ _0956_ vssd1 vssd1 vccd1 vccd1 _0957_ sky130_fd_sc_hd__and2_1
XANTENNA__4187__A2 net174 vssd1 vssd1 vccd1 vccd1 sky130_fd_sc_hd__diode_2
XANTENNA_fanout219_X net219 vssd1 vssd1 vccd1 vccd1 sky130_fd_sc_hd__diode_2
X_5698_ net318 net224 net219 net324 vssd1 vssd1 vccd1 vccd1 _0888_ sky130_fd_sc_hd__a22o_1
X_4718_ _3769_ _3772_ _3826_ _3825_ vssd1 vssd1 vccd1 vccd1 _3996_ sky130_fd_sc_hd__o31a_1
X_8486_ clknet_4_15_0_clk _0074_ net341 vssd1 vssd1 vccd1 vccd1 net35 sky130_fd_sc_hd__dfrtp_1
XANTENNA_fanout121_X net121 vssd1 vssd1 vccd1 vccd1 sky130_fd_sc_hd__diode_2
X_7506_ _2492_ _2498_ _2491_ vssd1 vssd1 vccd1 vccd1 _2751_ sky130_fd_sc_hd__a21boi_1
X_7437_ _2671_ _2677_ vssd1 vssd1 vccd1 vccd1 _2678_ sky130_fd_sc_hd__nand2b_1
X_4649_ net142 net84 vssd1 vssd1 vccd1 vccd1 _3927_ sky130_fd_sc_hd__nand2_1
X_7368_ net296 net193 vssd1 vssd1 vccd1 vccd1 _2605_ sky130_fd_sc_hd__nand2_1
XFILLER_1_415 vssd1 vssd1 vccd1 vccd1 sky130_fd_sc_hd__fill_1
XANTENNA__4895__B1 _4095_ vssd1 vssd1 vccd1 vccd1 sky130_fd_sc_hd__diode_2
XFILLER_89_533 vssd1 vssd1 vccd1 vccd1 sky130_fd_sc_hd__fill_1
X_6319_ _1302_ _1309_ _1301_ vssd1 vssd1 vccd1 vccd1 _1507_ sky130_fd_sc_hd__a21oi_1
X_7299_ PID_INST.k3_calc.d2.y\[5\] _1740_ _1741_ vssd1 vssd1 vccd1 vccd1 _2531_ sky130_fd_sc_hd__and3_1
XFILLER_76_238 vssd1 vssd1 vccd1 vccd1 sky130_fd_sc_hd__fill_1
XTAP_TAPCELL_ROW_4_242 vssd1 vccd1 sky130_fd_sc_hd__tapvpwrvgnd_1
XANTENNA_fanout79_A _3756_ vssd1 vssd1 vccd1 vccd1 sky130_fd_sc_hd__diode_2
XANTENNA__4229__A net109 vssd1 vssd1 vccd1 vccd1 sky130_fd_sc_hd__diode_2
XFILLER_57_474 vssd1 vssd1 vccd1 vccd1 sky130_fd_sc_hd__fill_2
XFILLER_17_316 vssd1 vssd1 vccd1 vccd1 sky130_fd_sc_hd__fill_1
XFILLER_72_455 vssd1 vssd1 vccd1 vccd1 sky130_fd_sc_hd__fill_1
XFILLER_72_444 vssd1 vssd1 vccd1 vccd1 sky130_fd_sc_hd__fill_4
XFILLER_44_168 vssd1 vssd1 vccd1 vccd1 sky130_fd_sc_hd__fill_2
XFILLER_13_522 vccd1 vssd1 vccd1 vssd1 sky130_ef_sc_hd__decap_40_12
XANTENNA__4178__A2 net173 vssd1 vssd1 vccd1 vccd1 sky130_fd_sc_hd__diode_2
XTAP_TAPCELL_ROW_10_299 vssd1 vccd1 sky130_fd_sc_hd__tapvpwrvgnd_1
XFILLER_4_286 vssd1 vssd1 vccd1 vccd1 sky130_fd_sc_hd__fill_1
XANTENNA__6338__B net83 vssd1 vssd1 vccd1 vccd1 sky130_fd_sc_hd__diode_2
XFILLER_0_481 vssd1 vssd1 vccd1 vccd1 sky130_fd_sc_hd__fill_2
XANTENNA__6057__C net278 vssd1 vssd1 vccd1 vccd1 sky130_fd_sc_hd__diode_2
XFILLER_0_492 vssd1 vssd1 vccd1 vccd1 sky130_fd_sc_hd__fill_2
XTAP_TAPCELL_ROW_85_1047 vssd1 vccd1 sky130_fd_sc_hd__tapvpwrvgnd_1
XTAP_TAPCELL_ROW_74_940 vssd1 vccd1 sky130_fd_sc_hd__tapvpwrvgnd_1
XFILLER_50_105 vssd1 vssd1 vccd1 vccd1 sky130_fd_sc_hd__fill_8
XTAP_TAPCELL_ROW_46_664 vssd1 vccd1 sky130_fd_sc_hd__tapvpwrvgnd_1
XFILLER_23_308 vccd1 vssd1 vccd1 vssd1 sky130_ef_sc_hd__decap_40_12
XFILLER_35_179 vssd1 vssd1 vccd1 vccd1 sky130_fd_sc_hd__fill_4
XTAP_TAPCELL_ROW_18_377 vssd1 vccd1 sky130_fd_sc_hd__tapvpwrvgnd_1
X_6670_ _1864_ _1865_ vssd1 vssd1 vccd1 vccd1 _1866_ sky130_fd_sc_hd__nand2_1
X_5621_ _0809_ _0810_ vssd1 vssd1 vccd1 vccd1 _0811_ sky130_fd_sc_hd__nor2_1
X_5552_ net291 net236 _0738_ _0740_ vssd1 vssd1 vccd1 vccd1 _0742_ sky130_fd_sc_hd__o2bb2a_1
X_8340_ _3616_ _3617_ vssd1 vssd1 vccd1 vccd1 _3618_ sky130_fd_sc_hd__xnor2_1
X_8271_ _3541_ _3543_ vssd1 vssd1 vccd1 vccd1 _3544_ sky130_fd_sc_hd__xnor2_1
X_4503_ net133 net150 vssd1 vssd1 vccd1 vccd1 _3781_ sky130_fd_sc_hd__nand2_1
XANTENNA__5417__B net65 vssd1 vssd1 vccd1 vccd1 sky130_fd_sc_hd__diode_2
X_5483_ _0648_ _0668_ _0670_ vssd1 vssd1 vccd1 vccd1 _0673_ sky130_fd_sc_hd__o21ai_1
X_4434_ net421 _3711_ _3712_ vssd1 vssd1 vccd1 vccd1 _0059_ sky130_fd_sc_hd__o21ba_1
X_7222_ _2187_ _2188_ _2186_ vssd1 vssd1 vccd1 vccd1 _2450_ sky130_fd_sc_hd__a21o_1
X_7153_ net307 PID_INST.k2_calc.sum_reg\[15\] _2265_ _2264_ vssd1 vssd1 vccd1 vccd1
+ _2376_ sky130_fd_sc_hd__a31oi_1
X_4365_ net214 net157 vssd1 vssd1 vccd1 vccd1 _3662_ sky130_fd_sc_hd__and2_1
X_7084_ _1974_ _1975_ _1973_ vssd1 vssd1 vccd1 vccd1 _2304_ sky130_fd_sc_hd__a21bo_1
X_6104_ net156 _1291_ _1292_ _1293_ vssd1 vssd1 vccd1 vccd1 _0060_ sky130_fd_sc_hd__a31o_1
X_6035_ _0813_ _0816_ _1223_ vssd1 vssd1 vccd1 vccd1 _1225_ sky130_fd_sc_hd__and3_1
XFILLER_58_238 vssd1 vssd1 vccd1 vccd1 sky130_fd_sc_hd__fill_4
XFILLER_58_227 vssd1 vssd1 vccd1 vccd1 sky130_fd_sc_hd__fill_2
X_4296_ net309 net15 net171 vssd1 vssd1 vccd1 vccd1 _0019_ sky130_fd_sc_hd__mux2_1
XANTENNA_fanout283_A net285 vssd1 vssd1 vccd1 vccd1 sky130_fd_sc_hd__diode_2
XFILLER_66_271 vssd1 vssd1 vccd1 vccd1 sky130_fd_sc_hd__fill_2
XTAP_TAPCELL_ROW_1_212 vssd1 vccd1 sky130_fd_sc_hd__tapvpwrvgnd_1
XFILLER_54_433 vssd1 vssd1 vccd1 vccd1 sky130_fd_sc_hd__fill_8
X_7986_ _3023_ _3026_ _3239_ vssd1 vssd1 vccd1 vccd1 _3241_ sky130_fd_sc_hd__and3_1
XFILLER_54_488 vssd1 vssd1 vccd1 vccd1 sky130_fd_sc_hd__fill_8
XFILLER_54_477 vssd1 vssd1 vccd1 vccd1 sky130_fd_sc_hd__fill_2
XFILLER_25_47 vssd1 vssd1 vccd1 vccd1 sky130_fd_sc_hd__fill_2
XFILLER_25_69 vssd1 vssd1 vccd1 vccd1 sky130_fd_sc_hd__fill_8
X_6937_ PID_INST.k3_calc.d2.y\[1\] _2034_ _2035_ vssd1 vssd1 vccd1 vccd1 _2149_ sky130_fd_sc_hd__and3_4
XANTENNA__7346__A2 net190 vssd1 vssd1 vccd1 vccd1 sky130_fd_sc_hd__diode_2
X_6868_ net139 net50 _2074_ vssd1 vssd1 vccd1 vccd1 _2076_ sky130_fd_sc_hd__o21ai_1
XFILLER_22_352 vccd1 vssd1 vccd1 vssd1 sky130_ef_sc_hd__decap_40_12
XTAP_TAPCELL_ROW_80_998 vssd1 vccd1 sky130_fd_sc_hd__tapvpwrvgnd_1
X_5819_ _0975_ _1008_ vssd1 vssd1 vccd1 vccd1 _1009_ sky130_fd_sc_hd__and2b_1
X_6799_ _2000_ _2001_ vssd1 vssd1 vccd1 vccd1 _2002_ sky130_fd_sc_hd__nand2_1
XFILLER_6_518 vssd1 vssd1 vccd1 vccd1 sky130_fd_sc_hd__fill_1
XFILLER_41_57 vssd1 vssd1 vccd1 vccd1 sky130_fd_sc_hd__fill_8
X_8469_ clknet_4_7_0_clk _0057_ net334 vssd1 vssd1 vccd1 vccd1 PID_INST.k2_calc.sum_reg\[25\]
+ sky130_fd_sc_hd__dfrtp_1
XFILLER_1_223 vssd1 vssd1 vccd1 vccd1 sky130_fd_sc_hd__fill_1
XFILLER_1_234 vssd1 vssd1 vccd1 vccd1 sky130_fd_sc_hd__fill_1
XFILLER_77_503 vssd1 vssd1 vccd1 vccd1 sky130_fd_sc_hd__fill_1
Xteam_03_342 vssd1 vssd1 vccd1 vccd1 team_03_342/HI gpio_oeb[18] sky130_fd_sc_hd__conb_1
XFILLER_77_569 vssd1 vssd1 vccd1 vccd1 sky130_fd_sc_hd__fill_1
Xteam_03_353 vssd1 vssd1 vccd1 vccd1 team_03_353/HI gpio_oeb[29] sky130_fd_sc_hd__conb_1
Xteam_03_375 vssd1 vssd1 vccd1 vccd1 team_03_375/HI gpio_out[17] sky130_fd_sc_hd__conb_1
Xteam_03_364 vssd1 vssd1 vccd1 vccd1 team_03_364/HI gpio_out[6] sky130_fd_sc_hd__conb_1
XFILLER_92_517 vssd1 vssd1 vccd1 vccd1 sky130_fd_sc_hd__fill_4
XFILLER_45_400 vccd1 vssd1 vccd1 vssd1 sky130_ef_sc_hd__decap_40_12
Xteam_03_386 vssd1 vssd1 vccd1 vccd1 gpio_oeb[10] team_03_386/LO sky130_fd_sc_hd__conb_1
XANTENNA_input11_A gpio_in[1] vssd1 vssd1 vccd1 vccd1 sky130_fd_sc_hd__diode_2
XFILLER_17_113 vccd1 vssd1 vccd1 vssd1 sky130_ef_sc_hd__decap_40_12
XTAP_TAPCELL_ROW_71_910 vssd1 vccd1 sky130_fd_sc_hd__tapvpwrvgnd_1
XFILLER_45_466 vccd1 vssd1 vccd1 vssd1 sky130_ef_sc_hd__decap_40_12
XFILLER_45_499 vssd1 vssd1 vccd1 vccd1 sky130_fd_sc_hd__fill_4
XTAP_TAPCELL_ROW_43_634 vssd1 vccd1 sky130_fd_sc_hd__tapvpwrvgnd_1
XFILLER_32_116 vssd1 vssd1 vccd1 vccd1 sky130_fd_sc_hd__fill_2
XFILLER_13_352 vssd1 vssd1 vccd1 vccd1 sky130_fd_sc_hd__fill_2
XTAP_TAPCELL_ROW_15_347 vssd1 vccd1 sky130_fd_sc_hd__tapvpwrvgnd_1
XANTENNA__6621__B net190 vssd1 vssd1 vccd1 vccd1 sky130_fd_sc_hd__diode_2
XFILLER_13_385 vssd1 vssd1 vccd1 vccd1 sky130_fd_sc_hd__fill_4
XANTENNA__4571__A2 net86 vssd1 vssd1 vccd1 vccd1 sky130_fd_sc_hd__diode_2
XANTENNA__7452__B net202 vssd1 vssd1 vccd1 vccd1 sky130_fd_sc_hd__diode_2
XANTENNA__5520__A1 net236 vssd1 vssd1 vccd1 vccd1 sky130_fd_sc_hd__diode_2
XANTENNA__4323__A2 net159 vssd1 vssd1 vccd1 vccd1 sky130_fd_sc_hd__diode_2
XFILLER_68_569 vssd1 vssd1 vccd1 vccd1 sky130_fd_sc_hd__fill_1
X_7840_ net117 net37 vssd1 vssd1 vccd1 vccd1 _3096_ sky130_fd_sc_hd__nor2_1
XFILLER_91_561 vssd1 vssd1 vccd1 vccd1 sky130_fd_sc_hd__fill_8
XFILLER_63_263 vssd1 vssd1 vccd1 vccd1 sky130_fd_sc_hd__fill_4
XFILLER_63_241 vssd1 vssd1 vccd1 vccd1 sky130_fd_sc_hd__fill_2
XFILLER_36_477 vccd1 vssd1 vccd1 vssd1 sky130_ef_sc_hd__decap_40_12
X_7771_ _3008_ _3025_ vssd1 vssd1 vccd1 vccd1 _3027_ sky130_fd_sc_hd__xnor2_1
X_4983_ _2178_ net73 vssd1 vssd1 vccd1 vccd1 _0173_ sky130_fd_sc_hd__nor2_1
XFILLER_23_105 vssd1 vssd1 vccd1 vccd1 sky130_fd_sc_hd__fill_2
XFILLER_23_127 vssd1 vssd1 vccd1 vccd1 sky130_fd_sc_hd__fill_1
X_6722_ net199 net312 net300 net193 vssd1 vssd1 vccd1 vccd1 _1920_ sky130_fd_sc_hd__and4_1
XFILLER_51_469 vssd1 vssd1 vccd1 vccd1 sky130_fd_sc_hd__fill_8
X_6653_ _1644_ _1652_ _1651_ vssd1 vssd1 vccd1 vccd1 _1847_ sky130_fd_sc_hd__a21oi_1
X_5604_ _0752_ _0756_ _0793_ vssd1 vssd1 vccd1 vccd1 _0794_ sky130_fd_sc_hd__a21oi_1
XFILLER_31_182 vssd1 vssd1 vccd1 vccd1 sky130_fd_sc_hd__fill_1
X_6584_ PID_INST.k3_calc.d2.y\[8\] _0222_ _0225_ _1500_ vssd1 vssd1 vccd1 vccd1 _1772_
+ sky130_fd_sc_hd__a31o_1
X_8323_ _3594_ _3598_ vssd1 vssd1 vccd1 vccd1 _3599_ sky130_fd_sc_hd__xnor2_1
X_5535_ _0722_ _0724_ vssd1 vssd1 vccd1 vccd1 _0725_ sky130_fd_sc_hd__xor2_1
X_8254_ _3463_ _3524_ vssd1 vssd1 vccd1 vccd1 _3525_ sky130_fd_sc_hd__xnor2_1
X_5466_ _0643_ _0644_ vssd1 vssd1 vccd1 vccd1 _0656_ sky130_fd_sc_hd__nor2_1
X_4417_ net181 _3700_ vssd1 vssd1 vccd1 vccd1 _3703_ sky130_fd_sc_hd__or2_1
X_7205_ _2430_ _2431_ vssd1 vssd1 vccd1 vccd1 _2432_ sky130_fd_sc_hd__xnor2_1
Xfanout313 net316 vssd1 vssd1 vccd1 vccd1 net313 sky130_fd_sc_hd__dlymetal6s2s_1
Xfanout302 net304 vssd1 vssd1 vccd1 vccd1 net302 sky130_fd_sc_hd__buf_2
X_8185_ _3448_ _3449_ vssd1 vssd1 vccd1 vccd1 _3451_ sky130_fd_sc_hd__or2_1
X_5397_ _0585_ _0586_ vssd1 vssd1 vccd1 vccd1 _0587_ sky130_fd_sc_hd__xnor2_1
X_7136_ _2356_ _2358_ vssd1 vssd1 vccd1 vccd1 _2359_ sky130_fd_sc_hd__nor2_1
Xfanout324 net325 vssd1 vssd1 vccd1 vccd1 net324 sky130_fd_sc_hd__buf_2
XANTENNA_input3_A gpio_in[10] vssd1 vssd1 vccd1 vccd1 sky130_fd_sc_hd__diode_2
X_4348_ net222 net19 vssd1 vssd1 vccd1 vccd1 _3647_ sky130_fd_sc_hd__xnor2_1
Xfanout335 net338 vssd1 vssd1 vccd1 vccd1 net335 sky130_fd_sc_hd__clkbuf_4
X_7067_ _2283_ _2284_ _2285_ vssd1 vssd1 vccd1 vccd1 _2287_ sky130_fd_sc_hd__o21ai_1
XFILLER_59_569 vssd1 vssd1 vccd1 vccd1 sky130_fd_sc_hd__fill_1
XFILLER_59_558 vssd1 vssd1 vccd1 vccd1 sky130_fd_sc_hd__fill_2
XANTENNA_fanout286_X net286 vssd1 vssd1 vccd1 vccd1 sky130_fd_sc_hd__diode_2
X_4279_ net14 PID_INST.k1_calc.d1.x\[2\] net157 vssd1 vssd1 vccd1 vccd1 _0002_ sky130_fd_sc_hd__mux2_1
XFILLER_74_528 vssd1 vssd1 vccd1 vccd1 sky130_fd_sc_hd__fill_1
X_6018_ _1206_ _1207_ vssd1 vssd1 vccd1 vccd1 _1208_ sky130_fd_sc_hd__nor2_1
XFILLER_27_400 vssd1 vssd1 vccd1 vccd1 sky130_fd_sc_hd__fill_4
XANTENNA__6706__B net187 vssd1 vssd1 vccd1 vccd1 sky130_fd_sc_hd__diode_2
XANTENNA__6425__C net258 vssd1 vssd1 vccd1 vccd1 sky130_fd_sc_hd__diode_2
X_7969_ _3223_ _3222_ vssd1 vssd1 vccd1 vccd1 _3224_ sky130_fd_sc_hd__and2b_1
XANTENNA__5578__A1 net314 vssd1 vssd1 vccd1 vccd1 sky130_fd_sc_hd__diode_2
XANTENNA__6722__A net199 vssd1 vssd1 vccd1 vccd1 sky130_fd_sc_hd__diode_2
XTAP_TAPCELL_ROW_12_317 vssd1 vccd1 sky130_fd_sc_hd__tapvpwrvgnd_1
XTAP_TAPCELL_ROW_40_604 vssd1 vccd1 sky130_fd_sc_hd__tapvpwrvgnd_1
XFILLER_52_89 vssd1 vssd1 vccd1 vccd1 sky130_fd_sc_hd__fill_1
XFILLER_52_78 vssd1 vssd1 vccd1 vccd1 sky130_fd_sc_hd__fill_4
XFILLER_50_491 vssd1 vssd1 vccd1 vccd1 sky130_fd_sc_hd__fill_1
XFILLER_22_193 vssd1 vssd1 vccd1 vccd1 sky130_fd_sc_hd__fill_2
XANTENNA__5338__A net123 vssd1 vssd1 vccd1 vccd1 sky130_fd_sc_hd__diode_2
XANTENNA__5060__D_N net77 vssd1 vssd1 vccd1 vccd1 sky130_fd_sc_hd__diode_2
XFILLER_2_565 vssd1 vssd1 vccd1 vccd1 sky130_fd_sc_hd__fill_2
XFILLER_89_182 vccd1 vssd1 vccd1 vssd1 sky130_ef_sc_hd__decap_40_12
XFILLER_65_517 vccd1 vssd1 vccd1 vssd1 sky130_ef_sc_hd__decap_40_12
XANTENNA_input14_X net14 vssd1 vssd1 vccd1 vccd1 sky130_fd_sc_hd__diode_2
XFILLER_73_561 vssd1 vssd1 vccd1 vccd1 sky130_fd_sc_hd__fill_8
XTAP_TAPCELL_ROW_82_1017 vssd1 vccd1 sky130_fd_sc_hd__tapvpwrvgnd_1
XTAP_TAPCELL_ROW_28_483 vssd1 vccd1 sky130_fd_sc_hd__tapvpwrvgnd_1
XFILLER_33_447 vssd1 vssd1 vccd1 vccd1 sky130_fd_sc_hd__fill_1
XFILLER_33_458 vssd1 vssd1 vccd1 vccd1 sky130_fd_sc_hd__fill_1
XANTENNA__7447__B net275 vssd1 vssd1 vccd1 vccd1 sky130_fd_sc_hd__diode_2
XFILLER_60_288 vssd1 vssd1 vccd1 vccd1 sky130_fd_sc_hd__fill_1
XFILLER_9_164 vssd1 vssd1 vccd1 vccd1 sky130_fd_sc_hd__fill_1
X_5320_ _0508_ _0509_ vssd1 vssd1 vccd1 vccd1 _0510_ sky130_fd_sc_hd__xnor2_1
X_5251_ _0438_ _0439_ vssd1 vssd1 vccd1 vccd1 _0441_ sky130_fd_sc_hd__xnor2_1
X_4202_ net16 net174 _2167_ vssd1 vssd1 vccd1 vccd1 _2178_ sky130_fd_sc_hd__o21ai_4
X_5182_ _0264_ _0272_ _0371_ vssd1 vssd1 vccd1 vccd1 _0372_ sky130_fd_sc_hd__o21ai_1
XFILLER_56_528 vssd1 vssd1 vccd1 vccd1 sky130_fd_sc_hd__fill_4
XFILLER_28_219 vssd1 vssd1 vccd1 vccd1 sky130_fd_sc_hd__fill_1
XFILLER_83_325 vssd1 vssd1 vccd1 vccd1 sky130_fd_sc_hd__fill_8
XANTENNA__4327__A net237 vssd1 vssd1 vccd1 vccd1 sky130_fd_sc_hd__diode_2
XFILLER_51_200 vssd1 vssd1 vccd1 vccd1 sky130_fd_sc_hd__fill_4
XFILLER_24_436 vssd1 vssd1 vccd1 vccd1 sky130_fd_sc_hd__fill_2
X_7823_ _3077_ _3078_ vssd1 vssd1 vccd1 vccd1 _3079_ sky130_fd_sc_hd__xnor2_1
X_7754_ net198 net213 PID_INST.k2_calc.reg_lc\[13\] vssd1 vssd1 vccd1 vccd1 _3010_
+ sky130_fd_sc_hd__and3_1
X_6705_ _1900_ _1901_ vssd1 vssd1 vccd1 vccd1 _1902_ sky130_fd_sc_hd__nor2_1
X_4966_ _0154_ _0155_ vssd1 vssd1 vccd1 vccd1 _0156_ sky130_fd_sc_hd__nor2_2
X_7685_ _2919_ _2937_ vssd1 vssd1 vccd1 vccd1 _2940_ sky130_fd_sc_hd__xnor2_1
X_4897_ _0083_ _0085_ vssd1 vssd1 vccd1 vccd1 _0087_ sky130_fd_sc_hd__nor2_2
X_6636_ _1612_ _1615_ _1613_ vssd1 vssd1 vccd1 vccd1 _1829_ sky130_fd_sc_hd__o21ba_1
X_6567_ _1689_ _1752_ vssd1 vssd1 vccd1 vccd1 _1754_ sky130_fd_sc_hd__xnor2_1
X_8306_ net317 PID_INST.k2_calc.sum_reg\[26\] vssd1 vssd1 vccd1 vccd1 _3581_ sky130_fd_sc_hd__nand2_1
XANTENNA_fanout201_X net201 vssd1 vssd1 vccd1 vccd1 sky130_fd_sc_hd__diode_2
X_5518_ net247 net285 net280 net249 vssd1 vssd1 vccd1 vccd1 _0708_ sky130_fd_sc_hd__a22o_1
XFILLER_3_307 vssd1 vssd1 vccd1 vccd1 sky130_fd_sc_hd__fill_4
X_6498_ _1684_ _1685_ vssd1 vssd1 vccd1 vccd1 _1686_ sky130_fd_sc_hd__xor2_1
X_8237_ net322 net178 _3316_ _3318_ vssd1 vssd1 vccd1 vccd1 _3507_ sky130_fd_sc_hd__a31o_1
XANTENNA__4299__A1 net18 vssd1 vssd1 vccd1 vccd1 sky130_fd_sc_hd__diode_2
X_5449_ _0638_ _0626_ vssd1 vssd1 vccd1 vccd1 _0639_ sky130_fd_sc_hd__and2b_1
Xfanout110 _2453_ vssd1 vssd1 vccd1 vccd1 net110 sky130_fd_sc_hd__buf_2
Xfanout121 PID_INST.k3_calc.d1.y\[2\] vssd1 vssd1 vccd1 vccd1 net121 sky130_fd_sc_hd__clkbuf_4
X_8168_ _3431_ _3432_ vssd1 vssd1 vccd1 vccd1 _3433_ sky130_fd_sc_hd__xnor2_1
X_7119_ _2334_ _2339_ vssd1 vssd1 vccd1 vccd1 _2340_ sky130_fd_sc_hd__nand2b_1
Xfanout165 PID_INST.k3_calc.d1.y\[13\] vssd1 vssd1 vccd1 vccd1 net165 sky130_fd_sc_hd__clkbuf_2
XANTENNA_input6_X net6 vssd1 vssd1 vccd1 vccd1 sky130_fd_sc_hd__diode_2
Xfanout154 net155 vssd1 vssd1 vccd1 vccd1 net154 sky130_fd_sc_hd__buf_2
Xfanout143 net144 vssd1 vssd1 vccd1 vccd1 net143 sky130_fd_sc_hd__buf_2
Xfanout132 PID_INST.k3_calc.d1.y\[8\] vssd1 vssd1 vccd1 vccd1 net132 sky130_fd_sc_hd__buf_2
XFILLER_86_152 vssd1 vssd1 vccd1 vccd1 sky130_fd_sc_hd__fill_4
X_8099_ net202 net272 net260 vssd1 vssd1 vccd1 vccd1 _3358_ sky130_fd_sc_hd__and3_1
Xfanout198 net200 vssd1 vssd1 vccd1 vccd1 net198 sky130_fd_sc_hd__buf_2
Xfanout187 PID_INST.k2_calc.sum_reg\[17\] vssd1 vssd1 vccd1 vccd1 net187 sky130_fd_sc_hd__clkbuf_4
XFILLER_59_388 vssd1 vssd1 vccd1 vccd1 sky130_fd_sc_hd__fill_4
XFILLER_59_377 vssd1 vssd1 vccd1 vccd1 sky130_fd_sc_hd__fill_8
Xfanout176 PID_INST.pid.curr_state\[1\] vssd1 vssd1 vccd1 vccd1 net176 sky130_fd_sc_hd__clkbuf_2
XFILLER_86_185 vssd1 vssd1 vccd1 vccd1 sky130_fd_sc_hd__fill_8
XFILLER_74_325 vssd1 vssd1 vccd1 vccd1 sky130_fd_sc_hd__fill_2
XANTENNA_fanout61_A net62 vssd1 vssd1 vccd1 vccd1 sky130_fd_sc_hd__diode_2
XFILLER_15_425 vssd1 vssd1 vccd1 vccd1 sky130_fd_sc_hd__fill_1
XFILLER_15_447 vssd1 vssd1 vccd1 vccd1 sky130_fd_sc_hd__fill_1
XFILLER_63_99 vssd1 vssd1 vccd1 vccd1 sky130_fd_sc_hd__fill_1
XTAP_TAPCELL_ROW_25_453 vssd1 vccd1 sky130_fd_sc_hd__tapvpwrvgnd_1
XFILLER_23_491 vccd1 vssd1 vccd1 vssd1 sky130_ef_sc_hd__decap_40_12
XANTENNA__5068__A net162 vssd1 vssd1 vccd1 vccd1 sky130_fd_sc_hd__diode_2
XANTENNA__7283__A net110 vssd1 vssd1 vccd1 vccd1 sky130_fd_sc_hd__diode_2
XFILLER_69_119 vssd1 vssd1 vccd1 vccd1 sky130_fd_sc_hd__fill_8
XFILLER_19_6 vssd1 vssd1 vccd1 vccd1 sky130_fd_sc_hd__fill_8
XFILLER_38_506 vssd1 vssd1 vccd1 vccd1 sky130_fd_sc_hd__fill_4
XANTENNA__5250__B net71 vssd1 vssd1 vccd1 vccd1 sky130_fd_sc_hd__diode_2
XFILLER_65_358 vssd1 vssd1 vccd1 vccd1 sky130_fd_sc_hd__fill_1
XFILLER_73_391 vssd1 vssd1 vccd1 vccd1 sky130_fd_sc_hd__fill_1
X_4820_ PID_INST.k1_calc.d1.x\[10\] PID_INST.k3_calc.prev_error\[10\] _4029_ _4031_
+ vssd1 vssd1 vccd1 vccd1 _4098_ sky130_fd_sc_hd__a31o_1
XFILLER_33_255 vssd1 vssd1 vccd1 vccd1 sky130_fd_sc_hd__fill_1
X_4751_ PID_INST.k1_calc.d1.x\[11\] PID_INST.k3_calc.prev_error\[11\] vssd1 vssd1
+ vccd1 vccd1 _4029_ sky130_fd_sc_hd__or2_1
XFILLER_21_439 vssd1 vssd1 vccd1 vccd1 sky130_fd_sc_hd__fill_4
X_7470_ _2709_ _2710_ _2711_ vssd1 vssd1 vccd1 vccd1 _2713_ sky130_fd_sc_hd__o21ai_1
X_4682_ _3957_ _3958_ vssd1 vssd1 vccd1 vccd1 _3960_ sky130_fd_sc_hd__or2_1
X_6421_ _1413_ _1415_ _1412_ vssd1 vssd1 vccd1 vccd1 _1609_ sky130_fd_sc_hd__o21ba_1
XANTENNA__5714__A1 net228 vssd1 vssd1 vccd1 vccd1 sky130_fd_sc_hd__diode_2
X_6352_ _1538_ _1539_ vssd1 vssd1 vccd1 vccd1 _1540_ sky130_fd_sc_hd__xor2_1
X_6283_ _1463_ _1464_ _1470_ vssd1 vssd1 vccd1 vccd1 _1472_ sky130_fd_sc_hd__a21o_1
X_5303_ _0415_ _0420_ _0414_ vssd1 vssd1 vccd1 vccd1 _0493_ sky130_fd_sc_hd__o21ba_1
X_8022_ net100 net40 _3134_ _3132_ vssd1 vssd1 vccd1 vccd1 _3276_ sky130_fd_sc_hd__o31a_1
X_5234_ _0421_ _0422_ vssd1 vssd1 vccd1 vccd1 _0424_ sky130_fd_sc_hd__xnor2_1
X_5165_ _0346_ _0353_ vssd1 vssd1 vccd1 vccd1 _0355_ sky130_fd_sc_hd__xnor2_1
XFILLER_68_141 vssd1 vssd1 vccd1 vccd1 sky130_fd_sc_hd__fill_1
XFILLER_29_528 vssd1 vssd1 vccd1 vccd1 sky130_fd_sc_hd__fill_4
XFILLER_68_185 vssd1 vssd1 vccd1 vccd1 sky130_fd_sc_hd__fill_8
X_5096_ _0195_ _0203_ _0284_ _0285_ vssd1 vssd1 vccd1 vccd1 _0286_ sky130_fd_sc_hd__a211oi_2
XFILLER_37_561 vssd1 vssd1 vccd1 vccd1 sky130_fd_sc_hd__fill_1
XTAP_TAPCELL_ROW_39_589 vssd1 vccd1 sky130_fd_sc_hd__tapvpwrvgnd_1
XANTENNA__7368__A net296 vssd1 vssd1 vccd1 vccd1 sky130_fd_sc_hd__diode_2
XFILLER_64_391 vssd1 vssd1 vccd1 vccd1 sky130_fd_sc_hd__fill_1
X_7806_ net91 net53 _2819_ _2818_ vssd1 vssd1 vccd1 vccd1 _3062_ sky130_fd_sc_hd__o31ai_2
XANTENNA__6703__C net226 vssd1 vssd1 vccd1 vccd1 sky130_fd_sc_hd__diode_2
X_5998_ _0472_ _0474_ _0543_ _0544_ vssd1 vssd1 vccd1 vccd1 _1188_ sky130_fd_sc_hd__a31o_1
XANTENNA__4205__A1 net15 vssd1 vssd1 vccd1 vccd1 sky130_fd_sc_hd__diode_2
X_7737_ _2892_ _2895_ _2893_ vssd1 vssd1 vccd1 vccd1 _2993_ sky130_fd_sc_hd__o21ba_1
X_4949_ _4114_ _4146_ _4145_ vssd1 vssd1 vccd1 vccd1 _0139_ sky130_fd_sc_hd__a21bo_1
XTAP_TAPCELL_ROW_22_423 vssd1 vccd1 sky130_fd_sc_hd__tapvpwrvgnd_1
XFILLER_33_36 vssd1 vssd1 vccd1 vccd1 sky130_fd_sc_hd__fill_1
XFILLER_33_47 vssd1 vssd1 vccd1 vccd1 sky130_fd_sc_hd__fill_1
X_7668_ net204 net262 _0785_ vssd1 vssd1 vccd1 vccd1 _2922_ sky130_fd_sc_hd__and3_1
X_6619_ net269 net232 net235 net266 vssd1 vssd1 vccd1 vccd1 _1811_ sky130_fd_sc_hd__a22oi_1
XANTENNA__8199__A net198 vssd1 vssd1 vccd1 vccd1 sky130_fd_sc_hd__diode_2
X_7599_ _2765_ _2777_ _2764_ vssd1 vssd1 vccd1 vccd1 _2850_ sky130_fd_sc_hd__a21boi_2
XFILLER_35_509 vssd1 vssd1 vccd1 vccd1 sky130_fd_sc_hd__fill_1
XFILLER_15_211 vssd1 vssd1 vccd1 vccd1 sky130_fd_sc_hd__fill_1
XFILLER_55_391 vssd1 vssd1 vccd1 vccd1 sky130_fd_sc_hd__fill_1
XFILLER_55_380 vssd1 vssd1 vccd1 vccd1 sky130_fd_sc_hd__fill_1
XANTENNA__6182__A net129 vssd1 vssd1 vccd1 vccd1 sky130_fd_sc_hd__diode_2
XFILLER_90_64 vssd1 vssd1 vccd1 vccd1 sky130_fd_sc_hd__fill_1
XFILLER_30_225 vssd1 vssd1 vccd1 vccd1 sky130_fd_sc_hd__fill_8
XFILLER_30_258 vssd1 vssd1 vccd1 vccd1 sky130_fd_sc_hd__fill_8
XFILLER_7_421 vssd1 vssd1 vccd1 vccd1 sky130_fd_sc_hd__fill_4
XFILLER_11_472 vssd1 vssd1 vccd1 vccd1 sky130_fd_sc_hd__fill_2
XTAP_TAPCELL_ROW_90_1105 vssd1 vccd1 sky130_fd_sc_hd__tapvpwrvgnd_1
XANTENNA__5245__B net74 vssd1 vssd1 vccd1 vccd1 sky130_fd_sc_hd__diode_2
XANTENNA__7741__A net293 vssd1 vssd1 vccd1 vccd1 sky130_fd_sc_hd__diode_2
XANTENNA__8486__CLK clknet_4_15_0_clk vssd1 vssd1 vccd1 vccd1 sky130_fd_sc_hd__diode_2
XFILLER_2_170 vccd1 vssd1 vccd1 vssd1 sky130_ef_sc_hd__decap_40_12
XFILLER_78_461 vssd1 vssd1 vccd1 vccd1 sky130_fd_sc_hd__fill_4
XANTENNA__6424__A2 net258 vssd1 vssd1 vccd1 vccd1 sky130_fd_sc_hd__diode_2
X_6970_ net97 net52 net50 net109 vssd1 vssd1 vccd1 vccd1 _2184_ sky130_fd_sc_hd__o22a_1
XFILLER_38_347 vssd1 vssd1 vccd1 vccd1 sky130_fd_sc_hd__fill_8
XTAP_TAPCELL_ROW_88_1078 vssd1 vccd1 sky130_fd_sc_hd__tapvpwrvgnd_1
X_5921_ _4025_ _1110_ vssd1 vssd1 vccd1 vccd1 _1111_ sky130_fd_sc_hd__xor2_1
XFILLER_19_561 vssd1 vssd1 vccd1 vccd1 sky130_fd_sc_hd__fill_8
XFILLER_0_73 vssd1 vssd1 vccd1 vccd1 sky130_fd_sc_hd__fill_8
XFILLER_34_520 vccd1 vssd1 vccd1 vssd1 sky130_ef_sc_hd__decap_40_12
XTAP_TAPCELL_ROW_36_559 vssd1 vccd1 sky130_fd_sc_hd__tapvpwrvgnd_1
X_5852_ _1029_ _1034_ _1038_ vssd1 vssd1 vccd1 vccd1 _1042_ sky130_fd_sc_hd__and3_1
X_5783_ _0928_ _0972_ vssd1 vssd1 vccd1 vccd1 _0973_ sky130_fd_sc_hd__nor2_1
X_4803_ _4078_ _4079_ _3989_ _4007_ vssd1 vssd1 vccd1 vccd1 _4081_ sky130_fd_sc_hd__a211oi_1
X_4734_ _3966_ _4011_ vssd1 vssd1 vccd1 vccd1 _4012_ sky130_fd_sc_hd__nand2_1
XFILLER_21_269 vssd1 vssd1 vccd1 vccd1 sky130_fd_sc_hd__fill_2
X_7522_ net98 net43 vssd1 vssd1 vccd1 vccd1 _2768_ sky130_fd_sc_hd__nor2_1
XFILLER_9_82 vssd1 vssd1 vccd1 vccd1 sky130_fd_sc_hd__fill_1
X_7453_ net198 net282 net277 net202 vssd1 vssd1 vccd1 vccd1 _2694_ sky130_fd_sc_hd__a22oi_1
X_4665_ net113 _3723_ net153 vssd1 vssd1 vccd1 vccd1 _3943_ sky130_fd_sc_hd__and3_1
X_7384_ _2351_ _2354_ _2352_ vssd1 vssd1 vccd1 vccd1 _2622_ sky130_fd_sc_hd__o21ba_1
XANTENNA_fanout209_A net213 vssd1 vssd1 vccd1 vccd1 sky130_fd_sc_hd__diode_2
X_4596_ net141 net81 vssd1 vssd1 vccd1 vccd1 _3874_ sky130_fd_sc_hd__nand2_1
XANTENNA_fanout111_A net112 vssd1 vssd1 vccd1 vccd1 sky130_fd_sc_hd__diode_2
X_6404_ _1584_ _1591_ vssd1 vssd1 vccd1 vccd1 _1592_ sky130_fd_sc_hd__xor2_1
X_6335_ _1521_ _1522_ vssd1 vssd1 vccd1 vccd1 _1523_ sky130_fd_sc_hd__nand2b_1
XFILLER_88_214 vssd1 vssd1 vccd1 vccd1 sky130_fd_sc_hd__fill_1
XANTENNA__7651__A net311 vssd1 vssd1 vccd1 vccd1 sky130_fd_sc_hd__diode_2
XFILLER_0_107 vssd1 vssd1 vccd1 vccd1 sky130_fd_sc_hd__fill_4
X_6266_ _1234_ _1454_ vssd1 vssd1 vccd1 vccd1 _1455_ sky130_fd_sc_hd__or2_1
X_8005_ _3177_ _3259_ vssd1 vssd1 vccd1 vccd1 _3260_ sky130_fd_sc_hd__and2_1
XANTENNA_fanout199_X net199 vssd1 vssd1 vccd1 vccd1 sky130_fd_sc_hd__diode_2
XANTENNA__4674__A1 net142 vssd1 vssd1 vccd1 vccd1 sky130_fd_sc_hd__diode_2
X_5217_ net163 net89 vssd1 vssd1 vccd1 vccd1 _0407_ sky130_fd_sc_hd__and2_1
X_6197_ _1384_ _1385_ vssd1 vssd1 vccd1 vccd1 _1386_ sky130_fd_sc_hd__nand2b_1
X_5148_ _0334_ _0337_ vssd1 vssd1 vccd1 vccd1 _0338_ sky130_fd_sc_hd__xnor2_1
XFILLER_84_442 vssd1 vssd1 vccd1 vccd1 sky130_fd_sc_hd__fill_4
X_5079_ _0267_ _0268_ vssd1 vssd1 vccd1 vccd1 _0269_ sky130_fd_sc_hd__or2_1
XFILLER_28_69 vssd1 vssd1 vccd1 vccd1 sky130_fd_sc_hd__fill_1
XFILLER_84_475 vssd1 vssd1 vccd1 vccd1 sky130_fd_sc_hd__fill_1
XANTENNA__6714__B net190 vssd1 vssd1 vccd1 vccd1 sky130_fd_sc_hd__diode_2
XFILLER_37_391 vssd1 vssd1 vccd1 vccd1 sky130_fd_sc_hd__fill_1
XFILLER_71_169 vssd1 vssd1 vccd1 vccd1 sky130_fd_sc_hd__fill_1
XFILLER_52_361 vssd1 vssd1 vccd1 vccd1 sky130_fd_sc_hd__fill_2
XFILLER_44_68 vssd1 vssd1 vccd1 vccd1 sky130_fd_sc_hd__fill_1
XFILLER_12_225 vssd1 vssd1 vccd1 vccd1 sky130_fd_sc_hd__fill_2
XANTENNA__7545__B net37 vssd1 vssd1 vccd1 vccd1 sky130_fd_sc_hd__diode_2
XANTENNA__4250__A net95 vssd1 vssd1 vccd1 vccd1 sky130_fd_sc_hd__diode_2
XFILLER_79_258 vssd1 vssd1 vccd1 vccd1 sky130_fd_sc_hd__fill_4
XFILLER_79_225 vssd1 vssd1 vccd1 vccd1 sky130_fd_sc_hd__fill_2
XFILLER_69_76 vssd1 vssd1 vccd1 vccd1 sky130_fd_sc_hd__fill_2
XANTENNA__6654__A2 net273 vssd1 vssd1 vccd1 vccd1 sky130_fd_sc_hd__diode_2
XFILLER_67_409 vssd1 vssd1 vccd1 vccd1 sky130_fd_sc_hd__fill_8
XTAP_TAPCELL_ROW_7_273 vssd1 vccd1 sky130_fd_sc_hd__tapvpwrvgnd_1
XFILLER_85_31 vssd1 vssd1 vccd1 vccd1 sky130_fd_sc_hd__fill_1
XFILLER_75_420 vccd1 vssd1 vccd1 vssd1 sky130_ef_sc_hd__decap_40_12
XFILLER_75_453 vssd1 vssd1 vccd1 vccd1 sky130_fd_sc_hd__fill_1
XFILLER_35_317 vssd1 vssd1 vccd1 vccd1 sky130_fd_sc_hd__fill_2
XFILLER_90_456 vccd1 vssd1 vccd1 vssd1 sky130_ef_sc_hd__decap_40_12
XFILLER_90_434 vssd1 vssd1 vccd1 vccd1 sky130_fd_sc_hd__fill_4
XANTENNA__8159__A2 net37 vssd1 vssd1 vccd1 vccd1 sky130_fd_sc_hd__diode_2
XFILLER_16_531 vssd1 vssd1 vccd1 vccd1 sky130_fd_sc_hd__fill_1
XFILLER_90_489 vssd1 vssd1 vccd1 vccd1 sky130_fd_sc_hd__fill_8
XFILLER_43_361 vssd1 vssd1 vccd1 vccd1 sky130_fd_sc_hd__fill_8
XTAP_TAPCELL_ROW_33_529 vssd1 vccd1 sky130_fd_sc_hd__tapvpwrvgnd_1
XFILLER_86_6 vssd1 vssd1 vccd1 vccd1 sky130_fd_sc_hd__fill_8
XFILLER_31_567 vssd1 vssd1 vccd1 vccd1 sky130_fd_sc_hd__fill_2
XANTENNA__6640__A net291 vssd1 vssd1 vccd1 vccd1 sky130_fd_sc_hd__diode_2
XANTENNA__7455__B net190 vssd1 vssd1 vccd1 vccd1 sky130_fd_sc_hd__diode_2
X_4450_ _3717_ _3726_ vssd1 vssd1 vccd1 vccd1 _3728_ sky130_fd_sc_hd__nor2_1
X_4381_ net201 net7 vssd1 vssd1 vccd1 vccd1 _3675_ sky130_fd_sc_hd__nor2_1
X_6120_ _1306_ _1307_ vssd1 vssd1 vccd1 vccd1 _1309_ sky130_fd_sc_hd__xnor2_1
XFILLER_85_217 vssd1 vssd1 vccd1 vccd1 sky130_fd_sc_hd__fill_4
X_6051_ _1239_ _1240_ vssd1 vssd1 vccd1 vccd1 _1241_ sky130_fd_sc_hd__nand2_1
XFILLER_78_280 vssd1 vssd1 vccd1 vccd1 sky130_fd_sc_hd__fill_4
X_5002_ _0189_ _0190_ _0187_ vssd1 vssd1 vccd1 vccd1 _0192_ sky130_fd_sc_hd__or3b_1
XFILLER_38_122 vssd1 vssd1 vccd1 vccd1 sky130_fd_sc_hd__fill_4
XFILLER_38_155 vssd1 vssd1 vccd1 vccd1 sky130_fd_sc_hd__fill_1
XTAP_TAPCELL_ROW_77_971 vssd1 vccd1 sky130_fd_sc_hd__tapvpwrvgnd_1
XFILLER_66_475 vssd1 vssd1 vccd1 vccd1 sky130_fd_sc_hd__fill_1
XFILLER_26_328 vssd1 vssd1 vccd1 vccd1 sky130_fd_sc_hd__fill_2
XFILLER_38_166 vssd1 vssd1 vccd1 vccd1 sky130_fd_sc_hd__fill_1
XFILLER_53_147 vssd1 vssd1 vccd1 vccd1 sky130_fd_sc_hd__fill_1
XTAP_TAPCELL_ROW_49_695 vssd1 vccd1 sky130_fd_sc_hd__tapvpwrvgnd_1
X_6953_ _2163_ _2164_ vssd1 vssd1 vccd1 vccd1 _2165_ sky130_fd_sc_hd__nand2_1
XFILLER_19_391 vssd1 vssd1 vccd1 vccd1 sky130_fd_sc_hd__fill_1
XANTENNA__4335__A net230 vssd1 vssd1 vccd1 vccd1 sky130_fd_sc_hd__diode_2
X_5904_ _1025_ _1052_ _1053_ _1093_ _1050_ vssd1 vssd1 vccd1 vccd1 _1094_ sky130_fd_sc_hd__a221o_1
X_6884_ _2080_ _2091_ vssd1 vssd1 vccd1 vccd1 _2093_ sky130_fd_sc_hd__xnor2_1
X_5835_ net251 net289 _1023_ vssd1 vssd1 vccd1 vccd1 _1025_ sky130_fd_sc_hd__and3_1
XFILLER_14_16 vssd1 vssd1 vccd1 vccd1 sky130_fd_sc_hd__fill_1
XPHY_EDGE_ROW_46_Left_139 vssd1 vssd1 vccd1 vccd1 sky130_fd_sc_hd__decap_3
XANTENNA__8388__RESET_B net328 vssd1 vssd1 vccd1 vccd1 sky130_fd_sc_hd__diode_2
X_5766_ _0945_ _0954_ vssd1 vssd1 vccd1 vccd1 _0956_ sky130_fd_sc_hd__xnor2_1
XANTENNA_fanout326_A net327 vssd1 vssd1 vccd1 vccd1 sky130_fd_sc_hd__diode_2
XANTENNA__7365__B net208 vssd1 vssd1 vccd1 vccd1 sky130_fd_sc_hd__diode_2
X_5697_ _0869_ _0886_ vssd1 vssd1 vccd1 vccd1 _0887_ sky130_fd_sc_hd__nand2_1
X_4717_ _3993_ _3994_ vssd1 vssd1 vccd1 vccd1 _3995_ sky130_fd_sc_hd__nor2_1
X_8485_ clknet_4_15_0_clk _0073_ net341 vssd1 vssd1 vccd1 vccd1 net34 sky130_fd_sc_hd__dfrtp_1
X_7505_ _2747_ _2748_ vssd1 vssd1 vccd1 vccd1 _2750_ sky130_fd_sc_hd__xor2_1
X_7436_ _2674_ _2676_ vssd1 vssd1 vccd1 vccd1 _2677_ sky130_fd_sc_hd__xnor2_1
X_4648_ _3919_ _3925_ vssd1 vssd1 vccd1 vccd1 _3926_ sky130_fd_sc_hd__xnor2_1
XANTENNA__5166__A net163 vssd1 vssd1 vccd1 vccd1 sky130_fd_sc_hd__diode_2
XANTENNA_fanout114_X net114 vssd1 vssd1 vccd1 vccd1 sky130_fd_sc_hd__diode_2
X_7367_ _2602_ _2603_ vssd1 vssd1 vccd1 vccd1 _2604_ sky130_fd_sc_hd__nor2_1
X_4579_ _3841_ _3842_ _3852_ _3855_ vssd1 vssd1 vccd1 vccd1 _3857_ sky130_fd_sc_hd__a211o_1
XPHY_EDGE_ROW_55_Left_148 vssd1 vssd1 vccd1 vccd1 sky130_fd_sc_hd__decap_3
X_6318_ _1499_ _1505_ vssd1 vssd1 vccd1 vccd1 _1506_ sky130_fd_sc_hd__xnor2_1
X_7298_ _2450_ _2457_ _2459_ vssd1 vssd1 vccd1 vccd1 _2530_ sky130_fd_sc_hd__a21bo_1
X_6249_ _1436_ _1437_ vssd1 vssd1 vccd1 vccd1 _1438_ sky130_fd_sc_hd__nor2_1
XFILLER_57_420 vssd1 vssd1 vccd1 vccd1 sky130_fd_sc_hd__fill_2
XFILLER_91_209 vssd1 vssd1 vccd1 vccd1 sky130_fd_sc_hd__fill_1
XTAP_TAPCELL_ROW_4_243 vssd1 vccd1 sky130_fd_sc_hd__tapvpwrvgnd_1
XFILLER_84_261 vssd1 vssd1 vccd1 vccd1 sky130_fd_sc_hd__fill_1
XANTENNA__6725__A net208 vssd1 vssd1 vccd1 vccd1 sky130_fd_sc_hd__diode_2
XFILLER_29_177 vssd1 vssd1 vccd1 vccd1 sky130_fd_sc_hd__fill_4
XPHY_EDGE_ROW_64_Left_157 vssd1 vssd1 vccd1 vccd1 sky130_fd_sc_hd__decap_3
XFILLER_55_89 vssd1 vssd1 vccd1 vccd1 sky130_fd_sc_hd__fill_2
XFILLER_13_501 vssd1 vssd1 vccd1 vccd1 sky130_fd_sc_hd__fill_2
XFILLER_25_350 vssd1 vssd1 vccd1 vccd1 sky130_fd_sc_hd__fill_2
XFILLER_32_309 vssd1 vssd1 vccd1 vccd1 sky130_fd_sc_hd__fill_4
XFILLER_71_44 vssd1 vssd1 vccd1 vccd1 sky130_fd_sc_hd__fill_4
XFILLER_9_505 vssd1 vssd1 vccd1 vccd1 sky130_fd_sc_hd__fill_4
XANTENNA__4899__B _0088_ vssd1 vssd1 vccd1 vccd1 sky130_fd_sc_hd__diode_2
XANTENNA__7521__B1 net97 vssd1 vssd1 vccd1 vccd1 sky130_fd_sc_hd__diode_2
XPHY_EDGE_ROW_73_Left_166 vssd1 vssd1 vccd1 vccd1 sky130_fd_sc_hd__decap_3
XFILLER_4_298 vssd1 vssd1 vccd1 vccd1 sky130_fd_sc_hd__fill_1
XFILLER_67_206 vccd1 vssd1 vccd1 vssd1 sky130_ef_sc_hd__decap_40_12
XANTENNA__6057__D net236 vssd1 vssd1 vccd1 vccd1 sky130_fd_sc_hd__diode_2
XFILLER_82_209 vssd1 vssd1 vccd1 vccd1 sky130_fd_sc_hd__fill_4
XFILLER_63_412 vssd1 vssd1 vccd1 vccd1 sky130_fd_sc_hd__fill_2
XFILLER_48_464 vccd1 vssd1 vccd1 vssd1 sky130_ef_sc_hd__decap_40_12
XPHY_EDGE_ROW_82_Left_175 vssd1 vssd1 vccd1 vccd1 sky130_fd_sc_hd__decap_3
XTAP_TAPCELL_ROW_74_941 vssd1 vccd1 sky130_fd_sc_hd__tapvpwrvgnd_1
XFILLER_63_434 vccd1 vssd1 vccd1 vssd1 sky130_ef_sc_hd__decap_40_12
XFILLER_90_253 vssd1 vssd1 vccd1 vccd1 sky130_fd_sc_hd__fill_8
XTAP_TAPCELL_ROW_85_1048 vssd1 vccd1 sky130_fd_sc_hd__tapvpwrvgnd_1
XTAP_TAPCELL_ROW_46_665 vssd1 vccd1 sky130_fd_sc_hd__tapvpwrvgnd_1
XFILLER_35_169 vssd1 vssd1 vccd1 vccd1 sky130_fd_sc_hd__fill_2
XFILLER_50_139 vssd1 vssd1 vccd1 vccd1 sky130_fd_sc_hd__fill_1
XFILLER_16_361 vssd1 vssd1 vccd1 vccd1 sky130_fd_sc_hd__fill_1
XFILLER_16_383 vssd1 vssd1 vccd1 vccd1 sky130_fd_sc_hd__fill_4
XTAP_TAPCELL_ROW_18_378 vssd1 vccd1 sky130_fd_sc_hd__tapvpwrvgnd_1
XANTENNA__8481__RESET_B net341 vssd1 vssd1 vccd1 vccd1 sky130_fd_sc_hd__diode_2
X_5620_ net323 net203 _0806_ _0808_ vssd1 vssd1 vccd1 vccd1 _0810_ sky130_fd_sc_hd__o2bb2a_1
X_5551_ _0738_ _0739_ net291 net236 vssd1 vssd1 vccd1 vccd1 _0741_ sky130_fd_sc_hd__and4b_1
X_8270_ _3262_ _3264_ _3411_ _3542_ vssd1 vssd1 vccd1 vccd1 _3543_ sky130_fd_sc_hd__a31o_1
X_4502_ _3723_ _3724_ vssd1 vssd1 vccd1 vccd1 _3780_ sky130_fd_sc_hd__xnor2_1
XPHY_EDGE_ROW_91_Left_184 vssd1 vssd1 vccd1 vccd1 sky130_fd_sc_hd__decap_3
X_5482_ _0662_ _0670_ _0671_ _0661_ vssd1 vssd1 vccd1 vccd1 _0672_ sky130_fd_sc_hd__a31o_1
XFILLER_6_50 vccd1 vssd1 vccd1 vssd1 sky130_ef_sc_hd__decap_40_12
X_7221_ _2086_ _2197_ _2200_ _2201_ vssd1 vssd1 vccd1 vccd1 _2449_ sky130_fd_sc_hd__a22o_1
X_4433_ net178 PID_INST.k2_calc.sum_reg\[26\] PID_INST.k2_calc.sum_reg\[27\] _3707_
+ vssd1 vssd1 vccd1 vccd1 _3712_ sky130_fd_sc_hd__and4_1
XFILLER_6_94 vssd1 vssd1 vccd1 vccd1 sky130_fd_sc_hd__fill_1
XFILLER_6_83 vssd1 vssd1 vccd1 vccd1 sky130_fd_sc_hd__fill_1
X_7152_ _2371_ _2372_ _2373_ vssd1 vssd1 vccd1 vccd1 _2375_ sky130_fd_sc_hd__o21ai_1
X_4364_ _3657_ _3658_ _3659_ vssd1 vssd1 vccd1 vccd1 _3661_ sky130_fd_sc_hd__or3_1
X_7083_ _2301_ _2302_ vssd1 vssd1 vccd1 vccd1 _2303_ sky130_fd_sc_hd__nor2_1
X_4295_ net316 net14 net171 vssd1 vssd1 vccd1 vccd1 _0018_ sky130_fd_sc_hd__mux2_1
XANTENNA__6079__B1 _0786_ vssd1 vssd1 vccd1 vccd1 sky130_fd_sc_hd__diode_2
X_6103_ net156 net21 vssd1 vssd1 vccd1 vccd1 _1293_ sky130_fd_sc_hd__and2b_1
X_6034_ _0813_ _0816_ _1223_ vssd1 vssd1 vccd1 vccd1 _1224_ sky130_fd_sc_hd__a21oi_2
XFILLER_39_420 vssd1 vssd1 vccd1 vccd1 sky130_fd_sc_hd__fill_1
XANTENNA_fanout276_A net277 vssd1 vssd1 vccd1 vccd1 sky130_fd_sc_hd__diode_2
XFILLER_54_401 vssd1 vssd1 vccd1 vccd1 sky130_fd_sc_hd__fill_2
XTAP_TAPCELL_ROW_1_213 vssd1 vccd1 sky130_fd_sc_hd__tapvpwrvgnd_1
X_7985_ _3023_ _3026_ _3239_ vssd1 vssd1 vccd1 vccd1 _3240_ sky130_fd_sc_hd__a21oi_1
XFILLER_26_114 vssd1 vssd1 vccd1 vccd1 sky130_fd_sc_hd__fill_2
X_6936_ net104 net37 vssd1 vssd1 vccd1 vccd1 _2148_ sky130_fd_sc_hd__nor2_1
X_6867_ net139 net50 _2074_ vssd1 vssd1 vccd1 vccd1 _2075_ sky130_fd_sc_hd__or3_1
XFILLER_22_320 vssd1 vssd1 vccd1 vccd1 sky130_fd_sc_hd__fill_4
XTAP_TAPCELL_ROW_80_999 vssd1 vccd1 sky130_fd_sc_hd__tapvpwrvgnd_1
XANTENNA__6280__A net223 vssd1 vssd1 vccd1 vccd1 sky130_fd_sc_hd__diode_2
X_5818_ _1001_ _1007_ vssd1 vssd1 vccd1 vccd1 _1008_ sky130_fd_sc_hd__or2_1
X_6798_ _1718_ _1721_ _1999_ vssd1 vssd1 vccd1 vccd1 _2001_ sky130_fd_sc_hd__nand3_1
X_5749_ net246 net290 _0892_ _0894_ vssd1 vssd1 vccd1 vccd1 _0939_ sky130_fd_sc_hd__o2bb2a_1
X_8468_ clknet_4_5_0_clk _0056_ net334 vssd1 vssd1 vccd1 vccd1 PID_INST.k2_calc.sum_reg\[24\]
+ sky130_fd_sc_hd__dfrtp_4
X_7419_ _2655_ _2656_ vssd1 vssd1 vccd1 vccd1 _2658_ sky130_fd_sc_hd__xnor2_1
X_8399_ clknet_4_3_0_clk _0019_ net335 vssd1 vssd1 vccd1 vccd1 PID_INST.k2_calc.reg_lc\[3\]
+ sky130_fd_sc_hd__dfrtp_1
XANTENNA_fanout91_A net92 vssd1 vssd1 vccd1 vccd1 sky130_fd_sc_hd__diode_2
XFILLER_89_353 vssd1 vssd1 vccd1 vccd1 sky130_fd_sc_hd__fill_2
XFILLER_89_386 vssd1 vssd1 vccd1 vccd1 sky130_fd_sc_hd__fill_1
XANTENNA__5911__X _1101_ vssd1 vssd1 vccd1 vccd1 sky130_fd_sc_hd__diode_2
XFILLER_2_19 vssd1 vssd1 vccd1 vccd1 sky130_fd_sc_hd__fill_8
Xteam_03_343 vssd1 vssd1 vccd1 vccd1 team_03_343/HI gpio_oeb[19] sky130_fd_sc_hd__conb_1
Xteam_03_354 vssd1 vssd1 vccd1 vccd1 team_03_354/HI gpio_oeb[30] sky130_fd_sc_hd__conb_1
XFILLER_77_559 vssd1 vssd1 vccd1 vccd1 sky130_fd_sc_hd__fill_1
Xteam_03_376 vssd1 vssd1 vccd1 vccd1 gpio_oeb[0] team_03_376/LO sky130_fd_sc_hd__conb_1
Xteam_03_365 vssd1 vssd1 vccd1 vccd1 team_03_365/HI gpio_out[7] sky130_fd_sc_hd__conb_1
Xteam_03_387 vssd1 vssd1 vccd1 vccd1 gpio_oeb[11] team_03_387/LO sky130_fd_sc_hd__conb_1
XANTENNA__6455__A net203 vssd1 vssd1 vccd1 vccd1 sky130_fd_sc_hd__diode_2
XFILLER_57_272 vssd1 vssd1 vccd1 vccd1 sky130_fd_sc_hd__fill_4
XFILLER_45_412 vssd1 vssd1 vccd1 vccd1 sky130_fd_sc_hd__fill_4
XANTENNA__4246__Y _2644_ vssd1 vssd1 vccd1 vccd1 sky130_fd_sc_hd__diode_2
XFILLER_17_125 vccd1 vssd1 vccd1 vssd1 sky130_ef_sc_hd__decap_40_12
XFILLER_45_478 vssd1 vssd1 vccd1 vccd1 sky130_fd_sc_hd__fill_2
XFILLER_82_54 vssd1 vssd1 vccd1 vccd1 sky130_fd_sc_hd__fill_1
XTAP_TAPCELL_ROW_71_911 vssd1 vccd1 sky130_fd_sc_hd__tapvpwrvgnd_1
XTAP_TAPCELL_ROW_43_635 vssd1 vccd1 sky130_fd_sc_hd__tapvpwrvgnd_1
XTAP_TAPCELL_ROW_15_348 vssd1 vccd1 sky130_fd_sc_hd__tapvpwrvgnd_1
XFILLER_9_313 vssd1 vssd1 vccd1 vccd1 sky130_fd_sc_hd__fill_1
XFILLER_9_302 vssd1 vssd1 vccd1 vccd1 sky130_fd_sc_hd__fill_2
XFILLER_40_161 vssd1 vssd1 vccd1 vccd1 sky130_fd_sc_hd__fill_1
XFILLER_9_335 vssd1 vssd1 vccd1 vccd1 sky130_fd_sc_hd__fill_1
XANTENNA__4556__B1 net78 vssd1 vssd1 vccd1 vccd1 sky130_fd_sc_hd__diode_2
XANTENNA__4308__A0 net252 vssd1 vssd1 vccd1 vccd1 sky130_fd_sc_hd__diode_2
XFILLER_56_7 vssd1 vssd1 vccd1 vccd1 sky130_fd_sc_hd__fill_1
XANTENNA__7452__C net282 vssd1 vssd1 vccd1 vccd1 sky130_fd_sc_hd__diode_2
XANTENNA__5520__A2 net296 vssd1 vssd1 vccd1 vccd1 sky130_fd_sc_hd__diode_2
XANTENNA__6349__B net74 vssd1 vssd1 vccd1 vccd1 sky130_fd_sc_hd__diode_2
XFILLER_68_548 vccd1 vssd1 vccd1 vssd1 sky130_ef_sc_hd__decap_40_12
XFILLER_48_261 vssd1 vssd1 vccd1 vccd1 sky130_fd_sc_hd__fill_1
XTAP_TAPCELL_ROW_59_790 vssd1 vccd1 sky130_fd_sc_hd__tapvpwrvgnd_1
X_7770_ _3008_ _3025_ vssd1 vssd1 vccd1 vccd1 _3026_ sky130_fd_sc_hd__or2_1
XFILLER_63_286 vssd1 vssd1 vccd1 vccd1 sky130_fd_sc_hd__fill_8
X_4982_ _0124_ _0128_ _0126_ vssd1 vssd1 vccd1 vccd1 _0172_ sky130_fd_sc_hd__o21ai_1
XFILLER_36_489 vssd1 vssd1 vccd1 vccd1 sky130_fd_sc_hd__fill_2
X_6721_ _1819_ _1822_ _1820_ vssd1 vssd1 vccd1 vccd1 _1919_ sky130_fd_sc_hd__o21ba_1
X_6652_ _1620_ _1634_ _1844_ vssd1 vssd1 vccd1 vccd1 _1846_ sky130_fd_sc_hd__and3_1
X_5603_ _0791_ _0792_ vssd1 vssd1 vccd1 vccd1 _0793_ sky130_fd_sc_hd__or2_1
XFILLER_31_194 vssd1 vssd1 vccd1 vccd1 sky130_fd_sc_hd__fill_1
X_8322_ _3595_ _3597_ vssd1 vssd1 vccd1 vccd1 _3598_ sky130_fd_sc_hd__xnor2_1
X_6583_ net97 net54 vssd1 vssd1 vccd1 vccd1 _1771_ sky130_fd_sc_hd__nor2_1
X_5534_ net249 net283 net295 net239 vssd1 vssd1 vccd1 vccd1 _0724_ sky130_fd_sc_hd__and4_1
X_8253_ _3522_ _3523_ vssd1 vssd1 vccd1 vccd1 _3524_ sky130_fd_sc_hd__nand2_1
X_5465_ net103 net58 vssd1 vssd1 vccd1 vccd1 _0655_ sky130_fd_sc_hd__or2_1
X_4416_ net181 _3700_ vssd1 vssd1 vccd1 vccd1 _3702_ sky130_fd_sc_hd__nand2_1
X_8184_ _3415_ _3447_ vssd1 vssd1 vccd1 vccd1 _3449_ sky130_fd_sc_hd__nor2_1
XANTENNA__5444__A net105 vssd1 vssd1 vccd1 vccd1 sky130_fd_sc_hd__diode_2
X_7204_ net99 net51 vssd1 vssd1 vccd1 vccd1 _2431_ sky130_fd_sc_hd__nor2_1
X_7135_ net208 net285 net280 net212 vssd1 vssd1 vccd1 vccd1 _2358_ sky130_fd_sc_hd__a22oi_1
Xfanout314 net316 vssd1 vssd1 vccd1 vccd1 net314 sky130_fd_sc_hd__buf_2
Xfanout303 net304 vssd1 vssd1 vccd1 vccd1 net303 sky130_fd_sc_hd__dlymetal6s2s_1
X_5396_ net115 net60 vssd1 vssd1 vccd1 vccd1 _0586_ sky130_fd_sc_hd__nor2_1
Xfanout325 PID_INST.k2_calc.reg_lc\[0\] vssd1 vssd1 vccd1 vccd1 net325 sky130_fd_sc_hd__buf_2
X_4347_ net226 _3646_ net161 vssd1 vssd1 vccd1 vccd1 _0038_ sky130_fd_sc_hd__mux2_1
Xfanout336 net338 vssd1 vssd1 vccd1 vccd1 net336 sky130_fd_sc_hd__buf_2
X_7066_ _2283_ _2284_ _2285_ vssd1 vssd1 vccd1 vccd1 _2286_ sky130_fd_sc_hd__or3_1
X_4278_ net13 PID_INST.k1_calc.d1.x\[1\] net157 vssd1 vssd1 vccd1 vccd1 _0001_ sky130_fd_sc_hd__mux2_1
XFILLER_74_507 vssd1 vssd1 vccd1 vccd1 sky130_fd_sc_hd__fill_4
X_6017_ _0580_ _0581_ _0579_ vssd1 vssd1 vccd1 vccd1 _1207_ sky130_fd_sc_hd__o21a_1
XANTENNA__6425__D net254 vssd1 vssd1 vccd1 vccd1 sky130_fd_sc_hd__diode_2
XFILLER_54_253 vccd1 vssd1 vccd1 vssd1 sky130_ef_sc_hd__decap_40_12
XFILLER_54_242 vssd1 vssd1 vccd1 vccd1 sky130_fd_sc_hd__fill_1
XFILLER_36_69 vssd1 vssd1 vccd1 vccd1 sky130_fd_sc_hd__fill_1
X_7968_ _3015_ _3017_ _3014_ vssd1 vssd1 vccd1 vccd1 _3223_ sky130_fd_sc_hd__o21ba_1
XANTENNA__5578__A2 net215 vssd1 vssd1 vccd1 vccd1 sky130_fd_sc_hd__diode_2
XFILLER_54_297 vssd1 vssd1 vccd1 vccd1 sky130_fd_sc_hd__fill_4
XFILLER_54_286 vssd1 vssd1 vccd1 vccd1 sky130_fd_sc_hd__fill_2
XFILLER_14_117 vssd1 vssd1 vccd1 vccd1 sky130_fd_sc_hd__fill_1
X_6919_ _2123_ _2128_ vssd1 vssd1 vccd1 vccd1 _2129_ sky130_fd_sc_hd__xnor2_1
X_7899_ net110 net38 vssd1 vssd1 vccd1 vccd1 _3154_ sky130_fd_sc_hd__nor2_1
XFILLER_14_139 vssd1 vssd1 vccd1 vccd1 sky130_fd_sc_hd__fill_1
XFILLER_42_448 vssd1 vssd1 vccd1 vccd1 sky130_fd_sc_hd__fill_2
XFILLER_42_459 vccd1 vssd1 vccd1 vssd1 sky130_ef_sc_hd__decap_40_12
XFILLER_50_470 vssd1 vssd1 vccd1 vccd1 sky130_fd_sc_hd__fill_2
XTAP_TAPCELL_ROW_12_318 vssd1 vccd1 sky130_fd_sc_hd__tapvpwrvgnd_1
XFILLER_22_150 vssd1 vssd1 vccd1 vccd1 sky130_fd_sc_hd__fill_1
XFILLER_22_161 vssd1 vssd1 vccd1 vccd1 sky130_fd_sc_hd__fill_8
XTAP_TAPCELL_ROW_40_605 vssd1 vccd1 sky130_fd_sc_hd__tapvpwrvgnd_1
XFILLER_10_323 vssd1 vssd1 vccd1 vccd1 sky130_fd_sc_hd__fill_2
XANTENNA__4538__B1 net89 vssd1 vssd1 vccd1 vccd1 sky130_fd_sc_hd__diode_2
XFILLER_10_356 vssd1 vssd1 vccd1 vccd1 sky130_fd_sc_hd__fill_2
XFILLER_10_378 vccd1 vssd1 vccd1 vssd1 sky130_ef_sc_hd__decap_40_12
XFILLER_2_533 vccd1 vssd1 vccd1 vssd1 sky130_ef_sc_hd__decap_40_12
XFILLER_89_150 vssd1 vssd1 vccd1 vccd1 sky130_fd_sc_hd__fill_4
XFILLER_77_54 vssd1 vssd1 vccd1 vccd1 sky130_fd_sc_hd__fill_2
XFILLER_89_194 vssd1 vssd1 vccd1 vccd1 sky130_fd_sc_hd__fill_8
XFILLER_77_334 vssd1 vssd1 vccd1 vccd1 sky130_fd_sc_hd__fill_2
XFILLER_65_529 vssd1 vssd1 vccd1 vccd1 sky130_fd_sc_hd__fill_4
XFILLER_18_401 vssd1 vssd1 vccd1 vccd1 sky130_fd_sc_hd__fill_1
XANTENNA__6185__A net127 vssd1 vssd1 vccd1 vccd1 sky130_fd_sc_hd__diode_2
XFILLER_18_412 vssd1 vssd1 vccd1 vccd1 sky130_fd_sc_hd__fill_8
XFILLER_18_423 vssd1 vssd1 vccd1 vccd1 sky130_fd_sc_hd__fill_1
XFILLER_73_551 vssd1 vssd1 vccd1 vccd1 sky130_fd_sc_hd__fill_8
XANTENNA__7963__B1 net190 vssd1 vssd1 vccd1 vccd1 sky130_fd_sc_hd__diode_2
XTAP_TAPCELL_ROW_82_1018 vssd1 vccd1 sky130_fd_sc_hd__tapvpwrvgnd_1
XTAP_TAPCELL_ROW_56_760 vssd1 vccd1 sky130_fd_sc_hd__tapvpwrvgnd_1
XTAP_TAPCELL_ROW_28_484 vssd1 vccd1 sky130_fd_sc_hd__tapvpwrvgnd_1
XFILLER_20_109 vssd1 vssd1 vccd1 vccd1 sky130_fd_sc_hd__fill_4
XFILLER_9_132 vssd1 vssd1 vccd1 vccd1 sky130_fd_sc_hd__fill_1
XFILLER_13_161 vssd1 vssd1 vccd1 vccd1 sky130_fd_sc_hd__fill_4
XFILLER_41_492 vssd1 vssd1 vccd1 vccd1 sky130_fd_sc_hd__fill_4
XFILLER_42_90 vssd1 vssd1 vccd1 vccd1 sky130_fd_sc_hd__fill_1
X_5250_ _2114_ net71 _0438_ vssd1 vssd1 vccd1 vccd1 _0440_ sky130_fd_sc_hd__or3_1
XFILLER_87_109 vssd1 vssd1 vccd1 vccd1 sky130_fd_sc_hd__fill_2
X_4201_ PID_INST.k3_calc.kd_term\[4\] net175 vssd1 vssd1 vccd1 vccd1 _2167_ sky130_fd_sc_hd__or2_1
XFILLER_68_312 vccd1 vssd1 vccd1 vssd1 sky130_ef_sc_hd__decap_40_12
X_5181_ _0364_ _0370_ vssd1 vssd1 vccd1 vccd1 _0371_ sky130_fd_sc_hd__xor2_1
XANTENNA__8294__B net276 vssd1 vssd1 vccd1 vccd1 sky130_fd_sc_hd__diode_2
XFILLER_3_62 vssd1 vssd1 vccd1 vccd1 sky130_fd_sc_hd__fill_4
XFILLER_83_315 vssd1 vssd1 vccd1 vccd1 sky130_fd_sc_hd__fill_1
XFILLER_28_209 vssd1 vssd1 vccd1 vccd1 sky130_fd_sc_hd__fill_2
XFILLER_83_337 vccd1 vssd1 vccd1 vssd1 sky130_ef_sc_hd__decap_40_12
XFILLER_91_381 vssd1 vssd1 vccd1 vccd1 sky130_fd_sc_hd__fill_1
X_7822_ net110 _1583_ vssd1 vssd1 vccd1 vccd1 _3078_ sky130_fd_sc_hd__nor2_1
X_7753_ net198 net272 net260 net213 vssd1 vssd1 vccd1 vccd1 _3009_ sky130_fd_sc_hd__a22o_1
XFILLER_51_223 vssd1 vssd1 vccd1 vccd1 sky130_fd_sc_hd__fill_1
X_4965_ _0082_ _0084_ _0152_ _0153_ vssd1 vssd1 vccd1 vccd1 _0155_ sky130_fd_sc_hd__a211oi_2
X_6704_ net270 net226 PID_INST.k2_calc.sum_reg\[5\] net265 vssd1 vssd1 vccd1 vccd1
+ _1901_ sky130_fd_sc_hd__a22oi_1
XFILLER_51_256 vssd1 vssd1 vccd1 vccd1 sky130_fd_sc_hd__fill_1
XANTENNA__5439__A net111 vssd1 vssd1 vccd1 vccd1 sky130_fd_sc_hd__diode_2
XANTENNA_fanout141_A net142 vssd1 vssd1 vccd1 vccd1 sky130_fd_sc_hd__diode_2
X_7684_ _2919_ _2937_ vssd1 vssd1 vccd1 vccd1 _2938_ sky130_fd_sc_hd__or2_1
XANTENNA_fanout239_A PID_INST.k2_calc.sum_reg\[3\] vssd1 vssd1 vccd1 vccd1 sky130_fd_sc_hd__diode_2
X_4896_ _0081_ _0082_ _4095_ _4099_ vssd1 vssd1 vccd1 vccd1 _0086_ sky130_fd_sc_hd__a211o_1
X_6635_ _1610_ _1617_ _1826_ vssd1 vssd1 vccd1 vccd1 _1828_ sky130_fd_sc_hd__nand3_1
XANTENNA__7654__A net293 vssd1 vssd1 vccd1 vccd1 sky130_fd_sc_hd__diode_2
XFILLER_22_27 vssd1 vssd1 vccd1 vccd1 sky130_fd_sc_hd__fill_1
XFILLER_22_38 vssd1 vssd1 vccd1 vccd1 sky130_fd_sc_hd__fill_1
X_6566_ _1752_ _1689_ vssd1 vssd1 vccd1 vccd1 _1753_ sky130_fd_sc_hd__nand2b_1
X_8305_ net322 PID_INST.k2_calc.sum_reg\[26\] _3503_ _3502_ vssd1 vssd1 vccd1 vccd1
+ _3580_ sky130_fd_sc_hd__a31o_1
X_5517_ net233 net296 vssd1 vssd1 vccd1 vccd1 _0707_ sky130_fd_sc_hd__nand2_1
X_8236_ _3503_ _3505_ vssd1 vssd1 vccd1 vccd1 _3506_ sky130_fd_sc_hd__xnor2_1
X_6497_ _1486_ _1487_ _1485_ vssd1 vssd1 vccd1 vccd1 _1685_ sky130_fd_sc_hd__a21o_1
X_5448_ _0633_ _0637_ _0631_ vssd1 vssd1 vccd1 vccd1 _0638_ sky130_fd_sc_hd__o21ba_1
XFILLER_59_301 vssd1 vssd1 vccd1 vccd1 sky130_fd_sc_hd__fill_2
Xfanout100 _2612_ vssd1 vssd1 vccd1 vccd1 net100 sky130_fd_sc_hd__clkbuf_4
X_5379_ _0148_ _0566_ _0568_ vssd1 vssd1 vccd1 vccd1 _0569_ sky130_fd_sc_hd__a21bo_1
Xfanout122 net123 vssd1 vssd1 vccd1 vccd1 net122 sky130_fd_sc_hd__buf_2
Xfanout111 net112 vssd1 vssd1 vccd1 vccd1 net111 sky130_fd_sc_hd__clkbuf_4
X_8167_ net102 net39 vssd1 vssd1 vccd1 vccd1 _3432_ sky130_fd_sc_hd__or2_1
X_8098_ net202 net260 net192 net272 vssd1 vssd1 vccd1 vccd1 _3357_ sky130_fd_sc_hd__a22o_1
X_7118_ _2337_ _2338_ vssd1 vssd1 vccd1 vccd1 _2339_ sky130_fd_sc_hd__xnor2_1
Xfanout155 net156 vssd1 vssd1 vccd1 vccd1 net155 sky130_fd_sc_hd__clkbuf_2
Xfanout144 net146 vssd1 vssd1 vccd1 vccd1 net144 sky130_fd_sc_hd__clkbuf_2
Xfanout133 net134 vssd1 vssd1 vccd1 vccd1 net133 sky130_fd_sc_hd__clkbuf_4
X_7049_ net215 net212 net285 net280 vssd1 vssd1 vccd1 vccd1 _2268_ sky130_fd_sc_hd__and4_1
Xfanout199 net200 vssd1 vssd1 vccd1 vccd1 net199 sky130_fd_sc_hd__buf_2
Xfanout188 PID_INST.k2_calc.sum_reg\[17\] vssd1 vssd1 vccd1 vccd1 net188 sky130_fd_sc_hd__buf_2
XFILLER_59_356 vssd1 vssd1 vccd1 vccd1 sky130_fd_sc_hd__fill_2
Xfanout177 PID_INST.pid.curr_state\[0\] vssd1 vssd1 vccd1 vccd1 net177 sky130_fd_sc_hd__clkbuf_2
Xfanout166 PID_INST.k3_calc.d1.y\[13\] vssd1 vssd1 vccd1 vccd1 net166 sky130_fd_sc_hd__buf_2
XFILLER_86_197 vssd1 vssd1 vccd1 vccd1 sky130_fd_sc_hd__fill_2
XFILLER_86_175 vssd1 vssd1 vccd1 vccd1 sky130_fd_sc_hd__fill_2
XPHY_EDGE_ROW_29_Right_29 vssd1 vssd1 vccd1 vccd1 sky130_fd_sc_hd__decap_3
XANTENNA__8198__B1 net189 vssd1 vssd1 vccd1 vccd1 sky130_fd_sc_hd__diode_2
XFILLER_27_220 vssd1 vssd1 vccd1 vccd1 sky130_fd_sc_hd__fill_4
XFILLER_27_253 vssd1 vssd1 vccd1 vccd1 sky130_fd_sc_hd__fill_2
XTAP_TAPCELL_ROW_53_730 vssd1 vccd1 sky130_fd_sc_hd__tapvpwrvgnd_1
XTAP_TAPCELL_ROW_25_454 vssd1 vccd1 sky130_fd_sc_hd__tapvpwrvgnd_1
XFILLER_30_407 vssd1 vssd1 vccd1 vccd1 sky130_fd_sc_hd__fill_1
XFILLER_8_29 vssd1 vssd1 vccd1 vccd1 sky130_fd_sc_hd__fill_2
XFILLER_8_18 vssd1 vssd1 vccd1 vccd1 sky130_fd_sc_hd__fill_1
XPHY_EDGE_ROW_38_Right_38 vssd1 vssd1 vccd1 vccd1 sky130_fd_sc_hd__decap_3
XFILLER_10_186 vssd1 vssd1 vccd1 vccd1 sky130_fd_sc_hd__fill_1
XFILLER_10_164 vssd1 vssd1 vccd1 vccd1 sky130_fd_sc_hd__fill_2
XFILLER_10_197 vssd1 vssd1 vccd1 vccd1 sky130_fd_sc_hd__fill_1
XANTENNA__7283__B net42 vssd1 vssd1 vccd1 vccd1 sky130_fd_sc_hd__diode_2
XFILLER_88_64 vssd1 vssd1 vccd1 vccd1 sky130_fd_sc_hd__fill_4
XFILLER_77_131 vssd1 vssd1 vccd1 vccd1 sky130_fd_sc_hd__fill_8
XPHY_EDGE_ROW_47_Right_47 vssd1 vssd1 vccd1 vccd1 sky130_fd_sc_hd__decap_3
XFILLER_92_167 vssd1 vssd1 vccd1 vccd1 sky130_fd_sc_hd__fill_1
XFILLER_73_370 vssd1 vssd1 vccd1 vccd1 sky130_fd_sc_hd__fill_1
XFILLER_18_253 vccd1 vssd1 vccd1 vssd1 sky130_ef_sc_hd__decap_40_12
XFILLER_33_223 vssd1 vssd1 vccd1 vccd1 sky130_fd_sc_hd__fill_1
XANTENNA__5411__A1 net104 vssd1 vssd1 vccd1 vccd1 sky130_fd_sc_hd__diode_2
XFILLER_33_278 vssd1 vssd1 vccd1 vccd1 sky130_fd_sc_hd__fill_2
XPHY_EDGE_ROW_56_Right_56 vssd1 vssd1 vccd1 vccd1 sky130_fd_sc_hd__decap_3
X_4750_ _3832_ _4001_ _4002_ _4000_ vssd1 vssd1 vccd1 vccd1 _4028_ sky130_fd_sc_hd__a22o_1
XFILLER_14_481 vssd1 vssd1 vccd1 vccd1 sky130_fd_sc_hd__fill_8
X_4681_ _3929_ _3956_ _3957_ _3958_ vssd1 vssd1 vccd1 vccd1 _3959_ sky130_fd_sc_hd__a22o_1
X_6420_ _1606_ _1607_ vssd1 vssd1 vccd1 vccd1 _1608_ sky130_fd_sc_hd__xnor2_1
XANTENNA__5714__A2 net306 vssd1 vssd1 vccd1 vccd1 sky130_fd_sc_hd__diode_2
X_6351_ _1987_ net72 vssd1 vssd1 vccd1 vccd1 _1539_ sky130_fd_sc_hd__nor2_1
X_5302_ _0489_ _0490_ vssd1 vssd1 vccd1 vccd1 _0492_ sky130_fd_sc_hd__xnor2_1
X_6282_ _1463_ _1464_ _1470_ vssd1 vssd1 vccd1 vccd1 _1471_ sky130_fd_sc_hd__nand3_1
XPHY_EDGE_ROW_65_Right_65 vssd1 vssd1 vccd1 vccd1 sky130_fd_sc_hd__decap_3
X_8021_ _3273_ _3274_ vssd1 vssd1 vccd1 vccd1 _3275_ sky130_fd_sc_hd__nand2_1
X_5233_ _0422_ _0421_ vssd1 vssd1 vccd1 vccd1 _0423_ sky130_fd_sc_hd__nand2b_1
X_5164_ _0353_ _0346_ vssd1 vssd1 vccd1 vccd1 _0354_ sky130_fd_sc_hd__nand2b_1
XANTENNA_fanout189_A net190 vssd1 vssd1 vccd1 vccd1 sky130_fd_sc_hd__diode_2
X_5095_ _0276_ _0283_ vssd1 vssd1 vccd1 vccd1 _0285_ sky130_fd_sc_hd__and2_1
XTAP_TAPCELL_ROW_67_866 vssd1 vccd1 sky130_fd_sc_hd__tapvpwrvgnd_1
XFILLER_83_167 vssd1 vssd1 vccd1 vccd1 sky130_fd_sc_hd__fill_1
XANTENNA__7368__B net193 vssd1 vssd1 vccd1 vccd1 sky130_fd_sc_hd__diode_2
X_7805_ _3059_ _3060_ vssd1 vssd1 vccd1 vccd1 _3061_ sky130_fd_sc_hd__or2_1
XPHY_EDGE_ROW_74_Right_74 vssd1 vssd1 vccd1 vccd1 sky130_fd_sc_hd__decap_3
XANTENNA__6703__D net230 vssd1 vssd1 vccd1 vccd1 sky130_fd_sc_hd__diode_2
XTAP_TAPCELL_ROW_50_700 vssd1 vccd1 sky130_fd_sc_hd__tapvpwrvgnd_1
XFILLER_12_407 vssd1 vssd1 vccd1 vccd1 sky130_fd_sc_hd__fill_4
XANTENNA__4205__A2 net173 vssd1 vssd1 vccd1 vccd1 sky130_fd_sc_hd__diode_2
X_5997_ _1183_ _1184_ vssd1 vssd1 vccd1 vccd1 _1187_ sky130_fd_sc_hd__xor2_2
X_7736_ _2905_ _2907_ _2904_ vssd1 vssd1 vccd1 vccd1 _2992_ sky130_fd_sc_hd__o21ba_1
X_4948_ _0101_ _0137_ vssd1 vssd1 vccd1 vccd1 _0138_ sky130_fd_sc_hd__xnor2_1
XFILLER_12_429 vssd1 vssd1 vccd1 vccd1 sky130_fd_sc_hd__fill_4
XTAP_TAPCELL_ROW_22_424 vssd1 vccd1 sky130_fd_sc_hd__tapvpwrvgnd_1
XFILLER_24_289 vssd1 vssd1 vccd1 vccd1 sky130_fd_sc_hd__fill_4
XFILLER_33_59 vssd1 vssd1 vccd1 vccd1 sky130_fd_sc_hd__fill_4
X_7667_ _2920_ vssd1 vssd1 vccd1 vccd1 _2921_ sky130_fd_sc_hd__inv_2
X_4879_ _4155_ _4156_ vssd1 vssd1 vccd1 vccd1 _4157_ sky130_fd_sc_hd__nand2_1
X_6618_ net270 net265 net232 net234 vssd1 vssd1 vccd1 vccd1 _1810_ sky130_fd_sc_hd__and4_1
XANTENNA_fanout311_X net311 vssd1 vssd1 vccd1 vccd1 sky130_fd_sc_hd__diode_2
XFILLER_20_495 vssd1 vssd1 vccd1 vccd1 sky130_fd_sc_hd__fill_1
X_7598_ _2836_ _2848_ vssd1 vssd1 vccd1 vccd1 _2849_ sky130_fd_sc_hd__xnor2_1
X_6549_ _1574_ _1575_ _1573_ vssd1 vssd1 vccd1 vccd1 _1736_ sky130_fd_sc_hd__o21ba_1
XPHY_EDGE_ROW_83_Right_83 vssd1 vssd1 vccd1 vccd1 sky130_fd_sc_hd__decap_3
X_8219_ net298 net179 PID_INST.k2_calc.sum_reg\[24\] net310 vssd1 vssd1 vccd1 vccd1
+ _3487_ sky130_fd_sc_hd__a22oi_1
XFILLER_28_551 vccd1 vssd1 vccd1 vssd1 sky130_ef_sc_hd__decap_40_12
XFILLER_74_189 vssd1 vssd1 vccd1 vccd1 sky130_fd_sc_hd__fill_1
XFILLER_74_55 vssd1 vssd1 vccd1 vccd1 sky130_fd_sc_hd__fill_2
XFILLER_62_307 vssd1 vssd1 vccd1 vccd1 sky130_fd_sc_hd__fill_1
XPHY_EDGE_ROW_92_Right_92 vssd1 vssd1 vccd1 vccd1 sky130_fd_sc_hd__decap_3
XFILLER_74_99 vssd1 vssd1 vccd1 vccd1 sky130_fd_sc_hd__fill_8
XFILLER_43_521 vssd1 vssd1 vccd1 vccd1 sky130_fd_sc_hd__fill_1
XFILLER_15_267 vssd1 vssd1 vccd1 vccd1 sky130_fd_sc_hd__fill_1
XANTENNA__6182__B _0156_ vssd1 vssd1 vccd1 vccd1 sky130_fd_sc_hd__diode_2
XFILLER_70_373 vssd1 vssd1 vccd1 vccd1 sky130_fd_sc_hd__fill_2
XFILLER_23_81 vssd1 vssd1 vccd1 vccd1 sky130_fd_sc_hd__fill_1
XANTENNA__7741__B net187 vssd1 vssd1 vccd1 vccd1 sky130_fd_sc_hd__diode_2
XANTENNA__5542__A net236 vssd1 vssd1 vccd1 vccd1 sky130_fd_sc_hd__diode_2
XFILLER_2_182 vccd1 vssd1 vccd1 vssd1 sky130_ef_sc_hd__decap_40_12
XFILLER_38_304 vssd1 vssd1 vccd1 vccd1 sky130_fd_sc_hd__fill_1
XTAP_TAPCELL_ROW_88_1079 vssd1 vccd1 sky130_fd_sc_hd__tapvpwrvgnd_1
X_5920_ _1107_ _1109_ vssd1 vssd1 vccd1 vccd1 _1110_ sky130_fd_sc_hd__xnor2_1
XFILLER_0_41 vssd1 vssd1 vccd1 vccd1 sky130_fd_sc_hd__fill_2
XTAP_TAPCELL_ROW_64_836 vssd1 vccd1 sky130_fd_sc_hd__tapvpwrvgnd_1
XFILLER_0_96 vssd1 vssd1 vccd1 vccd1 sky130_fd_sc_hd__fill_4
X_5851_ _1022_ _1040_ vssd1 vssd1 vccd1 vccd1 _1041_ sky130_fd_sc_hd__nor2_1
XFILLER_61_395 vssd1 vssd1 vccd1 vccd1 sky130_fd_sc_hd__fill_2
X_5782_ _0964_ _0971_ _0969_ vssd1 vssd1 vccd1 vccd1 _0972_ sky130_fd_sc_hd__a21o_1
X_4802_ _3989_ _4007_ _4078_ _4079_ vssd1 vssd1 vccd1 vccd1 _4080_ sky130_fd_sc_hd__o211a_1
XFILLER_21_204 vssd1 vssd1 vccd1 vccd1 sky130_fd_sc_hd__fill_1
XFILLER_21_237 vccd1 vssd1 vccd1 vssd1 sky130_ef_sc_hd__decap_40_12
XANTENNA__4199__A1 net17 vssd1 vssd1 vccd1 vccd1 sky130_fd_sc_hd__diode_2
X_4733_ _4008_ _4009_ vssd1 vssd1 vccd1 vccd1 _4011_ sky130_fd_sc_hd__xnor2_1
X_7521_ _2182_ _2502_ net97 net46 vssd1 vssd1 vccd1 vccd1 _2767_ sky130_fd_sc_hd__a211oi_2
X_7452_ net198 net202 net282 net277 vssd1 vssd1 vccd1 vccd1 _2693_ sky130_fd_sc_hd__and4_1
X_4664_ net148 PID_INST.k3_calc.d1.y\[1\] net151 net145 vssd1 vssd1 vccd1 vccd1 _3942_
+ sky130_fd_sc_hd__a31o_1
X_6403_ _1588_ _1589_ vssd1 vssd1 vccd1 vccd1 _1591_ sky130_fd_sc_hd__xnor2_1
X_7383_ _2617_ _2618_ _2619_ vssd1 vssd1 vccd1 vccd1 _2621_ sky130_fd_sc_hd__o21ai_1
X_4595_ _3758_ _3871_ vssd1 vssd1 vccd1 vccd1 _3873_ sky130_fd_sc_hd__xor2_1
XANTENNA__7932__A net217 vssd1 vssd1 vccd1 vccd1 sky130_fd_sc_hd__diode_2
X_6334_ _1312_ _1323_ _1520_ vssd1 vssd1 vccd1 vccd1 _1522_ sky130_fd_sc_hd__or3_1
XANTENNA__8430__CLK clknet_4_0_0_clk vssd1 vssd1 vccd1 vccd1 sky130_fd_sc_hd__diode_2
XANTENNA__7651__B net299 vssd1 vssd1 vccd1 vccd1 sky130_fd_sc_hd__diode_2
X_6265_ _1445_ _1453_ vssd1 vssd1 vccd1 vccd1 _1454_ sky130_fd_sc_hd__xnor2_1
X_8004_ _3257_ _3258_ vssd1 vssd1 vccd1 vccd1 _3259_ sky130_fd_sc_hd__nor2_2
XFILLER_0_119 vssd1 vssd1 vccd1 vccd1 sky130_fd_sc_hd__fill_1
X_5216_ net162 net89 vssd1 vssd1 vccd1 vccd1 _0406_ sky130_fd_sc_hd__nand2_1
XANTENNA__4674__A2 net86 vssd1 vssd1 vccd1 vccd1 sky130_fd_sc_hd__diode_2
X_6196_ _1172_ _1174_ vssd1 vssd1 vccd1 vccd1 _1385_ sky130_fd_sc_hd__nand2_1
XFILLER_84_410 vssd1 vssd1 vccd1 vccd1 sky130_fd_sc_hd__fill_8
XFILLER_29_304 vssd1 vssd1 vccd1 vccd1 sky130_fd_sc_hd__fill_4
XFILLER_29_337 vccd1 vssd1 vccd1 vssd1 sky130_ef_sc_hd__decap_40_12
X_5147_ _0160_ _0335_ _0336_ vssd1 vssd1 vccd1 vccd1 _0337_ sky130_fd_sc_hd__a21oi_1
XFILLER_56_145 vssd1 vssd1 vccd1 vccd1 sky130_fd_sc_hd__fill_1
X_5078_ net138 net87 _0188_ vssd1 vssd1 vccd1 vccd1 _0268_ sky130_fd_sc_hd__and3_1
XFILLER_29_359 vssd1 vssd1 vccd1 vccd1 sky130_fd_sc_hd__fill_8
XFILLER_44_307 vssd1 vssd1 vccd1 vccd1 sky130_fd_sc_hd__fill_1
XFILLER_52_340 vssd1 vssd1 vccd1 vccd1 sky130_fd_sc_hd__fill_2
XFILLER_40_524 vssd1 vssd1 vccd1 vccd1 sky130_fd_sc_hd__fill_1
X_7719_ net267 net201 net205 net263 vssd1 vssd1 vccd1 vccd1 _2975_ sky130_fd_sc_hd__a22oi_1
XFILLER_20_292 vssd1 vssd1 vccd1 vccd1 sky130_fd_sc_hd__fill_4
XANTENNA__8446__Q PID_INST.k2_calc.sum_reg\[2\] vssd1 vssd1 vccd1 vccd1 sky130_fd_sc_hd__diode_2
XTAP_TAPCELL_ROW_7_274 vssd1 vccd1 sky130_fd_sc_hd__tapvpwrvgnd_1
XANTENNA__5512__D net278 vssd1 vssd1 vccd1 vccd1 sky130_fd_sc_hd__diode_2
XFILLER_90_413 vssd1 vssd1 vccd1 vccd1 sky130_fd_sc_hd__fill_4
XFILLER_75_465 vssd1 vssd1 vccd1 vccd1 sky130_fd_sc_hd__fill_2
XFILLER_47_167 vssd1 vssd1 vccd1 vccd1 sky130_fd_sc_hd__fill_1
XANTENNA__4706__A net123 vssd1 vssd1 vccd1 vccd1 sky130_fd_sc_hd__diode_2
XFILLER_28_370 vssd1 vssd1 vccd1 vccd1 sky130_fd_sc_hd__fill_1
XFILLER_90_468 vssd1 vssd1 vccd1 vccd1 sky130_fd_sc_hd__fill_8
XTAP_TAPCELL_ROW_61_806 vssd1 vccd1 sky130_fd_sc_hd__tapvpwrvgnd_1
XFILLER_31_557 vssd1 vssd1 vccd1 vccd1 sky130_fd_sc_hd__fill_2
XFILLER_79_6 vssd1 vssd1 vccd1 vccd1 sky130_fd_sc_hd__fill_2
XFILLER_7_263 vssd1 vssd1 vccd1 vccd1 sky130_fd_sc_hd__fill_2
X_4380_ net201 net7 vssd1 vssd1 vccd1 vccd1 _3674_ sky130_fd_sc_hd__and2_1
X_6050_ _1236_ _1237_ _1238_ vssd1 vssd1 vccd1 vccd1 _1240_ sky130_fd_sc_hd__o21ai_1
X_5001_ _0189_ _0190_ vssd1 vssd1 vccd1 vccd1 _0191_ sky130_fd_sc_hd__or2_1
XFILLER_78_292 vssd1 vssd1 vccd1 vccd1 sky130_fd_sc_hd__fill_1
XTAP_TAPCELL_ROW_77_972 vssd1 vccd1 sky130_fd_sc_hd__tapvpwrvgnd_1
XFILLER_26_307 vssd1 vssd1 vccd1 vccd1 sky130_fd_sc_hd__fill_1
X_6952_ net93 net62 _2162_ vssd1 vssd1 vccd1 vccd1 _2164_ sky130_fd_sc_hd__o21ai_1
X_5903_ _1025_ _1052_ _1055_ _1071_ _1092_ vssd1 vssd1 vccd1 vccd1 _1093_ sky130_fd_sc_hd__o221a_1
XANTENNA__4335__B net17 vssd1 vssd1 vccd1 vccd1 sky130_fd_sc_hd__diode_2
XFILLER_53_159 vssd1 vssd1 vccd1 vccd1 sky130_fd_sc_hd__fill_2
X_6883_ _2080_ _2091_ vssd1 vssd1 vccd1 vccd1 _2092_ sky130_fd_sc_hd__nand2_1
XFILLER_34_340 vssd1 vssd1 vccd1 vccd1 sky130_fd_sc_hd__fill_2
X_5834_ net251 net289 vssd1 vssd1 vccd1 vccd1 _1024_ sky130_fd_sc_hd__nand2_1
X_5765_ _0945_ _0954_ vssd1 vssd1 vccd1 vccd1 _0955_ sky130_fd_sc_hd__and2b_1
XANTENNA__7365__C net285 vssd1 vssd1 vccd1 vccd1 sky130_fd_sc_hd__diode_2
XANTENNA_fanout319_A net321 vssd1 vssd1 vccd1 vccd1 sky130_fd_sc_hd__diode_2
X_5696_ _0866_ _0868_ vssd1 vssd1 vccd1 vccd1 _0886_ sky130_fd_sc_hd__or2_1
X_4716_ PID_INST.k1_calc.d1.x\[10\] PID_INST.k3_calc.prev_error\[10\] vssd1 vssd1
+ vccd1 vccd1 _3994_ sky130_fd_sc_hd__and2_1
X_8484_ clknet_4_15_0_clk _0072_ net341 vssd1 vssd1 vccd1 vccd1 net33 sky130_fd_sc_hd__dfrtp_1
X_7504_ _2747_ _2748_ vssd1 vssd1 vccd1 vccd1 _2749_ sky130_fd_sc_hd__nand2b_1
X_7435_ net293 net192 vssd1 vssd1 vccd1 vccd1 _2676_ sky130_fd_sc_hd__nand2_1
X_4647_ _3922_ _3924_ vssd1 vssd1 vccd1 vccd1 _3925_ sky130_fd_sc_hd__nand2_1
XFILLER_30_27 vssd1 vssd1 vccd1 vccd1 sky130_fd_sc_hd__fill_1
X_7366_ net204 net285 net280 net208 vssd1 vssd1 vccd1 vccd1 _2603_ sky130_fd_sc_hd__a22oi_1
XANTENNA__4344__A1 net230 vssd1 vssd1 vccd1 vccd1 sky130_fd_sc_hd__diode_2
XANTENNA_fanout107_X net107 vssd1 vssd1 vccd1 vccd1 sky130_fd_sc_hd__diode_2
X_4578_ _3852_ _3855_ _3841_ _3842_ vssd1 vssd1 vccd1 vccd1 _3856_ sky130_fd_sc_hd__o211ai_1
X_6317_ _1502_ _1503_ vssd1 vssd1 vccd1 vccd1 _1505_ sky130_fd_sc_hd__xnor2_1
XFILLER_89_557 vssd1 vssd1 vccd1 vccd1 sky130_fd_sc_hd__fill_2
XFILLER_89_524 vssd1 vssd1 vccd1 vccd1 sky130_fd_sc_hd__fill_2
X_7297_ _2403_ _2409_ _2411_ _2412_ vssd1 vssd1 vccd1 vccd1 _2529_ sky130_fd_sc_hd__a2bb2o_1
XFILLER_76_207 vssd1 vssd1 vccd1 vccd1 sky130_fd_sc_hd__fill_4
X_6248_ _1426_ _1427_ _1435_ vssd1 vssd1 vccd1 vccd1 _1437_ sky130_fd_sc_hd__a21oi_1
X_6179_ _1146_ _1151_ _1153_ vssd1 vssd1 vccd1 vccd1 _1368_ sky130_fd_sc_hd__a21bo_1
XFILLER_69_292 vccd1 vssd1 vccd1 vssd1 sky130_ef_sc_hd__decap_40_12
XFILLER_57_454 vssd1 vssd1 vccd1 vccd1 sky130_fd_sc_hd__fill_1
XTAP_TAPCELL_ROW_4_244 vssd1 vccd1 sky130_fd_sc_hd__tapvpwrvgnd_1
XFILLER_84_251 vssd1 vssd1 vccd1 vccd1 sky130_fd_sc_hd__fill_1
XFILLER_29_167 vssd1 vssd1 vccd1 vccd1 sky130_fd_sc_hd__fill_1
XFILLER_57_498 vssd1 vssd1 vccd1 vccd1 sky130_fd_sc_hd__fill_4
XANTENNA__4526__A net123 vssd1 vssd1 vccd1 vccd1 sky130_fd_sc_hd__diode_2
XANTENNA__4280__A0 net15 vssd1 vssd1 vccd1 vccd1 sky130_fd_sc_hd__diode_2
XFILLER_52_170 vssd1 vssd1 vccd1 vccd1 sky130_fd_sc_hd__fill_1
XANTENNA__7837__A net119 vssd1 vssd1 vccd1 vccd1 sky130_fd_sc_hd__diode_2
XFILLER_13_568 vssd1 vssd1 vccd1 vccd1 sky130_fd_sc_hd__fill_2
XFILLER_40_321 vssd1 vssd1 vccd1 vccd1 sky130_fd_sc_hd__fill_1
XFILLER_40_343 vssd1 vssd1 vccd1 vccd1 sky130_fd_sc_hd__fill_4
XANTENNA__8004__Y _3259_ vssd1 vssd1 vccd1 vccd1 sky130_fd_sc_hd__diode_2
XANTENNA__6460__B net297 vssd1 vssd1 vccd1 vccd1 sky130_fd_sc_hd__diode_2
XFILLER_67_218 vssd1 vssd1 vccd1 vccd1 sky130_fd_sc_hd__fill_4
XFILLER_0_461 vssd1 vssd1 vccd1 vccd1 sky130_fd_sc_hd__fill_1
XFILLER_48_421 vssd1 vssd1 vccd1 vccd1 sky130_fd_sc_hd__fill_1
XFILLER_90_221 vssd1 vssd1 vccd1 vccd1 sky130_fd_sc_hd__fill_2
XTAP_TAPCELL_ROW_74_942 vssd1 vccd1 sky130_fd_sc_hd__tapvpwrvgnd_1
XFILLER_63_446 vssd1 vssd1 vccd1 vccd1 sky130_fd_sc_hd__fill_2
XTAP_TAPCELL_ROW_85_1049 vssd1 vccd1 sky130_fd_sc_hd__tapvpwrvgnd_1
XFILLER_35_148 vssd1 vssd1 vccd1 vccd1 sky130_fd_sc_hd__fill_1
XFILLER_50_129 vssd1 vssd1 vccd1 vccd1 sky130_fd_sc_hd__fill_2
XTAP_TAPCELL_ROW_18_379 vssd1 vccd1 sky130_fd_sc_hd__tapvpwrvgnd_1
X_5550_ _0739_ vssd1 vssd1 vccd1 vccd1 _0740_ sky130_fd_sc_hd__inv_2
X_4501_ net132 net152 vssd1 vssd1 vccd1 vccd1 _3779_ sky130_fd_sc_hd__nand2_1
X_5481_ net103 net55 _0669_ vssd1 vssd1 vccd1 vccd1 _0671_ sky130_fd_sc_hd__o21ai_1
X_4432_ net178 PID_INST.k2_calc.sum_reg\[26\] _3707_ vssd1 vssd1 vccd1 vccd1 _3711_
+ sky130_fd_sc_hd__and3_1
X_7220_ _2446_ _2447_ vssd1 vssd1 vccd1 vccd1 _2448_ sky130_fd_sc_hd__xor2_1
XANTENNA__8297__B net187 vssd1 vssd1 vccd1 vccd1 sky130_fd_sc_hd__diode_2
X_7151_ _2371_ _2372_ _2373_ vssd1 vssd1 vccd1 vccd1 _2374_ sky130_fd_sc_hd__or3_1
X_4363_ _3658_ _3659_ _3657_ vssd1 vssd1 vccd1 vccd1 _3660_ sky130_fd_sc_hd__o21ai_1
X_7082_ _1964_ _1967_ _2300_ vssd1 vssd1 vccd1 vccd1 _2302_ sky130_fd_sc_hd__nor3_1
X_4294_ net321 net13 net171 vssd1 vssd1 vccd1 vccd1 _0017_ sky130_fd_sc_hd__mux2_1
X_6102_ _1102_ _1290_ vssd1 vssd1 vccd1 vccd1 _1292_ sky130_fd_sc_hd__or2_1
XFILLER_86_549 vccd1 vssd1 vccd1 vssd1 sky130_ef_sc_hd__decap_40_12
X_6033_ _1221_ _1222_ vssd1 vssd1 vccd1 vccd1 _1223_ sky130_fd_sc_hd__nand2_1
XTAP_TAPCELL_ROW_1_214 vssd1 vccd1 sky130_fd_sc_hd__tapvpwrvgnd_1
X_7984_ net309 net182 _3009_ _3010_ net272 vssd1 vssd1 vccd1 vccd1 _3239_ sky130_fd_sc_hd__a32oi_1
XFILLER_81_243 vssd1 vssd1 vccd1 vccd1 sky130_fd_sc_hd__fill_2
XFILLER_54_479 vssd1 vssd1 vccd1 vccd1 sky130_fd_sc_hd__fill_1
X_6935_ _2119_ _2145_ vssd1 vssd1 vccd1 vccd1 _2147_ sky130_fd_sc_hd__xnor2_2
XFILLER_41_107 vssd1 vssd1 vccd1 vccd1 sky130_fd_sc_hd__fill_4
X_6866_ _1771_ _2073_ vssd1 vssd1 vccd1 vccd1 _2074_ sky130_fd_sc_hd__xnor2_1
XANTENNA__6280__B net287 vssd1 vssd1 vccd1 vccd1 sky130_fd_sc_hd__diode_2
X_5817_ _1001_ _1005_ _1006_ vssd1 vssd1 vccd1 vccd1 _1007_ sky130_fd_sc_hd__nor3_1
X_6797_ _1718_ _1721_ _1999_ vssd1 vssd1 vccd1 vccd1 _2000_ sky130_fd_sc_hd__a21o_1
XFILLER_22_365 vccd1 vssd1 vccd1 vssd1 sky130_ef_sc_hd__decap_40_12
X_5748_ _0933_ _0934_ _0935_ vssd1 vssd1 vccd1 vccd1 _0938_ sky130_fd_sc_hd__or3_1
XFILLER_22_387 vccd1 vssd1 vccd1 vssd1 sky130_ef_sc_hd__decap_40_12
XFILLER_41_48 vssd1 vssd1 vccd1 vccd1 sky130_fd_sc_hd__fill_4
X_8467_ clknet_4_5_0_clk _0055_ net332 vssd1 vssd1 vccd1 vccd1 PID_INST.k2_calc.sum_reg\[23\]
+ sky130_fd_sc_hd__dfrtp_4
X_5679_ _0866_ _0868_ vssd1 vssd1 vccd1 vccd1 _0869_ sky130_fd_sc_hd__nand2_1
XANTENNA__7503__A1 net99 vssd1 vssd1 vccd1 vccd1 sky130_fd_sc_hd__diode_2
X_7418_ _2656_ _2655_ vssd1 vssd1 vccd1 vccd1 _2657_ sky130_fd_sc_hd__nand2b_1
X_8398_ clknet_4_3_0_clk _0018_ net335 vssd1 vssd1 vccd1 vccd1 PID_INST.k2_calc.reg_lc\[2\]
+ sky130_fd_sc_hd__dfrtp_1
XFILLER_89_321 vccd1 vssd1 vccd1 vssd1 sky130_ef_sc_hd__decap_40_12
X_7349_ _2583_ _2584_ vssd1 vssd1 vccd1 vccd1 _2585_ sky130_fd_sc_hd__xnor2_1
XFILLER_77_505 vccd1 vssd1 vccd1 vssd1 sky130_ef_sc_hd__decap_40_12
XANTENNA__4608__A2_N net88 vssd1 vssd1 vccd1 vccd1 sky130_fd_sc_hd__diode_2
XANTENNA__7806__A2 net53 vssd1 vssd1 vccd1 vccd1 sky130_fd_sc_hd__diode_2
XANTENNA_fanout84_A net85 vssd1 vssd1 vccd1 vccd1 sky130_fd_sc_hd__diode_2
XFILLER_66_12 vssd1 vssd1 vccd1 vccd1 sky130_fd_sc_hd__fill_1
Xteam_03_366 vssd1 vssd1 vccd1 vccd1 team_03_366/HI gpio_out[8] sky130_fd_sc_hd__conb_1
Xteam_03_355 vssd1 vssd1 vccd1 vccd1 team_03_355/HI gpio_oeb[31] sky130_fd_sc_hd__conb_1
Xteam_03_344 vssd1 vssd1 vccd1 vccd1 team_03_344/HI gpio_oeb[20] sky130_fd_sc_hd__conb_1
Xteam_03_388 vssd1 vssd1 vccd1 vccd1 gpio_oeb[12] team_03_388/LO sky130_fd_sc_hd__conb_1
Xteam_03_377 vssd1 vssd1 vccd1 vccd1 gpio_oeb[1] team_03_377/LO sky130_fd_sc_hd__conb_1
XFILLER_66_89 vssd1 vssd1 vccd1 vccd1 sky130_fd_sc_hd__fill_8
XANTENNA__4256__A net92 vssd1 vssd1 vccd1 vccd1 sky130_fd_sc_hd__diode_2
XFILLER_17_137 vssd1 vssd1 vccd1 vccd1 sky130_fd_sc_hd__fill_2
XFILLER_17_159 vssd1 vssd1 vccd1 vccd1 sky130_fd_sc_hd__fill_2
XTAP_TAPCELL_ROW_71_912 vssd1 vccd1 sky130_fd_sc_hd__tapvpwrvgnd_1
XFILLER_32_129 vssd1 vssd1 vccd1 vccd1 sky130_fd_sc_hd__fill_1
XTAP_TAPCELL_ROW_15_349 vssd1 vccd1 sky130_fd_sc_hd__tapvpwrvgnd_1
XFILLER_15_93 vssd1 vssd1 vccd1 vccd1 sky130_fd_sc_hd__fill_8
XFILLER_9_358 vssd1 vssd1 vccd1 vccd1 sky130_fd_sc_hd__fill_1
XANTENNA__4556__B2 net113 vssd1 vssd1 vccd1 vccd1 sky130_fd_sc_hd__diode_2
XANTENNA__4556__A1 net121 vssd1 vssd1 vccd1 vccd1 sky130_fd_sc_hd__diode_2
XANTENNA__8298__A2 net187 vssd1 vssd1 vccd1 vccd1 sky130_fd_sc_hd__diode_2
XANTENNA__4308__A1 net10 vssd1 vssd1 vccd1 vccd1 sky130_fd_sc_hd__diode_2
XANTENNA__7452__D net277 vssd1 vssd1 vccd1 vccd1 sky130_fd_sc_hd__diode_2
XFILLER_68_505 vccd1 vssd1 vccd1 vssd1 sky130_ef_sc_hd__decap_40_12
XFILLER_48_251 vssd1 vssd1 vccd1 vccd1 sky130_fd_sc_hd__fill_1
XTAP_TAPCELL_ROW_59_791 vssd1 vccd1 sky130_fd_sc_hd__tapvpwrvgnd_1
XFILLER_51_405 vssd1 vssd1 vccd1 vccd1 sky130_fd_sc_hd__fill_4
X_4981_ net125 net77 _0108_ _0106_ vssd1 vssd1 vccd1 vccd1 _0171_ sky130_fd_sc_hd__a31o_1
XFILLER_23_107 vssd1 vssd1 vccd1 vccd1 sky130_fd_sc_hd__fill_1
X_6720_ _1816_ _1824_ _1916_ vssd1 vssd1 vccd1 vccd1 _1918_ sky130_fd_sc_hd__nand3_1
X_6651_ _1620_ _1634_ _1844_ vssd1 vssd1 vccd1 vccd1 _1845_ sky130_fd_sc_hd__a21oi_1
X_5602_ _0773_ _0790_ vssd1 vssd1 vccd1 vccd1 _0792_ sky130_fd_sc_hd__and2_1
X_6582_ _1768_ _1769_ vssd1 vssd1 vccd1 vccd1 _1770_ sky130_fd_sc_hd__nor2_1
X_8321_ _3341_ _3596_ vssd1 vssd1 vccd1 vccd1 _3597_ sky130_fd_sc_hd__xor2_1
X_5533_ net251 net296 vssd1 vssd1 vccd1 vccd1 _0723_ sky130_fd_sc_hd__nand2_1
X_8252_ _3355_ _3381_ _3521_ vssd1 vssd1 vccd1 vccd1 _3523_ sky130_fd_sc_hd__nand3_1
XANTENNA__8101__A net305 vssd1 vssd1 vccd1 vccd1 sky130_fd_sc_hd__diode_2
X_5464_ _0652_ _0653_ vssd1 vssd1 vccd1 vccd1 _0654_ sky130_fd_sc_hd__nand2_1
X_4415_ _3700_ _3701_ vssd1 vssd1 vccd1 vccd1 _0051_ sky130_fd_sc_hd__nor2_1
X_8183_ _3415_ _3447_ vssd1 vssd1 vccd1 vccd1 _3448_ sky130_fd_sc_hd__and2_1
XANTENNA__5444__B net58 vssd1 vssd1 vccd1 vccd1 sky130_fd_sc_hd__diode_2
X_5395_ _0309_ _0561_ vssd1 vssd1 vccd1 vccd1 _0585_ sky130_fd_sc_hd__xor2_2
X_7203_ _2170_ _2428_ vssd1 vssd1 vccd1 vccd1 _2430_ sky130_fd_sc_hd__xnor2_1
X_7134_ net208 net212 net285 net280 vssd1 vssd1 vccd1 vccd1 _2356_ sky130_fd_sc_hd__and4_1
X_4346_ _3643_ _3645_ vssd1 vssd1 vccd1 vccd1 _3646_ sky130_fd_sc_hd__xnor2_1
Xfanout304 PID_INST.k2_calc.reg_lc\[4\] vssd1 vssd1 vccd1 vccd1 net304 sky130_fd_sc_hd__clkbuf_2
XFILLER_86_313 vssd1 vssd1 vccd1 vccd1 sky130_fd_sc_hd__fill_1
Xfanout315 net316 vssd1 vssd1 vccd1 vccd1 net315 sky130_fd_sc_hd__buf_1
Xfanout337 net338 vssd1 vssd1 vccd1 vccd1 net337 sky130_fd_sc_hd__clkbuf_4
XFILLER_59_505 vssd1 vssd1 vccd1 vccd1 sky130_fd_sc_hd__fill_4
Xfanout326 net327 vssd1 vssd1 vccd1 vccd1 net326 sky130_fd_sc_hd__clkbuf_4
X_7065_ _1934_ _1958_ vssd1 vssd1 vccd1 vccd1 _2285_ sky130_fd_sc_hd__nor2_1
X_4277_ net407 net158 _2961_ vssd1 vssd1 vccd1 vccd1 _0000_ sky130_fd_sc_hd__a21bo_1
XANTENNA__6556__A net104 vssd1 vssd1 vccd1 vccd1 sky130_fd_sc_hd__diode_2
X_6016_ _1203_ _1204_ vssd1 vssd1 vccd1 vccd1 _1206_ sky130_fd_sc_hd__xor2_1
XANTENNA_fanout174_X net174 vssd1 vssd1 vccd1 vccd1 sky130_fd_sc_hd__diode_2
XFILLER_82_541 vssd1 vssd1 vccd1 vccd1 sky130_fd_sc_hd__fill_2
XFILLER_36_48 vssd1 vssd1 vccd1 vccd1 sky130_fd_sc_hd__fill_4
XFILLER_36_59 vssd1 vssd1 vccd1 vccd1 sky130_fd_sc_hd__fill_8
X_7967_ _3220_ _3221_ vssd1 vssd1 vccd1 vccd1 _3222_ sky130_fd_sc_hd__xnor2_1
XFILLER_54_265 vssd1 vssd1 vccd1 vccd1 sky130_fd_sc_hd__fill_1
XFILLER_14_107 vssd1 vssd1 vccd1 vccd1 sky130_fd_sc_hd__fill_2
XFILLER_27_479 vssd1 vssd1 vccd1 vccd1 sky130_fd_sc_hd__fill_2
X_7898_ _3074_ _3083_ _3082_ vssd1 vssd1 vccd1 vccd1 _3153_ sky130_fd_sc_hd__a21o_1
XANTENNA_fanout341_X net341 vssd1 vssd1 vccd1 vccd1 sky130_fd_sc_hd__diode_2
X_6918_ net137 _0087_ vssd1 vssd1 vccd1 vccd1 _2128_ sky130_fd_sc_hd__nand2_1
XANTENNA__4523__B net84 vssd1 vssd1 vccd1 vccd1 sky130_fd_sc_hd__diode_2
X_6849_ _1755_ _2054_ vssd1 vssd1 vccd1 vccd1 _2056_ sky130_fd_sc_hd__xnor2_1
XANTENNA__8372__RESET_B net331 vssd1 vssd1 vccd1 vccd1 sky130_fd_sc_hd__diode_2
XFILLER_52_58 vssd1 vssd1 vccd1 vccd1 sky130_fd_sc_hd__fill_1
XTAP_TAPCELL_ROW_12_319 vssd1 vccd1 sky130_fd_sc_hd__tapvpwrvgnd_1
XANTENNA__4538__A1 net125 vssd1 vssd1 vccd1 vccd1 sky130_fd_sc_hd__diode_2
XANTENNA__4538__B2 net127 vssd1 vssd1 vccd1 vccd1 sky130_fd_sc_hd__diode_2
XFILLER_6_317 vssd1 vssd1 vccd1 vccd1 sky130_fd_sc_hd__fill_1
XFILLER_6_306 vssd1 vssd1 vccd1 vccd1 sky130_fd_sc_hd__fill_2
XFILLER_22_195 vssd1 vssd1 vccd1 vccd1 sky130_fd_sc_hd__fill_1
XTAP_TAPCELL_ROW_20_396 vssd1 vccd1 sky130_fd_sc_hd__tapvpwrvgnd_1
XFILLER_2_501 vccd1 vssd1 vccd1 vssd1 sky130_ef_sc_hd__decap_40_12
XFILLER_7_3 vssd1 vssd1 vccd1 vccd1 sky130_fd_sc_hd__fill_8
XFILLER_2_545 vccd1 vssd1 vccd1 vssd1 sky130_ef_sc_hd__decap_40_12
XFILLER_89_173 vssd1 vssd1 vccd1 vccd1 sky130_fd_sc_hd__fill_2
XANTENNA_fanout87_X net87 vssd1 vssd1 vccd1 vccd1 sky130_fd_sc_hd__diode_2
XANTENNA__5370__A net116 vssd1 vssd1 vccd1 vccd1 sky130_fd_sc_hd__diode_2
XANTENNA__4524__D_N net84 vssd1 vssd1 vccd1 vccd1 sky130_fd_sc_hd__diode_2
XFILLER_92_305 vssd1 vssd1 vccd1 vccd1 sky130_fd_sc_hd__fill_2
XFILLER_18_435 vccd1 vssd1 vccd1 vssd1 sky130_ef_sc_hd__decap_40_12
XANTENNA__7963__A1 net276 vssd1 vssd1 vccd1 vccd1 sky130_fd_sc_hd__diode_2
XTAP_TAPCELL_ROW_82_1019 vssd1 vccd1 sky130_fd_sc_hd__tapvpwrvgnd_1
XFILLER_60_213 vssd1 vssd1 vccd1 vccd1 sky130_fd_sc_hd__fill_1
XTAP_TAPCELL_ROW_56_761 vssd1 vccd1 sky130_fd_sc_hd__tapvpwrvgnd_1
XFILLER_45_298 vssd1 vssd1 vccd1 vccd1 sky130_fd_sc_hd__fill_1
XANTENNA__4273__X PID_INST.add_three.n_rst vssd1 vssd1 vccd1 vccd1 sky130_fd_sc_hd__diode_2
XFILLER_26_70 vssd1 vssd1 vccd1 vccd1 sky130_fd_sc_hd__fill_1
XFILLER_26_92 vssd1 vssd1 vccd1 vccd1 sky130_fd_sc_hd__fill_4
XTAP_TAPCELL_ROW_28_485 vssd1 vccd1 sky130_fd_sc_hd__tapvpwrvgnd_1
XFILLER_9_122 vssd1 vssd1 vccd1 vccd1 sky130_fd_sc_hd__fill_8
XFILLER_41_471 vssd1 vssd1 vccd1 vccd1 sky130_fd_sc_hd__fill_4
XANTENNA__5545__A net219 vssd1 vssd1 vccd1 vccd1 sky130_fd_sc_hd__diode_2
XANTENNA__5264__B net70 vssd1 vssd1 vccd1 vccd1 sky130_fd_sc_hd__diode_2
X_4200_ _2146_ vssd1 vssd1 vccd1 vccd1 PID_INST.k3_calc.d1.y\[5\] sky130_fd_sc_hd__inv_2
XFILLER_68_302 vssd1 vssd1 vccd1 vccd1 sky130_fd_sc_hd__fill_4
X_5180_ _0368_ _0369_ vssd1 vssd1 vccd1 vccd1 _0370_ sky130_fd_sc_hd__and2_1
XFILLER_68_324 vccd1 vssd1 vccd1 vssd1 sky130_ef_sc_hd__decap_40_12
XFILLER_3_74 vccd1 vssd1 vccd1 vssd1 sky130_ef_sc_hd__decap_40_12
XFILLER_83_349 vssd1 vssd1 vccd1 vccd1 sky130_fd_sc_hd__fill_2
XANTENNA__8364__Q PID_INST.k1_calc.d1.x\[0\] vssd1 vssd1 vccd1 vccd1 sky130_fd_sc_hd__diode_2
XFILLER_64_530 vssd1 vssd1 vccd1 vccd1 sky130_fd_sc_hd__fill_2
XANTENNA__4217__A0 net10 vssd1 vssd1 vccd1 vccd1 sky130_fd_sc_hd__diode_2
X_7821_ net98 net40 vssd1 vssd1 vccd1 vccd1 _3077_ sky130_fd_sc_hd__nor2_1
XFILLER_91_393 vssd1 vssd1 vccd1 vccd1 sky130_fd_sc_hd__fill_4
X_7752_ _2925_ _2933_ _2932_ vssd1 vssd1 vccd1 vccd1 _3008_ sky130_fd_sc_hd__a21oi_1
X_4964_ _0152_ _0153_ _0082_ _0084_ vssd1 vssd1 vccd1 vccd1 _0154_ sky130_fd_sc_hd__o211a_1
XFILLER_24_438 vssd1 vssd1 vccd1 vccd1 sky130_fd_sc_hd__fill_1
X_6703_ net270 net265 net226 net230 vssd1 vssd1 vccd1 vccd1 _1900_ sky130_fd_sc_hd__and4_1
XANTENNA__5439__B net63 vssd1 vssd1 vccd1 vccd1 sky130_fd_sc_hd__diode_2
XFILLER_32_460 vccd1 vssd1 vccd1 vssd1 sky130_ef_sc_hd__decap_40_12
X_7683_ _2935_ _2936_ vssd1 vssd1 vccd1 vccd1 _2937_ sky130_fd_sc_hd__nand2_1
X_4895_ _0081_ _0082_ _4095_ _4099_ vssd1 vssd1 vccd1 vccd1 _0085_ sky130_fd_sc_hd__a211oi_2
X_6634_ _1610_ _1617_ _1826_ vssd1 vssd1 vccd1 vccd1 _1827_ sky130_fd_sc_hd__a21o_1
XANTENNA__7654__B net189 vssd1 vssd1 vccd1 vccd1 sky130_fd_sc_hd__diode_2
X_6565_ _1690_ _1751_ vssd1 vssd1 vccd1 vccd1 _1752_ sky130_fd_sc_hd__xnor2_1
X_8304_ _3563_ _3577_ vssd1 vssd1 vccd1 vccd1 _3578_ sky130_fd_sc_hd__xnor2_1
XANTENNA_fanout301_A net304 vssd1 vssd1 vccd1 vccd1 sky130_fd_sc_hd__diode_2
X_5516_ net247 net249 net285 net280 vssd1 vssd1 vccd1 vccd1 _0706_ sky130_fd_sc_hd__and4_1
X_6496_ _1603_ _1682_ vssd1 vssd1 vccd1 vccd1 _1684_ sky130_fd_sc_hd__xor2_1
X_8235_ net322 PID_INST.k2_calc.sum_reg\[26\] vssd1 vssd1 vccd1 vccd1 _3505_ sky130_fd_sc_hd__nand2_1
X_5447_ _0615_ _0634_ _0636_ vssd1 vssd1 vccd1 vccd1 _0637_ sky130_fd_sc_hd__a21bo_1
XANTENNA__7670__A net309 vssd1 vssd1 vccd1 vccd1 sky130_fd_sc_hd__diode_2
X_5378_ PID_INST.k3_calc.d2.y\[3\] _0145_ _0146_ _0319_ vssd1 vssd1 vccd1 vccd1 _0568_
+ sky130_fd_sc_hd__a31o_1
Xfanout101 _2580_ vssd1 vssd1 vccd1 vccd1 net101 sky130_fd_sc_hd__clkbuf_4
Xfanout112 _2421_ vssd1 vssd1 vccd1 vccd1 net112 sky130_fd_sc_hd__clkbuf_4
X_8166_ _3131_ _3428_ _3430_ vssd1 vssd1 vccd1 vccd1 _3431_ sky130_fd_sc_hd__a21o_1
X_8097_ _3352_ _3353_ _3354_ vssd1 vssd1 vccd1 vccd1 _3356_ sky130_fd_sc_hd__o21bai_1
XFILLER_86_132 vssd1 vssd1 vccd1 vccd1 sky130_fd_sc_hd__fill_1
X_7117_ net200 net290 vssd1 vssd1 vccd1 vccd1 _2338_ sky130_fd_sc_hd__nand2_1
XANTENNA_fanout291_X net291 vssd1 vssd1 vccd1 vccd1 sky130_fd_sc_hd__diode_2
XFILLER_59_346 vssd1 vssd1 vccd1 vccd1 sky130_fd_sc_hd__fill_2
X_4329_ net233 net16 vssd1 vssd1 vccd1 vccd1 _3504_ sky130_fd_sc_hd__nand2_1
Xfanout156 _3713_ vssd1 vssd1 vccd1 vccd1 net156 sky130_fd_sc_hd__clkbuf_2
Xfanout134 PID_INST.k3_calc.d1.y\[9\] vssd1 vssd1 vccd1 vccd1 net134 sky130_fd_sc_hd__buf_2
Xfanout123 PID_INST.k3_calc.d1.y\[3\] vssd1 vssd1 vccd1 vccd1 net123 sky130_fd_sc_hd__clkbuf_4
Xfanout145 net146 vssd1 vssd1 vccd1 vccd1 net145 sky130_fd_sc_hd__buf_2
X_7048_ _2265_ _2266_ vssd1 vssd1 vccd1 vccd1 _2267_ sky130_fd_sc_hd__xnor2_1
Xfanout178 PID_INST.k2_calc.sum_reg\[25\] vssd1 vssd1 vccd1 vccd1 net178 sky130_fd_sc_hd__clkbuf_2
Xfanout189 net190 vssd1 vssd1 vccd1 vccd1 net189 sky130_fd_sc_hd__buf_2
Xfanout167 _1860_ vssd1 vssd1 vccd1 vccd1 net167 sky130_fd_sc_hd__clkbuf_4
XFILLER_74_327 vssd1 vssd1 vccd1 vccd1 sky130_fd_sc_hd__fill_1
XFILLER_67_390 vssd1 vssd1 vccd1 vccd1 sky130_fd_sc_hd__fill_2
XFILLER_82_360 vssd1 vssd1 vccd1 vccd1 sky130_fd_sc_hd__fill_4
XFILLER_70_511 vccd1 vssd1 vccd1 vssd1 sky130_ef_sc_hd__decap_40_12
XFILLER_70_533 vccd1 vssd1 vccd1 vssd1 sky130_ef_sc_hd__decap_40_12
XTAP_TAPCELL_ROW_53_731 vssd1 vccd1 sky130_fd_sc_hd__tapvpwrvgnd_1
XFILLER_15_449 vccd1 vssd1 vccd1 vssd1 sky130_ef_sc_hd__decap_40_12
XTAP_TAPCELL_ROW_25_455 vssd1 vccd1 sky130_fd_sc_hd__tapvpwrvgnd_1
XFILLER_30_419 vssd1 vssd1 vccd1 vccd1 sky130_fd_sc_hd__fill_1
XANTENNA__4821__X _4099_ vssd1 vssd1 vccd1 vccd1 sky130_fd_sc_hd__diode_2
XFILLER_6_103 vssd1 vssd1 vccd1 vccd1 sky130_fd_sc_hd__fill_8
XANTENNA__8449__Q PID_INST.k2_calc.sum_reg\[5\] vssd1 vssd1 vccd1 vccd1 sky130_fd_sc_hd__diode_2
XFILLER_12_83 vssd1 vssd1 vccd1 vccd1 sky130_fd_sc_hd__fill_1
XFILLER_88_98 vssd1 vssd1 vccd1 vccd1 sky130_fd_sc_hd__fill_2
XANTENNA__6436__A1 net199 vssd1 vssd1 vccd1 vccd1 sky130_fd_sc_hd__diode_2
XANTENNA__6436__B2 net208 vssd1 vssd1 vccd1 vccd1 sky130_fd_sc_hd__diode_2
XANTENNA__6627__C net259 vssd1 vssd1 vccd1 vccd1 sky130_fd_sc_hd__diode_2
XFILLER_92_113 vssd1 vssd1 vccd1 vccd1 sky130_fd_sc_hd__fill_2
XFILLER_92_102 vssd1 vssd1 vccd1 vccd1 sky130_fd_sc_hd__fill_8
XFILLER_77_176 vssd1 vssd1 vccd1 vccd1 sky130_fd_sc_hd__fill_2
XANTENNA__4971__C_N _4100_ vssd1 vssd1 vccd1 vccd1 sky130_fd_sc_hd__diode_2
XFILLER_61_511 vssd1 vssd1 vccd1 vccd1 sky130_fd_sc_hd__fill_1
XFILLER_46_563 vssd1 vssd1 vccd1 vccd1 sky130_fd_sc_hd__fill_2
XFILLER_18_265 vssd1 vssd1 vccd1 vccd1 sky130_fd_sc_hd__fill_4
XFILLER_14_471 vssd1 vssd1 vccd1 vccd1 sky130_fd_sc_hd__fill_4
X_4680_ _3900_ _3901_ vssd1 vssd1 vccd1 vccd1 _3958_ sky130_fd_sc_hd__xor2_1
XFILLER_41_290 vssd1 vssd1 vccd1 vccd1 sky130_fd_sc_hd__fill_4
X_6350_ _1536_ _1537_ vssd1 vssd1 vccd1 vccd1 _1538_ sky130_fd_sc_hd__nand2_1
X_5301_ _0490_ _0489_ vssd1 vssd1 vccd1 vccd1 _0491_ sky130_fd_sc_hd__and2b_1
X_6281_ _1468_ _1469_ vssd1 vssd1 vccd1 vccd1 _1470_ sky130_fd_sc_hd__xnor2_1
X_5232_ _0364_ _0370_ _0362_ vssd1 vssd1 vccd1 vccd1 _0422_ sky130_fd_sc_hd__a21oi_1
X_8020_ _3271_ _3272_ vssd1 vssd1 vccd1 vccd1 _3274_ sky130_fd_sc_hd__nand2_1
X_5163_ _0347_ _0352_ vssd1 vssd1 vccd1 vccd1 _0353_ sky130_fd_sc_hd__xnor2_1
X_5094_ _0276_ _0283_ vssd1 vssd1 vccd1 vccd1 _0284_ sky130_fd_sc_hd__nor2_1
XFILLER_83_146 vssd1 vssd1 vccd1 vccd1 sky130_fd_sc_hd__fill_2
XTAP_TAPCELL_ROW_67_867 vssd1 vccd1 sky130_fd_sc_hd__tapvpwrvgnd_1
XFILLER_49_390 vssd1 vssd1 vccd1 vccd1 sky130_fd_sc_hd__fill_2
XANTENNA__6834__A net112 vssd1 vssd1 vccd1 vccd1 sky130_fd_sc_hd__diode_2
XFILLER_64_360 vssd1 vssd1 vccd1 vccd1 sky130_fd_sc_hd__fill_2
XFILLER_64_382 vssd1 vssd1 vccd1 vccd1 sky130_fd_sc_hd__fill_1
XFILLER_52_533 vssd1 vssd1 vccd1 vccd1 sky130_fd_sc_hd__fill_8
X_7804_ _2826_ _3058_ vssd1 vssd1 vccd1 vccd1 _3060_ sky130_fd_sc_hd__and2b_1
XFILLER_24_246 vssd1 vssd1 vccd1 vccd1 sky130_fd_sc_hd__fill_1
XANTENNA__5169__B net89 vssd1 vssd1 vccd1 vccd1 sky130_fd_sc_hd__diode_2
X_5996_ _1185_ vssd1 vssd1 vccd1 vccd1 _1186_ sky130_fd_sc_hd__inv_2
X_7735_ _2890_ _2897_ _2989_ vssd1 vssd1 vccd1 vccd1 _2991_ sky130_fd_sc_hd__nand3_1
XTAP_TAPCELL_ROW_50_701 vssd1 vccd1 sky130_fd_sc_hd__tapvpwrvgnd_1
X_4947_ _0134_ _0135_ vssd1 vssd1 vccd1 vccd1 _0137_ sky130_fd_sc_hd__xor2_1
XTAP_TAPCELL_ROW_22_425 vssd1 vccd1 sky130_fd_sc_hd__tapvpwrvgnd_1
X_7666_ net202 net272 net260 net214 vssd1 vssd1 vccd1 vccd1 _2920_ sky130_fd_sc_hd__a22o_1
X_4878_ _4153_ _4154_ _4084_ _4087_ vssd1 vssd1 vccd1 vccd1 _4156_ sky130_fd_sc_hd__a211o_1
XANTENNA_fanout137_X net137 vssd1 vssd1 vccd1 vccd1 sky130_fd_sc_hd__diode_2
XFILLER_20_485 vssd1 vssd1 vccd1 vccd1 sky130_fd_sc_hd__fill_8
X_6617_ _1805_ _1807_ vssd1 vssd1 vccd1 vccd1 _1809_ sky130_fd_sc_hd__xor2_1
XANTENNA__8199__C net260 vssd1 vssd1 vccd1 vccd1 sky130_fd_sc_hd__diode_2
XANTENNA_fanout304_X net304 vssd1 vssd1 vccd1 vccd1 sky130_fd_sc_hd__diode_2
X_7597_ _2837_ _2846_ vssd1 vssd1 vccd1 vccd1 _2848_ sky130_fd_sc_hd__xnor2_1
XFILLER_3_117 vccd1 vssd1 vccd1 vssd1 sky130_ef_sc_hd__decap_40_12
X_6548_ _1732_ _1733_ vssd1 vssd1 vccd1 vccd1 _1735_ sky130_fd_sc_hd__xor2_2
X_6479_ net220 net287 vssd1 vssd1 vccd1 vccd1 _1667_ sky130_fd_sc_hd__nand2_1
XANTENNA__5913__A net139 vssd1 vssd1 vccd1 vccd1 sky130_fd_sc_hd__diode_2
X_8218_ net317 PID_INST.k2_calc.sum_reg\[24\] _3328_ _3327_ vssd1 vssd1 vccd1 vccd1
+ _3486_ sky130_fd_sc_hd__a31o_1
X_8149_ _3411_ _3412_ vssd1 vssd1 vccd1 vccd1 _3413_ sky130_fd_sc_hd__xnor2_1
XFILLER_28_530 vssd1 vssd1 vccd1 vccd1 sky130_fd_sc_hd__fill_2
XFILLER_62_319 vssd1 vssd1 vccd1 vccd1 sky130_fd_sc_hd__fill_4
XFILLER_55_360 vssd1 vssd1 vccd1 vccd1 sky130_fd_sc_hd__fill_8
XFILLER_43_511 vssd1 vssd1 vccd1 vccd1 sky130_fd_sc_hd__fill_2
XFILLER_28_563 vssd1 vssd1 vccd1 vccd1 sky130_fd_sc_hd__fill_4
XTAP_TAPCELL_ROW_38_580 vssd1 vccd1 sky130_fd_sc_hd__tapvpwrvgnd_1
XFILLER_70_363 vssd1 vssd1 vccd1 vccd1 sky130_fd_sc_hd__fill_1
XFILLER_90_44 vssd1 vssd1 vccd1 vccd1 sky130_fd_sc_hd__fill_8
XPHY_EDGE_ROW_4_Left_97 vssd1 vssd1 vccd1 vccd1 sky130_fd_sc_hd__decap_3
XFILLER_15_279 vssd1 vssd1 vccd1 vccd1 sky130_fd_sc_hd__fill_1
XFILLER_7_434 vssd1 vssd1 vccd1 vccd1 sky130_fd_sc_hd__fill_2
XFILLER_11_485 vccd1 vssd1 vccd1 vssd1 sky130_ef_sc_hd__decap_40_12
XANTENNA__5542__B net288 vssd1 vssd1 vccd1 vccd1 sky130_fd_sc_hd__diode_2
XFILLER_2_194 vssd1 vssd1 vccd1 vccd1 sky130_fd_sc_hd__fill_2
XANTENNA__8475__RESET_B net340 vssd1 vssd1 vccd1 vccd1 sky130_fd_sc_hd__diode_2
XANTENNA__8382__CLK clknet_4_11_0_clk vssd1 vssd1 vccd1 vccd1 sky130_fd_sc_hd__diode_2
XFILLER_38_316 vssd1 vssd1 vccd1 vccd1 sky130_fd_sc_hd__fill_4
XFILLER_19_541 vccd1 vssd1 vccd1 vssd1 sky130_ef_sc_hd__decap_40_12
XFILLER_80_138 vssd1 vssd1 vccd1 vccd1 sky130_fd_sc_hd__fill_2
XTAP_TAPCELL_ROW_64_837 vssd1 vccd1 sky130_fd_sc_hd__tapvpwrvgnd_1
XFILLER_34_533 vssd1 vssd1 vccd1 vccd1 sky130_fd_sc_hd__fill_4
XFILLER_61_341 vssd1 vssd1 vccd1 vccd1 sky130_fd_sc_hd__fill_1
X_5850_ _1020_ _1021_ vssd1 vssd1 vccd1 vccd1 _1040_ sky130_fd_sc_hd__and2_1
X_5781_ _0969_ _0970_ vssd1 vssd1 vccd1 vccd1 _0971_ sky130_fd_sc_hd__nor2_1
X_4801_ _4045_ _4077_ vssd1 vssd1 vccd1 vccd1 _4079_ sky130_fd_sc_hd__nand2_1
XANTENNA__4199__A2 net174 vssd1 vssd1 vccd1 vccd1 sky130_fd_sc_hd__diode_2
XFILLER_9_51 vssd1 vssd1 vccd1 vccd1 sky130_fd_sc_hd__fill_4
X_4732_ _4008_ _4009_ vssd1 vssd1 vccd1 vccd1 _4010_ sky130_fd_sc_hd__nand2b_1
XFILLER_21_249 vccd1 vssd1 vccd1 vssd1 sky130_ef_sc_hd__decap_40_12
X_7520_ _2452_ _2514_ _2517_ _2519_ vssd1 vssd1 vccd1 vccd1 _2766_ sky130_fd_sc_hd__a22o_1
XANTENNA__4902__A net121 vssd1 vssd1 vccd1 vccd1 sky130_fd_sc_hd__diode_2
X_7451_ _2690_ _2691_ vssd1 vssd1 vccd1 vccd1 _2692_ sky130_fd_sc_hd__xnor2_1
X_4663_ _3939_ _3940_ vssd1 vssd1 vccd1 vccd1 _3941_ sky130_fd_sc_hd__xnor2_1
X_6402_ net106 net41 _1588_ vssd1 vssd1 vccd1 vccd1 _1590_ sky130_fd_sc_hd__or3_1
X_7382_ _2617_ _2618_ _2619_ vssd1 vssd1 vccd1 vccd1 _2620_ sky130_fd_sc_hd__or3_1
X_4594_ _3758_ _3871_ vssd1 vssd1 vccd1 vccd1 _3872_ sky130_fd_sc_hd__nor2_1
XANTENNA__7932__B net209 vssd1 vssd1 vccd1 vccd1 sky130_fd_sc_hd__diode_2
XANTENNA__8098__B1 net192 vssd1 vssd1 vccd1 vccd1 sky130_fd_sc_hd__diode_2
XANTENNA_clkbuf_4_6_0_clk_A clknet_0_clk vssd1 vssd1 vccd1 vccd1 sky130_fd_sc_hd__diode_2
X_6333_ _1312_ _1323_ _1520_ vssd1 vssd1 vccd1 vccd1 _1521_ sky130_fd_sc_hd__o21a_1
X_6264_ _1450_ _1451_ vssd1 vssd1 vccd1 vccd1 _1453_ sky130_fd_sc_hd__xnor2_1
X_8003_ _3048_ _3051_ _3256_ vssd1 vssd1 vccd1 vccd1 _3258_ sky130_fd_sc_hd__nor3_1
XFILLER_88_249 vssd1 vssd1 vccd1 vccd1 sky130_fd_sc_hd__fill_2
X_5215_ _0342_ _0344_ vssd1 vssd1 vccd1 vccd1 _0405_ sky130_fd_sc_hd__or2_1
XFILLER_69_463 vssd1 vssd1 vccd1 vccd1 sky130_fd_sc_hd__fill_1
XANTENNA_fanout299_A net304 vssd1 vssd1 vccd1 vccd1 sky130_fd_sc_hd__diode_2
Xclkbuf_4_15_0_clk clknet_0_clk vssd1 vssd1 vccd1 vccd1 clknet_4_15_0_clk sky130_fd_sc_hd__clkbuf_8
X_6195_ _1381_ _1382_ vssd1 vssd1 vccd1 vccd1 _1384_ sky130_fd_sc_hd__xor2_1
X_5146_ _2210_ _0083_ _0085_ net70 _2178_ vssd1 vssd1 vccd1 vccd1 _0336_ sky130_fd_sc_hd__o32a_1
XANTENNA__7073__A1 net207 vssd1 vssd1 vccd1 vccd1 sky130_fd_sc_hd__diode_2
XFILLER_29_349 vssd1 vssd1 vccd1 vccd1 sky130_fd_sc_hd__fill_4
X_5077_ net138 net89 _3734_ net149 vssd1 vssd1 vccd1 vccd1 _0267_ sky130_fd_sc_hd__o2bb2a_1
XFILLER_56_157 vssd1 vssd1 vccd1 vccd1 sky130_fd_sc_hd__fill_2
XFILLER_37_371 vccd1 vssd1 vccd1 vssd1 sky130_ef_sc_hd__decap_40_12
XFILLER_37_393 vssd1 vssd1 vccd1 vccd1 sky130_fd_sc_hd__fill_1
XANTENNA_fanout254_X net254 vssd1 vssd1 vccd1 vccd1 sky130_fd_sc_hd__diode_2
XFILLER_52_363 vssd1 vssd1 vccd1 vccd1 sky130_fd_sc_hd__fill_1
X_5979_ net125 net68 vssd1 vssd1 vccd1 vccd1 _1169_ sky130_fd_sc_hd__nand2_1
XTAP_TAPCELL_ROW_35_550 vssd1 vccd1 sky130_fd_sc_hd__tapvpwrvgnd_1
XFILLER_40_536 vssd1 vssd1 vccd1 vccd1 sky130_fd_sc_hd__fill_8
X_7718_ net267 net263 net201 net205 vssd1 vssd1 vccd1 vccd1 _2974_ sky130_fd_sc_hd__and4_1
XANTENNA__4812__A net139 vssd1 vssd1 vccd1 vccd1 sky130_fd_sc_hd__diode_2
XFILLER_12_249 vssd1 vssd1 vccd1 vccd1 sky130_fd_sc_hd__fill_2
X_7649_ _2673_ _2676_ _2672_ vssd1 vssd1 vccd1 vccd1 _2902_ sky130_fd_sc_hd__o21ba_1
XANTENNA__6739__A net223 vssd1 vssd1 vccd1 vccd1 sky130_fd_sc_hd__diode_2
XFILLER_4_448 vssd1 vssd1 vccd1 vccd1 sky130_fd_sc_hd__fill_2
XTAP_TAPCELL_ROW_7_275 vssd1 vccd1 sky130_fd_sc_hd__tapvpwrvgnd_1
XFILLER_47_113 vssd1 vssd1 vccd1 vccd1 sky130_fd_sc_hd__fill_4
XFILLER_85_55 vssd1 vssd1 vccd1 vccd1 sky130_fd_sc_hd__fill_1
XFILLER_28_360 vssd1 vssd1 vccd1 vccd1 sky130_fd_sc_hd__fill_4
XFILLER_90_425 vssd1 vssd1 vccd1 vccd1 sky130_fd_sc_hd__fill_1
XANTENNA__4706__B net81 vssd1 vssd1 vccd1 vccd1 sky130_fd_sc_hd__diode_2
XFILLER_16_511 vssd1 vssd1 vccd1 vccd1 sky130_fd_sc_hd__fill_1
XFILLER_16_522 vssd1 vssd1 vccd1 vccd1 sky130_fd_sc_hd__fill_2
XFILLER_16_533 vssd1 vssd1 vccd1 vccd1 sky130_fd_sc_hd__fill_4
XTAP_TAPCELL_ROW_61_807 vssd1 vccd1 sky130_fd_sc_hd__tapvpwrvgnd_1
XFILLER_16_544 vccd1 vssd1 vccd1 vssd1 sky130_ef_sc_hd__decap_40_12
XFILLER_31_503 vssd1 vssd1 vccd1 vccd1 sky130_fd_sc_hd__fill_1
XFILLER_31_536 vssd1 vssd1 vccd1 vccd1 sky130_fd_sc_hd__fill_2
XFILLER_31_569 vssd1 vssd1 vccd1 vccd1 sky130_fd_sc_hd__fill_1
XFILLER_34_70 vssd1 vssd1 vccd1 vccd1 sky130_fd_sc_hd__fill_4
X_5000_ net135 net87 _0188_ vssd1 vssd1 vccd1 vccd1 _0190_ sky130_fd_sc_hd__and3_1
XFILLER_66_400 vssd1 vssd1 vccd1 vccd1 sky130_fd_sc_hd__fill_4
XFILLER_38_135 vssd1 vssd1 vccd1 vccd1 sky130_fd_sc_hd__fill_1
XFILLER_38_146 vssd1 vssd1 vccd1 vccd1 sky130_fd_sc_hd__fill_1
XTAP_TAPCELL_ROW_77_973 vssd1 vccd1 sky130_fd_sc_hd__tapvpwrvgnd_1
XFILLER_66_488 vssd1 vssd1 vccd1 vccd1 sky130_fd_sc_hd__fill_1
XFILLER_81_447 vssd1 vssd1 vccd1 vccd1 sky130_fd_sc_hd__fill_1
XTAP_TAPCELL_ROW_49_686 vssd1 vccd1 sky130_fd_sc_hd__tapvpwrvgnd_1
X_6951_ net93 net62 _2162_ vssd1 vssd1 vccd1 vccd1 _2163_ sky130_fd_sc_hd__or3_1
XFILLER_19_393 vccd1 vssd1 vccd1 vssd1 sky130_ef_sc_hd__decap_40_12
X_5902_ _1089_ _1091_ _1049_ vssd1 vssd1 vccd1 vccd1 _1092_ sky130_fd_sc_hd__o21a_1
X_6882_ _2081_ _2089_ vssd1 vssd1 vccd1 vccd1 _2091_ sky130_fd_sc_hd__xnor2_1
X_5833_ _1017_ _1019_ _1022_ vssd1 vssd1 vccd1 vccd1 _1023_ sky130_fd_sc_hd__a21o_1
XFILLER_22_514 vssd1 vssd1 vccd1 vccd1 sky130_fd_sc_hd__fill_2
XFILLER_34_363 vssd1 vssd1 vccd1 vccd1 sky130_fd_sc_hd__fill_1
XFILLER_14_29 vssd1 vssd1 vccd1 vccd1 sky130_fd_sc_hd__fill_1
XTAP_TAPCELL_ROW_32_520 vssd1 vccd1 sky130_fd_sc_hd__tapvpwrvgnd_1
X_5764_ _0911_ _0953_ vssd1 vssd1 vccd1 vccd1 _0954_ sky130_fd_sc_hd__nor2_1
X_7503_ net99 net48 _2496_ _2495_ vssd1 vssd1 vccd1 vccd1 _2748_ sky130_fd_sc_hd__o31ai_2
XANTENNA__7365__D net280 vssd1 vssd1 vccd1 vccd1 sky130_fd_sc_hd__diode_2
X_4715_ PID_INST.k1_calc.d1.x\[10\] PID_INST.k3_calc.prev_error\[10\] vssd1 vssd1
+ vccd1 vccd1 _3993_ sky130_fd_sc_hd__nor2_1
X_5695_ _0870_ _0873_ _0872_ vssd1 vssd1 vccd1 vccd1 _0885_ sky130_fd_sc_hd__o21a_1
X_8483_ clknet_4_14_0_clk _0071_ net341 vssd1 vssd1 vccd1 vccd1 net32 sky130_fd_sc_hd__dfrtp_1
X_7434_ _2672_ _2673_ vssd1 vssd1 vccd1 vccd1 _2674_ sky130_fd_sc_hd__nor2_1
XANTENNA_fanout214_A net217 vssd1 vssd1 vccd1 vccd1 sky130_fd_sc_hd__diode_2
X_4646_ _3905_ _3922_ _3923_ vssd1 vssd1 vccd1 vccd1 _3924_ sky130_fd_sc_hd__nand3_1
X_7365_ net204 net208 net285 net280 vssd1 vssd1 vccd1 vccd1 _2602_ sky130_fd_sc_hd__and4_1
XANTENNA__4344__A2 net17 vssd1 vssd1 vccd1 vccd1 sky130_fd_sc_hd__diode_2
X_4577_ _3775_ _3853_ _3854_ vssd1 vssd1 vccd1 vccd1 _3855_ sky130_fd_sc_hd__and3_1
XANTENNA__6559__A PID_INST.k3_calc.d2.y\[2\] vssd1 vssd1 vccd1 vccd1 sky130_fd_sc_hd__diode_2
X_6316_ net139 net53 _1502_ vssd1 vssd1 vccd1 vccd1 _1504_ sky130_fd_sc_hd__or3_1
XANTENNA__8397__RESET_B net331 vssd1 vssd1 vccd1 vccd1 sky130_fd_sc_hd__diode_2
X_7296_ _2525_ _2526_ vssd1 vssd1 vccd1 vccd1 _2528_ sky130_fd_sc_hd__xor2_1
X_6247_ _1426_ _1427_ _1435_ vssd1 vssd1 vccd1 vccd1 _1436_ sky130_fd_sc_hd__and3_1
X_6178_ _1364_ _1365_ vssd1 vssd1 vccd1 vccd1 _1367_ sky130_fd_sc_hd__xnor2_1
XFILLER_57_444 vssd1 vssd1 vccd1 vccd1 sky130_fd_sc_hd__fill_4
X_5129_ net114 net59 vssd1 vssd1 vccd1 vccd1 _0319_ sky130_fd_sc_hd__nor2_1
XTAP_TAPCELL_ROW_4_245 vssd1 vccd1 sky130_fd_sc_hd__tapvpwrvgnd_1
XFILLER_17_308 vssd1 vssd1 vccd1 vccd1 sky130_fd_sc_hd__fill_8
XFILLER_29_146 vssd1 vssd1 vccd1 vccd1 sky130_fd_sc_hd__fill_1
XANTENNA__4526__B net79 vssd1 vssd1 vccd1 vccd1 sky130_fd_sc_hd__diode_2
XFILLER_25_352 vssd1 vssd1 vccd1 vccd1 sky130_fd_sc_hd__fill_1
XFILLER_37_190 vssd1 vssd1 vccd1 vccd1 sky130_fd_sc_hd__fill_4
XFILLER_52_160 vssd1 vssd1 vccd1 vccd1 sky130_fd_sc_hd__fill_8
XFILLER_13_503 vssd1 vssd1 vccd1 vccd1 sky130_fd_sc_hd__fill_1
XANTENNA__6741__B net196 vssd1 vssd1 vccd1 vccd1 sky130_fd_sc_hd__diode_2
XFILLER_9_518 vccd1 vssd1 vccd1 vssd1 sky130_ef_sc_hd__decap_40_12
XANTENNA__7572__B net53 vssd1 vssd1 vccd1 vccd1 sky130_fd_sc_hd__diode_2
XFILLER_4_245 vssd1 vssd1 vccd1 vccd1 sky130_fd_sc_hd__fill_2
XFILLER_4_289 vssd1 vssd1 vccd1 vccd1 sky130_fd_sc_hd__fill_1
XFILLER_75_285 vssd1 vssd1 vccd1 vccd1 sky130_fd_sc_hd__fill_2
XTAP_TAPCELL_ROW_74_943 vssd1 vccd1 sky130_fd_sc_hd__tapvpwrvgnd_1
XTAP_TAPCELL_ROW_46_656 vssd1 vccd1 sky130_fd_sc_hd__tapvpwrvgnd_1
XFILLER_90_299 vssd1 vssd1 vccd1 vccd1 sky130_fd_sc_hd__fill_1
XFILLER_43_160 vssd1 vssd1 vccd1 vccd1 sky130_fd_sc_hd__fill_1
XFILLER_71_491 vssd1 vssd1 vccd1 vccd1 sky130_fd_sc_hd__fill_1
XANTENNA__5548__A net314 vssd1 vssd1 vccd1 vccd1 sky130_fd_sc_hd__diode_2
XANTENNA__4723__Y _4001_ vssd1 vssd1 vccd1 vccd1 sky130_fd_sc_hd__diode_2
XFILLER_31_311 vssd1 vssd1 vccd1 vccd1 sky130_fd_sc_hd__fill_4
XFILLER_43_193 vssd1 vssd1 vccd1 vccd1 sky130_fd_sc_hd__fill_4
XFILLER_31_366 vssd1 vssd1 vccd1 vccd1 sky130_fd_sc_hd__fill_2
X_5480_ net103 net55 _0669_ vssd1 vssd1 vccd1 vccd1 _0670_ sky130_fd_sc_hd__or3_1
X_4500_ _3724_ _3777_ vssd1 vssd1 vccd1 vccd1 _3778_ sky130_fd_sc_hd__and2_1
X_4431_ net424 _3709_ _3710_ vssd1 vssd1 vccd1 vccd1 _0058_ sky130_fd_sc_hd__a21o_1
XANTENNA_1 PID_INST.k3_calc.d1.y\[2\] vssd1 vssd1 vccd1 vccd1 sky130_fd_sc_hd__diode_2
X_7150_ _2259_ _2283_ vssd1 vssd1 vccd1 vccd1 _2373_ sky130_fd_sc_hd__nor2_1
X_4362_ net214 net4 vssd1 vssd1 vccd1 vccd1 _3659_ sky130_fd_sc_hd__and2_1
X_7081_ _1964_ _1967_ _2300_ vssd1 vssd1 vccd1 vccd1 _2301_ sky130_fd_sc_hd__o21a_1
X_4293_ net325 net12 net172 vssd1 vssd1 vccd1 vccd1 _0016_ sky130_fd_sc_hd__mux2_1
X_6101_ _1102_ _1290_ vssd1 vssd1 vccd1 vccd1 _1291_ sky130_fd_sc_hd__nand2_1
X_6032_ net203 net321 _1220_ vssd1 vssd1 vccd1 vccd1 _1222_ sky130_fd_sc_hd__a21o_1
XFILLER_54_403 vssd1 vssd1 vccd1 vccd1 sky130_fd_sc_hd__fill_1
XTAP_TAPCELL_ROW_1_215 vssd1 vccd1 sky130_fd_sc_hd__tapvpwrvgnd_1
XANTENNA__4627__A net113 vssd1 vssd1 vccd1 vccd1 sky130_fd_sc_hd__diode_2
XANTENNA__7579__A2 net51 vssd1 vssd1 vccd1 vccd1 sky130_fd_sc_hd__diode_2
X_7983_ _3234_ _3235_ _3236_ vssd1 vssd1 vccd1 vccd1 _3238_ sky130_fd_sc_hd__o21ai_1
XFILLER_54_414 vssd1 vssd1 vccd1 vccd1 sky130_fd_sc_hd__fill_4
XFILLER_54_469 vssd1 vssd1 vccd1 vccd1 sky130_fd_sc_hd__fill_4
X_6934_ _2120_ _2144_ vssd1 vssd1 vccd1 vccd1 _2145_ sky130_fd_sc_hd__xnor2_1
X_6865_ net109 net52 vssd1 vssd1 vccd1 vccd1 _2073_ sky130_fd_sc_hd__nor2_1
XANTENNA__4362__A net214 vssd1 vssd1 vccd1 vccd1 sky130_fd_sc_hd__diode_2
X_5816_ _0961_ _0976_ _0991_ _1000_ vssd1 vssd1 vccd1 vccd1 _1006_ sky130_fd_sc_hd__a211oi_1
XANTENNA_fanout331_A net339 vssd1 vssd1 vccd1 vccd1 sky130_fd_sc_hd__diode_2
X_6796_ _1992_ _1997_ vssd1 vssd1 vccd1 vccd1 _1999_ sky130_fd_sc_hd__xor2_1
X_5747_ _0933_ _0935_ vssd1 vssd1 vccd1 vccd1 _0937_ sky130_fd_sc_hd__nor2_1
XFILLER_10_528 vssd1 vssd1 vccd1 vccd1 sky130_fd_sc_hd__fill_4
XFILLER_22_399 vccd1 vssd1 vccd1 vssd1 sky130_ef_sc_hd__decap_40_12
X_8466_ clknet_4_5_0_clk _0054_ net333 vssd1 vssd1 vccd1 vccd1 PID_INST.k2_calc.sum_reg\[22\]
+ sky130_fd_sc_hd__dfrtp_1
XANTENNA_fanout217_X net217 vssd1 vssd1 vccd1 vccd1 sky130_fd_sc_hd__diode_2
X_7417_ _2560_ _2562_ _2559_ vssd1 vssd1 vccd1 vccd1 _2656_ sky130_fd_sc_hd__o21ba_1
X_5678_ _0864_ _0867_ vssd1 vssd1 vccd1 vccd1 _0868_ sky130_fd_sc_hd__and2_1
XANTENNA__6711__B1 net255 vssd1 vssd1 vccd1 vccd1 sky130_fd_sc_hd__diode_2
X_8397_ clknet_4_3_0_clk _0017_ net331 vssd1 vssd1 vccd1 vccd1 PID_INST.k2_calc.reg_lc\[1\]
+ sky130_fd_sc_hd__dfrtp_1
X_4629_ _3896_ _3897_ _3893_ vssd1 vssd1 vccd1 vccd1 _3907_ sky130_fd_sc_hd__a21o_1
X_7348_ net293 net195 vssd1 vssd1 vccd1 vccd1 _2584_ sky130_fd_sc_hd__nand2_1
XFILLER_1_215 vssd1 vssd1 vccd1 vccd1 sky130_fd_sc_hd__fill_8
XFILLER_89_355 vssd1 vssd1 vccd1 vccd1 sky130_fd_sc_hd__fill_1
XFILLER_89_333 vssd1 vssd1 vccd1 vccd1 sky130_fd_sc_hd__fill_2
X_7279_ _2435_ _2444_ _2508_ vssd1 vssd1 vccd1 vccd1 _2510_ sky130_fd_sc_hd__or3_1
XFILLER_77_517 vssd1 vssd1 vccd1 vccd1 sky130_fd_sc_hd__fill_4
Xteam_03_367 vssd1 vssd1 vccd1 vccd1 team_03_367/HI gpio_out[9] sky130_fd_sc_hd__conb_1
XANTENNA__5640__B net215 vssd1 vssd1 vccd1 vccd1 sky130_fd_sc_hd__diode_2
Xteam_03_345 vssd1 vssd1 vccd1 vccd1 team_03_345/HI gpio_oeb[21] sky130_fd_sc_hd__conb_1
Xteam_03_356 vssd1 vssd1 vccd1 vccd1 team_03_356/HI gpio_oeb[32] sky130_fd_sc_hd__conb_1
Xteam_03_378 vssd1 vssd1 vccd1 vccd1 gpio_oeb[2] team_03_378/LO sky130_fd_sc_hd__conb_1
Xteam_03_389 vssd1 vssd1 vccd1 vccd1 gpio_oeb[13] team_03_389/LO sky130_fd_sc_hd__conb_1
XFILLER_85_561 vssd1 vssd1 vccd1 vccd1 sky130_fd_sc_hd__fill_8
XFILLER_66_46 vssd1 vssd1 vccd1 vccd1 sky130_fd_sc_hd__fill_2
XFILLER_45_447 vssd1 vssd1 vccd1 vccd1 sky130_fd_sc_hd__fill_1
XTAP_TAPCELL_ROW_71_913 vssd1 vccd1 sky130_fd_sc_hd__tapvpwrvgnd_1
XFILLER_60_428 vssd1 vssd1 vccd1 vccd1 sky130_fd_sc_hd__fill_1
XFILLER_25_160 vssd1 vssd1 vccd1 vccd1 sky130_fd_sc_hd__fill_1
XTAP_TAPCELL_ROW_43_626 vssd1 vccd1 sky130_fd_sc_hd__tapvpwrvgnd_1
XFILLER_13_311 vssd1 vssd1 vccd1 vccd1 sky130_fd_sc_hd__fill_1
XFILLER_25_182 vccd1 vssd1 vccd1 vssd1 sky130_ef_sc_hd__decap_40_12
XFILLER_9_304 vssd1 vssd1 vccd1 vccd1 sky130_fd_sc_hd__fill_1
XANTENNA_clkbuf_4_14_0_clk_A clknet_0_clk vssd1 vssd1 vccd1 vccd1 sky130_fd_sc_hd__diode_2
XFILLER_9_337 vssd1 vssd1 vccd1 vccd1 sky130_fd_sc_hd__fill_1
XANTENNA__4556__A2 net81 vssd1 vssd1 vccd1 vccd1 sky130_fd_sc_hd__diode_2
XANTENNA__5087__B _3774_ vssd1 vssd1 vccd1 vccd1 sky130_fd_sc_hd__diode_2
XFILLER_5_510 vccd1 vssd1 vccd1 vssd1 sky130_ef_sc_hd__decap_40_12
XFILLER_5_565 vssd1 vssd1 vccd1 vccd1 sky130_fd_sc_hd__fill_2
XANTENNA__5534__C net295 vssd1 vssd1 vccd1 vccd1 sky130_fd_sc_hd__diode_2
XFILLER_68_528 vssd1 vssd1 vccd1 vccd1 sky130_fd_sc_hd__fill_1
XFILLER_68_517 vssd1 vssd1 vccd1 vccd1 sky130_fd_sc_hd__fill_2
XTAP_TAPCELL_ROW_59_792 vssd1 vccd1 sky130_fd_sc_hd__tapvpwrvgnd_1
XFILLER_48_285 vssd1 vssd1 vccd1 vccd1 sky130_fd_sc_hd__fill_1
XANTENNA__6662__A net207 vssd1 vssd1 vccd1 vccd1 sky130_fd_sc_hd__diode_2
XFILLER_36_447 vccd1 vssd1 vccd1 vssd1 sky130_ef_sc_hd__decap_40_12
X_4980_ _0150_ _0168_ vssd1 vssd1 vccd1 vccd1 _0170_ sky130_fd_sc_hd__xnor2_1
XFILLER_23_119 vssd1 vssd1 vccd1 vccd1 sky130_fd_sc_hd__fill_8
XFILLER_16_193 vssd1 vssd1 vccd1 vccd1 sky130_fd_sc_hd__fill_1
X_6650_ _1842_ _1843_ vssd1 vssd1 vccd1 vccd1 _1844_ sky130_fd_sc_hd__nand2_1
X_5601_ _0773_ _0790_ vssd1 vssd1 vccd1 vccd1 _0791_ sky130_fd_sc_hd__nor2_1
X_6581_ _1766_ _1767_ vssd1 vssd1 vccd1 vccd1 _1769_ sky130_fd_sc_hd__and2_1
X_8320_ net310 net178 vssd1 vssd1 vccd1 vccd1 _3596_ sky130_fd_sc_hd__nand2_1
X_5532_ _0707_ _0709_ vssd1 vssd1 vccd1 vccd1 _0722_ sky130_fd_sc_hd__xnor2_1
X_8251_ _3355_ _3381_ _3521_ vssd1 vssd1 vccd1 vccd1 _3522_ sky130_fd_sc_hd__a21o_1
X_5463_ _0650_ _0651_ vssd1 vssd1 vccd1 vccd1 _0653_ sky130_fd_sc_hd__or2_1
X_4414_ net185 _3698_ net183 vssd1 vssd1 vccd1 vccd1 _3701_ sky130_fd_sc_hd__a21oi_1
X_8182_ _3445_ _3446_ vssd1 vssd1 vccd1 vccd1 _3447_ sky130_fd_sc_hd__xor2_1
X_5394_ _0565_ _0569_ vssd1 vssd1 vccd1 vccd1 _0584_ sky130_fd_sc_hd__xor2_1
X_7202_ _2063_ _2427_ vssd1 vssd1 vccd1 vccd1 _2429_ sky130_fd_sc_hd__nand2_1
X_7133_ _2353_ _2354_ vssd1 vssd1 vccd1 vccd1 _2355_ sky130_fd_sc_hd__xnor2_1
Xfanout305 net309 vssd1 vssd1 vccd1 vccd1 net305 sky130_fd_sc_hd__clkbuf_4
X_4345_ _3579_ _3644_ vssd1 vssd1 vccd1 vccd1 _3645_ sky130_fd_sc_hd__nand2_1
Xfanout316 PID_INST.k2_calc.reg_lc\[2\] vssd1 vssd1 vccd1 vccd1 net316 sky130_fd_sc_hd__buf_2
Xfanout338 net339 vssd1 vssd1 vccd1 vccd1 net338 sky130_fd_sc_hd__clkbuf_2
Xfanout327 net339 vssd1 vssd1 vccd1 vccd1 net327 sky130_fd_sc_hd__clkbuf_4
XANTENNA__6837__A net105 vssd1 vssd1 vccd1 vccd1 sky130_fd_sc_hd__diode_2
X_7064_ _2259_ _2260_ _2282_ vssd1 vssd1 vccd1 vccd1 _2284_ sky130_fd_sc_hd__o21a_1
XFILLER_86_336 vssd1 vssd1 vccd1 vccd1 sky130_fd_sc_hd__fill_1
X_4276_ net12 net161 vssd1 vssd1 vccd1 vccd1 _2961_ sky130_fd_sc_hd__nand2_1
XFILLER_86_369 vssd1 vssd1 vccd1 vccd1 sky130_fd_sc_hd__fill_2
XANTENNA_fanout281_A PID_INST.k2_calc.reg_lc\[8\] vssd1 vssd1 vccd1 vccd1 sky130_fd_sc_hd__diode_2
X_6015_ _1204_ _1203_ vssd1 vssd1 vccd1 vccd1 _1205_ sky130_fd_sc_hd__nand2b_1
XFILLER_82_553 vssd1 vssd1 vccd1 vccd1 sky130_fd_sc_hd__fill_2
XANTENNA__7668__A net204 vssd1 vssd1 vccd1 vccd1 sky130_fd_sc_hd__diode_2
XFILLER_27_469 vssd1 vssd1 vccd1 vccd1 sky130_fd_sc_hd__fill_2
XFILLER_36_38 vssd1 vssd1 vccd1 vccd1 sky130_fd_sc_hd__fill_4
X_7966_ net294 net183 vssd1 vssd1 vccd1 vccd1 _3221_ sky130_fd_sc_hd__nand2_1
XFILLER_42_428 vssd1 vssd1 vccd1 vccd1 sky130_fd_sc_hd__fill_2
X_6917_ _2003_ _2126_ vssd1 vssd1 vccd1 vccd1 _2127_ sky130_fd_sc_hd__xor2_1
X_7897_ net117 net37 _3095_ _3094_ vssd1 vssd1 vccd1 vccd1 _3152_ sky130_fd_sc_hd__o31ai_2
XANTENNA__6722__D net193 vssd1 vssd1 vccd1 vccd1 sky130_fd_sc_hd__diode_2
XFILLER_50_461 vssd1 vssd1 vccd1 vccd1 sky130_fd_sc_hd__fill_2
X_6848_ _1756_ _2053_ vssd1 vssd1 vccd1 vccd1 _2055_ sky130_fd_sc_hd__nand2_1
XFILLER_22_141 vssd1 vssd1 vccd1 vccd1 sky130_fd_sc_hd__fill_4
XFILLER_50_472 vssd1 vssd1 vccd1 vccd1 sky130_fd_sc_hd__fill_1
X_6779_ _1979_ _1980_ vssd1 vssd1 vccd1 vccd1 _1981_ sky130_fd_sc_hd__nand2_1
XFILLER_10_358 vssd1 vssd1 vccd1 vccd1 sky130_fd_sc_hd__fill_1
XFILLER_10_369 vssd1 vssd1 vccd1 vccd1 sky130_fd_sc_hd__fill_2
X_8449_ clknet_4_13_0_clk _0037_ net336 vssd1 vssd1 vccd1 vccd1 PID_INST.k2_calc.sum_reg\[5\]
+ sky130_fd_sc_hd__dfrtp_2
XTAP_TAPCELL_ROW_20_397 vssd1 vccd1 sky130_fd_sc_hd__tapvpwrvgnd_1
XFILLER_2_513 vssd1 vssd1 vccd1 vccd1 sky130_fd_sc_hd__fill_2
XFILLER_2_557 vssd1 vssd1 vccd1 vccd1 sky130_fd_sc_hd__fill_8
XFILLER_89_163 vssd1 vssd1 vccd1 vccd1 sky130_fd_sc_hd__fill_4
XFILLER_77_45 vssd1 vssd1 vccd1 vccd1 sky130_fd_sc_hd__fill_1
XANTENNA__5370__B net65 vssd1 vssd1 vccd1 vccd1 sky130_fd_sc_hd__diode_2
XFILLER_85_391 vssd1 vssd1 vccd1 vccd1 sky130_fd_sc_hd__fill_1
XFILLER_18_447 vssd1 vssd1 vccd1 vccd1 sky130_fd_sc_hd__fill_4
XTAP_TAPCELL_ROW_56_762 vssd1 vccd1 sky130_fd_sc_hd__tapvpwrvgnd_1
XFILLER_45_266 vssd1 vssd1 vccd1 vccd1 sky130_fd_sc_hd__fill_1
XFILLER_26_60 vssd1 vssd1 vccd1 vccd1 sky130_fd_sc_hd__fill_1
XFILLER_60_225 vssd1 vssd1 vccd1 vccd1 sky130_fd_sc_hd__fill_2
XFILLER_13_185 vssd1 vssd1 vccd1 vccd1 sky130_fd_sc_hd__fill_1
XFILLER_9_167 vssd1 vssd1 vccd1 vccd1 sky130_fd_sc_hd__fill_1
XANTENNA__8429__RESET_B net327 vssd1 vssd1 vccd1 vccd1 sky130_fd_sc_hd__diode_2
XANTENNA__5545__B net273 vssd1 vssd1 vccd1 vccd1 sky130_fd_sc_hd__diode_2
XANTENNA__8489__CLK clknet_4_15_0_clk vssd1 vssd1 vccd1 vccd1 sky130_fd_sc_hd__diode_2
XANTENNA__6151__B2 net137 vssd1 vssd1 vccd1 vccd1 sky130_fd_sc_hd__diode_2
XANTENNA__6657__A net199 vssd1 vssd1 vccd1 vccd1 sky130_fd_sc_hd__diode_2
XPHY_EDGE_ROW_79_Left_172 vssd1 vssd1 vccd1 vccd1 sky130_fd_sc_hd__decap_3
XFILLER_68_336 vssd1 vssd1 vccd1 vccd1 sky130_fd_sc_hd__fill_4
XANTENNA__8294__D net183 vssd1 vssd1 vccd1 vccd1 sky130_fd_sc_hd__diode_2
XFILLER_49_561 vssd1 vssd1 vccd1 vccd1 sky130_fd_sc_hd__fill_1
XFILLER_3_86 vccd1 vssd1 vccd1 vssd1 sky130_ef_sc_hd__decap_40_12
XFILLER_64_553 vssd1 vssd1 vccd1 vccd1 sky130_fd_sc_hd__fill_1
X_7820_ net98 net39 vssd1 vssd1 vccd1 vccd1 _3076_ sky130_fd_sc_hd__nor2_1
X_7751_ _2900_ _2914_ _3005_ vssd1 vssd1 vccd1 vccd1 _3007_ sky130_fd_sc_hd__and3_1
XFILLER_51_225 vssd1 vssd1 vccd1 vccd1 sky130_fd_sc_hd__fill_2
X_4963_ PID_INST.k1_calc.d1.x\[14\] PID_INST.k3_calc.prev_error\[14\] vssd1 vssd1
+ vccd1 vccd1 _0153_ sky130_fd_sc_hd__and2_1
XFILLER_24_428 vssd1 vssd1 vccd1 vccd1 sky130_fd_sc_hd__fill_8
X_7682_ _2678_ _2680_ _2934_ vssd1 vssd1 vccd1 vccd1 _2936_ sky130_fd_sc_hd__nand3_1
X_6702_ net154 _1899_ _1687_ vssd1 vssd1 vccd1 vccd1 _0063_ sky130_fd_sc_hd__a21oi_1
XPHY_EDGE_ROW_88_Left_181 vssd1 vssd1 vccd1 vccd1 sky130_fd_sc_hd__decap_3
X_6633_ _1824_ _1825_ vssd1 vssd1 vccd1 vccd1 _1826_ sky130_fd_sc_hd__nand2_1
X_4894_ _4095_ _4099_ _0081_ _0082_ vssd1 vssd1 vccd1 vccd1 _0084_ sky130_fd_sc_hd__o211ai_4
XFILLER_32_472 vssd1 vssd1 vccd1 vccd1 sky130_fd_sc_hd__fill_1
X_6564_ _1743_ _1749_ vssd1 vssd1 vccd1 vccd1 _1751_ sky130_fd_sc_hd__xnor2_1
X_8303_ _3575_ _3576_ vssd1 vssd1 vccd1 vccd1 _3577_ sky130_fd_sc_hd__xnor2_1
X_5515_ _0701_ _0704_ vssd1 vssd1 vccd1 vccd1 _0705_ sky130_fd_sc_hd__xnor2_1
X_6495_ _1603_ _1682_ vssd1 vssd1 vccd1 vccd1 _1683_ sky130_fd_sc_hd__and2_1
X_8234_ _3501_ _3502_ vssd1 vssd1 vccd1 vccd1 _3503_ sky130_fd_sc_hd__nor2_1
X_5446_ net107 net58 net55 net105 vssd1 vssd1 vccd1 vccd1 _0636_ sky130_fd_sc_hd__o22ai_1
X_5377_ _0148_ _0566_ vssd1 vssd1 vccd1 vccd1 _0567_ sky130_fd_sc_hd__nand2_1
Xfanout113 PID_INST.k3_calc.d1.y\[1\] vssd1 vssd1 vccd1 vccd1 net113 sky130_fd_sc_hd__buf_2
X_8165_ _2707_ net42 net40 net96 vssd1 vssd1 vccd1 vccd1 _3430_ sky130_fd_sc_hd__o22a_1
Xfanout102 _2580_ vssd1 vssd1 vccd1 vccd1 net102 sky130_fd_sc_hd__clkbuf_2
X_8096_ _3352_ _3353_ _3354_ vssd1 vssd1 vccd1 vccd1 _3355_ sky130_fd_sc_hd__or3b_2
X_7116_ _2335_ _2336_ vssd1 vssd1 vccd1 vccd1 _2337_ sky130_fd_sc_hd__nor2_1
X_4328_ net237 _3450_ _3461_ vssd1 vssd1 vccd1 vccd1 _3493_ sky130_fd_sc_hd__o21a_1
Xfanout124 net125 vssd1 vssd1 vccd1 vccd1 net124 sky130_fd_sc_hd__clkbuf_4
Xfanout146 _3784_ vssd1 vssd1 vccd1 vccd1 net146 sky130_fd_sc_hd__clkbuf_2
Xfanout135 PID_INST.k3_calc.d1.y\[10\] vssd1 vssd1 vccd1 vccd1 net135 sky130_fd_sc_hd__buf_2
X_7047_ net307 net193 vssd1 vssd1 vccd1 vccd1 _2266_ sky130_fd_sc_hd__nand2_1
XFILLER_74_306 vssd1 vssd1 vccd1 vccd1 sky130_fd_sc_hd__fill_2
Xfanout179 PID_INST.k2_calc.sum_reg\[22\] vssd1 vssd1 vccd1 vccd1 net179 sky130_fd_sc_hd__buf_2
Xfanout157 net159 vssd1 vssd1 vccd1 vccd1 net157 sky130_fd_sc_hd__clkbuf_4
Xfanout168 _1860_ vssd1 vssd1 vccd1 vccd1 net168 sky130_fd_sc_hd__buf_2
X_4259_ _2771_ vssd1 vssd1 vccd1 vccd1 PID_INST.k3_calc.d2.y\[15\] sky130_fd_sc_hd__inv_2
XANTENNA_input1_A en vssd1 vssd1 vccd1 vccd1 sky130_fd_sc_hd__diode_2
XFILLER_74_339 vssd1 vssd1 vccd1 vccd1 sky130_fd_sc_hd__fill_1
XFILLER_74_317 vssd1 vssd1 vccd1 vccd1 sky130_fd_sc_hd__fill_4
XFILLER_47_59 vssd1 vssd1 vccd1 vccd1 sky130_fd_sc_hd__fill_4
XFILLER_47_48 vssd1 vssd1 vccd1 vccd1 sky130_fd_sc_hd__fill_1
XANTENNA__8198__A2 net260 vssd1 vssd1 vccd1 vccd1 sky130_fd_sc_hd__diode_2
XFILLER_55_564 vssd1 vssd1 vccd1 vccd1 sky130_fd_sc_hd__fill_2
XFILLER_15_417 vssd1 vssd1 vccd1 vccd1 sky130_fd_sc_hd__fill_1
XANTENNA__4208__A1 net14 vssd1 vssd1 vccd1 vccd1 sky130_fd_sc_hd__diode_2
X_7949_ _3197_ _3202_ vssd1 vssd1 vccd1 vccd1 _3204_ sky130_fd_sc_hd__xnor2_1
XFILLER_70_545 vccd1 vssd1 vccd1 vssd1 sky130_ef_sc_hd__decap_40_12
XTAP_TAPCELL_ROW_53_732 vssd1 vccd1 sky130_fd_sc_hd__tapvpwrvgnd_1
XANTENNA__8006__B _3259_ vssd1 vssd1 vccd1 vccd1 sky130_fd_sc_hd__diode_2
XFILLER_70_567 vssd1 vssd1 vccd1 vccd1 sky130_fd_sc_hd__fill_2
XFILLER_23_461 vccd1 vssd1 vccd1 vssd1 sky130_ef_sc_hd__decap_40_12
XFILLER_10_177 vssd1 vssd1 vccd1 vccd1 sky130_fd_sc_hd__fill_2
XFILLER_6_159 vccd1 vssd1 vccd1 vssd1 sky130_ef_sc_hd__decap_40_12
XFILLER_6_148 vssd1 vssd1 vccd1 vccd1 sky130_fd_sc_hd__fill_1
XFILLER_2_343 vssd1 vssd1 vccd1 vccd1 sky130_fd_sc_hd__fill_1
XFILLER_2_365 vccd1 vssd1 vccd1 vssd1 sky130_ef_sc_hd__decap_40_12
XFILLER_77_111 vssd1 vssd1 vccd1 vccd1 sky130_fd_sc_hd__fill_1
XANTENNA__6627__D net254 vssd1 vssd1 vccd1 vccd1 sky130_fd_sc_hd__diode_2
XANTENNA__4447__A1 PID_INST.k1_calc.d1.x\[0\] vssd1 vssd1 vccd1 vccd1 sky130_fd_sc_hd__diode_2
XFILLER_46_531 vssd1 vssd1 vccd1 vccd1 sky130_fd_sc_hd__fill_1
XANTENNA_input12_X net12 vssd1 vssd1 vccd1 vccd1 sky130_fd_sc_hd__diode_2
XFILLER_92_169 vssd1 vssd1 vccd1 vccd1 sky130_fd_sc_hd__fill_4
XFILLER_73_361 vssd1 vssd1 vccd1 vccd1 sky130_fd_sc_hd__fill_1
XFILLER_73_350 vssd1 vssd1 vccd1 vccd1 sky130_fd_sc_hd__fill_1
XFILLER_18_244 vssd1 vssd1 vccd1 vccd1 sky130_fd_sc_hd__fill_8
XFILLER_18_277 vssd1 vssd1 vccd1 vccd1 sky130_fd_sc_hd__fill_4
XFILLER_73_383 vssd1 vssd1 vccd1 vccd1 sky130_fd_sc_hd__fill_1
XFILLER_61_534 vssd1 vssd1 vccd1 vccd1 sky130_fd_sc_hd__fill_4
XFILLER_33_225 vssd1 vssd1 vccd1 vccd1 sky130_fd_sc_hd__fill_4
XFILLER_33_236 vccd1 vssd1 vccd1 vssd1 sky130_ef_sc_hd__decap_40_12
XANTENNA__4460__A _2210_ vssd1 vssd1 vccd1 vccd1 sky130_fd_sc_hd__diode_2
X_5300_ _0365_ _0416_ _0418_ vssd1 vssd1 vccd1 vccd1 _0490_ sky130_fd_sc_hd__o21ba_1
X_6280_ net223 net287 vssd1 vssd1 vccd1 vccd1 _1469_ sky130_fd_sc_hd__nand2_1
X_5231_ _0415_ _0420_ vssd1 vssd1 vccd1 vccd1 _0421_ sky130_fd_sc_hd__xor2_1
X_5162_ _0350_ _0351_ vssd1 vssd1 vccd1 vccd1 _0352_ sky130_fd_sc_hd__xnor2_1
X_5093_ _0277_ _0282_ vssd1 vssd1 vccd1 vccd1 _0283_ sky130_fd_sc_hd__xnor2_1
XFILLER_29_509 vssd1 vssd1 vccd1 vccd1 sky130_fd_sc_hd__fill_2
XTAP_TAPCELL_ROW_67_868 vssd1 vccd1 sky130_fd_sc_hd__tapvpwrvgnd_1
XFILLER_56_339 vssd1 vssd1 vccd1 vccd1 sky130_fd_sc_hd__fill_4
XFILLER_83_158 vssd1 vssd1 vccd1 vccd1 sky130_fd_sc_hd__fill_2
XFILLER_52_523 vssd1 vssd1 vccd1 vccd1 sky130_fd_sc_hd__fill_1
XANTENNA_clkbuf_4_2_0_clk_A clknet_0_clk vssd1 vssd1 vccd1 vccd1 sky130_fd_sc_hd__diode_2
X_7803_ net94 net48 _3058_ vssd1 vssd1 vccd1 vccd1 _3059_ sky130_fd_sc_hd__nor3_1
XANTENNA__7946__A net293 vssd1 vssd1 vccd1 vccd1 sky130_fd_sc_hd__diode_2
X_7734_ _2890_ _2897_ _2989_ vssd1 vssd1 vccd1 vccd1 _2990_ sky130_fd_sc_hd__a21o_1
X_5995_ _1184_ _1183_ vssd1 vssd1 vccd1 vccd1 _1185_ sky130_fd_sc_hd__nand2b_1
XANTENNA_fanout244_A PID_INST.k2_calc.sum_reg\[2\] vssd1 vssd1 vccd1 vccd1 sky130_fd_sc_hd__diode_2
XTAP_TAPCELL_ROW_50_702 vssd1 vccd1 sky130_fd_sc_hd__tapvpwrvgnd_1
X_4946_ _0135_ _0134_ vssd1 vssd1 vccd1 vccd1 _0136_ sky130_fd_sc_hd__nand2b_1
XANTENNA__6850__A net95 vssd1 vssd1 vccd1 vccd1 sky130_fd_sc_hd__diode_2
X_7665_ _2692_ _2701_ _2700_ vssd1 vssd1 vccd1 vccd1 _2919_ sky130_fd_sc_hd__a21oi_1
X_4877_ _4084_ _4087_ _4153_ _4154_ vssd1 vssd1 vccd1 vccd1 _4155_ sky130_fd_sc_hd__o211ai_4
X_7596_ _2846_ _2837_ vssd1 vssd1 vccd1 vccd1 _2847_ sky130_fd_sc_hd__nand2b_1
X_6616_ _1805_ _1807_ vssd1 vssd1 vccd1 vccd1 _1808_ sky130_fd_sc_hd__nor2_1
XANTENNA__8199__D net189 vssd1 vssd1 vccd1 vccd1 sky130_fd_sc_hd__diode_2
X_6547_ _1732_ _1733_ vssd1 vssd1 vccd1 vccd1 _1734_ sky130_fd_sc_hd__and2b_1
XANTENNA__4913__A2 net85 vssd1 vssd1 vccd1 vccd1 sky130_fd_sc_hd__diode_2
X_6478_ _1664_ _1665_ vssd1 vssd1 vccd1 vccd1 _1666_ sky130_fd_sc_hd__nor2_1
XFILLER_3_129 vccd1 vssd1 vccd1 vssd1 sky130_ef_sc_hd__decap_40_12
X_8217_ _3342_ _3344_ vssd1 vssd1 vccd1 vccd1 _3485_ sky130_fd_sc_hd__or2_1
X_5429_ _0616_ _0617_ vssd1 vssd1 vccd1 vccd1 _0619_ sky130_fd_sc_hd__xor2_1
XFILLER_59_111 vssd1 vssd1 vccd1 vccd1 sky130_fd_sc_hd__fill_1
X_8148_ _3262_ _3264_ _3260_ vssd1 vssd1 vccd1 vccd1 _3412_ sky130_fd_sc_hd__a21oi_1
XANTENNA_input4_X net4 vssd1 vssd1 vccd1 vccd1 sky130_fd_sc_hd__diode_2
XFILLER_87_486 vssd1 vssd1 vccd1 vccd1 sky130_fd_sc_hd__fill_2
X_8079_ _3199_ _3201_ _3198_ vssd1 vssd1 vccd1 vccd1 _3337_ sky130_fd_sc_hd__o21ba_1
XFILLER_74_79 vssd1 vssd1 vccd1 vccd1 sky130_fd_sc_hd__fill_4
XTAP_TAPCELL_ROW_38_581 vssd1 vccd1 sky130_fd_sc_hd__tapvpwrvgnd_1
XFILLER_82_191 vssd1 vssd1 vccd1 vccd1 sky130_fd_sc_hd__fill_4
XFILLER_70_375 vssd1 vssd1 vccd1 vccd1 sky130_fd_sc_hd__fill_1
XFILLER_90_56 vssd1 vssd1 vccd1 vccd1 sky130_fd_sc_hd__fill_8
XFILLER_11_442 vssd1 vssd1 vccd1 vccd1 sky130_fd_sc_hd__fill_4
XANTENNA__5376__A net111 vssd1 vssd1 vccd1 vccd1 sky130_fd_sc_hd__diode_2
XFILLER_11_464 vssd1 vssd1 vccd1 vccd1 sky130_fd_sc_hd__fill_8
XFILLER_7_446 vssd1 vssd1 vccd1 vccd1 sky130_fd_sc_hd__fill_2
XFILLER_11_497 vssd1 vssd1 vccd1 vccd1 sky130_fd_sc_hd__fill_4
XFILLER_23_94 vssd1 vssd1 vccd1 vccd1 sky130_fd_sc_hd__fill_2
XFILLER_78_475 vssd1 vssd1 vccd1 vccd1 sky130_fd_sc_hd__fill_1
XFILLER_38_328 vccd1 vssd1 vccd1 vssd1 sky130_ef_sc_hd__decap_40_12
XFILLER_17_6 vssd1 vssd1 vccd1 vccd1 sky130_fd_sc_hd__fill_2
XFILLER_0_43 vssd1 vssd1 vccd1 vccd1 sky130_fd_sc_hd__fill_1
XFILLER_19_553 vssd1 vssd1 vccd1 vccd1 sky130_fd_sc_hd__fill_2
XTAP_TAPCELL_ROW_64_838 vssd1 vccd1 sky130_fd_sc_hd__tapvpwrvgnd_1
XFILLER_46_372 vssd1 vssd1 vccd1 vccd1 sky130_fd_sc_hd__fill_4
XFILLER_0_65 vssd1 vssd1 vccd1 vccd1 sky130_fd_sc_hd__fill_1
X_4800_ _4045_ _4077_ vssd1 vssd1 vccd1 vccd1 _4078_ sky130_fd_sc_hd__or2_1
XFILLER_34_545 vssd1 vssd1 vccd1 vccd1 sky130_fd_sc_hd__fill_1
X_5780_ _0922_ _0929_ _0963_ _0968_ vssd1 vssd1 vccd1 vccd1 _0970_ sky130_fd_sc_hd__a211oi_1
XANTENNA__6593__A1 net114 vssd1 vssd1 vccd1 vccd1 sky130_fd_sc_hd__diode_2
X_4731_ _3822_ _3841_ vssd1 vssd1 vccd1 vccd1 _4009_ sky130_fd_sc_hd__nand2_1
XANTENNA__4902__B _4033_ vssd1 vssd1 vccd1 vccd1 sky130_fd_sc_hd__diode_2
X_7450_ net309 net186 vssd1 vssd1 vccd1 vccd1 _2691_ sky130_fd_sc_hd__nand2_1
XFILLER_9_85 vssd1 vssd1 vccd1 vccd1 sky130_fd_sc_hd__fill_4
XFILLER_9_74 vssd1 vssd1 vccd1 vccd1 sky130_fd_sc_hd__fill_8
X_4662_ net141 _3736_ vssd1 vssd1 vccd1 vccd1 _3940_ sky130_fd_sc_hd__nand2_1
X_6401_ net106 net41 vssd1 vssd1 vccd1 vccd1 _1589_ sky130_fd_sc_hd__nor2_1
X_7381_ _2348_ _2371_ vssd1 vssd1 vccd1 vccd1 _2619_ sky130_fd_sc_hd__nor2_1
X_4593_ net120 net84 vssd1 vssd1 vccd1 vccd1 _3871_ sky130_fd_sc_hd__nand2_1
XANTENNA__7932__C net256 vssd1 vssd1 vccd1 vccd1 sky130_fd_sc_hd__diode_2
XANTENNA__8098__A1 net202 vssd1 vssd1 vccd1 vccd1 sky130_fd_sc_hd__diode_2
X_6332_ _1510_ _1519_ vssd1 vssd1 vccd1 vccd1 _1520_ sky130_fd_sc_hd__xnor2_1
XFILLER_88_206 vssd1 vssd1 vccd1 vccd1 sky130_fd_sc_hd__fill_8
XANTENNA__7651__D net182 vssd1 vssd1 vccd1 vccd1 sky130_fd_sc_hd__diode_2
X_6263_ _1451_ _1450_ vssd1 vssd1 vccd1 vccd1 _1452_ sky130_fd_sc_hd__and2b_1
X_8002_ _3048_ _3051_ _3256_ vssd1 vssd1 vccd1 vccd1 _3257_ sky130_fd_sc_hd__o21a_1
X_5214_ net105 net49 vssd1 vssd1 vccd1 vccd1 _0404_ sky130_fd_sc_hd__nor2_1
X_6194_ _1381_ _1382_ vssd1 vssd1 vccd1 vccd1 _1383_ sky130_fd_sc_hd__nand2b_1
XANTENNA__5608__B1 net220 vssd1 vssd1 vccd1 vccd1 sky130_fd_sc_hd__diode_2
XANTENNA_fanout194_A net196 vssd1 vssd1 vccd1 vccd1 sky130_fd_sc_hd__diode_2
X_5145_ PID_INST.k3_calc.d1.y\[4\] _0084_ _0086_ vssd1 vssd1 vccd1 vccd1 _0335_ sky130_fd_sc_hd__and3_1
XANTENNA__7073__A2 net287 vssd1 vssd1 vccd1 vccd1 sky130_fd_sc_hd__diode_2
X_5076_ _0264_ _0265_ vssd1 vssd1 vccd1 vccd1 _0266_ sky130_fd_sc_hd__or2_1
XANTENNA__4365__A net214 vssd1 vssd1 vccd1 vccd1 sky130_fd_sc_hd__diode_2
XFILLER_25_534 vssd1 vssd1 vccd1 vccd1 sky130_fd_sc_hd__fill_2
XANTENNA__8022__A1 net100 vssd1 vssd1 vccd1 vccd1 sky130_fd_sc_hd__diode_2
XFILLER_37_383 vssd1 vssd1 vccd1 vccd1 sky130_fd_sc_hd__fill_8
XFILLER_44_27 vssd1 vssd1 vccd1 vccd1 sky130_fd_sc_hd__fill_1
XTAP_TAPCELL_ROW_35_551 vssd1 vccd1 sky130_fd_sc_hd__tapvpwrvgnd_1
X_5978_ _1165_ _1166_ vssd1 vssd1 vccd1 vccd1 _1168_ sky130_fd_sc_hd__xnor2_1
XFILLER_52_397 vssd1 vssd1 vccd1 vccd1 sky130_fd_sc_hd__fill_2
X_7717_ net154 _2971_ _2972_ _2973_ vssd1 vssd1 vccd1 vccd1 _0069_ sky130_fd_sc_hd__a31o_1
X_4929_ net135 net88 vssd1 vssd1 vccd1 vccd1 _0119_ sky130_fd_sc_hd__nand2_1
X_7648_ _2657_ _2665_ _2899_ vssd1 vssd1 vccd1 vccd1 _2901_ sky130_fd_sc_hd__nand3_1
XANTENNA__4347__A0 net226 vssd1 vssd1 vccd1 vccd1 sky130_fd_sc_hd__diode_2
X_7579_ net94 net51 net49 net96 vssd1 vssd1 vccd1 vccd1 _2828_ sky130_fd_sc_hd__o22a_1
XANTENNA__7836__A1 net117 vssd1 vssd1 vccd1 vccd1 sky130_fd_sc_hd__diode_2
XFILLER_87_272 vssd1 vssd1 vccd1 vccd1 sky130_fd_sc_hd__fill_2
XFILLER_75_434 vssd1 vssd1 vccd1 vccd1 sky130_fd_sc_hd__fill_4
XANTENNA_fanout62_X net62 vssd1 vssd1 vccd1 vccd1 sky130_fd_sc_hd__diode_2
XFILLER_75_478 vssd1 vssd1 vccd1 vccd1 sky130_fd_sc_hd__fill_2
XFILLER_47_169 vccd1 vssd1 vccd1 vssd1 sky130_ef_sc_hd__decap_40_12
XFILLER_35_309 vssd1 vssd1 vccd1 vccd1 sky130_fd_sc_hd__fill_8
XTAP_TAPCELL_ROW_87_1070 vssd1 vccd1 sky130_fd_sc_hd__tapvpwrvgnd_1
XFILLER_16_501 vssd1 vssd1 vccd1 vccd1 sky130_fd_sc_hd__fill_8
XTAP_TAPCELL_ROW_61_808 vssd1 vccd1 sky130_fd_sc_hd__tapvpwrvgnd_1
XFILLER_16_556 vccd1 vssd1 vccd1 vssd1 sky130_ef_sc_hd__decap_40_12
XFILLER_70_172 vssd1 vssd1 vccd1 vccd1 sky130_fd_sc_hd__fill_1
XFILLER_31_559 vssd1 vssd1 vccd1 vccd1 sky130_fd_sc_hd__fill_1
XANTENNA__5834__A net251 vssd1 vssd1 vccd1 vccd1 sky130_fd_sc_hd__diode_2
XANTENNA__4889__A1 _2389_ vssd1 vssd1 vccd1 vccd1 sky130_fd_sc_hd__diode_2
XFILLER_11_294 vssd1 vssd1 vccd1 vccd1 sky130_fd_sc_hd__fill_2
XFILLER_50_92 vssd1 vssd1 vccd1 vccd1 sky130_fd_sc_hd__fill_2
XFILLER_50_81 vssd1 vssd1 vccd1 vccd1 sky130_fd_sc_hd__fill_2
XFILLER_78_250 vssd1 vssd1 vccd1 vccd1 sky130_fd_sc_hd__fill_2
XFILLER_15_3 vccd1 vssd1 vccd1 vssd1 sky130_ef_sc_hd__decap_40_12
XANTENNA__4456__Y _3734_ vssd1 vssd1 vccd1 vccd1 sky130_fd_sc_hd__diode_2
XTAP_TAPCELL_ROW_77_974 vssd1 vccd1 sky130_fd_sc_hd__tapvpwrvgnd_1
X_6950_ _2053_ _2161_ vssd1 vssd1 vccd1 vccd1 _2162_ sky130_fd_sc_hd__xnor2_1
XFILLER_19_350 vssd1 vssd1 vccd1 vccd1 sky130_fd_sc_hd__fill_4
XFILLER_26_309 vssd1 vssd1 vccd1 vccd1 sky130_fd_sc_hd__fill_1
XFILLER_38_158 vssd1 vssd1 vccd1 vccd1 sky130_fd_sc_hd__fill_1
X_5901_ _1055_ _1071_ _1090_ vssd1 vssd1 vccd1 vccd1 _1091_ sky130_fd_sc_hd__a21bo_1
XFILLER_53_139 vssd1 vssd1 vccd1 vccd1 sky130_fd_sc_hd__fill_8
XTAP_TAPCELL_ROW_49_687 vssd1 vccd1 sky130_fd_sc_hd__tapvpwrvgnd_1
XFILLER_19_361 vssd1 vssd1 vccd1 vccd1 sky130_fd_sc_hd__fill_8
XFILLER_19_383 vssd1 vssd1 vccd1 vccd1 sky130_fd_sc_hd__fill_8
XFILLER_81_459 vccd1 vssd1 vccd1 vssd1 sky130_ef_sc_hd__decap_40_12
X_6881_ _2089_ _2081_ vssd1 vssd1 vccd1 vccd1 _2090_ sky130_fd_sc_hd__and2b_1
X_5832_ _1020_ _1021_ vssd1 vssd1 vccd1 vccd1 _1022_ sky130_fd_sc_hd__nor2_1
X_5763_ _0908_ _0910_ vssd1 vssd1 vccd1 vccd1 _0953_ sky130_fd_sc_hd__and2_1
XANTENNA__5774__C1 net288 vssd1 vssd1 vccd1 vccd1 sky130_fd_sc_hd__diode_2
XTAP_TAPCELL_ROW_32_521 vssd1 vccd1 sky130_fd_sc_hd__tapvpwrvgnd_1
X_4714_ _3803_ _3804_ _3802_ vssd1 vssd1 vccd1 vccd1 _3992_ sky130_fd_sc_hd__o21ai_1
X_7502_ _2745_ _2746_ vssd1 vssd1 vccd1 vccd1 _2747_ sky130_fd_sc_hd__xnor2_1
X_5694_ _0875_ _0877_ _0876_ vssd1 vssd1 vccd1 vccd1 _0884_ sky130_fd_sc_hd__o21ai_1
X_8482_ clknet_4_14_0_clk _0070_ net340 vssd1 vssd1 vccd1 vccd1 net31 sky130_fd_sc_hd__dfrtp_1
X_7433_ net299 net188 net184 net311 vssd1 vssd1 vccd1 vccd1 _2673_ sky130_fd_sc_hd__a22oi_1
XPHY_EDGE_ROW_15_Left_108 vssd1 vssd1 vccd1 vccd1 sky130_fd_sc_hd__decap_3
X_4645_ net120 net144 _3910_ _3920_ vssd1 vssd1 vccd1 vccd1 _3923_ sky130_fd_sc_hd__a22o_1
X_7364_ _2598_ _2599_ vssd1 vssd1 vccd1 vccd1 _2600_ sky130_fd_sc_hd__xnor2_1
XANTENNA_fanout207_A net208 vssd1 vssd1 vccd1 vccd1 sky130_fd_sc_hd__diode_2
X_4576_ _3761_ _3762_ net78 net141 vssd1 vssd1 vccd1 vccd1 _3854_ sky130_fd_sc_hd__a22o_1
X_6315_ net140 net54 vssd1 vssd1 vccd1 vccd1 _1503_ sky130_fd_sc_hd__nor2_1
XANTENNA__7818__A1 net110 vssd1 vssd1 vccd1 vccd1 sky130_fd_sc_hd__diode_2
XFILLER_89_537 vccd1 vssd1 vccd1 vssd1 sky130_ef_sc_hd__decap_40_12
X_7295_ _2525_ _2526_ vssd1 vssd1 vccd1 vccd1 _2527_ sky130_fd_sc_hd__nor2_1
XFILLER_89_559 vssd1 vssd1 vccd1 vccd1 sky130_fd_sc_hd__fill_1
X_6246_ _1432_ _1433_ vssd1 vssd1 vccd1 vccd1 _1435_ sky130_fd_sc_hd__xnor2_1
XFILLER_69_261 vssd1 vssd1 vccd1 vccd1 sky130_fd_sc_hd__fill_2
X_6177_ _1365_ _1364_ vssd1 vssd1 vccd1 vccd1 _1366_ sky130_fd_sc_hd__nand2b_1
X_5128_ _0316_ _0317_ vssd1 vssd1 vccd1 vccd1 _0318_ sky130_fd_sc_hd__nor2_1
XPHY_EDGE_ROW_24_Left_117 vssd1 vssd1 vccd1 vccd1 sky130_fd_sc_hd__decap_3
XFILLER_84_253 vssd1 vssd1 vccd1 vccd1 sky130_fd_sc_hd__fill_8
XFILLER_84_231 vccd1 vssd1 vccd1 vssd1 sky130_ef_sc_hd__decap_40_12
XANTENNA__8366__RESET_B net327 vssd1 vssd1 vccd1 vccd1 sky130_fd_sc_hd__diode_2
X_5059_ net130 net82 _0200_ _0199_ vssd1 vssd1 vccd1 vccd1 _0249_ sky130_fd_sc_hd__a31o_1
XFILLER_72_448 vssd1 vssd1 vccd1 vccd1 sky130_fd_sc_hd__fill_2
XFILLER_25_342 vssd1 vssd1 vccd1 vccd1 sky130_fd_sc_hd__fill_4
XANTENNA__5638__B net210 vssd1 vssd1 vccd1 vccd1 sky130_fd_sc_hd__diode_2
XFILLER_13_537 vccd1 vssd1 vccd1 vssd1 sky130_ef_sc_hd__decap_40_12
XPHY_EDGE_ROW_33_Left_126 vssd1 vssd1 vccd1 vccd1 sky130_fd_sc_hd__decap_3
XANTENNA__8030__A net100 vssd1 vssd1 vccd1 vccd1 sky130_fd_sc_hd__diode_2
XFILLER_20_95 vssd1 vssd1 vccd1 vccd1 sky130_fd_sc_hd__fill_8
XPHY_EDGE_ROW_42_Left_135 vssd1 vssd1 vccd1 vccd1 sky130_fd_sc_hd__decap_3
XANTENNA_clkbuf_4_10_0_clk_A clknet_0_clk vssd1 vssd1 vccd1 vccd1 sky130_fd_sc_hd__diode_2
XFILLER_75_253 vssd1 vssd1 vccd1 vccd1 sky130_fd_sc_hd__fill_4
XANTENNA__4276__Y _2961_ vssd1 vssd1 vccd1 vccd1 sky130_fd_sc_hd__diode_2
XFILLER_90_223 vssd1 vssd1 vccd1 vccd1 sky130_fd_sc_hd__fill_1
XFILLER_75_297 vssd1 vssd1 vccd1 vccd1 sky130_fd_sc_hd__fill_8
XTAP_TAPCELL_ROW_74_944 vssd1 vccd1 sky130_fd_sc_hd__tapvpwrvgnd_1
XTAP_TAPCELL_ROW_46_657 vssd1 vccd1 sky130_fd_sc_hd__tapvpwrvgnd_1
XFILLER_16_342 vssd1 vssd1 vccd1 vccd1 sky130_fd_sc_hd__fill_2
XFILLER_28_180 vssd1 vssd1 vccd1 vccd1 sky130_fd_sc_hd__fill_4
XFILLER_28_191 vssd1 vssd1 vccd1 vccd1 sky130_fd_sc_hd__fill_4
XFILLER_16_375 vssd1 vssd1 vccd1 vccd1 sky130_fd_sc_hd__fill_1
XFILLER_84_6 vssd1 vssd1 vccd1 vccd1 sky130_fd_sc_hd__fill_8
XPHY_EDGE_ROW_51_Left_144 vssd1 vssd1 vccd1 vccd1 sky130_fd_sc_hd__decap_3
Xclkbuf_4_14_0_clk clknet_0_clk vssd1 vssd1 vccd1 vccd1 clknet_4_14_0_clk sky130_fd_sc_hd__clkbuf_8
XFILLER_61_91 vssd1 vssd1 vccd1 vccd1 sky130_fd_sc_hd__fill_1
X_4430_ PID_INST.k2_calc.sum_reg\[26\] _3707_ net178 vssd1 vssd1 vccd1 vccd1 _3710_
+ sky130_fd_sc_hd__and3b_1
XANTENNA__5564__A net220 vssd1 vssd1 vccd1 vccd1 sky130_fd_sc_hd__diode_2
XFILLER_6_75 vssd1 vssd1 vccd1 vccd1 sky130_fd_sc_hd__fill_8
X_4361_ net214 net4 vssd1 vssd1 vccd1 vccd1 _3658_ sky130_fd_sc_hd__nor2_1
X_6100_ _1211_ _1288_ vssd1 vssd1 vccd1 vccd1 _1290_ sky130_fd_sc_hd__xnor2_1
X_7080_ _2298_ _2299_ vssd1 vssd1 vccd1 vccd1 _2300_ sky130_fd_sc_hd__nor2_1
X_4292_ net394 net10 net161 vssd1 vssd1 vccd1 vccd1 _0015_ sky130_fd_sc_hd__mux2_1
XPHY_EDGE_ROW_60_Left_153 vssd1 vssd1 vccd1 vccd1 sky130_fd_sc_hd__decap_3
X_6031_ net203 net321 _1220_ vssd1 vssd1 vccd1 vccd1 _1221_ sky130_fd_sc_hd__nand3_1
XFILLER_66_253 vssd1 vssd1 vccd1 vccd1 sky130_fd_sc_hd__fill_2
XANTENNA__4627__B net88 vssd1 vssd1 vccd1 vccd1 sky130_fd_sc_hd__diode_2
XFILLER_39_445 vssd1 vssd1 vccd1 vccd1 sky130_fd_sc_hd__fill_2
X_7982_ _3234_ _3235_ _3236_ vssd1 vssd1 vccd1 vccd1 _3237_ sky130_fd_sc_hd__or3_1
XFILLER_66_286 vssd1 vssd1 vccd1 vccd1 sky130_fd_sc_hd__fill_1
XFILLER_26_128 vssd1 vssd1 vccd1 vccd1 sky130_fd_sc_hd__fill_4
XFILLER_81_223 vssd1 vssd1 vccd1 vccd1 sky130_fd_sc_hd__fill_1
X_6933_ _2121_ _2143_ vssd1 vssd1 vccd1 vccd1 _2144_ sky130_fd_sc_hd__xnor2_1
XFILLER_54_448 vssd1 vssd1 vccd1 vccd1 sky130_fd_sc_hd__fill_8
XFILLER_19_180 vccd1 vssd1 vccd1 vssd1 sky130_ef_sc_hd__decap_40_12
XANTENNA__4643__A net120 vssd1 vssd1 vccd1 vccd1 sky130_fd_sc_hd__diode_2
X_6864_ _2068_ _2069_ vssd1 vssd1 vccd1 vccd1 _2071_ sky130_fd_sc_hd__xnor2_1
XFILLER_34_150 vssd1 vssd1 vccd1 vccd1 sky130_fd_sc_hd__fill_1
XANTENNA_fanout157_A net159 vssd1 vssd1 vccd1 vccd1 sky130_fd_sc_hd__diode_2
X_5815_ _1002_ _1003_ vssd1 vssd1 vccd1 vccd1 _1005_ sky130_fd_sc_hd__xnor2_1
XTAP_TAPCELL_ROW_17_370 vssd1 vccd1 sky130_fd_sc_hd__tapvpwrvgnd_1
XFILLER_34_194 vssd1 vssd1 vccd1 vccd1 sky130_fd_sc_hd__fill_2
XANTENNA__4362__B net4 vssd1 vssd1 vccd1 vccd1 sky130_fd_sc_hd__diode_2
X_6795_ _1997_ _1992_ vssd1 vssd1 vccd1 vccd1 _1998_ sky130_fd_sc_hd__nand2b_1
X_5746_ _0935_ vssd1 vssd1 vccd1 vccd1 _0936_ sky130_fd_sc_hd__inv_2
X_8465_ clknet_4_7_0_clk _0053_ net333 vssd1 vssd1 vccd1 vccd1 PID_INST.k2_calc.sum_reg\[21\]
+ sky130_fd_sc_hd__dfrtp_1
X_5677_ _0861_ _0863_ vssd1 vssd1 vccd1 vccd1 _0867_ sky130_fd_sc_hd__nand2_1
X_7416_ _2653_ _2654_ vssd1 vssd1 vccd1 vccd1 _2655_ sky130_fd_sc_hd__xnor2_1
XANTENNA__5474__A net107 vssd1 vssd1 vccd1 vccd1 sky130_fd_sc_hd__diode_2
X_4628_ net120 net86 _3905_ vssd1 vssd1 vccd1 vccd1 _3906_ sky130_fd_sc_hd__and3_1
XANTENNA_fanout112_X net112 vssd1 vssd1 vccd1 vccd1 sky130_fd_sc_hd__diode_2
X_8396_ clknet_4_6_0_clk _0016_ net338 vssd1 vssd1 vccd1 vccd1 PID_INST.k2_calc.reg_lc\[0\]
+ sky130_fd_sc_hd__dfrtp_1
XFILLER_89_312 vssd1 vssd1 vccd1 vccd1 sky130_fd_sc_hd__fill_2
X_7347_ _2581_ _2582_ vssd1 vssd1 vccd1 vccd1 _2583_ sky130_fd_sc_hd__nor2_1
X_4559_ _3824_ _3835_ _3836_ vssd1 vssd1 vccd1 vccd1 _3837_ sky130_fd_sc_hd__nand3_1
X_7278_ _2435_ _2444_ _2508_ vssd1 vssd1 vccd1 vccd1 _2509_ sky130_fd_sc_hd__o21ai_1
X_6229_ _1212_ _1215_ _1416_ vssd1 vssd1 vccd1 vccd1 _1418_ sky130_fd_sc_hd__or3_1
Xteam_03_346 vssd1 vssd1 vccd1 vccd1 team_03_346/HI gpio_oeb[22] sky130_fd_sc_hd__conb_1
Xteam_03_357 vssd1 vssd1 vccd1 vccd1 team_03_357/HI gpio_oeb[33] sky130_fd_sc_hd__conb_1
Xteam_03_368 vssd1 vssd1 vccd1 vccd1 team_03_368/HI gpio_out[10] sky130_fd_sc_hd__conb_1
Xteam_03_379 vssd1 vssd1 vccd1 vccd1 gpio_oeb[3] team_03_379/LO sky130_fd_sc_hd__conb_1
XTAP_TAPCELL_ROW_84_1040 vssd1 vccd1 sky130_fd_sc_hd__tapvpwrvgnd_1
XTAP_TAPCELL_ROW_71_914 vssd1 vccd1 sky130_fd_sc_hd__tapvpwrvgnd_1
XFILLER_82_79 vssd1 vssd1 vccd1 vccd1 sky130_fd_sc_hd__fill_4
XFILLER_25_194 vssd1 vssd1 vccd1 vccd1 sky130_fd_sc_hd__fill_4
XTAP_TAPCELL_ROW_43_627 vssd1 vccd1 sky130_fd_sc_hd__tapvpwrvgnd_1
XFILLER_13_389 vssd1 vssd1 vccd1 vccd1 sky130_fd_sc_hd__fill_2
XFILLER_40_164 vccd1 vssd1 vccd1 vssd1 sky130_ef_sc_hd__decap_40_12
XFILLER_40_197 vssd1 vssd1 vccd1 vccd1 sky130_fd_sc_hd__fill_2
XFILLER_5_522 vccd1 vssd1 vccd1 vssd1 sky130_ef_sc_hd__decap_40_12
XANTENNA__5534__D net239 vssd1 vssd1 vccd1 vccd1 sky130_fd_sc_hd__diode_2
XFILLER_48_253 vssd1 vssd1 vccd1 vccd1 sky130_fd_sc_hd__fill_1
XANTENNA__7758__B net276 vssd1 vssd1 vccd1 vccd1 sky130_fd_sc_hd__diode_2
XTAP_TAPCELL_ROW_59_793 vssd1 vccd1 sky130_fd_sc_hd__tapvpwrvgnd_1
XFILLER_36_459 vssd1 vssd1 vccd1 vccd1 sky130_fd_sc_hd__fill_4
XANTENNA__6662__B net295 vssd1 vssd1 vccd1 vccd1 sky130_fd_sc_hd__diode_2
XFILLER_63_267 vssd1 vssd1 vccd1 vccd1 sky130_fd_sc_hd__fill_1
XFILLER_16_161 vssd1 vssd1 vccd1 vccd1 sky130_fd_sc_hd__fill_1
XTAP_TAPCELL_ROW_14_340 vssd1 vccd1 sky130_fd_sc_hd__tapvpwrvgnd_1
X_5600_ _0788_ _0789_ vssd1 vssd1 vccd1 vccd1 _0790_ sky130_fd_sc_hd__nand2_1
X_6580_ _1766_ _1767_ vssd1 vssd1 vccd1 vccd1 _1768_ sky130_fd_sc_hd__nor2_1
X_5531_ _0719_ _0720_ vssd1 vssd1 vccd1 vccd1 _0721_ sky130_fd_sc_hd__or2_1
X_8250_ _3484_ _3520_ vssd1 vssd1 vccd1 vccd1 _3521_ sky130_fd_sc_hd__xnor2_1
XFILLER_8_382 vssd1 vssd1 vccd1 vccd1 sky130_fd_sc_hd__fill_2
XFILLER_8_360 vssd1 vssd1 vccd1 vccd1 sky130_fd_sc_hd__fill_4
X_5462_ _0650_ _0651_ vssd1 vssd1 vccd1 vccd1 _0652_ sky130_fd_sc_hd__nand2_1
X_7201_ PID_INST.k3_calc.d2.y\[11\] _0222_ _0225_ vssd1 vssd1 vccd1 vccd1 _2428_ sky130_fd_sc_hd__and3_1
X_4413_ net185 net183 _3698_ vssd1 vssd1 vccd1 vccd1 _3700_ sky130_fd_sc_hd__and3_1
X_8181_ _3288_ _3289_ _3302_ vssd1 vssd1 vccd1 vccd1 _3446_ sky130_fd_sc_hd__o21a_1
X_5393_ _0571_ _0576_ vssd1 vssd1 vccd1 vccd1 _0583_ sky130_fd_sc_hd__xnor2_1
X_7132_ net308 net190 vssd1 vssd1 vccd1 vccd1 _2354_ sky130_fd_sc_hd__nand2_1
X_4344_ net230 net17 _3601_ vssd1 vssd1 vccd1 vccd1 _3644_ sky130_fd_sc_hd__a21o_1
X_7063_ _2259_ _2260_ _2282_ vssd1 vssd1 vccd1 vccd1 _2283_ sky130_fd_sc_hd__nor3_1
XFILLER_86_304 vssd1 vssd1 vccd1 vccd1 sky130_fd_sc_hd__fill_1
Xfanout317 net321 vssd1 vssd1 vccd1 vccd1 net317 sky130_fd_sc_hd__clkbuf_4
Xfanout306 net308 vssd1 vssd1 vccd1 vccd1 net306 sky130_fd_sc_hd__buf_2
Xfanout339 PID_INST.add_three.n_rst vssd1 vssd1 vccd1 vccd1 net339 sky130_fd_sc_hd__clkbuf_4
Xfanout328 net339 vssd1 vssd1 vccd1 vccd1 net328 sky130_fd_sc_hd__clkbuf_4
X_4275_ _1762_ net176 _2823_ vssd1 vssd1 vccd1 vccd1 _2950_ sky130_fd_sc_hd__or3b_1
X_6014_ _0478_ _0552_ _0553_ _0551_ vssd1 vssd1 vccd1 vccd1 _1204_ sky130_fd_sc_hd__a31oi_2
XFILLER_67_540 vssd1 vssd1 vccd1 vccd1 sky130_fd_sc_hd__fill_8
XANTENNA_fanout274_A net275 vssd1 vssd1 vccd1 vccd1 sky130_fd_sc_hd__diode_2
XFILLER_27_404 vssd1 vssd1 vccd1 vccd1 sky130_fd_sc_hd__fill_2
XFILLER_27_426 vssd1 vssd1 vccd1 vccd1 sky130_fd_sc_hd__fill_4
XFILLER_82_543 vssd1 vssd1 vccd1 vccd1 sky130_fd_sc_hd__fill_1
XANTENNA__7668__B net262 vssd1 vssd1 vccd1 vccd1 sky130_fd_sc_hd__diode_2
X_7965_ _3218_ _3219_ vssd1 vssd1 vccd1 vccd1 _3220_ sky130_fd_sc_hd__nor2_1
XFILLER_82_565 vssd1 vssd1 vccd1 vccd1 sky130_fd_sc_hd__fill_4
XFILLER_14_109 vssd1 vssd1 vccd1 vccd1 sky130_fd_sc_hd__fill_1
X_6916_ _2124_ _2125_ vssd1 vssd1 vccd1 vccd1 _2126_ sky130_fd_sc_hd__xnor2_1
X_7896_ _3149_ _3150_ vssd1 vssd1 vccd1 vccd1 _3151_ sky130_fd_sc_hd__nor2_1
XANTENNA__5619__D net203 vssd1 vssd1 vccd1 vccd1 sky130_fd_sc_hd__diode_2
XFILLER_52_27 vssd1 vssd1 vccd1 vccd1 sky130_fd_sc_hd__fill_1
X_6847_ net91 net65 vssd1 vssd1 vccd1 vccd1 _2054_ sky130_fd_sc_hd__nor2_1
X_6778_ _1887_ _1888_ _1886_ vssd1 vssd1 vccd1 vccd1 _1980_ sky130_fd_sc_hd__o21ai_1
XFILLER_10_315 vssd1 vssd1 vccd1 vccd1 sky130_fd_sc_hd__fill_1
XANTENNA_fanout327_X net327 vssd1 vssd1 vccd1 vccd1 sky130_fd_sc_hd__diode_2
X_5729_ _0917_ _0918_ vssd1 vssd1 vccd1 vccd1 _0919_ sky130_fd_sc_hd__or2_1
XFILLER_22_197 vccd1 vssd1 vccd1 vssd1 sky130_ef_sc_hd__decap_40_12
X_8448_ clknet_4_13_0_clk _0036_ net336 vssd1 vssd1 vccd1 vccd1 PID_INST.k2_calc.sum_reg\[4\]
+ sky130_fd_sc_hd__dfrtp_1
XTAP_TAPCELL_ROW_20_398 vssd1 vccd1 sky130_fd_sc_hd__tapvpwrvgnd_1
X_8379_ clknet_4_6_0_clk _0015_ net337 vssd1 vssd1 vccd1 vccd1 PID_INST.k1_calc.d1.x\[15\]
+ sky130_fd_sc_hd__dfrtp_1
XANTENNA__8381__RESET_B net328 vssd1 vssd1 vccd1 vccd1 sky130_fd_sc_hd__diode_2
XFILLER_77_337 vccd1 vssd1 vccd1 vssd1 sky130_ef_sc_hd__decap_40_12
XFILLER_77_57 vccd1 vssd1 vccd1 vssd1 sky130_ef_sc_hd__decap_40_12
XFILLER_92_307 vssd1 vssd1 vccd1 vccd1 sky130_fd_sc_hd__fill_1
XANTENNA__7859__A _3053_ vssd1 vssd1 vccd1 vccd1 sky130_fd_sc_hd__diode_2
XFILLER_85_381 vssd1 vssd1 vccd1 vccd1 sky130_fd_sc_hd__fill_8
XFILLER_45_223 vssd1 vssd1 vccd1 vccd1 sky130_fd_sc_hd__fill_1
XFILLER_18_459 vccd1 vssd1 vccd1 vssd1 sky130_ef_sc_hd__decap_40_12
XTAP_TAPCELL_ROW_56_763 vssd1 vccd1 sky130_fd_sc_hd__tapvpwrvgnd_1
XFILLER_26_83 vssd1 vssd1 vccd1 vccd1 sky130_fd_sc_hd__fill_1
XTAP_TAPCELL_ROW_28_476 vssd1 vccd1 sky130_fd_sc_hd__tapvpwrvgnd_1
XFILLER_9_113 vssd1 vssd1 vccd1 vccd1 sky130_fd_sc_hd__fill_4
XFILLER_9_102 vssd1 vssd1 vccd1 vccd1 sky130_fd_sc_hd__fill_1
XANTENNA__5826__B net251 vssd1 vssd1 vccd1 vccd1 sky130_fd_sc_hd__diode_2
XFILLER_9_135 vssd1 vssd1 vccd1 vccd1 sky130_fd_sc_hd__fill_4
XTAP_TAPCELL_ROW_11_310 vssd1 vccd1 sky130_fd_sc_hd__tapvpwrvgnd_1
XANTENNA__6003__A net108 vssd1 vssd1 vccd1 vccd1 sky130_fd_sc_hd__diode_2
XFILLER_54_7 vssd1 vssd1 vccd1 vccd1 sky130_fd_sc_hd__fill_1
XANTENNA__6151__A2 net78 vssd1 vssd1 vccd1 vccd1 sky130_fd_sc_hd__diode_2
XFILLER_5_374 vccd1 vssd1 vccd1 vssd1 sky130_ef_sc_hd__decap_40_12
XANTENNA__5552__A2_N net236 vssd1 vssd1 vccd1 vccd1 sky130_fd_sc_hd__diode_2
XFILLER_68_348 vssd1 vssd1 vccd1 vccd1 sky130_fd_sc_hd__fill_4
XANTENNA__4177__B net175 vssd1 vssd1 vccd1 vccd1 sky130_fd_sc_hd__diode_2
XFILLER_3_98 vccd1 vssd1 vccd1 vssd1 sky130_ef_sc_hd__decap_40_12
XFILLER_83_307 vssd1 vssd1 vccd1 vccd1 sky130_fd_sc_hd__fill_8
XFILLER_76_381 vssd1 vssd1 vccd1 vccd1 sky130_fd_sc_hd__fill_1
XFILLER_91_351 vssd1 vssd1 vccd1 vccd1 sky130_fd_sc_hd__fill_2
XFILLER_51_204 vssd1 vssd1 vccd1 vccd1 sky130_fd_sc_hd__fill_2
X_7750_ _2900_ _2914_ _3005_ vssd1 vssd1 vccd1 vccd1 _3006_ sky130_fd_sc_hd__a21oi_1
X_4962_ PID_INST.k1_calc.d1.x\[14\] PID_INST.k3_calc.prev_error\[14\] vssd1 vssd1
+ vccd1 vccd1 _0152_ sky130_fd_sc_hd__nor2_1
XFILLER_51_215 vssd1 vssd1 vccd1 vccd1 sky130_fd_sc_hd__fill_8
XFILLER_17_481 vssd1 vssd1 vccd1 vccd1 sky130_fd_sc_hd__fill_8
X_7681_ _2678_ _2680_ _2934_ vssd1 vssd1 vccd1 vccd1 _2935_ sky130_fd_sc_hd__a21o_1
X_4893_ _4095_ _4099_ _0081_ _0082_ vssd1 vssd1 vccd1 vccd1 _0083_ sky130_fd_sc_hd__o211a_1
X_6701_ _1897_ _1898_ vssd1 vssd1 vccd1 vccd1 _1899_ sky130_fd_sc_hd__xnor2_1
X_6632_ _1818_ _1823_ vssd1 vssd1 vccd1 vccd1 _1825_ sky130_fd_sc_hd__or2_1
XFILLER_32_495 vccd1 vssd1 vccd1 vssd1 sky130_ef_sc_hd__decap_40_12
X_6563_ _1743_ _1749_ vssd1 vssd1 vccd1 vccd1 _1750_ sky130_fd_sc_hd__nand2b_1
X_8302_ _3569_ _3570_ vssd1 vssd1 vccd1 vccd1 _3576_ sky130_fd_sc_hd__xnor2_1
X_5514_ _0702_ _0703_ vssd1 vssd1 vccd1 vccd1 _0704_ sky130_fd_sc_hd__nor2_1
X_6494_ _1680_ _1681_ vssd1 vssd1 vccd1 vccd1 _1682_ sky130_fd_sc_hd__nor2_1
XANTENNA__8433__CLK clknet_4_1_0_clk vssd1 vssd1 vccd1 vccd1 sky130_fd_sc_hd__diode_2
X_8233_ net267 net263 net194 net191 vssd1 vssd1 vccd1 vccd1 _3502_ sky130_fd_sc_hd__and4_1
X_5445_ _0615_ _0634_ vssd1 vssd1 vccd1 vccd1 _0635_ sky130_fd_sc_hd__nand2_1
X_8164_ _2707_ net40 vssd1 vssd1 vccd1 vccd1 _3428_ sky130_fd_sc_hd__nor2_1
X_7115_ net300 net193 net188 net313 vssd1 vssd1 vccd1 vccd1 _2336_ sky130_fd_sc_hd__a22oi_1
X_5376_ net111 net59 vssd1 vssd1 vccd1 vccd1 _0566_ sky130_fd_sc_hd__nor2_1
Xfanout103 _2548_ vssd1 vssd1 vccd1 vccd1 net103 sky130_fd_sc_hd__clkbuf_4
X_8095_ _3195_ _3206_ _3194_ vssd1 vssd1 vccd1 vccd1 _3354_ sky130_fd_sc_hd__a21bo_1
XANTENNA__4368__A net209 vssd1 vssd1 vccd1 vccd1 sky130_fd_sc_hd__diode_2
X_4327_ net237 _3472_ vssd1 vssd1 vccd1 vccd1 _0035_ sky130_fd_sc_hd__xnor2_1
Xfanout136 PID_INST.k3_calc.d1.y\[10\] vssd1 vssd1 vccd1 vccd1 net136 sky130_fd_sc_hd__buf_1
Xfanout114 net115 vssd1 vssd1 vccd1 vccd1 net114 sky130_fd_sc_hd__clkbuf_4
Xfanout147 _2389_ vssd1 vssd1 vccd1 vccd1 net147 sky130_fd_sc_hd__clkbuf_4
Xfanout125 PID_INST.k3_calc.d1.y\[4\] vssd1 vssd1 vccd1 vccd1 net125 sky130_fd_sc_hd__clkbuf_4
X_7046_ _0735_ _1641_ _2264_ vssd1 vssd1 vccd1 vccd1 _2265_ sky130_fd_sc_hd__a21oi_1
Xfanout158 net159 vssd1 vssd1 vccd1 vccd1 net158 sky130_fd_sc_hd__clkbuf_2
Xfanout169 _1849_ vssd1 vssd1 vccd1 vccd1 net169 sky130_fd_sc_hd__clkbuf_2
X_4258_ net10 net168 _2760_ vssd1 vssd1 vccd1 vccd1 _2771_ sky130_fd_sc_hd__o21ai_2
XFILLER_47_16 vssd1 vssd1 vccd1 vccd1 sky130_fd_sc_hd__fill_1
XFILLER_86_167 vssd1 vssd1 vccd1 vccd1 sky130_fd_sc_hd__fill_8
XFILLER_47_38 vssd1 vssd1 vccd1 vccd1 sky130_fd_sc_hd__fill_4
XANTENNA__6583__A net97 vssd1 vssd1 vccd1 vccd1 sky130_fd_sc_hd__diode_2
XANTENNA__5077__A1_N net138 vssd1 vssd1 vccd1 vccd1 sky130_fd_sc_hd__diode_2
XANTENNA_fanout277_X net277 vssd1 vssd1 vccd1 vccd1 sky130_fd_sc_hd__diode_2
XFILLER_27_212 vssd1 vssd1 vccd1 vccd1 sky130_fd_sc_hd__fill_2
X_4189_ PID_INST.k3_calc.kd_term\[8\] net175 vssd1 vssd1 vccd1 vccd1 _2040_ sky130_fd_sc_hd__or2_1
XANTENNA__4208__A2 net173 vssd1 vssd1 vccd1 vccd1 sky130_fd_sc_hd__diode_2
X_7948_ _3197_ _3202_ vssd1 vssd1 vccd1 vccd1 _3203_ sky130_fd_sc_hd__and2b_1
XTAP_TAPCELL_ROW_53_733 vssd1 vccd1 sky130_fd_sc_hd__tapvpwrvgnd_1
XFILLER_15_429 vccd1 vssd1 vccd1 vssd1 sky130_ef_sc_hd__decap_40_12
XFILLER_27_278 vssd1 vssd1 vccd1 vccd1 sky130_fd_sc_hd__fill_2
XFILLER_42_204 vccd1 vssd1 vccd1 vssd1 sky130_ef_sc_hd__decap_40_12
XTAP_TAPCELL_ROW_81_1010 vssd1 vccd1 sky130_fd_sc_hd__tapvpwrvgnd_1
XFILLER_70_557 vssd1 vssd1 vccd1 vccd1 sky130_fd_sc_hd__fill_2
XTAP_TAPCELL_ROW_25_446 vssd1 vccd1 sky130_fd_sc_hd__tapvpwrvgnd_1
XANTENNA__5927__A net114 vssd1 vssd1 vccd1 vccd1 sky130_fd_sc_hd__diode_2
XFILLER_23_473 vssd1 vssd1 vccd1 vccd1 sky130_fd_sc_hd__fill_1
X_7879_ _3132_ _3133_ vssd1 vssd1 vccd1 vccd1 _3134_ sky130_fd_sc_hd__nand2_1
XFILLER_10_123 vssd1 vssd1 vccd1 vccd1 sky130_fd_sc_hd__fill_2
XFILLER_12_85 vssd1 vssd1 vccd1 vccd1 sky130_fd_sc_hd__fill_1
XANTENNA_fanout92_X net92 vssd1 vssd1 vccd1 vccd1 sky130_fd_sc_hd__diode_2
XFILLER_77_101 vssd1 vssd1 vccd1 vccd1 sky130_fd_sc_hd__fill_8
XFILLER_2_377 vssd1 vssd1 vccd1 vccd1 sky130_fd_sc_hd__fill_4
XFILLER_92_115 vssd1 vssd1 vccd1 vccd1 sky130_fd_sc_hd__fill_1
XFILLER_77_167 vssd1 vssd1 vccd1 vccd1 sky130_fd_sc_hd__fill_1
XFILLER_65_307 vssd1 vssd1 vccd1 vccd1 sky130_fd_sc_hd__fill_2
XFILLER_46_565 vssd1 vssd1 vccd1 vccd1 sky130_fd_sc_hd__fill_1
XPHY_EDGE_ROW_16_Right_16 vssd1 vssd1 vccd1 vccd1 sky130_fd_sc_hd__decap_3
XANTENNA__4217__S net174 vssd1 vssd1 vccd1 vccd1 sky130_fd_sc_hd__diode_2
XFILLER_33_248 vssd1 vssd1 vccd1 vccd1 sky130_fd_sc_hd__fill_1
XANTENNA__4460__B _3734_ vssd1 vssd1 vccd1 vccd1 sky130_fd_sc_hd__diode_2
XPHY_EDGE_ROW_25_Right_25 vssd1 vssd1 vccd1 vccd1 sky130_fd_sc_hd__decap_3
XANTENNA__5572__A _0734_ vssd1 vssd1 vccd1 vccd1 sky130_fd_sc_hd__diode_2
X_5230_ _0418_ _0419_ vssd1 vssd1 vccd1 vccd1 _0420_ sky130_fd_sc_hd__or2_1
XANTENNA__5291__B net85 vssd1 vssd1 vccd1 vccd1 sky130_fd_sc_hd__diode_2
X_5161_ _2146_ net71 vssd1 vssd1 vccd1 vccd1 _0351_ sky130_fd_sc_hd__nor2_1
X_5092_ _0190_ _0281_ vssd1 vssd1 vccd1 vccd1 _0282_ sky130_fd_sc_hd__xor2_1
XFILLER_83_148 vssd1 vssd1 vccd1 vccd1 sky130_fd_sc_hd__fill_1
XFILLER_83_126 vccd1 vssd1 vccd1 vssd1 sky130_ef_sc_hd__decap_40_12
XANTENNA__4916__A net127 vssd1 vssd1 vccd1 vccd1 sky130_fd_sc_hd__diode_2
XPHY_EDGE_ROW_34_Right_34 vssd1 vssd1 vccd1 vccd1 sky130_fd_sc_hd__decap_3
XTAP_TAPCELL_ROW_67_869 vssd1 vccd1 sky130_fd_sc_hd__tapvpwrvgnd_1
XFILLER_24_226 vccd1 vssd1 vccd1 vssd1 sky130_ef_sc_hd__decap_40_12
X_7802_ _3056_ _3057_ vssd1 vssd1 vccd1 vccd1 _3058_ sky130_fd_sc_hd__or2_1
X_5994_ _0539_ _0540_ _0538_ vssd1 vssd1 vccd1 vccd1 _1184_ sky130_fd_sc_hd__o21ba_1
XANTENNA__7946__B net186 vssd1 vssd1 vccd1 vccd1 sky130_fd_sc_hd__diode_2
X_7733_ _2987_ _2988_ vssd1 vssd1 vccd1 vccd1 _2989_ sky130_fd_sc_hd__nand2_1
X_4945_ _4124_ _4141_ _4143_ vssd1 vssd1 vccd1 vccd1 _0135_ sky130_fd_sc_hd__a21oi_1
XTAP_TAPCELL_ROW_50_703 vssd1 vccd1 sky130_fd_sc_hd__tapvpwrvgnd_1
XTAP_TAPCELL_ROW_22_416 vssd1 vccd1 sky130_fd_sc_hd__tapvpwrvgnd_1
X_7664_ _2668_ _2682_ _2916_ vssd1 vssd1 vccd1 vccd1 _2918_ sky130_fd_sc_hd__and3_1
XANTENNA_fanout237_A PID_INST.k2_calc.sum_reg\[3\] vssd1 vssd1 vccd1 vccd1 sky130_fd_sc_hd__diode_2
X_4876_ _4151_ _4152_ _4080_ net67 vssd1 vssd1 vccd1 vccd1 _4154_ sky130_fd_sc_hd__a211o_1
XFILLER_20_421 vssd1 vssd1 vccd1 vccd1 sky130_fd_sc_hd__fill_1
XFILLER_32_270 vssd1 vssd1 vccd1 vccd1 sky130_fd_sc_hd__fill_4
XPHY_EDGE_ROW_43_Right_43 vssd1 vssd1 vccd1 vccd1 sky130_fd_sc_hd__decap_3
X_6615_ _1489_ _1602_ _1601_ vssd1 vssd1 vccd1 vccd1 _1807_ sky130_fd_sc_hd__a21oi_2
X_7595_ _2838_ _2844_ vssd1 vssd1 vccd1 vccd1 _2846_ sky130_fd_sc_hd__xnor2_1
X_6546_ _1565_ _1568_ vssd1 vssd1 vccd1 vccd1 _1733_ sky130_fd_sc_hd__nand2_1
X_6477_ _1455_ _1458_ _1663_ vssd1 vssd1 vccd1 vccd1 _1665_ sky130_fd_sc_hd__and3_1
X_8216_ _3482_ _3483_ vssd1 vssd1 vccd1 vccd1 _3484_ sky130_fd_sc_hd__nor2_1
X_5428_ _0616_ _0617_ vssd1 vssd1 vccd1 vccd1 _0618_ sky130_fd_sc_hd__and2b_1
X_8147_ _3407_ _3410_ vssd1 vssd1 vccd1 vccd1 _3411_ sky130_fd_sc_hd__nor2_1
X_5359_ _0546_ _0547_ net103 vssd1 vssd1 vccd1 vccd1 _0549_ sky130_fd_sc_hd__a21o_1
X_8078_ _3184_ _3191_ _3334_ vssd1 vssd1 vccd1 vccd1 _3336_ sky130_fd_sc_hd__nand3_1
XFILLER_58_59 vssd1 vssd1 vccd1 vccd1 sky130_fd_sc_hd__fill_2
X_7029_ net313 net300 net195 net190 vssd1 vssd1 vccd1 vccd1 _2247_ sky130_fd_sc_hd__and4_1
XPHY_EDGE_ROW_52_Right_52 vssd1 vssd1 vccd1 vccd1 sky130_fd_sc_hd__decap_3
XFILLER_47_329 vssd1 vssd1 vccd1 vccd1 sky130_fd_sc_hd__fill_4
XFILLER_74_115 vccd1 vssd1 vccd1 vssd1 sky130_ef_sc_hd__decap_40_12
XANTENNA__4826__A _2210_ vssd1 vssd1 vccd1 vccd1 sky130_fd_sc_hd__diode_2
XANTENNA__8479__CLK clknet_4_11_0_clk vssd1 vssd1 vccd1 vccd1 sky130_fd_sc_hd__diode_2
XFILLER_43_513 vssd1 vssd1 vccd1 vccd1 sky130_fd_sc_hd__fill_1
XTAP_TAPCELL_ROW_38_582 vssd1 vccd1 sky130_fd_sc_hd__tapvpwrvgnd_1
XFILLER_70_354 vssd1 vssd1 vccd1 vccd1 sky130_fd_sc_hd__fill_1
XFILLER_43_546 vssd1 vssd1 vccd1 vccd1 sky130_fd_sc_hd__fill_2
XANTENNA__4601__A2 net81 vssd1 vssd1 vccd1 vccd1 sky130_fd_sc_hd__diode_2
XPHY_EDGE_ROW_61_Right_61 vssd1 vssd1 vccd1 vccd1 sky130_fd_sc_hd__decap_3
XFILLER_23_281 vssd1 vssd1 vccd1 vccd1 sky130_fd_sc_hd__fill_4
XFILLER_23_51 vssd1 vssd1 vccd1 vccd1 sky130_fd_sc_hd__fill_1
XFILLER_7_436 vssd1 vssd1 vccd1 vccd1 sky130_fd_sc_hd__fill_1
XPHY_EDGE_ROW_70_Right_70 vssd1 vssd1 vccd1 vccd1 sky130_fd_sc_hd__decap_3
XFILLER_2_141 vssd1 vssd1 vccd1 vccd1 sky130_fd_sc_hd__fill_4
XFILLER_78_465 vssd1 vssd1 vccd1 vccd1 sky130_fd_sc_hd__fill_2
XFILLER_46_340 vssd1 vssd1 vccd1 vccd1 sky130_fd_sc_hd__fill_1
XFILLER_80_118 vccd1 vssd1 vccd1 vssd1 sky130_ef_sc_hd__decap_40_12
XTAP_TAPCELL_ROW_64_839 vssd1 vccd1 sky130_fd_sc_hd__tapvpwrvgnd_1
XFILLER_0_55 vssd1 vssd1 vccd1 vccd1 sky130_fd_sc_hd__fill_1
XFILLER_61_332 vssd1 vssd1 vccd1 vccd1 sky130_fd_sc_hd__fill_4
XFILLER_61_321 vssd1 vssd1 vccd1 vccd1 sky130_fd_sc_hd__fill_4
XFILLER_46_395 vccd1 vssd1 vccd1 vssd1 sky130_ef_sc_hd__decap_40_12
XANTENNA__6593__A2 net47 vssd1 vssd1 vccd1 vccd1 sky130_fd_sc_hd__diode_2
XFILLER_9_42 vssd1 vssd1 vccd1 vccd1 sky130_fd_sc_hd__fill_2
X_4730_ _3990_ _4006_ vssd1 vssd1 vccd1 vccd1 _4008_ sky130_fd_sc_hd__xnor2_1
XFILLER_14_292 vssd1 vssd1 vccd1 vccd1 sky130_fd_sc_hd__fill_1
XANTENNA__4902__C _4034_ vssd1 vssd1 vccd1 vccd1 sky130_fd_sc_hd__diode_2
XANTENNA__8484__RESET_B net341 vssd1 vssd1 vccd1 vccd1 sky130_fd_sc_hd__diode_2
X_4661_ _3937_ _3938_ vssd1 vssd1 vccd1 vccd1 _3939_ sky130_fd_sc_hd__and2b_1
X_7380_ _2593_ _2594_ _2616_ vssd1 vssd1 vccd1 vccd1 _2618_ sky130_fd_sc_hd__o21a_1
XANTENNA__8413__RESET_B net327 vssd1 vssd1 vccd1 vccd1 sky130_fd_sc_hd__diode_2
X_6400_ _1193_ _1585_ _1587_ vssd1 vssd1 vccd1 vccd1 _1588_ sky130_fd_sc_hd__a21o_1
X_4592_ _3862_ _3868_ vssd1 vssd1 vccd1 vccd1 _3870_ sky130_fd_sc_hd__xnor2_1
X_6331_ _1315_ _1518_ vssd1 vssd1 vccd1 vccd1 _1519_ sky130_fd_sc_hd__xnor2_1
XANTENNA__8098__A2 net260 vssd1 vssd1 vccd1 vccd1 sky130_fd_sc_hd__diode_2
XANTENNA__7932__D net252 vssd1 vssd1 vccd1 vccd1 sky130_fd_sc_hd__diode_2
X_6262_ _1248_ _1250_ _1247_ vssd1 vssd1 vccd1 vccd1 _1451_ sky130_fd_sc_hd__o21ba_1
X_8001_ _3254_ _3255_ vssd1 vssd1 vccd1 vccd1 _3256_ sky130_fd_sc_hd__nor2_1
XFILLER_88_218 vssd1 vssd1 vccd1 vccd1 sky130_fd_sc_hd__fill_2
X_5213_ _0301_ _0400_ _0401_ _0402_ vssd1 vssd1 vccd1 vccd1 _0403_ sky130_fd_sc_hd__a211o_1
X_6193_ _1158_ _1175_ _1157_ vssd1 vssd1 vccd1 vccd1 _1382_ sky130_fd_sc_hd__a21bo_1
X_5144_ _2242_ _0154_ _0155_ vssd1 vssd1 vccd1 vccd1 _0334_ sky130_fd_sc_hd__or3_1
XFILLER_84_402 vssd1 vssd1 vccd1 vccd1 sky130_fd_sc_hd__fill_1
XANTENNA__5608__A1 net314 vssd1 vssd1 vccd1 vccd1 sky130_fd_sc_hd__diode_2
XFILLER_29_318 vssd1 vssd1 vccd1 vccd1 sky130_fd_sc_hd__fill_4
XFILLER_84_446 vssd1 vssd1 vccd1 vccd1 sky130_fd_sc_hd__fill_1
X_5075_ _0182_ _0184_ _0263_ vssd1 vssd1 vccd1 vccd1 _0265_ sky130_fd_sc_hd__and3_1
XFILLER_84_468 vssd1 vssd1 vccd1 vccd1 sky130_fd_sc_hd__fill_2
XANTENNA__4365__B net157 vssd1 vssd1 vccd1 vccd1 sky130_fd_sc_hd__diode_2
XANTENNA__8022__A2 net40 vssd1 vssd1 vccd1 vccd1 sky130_fd_sc_hd__diode_2
XFILLER_52_365 vccd1 vssd1 vccd1 vssd1 sky130_ef_sc_hd__decap_40_12
XTAP_TAPCELL_ROW_35_552 vssd1 vccd1 sky130_fd_sc_hd__tapvpwrvgnd_1
X_5977_ _1166_ _1165_ vssd1 vssd1 vccd1 vccd1 _1167_ sky130_fd_sc_hd__nand2b_1
XANTENNA__4381__A net201 vssd1 vssd1 vccd1 vccd1 sky130_fd_sc_hd__diode_2
X_7716_ net154 net30 vssd1 vssd1 vccd1 vccd1 _2973_ sky130_fd_sc_hd__and2b_1
X_4928_ _0116_ _0117_ vssd1 vssd1 vccd1 vccd1 _0118_ sky130_fd_sc_hd__or2_1
XANTENNA_fanout142_X net142 vssd1 vssd1 vccd1 vccd1 sky130_fd_sc_hd__diode_2
X_7647_ _2657_ _2665_ _2899_ vssd1 vssd1 vccd1 vccd1 _2900_ sky130_fd_sc_hd__a21o_1
X_4859_ net130 net85 vssd1 vssd1 vccd1 vccd1 _4137_ sky130_fd_sc_hd__nand2_1
X_7578_ _2493_ _2826_ vssd1 vssd1 vccd1 vccd1 _2827_ sky130_fd_sc_hd__nand2_1
XFILLER_4_428 vccd1 vssd1 vccd1 vssd1 sky130_ef_sc_hd__decap_40_12
X_6529_ _1562_ _1563_ _1560_ vssd1 vssd1 vccd1 vccd1 _1716_ sky130_fd_sc_hd__o21ai_1
XANTENNA__6101__A _1102_ vssd1 vssd1 vccd1 vccd1 sky130_fd_sc_hd__diode_2
XTAP_TAPCELL_ROW_7_266 vssd1 vccd1 sky130_fd_sc_hd__tapvpwrvgnd_1
XFILLER_87_240 vssd1 vssd1 vccd1 vccd1 sky130_fd_sc_hd__fill_2
XFILLER_75_457 vssd1 vssd1 vccd1 vccd1 sky130_fd_sc_hd__fill_8
XANTENNA__4283__A0 net18 vssd1 vssd1 vccd1 vccd1 sky130_fd_sc_hd__diode_2
XFILLER_18_40 vssd1 vssd1 vccd1 vccd1 sky130_fd_sc_hd__fill_2
XFILLER_18_51 vssd1 vssd1 vccd1 vccd1 sky130_fd_sc_hd__fill_1
XFILLER_90_438 vssd1 vssd1 vccd1 vccd1 sky130_fd_sc_hd__fill_1
XTAP_TAPCELL_ROW_87_1071 vssd1 vccd1 sky130_fd_sc_hd__tapvpwrvgnd_1
XFILLER_62_129 vssd1 vssd1 vccd1 vccd1 sky130_fd_sc_hd__fill_1
XANTENNA__7867__A net92 vssd1 vssd1 vccd1 vccd1 sky130_fd_sc_hd__diode_2
XTAP_TAPCELL_ROW_61_809 vssd1 vccd1 sky130_fd_sc_hd__tapvpwrvgnd_1
XFILLER_16_568 vssd1 vssd1 vccd1 vccd1 sky130_fd_sc_hd__fill_2
XFILLER_31_505 vssd1 vssd1 vccd1 vccd1 sky130_fd_sc_hd__fill_8
XFILLER_31_516 vccd1 vssd1 vccd1 vssd1 sky130_ef_sc_hd__decap_40_12
XFILLER_70_195 vssd1 vssd1 vccd1 vccd1 sky130_fd_sc_hd__fill_1
XFILLER_31_538 vssd1 vssd1 vccd1 vccd1 sky130_fd_sc_hd__fill_1
XFILLER_31_549 vssd1 vssd1 vccd1 vccd1 sky130_fd_sc_hd__fill_8
XFILLER_34_83 vssd1 vssd1 vccd1 vccd1 sky130_fd_sc_hd__fill_1
XFILLER_7_222 vssd1 vssd1 vccd1 vccd1 sky130_fd_sc_hd__fill_2
XFILLER_7_244 vccd1 vssd1 vccd1 vssd1 sky130_ef_sc_hd__decap_40_12
XFILLER_7_233 vssd1 vssd1 vccd1 vccd1 sky130_fd_sc_hd__fill_2
XANTENNA__4889__A2 net71 vssd1 vssd1 vccd1 vccd1 sky130_fd_sc_hd__diode_2
XANTENNA__5834__B net289 vssd1 vssd1 vccd1 vccd1 sky130_fd_sc_hd__diode_2
XFILLER_3_483 vssd1 vssd1 vccd1 vccd1 sky130_fd_sc_hd__fill_4
XFILLER_66_413 vssd1 vssd1 vccd1 vccd1 sky130_fd_sc_hd__fill_2
XFILLER_38_126 vssd1 vssd1 vccd1 vccd1 sky130_fd_sc_hd__fill_2
XTAP_TAPCELL_ROW_77_975 vssd1 vccd1 sky130_fd_sc_hd__tapvpwrvgnd_1
X_5900_ _1085_ _1086_ _0734_ _1082_ vssd1 vssd1 vccd1 vccd1 _1090_ sky130_fd_sc_hd__a211o_1
XTAP_TAPCELL_ROW_49_688 vssd1 vccd1 sky130_fd_sc_hd__tapvpwrvgnd_1
XFILLER_74_490 vssd1 vssd1 vccd1 vccd1 sky130_fd_sc_hd__fill_2
X_6880_ _2082_ _2088_ vssd1 vssd1 vccd1 vccd1 _2089_ sky130_fd_sc_hd__xnor2_1
X_5831_ _0723_ _0784_ vssd1 vssd1 vccd1 vccd1 _1021_ sky130_fd_sc_hd__or2_1
XFILLER_61_151 vssd1 vssd1 vccd1 vccd1 sky130_fd_sc_hd__fill_1
X_5762_ _0707_ _0784_ vssd1 vssd1 vccd1 vccd1 _0952_ sky130_fd_sc_hd__or2_1
XTAP_TAPCELL_ROW_32_522 vssd1 vccd1 sky130_fd_sc_hd__tapvpwrvgnd_1
X_4713_ _3833_ _3835_ vssd1 vssd1 vccd1 vccd1 _3991_ sky130_fd_sc_hd__nand2_1
X_7501_ net93 net55 _2487_ _2486_ vssd1 vssd1 vccd1 vccd1 _2746_ sky130_fd_sc_hd__o31a_1
X_5693_ _0733_ _0882_ vssd1 vssd1 vccd1 vccd1 _0883_ sky130_fd_sc_hd__xnor2_1
X_8481_ clknet_4_14_0_clk _0069_ net341 vssd1 vssd1 vccd1 vccd1 net30 sky130_fd_sc_hd__dfrtp_1
X_7432_ net311 net299 net188 net184 vssd1 vssd1 vccd1 vccd1 _2672_ sky130_fd_sc_hd__and4_1
X_4644_ _3921_ vssd1 vssd1 vccd1 vccd1 _3922_ sky130_fd_sc_hd__inv_2
X_7363_ net308 net188 vssd1 vssd1 vccd1 vccd1 _2599_ sky130_fd_sc_hd__nand2_1
X_4575_ _3843_ _3851_ vssd1 vssd1 vccd1 vccd1 _3853_ sky130_fd_sc_hd__xnor2_1
X_6314_ _1305_ _1500_ _1501_ vssd1 vssd1 vccd1 vccd1 _1502_ sky130_fd_sc_hd__a21bo_1
X_7294_ _2444_ _2445_ _2447_ _2461_ vssd1 vssd1 vccd1 vccd1 _2526_ sky130_fd_sc_hd__o31a_1
XANTENNA__7818__A2 net40 vssd1 vssd1 vccd1 vccd1 sky130_fd_sc_hd__diode_2
X_6245_ _1433_ _1432_ vssd1 vssd1 vccd1 vccd1 _1434_ sky130_fd_sc_hd__nand2b_1
XFILLER_89_549 vssd1 vssd1 vccd1 vccd1 sky130_fd_sc_hd__fill_8
XANTENNA__6856__A net101 vssd1 vssd1 vccd1 vccd1 sky130_fd_sc_hd__diode_2
X_6176_ _1144_ _1154_ _1143_ vssd1 vssd1 vccd1 vccd1 _1365_ sky130_fd_sc_hd__a21oi_1
XTAP_TAPCELL_ROW_4_236 vssd1 vccd1 sky130_fd_sc_hd__tapvpwrvgnd_1
X_5127_ _0308_ _0311_ _0315_ vssd1 vssd1 vccd1 vccd1 _0317_ sky130_fd_sc_hd__and3_1
XFILLER_29_104 vssd1 vssd1 vccd1 vccd1 sky130_fd_sc_hd__fill_2
XFILLER_29_115 vssd1 vssd1 vccd1 vccd1 sky130_fd_sc_hd__fill_4
XFILLER_29_126 vccd1 vssd1 vccd1 vssd1 sky130_ef_sc_hd__decap_40_12
XFILLER_84_243 vssd1 vssd1 vccd1 vccd1 sky130_fd_sc_hd__fill_8
XPHY_EDGE_ROW_2_Right_2 vssd1 vssd1 vccd1 vccd1 sky130_fd_sc_hd__decap_3
X_5058_ _0173_ _0176_ _0174_ vssd1 vssd1 vccd1 vccd1 _0248_ sky130_fd_sc_hd__a21o_1
XFILLER_84_298 vssd1 vssd1 vccd1 vccd1 sky130_fd_sc_hd__fill_2
XFILLER_44_118 vssd1 vssd1 vccd1 vccd1 sky130_fd_sc_hd__fill_2
XFILLER_25_332 vssd1 vssd1 vccd1 vccd1 sky130_fd_sc_hd__fill_4
XFILLER_52_151 vssd1 vssd1 vccd1 vccd1 sky130_fd_sc_hd__fill_1
XANTENNA__4823__B _4100_ vssd1 vssd1 vccd1 vccd1 sky130_fd_sc_hd__diode_2
XFILLER_13_505 vssd1 vssd1 vccd1 vccd1 sky130_fd_sc_hd__fill_2
XFILLER_13_549 vssd1 vssd1 vccd1 vccd1 sky130_fd_sc_hd__fill_4
XFILLER_40_335 vssd1 vssd1 vccd1 vccd1 sky130_fd_sc_hd__fill_2
XFILLER_71_59 vssd1 vssd1 vccd1 vccd1 sky130_fd_sc_hd__fill_2
XFILLER_71_48 vssd1 vssd1 vccd1 vccd1 sky130_fd_sc_hd__fill_1
XFILLER_9_509 vssd1 vssd1 vccd1 vccd1 sky130_fd_sc_hd__fill_2
XANTENNA__5000__A net135 vssd1 vssd1 vccd1 vccd1 sky130_fd_sc_hd__diode_2
XFILLER_40_368 vccd1 vssd1 vccd1 vssd1 sky130_ef_sc_hd__decap_40_12
XFILLER_4_247 vssd1 vssd1 vccd1 vccd1 sky130_fd_sc_hd__fill_1
XFILLER_0_431 vssd1 vssd1 vccd1 vccd1 sky130_fd_sc_hd__fill_1
XFILLER_0_442 vssd1 vssd1 vccd1 vccd1 sky130_fd_sc_hd__fill_4
XFILLER_48_435 vccd1 vssd1 vccd1 vssd1 sky130_ef_sc_hd__decap_40_12
XTAP_TAPCELL_ROW_74_945 vssd1 vccd1 sky130_fd_sc_hd__tapvpwrvgnd_1
XTAP_TAPCELL_ROW_46_658 vssd1 vccd1 sky130_fd_sc_hd__tapvpwrvgnd_1
XFILLER_90_279 vssd1 vssd1 vccd1 vccd1 sky130_fd_sc_hd__fill_2
XFILLER_45_60 vssd1 vssd1 vccd1 vccd1 sky130_fd_sc_hd__fill_1
XFILLER_71_471 vccd1 vssd1 vccd1 vssd1 sky130_ef_sc_hd__decap_40_12
XANTENNA__5548__C net220 vssd1 vssd1 vccd1 vccd1 sky130_fd_sc_hd__diode_2
XFILLER_61_70 vssd1 vssd1 vccd1 vccd1 sky130_fd_sc_hd__fill_1
XANTENNA__8221__A net293 vssd1 vssd1 vccd1 vccd1 sky130_fd_sc_hd__diode_2
XFILLER_77_6 vssd1 vssd1 vccd1 vccd1 sky130_fd_sc_hd__fill_2
XANTENNA__5564__B net306 vssd1 vssd1 vccd1 vccd1 sky130_fd_sc_hd__diode_2
X_4360_ _3651_ _3653_ _3650_ vssd1 vssd1 vccd1 vccd1 _3657_ sky130_fd_sc_hd__o21ba_1
XFILLER_6_65 vssd1 vssd1 vccd1 vccd1 sky130_fd_sc_hd__fill_1
X_4291_ net398 net9 net161 vssd1 vssd1 vccd1 vccd1 _0014_ sky130_fd_sc_hd__mux2_1
X_6030_ _1217_ _1218_ vssd1 vssd1 vccd1 vccd1 _1220_ sky130_fd_sc_hd__xor2_1
XTAP_TAPCELL_ROW_1_206 vssd1 vccd1 sky130_fd_sc_hd__tapvpwrvgnd_1
X_7981_ _3006_ _3028_ vssd1 vssd1 vccd1 vccd1 _3236_ sky130_fd_sc_hd__nor2_1
XANTENNA__7984__A1 net309 vssd1 vssd1 vccd1 vccd1 sky130_fd_sc_hd__diode_2
X_6932_ _2122_ _2142_ vssd1 vssd1 vccd1 vccd1 _2143_ sky130_fd_sc_hd__xnor2_1
XFILLER_19_192 vccd1 vssd1 vccd1 vssd1 sky130_ef_sc_hd__decap_40_12
XFILLER_81_279 vssd1 vssd1 vccd1 vccd1 sky130_fd_sc_hd__fill_1
X_6863_ _2068_ _2069_ vssd1 vssd1 vccd1 vccd1 _2070_ sky130_fd_sc_hd__and2b_1
XANTENNA__7300__A net117 vssd1 vssd1 vccd1 vccd1 sky130_fd_sc_hd__diode_2
XFILLER_62_482 vssd1 vssd1 vccd1 vccd1 sky130_fd_sc_hd__fill_2
XFILLER_62_471 vssd1 vssd1 vccd1 vccd1 sky130_fd_sc_hd__fill_4
X_5814_ _1002_ _1003_ vssd1 vssd1 vccd1 vccd1 _1004_ sky130_fd_sc_hd__nor2_1
XTAP_TAPCELL_ROW_17_371 vssd1 vccd1 sky130_fd_sc_hd__tapvpwrvgnd_1
XFILLER_22_324 vssd1 vssd1 vccd1 vccd1 sky130_fd_sc_hd__fill_2
X_6794_ _1995_ _1996_ vssd1 vssd1 vccd1 vccd1 _1997_ sky130_fd_sc_hd__xnor2_1
X_5745_ net324 net230 vssd1 vssd1 vccd1 vccd1 _0935_ sky130_fd_sc_hd__nand2_1
XANTENNA_fanout317_A net321 vssd1 vssd1 vccd1 vccd1 sky130_fd_sc_hd__diode_2
X_8464_ clknet_4_7_0_clk _0052_ net333 vssd1 vssd1 vccd1 vccd1 PID_INST.k2_calc.sum_reg\[20\]
+ sky130_fd_sc_hd__dfrtp_1
X_5676_ _0700_ _0865_ vssd1 vssd1 vccd1 vccd1 _0866_ sky130_fd_sc_hd__and2_1
X_7415_ net322 PID_INST.k2_calc.sum_reg\[21\] vssd1 vssd1 vccd1 vccd1 _2654_ sky130_fd_sc_hd__nand2_1
X_4627_ net113 net88 vssd1 vssd1 vccd1 vccd1 _3905_ sky130_fd_sc_hd__and2_1
XANTENNA__6711__A2 net258 vssd1 vssd1 vccd1 vccd1 sky130_fd_sc_hd__diode_2
X_8395_ clknet_4_12_0_clk PID_INST.k3_calc.d2.y\[15\] net329 vssd1 vssd1 vccd1 vccd1
+ PID_INST.k3_calc.timescaling_term\[15\] sky130_fd_sc_hd__dfrtp_1
X_7346_ net299 net190 net186 net311 vssd1 vssd1 vccd1 vccd1 _2582_ sky130_fd_sc_hd__a22oi_1
X_4558_ PID_INST.k3_calc.d1.y\[0\] net75 _3833_ _3834_ vssd1 vssd1 vccd1 vccd1 _3836_
+ sky130_fd_sc_hd__a22o_1
XANTENNA_fanout105_X net105 vssd1 vssd1 vccd1 vccd1 sky130_fd_sc_hd__diode_2
XFILLER_89_335 vssd1 vssd1 vccd1 vccd1 sky130_fd_sc_hd__fill_1
X_4489_ _3764_ _3765_ _3766_ vssd1 vssd1 vccd1 vccd1 _3767_ sky130_fd_sc_hd__or3_4
XANTENNA__6586__A net139 vssd1 vssd1 vccd1 vccd1 sky130_fd_sc_hd__diode_2
X_7277_ _2506_ _2507_ vssd1 vssd1 vccd1 vccd1 _2508_ sky130_fd_sc_hd__nor2_1
X_6228_ _1212_ _1215_ _1416_ vssd1 vssd1 vccd1 vccd1 _1417_ sky130_fd_sc_hd__o21ai_1
Xteam_03_347 vssd1 vssd1 vccd1 vccd1 team_03_347/HI gpio_oeb[23] sky130_fd_sc_hd__conb_1
Xteam_03_358 vssd1 vssd1 vccd1 vccd1 team_03_358/HI gpio_out[0] sky130_fd_sc_hd__conb_1
XFILLER_66_26 vssd1 vssd1 vccd1 vccd1 sky130_fd_sc_hd__fill_2
X_6159_ _1134_ _1140_ _1133_ vssd1 vssd1 vccd1 vccd1 _1348_ sky130_fd_sc_hd__a21bo_1
Xteam_03_369 vssd1 vssd1 vccd1 vccd1 team_03_369/HI gpio_out[11] sky130_fd_sc_hd__conb_1
XFILLER_66_48 vssd1 vssd1 vccd1 vccd1 sky130_fd_sc_hd__fill_1
XFILLER_57_276 vssd1 vssd1 vccd1 vccd1 sky130_fd_sc_hd__fill_2
XFILLER_45_416 vssd1 vssd1 vccd1 vccd1 sky130_fd_sc_hd__fill_2
XFILLER_17_107 vssd1 vssd1 vccd1 vccd1 sky130_fd_sc_hd__fill_1
XANTENNA__8306__A net317 vssd1 vssd1 vccd1 vccd1 sky130_fd_sc_hd__diode_2
XFILLER_72_235 vssd1 vssd1 vccd1 vccd1 sky130_fd_sc_hd__fill_8
XTAP_TAPCELL_ROW_84_1041 vssd1 vccd1 sky130_fd_sc_hd__tapvpwrvgnd_1
XTAP_TAPCELL_ROW_71_915 vssd1 vccd1 sky130_fd_sc_hd__tapvpwrvgnd_1
XFILLER_15_41 vssd1 vssd1 vccd1 vccd1 sky130_fd_sc_hd__fill_1
XTAP_TAPCELL_ROW_43_628 vssd1 vccd1 sky130_fd_sc_hd__tapvpwrvgnd_1
XFILLER_13_335 vssd1 vssd1 vccd1 vccd1 sky130_fd_sc_hd__fill_1
XFILLER_15_52 vssd1 vssd1 vccd1 vccd1 sky130_fd_sc_hd__fill_1
XFILLER_40_176 vssd1 vssd1 vccd1 vccd1 sky130_fd_sc_hd__fill_2
XFILLER_5_501 vssd1 vssd1 vccd1 vccd1 sky130_fd_sc_hd__fill_2
XFILLER_5_534 vccd1 vssd1 vccd1 vssd1 sky130_ef_sc_hd__decap_40_12
XANTENNA__7880__A net99 vssd1 vssd1 vccd1 vccd1 sky130_fd_sc_hd__diode_2
XFILLER_0_261 vssd1 vssd1 vccd1 vccd1 sky130_fd_sc_hd__fill_1
XFILLER_76_530 vssd1 vssd1 vccd1 vccd1 sky130_fd_sc_hd__fill_2
XFILLER_91_500 vssd1 vssd1 vccd1 vccd1 sky130_fd_sc_hd__fill_4
XANTENNA__7758__C net196 vssd1 vssd1 vccd1 vccd1 sky130_fd_sc_hd__diode_2
XTAP_TAPCELL_ROW_59_794 vssd1 vccd1 sky130_fd_sc_hd__tapvpwrvgnd_1
XFILLER_31_143 vssd1 vssd1 vccd1 vccd1 sky130_fd_sc_hd__fill_2
XTAP_TAPCELL_ROW_14_341 vssd1 vccd1 sky130_fd_sc_hd__tapvpwrvgnd_1
XFILLER_75_3 vssd1 vssd1 vccd1 vccd1 sky130_fd_sc_hd__fill_1
X_5530_ _0700_ _0718_ vssd1 vssd1 vccd1 vccd1 _0720_ sky130_fd_sc_hd__and2_1
XFILLER_8_372 vssd1 vssd1 vccd1 vccd1 sky130_fd_sc_hd__fill_1
X_5461_ net105 net60 vssd1 vssd1 vccd1 vccd1 _0651_ sky130_fd_sc_hd__nor2_1
X_4412_ net185 _3698_ vssd1 vssd1 vccd1 vccd1 _0050_ sky130_fd_sc_hd__xor2_1
X_7200_ PID_INST.k3_calc.d2.y\[12\] _0222_ _0225_ vssd1 vssd1 vccd1 vccd1 _2427_ sky130_fd_sc_hd__and3_1
X_8180_ _3427_ _3444_ vssd1 vssd1 vccd1 vccd1 _3445_ sky130_fd_sc_hd__xnor2_1
X_5392_ _0580_ _0581_ vssd1 vssd1 vccd1 vccd1 _0582_ sky130_fd_sc_hd__xnor2_1
X_7131_ _2351_ _2352_ vssd1 vssd1 vccd1 vccd1 _2353_ sky130_fd_sc_hd__nor2_1
X_4343_ _3633_ _3642_ vssd1 vssd1 vccd1 vccd1 _3643_ sky130_fd_sc_hd__nor2_1
X_7062_ _2261_ _2280_ vssd1 vssd1 vccd1 vccd1 _2282_ sky130_fd_sc_hd__xnor2_1
Xfanout307 net308 vssd1 vssd1 vccd1 vccd1 net307 sky130_fd_sc_hd__clkbuf_2
Xfanout318 net319 vssd1 vssd1 vccd1 vccd1 net318 sky130_fd_sc_hd__buf_2
X_4274_ net176 _2823_ net177 vssd1 vssd1 vccd1 vccd1 _2939_ sky130_fd_sc_hd__and3b_1
Xfanout329 net339 vssd1 vssd1 vccd1 vccd1 net329 sky130_fd_sc_hd__clkbuf_2
X_6013_ _1200_ _1201_ vssd1 vssd1 vccd1 vccd1 _1203_ sky130_fd_sc_hd__xnor2_1
XFILLER_39_232 vssd1 vssd1 vccd1 vccd1 sky130_fd_sc_hd__fill_2
XFILLER_82_511 vccd1 vssd1 vccd1 vssd1 sky130_ef_sc_hd__decap_40_12
XANTENNA__7406__B1 _2643_ vssd1 vssd1 vccd1 vccd1 sky130_fd_sc_hd__diode_2
X_7964_ net281 net277 net192 net189 vssd1 vssd1 vccd1 vccd1 _3219_ sky130_fd_sc_hd__and4_1
XFILLER_82_533 vssd1 vssd1 vccd1 vccd1 sky130_fd_sc_hd__fill_2
XFILLER_27_438 vssd1 vssd1 vccd1 vccd1 sky130_fd_sc_hd__fill_2
X_6915_ net164 _3999_ vssd1 vssd1 vccd1 vccd1 _2125_ sky130_fd_sc_hd__nand2_1
XFILLER_42_419 vssd1 vssd1 vccd1 vccd1 sky130_fd_sc_hd__fill_1
X_7895_ _3147_ _3148_ vssd1 vssd1 vccd1 vccd1 _3150_ sky130_fd_sc_hd__and2_1
XFILLER_50_452 vssd1 vssd1 vccd1 vccd1 sky130_fd_sc_hd__fill_1
X_6846_ net91 net63 vssd1 vssd1 vccd1 vccd1 _2053_ sky130_fd_sc_hd__nor2_1
X_6777_ _1977_ _1978_ vssd1 vssd1 vccd1 vccd1 _1979_ sky130_fd_sc_hd__nor2_1
XFILLER_50_463 vssd1 vssd1 vccd1 vccd1 sky130_fd_sc_hd__fill_1
X_5728_ net239 net288 _0906_ _0912_ vssd1 vssd1 vccd1 vccd1 _0918_ sky130_fd_sc_hd__a211oi_1
XFILLER_6_309 vssd1 vssd1 vccd1 vccd1 sky130_fd_sc_hd__fill_8
X_5659_ _0846_ _0838_ vssd1 vssd1 vccd1 vccd1 _0849_ sky130_fd_sc_hd__nand2b_1
X_8447_ clknet_4_12_0_clk _0035_ net336 vssd1 vssd1 vccd1 vccd1 PID_INST.k2_calc.sum_reg\[3\]
+ sky130_fd_sc_hd__dfrtp_2
XTAP_TAPCELL_ROW_20_399 vssd1 vccd1 sky130_fd_sc_hd__tapvpwrvgnd_1
X_8378_ clknet_4_13_0_clk _0014_ net335 vssd1 vssd1 vccd1 vccd1 PID_INST.k1_calc.d1.x\[14\]
+ sky130_fd_sc_hd__dfrtp_1
XFILLER_2_515 vssd1 vssd1 vccd1 vccd1 sky130_fd_sc_hd__fill_1
X_7329_ _2561_ _2562_ vssd1 vssd1 vccd1 vccd1 _2563_ sky130_fd_sc_hd__xnor2_1
XFILLER_89_154 vssd1 vssd1 vccd1 vccd1 sky130_fd_sc_hd__fill_2
XFILLER_77_14 vssd1 vssd1 vccd1 vccd1 sky130_fd_sc_hd__fill_1
XFILLER_77_316 vssd1 vssd1 vccd1 vccd1 sky130_fd_sc_hd__fill_4
XFILLER_77_69 vssd1 vssd1 vccd1 vccd1 sky130_fd_sc_hd__fill_2
XANTENNA_fanout82_A net83 vssd1 vssd1 vccd1 vccd1 sky130_fd_sc_hd__diode_2
XFILLER_77_349 vccd1 vssd1 vccd1 vssd1 sky130_ef_sc_hd__decap_40_12
Xclkbuf_4_13_0_clk clknet_0_clk vssd1 vssd1 vccd1 vccd1 clknet_4_13_0_clk sky130_fd_sc_hd__clkbuf_8
XFILLER_73_533 vssd1 vssd1 vccd1 vccd1 sky130_fd_sc_hd__fill_1
XTAP_TAPCELL_ROW_56_764 vssd1 vccd1 sky130_fd_sc_hd__tapvpwrvgnd_1
XFILLER_60_227 vssd1 vssd1 vccd1 vccd1 sky130_fd_sc_hd__fill_1
XFILLER_60_205 vssd1 vssd1 vccd1 vccd1 sky130_fd_sc_hd__fill_8
XTAP_TAPCELL_ROW_28_477 vssd1 vccd1 sky130_fd_sc_hd__tapvpwrvgnd_1
XFILLER_13_165 vssd1 vssd1 vccd1 vccd1 sky130_fd_sc_hd__fill_2
XANTENNA__5826__C net311 vssd1 vssd1 vccd1 vccd1 sky130_fd_sc_hd__diode_2
XTAP_TAPCELL_ROW_11_311 vssd1 vccd1 sky130_fd_sc_hd__tapvpwrvgnd_1
XFILLER_41_496 vssd1 vssd1 vccd1 vccd1 sky130_fd_sc_hd__fill_2
XFILLER_42_83 vssd1 vssd1 vccd1 vccd1 sky130_fd_sc_hd__fill_1
XANTENNA__6003__B net44 vssd1 vssd1 vccd1 vccd1 sky130_fd_sc_hd__diode_2
XFILLER_5_386 vssd1 vssd1 vccd1 vccd1 sky130_fd_sc_hd__fill_4
XANTENNA__6439__A1 net216 vssd1 vssd1 vccd1 vccd1 sky130_fd_sc_hd__diode_2
XFILLER_3_55 vssd1 vssd1 vccd1 vccd1 sky130_fd_sc_hd__fill_1
XANTENNA__8385__CLK clknet_4_9_0_clk vssd1 vssd1 vccd1 vccd1 sky130_fd_sc_hd__diode_2
XFILLER_3_66 vssd1 vssd1 vccd1 vccd1 sky130_fd_sc_hd__fill_2
XFILLER_64_533 vccd1 vssd1 vccd1 vssd1 sky130_ef_sc_hd__decap_40_12
XFILLER_64_522 vssd1 vssd1 vccd1 vccd1 sky130_fd_sc_hd__fill_8
XFILLER_51_227 vssd1 vssd1 vccd1 vccd1 sky130_fd_sc_hd__fill_1
X_4961_ _0102_ _0111_ _0110_ vssd1 vssd1 vccd1 vccd1 _0151_ sky130_fd_sc_hd__o21ai_1
XFILLER_24_419 vssd1 vssd1 vccd1 vccd1 sky130_fd_sc_hd__fill_1
XFILLER_83_90 vssd1 vssd1 vccd1 vccd1 sky130_fd_sc_hd__fill_1
X_7680_ _2925_ _2933_ vssd1 vssd1 vccd1 vccd1 _2934_ sky130_fd_sc_hd__xnor2_1
X_4892_ PID_INST.k1_calc.d1.x\[13\] PID_INST.k3_calc.prev_error\[13\] vssd1 vssd1
+ vccd1 vccd1 _0082_ sky130_fd_sc_hd__nand2_4
X_6700_ _1684_ _1685_ _1683_ vssd1 vssd1 vccd1 vccd1 _1898_ sky130_fd_sc_hd__a21o_1
X_6631_ _1818_ _1823_ vssd1 vssd1 vccd1 vccd1 _1824_ sky130_fd_sc_hd__nand2_1
X_8301_ _3573_ _3574_ vssd1 vssd1 vccd1 vccd1 _3575_ sky130_fd_sc_hd__and2b_1
X_6562_ _1586_ _1748_ vssd1 vssd1 vccd1 vccd1 _1749_ sky130_fd_sc_hd__xor2_1
XANTENNA__7009__B net266 vssd1 vssd1 vccd1 vccd1 sky130_fd_sc_hd__diode_2
X_5513_ net244 net283 net278 net247 vssd1 vssd1 vccd1 vccd1 _0703_ sky130_fd_sc_hd__a22oi_1
X_6493_ _1480_ _1482_ _1679_ vssd1 vssd1 vccd1 vccd1 _1681_ sky130_fd_sc_hd__nor3_1
XANTENNA__6127__B1 net50 vssd1 vssd1 vccd1 vccd1 sky130_fd_sc_hd__diode_2
X_8232_ net263 net194 net191 net267 vssd1 vssd1 vccd1 vccd1 _3501_ sky130_fd_sc_hd__a22oi_1
X_5444_ net105 net58 vssd1 vssd1 vccd1 vccd1 _0634_ sky130_fd_sc_hd__nor2_1
X_8163_ _3416_ _3425_ vssd1 vssd1 vccd1 vccd1 _3427_ sky130_fd_sc_hd__xnor2_1
X_7114_ net313 net300 net193 net188 vssd1 vssd1 vccd1 vccd1 _2335_ sky130_fd_sc_hd__and4_1
X_5375_ _0563_ _0564_ vssd1 vssd1 vccd1 vccd1 _0565_ sky130_fd_sc_hd__nand2_1
XANTENNA__4649__A net142 vssd1 vssd1 vccd1 vccd1 sky130_fd_sc_hd__diode_2
Xfanout104 _2548_ vssd1 vssd1 vccd1 vccd1 net104 sky130_fd_sc_hd__buf_2
X_8094_ _3335_ _3336_ _3350_ vssd1 vssd1 vccd1 vccd1 _3353_ sky130_fd_sc_hd__a21oi_1
XFILLER_86_113 vccd1 vssd1 vccd1 vssd1 sky130_ef_sc_hd__decap_40_12
XANTENNA__4368__B net5 vssd1 vssd1 vccd1 vccd1 sky130_fd_sc_hd__diode_2
X_4326_ net159 _3450_ _3461_ vssd1 vssd1 vccd1 vccd1 _3472_ sky130_fd_sc_hd__or3b_1
Xfanout126 net127 vssd1 vssd1 vccd1 vccd1 net126 sky130_fd_sc_hd__buf_2
Xfanout115 _2357_ vssd1 vssd1 vccd1 vccd1 net115 sky130_fd_sc_hd__buf_4
Xfanout137 PID_INST.k3_calc.d1.y\[11\] vssd1 vssd1 vccd1 vccd1 net137 sky130_fd_sc_hd__buf_2
X_7045_ net219 net232 net274 net262 vssd1 vssd1 vccd1 vccd1 _2264_ sky130_fd_sc_hd__and4_1
Xfanout159 _2950_ vssd1 vssd1 vccd1 vccd1 net159 sky130_fd_sc_hd__buf_2
X_4257_ net425 net170 vssd1 vssd1 vccd1 vccd1 _2760_ sky130_fd_sc_hd__or2_1
Xfanout148 _2242_ vssd1 vssd1 vccd1 vccd1 net148 sky130_fd_sc_hd__clkbuf_4
X_4188_ _2019_ vssd1 vssd1 vccd1 vccd1 PID_INST.k3_calc.d1.y\[9\] sky130_fd_sc_hd__inv_2
X_7947_ _3200_ _3201_ vssd1 vssd1 vccd1 vccd1 _3202_ sky130_fd_sc_hd__xnor2_1
XFILLER_63_38 vssd1 vssd1 vccd1 vccd1 sky130_fd_sc_hd__fill_1
XFILLER_42_216 vssd1 vssd1 vccd1 vccd1 sky130_fd_sc_hd__fill_2
XANTENNA__7695__A net286 vssd1 vssd1 vccd1 vccd1 sky130_fd_sc_hd__diode_2
XTAP_TAPCELL_ROW_81_1011 vssd1 vccd1 sky130_fd_sc_hd__tapvpwrvgnd_1
XFILLER_70_569 vssd1 vssd1 vccd1 vccd1 sky130_fd_sc_hd__fill_1
XTAP_TAPCELL_ROW_53_734 vssd1 vccd1 sky130_fd_sc_hd__tapvpwrvgnd_1
XTAP_TAPCELL_ROW_25_447 vssd1 vccd1 sky130_fd_sc_hd__tapvpwrvgnd_1
X_7878_ net96 net44 net42 net101 vssd1 vssd1 vccd1 vccd1 _3133_ sky130_fd_sc_hd__o22ai_1
X_6829_ _1737_ _1739_ _2033_ vssd1 vssd1 vccd1 vccd1 _2034_ sky130_fd_sc_hd__o21ai_2
XANTENNA__4831__B net70 vssd1 vssd1 vccd1 vccd1 sky130_fd_sc_hd__diode_2
XFILLER_6_139 vssd1 vssd1 vccd1 vccd1 sky130_fd_sc_hd__fill_1
XFILLER_12_42 vssd1 vssd1 vccd1 vccd1 sky130_fd_sc_hd__fill_2
XFILLER_88_68 vssd1 vssd1 vccd1 vccd1 sky130_fd_sc_hd__fill_2
XFILLER_88_57 vssd1 vssd1 vccd1 vccd1 sky130_fd_sc_hd__fill_4
XFILLER_5_3 vccd1 vssd1 vccd1 vssd1 sky130_ef_sc_hd__decap_40_12
XFILLER_77_113 vccd1 vssd1 vccd1 vssd1 sky130_ef_sc_hd__decap_40_12
XANTENNA_fanout85_X net85 vssd1 vssd1 vccd1 vccd1 sky130_fd_sc_hd__diode_2
XFILLER_65_319 vssd1 vssd1 vccd1 vccd1 sky130_fd_sc_hd__fill_2
XFILLER_58_360 vssd1 vssd1 vccd1 vccd1 sky130_fd_sc_hd__fill_4
XANTENNA__7589__B net42 vssd1 vssd1 vccd1 vccd1 sky130_fd_sc_hd__diode_2
XFILLER_37_83 vssd1 vssd1 vccd1 vccd1 sky130_fd_sc_hd__fill_2
XFILLER_33_205 vssd1 vssd1 vccd1 vccd1 sky130_fd_sc_hd__fill_4
XFILLER_14_452 vssd1 vssd1 vccd1 vccd1 sky130_fd_sc_hd__fill_2
XANTENNA__8064__A1_N net322 vssd1 vssd1 vccd1 vccd1 sky130_fd_sc_hd__diode_2
XANTENNA__5883__A2 net237 vssd1 vssd1 vccd1 vccd1 sky130_fd_sc_hd__diode_2
X_5160_ _0348_ _0349_ vssd1 vssd1 vccd1 vccd1 _0350_ sky130_fd_sc_hd__nand2_1
XFILLER_68_124 vssd1 vssd1 vccd1 vccd1 sky130_fd_sc_hd__fill_1
X_5091_ _0197_ _0278_ vssd1 vssd1 vccd1 vccd1 _0281_ sky130_fd_sc_hd__xnor2_1
XFILLER_83_138 vssd1 vssd1 vccd1 vccd1 sky130_fd_sc_hd__fill_8
XFILLER_49_393 vssd1 vssd1 vccd1 vccd1 sky130_fd_sc_hd__fill_4
XFILLER_49_371 vccd1 vssd1 vccd1 vssd1 sky130_ef_sc_hd__decap_40_12
XFILLER_64_330 vssd1 vssd1 vccd1 vccd1 sky130_fd_sc_hd__fill_1
XANTENNA__5399__A1 net115 vssd1 vssd1 vccd1 vccd1 sky130_fd_sc_hd__diode_2
X_7801_ _3054_ _3055_ vssd1 vssd1 vccd1 vccd1 _3057_ sky130_fd_sc_hd__nor2_1
X_5993_ _1180_ _1181_ vssd1 vssd1 vccd1 vccd1 _1183_ sky130_fd_sc_hd__xnor2_2
X_7732_ _2981_ _2986_ vssd1 vssd1 vccd1 vccd1 _2988_ sky130_fd_sc_hd__or2_1
X_4944_ _0112_ _0133_ vssd1 vssd1 vccd1 vccd1 _0134_ sky130_fd_sc_hd__xnor2_1
XFILLER_24_238 vssd1 vssd1 vccd1 vccd1 sky130_fd_sc_hd__fill_2
XTAP_TAPCELL_ROW_50_704 vssd1 vccd1 sky130_fd_sc_hd__tapvpwrvgnd_1
X_7663_ _2668_ _2682_ _2916_ vssd1 vssd1 vccd1 vccd1 _2917_ sky130_fd_sc_hd__a21oi_1
X_4875_ _4080_ net67 _4151_ _4152_ vssd1 vssd1 vccd1 vccd1 _4153_ sky130_fd_sc_hd__o211ai_4
XTAP_TAPCELL_ROW_22_417 vssd1 vccd1 sky130_fd_sc_hd__tapvpwrvgnd_1
X_7594_ _2842_ _2843_ vssd1 vssd1 vccd1 vccd1 _2844_ sky130_fd_sc_hd__xnor2_1
X_6614_ _1802_ _1803_ vssd1 vssd1 vccd1 vccd1 _1805_ sky130_fd_sc_hd__xnor2_1
X_6545_ _1730_ _1731_ vssd1 vssd1 vccd1 vccd1 _1732_ sky130_fd_sc_hd__xor2_2
X_8215_ _3480_ _3481_ _3370_ _3372_ vssd1 vssd1 vccd1 vccd1 _3483_ sky130_fd_sc_hd__o211a_1
X_6476_ _1455_ _1458_ _1663_ vssd1 vssd1 vccd1 vccd1 _1664_ sky130_fd_sc_hd__a21oi_1
X_5427_ net103 net51 vssd1 vssd1 vccd1 vccd1 _0617_ sky130_fd_sc_hd__nor2_1
XANTENNA__5874__A2 net237 vssd1 vssd1 vccd1 vccd1 sky130_fd_sc_hd__diode_2
X_8146_ _3314_ _3315_ _3406_ vssd1 vssd1 vccd1 vccd1 _3410_ sky130_fd_sc_hd__and3_1
X_5358_ _0546_ _0547_ vssd1 vssd1 vccd1 vccd1 _0548_ sky130_fd_sc_hd__and2_1
X_8077_ _3184_ _3191_ _3334_ vssd1 vssd1 vccd1 vccd1 _3335_ sky130_fd_sc_hd__a21o_1
X_4309_ net251 _2961_ vssd1 vssd1 vccd1 vccd1 _0032_ sky130_fd_sc_hd__xnor2_1
XFILLER_87_488 vssd1 vssd1 vccd1 vccd1 sky130_fd_sc_hd__fill_1
X_7028_ _1908_ _1911_ _1909_ vssd1 vssd1 vccd1 vccd1 _2246_ sky130_fd_sc_hd__o21ba_1
XFILLER_47_319 vssd1 vssd1 vccd1 vccd1 sky130_fd_sc_hd__fill_4
X_5289_ PID_INST.k3_calc.d2.y\[1\] _0474_ _0475_ vssd1 vssd1 vccd1 vccd1 _0479_ sky130_fd_sc_hd__and3_1
XFILLER_74_127 vccd1 vssd1 vccd1 vssd1 sky130_ef_sc_hd__decap_40_12
XFILLER_28_533 vssd1 vssd1 vccd1 vccd1 sky130_fd_sc_hd__fill_2
XFILLER_74_149 vssd1 vssd1 vccd1 vccd1 sky130_fd_sc_hd__fill_2
XFILLER_74_26 vssd1 vssd1 vccd1 vccd1 sky130_fd_sc_hd__fill_2
XFILLER_15_249 vccd1 vssd1 vccd1 vssd1 sky130_ef_sc_hd__decap_40_12
XTAP_TAPCELL_ROW_38_583 vssd1 vccd1 sky130_fd_sc_hd__tapvpwrvgnd_1
XFILLER_90_69 vccd1 vssd1 vccd1 vssd1 sky130_ef_sc_hd__decap_40_12
XANTENNA__6339__B1 net80 vssd1 vssd1 vccd1 vccd1 sky130_fd_sc_hd__diode_2
XFILLER_2_197 vccd1 vssd1 vccd1 vssd1 sky130_ef_sc_hd__decap_40_12
XFILLER_78_477 vccd1 vssd1 vccd1 vssd1 sky130_ef_sc_hd__decap_40_12
XANTENNA__5504__A2_N net239 vssd1 vssd1 vccd1 vccd1 sky130_fd_sc_hd__diode_2
XFILLER_0_23 vssd1 vssd1 vccd1 vccd1 sky130_fd_sc_hd__fill_1
XFILLER_19_555 vssd1 vssd1 vccd1 vccd1 sky130_fd_sc_hd__fill_1
XANTENNA__8423__CLK clknet_4_1_0_clk vssd1 vssd1 vccd1 vccd1 sky130_fd_sc_hd__diode_2
XFILLER_46_385 vssd1 vssd1 vccd1 vccd1 sky130_fd_sc_hd__fill_2
XFILLER_46_363 vssd1 vssd1 vccd1 vccd1 sky130_fd_sc_hd__fill_1
XANTENNA__6951__B net62 vssd1 vssd1 vccd1 vccd1 sky130_fd_sc_hd__diode_2
XANTENNA_clkload8_A clknet_4_9_0_clk vssd1 vssd1 vccd1 vccd1 sky130_fd_sc_hd__diode_2
XFILLER_0_89 vssd1 vssd1 vccd1 vccd1 sky130_fd_sc_hd__fill_1
XFILLER_9_21 vssd1 vssd1 vccd1 vccd1 sky130_fd_sc_hd__fill_1
XFILLER_61_399 vssd1 vssd1 vccd1 vccd1 sky130_fd_sc_hd__fill_8
X_4660_ PID_INST.k3_calc.d1.y\[1\] net145 _3930_ _3936_ vssd1 vssd1 vccd1 vccd1 _3938_
+ sky130_fd_sc_hd__a22o_1
X_4591_ _3862_ _3868_ vssd1 vssd1 vccd1 vccd1 _3869_ sky130_fd_sc_hd__nand2_1
X_6330_ _1511_ _1517_ vssd1 vssd1 vccd1 vccd1 _1518_ sky130_fd_sc_hd__xor2_1
X_6261_ _1448_ _1449_ vssd1 vssd1 vccd1 vccd1 _1450_ sky130_fd_sc_hd__xnor2_1
X_8000_ _3042_ _3046_ _3253_ vssd1 vssd1 vccd1 vccd1 _3255_ sky130_fd_sc_hd__nor3_1
X_5212_ _0299_ _0399_ vssd1 vssd1 vccd1 vccd1 _0402_ sky130_fd_sc_hd__and2_1
X_6192_ _1367_ _1380_ vssd1 vssd1 vccd1 vccd1 _1381_ sky130_fd_sc_hd__xnor2_1
X_5143_ _0160_ _0239_ _0240_ _0238_ vssd1 vssd1 vccd1 vccd1 _0333_ sky130_fd_sc_hd__o2bb2ai_1
XANTENNA__5608__A2 net210 vssd1 vssd1 vccd1 vccd1 sky130_fd_sc_hd__diode_2
XFILLER_29_308 vssd1 vssd1 vccd1 vccd1 sky130_fd_sc_hd__fill_1
XFILLER_69_499 vssd1 vssd1 vccd1 vccd1 sky130_fd_sc_hd__fill_4
X_5074_ _0182_ _0184_ _0263_ vssd1 vssd1 vccd1 vccd1 _0264_ sky130_fd_sc_hd__a21oi_1
XANTENNA__4292__A1 net10 vssd1 vssd1 vccd1 vccd1 sky130_fd_sc_hd__diode_2
XFILLER_52_311 vssd1 vssd1 vccd1 vccd1 sky130_fd_sc_hd__fill_1
XFILLER_25_503 vssd1 vssd1 vccd1 vccd1 sky130_fd_sc_hd__fill_1
XFILLER_52_377 vssd1 vssd1 vccd1 vccd1 sky130_fd_sc_hd__fill_4
XFILLER_25_569 vssd1 vssd1 vccd1 vccd1 sky130_fd_sc_hd__fill_1
X_5976_ _0453_ _0521_ _0522_ _0523_ vssd1 vssd1 vccd1 vccd1 _1166_ sky130_fd_sc_hd__o2bb2a_1
XTAP_TAPCELL_ROW_35_553 vssd1 vccd1 sky130_fd_sc_hd__tapvpwrvgnd_1
XANTENNA__4381__B net7 vssd1 vssd1 vccd1 vccd1 sky130_fd_sc_hd__diode_2
XFILLER_52_388 vssd1 vssd1 vccd1 vccd1 sky130_fd_sc_hd__fill_2
X_7715_ _2816_ _2970_ vssd1 vssd1 vccd1 vccd1 _2972_ sky130_fd_sc_hd__nand2_1
X_4927_ net137 net143 _0113_ _0115_ vssd1 vssd1 vccd1 vccd1 _0117_ sky130_fd_sc_hd__a22oi_1
X_7646_ _2897_ _2898_ vssd1 vssd1 vccd1 vccd1 _2899_ sky130_fd_sc_hd__nand2_1
X_4858_ _4064_ _4134_ vssd1 vssd1 vccd1 vccd1 _4136_ sky130_fd_sc_hd__xnor2_1
XANTENNA_fanout135_X net135 vssd1 vssd1 vccd1 vccd1 sky130_fd_sc_hd__diode_2
X_4789_ net129 net85 vssd1 vssd1 vccd1 vccd1 _4067_ sky130_fd_sc_hd__nand2_1
XFILLER_20_296 vssd1 vssd1 vccd1 vccd1 sky130_fd_sc_hd__fill_2
X_7577_ net93 net48 vssd1 vssd1 vccd1 vccd1 _2826_ sky130_fd_sc_hd__nor2_1
X_6528_ _1713_ _1714_ vssd1 vssd1 vccd1 vccd1 _1715_ sky130_fd_sc_hd__and2_1
X_6459_ _1645_ _1646_ vssd1 vssd1 vccd1 vccd1 _1647_ sky130_fd_sc_hd__nor2_1
XFILLER_79_208 vssd1 vssd1 vccd1 vccd1 sky130_fd_sc_hd__fill_1
X_8129_ _3389_ _3390_ vssd1 vssd1 vccd1 vccd1 _3391_ sky130_fd_sc_hd__xnor2_1
XFILLER_87_252 vssd1 vssd1 vccd1 vccd1 sky130_fd_sc_hd__fill_4
XFILLER_85_25 vssd1 vssd1 vccd1 vccd1 sky130_fd_sc_hd__fill_4
XTAP_TAPCELL_ROW_7_267 vssd1 vccd1 sky130_fd_sc_hd__tapvpwrvgnd_1
XFILLER_87_274 vssd1 vssd1 vccd1 vccd1 sky130_fd_sc_hd__fill_1
XFILLER_85_47 vssd1 vssd1 vccd1 vccd1 sky130_fd_sc_hd__fill_8
XANTENNA__8028__B net40 vssd1 vssd1 vccd1 vccd1 sky130_fd_sc_hd__diode_2
XFILLER_90_417 vssd1 vssd1 vccd1 vccd1 sky130_fd_sc_hd__fill_2
XTAP_TAPCELL_ROW_87_1072 vssd1 vccd1 sky130_fd_sc_hd__tapvpwrvgnd_1
XFILLER_43_333 vssd1 vssd1 vccd1 vccd1 sky130_fd_sc_hd__fill_2
XFILLER_31_528 vssd1 vssd1 vccd1 vccd1 sky130_fd_sc_hd__fill_8
XANTENNA__4338__A2 net16 vssd1 vssd1 vccd1 vccd1 sky130_fd_sc_hd__diode_2
XFILLER_7_256 vssd1 vssd1 vccd1 vccd1 sky130_fd_sc_hd__fill_1
XFILLER_50_94 vssd1 vssd1 vccd1 vccd1 sky130_fd_sc_hd__fill_1
XFILLER_50_83 vssd1 vssd1 vccd1 vccd1 sky130_fd_sc_hd__fill_1
XFILLER_3_473 vssd1 vssd1 vccd1 vccd1 sky130_fd_sc_hd__fill_1
XFILLER_81_428 vssd1 vssd1 vccd1 vccd1 sky130_fd_sc_hd__fill_2
XFILLER_53_119 vssd1 vssd1 vccd1 vccd1 sky130_fd_sc_hd__fill_4
XTAP_TAPCELL_ROW_49_689 vssd1 vccd1 sky130_fd_sc_hd__tapvpwrvgnd_1
X_5830_ _1017_ _1019_ vssd1 vssd1 vccd1 vccd1 _1020_ sky130_fd_sc_hd__xnor2_1
XFILLER_22_506 vssd1 vssd1 vccd1 vccd1 sky130_fd_sc_hd__fill_8
X_5761_ _0707_ _0784_ vssd1 vssd1 vccd1 vccd1 _0951_ sky130_fd_sc_hd__nor2_1
XFILLER_22_528 vssd1 vssd1 vccd1 vccd1 sky130_fd_sc_hd__fill_4
XTAP_TAPCELL_ROW_32_523 vssd1 vccd1 sky130_fd_sc_hd__tapvpwrvgnd_1
XFILLER_91_90 vssd1 vssd1 vccd1 vccd1 sky130_fd_sc_hd__fill_2
X_4712_ _3987_ _3988_ vssd1 vssd1 vccd1 vccd1 _3990_ sky130_fd_sc_hd__xor2_1
X_7500_ _2738_ _2742_ vssd1 vssd1 vccd1 vccd1 _2745_ sky130_fd_sc_hd__xnor2_1
XFILLER_30_550 vssd1 vssd1 vccd1 vccd1 sky130_fd_sc_hd__fill_1
X_8480_ clknet_4_11_0_clk _0068_ net340 vssd1 vssd1 vccd1 vccd1 net29 sky130_fd_sc_hd__dfrtp_1
X_7431_ _2567_ _2571_ _2568_ vssd1 vssd1 vccd1 vccd1 _2671_ sky130_fd_sc_hd__o21ba_1
X_5692_ _0880_ _0881_ vssd1 vssd1 vccd1 vccd1 _0882_ sky130_fd_sc_hd__nor2_1
XANTENNA__6723__B1 net193 vssd1 vssd1 vccd1 vccd1 sky130_fd_sc_hd__diode_2
X_4643_ net120 net144 _3910_ _3920_ vssd1 vssd1 vccd1 vccd1 _3921_ sky130_fd_sc_hd__and4_1
X_7362_ _2596_ _2597_ vssd1 vssd1 vccd1 vccd1 _2598_ sky130_fd_sc_hd__nor2_1
X_4574_ _3851_ _3843_ vssd1 vssd1 vccd1 vccd1 _3852_ sky130_fd_sc_hd__and2b_1
X_6313_ net97 net59 net56 net109 vssd1 vssd1 vccd1 vccd1 _1501_ sky130_fd_sc_hd__o22ai_1
X_7293_ _2511_ _2524_ vssd1 vssd1 vccd1 vccd1 _2525_ sky130_fd_sc_hd__xor2_1
X_6244_ _1229_ _1231_ _1228_ vssd1 vssd1 vccd1 vccd1 _1433_ sky130_fd_sc_hd__o21ba_1
X_6175_ _1350_ _1363_ vssd1 vssd1 vccd1 vccd1 _1364_ sky130_fd_sc_hd__xor2_1
XFILLER_69_263 vssd1 vssd1 vccd1 vccd1 sky130_fd_sc_hd__fill_1
XFILLER_57_425 vccd1 vssd1 vccd1 vssd1 sky130_ef_sc_hd__decap_40_12
XTAP_TAPCELL_ROW_4_237 vssd1 vccd1 sky130_fd_sc_hd__tapvpwrvgnd_1
X_5126_ _0311_ _0315_ _0308_ vssd1 vssd1 vccd1 vccd1 _0316_ sky130_fd_sc_hd__a21oi_1
X_5057_ _0232_ _0245_ vssd1 vssd1 vccd1 vccd1 _0247_ sky130_fd_sc_hd__xnor2_1
XFILLER_29_138 vssd1 vssd1 vccd1 vccd1 sky130_fd_sc_hd__fill_8
XFILLER_72_417 vssd1 vssd1 vccd1 vccd1 sky130_fd_sc_hd__fill_2
XFILLER_65_491 vssd1 vssd1 vccd1 vccd1 sky130_fd_sc_hd__fill_4
XANTENNA_fanout252_X net252 vssd1 vssd1 vccd1 vccd1 sky130_fd_sc_hd__diode_2
XANTENNA__4392__A net194 vssd1 vssd1 vccd1 vccd1 sky130_fd_sc_hd__diode_2
XFILLER_52_141 vssd1 vssd1 vccd1 vccd1 sky130_fd_sc_hd__fill_8
X_5959_ _0506_ _1148_ _1147_ vssd1 vssd1 vccd1 vccd1 _1149_ sky130_fd_sc_hd__a21bo_1
XANTENNA__5000__B net87 vssd1 vssd1 vccd1 vccd1 sky130_fd_sc_hd__diode_2
XFILLER_40_347 vssd1 vssd1 vccd1 vccd1 sky130_fd_sc_hd__fill_2
X_7629_ _2553_ _2557_ _2806_ _2880_ _2805_ vssd1 vssd1 vccd1 vccd1 _2881_ sky130_fd_sc_hd__a311o_1
XFILLER_4_215 vccd1 vssd1 vccd1 vssd1 sky130_ef_sc_hd__decap_40_12
XFILLER_4_204 vssd1 vssd1 vccd1 vccd1 sky130_fd_sc_hd__fill_4
XFILLER_4_237 vssd1 vssd1 vccd1 vccd1 sky130_fd_sc_hd__fill_8
XANTENNA__6766__B net287 vssd1 vssd1 vccd1 vccd1 sky130_fd_sc_hd__diode_2
XANTENNA__8039__A net98 vssd1 vssd1 vccd1 vccd1 sky130_fd_sc_hd__diode_2
XFILLER_75_244 vssd1 vssd1 vccd1 vccd1 sky130_fd_sc_hd__fill_2
XFILLER_48_447 vccd1 vssd1 vccd1 vssd1 sky130_ef_sc_hd__decap_40_12
XFILLER_75_277 vssd1 vssd1 vccd1 vccd1 sky130_fd_sc_hd__fill_2
XTAP_TAPCELL_ROW_46_659 vssd1 vccd1 sky130_fd_sc_hd__tapvpwrvgnd_1
XFILLER_71_483 vssd1 vssd1 vccd1 vccd1 sky130_fd_sc_hd__fill_8
XFILLER_91_9 vccd1 vssd1 vccd1 vssd1 sky130_ef_sc_hd__decap_40_12
XANTENNA__5548__D net227 vssd1 vssd1 vccd1 vccd1 sky130_fd_sc_hd__diode_2
XFILLER_31_358 vssd1 vssd1 vccd1 vccd1 sky130_fd_sc_hd__fill_8
XANTENNA__6957__A net95 vssd1 vssd1 vccd1 vccd1 sky130_fd_sc_hd__diode_2
X_4290_ PID_INST.k1_calc.d1.x\[13\] net8 net161 vssd1 vssd1 vccd1 vccd1 _0013_ sky130_fd_sc_hd__mux2_1
XFILLER_3_281 vssd1 vssd1 vccd1 vccd1 sky130_fd_sc_hd__fill_1
XFILLER_86_509 vssd1 vssd1 vccd1 vccd1 sky130_fd_sc_hd__fill_4
XFILLER_79_561 vssd1 vssd1 vccd1 vccd1 sky130_fd_sc_hd__fill_1
XANTENNA__7433__B2 net311 vssd1 vssd1 vccd1 vccd1 sky130_fd_sc_hd__diode_2
XANTENNA__7433__A1 net299 vssd1 vssd1 vccd1 vccd1 sky130_fd_sc_hd__diode_2
XTAP_TAPCELL_ROW_1_207 vssd1 vccd1 sky130_fd_sc_hd__tapvpwrvgnd_1
XFILLER_39_447 vssd1 vssd1 vccd1 vccd1 sky130_fd_sc_hd__fill_1
X_7980_ _3210_ _3211_ _3233_ vssd1 vssd1 vccd1 vccd1 _3235_ sky130_fd_sc_hd__o21a_1
XANTENNA__7984__A2 net182 vssd1 vssd1 vccd1 vccd1 sky130_fd_sc_hd__diode_2
XFILLER_81_247 vccd1 vssd1 vccd1 vssd1 sky130_ef_sc_hd__decap_40_12
XFILLER_81_225 vccd1 vssd1 vccd1 vssd1 sky130_ef_sc_hd__decap_40_12
X_6931_ _2138_ _2141_ vssd1 vssd1 vccd1 vccd1 _2142_ sky130_fd_sc_hd__xnor2_1
X_6862_ _1763_ _1765_ _1761_ vssd1 vssd1 vccd1 vccd1 _2069_ sky130_fd_sc_hd__a21bo_1
XFILLER_34_141 vssd1 vssd1 vccd1 vccd1 sky130_fd_sc_hd__fill_1
X_5813_ net245 net289 vssd1 vssd1 vccd1 vccd1 _1003_ sky130_fd_sc_hd__nand2_1
XTAP_TAPCELL_ROW_17_372 vssd1 vccd1 sky130_fd_sc_hd__tapvpwrvgnd_1
XFILLER_22_314 vssd1 vssd1 vccd1 vccd1 sky130_fd_sc_hd__fill_1
X_6793_ net132 net69 vssd1 vssd1 vccd1 vccd1 _1996_ sky130_fd_sc_hd__nand2_1
X_5744_ net318 net224 _0889_ _0933_ _0862_ vssd1 vssd1 vccd1 vccd1 _0934_ sky130_fd_sc_hd__a32o_1
XFILLER_10_509 vssd1 vssd1 vccd1 vccd1 sky130_fd_sc_hd__fill_2
X_5675_ _0693_ _0694_ _0699_ vssd1 vssd1 vccd1 vccd1 _0865_ sky130_fd_sc_hd__o21ai_1
X_8463_ clknet_4_5_0_clk _0051_ net333 vssd1 vssd1 vccd1 vccd1 PID_INST.k2_calc.sum_reg\[19\]
+ sky130_fd_sc_hd__dfrtp_1
XANTENNA_fanout212_A net213 vssd1 vssd1 vccd1 vccd1 sky130_fd_sc_hd__diode_2
X_7414_ _2651_ _2652_ vssd1 vssd1 vccd1 vccd1 _2653_ sky130_fd_sc_hd__nor2_1
X_8394_ clknet_4_12_0_clk PID_INST.k3_calc.d2.y\[14\] net329 vssd1 vssd1 vccd1 vccd1
+ PID_INST.k3_calc.timescaling_term\[14\] sky130_fd_sc_hd__dfrtp_1
X_4626_ _3880_ _3884_ _3902_ vssd1 vssd1 vccd1 vccd1 _3904_ sky130_fd_sc_hd__a21o_1
X_7345_ net311 net299 net190 net186 vssd1 vssd1 vccd1 vccd1 _2581_ sky130_fd_sc_hd__and4_1
X_4557_ net142 net75 _3833_ _3834_ vssd1 vssd1 vccd1 vccd1 _3835_ sky130_fd_sc_hd__nand4_1
XFILLER_1_207 vssd1 vssd1 vccd1 vccd1 sky130_fd_sc_hd__fill_1
XANTENNA__6867__A net139 vssd1 vssd1 vccd1 vccd1 sky130_fd_sc_hd__diode_2
X_4488_ _3740_ _3742_ _3739_ vssd1 vssd1 vccd1 vccd1 _3766_ sky130_fd_sc_hd__a21bo_1
X_7276_ _2501_ _2504_ vssd1 vssd1 vccd1 vccd1 _2507_ sky130_fd_sc_hd__and2_1
XFILLER_89_369 vssd1 vssd1 vccd1 vccd1 sky130_fd_sc_hd__fill_1
X_6227_ _1414_ _1415_ vssd1 vssd1 vccd1 vccd1 _1416_ sky130_fd_sc_hd__xnor2_1
XFILLER_85_520 vssd1 vssd1 vccd1 vccd1 sky130_fd_sc_hd__fill_1
X_6158_ _1345_ _1346_ vssd1 vssd1 vccd1 vccd1 _1347_ sky130_fd_sc_hd__nand2_1
Xteam_03_348 vssd1 vssd1 vccd1 vccd1 team_03_348/HI gpio_oeb[24] sky130_fd_sc_hd__conb_1
Xteam_03_359 vssd1 vssd1 vccd1 vccd1 team_03_359/HI gpio_out[1] sky130_fd_sc_hd__conb_1
X_5109_ _0297_ _0298_ vssd1 vssd1 vccd1 vccd1 _0299_ sky130_fd_sc_hd__nor2_1
X_6089_ _0762_ _0764_ _1277_ _1278_ vssd1 vssd1 vccd1 vccd1 _1279_ sky130_fd_sc_hd__a211oi_1
XTAP_TAPCELL_ROW_84_1042 vssd1 vccd1 sky130_fd_sc_hd__tapvpwrvgnd_1
XFILLER_82_26 vssd1 vssd1 vccd1 vccd1 sky130_fd_sc_hd__fill_2
XFILLER_82_59 vssd1 vssd1 vccd1 vccd1 sky130_fd_sc_hd__fill_4
XTAP_TAPCELL_ROW_43_629 vssd1 vccd1 sky130_fd_sc_hd__tapvpwrvgnd_1
XANTENNA__4850__A net135 vssd1 vssd1 vccd1 vccd1 sky130_fd_sc_hd__diode_2
XANTENNA__8041__B net37 vssd1 vssd1 vccd1 vccd1 sky130_fd_sc_hd__diode_2
XFILLER_40_199 vssd1 vssd1 vccd1 vccd1 sky130_fd_sc_hd__fill_1
XFILLER_31_30 vssd1 vssd1 vccd1 vccd1 sky130_fd_sc_hd__fill_1
XANTENNA__7360__B1 net262 vssd1 vssd1 vccd1 vccd1 sky130_fd_sc_hd__diode_2
XFILLER_5_546 vccd1 vssd1 vccd1 vssd1 sky130_ef_sc_hd__decap_40_12
XANTENNA__7880__B net40 vssd1 vssd1 vccd1 vccd1 sky130_fd_sc_hd__diode_2
Xoutput30 net30 vssd1 vssd1 vccd1 vccd1 gpio_out[27] sky130_fd_sc_hd__buf_2
XFILLER_0_251 vssd1 vssd1 vccd1 vccd1 sky130_fd_sc_hd__fill_1
XFILLER_76_553 vssd1 vssd1 vccd1 vccd1 sky130_fd_sc_hd__fill_2
XFILLER_48_222 vssd1 vssd1 vccd1 vccd1 sky130_fd_sc_hd__fill_1
XFILLER_91_523 vccd1 vssd1 vccd1 vssd1 sky130_ef_sc_hd__decap_40_12
XANTENNA__7758__D net192 vssd1 vssd1 vccd1 vccd1 sky130_fd_sc_hd__diode_2
XFILLER_63_225 vccd1 vssd1 vccd1 vssd1 sky130_ef_sc_hd__decap_40_12
XTAP_TAPCELL_ROW_59_795 vssd1 vccd1 sky130_fd_sc_hd__tapvpwrvgnd_1
XFILLER_51_409 vssd1 vssd1 vccd1 vccd1 sky130_fd_sc_hd__fill_1
XFILLER_44_472 vssd1 vssd1 vccd1 vccd1 sky130_fd_sc_hd__fill_1
XFILLER_31_133 vssd1 vssd1 vccd1 vccd1 sky130_fd_sc_hd__fill_2
XTAP_TAPCELL_ROW_14_342 vssd1 vccd1 sky130_fd_sc_hd__tapvpwrvgnd_1
X_5460_ _0629_ _0643_ _0649_ vssd1 vssd1 vccd1 vccd1 _0650_ sky130_fd_sc_hd__a21oi_1
XFILLER_68_3 vccd1 vssd1 vccd1 vssd1 sky130_ef_sc_hd__decap_40_12
X_4411_ _3698_ _3699_ vssd1 vssd1 vccd1 vccd1 _0049_ sky130_fd_sc_hd__nor2_1
X_5391_ _0574_ _0575_ _0573_ vssd1 vssd1 vccd1 vccd1 _0581_ sky130_fd_sc_hd__a21oi_1
X_7130_ net229 net262 _0785_ vssd1 vssd1 vccd1 vccd1 _2352_ sky130_fd_sc_hd__and3_1
X_4342_ net226 net18 vssd1 vssd1 vccd1 vccd1 _3642_ sky130_fd_sc_hd__nor2_1
XANTENNA__4478__Y _3756_ vssd1 vssd1 vccd1 vccd1 sky130_fd_sc_hd__diode_2
X_7061_ _2261_ _2280_ vssd1 vssd1 vccd1 vccd1 _2281_ sky130_fd_sc_hd__or2_1
Xfanout319 net321 vssd1 vssd1 vccd1 vccd1 net319 sky130_fd_sc_hd__buf_2
Xfanout308 net309 vssd1 vssd1 vccd1 vccd1 net308 sky130_fd_sc_hd__clkbuf_4
X_4273_ net20 net1 vssd1 vssd1 vccd1 vccd1 PID_INST.add_three.n_rst sky130_fd_sc_hd__and2_1
X_6012_ _1201_ _1200_ vssd1 vssd1 vccd1 vccd1 _1202_ sky130_fd_sc_hd__nand2b_1
.ends
