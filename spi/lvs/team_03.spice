* NGSPICE file created from team_03.ext - technology: sky130A

* Black-box entry subcircuit for sky130_fd_sc_hd__diode_2 abstract view
.subckt sky130_fd_sc_hd__diode_2 DIODE VGND VNB VPB VPWR
.ends

* Black-box entry subcircuit for sky130_fd_sc_hd__fill_1 abstract view
.subckt sky130_fd_sc_hd__fill_1 VGND VNB VPB VPWR
.ends

* Black-box entry subcircuit for sky130_fd_sc_hd__nor2_2 abstract view
.subckt sky130_fd_sc_hd__nor2_2 A B VGND VNB VPB VPWR Y
.ends

* Black-box entry subcircuit for sky130_fd_sc_hd__nand2_2 abstract view
.subckt sky130_fd_sc_hd__nand2_2 A B VGND VNB VPB VPWR Y
.ends

* Black-box entry subcircuit for sky130_fd_sc_hd__inv_2 abstract view
.subckt sky130_fd_sc_hd__inv_2 A VGND VNB VPB VPWR Y
.ends

* Black-box entry subcircuit for sky130_fd_sc_hd__fill_8 abstract view
.subckt sky130_fd_sc_hd__fill_8 VGND VNB VPB VPWR
.ends

* Black-box entry subcircuit for sky130_fd_sc_hd__a21o_2 abstract view
.subckt sky130_fd_sc_hd__a21o_2 A1 A2 B1 VGND VNB VPB VPWR X
.ends

* Black-box entry subcircuit for sky130_fd_sc_hd__xnor2_2 abstract view
.subckt sky130_fd_sc_hd__xnor2_2 A B VGND VNB VPB VPWR Y
.ends

* Black-box entry subcircuit for sky130_fd_sc_hd__dfrtp_2 abstract view
.subckt sky130_fd_sc_hd__dfrtp_2 CLK D RESET_B VGND VNB VPB VPWR Q
.ends

* Black-box entry subcircuit for sky130_fd_sc_hd__and3_2 abstract view
.subckt sky130_fd_sc_hd__and3_2 A B C VGND VNB VPB VPWR X
.ends

* Black-box entry subcircuit for sky130_fd_sc_hd__nand2b_2 abstract view
.subckt sky130_fd_sc_hd__nand2b_2 A_N B VGND VNB VPB VPWR Y
.ends

* Black-box entry subcircuit for sky130_fd_sc_hd__or2_2 abstract view
.subckt sky130_fd_sc_hd__or2_2 A B VGND VNB VPB VPWR X
.ends

* Black-box entry subcircuit for sky130_fd_sc_hd__tapvpwrvgnd_1 abstract view
.subckt sky130_fd_sc_hd__tapvpwrvgnd_1 VGND VPWR
.ends

* Black-box entry subcircuit for sky130_fd_sc_hd__fill_2 abstract view
.subckt sky130_fd_sc_hd__fill_2 VGND VNB VPB VPWR
.ends

* Black-box entry subcircuit for sky130_fd_sc_hd__buf_2 abstract view
.subckt sky130_fd_sc_hd__buf_2 A VGND VNB VPB VPWR X
.ends

* Black-box entry subcircuit for sky130_fd_sc_hd__decap_3 abstract view
.subckt sky130_fd_sc_hd__decap_3 VGND VNB VPB VPWR
.ends

* Black-box entry subcircuit for sky130_fd_sc_hd__fill_4 abstract view
.subckt sky130_fd_sc_hd__fill_4 VGND VNB VPB VPWR
.ends

* Black-box entry subcircuit for sky130_fd_sc_hd__a21oi_2 abstract view
.subckt sky130_fd_sc_hd__a21oi_2 A1 A2 B1 VGND VNB VPB VPWR Y
.ends

* Black-box entry subcircuit for sky130_fd_sc_hd__mux2_1 abstract view
.subckt sky130_fd_sc_hd__mux2_1 A0 A1 S VGND VNB VPB VPWR X
.ends

* Black-box entry subcircuit for sky130_fd_sc_hd__and2_2 abstract view
.subckt sky130_fd_sc_hd__and2_2 A B VGND VNB VPB VPWR X
.ends

* Black-box entry subcircuit for sky130_fd_sc_hd__clkdlybuf4s25_1 abstract view
.subckt sky130_fd_sc_hd__clkdlybuf4s25_1 A VGND VNB VPB VPWR X
.ends

* Black-box entry subcircuit for sky130_fd_sc_hd__buf_8 abstract view
.subckt sky130_fd_sc_hd__buf_8 A VGND VNB VPB VPWR X
.ends

* Black-box entry subcircuit for sky130_fd_sc_hd__mux2_4 abstract view
.subckt sky130_fd_sc_hd__mux2_4 A0 A1 S VGND VNB VPB VPWR X
.ends

* Black-box entry subcircuit for sky130_fd_sc_hd__and4b_2 abstract view
.subckt sky130_fd_sc_hd__and4b_2 A_N B C D VGND VNB VPB VPWR X
.ends

* Black-box entry subcircuit for sky130_fd_sc_hd__xor2_2 abstract view
.subckt sky130_fd_sc_hd__xor2_2 A B VGND VNB VPB VPWR X
.ends

* Black-box entry subcircuit for sky130_ef_sc_hd__decap_40_12 abstract view
.subckt sky130_ef_sc_hd__decap_40_12 VNB VPB VGND VPWR
.ends

* Black-box entry subcircuit for sky130_fd_sc_hd__and2b_2 abstract view
.subckt sky130_fd_sc_hd__and2b_2 A_N B VGND VNB VPB VPWR X
.ends

* Black-box entry subcircuit for sky130_fd_sc_hd__nand3_2 abstract view
.subckt sky130_fd_sc_hd__nand3_2 A B C VGND VNB VPB VPWR Y
.ends

* Black-box entry subcircuit for sky130_fd_sc_hd__o211a_2 abstract view
.subckt sky130_fd_sc_hd__o211a_2 A1 A2 B1 C1 VGND VNB VPB VPWR X
.ends

* Black-box entry subcircuit for sky130_fd_sc_hd__o21ai_2 abstract view
.subckt sky130_fd_sc_hd__o21ai_2 A1 A2 B1 VGND VNB VPB VPWR Y
.ends

* Black-box entry subcircuit for sky130_fd_sc_hd__clkbuf_8 abstract view
.subckt sky130_fd_sc_hd__clkbuf_8 A VGND VNB VPB VPWR X
.ends

* Black-box entry subcircuit for sky130_fd_sc_hd__a22o_2 abstract view
.subckt sky130_fd_sc_hd__a22o_2 A1 A2 B1 B2 VGND VNB VPB VPWR X
.ends

* Black-box entry subcircuit for sky130_fd_sc_hd__a32o_2 abstract view
.subckt sky130_fd_sc_hd__a32o_2 A1 A2 A3 B1 B2 VGND VNB VPB VPWR X
.ends

* Black-box entry subcircuit for sky130_fd_sc_hd__a31o_2 abstract view
.subckt sky130_fd_sc_hd__a31o_2 A1 A2 A3 B1 VGND VNB VPB VPWR X
.ends

* Black-box entry subcircuit for sky130_fd_sc_hd__xnor2_4 abstract view
.subckt sky130_fd_sc_hd__xnor2_4 A B VGND VNB VPB VPWR Y
.ends

* Black-box entry subcircuit for sky130_fd_sc_hd__o21ba_2 abstract view
.subckt sky130_fd_sc_hd__o21ba_2 A1 A2 B1_N VGND VNB VPB VPWR X
.ends

* Black-box entry subcircuit for sky130_fd_sc_hd__and4_2 abstract view
.subckt sky130_fd_sc_hd__and4_2 A B C D VGND VNB VPB VPWR X
.ends

* Black-box entry subcircuit for sky130_fd_sc_hd__nor3_2 abstract view
.subckt sky130_fd_sc_hd__nor3_2 A B C VGND VNB VPB VPWR Y
.ends

* Black-box entry subcircuit for sky130_fd_sc_hd__a22oi_2 abstract view
.subckt sky130_fd_sc_hd__a22oi_2 A1 A2 B1 B2 VGND VNB VPB VPWR Y
.ends

* Black-box entry subcircuit for sky130_fd_sc_hd__a21bo_2 abstract view
.subckt sky130_fd_sc_hd__a21bo_2 A1 A2 B1_N VGND VNB VPB VPWR X
.ends

* Black-box entry subcircuit for sky130_fd_sc_hd__o21a_2 abstract view
.subckt sky130_fd_sc_hd__o21a_2 A1 A2 B1 VGND VNB VPB VPWR X
.ends

* Black-box entry subcircuit for sky130_fd_sc_hd__a21o_4 abstract view
.subckt sky130_fd_sc_hd__a21o_4 A1 A2 B1 VGND VNB VPB VPWR X
.ends

* Black-box entry subcircuit for sky130_fd_sc_hd__a221o_2 abstract view
.subckt sky130_fd_sc_hd__a221o_2 A1 A2 B1 B2 C1 VGND VNB VPB VPWR X
.ends

* Black-box entry subcircuit for sky130_fd_sc_hd__dlygate4sd3_1 abstract view
.subckt sky130_fd_sc_hd__dlygate4sd3_1 A VGND VNB VPB VPWR X
.ends

* Black-box entry subcircuit for sky130_fd_sc_hd__o221a_4 abstract view
.subckt sky130_fd_sc_hd__o221a_4 A1 A2 B1 B2 C1 VGND VNB VPB VPWR X
.ends

* Black-box entry subcircuit for sky130_fd_sc_hd__o21bai_2 abstract view
.subckt sky130_fd_sc_hd__o21bai_2 A1 A2 B1_N VGND VNB VPB VPWR Y
.ends

* Black-box entry subcircuit for sky130_fd_sc_hd__buf_6 abstract view
.subckt sky130_fd_sc_hd__buf_6 A VGND VNB VPB VPWR X
.ends

* Black-box entry subcircuit for sky130_fd_sc_hd__a311oi_2 abstract view
.subckt sky130_fd_sc_hd__a311oi_2 A1 A2 A3 B1 C1 VGND VNB VPB VPWR Y
.ends

* Black-box entry subcircuit for sky130_fd_sc_hd__o2bb2a_2 abstract view
.subckt sky130_fd_sc_hd__o2bb2a_2 A1_N A2_N B1 B2 VGND VNB VPB VPWR X
.ends

* Black-box entry subcircuit for sky130_fd_sc_hd__or3_2 abstract view
.subckt sky130_fd_sc_hd__or3_2 A B C VGND VNB VPB VPWR X
.ends

* Black-box entry subcircuit for sky130_fd_sc_hd__a31o_4 abstract view
.subckt sky130_fd_sc_hd__a31o_4 A1 A2 A3 B1 VGND VNB VPB VPWR X
.ends

* Black-box entry subcircuit for sky130_fd_sc_hd__a211o_4 abstract view
.subckt sky130_fd_sc_hd__a211o_4 A1 A2 B1 C1 VGND VNB VPB VPWR X
.ends

* Black-box entry subcircuit for sky130_fd_sc_hd__or2_4 abstract view
.subckt sky130_fd_sc_hd__or2_4 A B VGND VNB VPB VPWR X
.ends

* Black-box entry subcircuit for sky130_fd_sc_hd__clkbuf_4 abstract view
.subckt sky130_fd_sc_hd__clkbuf_4 A VGND VNB VPB VPWR X
.ends

* Black-box entry subcircuit for sky130_fd_sc_hd__o31a_2 abstract view
.subckt sky130_fd_sc_hd__o31a_2 A1 A2 A3 B1 VGND VNB VPB VPWR X
.ends

* Black-box entry subcircuit for sky130_fd_sc_hd__o22a_2 abstract view
.subckt sky130_fd_sc_hd__o22a_2 A1 A2 B1 B2 VGND VNB VPB VPWR X
.ends

* Black-box entry subcircuit for sky130_fd_sc_hd__a2111o_2 abstract view
.subckt sky130_fd_sc_hd__a2111o_2 A1 A2 B1 C1 D1 VGND VNB VPB VPWR X
.ends

* Black-box entry subcircuit for sky130_fd_sc_hd__buf_4 abstract view
.subckt sky130_fd_sc_hd__buf_4 A VGND VNB VPB VPWR X
.ends

* Black-box entry subcircuit for sky130_fd_sc_hd__or3b_2 abstract view
.subckt sky130_fd_sc_hd__or3b_2 A B C_N VGND VNB VPB VPWR X
.ends

* Black-box entry subcircuit for sky130_fd_sc_hd__nand3_4 abstract view
.subckt sky130_fd_sc_hd__nand3_4 A B C VGND VNB VPB VPWR Y
.ends

* Black-box entry subcircuit for sky130_fd_sc_hd__a31oi_2 abstract view
.subckt sky130_fd_sc_hd__a31oi_2 A1 A2 A3 B1 VGND VNB VPB VPWR Y
.ends

* Black-box entry subcircuit for sky130_fd_sc_hd__o21ai_4 abstract view
.subckt sky130_fd_sc_hd__o21ai_4 A1 A2 B1 VGND VNB VPB VPWR Y
.ends

* Black-box entry subcircuit for sky130_fd_sc_hd__a311o_2 abstract view
.subckt sky130_fd_sc_hd__a311o_2 A1 A2 A3 B1 C1 VGND VNB VPB VPWR X
.ends

* Black-box entry subcircuit for sky130_fd_sc_hd__nor2_4 abstract view
.subckt sky130_fd_sc_hd__nor2_4 A B VGND VNB VPB VPWR Y
.ends

* Black-box entry subcircuit for sky130_fd_sc_hd__a32oi_2 abstract view
.subckt sky130_fd_sc_hd__a32oi_2 A1 A2 A3 B1 B2 VGND VNB VPB VPWR Y
.ends

* Black-box entry subcircuit for sky130_fd_sc_hd__a211o_2 abstract view
.subckt sky130_fd_sc_hd__a211o_2 A1 A2 B1 C1 VGND VNB VPB VPWR X
.ends

* Black-box entry subcircuit for sky130_fd_sc_hd__o31ai_2 abstract view
.subckt sky130_fd_sc_hd__o31ai_2 A1 A2 A3 B1 VGND VNB VPB VPWR Y
.ends

* Black-box entry subcircuit for sky130_fd_sc_hd__a211oi_2 abstract view
.subckt sky130_fd_sc_hd__a211oi_2 A1 A2 B1 C1 VGND VNB VPB VPWR Y
.ends

* Black-box entry subcircuit for sky130_fd_sc_hd__nor3b_2 abstract view
.subckt sky130_fd_sc_hd__nor3b_2 A B C_N VGND VNB VPB VPWR Y
.ends

* Black-box entry subcircuit for sky130_fd_sc_hd__inv_4 abstract view
.subckt sky130_fd_sc_hd__inv_4 A VGND VNB VPB VPWR Y
.ends

* Black-box entry subcircuit for sky130_fd_sc_hd__nand4_2 abstract view
.subckt sky130_fd_sc_hd__nand4_2 A B C D VGND VNB VPB VPWR Y
.ends

* Black-box entry subcircuit for sky130_fd_sc_hd__o32a_2 abstract view
.subckt sky130_fd_sc_hd__o32a_2 A1 A2 A3 B1 B2 VGND VNB VPB VPWR X
.ends

* Black-box entry subcircuit for sky130_fd_sc_hd__nand2_4 abstract view
.subckt sky130_fd_sc_hd__nand2_4 A B VGND VNB VPB VPWR Y
.ends

* Black-box entry subcircuit for sky130_fd_sc_hd__a21oi_4 abstract view
.subckt sky130_fd_sc_hd__a21oi_4 A1 A2 B1 VGND VNB VPB VPWR Y
.ends

* Black-box entry subcircuit for sky130_fd_sc_hd__o22ai_2 abstract view
.subckt sky130_fd_sc_hd__o22ai_2 A1 A2 B1 B2 VGND VNB VPB VPWR Y
.ends

* Black-box entry subcircuit for sky130_fd_sc_hd__and3_4 abstract view
.subckt sky130_fd_sc_hd__and3_4 A B C VGND VNB VPB VPWR X
.ends

* Black-box entry subcircuit for sky130_fd_sc_hd__clkbuf_2 abstract view
.subckt sky130_fd_sc_hd__clkbuf_2 A VGND VNB VPB VPWR X
.ends

* Black-box entry subcircuit for sky130_fd_sc_hd__o21ba_4 abstract view
.subckt sky130_fd_sc_hd__o21ba_4 A1 A2 B1_N VGND VNB VPB VPWR X
.ends

* Black-box entry subcircuit for sky130_fd_sc_hd__a2bb2o_2 abstract view
.subckt sky130_fd_sc_hd__a2bb2o_2 A1_N A2_N B1 B2 VGND VNB VPB VPWR X
.ends

* Black-box entry subcircuit for sky130_fd_sc_hd__and4bb_2 abstract view
.subckt sky130_fd_sc_hd__and4bb_2 A_N B_N C D VGND VNB VPB VPWR X
.ends

* Black-box entry subcircuit for sky130_fd_sc_hd__a21bo_4 abstract view
.subckt sky130_fd_sc_hd__a21bo_4 A1 A2 B1_N VGND VNB VPB VPWR X
.ends

* Black-box entry subcircuit for sky130_fd_sc_hd__nand2b_4 abstract view
.subckt sky130_fd_sc_hd__nand2b_4 A_N B VGND VNB VPB VPWR Y
.ends

* Black-box entry subcircuit for sky130_fd_sc_hd__dlymetal6s2s_1 abstract view
.subckt sky130_fd_sc_hd__dlymetal6s2s_1 A VGND VNB VPB VPWR X
.ends

* Black-box entry subcircuit for sky130_fd_sc_hd__or4bb_4 abstract view
.subckt sky130_fd_sc_hd__or4bb_4 A B C_N D_N VGND VNB VPB VPWR X
.ends

* Black-box entry subcircuit for sky130_fd_sc_hd__o21a_4 abstract view
.subckt sky130_fd_sc_hd__o21a_4 A1 A2 B1 VGND VNB VPB VPWR X
.ends

* Black-box entry subcircuit for sky130_fd_sc_hd__o211ai_2 abstract view
.subckt sky130_fd_sc_hd__o211ai_2 A1 A2 B1 C1 VGND VNB VPB VPWR Y
.ends

* Black-box entry subcircuit for sky130_fd_sc_hd__dlymetal6s4s_1 abstract view
.subckt sky130_fd_sc_hd__dlymetal6s4s_1 A VGND VNB VPB VPWR X
.ends

* Black-box entry subcircuit for sky130_fd_sc_hd__buf_1 abstract view
.subckt sky130_fd_sc_hd__buf_1 A VGND VNB VPB VPWR X
.ends

* Black-box entry subcircuit for sky130_fd_sc_hd__clkbuf_16 abstract view
.subckt sky130_fd_sc_hd__clkbuf_16 A VGND VNB VPB VPWR X
.ends

* Black-box entry subcircuit for sky130_fd_sc_hd__and2_4 abstract view
.subckt sky130_fd_sc_hd__and2_4 A B VGND VNB VPB VPWR X
.ends

* Black-box entry subcircuit for sky130_fd_sc_hd__or4_4 abstract view
.subckt sky130_fd_sc_hd__or4_4 A B C D VGND VNB VPB VPWR X
.ends

* Black-box entry subcircuit for sky130_fd_sc_hd__conb_1 abstract view
.subckt sky130_fd_sc_hd__conb_1 VGND VNB VPB VPWR HI LO
.ends

* Black-box entry subcircuit for sky130_fd_sc_hd__or3_4 abstract view
.subckt sky130_fd_sc_hd__or3_4 A B C VGND VNB VPB VPWR X
.ends

* Black-box entry subcircuit for sky130_fd_sc_hd__and3b_2 abstract view
.subckt sky130_fd_sc_hd__and3b_2 A_N B C VGND VNB VPB VPWR X
.ends

* Black-box entry subcircuit for sky130_fd_sc_hd__o221ai_2 abstract view
.subckt sky130_fd_sc_hd__o221ai_2 A1 A2 B1 B2 C1 VGND VNB VPB VPWR Y
.ends

* Black-box entry subcircuit for sky130_fd_sc_hd__o311a_2 abstract view
.subckt sky130_fd_sc_hd__o311a_2 A1 A2 A3 B1 C1 VGND VNB VPB VPWR X
.ends

* Black-box entry subcircuit for sky130_fd_sc_hd__a41o_2 abstract view
.subckt sky130_fd_sc_hd__a41o_2 A1 A2 A3 A4 B1 VGND VNB VPB VPWR X
.ends

* Black-box entry subcircuit for sky130_fd_sc_hd__o22ai_4 abstract view
.subckt sky130_fd_sc_hd__o22ai_4 A1 A2 B1 B2 VGND VNB VPB VPWR Y
.ends

* Black-box entry subcircuit for sky130_fd_sc_hd__a211oi_4 abstract view
.subckt sky130_fd_sc_hd__a211oi_4 A1 A2 B1 C1 VGND VNB VPB VPWR Y
.ends

* Black-box entry subcircuit for sky130_fd_sc_hd__a21boi_2 abstract view
.subckt sky130_fd_sc_hd__a21boi_2 A1 A2 B1_N VGND VNB VPB VPWR Y
.ends

* Black-box entry subcircuit for sky130_fd_sc_hd__a2bb2oi_2 abstract view
.subckt sky130_fd_sc_hd__a2bb2oi_2 A1_N A2_N B1 B2 VGND VNB VPB VPWR Y
.ends

* Black-box entry subcircuit for sky130_fd_sc_hd__o2bb2a_4 abstract view
.subckt sky130_fd_sc_hd__o2bb2a_4 A1_N A2_N B1 B2 VGND VNB VPB VPWR X
.ends

* Black-box entry subcircuit for sky130_fd_sc_hd__o41a_2 abstract view
.subckt sky130_fd_sc_hd__o41a_2 A1 A2 A3 A4 B1 VGND VNB VPB VPWR X
.ends

* Black-box entry subcircuit for sky130_fd_sc_hd__or4_2 abstract view
.subckt sky130_fd_sc_hd__or4_2 A B C D VGND VNB VPB VPWR X
.ends

* Black-box entry subcircuit for sky130_fd_sc_hd__or4bb_2 abstract view
.subckt sky130_fd_sc_hd__or4bb_2 A B C_N D_N VGND VNB VPB VPWR X
.ends

* Black-box entry subcircuit for sky130_fd_sc_hd__nor4_2 abstract view
.subckt sky130_fd_sc_hd__nor4_2 A B C D VGND VNB VPB VPWR Y
.ends

* Black-box entry subcircuit for sky130_fd_sc_hd__nand3b_2 abstract view
.subckt sky130_fd_sc_hd__nand3b_2 A_N B C VGND VNB VPB VPWR Y
.ends

* Black-box entry subcircuit for sky130_fd_sc_hd__nand4_4 abstract view
.subckt sky130_fd_sc_hd__nand4_4 A B C D VGND VNB VPB VPWR Y
.ends

* Black-box entry subcircuit for sky130_fd_sc_hd__nor3_4 abstract view
.subckt sky130_fd_sc_hd__nor3_4 A B C VGND VNB VPB VPWR Y
.ends

* Black-box entry subcircuit for sky130_fd_sc_hd__or3b_4 abstract view
.subckt sky130_fd_sc_hd__or3b_4 A B C_N VGND VNB VPB VPWR X
.ends

* Black-box entry subcircuit for sky130_fd_sc_hd__o41ai_2 abstract view
.subckt sky130_fd_sc_hd__o41ai_2 A1 A2 A3 A4 B1 VGND VNB VPB VPWR Y
.ends

* Black-box entry subcircuit for sky130_fd_sc_hd__mux2_2 abstract view
.subckt sky130_fd_sc_hd__mux2_2 A0 A1 S VGND VNB VPB VPWR X
.ends

* Black-box entry subcircuit for sky130_fd_sc_hd__a2bb2o_4 abstract view
.subckt sky130_fd_sc_hd__a2bb2o_4 A1_N A2_N B1 B2 VGND VNB VPB VPWR X
.ends

* Black-box entry subcircuit for sky130_fd_sc_hd__o311ai_4 abstract view
.subckt sky130_fd_sc_hd__o311ai_4 A1 A2 A3 B1 C1 VGND VNB VPB VPWR Y
.ends

* Black-box entry subcircuit for sky130_fd_sc_hd__nand2_8 abstract view
.subckt sky130_fd_sc_hd__nand2_8 A B VGND VNB VPB VPWR Y
.ends

* Black-box entry subcircuit for sky130_fd_sc_hd__dfstp_2 abstract view
.subckt sky130_fd_sc_hd__dfstp_2 CLK D SET_B VGND VNB VPB VPWR Q
.ends

* Black-box entry subcircuit for sky130_fd_sc_hd__o2bb2ai_2 abstract view
.subckt sky130_fd_sc_hd__o2bb2ai_2 A1_N A2_N B1 B2 VGND VNB VPB VPWR Y
.ends

* Black-box entry subcircuit for sky130_fd_sc_hd__o311a_4 abstract view
.subckt sky130_fd_sc_hd__o311a_4 A1 A2 A3 B1 C1 VGND VNB VPB VPWR X
.ends

.subckt team_03 clk en gpio_in[0] gpio_in[10] gpio_in[11] gpio_in[12] gpio_in[13]
+ gpio_in[14] gpio_in[15] gpio_in[16] gpio_in[17] gpio_in[18] gpio_in[19] gpio_in[1]
+ gpio_in[20] gpio_in[21] gpio_in[22] gpio_in[23] gpio_in[24] gpio_in[25] gpio_in[26]
+ gpio_in[27] gpio_in[28] gpio_in[29] gpio_in[2] gpio_in[30] gpio_in[31] gpio_in[32]
+ gpio_in[33] gpio_in[3] gpio_in[4] gpio_in[5] gpio_in[6] gpio_in[7] gpio_in[8] gpio_in[9]
+ gpio_oeb[0] gpio_oeb[10] gpio_oeb[11] gpio_oeb[12] gpio_oeb[13] gpio_oeb[14] gpio_oeb[15]
+ gpio_oeb[16] gpio_oeb[17] gpio_oeb[18] gpio_oeb[19] gpio_oeb[1] gpio_oeb[20] gpio_oeb[21]
+ gpio_oeb[22] gpio_oeb[23] gpio_oeb[24] gpio_oeb[25] gpio_oeb[26] gpio_oeb[27] gpio_oeb[28]
+ gpio_oeb[29] gpio_oeb[2] gpio_oeb[30] gpio_oeb[31] gpio_oeb[32] gpio_oeb[33] gpio_oeb[3]
+ gpio_oeb[4] gpio_oeb[5] gpio_oeb[6] gpio_oeb[7] gpio_oeb[8] gpio_oeb[9] gpio_out[0]
+ gpio_out[10] gpio_out[11] gpio_out[12] gpio_out[13] gpio_out[14] gpio_out[15] gpio_out[16]
+ gpio_out[17] gpio_out[18] gpio_out[19] gpio_out[1] gpio_out[20] gpio_out[21] gpio_out[22]
+ gpio_out[23] gpio_out[24] gpio_out[25] gpio_out[26] gpio_out[27] gpio_out[28] gpio_out[29]
+ gpio_out[2] gpio_out[30] gpio_out[31] gpio_out[32] gpio_out[33] gpio_out[3] gpio_out[4]
+ gpio_out[5] gpio_out[6] gpio_out[7] gpio_out[8] gpio_out[9] nrst vccd1 vssd1
XANTENNA__4654__B _4709_/B vssd1 vssd1 vccd1 vccd1 sky130_fd_sc_hd__diode_2
XFILLER_54_225 vssd1 vssd1 vccd1 vccd1 sky130_fd_sc_hd__fill_1
X_7963_ _7963_/A _7963_/B vssd1 vssd1 vccd1 vccd1 _7975_/A sky130_fd_sc_hd__nor2_2
XANTENNA__8126__B _8126_/B vssd1 vssd1 vccd1 vccd1 sky130_fd_sc_hd__diode_2
X_6914_ _7152_/B _6914_/B vssd1 vssd1 vccd1 vccd1 _6916_/A sky130_fd_sc_hd__nand2_2
X_7894_ _7897_/D vssd1 vssd1 vccd1 vccd1 _7894_/Y sky130_fd_sc_hd__inv_2
XANTENNA__6917__B1 _7875_/D vssd1 vssd1 vccd1 vccd1 sky130_fd_sc_hd__diode_2
XFILLER_52_29 vssd1 vssd1 vccd1 vccd1 sky130_fd_sc_hd__fill_8
X_6845_ _6846_/A _6846_/B _6846_/C vssd1 vssd1 vccd1 vccd1 _6946_/A sky130_fd_sc_hd__a21o_2
X_6776_ _6776_/A _6776_/B vssd1 vssd1 vccd1 vccd1 _6778_/B sky130_fd_sc_hd__xnor2_2
XANTENNA__5485__B _5657_/B vssd1 vssd1 vccd1 vccd1 sky130_fd_sc_hd__diode_2
X_5727_ _6091_/A _6582_/B vssd1 vssd1 vccd1 vccd1 _5728_/B sky130_fd_sc_hd__nand2_2
X_8446_ clkload1/A _8446_/D load_slew366/X vssd1 vssd1 vccd1 vccd1 _8446_/Q sky130_fd_sc_hd__dfrtp_2
X_5658_ _8165_/A _5670_/B _5669_/C vssd1 vssd1 vccd1 vccd1 _5659_/C sky130_fd_sc_hd__and3_2
XANTENNA__7893__B2 _7998_/B vssd1 vssd1 vccd1 vccd1 sky130_fd_sc_hd__diode_2
X_8377_ clkload9/A _8377_/D fanout372/X vssd1 vssd1 vccd1 vccd1 _8377_/Q sky130_fd_sc_hd__dfrtp_2
X_5589_ _5590_/A _5590_/B vssd1 vssd1 vccd1 vccd1 _5593_/A sky130_fd_sc_hd__nand2b_2
X_4609_ _4610_/A _4610_/B vssd1 vssd1 vccd1 vccd1 _4609_/Y sky130_fd_sc_hd__nor2_2
X_7328_ _7329_/A _7329_/B vssd1 vssd1 vccd1 vccd1 _7328_/Y sky130_fd_sc_hd__nand2b_2
X_7259_ _7480_/B _7259_/B vssd1 vssd1 vccd1 vccd1 _7261_/C sky130_fd_sc_hd__or2_2
XFILLER_58_542 vssd1 vssd1 vccd1 vccd1 sky130_fd_sc_hd__fill_1
XTAP_TAPCELL_ROW_56_765 vssd1 vccd1 sky130_fd_sc_hd__tapvpwrvgnd_1
XFILLER_60_217 vssd1 vssd1 vccd1 vccd1 sky130_fd_sc_hd__fill_8
XTAP_TAPCELL_ROW_28_478 vssd1 vccd1 sky130_fd_sc_hd__tapvpwrvgnd_1
XFILLER_42_62 vssd1 vssd1 vccd1 vccd1 sky130_fd_sc_hd__fill_2
XTAP_TAPCELL_ROW_11_312 vssd1 vccd1 sky130_fd_sc_hd__tapvpwrvgnd_1
XANTENNA__7891__A _8110_/B vssd1 vssd1 vccd1 vccd1 sky130_fd_sc_hd__diode_2
Xrebuffer492 _4488_/A vssd1 vssd1 vccd1 vccd1 _4789_/B1 sky130_fd_sc_hd__buf_2
Xrebuffer481 _4728_/X vssd1 vssd1 vccd1 vccd1 _4733_/A sky130_fd_sc_hd__buf_2
Xrebuffer470 _4667_/A vssd1 vssd1 vccd1 vccd1 _4649_/A sky130_fd_sc_hd__buf_2
XPHY_EDGE_ROW_39_Left_132 vssd1 vssd1 vccd1 vccd1 sky130_fd_sc_hd__decap_3
XANTENNA__5842__C _6238_/B vssd1 vssd1 vccd1 vccd1 sky130_fd_sc_hd__diode_2
XFILLER_5_376 vssd1 vssd1 vccd1 vccd1 sky130_fd_sc_hd__fill_1
XFILLER_68_306 vssd1 vssd1 vccd1 vccd1 sky130_fd_sc_hd__fill_2
XANTENNA__8227__A _8228_/A vssd1 vssd1 vccd1 vccd1 sky130_fd_sc_hd__diode_2
XFILLER_76_350 vssd1 vssd1 vccd1 vccd1 sky130_fd_sc_hd__fill_4
XANTENNA__7131__A _7131_/A vssd1 vssd1 vccd1 vccd1 sky130_fd_sc_hd__diode_2
XPHY_EDGE_ROW_48_Left_141 vssd1 vssd1 vccd1 vccd1 sky130_fd_sc_hd__decap_3
XANTENNA__8407__RESET_B load_slew358/X vssd1 vssd1 vccd1 vccd1 sky130_fd_sc_hd__diode_2
XFILLER_64_556 vssd1 vssd1 vccd1 vccd1 sky130_fd_sc_hd__fill_1
XANTENNA__6970__A _6970_/A vssd1 vssd1 vccd1 vccd1 sky130_fd_sc_hd__diode_2
X_4960_ _5037_/B vssd1 vssd1 vccd1 vccd1 _4962_/A sky130_fd_sc_hd__inv_2
XFILLER_44_291 vssd1 vssd1 vccd1 vccd1 sky130_fd_sc_hd__fill_1
X_4891_ _4891_/A _4891_/B vssd1 vssd1 vccd1 vccd1 _4906_/A sky130_fd_sc_hd__nand2_2
XFILLER_32_453 vssd1 vssd1 vccd1 vccd1 sky130_fd_sc_hd__fill_1
XFILLER_32_475 vssd1 vssd1 vccd1 vccd1 sky130_fd_sc_hd__fill_1
X_6630_ _7603_/A _6631_/B vssd1 vssd1 vccd1 vccd1 _6632_/B sky130_fd_sc_hd__nor2_2
X_6561_ _6474_/A _6474_/B _6472_/A vssd1 vssd1 vccd1 vccd1 _6563_/B sky130_fd_sc_hd__a21oi_2
XANTENNA__8116__A2 _8126_/B vssd1 vssd1 vccd1 vccd1 sky130_fd_sc_hd__diode_2
X_8300_ _6207_/A input7/X _8303_/S vssd1 vssd1 vccd1 vccd1 _8375_/D sky130_fd_sc_hd__mux2_1
X_5512_ _5512_/A _5512_/B vssd1 vssd1 vccd1 vccd1 _5692_/A sky130_fd_sc_hd__and2_2
X_6492_ _6492_/A _6492_/B vssd1 vssd1 vccd1 vccd1 _6494_/A sky130_fd_sc_hd__nor2_2
XPHY_EDGE_ROW_57_Left_150 vssd1 vssd1 vccd1 vccd1 sky130_fd_sc_hd__decap_3
XANTENNA__4689__A1 _4709_/B vssd1 vssd1 vccd1 vccd1 sky130_fd_sc_hd__diode_2
X_8231_ _8228_/A _8230_/Y _8259_/A vssd1 vssd1 vccd1 vccd1 _8346_/D sky130_fd_sc_hd__mux2_1
X_5443_ _5438_/A _5438_/C _5438_/B vssd1 vssd1 vccd1 vccd1 _5444_/B sky130_fd_sc_hd__a21oi_2
X_8162_ _8161_/B _8161_/A _6689_/A vssd1 vssd1 vccd1 vccd1 _8162_/X sky130_fd_sc_hd__a21o_2
X_5374_ _5375_/A _5375_/B vssd1 vssd1 vccd1 vccd1 _5380_/A sky130_fd_sc_hd__or2_2
XANTENNA__4649__B _4686_/B vssd1 vssd1 vccd1 vccd1 sky130_fd_sc_hd__diode_2
X_7113_ _7114_/B _7114_/A vssd1 vssd1 vccd1 vccd1 _7352_/B sky130_fd_sc_hd__nand2b_2
X_4325_ _4325_/A _4325_/B vssd1 vssd1 vccd1 vccd1 _4325_/Y sky130_fd_sc_hd__xnor2_2
X_8093_ _8093_/A _8093_/B vssd1 vssd1 vccd1 vccd1 _8094_/B sky130_fd_sc_hd__xnor2_2
Xfanout116 _4366_/X vssd1 vssd1 vccd1 vccd1 _4704_/B sky130_fd_sc_hd__clkdlybuf4s25_1
Xfanout127 _7098_/A vssd1 vssd1 vccd1 vccd1 _8409_/D sky130_fd_sc_hd__clkdlybuf4s25_1
Xfanout138 _8427_/D vssd1 vssd1 vccd1 vccd1 _4623_/A sky130_fd_sc_hd__buf_8
XFILLER_86_125 vssd1 vssd1 vccd1 vccd1 sky130_fd_sc_hd__fill_1
Xfanout149 _4360_/X vssd1 vssd1 vccd1 vccd1 _4780_/B sky130_fd_sc_hd__clkdlybuf4s25_1
X_7044_ _7045_/A _7045_/B vssd1 vssd1 vccd1 vccd1 _7046_/B sky130_fd_sc_hd__or2_2
X_4256_ _8385_/Q _8444_/Q vssd1 vssd1 vccd1 vccd1 _4257_/B sky130_fd_sc_hd__or2_2
XFILLER_74_309 vssd1 vssd1 vccd1 vccd1 sky130_fd_sc_hd__fill_2
X_4187_ _8437_/Q _8254_/B _8398_/D vssd1 vssd1 vccd1 vccd1 _4187_/X sky130_fd_sc_hd__mux2_4
XANTENNA__7041__A _7042_/A vssd1 vssd1 vccd1 vccd1 sky130_fd_sc_hd__diode_2
XFILLER_55_512 vssd1 vssd1 vccd1 vccd1 sky130_fd_sc_hd__fill_4
XANTENNA_fanout165_X _8422_/D vssd1 vssd1 vccd1 vccd1 sky130_fd_sc_hd__diode_2
XFILLER_82_386 vssd1 vssd1 vccd1 vccd1 sky130_fd_sc_hd__fill_4
X_7946_ _7686_/B _7947_/B _7947_/A vssd1 vssd1 vccd1 vccd1 _7946_/Y sky130_fd_sc_hd__a21oi_2
XFILLER_70_548 vssd1 vssd1 vccd1 vccd1 sky130_fd_sc_hd__fill_1
X_7877_ _7875_/X _7877_/B _8125_/A _7877_/D vssd1 vssd1 vccd1 vccd1 _7878_/B sky130_fd_sc_hd__and4b_2
XTAP_TAPCELL_ROW_81_1012 vssd1 vccd1 sky130_fd_sc_hd__tapvpwrvgnd_1
XTAP_TAPCELL_ROW_53_735 vssd1 vccd1 sky130_fd_sc_hd__tapvpwrvgnd_1
XTAP_TAPCELL_ROW_25_448 vssd1 vccd1 sky130_fd_sc_hd__tapvpwrvgnd_1
X_6828_ _6828_/A _6828_/B vssd1 vssd1 vccd1 vccd1 _6852_/A sky130_fd_sc_hd__xor2_2
X_6759_ _6759_/A _6759_/B vssd1 vssd1 vccd1 vccd1 _6761_/B sky130_fd_sc_hd__xor2_2
X_8429_ clkload6/A _8429_/D load_slew360/X vssd1 vssd1 vccd1 vccd1 _8429_/Q sky130_fd_sc_hd__dfrtp_2
XFILLER_88_69 vssd1 vssd1 vccd1 vccd1 sky130_fd_sc_hd__fill_2
XTAP_TAPCELL_ROW_92_1130 vssd1 vccd1 sky130_fd_sc_hd__tapvpwrvgnd_1
XANTENNA__8291__A1 _8179_/B vssd1 vssd1 vccd1 vccd1 sky130_fd_sc_hd__diode_2
XANTENNA_fanout78_X _6738_/B vssd1 vssd1 vccd1 vccd1 sky130_fd_sc_hd__diode_2
XFILLER_77_169 vssd1 vssd1 vccd1 vccd1 sky130_fd_sc_hd__fill_8
XFILLER_58_372 vssd1 vssd1 vccd1 vccd1 sky130_fd_sc_hd__fill_1
XFILLER_73_320 vssd1 vssd1 vccd1 vccd1 sky130_fd_sc_hd__fill_1
XTAP_TAPCELL_ROW_69_890 vssd1 vccd1 sky130_fd_sc_hd__tapvpwrvgnd_1
XFILLER_92_128 vssd1 vccd1 vssd1 vccd1 sky130_ef_sc_hd__decap_40_12
XANTENNA__4294__B _5163_/C vssd1 vssd1 vccd1 vccd1 sky130_fd_sc_hd__diode_2
XFILLER_85_191 vssd1 vssd1 vccd1 vccd1 sky130_fd_sc_hd__fill_1
XFILLER_53_50 vssd1 vssd1 vccd1 vccd1 sky130_fd_sc_hd__fill_4
XFILLER_41_283 vssd1 vssd1 vccd1 vccd1 sky130_fd_sc_hd__fill_1
XANTENNA__8352__CLK _8405_/CLK vssd1 vssd1 vccd1 vccd1 sky130_fd_sc_hd__diode_2
XANTENNA__7609__A1 _7969_/A vssd1 vssd1 vccd1 vccd1 sky130_fd_sc_hd__diode_2
XFILLER_68_136 vssd1 vssd1 vccd1 vccd1 sky130_fd_sc_hd__fill_4
X_5090_ _5096_/A _5096_/B vssd1 vssd1 vccd1 vccd1 _5090_/Y sky130_fd_sc_hd__nand2b_2
XFILLER_83_117 vssd1 vssd1 vccd1 vccd1 sky130_fd_sc_hd__fill_2
X_7800_ _7799_/A _7799_/B _6689_/A vssd1 vssd1 vccd1 vccd1 _7800_/X sky130_fd_sc_hd__a21o_2
X_5992_ _5994_/A _5994_/B vssd1 vssd1 vccd1 vccd1 _5992_/X sky130_fd_sc_hd__and2b_2
XFILLER_17_291 vssd1 vssd1 vccd1 vccd1 sky130_fd_sc_hd__fill_1
X_7731_ _7731_/A _7731_/B _7731_/C vssd1 vssd1 vccd1 vccd1 _7743_/B sky130_fd_sc_hd__nand3_2
X_4943_ _4943_/A _4943_/B vssd1 vssd1 vccd1 vccd1 _4944_/A sky130_fd_sc_hd__xor2_2
X_7662_ _7662_/A _7662_/B vssd1 vssd1 vccd1 vccd1 _7710_/A sky130_fd_sc_hd__nand2_2
XTAP_TAPCELL_ROW_50_705 vssd1 vccd1 sky130_fd_sc_hd__tapvpwrvgnd_1
X_6613_ _7304_/A _8081_/B vssd1 vssd1 vccd1 vccd1 _6973_/A sky130_fd_sc_hd__nor2_2
X_4874_ _4799_/X _4801_/X _4875_/A2 _4873_/X vssd1 vssd1 vccd1 vccd1 _4874_/X sky130_fd_sc_hd__o211a_2
XTAP_TAPCELL_ROW_22_418 vssd1 vccd1 sky130_fd_sc_hd__tapvpwrvgnd_1
X_7593_ _7594_/A _7594_/B _7594_/C vssd1 vssd1 vccd1 vccd1 _7595_/A sky130_fd_sc_hd__o21ai_2
Xclkbuf_4_12_0_clk clkbuf_0_clk/X vssd1 vssd1 vccd1 vccd1 _8402_/CLK sky130_fd_sc_hd__clkbuf_8
X_6544_ _6545_/A _6545_/B _6545_/C vssd1 vssd1 vccd1 vccd1 _6869_/A sky130_fd_sc_hd__a21oi_2
X_6475_ _6476_/A _6476_/B vssd1 vssd1 vccd1 vccd1 _6475_/X sky130_fd_sc_hd__and2_2
X_8214_ _8215_/A input4/X vssd1 vssd1 vccd1 vccd1 _8223_/A sky130_fd_sc_hd__and2_2
X_5426_ _5426_/A _5426_/B vssd1 vssd1 vccd1 vccd1 _5435_/A sky130_fd_sc_hd__xor2_2
XFILLER_87_412 vssd1 vssd1 vccd1 vccd1 sky130_fd_sc_hd__fill_2
X_8145_ _8145_/A _8145_/B vssd1 vssd1 vccd1 vccd1 _8146_/B sky130_fd_sc_hd__xnor2_2
X_5357_ _5445_/B _5445_/A vssd1 vssd1 vccd1 vccd1 _5375_/A sky130_fd_sc_hd__nand2b_2
X_8076_ _7680_/Y _8085_/A _7957_/Y _7959_/B vssd1 vssd1 vccd1 vccd1 _8078_/A sky130_fd_sc_hd__a22o_2
X_5288_ _5286_/X _5288_/B vssd1 vssd1 vccd1 vccd1 _5291_/A sky130_fd_sc_hd__and2b_2
X_4308_ _4761_/A _5710_/B _5710_/C _5954_/B _4623_/A vssd1 vssd1 vccd1 vccd1 _4308_/X
+ sky130_fd_sc_hd__a32o_2
XANTENNA_fanout282_X _7897_/B vssd1 vssd1 vccd1 vccd1 sky130_fd_sc_hd__diode_2
XFILLER_59_169 vssd1 vssd1 vccd1 vccd1 sky130_fd_sc_hd__fill_4
X_7027_ _7027_/A _7027_/B vssd1 vssd1 vccd1 vccd1 _7029_/B sky130_fd_sc_hd__nor2_2
X_4239_ _8379_/Q _8438_/Q _4362_/B _4236_/X vssd1 vssd1 vccd1 vccd1 _4366_/B sky130_fd_sc_hd__a31o_2
XFILLER_28_512 vssd1 vssd1 vccd1 vccd1 sky130_fd_sc_hd__fill_2
XANTENNA__6036__B1 _6035_/D vssd1 vssd1 vccd1 vccd1 sky130_fd_sc_hd__diode_2
XFILLER_28_567 vssd1 vssd1 vccd1 vccd1 sky130_fd_sc_hd__fill_1
XFILLER_43_515 vssd1 vssd1 vccd1 vccd1 sky130_fd_sc_hd__fill_1
XFILLER_82_150 vssd1 vssd1 vccd1 vccd1 sky130_fd_sc_hd__fill_8
XTAP_TAPCELL_ROW_66_860 vssd1 vccd1 sky130_fd_sc_hd__tapvpwrvgnd_1
XFILLER_15_239 vssd1 vssd1 vccd1 vccd1 sky130_fd_sc_hd__fill_4
X_7929_ _7929_/A _7929_/B vssd1 vssd1 vccd1 vccd1 _7931_/C sky130_fd_sc_hd__xnor2_2
XTAP_TAPCELL_ROW_38_584 vssd1 vccd1 sky130_fd_sc_hd__tapvpwrvgnd_1
XANTENNA__7536__B1 _7864_/B vssd1 vssd1 vccd1 vccd1 sky130_fd_sc_hd__diode_2
XFILLER_23_20 vssd1 vssd1 vccd1 vccd1 sky130_fd_sc_hd__fill_2
XFILLER_23_283 vssd1 vssd1 vccd1 vccd1 sky130_fd_sc_hd__fill_1
XFILLER_11_467 vssd1 vssd1 vccd1 vccd1 sky130_fd_sc_hd__fill_4
XFILLER_11_489 vssd1 vssd1 vccd1 vccd1 sky130_fd_sc_hd__fill_2
XFILLER_38_309 vssd1 vssd1 vccd1 vccd1 sky130_fd_sc_hd__fill_1
XFILLER_19_512 vssd1 vccd1 vssd1 vccd1 sky130_ef_sc_hd__decap_40_12
XANTENNA_input10_X _8254_/B vssd1 vssd1 vccd1 vccd1 sky130_fd_sc_hd__diode_2
XFILLER_0_57 vssd1 vssd1 vccd1 vccd1 sky130_fd_sc_hd__fill_2
XFILLER_61_345 vssd1 vssd1 vccd1 vccd1 sky130_fd_sc_hd__fill_2
XFILLER_73_194 vssd1 vssd1 vccd1 vccd1 sky130_fd_sc_hd__fill_2
XANTENNA__8240__A _8241_/A vssd1 vssd1 vccd1 vccd1 sky130_fd_sc_hd__diode_2
X_4590_ _4590_/A _4590_/B vssd1 vssd1 vccd1 vccd1 _4616_/B sky130_fd_sc_hd__xnor2_4
XFILLER_9_99 vssd1 vssd1 vccd1 vccd1 sky130_fd_sc_hd__fill_4
XANTENNA__5583__B _5826_/A vssd1 vssd1 vccd1 vccd1 sky130_fd_sc_hd__diode_2
XANTENNA__5305__A2 _6016_/A vssd1 vssd1 vccd1 vccd1 sky130_fd_sc_hd__diode_2
X_6260_ _6260_/A _6260_/B vssd1 vssd1 vccd1 vccd1 _6262_/C sky130_fd_sc_hd__nor2_2
X_6191_ _5990_/A _5990_/B _5919_/X vssd1 vssd1 vccd1 vccd1 _6193_/B sky130_fd_sc_hd__o21ba_2
X_5211_ _5209_/X _5211_/B vssd1 vssd1 vccd1 vccd1 _5301_/A sky130_fd_sc_hd__and2b_2
X_5142_ _5142_/A _5142_/B vssd1 vssd1 vccd1 vccd1 _5144_/C sky130_fd_sc_hd__xnor2_2
XFILLER_69_456 vssd1 vssd1 vccd1 vccd1 sky130_fd_sc_hd__fill_1
XFILLER_56_128 vssd1 vssd1 vccd1 vccd1 sky130_fd_sc_hd__fill_1
X_5073_ _5073_/A _5073_/B vssd1 vssd1 vccd1 vccd1 _5079_/A sky130_fd_sc_hd__xnor2_2
XFILLER_25_526 vssd1 vssd1 vccd1 vccd1 sky130_fd_sc_hd__fill_2
XFILLER_52_323 vssd1 vssd1 vccd1 vccd1 sky130_fd_sc_hd__fill_1
XTAP_TAPCELL_ROW_63_830 vssd1 vccd1 sky130_fd_sc_hd__tapvpwrvgnd_1
XFILLER_92_481 vssd1 vssd1 vccd1 vccd1 sky130_fd_sc_hd__fill_2
XFILLER_40_518 vssd1 vssd1 vccd1 vccd1 sky130_fd_sc_hd__fill_1
X_5975_ _5977_/A _5977_/B vssd1 vssd1 vccd1 vccd1 _5978_/A sky130_fd_sc_hd__nor2_2
XTAP_TAPCELL_ROW_35_554 vssd1 vccd1 sky130_fd_sc_hd__tapvpwrvgnd_1
XANTENNA_fanout242_A _8103_/A vssd1 vssd1 vccd1 vccd1 sky130_fd_sc_hd__diode_2
X_7714_ _7714_/A _7853_/A _7714_/C _7714_/D vssd1 vssd1 vccd1 vccd1 _7716_/A sky130_fd_sc_hd__and4_2
X_4926_ _4979_/A _4700_/B _4496_/D _5155_/A vssd1 vssd1 vccd1 vccd1 _4927_/B sky130_fd_sc_hd__a22o_2
X_7645_ _7646_/A _7646_/B vssd1 vssd1 vccd1 vccd1 _7662_/A sky130_fd_sc_hd__nand2b_2
X_4857_ _8429_/D _4919_/B vssd1 vssd1 vccd1 vccd1 _4863_/A sky130_fd_sc_hd__nand2_2
X_7576_ _7785_/A _7576_/B vssd1 vssd1 vccd1 vccd1 _7585_/A sky130_fd_sc_hd__nand2_2
X_6527_ _6528_/B _6528_/A vssd1 vssd1 vccd1 vccd1 _6849_/A sky130_fd_sc_hd__and2b_2
X_4788_ _4788_/A _4788_/B vssd1 vssd1 vccd1 vccd1 _4791_/A sky130_fd_sc_hd__xnor2_4
X_6458_ _6458_/A _6458_/B _6458_/C vssd1 vssd1 vccd1 vccd1 _6459_/B sky130_fd_sc_hd__and3_2
XFILLER_69_49 vssd1 vssd1 vccd1 vccd1 sky130_fd_sc_hd__fill_2
X_6389_ _6389_/A _6389_/B vssd1 vssd1 vccd1 vccd1 _6391_/B sky130_fd_sc_hd__xor2_2
X_5409_ _5409_/A _5409_/B vssd1 vssd1 vccd1 vccd1 _5410_/B sky130_fd_sc_hd__and2_2
X_8128_ _8128_/A _8128_/B vssd1 vssd1 vccd1 vccd1 _8129_/B sky130_fd_sc_hd__xnor2_2
XANTENNA__4837__B _4931_/C vssd1 vssd1 vccd1 vccd1 sky130_fd_sc_hd__diode_2
XANTENNA__7213__B _7515_/A vssd1 vssd1 vccd1 vccd1 sky130_fd_sc_hd__diode_2
XFILLER_87_231 vssd1 vssd1 vccd1 vccd1 sky130_fd_sc_hd__fill_1
XTAP_TAPCELL_ROW_7_268 vssd1 vccd1 sky130_fd_sc_hd__tapvpwrvgnd_1
XFILLER_85_48 vssd1 vssd1 vccd1 vccd1 sky130_fd_sc_hd__fill_2
X_8059_ _8059_/A _8059_/B _8059_/C vssd1 vssd1 vccd1 vccd1 _8060_/B sky130_fd_sc_hd__nor3_2
XFILLER_83_470 vssd1 vssd1 vccd1 vccd1 sky130_fd_sc_hd__fill_2
XFILLER_90_429 vssd1 vssd1 vccd1 vccd1 sky130_fd_sc_hd__fill_1
XFILLER_16_537 vssd1 vssd1 vccd1 vccd1 sky130_fd_sc_hd__fill_2
XFILLER_55_194 vssd1 vssd1 vccd1 vccd1 sky130_fd_sc_hd__fill_8
XTAP_TAPCELL_ROW_87_1073 vssd1 vccd1 sky130_fd_sc_hd__tapvpwrvgnd_1
XFILLER_31_507 vssd1 vssd1 vccd1 vccd1 sky130_fd_sc_hd__fill_1
XFILLER_70_131 vssd1 vssd1 vccd1 vccd1 sky130_fd_sc_hd__fill_8
XANTENNA__5783__A2 _5780_/B vssd1 vssd1 vccd1 vccd1 sky130_fd_sc_hd__diode_2
XFILLER_70_164 vssd1 vssd1 vccd1 vccd1 sky130_fd_sc_hd__fill_2
XFILLER_34_85 vssd1 vssd1 vccd1 vccd1 sky130_fd_sc_hd__fill_4
XFILLER_70_197 vssd1 vssd1 vccd1 vccd1 sky130_fd_sc_hd__fill_2
XANTENNA__4747__B wire92/X vssd1 vssd1 vccd1 vccd1 sky130_fd_sc_hd__diode_2
XANTENNA__7123__B _7426_/A vssd1 vssd1 vccd1 vccd1 sky130_fd_sc_hd__diode_2
XANTENNA__8219__B input5/X vssd1 vssd1 vccd1 vccd1 sky130_fd_sc_hd__diode_2
XTAP_TAPCELL_ROW_77_966 vssd1 vccd1 sky130_fd_sc_hd__tapvpwrvgnd_1
XANTENNA__7748__B1 _8103_/D vssd1 vssd1 vccd1 vccd1 sky130_fd_sc_hd__diode_2
XFILLER_74_481 vssd1 vssd1 vccd1 vccd1 sky130_fd_sc_hd__fill_2
Xload_slew52 _5915_/B vssd1 vssd1 vccd1 vccd1 _6762_/B sky130_fd_sc_hd__buf_2
XANTENNA__4482__B _4931_/C vssd1 vssd1 vccd1 vccd1 sky130_fd_sc_hd__diode_2
XFILLER_22_507 vssd1 vssd1 vccd1 vccd1 sky130_fd_sc_hd__fill_2
XFILLER_61_175 vssd1 vssd1 vccd1 vccd1 sky130_fd_sc_hd__fill_2
X_5760_ _5761_/B _5761_/A vssd1 vssd1 vccd1 vccd1 _6139_/A sky130_fd_sc_hd__and2b_2
XTAP_TAPCELL_ROW_60_800 vssd1 vccd1 sky130_fd_sc_hd__tapvpwrvgnd_1
X_5691_ _5514_/Y _5553_/X _5689_/Y _5690_/X vssd1 vssd1 vccd1 vccd1 _5692_/B sky130_fd_sc_hd__a22oi_2
X_4711_ _8422_/D _4711_/B vssd1 vssd1 vccd1 vccd1 _4713_/B sky130_fd_sc_hd__nand2_2
XTAP_TAPCELL_ROW_32_524 vssd1 vccd1 sky130_fd_sc_hd__tapvpwrvgnd_1
XANTENNA__5594__A _6035_/C vssd1 vssd1 vccd1 vccd1 sky130_fd_sc_hd__diode_2
X_7430_ _7430_/A _7430_/B vssd1 vssd1 vccd1 vccd1 _7433_/A sky130_fd_sc_hd__xnor2_2
X_4642_ _4643_/A _4643_/B vssd1 vssd1 vccd1 vccd1 _4642_/X sky130_fd_sc_hd__and2b_2
XANTENNA__5881__X _5883_/B vssd1 vssd1 vccd1 vccd1 sky130_fd_sc_hd__diode_2
X_7361_ _7361_/A _7361_/B vssd1 vssd1 vccd1 vccd1 _7361_/X sky130_fd_sc_hd__xor2_2
X_4573_ _4573_/A _4574_/A vssd1 vssd1 vccd1 vccd1 _4573_/Y sky130_fd_sc_hd__nand2_2
X_7292_ _7105_/A _7105_/B _7106_/Y vssd1 vssd1 vccd1 vccd1 _7351_/A sky130_fd_sc_hd__a21bo_2
X_6312_ _6312_/A _6312_/B vssd1 vssd1 vccd1 vccd1 _6314_/B sky130_fd_sc_hd__xnor2_2
X_6243_ _6037_/B _6039_/B _6037_/A vssd1 vssd1 vccd1 vccd1 _6245_/B sky130_fd_sc_hd__o21ba_2
XANTENNA__6239__B1 _6238_/D vssd1 vssd1 vccd1 vccd1 sky130_fd_sc_hd__diode_2
X_6174_ _6174_/A _7007_/B vssd1 vssd1 vccd1 vccd1 _6175_/B sky130_fd_sc_hd__nor2_2
XANTENNA__4149__S _4160_/B vssd1 vssd1 vccd1 vccd1 sky130_fd_sc_hd__diode_2
XANTENNA_fanout192_A _4223_/B vssd1 vssd1 vccd1 vccd1 sky130_fd_sc_hd__diode_2
XFILLER_69_286 vssd1 vssd1 vccd1 vccd1 sky130_fd_sc_hd__fill_2
X_5125_ _5125_/A _5125_/B vssd1 vssd1 vccd1 vccd1 _5202_/A sky130_fd_sc_hd__xnor2_2
XTAP_TAPCELL_ROW_4_238 vssd1 vccd1 sky130_fd_sc_hd__tapvpwrvgnd_1
X_5056_ _8414_/D _5254_/B vssd1 vssd1 vccd1 vccd1 _5108_/A sky130_fd_sc_hd__nand2_2
XANTENNA__4673__A _4709_/B vssd1 vssd1 vccd1 vccd1 sky130_fd_sc_hd__diode_2
XFILLER_13_507 vssd1 vssd1 vccd1 vccd1 sky130_fd_sc_hd__fill_1
XFILLER_71_17 vssd1 vssd1 vccd1 vccd1 sky130_fd_sc_hd__fill_1
XFILLER_80_484 vssd1 vssd1 vccd1 vccd1 sky130_fd_sc_hd__fill_2
X_5958_ _5959_/A _5959_/B vssd1 vssd1 vccd1 vccd1 _6125_/A sky130_fd_sc_hd__nand2b_2
XFILLER_21_540 vssd1 vssd1 vccd1 vccd1 sky130_fd_sc_hd__fill_8
XFILLER_52_197 vssd1 vssd1 vccd1 vccd1 sky130_fd_sc_hd__fill_4
X_4909_ _4863_/A _4863_/B _4861_/X vssd1 vssd1 vccd1 vccd1 _4916_/A sky130_fd_sc_hd__o21a_2
X_5889_ _8417_/D _6738_/B vssd1 vssd1 vccd1 vccd1 _5891_/B sky130_fd_sc_hd__nand2_2
X_7628_ _7626_/A _7686_/A _7627_/X vssd1 vssd1 vccd1 vccd1 _7629_/B sky130_fd_sc_hd__o21a_2
X_7559_ _7467_/B _7469_/B _7467_/A vssd1 vssd1 vccd1 vccd1 _7561_/B sky130_fd_sc_hd__o21ba_2
XANTENNA__8413__CLK clkload4/A vssd1 vssd1 vccd1 vccd1 sky130_fd_sc_hd__diode_2
XFILLER_20_87 vssd1 vssd1 vccd1 vccd1 sky130_fd_sc_hd__fill_1
XFILLER_0_444 vssd1 vssd1 vccd1 vccd1 sky130_fd_sc_hd__fill_4
XFILLER_0_488 vssd1 vssd1 vccd1 vccd1 sky130_fd_sc_hd__fill_1
XFILLER_29_30 vssd1 vssd1 vccd1 vccd1 sky130_fd_sc_hd__fill_1
XANTENNA_input18_A gpio_in[8] vssd1 vssd1 vccd1 vccd1 sky130_fd_sc_hd__diode_2
XPHY_EDGE_ROW_11_Left_104 vssd1 vssd1 vccd1 vccd1 sky130_fd_sc_hd__decap_3
XTAP_TAPCELL_ROW_74_936 vssd1 vccd1 sky130_fd_sc_hd__tapvpwrvgnd_1
XANTENNA__6303__A _6572_/A vssd1 vssd1 vccd1 vccd1 sky130_fd_sc_hd__diode_2
XFILLER_8_533 vssd1 vccd1 vssd1 vccd1 sky130_ef_sc_hd__decap_40_12
XFILLER_6_12 vssd1 vssd1 vccd1 vccd1 sky130_fd_sc_hd__fill_1
XPHY_EDGE_ROW_20_Left_113 vssd1 vssd1 vccd1 vccd1 sky130_fd_sc_hd__decap_3
XTAP_TAPCELL_ROW_1_208 vssd1 vccd1 sky130_fd_sc_hd__tapvpwrvgnd_1
X_6930_ _6931_/A _6931_/B vssd1 vssd1 vccd1 vccd1 _7174_/B sky130_fd_sc_hd__and2_2
XFILLER_81_248 vssd1 vssd1 vccd1 vccd1 sky130_fd_sc_hd__fill_1
X_6861_ _8121_/A _8266_/A _6862_/C vssd1 vssd1 vccd1 vccd1 _6863_/A sky130_fd_sc_hd__a21oi_2
X_6792_ _6792_/A _6792_/B vssd1 vssd1 vccd1 vccd1 _6794_/B sky130_fd_sc_hd__xnor2_2
X_5812_ _5300_/Y _5211_/B _5209_/X vssd1 vssd1 vccd1 vccd1 _5812_/X sky130_fd_sc_hd__a21o_4
XFILLER_34_197 vssd1 vssd1 vccd1 vccd1 sky130_fd_sc_hd__fill_1
X_5743_ _5743_/A _5743_/B vssd1 vssd1 vccd1 vccd1 _5746_/A sky130_fd_sc_hd__xnor2_2
XTAP_TAPCELL_ROW_17_373 vssd1 vccd1 sky130_fd_sc_hd__tapvpwrvgnd_1
XANTENNA__8131__C _8257_/A vssd1 vssd1 vccd1 vccd1 sky130_fd_sc_hd__diode_2
X_5674_ _5654_/A _5654_/B _5662_/X _5664_/Y _5673_/X vssd1 vssd1 vccd1 vccd1 _5674_/X
+ sky130_fd_sc_hd__a221o_2
X_8393_ clkload7/A _8393_/D fanout372/A vssd1 vssd1 vccd1 vccd1 _8393_/Q sky130_fd_sc_hd__dfrtp_2
X_7413_ _7413_/A _7413_/B vssd1 vssd1 vccd1 vccd1 _7414_/B sky130_fd_sc_hd__xor2_2
X_4625_ _4625_/A _4686_/B vssd1 vssd1 vccd1 vccd1 _4626_/B sky130_fd_sc_hd__nand2_2
XANTENNA__4183__A1 input9/X vssd1 vssd1 vccd1 vccd1 sky130_fd_sc_hd__diode_2
Xhold511 _8399_/Q vssd1 vssd1 vccd1 vccd1 _8405_/D sky130_fd_sc_hd__dlygate4sd3_1
X_7344_ _7395_/B _7343_/B _7343_/C vssd1 vssd1 vccd1 vccd1 _7345_/B sky130_fd_sc_hd__o21a_2
X_4556_ _4557_/A _4709_/C vssd1 vssd1 vccd1 vccd1 _4558_/A sky130_fd_sc_hd__nand2_2
Xhold544 _8326_/Q vssd1 vssd1 vccd1 vccd1 hold544/X sky130_fd_sc_hd__dlygate4sd3_1
Xhold533 _8333_/Q vssd1 vssd1 vccd1 vccd1 hold533/X sky130_fd_sc_hd__dlygate4sd3_1
Xhold522 _8394_/Q vssd1 vssd1 vccd1 vccd1 _8453_/D sky130_fd_sc_hd__dlygate4sd3_1
XANTENNA__7121__A1 _6217_/C vssd1 vssd1 vccd1 vccd1 sky130_fd_sc_hd__diode_2
XANTENNA__7121__B2 _7120_/A vssd1 vssd1 vccd1 vccd1 sky130_fd_sc_hd__diode_2
Xhold555 _8384_/Q vssd1 vssd1 vccd1 vccd1 hold555/X sky130_fd_sc_hd__dlygate4sd3_1
X_7275_ _7990_/A _7897_/B vssd1 vssd1 vccd1 vccd1 _7276_/B sky130_fd_sc_hd__nand2_2
X_4487_ _5157_/A _4487_/B vssd1 vssd1 vccd1 vccd1 _4488_/B sky130_fd_sc_hd__nand2_2
X_6226_ _6226_/A _6226_/B vssd1 vssd1 vccd1 vccd1 _6228_/B sky130_fd_sc_hd__xnor2_2
XANTENNA__6883__A _6883_/A vssd1 vssd1 vccd1 vccd1 sky130_fd_sc_hd__diode_2
X_6157_ _8412_/D wire66/X _6156_/B _8411_/D vssd1 vssd1 vccd1 vccd1 _6157_/Y sky130_fd_sc_hd__a22oi_2
XFILLER_57_223 vssd1 vssd1 vccd1 vccd1 sky130_fd_sc_hd__fill_1
XFILLER_85_521 vssd1 vssd1 vccd1 vccd1 sky130_fd_sc_hd__fill_4
X_5108_ _5108_/A _5787_/A vssd1 vssd1 vccd1 vccd1 _5110_/B sky130_fd_sc_hd__xnor2_2
XANTENNA__5499__A _8220_/A vssd1 vssd1 vccd1 vccd1 sky130_fd_sc_hd__diode_2
XFILLER_57_267 vssd1 vssd1 vccd1 vccd1 sky130_fd_sc_hd__fill_4
X_6088_ _5974_/A _5974_/B _5972_/X vssd1 vssd1 vccd1 vccd1 _6138_/A sky130_fd_sc_hd__a21o_2
XFILLER_38_481 vssd1 vssd1 vccd1 vccd1 sky130_fd_sc_hd__fill_1
X_5039_ _5036_/X _4886_/X _5037_/X _4962_/B _5040_/A vssd1 vssd1 vccd1 vccd1 _5192_/C
+ sky130_fd_sc_hd__o221a_4
XFILLER_82_16 vssd1 vssd1 vccd1 vccd1 sky130_fd_sc_hd__fill_4
XTAP_TAPCELL_ROW_84_1043 vssd1 vccd1 sky130_fd_sc_hd__tapvpwrvgnd_1
XTAP_TAPCELL_ROW_71_906 vssd1 vccd1 sky130_fd_sc_hd__tapvpwrvgnd_1
XANTENNA__8025__D _8257_/A vssd1 vssd1 vccd1 vccd1 sky130_fd_sc_hd__diode_2
XFILLER_40_123 vssd1 vssd1 vccd1 vccd1 sky130_fd_sc_hd__fill_1
XFILLER_40_134 vssd1 vssd1 vccd1 vccd1 sky130_fd_sc_hd__fill_1
XFILLER_40_156 vssd1 vssd1 vccd1 vccd1 sky130_fd_sc_hd__fill_1
XANTENNA__4174__A1 _4207_/B vssd1 vssd1 vccd1 vccd1 sky130_fd_sc_hd__diode_2
Xoutput31 _8330_/Q vssd1 vssd1 vccd1 vccd1 gpio_out[28] sky130_fd_sc_hd__clkdlybuf4s25_1
XANTENNA__7889__A _7889_/A vssd1 vssd1 vccd1 vccd1 sky130_fd_sc_hd__diode_2
XFILLER_76_521 vssd1 vssd1 vccd1 vccd1 sky130_fd_sc_hd__fill_8
XFILLER_76_543 vssd1 vssd1 vccd1 vccd1 sky130_fd_sc_hd__fill_2
XFILLER_29_481 vssd1 vssd1 vccd1 vccd1 sky130_fd_sc_hd__fill_4
XFILLER_16_120 vssd1 vssd1 vccd1 vccd1 sky130_fd_sc_hd__fill_2
XFILLER_16_197 vssd1 vssd1 vccd1 vccd1 sky130_fd_sc_hd__fill_1
XANTENNA__8232__B input7/X vssd1 vssd1 vccd1 vccd1 sky130_fd_sc_hd__diode_2
XFILLER_31_167 vssd1 vssd1 vccd1 vccd1 sky130_fd_sc_hd__fill_1
XTAP_TAPCELL_ROW_14_343 vssd1 vccd1 sky130_fd_sc_hd__tapvpwrvgnd_1
XANTENNA__6033__A _6433_/A vssd1 vssd1 vccd1 vccd1 sky130_fd_sc_hd__diode_2
XANTENNA__4165__A1 _4227_/S vssd1 vssd1 vccd1 vccd1 sky130_fd_sc_hd__diode_2
X_4410_ _4411_/A _4411_/B vssd1 vssd1 vccd1 vccd1 _4410_/X sky130_fd_sc_hd__and2b_2
X_5390_ _5355_/A _5354_/B _5354_/A vssd1 vssd1 vccd1 vccd1 _5436_/B sky130_fd_sc_hd__o21ba_2
XANTENNA__8300__A0 _6207_/A vssd1 vssd1 vccd1 vccd1 sky130_fd_sc_hd__diode_2
X_4341_ _4341_/A _4341_/B vssd1 vssd1 vccd1 vccd1 _4390_/A sky130_fd_sc_hd__nor2_2
Xfanout309 _8346_/Q vssd1 vssd1 vccd1 vccd1 _8228_/A sky130_fd_sc_hd__clkdlybuf4s25_1
X_7060_ _8417_/D wire64/X wire59/X _8418_/D vssd1 vssd1 vccd1 vccd1 _7060_/Y sky130_fd_sc_hd__a22oi_2
X_4272_ _8388_/Q _8447_/Q _4270_/X vssd1 vssd1 vccd1 vccd1 _4274_/C sky130_fd_sc_hd__o21ai_2
X_6011_ _6011_/A _6011_/B vssd1 vssd1 vccd1 vccd1 _6013_/B sky130_fd_sc_hd__xnor2_2
XANTENNA__6208__A _7131_/A vssd1 vssd1 vccd1 vccd1 sky130_fd_sc_hd__diode_2
X_7962_ _7962_/A _7962_/B _7962_/C vssd1 vssd1 vccd1 vccd1 _7963_/B sky130_fd_sc_hd__nor3_2
XANTENNA__6090__A1 _6090_/A1 vssd1 vssd1 vccd1 vccd1 sky130_fd_sc_hd__diode_2
X_6913_ _7152_/A _6912_/B _6912_/C vssd1 vssd1 vccd1 vccd1 _6914_/B sky130_fd_sc_hd__a21o_2
X_7893_ _7895_/A _8267_/B _8125_/B _7998_/B vssd1 vssd1 vccd1 vccd1 _7897_/D sky130_fd_sc_hd__a22o_2
XANTENNA__6917__A1 _7889_/A vssd1 vssd1 vccd1 vccd1 sky130_fd_sc_hd__diode_2
XANTENNA__6917__B2 _7889_/B vssd1 vssd1 vccd1 vccd1 sky130_fd_sc_hd__diode_2
X_6844_ _6937_/B _6844_/B vssd1 vssd1 vccd1 vccd1 _6846_/C sky130_fd_sc_hd__or2_2
XANTENNA__8142__B _8142_/B vssd1 vssd1 vccd1 vccd1 sky130_fd_sc_hd__diode_2
XFILLER_50_465 vssd1 vssd1 vccd1 vccd1 sky130_fd_sc_hd__fill_1
X_6775_ _6775_/A _6775_/B vssd1 vssd1 vccd1 vccd1 _6776_/B sky130_fd_sc_hd__xnor2_2
XANTENNA_fanout322_A _8343_/Q vssd1 vssd1 vccd1 vccd1 sky130_fd_sc_hd__diode_2
X_5726_ _5726_/A _5726_/B vssd1 vssd1 vccd1 vccd1 _5728_/A sky130_fd_sc_hd__nand2_2
X_8445_ clkload2/A _8445_/D fanout379/X vssd1 vssd1 vccd1 vccd1 _8445_/Q sky130_fd_sc_hd__dfrtp_2
XANTENNA_fanout110_X _4700_/B vssd1 vssd1 vccd1 vccd1 sky130_fd_sc_hd__diode_2
X_5657_ _8168_/A _5657_/B vssd1 vssd1 vccd1 vccd1 _5669_/C sky130_fd_sc_hd__and2_2
X_8376_ clkload9/A _8376_/D load_slew373/X vssd1 vssd1 vccd1 vccd1 _8376_/Q sky130_fd_sc_hd__dfrtp_2
X_5588_ _5597_/A _5588_/B vssd1 vssd1 vccd1 vccd1 _5590_/B sky130_fd_sc_hd__and2_2
X_4608_ _8422_/D _4608_/B vssd1 vssd1 vccd1 vccd1 _4610_/B sky130_fd_sc_hd__nand2_2
XANTENNA__4398__A _8430_/D vssd1 vssd1 vccd1 vccd1 sky130_fd_sc_hd__diode_2
X_7327_ _7051_/B _7326_/Y _7325_/X vssd1 vssd1 vccd1 vccd1 _7329_/B sky130_fd_sc_hd__o21a_2
X_4539_ _4539_/A _4539_/B vssd1 vssd1 vccd1 vccd1 _4540_/B sky130_fd_sc_hd__xnor2_2
X_7258_ _7258_/A _7258_/B vssd1 vssd1 vccd1 vccd1 _7259_/B sky130_fd_sc_hd__nor2_2
XFILLER_77_318 vssd1 vssd1 vccd1 vccd1 sky130_fd_sc_hd__fill_1
XFILLER_89_167 vssd1 vssd1 vccd1 vccd1 sky130_fd_sc_hd__fill_1
X_6209_ _6210_/A _6420_/A _6210_/C vssd1 vssd1 vccd1 vccd1 _6212_/B sky130_fd_sc_hd__o21a_2
X_7189_ _7281_/A _7188_/B _7188_/C vssd1 vssd1 vccd1 vccd1 _7191_/B sky130_fd_sc_hd__a21o_2
XFILLER_45_237 vssd1 vssd1 vccd1 vccd1 sky130_fd_sc_hd__fill_1
XFILLER_73_546 vssd1 vssd1 vccd1 vccd1 sky130_fd_sc_hd__fill_1
XTAP_TAPCELL_ROW_28_479 vssd1 vccd1 sky130_fd_sc_hd__tapvpwrvgnd_1
XANTENNA__7875__C _7875_/C vssd1 vssd1 vccd1 vccd1 sky130_fd_sc_hd__diode_2
XANTENNA__7581__A1 _7990_/A vssd1 vssd1 vccd1 vccd1 sky130_fd_sc_hd__diode_2
XTAP_TAPCELL_ROW_11_313 vssd1 vccd1 sky130_fd_sc_hd__tapvpwrvgnd_1
XFILLER_42_74 vssd1 vssd1 vccd1 vccd1 sky130_fd_sc_hd__fill_1
Xrebuffer493 _5163_/A vssd1 vssd1 vccd1 vccd1 _6114_/A sky130_fd_sc_hd__buf_2
Xrebuffer482 _6790_/B vssd1 vssd1 vccd1 vccd1 _6789_/B sky130_fd_sc_hd__buf_2
Xrebuffer471 _4686_/C vssd1 vssd1 vccd1 vccd1 _4671_/B sky130_fd_sc_hd__buf_2
Xrebuffer460 _4159_/X vssd1 vssd1 vccd1 vccd1 _8428_/D sky130_fd_sc_hd__buf_2
XANTENNA__5842__D _6035_/C vssd1 vssd1 vccd1 vccd1 sky130_fd_sc_hd__diode_2
XFILLER_3_24 vssd1 vssd1 vccd1 vccd1 sky130_fd_sc_hd__fill_4
XANTENNA__8227__B input6/X vssd1 vssd1 vccd1 vccd1 sky130_fd_sc_hd__diode_2
XANTENNA__6970__B _7299_/B vssd1 vssd1 vccd1 vccd1 sky130_fd_sc_hd__diode_2
XFILLER_17_451 vssd1 vssd1 vccd1 vccd1 sky130_fd_sc_hd__fill_1
XFILLER_44_270 vssd1 vssd1 vccd1 vccd1 sky130_fd_sc_hd__fill_4
XFILLER_83_81 vssd1 vssd1 vccd1 vccd1 sky130_fd_sc_hd__fill_8
X_4890_ _4880_/B _4886_/X _4878_/Y vssd1 vssd1 vccd1 vccd1 _4963_/A sky130_fd_sc_hd__a21oi_2
XANTENNA__8447__RESET_B load_slew360/X vssd1 vssd1 vccd1 vccd1 sky130_fd_sc_hd__diode_2
XFILLER_80_3 vssd1 vssd1 vccd1 vccd1 sky130_fd_sc_hd__fill_2
X_6560_ _6873_/A _6560_/B vssd1 vssd1 vccd1 vccd1 _6563_/A sky130_fd_sc_hd__or2_2
X_5511_ _5876_/B _5510_/B _5509_/Y vssd1 vssd1 vccd1 vccd1 _5512_/B sky130_fd_sc_hd__o21bai_2
X_6491_ _7129_/A _6892_/B _6798_/B _7210_/A vssd1 vssd1 vccd1 vccd1 _6492_/B sky130_fd_sc_hd__and4_2
X_8230_ _8235_/A _8230_/B vssd1 vssd1 vccd1 vccd1 _8230_/Y sky130_fd_sc_hd__xnor2_2
X_5442_ _5442_/A _5442_/B vssd1 vssd1 vccd1 vccd1 _5453_/A sky130_fd_sc_hd__xnor2_2
X_8161_ _8161_/A _8161_/B vssd1 vssd1 vccd1 vccd1 _8161_/Y sky130_fd_sc_hd__nor2_2
X_5373_ _5412_/B _5373_/B vssd1 vssd1 vccd1 vccd1 _5375_/B sky130_fd_sc_hd__or2_2
X_8092_ _8092_/A _8092_/B vssd1 vssd1 vccd1 vccd1 _8094_/A sky130_fd_sc_hd__xnor2_2
X_7112_ _7352_/A _7112_/B vssd1 vssd1 vccd1 vccd1 _7114_/B sky130_fd_sc_hd__nand2_2
X_4324_ _4274_/B _4322_/X _4323_/X vssd1 vssd1 vccd1 vccd1 _4325_/B sky130_fd_sc_hd__a21oi_2
XANTENNA__6835__B1 _7723_/D vssd1 vssd1 vccd1 vccd1 sky130_fd_sc_hd__diode_2
XANTENNA_rebuffer458_X _8179_/B vssd1 vssd1 vccd1 vccd1 sky130_fd_sc_hd__diode_2
Xfanout106 _4343_/Y vssd1 vssd1 vccd1 vccd1 _4629_/B sky130_fd_sc_hd__clkdlybuf4s25_1
Xfanout128 _4191_/Y vssd1 vssd1 vccd1 vccd1 _7098_/A sky130_fd_sc_hd__clkdlybuf4s25_1
X_7043_ _6880_/A _6880_/B _6876_/X vssd1 vssd1 vccd1 vccd1 _7045_/B sky130_fd_sc_hd__a21o_2
Xfanout139 fanout140/X vssd1 vssd1 vccd1 vccd1 _8427_/D sky130_fd_sc_hd__buf_6
X_4255_ _8385_/Q _8444_/Q _4258_/B _4252_/X _4299_/B vssd1 vssd1 vccd1 vccd1 _4255_/Y
+ sky130_fd_sc_hd__a311oi_2
X_4186_ _6374_/A vssd1 vssd1 vccd1 vccd1 _7299_/A sky130_fd_sc_hd__inv_2
XANTENNA_fanout272_A _6832_/A vssd1 vssd1 vccd1 vccd1 sky130_fd_sc_hd__diode_2
XFILLER_55_502 vssd1 vssd1 vccd1 vccd1 sky130_fd_sc_hd__fill_2
XFILLER_55_524 vssd1 vssd1 vccd1 vccd1 sky130_fd_sc_hd__fill_2
XFILLER_55_546 vssd1 vssd1 vccd1 vccd1 sky130_fd_sc_hd__fill_1
XFILLER_82_332 vssd1 vssd1 vccd1 vccd1 sky130_fd_sc_hd__fill_1
XFILLER_42_218 vssd1 vssd1 vccd1 vccd1 sky130_fd_sc_hd__fill_1
XFILLER_82_365 vssd1 vssd1 vccd1 vccd1 sky130_fd_sc_hd__fill_1
X_7945_ _7810_/A _7810_/B _7811_/Y vssd1 vssd1 vccd1 vccd1 _7980_/A sky130_fd_sc_hd__a21bo_2
XFILLER_82_398 vssd1 vssd1 vccd1 vccd1 sky130_fd_sc_hd__fill_1
X_7876_ _8125_/A _7877_/B _7874_/Y _7875_/X vssd1 vssd1 vccd1 vccd1 _7878_/A sky130_fd_sc_hd__o2bb2a_2
XTAP_TAPCELL_ROW_81_1013 vssd1 vccd1 sky130_fd_sc_hd__tapvpwrvgnd_1
XTAP_TAPCELL_ROW_25_449 vssd1 vccd1 sky130_fd_sc_hd__tapvpwrvgnd_1
X_6827_ _6827_/A _6827_/B vssd1 vssd1 vccd1 vccd1 _6828_/B sky130_fd_sc_hd__nand2_2
XANTENNA_fanout325_X _5842_/B vssd1 vssd1 vccd1 vccd1 sky130_fd_sc_hd__diode_2
XFILLER_10_137 vssd1 vssd1 vccd1 vccd1 sky130_fd_sc_hd__fill_1
X_6758_ _6759_/A _6759_/B vssd1 vssd1 vccd1 vccd1 _7001_/A sky130_fd_sc_hd__or2_2
X_6689_ _6689_/A _6689_/B _6689_/C vssd1 vssd1 vccd1 vccd1 _6689_/X sky130_fd_sc_hd__or3_2
X_5709_ _5709_/A _5709_/B vssd1 vssd1 vccd1 vccd1 _5717_/A sky130_fd_sc_hd__xnor2_2
X_8428_ clkload6/A _8428_/D fanout359/X vssd1 vssd1 vccd1 vccd1 _8428_/Q sky130_fd_sc_hd__dfrtp_2
XFILLER_2_303 vssd1 vssd1 vccd1 vccd1 sky130_fd_sc_hd__fill_1
XFILLER_88_26 vssd1 vssd1 vccd1 vccd1 sky130_fd_sc_hd__fill_2
XFILLER_88_37 vssd1 vssd1 vccd1 vccd1 sky130_fd_sc_hd__fill_1
X_8359_ _8361_/CLK _8359_/D load_slew384/X vssd1 vssd1 vccd1 vccd1 _8359_/Q sky130_fd_sc_hd__dfrtp_2
XTAP_TAPCELL_ROW_92_1120 vssd1 vccd1 sky130_fd_sc_hd__tapvpwrvgnd_1
XTAP_TAPCELL_ROW_92_1131 vssd1 vccd1 sky130_fd_sc_hd__tapvpwrvgnd_1
XFILLER_77_159 vssd1 vssd1 vccd1 vccd1 sky130_fd_sc_hd__fill_1
XTAP_TAPCELL_ROW_69_891 vssd1 vccd1 sky130_fd_sc_hd__tapvpwrvgnd_1
XFILLER_5_141 vssd1 vssd1 vccd1 vccd1 sky130_fd_sc_hd__fill_1
XFILLER_68_104 vssd1 vssd1 vccd1 vccd1 sky130_fd_sc_hd__fill_1
XANTENNA__8034__A2 _8136_/A vssd1 vssd1 vccd1 vccd1 sky130_fd_sc_hd__diode_2
XFILLER_37_502 vssd1 vssd1 vccd1 vccd1 sky130_fd_sc_hd__fill_2
XFILLER_64_354 vssd1 vssd1 vccd1 vccd1 sky130_fd_sc_hd__fill_1
XFILLER_64_365 vssd1 vssd1 vccd1 vccd1 sky130_fd_sc_hd__fill_1
X_5991_ _5993_/A _5993_/B vssd1 vssd1 vccd1 vccd1 _5994_/B sky130_fd_sc_hd__nand2_2
XFILLER_64_387 vssd1 vssd1 vccd1 vccd1 sky130_fd_sc_hd__fill_1
X_7730_ _7731_/A _7731_/B _7731_/C vssd1 vssd1 vccd1 vccd1 _7887_/A sky130_fd_sc_hd__a21o_2
X_4942_ _4943_/A _4943_/B vssd1 vssd1 vccd1 vccd1 _4942_/Y sky130_fd_sc_hd__nand2b_2
XFILLER_91_184 vssd1 vssd1 vccd1 vccd1 sky130_fd_sc_hd__fill_1
X_7661_ _7513_/A _7657_/A _7661_/A3 _7660_/X vssd1 vssd1 vccd1 vccd1 _7661_/X sky130_fd_sc_hd__a31o_4
X_6612_ _6724_/A _7095_/B _7095_/C vssd1 vssd1 vccd1 vccd1 _6617_/A sky130_fd_sc_hd__and3_2
X_4873_ _4872_/A _4872_/C _4872_/B vssd1 vssd1 vccd1 vccd1 _4873_/X sky130_fd_sc_hd__a21o_2
XTAP_TAPCELL_ROW_22_419 vssd1 vccd1 sky130_fd_sc_hd__tapvpwrvgnd_1
X_7592_ _7592_/A _7592_/B vssd1 vssd1 vccd1 vccd1 _7594_/C sky130_fd_sc_hd__xnor2_2
X_6543_ _6432_/A _6434_/B _6432_/B vssd1 vssd1 vccd1 vccd1 _6545_/C sky130_fd_sc_hd__o21ba_2
X_6474_ _6474_/A _6474_/B vssd1 vssd1 vccd1 vccd1 _6476_/B sky130_fd_sc_hd__xor2_2
XTAP_TAPCELL_ROW_30_496 vssd1 vccd1 sky130_fd_sc_hd__tapvpwrvgnd_1
XANTENNA_fanout118_A _4366_/X vssd1 vssd1 vccd1 vccd1 sky130_fd_sc_hd__diode_2
X_8213_ _8207_/Y _8211_/B _8209_/B vssd1 vssd1 vccd1 vccd1 _8222_/A sky130_fd_sc_hd__o21a_2
X_5425_ _5426_/A _5426_/B vssd1 vssd1 vccd1 vccd1 _5854_/B sky130_fd_sc_hd__nand2b_2
XPHY_EDGE_ROW_12_Right_12 vssd1 vssd1 vccd1 vccd1 sky130_fd_sc_hd__decap_3
X_8144_ _8144_/A _8144_/B vssd1 vssd1 vccd1 vccd1 _8146_/A sky130_fd_sc_hd__xnor2_2
X_5356_ _5307_/A _5306_/B _5306_/A vssd1 vssd1 vccd1 vccd1 _5445_/B sky130_fd_sc_hd__o21ba_2
X_8075_ _7972_/A _7972_/B _7973_/X vssd1 vssd1 vccd1 vccd1 _8095_/A sky130_fd_sc_hd__a21oi_2
X_5287_ _5286_/A _5286_/B _5286_/C vssd1 vssd1 vccd1 vccd1 _5288_/B sky130_fd_sc_hd__a21o_2
X_4307_ _4531_/B _4531_/C vssd1 vssd1 vccd1 vccd1 _6114_/B sky130_fd_sc_hd__nor2_2
XFILLER_59_148 vssd1 vssd1 vccd1 vccd1 sky130_fd_sc_hd__fill_2
X_7026_ _7026_/A _7026_/B vssd1 vssd1 vccd1 vccd1 _7029_/A sky130_fd_sc_hd__xnor2_2
X_4238_ _8380_/Q _8439_/Q vssd1 vssd1 vccd1 vccd1 _4362_/B sky130_fd_sc_hd__xor2_2
XFILLER_55_310 vssd1 vssd1 vccd1 vccd1 sky130_fd_sc_hd__fill_2
XFILLER_74_107 vssd1 vssd1 vccd1 vccd1 sky130_fd_sc_hd__fill_2
XFILLER_74_118 vssd1 vssd1 vccd1 vccd1 sky130_fd_sc_hd__fill_4
XANTENNA__6036__A1 _6435_/A vssd1 vssd1 vccd1 vccd1 sky130_fd_sc_hd__diode_2
XANTENNA__6036__B2 _6238_/B vssd1 vssd1 vccd1 vccd1 sky130_fd_sc_hd__diode_2
X_4169_ _4674_/A vssd1 vssd1 vccd1 vccd1 _4169_/Y sky130_fd_sc_hd__inv_2
XFILLER_43_505 vssd1 vssd1 vccd1 vccd1 sky130_fd_sc_hd__fill_8
XTAP_TAPCELL_ROW_66_861 vssd1 vccd1 sky130_fd_sc_hd__tapvpwrvgnd_1
XPHY_EDGE_ROW_21_Right_21 vssd1 vssd1 vccd1 vccd1 sky130_fd_sc_hd__decap_3
X_7928_ _7929_/B _7929_/A vssd1 vssd1 vccd1 vccd1 _8059_/B sky130_fd_sc_hd__and2b_2
XTAP_TAPCELL_ROW_38_585 vssd1 vccd1 sky130_fd_sc_hd__tapvpwrvgnd_1
XANTENNA__7536__A1 _8016_/A vssd1 vssd1 vccd1 vccd1 sky130_fd_sc_hd__diode_2
X_7859_ _7859_/A _7859_/B vssd1 vssd1 vccd1 vccd1 _7867_/A sky130_fd_sc_hd__xnor2_2
XFILLER_23_54 vssd1 vssd1 vccd1 vccd1 sky130_fd_sc_hd__fill_2
XFILLER_7_428 vssd1 vssd1 vccd1 vccd1 sky130_fd_sc_hd__fill_1
XPHY_EDGE_ROW_30_Right_30 vssd1 vssd1 vccd1 vccd1 sky130_fd_sc_hd__decap_3
XPHY_EDGE_ROW_76_Left_169 vssd1 vssd1 vccd1 vccd1 sky130_fd_sc_hd__decap_3
XFILLER_2_177 vssd1 vssd1 vccd1 vccd1 sky130_fd_sc_hd__fill_1
XFILLER_19_524 vssd1 vssd1 vccd1 vccd1 sky130_fd_sc_hd__fill_4
XFILLER_46_343 vssd1 vssd1 vccd1 vccd1 sky130_fd_sc_hd__fill_1
XFILLER_34_505 vssd1 vssd1 vccd1 vccd1 sky130_fd_sc_hd__fill_2
XFILLER_61_335 vssd1 vssd1 vccd1 vccd1 sky130_fd_sc_hd__fill_1
XPHY_EDGE_ROW_85_Left_178 vssd1 vssd1 vccd1 vccd1 sky130_fd_sc_hd__decap_3
XFILLER_9_67 vssd1 vssd1 vccd1 vccd1 sky130_fd_sc_hd__fill_2
XANTENNA__8240__B input8/X vssd1 vssd1 vccd1 vccd1 sky130_fd_sc_hd__diode_2
XFILLER_6_461 vssd1 vssd1 vccd1 vccd1 sky130_fd_sc_hd__fill_1
XFILLER_6_472 vssd1 vssd1 vccd1 vccd1 sky130_fd_sc_hd__fill_4
X_5210_ _5208_/X _5694_/B _5099_/Y _5234_/A vssd1 vssd1 vccd1 vccd1 _5211_/B sky130_fd_sc_hd__a211o_4
X_6190_ _6190_/A _6190_/B vssd1 vssd1 vccd1 vccd1 _6193_/A sky130_fd_sc_hd__xnor2_2
XANTENNA__4496__A _4919_/A vssd1 vssd1 vccd1 vccd1 sky130_fd_sc_hd__diode_2
X_5141_ _5142_/A _5142_/B vssd1 vssd1 vccd1 vccd1 _5141_/X sky130_fd_sc_hd__and2b_2
X_5072_ _5072_/A _5072_/B vssd1 vssd1 vccd1 vccd1 _5081_/A sky130_fd_sc_hd__xor2_2
XANTENNA__5104__B _7007_/B vssd1 vssd1 vccd1 vccd1 sky130_fd_sc_hd__diode_2
XFILLER_84_438 vssd1 vssd1 vccd1 vccd1 sky130_fd_sc_hd__fill_1
XFILLER_25_505 vssd1 vccd1 vssd1 vccd1 sky130_ef_sc_hd__decap_40_12
XFILLER_25_538 vssd1 vssd1 vccd1 vccd1 sky130_fd_sc_hd__fill_4
XFILLER_64_195 vssd1 vssd1 vccd1 vccd1 sky130_fd_sc_hd__fill_1
XTAP_TAPCELL_ROW_63_831 vssd1 vccd1 sky130_fd_sc_hd__tapvpwrvgnd_1
X_7713_ _7713_/A _7713_/B vssd1 vssd1 vccd1 vccd1 _7798_/A sky130_fd_sc_hd__xnor2_2
X_5974_ _5974_/A _5974_/B vssd1 vssd1 vccd1 vccd1 _5977_/B sky130_fd_sc_hd__xor2_2
XTAP_TAPCELL_ROW_35_555 vssd1 vccd1 sky130_fd_sc_hd__tapvpwrvgnd_1
X_4925_ _4979_/A _5953_/B _4925_/C vssd1 vssd1 vccd1 vccd1 _4925_/X sky130_fd_sc_hd__and3_2
XANTENNA_fanout235_A _8371_/Q vssd1 vssd1 vccd1 vccd1 sky130_fd_sc_hd__diode_2
X_7644_ _7414_/A _7414_/B _7396_/Y vssd1 vssd1 vccd1 vccd1 _7646_/B sky130_fd_sc_hd__a21bo_2
X_4856_ _4856_/A _4856_/B vssd1 vssd1 vccd1 vccd1 _4864_/A sky130_fd_sc_hd__xnor2_2
XFILLER_20_243 vssd1 vssd1 vccd1 vccd1 sky130_fd_sc_hd__fill_1
X_7575_ _7574_/A _7574_/B _7574_/C vssd1 vssd1 vccd1 vccd1 _7576_/B sky130_fd_sc_hd__o21ai_2
X_6526_ _6437_/B _6439_/B _6437_/A vssd1 vssd1 vccd1 vccd1 _6528_/B sky130_fd_sc_hd__o21ba_2
X_4787_ _4787_/A _4787_/B vssd1 vssd1 vccd1 vccd1 _4788_/B sky130_fd_sc_hd__or2_4
XFILLER_69_17 vssd1 vssd1 vccd1 vccd1 sky130_fd_sc_hd__fill_1
X_6457_ _6458_/A _6458_/B _6458_/C vssd1 vssd1 vccd1 vccd1 _6459_/A sky130_fd_sc_hd__a21oi_2
X_6388_ _6389_/A _6389_/B vssd1 vssd1 vccd1 vccd1 _6678_/B sky130_fd_sc_hd__nand2_2
X_5408_ _5409_/A _5409_/B vssd1 vssd1 vccd1 vccd1 _5864_/A sky130_fd_sc_hd__nor2_2
X_8127_ _8127_/A _8127_/B vssd1 vssd1 vccd1 vccd1 _8128_/B sky130_fd_sc_hd__xnor2_2
X_5339_ _5339_/A _5339_/B vssd1 vssd1 vccd1 vccd1 _5341_/A sky130_fd_sc_hd__nor2_2
XTAP_TAPCELL_ROW_7_269 vssd1 vccd1 sky130_fd_sc_hd__tapvpwrvgnd_1
X_8058_ _8059_/A _8059_/B _8059_/C vssd1 vssd1 vccd1 vccd1 _8156_/A sky130_fd_sc_hd__o21a_2
XFILLER_47_129 vssd1 vccd1 vssd1 vccd1 sky130_ef_sc_hd__decap_40_12
XFILLER_75_449 vssd1 vssd1 vccd1 vccd1 sky130_fd_sc_hd__fill_4
X_7009_ _6739_/A _7051_/A _7008_/X vssd1 vssd1 vccd1 vccd1 _7012_/A sky130_fd_sc_hd__o21ba_2
XFILLER_90_419 vssd1 vssd1 vccd1 vccd1 sky130_fd_sc_hd__fill_1
XFILLER_16_549 vssd1 vssd1 vccd1 vccd1 sky130_fd_sc_hd__fill_2
XFILLER_70_110 vssd1 vssd1 vccd1 vccd1 sky130_fd_sc_hd__fill_1
XTAP_TAPCELL_ROW_87_1074 vssd1 vccd1 sky130_fd_sc_hd__tapvpwrvgnd_1
XFILLER_70_154 vssd1 vssd1 vccd1 vccd1 sky130_fd_sc_hd__fill_1
XFILLER_34_53 vssd1 vssd1 vccd1 vccd1 sky130_fd_sc_hd__fill_2
XFILLER_50_85 vssd1 vssd1 vccd1 vccd1 sky130_fd_sc_hd__fill_2
XFILLER_3_464 vssd1 vssd1 vccd1 vccd1 sky130_fd_sc_hd__fill_1
XFILLER_3_475 vssd1 vssd1 vccd1 vccd1 sky130_fd_sc_hd__fill_2
Xload_slew117 _4704_/B vssd1 vssd1 vccd1 vccd1 _4686_/B sky130_fd_sc_hd__clkbuf_4
XTAP_TAPCELL_ROW_77_967 vssd1 vccd1 sky130_fd_sc_hd__tapvpwrvgnd_1
Xclkbuf_4_11_0_clk clkbuf_0_clk/X vssd1 vssd1 vccd1 vccd1 _8369_/CLK sky130_fd_sc_hd__clkbuf_8
XANTENNA__7748__A1 _7889_/A vssd1 vssd1 vccd1 vccd1 sky130_fd_sc_hd__diode_2
XANTENNA__7748__B2 _7889_/B vssd1 vssd1 vccd1 vccd1 sky130_fd_sc_hd__diode_2
Xload_slew75 _5272_/B vssd1 vssd1 vccd1 vccd1 _5254_/B sky130_fd_sc_hd__clkbuf_4
XTAP_TAPCELL_ROW_60_801 vssd1 vccd1 sky130_fd_sc_hd__tapvpwrvgnd_1
X_5690_ _5688_/X _5687_/Y _5553_/X _5514_/Y vssd1 vssd1 vccd1 vccd1 _5690_/X sky130_fd_sc_hd__o2bb2a_2
X_4710_ _4674_/A _4709_/C _4366_/X vssd1 vssd1 vccd1 vccd1 _4711_/B sky130_fd_sc_hd__a21o_2
XTAP_TAPCELL_ROW_32_525 vssd1 vccd1 sky130_fd_sc_hd__tapvpwrvgnd_1
XFILLER_91_81 vssd1 vssd1 vccd1 vccd1 sky130_fd_sc_hd__fill_1
X_4641_ _4641_/A _4641_/B vssd1 vssd1 vccd1 vccd1 _4643_/B sky130_fd_sc_hd__xnor2_4
X_7360_ _7206_/Y _7208_/B _7205_/A vssd1 vssd1 vccd1 vccd1 _7361_/B sky130_fd_sc_hd__o21ba_2
X_4572_ _4573_/A _4574_/A vssd1 vssd1 vccd1 vccd1 _4572_/Y sky130_fd_sc_hd__nor2_2
X_7291_ _7506_/B _7291_/B vssd1 vssd1 vccd1 vccd1 _7359_/A sky130_fd_sc_hd__nor2_2
X_6311_ _6119_/A _6119_/B _6117_/A vssd1 vssd1 vccd1 vccd1 _6312_/B sky130_fd_sc_hd__o21a_2
X_6242_ _6242_/A _6242_/B vssd1 vssd1 vccd1 vccd1 _6245_/A sky130_fd_sc_hd__xnor2_2
XANTENNA__4657__C _4979_/C vssd1 vssd1 vccd1 vccd1 sky130_fd_sc_hd__diode_2
XANTENNA__6239__A1 _6435_/A vssd1 vssd1 vccd1 vccd1 sky130_fd_sc_hd__diode_2
XANTENNA__6239__B2 _6238_/B vssd1 vssd1 vccd1 vccd1 sky130_fd_sc_hd__diode_2
X_6173_ _6173_/A _6348_/A vssd1 vssd1 vccd1 vccd1 _6175_/A sky130_fd_sc_hd__xor2_2
X_5124_ _5125_/A _5125_/B vssd1 vssd1 vccd1 vccd1 _5806_/A sky130_fd_sc_hd__and2b_2
XTAP_TAPCELL_ROW_4_239 vssd1 vccd1 sky130_fd_sc_hd__tapvpwrvgnd_1
X_5055_ _5055_/A _5055_/B vssd1 vssd1 vccd1 vccd1 wire77/A sky130_fd_sc_hd__xnor2_2
XTAP_TAPCELL_ROW_48_680 vssd1 vccd1 sky130_fd_sc_hd__tapvpwrvgnd_1
XFILLER_52_143 vssd1 vssd1 vccd1 vccd1 sky130_fd_sc_hd__fill_1
X_5957_ _5706_/A _5706_/B _5704_/B vssd1 vssd1 vccd1 vccd1 _5959_/B sky130_fd_sc_hd__o21ai_2
X_4908_ _5747_/A _5149_/B _4833_/A _4831_/B vssd1 vssd1 vccd1 vccd1 _4917_/A sky130_fd_sc_hd__a31o_2
XANTENNA_fanout238_X _5826_/A vssd1 vssd1 vccd1 vccd1 sky130_fd_sc_hd__diode_2
X_7627_ _7685_/A wire64/X wire59/X _7820_/A vssd1 vssd1 vccd1 vccd1 _7627_/X sky130_fd_sc_hd__a22o_2
X_5888_ _8417_/D wire77/X vssd1 vssd1 vccd1 vccd1 _6173_/A sky130_fd_sc_hd__nand2_2
X_4839_ _6588_/A _4780_/B _4931_/C _5163_/A vssd1 vssd1 vccd1 vccd1 _4840_/B sky130_fd_sc_hd__a22o_2
X_7558_ _7558_/A _7558_/B vssd1 vssd1 vccd1 vccd1 _7561_/A sky130_fd_sc_hd__xnor2_2
X_7489_ _7489_/A _7489_/B _7489_/C vssd1 vssd1 vccd1 vccd1 _7490_/B sky130_fd_sc_hd__and3_2
X_6509_ _6510_/A _6510_/B vssd1 vssd1 vccd1 vccd1 _6846_/B sky130_fd_sc_hd__nand2b_2
XFILLER_45_30 vssd1 vssd1 vccd1 vccd1 sky130_fd_sc_hd__fill_2
XFILLER_56_460 vssd1 vssd1 vccd1 vccd1 sky130_fd_sc_hd__fill_2
XFILLER_90_238 vssd1 vssd1 vccd1 vccd1 sky130_fd_sc_hd__fill_1
XTAP_TAPCELL_ROW_74_937 vssd1 vccd1 sky130_fd_sc_hd__tapvpwrvgnd_1
XFILLER_71_441 vssd1 vssd1 vccd1 vccd1 sky130_fd_sc_hd__fill_4
XFILLER_83_290 vssd1 vssd1 vccd1 vccd1 sky130_fd_sc_hd__fill_1
XFILLER_12_530 vssd1 vssd1 vccd1 vccd1 sky130_fd_sc_hd__fill_2
XFILLER_8_545 vssd1 vssd1 vccd1 vccd1 sky130_fd_sc_hd__fill_1
XANTENNA__4716__A1 _8422_/D vssd1 vssd1 vccd1 vccd1 sky130_fd_sc_hd__diode_2
XFILLER_8_567 vssd1 vssd1 vccd1 vccd1 sky130_fd_sc_hd__fill_2
XFILLER_6_57 vssd1 vssd1 vccd1 vccd1 sky130_fd_sc_hd__fill_1
XANTENNA__7666__B1 _7966_/B vssd1 vssd1 vccd1 vccd1 sky130_fd_sc_hd__diode_2
XANTENNA_load_slew61_X _5902_/B vssd1 vssd1 vccd1 vccd1 sky130_fd_sc_hd__diode_2
XFILLER_79_552 vssd1 vssd1 vccd1 vccd1 sky130_fd_sc_hd__fill_2
XANTENNA__8246__A _8246_/A vssd1 vssd1 vccd1 vccd1 sky130_fd_sc_hd__diode_2
XFILLER_39_438 vssd1 vssd1 vccd1 vccd1 sky130_fd_sc_hd__fill_1
XFILLER_66_213 vssd1 vssd1 vccd1 vccd1 sky130_fd_sc_hd__fill_1
XFILLER_19_140 vssd1 vssd1 vccd1 vccd1 sky130_fd_sc_hd__fill_1
XTAP_TAPCELL_ROW_1_209 vssd1 vccd1 sky130_fd_sc_hd__tapvpwrvgnd_1
X_6860_ _6957_/A _6860_/B vssd1 vssd1 vccd1 vccd1 _6862_/C sky130_fd_sc_hd__nor2_2
XANTENNA__5197__A1_N _6611_/A vssd1 vssd1 vccd1 vccd1 sky130_fd_sc_hd__diode_2
X_6791_ _6792_/B _6792_/A vssd1 vssd1 vccd1 vccd1 _7039_/A sky130_fd_sc_hd__and2b_2
X_5811_ _5811_/A _5811_/B vssd1 vssd1 vccd1 vccd1 _5813_/A sky130_fd_sc_hd__xnor2_2
XTAP_TAPCELL_ROW_45_650 vssd1 vccd1 sky130_fd_sc_hd__tapvpwrvgnd_1
X_5742_ _5930_/A _6572_/B vssd1 vssd1 vccd1 vccd1 _5743_/B sky130_fd_sc_hd__nand2_2
XTAP_TAPCELL_ROW_17_374 vssd1 vccd1 sky130_fd_sc_hd__tapvpwrvgnd_1
XANTENNA_load_slew358_X load_slew358/X vssd1 vssd1 vccd1 vccd1 sky130_fd_sc_hd__diode_2
XANTENNA__8131__D _8263_/A vssd1 vssd1 vccd1 vccd1 sky130_fd_sc_hd__diode_2
X_5673_ _5660_/Y _5668_/X _5671_/X _5672_/X vssd1 vssd1 vccd1 vccd1 _5673_/X sky130_fd_sc_hd__o31a_2
X_8392_ clkload7/A _8392_/D load_slew358/X vssd1 vssd1 vccd1 vccd1 _8392_/Q sky130_fd_sc_hd__dfrtp_2
X_7412_ _7412_/A _7412_/B vssd1 vssd1 vccd1 vccd1 _7413_/B sky130_fd_sc_hd__xor2_2
X_4624_ _4623_/A _4709_/C _4596_/A _4623_/Y _4558_/A vssd1 vssd1 vccd1 vccd1 _4626_/A
+ sky130_fd_sc_hd__a32o_2
XPHY_EDGE_ROW_6_Right_6 vssd1 vssd1 vccd1 vccd1 sky130_fd_sc_hd__decap_3
X_7343_ _7395_/B _7343_/B _7343_/C vssd1 vssd1 vccd1 vccd1 _7345_/A sky130_fd_sc_hd__nor3_2
X_4555_ _4555_/A _4555_/B vssd1 vssd1 vccd1 vccd1 _4568_/A sky130_fd_sc_hd__xnor2_2
Xhold545 _8327_/Q vssd1 vssd1 vccd1 vccd1 hold545/X sky130_fd_sc_hd__dlygate4sd3_1
Xhold534 _8420_/Q vssd1 vssd1 vccd1 vccd1 hold534/X sky130_fd_sc_hd__dlygate4sd3_1
Xhold523 _8390_/Q vssd1 vssd1 vccd1 vccd1 _8449_/D sky130_fd_sc_hd__dlygate4sd3_1
Xhold512 _8397_/Q vssd1 vssd1 vccd1 vccd1 _8403_/D sky130_fd_sc_hd__dlygate4sd3_1
X_7274_ _7274_/A _7274_/B vssd1 vssd1 vccd1 vccd1 _7276_/A sky130_fd_sc_hd__nor2_2
X_4486_ _4486_/A _4486_/B vssd1 vssd1 vccd1 vccd1 _4488_/A sky130_fd_sc_hd__xnor2_2
X_6225_ _6226_/A _6226_/B vssd1 vssd1 vccd1 vccd1 _6447_/B sky130_fd_sc_hd__nand2b_2
XANTENNA__6883__B _7120_/A vssd1 vssd1 vccd1 vccd1 sky130_fd_sc_hd__diode_2
X_6156_ _8412_/D _6156_/B vssd1 vssd1 vccd1 vccd1 _6373_/A sky130_fd_sc_hd__nand2_2
XANTENNA_clkbuf_4_4_0_clk_X clkload4/A vssd1 vssd1 vccd1 vccd1 sky130_fd_sc_hd__diode_2
X_5107_ _5107_/A _5788_/A vssd1 vssd1 vccd1 vccd1 _5793_/A sky130_fd_sc_hd__or2_2
X_6087_ _5916_/A _5916_/B _5913_/Y vssd1 vssd1 vccd1 vccd1 _6153_/A sky130_fd_sc_hd__o21ai_2
XANTENNA__7995__A _8110_/B vssd1 vssd1 vccd1 vccd1 sky130_fd_sc_hd__diode_2
XFILLER_57_279 vssd1 vssd1 vccd1 vccd1 sky130_fd_sc_hd__fill_1
X_5038_ _4887_/B _5036_/X _5037_/X _4962_/B vssd1 vssd1 vccd1 vccd1 _5040_/B sky130_fd_sc_hd__o22a_2
XFILLER_25_121 vssd1 vssd1 vccd1 vccd1 sky130_fd_sc_hd__fill_1
XFILLER_82_39 vssd1 vssd1 vccd1 vccd1 sky130_fd_sc_hd__fill_1
XTAP_TAPCELL_ROW_71_907 vssd1 vccd1 sky130_fd_sc_hd__tapvpwrvgnd_1
XFILLER_13_305 vssd1 vssd1 vccd1 vccd1 sky130_fd_sc_hd__fill_1
XTAP_TAPCELL_ROW_84_1044 vssd1 vccd1 sky130_fd_sc_hd__tapvpwrvgnd_1
X_6989_ _6987_/A _7082_/A _6988_/Y vssd1 vssd1 vccd1 vccd1 _6991_/A sky130_fd_sc_hd__a21o_2
XANTENNA__7219__B _7862_/B vssd1 vssd1 vccd1 vccd1 sky130_fd_sc_hd__diode_2
XANTENNA__4189__A_N wire387/A vssd1 vssd1 vccd1 vccd1 sky130_fd_sc_hd__diode_2
Xoutput32 _8331_/Q vssd1 vssd1 vccd1 vccd1 gpio_out[29] sky130_fd_sc_hd__clkdlybuf4s25_1
Xoutput21 _8320_/Q vssd1 vssd1 vccd1 vccd1 gpio_out[18] sky130_fd_sc_hd__clkdlybuf4s25_1
XANTENNA__7889__B _7889_/B vssd1 vssd1 vccd1 vccd1 sky130_fd_sc_hd__diode_2
XFILLER_0_253 vssd1 vssd1 vccd1 vccd1 sky130_fd_sc_hd__fill_1
XFILLER_0_297 vssd1 vssd1 vccd1 vccd1 sky130_fd_sc_hd__fill_1
XFILLER_76_533 vssd1 vssd1 vccd1 vccd1 sky130_fd_sc_hd__fill_2
XFILLER_91_503 vssd1 vssd1 vccd1 vccd1 sky130_fd_sc_hd__fill_1
XTAP_TAPCELL_ROW_59_786 vssd1 vccd1 sky130_fd_sc_hd__tapvpwrvgnd_1
XTAP_TAPCELL_ROW_42_620 vssd1 vccd1 sky130_fd_sc_hd__tapvpwrvgnd_1
XTAP_TAPCELL_ROW_14_344 vssd1 vccd1 sky130_fd_sc_hd__tapvpwrvgnd_1
XANTENNA__6033__B _8241_/A vssd1 vssd1 vccd1 vccd1 sky130_fd_sc_hd__diode_2
XANTENNA__7129__B _7862_/B vssd1 vssd1 vccd1 vccd1 sky130_fd_sc_hd__diode_2
XFILLER_82_7 vssd1 vssd1 vccd1 vccd1 sky130_fd_sc_hd__fill_2
XPHY_EDGE_ROW_59_Right_59 vssd1 vssd1 vccd1 vccd1 sky130_fd_sc_hd__decap_3
XANTENNA__8300__A1 input7/X vssd1 vssd1 vccd1 vccd1 sky130_fd_sc_hd__diode_2
X_4340_ _8430_/D fanout111/X _5703_/B _4772_/A vssd1 vssd1 vccd1 vccd1 _4341_/B sky130_fd_sc_hd__o2bb2a_2
X_4271_ _4249_/Y _4255_/Y _4259_/Y _4314_/A _4262_/A vssd1 vssd1 vccd1 vccd1 _4274_/B
+ sky130_fd_sc_hd__a2111o_2
X_6010_ _6011_/A _6010_/B _6223_/B vssd1 vssd1 vccd1 vccd1 _6215_/A sky130_fd_sc_hd__or3_2
XFILLER_39_213 vssd1 vssd1 vccd1 vccd1 sky130_fd_sc_hd__fill_1
XFILLER_67_511 vssd1 vssd1 vccd1 vccd1 sky130_fd_sc_hd__fill_1
XPHY_EDGE_ROW_68_Right_68 vssd1 vssd1 vccd1 vccd1 sky130_fd_sc_hd__decap_3
XANTENNA__6208__B _6798_/B vssd1 vssd1 vccd1 vccd1 sky130_fd_sc_hd__diode_2
XFILLER_39_279 vssd1 vssd1 vccd1 vccd1 sky130_fd_sc_hd__fill_1
X_7961_ _7962_/A _7962_/B _7962_/C vssd1 vssd1 vccd1 vccd1 _7963_/A sky130_fd_sc_hd__o21a_2
XANTENNA__4654__D _4692_/B vssd1 vssd1 vccd1 vccd1 sky130_fd_sc_hd__diode_2
XANTENNA__6090__A2 _6712_/B vssd1 vssd1 vccd1 vccd1 sky130_fd_sc_hd__diode_2
XANTENNA__8263__X _8267_/C vssd1 vssd1 vccd1 vccd1 sky130_fd_sc_hd__diode_2
X_7892_ _7892_/A _7892_/B vssd1 vssd1 vccd1 vccd1 _7903_/A sky130_fd_sc_hd__xnor2_2
X_6912_ _7152_/A _6912_/B _6912_/C vssd1 vssd1 vccd1 vccd1 _7152_/B sky130_fd_sc_hd__nand3_2
X_6843_ _6843_/A _6843_/B vssd1 vssd1 vccd1 vccd1 _6844_/B sky130_fd_sc_hd__nor2_2
XANTENNA__6917__A2 _7875_/C vssd1 vssd1 vccd1 vccd1 sky130_fd_sc_hd__diode_2
XFILLER_22_124 vssd1 vssd1 vccd1 vccd1 sky130_fd_sc_hd__fill_4
XANTENNA_fanout148_A _4360_/X vssd1 vssd1 vccd1 vccd1 sky130_fd_sc_hd__diode_2
XFILLER_22_157 vssd1 vssd1 vccd1 vccd1 sky130_fd_sc_hd__fill_2
X_6774_ _7409_/A _7084_/B _6775_/A vssd1 vssd1 vccd1 vccd1 _6774_/X sky130_fd_sc_hd__or3_2
XPHY_EDGE_ROW_77_Right_77 vssd1 vssd1 vccd1 vccd1 sky130_fd_sc_hd__decap_3
XFILLER_50_477 vssd1 vssd1 vccd1 vccd1 sky130_fd_sc_hd__fill_1
XFILLER_50_488 vssd1 vssd1 vccd1 vccd1 sky130_fd_sc_hd__fill_4
X_5725_ _6572_/A _6704_/B _6703_/B _6712_/A vssd1 vssd1 vccd1 vccd1 _5726_/B sky130_fd_sc_hd__a22o_2
X_8444_ clkload0/A _8444_/D wire368/X vssd1 vssd1 vccd1 vccd1 _8444_/Q sky130_fd_sc_hd__dfrtp_2
X_5656_ _5656_/A _5656_/B vssd1 vssd1 vccd1 vccd1 _5662_/A sky130_fd_sc_hd__nor2_2
X_4607_ _4607_/A _4607_/B vssd1 vssd1 vccd1 vccd1 _4610_/A sky130_fd_sc_hd__xnor2_2
X_8375_ clkload9/A _8375_/D load_slew373/X vssd1 vssd1 vccd1 vccd1 _8375_/Q sky130_fd_sc_hd__dfrtp_2
X_5587_ _5587_/A _5587_/B _5587_/C vssd1 vssd1 vccd1 vccd1 _5588_/B sky130_fd_sc_hd__nand3_2
XFILLER_89_113 vssd1 vssd1 vccd1 vccd1 sky130_fd_sc_hd__fill_4
X_7326_ _7820_/A _7326_/B vssd1 vssd1 vccd1 vccd1 _7326_/Y sky130_fd_sc_hd__nand2_2
X_4538_ _4539_/A _4539_/B vssd1 vssd1 vccd1 vccd1 _4538_/Y sky130_fd_sc_hd__nand2b_2
XANTENNA__6894__A _7131_/A vssd1 vssd1 vccd1 vccd1 sky130_fd_sc_hd__diode_2
X_7257_ _7258_/A _7258_/B vssd1 vssd1 vccd1 vccd1 _7480_/B sky130_fd_sc_hd__and2_2
X_4469_ _4469_/A _4469_/B vssd1 vssd1 vccd1 vccd1 _4508_/A sky130_fd_sc_hd__xnor2_2
XFILLER_77_308 vssd1 vssd1 vccd1 vccd1 sky130_fd_sc_hd__fill_1
X_6208_ _7131_/A _6798_/B vssd1 vssd1 vccd1 vccd1 _6210_/C sky130_fd_sc_hd__nand2_2
XPHY_EDGE_ROW_86_Right_86 vssd1 vssd1 vccd1 vccd1 sky130_fd_sc_hd__decap_3
X_7188_ _7281_/A _7188_/B _7188_/C vssd1 vssd1 vccd1 vccd1 _7281_/B sky130_fd_sc_hd__nand3_2
XFILLER_58_555 vssd1 vssd1 vccd1 vccd1 sky130_fd_sc_hd__fill_1
XFILLER_58_566 vssd1 vssd1 vccd1 vccd1 sky130_fd_sc_hd__fill_4
X_6139_ _6139_/A _6139_/B vssd1 vssd1 vccd1 vccd1 _6139_/X sky130_fd_sc_hd__or2_2
XTAP_TAPCELL_ROW_56_756 vssd1 vccd1 sky130_fd_sc_hd__tapvpwrvgnd_1
XFILLER_26_43 vssd1 vssd1 vccd1 vccd1 sky130_fd_sc_hd__fill_4
XANTENNA__7875__D _7875_/D vssd1 vssd1 vccd1 vccd1 sky130_fd_sc_hd__diode_2
XFILLER_13_113 vssd1 vssd1 vccd1 vccd1 sky130_fd_sc_hd__fill_1
XFILLER_41_433 vssd1 vssd1 vccd1 vccd1 sky130_fd_sc_hd__fill_1
XFILLER_9_128 vssd1 vssd1 vccd1 vccd1 sky130_fd_sc_hd__fill_1
XFILLER_42_64 vssd1 vssd1 vccd1 vccd1 sky130_fd_sc_hd__fill_1
XTAP_TAPCELL_ROW_11_314 vssd1 vccd1 sky130_fd_sc_hd__tapvpwrvgnd_1
Xrebuffer450 _5194_/X vssd1 vssd1 vccd1 vccd1 _7081_/B sky130_fd_sc_hd__buf_2
Xrebuffer483 fanout48/X vssd1 vssd1 vccd1 vccd1 _8082_/C sky130_fd_sc_hd__buf_2
Xrebuffer472 _5198_/B vssd1 vssd1 vccd1 vccd1 _5696_/B sky130_fd_sc_hd__buf_2
Xrebuffer461 _4872_/Y vssd1 vssd1 vccd1 vccd1 _4875_/A2 sky130_fd_sc_hd__buf_4
Xrebuffer494 _4780_/A vssd1 vssd1 vccd1 vccd1 _5163_/A sky130_fd_sc_hd__buf_4
XANTENNA__8294__A0 _6435_/A vssd1 vssd1 vccd1 vccd1 sky130_fd_sc_hd__diode_2
XFILLER_49_500 vssd1 vssd1 vccd1 vccd1 sky130_fd_sc_hd__fill_4
XFILLER_49_533 vssd1 vssd1 vccd1 vccd1 sky130_fd_sc_hd__fill_2
XANTENNA__8426__CLK clkload6/A vssd1 vssd1 vccd1 vccd1 sky130_fd_sc_hd__diode_2
XFILLER_67_83 vssd1 vssd1 vccd1 vccd1 sky130_fd_sc_hd__fill_4
XANTENNA__4204__A_N input4/X vssd1 vssd1 vccd1 vccd1 sky130_fd_sc_hd__diode_2
XANTENNA__6970__C _7299_/C vssd1 vssd1 vccd1 vccd1 sky130_fd_sc_hd__diode_2
X_5510_ _5876_/B _5510_/B _5509_/Y vssd1 vssd1 vccd1 vccd1 _5512_/A sky130_fd_sc_hd__or3b_2
XFILLER_73_3 vssd1 vssd1 vccd1 vccd1 sky130_fd_sc_hd__fill_4
X_6490_ _7129_/A _6798_/B _7210_/A _6892_/B vssd1 vssd1 vccd1 vccd1 _6492_/A sky130_fd_sc_hd__a22oi_2
XANTENNA__8416__RESET_B wire364/X vssd1 vssd1 vccd1 vccd1 sky130_fd_sc_hd__diode_2
X_5441_ _5441_/A _5441_/B vssd1 vssd1 vccd1 vccd1 _5442_/B sky130_fd_sc_hd__nand2_2
X_8160_ _8160_/A _8160_/B vssd1 vssd1 vccd1 vccd1 _8161_/B sky130_fd_sc_hd__xnor2_2
X_5372_ _5372_/A _5372_/B vssd1 vssd1 vccd1 vccd1 _5373_/B sky130_fd_sc_hd__nor2_2
X_8091_ _8091_/A _8091_/B vssd1 vssd1 vccd1 vccd1 _8092_/B sky130_fd_sc_hd__xnor2_2
X_7111_ _7111_/A _7111_/B vssd1 vssd1 vccd1 vccd1 _7112_/B sky130_fd_sc_hd__nand2_2
X_4323_ _4267_/Y _4281_/B _4279_/Y vssd1 vssd1 vccd1 vccd1 _4323_/X sky130_fd_sc_hd__a21o_2
XANTENNA__6835__B2 _7998_/B vssd1 vssd1 vccd1 vccd1 sky130_fd_sc_hd__diode_2
XANTENNA__7603__A _7603_/A vssd1 vssd1 vccd1 vccd1 sky130_fd_sc_hd__diode_2
Xfanout118 _4366_/X vssd1 vssd1 vccd1 vccd1 _4384_/B sky130_fd_sc_hd__clkdlybuf4s25_1
Xfanout129 _7299_/A vssd1 vssd1 vccd1 vccd1 _8410_/D sky130_fd_sc_hd__clkdlybuf4s25_1
X_7042_ _7042_/A _7042_/B vssd1 vssd1 vccd1 vccd1 _7045_/A sky130_fd_sc_hd__xor2_2
X_4254_ _8386_/Q _8445_/Q vssd1 vssd1 vccd1 vccd1 _4258_/B sky130_fd_sc_hd__or2_2
X_4185_ _4198_/B _8410_/Q _4184_/Y vssd1 vssd1 vccd1 vccd1 _6374_/A sky130_fd_sc_hd__o21ai_2
XFILLER_55_536 vssd1 vssd1 vccd1 vccd1 sky130_fd_sc_hd__fill_4
XFILLER_55_558 vssd1 vssd1 vccd1 vccd1 sky130_fd_sc_hd__fill_2
X_7944_ _7845_/A _7845_/B _7846_/Y vssd1 vssd1 vccd1 vccd1 _7982_/A sky130_fd_sc_hd__o21a_2
XANTENNA_fanout265_A _6517_/B vssd1 vssd1 vccd1 vccd1 sky130_fd_sc_hd__diode_2
XFILLER_55_569 vssd1 vssd1 vccd1 vccd1 sky130_fd_sc_hd__fill_1
XFILLER_70_506 vssd1 vssd1 vccd1 vccd1 sky130_fd_sc_hd__fill_1
X_7875_ _7875_/A _7875_/B _7875_/C _7875_/D vssd1 vssd1 vccd1 vccd1 _7875_/X sky130_fd_sc_hd__and4_2
XTAP_TAPCELL_ROW_81_1014 vssd1 vccd1 sky130_fd_sc_hd__tapvpwrvgnd_1
XTAP_TAPCELL_ROW_53_726 vssd1 vccd1 sky130_fd_sc_hd__tapvpwrvgnd_1
XFILLER_23_433 vssd1 vssd1 vccd1 vccd1 sky130_fd_sc_hd__fill_1
X_6826_ _6915_/B _6826_/B vssd1 vssd1 vccd1 vccd1 _6828_/A sky130_fd_sc_hd__nand2_2
X_6757_ _8414_/D _6757_/B vssd1 vssd1 vccd1 vccd1 _6759_/B sky130_fd_sc_hd__nand2_2
XANTENNA__6771__B1 _6986_/B vssd1 vssd1 vccd1 vccd1 sky130_fd_sc_hd__diode_2
X_5708_ _5709_/A _5709_/B vssd1 vssd1 vccd1 vccd1 _5964_/A sky130_fd_sc_hd__nand2b_2
XANTENNA_fanout318_X _6894_/B vssd1 vssd1 vccd1 vccd1 sky130_fd_sc_hd__diode_2
X_6688_ _6688_/A _6688_/B vssd1 vssd1 vccd1 vccd1 _6689_/C sky130_fd_sc_hd__and2_2
X_8427_ clkload6/A _8427_/D load_slew360/X vssd1 vssd1 vccd1 vccd1 _8427_/Q sky130_fd_sc_hd__dfrtp_2
X_5639_ _5640_/A _5640_/B _5640_/C vssd1 vssd1 vccd1 vccd1 _5639_/X sky130_fd_sc_hd__o21a_2
X_8358_ _8361_/CLK _8358_/D load_slew384/X vssd1 vssd1 vccd1 vccd1 _8358_/Q sky130_fd_sc_hd__dfrtp_2
X_7309_ _7082_/A _7082_/B _7084_/X vssd1 vssd1 vccd1 vccd1 _7317_/A sky130_fd_sc_hd__a21bo_2
XTAP_TAPCELL_ROW_92_1132 vssd1 vccd1 sky130_fd_sc_hd__tapvpwrvgnd_1
XTAP_TAPCELL_ROW_92_1121 vssd1 vccd1 sky130_fd_sc_hd__tapvpwrvgnd_1
X_8289_ _6433_/A _8168_/B _8396_/D vssd1 vssd1 vccd1 vccd1 _8364_/D sky130_fd_sc_hd__mux2_1
XTAP_TAPCELL_ROW_69_892 vssd1 vccd1 sky130_fd_sc_hd__tapvpwrvgnd_1
XFILLER_61_539 vssd1 vssd1 vccd1 vccd1 sky130_fd_sc_hd__fill_1
XFILLER_53_41 vssd1 vssd1 vccd1 vccd1 sky130_fd_sc_hd__fill_1
XFILLER_14_477 vssd1 vssd1 vccd1 vccd1 sky130_fd_sc_hd__fill_4
XFILLER_14_499 vssd1 vssd1 vccd1 vccd1 sky130_fd_sc_hd__fill_1
XANTENNA_clkbuf_4_12_0_clk_X _8402_/CLK vssd1 vssd1 vccd1 vccd1 sky130_fd_sc_hd__diode_2
XFILLER_37_525 vssd1 vssd1 vccd1 vccd1 sky130_fd_sc_hd__fill_1
XFILLER_64_300 vssd1 vssd1 vccd1 vccd1 sky130_fd_sc_hd__fill_8
XFILLER_83_119 vssd1 vssd1 vccd1 vccd1 sky130_fd_sc_hd__fill_1
XFILLER_64_322 vssd1 vssd1 vccd1 vccd1 sky130_fd_sc_hd__fill_1
XFILLER_64_333 vssd1 vssd1 vccd1 vccd1 sky130_fd_sc_hd__fill_8
XFILLER_76_193 vssd1 vssd1 vccd1 vccd1 sky130_fd_sc_hd__fill_2
XANTENNA__8254__A _8257_/A vssd1 vssd1 vccd1 vccd1 sky130_fd_sc_hd__diode_2
XFILLER_37_569 vssd1 vssd1 vccd1 vccd1 sky130_fd_sc_hd__fill_1
XFILLER_52_517 vssd1 vssd1 vccd1 vccd1 sky130_fd_sc_hd__fill_1
X_5990_ _5990_/A _5990_/B vssd1 vssd1 vccd1 vccd1 _5994_/A sky130_fd_sc_hd__xnor2_2
XFILLER_24_219 vssd1 vssd1 vccd1 vccd1 sky130_fd_sc_hd__fill_1
X_4941_ _4941_/A _4941_/B vssd1 vssd1 vccd1 vccd1 _4943_/A sky130_fd_sc_hd__nor2_2
XFILLER_60_550 vssd1 vssd1 vccd1 vccd1 sky130_fd_sc_hd__fill_4
X_7660_ _7655_/A _7655_/B _7659_/X vssd1 vssd1 vccd1 vccd1 _7660_/X sky130_fd_sc_hd__a21o_2
X_4872_ _4872_/A _4872_/B _4872_/C vssd1 vssd1 vccd1 vccd1 _4872_/Y sky130_fd_sc_hd__nand3_4
X_6611_ _6611_/A _7966_/B vssd1 vssd1 vccd1 vccd1 _6621_/A sky130_fd_sc_hd__or2_2
X_7591_ _7586_/B _7496_/B _7498_/B _7500_/X vssd1 vssd1 vccd1 vccd1 _7592_/B sky130_fd_sc_hd__a31oi_2
XANTENNA__6502__A _7140_/A vssd1 vssd1 vccd1 vccd1 sky130_fd_sc_hd__diode_2
X_6542_ _6541_/A _6541_/B _6541_/C vssd1 vssd1 vccd1 vccd1 _6550_/B sky130_fd_sc_hd__o21ai_2
X_6473_ _6473_/A _6473_/B vssd1 vssd1 vccd1 vccd1 _6474_/B sky130_fd_sc_hd__nand2_2
XTAP_TAPCELL_ROW_30_497 vssd1 vccd1 sky130_fd_sc_hd__tapvpwrvgnd_1
XFILLER_9_481 vssd1 vssd1 vccd1 vccd1 sky130_fd_sc_hd__fill_1
X_8212_ _8208_/A _8211_/Y _8313_/S vssd1 vssd1 vccd1 vccd1 _8343_/D sky130_fd_sc_hd__mux2_1
X_5424_ _8184_/A _5826_/A _5389_/B _5388_/A vssd1 vssd1 vccd1 vccd1 _5426_/B sky130_fd_sc_hd__a31o_2
X_8143_ _8143_/A _8143_/B vssd1 vssd1 vccd1 vccd1 _8145_/B sky130_fd_sc_hd__xnor2_2
X_5355_ _5355_/A _5355_/B vssd1 vssd1 vccd1 vccd1 _5445_/A sky130_fd_sc_hd__xnor2_2
XFILLER_87_414 vssd1 vssd1 vccd1 vccd1 sky130_fd_sc_hd__fill_1
X_8074_ _7980_/A _7979_/Y _7978_/A vssd1 vssd1 vccd1 vccd1 _8159_/A sky130_fd_sc_hd__a21oi_2
X_5286_ _5286_/A _5286_/B _5286_/C vssd1 vssd1 vccd1 vccd1 _5286_/X sky130_fd_sc_hd__and3_2
X_4306_ _5710_/B _5710_/C vssd1 vssd1 vccd1 vccd1 _4772_/B sky130_fd_sc_hd__nand2_2
XANTENNA__7052__B _7326_/B vssd1 vssd1 vccd1 vccd1 sky130_fd_sc_hd__diode_2
XANTENNA_fanout382_A fanout383/X vssd1 vssd1 vccd1 vccd1 sky130_fd_sc_hd__diode_2
X_7025_ _7025_/A _7025_/B vssd1 vssd1 vccd1 vccd1 _7026_/B sky130_fd_sc_hd__or2_2
X_4237_ _8379_/Q _8438_/Q vssd1 vssd1 vccd1 vccd1 _4362_/A sky130_fd_sc_hd__nand2_2
XFILLER_55_300 vssd1 vssd1 vccd1 vccd1 sky130_fd_sc_hd__fill_2
XANTENNA__4963__Y _6757_/B vssd1 vssd1 vccd1 vccd1 sky130_fd_sc_hd__diode_2
XANTENNA__6036__A2 _8208_/A vssd1 vssd1 vccd1 vccd1 sky130_fd_sc_hd__diode_2
X_4168_ _4227_/S _8424_/Q _4167_/Y vssd1 vssd1 vccd1 vccd1 _4674_/A sky130_fd_sc_hd__o21ai_4
XANTENNA__4692__A _8422_/D vssd1 vssd1 vccd1 vccd1 sky130_fd_sc_hd__diode_2
XFILLER_82_141 vssd1 vssd1 vccd1 vccd1 sky130_fd_sc_hd__fill_4
XTAP_TAPCELL_ROW_66_862 vssd1 vccd1 sky130_fd_sc_hd__tapvpwrvgnd_1
X_7927_ _7778_/B _7780_/B _7778_/A vssd1 vssd1 vccd1 vccd1 _7929_/B sky130_fd_sc_hd__o21ba_2
X_7858_ _7859_/B _7859_/A vssd1 vssd1 vccd1 vccd1 _8040_/A sky130_fd_sc_hd__nand2b_2
XANTENNA__7536__A2 _7725_/B vssd1 vssd1 vccd1 vccd1 sky130_fd_sc_hd__diode_2
XFILLER_51_561 vssd1 vssd1 vccd1 vccd1 sky130_fd_sc_hd__fill_1
X_6809_ _6809_/A _6809_/B vssd1 vssd1 vccd1 vccd1 _6810_/B sky130_fd_sc_hd__or2_2
X_7789_ _7587_/A _7587_/B _7590_/A vssd1 vssd1 vccd1 vccd1 _7790_/C sky130_fd_sc_hd__a21oi_2
XFILLER_23_66 vssd1 vssd1 vccd1 vccd1 sky130_fd_sc_hd__fill_8
XANTENNA__7942__S _8071_/S vssd1 vssd1 vccd1 vccd1 sky130_fd_sc_hd__diode_2
XFILLER_3_3 vssd1 vssd1 vccd1 vccd1 sky130_fd_sc_hd__fill_2
XFILLER_48_41 vssd1 vssd1 vccd1 vccd1 sky130_fd_sc_hd__fill_2
XANTENNA__7897__B _7897_/B vssd1 vssd1 vccd1 vccd1 sky130_fd_sc_hd__diode_2
XFILLER_19_503 vssd1 vssd1 vccd1 vccd1 sky130_fd_sc_hd__fill_1
XFILLER_46_300 vssd1 vssd1 vccd1 vccd1 sky130_fd_sc_hd__fill_2
XFILLER_64_40 vssd1 vssd1 vccd1 vccd1 sky130_fd_sc_hd__fill_4
XFILLER_9_57 vssd1 vssd1 vccd1 vccd1 sky130_fd_sc_hd__fill_1
XFILLER_6_495 vssd1 vssd1 vccd1 vccd1 sky130_fd_sc_hd__fill_4
XANTENNA__4777__A _5157_/A vssd1 vssd1 vccd1 vccd1 sky130_fd_sc_hd__diode_2
XANTENNA__4496__B _8430_/D vssd1 vssd1 vccd1 vccd1 sky130_fd_sc_hd__diode_2
XFILLER_36_3 vssd1 vssd1 vccd1 vccd1 sky130_fd_sc_hd__fill_2
X_5140_ _5140_/A _5140_/B vssd1 vssd1 vccd1 vccd1 _5142_/B sky130_fd_sc_hd__xor2_2
X_5071_ _5071_/A _5071_/B vssd1 vssd1 vccd1 vccd1 _5072_/B sky130_fd_sc_hd__xnor2_2
XFILLER_84_428 vssd1 vssd1 vccd1 vccd1 sky130_fd_sc_hd__fill_4
XANTENNA__7600__B _7966_/B vssd1 vssd1 vccd1 vccd1 sky130_fd_sc_hd__diode_2
XFILLER_92_461 vssd1 vssd1 vccd1 vccd1 sky130_fd_sc_hd__fill_2
XANTENNA__5401__A _8215_/A vssd1 vssd1 vccd1 vccd1 sky130_fd_sc_hd__diode_2
X_5973_ _5973_/A _5973_/B vssd1 vssd1 vccd1 vccd1 _5974_/B sky130_fd_sc_hd__xnor2_2
X_7712_ _7652_/A _7652_/B _7651_/B _7713_/A _7649_/Y vssd1 vssd1 vccd1 vccd1 _7850_/B
+ sky130_fd_sc_hd__a311o_2
X_4924_ _4924_/A _4924_/B vssd1 vssd1 vccd1 vccd1 _4944_/B sky130_fd_sc_hd__xnor2_2
XTAP_TAPCELL_ROW_63_832 vssd1 vccd1 sky130_fd_sc_hd__tapvpwrvgnd_1
XANTENNA__8431__RESET_B wire362/X vssd1 vssd1 vccd1 vccd1 sky130_fd_sc_hd__diode_2
X_7643_ _7643_/A _7643_/B vssd1 vssd1 vccd1 vccd1 _7646_/A sky130_fd_sc_hd__xnor2_2
X_4855_ _4856_/B _4856_/A vssd1 vssd1 vccd1 vccd1 _4855_/X sky130_fd_sc_hd__and2b_2
XANTENNA_fanout130_A _7095_/A vssd1 vssd1 vccd1 vccd1 sky130_fd_sc_hd__diode_2
XANTENNA_fanout228_A _7875_/A vssd1 vssd1 vccd1 vccd1 sky130_fd_sc_hd__diode_2
X_7574_ _7574_/A _7574_/B _7574_/C vssd1 vssd1 vccd1 vccd1 _7785_/A sky130_fd_sc_hd__or3_2
X_4786_ _4843_/B _4785_/C _4785_/A vssd1 vssd1 vccd1 vccd1 _4787_/B sky130_fd_sc_hd__a21oi_2
X_6525_ _6525_/A _6525_/B vssd1 vssd1 vccd1 vccd1 _6528_/A sky130_fd_sc_hd__xnor2_2
X_6456_ _6235_/A _6237_/B _6235_/B vssd1 vssd1 vccd1 vccd1 _6458_/C sky130_fd_sc_hd__o21ba_2
XANTENNA__5701__B2 _4700_/B vssd1 vssd1 vccd1 vccd1 sky130_fd_sc_hd__diode_2
X_6387_ _6387_/A _6387_/B vssd1 vssd1 vccd1 vccd1 _6389_/B sky130_fd_sc_hd__xor2_2
X_5407_ _5407_/A _5407_/B vssd1 vssd1 vccd1 vccd1 _5409_/B sky130_fd_sc_hd__or2_2
X_8126_ _8126_/A _8126_/B vssd1 vssd1 vccd1 vccd1 _8127_/B sky130_fd_sc_hd__nand2_2
X_5338_ _5618_/A _8202_/A _5569_/C _5569_/D vssd1 vssd1 vccd1 vccd1 _5339_/B sky130_fd_sc_hd__and4_2
XANTENNA__7998__A _7998_/A vssd1 vssd1 vccd1 vccd1 sky130_fd_sc_hd__diode_2
X_8057_ _8057_/A _8057_/B vssd1 vssd1 vccd1 vccd1 _8059_/C sky130_fd_sc_hd__xnor2_2
X_7008_ _8082_/A _7007_/B _6737_/Y vssd1 vssd1 vccd1 vccd1 _7008_/X sky130_fd_sc_hd__o21a_2
X_5269_ _5269_/A _5269_/B vssd1 vssd1 vccd1 vccd1 _5278_/A sky130_fd_sc_hd__xnor2_2
XFILLER_28_300 vssd1 vssd1 vccd1 vccd1 sky130_fd_sc_hd__fill_1
XFILLER_16_539 vssd1 vssd1 vccd1 vccd1 sky130_fd_sc_hd__fill_1
XFILLER_83_483 vssd1 vssd1 vccd1 vccd1 sky130_fd_sc_hd__fill_2
XTAP_TAPCELL_ROW_87_1075 vssd1 vccd1 sky130_fd_sc_hd__tapvpwrvgnd_1
XFILLER_11_200 vssd1 vssd1 vccd1 vccd1 sky130_fd_sc_hd__fill_1
XFILLER_34_76 vssd1 vssd1 vccd1 vccd1 sky130_fd_sc_hd__fill_2
XFILLER_70_199 vssd1 vssd1 vccd1 vccd1 sky130_fd_sc_hd__fill_1
XANTENNA__8182__A2 _4144_/Y vssd1 vssd1 vccd1 vccd1 sky130_fd_sc_hd__diode_2
XFILLER_11_299 vssd1 vssd1 vccd1 vccd1 sky130_fd_sc_hd__fill_2
XFILLER_3_443 vssd1 vssd1 vccd1 vccd1 sky130_fd_sc_hd__fill_4
Xload_slew107 _4629_/B vssd1 vssd1 vccd1 vccd1 _4692_/B sky130_fd_sc_hd__buf_4
XFILLER_78_244 vssd1 vssd1 vccd1 vccd1 sky130_fd_sc_hd__fill_8
XFILLER_78_288 vssd1 vssd1 vccd1 vccd1 sky130_fd_sc_hd__fill_1
XFILLER_78_299 vssd1 vssd1 vccd1 vccd1 sky130_fd_sc_hd__fill_1
Xfanout290 _8353_/Q vssd1 vssd1 vccd1 vccd1 _8266_/A sky130_fd_sc_hd__clkdlybuf4s25_1
XFILLER_19_366 vssd1 vssd1 vccd1 vccd1 sky130_fd_sc_hd__fill_1
XTAP_TAPCELL_ROW_77_968 vssd1 vccd1 sky130_fd_sc_hd__tapvpwrvgnd_1
XANTENNA__7748__A2 _7897_/B vssd1 vssd1 vccd1 vccd1 sky130_fd_sc_hd__diode_2
XANTENNA_clkload6_A clkload6/A vssd1 vssd1 vccd1 vccd1 sky130_fd_sc_hd__diode_2
Xload_slew54 _6641_/B vssd1 vssd1 vccd1 vccd1 _7685_/B sky130_fd_sc_hd__clkbuf_4
XFILLER_61_111 vssd1 vssd1 vccd1 vccd1 sky130_fd_sc_hd__fill_1
XTAP_TAPCELL_ROW_60_802 vssd1 vccd1 sky130_fd_sc_hd__tapvpwrvgnd_1
X_4640_ _4640_/A _4640_/B vssd1 vssd1 vccd1 vccd1 _4643_/A sky130_fd_sc_hd__nor2_4
X_6310_ _6310_/A _6310_/B vssd1 vssd1 vccd1 vccd1 _6312_/A sky130_fd_sc_hd__xnor2_2
X_4571_ _4591_/A _4571_/A2 _4569_/A vssd1 vssd1 vccd1 vccd1 _4574_/A sky130_fd_sc_hd__a21oi_2
X_7290_ _7290_/A _7290_/B _7290_/C vssd1 vssd1 vccd1 vccd1 _7291_/B sky130_fd_sc_hd__nor3_2
X_6241_ _6438_/A _8346_/Q vssd1 vssd1 vccd1 vccd1 _6242_/B sky130_fd_sc_hd__nand2_2
X_6172_ _8418_/D _6738_/B vssd1 vssd1 vccd1 vccd1 _6348_/A sky130_fd_sc_hd__nand2_2
XANTENNA__6239__A2 _6894_/B vssd1 vssd1 vccd1 vccd1 sky130_fd_sc_hd__diode_2
X_5123_ _5072_/A _5072_/B _5070_/Y vssd1 vssd1 vccd1 vccd1 _5125_/B sky130_fd_sc_hd__o21ai_2
XFILLER_29_119 vssd1 vssd1 vccd1 vccd1 sky130_fd_sc_hd__fill_1
XFILLER_84_214 vssd1 vssd1 vccd1 vccd1 sky130_fd_sc_hd__fill_2
XFILLER_84_236 vssd1 vssd1 vccd1 vccd1 sky130_fd_sc_hd__fill_8
X_5054_ _5054_/A _5054_/B vssd1 vssd1 vccd1 vccd1 _5055_/B sky130_fd_sc_hd__nor2_2
XANTENNA__5131__A _5928_/A vssd1 vssd1 vccd1 vccd1 sky130_fd_sc_hd__diode_2
XANTENNA_fanout178_A _4762_/A vssd1 vssd1 vccd1 vccd1 sky130_fd_sc_hd__diode_2
XFILLER_1_80 vssd1 vssd1 vccd1 vccd1 sky130_fd_sc_hd__fill_2
XFILLER_52_100 vssd1 vssd1 vccd1 vccd1 sky130_fd_sc_hd__fill_1
XTAP_TAPCELL_ROW_48_681 vssd1 vccd1 sky130_fd_sc_hd__tapvpwrvgnd_1
XFILLER_52_166 vssd1 vssd1 vccd1 vccd1 sky130_fd_sc_hd__fill_2
X_5956_ _5956_/A _5956_/B vssd1 vssd1 vccd1 vccd1 _5959_/A sky130_fd_sc_hd__xnor2_2
XFILLER_33_391 vssd1 vssd1 vccd1 vccd1 sky130_fd_sc_hd__fill_1
X_5887_ _5771_/A _5768_/Y _5769_/X _5772_/B _5772_/A vssd1 vssd1 vccd1 vccd1 _5995_/A
+ sky130_fd_sc_hd__a32oi_2
X_4907_ _4970_/A _4906_/C _4906_/A vssd1 vssd1 vccd1 vccd1 _4953_/B sky130_fd_sc_hd__a21o_2
X_7626_ _7626_/A _7686_/A vssd1 vssd1 vccd1 vccd1 _7626_/Y sky130_fd_sc_hd__nor2_2
X_4838_ _4838_/A _4838_/B vssd1 vssd1 vccd1 vccd1 _4840_/A sky130_fd_sc_hd__or2_2
X_7557_ _8001_/A _8126_/B vssd1 vssd1 vccd1 vccd1 _7558_/B sky130_fd_sc_hd__nand2_2
X_4769_ _5724_/A _4770_/B vssd1 vssd1 vccd1 vccd1 _4860_/A sky130_fd_sc_hd__nor2_2
XANTENNA_fanout300_X _7725_/B vssd1 vssd1 vccd1 vccd1 sky130_fd_sc_hd__diode_2
X_7488_ _7489_/A _7489_/B _7489_/C vssd1 vssd1 vccd1 vccd1 _7589_/A sky130_fd_sc_hd__a21oi_2
X_6508_ _6508_/A _6508_/B vssd1 vssd1 vccd1 vccd1 _6510_/B sky130_fd_sc_hd__xnor2_2
X_6439_ _6439_/A _6439_/B vssd1 vssd1 vccd1 vccd1 _6442_/A sky130_fd_sc_hd__xnor2_2
XANTENNA__7427__A1 _7515_/A vssd1 vssd1 vccd1 vccd1 sky130_fd_sc_hd__diode_2
XFILLER_88_531 vssd1 vssd1 vccd1 vccd1 sky130_fd_sc_hd__fill_1
X_8109_ _8110_/A _8277_/A _8361_/Q _8110_/B vssd1 vssd1 vccd1 vccd1 _8111_/C sky130_fd_sc_hd__a22o_2
XANTENNA__7427__B2 _7426_/A vssd1 vssd1 vccd1 vccd1 sky130_fd_sc_hd__diode_2
XFILLER_48_406 vssd1 vssd1 vccd1 vccd1 sky130_fd_sc_hd__fill_1
XFILLER_29_54 vssd1 vssd1 vccd1 vccd1 sky130_fd_sc_hd__fill_2
XFILLER_56_472 vssd1 vssd1 vccd1 vccd1 sky130_fd_sc_hd__fill_4
XTAP_TAPCELL_ROW_74_938 vssd1 vccd1 sky130_fd_sc_hd__tapvpwrvgnd_1
XANTENNA__8353__RESET_B fanout383/X vssd1 vssd1 vccd1 vccd1 sky130_fd_sc_hd__diode_2
XANTENNA_fanout46_X _6986_/B vssd1 vssd1 vccd1 vccd1 sky130_fd_sc_hd__diode_2
XFILLER_71_431 vssd1 vssd1 vccd1 vccd1 sky130_fd_sc_hd__fill_2
XFILLER_71_464 vssd1 vssd1 vccd1 vccd1 sky130_fd_sc_hd__fill_4
XFILLER_61_85 vssd1 vssd1 vccd1 vccd1 sky130_fd_sc_hd__fill_4
XANTENNA__4716__A2 _4487_/B vssd1 vssd1 vccd1 vccd1 sky130_fd_sc_hd__diode_2
XANTENNA__7666__A1 _7969_/A vssd1 vssd1 vccd1 vccd1 sky130_fd_sc_hd__diode_2
XANTENNA__5429__B1 _6001_/A vssd1 vssd1 vccd1 vccd1 sky130_fd_sc_hd__diode_2
XANTENNA__8246__B input9/X vssd1 vssd1 vccd1 vccd1 sky130_fd_sc_hd__diode_2
XANTENNA__8262__A _8263_/A vssd1 vssd1 vccd1 vccd1 sky130_fd_sc_hd__diode_2
XFILLER_62_453 vssd1 vssd1 vccd1 vccd1 sky130_fd_sc_hd__fill_4
X_6790_ _6790_/A _6790_/B vssd1 vssd1 vccd1 vccd1 _6792_/B sky130_fd_sc_hd__xnor2_2
X_5810_ _5811_/B _5811_/A vssd1 vssd1 vccd1 vccd1 _5810_/X sky130_fd_sc_hd__and2b_2
XTAP_TAPCELL_ROW_45_651 vssd1 vccd1 sky130_fd_sc_hd__tapvpwrvgnd_1
X_5741_ _5739_/A _5943_/A _5740_/X vssd1 vssd1 vccd1 vccd1 _5743_/A sky130_fd_sc_hd__o21ai_2
XTAP_TAPCELL_ROW_17_375 vssd1 vccd1 sky130_fd_sc_hd__tapvpwrvgnd_1
X_7411_ _7412_/B _7412_/A vssd1 vssd1 vccd1 vccd1 _7411_/Y sky130_fd_sc_hd__nand2b_2
X_5672_ _5660_/Y _5671_/X _5664_/Y _5662_/X vssd1 vssd1 vccd1 vccd1 _5672_/X sky130_fd_sc_hd__a211o_2
X_8391_ clkload1/A _8391_/D fanout372/A vssd1 vssd1 vccd1 vccd1 _8391_/Q sky130_fd_sc_hd__dfrtp_2
X_4623_ _4623_/A _4709_/D vssd1 vssd1 vccd1 vccd1 _4623_/Y sky130_fd_sc_hd__nand2_2
X_7342_ _7077_/B _7089_/B _7077_/A vssd1 vssd1 vccd1 vccd1 _7343_/C sky130_fd_sc_hd__o21ba_2
X_4554_ _4554_/A _4554_/B vssd1 vssd1 vccd1 vccd1 _4574_/B sky130_fd_sc_hd__or2_4
XANTENNA__4301__Y _4770_/B vssd1 vssd1 vccd1 vccd1 sky130_fd_sc_hd__diode_2
Xhold535 _8322_/Q vssd1 vssd1 vccd1 vccd1 hold535/X sky130_fd_sc_hd__dlygate4sd3_1
Xhold524 _8387_/Q vssd1 vssd1 vccd1 vccd1 _8446_/D sky130_fd_sc_hd__dlygate4sd3_1
Xhold513 _8398_/Q vssd1 vssd1 vccd1 vccd1 _8404_/D sky130_fd_sc_hd__dlygate4sd3_1
X_7273_ _7273_/A _7273_/B _7273_/C vssd1 vssd1 vccd1 vccd1 _7274_/B sky130_fd_sc_hd__and3_2
Xhold546 _8329_/Q vssd1 vssd1 vccd1 vccd1 hold546/X sky130_fd_sc_hd__dlygate4sd3_1
X_6224_ _6447_/A _6224_/B vssd1 vssd1 vccd1 vccd1 _6226_/B sky130_fd_sc_hd__and2_2
X_4485_ _5155_/A _4931_/D vssd1 vssd1 vccd1 vccd1 _4486_/A sky130_fd_sc_hd__nand2_2
XANTENNA__4340__B1 _5703_/B vssd1 vssd1 vccd1 vccd1 sky130_fd_sc_hd__diode_2
XANTENNA__4965__A _5983_/A vssd1 vssd1 vccd1 vccd1 sky130_fd_sc_hd__diode_2
XANTENNA_fanout295_A _6517_/D vssd1 vssd1 vccd1 vccd1 sky130_fd_sc_hd__diode_2
X_6155_ _8412_/D _6360_/B _5903_/A _5900_/Y vssd1 vssd1 vccd1 vccd1 _6163_/A sky130_fd_sc_hd__a31o_2
XFILLER_57_225 vssd1 vssd1 vccd1 vccd1 sky130_fd_sc_hd__fill_1
XFILLER_57_236 vssd1 vssd1 vccd1 vccd1 sky130_fd_sc_hd__fill_4
XFILLER_66_19 vssd1 vssd1 vccd1 vccd1 sky130_fd_sc_hd__fill_1
X_6086_ _5767_/B _5983_/Y _5986_/B _5986_/A vssd1 vssd1 vccd1 vccd1 _6154_/A sky130_fd_sc_hd__a22o_2
X_5106_ _8415_/D _6738_/B vssd1 vssd1 vccd1 vccd1 _5787_/A sky130_fd_sc_hd__nand2_2
X_5037_ _5037_/A _5037_/B vssd1 vssd1 vccd1 vccd1 _5037_/X sky130_fd_sc_hd__and2_2
XTAP_TAPCELL_ROW_71_908 vssd1 vccd1 sky130_fd_sc_hd__tapvpwrvgnd_1
XANTENNA_fanout250_X _8103_/B vssd1 vssd1 vccd1 vccd1 sky130_fd_sc_hd__diode_2
XFILLER_53_464 vssd1 vssd1 vccd1 vccd1 sky130_fd_sc_hd__fill_1
XTAP_TAPCELL_ROW_84_1045 vssd1 vccd1 sky130_fd_sc_hd__tapvpwrvgnd_1
XANTENNA__6396__B2 _6001_/A vssd1 vssd1 vccd1 vccd1 sky130_fd_sc_hd__diode_2
XFILLER_13_339 vssd1 vssd1 vccd1 vccd1 sky130_fd_sc_hd__fill_1
X_6988_ _4147_/Y _5195_/Y _6770_/Y vssd1 vssd1 vccd1 vccd1 _6988_/Y sky130_fd_sc_hd__a21oi_2
XFILLER_15_67 vssd1 vssd1 vccd1 vccd1 sky130_fd_sc_hd__fill_1
X_5939_ _6712_/A _6582_/B vssd1 vssd1 vccd1 vccd1 _5941_/A sky130_fd_sc_hd__nand2_2
XANTENNA__7219__C _7714_/A vssd1 vssd1 vccd1 vccd1 sky130_fd_sc_hd__diode_2
XFILLER_31_22 vssd1 vssd1 vccd1 vccd1 sky130_fd_sc_hd__fill_2
XFILLER_5_505 vssd1 vssd1 vccd1 vccd1 sky130_fd_sc_hd__fill_2
X_7609_ _7969_/A _7954_/B _7387_/X _7386_/Y vssd1 vssd1 vccd1 vccd1 _7619_/A sky130_fd_sc_hd__o31ai_2
Xclkbuf_4_10_0_clk clkbuf_0_clk/X vssd1 vssd1 vccd1 vccd1 _8382_/CLK sky130_fd_sc_hd__clkbuf_8
Xoutput33 _8332_/Q vssd1 vssd1 vccd1 vccd1 gpio_out[30] sky130_fd_sc_hd__clkdlybuf4s25_1
Xoutput22 _8321_/Q vssd1 vssd1 vccd1 vccd1 gpio_out[19] sky130_fd_sc_hd__clkdlybuf4s25_1
XANTENNA__7889__C _8103_/D vssd1 vssd1 vccd1 vccd1 sky130_fd_sc_hd__diode_2
XFILLER_76_545 vssd1 vssd1 vccd1 vccd1 sky130_fd_sc_hd__fill_1
XTAP_TAPCELL_ROW_59_787 vssd1 vccd1 sky130_fd_sc_hd__tapvpwrvgnd_1
XFILLER_31_125 vssd1 vssd1 vccd1 vccd1 sky130_fd_sc_hd__fill_1
XTAP_TAPCELL_ROW_42_621 vssd1 vccd1 sky130_fd_sc_hd__tapvpwrvgnd_1
XFILLER_72_73 vssd1 vssd1 vccd1 vccd1 sky130_fd_sc_hd__fill_2
XTAP_TAPCELL_ROW_14_345 vssd1 vccd1 sky130_fd_sc_hd__tapvpwrvgnd_1
XANTENNA__7129__C _7515_/A vssd1 vssd1 vccd1 vccd1 sky130_fd_sc_hd__diode_2
XFILLER_12_350 vssd1 vssd1 vccd1 vccd1 sky130_fd_sc_hd__fill_1
XANTENNA__7426__A _7426_/A vssd1 vssd1 vccd1 vccd1 sky130_fd_sc_hd__diode_2
XANTENNA__4769__B _4770_/B vssd1 vssd1 vccd1 vccd1 sky130_fd_sc_hd__diode_2
X_4270_ _8387_/Q _8446_/Q _8388_/Q _8447_/Q vssd1 vssd1 vccd1 vccd1 _4270_/X sky130_fd_sc_hd__a22o_2
XANTENNA__8257__A _8257_/A vssd1 vssd1 vccd1 vccd1 sky130_fd_sc_hd__diode_2
XFILLER_67_501 vssd1 vssd1 vccd1 vccd1 sky130_fd_sc_hd__fill_2
X_7960_ _7960_/A _7960_/B vssd1 vssd1 vccd1 vccd1 _7962_/C sky130_fd_sc_hd__xor2_2
XFILLER_54_239 vssd1 vssd1 vccd1 vccd1 sky130_fd_sc_hd__fill_1
X_7891_ _8110_/B _8359_/Q vssd1 vssd1 vccd1 vccd1 _7892_/B sky130_fd_sc_hd__nand2_2
X_6911_ _6911_/A _6911_/B vssd1 vssd1 vccd1 vccd1 _6912_/C sky130_fd_sc_hd__xnor2_2
XANTENNA__6505__A _7233_/A vssd1 vssd1 vccd1 vccd1 sky130_fd_sc_hd__diode_2
X_6842_ _6843_/A _6843_/B vssd1 vssd1 vccd1 vccd1 _6937_/B sky130_fd_sc_hd__and2_2
XFILLER_35_486 vssd1 vssd1 vccd1 vccd1 sky130_fd_sc_hd__fill_2
XFILLER_62_261 vssd1 vssd1 vccd1 vccd1 sky130_fd_sc_hd__fill_2
XFILLER_22_136 vssd1 vssd1 vccd1 vccd1 sky130_fd_sc_hd__fill_4
XFILLER_62_294 vssd1 vssd1 vccd1 vccd1 sky130_fd_sc_hd__fill_1
X_6773_ _7409_/A _7084_/B vssd1 vssd1 vccd1 vccd1 _6775_/B sky130_fd_sc_hd__nor2_2
XFILLER_10_309 vssd1 vssd1 vccd1 vccd1 sky130_fd_sc_hd__fill_2
X_5724_ _5724_/A _5952_/A _5147_/B vssd1 vssd1 vccd1 vccd1 _5726_/A sky130_fd_sc_hd__or3b_2
X_8443_ clkload0/A _8443_/D wire368/X vssd1 vssd1 vccd1 vccd1 _8443_/Q sky130_fd_sc_hd__dfrtp_2
X_5655_ _5655_/A _5655_/B vssd1 vssd1 vccd1 vccd1 _5656_/B sky130_fd_sc_hd__and2_2
X_8374_ clkload9/A _8374_/D load_slew373/X vssd1 vssd1 vccd1 vccd1 _8374_/Q sky130_fd_sc_hd__dfrtp_2
X_4606_ _4580_/A _4631_/A _4605_/X vssd1 vssd1 vccd1 vccd1 _4607_/B sky130_fd_sc_hd__o21ba_2
XANTENNA__5353__A2 _5386_/C vssd1 vssd1 vccd1 vccd1 sky130_fd_sc_hd__diode_2
X_7325_ _7685_/A _7326_/B wire72/X _7820_/A vssd1 vssd1 vccd1 vccd1 _7325_/X sky130_fd_sc_hd__a22o_2
X_5586_ _5587_/A _5587_/B _5587_/C vssd1 vssd1 vccd1 vccd1 _5597_/A sky130_fd_sc_hd__a21o_2
XFILLER_2_508 vssd1 vssd1 vccd1 vccd1 sky130_fd_sc_hd__fill_4
X_4537_ _4537_/A _4537_/B vssd1 vssd1 vccd1 vccd1 _4539_/B sky130_fd_sc_hd__xnor2_2
XANTENNA__6894__B _6894_/B vssd1 vssd1 vccd1 vccd1 sky130_fd_sc_hd__diode_2
X_7256_ _7256_/A _7256_/B vssd1 vssd1 vccd1 vccd1 _7258_/B sky130_fd_sc_hd__xnor2_2
X_4468_ _4469_/A _4469_/B vssd1 vssd1 vccd1 vccd1 _4805_/B sky130_fd_sc_hd__nand2b_2
XFILLER_89_169 vssd1 vssd1 vccd1 vccd1 sky130_fd_sc_hd__fill_4
X_7187_ _7187_/A _7284_/B vssd1 vssd1 vccd1 vccd1 _7188_/C sky130_fd_sc_hd__nor2_2
X_6207_ _6207_/A _6892_/B _6482_/B _6485_/B vssd1 vssd1 vccd1 vccd1 _6420_/A sky130_fd_sc_hd__and4_2
XANTENNA_fanout298_X _6517_/D vssd1 vssd1 vccd1 vccd1 sky130_fd_sc_hd__diode_2
X_6138_ _6138_/A _6138_/B vssd1 vssd1 vccd1 vccd1 _6138_/Y sky130_fd_sc_hd__xnor2_2
X_4399_ _8430_/D _4780_/B _4399_/C vssd1 vssd1 vccd1 vccd1 _4402_/B sky130_fd_sc_hd__and3_2
XANTENNA__5303__B _5826_/A vssd1 vssd1 vccd1 vccd1 sky130_fd_sc_hd__diode_2
X_6069_ _6069_/A _6069_/B vssd1 vssd1 vccd1 vccd1 _6071_/C sky130_fd_sc_hd__xnor2_2
XTAP_TAPCELL_ROW_56_757 vssd1 vccd1 sky130_fd_sc_hd__tapvpwrvgnd_1
XANTENNA__8378__CLK _8402_/CLK vssd1 vssd1 vccd1 vccd1 sky130_fd_sc_hd__diode_2
XFILLER_53_294 vssd1 vssd1 vccd1 vccd1 sky130_fd_sc_hd__fill_2
XANTENNA__4156__A_N input19/X vssd1 vssd1 vccd1 vccd1 sky130_fd_sc_hd__diode_2
XTAP_TAPCELL_ROW_11_315 vssd1 vccd1 sky130_fd_sc_hd__tapvpwrvgnd_1
Xrebuffer440 _4670_/B vssd1 vssd1 vccd1 vccd1 _4650_/A3 sky130_fd_sc_hd__buf_2
Xrebuffer484 _6732_/B vssd1 vssd1 vccd1 vccd1 _6967_/A2 sky130_fd_sc_hd__buf_2
Xrebuffer473 _4155_/A vssd1 vssd1 vccd1 vccd1 _4770_/A sky130_fd_sc_hd__buf_2
Xrebuffer462 wire385/X vssd1 vssd1 vccd1 vccd1 _8208_/B sky130_fd_sc_hd__buf_2
Xrebuffer451 _4676_/A vssd1 vssd1 vccd1 vccd1 _4683_/A sky130_fd_sc_hd__buf_2
Xrebuffer495 _4158_/A vssd1 vssd1 vccd1 vccd1 _4772_/A sky130_fd_sc_hd__buf_2
XANTENNA__8294__A1 _8196_/B vssd1 vssd1 vccd1 vccd1 sky130_fd_sc_hd__diode_2
XFILLER_36_228 vssd1 vssd1 vccd1 vccd1 sky130_fd_sc_hd__fill_1
XFILLER_17_497 vssd1 vssd1 vccd1 vccd1 sky130_fd_sc_hd__fill_2
XFILLER_32_423 vssd1 vssd1 vccd1 vccd1 sky130_fd_sc_hd__fill_1
XTAP_TAPCELL_ROW_27_470 vssd1 vccd1 sky130_fd_sc_hd__tapvpwrvgnd_1
XPHY_EDGE_ROW_17_Left_110 vssd1 vssd1 vccd1 vccd1 sky130_fd_sc_hd__decap_3
XFILLER_32_489 vssd1 vssd1 vccd1 vccd1 sky130_fd_sc_hd__fill_2
XANTENNA__5883__B _5883_/B vssd1 vssd1 vccd1 vccd1 sky130_fd_sc_hd__diode_2
X_5440_ _5440_/A _5444_/A vssd1 vssd1 vccd1 vccd1 _5441_/B sky130_fd_sc_hd__or2_2
XFILLER_66_3 vssd1 vssd1 vccd1 vccd1 sky130_fd_sc_hd__fill_1
X_5371_ _5372_/A _5372_/B vssd1 vssd1 vccd1 vccd1 _5412_/B sky130_fd_sc_hd__and2_2
X_8090_ _8090_/A _8090_/B vssd1 vssd1 vccd1 vccd1 _8091_/B sky130_fd_sc_hd__xnor2_2
X_7110_ _7111_/A _7111_/B vssd1 vssd1 vccd1 vccd1 _7352_/A sky130_fd_sc_hd__or2_2
X_4322_ _4282_/A _4279_/Y _4281_/B _4274_/C vssd1 vssd1 vccd1 vccd1 _4322_/X sky130_fd_sc_hd__o211a_2
XANTENNA__6835__A2 _7723_/C vssd1 vssd1 vccd1 vccd1 sky130_fd_sc_hd__diode_2
XANTENNA__7603__B _7603_/B vssd1 vssd1 vccd1 vccd1 sky130_fd_sc_hd__diode_2
Xfanout108 _4657_/B vssd1 vssd1 vccd1 vccd1 _4979_/B sky130_fd_sc_hd__clkdlybuf4s25_1
X_7041_ _7042_/A _7042_/B vssd1 vssd1 vccd1 vccd1 _7041_/X sky130_fd_sc_hd__and2_2
X_4253_ _8385_/Q _8444_/Q vssd1 vssd1 vccd1 vccd1 _4303_/A sky130_fd_sc_hd__nand2_2
XFILLER_86_106 vssd1 vssd1 vccd1 vccd1 sky130_fd_sc_hd__fill_1
X_4184_ _8184_/B _4198_/B vssd1 vssd1 vccd1 vccd1 _4184_/Y sky130_fd_sc_hd__nand2b_2
XFILLER_27_217 vssd1 vssd1 vccd1 vccd1 sky130_fd_sc_hd__fill_1
X_7943_ _7848_/A _7848_/B _7938_/A vssd1 vssd1 vccd1 vccd1 _7984_/B sky130_fd_sc_hd__a21bo_2
XANTENNA_fanout160_A _4177_/Y vssd1 vssd1 vccd1 vccd1 sky130_fd_sc_hd__diode_2
XANTENNA_fanout258_A _6517_/A vssd1 vssd1 vccd1 vccd1 sky130_fd_sc_hd__diode_2
X_7874_ _7877_/D vssd1 vssd1 vccd1 vccd1 _7874_/Y sky130_fd_sc_hd__inv_2
XTAP_TAPCELL_ROW_81_1015 vssd1 vccd1 sky130_fd_sc_hd__tapvpwrvgnd_1
XTAP_TAPCELL_ROW_53_727 vssd1 vccd1 sky130_fd_sc_hd__tapvpwrvgnd_1
XFILLER_35_294 vssd1 vssd1 vccd1 vccd1 sky130_fd_sc_hd__fill_1
X_6825_ _6915_/A _6824_/B _6824_/C vssd1 vssd1 vccd1 vccd1 _6826_/B sky130_fd_sc_hd__a21o_2
XFILLER_50_253 vssd1 vssd1 vccd1 vccd1 sky130_fd_sc_hd__fill_4
X_6756_ _8415_/D _7685_/B vssd1 vssd1 vccd1 vccd1 _7071_/A sky130_fd_sc_hd__nand2_2
XANTENNA__6771__B2 _7603_/A vssd1 vssd1 vccd1 vccd1 sky130_fd_sc_hd__diode_2
X_5707_ _5169_/A _5169_/B _5167_/Y vssd1 vssd1 vccd1 vccd1 _5709_/B sky130_fd_sc_hd__a21bo_2
X_6687_ _6688_/A _6688_/B vssd1 vssd1 vccd1 vccd1 _6689_/B sky130_fd_sc_hd__nor2_2
X_8426_ clkload6/A _8426_/D fanout357/X vssd1 vssd1 vccd1 vccd1 _8426_/Q sky130_fd_sc_hd__dfrtp_2
X_5638_ _5638_/A _5638_/B vssd1 vssd1 vccd1 vccd1 _5640_/C sky130_fd_sc_hd__and2_2
X_8357_ _8361_/CLK _8357_/D load_slew384/X vssd1 vssd1 vccd1 vccd1 _8357_/Q sky130_fd_sc_hd__dfrtp_2
X_5569_ _5569_/A _5647_/A _5569_/C _5569_/D vssd1 vssd1 vccd1 vccd1 _5571_/A sky130_fd_sc_hd__and4_2
XFILLER_2_316 vssd1 vssd1 vccd1 vccd1 sky130_fd_sc_hd__fill_1
X_7308_ _7308_/A _7308_/B vssd1 vssd1 vccd1 vccd1 _7346_/A sky130_fd_sc_hd__xor2_2
XTAP_TAPCELL_ROW_92_1133 vssd1 vccd1 sky130_fd_sc_hd__tapvpwrvgnd_1
XTAP_TAPCELL_ROW_92_1122 vssd1 vccd1 sky130_fd_sc_hd__tapvpwrvgnd_1
X_8288_ _6460_/A _8164_/B _8396_/D vssd1 vssd1 vccd1 vccd1 _8363_/D sky130_fd_sc_hd__mux2_1
XFILLER_77_106 vssd1 vssd1 vccd1 vccd1 sky130_fd_sc_hd__fill_4
X_7239_ _7458_/A _7239_/B _7239_/C vssd1 vssd1 vccd1 vccd1 _7458_/B sky130_fd_sc_hd__nand3_2
XFILLER_37_32 vssd1 vssd1 vccd1 vccd1 sky130_fd_sc_hd__fill_1
XTAP_TAPCELL_ROW_69_893 vssd1 vccd1 sky130_fd_sc_hd__tapvpwrvgnd_1
XANTENNA__6145__A _7304_/A vssd1 vssd1 vccd1 vccd1 sky130_fd_sc_hd__diode_2
XTAP_TAPCELL_ROW_24_440 vssd1 vccd1 sky130_fd_sc_hd__tapvpwrvgnd_1
XFILLER_5_121 vssd1 vssd1 vccd1 vccd1 sky130_fd_sc_hd__fill_2
XANTENNA__4525__B1 _4692_/B vssd1 vssd1 vccd1 vccd1 sky130_fd_sc_hd__diode_2
XANTENNA__8254__B _8254_/B vssd1 vssd1 vccd1 vccd1 sky130_fd_sc_hd__diode_2
X_4940_ _4940_/A _4940_/B vssd1 vssd1 vccd1 vccd1 _4943_/B sky130_fd_sc_hd__xor2_2
X_4871_ _4871_/A _4871_/B vssd1 vssd1 vccd1 vccd1 _4872_/B sky130_fd_sc_hd__xnor2_4
XFILLER_32_253 vssd1 vssd1 vccd1 vccd1 sky130_fd_sc_hd__fill_1
X_7590_ _7590_/A _7590_/B vssd1 vssd1 vccd1 vccd1 _7592_/A sky130_fd_sc_hd__nor2_2
X_6610_ _7299_/B _7299_/C vssd1 vssd1 vccd1 vccd1 _7966_/B sky130_fd_sc_hd__nand2_2
XFILLER_20_426 vssd1 vssd1 vccd1 vccd1 sky130_fd_sc_hd__fill_1
X_6541_ _6541_/A _6541_/B _6541_/C vssd1 vssd1 vccd1 vccd1 _6866_/A sky130_fd_sc_hd__or3_2
XANTENNA__6502__B _8126_/A vssd1 vssd1 vccd1 vccd1 sky130_fd_sc_hd__diode_2
X_6472_ _6472_/A _6472_/B vssd1 vssd1 vccd1 vccd1 _6474_/A sky130_fd_sc_hd__nor2_2
XTAP_TAPCELL_ROW_30_498 vssd1 vccd1 sky130_fd_sc_hd__tapvpwrvgnd_1
XANTENNA__5118__B _5902_/B vssd1 vssd1 vccd1 vccd1 sky130_fd_sc_hd__diode_2
X_8211_ _8211_/A _8211_/B vssd1 vssd1 vccd1 vccd1 _8211_/Y sky130_fd_sc_hd__xnor2_2
X_5423_ _5854_/A _5423_/B vssd1 vssd1 vccd1 vccd1 _5426_/A sky130_fd_sc_hd__nand2_2
XANTENNA__8258__A1 _4144_/Y vssd1 vssd1 vccd1 vccd1 sky130_fd_sc_hd__diode_2
X_8142_ _8142_/A _8142_/B vssd1 vssd1 vccd1 vccd1 _8143_/B sky130_fd_sc_hd__xnor2_2
X_5354_ _5354_/A _5354_/B vssd1 vssd1 vccd1 vccd1 _5355_/B sky130_fd_sc_hd__nor2_2
X_4305_ _4303_/A _4979_/B _4303_/B vssd1 vssd1 vccd1 vccd1 _5710_/C sky130_fd_sc_hd__a21o_2
XFILLER_59_106 vssd1 vssd1 vccd1 vccd1 sky130_fd_sc_hd__fill_1
X_8073_ _7984_/B _7984_/A _7981_/Y vssd1 vssd1 vccd1 vccd1 _8160_/A sky130_fd_sc_hd__a21oi_2
X_5285_ _5285_/A _5285_/B vssd1 vssd1 vccd1 vccd1 _5286_/C sky130_fd_sc_hd__nand2_2
X_7024_ _7021_/X _7022_/Y _6764_/A _6764_/Y vssd1 vssd1 vccd1 vccd1 _7025_/B sky130_fd_sc_hd__a211oi_2
X_4236_ _8380_/Q _8439_/Q vssd1 vssd1 vccd1 vccd1 _4236_/X sky130_fd_sc_hd__and2_2
XFILLER_74_109 vssd1 vssd1 vccd1 vccd1 sky130_fd_sc_hd__fill_1
X_4167_ _8174_/B _4227_/S vssd1 vssd1 vccd1 vccd1 _4167_/Y sky130_fd_sc_hd__nand2b_2
XFILLER_55_312 vssd1 vssd1 vccd1 vccd1 sky130_fd_sc_hd__fill_1
XANTENNA__4692__B _4692_/B vssd1 vssd1 vccd1 vccd1 sky130_fd_sc_hd__diode_2
XANTENNA__8164__B _8164_/B vssd1 vssd1 vccd1 vccd1 sky130_fd_sc_hd__diode_2
XTAP_TAPCELL_ROW_66_863 vssd1 vccd1 sky130_fd_sc_hd__tapvpwrvgnd_1
XFILLER_43_529 vssd1 vssd1 vccd1 vccd1 sky130_fd_sc_hd__fill_1
XFILLER_82_175 vssd1 vssd1 vccd1 vccd1 sky130_fd_sc_hd__fill_8
X_7926_ _8059_/A _7926_/B vssd1 vssd1 vccd1 vccd1 _7929_/A sky130_fd_sc_hd__nor2_2
XTAP_TAPCELL_ROW_38_576 vssd1 vccd1 sky130_fd_sc_hd__tapvpwrvgnd_1
XANTENNA__8194__A0 _7120_/A vssd1 vssd1 vccd1 vccd1 sky130_fd_sc_hd__diode_2
XFILLER_82_197 vssd1 vssd1 vccd1 vccd1 sky130_fd_sc_hd__fill_4
X_7857_ _7716_/B _7718_/B _7716_/A vssd1 vssd1 vccd1 vccd1 _7859_/B sky130_fd_sc_hd__o21ba_2
XFILLER_90_29 vssd1 vssd1 vccd1 vccd1 sky130_fd_sc_hd__fill_2
X_6808_ _6809_/A _6809_/B vssd1 vssd1 vccd1 vccd1 _6900_/B sky130_fd_sc_hd__nand2_2
X_7788_ _7788_/A _7788_/B _7786_/X vssd1 vssd1 vccd1 vccd1 _7790_/B sky130_fd_sc_hd__nor3b_2
XTAP_TAPCELL_ROW_21_410 vssd1 vccd1 sky130_fd_sc_hd__tapvpwrvgnd_1
XANTENNA__7508__B _7509_/B vssd1 vssd1 vccd1 vccd1 sky130_fd_sc_hd__diode_2
X_6739_ _6739_/A _6739_/B vssd1 vssd1 vccd1 vccd1 _6741_/A sky130_fd_sc_hd__xor2_2
X_8409_ clkload7/A _8409_/D load_slew358/X vssd1 vssd1 vccd1 vccd1 _8409_/Q sky130_fd_sc_hd__dfrtp_2
XFILLER_2_135 vssd1 vssd1 vccd1 vccd1 sky130_fd_sc_hd__fill_1
XANTENNA__7897__C _8001_/A vssd1 vssd1 vccd1 vccd1 sky130_fd_sc_hd__diode_2
XFILLER_73_120 vssd1 vssd1 vccd1 vccd1 sky130_fd_sc_hd__fill_4
XFILLER_64_85 vssd1 vssd1 vccd1 vccd1 sky130_fd_sc_hd__fill_4
XFILLER_14_253 vssd1 vssd1 vccd1 vccd1 sky130_fd_sc_hd__fill_2
XFILLER_9_36 vssd1 vssd1 vccd1 vccd1 sky130_fd_sc_hd__fill_2
XFILLER_80_51 vssd1 vssd1 vccd1 vccd1 sky130_fd_sc_hd__fill_4
XFILLER_9_47 vssd1 vssd1 vccd1 vccd1 sky130_fd_sc_hd__fill_2
XANTENNA__7160__B2 _7998_/B vssd1 vssd1 vccd1 vccd1 sky130_fd_sc_hd__diode_2
XFILLER_6_485 vssd1 vssd1 vccd1 vccd1 sky130_fd_sc_hd__fill_1
XANTENNA__4777__B _4972_/B vssd1 vssd1 vccd1 vccd1 sky130_fd_sc_hd__diode_2
XANTENNA__4496__C _4700_/B vssd1 vssd1 vccd1 vccd1 sky130_fd_sc_hd__diode_2
X_5070_ _5071_/A _5071_/B vssd1 vssd1 vccd1 vccd1 _5070_/Y sky130_fd_sc_hd__nand2_2
XTAP_TAPCELL_ROW_9_290 vssd1 vccd1 sky130_fd_sc_hd__tapvpwrvgnd_1
XFILLER_29_3 vssd1 vssd1 vccd1 vccd1 sky130_fd_sc_hd__fill_1
XFILLER_84_418 vssd1 vssd1 vccd1 vccd1 sky130_fd_sc_hd__fill_2
XANTENNA__8265__A _8267_/C vssd1 vssd1 vccd1 vccd1 sky130_fd_sc_hd__diode_2
XFILLER_77_492 vssd1 vssd1 vccd1 vccd1 sky130_fd_sc_hd__fill_2
X_5972_ _5973_/B _5973_/A vssd1 vssd1 vccd1 vccd1 _5972_/X sky130_fd_sc_hd__and2b_2
XFILLER_52_337 vssd1 vssd1 vccd1 vccd1 sky130_fd_sc_hd__fill_1
XFILLER_64_197 vssd1 vssd1 vccd1 vccd1 sky130_fd_sc_hd__fill_4
X_7711_ _7652_/A _7652_/B _7651_/B _7649_/Y vssd1 vssd1 vccd1 vccd1 _7713_/B sky130_fd_sc_hd__a31o_4
X_4923_ _4923_/A _4923_/B vssd1 vssd1 vccd1 vccd1 _4924_/B sky130_fd_sc_hd__xor2_2
XTAP_TAPCELL_ROW_63_833 vssd1 vccd1 sky130_fd_sc_hd__tapvpwrvgnd_1
XTAP_TAPCELL_ROW_35_546 vssd1 vccd1 sky130_fd_sc_hd__tapvpwrvgnd_1
XFILLER_33_551 vssd1 vssd1 vccd1 vccd1 sky130_fd_sc_hd__fill_1
X_7642_ _7642_/A _7642_/B vssd1 vssd1 vccd1 vccd1 _7643_/B sky130_fd_sc_hd__nor2_2
X_4854_ _4788_/A _4787_/B _4787_/A vssd1 vssd1 vccd1 vccd1 _4856_/B sky130_fd_sc_hd__o21ba_2
X_7573_ _7547_/B _7457_/B _7459_/B _7485_/A vssd1 vssd1 vccd1 vccd1 _7574_/C sky130_fd_sc_hd__a31oi_2
X_4785_ _4785_/A _4843_/B _4785_/C vssd1 vssd1 vccd1 vccd1 _4787_/A sky130_fd_sc_hd__and3_2
X_6524_ _8110_/A _7723_/D vssd1 vssd1 vccd1 vccd1 _6525_/B sky130_fd_sc_hd__nand2_2
X_6455_ _6540_/B _6454_/B _6454_/C vssd1 vssd1 vccd1 vccd1 _6462_/B sky130_fd_sc_hd__o21ai_2
X_6386_ _6387_/A _6387_/B vssd1 vssd1 vccd1 vccd1 _6678_/A sky130_fd_sc_hd__or2_2
X_5406_ _5406_/A _5406_/B vssd1 vssd1 vccd1 vccd1 _5407_/B sky130_fd_sc_hd__nor2_2
XANTENNA__4179__S _8398_/D vssd1 vssd1 vccd1 vccd1 sky130_fd_sc_hd__diode_2
XFILLER_87_212 vssd1 vssd1 vccd1 vccd1 sky130_fd_sc_hd__fill_4
X_8125_ _8125_/A _8125_/B vssd1 vssd1 vccd1 vccd1 _8128_/A sky130_fd_sc_hd__nand2_2
X_5337_ _5618_/A _5569_/C _5569_/D _8202_/A vssd1 vssd1 vccd1 vccd1 _5339_/A sky130_fd_sc_hd__a22oi_2
XANTENNA__7998__B _7998_/B vssd1 vssd1 vccd1 vccd1 sky130_fd_sc_hd__diode_2
X_8056_ _8056_/A _8056_/B vssd1 vssd1 vccd1 vccd1 _8057_/B sky130_fd_sc_hd__nor2_2
X_5268_ _5269_/A _5269_/B vssd1 vssd1 vccd1 vccd1 _5268_/Y sky130_fd_sc_hd__nand2_2
X_7007_ _8082_/B _7007_/B vssd1 vssd1 vccd1 vccd1 _7051_/A sky130_fd_sc_hd__or2_2
X_4219_ _7820_/A vssd1 vssd1 vccd1 vccd1 _8082_/B sky130_fd_sc_hd__inv_2
X_5199_ _5696_/B _5198_/C _5198_/A vssd1 vssd1 vccd1 vccd1 _5200_/C sky130_fd_sc_hd__a21oi_2
X_7909_ _7909_/A _7909_/B _7909_/C vssd1 vssd1 vccd1 vccd1 _7910_/D sky130_fd_sc_hd__nor3_2
XFILLER_24_551 vssd1 vssd1 vccd1 vccd1 sky130_fd_sc_hd__fill_8
XFILLER_34_55 vssd1 vssd1 vccd1 vccd1 sky130_fd_sc_hd__fill_1
Xwire103 wire103/A vssd1 vssd1 vccd1 vccd1 _5953_/B sky130_fd_sc_hd__clkbuf_4
XFILLER_3_477 vssd1 vssd1 vccd1 vccd1 sky130_fd_sc_hd__fill_1
Xload_slew119 _4384_/B vssd1 vssd1 vccd1 vccd1 _4931_/D sky130_fd_sc_hd__buf_4
XFILLER_59_85 vssd1 vssd1 vccd1 vccd1 sky130_fd_sc_hd__fill_2
XTAP_TAPCELL_ROW_6_260 vssd1 vccd1 sky130_fd_sc_hd__tapvpwrvgnd_1
XFILLER_59_481 vssd1 vssd1 vccd1 vccd1 sky130_fd_sc_hd__fill_2
XFILLER_66_429 vssd1 vssd1 vccd1 vccd1 sky130_fd_sc_hd__fill_2
Xfanout280 _8358_/Q vssd1 vssd1 vccd1 vccd1 _8277_/A sky130_fd_sc_hd__clkdlybuf4s25_1
Xfanout291 _8264_/A vssd1 vssd1 vccd1 vccd1 _7875_/D sky130_fd_sc_hd__clkdlybuf4s25_1
XFILLER_75_73 vssd1 vssd1 vccd1 vccd1 sky130_fd_sc_hd__fill_2
XTAP_TAPCELL_ROW_77_969 vssd1 vccd1 sky130_fd_sc_hd__tapvpwrvgnd_1
XANTENNA__5221__B _5902_/B vssd1 vssd1 vccd1 vccd1 sky130_fd_sc_hd__diode_2
XFILLER_61_101 vssd1 vssd1 vccd1 vccd1 sky130_fd_sc_hd__fill_2
XFILLER_15_551 vssd1 vssd1 vccd1 vccd1 sky130_fd_sc_hd__fill_1
XTAP_TAPCELL_ROW_60_803 vssd1 vccd1 sky130_fd_sc_hd__tapvpwrvgnd_1
XANTENNA__6333__A _7095_/B vssd1 vssd1 vccd1 vccd1 sky130_fd_sc_hd__diode_2
XTAP_TAPCELL_ROW_32_516 vssd1 vccd1 sky130_fd_sc_hd__tapvpwrvgnd_1
XFILLER_91_61 vssd1 vssd1 vccd1 vccd1 sky130_fd_sc_hd__fill_2
X_4570_ _4570_/A vssd1 vssd1 vccd1 vccd1 _4591_/B sky130_fd_sc_hd__inv_4
X_6240_ _6240_/A _6240_/B vssd1 vssd1 vccd1 vccd1 _6242_/A sky130_fd_sc_hd__nor2_2
XANTENNA__4300__B _4979_/C vssd1 vssd1 vccd1 vccd1 sky130_fd_sc_hd__diode_2
X_6171_ _8418_/D wire77/X vssd1 vssd1 vccd1 vccd1 _6349_/A sky130_fd_sc_hd__nand2_2
X_5122_ _5122_/A _5122_/B vssd1 vssd1 vccd1 vccd1 _5125_/A sky130_fd_sc_hd__xnor2_2
XANTENNA__7611__B _8081_/B vssd1 vssd1 vccd1 vccd1 sky130_fd_sc_hd__diode_2
X_5053_ _8413_/D _6738_/B vssd1 vssd1 vccd1 vccd1 _5067_/A sky130_fd_sc_hd__nand2_2
XFILLER_37_142 vssd1 vssd1 vccd1 vccd1 sky130_fd_sc_hd__fill_4
XANTENNA__5131__B wire92/X vssd1 vssd1 vccd1 vccd1 sky130_fd_sc_hd__diode_2
XPHY_EDGE_ROW_9_Left_102 vssd1 vssd1 vccd1 vccd1 sky130_fd_sc_hd__decap_3
XTAP_TAPCELL_ROW_48_682 vssd1 vccd1 sky130_fd_sc_hd__tapvpwrvgnd_1
X_5955_ _5955_/A _6115_/A vssd1 vssd1 vccd1 vccd1 _5956_/B sky130_fd_sc_hd__xor2_2
XANTENNA_fanout240_A _6435_/A vssd1 vssd1 vccd1 vccd1 sky130_fd_sc_hd__diode_2
XANTENNA_fanout338_A _6883_/A vssd1 vssd1 vccd1 vccd1 sky130_fd_sc_hd__diode_2
X_5886_ _5809_/A _5809_/B _5807_/X vssd1 vssd1 vccd1 vccd1 _5997_/A sky130_fd_sc_hd__a21o_2
X_4906_ _4906_/A _4970_/A _4906_/C vssd1 vssd1 vccd1 vccd1 _4970_/B sky130_fd_sc_hd__nand3_2
XFILLER_21_532 vssd1 vssd1 vccd1 vccd1 sky130_fd_sc_hd__fill_1
X_7625_ _7820_/A wire64/X vssd1 vssd1 vccd1 vccd1 _7686_/A sky130_fd_sc_hd__nand2_2
X_4837_ _6588_/A _4931_/C vssd1 vssd1 vccd1 vccd1 _4838_/B sky130_fd_sc_hd__nand2_2
XANTENNA__5922__A2 _6757_/B vssd1 vssd1 vccd1 vccd1 sky130_fd_sc_hd__diode_2
XANTENNA_fanout126_X _6970_/A vssd1 vssd1 vccd1 vccd1 sky130_fd_sc_hd__diode_2
X_7556_ _7556_/A _7556_/B vssd1 vssd1 vccd1 vccd1 _7558_/A sky130_fd_sc_hd__nor2_2
X_4768_ _4768_/A _4768_/B vssd1 vssd1 vccd1 vccd1 _4797_/A sky130_fd_sc_hd__xnor2_2
X_7487_ _7246_/A _7248_/B _7246_/B vssd1 vssd1 vccd1 vccd1 _7489_/C sky130_fd_sc_hd__o21ba_2
X_6507_ _6508_/A _6508_/B vssd1 vssd1 vccd1 vccd1 _6846_/A sky130_fd_sc_hd__nand2b_2
X_4699_ _4699_/A _4704_/C vssd1 vssd1 vccd1 vccd1 _4700_/C sky130_fd_sc_hd__xnor2_2
X_6438_ _6438_/A _7140_/D vssd1 vssd1 vccd1 vccd1 _6439_/B sky130_fd_sc_hd__nand2_2
XANTENNA__6201__A1_N _6397_/C vssd1 vssd1 vccd1 vccd1 sky130_fd_sc_hd__diode_2
X_8108_ _8108_/A _8108_/B _8359_/Q _8360_/Q vssd1 vssd1 vccd1 vccd1 _8111_/B sky130_fd_sc_hd__nand4_2
X_6369_ _5775_/B _6373_/A _6160_/X vssd1 vssd1 vccd1 vccd1 _6379_/A sky130_fd_sc_hd__o21ba_2
XFILLER_29_22 vssd1 vssd1 vccd1 vccd1 sky130_fd_sc_hd__fill_8
X_8039_ _8040_/A _8040_/B _8040_/C vssd1 vssd1 vccd1 vccd1 _8041_/B sky130_fd_sc_hd__a21o_2
XTAP_TAPCELL_ROW_3_230 vssd1 vccd1 sky130_fd_sc_hd__tapvpwrvgnd_1
XANTENNA__5041__B _6997_/B vssd1 vssd1 vccd1 vccd1 sky130_fd_sc_hd__diode_2
XFILLER_45_21 vssd1 vssd1 vccd1 vccd1 sky130_fd_sc_hd__fill_4
XFILLER_56_451 vssd1 vssd1 vccd1 vccd1 sky130_fd_sc_hd__fill_1
XTAP_TAPCELL_ROW_74_939 vssd1 vccd1 sky130_fd_sc_hd__tapvpwrvgnd_1
XFILLER_28_197 vssd1 vssd1 vccd1 vccd1 sky130_fd_sc_hd__fill_1
XFILLER_45_32 vssd1 vssd1 vccd1 vccd1 sky130_fd_sc_hd__fill_1
XANTENNA_fanout39_X _8077_/B vssd1 vssd1 vccd1 vccd1 sky130_fd_sc_hd__diode_2
XANTENNA__7249__A _8103_/A vssd1 vssd1 vccd1 vccd1 sky130_fd_sc_hd__diode_2
XFILLER_8_525 vssd1 vssd1 vccd1 vccd1 sky130_fd_sc_hd__fill_4
XFILLER_8_569 vssd1 vssd1 vccd1 vccd1 sky130_fd_sc_hd__fill_1
XANTENNA__7666__A2 _7806_/B vssd1 vssd1 vccd1 vccd1 sky130_fd_sc_hd__diode_2
XFILLER_79_510 vssd1 vssd1 vccd1 vccd1 sky130_fd_sc_hd__fill_1
XANTENNA__5429__A1 _6198_/A vssd1 vssd1 vccd1 vccd1 sky130_fd_sc_hd__diode_2
XFILLER_79_554 vssd1 vssd1 vccd1 vccd1 sky130_fd_sc_hd__fill_1
XANTENNA__5429__B2 _6005_/B vssd1 vssd1 vccd1 vccd1 sky130_fd_sc_hd__diode_2
XFILLER_20_7 vssd1 vssd1 vccd1 vccd1 sky130_fd_sc_hd__fill_2
XFILLER_86_83 vssd1 vssd1 vccd1 vccd1 sky130_fd_sc_hd__fill_1
XFILLER_47_451 vssd1 vssd1 vccd1 vccd1 sky130_fd_sc_hd__fill_1
XFILLER_81_218 vssd1 vssd1 vccd1 vccd1 sky130_fd_sc_hd__fill_4
XANTENNA_max_cap40_X _7095_/B vssd1 vssd1 vccd1 vccd1 sky130_fd_sc_hd__diode_2
XFILLER_22_307 vssd1 vssd1 vccd1 vccd1 sky130_fd_sc_hd__fill_1
XFILLER_34_156 vssd1 vssd1 vccd1 vccd1 sky130_fd_sc_hd__fill_4
XFILLER_62_465 vssd1 vssd1 vccd1 vccd1 sky130_fd_sc_hd__fill_2
XTAP_TAPCELL_ROW_45_652 vssd1 vccd1 sky130_fd_sc_hd__tapvpwrvgnd_1
X_5740_ _6294_/A wire90/X _6701_/B _5928_/A vssd1 vssd1 vccd1 vccd1 _5740_/X sky130_fd_sc_hd__a22o_2
XANTENNA__4168__A1 _4227_/S vssd1 vssd1 vccd1 vccd1 sky130_fd_sc_hd__diode_2
X_7410_ _7410_/A _7410_/B vssd1 vssd1 vccd1 vccd1 _7412_/B sky130_fd_sc_hd__xnor2_2
X_5671_ _5668_/C _5671_/B _5671_/C _5671_/D vssd1 vssd1 vccd1 vccd1 _5671_/X sky130_fd_sc_hd__and4b_2
X_8390_ clkload3/A _8390_/D fanout372/A vssd1 vssd1 vccd1 vccd1 _8390_/Q sky130_fd_sc_hd__dfrtp_2
X_4622_ _4622_/A _4622_/B vssd1 vssd1 vccd1 vccd1 _4634_/B sky130_fd_sc_hd__xnor2_2
X_7341_ _7395_/A _7340_/C _7340_/A vssd1 vssd1 vccd1 vccd1 _7343_/B sky130_fd_sc_hd__o21a_2
X_4553_ _4553_/A _4553_/B vssd1 vssd1 vccd1 vccd1 _4554_/A sky130_fd_sc_hd__and2_2
Xhold536 _8324_/Q vssd1 vssd1 vccd1 vccd1 hold536/X sky130_fd_sc_hd__dlygate4sd3_1
Xhold525 _8380_/Q vssd1 vssd1 vccd1 vccd1 _8439_/D sky130_fd_sc_hd__dlygate4sd3_1
Xhold514 _8396_/Q vssd1 vssd1 vccd1 vccd1 _8401_/D sky130_fd_sc_hd__dlygate4sd3_1
X_7272_ _7273_/A _7273_/B _7273_/C vssd1 vssd1 vccd1 vccd1 _7274_/A sky130_fd_sc_hd__a21oi_2
X_4484_ _4483_/A _4782_/A _4481_/X vssd1 vssd1 vccd1 vccd1 _4486_/B sky130_fd_sc_hd__o21ai_2
Xhold547 _8334_/Q vssd1 vssd1 vccd1 vccd1 hold547/X sky130_fd_sc_hd__dlygate4sd3_1
X_6223_ _6223_/A _6223_/B _6223_/C vssd1 vssd1 vccd1 vccd1 _6224_/B sky130_fd_sc_hd__or3_2
XANTENNA__7622__A _7958_/A vssd1 vssd1 vccd1 vccd1 sky130_fd_sc_hd__diode_2
X_6154_ _6154_/A _6154_/B vssd1 vssd1 vccd1 vccd1 _6190_/A sky130_fd_sc_hd__xnor2_2
XANTENNA__6238__A _6435_/A vssd1 vssd1 vccd1 vccd1 sky130_fd_sc_hd__diode_2
XFILLER_57_215 vssd1 vssd1 vccd1 vccd1 sky130_fd_sc_hd__fill_1
X_6085_ _5989_/A _5989_/B _5987_/X vssd1 vssd1 vccd1 vccd1 _6194_/A sky130_fd_sc_hd__o21bai_2
X_5105_ _8415_/D wire77/X vssd1 vssd1 vccd1 vccd1 _5788_/A sky130_fd_sc_hd__nand2_2
XANTENNA_fanout288_A _8266_/A vssd1 vssd1 vccd1 vccd1 sky130_fd_sc_hd__diode_2
X_5036_ _4878_/Y _4962_/B _5037_/B vssd1 vssd1 vccd1 vccd1 _5036_/X sky130_fd_sc_hd__o21a_2
XTAP_TAPCELL_ROW_0_200 vssd1 vccd1 sky130_fd_sc_hd__tapvpwrvgnd_1
XFILLER_65_281 vssd1 vssd1 vccd1 vccd1 sky130_fd_sc_hd__fill_4
X_6987_ _6987_/A _7082_/A vssd1 vssd1 vccd1 vccd1 _6987_/Y sky130_fd_sc_hd__nand2_2
XTAP_TAPCELL_ROW_71_909 vssd1 vccd1 sky130_fd_sc_hd__tapvpwrvgnd_1
XANTENNA_fanout243_X _8103_/A vssd1 vssd1 vccd1 vccd1 sky130_fd_sc_hd__diode_2
XFILLER_15_57 vssd1 vssd1 vccd1 vccd1 sky130_fd_sc_hd__fill_2
XFILLER_25_189 vssd1 vssd1 vccd1 vccd1 sky130_fd_sc_hd__fill_2
X_5938_ _6712_/A wire90/X vssd1 vssd1 vccd1 vccd1 _6106_/A sky130_fd_sc_hd__nand2_2
XANTENNA__6404__C _6485_/B vssd1 vssd1 vccd1 vccd1 sky130_fd_sc_hd__diode_2
XANTENNA__4159__A1 _8196_/B vssd1 vssd1 vccd1 vccd1 sky130_fd_sc_hd__diode_2
X_5869_ _5869_/A vssd1 vssd1 vccd1 vccd1 _5869_/Y sky130_fd_sc_hd__inv_2
X_7608_ _7608_/A _7608_/B vssd1 vssd1 vccd1 vccd1 _7643_/A sky130_fd_sc_hd__xnor2_2
XFILLER_31_45 vssd1 vssd1 vccd1 vccd1 sky130_fd_sc_hd__fill_2
X_7539_ _7539_/A _7539_/B vssd1 vssd1 vccd1 vccd1 _7541_/B sky130_fd_sc_hd__xnor2_2
XANTENNA__4221__A _8071_/S vssd1 vssd1 vccd1 vccd1 sky130_fd_sc_hd__diode_2
Xoutput34 _8333_/Q vssd1 vssd1 vccd1 vccd1 gpio_out[31] sky130_fd_sc_hd__clkdlybuf4s25_1
Xoutput23 _8322_/Q vssd1 vssd1 vccd1 vccd1 gpio_out[20] sky130_fd_sc_hd__clkdlybuf4s25_1
XANTENNA__6148__A _6978_/A vssd1 vssd1 vccd1 vccd1 sky130_fd_sc_hd__diode_2
XFILLER_76_535 vssd1 vssd1 vccd1 vccd1 sky130_fd_sc_hd__fill_1
XANTENNA_input16_A gpio_in[6] vssd1 vssd1 vccd1 vccd1 sky130_fd_sc_hd__diode_2
XFILLER_63_207 vssd1 vssd1 vccd1 vccd1 sky130_fd_sc_hd__fill_4
XTAP_TAPCELL_ROW_59_788 vssd1 vccd1 sky130_fd_sc_hd__tapvpwrvgnd_1
XFILLER_71_240 vssd1 vssd1 vccd1 vccd1 sky130_fd_sc_hd__fill_2
XFILLER_44_498 vssd1 vssd1 vccd1 vccd1 sky130_fd_sc_hd__fill_1
XFILLER_72_41 vssd1 vssd1 vccd1 vccd1 sky130_fd_sc_hd__fill_2
XTAP_TAPCELL_ROW_42_622 vssd1 vccd1 sky130_fd_sc_hd__tapvpwrvgnd_1
XFILLER_31_159 vssd1 vssd1 vccd1 vccd1 sky130_fd_sc_hd__fill_1
XANTENNA__7129__D _7714_/A vssd1 vssd1 vccd1 vccd1 sky130_fd_sc_hd__diode_2
XANTENNA__6611__A _6611_/A vssd1 vssd1 vccd1 vccd1 sky130_fd_sc_hd__diode_2
XANTENNA__7426__B _7515_/A vssd1 vssd1 vccd1 vccd1 sky130_fd_sc_hd__diode_2
XFILLER_67_568 vssd1 vssd1 vccd1 vccd1 sky130_fd_sc_hd__fill_2
XFILLER_47_281 vssd1 vssd1 vccd1 vccd1 sky130_fd_sc_hd__fill_1
X_7890_ _7890_/A _7890_/B vssd1 vssd1 vccd1 vccd1 _7892_/A sky130_fd_sc_hd__nor2_2
X_6910_ _6911_/A _6911_/B vssd1 vssd1 vccd1 vccd1 _7171_/B sky130_fd_sc_hd__nand2b_2
X_6841_ _6841_/A _6841_/B vssd1 vssd1 vccd1 vccd1 _6843_/B sky130_fd_sc_hd__xnor2_2
XANTENNA__8423__D _8423_/D vssd1 vssd1 vccd1 vccd1 sky130_fd_sc_hd__diode_2
XFILLER_50_457 vssd1 vssd1 vccd1 vccd1 sky130_fd_sc_hd__fill_1
X_6772_ _6632_/B _6770_/Y _6771_/X vssd1 vssd1 vccd1 vccd1 _6775_/A sky130_fd_sc_hd__a21o_2
XFILLER_22_159 vssd1 vssd1 vccd1 vccd1 sky130_fd_sc_hd__fill_1
X_5723_ _6572_/A _6703_/B vssd1 vssd1 vccd1 vccd1 _5952_/A sky130_fd_sc_hd__nand2_2
XANTENNA__6521__A _7998_/A vssd1 vssd1 vccd1 vccd1 sky130_fd_sc_hd__diode_2
XANTENNA__8212__S _8313_/S vssd1 vssd1 vccd1 vccd1 sky130_fd_sc_hd__diode_2
X_8442_ clkload2/A _8442_/D wire368/X vssd1 vssd1 vccd1 vccd1 _8442_/Q sky130_fd_sc_hd__dfrtp_2
X_5654_ _5654_/A _5654_/B vssd1 vssd1 vccd1 vccd1 _5654_/X sky130_fd_sc_hd__or2_2
X_8373_ clkload8/A _8373_/D fanout374/X vssd1 vssd1 vccd1 vccd1 _8373_/Q sky130_fd_sc_hd__dfrtp_2
X_4605_ _4265_/A _4531_/B _4531_/C _4770_/B _4674_/A vssd1 vssd1 vccd1 vccd1 _4605_/X
+ sky130_fd_sc_hd__o32a_2
X_7324_ _8419_/D wire59/X vssd1 vssd1 vccd1 vccd1 _7329_/A sky130_fd_sc_hd__nand2_2
X_5585_ _5585_/A _5585_/B vssd1 vssd1 vccd1 vccd1 _5587_/C sky130_fd_sc_hd__nand2_2
X_4536_ _4528_/A _4528_/B _4526_/A vssd1 vssd1 vccd1 vccd1 _4539_/A sky130_fd_sc_hd__a21oi_2
X_7255_ _7256_/B _7256_/A vssd1 vssd1 vccd1 vccd1 _7480_/A sky130_fd_sc_hd__and2b_2
X_4467_ _4467_/A _4467_/B vssd1 vssd1 vccd1 vccd1 _4469_/B sky130_fd_sc_hd__xnor2_2
X_7186_ _7990_/A _8125_/B _7186_/C vssd1 vssd1 vccd1 vccd1 _7284_/B sky130_fd_sc_hd__and3_2
X_6206_ _6207_/A _6482_/B _6485_/B _6892_/B vssd1 vssd1 vccd1 vccd1 _6210_/A sky130_fd_sc_hd__a22oi_2
X_4398_ _8430_/D _4780_/B vssd1 vssd1 vccd1 vccd1 _4518_/B sky130_fd_sc_hd__nand2_4
XANTENNA__4187__S _8398_/D vssd1 vssd1 vccd1 vccd1 sky130_fd_sc_hd__diode_2
XANTENNA__8167__B _8168_/B vssd1 vssd1 vccd1 vccd1 sky130_fd_sc_hd__diode_2
XANTENNA_input8_A gpio_in[15] vssd1 vssd1 vccd1 vccd1 sky130_fd_sc_hd__diode_2
X_6137_ _6138_/B _6138_/A vssd1 vssd1 vccd1 vccd1 _6332_/A sky130_fd_sc_hd__and2b_2
XFILLER_58_535 vssd1 vssd1 vccd1 vccd1 sky130_fd_sc_hd__fill_2
XFILLER_73_505 vssd1 vssd1 vccd1 vccd1 sky130_fd_sc_hd__fill_4
XFILLER_73_527 vssd1 vssd1 vccd1 vccd1 sky130_fd_sc_hd__fill_4
X_6068_ _6069_/B _6069_/A vssd1 vssd1 vccd1 vccd1 _6274_/B sky130_fd_sc_hd__and2b_2
XFILLER_26_421 vssd1 vssd1 vccd1 vccd1 sky130_fd_sc_hd__fill_1
X_5019_ _5019_/A _5019_/B vssd1 vssd1 vccd1 vccd1 _5022_/A sky130_fd_sc_hd__xor2_2
XTAP_TAPCELL_ROW_56_758 vssd1 vccd1 sky130_fd_sc_hd__tapvpwrvgnd_1
XANTENNA__6431__A _6517_/A vssd1 vssd1 vccd1 vccd1 sky130_fd_sc_hd__diode_2
Xrebuffer441 _4166_/Y vssd1 vssd1 vccd1 vccd1 _8425_/D sky130_fd_sc_hd__buf_2
Xrebuffer474 _5205_/C vssd1 vssd1 vccd1 vccd1 _5806_/B sky130_fd_sc_hd__buf_2
Xrebuffer463 _4158_/Y vssd1 vssd1 vccd1 vccd1 fanout142/A sky130_fd_sc_hd__buf_2
Xrebuffer452 _5037_/A vssd1 vssd1 vccd1 vccd1 _4880_/B sky130_fd_sc_hd__buf_2
Xrebuffer496 _4187_/X vssd1 vssd1 vccd1 vccd1 _8437_/D sky130_fd_sc_hd__buf_2
Xrebuffer485 _4661_/Y vssd1 vssd1 vccd1 vccd1 _4665_/B sky130_fd_sc_hd__buf_2
XANTENNA__6829__B1 _7875_/C vssd1 vssd1 vccd1 vccd1 sky130_fd_sc_hd__diode_2
XANTENNA__8077__B _8077_/B vssd1 vssd1 vccd1 vccd1 sky130_fd_sc_hd__diode_2
XFILLER_49_524 vssd1 vssd1 vccd1 vccd1 sky130_fd_sc_hd__fill_1
XFILLER_76_343 vssd1 vssd1 vccd1 vccd1 sky130_fd_sc_hd__fill_2
XFILLER_88_192 vssd1 vssd1 vccd1 vccd1 sky130_fd_sc_hd__fill_4
XFILLER_67_96 vssd1 vssd1 vccd1 vccd1 sky130_fd_sc_hd__fill_1
XFILLER_76_354 vssd1 vssd1 vccd1 vccd1 sky130_fd_sc_hd__fill_2
XFILLER_76_365 vssd1 vssd1 vccd1 vccd1 sky130_fd_sc_hd__fill_4
XANTENNA_input19_X input19/X vssd1 vssd1 vccd1 vccd1 sky130_fd_sc_hd__diode_2
XTAP_TAPCELL_ROW_27_471 vssd1 vccd1 sky130_fd_sc_hd__tapvpwrvgnd_1
XFILLER_40_490 vssd1 vssd1 vccd1 vccd1 sky130_fd_sc_hd__fill_1
XFILLER_8_141 vssd1 vssd1 vccd1 vccd1 sky130_fd_sc_hd__fill_2
XANTENNA__5740__B1 _6701_/B vssd1 vssd1 vccd1 vccd1 sky130_fd_sc_hd__diode_2
X_5370_ _5370_/A _5370_/B vssd1 vssd1 vccd1 vccd1 _5372_/B sky130_fd_sc_hd__xnor2_2
X_4321_ _4321_/A _4321_/B vssd1 vssd1 vccd1 vccd1 _4325_/A sky130_fd_sc_hd__nand2_2
Xfanout109 _4700_/B vssd1 vssd1 vccd1 vccd1 _4654_/C sky130_fd_sc_hd__clkdlybuf4s25_1
X_7040_ _7040_/A _7040_/B vssd1 vssd1 vccd1 vccd1 _7042_/B sky130_fd_sc_hd__xnor2_2
X_4252_ _8386_/Q _8445_/Q vssd1 vssd1 vccd1 vccd1 _4252_/X sky130_fd_sc_hd__and2_2
X_4183_ _8436_/Q input9/X _8398_/D vssd1 vssd1 vccd1 vccd1 _4183_/X sky130_fd_sc_hd__mux2_4
XANTENNA__8425__RESET_B load_slew360/X vssd1 vssd1 vccd1 vccd1 sky130_fd_sc_hd__diode_2
XFILLER_55_516 vssd1 vssd1 vccd1 vccd1 sky130_fd_sc_hd__fill_1
XFILLER_55_549 vssd1 vssd1 vccd1 vccd1 sky130_fd_sc_hd__fill_2
X_7942_ hold542/X _7941_/Y _8071_/S vssd1 vssd1 vccd1 vccd1 _8332_/D sky130_fd_sc_hd__mux2_1
XANTENNA__4307__Y _6114_/B vssd1 vssd1 vccd1 vccd1 sky130_fd_sc_hd__diode_2
X_7873_ _7875_/A _7875_/C _7875_/D _7875_/B vssd1 vssd1 vccd1 vccd1 _7877_/D sky130_fd_sc_hd__a22o_2
XTAP_TAPCELL_ROW_53_728 vssd1 vccd1 sky130_fd_sc_hd__tapvpwrvgnd_1
XFILLER_50_210 vssd1 vssd1 vccd1 vccd1 sky130_fd_sc_hd__fill_1
XFILLER_90_390 vssd1 vssd1 vccd1 vccd1 sky130_fd_sc_hd__fill_2
X_6824_ _6915_/A _6824_/B _6824_/C vssd1 vssd1 vccd1 vccd1 _6915_/B sky130_fd_sc_hd__nand3_2
XFILLER_50_265 vssd1 vssd1 vccd1 vccd1 sky130_fd_sc_hd__fill_4
X_6755_ _6755_/A _6755_/B _6755_/C vssd1 vssd1 vccd1 vccd1 _6764_/B sky130_fd_sc_hd__and3_2
XANTENNA_fanout320_A _8208_/A vssd1 vssd1 vccd1 vccd1 sky130_fd_sc_hd__diode_2
X_5706_ _5706_/A _5706_/B vssd1 vssd1 vccd1 vccd1 _5709_/A sky130_fd_sc_hd__xnor2_2
XFILLER_31_490 vssd1 vssd1 vccd1 vccd1 sky130_fd_sc_hd__fill_1
X_8425_ clkload1/A _8425_/D load_slew360/X vssd1 vssd1 vccd1 vccd1 _8425_/Q sky130_fd_sc_hd__dfrtp_2
X_6686_ _6479_/A _6479_/B _6475_/X vssd1 vssd1 vccd1 vccd1 _6688_/B sky130_fd_sc_hd__a21o_2
XFILLER_12_69 vssd1 vssd1 vccd1 vccd1 sky130_fd_sc_hd__fill_1
X_5637_ _5637_/A _5637_/B vssd1 vssd1 vccd1 vccd1 _5638_/B sky130_fd_sc_hd__or2_2
X_8356_ _8361_/CLK _8356_/D load_slew384/X vssd1 vssd1 vccd1 vccd1 _8356_/Q sky130_fd_sc_hd__dfrtp_2
X_5568_ _5568_/A _6433_/A vssd1 vssd1 vccd1 vccd1 _5572_/A sky130_fd_sc_hd__nand2_2
XFILLER_88_29 vssd1 vssd1 vccd1 vccd1 sky130_fd_sc_hd__fill_8
X_8287_ _8287_/A _8287_/B vssd1 vssd1 vccd1 vccd1 _8362_/D sky130_fd_sc_hd__xnor2_2
X_7307_ _7307_/A _7307_/B vssd1 vssd1 vccd1 vccd1 _7308_/B sky130_fd_sc_hd__xnor2_2
X_4519_ _4557_/A _4686_/B vssd1 vssd1 vccd1 vccd1 _4555_/A sky130_fd_sc_hd__nand2_2
XTAP_TAPCELL_ROW_92_1134 vssd1 vccd1 sky130_fd_sc_hd__tapvpwrvgnd_1
XTAP_TAPCELL_ROW_92_1123 vssd1 vccd1 sky130_fd_sc_hd__tapvpwrvgnd_1
X_7238_ _7238_/A _7238_/B vssd1 vssd1 vccd1 vccd1 _7239_/C sky130_fd_sc_hd__xnor2_2
X_5499_ _8220_/A _5594_/B vssd1 vssd1 vccd1 vccd1 _5501_/B sky130_fd_sc_hd__and2_2
X_7169_ _7264_/B _7169_/B vssd1 vssd1 vccd1 vccd1 _7171_/C sky130_fd_sc_hd__or2_2
XFILLER_37_55 vssd1 vssd1 vccd1 vccd1 sky130_fd_sc_hd__fill_1
XTAP_TAPCELL_ROW_69_894 vssd1 vccd1 sky130_fd_sc_hd__tapvpwrvgnd_1
XFILLER_26_240 vssd1 vssd1 vccd1 vccd1 sky130_fd_sc_hd__fill_1
XANTENNA__6145__B _6986_/B vssd1 vssd1 vccd1 vccd1 sky130_fd_sc_hd__diode_2
XFILLER_53_54 vssd1 vssd1 vccd1 vccd1 sky130_fd_sc_hd__fill_2
XFILLER_14_468 vssd1 vssd1 vccd1 vccd1 sky130_fd_sc_hd__fill_8
XFILLER_53_65 vssd1 vssd1 vccd1 vccd1 sky130_fd_sc_hd__fill_2
XTAP_TAPCELL_ROW_24_441 vssd1 vccd1 sky130_fd_sc_hd__tapvpwrvgnd_1
XFILLER_41_276 vssd1 vssd1 vccd1 vccd1 sky130_fd_sc_hd__fill_4
XANTENNA__4828__A2 _4770_/B vssd1 vssd1 vccd1 vccd1 sky130_fd_sc_hd__diode_2
XFILLER_78_73 vssd1 vssd1 vccd1 vccd1 sky130_fd_sc_hd__fill_4
XFILLER_78_95 vssd1 vssd1 vccd1 vccd1 sky130_fd_sc_hd__fill_2
XFILLER_37_505 vssd1 vssd1 vccd1 vccd1 sky130_fd_sc_hd__fill_2
XFILLER_76_162 vssd1 vssd1 vccd1 vccd1 sky130_fd_sc_hd__fill_2
XFILLER_76_195 vssd1 vssd1 vccd1 vccd1 sky130_fd_sc_hd__fill_1
X_4870_ _4871_/B _4871_/A vssd1 vssd1 vccd1 vccd1 _4870_/Y sky130_fd_sc_hd__nand2b_2
X_6540_ _6540_/A _6540_/B vssd1 vssd1 vccd1 vccd1 _6541_/C sky130_fd_sc_hd__nor2_2
X_6471_ _6471_/A _6471_/B _6471_/C vssd1 vssd1 vccd1 vccd1 _6472_/B sky130_fd_sc_hd__nor3_2
X_8210_ _8201_/Y _8205_/B _8203_/B vssd1 vssd1 vccd1 vccd1 _8211_/B sky130_fd_sc_hd__o21a_2
X_5422_ _5422_/A _5422_/B vssd1 vssd1 vccd1 vccd1 _5423_/B sky130_fd_sc_hd__or2_2
XTAP_TAPCELL_ROW_30_499 vssd1 vccd1 sky130_fd_sc_hd__tapvpwrvgnd_1
X_8141_ _8141_/A _8141_/B vssd1 vssd1 vccd1 vccd1 _8142_/B sky130_fd_sc_hd__xnor2_2
X_5353_ _5559_/B _5386_/C _5417_/D _5386_/A vssd1 vssd1 vccd1 vccd1 _5354_/B sky130_fd_sc_hd__a22oi_2
XANTENNA__7466__B1 _7875_/D vssd1 vssd1 vccd1 vccd1 sky130_fd_sc_hd__diode_2
X_4304_ _4303_/A _4979_/B _4303_/B vssd1 vssd1 vccd1 vccd1 _4531_/C sky130_fd_sc_hd__a21oi_2
X_8072_ _8070_/B _8067_/B _8072_/B1 vssd1 vssd1 vccd1 vccd1 _8161_/A sky130_fd_sc_hd__a21oi_4
X_5284_ _5246_/A _5246_/B _5250_/A _5246_/D vssd1 vssd1 vccd1 vccd1 _5286_/B sky130_fd_sc_hd__o22ai_2
XFILLER_87_438 vssd1 vssd1 vccd1 vccd1 sky130_fd_sc_hd__fill_4
XFILLER_87_449 vssd1 vssd1 vccd1 vccd1 sky130_fd_sc_hd__fill_2
X_7023_ _6764_/A _6764_/Y _7021_/X _7022_/Y vssd1 vssd1 vccd1 vccd1 _7025_/A sky130_fd_sc_hd__o211a_2
X_4235_ _4233_/X _4235_/B vssd1 vssd1 vccd1 vccd1 _4366_/A sky130_fd_sc_hd__and2b_2
X_4166_ _4166_/A vssd1 vssd1 vccd1 vccd1 _4166_/Y sky130_fd_sc_hd__inv_4
XFILLER_55_302 vssd1 vssd1 vccd1 vccd1 sky130_fd_sc_hd__fill_1
XANTENNA_fanout270_A _6433_/A vssd1 vssd1 vccd1 vccd1 sky130_fd_sc_hd__diode_2
XFILLER_55_335 vssd1 vssd1 vccd1 vccd1 sky130_fd_sc_hd__fill_1
XTAP_TAPCELL_ROW_66_864 vssd1 vccd1 sky130_fd_sc_hd__tapvpwrvgnd_1
X_7925_ _8055_/B _7924_/B _7924_/C vssd1 vssd1 vccd1 vccd1 _7926_/B sky130_fd_sc_hd__a21oi_2
XTAP_TAPCELL_ROW_38_577 vssd1 vccd1 sky130_fd_sc_hd__tapvpwrvgnd_1
XANTENNA_fanout156_X _5983_/A vssd1 vssd1 vccd1 vccd1 sky130_fd_sc_hd__diode_2
XFILLER_70_349 vssd1 vssd1 vccd1 vccd1 sky130_fd_sc_hd__fill_4
X_7856_ _7856_/A _7856_/B vssd1 vssd1 vccd1 vccd1 _7859_/A sky130_fd_sc_hd__nor2_2
X_6807_ _6807_/A _6807_/B vssd1 vssd1 vccd1 vccd1 _6809_/B sky130_fd_sc_hd__xnor2_2
X_7787_ _7788_/A _7788_/B _7786_/X vssd1 vssd1 vccd1 vccd1 _7931_/B sky130_fd_sc_hd__o21ba_2
X_4999_ _4997_/X _4999_/B vssd1 vssd1 vccd1 vccd1 _5001_/A sky130_fd_sc_hd__and2b_2
XTAP_TAPCELL_ROW_21_411 vssd1 vccd1 sky130_fd_sc_hd__tapvpwrvgnd_1
X_6738_ _7820_/A _6738_/B vssd1 vssd1 vccd1 vccd1 _6739_/B sky130_fd_sc_hd__nand2_2
X_6669_ _6669_/A _6669_/B vssd1 vssd1 vccd1 vccd1 _6672_/A sky130_fd_sc_hd__xnor2_2
XPHY_EDGE_ROW_36_Left_129 vssd1 vssd1 vccd1 vccd1 sky130_fd_sc_hd__decap_3
X_8408_ clkload6/A _8408_/D load_slew358/X vssd1 vssd1 vccd1 vccd1 _8408_/Q sky130_fd_sc_hd__dfrtp_2
X_8339_ _8382_/CLK _8339_/D fanout369/X vssd1 vssd1 vccd1 vccd1 _8339_/Q sky130_fd_sc_hd__dfrtp_2
XFILLER_3_5 vssd1 vssd1 vccd1 vccd1 sky130_fd_sc_hd__fill_1
XANTENNA__5044__B _5780_/B vssd1 vssd1 vccd1 vccd1 sky130_fd_sc_hd__diode_2
XFILLER_48_43 vssd1 vssd1 vccd1 vccd1 sky130_fd_sc_hd__fill_1
XFILLER_19_505 vssd1 vssd1 vccd1 vccd1 sky130_fd_sc_hd__fill_1
XPHY_EDGE_ROW_45_Left_138 vssd1 vssd1 vccd1 vccd1 sky130_fd_sc_hd__decap_3
XANTENNA_fanout69_X _5267_/B vssd1 vssd1 vccd1 vccd1 sky130_fd_sc_hd__diode_2
XFILLER_48_98 vssd1 vssd1 vccd1 vccd1 sky130_fd_sc_hd__fill_2
XFILLER_86_493 vssd1 vssd1 vccd1 vccd1 sky130_fd_sc_hd__fill_4
XFILLER_73_132 vssd1 vssd1 vccd1 vccd1 sky130_fd_sc_hd__fill_4
XFILLER_64_31 vssd1 vssd1 vccd1 vccd1 sky130_fd_sc_hd__fill_1
XANTENNA__4994__A1 _5930_/A vssd1 vssd1 vccd1 vccd1 sky130_fd_sc_hd__diode_2
XFILLER_73_198 vssd1 vssd1 vccd1 vccd1 sky130_fd_sc_hd__fill_1
XFILLER_42_552 vssd1 vssd1 vccd1 vccd1 sky130_fd_sc_hd__fill_1
Xfanout91 _4325_/Y vssd1 vssd1 vccd1 vccd1 wire92/A sky130_fd_sc_hd__clkdlybuf4s25_1
XPHY_EDGE_ROW_54_Left_147 vssd1 vssd1 vccd1 vccd1 sky130_fd_sc_hd__decap_3
XANTENNA__8310__S _8313_/S vssd1 vssd1 vccd1 vccd1 sky130_fd_sc_hd__diode_2
XANTENNA__7160__A2 _7725_/B vssd1 vssd1 vccd1 vccd1 sky130_fd_sc_hd__diode_2
XFILLER_36_5 vssd1 vssd1 vccd1 vccd1 sky130_fd_sc_hd__fill_1
XTAP_TAPCELL_ROW_9_291 vssd1 vccd1 sky130_fd_sc_hd__tapvpwrvgnd_1
XPHY_EDGE_ROW_63_Left_156 vssd1 vssd1 vccd1 vccd1 sky130_fd_sc_hd__decap_3
XANTENNA__5889__B _6738_/B vssd1 vssd1 vccd1 vccd1 sky130_fd_sc_hd__diode_2
XFILLER_92_441 vssd1 vssd1 vccd1 vccd1 sky130_fd_sc_hd__fill_4
XANTENNA__5401__C _8220_/A vssd1 vssd1 vccd1 vccd1 sky130_fd_sc_hd__diode_2
X_5971_ _5971_/A _5971_/B vssd1 vssd1 vccd1 vccd1 _5973_/B sky130_fd_sc_hd__nor2_2
XANTENNA__5631__C1 _5669_/B vssd1 vssd1 vccd1 vccd1 sky130_fd_sc_hd__diode_2
XFILLER_64_187 vssd1 vssd1 vccd1 vccd1 sky130_fd_sc_hd__fill_1
X_7710_ _7710_/A _7710_/B vssd1 vssd1 vccd1 vccd1 _7713_/A sky130_fd_sc_hd__xor2_2
X_4922_ _4923_/B _4923_/A vssd1 vssd1 vccd1 vccd1 _4922_/Y sky130_fd_sc_hd__nand2b_2
XTAP_TAPCELL_ROW_63_834 vssd1 vccd1 sky130_fd_sc_hd__tapvpwrvgnd_1
XTAP_TAPCELL_ROW_35_547 vssd1 vccd1 sky130_fd_sc_hd__tapvpwrvgnd_1
XFILLER_33_563 vssd1 vssd1 vccd1 vccd1 sky130_fd_sc_hd__fill_4
X_7641_ _7640_/B _7641_/B vssd1 vssd1 vccd1 vccd1 _7642_/B sky130_fd_sc_hd__and2b_2
X_4853_ _4941_/B _4853_/B vssd1 vssd1 vccd1 vccd1 _4856_/A sky130_fd_sc_hd__nor2_2
XPHY_EDGE_ROW_72_Left_165 vssd1 vssd1 vccd1 vccd1 sky130_fd_sc_hd__decap_3
X_7572_ _7572_/A _7572_/B vssd1 vssd1 vccd1 vccd1 _7574_/B sky130_fd_sc_hd__and2_2
X_4784_ _4979_/A _4931_/D _4843_/A _4783_/D vssd1 vssd1 vccd1 vccd1 _4785_/C sky130_fd_sc_hd__a22o_2
X_6523_ _6523_/A _6523_/B vssd1 vssd1 vccd1 vccd1 _6525_/A sky130_fd_sc_hd__nor2_2
X_6454_ _6540_/B _6454_/B _6454_/C vssd1 vssd1 vccd1 vccd1 _6553_/A sky130_fd_sc_hd__or3_2
XANTENNA_fanout116_A _4366_/X vssd1 vssd1 vccd1 vccd1 sky130_fd_sc_hd__diode_2
X_5405_ _5406_/A _5406_/B vssd1 vssd1 vccd1 vccd1 _5407_/A sky130_fd_sc_hd__and2_2
X_6385_ _6187_/X _6385_/B vssd1 vssd1 vccd1 vccd1 _6387_/B sky130_fd_sc_hd__and2b_2
X_8124_ _8133_/B _8263_/A _8028_/A _8026_/B vssd1 vssd1 vccd1 vccd1 _8129_/A sky130_fd_sc_hd__a31o_2
X_5336_ _5342_/B _5477_/A _5342_/A vssd1 vssd1 vccd1 vccd1 _5458_/B sky130_fd_sc_hd__o21ai_2
XPHY_EDGE_ROW_81_Left_174 vssd1 vssd1 vccd1 vccd1 sky130_fd_sc_hd__decap_3
X_8055_ _8055_/A _8055_/B _8055_/C vssd1 vssd1 vccd1 vccd1 _8056_/B sky130_fd_sc_hd__and3_2
X_5267_ _5267_/A _5267_/B vssd1 vssd1 vccd1 vccd1 _5269_/B sky130_fd_sc_hd__nor2_2
X_7006_ _7006_/A _7006_/B vssd1 vssd1 vccd1 vccd1 _7017_/A sky130_fd_sc_hd__xnor2_2
X_4218_ hold538/X _8254_/B _4218_/S vssd1 vssd1 vccd1 vccd1 _8421_/D sky130_fd_sc_hd__mux2_1
XFILLER_68_471 vssd1 vssd1 vccd1 vccd1 sky130_fd_sc_hd__fill_1
X_5198_ _5198_/A _5198_/B _5198_/C vssd1 vssd1 vccd1 vccd1 _5200_/A sky130_fd_sc_hd__and3_4
XANTENNA_fanout273_X _6832_/A vssd1 vssd1 vccd1 vccd1 sky130_fd_sc_hd__diode_2
XFILLER_18_46 vssd1 vssd1 vccd1 vccd1 sky130_fd_sc_hd__fill_1
XFILLER_55_132 vssd1 vssd1 vccd1 vccd1 sky130_fd_sc_hd__fill_1
X_4149_ _8433_/Q input6/X _4160_/B vssd1 vssd1 vccd1 vccd1 _4149_/X sky130_fd_sc_hd__mux2_4
XFILLER_83_485 vssd1 vssd1 vccd1 vccd1 sky130_fd_sc_hd__fill_1
XTAP_TAPCELL_ROW_87_1066 vssd1 vccd1 sky130_fd_sc_hd__tapvpwrvgnd_1
XFILLER_70_124 vssd1 vssd1 vccd1 vccd1 sky130_fd_sc_hd__fill_2
X_7908_ _7909_/A _7909_/B _7909_/C vssd1 vssd1 vccd1 vccd1 _7988_/B sky130_fd_sc_hd__o21a_2
XFILLER_24_541 vssd1 vssd1 vccd1 vccd1 sky130_fd_sc_hd__fill_4
XFILLER_34_34 vssd1 vssd1 vccd1 vccd1 sky130_fd_sc_hd__fill_1
XPHY_EDGE_ROW_90_Left_183 vssd1 vssd1 vccd1 vccd1 sky130_fd_sc_hd__decap_3
XFILLER_34_89 vssd1 vssd1 vccd1 vccd1 sky130_fd_sc_hd__fill_2
X_7839_ _7839_/A _7839_/B vssd1 vssd1 vccd1 vccd1 _7840_/B sky130_fd_sc_hd__nand2_2
XFILLER_11_279 vssd1 vssd1 vccd1 vccd1 sky130_fd_sc_hd__fill_1
XFILLER_50_33 vssd1 vssd1 vccd1 vccd1 sky130_fd_sc_hd__fill_2
Xclkload0 clkload0/A vssd1 vssd1 vccd1 vccd1 clkload0/X sky130_fd_sc_hd__clkbuf_4
XANTENNA__7535__A _8016_/A vssd1 vssd1 vccd1 vccd1 sky130_fd_sc_hd__diode_2
XFILLER_50_66 vssd1 vssd1 vccd1 vccd1 sky130_fd_sc_hd__fill_2
XANTENNA__4894__A _5747_/A vssd1 vssd1 vccd1 vccd1 sky130_fd_sc_hd__diode_2
XTAP_TAPCELL_ROW_6_261 vssd1 vccd1 sky130_fd_sc_hd__tapvpwrvgnd_1
Xfanout270 _6433_/A vssd1 vssd1 vccd1 vccd1 _5657_/B sky130_fd_sc_hd__clkdlybuf4s25_1
Xfanout281 _8357_/Q vssd1 vssd1 vccd1 vccd1 _8103_/D sky130_fd_sc_hd__clkdlybuf4s25_1
Xfanout292 _8352_/Q vssd1 vssd1 vccd1 vccd1 _8264_/A sky130_fd_sc_hd__clkdlybuf4s25_1
XPHY_EDGE_ROW_3_Left_96 vssd1 vssd1 vccd1 vccd1 sky130_fd_sc_hd__decap_3
XFILLER_46_110 vssd1 vssd1 vccd1 vccd1 sky130_fd_sc_hd__fill_1
XFILLER_75_52 vssd1 vssd1 vccd1 vccd1 sky130_fd_sc_hd__fill_4
Xload_slew56 _6156_/B vssd1 vssd1 vccd1 vccd1 _5128_/C sky130_fd_sc_hd__clkbuf_2
Xload_slew45 _7080_/B vssd1 vssd1 vccd1 vccd1 _8082_/D sky130_fd_sc_hd__clkbuf_4
XTAP_TAPCELL_ROW_60_804 vssd1 vccd1 sky130_fd_sc_hd__tapvpwrvgnd_1
XANTENNA__6333__B _7095_/C vssd1 vssd1 vccd1 vccd1 sky130_fd_sc_hd__diode_2
XANTENNA__7429__B _7714_/A vssd1 vssd1 vccd1 vccd1 sky130_fd_sc_hd__diode_2
XTAP_TAPCELL_ROW_32_517 vssd1 vccd1 sky130_fd_sc_hd__tapvpwrvgnd_1
XFILLER_30_533 vssd1 vssd1 vccd1 vccd1 sky130_fd_sc_hd__fill_2
XFILLER_91_95 vssd1 vssd1 vccd1 vccd1 sky130_fd_sc_hd__fill_4
XFILLER_41_3 vssd1 vssd1 vccd1 vccd1 sky130_fd_sc_hd__fill_1
X_6170_ _6170_/A _6170_/B vssd1 vssd1 vccd1 vccd1 _6180_/A sky130_fd_sc_hd__xor2_2
X_5121_ _5121_/A _5121_/B vssd1 vssd1 vccd1 vccd1 _5122_/B sky130_fd_sc_hd__xnor2_2
XANTENNA__4655__B1 _4692_/B vssd1 vssd1 vccd1 vccd1 sky130_fd_sc_hd__diode_2
XFILLER_84_205 vssd1 vssd1 vccd1 vccd1 sky130_fd_sc_hd__fill_2
X_5052_ _5052_/A _5052_/B vssd1 vssd1 vccd1 vccd1 _5052_/X sky130_fd_sc_hd__xor2_2
XANTENNA__4309__A _4761_/A vssd1 vssd1 vccd1 vccd1 sky130_fd_sc_hd__diode_2
XANTENNA__8406__CLK clkload6/A vssd1 vssd1 vccd1 vccd1 sky130_fd_sc_hd__diode_2
XFILLER_1_82 vssd1 vssd1 vccd1 vccd1 sky130_fd_sc_hd__fill_1
XFILLER_65_496 vssd1 vssd1 vccd1 vccd1 sky130_fd_sc_hd__fill_2
XTAP_TAPCELL_ROW_48_683 vssd1 vccd1 sky130_fd_sc_hd__tapvpwrvgnd_1
XANTENNA__6524__A _8110_/A vssd1 vssd1 vccd1 vccd1 sky130_fd_sc_hd__diode_2
XFILLER_52_168 vssd1 vssd1 vccd1 vccd1 sky130_fd_sc_hd__fill_1
X_5954_ _6114_/A _5954_/B vssd1 vssd1 vccd1 vccd1 _6115_/A sky130_fd_sc_hd__nand2_2
XFILLER_21_511 vssd1 vssd1 vccd1 vccd1 sky130_fd_sc_hd__fill_2
X_5885_ hold554/X _5884_/X _8071_/S vssd1 vssd1 vccd1 vccd1 _8320_/D sky130_fd_sc_hd__mux2_1
X_4905_ _4904_/B _4904_/C _4904_/A vssd1 vssd1 vccd1 vccd1 _4906_/C sky130_fd_sc_hd__a21o_2
XANTENNA_fanout233_A _8371_/Q vssd1 vssd1 vccd1 vccd1 sky130_fd_sc_hd__diode_2
X_7624_ _7624_/A _7624_/B vssd1 vssd1 vccd1 vccd1 _7634_/A sky130_fd_sc_hd__xnor2_2
X_4836_ _4836_/A _4836_/B vssd1 vssd1 vccd1 vccd1 _4868_/A sky130_fd_sc_hd__xnor2_2
X_7555_ _8103_/A _7875_/D _7877_/B _7754_/B vssd1 vssd1 vccd1 vccd1 _7556_/B sky130_fd_sc_hd__a22oi_2
X_6506_ _6506_/A _6506_/B vssd1 vssd1 vccd1 vccd1 _6508_/B sky130_fd_sc_hd__xnor2_2
X_4767_ _4767_/A _4767_/B vssd1 vssd1 vccd1 vccd1 _4768_/B sky130_fd_sc_hd__xnor2_2
XFILLER_20_25 vssd1 vssd1 vccd1 vccd1 sky130_fd_sc_hd__fill_2
X_7486_ _7485_/A _7485_/B _7485_/C vssd1 vssd1 vccd1 vccd1 _7494_/B sky130_fd_sc_hd__o21ai_2
X_4698_ _4704_/C _4699_/A vssd1 vssd1 vccd1 vccd1 _4701_/A sky130_fd_sc_hd__and2b_2
XFILLER_20_47 vssd1 vssd1 vccd1 vccd1 sky130_fd_sc_hd__fill_4
X_6437_ _6437_/A _6437_/B vssd1 vssd1 vccd1 vccd1 _6439_/A sky130_fd_sc_hd__nor2_2
X_6368_ _6368_/A _6368_/B vssd1 vssd1 vccd1 vccd1 _6380_/A sky130_fd_sc_hd__nor2_2
XFILLER_0_437 vssd1 vssd1 vccd1 vccd1 sky130_fd_sc_hd__fill_2
XFILLER_88_533 vssd1 vssd1 vccd1 vccd1 sky130_fd_sc_hd__fill_4
X_8107_ _8108_/A _8359_/Q _8360_/Q _8108_/B vssd1 vssd1 vccd1 vccd1 _8111_/A sky130_fd_sc_hd__a22o_2
X_5319_ _5319_/A _5319_/B vssd1 vssd1 vccd1 vccd1 _5326_/A sky130_fd_sc_hd__xnor2_2
X_6299_ _8434_/D _6582_/B vssd1 vssd1 vccd1 vccd1 _6300_/C sky130_fd_sc_hd__and2_2
XFILLER_48_419 vssd1 vssd1 vccd1 vccd1 sky130_fd_sc_hd__fill_1
X_8038_ _8038_/A _8038_/B vssd1 vssd1 vccd1 vccd1 _8040_/C sky130_fd_sc_hd__or2_2
XTAP_TAPCELL_ROW_3_231 vssd1 vccd1 sky130_fd_sc_hd__tapvpwrvgnd_1
XFILLER_90_208 vssd1 vssd1 vccd1 vccd1 sky130_fd_sc_hd__fill_1
XFILLER_45_55 vssd1 vssd1 vccd1 vccd1 sky130_fd_sc_hd__fill_1
XANTENNA__7249__B _7754_/B vssd1 vssd1 vccd1 vccd1 sky130_fd_sc_hd__diode_2
XFILLER_12_566 vssd1 vssd1 vccd1 vccd1 sky130_fd_sc_hd__fill_4
XANTENNA__8312__A1 _8208_/B vssd1 vssd1 vccd1 vccd1 sky130_fd_sc_hd__diode_2
XANTENNA__8362__RESET_B _4226_/X vssd1 vssd1 vccd1 vccd1 sky130_fd_sc_hd__diode_2
XANTENNA__5429__A2 _6207_/A vssd1 vssd1 vccd1 vccd1 sky130_fd_sc_hd__diode_2
XANTENNA__8429__CLK clkload6/A vssd1 vssd1 vccd1 vccd1 sky130_fd_sc_hd__diode_2
XFILLER_79_566 vssd1 vssd1 vccd1 vccd1 sky130_fd_sc_hd__fill_2
XANTENNA__4207__A_N input6/X vssd1 vssd1 vccd1 vccd1 sky130_fd_sc_hd__diode_2
XFILLER_34_124 vssd1 vssd1 vccd1 vccd1 sky130_fd_sc_hd__fill_4
XTAP_TAPCELL_ROW_45_653 vssd1 vccd1 sky130_fd_sc_hd__tapvpwrvgnd_1
XANTENNA__7159__B _7998_/B vssd1 vssd1 vccd1 vccd1 sky130_fd_sc_hd__diode_2
XFILLER_34_179 vssd1 vssd1 vccd1 vccd1 sky130_fd_sc_hd__fill_1
XFILLER_62_477 vssd1 vssd1 vccd1 vccd1 sky130_fd_sc_hd__fill_1
XFILLER_62_499 vssd1 vssd1 vccd1 vccd1 sky130_fd_sc_hd__fill_4
XTAP_TAPCELL_ROW_17_366 vssd1 vccd1 sky130_fd_sc_hd__tapvpwrvgnd_1
XFILLER_30_330 vssd1 vssd1 vccd1 vccd1 sky130_fd_sc_hd__fill_1
X_5670_ _8174_/A _5670_/B vssd1 vssd1 vccd1 vccd1 _5671_/C sky130_fd_sc_hd__nand2b_2
XANTENNA_clkbuf_0_clk_A clk vssd1 vssd1 vccd1 vccd1 sky130_fd_sc_hd__diode_2
X_4621_ _4621_/A _4621_/B vssd1 vssd1 vccd1 vccd1 _4638_/B sky130_fd_sc_hd__xnor2_2
XANTENNA__8303__A1 _8254_/B vssd1 vssd1 vccd1 vccd1 sky130_fd_sc_hd__diode_2
X_7340_ _7340_/A _7395_/A _7340_/C vssd1 vssd1 vccd1 vccd1 _7395_/B sky130_fd_sc_hd__nor3_2
X_4552_ _4552_/A _4552_/B vssd1 vssd1 vccd1 vccd1 _4585_/B sky130_fd_sc_hd__xor2_2
Xhold526 _8385_/Q vssd1 vssd1 vccd1 vccd1 _8444_/D sky130_fd_sc_hd__dlygate4sd3_1
Xhold515 _8402_/Q vssd1 vssd1 vccd1 vccd1 _8399_/D sky130_fd_sc_hd__dlygate4sd3_1
X_7271_ _7156_/A _7158_/B _7156_/B vssd1 vssd1 vccd1 vccd1 _7273_/C sky130_fd_sc_hd__o21ba_2
X_4483_ _4483_/A _4782_/A vssd1 vssd1 vccd1 vccd1 _4785_/A sky130_fd_sc_hd__nor2_2
Xhold548 _8328_/Q vssd1 vssd1 vccd1 vccd1 hold548/X sky130_fd_sc_hd__dlygate4sd3_1
Xhold537 _8362_/Q vssd1 vssd1 vccd1 vccd1 _8287_/A sky130_fd_sc_hd__dlygate4sd3_1
X_6222_ _6223_/A _6223_/B _6223_/C vssd1 vssd1 vccd1 vccd1 _6447_/A sky130_fd_sc_hd__o21ai_2
XANTENNA__7622__B _8082_/C vssd1 vssd1 vccd1 vccd1 sky130_fd_sc_hd__diode_2
XANTENNA_clkbuf_4_9_0_clk_A clkbuf_0_clk/X vssd1 vssd1 vccd1 vccd1 sky130_fd_sc_hd__diode_2
XANTENNA__6519__A _6832_/A vssd1 vssd1 vccd1 vccd1 sky130_fd_sc_hd__diode_2
X_6153_ _6153_/A _6153_/B vssd1 vssd1 vccd1 vccd1 _6154_/B sky130_fd_sc_hd__xnor2_2
XANTENNA__6238__B _6238_/B vssd1 vssd1 vccd1 vccd1 sky130_fd_sc_hd__diode_2
XFILLER_85_525 vssd1 vssd1 vccd1 vccd1 sky130_fd_sc_hd__fill_1
X_6084_ _5995_/A _5993_/X _5992_/X vssd1 vssd1 vccd1 vccd1 _6196_/A sky130_fd_sc_hd__o21ba_2
X_5104_ _5104_/A _7007_/B vssd1 vssd1 vccd1 vccd1 _5110_/A sky130_fd_sc_hd__or2_2
X_5035_ _5035_/A _5035_/B vssd1 vssd1 vccd1 vccd1 _5040_/A sky130_fd_sc_hd__xnor2_2
XANTENNA_fanout183_A _6572_/A vssd1 vssd1 vccd1 vccd1 sky130_fd_sc_hd__diode_2
XTAP_TAPCELL_ROW_0_201 vssd1 vccd1 sky130_fd_sc_hd__tapvpwrvgnd_1
XFILLER_25_124 vssd1 vssd1 vccd1 vccd1 sky130_fd_sc_hd__fill_1
X_6986_ _7808_/A _6986_/B vssd1 vssd1 vccd1 vccd1 _7082_/A sky130_fd_sc_hd__nor2_2
XTAP_TAPCELL_ROW_84_1036 vssd1 vccd1 sky130_fd_sc_hd__tapvpwrvgnd_1
XFILLER_15_25 vssd1 vssd1 vccd1 vccd1 sky130_fd_sc_hd__fill_2
X_5937_ _8433_/D wire99/X _5713_/B _5711_/X vssd1 vssd1 vccd1 vccd1 _5945_/A sky130_fd_sc_hd__a31o_2
XANTENNA__6404__D _6798_/B vssd1 vssd1 vccd1 vccd1 sky130_fd_sc_hd__diode_2
XANTENNA_fanout236_X _8125_/A vssd1 vssd1 vccd1 vccd1 sky130_fd_sc_hd__diode_2
X_7607_ _7608_/B _7608_/A vssd1 vssd1 vccd1 vccd1 _7607_/Y sky130_fd_sc_hd__nand2b_2
X_5868_ _5868_/A _5868_/B _5868_/C vssd1 vssd1 vccd1 vccd1 _5869_/A sky130_fd_sc_hd__nor3_2
XANTENNA__6701__B _6701_/B vssd1 vssd1 vccd1 vccd1 sky130_fd_sc_hd__diode_2
X_5799_ _5800_/A _5800_/B vssd1 vssd1 vccd1 vccd1 _5799_/Y sky130_fd_sc_hd__nor2_2
X_4819_ _4819_/A _4819_/B _4819_/C vssd1 vssd1 vccd1 vccd1 _4891_/A sky130_fd_sc_hd__nand3_2
XFILLER_5_507 vssd1 vssd1 vccd1 vccd1 sky130_fd_sc_hd__fill_1
X_7538_ _8125_/A _7875_/C vssd1 vssd1 vccd1 vccd1 _7539_/B sky130_fd_sc_hd__nand2_2
XANTENNA__4221__B _4223_/B vssd1 vssd1 vccd1 vccd1 sky130_fd_sc_hd__diode_2
X_7469_ _7469_/A _7469_/B vssd1 vssd1 vccd1 vccd1 _7472_/A sky130_fd_sc_hd__xnor2_2
Xoutput24 _8323_/Q vssd1 vssd1 vccd1 vccd1 gpio_out[21] sky130_fd_sc_hd__clkdlybuf4s25_1
XANTENNA_fanout96_A _5147_/B vssd1 vssd1 vccd1 vccd1 sky130_fd_sc_hd__diode_2
Xoutput35 _8334_/Q vssd1 vssd1 vccd1 vccd1 gpio_out[32] sky130_fd_sc_hd__clkdlybuf4s25_1
XFILLER_76_514 vssd1 vssd1 vccd1 vccd1 sky130_fd_sc_hd__fill_2
XTAP_TAPCELL_ROW_59_789 vssd1 vccd1 sky130_fd_sc_hd__tapvpwrvgnd_1
XFILLER_29_485 vssd1 vssd1 vccd1 vccd1 sky130_fd_sc_hd__fill_1
XFILLER_56_260 vssd1 vccd1 vssd1 vccd1 sky130_ef_sc_hd__decap_40_12
XANTENNA__8082__C _8082_/C vssd1 vssd1 vccd1 vccd1 sky130_fd_sc_hd__diode_2
XFILLER_56_293 vssd1 vssd1 vccd1 vccd1 sky130_fd_sc_hd__fill_1
XPHY_EDGE_ROW_19_Right_19 vssd1 vssd1 vccd1 vccd1 sky130_fd_sc_hd__decap_3
XFILLER_71_296 vssd1 vssd1 vccd1 vccd1 sky130_fd_sc_hd__fill_4
XTAP_TAPCELL_ROW_42_623 vssd1 vccd1 sky130_fd_sc_hd__tapvpwrvgnd_1
XTAP_TAPCELL_ROW_14_336 vssd1 vccd1 sky130_fd_sc_hd__tapvpwrvgnd_1
XFILLER_8_301 vssd1 vssd1 vccd1 vccd1 sky130_fd_sc_hd__fill_2
XANTENNA__6611__B _7966_/B vssd1 vssd1 vccd1 vccd1 sky130_fd_sc_hd__diode_2
XANTENNA__8297__A0 _6016_/A vssd1 vssd1 vccd1 vccd1 sky130_fd_sc_hd__diode_2
XFILLER_4_551 vssd1 vssd1 vccd1 vccd1 sky130_fd_sc_hd__fill_2
XPHY_EDGE_ROW_28_Right_28 vssd1 vssd1 vccd1 vccd1 sky130_fd_sc_hd__decap_3
XFILLER_67_503 vssd1 vssd1 vccd1 vccd1 sky130_fd_sc_hd__fill_1
XFILLER_79_385 vssd1 vssd1 vccd1 vccd1 sky130_fd_sc_hd__fill_2
XPHY_EDGE_ROW_37_Right_37 vssd1 vssd1 vccd1 vccd1 sky130_fd_sc_hd__decap_3
XFILLER_62_241 vssd1 vssd1 vccd1 vccd1 sky130_fd_sc_hd__fill_2
X_6840_ _6841_/B _6841_/A vssd1 vssd1 vccd1 vccd1 _6937_/A sky130_fd_sc_hd__and2b_2
XFILLER_35_488 vssd1 vssd1 vccd1 vccd1 sky130_fd_sc_hd__fill_1
X_6771_ _7668_/A _7081_/B _6986_/B _7603_/A vssd1 vssd1 vccd1 vccd1 _6771_/X sky130_fd_sc_hd__o22a_2
X_5722_ _5711_/A _5156_/B _5160_/B vssd1 vssd1 vccd1 vccd1 _5730_/A sky130_fd_sc_hd__a21o_2
XANTENNA__6080__Y _6080_/Y vssd1 vssd1 vccd1 vccd1 sky130_fd_sc_hd__diode_2
XANTENNA__6521__B _8103_/B vssd1 vssd1 vccd1 vccd1 sky130_fd_sc_hd__diode_2
X_8441_ clkload2/A _8441_/D wire368/X vssd1 vssd1 vccd1 vccd1 _8441_/Q sky130_fd_sc_hd__dfrtp_2
X_5653_ _5652_/B _5652_/C _5652_/A vssd1 vssd1 vccd1 vccd1 _5654_/B sky130_fd_sc_hd__a21bo_2
X_8372_ clkload3/A _8372_/D load_slew366/X vssd1 vssd1 vccd1 vccd1 _8372_/Q sky130_fd_sc_hd__dfrtp_2
X_5584_ _5584_/A _5584_/B vssd1 vssd1 vccd1 vccd1 _5585_/B sky130_fd_sc_hd__or2_2
X_4604_ _4602_/B _4602_/A _4603_/X vssd1 vssd1 vccd1 vccd1 _4611_/A sky130_fd_sc_hd__o21ba_4
XPHY_EDGE_ROW_46_Right_46 vssd1 vssd1 vccd1 vccd1 sky130_fd_sc_hd__decap_3
XANTENNA__8288__A0 _6460_/A vssd1 vssd1 vccd1 vccd1 sky130_fd_sc_hd__diode_2
X_7323_ _7004_/B _7059_/Y _7063_/A _7063_/B vssd1 vssd1 vccd1 vccd1 _7333_/A sky130_fd_sc_hd__a2bb2o_2
X_4535_ _4744_/A _5147_/B _4576_/B _4532_/Y vssd1 vssd1 vccd1 vccd1 _4540_/A sky130_fd_sc_hd__a31o_2
X_7254_ _7161_/B _7163_/B _7161_/A vssd1 vssd1 vccd1 vccd1 _7256_/B sky130_fd_sc_hd__o21ba_2
X_4466_ _4467_/A _4467_/B vssd1 vssd1 vccd1 vccd1 _4805_/A sky130_fd_sc_hd__nand2b_2
X_7185_ _7990_/A _8125_/B _7186_/C vssd1 vssd1 vccd1 vccd1 _7187_/A sky130_fd_sc_hd__a21oi_2
X_6205_ _6412_/A _6205_/B vssd1 vssd1 vccd1 vccd1 _6213_/A sky130_fd_sc_hd__nand2_2
X_4397_ _4397_/A _4397_/B vssd1 vssd1 vccd1 vccd1 _4402_/A sky130_fd_sc_hd__xor2_2
XFILLER_58_503 vssd1 vssd1 vccd1 vccd1 sky130_fd_sc_hd__fill_1
XFILLER_58_525 vssd1 vssd1 vccd1 vccd1 sky130_fd_sc_hd__fill_1
X_6136_ _6136_/A _6136_/B vssd1 vssd1 vccd1 vccd1 _6138_/B sky130_fd_sc_hd__xor2_2
X_6067_ _6460_/A _8241_/A _5867_/A _5863_/X vssd1 vssd1 vccd1 vccd1 _6069_/B sky130_fd_sc_hd__a31oi_2
XPHY_EDGE_ROW_55_Right_55 vssd1 vssd1 vccd1 vccd1 sky130_fd_sc_hd__decap_3
XANTENNA__8183__B _8184_/B vssd1 vssd1 vccd1 vccd1 sky130_fd_sc_hd__diode_2
X_5018_ _5019_/A _5019_/B vssd1 vssd1 vccd1 vccd1 _5144_/A sky130_fd_sc_hd__and2b_2
XANTENNA__8212__A0 _8208_/A vssd1 vssd1 vccd1 vccd1 sky130_fd_sc_hd__diode_2
XTAP_TAPCELL_ROW_56_759 vssd1 vccd1 sky130_fd_sc_hd__tapvpwrvgnd_1
XFILLER_13_116 vssd1 vssd1 vccd1 vccd1 sky130_fd_sc_hd__fill_1
X_6969_ _6615_/B _6974_/A _6728_/B _6728_/A vssd1 vssd1 vccd1 vccd1 _6977_/A sky130_fd_sc_hd__a22oi_2
XANTENNA__6712__A _6712_/A vssd1 vssd1 vccd1 vccd1 sky130_fd_sc_hd__diode_2
XANTENNA__6431__B _6517_/B vssd1 vssd1 vccd1 vccd1 sky130_fd_sc_hd__diode_2
XFILLER_21_160 vssd1 vssd1 vccd1 vccd1 sky130_fd_sc_hd__fill_1
XFILLER_21_171 vssd1 vssd1 vccd1 vccd1 sky130_fd_sc_hd__fill_1
XFILLER_42_45 vssd1 vssd1 vccd1 vccd1 sky130_fd_sc_hd__fill_1
XTAP_TAPCELL_ROW_11_306 vssd1 vccd1 sky130_fd_sc_hd__tapvpwrvgnd_1
XPHY_EDGE_ROW_64_Right_64 vssd1 vssd1 vccd1 vccd1 sky130_fd_sc_hd__decap_3
XFILLER_5_337 vssd1 vssd1 vccd1 vccd1 sky130_fd_sc_hd__fill_1
Xrebuffer475 _6793_/X vssd1 vssd1 vccd1 vccd1 _7039_/B sky130_fd_sc_hd__buf_2
Xrebuffer464 _4183_/X vssd1 vssd1 vccd1 vccd1 _8436_/D sky130_fd_sc_hd__buf_2
Xrebuffer453 _4155_/Y vssd1 vssd1 vccd1 vccd1 _6576_/A sky130_fd_sc_hd__buf_2
Xrebuffer442 _4521_/B vssd1 vssd1 vccd1 vccd1 _4530_/A1 sky130_fd_sc_hd__buf_2
XANTENNA__6829__A1 _6830_/A vssd1 vssd1 vccd1 vccd1 sky130_fd_sc_hd__diode_2
Xrebuffer497 _5300_/Y vssd1 vssd1 vccd1 vccd1 _5301_/B sky130_fd_sc_hd__buf_2
Xrebuffer486 _4724_/Y vssd1 vssd1 vccd1 vccd1 _5052_/B sky130_fd_sc_hd__buf_4
XANTENNA__6829__B2 _6830_/B vssd1 vssd1 vccd1 vccd1 sky130_fd_sc_hd__diode_2
XFILLER_3_28 vssd1 vssd1 vccd1 vccd1 sky130_fd_sc_hd__fill_2
XANTENNA__5063__A _6631_/A vssd1 vssd1 vccd1 vccd1 sky130_fd_sc_hd__diode_2
XFILLER_76_322 vssd1 vssd1 vccd1 vccd1 sky130_fd_sc_hd__fill_1
XPHY_EDGE_ROW_73_Right_73 vssd1 vssd1 vccd1 vccd1 sky130_fd_sc_hd__decap_3
XFILLER_76_377 vssd1 vssd1 vccd1 vccd1 sky130_fd_sc_hd__fill_1
XFILLER_17_488 vssd1 vssd1 vccd1 vccd1 sky130_fd_sc_hd__fill_2
XFILLER_44_274 vssd1 vssd1 vccd1 vccd1 sky130_fd_sc_hd__fill_2
XTAP_TAPCELL_ROW_27_472 vssd1 vccd1 sky130_fd_sc_hd__tapvpwrvgnd_1
XANTENNA__8313__S _8313_/S vssd1 vssd1 vccd1 vccd1 sky130_fd_sc_hd__diode_2
XPHY_EDGE_ROW_82_Right_82 vssd1 vssd1 vccd1 vccd1 sky130_fd_sc_hd__decap_3
XANTENNA__7437__B _8136_/A vssd1 vssd1 vccd1 vccd1 sky130_fd_sc_hd__diode_2
XANTENNA__5740__B2 _5928_/A vssd1 vssd1 vccd1 vccd1 sky130_fd_sc_hd__diode_2
XANTENNA_max_cap151_X _7958_/A vssd1 vssd1 vccd1 vccd1 sky130_fd_sc_hd__diode_2
X_4320_ _8391_/Q _8450_/Q vssd1 vssd1 vccd1 vccd1 _4321_/B sky130_fd_sc_hd__or2_2
X_4251_ _8384_/Q _8443_/Q _4250_/X vssd1 vssd1 vccd1 vccd1 _4299_/B sky130_fd_sc_hd__a21o_2
XPHY_EDGE_ROW_91_Right_91 vssd1 vssd1 vccd1 vccd1 sky130_fd_sc_hd__decap_3
X_4182_ _4182_/A vssd1 vssd1 vccd1 vccd1 _7095_/A sky130_fd_sc_hd__inv_2
XANTENNA__8284__A _8361_/Q vssd1 vssd1 vccd1 vccd1 sky130_fd_sc_hd__diode_2
XFILLER_67_366 vssd1 vssd1 vccd1 vccd1 sky130_fd_sc_hd__fill_4
X_7941_ _7941_/A _7941_/B vssd1 vssd1 vccd1 vccd1 _7941_/Y sky130_fd_sc_hd__xnor2_2
X_7872_ _7724_/A _7726_/B _7724_/B vssd1 vssd1 vccd1 vccd1 _7880_/A sky130_fd_sc_hd__o21ba_2
XFILLER_63_561 vssd1 vssd1 vccd1 vccd1 sky130_fd_sc_hd__fill_8
XTAP_TAPCELL_ROW_81_1006 vssd1 vccd1 sky130_fd_sc_hd__tapvpwrvgnd_1
XTAP_TAPCELL_ROW_53_729 vssd1 vccd1 sky130_fd_sc_hd__tapvpwrvgnd_1
XFILLER_23_447 vssd1 vssd1 vccd1 vccd1 sky130_fd_sc_hd__fill_1
X_6823_ _6823_/A _6823_/B vssd1 vssd1 vccd1 vccd1 _6824_/C sky130_fd_sc_hd__xnor2_2
X_6754_ _6755_/A _6755_/B _6755_/C vssd1 vssd1 vccd1 vccd1 _6764_/A sky130_fd_sc_hd__a21oi_2
X_6685_ _6685_/A _6685_/B vssd1 vssd1 vccd1 vccd1 _6688_/A sky130_fd_sc_hd__xor2_2
X_5705_ _6114_/A _5953_/B vssd1 vssd1 vccd1 vccd1 _5706_/B sky130_fd_sc_hd__nand2_2
X_8424_ clkload0/A _8424_/D load_slew366/X vssd1 vssd1 vccd1 vccd1 _8424_/Q sky130_fd_sc_hd__dfrtp_2
X_5636_ _5641_/A _5641_/B vssd1 vssd1 vccd1 vccd1 _5640_/B sky130_fd_sc_hd__and2b_2
XANTENNA_fanout313_A _6238_/D vssd1 vssd1 vccd1 vccd1 sky130_fd_sc_hd__diode_2
X_8355_ _8361_/CLK _8355_/D load_slew384/X vssd1 vssd1 vccd1 vccd1 _8355_/Q sky130_fd_sc_hd__dfrtp_2
X_5567_ _5587_/A _5567_/B vssd1 vssd1 vccd1 vccd1 _5574_/A sky130_fd_sc_hd__nand2_2
X_8286_ _8287_/B _8286_/B vssd1 vssd1 vccd1 vccd1 _8361_/D sky130_fd_sc_hd__and2_2
X_7306_ _7307_/B _7307_/A vssd1 vssd1 vccd1 vccd1 _7306_/X sky130_fd_sc_hd__and2b_2
X_5498_ _5498_/A _5498_/B vssd1 vssd1 vccd1 vccd1 _5501_/A sky130_fd_sc_hd__xnor2_2
X_4518_ _4558_/B _4518_/B vssd1 vssd1 vccd1 vccd1 _4555_/B sky130_fd_sc_hd__xnor2_4
XTAP_TAPCELL_ROW_92_1135 vssd1 vccd1 sky130_fd_sc_hd__tapvpwrvgnd_1
XTAP_TAPCELL_ROW_92_1124 vssd1 vccd1 sky130_fd_sc_hd__tapvpwrvgnd_1
X_7237_ _7238_/A _7238_/B vssd1 vssd1 vccd1 vccd1 _7477_/B sky130_fd_sc_hd__nand2b_2
X_4449_ _4332_/A _4332_/B _4333_/Y vssd1 vssd1 vccd1 vccd1 _4469_/A sky130_fd_sc_hd__a21oi_2
X_7168_ _7168_/A _7168_/B vssd1 vssd1 vccd1 vccd1 _7169_/B sky130_fd_sc_hd__nor2_2
X_7099_ _7099_/A _7099_/B vssd1 vssd1 vccd1 vccd1 _7102_/A sky130_fd_sc_hd__xnor2_2
X_6119_ _6119_/A _6119_/B vssd1 vssd1 vccd1 vccd1 _6122_/A sky130_fd_sc_hd__xnor2_2
XTAP_TAPCELL_ROW_69_895 vssd1 vccd1 sky130_fd_sc_hd__tapvpwrvgnd_1
XFILLER_81_391 vssd1 vssd1 vccd1 vccd1 sky130_fd_sc_hd__fill_1
XANTENNA__7538__A _8125_/A vssd1 vssd1 vccd1 vccd1 sky130_fd_sc_hd__diode_2
XTAP_TAPCELL_ROW_24_442 vssd1 vccd1 sky130_fd_sc_hd__tapvpwrvgnd_1
XANTENNA__4897__A _5020_/A vssd1 vssd1 vccd1 vccd1 sky130_fd_sc_hd__diode_2
XFILLER_5_123 vssd1 vssd1 vccd1 vccd1 sky130_fd_sc_hd__fill_1
XFILLER_78_85 vssd1 vssd1 vccd1 vccd1 sky130_fd_sc_hd__fill_2
XFILLER_89_491 vssd1 vssd1 vccd1 vccd1 sky130_fd_sc_hd__fill_8
XANTENNA__8308__S _8313_/S vssd1 vssd1 vccd1 vccd1 sky130_fd_sc_hd__diode_2
XFILLER_76_141 vssd1 vssd1 vccd1 vccd1 sky130_fd_sc_hd__fill_2
XFILLER_64_325 vssd1 vssd1 vccd1 vccd1 sky130_fd_sc_hd__fill_2
XFILLER_60_520 vssd1 vssd1 vccd1 vccd1 sky130_fd_sc_hd__fill_2
XFILLER_60_531 vssd1 vssd1 vccd1 vccd1 sky130_fd_sc_hd__fill_1
XANTENNA__4143__Y _6689_/A vssd1 vssd1 vccd1 vccd1 sky130_fd_sc_hd__diode_2
XANTENNA__6502__D _6894_/B vssd1 vssd1 vccd1 vccd1 sky130_fd_sc_hd__diode_2
XFILLER_71_3 vssd1 vssd1 vccd1 vccd1 sky130_fd_sc_hd__fill_4
X_6470_ _6471_/A _6471_/B _6471_/C vssd1 vssd1 vccd1 vccd1 _6472_/A sky130_fd_sc_hd__o21a_2
X_5421_ _5422_/A _5422_/B vssd1 vssd1 vccd1 vccd1 _5854_/A sky130_fd_sc_hd__nand2_2
X_8140_ _8140_/A _8140_/B vssd1 vssd1 vccd1 vccd1 _8141_/B sky130_fd_sc_hd__xnor2_2
X_5352_ _5415_/B _5386_/A _6016_/A _5417_/D vssd1 vssd1 vccd1 vccd1 _5354_/A sky130_fd_sc_hd__and4_2
XANTENNA__7466__A1 _8103_/A vssd1 vssd1 vccd1 vccd1 sky130_fd_sc_hd__diode_2
XANTENNA__7466__B2 _7754_/B vssd1 vssd1 vccd1 vccd1 sky130_fd_sc_hd__diode_2
XANTENNA__8429__D _8429_/D vssd1 vssd1 vccd1 vccd1 sky130_fd_sc_hd__diode_2
X_8071_ hold533/X _8070_/Y _8071_/S vssd1 vssd1 vccd1 vccd1 _8333_/D sky130_fd_sc_hd__mux2_1
X_4303_ _4303_/A _4303_/B _4979_/B vssd1 vssd1 vccd1 vccd1 _5710_/B sky130_fd_sc_hd__nand3_2
XFILLER_87_428 vssd1 vssd1 vccd1 vccd1 sky130_fd_sc_hd__fill_2
X_7022_ _7076_/A _7021_/C _7021_/A vssd1 vssd1 vccd1 vccd1 _7022_/Y sky130_fd_sc_hd__o21ai_2
X_5283_ _5283_/A _5283_/B _5283_/C vssd1 vssd1 vccd1 vccd1 _5283_/X sky130_fd_sc_hd__and3_2
X_4234_ _8381_/Q _8440_/Q vssd1 vssd1 vccd1 vccd1 _4235_/B sky130_fd_sc_hd__or2_2
XANTENNA__7218__B2 _7862_/B vssd1 vssd1 vccd1 vccd1 sky130_fd_sc_hd__diode_2
XANTENNA__8218__S _8313_/S vssd1 vssd1 vccd1 vccd1 sky130_fd_sc_hd__diode_2
X_4165_ _4227_/S _8425_/Q _4164_/Y vssd1 vssd1 vccd1 vccd1 _4166_/A sky130_fd_sc_hd__o21ai_4
XANTENNA_fanout263_A _5838_/C vssd1 vssd1 vccd1 vccd1 sky130_fd_sc_hd__diode_2
X_7924_ _8055_/B _7924_/B _7924_/C vssd1 vssd1 vccd1 vccd1 _8059_/A sky130_fd_sc_hd__and3_2
XTAP_TAPCELL_ROW_66_865 vssd1 vccd1 sky130_fd_sc_hd__tapvpwrvgnd_1
XTAP_TAPCELL_ROW_38_578 vssd1 vccd1 sky130_fd_sc_hd__tapvpwrvgnd_1
X_7855_ _7853_/X _8136_/A _8032_/A _7855_/D vssd1 vssd1 vccd1 vccd1 _7856_/B sky130_fd_sc_hd__and4b_2
XANTENNA__6262__A _6460_/A vssd1 vssd1 vccd1 vccd1 sky130_fd_sc_hd__diode_2
X_6806_ _7131_/A _7515_/A vssd1 vssd1 vccd1 vccd1 _6807_/B sky130_fd_sc_hd__nand2_2
X_7786_ _7931_/A _7786_/B vssd1 vssd1 vccd1 vccd1 _7786_/X sky130_fd_sc_hd__or2_2
X_4998_ _6091_/A _5147_/B _6703_/B _6294_/A vssd1 vssd1 vccd1 vccd1 _4999_/B sky130_fd_sc_hd__a22o_2
XTAP_TAPCELL_ROW_21_412 vssd1 vccd1 sky130_fd_sc_hd__tapvpwrvgnd_1
X_6737_ _7820_/A wire77/X vssd1 vssd1 vccd1 vccd1 _6737_/Y sky130_fd_sc_hd__nand2_2
XANTENNA__7154__B1 _7877_/B vssd1 vssd1 vccd1 vccd1 sky130_fd_sc_hd__diode_2
XANTENNA_fanout316_X _8215_/A vssd1 vssd1 vccd1 vccd1 sky130_fd_sc_hd__diode_2
X_6668_ _6668_/A _6668_/B vssd1 vssd1 vccd1 vccd1 _6669_/B sky130_fd_sc_hd__nor2_2
X_8407_ clkload6/A _8407_/D load_slew358/X vssd1 vssd1 vccd1 vccd1 _8407_/Q sky130_fd_sc_hd__dfrtp_2
X_6599_ _6599_/A _6599_/B vssd1 vssd1 vccd1 vccd1 _6600_/B sky130_fd_sc_hd__and2_2
X_5619_ _5618_/A _5594_/B _5618_/C vssd1 vssd1 vccd1 vccd1 _5620_/B sky130_fd_sc_hd__a21o_2
X_8338_ _8382_/CLK _8338_/D load_slew370/X vssd1 vssd1 vccd1 vccd1 _8338_/Q sky130_fd_sc_hd__dfrtp_2
X_8269_ _8271_/B _8269_/B vssd1 vssd1 vccd1 vccd1 _8354_/D sky130_fd_sc_hd__nor2_2
XFILLER_48_55 vssd1 vssd1 vccd1 vccd1 sky130_fd_sc_hd__fill_2
XFILLER_58_152 vssd1 vssd1 vccd1 vccd1 sky130_fd_sc_hd__fill_1
XFILLER_14_244 vssd1 vssd1 vccd1 vccd1 sky130_fd_sc_hd__fill_2
Xfanout81 _4812_/Y vssd1 vssd1 vccd1 vccd1 _6712_/B sky130_fd_sc_hd__clkdlybuf4s25_1
XFILLER_10_483 vssd1 vssd1 vccd1 vccd1 sky130_fd_sc_hd__fill_2
XTAP_TAPCELL_ROW_9_292 vssd1 vccd1 sky130_fd_sc_hd__tapvpwrvgnd_1
XFILLER_18_550 vssd1 vssd1 vccd1 vccd1 sky130_fd_sc_hd__fill_4
X_5970_ _5970_/A _5970_/B vssd1 vssd1 vccd1 vccd1 _5973_/A sky130_fd_sc_hd__xor2_2
XFILLER_92_453 vssd1 vssd1 vccd1 vccd1 sky130_fd_sc_hd__fill_2
XANTENNA__7896__A2_N _7897_/B vssd1 vssd1 vccd1 vccd1 sky130_fd_sc_hd__diode_2
X_4921_ _4770_/A _4772_/B _4990_/S _4920_/X vssd1 vssd1 vccd1 vccd1 _4923_/B sky130_fd_sc_hd__o31ai_2
XTAP_TAPCELL_ROW_63_835 vssd1 vccd1 sky130_fd_sc_hd__tapvpwrvgnd_1
X_7640_ _7641_/B _7640_/B vssd1 vssd1 vccd1 vccd1 _7642_/A sky130_fd_sc_hd__and2b_2
X_4852_ _4852_/A _4852_/B vssd1 vssd1 vccd1 vccd1 _4853_/B sky130_fd_sc_hd__and2_2
XTAP_TAPCELL_ROW_35_548 vssd1 vccd1 sky130_fd_sc_hd__tapvpwrvgnd_1
XFILLER_20_214 vssd1 vssd1 vccd1 vccd1 sky130_fd_sc_hd__fill_1
X_7571_ _7572_/A _7572_/B vssd1 vssd1 vccd1 vccd1 _7574_/A sky130_fd_sc_hd__nor2_2
X_4783_ _4979_/A _4931_/D _4843_/A _4783_/D vssd1 vssd1 vccd1 vccd1 _4843_/B sky130_fd_sc_hd__nand4_2
X_6522_ _7998_/A _7140_/C _7723_/C _8103_/B vssd1 vssd1 vccd1 vccd1 _6523_/B sky130_fd_sc_hd__a22oi_2
X_6453_ _6453_/A _6453_/B vssd1 vssd1 vccd1 vccd1 _6454_/C sky130_fd_sc_hd__nor2_2
X_5404_ _5404_/A _5404_/B vssd1 vssd1 vccd1 vccd1 _5406_/B sky130_fd_sc_hd__xnor2_2
XANTENNA_fanout109_A _4700_/B vssd1 vssd1 vccd1 vccd1 sky130_fd_sc_hd__diode_2
X_8123_ _8004_/A _8004_/B _8007_/A vssd1 vssd1 vccd1 vccd1 _8142_/A sky130_fd_sc_hd__a21o_2
X_6384_ _6384_/A _6384_/B vssd1 vssd1 vccd1 vccd1 _6387_/A sky130_fd_sc_hd__xnor2_2
X_5335_ _5342_/B _5334_/Y _5647_/A _5392_/B vssd1 vssd1 vccd1 vccd1 _5477_/A sky130_fd_sc_hd__and4bb_2
XFILLER_87_225 vssd1 vssd1 vccd1 vccd1 sky130_fd_sc_hd__fill_4
X_8054_ _8055_/A _8055_/B _8055_/C vssd1 vssd1 vccd1 vccd1 _8056_/A sky130_fd_sc_hd__a21oi_2
X_5266_ _5266_/A _5266_/B vssd1 vssd1 vccd1 vccd1 _5269_/A sky130_fd_sc_hd__nor2_2
XFILLER_87_258 vssd1 vssd1 vccd1 vccd1 sky130_fd_sc_hd__fill_1
X_7005_ _8416_/D wire64/X vssd1 vssd1 vccd1 vccd1 _7006_/B sky130_fd_sc_hd__nand2_2
X_4217_ _7685_/A vssd1 vssd1 vccd1 vccd1 _8082_/A sky130_fd_sc_hd__inv_2
X_5197_ _6611_/A _6631_/B _5129_/X _5696_/A vssd1 vssd1 vccd1 vccd1 _5198_/C sky130_fd_sc_hd__a2bb2o_2
XFILLER_55_111 vssd1 vssd1 vccd1 vccd1 sky130_fd_sc_hd__fill_1
X_4148_ _8434_/Q input7/X _4160_/B vssd1 vssd1 vccd1 vccd1 _4148_/X sky130_fd_sc_hd__mux2_4
XTAP_TAPCELL_ROW_79_990 vssd1 vccd1 sky130_fd_sc_hd__tapvpwrvgnd_1
XANTENNA_fanout266_X _6517_/B vssd1 vssd1 vccd1 vccd1 sky130_fd_sc_hd__diode_2
XFILLER_55_166 vssd1 vssd1 vccd1 vccd1 sky130_fd_sc_hd__fill_2
XTAP_TAPCELL_ROW_87_1067 vssd1 vccd1 sky130_fd_sc_hd__tapvpwrvgnd_1
XANTENNA__8191__B _8191_/B vssd1 vssd1 vccd1 vccd1 sky130_fd_sc_hd__diode_2
X_7907_ _7988_/A _7907_/B vssd1 vssd1 vccd1 vccd1 _7909_/C sky130_fd_sc_hd__nor2_2
X_7838_ _7839_/A _7839_/B vssd1 vssd1 vccd1 vccd1 _7977_/A sky130_fd_sc_hd__or2_2
XANTENNA__5925__A1 _5747_/A vssd1 vssd1 vccd1 vccd1 sky130_fd_sc_hd__diode_2
XFILLER_11_225 vssd1 vssd1 vccd1 vccd1 sky130_fd_sc_hd__fill_4
X_7769_ _7917_/B _7769_/B vssd1 vssd1 vccd1 vccd1 _7771_/B sky130_fd_sc_hd__nand2_2
Xwire105 wire105/A vssd1 vssd1 vccd1 vccd1 _4496_/D sky130_fd_sc_hd__buf_4
Xclkload1 clkload1/A vssd1 vssd1 vccd1 vccd1 clkload1/X sky130_fd_sc_hd__clkbuf_4
XFILLER_1_3 vssd1 vssd1 vccd1 vccd1 sky130_fd_sc_hd__fill_1
XANTENNA__4894__B wire92/X vssd1 vssd1 vccd1 vccd1 sky130_fd_sc_hd__diode_2
XANTENNA_fanout81_X _6712_/B vssd1 vssd1 vccd1 vccd1 sky130_fd_sc_hd__diode_2
XFILLER_78_258 vssd1 vssd1 vccd1 vccd1 sky130_fd_sc_hd__fill_2
XTAP_TAPCELL_ROW_6_262 vssd1 vccd1 sky130_fd_sc_hd__tapvpwrvgnd_1
Xfanout260 _6830_/A vssd1 vssd1 vccd1 vccd1 _7889_/A sky130_fd_sc_hd__clkdlybuf4s25_1
Xfanout271 _6832_/A vssd1 vssd1 vccd1 vccd1 _6433_/A sky130_fd_sc_hd__clkdlybuf4s25_1
Xfanout282 _8356_/Q vssd1 vssd1 vccd1 vccd1 _7897_/B sky130_fd_sc_hd__clkdlybuf4s25_1
Xfanout293 _8263_/A vssd1 vssd1 vccd1 vccd1 _7875_/C sky130_fd_sc_hd__clkdlybuf4s25_1
XFILLER_75_75 vssd1 vssd1 vccd1 vccd1 sky130_fd_sc_hd__fill_1
XFILLER_61_103 vssd1 vssd1 vccd1 vccd1 sky130_fd_sc_hd__fill_1
XFILLER_27_391 vssd1 vssd1 vccd1 vccd1 sky130_fd_sc_hd__fill_1
XTAP_TAPCELL_ROW_60_805 vssd1 vccd1 sky130_fd_sc_hd__tapvpwrvgnd_1
XTAP_TAPCELL_ROW_32_518 vssd1 vccd1 sky130_fd_sc_hd__tapvpwrvgnd_1
XFILLER_91_63 vssd1 vssd1 vccd1 vccd1 sky130_fd_sc_hd__fill_1
XFILLER_30_556 vssd1 vssd1 vccd1 vccd1 sky130_fd_sc_hd__fill_1
XANTENNA__6630__A _7603_/A vssd1 vssd1 vccd1 vccd1 sky130_fd_sc_hd__diode_2
XANTENNA__7669__A1 _6631_/A vssd1 vssd1 vccd1 vccd1 sky130_fd_sc_hd__diode_2
XANTENNA__7461__A _7889_/A vssd1 vssd1 vccd1 vccd1 sky130_fd_sc_hd__diode_2
XFILLER_34_3 vssd1 vccd1 vssd1 vccd1 sky130_ef_sc_hd__decap_40_12
XFILLER_69_225 vssd1 vssd1 vccd1 vccd1 sky130_fd_sc_hd__fill_1
X_5120_ _8409_/D wire66/X vssd1 vssd1 vccd1 vccd1 _5121_/B sky130_fd_sc_hd__nand2_2
X_5051_ _5051_/A _5051_/B vssd1 vssd1 vccd1 vccd1 _5072_/A sky130_fd_sc_hd__xor2_2
XANTENNA__4655__A1 _4709_/A vssd1 vssd1 vccd1 vccd1 sky130_fd_sc_hd__diode_2
XANTENNA__4655__B2 _4709_/B vssd1 vssd1 vccd1 vccd1 sky130_fd_sc_hd__diode_2
XFILLER_37_111 vssd1 vssd1 vccd1 vccd1 sky130_fd_sc_hd__fill_1
XFILLER_65_464 vssd1 vssd1 vccd1 vccd1 sky130_fd_sc_hd__fill_4
XFILLER_65_475 vssd1 vccd1 vssd1 vccd1 sky130_ef_sc_hd__decap_40_12
XTAP_TAPCELL_ROW_76_960 vssd1 vccd1 sky130_fd_sc_hd__tapvpwrvgnd_1
XTAP_TAPCELL_ROW_48_684 vssd1 vccd1 sky130_fd_sc_hd__tapvpwrvgnd_1
XANTENNA__6524__B _7723_/D vssd1 vssd1 vccd1 vccd1 sky130_fd_sc_hd__diode_2
XFILLER_80_445 vssd1 vssd1 vccd1 vccd1 sky130_fd_sc_hd__fill_1
X_5953_ _6588_/A _5953_/B vssd1 vssd1 vccd1 vccd1 _5955_/A sky130_fd_sc_hd__nand2_2
XANTENNA_clkbuf_4_5_0_clk_A clkbuf_0_clk/X vssd1 vssd1 vccd1 vccd1 sky130_fd_sc_hd__diode_2
X_5884_ _5884_/A _5884_/B vssd1 vssd1 vccd1 vccd1 _5884_/X sky130_fd_sc_hd__xor2_2
X_4904_ _4904_/A _4904_/B _4904_/C vssd1 vssd1 vccd1 vccd1 _4970_/A sky130_fd_sc_hd__nand3_2
X_7623_ _7623_/A _7623_/B vssd1 vssd1 vccd1 vccd1 _7624_/B sky130_fd_sc_hd__xnor2_2
X_4835_ _4835_/A _4835_/B vssd1 vssd1 vccd1 vccd1 _4836_/B sky130_fd_sc_hd__xor2_2
X_7554_ _8103_/A _7754_/B _7875_/D _7877_/B vssd1 vssd1 vccd1 vccd1 _7556_/A sky130_fd_sc_hd__and4_2
X_4766_ _4767_/A _4767_/B vssd1 vssd1 vccd1 vccd1 _4766_/X sky130_fd_sc_hd__and2b_2
XANTENNA_fanout226_A _5386_/C vssd1 vssd1 vccd1 vccd1 sky130_fd_sc_hd__diode_2
X_6505_ _7233_/A _6903_/C vssd1 vssd1 vccd1 vccd1 _6506_/B sky130_fd_sc_hd__nand2_2
X_7485_ _7485_/A _7485_/B _7485_/C vssd1 vssd1 vccd1 vccd1 _7586_/A sky130_fd_sc_hd__or3_2
X_4697_ _4697_/A _4697_/B vssd1 vssd1 vccd1 vccd1 _4699_/A sky130_fd_sc_hd__xnor2_4
X_6436_ _6435_/A _6903_/C _7140_/C _8103_/B vssd1 vssd1 vccd1 vccd1 _6437_/B sky130_fd_sc_hd__a22oi_2
X_6367_ _6367_/A _6367_/B _6367_/C vssd1 vssd1 vccd1 vccd1 _6368_/B sky130_fd_sc_hd__and3_2
XFILLER_0_416 vssd1 vssd1 vccd1 vccd1 sky130_fd_sc_hd__fill_4
X_8106_ _8106_/A _8106_/B vssd1 vssd1 vccd1 vccd1 _8114_/A sky130_fd_sc_hd__xnor2_2
X_5318_ _5319_/B _5319_/A vssd1 vssd1 vccd1 vccd1 _5450_/A sky130_fd_sc_hd__and2b_2
XFILLER_0_449 vssd1 vssd1 vccd1 vccd1 sky130_fd_sc_hd__fill_4
XFILLER_88_545 vssd1 vssd1 vccd1 vccd1 sky130_fd_sc_hd__fill_1
X_6298_ _6298_/A _6298_/B vssd1 vssd1 vccd1 vccd1 _6324_/A sky130_fd_sc_hd__xnor2_2
XANTENNA__5843__B1 _6238_/B vssd1 vssd1 vccd1 vccd1 sky130_fd_sc_hd__diode_2
XANTENNA_fanout383_X fanout383/X vssd1 vssd1 vccd1 vccd1 sky130_fd_sc_hd__diode_2
XFILLER_29_46 vssd1 vssd1 vccd1 vccd1 sky130_fd_sc_hd__fill_1
XFILLER_29_57 vssd1 vssd1 vccd1 vccd1 sky130_fd_sc_hd__fill_2
X_8037_ _8037_/A _8037_/B vssd1 vssd1 vccd1 vccd1 _8038_/B sky130_fd_sc_hd__nor2_2
X_5249_ _5249_/A _5249_/B vssd1 vssd1 vccd1 vccd1 _5250_/C sky130_fd_sc_hd__or2_2
XFILLER_68_291 vssd1 vssd1 vccd1 vccd1 sky130_fd_sc_hd__fill_2
XTAP_TAPCELL_ROW_3_232 vssd1 vccd1 sky130_fd_sc_hd__tapvpwrvgnd_1
XFILLER_28_155 vssd1 vssd1 vccd1 vccd1 sky130_fd_sc_hd__fill_4
XFILLER_16_328 vssd1 vssd1 vccd1 vccd1 sky130_fd_sc_hd__fill_1
XFILLER_28_177 vssd1 vssd1 vccd1 vccd1 sky130_fd_sc_hd__fill_2
XFILLER_56_497 vssd1 vssd1 vccd1 vccd1 sky130_fd_sc_hd__fill_2
XANTENNA_fanout41_A _7296_/B vssd1 vssd1 vccd1 vccd1 sky130_fd_sc_hd__diode_2
XFILLER_71_445 vssd1 vssd1 vccd1 vccd1 sky130_fd_sc_hd__fill_2
XFILLER_43_169 vssd1 vssd1 vccd1 vccd1 sky130_fd_sc_hd__fill_1
XANTENNA__6571__A1 _6572_/A vssd1 vssd1 vccd1 vccd1 sky130_fd_sc_hd__diode_2
XFILLER_10_70 vssd1 vssd1 vccd1 vccd1 sky130_fd_sc_hd__fill_1
XFILLER_86_52 vssd1 vssd1 vccd1 vccd1 sky130_fd_sc_hd__fill_4
XFILLER_86_85 vssd1 vssd1 vccd1 vccd1 sky130_fd_sc_hd__fill_4
XANTENNA__8316__S _8397_/D vssd1 vssd1 vccd1 vccd1 sky130_fd_sc_hd__diode_2
XANTENNA_clkload4_A clkload4/A vssd1 vssd1 vccd1 vccd1 sky130_fd_sc_hd__diode_2
XFILLER_47_497 vssd1 vssd1 vccd1 vccd1 sky130_fd_sc_hd__fill_2
XFILLER_62_423 vssd1 vssd1 vccd1 vccd1 sky130_fd_sc_hd__fill_1
XTAP_TAPCELL_ROW_73_930 vssd1 vccd1 sky130_fd_sc_hd__tapvpwrvgnd_1
XTAP_TAPCELL_ROW_45_654 vssd1 vccd1 sky130_fd_sc_hd__tapvpwrvgnd_1
XANTENNA__7159__C _7725_/B vssd1 vssd1 vccd1 vccd1 sky130_fd_sc_hd__diode_2
XFILLER_34_169 vssd1 vssd1 vccd1 vccd1 sky130_fd_sc_hd__fill_1
XTAP_TAPCELL_ROW_17_367 vssd1 vccd1 sky130_fd_sc_hd__tapvpwrvgnd_1
XFILLER_30_342 vssd1 vssd1 vccd1 vccd1 sky130_fd_sc_hd__fill_1
X_4620_ _5054_/B vssd1 vssd1 vccd1 vccd1 _4727_/B sky130_fd_sc_hd__inv_2
X_4551_ _4551_/A _4551_/B vssd1 vssd1 vccd1 vccd1 _4588_/A sky130_fd_sc_hd__xor2_2
Xhold527 _8382_/Q vssd1 vssd1 vccd1 vccd1 _8441_/D sky130_fd_sc_hd__dlygate4sd3_1
Xhold516 _8381_/Q vssd1 vssd1 vccd1 vccd1 _8440_/D sky130_fd_sc_hd__dlygate4sd3_1
X_7270_ _7269_/A _7269_/B _7269_/C vssd1 vssd1 vccd1 vccd1 _7277_/B sky130_fd_sc_hd__o21ai_2
X_4482_ _5710_/A _4931_/C vssd1 vssd1 vccd1 vccd1 _4782_/A sky130_fd_sc_hd__nand2_4
XANTENNA__8419__RESET_B wire364/X vssd1 vssd1 vccd1 vccd1 sky130_fd_sc_hd__diode_2
Xhold549 _8331_/Q vssd1 vssd1 vccd1 vccd1 hold549/X sky130_fd_sc_hd__dlygate4sd3_1
Xhold538 _8421_/Q vssd1 vssd1 vccd1 vccd1 hold538/X sky130_fd_sc_hd__dlygate4sd3_1
X_6221_ _6221_/A _6221_/B vssd1 vssd1 vccd1 vccd1 _6223_/C sky130_fd_sc_hd__xnor2_2
X_6152_ _6153_/B _6153_/A vssd1 vssd1 vccd1 vccd1 _6152_/X sky130_fd_sc_hd__and2b_2
XANTENNA__6519__B _8263_/A vssd1 vssd1 vccd1 vccd1 sky130_fd_sc_hd__diode_2
X_5103_ _5103_/A _5103_/B vssd1 vssd1 vccd1 vccd1 _5207_/A sky130_fd_sc_hd__nand2_2
XANTENNA__7814__A1 _7958_/A vssd1 vssd1 vccd1 vccd1 sky130_fd_sc_hd__diode_2
X_6083_ _5998_/X _5999_/A _5996_/Y vssd1 vssd1 vccd1 vccd1 _6197_/A sky130_fd_sc_hd__a21bo_4
XANTENNA__6238__C _7714_/A vssd1 vssd1 vccd1 vccd1 sky130_fd_sc_hd__diode_2
X_5034_ _5035_/B _5035_/A vssd1 vssd1 vccd1 vccd1 _5192_/A sky130_fd_sc_hd__and2b_2
XFILLER_38_453 vssd1 vssd1 vccd1 vccd1 sky130_fd_sc_hd__fill_1
XTAP_TAPCELL_ROW_0_202 vssd1 vccd1 sky130_fd_sc_hd__tapvpwrvgnd_1
X_6985_ _6763_/A _6763_/B _6760_/Y vssd1 vssd1 vccd1 vccd1 _6993_/A sky130_fd_sc_hd__o21ai_2
XTAP_TAPCELL_ROW_84_1037 vssd1 vccd1 sky130_fd_sc_hd__tapvpwrvgnd_1
XANTENNA_fanout343_A _6795_/A vssd1 vssd1 vccd1 vccd1 sky130_fd_sc_hd__diode_2
XFILLER_53_478 vssd1 vssd1 vccd1 vccd1 sky130_fd_sc_hd__fill_1
X_5936_ _5728_/A _5728_/B _5726_/A vssd1 vssd1 vccd1 vccd1 _5947_/A sky130_fd_sc_hd__o21ai_2
XANTENNA_fanout131_X _4709_/B vssd1 vssd1 vccd1 vccd1 sky130_fd_sc_hd__diode_2
X_7606_ _7606_/A _7606_/B vssd1 vssd1 vccd1 vccd1 _7608_/B sky130_fd_sc_hd__xnor2_2
X_5867_ _5867_/A _5867_/B vssd1 vssd1 vccd1 vccd1 _5868_/C sky130_fd_sc_hd__xor2_2
XANTENNA_fanout229_X _7875_/A vssd1 vssd1 vccd1 vccd1 sky130_fd_sc_hd__diode_2
X_5798_ _5798_/A _5798_/B vssd1 vssd1 vccd1 vccd1 _5800_/B sky130_fd_sc_hd__xor2_2
X_4818_ _4902_/A _4895_/B _4750_/B _4748_/Y vssd1 vssd1 vccd1 vccd1 _4819_/C sky130_fd_sc_hd__a31o_2
XFILLER_31_47 vssd1 vssd1 vccd1 vccd1 sky130_fd_sc_hd__fill_1
X_7537_ _7537_/A _7537_/B vssd1 vssd1 vccd1 vccd1 _7539_/A sky130_fd_sc_hd__nor2_2
X_4749_ _4749_/A _4749_/B vssd1 vssd1 vccd1 vccd1 _4750_/B sky130_fd_sc_hd__xor2_2
X_7468_ _8001_/A _7877_/B vssd1 vssd1 vccd1 vccd1 _7469_/B sky130_fd_sc_hd__nand2_2
Xoutput25 _8324_/Q vssd1 vssd1 vccd1 vccd1 gpio_out[22] sky130_fd_sc_hd__clkdlybuf4s25_1
X_6419_ _6420_/A _6420_/B _6420_/C vssd1 vssd1 vccd1 vccd1 _6533_/A sky130_fd_sc_hd__o21ai_2
Xoutput36 _8506_/X vssd1 vssd1 vccd1 vccd1 gpio_out[33] sky130_fd_sc_hd__clkdlybuf4s25_1
X_7399_ _7317_/A _7317_/B _7315_/X vssd1 vssd1 vccd1 vccd1 _7412_/A sky130_fd_sc_hd__a21o_2
XANTENNA_fanout89_A wire92/X vssd1 vssd1 vccd1 vccd1 sky130_fd_sc_hd__diode_2
XFILLER_56_55 vssd1 vssd1 vccd1 vccd1 sky130_fd_sc_hd__fill_1
XFILLER_56_272 vssd1 vssd1 vccd1 vccd1 sky130_fd_sc_hd__fill_4
XFILLER_56_283 vssd1 vssd1 vccd1 vccd1 sky130_fd_sc_hd__fill_4
XANTENNA_fanout44_X _7080_/B vssd1 vssd1 vccd1 vccd1 sky130_fd_sc_hd__diode_2
XFILLER_44_445 vssd1 vssd1 vccd1 vccd1 sky130_fd_sc_hd__fill_1
XANTENNA__5595__A2 _6433_/A vssd1 vssd1 vccd1 vccd1 sky130_fd_sc_hd__diode_2
XANTENNA__8082__D _8082_/D vssd1 vssd1 vccd1 vccd1 sky130_fd_sc_hd__diode_2
XFILLER_44_467 vssd1 vssd1 vccd1 vccd1 sky130_fd_sc_hd__fill_1
XFILLER_71_264 vssd1 vccd1 vssd1 vccd1 sky130_ef_sc_hd__decap_40_12
XTAP_TAPCELL_ROW_70_900 vssd1 vccd1 sky130_fd_sc_hd__tapvpwrvgnd_1
XTAP_TAPCELL_ROW_42_624 vssd1 vccd1 sky130_fd_sc_hd__tapvpwrvgnd_1
XTAP_TAPCELL_ROW_14_337 vssd1 vccd1 sky130_fd_sc_hd__tapvpwrvgnd_1
XFILLER_72_87 vssd1 vssd1 vccd1 vccd1 sky130_fd_sc_hd__fill_1
XANTENNA__8297__A1 input4/X vssd1 vssd1 vccd1 vccd1 sky130_fd_sc_hd__diode_2
XANTENNA__7723__B _7862_/B vssd1 vssd1 vccd1 vccd1 sky130_fd_sc_hd__diode_2
XANTENNA__5243__B _5899_/B vssd1 vssd1 vccd1 vccd1 sky130_fd_sc_hd__diode_2
XFILLER_67_526 vssd1 vssd1 vccd1 vccd1 sky130_fd_sc_hd__fill_2
XANTENNA__8343__Q _8343_/Q vssd1 vssd1 vccd1 vccd1 sky130_fd_sc_hd__diode_2
XFILLER_35_467 vssd1 vssd1 vccd1 vccd1 sky130_fd_sc_hd__fill_2
XFILLER_62_253 vssd1 vssd1 vccd1 vccd1 sky130_fd_sc_hd__fill_8
X_6770_ _7668_/A _6986_/B vssd1 vssd1 vccd1 vccd1 _6770_/Y sky130_fd_sc_hd__nor2_2
XFILLER_22_128 vssd1 vssd1 vccd1 vccd1 sky130_fd_sc_hd__fill_1
X_5721_ _6091_/A _6703_/B _5148_/B _5151_/A vssd1 vssd1 vccd1 vccd1 _5732_/A sky130_fd_sc_hd__a31o_2
XANTENNA__7186__A _7990_/A vssd1 vssd1 vccd1 vccd1 sky130_fd_sc_hd__diode_2
XANTENNA__6521__C _7140_/C vssd1 vssd1 vccd1 vccd1 sky130_fd_sc_hd__diode_2
X_8440_ clkload2/A _8440_/D wire368/X vssd1 vssd1 vccd1 vccd1 _8440_/Q sky130_fd_sc_hd__dfrtp_2
X_5652_ _5652_/A _5652_/B _5652_/C vssd1 vssd1 vccd1 vccd1 _5664_/A sky130_fd_sc_hd__and3_2
X_8371_ clkload8/A _8371_/D wire377/X vssd1 vssd1 vccd1 vccd1 _8371_/Q sky130_fd_sc_hd__dfrtp_2
X_5583_ _5583_/A _5826_/A vssd1 vssd1 vccd1 vccd1 _5590_/A sky130_fd_sc_hd__nand2_2
X_4603_ _4622_/A _4622_/B vssd1 vssd1 vccd1 vccd1 _4603_/X sky130_fd_sc_hd__and2b_2
XANTENNA__8288__A1 _8164_/B vssd1 vssd1 vccd1 vccd1 sky130_fd_sc_hd__diode_2
X_7322_ _7322_/A _7322_/B vssd1 vssd1 vccd1 vccd1 _7336_/A sky130_fd_sc_hd__xor2_2
X_4534_ _4534_/A _4580_/A vssd1 vssd1 vccd1 vccd1 _4576_/B sky130_fd_sc_hd__xor2_2
XFILLER_89_117 vssd1 vssd1 vccd1 vccd1 sky130_fd_sc_hd__fill_1
X_7253_ _7253_/A _7253_/B vssd1 vssd1 vccd1 vccd1 _7256_/A sky130_fd_sc_hd__xnor2_2
X_4465_ _4465_/A _4465_/B vssd1 vssd1 vccd1 vccd1 _4467_/B sky130_fd_sc_hd__xor2_2
X_7184_ _7284_/A _7184_/B vssd1 vssd1 vccd1 vccd1 _7186_/C sky130_fd_sc_hd__nor2_2
X_6204_ _6204_/A _6204_/B vssd1 vssd1 vccd1 vccd1 _6205_/B sky130_fd_sc_hd__or2_2
X_4396_ _4396_/A _4396_/B vssd1 vssd1 vccd1 vccd1 _4411_/A sky130_fd_sc_hd__xnor2_4
XANTENNA_fanout293_A _8263_/A vssd1 vssd1 vccd1 vccd1 sky130_fd_sc_hd__diode_2
X_6135_ _6136_/B _6136_/A vssd1 vssd1 vccd1 vccd1 _6135_/Y sky130_fd_sc_hd__nand2b_2
XFILLER_58_537 vssd1 vssd1 vccd1 vccd1 sky130_fd_sc_hd__fill_1
X_6066_ _6274_/A _6066_/B vssd1 vssd1 vccd1 vccd1 _6069_/A sky130_fd_sc_hd__and2b_2
XTAP_TAPCELL_ROW_90_1096 vssd1 vccd1 sky130_fd_sc_hd__tapvpwrvgnd_1
X_5017_ _5017_/A _5017_/B vssd1 vssd1 vccd1 vccd1 _5019_/B sky130_fd_sc_hd__nand2_2
XANTENNA_fanout179_X _4762_/A vssd1 vssd1 vccd1 vccd1 sky130_fd_sc_hd__diode_2
XFILLER_26_25 vssd1 vssd1 vccd1 vccd1 sky130_fd_sc_hd__fill_2
XFILLER_26_36 vssd1 vssd1 vccd1 vccd1 sky130_fd_sc_hd__fill_1
XFILLER_26_47 vssd1 vssd1 vccd1 vccd1 sky130_fd_sc_hd__fill_2
XANTENNA__7808__B _8077_/B vssd1 vssd1 vccd1 vccd1 sky130_fd_sc_hd__diode_2
X_6968_ _6776_/A _6776_/B _6777_/Y vssd1 vssd1 vccd1 vccd1 _6981_/A sky130_fd_sc_hd__a21bo_2
XANTENNA__6712__B _6712_/B vssd1 vssd1 vccd1 vccd1 sky130_fd_sc_hd__diode_2
XANTENNA__7096__A _7603_/A vssd1 vssd1 vccd1 vccd1 sky130_fd_sc_hd__diode_2
X_6899_ _6900_/A _6900_/B _6900_/C vssd1 vssd1 vccd1 vccd1 _7152_/A sky130_fd_sc_hd__a21o_2
X_5919_ _5920_/A _5920_/B vssd1 vssd1 vccd1 vccd1 _5919_/X sky130_fd_sc_hd__and2b_2
XANTENNA__6431__C _8241_/A vssd1 vssd1 vccd1 vccd1 sky130_fd_sc_hd__diode_2
XTAP_TAPCELL_ROW_11_307 vssd1 vccd1 sky130_fd_sc_hd__tapvpwrvgnd_1
Xrebuffer465 _4515_/B vssd1 vssd1 vccd1 vccd1 _4425_/B sky130_fd_sc_hd__buf_2
Xrebuffer454 _4169_/Y vssd1 vssd1 vccd1 vccd1 _8424_/D sky130_fd_sc_hd__buf_2
Xrebuffer443 _4179_/X vssd1 vssd1 vccd1 vccd1 _8435_/D sky130_fd_sc_hd__buf_2
Xrebuffer487 _4730_/X vssd1 vssd1 vccd1 vccd1 _4731_/B sky130_fd_sc_hd__buf_4
Xrebuffer498 _4646_/A vssd1 vssd1 vccd1 vccd1 _4625_/A sky130_fd_sc_hd__buf_2
Xrebuffer476 _5192_/C vssd1 vssd1 vccd1 vccd1 _5762_/A2 sky130_fd_sc_hd__buf_2
XANTENNA__6829__A2 _7864_/B vssd1 vssd1 vccd1 vccd1 sky130_fd_sc_hd__diode_2
XANTENNA__5063__B _5267_/B vssd1 vssd1 vccd1 vccd1 sky130_fd_sc_hd__diode_2
XFILLER_67_32 vssd1 vccd1 vssd1 vccd1 sky130_ef_sc_hd__decap_40_12
XFILLER_67_87 vssd1 vssd1 vccd1 vccd1 sky130_fd_sc_hd__fill_2
XFILLER_76_356 vssd1 vssd1 vccd1 vccd1 sky130_fd_sc_hd__fill_1
XANTENNA_clkbuf_4_13_0_clk_A clkbuf_0_clk/X vssd1 vssd1 vccd1 vccd1 sky130_fd_sc_hd__diode_2
XFILLER_64_529 vssd1 vssd1 vccd1 vccd1 sky130_fd_sc_hd__fill_2
XANTENNA__6903__A _7140_/A vssd1 vssd1 vccd1 vccd1 sky130_fd_sc_hd__diode_2
XTAP_TAPCELL_ROW_27_473 vssd1 vccd1 sky130_fd_sc_hd__tapvpwrvgnd_1
XFILLER_16_91 vssd1 vssd1 vccd1 vccd1 sky130_fd_sc_hd__fill_1
XFILLER_8_121 vssd1 vssd1 vccd1 vccd1 sky130_fd_sc_hd__fill_1
XFILLER_73_7 vssd1 vssd1 vccd1 vccd1 sky130_fd_sc_hd__fill_1
XFILLER_8_143 vssd1 vssd1 vccd1 vccd1 sky130_fd_sc_hd__fill_1
XANTENNA__7734__A _8016_/A vssd1 vssd1 vccd1 vccd1 sky130_fd_sc_hd__diode_2
X_4250_ _4342_/A _4342_/B vssd1 vssd1 vccd1 vccd1 _4250_/X sky130_fd_sc_hd__and2_2
XFILLER_86_109 vssd1 vssd1 vccd1 vccd1 sky130_fd_sc_hd__fill_4
X_4181_ _4207_/B _8411_/Q _4180_/Y vssd1 vssd1 vccd1 vccd1 _4182_/A sky130_fd_sc_hd__o21ai_4
X_7940_ _7940_/A1 _7799_/B _7940_/B1 vssd1 vssd1 vccd1 vccd1 _7941_/B sky130_fd_sc_hd__a21oi_2
XFILLER_63_540 vssd1 vssd1 vccd1 vccd1 sky130_fd_sc_hd__fill_1
X_7871_ _7736_/B _7738_/B _7736_/A vssd1 vssd1 vccd1 vccd1 _7882_/A sky130_fd_sc_hd__o21ba_2
X_6822_ _6823_/A _6823_/B vssd1 vssd1 vccd1 vccd1 _6934_/B sky130_fd_sc_hd__nand2b_2
XFILLER_90_392 vssd1 vssd1 vccd1 vccd1 sky130_fd_sc_hd__fill_1
XTAP_TAPCELL_ROW_81_1007 vssd1 vccd1 sky130_fd_sc_hd__tapvpwrvgnd_1
XFILLER_50_245 vssd1 vssd1 vccd1 vccd1 sky130_fd_sc_hd__fill_2
X_6753_ _7019_/B _6753_/B vssd1 vssd1 vccd1 vccd1 _6755_/C sky130_fd_sc_hd__or2_2
X_6684_ _6685_/A _6685_/B vssd1 vssd1 vccd1 vccd1 _6684_/X sky130_fd_sc_hd__and2_2
X_5704_ _5704_/A _5704_/B vssd1 vssd1 vccd1 vccd1 _5706_/A sky130_fd_sc_hd__nand2_2
XANTENNA__8434__RESET_B wire362/X vssd1 vssd1 vccd1 vccd1 sky130_fd_sc_hd__diode_2
X_8423_ clkload1/A _8423_/D load_slew360/X vssd1 vssd1 vccd1 vccd1 _8423_/Q sky130_fd_sc_hd__dfrtp_2
X_5635_ _5635_/A _5635_/B vssd1 vssd1 vccd1 vccd1 _5641_/B sky130_fd_sc_hd__nor2_2
XFILLER_12_49 vssd1 vssd1 vccd1 vccd1 sky130_fd_sc_hd__fill_1
XANTENNA_fanout306_A _7723_/C vssd1 vssd1 vccd1 vccd1 sky130_fd_sc_hd__diode_2
X_8354_ _8361_/CLK _8354_/D load_slew384/X vssd1 vssd1 vccd1 vccd1 _8354_/Q sky130_fd_sc_hd__dfrtp_2
X_5566_ _5566_/A _5566_/B vssd1 vssd1 vccd1 vccd1 _5567_/B sky130_fd_sc_hd__or2_2
XANTENNA__8130__B1 _8263_/A vssd1 vssd1 vccd1 vccd1 sky130_fd_sc_hd__diode_2
X_8285_ _8361_/Q _8285_/B vssd1 vssd1 vccd1 vccd1 _8286_/B sky130_fd_sc_hd__or2_2
X_7305_ _7305_/A _7305_/B vssd1 vssd1 vccd1 vccd1 _7307_/B sky130_fd_sc_hd__xnor2_2
X_5497_ _5498_/B _5498_/A vssd1 vssd1 vccd1 vccd1 _5513_/A sky130_fd_sc_hd__and2b_2
X_4517_ _8429_/D _4931_/C vssd1 vssd1 vccd1 vccd1 _4558_/B sky130_fd_sc_hd__nand2_4
XTAP_TAPCELL_ROW_92_1125 vssd1 vccd1 sky130_fd_sc_hd__tapvpwrvgnd_1
X_7236_ _7236_/A _7236_/B vssd1 vssd1 vccd1 vccd1 _7238_/B sky130_fd_sc_hd__xnor2_2
X_4448_ _4337_/A _4337_/B _4335_/Y vssd1 vssd1 vccd1 vccd1 _4512_/A sky130_fd_sc_hd__a21bo_2
XANTENNA_fanout296_X _7864_/B vssd1 vssd1 vccd1 vccd1 sky130_fd_sc_hd__diode_2
X_7167_ _7168_/A _7168_/B vssd1 vssd1 vccd1 vccd1 _7264_/B sky130_fd_sc_hd__and2_2
X_4379_ _4379_/A _4379_/B vssd1 vssd1 vccd1 vccd1 _4393_/A sky130_fd_sc_hd__xnor2_2
XFILLER_46_507 vssd1 vccd1 vssd1 vccd1 sky130_ef_sc_hd__decap_40_12
XFILLER_58_334 vssd1 vssd1 vccd1 vccd1 sky130_fd_sc_hd__fill_2
X_7098_ _7098_/A _7299_/B _7299_/C vssd1 vssd1 vccd1 vccd1 _7099_/B sky130_fd_sc_hd__and3_2
X_6118_ _8435_/D wire99/X vssd1 vssd1 vccd1 vccd1 _6119_/B sky130_fd_sc_hd__nand2_2
X_6049_ _6259_/A _6047_/Y _5848_/X _5852_/A vssd1 vssd1 vccd1 vccd1 _6050_/C sky130_fd_sc_hd__a211o_2
XFILLER_26_264 vssd1 vssd1 vccd1 vccd1 sky130_fd_sc_hd__fill_1
XANTENNA__6723__A _6723_/A vssd1 vssd1 vccd1 vccd1 sky130_fd_sc_hd__diode_2
XFILLER_53_23 vssd1 vssd1 vccd1 vccd1 sky130_fd_sc_hd__fill_1
XFILLER_81_370 vssd1 vssd1 vccd1 vccd1 sky130_fd_sc_hd__fill_1
XANTENNA__7538__B _7875_/C vssd1 vssd1 vccd1 vccd1 sky130_fd_sc_hd__diode_2
XFILLER_53_67 vssd1 vssd1 vccd1 vccd1 sky130_fd_sc_hd__fill_1
XTAP_TAPCELL_ROW_24_443 vssd1 vccd1 sky130_fd_sc_hd__tapvpwrvgnd_1
XANTENNA__7554__A _8103_/A vssd1 vssd1 vccd1 vccd1 sky130_fd_sc_hd__diode_2
XFILLER_5_102 vssd1 vssd1 vccd1 vccd1 sky130_fd_sc_hd__fill_1
XFILLER_5_113 vssd1 vssd1 vccd1 vccd1 sky130_fd_sc_hd__fill_8
XFILLER_78_53 vssd1 vssd1 vccd1 vccd1 sky130_fd_sc_hd__fill_2
XFILLER_49_301 vssd1 vssd1 vccd1 vccd1 sky130_fd_sc_hd__fill_1
XFILLER_37_507 vssd1 vssd1 vccd1 vccd1 sky130_fd_sc_hd__fill_1
XFILLER_76_120 vssd1 vssd1 vccd1 vccd1 sky130_fd_sc_hd__fill_2
XFILLER_76_197 vssd1 vssd1 vccd1 vccd1 sky130_fd_sc_hd__fill_1
XANTENNA__6352__B wire72/X vssd1 vssd1 vccd1 vccd1 sky130_fd_sc_hd__diode_2
XFILLER_60_554 vssd1 vssd1 vccd1 vccd1 sky130_fd_sc_hd__fill_2
X_5420_ _5420_/A _5420_/B vssd1 vssd1 vccd1 vccd1 _5422_/B sky130_fd_sc_hd__xnor2_2
X_5351_ _5386_/B _5826_/A vssd1 vssd1 vccd1 vccd1 _5355_/A sky130_fd_sc_hd__nand2_2
XANTENNA__5415__C _6005_/B vssd1 vssd1 vccd1 vccd1 sky130_fd_sc_hd__diode_2
XANTENNA__7466__A2 _7875_/C vssd1 vssd1 vccd1 vccd1 sky130_fd_sc_hd__diode_2
X_8070_ _8070_/A _8070_/B vssd1 vssd1 vccd1 vccd1 _8070_/Y sky130_fd_sc_hd__xnor2_2
X_5282_ _5281_/A _5281_/B _5280_/X _5264_/B vssd1 vssd1 vccd1 vccd1 _5283_/C sky130_fd_sc_hd__a22o_2
X_4302_ _4303_/A _4303_/B _4979_/B vssd1 vssd1 vccd1 vccd1 _4531_/B sky130_fd_sc_hd__and3_2
X_7021_ _7021_/A _7076_/A _7021_/C vssd1 vssd1 vccd1 vccd1 _7021_/X sky130_fd_sc_hd__or3_2
X_4233_ _8381_/Q _8440_/Q vssd1 vssd1 vccd1 vccd1 _4233_/X sky130_fd_sc_hd__and2_2
XANTENNA__7218__A2 _7714_/A vssd1 vssd1 vccd1 vccd1 sky130_fd_sc_hd__diode_2
X_4164_ wire387/X _4227_/S vssd1 vssd1 vccd1 vccd1 _4164_/Y sky130_fd_sc_hd__nand2b_4
XFILLER_55_326 vssd1 vssd1 vccd1 vccd1 sky130_fd_sc_hd__fill_2
X_7923_ _7781_/B _7781_/C _7781_/A vssd1 vssd1 vccd1 vccd1 _7924_/C sky130_fd_sc_hd__a21bo_2
XFILLER_36_551 vssd1 vssd1 vccd1 vccd1 sky130_fd_sc_hd__fill_1
XFILLER_82_145 vssd1 vssd1 vccd1 vccd1 sky130_fd_sc_hd__fill_1
XFILLER_82_167 vssd1 vssd1 vccd1 vccd1 sky130_fd_sc_hd__fill_1
XTAP_TAPCELL_ROW_38_579 vssd1 vccd1 sky130_fd_sc_hd__tapvpwrvgnd_1
XFILLER_23_223 vssd1 vssd1 vccd1 vccd1 sky130_fd_sc_hd__fill_1
X_7854_ _8032_/A _8136_/A _7852_/Y _7853_/X vssd1 vssd1 vccd1 vccd1 _7856_/A sky130_fd_sc_hd__o2bb2a_2
XANTENNA__6262__B _8257_/A vssd1 vssd1 vccd1 vccd1 sky130_fd_sc_hd__diode_2
X_7785_ _7785_/A _7785_/B _7785_/C vssd1 vssd1 vccd1 vccd1 _7786_/B sky130_fd_sc_hd__and3_2
X_6805_ _6805_/A _6805_/B vssd1 vssd1 vccd1 vccd1 _6807_/A sky130_fd_sc_hd__nor2_2
XFILLER_23_37 vssd1 vssd1 vccd1 vccd1 sky130_fd_sc_hd__fill_2
X_6736_ _6736_/A _6736_/B vssd1 vssd1 vccd1 vccd1 _6785_/A sky130_fd_sc_hd__xnor2_2
X_4997_ _6091_/A _6294_/A _6704_/B _6703_/B vssd1 vssd1 vccd1 vccd1 _4997_/X sky130_fd_sc_hd__and4_2
XTAP_TAPCELL_ROW_21_413 vssd1 vccd1 sky130_fd_sc_hd__tapvpwrvgnd_1
XANTENNA__4192__A_N _8174_/B vssd1 vssd1 vccd1 vccd1 sky130_fd_sc_hd__diode_2
X_6667_ _6667_/A _6667_/B vssd1 vssd1 vccd1 vccd1 _6668_/B sky130_fd_sc_hd__nor2_2
XANTENNA_fanout309_X _8228_/A vssd1 vssd1 vccd1 vccd1 sky130_fd_sc_hd__diode_2
X_8406_ clkload6/A _8406_/D load_slew358/X vssd1 vssd1 vccd1 vccd1 _8406_/Q sky130_fd_sc_hd__dfrtp_2
X_6598_ _6599_/A _6599_/B vssd1 vssd1 vccd1 vccd1 _6600_/A sky130_fd_sc_hd__nor2_2
X_5618_ _5618_/A _5669_/B _5618_/C vssd1 vssd1 vccd1 vccd1 _5620_/A sky130_fd_sc_hd__nand3_2
X_8337_ _8382_/CLK _8337_/D load_slew370/X vssd1 vssd1 vccd1 vccd1 _8337_/Q sky130_fd_sc_hd__dfrtp_2
X_5549_ _5548_/A _5680_/A vssd1 vssd1 vccd1 vccd1 _5551_/B sky130_fd_sc_hd__and2b_2
XANTENNA__7524__D _7723_/C vssd1 vssd1 vccd1 vccd1 sky130_fd_sc_hd__diode_2
X_8268_ _8267_/A _8267_/C _8267_/B vssd1 vssd1 vccd1 vccd1 _8269_/B sky130_fd_sc_hd__a21oi_2
X_8199_ _8199_/A _8199_/B vssd1 vssd1 vccd1 vccd1 _8199_/X sky130_fd_sc_hd__xor2_2
X_7219_ _7219_/A _7862_/B _7714_/A _7853_/A vssd1 vssd1 vccd1 vccd1 _7220_/B sky130_fd_sc_hd__and4_2
XFILLER_86_440 vssd1 vssd1 vccd1 vccd1 sky130_fd_sc_hd__fill_1
XFILLER_58_197 vssd1 vssd1 vccd1 vccd1 sky130_fd_sc_hd__fill_2
XFILLER_27_540 vssd1 vssd1 vccd1 vccd1 sky130_fd_sc_hd__fill_8
XFILLER_64_44 vssd1 vssd1 vccd1 vccd1 sky130_fd_sc_hd__fill_1
XFILLER_73_156 vssd1 vssd1 vccd1 vccd1 sky130_fd_sc_hd__fill_4
XANTENNA__6172__B _6738_/B vssd1 vssd1 vccd1 vccd1 sky130_fd_sc_hd__diode_2
XANTENNA__8356__RESET_B load_slew384/X vssd1 vssd1 vccd1 vccd1 sky130_fd_sc_hd__diode_2
XFILLER_14_223 vssd1 vssd1 vccd1 vccd1 sky130_fd_sc_hd__fill_1
Xfanout82 _4812_/Y vssd1 vssd1 vccd1 vccd1 _5138_/B sky130_fd_sc_hd__clkdlybuf4s25_1
Xfanout71 _4733_/X vssd1 vssd1 vccd1 vccd1 wire72/A sky130_fd_sc_hd__clkdlybuf4s25_1
Xfanout60 _6360_/B vssd1 vssd1 vccd1 vccd1 _5289_/B sky130_fd_sc_hd__clkdlybuf4s25_1
XFILLER_80_87 vssd1 vssd1 vccd1 vccd1 sky130_fd_sc_hd__fill_2
Xfanout93 _6300_/B vssd1 vssd1 vccd1 vccd1 _6703_/B sky130_fd_sc_hd__dlymetal6s2s_1
XFILLER_10_495 vssd1 vssd1 vccd1 vccd1 sky130_fd_sc_hd__fill_1
XANTENNA__4420__B _4692_/B vssd1 vssd1 vccd1 vccd1 sky130_fd_sc_hd__diode_2
XFILLER_6_499 vssd1 vssd1 vccd1 vccd1 sky130_fd_sc_hd__fill_2
XFILLER_89_85 vssd1 vssd1 vccd1 vccd1 sky130_fd_sc_hd__fill_1
XANTENNA__8319__S _8397_/D vssd1 vssd1 vccd1 vccd1 sky130_fd_sc_hd__diode_2
XTAP_TAPCELL_ROW_9_293 vssd1 vccd1 sky130_fd_sc_hd__tapvpwrvgnd_1
XANTENNA__6347__B _6738_/B vssd1 vssd1 vccd1 vccd1 sky130_fd_sc_hd__diode_2
XFILLER_64_112 vssd1 vssd1 vccd1 vccd1 sky130_fd_sc_hd__fill_2
X_4920_ _6712_/A _5710_/B _5710_/C _4919_/B _8430_/D vssd1 vssd1 vccd1 vccd1 _4920_/X
+ sky130_fd_sc_hd__a32o_2
X_4851_ _4852_/A _4852_/B vssd1 vssd1 vccd1 vccd1 _4941_/B sky130_fd_sc_hd__nor2_2
XTAP_TAPCELL_ROW_35_549 vssd1 vccd1 sky130_fd_sc_hd__tapvpwrvgnd_1
XANTENNA__8351__Q _8351_/Q vssd1 vssd1 vccd1 vccd1 sky130_fd_sc_hd__diode_2
X_7570_ _7777_/B _7570_/B vssd1 vssd1 vccd1 vccd1 _7572_/B sky130_fd_sc_hd__nand2_2
X_4782_ _4782_/A _4838_/A vssd1 vssd1 vccd1 vccd1 _4783_/D sky130_fd_sc_hd__nand2_2
X_6521_ _7998_/A _8103_/B _7140_/C _7723_/C vssd1 vssd1 vccd1 vccd1 _6523_/A sky130_fd_sc_hd__and4_2
X_6452_ _6540_/A _6451_/B _6451_/C vssd1 vssd1 vccd1 vccd1 _6454_/B sky130_fd_sc_hd__o21a_2
X_5403_ _5403_/A _5403_/B vssd1 vssd1 vccd1 vccd1 _5404_/B sky130_fd_sc_hd__nor2_2
X_8122_ _8122_/A _8122_/B vssd1 vssd1 vccd1 vccd1 _8143_/A sky130_fd_sc_hd__xor2_2
X_6383_ _6383_/A _6383_/B vssd1 vssd1 vccd1 vccd1 _6384_/B sky130_fd_sc_hd__xnor2_2
X_5334_ _5555_/A _5521_/C _5393_/D _8179_/A vssd1 vssd1 vccd1 vccd1 _5334_/Y sky130_fd_sc_hd__a22oi_2
XANTENNA_clkbuf_4_1_0_clk_A clkbuf_0_clk/X vssd1 vssd1 vccd1 vccd1 sky130_fd_sc_hd__diode_2
X_8053_ _8053_/A _8053_/B vssd1 vssd1 vccd1 vccd1 _8055_/C sky130_fd_sc_hd__or2_2
X_5265_ _8408_/D _5272_/B _5254_/C vssd1 vssd1 vccd1 vccd1 _5266_/B sky130_fd_sc_hd__a21oi_2
X_7004_ _7004_/A _7004_/B vssd1 vssd1 vccd1 vccd1 _7006_/A sky130_fd_sc_hd__xnor2_2
X_5196_ _6631_/B _6611_/A _5129_/X _5696_/A vssd1 vssd1 vccd1 vccd1 _5198_/B sky130_fd_sc_hd__or4bb_4
X_4216_ hold534/X input9/X _4218_/S vssd1 vssd1 vccd1 vccd1 _8420_/D sky130_fd_sc_hd__mux2_1
X_4147_ _5104_/A vssd1 vssd1 vccd1 vccd1 _4147_/Y sky130_fd_sc_hd__inv_2
XFILLER_18_59 vssd1 vssd1 vccd1 vccd1 sky130_fd_sc_hd__fill_1
XTAP_TAPCELL_ROW_79_991 vssd1 vccd1 sky130_fd_sc_hd__tapvpwrvgnd_1
XTAP_TAPCELL_ROW_87_1068 vssd1 vccd1 sky130_fd_sc_hd__tapvpwrvgnd_1
X_7906_ _7906_/A _7906_/B _7906_/C vssd1 vssd1 vccd1 vccd1 _7907_/B sky130_fd_sc_hd__and3_2
XANTENNA_fanout259_X _6517_/A vssd1 vssd1 vccd1 vccd1 sky130_fd_sc_hd__diode_2
X_7837_ _7698_/A _7698_/B _7697_/A vssd1 vssd1 vccd1 vccd1 _7839_/B sky130_fd_sc_hd__a21oi_2
XANTENNA__5925__A2 _6712_/B vssd1 vssd1 vccd1 vccd1 sky130_fd_sc_hd__diode_2
X_7768_ _7768_/A _7768_/B _7766_/Y vssd1 vssd1 vccd1 vccd1 _7769_/B sky130_fd_sc_hd__or3b_2
XANTENNA__7816__B _8081_/B vssd1 vssd1 vccd1 vccd1 sky130_fd_sc_hd__diode_2
XFILLER_50_24 vssd1 vssd1 vccd1 vccd1 sky130_fd_sc_hd__fill_4
XFILLER_7_208 vssd1 vssd1 vccd1 vccd1 sky130_fd_sc_hd__fill_1
X_7699_ _7638_/A _7638_/B _7637_/A vssd1 vssd1 vccd1 vccd1 _7701_/B sky130_fd_sc_hd__a21oi_2
Xclkload2 clkload2/A vssd1 vssd1 vccd1 vccd1 clkload2/X sky130_fd_sc_hd__clkbuf_4
X_6719_ _6719_/A _6719_/B vssd1 vssd1 vccd1 vccd1 _6720_/B sky130_fd_sc_hd__xnor2_2
XFILLER_50_68 vssd1 vssd1 vccd1 vccd1 sky130_fd_sc_hd__fill_1
XFILLER_3_447 vssd1 vssd1 vccd1 vccd1 sky130_fd_sc_hd__fill_1
Xfanout250 _8368_/Q vssd1 vssd1 vccd1 vccd1 _8103_/B sky130_fd_sc_hd__clkdlybuf4s25_1
XFILLER_59_451 vssd1 vssd1 vccd1 vccd1 sky130_fd_sc_hd__fill_1
XFILLER_59_462 vssd1 vssd1 vccd1 vccd1 sky130_fd_sc_hd__fill_4
Xfanout261 _6830_/A vssd1 vssd1 vccd1 vccd1 _8108_/A sky130_fd_sc_hd__clkdlybuf4s25_1
Xfanout272 _6832_/A vssd1 vssd1 vccd1 vccd1 _8110_/B sky130_fd_sc_hd__clkdlybuf4s25_1
Xfanout283 _8356_/Q vssd1 vssd1 vccd1 vccd1 _8274_/A sky130_fd_sc_hd__clkdlybuf4s25_1
XTAP_TAPCELL_ROW_6_263 vssd1 vccd1 sky130_fd_sc_hd__tapvpwrvgnd_1
Xfanout294 _8351_/Q vssd1 vssd1 vccd1 vccd1 _8263_/A sky130_fd_sc_hd__clkdlybuf4s25_1
XFILLER_74_465 vssd1 vssd1 vccd1 vccd1 sky130_fd_sc_hd__fill_4
XFILLER_61_126 vssd1 vssd1 vccd1 vccd1 sky130_fd_sc_hd__fill_4
XANTENNA__6614__C _6970_/A vssd1 vssd1 vccd1 vccd1 sky130_fd_sc_hd__diode_2
XFILLER_42_373 vssd1 vssd1 vccd1 vccd1 sky130_fd_sc_hd__fill_1
XTAP_TAPCELL_ROW_32_519 vssd1 vccd1 sky130_fd_sc_hd__tapvpwrvgnd_1
XANTENNA__6630__B _6631_/B vssd1 vssd1 vccd1 vccd1 sky130_fd_sc_hd__diode_2
XANTENNA__7669__A2 _8077_/B vssd1 vssd1 vccd1 vccd1 sky130_fd_sc_hd__diode_2
XTAP_TAPCELL_ROW_40_596 vssd1 vccd1 sky130_fd_sc_hd__tapvpwrvgnd_1
XANTENNA__7461__B _7889_/B vssd1 vssd1 vccd1 vccd1 sky130_fd_sc_hd__diode_2
X_5050_ _8409_/D _5902_/B vssd1 vssd1 vccd1 vccd1 _5051_/B sky130_fd_sc_hd__nand2_2
XANTENNA__6077__B _6078_/B vssd1 vssd1 vccd1 vccd1 sky130_fd_sc_hd__diode_2
XANTENNA__8346__Q _8346_/Q vssd1 vssd1 vccd1 vccd1 sky130_fd_sc_hd__diode_2
XFILLER_77_270 vssd1 vssd1 vccd1 vccd1 sky130_fd_sc_hd__fill_1
XFILLER_77_281 vssd1 vssd1 vccd1 vccd1 sky130_fd_sc_hd__fill_2
XTAP_TAPCELL_ROW_76_961 vssd1 vccd1 sky130_fd_sc_hd__tapvpwrvgnd_1
XFILLER_92_251 vssd1 vssd1 vccd1 vccd1 sky130_fd_sc_hd__fill_1
XFILLER_1_95 vssd1 vssd1 vccd1 vccd1 sky130_fd_sc_hd__fill_2
XFILLER_65_487 vssd1 vssd1 vccd1 vccd1 sky130_fd_sc_hd__fill_1
XFILLER_65_498 vssd1 vssd1 vccd1 vccd1 sky130_fd_sc_hd__fill_1
X_5952_ _5952_/A _5952_/B vssd1 vssd1 vccd1 vccd1 _5962_/A sky130_fd_sc_hd__xnor2_2
XTAP_TAPCELL_ROW_48_685 vssd1 vccd1 sky130_fd_sc_hd__tapvpwrvgnd_1
XFILLER_52_137 vssd1 vssd1 vccd1 vccd1 sky130_fd_sc_hd__fill_2
X_4903_ _8423_/D _5138_/B _4902_/C _4902_/D vssd1 vssd1 vccd1 vccd1 _4904_/C sky130_fd_sc_hd__a22o_2
XFILLER_80_479 vssd1 vssd1 vccd1 vccd1 sky130_fd_sc_hd__fill_2
X_5883_ _5883_/A _5883_/B vssd1 vssd1 vccd1 vccd1 _5884_/B sky130_fd_sc_hd__xor2_2
XANTENNA__5368__B1 _5838_/C vssd1 vssd1 vccd1 vccd1 sky130_fd_sc_hd__diode_2
XFILLER_60_181 vssd1 vssd1 vccd1 vccd1 sky130_fd_sc_hd__fill_1
X_7622_ _7958_/A _8082_/C vssd1 vssd1 vccd1 vccd1 _7623_/B sky130_fd_sc_hd__nor2_2
X_4834_ _4835_/A _4835_/B vssd1 vssd1 vccd1 vccd1 _4834_/Y sky130_fd_sc_hd__nor2_2
X_7553_ _7553_/A _7553_/B vssd1 vssd1 vccd1 vccd1 _7563_/A sky130_fd_sc_hd__xnor2_2
X_4765_ _4765_/A _4765_/B vssd1 vssd1 vccd1 vccd1 _4767_/B sky130_fd_sc_hd__xnor2_2
XANTENNA__4979__C _4979_/C vssd1 vssd1 vccd1 vccd1 sky130_fd_sc_hd__diode_2
X_6504_ _6504_/A _6504_/B vssd1 vssd1 vccd1 vccd1 _6506_/A sky130_fd_sc_hd__nor2_2
XANTENNA_fanout219_A _7862_/B vssd1 vssd1 vccd1 vccd1 sky130_fd_sc_hd__diode_2
X_7484_ _7458_/B _7241_/B _7243_/B _7269_/A vssd1 vssd1 vccd1 vccd1 _7485_/C sky130_fd_sc_hd__a31oi_2
X_4696_ _8425_/D _4709_/A _4709_/C _4709_/D vssd1 vssd1 vccd1 vccd1 _4704_/C sky130_fd_sc_hd__nand4_2
XFILLER_20_27 vssd1 vssd1 vccd1 vccd1 sky130_fd_sc_hd__fill_1
X_6435_ _6435_/A _8103_/B _6903_/C _7140_/C vssd1 vssd1 vccd1 vccd1 _6437_/A sky130_fd_sc_hd__and4_2
XANTENNA__4343__A1 _5163_/B vssd1 vssd1 vccd1 vccd1 sky130_fd_sc_hd__diode_2
X_6366_ _6367_/A _6367_/B _6367_/C vssd1 vssd1 vccd1 vccd1 _6368_/A sky130_fd_sc_hd__a21oi_2
XFILLER_88_502 vssd1 vssd1 vccd1 vccd1 sky130_fd_sc_hd__fill_1
X_8105_ _8105_/A _8105_/B vssd1 vssd1 vccd1 vccd1 _8106_/B sky130_fd_sc_hd__nand2_2
X_5317_ _5317_/A _5332_/A vssd1 vssd1 vccd1 vccd1 _5319_/B sky130_fd_sc_hd__nor2_2
X_8036_ _8037_/A _8037_/B vssd1 vssd1 vccd1 vccd1 _8038_/A sky130_fd_sc_hd__and2_2
X_6297_ _6297_/A _6297_/B vssd1 vssd1 vccd1 vccd1 _6298_/B sky130_fd_sc_hd__xnor2_2
XANTENNA__5843__A1 _6435_/A vssd1 vssd1 vccd1 vccd1 sky130_fd_sc_hd__diode_2
X_5248_ _5249_/A _5249_/B vssd1 vssd1 vccd1 vccd1 _5250_/B sky130_fd_sc_hd__nand2_2
XANTENNA__5843__B2 _6035_/C vssd1 vssd1 vccd1 vccd1 sky130_fd_sc_hd__diode_2
X_5179_ _4993_/B _4993_/A _5005_/X vssd1 vssd1 vccd1 vccd1 _5181_/B sky130_fd_sc_hd__o21a_4
XTAP_TAPCELL_ROW_3_233 vssd1 vccd1 sky130_fd_sc_hd__tapvpwrvgnd_1
XFILLER_28_167 vssd1 vssd1 vccd1 vccd1 sky130_fd_sc_hd__fill_2
XFILLER_43_126 vssd1 vssd1 vccd1 vccd1 sky130_fd_sc_hd__fill_2
XANTENNA__7249__D _8351_/Q vssd1 vssd1 vccd1 vccd1 sky130_fd_sc_hd__diode_2
XFILLER_12_557 vssd1 vssd1 vccd1 vccd1 sky130_fd_sc_hd__fill_2
XFILLER_8_517 vssd1 vssd1 vccd1 vccd1 sky130_fd_sc_hd__fill_2
XANTENNA__5066__B wire77/A vssd1 vssd1 vccd1 vccd1 sky130_fd_sc_hd__diode_2
XFILLER_6_29 vssd1 vssd1 vccd1 vccd1 sky130_fd_sc_hd__fill_1
XANTENNA__5126__A3 _5902_/B vssd1 vssd1 vccd1 vccd1 sky130_fd_sc_hd__diode_2
XFILLER_3_277 vssd1 vssd1 vccd1 vccd1 sky130_fd_sc_hd__fill_1
XFILLER_10_93 vssd1 vssd1 vccd1 vccd1 sky130_fd_sc_hd__fill_1
XFILLER_79_557 vssd1 vssd1 vccd1 vccd1 sky130_fd_sc_hd__fill_1
XANTENNA__7823__A2 _8082_/C vssd1 vssd1 vccd1 vccd1 sky130_fd_sc_hd__diode_2
XANTENNA__6906__A _7233_/A vssd1 vssd1 vccd1 vccd1 sky130_fd_sc_hd__diode_2
XFILLER_59_281 vssd1 vssd1 vccd1 vccd1 sky130_fd_sc_hd__fill_2
XFILLER_86_75 vssd1 vssd1 vccd1 vccd1 sky130_fd_sc_hd__fill_2
XFILLER_62_435 vssd1 vssd1 vccd1 vccd1 sky130_fd_sc_hd__fill_2
XTAP_TAPCELL_ROW_73_931 vssd1 vccd1 sky130_fd_sc_hd__tapvpwrvgnd_1
XANTENNA__4145__B _4207_/B vssd1 vssd1 vccd1 vccd1 sky130_fd_sc_hd__diode_2
XTAP_TAPCELL_ROW_45_655 vssd1 vccd1 sky130_fd_sc_hd__tapvpwrvgnd_1
XTAP_TAPCELL_ROW_17_368 vssd1 vccd1 sky130_fd_sc_hd__tapvpwrvgnd_1
XANTENNA__7737__A _8125_/A vssd1 vssd1 vccd1 vccd1 sky130_fd_sc_hd__diode_2
XANTENNA_max_cap386_A input19/X vssd1 vssd1 vccd1 vccd1 sky130_fd_sc_hd__diode_2
XANTENNA__6360__B _6360_/B vssd1 vssd1 vccd1 vccd1 sky130_fd_sc_hd__diode_2
X_4550_ _4729_/A _4729_/B vssd1 vssd1 vccd1 vccd1 _4550_/Y sky130_fd_sc_hd__nand2_2
XANTENNA__7511__A1 _7359_/A vssd1 vssd1 vccd1 vccd1 sky130_fd_sc_hd__diode_2
XFILLER_7_561 vssd1 vssd1 vccd1 vccd1 sky130_fd_sc_hd__fill_8
Xhold517 _8393_/Q vssd1 vssd1 vccd1 vccd1 _8452_/D sky130_fd_sc_hd__dlygate4sd3_1
X_4481_ _5710_/A _4780_/B _4931_/C _4979_/A vssd1 vssd1 vccd1 vccd1 _4481_/X sky130_fd_sc_hd__a22o_2
Xhold539 _8323_/Q vssd1 vssd1 vccd1 vccd1 hold539/X sky130_fd_sc_hd__dlygate4sd3_1
Xhold528 _8379_/Q vssd1 vssd1 vccd1 vccd1 _8438_/D sky130_fd_sc_hd__dlygate4sd3_1
X_6220_ _7233_/A _7515_/A vssd1 vssd1 vccd1 vccd1 _6221_/B sky130_fd_sc_hd__nand2_2
X_6151_ _6151_/A _6151_/B vssd1 vssd1 vccd1 vccd1 _6153_/B sky130_fd_sc_hd__xnor2_2
X_5102_ _5102_/A _5102_/B _5102_/C vssd1 vssd1 vccd1 vccd1 _5234_/A sky130_fd_sc_hd__and3_2
XFILLER_85_505 vssd1 vssd1 vccd1 vccd1 sky130_fd_sc_hd__fill_2
X_6082_ _7658_/S _6080_/Y _6081_/Y vssd1 vssd1 vccd1 vccd1 _8321_/D sky130_fd_sc_hd__a21oi_2
XANTENNA__6238__D _6238_/D vssd1 vssd1 vccd1 vccd1 sky130_fd_sc_hd__diode_2
X_5033_ _5033_/A _5033_/B vssd1 vssd1 vccd1 vccd1 _5035_/B sky130_fd_sc_hd__xnor2_2
XTAP_TAPCELL_ROW_0_203 vssd1 vccd1 sky130_fd_sc_hd__tapvpwrvgnd_1
XPHY_EDGE_ROW_69_Left_162 vssd1 vssd1 vccd1 vccd1 sky130_fd_sc_hd__decap_3
XANTENNA_fanout169_A _4183_/X vssd1 vssd1 vccd1 vccd1 sky130_fd_sc_hd__diode_2
X_6984_ _6632_/B _6770_/Y _6774_/X vssd1 vssd1 vccd1 vccd1 _6994_/A sky130_fd_sc_hd__a21bo_2
XTAP_TAPCELL_ROW_84_1038 vssd1 vccd1 sky130_fd_sc_hd__tapvpwrvgnd_1
X_5935_ _5935_/A _5935_/B vssd1 vssd1 vccd1 vccd1 _5970_/A sky130_fd_sc_hd__xor2_2
XANTENNA_fanout336_A _6883_/A vssd1 vssd1 vccd1 vccd1 sky130_fd_sc_hd__diode_2
XFILLER_80_287 vssd1 vssd1 vccd1 vccd1 sky130_fd_sc_hd__fill_4
X_5866_ _6460_/A _8241_/A vssd1 vssd1 vccd1 vccd1 _5867_/B sky130_fd_sc_hd__nand2_2
X_7605_ _7605_/A _7605_/B vssd1 vssd1 vccd1 vccd1 _7606_/B sky130_fd_sc_hd__xor2_2
X_4817_ _4902_/A _4897_/B _4816_/C _4816_/D vssd1 vssd1 vccd1 vccd1 _4819_/B sky130_fd_sc_hd__a22o_2
X_5797_ _5112_/A _5782_/A _5109_/X vssd1 vssd1 vccd1 vccd1 _5798_/B sky130_fd_sc_hd__o21ai_2
XFILLER_31_37 vssd1 vssd1 vccd1 vccd1 sky130_fd_sc_hd__fill_8
X_7536_ _8016_/A _7725_/B _7864_/B _7875_/B vssd1 vssd1 vccd1 vccd1 _7537_/B sky130_fd_sc_hd__a22oi_2
X_4748_ _4749_/A _4749_/B vssd1 vssd1 vccd1 vccd1 _4748_/Y sky130_fd_sc_hd__nor2_2
XPHY_EDGE_ROW_78_Left_171 vssd1 vssd1 vccd1 vccd1 sky130_fd_sc_hd__decap_3
X_7467_ _7467_/A _7467_/B vssd1 vssd1 vccd1 vccd1 _7469_/A sky130_fd_sc_hd__nor2_2
X_4679_ _4679_/A _4679_/B vssd1 vssd1 vccd1 vccd1 _4680_/B sky130_fd_sc_hd__nand2_2
X_6418_ _6418_/A _6418_/B vssd1 vssd1 vccd1 vccd1 _6420_/C sky130_fd_sc_hd__xnor2_2
XPHY_EDGE_ROW_1_Right_1 vssd1 vssd1 vccd1 vccd1 sky130_fd_sc_hd__decap_3
Xoutput26 _8325_/Q vssd1 vssd1 vccd1 vccd1 gpio_out[23] sky130_fd_sc_hd__clkdlybuf4s25_1
X_7398_ _7305_/A _7305_/B _7302_/Y vssd1 vssd1 vccd1 vccd1 _7413_/A sky130_fd_sc_hd__a21oi_2
X_6349_ _6349_/A _6650_/A vssd1 vssd1 vccd1 vccd1 _6351_/A sky130_fd_sc_hd__xnor2_2
XANTENNA__5277__C1 _6611_/A vssd1 vssd1 vccd1 vccd1 sky130_fd_sc_hd__diode_2
XANTENNA__6726__A _6970_/A vssd1 vssd1 vccd1 vccd1 sky130_fd_sc_hd__diode_2
X_8019_ _8019_/A _8019_/B vssd1 vssd1 vccd1 vccd1 _8021_/B sky130_fd_sc_hd__xnor2_2
XPHY_EDGE_ROW_87_Left_180 vssd1 vssd1 vccd1 vccd1 sky130_fd_sc_hd__decap_3
XFILLER_71_221 vssd1 vssd1 vccd1 vccd1 sky130_fd_sc_hd__fill_2
XFILLER_71_276 vssd1 vssd1 vccd1 vccd1 sky130_fd_sc_hd__fill_4
XTAP_TAPCELL_ROW_70_901 vssd1 vccd1 sky130_fd_sc_hd__tapvpwrvgnd_1
XANTENNA__7557__A _8001_/A vssd1 vssd1 vccd1 vccd1 sky130_fd_sc_hd__diode_2
XFILLER_24_170 vssd1 vssd1 vccd1 vccd1 sky130_fd_sc_hd__fill_4
XTAP_TAPCELL_ROW_42_625 vssd1 vccd1 sky130_fd_sc_hd__tapvpwrvgnd_1
XTAP_TAPCELL_ROW_14_338 vssd1 vccd1 sky130_fd_sc_hd__tapvpwrvgnd_1
XANTENNA__7723__C _7723_/C vssd1 vssd1 vccd1 vccd1 sky130_fd_sc_hd__diode_2
XFILLER_4_553 vssd1 vssd1 vccd1 vccd1 sky130_fd_sc_hd__fill_1
XFILLER_79_332 vssd1 vssd1 vccd1 vccd1 sky130_fd_sc_hd__fill_4
XANTENNA_load_slew45_X _8082_/D vssd1 vssd1 vccd1 vccd1 sky130_fd_sc_hd__diode_2
XFILLER_67_505 vssd1 vssd1 vccd1 vccd1 sky130_fd_sc_hd__fill_4
XFILLER_79_365 vssd1 vccd1 vssd1 vccd1 sky130_ef_sc_hd__decap_40_12
XFILLER_67_549 vssd1 vssd1 vccd1 vccd1 sky130_fd_sc_hd__fill_4
XFILLER_82_508 vssd1 vssd1 vccd1 vccd1 sky130_fd_sc_hd__fill_2
XTAP_TAPCELL_ROW_58_780 vssd1 vccd1 sky130_fd_sc_hd__tapvpwrvgnd_1
XFILLER_62_243 vssd1 vssd1 vccd1 vccd1 sky130_fd_sc_hd__fill_1
X_5720_ _5720_/A _5720_/B vssd1 vssd1 vccd1 vccd1 _5733_/A sky130_fd_sc_hd__xor2_2
XANTENNA__7186__B _8125_/B vssd1 vssd1 vccd1 vccd1 sky130_fd_sc_hd__diode_2
XANTENNA__6521__D _7723_/C vssd1 vssd1 vccd1 vccd1 sky130_fd_sc_hd__diode_2
X_5651_ _5651_/A _5651_/B vssd1 vssd1 vccd1 vccd1 _5652_/C sky130_fd_sc_hd__and2_2
X_8370_ clkload8/A _8370_/D wire377/X vssd1 vssd1 vccd1 vccd1 _8370_/Q sky130_fd_sc_hd__dfrtp_2
X_5582_ _5582_/A _5582_/B vssd1 vssd1 vccd1 vccd1 _5625_/A sky130_fd_sc_hd__and2_2
X_4602_ _4602_/A _4602_/B vssd1 vssd1 vccd1 vccd1 _4622_/B sky130_fd_sc_hd__xor2_2
XFILLER_7_61 vssd1 vssd1 vccd1 vccd1 sky130_fd_sc_hd__fill_2
X_7321_ _8416_/D _7820_/B vssd1 vssd1 vccd1 vccd1 _7322_/B sky130_fd_sc_hd__nand2_2
X_4533_ _4744_/A _5147_/B vssd1 vssd1 vccd1 vccd1 _4576_/A sky130_fd_sc_hd__nand2_2
X_7252_ _8001_/A _8352_/Q vssd1 vssd1 vccd1 vccd1 _7253_/B sky130_fd_sc_hd__nand2_2
X_6203_ _6204_/A _6204_/B vssd1 vssd1 vccd1 vccd1 _6412_/A sky130_fd_sc_hd__nand2_2
X_4464_ _4464_/A _4464_/B vssd1 vssd1 vccd1 vccd1 _4465_/B sky130_fd_sc_hd__xnor2_2
XANTENNA__4340__A1_N _8430_/D vssd1 vssd1 vccd1 vccd1 sky130_fd_sc_hd__diode_2
X_7183_ _7183_/A _7183_/B _7183_/C vssd1 vssd1 vccd1 vccd1 _7184_/B sky130_fd_sc_hd__and3_2
X_4395_ _4396_/A _4396_/B vssd1 vssd1 vccd1 vccd1 _4506_/B sky130_fd_sc_hd__nor2_2
X_6134_ _6134_/A _6134_/B vssd1 vssd1 vccd1 vccd1 _6136_/B sky130_fd_sc_hd__xnor2_2
XFILLER_85_335 vssd1 vssd1 vccd1 vccd1 sky130_fd_sc_hd__fill_1
X_6065_ _6062_/Y _6063_/Y _5868_/A _5869_/A vssd1 vssd1 vccd1 vccd1 _6066_/B sky130_fd_sc_hd__a211o_2
XTAP_TAPCELL_ROW_90_1097 vssd1 vccd1 sky130_fd_sc_hd__tapvpwrvgnd_1
X_5016_ _5016_/A _5016_/B vssd1 vssd1 vccd1 vccd1 _5019_/A sky130_fd_sc_hd__xnor2_2
X_6967_ _6732_/A _6967_/A2 _6730_/Y vssd1 vssd1 vccd1 vccd1 _6983_/A sky130_fd_sc_hd__o21ai_2
XANTENNA_fanout241_X _6435_/A vssd1 vssd1 vccd1 vccd1 sky130_fd_sc_hd__diode_2
X_5918_ _5907_/B _5796_/B _5798_/B _5799_/Y vssd1 vssd1 vccd1 vccd1 _5920_/B sky130_fd_sc_hd__a31o_2
XANTENNA__7096__B _8081_/B vssd1 vssd1 vccd1 vccd1 sky130_fd_sc_hd__diode_2
XANTENNA_fanout339_X _6883_/A vssd1 vssd1 vccd1 vccd1 sky130_fd_sc_hd__diode_2
XFILLER_42_25 vssd1 vssd1 vccd1 vccd1 sky130_fd_sc_hd__fill_2
X_6898_ _7137_/B _6898_/B vssd1 vssd1 vccd1 vccd1 _6900_/C sky130_fd_sc_hd__nand2_2
X_5849_ _5849_/A _5849_/B vssd1 vssd1 vccd1 vccd1 _5851_/B sky130_fd_sc_hd__xnor2_2
XTAP_TAPCELL_ROW_11_308 vssd1 vccd1 sky130_fd_sc_hd__tapvpwrvgnd_1
XANTENNA__6431__D _8246_/A vssd1 vssd1 vccd1 vccd1 sky130_fd_sc_hd__diode_2
X_7519_ _7519_/A _7519_/B vssd1 vssd1 vccd1 vccd1 _7522_/A sky130_fd_sc_hd__xnor2_2
Xrebuffer466 _4641_/A vssd1 vssd1 vccd1 vccd1 _4617_/B sky130_fd_sc_hd__buf_2
Xrebuffer455 _4148_/X vssd1 vssd1 vccd1 vccd1 _8434_/D sky130_fd_sc_hd__buf_2
Xrebuffer444 _4652_/B vssd1 vssd1 vccd1 vccd1 _4651_/A sky130_fd_sc_hd__buf_2
Xrebuffer488 _6393_/B vssd1 vssd1 vccd1 vccd1 _6394_/B sky130_fd_sc_hd__buf_2
Xrebuffer499 _4507_/A vssd1 vssd1 vccd1 vccd1 _4803_/B1 sky130_fd_sc_hd__buf_2
Xrebuffer477 _5202_/B vssd1 vssd1 vccd1 vccd1 _5695_/B sky130_fd_sc_hd__buf_2
XANTENNA__8001__A _8001_/A vssd1 vssd1 vccd1 vccd1 sky130_fd_sc_hd__diode_2
XFILLER_1_501 vssd1 vssd1 vccd1 vccd1 sky130_fd_sc_hd__fill_2
XFILLER_1_512 vssd1 vssd1 vccd1 vccd1 sky130_fd_sc_hd__fill_1
XFILLER_49_505 vssd1 vssd1 vccd1 vccd1 sky130_fd_sc_hd__fill_4
XANTENNA_input14_A gpio_in[4] vssd1 vssd1 vccd1 vccd1 sky130_fd_sc_hd__diode_2
XFILLER_83_54 vssd1 vssd1 vccd1 vccd1 sky130_fd_sc_hd__fill_2
XFILLER_83_65 vssd1 vssd1 vccd1 vccd1 sky130_fd_sc_hd__fill_2
XTAP_TAPCELL_ROW_55_750 vssd1 vccd1 sky130_fd_sc_hd__tapvpwrvgnd_1
XFILLER_83_98 vssd1 vssd1 vccd1 vccd1 sky130_fd_sc_hd__fill_4
XTAP_TAPCELL_ROW_27_474 vssd1 vccd1 sky130_fd_sc_hd__tapvpwrvgnd_1
XANTENNA__4704__A _4709_/B vssd1 vssd1 vccd1 vccd1 sky130_fd_sc_hd__diode_2
XFILLER_8_133 vssd1 vssd1 vccd1 vccd1 sky130_fd_sc_hd__fill_1
X_4180_ _8191_/B _4207_/B vssd1 vssd1 vccd1 vccd1 _4180_/Y sky130_fd_sc_hd__nand2b_2
XFILLER_67_324 vssd1 vssd1 vccd1 vccd1 sky130_fd_sc_hd__fill_2
XFILLER_67_379 vssd1 vssd1 vccd1 vccd1 sky130_fd_sc_hd__fill_1
X_7870_ _7870_/A _7870_/B _7870_/C vssd1 vssd1 vccd1 vccd1 _7883_/B sky130_fd_sc_hd__nand3_2
X_6821_ _6821_/A _6821_/B vssd1 vssd1 vccd1 vccd1 _6823_/B sky130_fd_sc_hd__xnor2_2
XTAP_TAPCELL_ROW_81_1008 vssd1 vccd1 sky130_fd_sc_hd__tapvpwrvgnd_1
XFILLER_23_449 vssd1 vssd1 vccd1 vccd1 sky130_fd_sc_hd__fill_1
X_6752_ _6752_/A _6752_/B vssd1 vssd1 vccd1 vccd1 _6753_/B sky130_fd_sc_hd__and2_2
X_6683_ _6683_/A _6683_/B vssd1 vssd1 vccd1 vccd1 _6685_/B sky130_fd_sc_hd__xnor2_2
X_5703_ _5703_/A _5703_/B _5702_/X vssd1 vssd1 vccd1 vccd1 _5704_/B sky130_fd_sc_hd__or3b_2
X_8422_ clkload0/A _8422_/D load_slew366/X vssd1 vssd1 vccd1 vccd1 _8422_/Q sky130_fd_sc_hd__dfrtp_2
X_5634_ _5651_/A _5634_/B vssd1 vssd1 vccd1 vccd1 _5635_/B sky130_fd_sc_hd__and2_2
X_8353_ _8405_/CLK _8353_/D fanout383/X vssd1 vssd1 vccd1 vccd1 _8353_/Q sky130_fd_sc_hd__dfrtp_2
X_7304_ _7304_/A _8077_/B vssd1 vssd1 vccd1 vccd1 _7305_/B sky130_fd_sc_hd__nor2_2
X_5565_ _5566_/A _5566_/B vssd1 vssd1 vccd1 vccd1 _5587_/A sky130_fd_sc_hd__nand2_2
XANTENNA__8130__A1 _6207_/A vssd1 vssd1 vccd1 vccd1 sky130_fd_sc_hd__diode_2
X_8284_ _8361_/Q _8285_/B vssd1 vssd1 vccd1 vccd1 _8287_/B sky130_fd_sc_hd__nand2_2
X_5496_ _5339_/A _5341_/B _5339_/B vssd1 vssd1 vccd1 vccd1 _5498_/B sky130_fd_sc_hd__o21ba_2
X_4516_ _4516_/A _4516_/B vssd1 vssd1 vccd1 vccd1 _4521_/B sky130_fd_sc_hd__xnor2_2
XTAP_TAPCELL_ROW_92_1126 vssd1 vccd1 sky130_fd_sc_hd__tapvpwrvgnd_1
X_7235_ _7236_/A _7236_/B vssd1 vssd1 vccd1 vccd1 _7477_/A sky130_fd_sc_hd__nand2b_2
X_4447_ _4447_/A _4447_/B vssd1 vssd1 vccd1 vccd1 _4514_/A sky130_fd_sc_hd__nand2_2
X_7166_ _7166_/A _7166_/B vssd1 vssd1 vccd1 vccd1 _7168_/B sky130_fd_sc_hd__xnor2_2
XANTENNA_input6_A gpio_in[13] vssd1 vssd1 vccd1 vccd1 sky130_fd_sc_hd__diode_2
X_6117_ _6117_/A _6117_/B vssd1 vssd1 vccd1 vccd1 _6119_/A sky130_fd_sc_hd__nand2_2
X_4378_ _4379_/A _4378_/B vssd1 vssd1 vccd1 vccd1 _4502_/B sky130_fd_sc_hd__and2_2
X_7097_ _7097_/A _7097_/B vssd1 vssd1 vccd1 vccd1 _7099_/A sky130_fd_sc_hd__xor2_2
X_6048_ _5848_/X _5852_/A _6259_/A _6047_/Y vssd1 vssd1 vccd1 vccd1 _6259_/B sky130_fd_sc_hd__o211ai_2
XTAP_TAPCELL_ROW_69_886 vssd1 vccd1 sky130_fd_sc_hd__tapvpwrvgnd_1
XFILLER_54_552 vssd1 vssd1 vccd1 vccd1 sky130_fd_sc_hd__fill_1
XANTENNA__6723__B _8077_/B vssd1 vssd1 vccd1 vccd1 sky130_fd_sc_hd__diode_2
X_7999_ _8274_/A _7999_/B vssd1 vssd1 vccd1 vccd1 _7999_/X sky130_fd_sc_hd__and2_2
XTAP_TAPCELL_ROW_52_720 vssd1 vccd1 sky130_fd_sc_hd__tapvpwrvgnd_1
XFILLER_41_246 vssd1 vssd1 vccd1 vccd1 sky130_fd_sc_hd__fill_4
XFILLER_53_57 vssd1 vssd1 vccd1 vccd1 sky130_fd_sc_hd__fill_8
XTAP_TAPCELL_ROW_24_444 vssd1 vccd1 sky130_fd_sc_hd__tapvpwrvgnd_1
XANTENNA__7554__B _7754_/B vssd1 vssd1 vccd1 vccd1 sky130_fd_sc_hd__diode_2
XFILLER_5_147 vssd1 vssd1 vccd1 vccd1 sky130_fd_sc_hd__fill_1
XFILLER_1_364 vssd1 vssd1 vccd1 vccd1 sky130_fd_sc_hd__fill_1
XFILLER_78_87 vssd1 vssd1 vccd1 vccd1 sky130_fd_sc_hd__fill_1
XFILLER_49_335 vssd1 vssd1 vccd1 vccd1 sky130_fd_sc_hd__fill_1
XANTENNA_input17_X _8191_/B vssd1 vssd1 vccd1 vccd1 sky130_fd_sc_hd__diode_2
XFILLER_91_113 vssd1 vssd1 vccd1 vccd1 sky130_fd_sc_hd__fill_2
XANTENNA__4153__B _4160_/B vssd1 vssd1 vccd1 vccd1 sky130_fd_sc_hd__diode_2
X_5350_ _8228_/A _5669_/B _5350_/C vssd1 vssd1 vccd1 vccd1 _5464_/A sky130_fd_sc_hd__nand3_2
X_5281_ _5281_/A _5281_/B vssd1 vssd1 vccd1 vccd1 _5283_/B sky130_fd_sc_hd__or2_2
X_4301_ _4979_/B _4979_/C vssd1 vssd1 vccd1 vccd1 _4770_/B sky130_fd_sc_hd__nand2_2
XANTENNA__5415__D _6006_/A vssd1 vssd1 vccd1 vccd1 sky130_fd_sc_hd__diode_2
X_7020_ _7021_/A _7076_/A _7021_/C vssd1 vssd1 vccd1 vccd1 _7076_/B sky130_fd_sc_hd__nor3_2
X_4232_ _8382_/Q _8441_/Q vssd1 vssd1 vccd1 vccd1 _4292_/A sky130_fd_sc_hd__or2_2
XANTENNA__6398__A1_N _6397_/C vssd1 vssd1 vccd1 vccd1 sky130_fd_sc_hd__diode_2
XANTENNA__8409__CLK clkload7/A vssd1 vssd1 vccd1 vccd1 sky130_fd_sc_hd__diode_2
X_4163_ hold552/X _8184_/B _4227_/S vssd1 vssd1 vccd1 vccd1 _8426_/D sky130_fd_sc_hd__mux2_4
XFILLER_28_508 vssd1 vssd1 vccd1 vccd1 sky130_fd_sc_hd__fill_4
XFILLER_55_349 vssd1 vssd1 vccd1 vccd1 sky130_fd_sc_hd__fill_1
X_7922_ _8055_/A _7921_/B _7921_/C vssd1 vssd1 vccd1 vccd1 _7924_/B sky130_fd_sc_hd__a21o_2
XTAP_TAPCELL_ROW_66_856 vssd1 vccd1 sky130_fd_sc_hd__tapvpwrvgnd_1
X_7853_ _7853_/A _8030_/A _8136_/C _8136_/D vssd1 vssd1 vccd1 vccd1 _7853_/X sky130_fd_sc_hd__and4_2
XANTENNA_fanout249_A _8103_/B vssd1 vssd1 vccd1 vccd1 sky130_fd_sc_hd__diode_2
XFILLER_63_393 vssd1 vssd1 vccd1 vccd1 sky130_fd_sc_hd__fill_1
X_7784_ _7785_/A _7785_/B _7785_/C vssd1 vssd1 vccd1 vccd1 _7931_/A sky130_fd_sc_hd__a21oi_2
X_6804_ _7129_/A _6892_/B _7210_/A _7426_/A vssd1 vssd1 vccd1 vccd1 _6805_/B sky130_fd_sc_hd__and4_2
X_4996_ _6091_/A _6703_/B vssd1 vssd1 vccd1 vccd1 _5148_/A sky130_fd_sc_hd__nand2_2
XFILLER_23_16 vssd1 vssd1 vccd1 vccd1 sky130_fd_sc_hd__fill_4
X_6735_ _6736_/B _6736_/A vssd1 vssd1 vccd1 vccd1 _6966_/B sky130_fd_sc_hd__nand2b_2
XANTENNA__7655__A _7655_/A vssd1 vssd1 vccd1 vccd1 sky130_fd_sc_hd__diode_2
XTAP_TAPCELL_ROW_21_414 vssd1 vccd1 sky130_fd_sc_hd__tapvpwrvgnd_1
XANTENNA__7154__A2 _7875_/D vssd1 vssd1 vccd1 vccd1 sky130_fd_sc_hd__diode_2
X_6666_ _6667_/A _6667_/B vssd1 vssd1 vccd1 vccd1 _6668_/A sky130_fd_sc_hd__and2_2
XANTENNA_wire64_A wire64/A vssd1 vssd1 vccd1 vccd1 sky130_fd_sc_hd__diode_2
X_8405_ _8405_/CLK _8405_/D fanout378/X vssd1 vssd1 vccd1 vccd1 _8405_/Q sky130_fd_sc_hd__dfrtp_2
X_6597_ _6320_/A _6320_/B _6319_/A vssd1 vssd1 vccd1 vccd1 _6599_/B sky130_fd_sc_hd__a21oi_2
X_5617_ _5635_/A _5617_/B vssd1 vssd1 vccd1 vccd1 _5618_/C sky130_fd_sc_hd__xnor2_2
X_8336_ _8382_/CLK _8336_/D load_slew370/X vssd1 vssd1 vccd1 vccd1 _8336_/Q sky130_fd_sc_hd__dfrtp_2
X_5548_ _5548_/A _5548_/B _5548_/C vssd1 vssd1 vccd1 vccd1 _5680_/A sky130_fd_sc_hd__or3_2
X_8267_ _8267_/A _8267_/B _8267_/C vssd1 vssd1 vccd1 vccd1 _8271_/B sky130_fd_sc_hd__and3_2
X_7218_ _7219_/A _7714_/A _7853_/A _7862_/B vssd1 vssd1 vccd1 vccd1 _7220_/A sky130_fd_sc_hd__a22oi_2
X_5479_ _5559_/B _5393_/B _6238_/B _5555_/A vssd1 vssd1 vccd1 vccd1 _5479_/Y sky130_fd_sc_hd__a22oi_2
XFILLER_48_13 vssd1 vssd1 vccd1 vccd1 sky130_fd_sc_hd__fill_1
X_8198_ _8193_/A _8192_/A _8192_/B vssd1 vssd1 vccd1 vccd1 _8199_/B sky130_fd_sc_hd__o21ba_2
XANTENNA_input9_X input9/X vssd1 vssd1 vccd1 vccd1 sky130_fd_sc_hd__diode_2
XFILLER_48_57 vssd1 vssd1 vccd1 vccd1 sky130_fd_sc_hd__fill_1
X_7149_ _7242_/A _7149_/B _7149_/C vssd1 vssd1 vccd1 vccd1 _7242_/B sky130_fd_sc_hd__nand3_2
XFILLER_58_165 vssd1 vssd1 vccd1 vccd1 sky130_fd_sc_hd__fill_4
XFILLER_27_563 vssd1 vssd1 vccd1 vccd1 sky130_fd_sc_hd__fill_2
XPHY_EDGE_ROW_14_Left_107 vssd1 vssd1 vccd1 vccd1 sky130_fd_sc_hd__decap_3
XFILLER_64_89 vssd1 vssd1 vccd1 vccd1 sky130_fd_sc_hd__fill_2
XFILLER_80_55 vssd1 vssd1 vccd1 vccd1 sky130_fd_sc_hd__fill_1
Xfanout83 _4743_/X vssd1 vssd1 vccd1 vccd1 _6572_/B sky130_fd_sc_hd__clkdlybuf4s25_1
XFILLER_80_99 vssd1 vssd1 vccd1 vccd1 sky130_fd_sc_hd__fill_1
Xfanout94 _4432_/B vssd1 vssd1 vccd1 vccd1 _6300_/B sky130_fd_sc_hd__dlymetal6s4s_1
XANTENNA__4903__A1 _8423_/D vssd1 vssd1 vccd1 vccd1 sky130_fd_sc_hd__diode_2
XPHY_EDGE_ROW_23_Left_116 vssd1 vssd1 vccd1 vccd1 sky130_fd_sc_hd__decap_3
XANTENNA__5459__A2 _6006_/A vssd1 vssd1 vccd1 vccd1 sky130_fd_sc_hd__diode_2
XANTENNA__6628__B _6986_/B vssd1 vssd1 vccd1 vccd1 sky130_fd_sc_hd__diode_2
XTAP_TAPCELL_ROW_9_294 vssd1 vccd1 sky130_fd_sc_hd__tapvpwrvgnd_1
XANTENNA__4429__A _4709_/B vssd1 vssd1 vccd1 vccd1 sky130_fd_sc_hd__diode_2
XPHY_EDGE_ROW_32_Left_125 vssd1 vssd1 vccd1 vccd1 sky130_fd_sc_hd__decap_3
XFILLER_92_477 vssd1 vssd1 vccd1 vccd1 sky130_fd_sc_hd__fill_4
XFILLER_64_179 vssd1 vssd1 vccd1 vccd1 sky130_fd_sc_hd__fill_2
XTAP_TAPCELL_ROW_63_826 vssd1 vccd1 sky130_fd_sc_hd__tapvpwrvgnd_1
X_4850_ _4850_/A _4850_/B vssd1 vssd1 vccd1 vccd1 _4852_/B sky130_fd_sc_hd__xor2_2
XFILLER_60_385 vssd1 vssd1 vccd1 vccd1 sky130_fd_sc_hd__fill_1
X_6520_ _6520_/A _6520_/B vssd1 vssd1 vccd1 vccd1 _6530_/A sky130_fd_sc_hd__xnor2_2
X_4781_ _4838_/A _4782_/A vssd1 vssd1 vccd1 vccd1 _4843_/A sky130_fd_sc_hd__or2_4
X_6451_ _6540_/A _6451_/B _6451_/C vssd1 vssd1 vccd1 vccd1 _6540_/B sky130_fd_sc_hd__nor3_2
XPHY_EDGE_ROW_41_Left_134 vssd1 vssd1 vccd1 vccd1 sky130_fd_sc_hd__decap_3
X_6382_ _6383_/B _6383_/A vssd1 vssd1 vccd1 vccd1 _6382_/X sky130_fd_sc_hd__and2b_2
X_5402_ _8215_/A _5838_/A _8220_/A _5838_/C vssd1 vssd1 vccd1 vccd1 _5403_/B sky130_fd_sc_hd__a22oi_2
X_8121_ _8121_/A _8362_/Q vssd1 vssd1 vccd1 vccd1 _8122_/B sky130_fd_sc_hd__nand2_2
X_5333_ _8174_/A _8179_/A _5521_/C _5559_/C vssd1 vssd1 vccd1 vccd1 _5342_/B sky130_fd_sc_hd__and4_2
XANTENNA__5723__A _6572_/A vssd1 vssd1 vccd1 vccd1 sky130_fd_sc_hd__diode_2
XFILLER_87_205 vssd1 vssd1 vccd1 vccd1 sky130_fd_sc_hd__fill_2
XFILLER_87_216 vssd1 vssd1 vccd1 vccd1 sky130_fd_sc_hd__fill_1
X_8052_ _8051_/B _8051_/C _8051_/A vssd1 vssd1 vccd1 vccd1 _8053_/B sky130_fd_sc_hd__a21oi_2
X_5264_ _5264_/A _5264_/B vssd1 vssd1 vccd1 vccd1 _5283_/A sky130_fd_sc_hd__nand2_2
XANTENNA__4339__A _8430_/D vssd1 vssd1 vccd1 vccd1 sky130_fd_sc_hd__diode_2
X_7003_ _8417_/D wire59/X vssd1 vssd1 vccd1 vccd1 _7004_/B sky130_fd_sc_hd__nand2_2
X_5195_ _6631_/B vssd1 vssd1 vccd1 vccd1 _5195_/Y sky130_fd_sc_hd__inv_2
X_4215_ _7954_/A vssd1 vssd1 vccd1 vccd1 _4215_/Y sky130_fd_sc_hd__inv_2
X_4146_ _4207_/B _8413_/Q _4145_/Y vssd1 vssd1 vccd1 vccd1 _5104_/A sky130_fd_sc_hd__o21ai_2
XPHY_EDGE_ROW_50_Left_143 vssd1 vssd1 vccd1 vccd1 sky130_fd_sc_hd__decap_3
XTAP_TAPCELL_ROW_79_992 vssd1 vccd1 sky130_fd_sc_hd__tapvpwrvgnd_1
XANTENNA__8170__D_N _8164_/B vssd1 vssd1 vccd1 vccd1 sky130_fd_sc_hd__diode_2
X_7905_ _7906_/A _7906_/B _7906_/C vssd1 vssd1 vccd1 vccd1 _7988_/A sky130_fd_sc_hd__a21oi_2
XTAP_TAPCELL_ROW_87_1069 vssd1 vccd1 sky130_fd_sc_hd__tapvpwrvgnd_1
XANTENNA_fanout154_X _6611_/A vssd1 vssd1 vccd1 vccd1 sky130_fd_sc_hd__diode_2
X_7836_ _7962_/B _7836_/B vssd1 vssd1 vccd1 vccd1 _7839_/A sky130_fd_sc_hd__or2_2
XFILLER_34_48 vssd1 vssd1 vccd1 vccd1 sky130_fd_sc_hd__fill_1
XFILLER_11_216 vssd1 vssd1 vccd1 vccd1 sky130_fd_sc_hd__fill_1
X_7767_ _7768_/A _7768_/B _7766_/Y vssd1 vssd1 vccd1 vccd1 _7917_/B sky130_fd_sc_hd__o21bai_2
X_4979_ _4979_/A _4979_/B _4979_/C vssd1 vssd1 vccd1 vccd1 _5711_/A sky130_fd_sc_hd__and3_2
XANTENNA_fanout321_X _8208_/A vssd1 vssd1 vccd1 vccd1 sky130_fd_sc_hd__diode_2
X_7698_ _7698_/A _7698_/B vssd1 vssd1 vccd1 vccd1 _7701_/A sky130_fd_sc_hd__xnor2_2
Xclkload3 clkload3/A vssd1 vssd1 vccd1 vccd1 clkload3/X sky130_fd_sc_hd__clkbuf_4
X_6718_ _6718_/A _6718_/B vssd1 vssd1 vccd1 vccd1 _6719_/B sky130_fd_sc_hd__xnor2_2
XANTENNA__7535__D _7864_/B vssd1 vssd1 vccd1 vccd1 sky130_fd_sc_hd__diode_2
X_6649_ _7685_/A _6738_/B vssd1 vssd1 vccd1 vccd1 _6651_/B sky130_fd_sc_hd__nand2_2
X_8319_ _8453_/D _8254_/B _8397_/D vssd1 vssd1 vccd1 vccd1 _8394_/D sky130_fd_sc_hd__mux2_1
Xfanout240 _6435_/A vssd1 vssd1 vccd1 vccd1 _5393_/B sky130_fd_sc_hd__clkdlybuf4s25_1
XFILLER_59_441 vssd1 vssd1 vccd1 vccd1 sky130_fd_sc_hd__fill_2
Xfanout251 _5392_/B vssd1 vssd1 vccd1 vccd1 _5612_/B sky130_fd_sc_hd__clkdlybuf4s25_1
Xfanout262 _8366_/Q vssd1 vssd1 vccd1 vccd1 _6830_/A sky130_fd_sc_hd__clkdlybuf4s25_1
Xfanout273 _8364_/Q vssd1 vssd1 vccd1 vccd1 _6832_/A sky130_fd_sc_hd__clkdlybuf4s25_1
XTAP_TAPCELL_ROW_6_264 vssd1 vccd1 sky130_fd_sc_hd__tapvpwrvgnd_1
XANTENNA_fanout67_X _7326_/B vssd1 vssd1 vccd1 vccd1 sky130_fd_sc_hd__diode_2
Xfanout284 _8355_/Q vssd1 vssd1 vccd1 vccd1 _8125_/B sky130_fd_sc_hd__clkdlybuf4s25_1
Xfanout295 _6517_/D vssd1 vssd1 vccd1 vccd1 _8257_/A sky130_fd_sc_hd__clkdlybuf4s25_1
XFILLER_74_477 vssd1 vssd1 vccd1 vccd1 sky130_fd_sc_hd__fill_4
XFILLER_15_566 vssd1 vssd1 vccd1 vccd1 sky130_fd_sc_hd__fill_4
XANTENNA__8315__A1 input6/X vssd1 vssd1 vccd1 vccd1 sky130_fd_sc_hd__diode_2
XFILLER_30_569 vssd1 vssd1 vccd1 vccd1 sky130_fd_sc_hd__fill_1
XANTENNA__5129__A1 _6970_/A vssd1 vssd1 vccd1 vccd1 sky130_fd_sc_hd__diode_2
XANTENNA__5129__B2 _6724_/A vssd1 vssd1 vccd1 vccd1 sky130_fd_sc_hd__diode_2
XTAP_TAPCELL_ROW_40_597 vssd1 vccd1 sky130_fd_sc_hd__tapvpwrvgnd_1
XANTENNA__7461__C _8126_/B vssd1 vssd1 vccd1 vccd1 sky130_fd_sc_hd__diode_2
XANTENNA__5262__B _5780_/B vssd1 vssd1 vccd1 vccd1 sky130_fd_sc_hd__diode_2
XFILLER_2_481 vssd1 vssd1 vccd1 vccd1 sky130_fd_sc_hd__fill_1
XANTENNA__8251__A0 _8246_/A vssd1 vssd1 vccd1 vccd1 sky130_fd_sc_hd__diode_2
XFILLER_37_146 vssd1 vssd1 vccd1 vccd1 sky130_fd_sc_hd__fill_1
XTAP_TAPCELL_ROW_76_962 vssd1 vccd1 sky130_fd_sc_hd__tapvpwrvgnd_1
XFILLER_25_308 vssd1 vssd1 vccd1 vccd1 sky130_fd_sc_hd__fill_1
X_5951_ _5949_/X _5951_/B vssd1 vssd1 vccd1 vccd1 _5952_/B sky130_fd_sc_hd__and2b_2
X_4902_ _4902_/A _5138_/B _4902_/C _4902_/D vssd1 vssd1 vccd1 vccd1 _4904_/B sky130_fd_sc_hd__nand4_2
X_5882_ _5883_/A _5883_/B vssd1 vssd1 vccd1 vccd1 _5882_/X sky130_fd_sc_hd__and2_2
XANTENNA__5368__A1 _6035_/C vssd1 vssd1 vccd1 vccd1 sky130_fd_sc_hd__diode_2
XANTENNA__5368__B2 _8215_/A vssd1 vssd1 vccd1 vccd1 sky130_fd_sc_hd__diode_2
X_7621_ _7621_/A _7820_/B vssd1 vssd1 vccd1 vccd1 _7623_/A sky130_fd_sc_hd__nand2_2
X_4833_ _4833_/A _4833_/B vssd1 vssd1 vccd1 vccd1 _4835_/B sky130_fd_sc_hd__xor2_2
XANTENNA__8306__A1 _8174_/B vssd1 vssd1 vccd1 vccd1 sky130_fd_sc_hd__diode_2
XFILLER_21_569 vssd1 vssd1 vccd1 vccd1 sky130_fd_sc_hd__fill_1
X_7552_ _8110_/B _8103_/D vssd1 vssd1 vccd1 vccd1 _7553_/B sky130_fd_sc_hd__nand2_2
X_4764_ _4762_/X _4764_/B vssd1 vssd1 vccd1 vccd1 _4765_/B sky130_fd_sc_hd__and2b_2
X_7483_ _7483_/A _7483_/B vssd1 vssd1 vccd1 vccd1 _7485_/B sky130_fd_sc_hd__and2_2
X_6503_ _7140_/A _6892_/D _6894_/B _8126_/A vssd1 vssd1 vccd1 vccd1 _6504_/B sky130_fd_sc_hd__a22oi_2
X_6434_ _6434_/A _6434_/B vssd1 vssd1 vccd1 vccd1 _6444_/A sky130_fd_sc_hd__xnor2_2
X_4695_ _4695_/A _4695_/B vssd1 vssd1 vccd1 vccd1 _4695_/Y sky130_fd_sc_hd__nand2_2
X_6365_ _6365_/A _6365_/B vssd1 vssd1 vccd1 vccd1 _6367_/C sky130_fd_sc_hd__xor2_2
X_8104_ _8103_/A _8274_/A _8357_/Q _7754_/B vssd1 vssd1 vccd1 vccd1 _8105_/B sky130_fd_sc_hd__a22o_2
X_6296_ _6297_/B _6297_/A vssd1 vssd1 vccd1 vccd1 _6296_/X sky130_fd_sc_hd__and2b_2
X_5316_ _5317_/A _5315_/Y _8191_/A _5612_/B vssd1 vssd1 vccd1 vccd1 _5332_/A sky130_fd_sc_hd__and4bb_2
XFILLER_0_429 vssd1 vssd1 vccd1 vccd1 sky130_fd_sc_hd__fill_8
X_8035_ _8035_/A _8035_/B vssd1 vssd1 vccd1 vccd1 _8037_/B sky130_fd_sc_hd__xor2_2
X_5247_ _5246_/A _5286_/A vssd1 vssd1 vccd1 vccd1 _5249_/B sky130_fd_sc_hd__nand2b_2
XANTENNA__5843__A2 _5842_/B vssd1 vssd1 vccd1 vccd1 sky130_fd_sc_hd__diode_2
XFILLER_29_59 vssd1 vssd1 vccd1 vccd1 sky130_fd_sc_hd__fill_1
XFILLER_75_208 vssd1 vssd1 vccd1 vccd1 sky130_fd_sc_hd__fill_2
XFILLER_88_569 vssd1 vssd1 vccd1 vccd1 sky130_fd_sc_hd__fill_1
X_5178_ _5178_/A _5178_/B vssd1 vssd1 vccd1 vccd1 _5181_/A sky130_fd_sc_hd__xor2_2
XTAP_TAPCELL_ROW_3_234 vssd1 vccd1 sky130_fd_sc_hd__tapvpwrvgnd_1
XANTENNA_fanout271_X _6433_/A vssd1 vssd1 vccd1 vccd1 sky130_fd_sc_hd__diode_2
XFILLER_28_179 vssd1 vssd1 vccd1 vccd1 sky130_fd_sc_hd__fill_1
XFILLER_45_25 vssd1 vssd1 vccd1 vccd1 sky130_fd_sc_hd__fill_2
XFILLER_56_477 vssd1 vssd1 vccd1 vccd1 sky130_fd_sc_hd__fill_1
XFILLER_56_499 vssd1 vssd1 vccd1 vccd1 sky130_fd_sc_hd__fill_1
XFILLER_71_447 vssd1 vssd1 vccd1 vccd1 sky130_fd_sc_hd__fill_1
XFILLER_24_363 vssd1 vssd1 vccd1 vccd1 sky130_fd_sc_hd__fill_1
XFILLER_51_182 vssd1 vssd1 vccd1 vccd1 sky130_fd_sc_hd__fill_1
X_7819_ _7820_/A _7685_/B _7820_/B _7685_/A vssd1 vssd1 vccd1 vccd1 _7819_/X sky130_fd_sc_hd__a22o_2
XFILLER_12_547 vssd1 vssd1 vccd1 vccd1 sky130_fd_sc_hd__fill_1
XFILLER_79_503 vssd1 vssd1 vccd1 vccd1 sky130_fd_sc_hd__fill_1
XFILLER_79_525 vssd1 vssd1 vccd1 vccd1 sky130_fd_sc_hd__fill_8
XANTENNA__6906__B _7723_/C vssd1 vssd1 vccd1 vccd1 sky130_fd_sc_hd__diode_2
XFILLER_47_411 vssd1 vssd1 vccd1 vccd1 sky130_fd_sc_hd__fill_1
XANTENNA__4707__A _8422_/D vssd1 vssd1 vccd1 vccd1 sky130_fd_sc_hd__diode_2
XFILLER_74_274 vssd1 vssd1 vccd1 vccd1 sky130_fd_sc_hd__fill_4
XTAP_TAPCELL_ROW_73_932 vssd1 vccd1 sky130_fd_sc_hd__tapvpwrvgnd_1
XTAP_TAPCELL_ROW_17_369 vssd1 vccd1 sky130_fd_sc_hd__tapvpwrvgnd_1
XANTENNA__7737__B _7875_/D vssd1 vssd1 vccd1 vccd1 sky130_fd_sc_hd__diode_2
XFILLER_89_6 vssd1 vssd1 vccd1 vccd1 sky130_fd_sc_hd__fill_4
Xhold518 _8386_/Q vssd1 vssd1 vccd1 vccd1 _8445_/D sky130_fd_sc_hd__dlygate4sd3_1
X_4480_ _4480_/A _4480_/B vssd1 vssd1 vccd1 vccd1 _4504_/A sky130_fd_sc_hd__xor2_2
Xhold529 _8389_/Q vssd1 vssd1 vccd1 vccd1 _8448_/D sky130_fd_sc_hd__dlygate4sd3_1
X_6150_ _6150_/A _6150_/B vssd1 vssd1 vccd1 vccd1 _6151_/B sky130_fd_sc_hd__xnor2_2
X_5101_ _5082_/X _5083_/Y _5090_/Y _5097_/X vssd1 vssd1 vccd1 vccd1 _5102_/C sky130_fd_sc_hd__o211ai_2
X_6081_ _7658_/S _6081_/B vssd1 vssd1 vccd1 vccd1 _6081_/Y sky130_fd_sc_hd__nor2_2
X_5032_ _5033_/A _5033_/B vssd1 vssd1 vccd1 vccd1 _5032_/Y sky130_fd_sc_hd__nand2_2
XFILLER_25_105 vssd1 vssd1 vccd1 vccd1 sky130_fd_sc_hd__fill_1
XFILLER_38_477 vssd1 vssd1 vccd1 vccd1 sky130_fd_sc_hd__fill_4
XTAP_TAPCELL_ROW_0_204 vssd1 vccd1 sky130_fd_sc_hd__tapvpwrvgnd_1
XFILLER_65_285 vssd1 vssd1 vccd1 vccd1 sky130_fd_sc_hd__fill_2
XFILLER_65_296 vssd1 vssd1 vccd1 vccd1 sky130_fd_sc_hd__fill_2
X_6983_ _6983_/A _6983_/B vssd1 vssd1 vccd1 vccd1 _7030_/A sky130_fd_sc_hd__xnor2_2
XTAP_TAPCELL_ROW_84_1039 vssd1 vccd1 sky130_fd_sc_hd__tapvpwrvgnd_1
XANTENNA__6832__A _6832_/A vssd1 vssd1 vccd1 vccd1 sky130_fd_sc_hd__diode_2
X_5934_ _5934_/A _5934_/B vssd1 vssd1 vccd1 vccd1 _5935_/B sky130_fd_sc_hd__nor2_2
X_5865_ _5863_/X _5865_/B vssd1 vssd1 vccd1 vccd1 _5867_/A sky130_fd_sc_hd__and2b_2
XANTENNA_fanout231_A _8371_/Q vssd1 vssd1 vccd1 vccd1 sky130_fd_sc_hd__diode_2
X_7604_ _7605_/A _7605_/B vssd1 vssd1 vccd1 vccd1 _7673_/B sky130_fd_sc_hd__nand2_2
X_4816_ _4902_/A _4897_/B _4816_/C _4816_/D vssd1 vssd1 vccd1 vccd1 _4819_/A sky130_fd_sc_hd__nand4_2
X_5796_ _5907_/B _5796_/B vssd1 vssd1 vccd1 vccd1 _5798_/A sky130_fd_sc_hd__nand2_2
X_7535_ _8016_/A _7875_/B _8133_/C _7864_/B vssd1 vssd1 vccd1 vccd1 _7537_/A sky130_fd_sc_hd__and4_2
X_4747_ _5020_/A wire92/X vssd1 vssd1 vccd1 vccd1 _4749_/B sky130_fd_sc_hd__nand2_2
X_7466_ _8103_/A _7875_/C _7875_/D _7754_/B vssd1 vssd1 vccd1 vccd1 _7467_/B sky130_fd_sc_hd__a22oi_2
X_4678_ _4679_/A _4679_/B vssd1 vssd1 vccd1 vccd1 _4680_/A sky130_fd_sc_hd__or2_4
X_7397_ _7397_/A _7397_/B vssd1 vssd1 vccd1 vccd1 _7414_/A sky130_fd_sc_hd__xnor2_2
X_6417_ _7233_/A _6894_/B vssd1 vssd1 vccd1 vccd1 _6418_/B sky130_fd_sc_hd__nand2_2
Xoutput27 _8326_/Q vssd1 vssd1 vccd1 vccd1 gpio_out[24] sky130_fd_sc_hd__clkdlybuf4s25_1
X_6348_ _6348_/A _6651_/A vssd1 vssd1 vccd1 vccd1 _6656_/A sky130_fd_sc_hd__or2_2
XFILLER_76_506 vssd1 vssd1 vccd1 vccd1 sky130_fd_sc_hd__fill_8
X_6279_ _6280_/A _6280_/B vssd1 vssd1 vccd1 vccd1 _6279_/X sky130_fd_sc_hd__and2_2
XANTENNA__6726__B _7095_/B vssd1 vssd1 vccd1 vccd1 sky130_fd_sc_hd__diode_2
X_8018_ _8125_/A _8126_/B vssd1 vssd1 vccd1 vccd1 _8019_/B sky130_fd_sc_hd__nand2_2
XFILLER_29_499 vssd1 vssd1 vccd1 vccd1 sky130_fd_sc_hd__fill_4
XFILLER_71_211 vssd1 vssd1 vccd1 vccd1 sky130_fd_sc_hd__fill_2
XTAP_TAPCELL_ROW_70_902 vssd1 vccd1 sky130_fd_sc_hd__tapvpwrvgnd_1
XANTENNA__7557__B _8126_/B vssd1 vssd1 vccd1 vccd1 sky130_fd_sc_hd__diode_2
XFILLER_71_288 vssd1 vssd1 vccd1 vccd1 sky130_fd_sc_hd__fill_1
XANTENNA__5358__A _8202_/A vssd1 vssd1 vccd1 vccd1 sky130_fd_sc_hd__diode_2
XTAP_TAPCELL_ROW_14_339 vssd1 vccd1 sky130_fd_sc_hd__tapvpwrvgnd_1
XANTENNA__7723__D _7723_/D vssd1 vssd1 vccd1 vccd1 sky130_fd_sc_hd__diode_2
XFILLER_79_377 vssd1 vssd1 vccd1 vccd1 sky130_fd_sc_hd__fill_8
XANTENNA__8206__A0 _8202_/A vssd1 vssd1 vccd1 vccd1 sky130_fd_sc_hd__diode_2
XFILLER_75_561 vssd1 vssd1 vccd1 vccd1 sky130_fd_sc_hd__fill_1
XANTENNA__4156__B _4160_/B vssd1 vssd1 vccd1 vccd1 sky130_fd_sc_hd__diode_2
XTAP_TAPCELL_ROW_58_781 vssd1 vccd1 sky130_fd_sc_hd__tapvpwrvgnd_1
XFILLER_35_469 vssd1 vssd1 vccd1 vccd1 sky130_fd_sc_hd__fill_1
XFILLER_46_90 vssd1 vssd1 vccd1 vccd1 sky130_fd_sc_hd__fill_2
Xmax_cap80 _8050_/B vssd1 vssd1 vccd1 vccd1 _7913_/A sky130_fd_sc_hd__buf_1
XFILLER_15_160 vssd1 vssd1 vccd1 vccd1 sky130_fd_sc_hd__fill_1
Xclkbuf_0_clk clk vssd1 vssd1 vccd1 vccd1 clkbuf_0_clk/X sky130_fd_sc_hd__clkbuf_16
X_5650_ _8165_/A _5612_/B _5671_/D vssd1 vssd1 vccd1 vccd1 _5651_/B sky130_fd_sc_hd__a21o_2
XFILLER_30_163 vssd1 vssd1 vccd1 vccd1 sky130_fd_sc_hd__fill_4
XFILLER_87_3 vssd1 vssd1 vccd1 vccd1 sky130_fd_sc_hd__fill_2
X_4601_ _4562_/Y _4600_/Y _4607_/A vssd1 vssd1 vccd1 vccd1 _4622_/A sky130_fd_sc_hd__a21o_2
X_5581_ _5842_/B _5594_/B _5579_/C vssd1 vssd1 vccd1 vccd1 _5582_/B sky130_fd_sc_hd__a21o_2
X_7320_ _7320_/A _7320_/B vssd1 vssd1 vccd1 vccd1 _7322_/A sky130_fd_sc_hd__nor2_2
X_4532_ _4534_/A _4580_/A vssd1 vssd1 vccd1 vccd1 _4532_/Y sky130_fd_sc_hd__nor2_2
X_7251_ _7251_/A _7251_/B vssd1 vssd1 vccd1 vccd1 _7253_/A sky130_fd_sc_hd__nor2_2
X_4463_ _4464_/A _4464_/B vssd1 vssd1 vccd1 vccd1 _4463_/Y sky130_fd_sc_hd__nand2_2
X_6202_ _6401_/B _6202_/B vssd1 vssd1 vccd1 vccd1 _6204_/B sky130_fd_sc_hd__nor2_2
X_7182_ _7183_/A _7183_/B _7183_/C vssd1 vssd1 vccd1 vccd1 _7284_/A sky130_fd_sc_hd__a21oi_2
X_4394_ _4506_/A _4394_/B vssd1 vssd1 vccd1 vccd1 _4396_/B sky130_fd_sc_hd__or2_4
XPHY_EDGE_ROW_15_Right_15 vssd1 vssd1 vccd1 vccd1 sky130_fd_sc_hd__decap_3
X_6133_ _5970_/A _5970_/B _5968_/X vssd1 vssd1 vccd1 vccd1 _6134_/B sky130_fd_sc_hd__a21oi_2
X_6064_ _5868_/A _5869_/A _6062_/Y _6063_/Y vssd1 vssd1 vccd1 vccd1 _6274_/A sky130_fd_sc_hd__o211a_2
XTAP_TAPCELL_ROW_90_1098 vssd1 vccd1 sky130_fd_sc_hd__tapvpwrvgnd_1
XFILLER_73_509 vssd1 vssd1 vccd1 vccd1 sky130_fd_sc_hd__fill_2
X_5015_ _8425_/D _6572_/B vssd1 vssd1 vccd1 vccd1 _5016_/B sky130_fd_sc_hd__nand2_2
XANTENNA_fanout181_A _6712_/A vssd1 vssd1 vccd1 vccd1 sky130_fd_sc_hd__diode_2
XFILLER_26_27 vssd1 vssd1 vccd1 vccd1 sky130_fd_sc_hd__fill_1
X_6966_ _6966_/A _6966_/B vssd1 vssd1 vccd1 vccd1 _7034_/A sky130_fd_sc_hd__nand2_2
XPHY_EDGE_ROW_24_Right_24 vssd1 vssd1 vccd1 vccd1 sky130_fd_sc_hd__decap_3
X_5917_ _5917_/A _5917_/B vssd1 vssd1 vccd1 vccd1 _5920_/A sky130_fd_sc_hd__xnor2_2
X_6897_ _6897_/A _6897_/B vssd1 vssd1 vccd1 vccd1 _6898_/B sky130_fd_sc_hd__or2_2
XFILLER_42_37 vssd1 vssd1 vccd1 vccd1 sky130_fd_sc_hd__fill_1
XFILLER_42_48 vssd1 vssd1 vccd1 vccd1 sky130_fd_sc_hd__fill_1
X_5848_ _5849_/B _5849_/A vssd1 vssd1 vccd1 vccd1 _5848_/X sky130_fd_sc_hd__and2b_2
XTAP_TAPCELL_ROW_11_309 vssd1 vccd1 sky130_fd_sc_hd__tapvpwrvgnd_1
X_5779_ _5779_/A _5779_/B vssd1 vssd1 vccd1 vccd1 _5800_/A sky130_fd_sc_hd__xor2_2
X_7518_ _8032_/A _7853_/A vssd1 vssd1 vccd1 vccd1 _7519_/B sky130_fd_sc_hd__nand2_2
Xrebuffer456 _4638_/X vssd1 vssd1 vccd1 vccd1 _4664_/B sky130_fd_sc_hd__buf_2
Xrebuffer445 _4373_/B vssd1 vssd1 vccd1 vccd1 _4386_/B sky130_fd_sc_hd__buf_2
Xrebuffer489 _7940_/A1 vssd1 vssd1 vccd1 vccd1 _7799_/A sky130_fd_sc_hd__buf_2
Xrebuffer478 _5200_/A vssd1 vssd1 vccd1 vccd1 _5201_/A1 sky130_fd_sc_hd__buf_2
Xrebuffer467 _4644_/B vssd1 vssd1 vccd1 vccd1 _4635_/A2 sky130_fd_sc_hd__buf_2
XANTENNA__8001__B _8103_/D vssd1 vssd1 vccd1 vccd1 sky130_fd_sc_hd__diode_2
X_7449_ _8125_/A _7864_/B vssd1 vssd1 vccd1 vccd1 _7450_/B sky130_fd_sc_hd__nand2_2
XPHY_EDGE_ROW_33_Right_33 vssd1 vssd1 vccd1 vccd1 sky130_fd_sc_hd__decap_3
XFILLER_88_141 vssd1 vssd1 vccd1 vccd1 sky130_fd_sc_hd__fill_1
XFILLER_76_314 vssd1 vssd1 vccd1 vccd1 sky130_fd_sc_hd__fill_2
XFILLER_88_185 vssd1 vssd1 vccd1 vccd1 sky130_fd_sc_hd__fill_1
XPHY_EDGE_ROW_42_Right_42 vssd1 vssd1 vccd1 vccd1 sky130_fd_sc_hd__decap_3
XFILLER_17_447 vssd1 vssd1 vccd1 vccd1 sky130_fd_sc_hd__fill_1
XFILLER_72_542 vssd1 vccd1 vssd1 vccd1 sky130_ef_sc_hd__decap_40_12
XTAP_TAPCELL_ROW_55_751 vssd1 vccd1 sky130_fd_sc_hd__tapvpwrvgnd_1
XTAP_TAPCELL_ROW_27_475 vssd1 vccd1 sky130_fd_sc_hd__tapvpwrvgnd_1
XFILLER_12_141 vssd1 vssd1 vccd1 vccd1 sky130_fd_sc_hd__fill_1
XANTENNA__5725__A1 _6572_/A vssd1 vssd1 vccd1 vccd1 sky130_fd_sc_hd__diode_2
XANTENNA__5725__B2 _6712_/A vssd1 vssd1 vccd1 vccd1 sky130_fd_sc_hd__diode_2
XFILLER_12_174 vssd1 vssd1 vccd1 vccd1 sky130_fd_sc_hd__fill_1
XANTENNA__5816__A _6207_/A vssd1 vssd1 vccd1 vccd1 sky130_fd_sc_hd__diode_2
XANTENNA__7734__C _7864_/B vssd1 vssd1 vccd1 vccd1 sky130_fd_sc_hd__diode_2
XPHY_EDGE_ROW_51_Right_51 vssd1 vssd1 vccd1 vccd1 sky130_fd_sc_hd__decap_3
XFILLER_4_373 vssd1 vssd1 vccd1 vccd1 sky130_fd_sc_hd__fill_1
XFILLER_79_163 vssd1 vssd1 vccd1 vccd1 sky130_fd_sc_hd__fill_1
XANTENNA__5270__B _5899_/B vssd1 vssd1 vccd1 vccd1 sky130_fd_sc_hd__diode_2
XPHY_EDGE_ROW_60_Right_60 vssd1 vssd1 vccd1 vccd1 sky130_fd_sc_hd__decap_3
XFILLER_63_531 vssd1 vssd1 vccd1 vccd1 sky130_fd_sc_hd__fill_1
XFILLER_75_391 vssd1 vssd1 vccd1 vccd1 sky130_fd_sc_hd__fill_1
XANTENNA__4216__A1 input9/X vssd1 vssd1 vccd1 vccd1 sky130_fd_sc_hd__diode_2
X_6820_ _6821_/A _6821_/B vssd1 vssd1 vccd1 vccd1 _6934_/A sky130_fd_sc_hd__nand2b_2
XTAP_TAPCELL_ROW_81_1009 vssd1 vccd1 sky130_fd_sc_hd__tapvpwrvgnd_1
X_6751_ _6752_/A _6752_/B vssd1 vssd1 vccd1 vccd1 _7019_/B sky130_fd_sc_hd__nor2_2
X_6682_ _6394_/A _6394_/B _6390_/X vssd1 vssd1 vccd1 vccd1 _6683_/B sky130_fd_sc_hd__a21o_2
X_5702_ _5710_/A _5953_/B _5165_/B _6114_/A _4972_/B vssd1 vssd1 vccd1 vccd1 _5702_/X
+ sky130_fd_sc_hd__a32o_2
X_8421_ clkload5/A _8421_/D wire364/X vssd1 vssd1 vccd1 vccd1 _8421_/Q sky130_fd_sc_hd__dfrtp_2
X_5633_ _5640_/A _5633_/B vssd1 vssd1 vccd1 vccd1 _5641_/A sky130_fd_sc_hd__or2_2
X_8352_ _8405_/CLK _8352_/D fanout378/X vssd1 vssd1 vccd1 vccd1 _8352_/Q sky130_fd_sc_hd__dfrtp_2
X_5564_ _5564_/A _5564_/B vssd1 vssd1 vccd1 vccd1 _5566_/B sky130_fd_sc_hd__nor2_2
X_7303_ _7303_/A _7303_/B vssd1 vssd1 vccd1 vccd1 _7305_/A sky130_fd_sc_hd__xor2_2
X_4515_ _4515_/A _4515_/B vssd1 vssd1 vccd1 vccd1 _4541_/A sky130_fd_sc_hd__xnor2_2
XANTENNA__8130__A2 _8257_/A vssd1 vssd1 vccd1 vccd1 sky130_fd_sc_hd__diode_2
X_8283_ _8285_/B _8283_/B vssd1 vssd1 vccd1 vccd1 _8360_/D sky130_fd_sc_hd__nor2_2
X_5495_ _5495_/A _5495_/B _5540_/A vssd1 vssd1 vccd1 vccd1 _5505_/A sky130_fd_sc_hd__or3_2
XTAP_TAPCELL_ROW_92_1116 vssd1 vccd1 sky130_fd_sc_hd__tapvpwrvgnd_1
X_7234_ _7234_/A _7234_/B vssd1 vssd1 vccd1 vccd1 _7236_/B sky130_fd_sc_hd__xnor2_2
X_4446_ _4549_/B _4549_/A vssd1 vssd1 vccd1 vccd1 _4447_/B sky130_fd_sc_hd__nand2b_2
XTAP_TAPCELL_ROW_92_1127 vssd1 vccd1 sky130_fd_sc_hd__tapvpwrvgnd_1
X_7165_ _7166_/B _7166_/A vssd1 vssd1 vccd1 vccd1 _7264_/A sky130_fd_sc_hd__and2b_2
X_4377_ _4379_/B vssd1 vssd1 vccd1 vccd1 _4378_/B sky130_fd_sc_hd__inv_2
X_6116_ _5703_/A _4770_/B _6114_/Y vssd1 vssd1 vccd1 vccd1 _6117_/B sky130_fd_sc_hd__o21ai_2
XFILLER_58_325 vssd1 vssd1 vccd1 vccd1 sky130_fd_sc_hd__fill_1
XFILLER_58_336 vssd1 vssd1 vccd1 vccd1 sky130_fd_sc_hd__fill_1
X_7096_ _7603_/A _8081_/B vssd1 vssd1 vccd1 vccd1 _7097_/B sky130_fd_sc_hd__nor2_2
XANTENNA_fanout184_X _6572_/A vssd1 vssd1 vccd1 vccd1 sky130_fd_sc_hd__diode_2
XFILLER_39_561 vssd1 vssd1 vccd1 vccd1 sky130_fd_sc_hd__fill_8
XFILLER_85_166 vssd1 vssd1 vccd1 vccd1 sky130_fd_sc_hd__fill_2
X_6047_ _6047_/A _6047_/B _6047_/C vssd1 vssd1 vccd1 vccd1 _6047_/Y sky130_fd_sc_hd__nand3_2
XTAP_TAPCELL_ROW_69_887 vssd1 vccd1 sky130_fd_sc_hd__tapvpwrvgnd_1
XFILLER_85_199 vssd1 vssd1 vccd1 vccd1 sky130_fd_sc_hd__fill_8
XANTENNA__6292__A _6712_/A vssd1 vssd1 vccd1 vccd1 sky130_fd_sc_hd__diode_2
XFILLER_26_288 vssd1 vssd1 vccd1 vccd1 sky130_fd_sc_hd__fill_1
XFILLER_53_14 vssd1 vssd1 vccd1 vccd1 sky130_fd_sc_hd__fill_2
X_7998_ _7998_/A _7998_/B _8271_/A vssd1 vssd1 vccd1 vccd1 _7999_/B sky130_fd_sc_hd__and3_2
XANTENNA__4524__B _4761_/A vssd1 vssd1 vccd1 vccd1 sky130_fd_sc_hd__diode_2
X_6949_ _6949_/A _6949_/B vssd1 vssd1 vccd1 vccd1 _6950_/C sky130_fd_sc_hd__xnor2_2
XTAP_TAPCELL_ROW_52_721 vssd1 vccd1 sky130_fd_sc_hd__tapvpwrvgnd_1
XTAP_TAPCELL_ROW_24_445 vssd1 vccd1 sky130_fd_sc_hd__tapvpwrvgnd_1
XANTENNA__6904__B1 _7140_/C vssd1 vssd1 vccd1 vccd1 sky130_fd_sc_hd__diode_2
XANTENNA__7554__C _7875_/D vssd1 vssd1 vccd1 vccd1 sky130_fd_sc_hd__diode_2
XFILLER_5_137 vssd1 vssd1 vccd1 vccd1 sky130_fd_sc_hd__fill_4
XFILLER_78_33 vssd1 vssd1 vccd1 vccd1 sky130_fd_sc_hd__fill_2
XANTENNA_fanout97_X _5147_/B vssd1 vssd1 vccd1 vccd1 sky130_fd_sc_hd__diode_2
XFILLER_78_77 vssd1 vssd1 vccd1 vccd1 sky130_fd_sc_hd__fill_2
XFILLER_89_461 vssd1 vssd1 vccd1 vccd1 sky130_fd_sc_hd__fill_4
XFILLER_89_483 vssd1 vssd1 vccd1 vccd1 sky130_fd_sc_hd__fill_1
XFILLER_45_520 vssd1 vssd1 vccd1 vccd1 sky130_fd_sc_hd__fill_1
XANTENNA__6199__A1 _6198_/A vssd1 vssd1 vccd1 vccd1 sky130_fd_sc_hd__diode_2
XFILLER_27_70 vssd1 vssd1 vccd1 vccd1 sky130_fd_sc_hd__fill_2
XFILLER_57_391 vssd1 vssd1 vccd1 vccd1 sky130_fd_sc_hd__fill_1
XFILLER_91_169 vssd1 vssd1 vccd1 vccd1 sky130_fd_sc_hd__fill_2
XFILLER_60_512 vssd1 vssd1 vccd1 vccd1 sky130_fd_sc_hd__fill_8
XFILLER_17_299 vssd1 vssd1 vccd1 vccd1 sky130_fd_sc_hd__fill_1
XFILLER_64_5 vssd1 vssd1 vccd1 vccd1 sky130_fd_sc_hd__fill_1
X_5280_ _5264_/A _5263_/B _5263_/C vssd1 vssd1 vccd1 vccd1 _5280_/X sky130_fd_sc_hd__a21o_2
X_4300_ _4979_/B _4979_/C vssd1 vssd1 vccd1 vccd1 _5954_/B sky130_fd_sc_hd__and2_2
XANTENNA_wire364_A wire364/A vssd1 vssd1 vccd1 vccd1 sky130_fd_sc_hd__diode_2
X_4231_ _4262_/B _4231_/B vssd1 vssd1 vccd1 vccd1 _4314_/A sky130_fd_sc_hd__nand2_2
XFILLER_4_85 vssd1 vssd1 vccd1 vccd1 sky130_fd_sc_hd__fill_1
XANTENNA__4168__Y _4674_/A vssd1 vssd1 vccd1 vccd1 sky130_fd_sc_hd__diode_2
X_4162_ _4311_/A vssd1 vssd1 vccd1 vccd1 _4162_/Y sky130_fd_sc_hd__inv_2
XFILLER_67_166 vssd1 vssd1 vccd1 vccd1 sky130_fd_sc_hd__fill_2
XFILLER_55_339 vssd1 vssd1 vccd1 vccd1 sky130_fd_sc_hd__fill_1
XFILLER_82_125 vssd1 vssd1 vccd1 vccd1 sky130_fd_sc_hd__fill_2
X_7921_ _8055_/A _7921_/B _7921_/C vssd1 vssd1 vccd1 vccd1 _8055_/B sky130_fd_sc_hd__nand3_2
XFILLER_36_531 vssd1 vssd1 vccd1 vccd1 sky130_fd_sc_hd__fill_1
XFILLER_70_309 vssd1 vssd1 vccd1 vccd1 sky130_fd_sc_hd__fill_2
XFILLER_82_158 vssd1 vssd1 vccd1 vccd1 sky130_fd_sc_hd__fill_2
XTAP_TAPCELL_ROW_66_857 vssd1 vccd1 sky130_fd_sc_hd__tapvpwrvgnd_1
XANTENNA__7387__B1 _8082_/D vssd1 vssd1 vccd1 vccd1 sky130_fd_sc_hd__diode_2
XFILLER_63_350 vssd1 vssd1 vccd1 vccd1 sky130_fd_sc_hd__fill_4
X_7852_ _7855_/D vssd1 vssd1 vccd1 vccd1 _7852_/Y sky130_fd_sc_hd__inv_2
XFILLER_23_225 vssd1 vssd1 vccd1 vccd1 sky130_fd_sc_hd__fill_1
X_7783_ _7783_/A _7783_/B vssd1 vssd1 vccd1 vccd1 _7785_/C sky130_fd_sc_hd__or2_2
X_6803_ _7129_/A _7210_/A _6892_/C _6892_/B vssd1 vssd1 vccd1 vccd1 _6805_/A sky130_fd_sc_hd__a22oi_2
X_4995_ _4924_/A _4924_/B _4922_/Y vssd1 vssd1 vccd1 vccd1 _5003_/A sky130_fd_sc_hd__o21a_2
X_6734_ _6734_/A _6734_/B vssd1 vssd1 vccd1 vccd1 _6736_/B sky130_fd_sc_hd__xor2_2
XFILLER_23_39 vssd1 vssd1 vccd1 vccd1 sky130_fd_sc_hd__fill_1
XTAP_TAPCELL_ROW_21_415 vssd1 vccd1 sky130_fd_sc_hd__tapvpwrvgnd_1
X_8404_ clkload9/A _8404_/D fanout378/X vssd1 vssd1 vccd1 vccd1 _8404_/Q sky130_fd_sc_hd__dfrtp_2
X_6665_ _6359_/Y _6365_/B _6357_/X vssd1 vssd1 vccd1 vccd1 _6667_/B sky130_fd_sc_hd__o21bai_2
XANTENNA_fanout311_A _8346_/Q vssd1 vssd1 vccd1 vccd1 sky130_fd_sc_hd__diode_2
X_6596_ _6596_/A _6596_/B vssd1 vssd1 vccd1 vccd1 _6599_/A sky130_fd_sc_hd__nand2_2
X_5616_ _5556_/A _5558_/B _5556_/B vssd1 vssd1 vccd1 vccd1 _5617_/B sky130_fd_sc_hd__o21ba_2
X_8335_ _8382_/CLK _8335_/D load_slew370/X vssd1 vssd1 vccd1 vccd1 _8335_/Q sky130_fd_sc_hd__dfrtp_2
X_5547_ _5540_/A _5540_/C _5540_/B vssd1 vssd1 vccd1 vccd1 _5548_/C sky130_fd_sc_hd__a21oi_2
X_8266_ _8266_/A _8267_/C vssd1 vssd1 vccd1 vccd1 _8353_/D sky130_fd_sc_hd__xor2_2
X_5478_ _5559_/B _5555_/A _5521_/C _5559_/C vssd1 vssd1 vccd1 vccd1 _5487_/B sky130_fd_sc_hd__and4_2
X_7217_ _7217_/A _7217_/B vssd1 vssd1 vccd1 vccd1 _7224_/A sky130_fd_sc_hd__xnor2_2
X_4429_ _4709_/B _4430_/B vssd1 vssd1 vccd1 vccd1 _4534_/A sky130_fd_sc_hd__nand2_2
X_8197_ _8197_/A _8197_/B vssd1 vssd1 vccd1 vccd1 _8199_/A sky130_fd_sc_hd__nand2_2
XANTENNA__4519__B _4686_/B vssd1 vssd1 vccd1 vccd1 sky130_fd_sc_hd__diode_2
X_7148_ _7148_/A _7148_/B vssd1 vssd1 vccd1 vccd1 _7149_/C sky130_fd_sc_hd__xnor2_2
X_7079_ _7001_/A _7001_/B _6999_/Y vssd1 vssd1 vccd1 vccd1 _7087_/A sky130_fd_sc_hd__o21ai_2
XFILLER_58_199 vssd1 vssd1 vccd1 vccd1 sky130_fd_sc_hd__fill_1
XFILLER_73_136 vssd1 vssd1 vccd1 vccd1 sky130_fd_sc_hd__fill_2
XFILLER_73_169 vssd1 vssd1 vccd1 vccd1 sky130_fd_sc_hd__fill_1
XTAP_TAPCELL_ROW_37_570 vssd1 vccd1 sky130_fd_sc_hd__tapvpwrvgnd_1
Xfanout73 _4733_/X vssd1 vssd1 vccd1 vccd1 _5899_/B sky130_fd_sc_hd__clkdlybuf4s25_1
Xfanout51 _5040_/X vssd1 vssd1 vccd1 vccd1 _5915_/B sky130_fd_sc_hd__clkbuf_2
XANTENNA__5366__A _8220_/A vssd1 vssd1 vccd1 vccd1 sky130_fd_sc_hd__diode_2
XFILLER_22_280 vssd1 vssd1 vccd1 vccd1 sky130_fd_sc_hd__fill_1
Xfanout95 _4275_/X vssd1 vssd1 vccd1 vccd1 _4432_/B sky130_fd_sc_hd__clkdlybuf4s25_1
Xfanout84 _4743_/X vssd1 vssd1 vccd1 vccd1 _4897_/B sky130_fd_sc_hd__clkdlybuf4s25_1
XTAP_TAPCELL_ROW_9_295 vssd1 vccd1 sky130_fd_sc_hd__tapvpwrvgnd_1
XANTENNA__6925__A _8001_/A vssd1 vssd1 vccd1 vccd1 sky130_fd_sc_hd__diode_2
XFILLER_92_434 vssd1 vssd1 vccd1 vccd1 sky130_fd_sc_hd__fill_1
XANTENNA__6644__B wire72/X vssd1 vssd1 vccd1 vccd1 sky130_fd_sc_hd__diode_2
XFILLER_52_309 vssd1 vssd1 vccd1 vccd1 sky130_fd_sc_hd__fill_2
XTAP_TAPCELL_ROW_63_827 vssd1 vccd1 sky130_fd_sc_hd__tapvpwrvgnd_1
XANTENNA__4164__B _4227_/S vssd1 vssd1 vccd1 vccd1 sky130_fd_sc_hd__diode_2
XANTENNA__7756__A _8001_/A vssd1 vssd1 vccd1 vccd1 sky130_fd_sc_hd__diode_2
XFILLER_33_567 vssd1 vssd1 vccd1 vccd1 sky130_fd_sc_hd__fill_1
X_4780_ _4780_/A _4780_/B vssd1 vssd1 vccd1 vccd1 _4838_/A sky130_fd_sc_hd__nand2_2
XFILLER_20_206 vssd1 vssd1 vccd1 vccd1 sky130_fd_sc_hd__fill_1
Xclkload10 _8382_/CLK vssd1 vssd1 vccd1 vccd1 clkload10/X sky130_fd_sc_hd__clkbuf_4
X_6450_ _6450_/A _6450_/B vssd1 vssd1 vccd1 vccd1 _6451_/C sky130_fd_sc_hd__xnor2_2
X_6381_ _6185_/A _6184_/B _6184_/A vssd1 vssd1 vccd1 vccd1 _6383_/B sky130_fd_sc_hd__o21ba_2
X_5401_ _8215_/A _5838_/A _8220_/A _5670_/B vssd1 vssd1 vccd1 vccd1 _5403_/A sky130_fd_sc_hd__and4_2
XANTENNA__8097__A1 _7990_/A vssd1 vssd1 vccd1 vccd1 sky130_fd_sc_hd__diode_2
X_8120_ _6832_/A _8360_/Q _7996_/A _7994_/B vssd1 vssd1 vccd1 vccd1 _8122_/A sky130_fd_sc_hd__a31o_2
X_5332_ _5332_/A _5332_/B vssd1 vssd1 vccd1 vccd1 _5342_/A sky130_fd_sc_hd__nor2_2
X_8051_ _8051_/A _8051_/B _8051_/C vssd1 vssd1 vccd1 vccd1 _8053_/A sky130_fd_sc_hd__and3_2
X_5263_ _5264_/A _5263_/B _5263_/C vssd1 vssd1 vccd1 vccd1 _5264_/B sky130_fd_sc_hd__nand3_2
XANTENNA__4339__B _4700_/B vssd1 vssd1 vccd1 vccd1 sky130_fd_sc_hd__diode_2
XFILLER_68_431 vssd1 vssd1 vccd1 vccd1 sky130_fd_sc_hd__fill_1
XFILLER_87_239 vssd1 vssd1 vccd1 vccd1 sky130_fd_sc_hd__fill_4
X_7002_ _8418_/D wire59/X vssd1 vssd1 vccd1 vccd1 _7002_/Y sky130_fd_sc_hd__nand2_2
X_5194_ _5194_/A _5194_/B vssd1 vssd1 vccd1 vccd1 _5194_/X sky130_fd_sc_hd__and2_4
X_4214_ _4218_/S _8419_/Q _4213_/Y vssd1 vssd1 vccd1 vccd1 _7954_/A sky130_fd_sc_hd__o21ai_2
XFILLER_18_17 vssd1 vssd1 vccd1 vccd1 sky130_fd_sc_hd__fill_4
X_4145_ input19/X _4207_/B vssd1 vssd1 vccd1 vccd1 _4145_/Y sky130_fd_sc_hd__nand2b_2
XFILLER_68_497 vssd1 vssd1 vccd1 vccd1 sky130_fd_sc_hd__fill_2
XTAP_TAPCELL_ROW_79_993 vssd1 vccd1 sky130_fd_sc_hd__tapvpwrvgnd_1
XANTENNA_fanout261_A _6830_/A vssd1 vssd1 vccd1 vccd1 sky130_fd_sc_hd__diode_2
XANTENNA_fanout359_A wire362/A vssd1 vssd1 vccd1 vccd1 sky130_fd_sc_hd__diode_2
XFILLER_55_169 vssd1 vccd1 vssd1 vccd1 sky130_ef_sc_hd__decap_40_12
X_7904_ _7904_/A _7904_/B vssd1 vssd1 vccd1 vccd1 _7906_/C sky130_fd_sc_hd__or2_2
XFILLER_24_545 vssd1 vssd1 vccd1 vccd1 sky130_fd_sc_hd__fill_1
XFILLER_51_320 vssd1 vssd1 vccd1 vccd1 sky130_fd_sc_hd__fill_2
XFILLER_70_139 vssd1 vssd1 vccd1 vccd1 sky130_fd_sc_hd__fill_1
X_7835_ _7835_/A _7835_/B vssd1 vssd1 vccd1 vccd1 _7836_/B sky130_fd_sc_hd__nor2_2
XANTENNA__5885__S _8071_/S vssd1 vssd1 vccd1 vccd1 sky130_fd_sc_hd__diode_2
XFILLER_24_567 vssd1 vssd1 vccd1 vccd1 sky130_fd_sc_hd__fill_2
XTAP_TAPCELL_ROW_34_540 vssd1 vccd1 sky130_fd_sc_hd__tapvpwrvgnd_1
XANTENNA__7385__B _8082_/D vssd1 vssd1 vccd1 vccd1 sky130_fd_sc_hd__diode_2
X_7766_ _7917_/A _7766_/B vssd1 vssd1 vccd1 vccd1 _7766_/Y sky130_fd_sc_hd__nand2_2
X_4978_ _4978_/A _4978_/B vssd1 vssd1 vccd1 vccd1 _4985_/A sky130_fd_sc_hd__xor2_2
X_7697_ _7697_/A _7697_/B vssd1 vssd1 vccd1 vccd1 _7698_/B sky130_fd_sc_hd__nor2_2
Xclkload4 clkload4/A vssd1 vssd1 vccd1 vccd1 clkload4/X sky130_fd_sc_hd__clkbuf_4
X_6717_ _6717_/A _6717_/B vssd1 vssd1 vccd1 vccd1 _6718_/B sky130_fd_sc_hd__xnor2_2
X_6648_ _7685_/A wire77/X vssd1 vssd1 vccd1 vccd1 _6739_/A sky130_fd_sc_hd__nand2_2
XANTENNA__8088__A1 _7958_/A vssd1 vssd1 vccd1 vccd1 sky130_fd_sc_hd__diode_2
X_8318_ _8452_/D input9/X _8397_/D vssd1 vssd1 vccd1 vccd1 _8393_/D sky130_fd_sc_hd__mux2_1
X_6579_ _6580_/B _6580_/A vssd1 vssd1 vccd1 vccd1 _6579_/X sky130_fd_sc_hd__and2b_2
X_8249_ _8249_/A _8249_/B vssd1 vssd1 vccd1 vccd1 _8250_/B sky130_fd_sc_hd__or2_2
XANTENNA__5352__C _6016_/A vssd1 vssd1 vccd1 vccd1 sky130_fd_sc_hd__diode_2
Xfanout230 _8372_/Q vssd1 vssd1 vccd1 vccd1 _5386_/C sky130_fd_sc_hd__clkdlybuf4s25_1
Xfanout241 _7998_/A vssd1 vssd1 vccd1 vccd1 _6435_/A sky130_fd_sc_hd__clkdlybuf4s25_1
Xfanout252 _6438_/A vssd1 vssd1 vccd1 vccd1 _5392_/B sky130_fd_sc_hd__clkdlybuf4s25_1
Xfanout263 _5838_/C vssd1 vssd1 vccd1 vccd1 _5670_/B sky130_fd_sc_hd__clkdlybuf4s25_1
Xfanout274 _6548_/A vssd1 vssd1 vccd1 vccd1 _5669_/B sky130_fd_sc_hd__clkdlybuf4s25_1
XTAP_TAPCELL_ROW_6_265 vssd1 vccd1 sky130_fd_sc_hd__tapvpwrvgnd_1
Xfanout285 _8355_/Q vssd1 vssd1 vccd1 vccd1 _8271_/A sky130_fd_sc_hd__clkdlybuf4s25_1
Xfanout296 _6517_/D vssd1 vssd1 vccd1 vccd1 _7864_/B sky130_fd_sc_hd__clkdlybuf4s25_1
XFILLER_74_445 vssd1 vccd1 vssd1 vccd1 sky130_ef_sc_hd__decap_40_12
XFILLER_34_309 vssd1 vssd1 vccd1 vccd1 sky130_fd_sc_hd__fill_1
XFILLER_74_489 vssd1 vssd1 vccd1 vccd1 sky130_fd_sc_hd__fill_8
XANTENNA__8012__A1 _8125_/A vssd1 vssd1 vccd1 vccd1 sky130_fd_sc_hd__diode_2
XANTENNA__6480__A _6689_/A vssd1 vssd1 vccd1 vccd1 sky130_fd_sc_hd__diode_2
XANTENNA__6574__A1 _6572_/A vssd1 vssd1 vccd1 vccd1 sky130_fd_sc_hd__diode_2
XANTENNA__6574__B2 _6712_/A vssd1 vssd1 vccd1 vccd1 sky130_fd_sc_hd__diode_2
XANTENNA__7295__B _7806_/B vssd1 vssd1 vccd1 vccd1 sky130_fd_sc_hd__diode_2
XANTENNA__7523__B1 _7723_/C vssd1 vssd1 vccd1 vccd1 sky130_fd_sc_hd__diode_2
XTAP_TAPCELL_ROW_40_598 vssd1 vccd1 sky130_fd_sc_hd__tapvpwrvgnd_1
XANTENNA__7461__D _8125_/B vssd1 vssd1 vccd1 vccd1 sky130_fd_sc_hd__diode_2
XANTENNA__5837__B1 _5838_/C vssd1 vssd1 vccd1 vccd1 sky130_fd_sc_hd__diode_2
XFILLER_77_283 vssd1 vssd1 vccd1 vccd1 sky130_fd_sc_hd__fill_1
XANTENNA__6374__B _6631_/B vssd1 vssd1 vccd1 vccd1 sky130_fd_sc_hd__diode_2
XANTENNA__4175__A _6631_/A vssd1 vssd1 vccd1 vccd1 sky130_fd_sc_hd__diode_2
XFILLER_37_169 vssd1 vssd1 vccd1 vccd1 sky130_fd_sc_hd__fill_4
XFILLER_80_415 vssd1 vssd1 vccd1 vccd1 sky130_fd_sc_hd__fill_2
X_5950_ _8434_/D wire99/X _6108_/A vssd1 vssd1 vccd1 vccd1 _5951_/B sky130_fd_sc_hd__a21o_2
XTAP_TAPCELL_ROW_76_963 vssd1 vccd1 sky130_fd_sc_hd__tapvpwrvgnd_1
XTAP_TAPCELL_ROW_48_676 vssd1 vccd1 sky130_fd_sc_hd__tapvpwrvgnd_1
XFILLER_92_253 vssd1 vccd1 vssd1 vccd1 sky130_ef_sc_hd__decap_40_12
XANTENNA__8003__A1 _8001_/A vssd1 vssd1 vccd1 vccd1 sky130_fd_sc_hd__diode_2
XFILLER_52_139 vssd1 vssd1 vccd1 vccd1 sky130_fd_sc_hd__fill_1
X_4901_ _5017_/B _4900_/C _4900_/A vssd1 vssd1 vccd1 vccd1 _4902_/D sky130_fd_sc_hd__a21o_2
XFILLER_33_353 vssd1 vssd1 vccd1 vccd1 sky130_fd_sc_hd__fill_1
X_7620_ _8081_/A _8082_/C vssd1 vssd1 vccd1 vccd1 _7682_/A sky130_fd_sc_hd__or2_2
X_5881_ _5881_/A _5881_/B vssd1 vssd1 vccd1 vccd1 _5883_/B sky130_fd_sc_hd__xor2_2
XFILLER_60_161 vssd1 vssd1 vccd1 vccd1 sky130_fd_sc_hd__fill_1
X_4832_ _5747_/A _6582_/B vssd1 vssd1 vccd1 vccd1 _4833_/B sky130_fd_sc_hd__nand2_2
XTAP_TAPCELL_ROW_31_510 vssd1 vccd1 sky130_fd_sc_hd__tapvpwrvgnd_1
XFILLER_21_559 vssd1 vssd1 vccd1 vccd1 sky130_fd_sc_hd__fill_1
X_7551_ _7551_/A _7551_/B vssd1 vssd1 vccd1 vccd1 _7553_/A sky130_fd_sc_hd__nor2_2
X_4763_ _8427_/D _4830_/C _4473_/Y vssd1 vssd1 vccd1 vccd1 _4764_/B sky130_fd_sc_hd__a21bo_2
X_7482_ _7483_/A _7483_/B vssd1 vssd1 vccd1 vccd1 _7485_/A sky130_fd_sc_hd__nor2_2
X_6502_ _7140_/A _8126_/A _6892_/D _6894_/B vssd1 vssd1 vccd1 vccd1 _6504_/A sky130_fd_sc_hd__and4_2
X_4694_ _4694_/A _4694_/B vssd1 vssd1 vccd1 vccd1 _4721_/B sky130_fd_sc_hd__nand2_2
X_6433_ _6433_/A _8257_/A vssd1 vssd1 vccd1 vccd1 _6434_/B sky130_fd_sc_hd__nand2_2
XANTENNA__8110__A _8110_/A vssd1 vssd1 vccd1 vccd1 sky130_fd_sc_hd__diode_2
X_6364_ _6364_/A _6364_/B vssd1 vssd1 vccd1 vccd1 _6365_/B sky130_fd_sc_hd__xnor2_2
X_8103_ _8103_/A _8103_/B _8274_/A _8103_/D vssd1 vssd1 vccd1 vccd1 _8105_/A sky130_fd_sc_hd__nand4_2
X_6295_ _6295_/A _6295_/B vssd1 vssd1 vccd1 vccd1 _6297_/B sky130_fd_sc_hd__xnor2_2
X_5315_ _8179_/A _5521_/C _5559_/C _5647_/A vssd1 vssd1 vccd1 vccd1 _5315_/Y sky130_fd_sc_hd__a22oi_2
XFILLER_88_537 vssd1 vssd1 vccd1 vccd1 sky130_fd_sc_hd__fill_1
X_8034_ _8032_/A _8136_/A _7855_/D _7853_/X vssd1 vssd1 vccd1 vccd1 _8035_/B sky130_fd_sc_hd__a31o_2
X_5246_ _5246_/A _5246_/B _5250_/A _5246_/D vssd1 vssd1 vccd1 vccd1 _5286_/A sky130_fd_sc_hd__or4_4
XFILLER_29_38 vssd1 vssd1 vccd1 vccd1 sky130_fd_sc_hd__fill_8
XPHY_EDGE_ROW_89_Right_89 vssd1 vssd1 vccd1 vccd1 sky130_fd_sc_hd__decap_3
X_5177_ _5177_/A _5177_/B vssd1 vssd1 vccd1 vccd1 _5178_/B sky130_fd_sc_hd__xor2_2
XTAP_TAPCELL_ROW_3_235 vssd1 vccd1 sky130_fd_sc_hd__tapvpwrvgnd_1
XFILLER_28_169 vssd1 vssd1 vccd1 vccd1 sky130_fd_sc_hd__fill_1
XFILLER_83_275 vssd1 vssd1 vccd1 vccd1 sky130_fd_sc_hd__fill_2
XFILLER_43_128 vssd1 vssd1 vccd1 vccd1 sky130_fd_sc_hd__fill_1
XANTENNA__4813__A _5020_/A vssd1 vssd1 vccd1 vccd1 sky130_fd_sc_hd__diode_2
XANTENNA__7753__B1 _8126_/B vssd1 vssd1 vccd1 vccd1 sky130_fd_sc_hd__diode_2
X_7818_ _7623_/B _7680_/Y _7684_/A _7684_/B vssd1 vssd1 vccd1 vccd1 _7830_/A sky130_fd_sc_hd__a22o_2
XFILLER_12_559 vssd1 vssd1 vccd1 vccd1 sky130_fd_sc_hd__fill_1
XFILLER_8_519 vssd1 vssd1 vccd1 vccd1 sky130_fd_sc_hd__fill_1
X_7749_ _7889_/A _7889_/B _7897_/B _8103_/D vssd1 vssd1 vccd1 vccd1 _7750_/B sky130_fd_sc_hd__and4_2
XFILLER_59_272 vssd1 vssd1 vccd1 vccd1 sky130_fd_sc_hd__fill_8
XFILLER_86_77 vssd1 vssd1 vccd1 vccd1 sky130_fd_sc_hd__fill_1
XFILLER_47_434 vssd1 vssd1 vccd1 vccd1 sky130_fd_sc_hd__fill_1
XFILLER_59_283 vssd1 vssd1 vccd1 vccd1 sky130_fd_sc_hd__fill_1
XFILLER_74_253 vssd1 vssd1 vccd1 vccd1 sky130_fd_sc_hd__fill_1
XFILLER_34_128 vssd1 vssd1 vccd1 vccd1 sky130_fd_sc_hd__fill_2
XFILLER_34_139 vssd1 vssd1 vccd1 vccd1 sky130_fd_sc_hd__fill_1
XTAP_TAPCELL_ROW_73_933 vssd1 vccd1 sky130_fd_sc_hd__tapvpwrvgnd_1
XANTENNA__6922__B _7998_/B vssd1 vssd1 vccd1 vccd1 sky130_fd_sc_hd__diode_2
XTAP_TAPCELL_ROW_45_646 vssd1 vccd1 sky130_fd_sc_hd__tapvpwrvgnd_1
XANTENNA__6547__A1 _6460_/A vssd1 vssd1 vccd1 vccd1 sky130_fd_sc_hd__diode_2
XFILLER_35_81 vssd1 vssd1 vccd1 vccd1 sky130_fd_sc_hd__fill_1
XFILLER_51_80 vssd1 vssd1 vccd1 vccd1 sky130_fd_sc_hd__fill_4
Xhold519 _8383_/Q vssd1 vssd1 vccd1 vccd1 _8442_/D sky130_fd_sc_hd__dlygate4sd3_1
XFILLER_32_3 vssd1 vssd1 vccd1 vccd1 sky130_fd_sc_hd__fill_2
X_6080_ _6080_/A _6080_/B vssd1 vssd1 vccd1 vccd1 _6080_/Y sky130_fd_sc_hd__xnor2_2
X_5100_ _4965_/B _5092_/B _5095_/A _5094_/Y vssd1 vssd1 vccd1 vccd1 _5102_/B sky130_fd_sc_hd__a2bb2o_2
X_5031_ _5031_/A _5031_/B vssd1 vssd1 vccd1 vccd1 _5033_/B sky130_fd_sc_hd__xnor2_4
XFILLER_65_264 vssd1 vssd1 vccd1 vccd1 sky130_fd_sc_hd__fill_2
XTAP_TAPCELL_ROW_0_205 vssd1 vccd1 sky130_fd_sc_hd__tapvpwrvgnd_1
XANTENNA_load_slew384_X load_slew384/X vssd1 vssd1 vccd1 vccd1 sky130_fd_sc_hd__diode_2
XFILLER_80_212 vssd1 vssd1 vccd1 vccd1 sky130_fd_sc_hd__fill_1
X_6982_ _6983_/B _6983_/A vssd1 vssd1 vccd1 vccd1 _7049_/B sky130_fd_sc_hd__nand2b_2
XANTENNA__6832__B _8264_/A vssd1 vssd1 vccd1 vccd1 sky130_fd_sc_hd__diode_2
X_5933_ _5933_/A _5933_/B _5933_/C vssd1 vssd1 vccd1 vccd1 _5934_/B sky130_fd_sc_hd__nor3_2
XANTENNA__7735__B1 _7875_/C vssd1 vssd1 vccd1 vccd1 sky130_fd_sc_hd__diode_2
X_5864_ _5864_/A _5864_/B _5862_/X vssd1 vssd1 vccd1 vccd1 _5865_/B sky130_fd_sc_hd__or3b_2
X_7603_ _7603_/A _7603_/B vssd1 vssd1 vccd1 vccd1 _7605_/B sky130_fd_sc_hd__nor2_2
X_4815_ _5020_/A _4895_/B _4895_/C vssd1 vssd1 vccd1 vccd1 _4816_/D sky130_fd_sc_hd__a21o_2
X_7534_ _7436_/A _7438_/B _7436_/B vssd1 vssd1 vccd1 vccd1 _7541_/A sky130_fd_sc_hd__o21ba_2
X_5795_ _5795_/A _5795_/B vssd1 vssd1 vccd1 vccd1 _5796_/B sky130_fd_sc_hd__nand2_2
XANTENNA_fanout224_A _6006_/A vssd1 vssd1 vccd1 vccd1 sky130_fd_sc_hd__diode_2
X_4746_ _8425_/D wire92/X vssd1 vssd1 vccd1 vccd1 _4895_/C sky130_fd_sc_hd__and2_2
X_7465_ _8103_/A _7754_/B _7875_/C _7875_/D vssd1 vssd1 vccd1 vccd1 _7467_/A sky130_fd_sc_hd__and4_2
X_4677_ _4668_/Y _4677_/A2 _4690_/A vssd1 vssd1 vccd1 vccd1 _4679_/B sky130_fd_sc_hd__a21oi_2
XANTENNA__6279__B _6280_/B vssd1 vssd1 vccd1 vccd1 sky130_fd_sc_hd__diode_2
X_7396_ _7397_/B _7397_/A vssd1 vssd1 vccd1 vccd1 _7396_/Y sky130_fd_sc_hd__nand2b_2
X_6416_ _6416_/A _6416_/B vssd1 vssd1 vccd1 vccd1 _6418_/A sky130_fd_sc_hd__nor2_2
Xoutput28 _8327_/Q vssd1 vssd1 vccd1 vccd1 gpio_out[25] sky130_fd_sc_hd__clkdlybuf4s25_1
X_6347_ _8419_/D _6738_/B vssd1 vssd1 vccd1 vccd1 _6650_/A sky130_fd_sc_hd__nand2_2
XANTENNA__5277__B2 _5267_/B vssd1 vssd1 vccd1 vccd1 sky130_fd_sc_hd__diode_2
X_6278_ _6473_/B _6278_/B vssd1 vssd1 vccd1 vccd1 _6280_/B sky130_fd_sc_hd__and2_2
XFILLER_76_529 vssd1 vssd1 vccd1 vccd1 sky130_fd_sc_hd__fill_2
X_8017_ _8017_/A _8017_/B vssd1 vssd1 vccd1 vccd1 _8019_/A sky130_fd_sc_hd__nor2_2
X_5229_ _5229_/A _5229_/B vssd1 vssd1 vccd1 vccd1 _5236_/A sky130_fd_sc_hd__nor2_2
XANTENNA__6726__C _7095_/C vssd1 vssd1 vccd1 vccd1 sky130_fd_sc_hd__diode_2
XFILLER_29_434 vssd1 vssd1 vccd1 vccd1 sky130_fd_sc_hd__fill_1
XANTENNA__4527__B _4770_/B vssd1 vssd1 vccd1 vccd1 sky130_fd_sc_hd__diode_2
XFILLER_71_223 vssd1 vssd1 vccd1 vccd1 sky130_fd_sc_hd__fill_1
XTAP_TAPCELL_ROW_70_903 vssd1 vccd1 sky130_fd_sc_hd__tapvpwrvgnd_1
XANTENNA__8015__A _8016_/A vssd1 vssd1 vccd1 vccd1 sky130_fd_sc_hd__diode_2
XTAP_TAPCELL_ROW_42_616 vssd1 vccd1 sky130_fd_sc_hd__tapvpwrvgnd_1
XANTENNA__8394__CLK clkload7/A vssd1 vssd1 vccd1 vccd1 sky130_fd_sc_hd__diode_2
XFILLER_52_481 vssd1 vssd1 vccd1 vccd1 sky130_fd_sc_hd__fill_1
XTAP_TAPCELL_ROW_58_782 vssd1 vccd1 sky130_fd_sc_hd__tapvpwrvgnd_1
XANTENNA__6652__B _7007_/B vssd1 vssd1 vccd1 vccd1 sky130_fd_sc_hd__diode_2
XANTENNA_load_slew177_A fanout176/X vssd1 vssd1 vccd1 vccd1 sky130_fd_sc_hd__diode_2
X_4600_ _4649_/A _4654_/C vssd1 vssd1 vccd1 vccd1 _4600_/Y sky130_fd_sc_hd__nand2_2
XFILLER_7_30 vssd1 vssd1 vccd1 vccd1 sky130_fd_sc_hd__fill_1
X_5580_ _5580_/A _5582_/A vssd1 vssd1 vccd1 vccd1 _5604_/A sky130_fd_sc_hd__nand2_2
X_4531_ _4674_/A _4531_/B _4531_/C vssd1 vssd1 vccd1 vccd1 _4580_/A sky130_fd_sc_hd__or3_2
X_7250_ _7895_/A _7249_/C _8351_/Q _7754_/B vssd1 vssd1 vccd1 vccd1 _7251_/B sky130_fd_sc_hd__a22oi_2
X_4462_ _4462_/A _4462_/B vssd1 vssd1 vccd1 vccd1 _4464_/B sky130_fd_sc_hd__xnor2_2
XANTENNA__8368__Q _8368_/Q vssd1 vssd1 vccd1 vccd1 sky130_fd_sc_hd__diode_2
X_6201_ _6397_/C _6482_/A _6401_/A _6199_/Y vssd1 vssd1 vccd1 vccd1 _6202_/B sky130_fd_sc_hd__o2bb2a_2
X_7181_ _6919_/A _6921_/B _6919_/B vssd1 vssd1 vccd1 vccd1 _7183_/C sky130_fd_sc_hd__o21ba_2
X_4393_ _4393_/A _4393_/B _4393_/C vssd1 vssd1 vccd1 vccd1 _4394_/B sky130_fd_sc_hd__nor3_2
X_6132_ _6132_/A _6132_/B vssd1 vssd1 vccd1 vccd1 _6134_/A sky130_fd_sc_hd__xnor2_2
X_6063_ _6061_/A _6061_/B _6061_/C vssd1 vssd1 vccd1 vccd1 _6063_/Y sky130_fd_sc_hd__o21ai_2
XTAP_TAPCELL_ROW_90_1099 vssd1 vccd1 sky130_fd_sc_hd__tapvpwrvgnd_1
X_5014_ _4894_/Y _5132_/A _5013_/X vssd1 vssd1 vccd1 vccd1 _5016_/A sky130_fd_sc_hd__o21ai_2
XFILLER_38_253 vssd1 vssd1 vccd1 vccd1 sky130_fd_sc_hd__fill_1
XFILLER_66_562 vssd1 vssd1 vccd1 vccd1 sky130_fd_sc_hd__fill_1
XFILLER_38_297 vssd1 vssd1 vccd1 vccd1 sky130_fd_sc_hd__fill_1
XFILLER_53_223 vssd1 vssd1 vccd1 vccd1 sky130_fd_sc_hd__fill_1
XFILLER_81_510 vssd1 vssd1 vccd1 vccd1 sky130_fd_sc_hd__fill_1
X_6965_ _7201_/B _6965_/B vssd1 vssd1 vccd1 vccd1 _7042_/A sky130_fd_sc_hd__nor2_2
XFILLER_34_470 vssd1 vssd1 vccd1 vccd1 sky130_fd_sc_hd__fill_1
X_5916_ _5916_/A _5916_/B vssd1 vssd1 vccd1 vccd1 _5917_/B sky130_fd_sc_hd__xnor2_2
X_6896_ _6897_/A _6897_/B vssd1 vssd1 vccd1 vccd1 _7137_/B sky130_fd_sc_hd__nand2_2
XANTENNA__4195__A_N _8168_/B vssd1 vssd1 vccd1 vccd1 sky130_fd_sc_hd__diode_2
XFILLER_42_27 vssd1 vssd1 vccd1 vccd1 sky130_fd_sc_hd__fill_1
X_5847_ _5396_/A _5395_/B _5395_/A vssd1 vssd1 vccd1 vccd1 _5849_/B sky130_fd_sc_hd__o21ba_2
XANTENNA_fanout227_X _8016_/A vssd1 vssd1 vccd1 vccd1 sky130_fd_sc_hd__diode_2
X_5778_ _8409_/D _6156_/B vssd1 vssd1 vccd1 vccd1 _5779_/B sky130_fd_sc_hd__nand2_2
X_7517_ _7517_/A _7517_/B vssd1 vssd1 vccd1 vccd1 _7519_/A sky130_fd_sc_hd__nor2_2
Xrebuffer457 _4166_/A vssd1 vssd1 vccd1 vccd1 _4527_/A sky130_fd_sc_hd__buf_2
Xrebuffer446 _4162_/Y vssd1 vssd1 vccd1 vccd1 _6090_/A1 sky130_fd_sc_hd__buf_2
X_4729_ _4729_/A _4729_/B vssd1 vssd1 vccd1 vccd1 _4733_/B sky130_fd_sc_hd__xor2_2
Xrebuffer479 _5205_/X vssd1 vssd1 vccd1 vccd1 _5694_/A sky130_fd_sc_hd__buf_2
Xrebuffer468 _4700_/C vssd1 vssd1 vccd1 vccd1 _4702_/B1 sky130_fd_sc_hd__buf_2
X_7448_ _7448_/A _7448_/B vssd1 vssd1 vccd1 vccd1 _7450_/A sky130_fd_sc_hd__nor2_2
XFILLER_1_503 vssd1 vssd1 vccd1 vccd1 sky130_fd_sc_hd__fill_1
X_7379_ _7336_/B _7379_/B vssd1 vssd1 vccd1 vccd1 _7381_/B sky130_fd_sc_hd__and2b_2
XFILLER_88_197 vssd1 vssd1 vccd1 vccd1 sky130_fd_sc_hd__fill_8
XFILLER_57_551 vssd1 vssd1 vccd1 vccd1 sky130_fd_sc_hd__fill_2
XFILLER_72_554 vssd1 vssd1 vccd1 vccd1 sky130_fd_sc_hd__fill_4
XFILLER_83_67 vssd1 vssd1 vccd1 vccd1 sky130_fd_sc_hd__fill_1
XTAP_TAPCELL_ROW_55_752 vssd1 vccd1 sky130_fd_sc_hd__tapvpwrvgnd_1
XANTENNA__6903__D _7140_/C vssd1 vssd1 vccd1 vccd1 sky130_fd_sc_hd__diode_2
XFILLER_12_131 vssd1 vssd1 vccd1 vccd1 sky130_fd_sc_hd__fill_1
XFILLER_40_484 vssd1 vssd1 vccd1 vccd1 sky130_fd_sc_hd__fill_4
XANTENNA__5816__B _6001_/A vssd1 vssd1 vccd1 vccd1 sky130_fd_sc_hd__diode_2
XANTENNA__7734__D _7875_/C vssd1 vssd1 vccd1 vccd1 sky130_fd_sc_hd__diode_2
XFILLER_8_157 vssd1 vssd1 vccd1 vccd1 sky130_fd_sc_hd__fill_4
XANTENNA__4161__A1 _4160_/B vssd1 vssd1 vccd1 vccd1 sky130_fd_sc_hd__diode_2
XFILLER_4_396 vssd1 vssd1 vccd1 vccd1 sky130_fd_sc_hd__fill_1
XANTENNA__4167__B _4227_/S vssd1 vssd1 vccd1 vccd1 sky130_fd_sc_hd__diode_2
XFILLER_82_307 vssd1 vssd1 vccd1 vccd1 sky130_fd_sc_hd__fill_1
XFILLER_63_543 vssd1 vccd1 vssd1 vccd1 sky130_ef_sc_hd__decap_40_12
X_6750_ _6750_/A _6750_/B vssd1 vssd1 vccd1 vccd1 _6752_/B sky130_fd_sc_hd__xor2_2
X_5701_ _5710_/A _5953_/B _5165_/B _6588_/A _4700_/B vssd1 vssd1 vccd1 vccd1 _5704_/A
+ sky130_fd_sc_hd__a32o_2
X_6681_ _6681_/A _6681_/B vssd1 vssd1 vccd1 vccd1 _6683_/A sky130_fd_sc_hd__nand2_2
X_8420_ clkload5/A _8420_/D wire364/X vssd1 vssd1 vccd1 vccd1 _8420_/Q sky130_fd_sc_hd__dfrtp_2
X_5632_ _5568_/A _5669_/B _5607_/A _5611_/A vssd1 vssd1 vccd1 vccd1 _5633_/B sky130_fd_sc_hd__a211oi_2
X_8351_ _8405_/CLK _8351_/D wire377/X vssd1 vssd1 vccd1 vccd1 _8351_/Q sky130_fd_sc_hd__dfrtp_2
X_5563_ _5555_/A _5612_/B _5530_/B _5522_/Y vssd1 vssd1 vccd1 vccd1 _5564_/B sky130_fd_sc_hd__o2bb2a_2
X_7302_ _7303_/A _7303_/B vssd1 vssd1 vccd1 vccd1 _7302_/Y sky130_fd_sc_hd__nor2_2
X_4514_ _4514_/A _4514_/B vssd1 vssd1 vccd1 vccd1 _4731_/A sky130_fd_sc_hd__xor2_2
X_8282_ _8359_/Q _8281_/C _8360_/Q vssd1 vssd1 vccd1 vccd1 _8283_/B sky130_fd_sc_hd__a21oi_2
X_5494_ _5498_/A _5494_/B _5494_/C vssd1 vssd1 vccd1 vccd1 _5540_/A sky130_fd_sc_hd__or3_2
XTAP_TAPCELL_ROW_92_1117 vssd1 vccd1 sky130_fd_sc_hd__tapvpwrvgnd_1
XANTENNA__5742__A _5930_/A vssd1 vssd1 vccd1 vccd1 sky130_fd_sc_hd__diode_2
X_7233_ _7233_/A _8133_/C vssd1 vssd1 vccd1 vccd1 _7234_/B sky130_fd_sc_hd__nand2_2
X_4445_ _4445_/A _4445_/B vssd1 vssd1 vccd1 vccd1 _4549_/B sky130_fd_sc_hd__xor2_2
XTAP_TAPCELL_ROW_92_1128 vssd1 vccd1 sky130_fd_sc_hd__tapvpwrvgnd_1
X_7164_ _6924_/B _6926_/B _6924_/A vssd1 vssd1 vccd1 vccd1 _7166_/B sky130_fd_sc_hd__o21ba_2
X_4376_ _4502_/A _4376_/B vssd1 vssd1 vccd1 vccd1 _4379_/B sky130_fd_sc_hd__or2_2
X_6115_ _6115_/A _6308_/A vssd1 vssd1 vccd1 vccd1 _6117_/A sky130_fd_sc_hd__or2_2
XANTENNA_fanout291_A _8264_/A vssd1 vssd1 vccd1 vccd1 sky130_fd_sc_hd__diode_2
X_7095_ _7095_/A _7095_/B _7095_/C vssd1 vssd1 vccd1 vccd1 _7298_/A sky130_fd_sc_hd__and3_2
X_6046_ _6047_/A _6047_/B _6047_/C vssd1 vssd1 vccd1 vccd1 _6259_/A sky130_fd_sc_hd__a21o_2
XTAP_TAPCELL_ROW_69_888 vssd1 vccd1 sky130_fd_sc_hd__tapvpwrvgnd_1
XFILLER_66_370 vssd1 vssd1 vccd1 vccd1 sky130_fd_sc_hd__fill_1
XANTENNA__6292__B _6701_/B vssd1 vssd1 vccd1 vccd1 sky130_fd_sc_hd__diode_2
XANTENNA__8412__RESET_B load_slew358/X vssd1 vssd1 vccd1 vccd1 sky130_fd_sc_hd__diode_2
XFILLER_41_204 vssd1 vssd1 vccd1 vccd1 sky130_fd_sc_hd__fill_1
XFILLER_41_215 vssd1 vssd1 vccd1 vccd1 sky130_fd_sc_hd__fill_1
X_7997_ _7895_/A _8271_/A _7897_/B _7998_/B vssd1 vssd1 vccd1 vccd1 _7997_/X sky130_fd_sc_hd__a22o_2
XANTENNA_fanout344_X _6795_/A vssd1 vssd1 vccd1 vccd1 sky130_fd_sc_hd__diode_2
XFILLER_53_37 vssd1 vssd1 vccd1 vccd1 sky130_fd_sc_hd__fill_4
X_6948_ _8121_/A _8126_/B vssd1 vssd1 vccd1 vccd1 _6949_/B sky130_fd_sc_hd__nand2_2
XTAP_TAPCELL_ROW_52_722 vssd1 vccd1 sky130_fd_sc_hd__tapvpwrvgnd_1
XFILLER_22_440 vssd1 vssd1 vccd1 vccd1 sky130_fd_sc_hd__fill_1
X_6879_ _6880_/A _6880_/B vssd1 vssd1 vccd1 vccd1 _6881_/B sky130_fd_sc_hd__nand2_2
XANTENNA__4821__A _4821_/A vssd1 vssd1 vccd1 vccd1 sky130_fd_sc_hd__diode_2
XANTENNA__6904__A1 _7140_/A vssd1 vssd1 vccd1 vccd1 sky130_fd_sc_hd__diode_2
XANTENNA__7554__D _7877_/B vssd1 vssd1 vccd1 vccd1 sky130_fd_sc_hd__diode_2
XANTENNA__8432__CLK clkload4/A vssd1 vssd1 vccd1 vccd1 sky130_fd_sc_hd__diode_2
XANTENNA__4210__A_N input7/X vssd1 vssd1 vccd1 vccd1 sky130_fd_sc_hd__diode_2
Xteam_03_430 vssd1 vssd1 vccd1 vccd1 gpio_oeb[9] team_03_430/LO sky130_fd_sc_hd__conb_1
XFILLER_64_329 vssd1 vssd1 vccd1 vccd1 sky130_fd_sc_hd__fill_2
XFILLER_76_189 vssd1 vssd1 vccd1 vccd1 sky130_fd_sc_hd__fill_4
XFILLER_45_543 vssd1 vssd1 vccd1 vccd1 sky130_fd_sc_hd__fill_1
XFILLER_71_7 vssd1 vssd1 vccd1 vccd1 sky130_fd_sc_hd__fill_1
XFILLER_9_477 vssd1 vssd1 vccd1 vccd1 sky130_fd_sc_hd__fill_4
XANTENNA__4382__A1 _5157_/A vssd1 vssd1 vccd1 vccd1 sky130_fd_sc_hd__diode_2
XFILLER_4_31 vssd1 vssd1 vccd1 vccd1 sky130_fd_sc_hd__fill_1
X_4230_ _8387_/Q _8446_/Q vssd1 vssd1 vccd1 vccd1 _4231_/B sky130_fd_sc_hd__or2_2
XFILLER_4_64 vssd1 vssd1 vccd1 vccd1 sky130_fd_sc_hd__fill_2
X_4161_ _4160_/B _8427_/Q _4160_/Y vssd1 vssd1 vccd1 vccd1 _4311_/A sky130_fd_sc_hd__o21ai_4
XANTENNA__4178__A _7969_/A vssd1 vssd1 vccd1 vccd1 sky130_fd_sc_hd__diode_2
X_7920_ _7920_/A _7920_/B vssd1 vssd1 vccd1 vccd1 _7921_/C sky130_fd_sc_hd__xnor2_2
X_7851_ _8030_/A _7714_/C _8136_/D _7853_/A vssd1 vssd1 vccd1 vccd1 _7855_/D sky130_fd_sc_hd__a22o_2
XTAP_TAPCELL_ROW_89_1090 vssd1 vccd1 sky130_fd_sc_hd__tapvpwrvgnd_1
XTAP_TAPCELL_ROW_66_858 vssd1 vccd1 sky130_fd_sc_hd__tapvpwrvgnd_1
XANTENNA__4625__B _4686_/B vssd1 vssd1 vccd1 vccd1 sky130_fd_sc_hd__diode_2
X_6802_ _6802_/A _6802_/B vssd1 vssd1 vccd1 vccd1 _6809_/A sky130_fd_sc_hd__xnor2_2
XFILLER_51_535 vssd1 vssd1 vccd1 vccd1 sky130_fd_sc_hd__fill_1
XFILLER_51_546 vssd1 vssd1 vccd1 vccd1 sky130_fd_sc_hd__fill_1
X_7782_ _7781_/A _7781_/B _7781_/C vssd1 vssd1 vccd1 vccd1 _7783_/B sky130_fd_sc_hd__a21oi_2
X_4994_ _5930_/A _6582_/B _4914_/A _4912_/A vssd1 vssd1 vccd1 vccd1 _5004_/A sky130_fd_sc_hd__a31o_2
X_6733_ _6734_/A _6734_/B vssd1 vssd1 vccd1 vccd1 _6966_/A sky130_fd_sc_hd__nand2b_2
X_6664_ _6664_/A _6664_/B vssd1 vssd1 vccd1 vccd1 _6667_/A sky130_fd_sc_hd__and2_2
X_8403_ clkload9/A _8403_/D fanout372/A vssd1 vssd1 vccd1 vccd1 _8403_/Q sky130_fd_sc_hd__dfrtp_2
X_5615_ _5651_/A _5634_/B vssd1 vssd1 vccd1 vccd1 _5635_/A sky130_fd_sc_hd__nor2_2
X_6595_ _6595_/A _6595_/B vssd1 vssd1 vccd1 vccd1 _6596_/B sky130_fd_sc_hd__nand2_2
X_8334_ _8334_/CLK _8334_/D load_slew381/X vssd1 vssd1 vccd1 vccd1 _8334_/Q sky130_fd_sc_hd__dfrtp_2
X_5546_ _5546_/A _5546_/B vssd1 vssd1 vccd1 vccd1 _5548_/B sky130_fd_sc_hd__xor2_2
X_8265_ _8267_/C _8265_/B vssd1 vssd1 vccd1 vccd1 _8352_/D sky130_fd_sc_hd__nor2_2
X_5477_ _5477_/A _5477_/B vssd1 vssd1 vccd1 vccd1 _5487_/A sky130_fd_sc_hd__nor2_2
X_7216_ _7217_/B _7217_/A vssd1 vssd1 vccd1 vccd1 _7443_/A sky130_fd_sc_hd__nand2b_2
X_4428_ _4441_/B _4441_/A vssd1 vssd1 vccd1 vccd1 _4428_/Y sky130_fd_sc_hd__nand2b_2
X_8196_ _8196_/A _8196_/B vssd1 vssd1 vccd1 vccd1 _8197_/B sky130_fd_sc_hd__nand2_2
XANTENNA_fanout294_X _8263_/A vssd1 vssd1 vccd1 vccd1 sky130_fd_sc_hd__diode_2
XFILLER_48_37 vssd1 vssd1 vccd1 vccd1 sky130_fd_sc_hd__fill_4
XFILLER_86_421 vssd1 vssd1 vccd1 vccd1 sky130_fd_sc_hd__fill_2
X_7147_ _7148_/A _7148_/B vssd1 vssd1 vccd1 vccd1 _7261_/B sky130_fd_sc_hd__nand2b_2
X_4359_ _8379_/Q _8438_/Q vssd1 vssd1 vccd1 vccd1 _4360_/B sky130_fd_sc_hd__or2_2
X_7078_ _7603_/A _7084_/B _6988_/Y _6987_/Y vssd1 vssd1 vccd1 vccd1 _7088_/A sky130_fd_sc_hd__o31ai_2
X_6029_ _6029_/A _6029_/B vssd1 vssd1 vccd1 vccd1 _6050_/A sky130_fd_sc_hd__and2_2
XTAP_TAPCELL_ROW_37_571 vssd1 vccd1 sky130_fd_sc_hd__tapvpwrvgnd_1
XFILLER_80_13 vssd1 vssd1 vccd1 vccd1 sky130_fd_sc_hd__fill_2
Xfanout74 wire77/A vssd1 vssd1 vccd1 vccd1 _5272_/B sky130_fd_sc_hd__clkbuf_2
Xfanout63 _4887_/Y vssd1 vssd1 vccd1 vccd1 wire64/A sky130_fd_sc_hd__clkdlybuf4s25_1
Xfanout41 _7296_/B vssd1 vssd1 vccd1 vccd1 _8081_/B sky130_fd_sc_hd__clkbuf_2
XANTENNA__5366__B _5657_/B vssd1 vssd1 vccd1 vccd1 sky130_fd_sc_hd__diode_2
XFILLER_13_40 vssd1 vssd1 vccd1 vccd1 sky130_fd_sc_hd__fill_2
Xfanout96 _5147_/B vssd1 vssd1 vccd1 vccd1 _6704_/B sky130_fd_sc_hd__clkdlybuf4s25_1
Xfanout85 _4455_/Y vssd1 vssd1 vccd1 vccd1 _6701_/B sky130_fd_sc_hd__clkdlybuf4s25_1
XFILLER_6_414 vssd1 vssd1 vccd1 vccd1 sky130_fd_sc_hd__fill_1
XFILLER_49_123 vssd1 vssd1 vccd1 vccd1 sky130_fd_sc_hd__fill_1
XANTENNA__8328__CLK _8402_/CLK vssd1 vssd1 vccd1 vccd1 sky130_fd_sc_hd__diode_2
XFILLER_77_443 vssd1 vssd1 vccd1 vccd1 sky130_fd_sc_hd__fill_4
XTAP_TAPCELL_ROW_63_828 vssd1 vccd1 sky130_fd_sc_hd__tapvpwrvgnd_1
XFILLER_72_170 vssd1 vssd1 vccd1 vccd1 sky130_fd_sc_hd__fill_1
XANTENNA__7756__B _8125_/B vssd1 vssd1 vccd1 vccd1 sky130_fd_sc_hd__diode_2
XANTENNA__4180__B _4207_/B vssd1 vssd1 vccd1 vccd1 sky130_fd_sc_hd__diode_2
Xclkload11 _8369_/CLK vssd1 vssd1 vccd1 vccd1 clkload11/X sky130_fd_sc_hd__clkbuf_4
X_6380_ _6380_/A _6380_/B vssd1 vssd1 vccd1 vccd1 _6383_/A sky130_fd_sc_hd__xnor2_2
X_5400_ _8228_/A _5657_/B vssd1 vssd1 vccd1 vccd1 _5404_/A sky130_fd_sc_hd__nand2_2
XANTENNA__8097__A2 _8361_/Q vssd1 vssd1 vccd1 vccd1 sky130_fd_sc_hd__diode_2
X_5331_ _8191_/A _5612_/B _5317_/A _5315_/Y vssd1 vssd1 vccd1 vccd1 _5332_/B sky130_fd_sc_hd__o2bb2a_2
X_8050_ _8050_/A _8050_/B _8050_/C vssd1 vssd1 vccd1 vccd1 _8051_/C sky130_fd_sc_hd__or3_2
X_7001_ _7001_/A _7001_/B vssd1 vssd1 vccd1 vccd1 _7021_/A sky130_fd_sc_hd__xnor2_2
X_5262_ _8406_/D _5780_/B vssd1 vssd1 vccd1 vccd1 _5263_/C sky130_fd_sc_hd__and2_2
XFILLER_87_229 vssd1 vssd1 vccd1 vccd1 sky130_fd_sc_hd__fill_2
X_5193_ _5192_/A _5762_/A2 _5192_/B vssd1 vssd1 vccd1 vccd1 _5194_/B sky130_fd_sc_hd__o21ai_2
X_4213_ input8/X _4218_/S vssd1 vssd1 vccd1 vccd1 _4213_/Y sky130_fd_sc_hd__nand2b_2
X_4144_ _8397_/D vssd1 vssd1 vccd1 vccd1 _4144_/Y sky130_fd_sc_hd__inv_2
XFILLER_18_29 vssd1 vssd1 vccd1 vccd1 sky130_fd_sc_hd__fill_4
XFILLER_83_402 vssd1 vssd1 vccd1 vccd1 sky130_fd_sc_hd__fill_1
XTAP_TAPCELL_ROW_79_994 vssd1 vccd1 sky130_fd_sc_hd__tapvpwrvgnd_1
XFILLER_83_446 vssd1 vssd1 vccd1 vccd1 sky130_fd_sc_hd__fill_2
XFILLER_83_479 vssd1 vssd1 vccd1 vccd1 sky130_fd_sc_hd__fill_4
X_7903_ _7903_/A _7903_/B vssd1 vssd1 vccd1 vccd1 _7904_/B sky130_fd_sc_hd__nor2_2
XANTENNA_fanout254_A _8110_/A vssd1 vssd1 vccd1 vccd1 sky130_fd_sc_hd__diode_2
XFILLER_24_524 vssd1 vssd1 vccd1 vccd1 sky130_fd_sc_hd__fill_1
X_7834_ _7835_/A _7835_/B vssd1 vssd1 vccd1 vccd1 _7962_/B sky130_fd_sc_hd__and2_2
X_7765_ _7765_/A _7765_/B _7765_/C vssd1 vssd1 vccd1 vccd1 _7766_/B sky130_fd_sc_hd__nand3_2
XTAP_TAPCELL_ROW_34_541 vssd1 vccd1 sky130_fd_sc_hd__tapvpwrvgnd_1
XANTENNA__4371__A _4919_/A vssd1 vssd1 vccd1 vccd1 sky130_fd_sc_hd__diode_2
X_6716_ _6716_/A _6716_/B vssd1 vssd1 vccd1 vccd1 _6717_/B sky130_fd_sc_hd__xnor2_2
X_4977_ _4978_/A _4978_/B vssd1 vssd1 vccd1 vccd1 _4977_/Y sky130_fd_sc_hd__nand2b_2
X_7696_ _7696_/A _7696_/B _7696_/C vssd1 vssd1 vccd1 vccd1 _7697_/B sky130_fd_sc_hd__nor3_2
Xclkload5 clkload5/A vssd1 vssd1 vccd1 vccd1 clkload5/X sky130_fd_sc_hd__clkbuf_4
XFILLER_50_38 vssd1 vssd1 vccd1 vccd1 sky130_fd_sc_hd__fill_8
X_6647_ _6645_/A _6748_/A _6646_/X vssd1 vssd1 vccd1 vccd1 _6658_/A sky130_fd_sc_hd__o21ai_2
XANTENNA_fanout307_X _7723_/C vssd1 vssd1 vccd1 vccd1 sky130_fd_sc_hd__diode_2
X_6578_ _6578_/A _6578_/B vssd1 vssd1 vccd1 vccd1 _6580_/B sky130_fd_sc_hd__xnor2_2
XANTENNA__8088__A2 _7806_/B vssd1 vssd1 vccd1 vccd1 sky130_fd_sc_hd__diode_2
X_8317_ _8451_/D input8/X _8397_/D vssd1 vssd1 vccd1 vccd1 _8392_/D sky130_fd_sc_hd__mux2_1
X_5529_ _5529_/A _5529_/B vssd1 vssd1 vccd1 vccd1 _5584_/A sky130_fd_sc_hd__xnor2_2
X_8248_ _8248_/A _8248_/B vssd1 vssd1 vccd1 vccd1 _8249_/B sky130_fd_sc_hd__nor2_2
X_8179_ _8179_/A _8179_/B vssd1 vssd1 vccd1 vccd1 _8179_/X sky130_fd_sc_hd__xor2_2
Xfanout220 _7862_/B vssd1 vssd1 vccd1 vccd1 _6892_/B sky130_fd_sc_hd__clkdlybuf4s25_1
Xfanout231 _8371_/Q vssd1 vssd1 vccd1 vccd1 _5417_/D sky130_fd_sc_hd__clkdlybuf4s25_1
XANTENNA__5930__A _5930_/A vssd1 vssd1 vccd1 vccd1 sky130_fd_sc_hd__diode_2
Xfanout242 _8103_/A vssd1 vssd1 vccd1 vccd1 _7895_/A sky130_fd_sc_hd__clkdlybuf4s25_1
Xfanout253 _8367_/Q vssd1 vssd1 vccd1 vccd1 _6438_/A sky130_fd_sc_hd__clkdlybuf4s25_1
Xfanout264 _5838_/C vssd1 vssd1 vccd1 vccd1 _5569_/D sky130_fd_sc_hd__clkdlybuf4s25_1
XANTENNA__6745__B _7326_/B vssd1 vssd1 vccd1 vccd1 sky130_fd_sc_hd__diode_2
XFILLER_86_251 vssd1 vssd1 vccd1 vccd1 sky130_fd_sc_hd__fill_1
Xfanout275 _6548_/A vssd1 vssd1 vccd1 vccd1 _5594_/B sky130_fd_sc_hd__clkdlybuf4s25_1
Xfanout286 _8354_/Q vssd1 vssd1 vccd1 vccd1 _8126_/B sky130_fd_sc_hd__clkdlybuf4s25_1
Xfanout297 _6517_/D vssd1 vssd1 vccd1 vccd1 _7249_/C sky130_fd_sc_hd__clkdlybuf4s25_1
XANTENNA__8018__A _8125_/A vssd1 vssd1 vccd1 vccd1 sky130_fd_sc_hd__diode_2
XFILLER_75_57 vssd1 vssd1 vccd1 vccd1 sky130_fd_sc_hd__fill_2
XFILLER_15_502 vssd1 vssd1 vccd1 vccd1 sky130_fd_sc_hd__fill_2
XANTENNA__8012__A2 _7877_/B vssd1 vssd1 vccd1 vccd1 sky130_fd_sc_hd__diode_2
XFILLER_54_181 vssd1 vssd1 vccd1 vccd1 sky130_fd_sc_hd__fill_2
XANTENNA__6574__A2 _6701_/B vssd1 vssd1 vccd1 vccd1 sky130_fd_sc_hd__diode_2
XFILLER_30_516 vssd1 vssd1 vccd1 vccd1 sky130_fd_sc_hd__fill_2
XFILLER_6_244 vssd1 vssd1 vccd1 vccd1 sky130_fd_sc_hd__fill_1
XTAP_TAPCELL_ROW_40_599 vssd1 vccd1 sky130_fd_sc_hd__tapvpwrvgnd_1
XFILLER_40_71 vssd1 vssd1 vccd1 vccd1 sky130_fd_sc_hd__fill_1
XANTENNA__6001__A _6001_/A vssd1 vssd1 vccd1 vccd1 sky130_fd_sc_hd__diode_2
XANTENNA__5837__B2 _8228_/A vssd1 vssd1 vccd1 vccd1 sky130_fd_sc_hd__diode_2
XANTENNA__5840__A _6433_/A vssd1 vssd1 vccd1 vccd1 sky130_fd_sc_hd__diode_2
XFILLER_77_262 vssd1 vssd1 vccd1 vccd1 sky130_fd_sc_hd__fill_8
XFILLER_1_43 vssd1 vssd1 vccd1 vccd1 sky130_fd_sc_hd__fill_1
XFILLER_1_54 vssd1 vssd1 vccd1 vccd1 sky130_fd_sc_hd__fill_2
XFILLER_37_126 vssd1 vssd1 vccd1 vccd1 sky130_fd_sc_hd__fill_2
XFILLER_80_405 vssd1 vssd1 vccd1 vccd1 sky130_fd_sc_hd__fill_4
XTAP_TAPCELL_ROW_76_964 vssd1 vccd1 sky130_fd_sc_hd__tapvpwrvgnd_1
XTAP_TAPCELL_ROW_48_677 vssd1 vccd1 sky130_fd_sc_hd__tapvpwrvgnd_1
XFILLER_92_265 vssd1 vssd1 vccd1 vccd1 sky130_fd_sc_hd__fill_2
XFILLER_92_243 vssd1 vssd1 vccd1 vccd1 sky130_fd_sc_hd__fill_8
XANTENNA__8003__A2 _7897_/B vssd1 vssd1 vccd1 vccd1 sky130_fd_sc_hd__diode_2
XFILLER_52_129 vssd1 vssd1 vccd1 vccd1 sky130_fd_sc_hd__fill_1
XFILLER_73_490 vssd1 vssd1 vccd1 vccd1 sky130_fd_sc_hd__fill_4
X_5880_ _5692_/A _5692_/B _5512_/A vssd1 vssd1 vccd1 vccd1 _5881_/B sky130_fd_sc_hd__a21bo_2
X_4900_ _4900_/A _5017_/B _4900_/C vssd1 vssd1 vccd1 vccd1 _4902_/C sky130_fd_sc_hd__nand3_2
XTAP_TAPCELL_ROW_86_1060 vssd1 vccd1 sky130_fd_sc_hd__tapvpwrvgnd_1
X_4831_ _4831_/A _4831_/B vssd1 vssd1 vccd1 vccd1 _4833_/A sky130_fd_sc_hd__nor2_2
XFILLER_60_195 vssd1 vssd1 vccd1 vccd1 sky130_fd_sc_hd__fill_1
X_7550_ _7889_/A _7889_/B _8125_/B _7897_/B vssd1 vssd1 vccd1 vccd1 _7551_/B sky130_fd_sc_hd__and4_2
X_4762_ _4762_/A _8427_/D _6704_/B wire99/X vssd1 vssd1 vccd1 vccd1 _4762_/X sky130_fd_sc_hd__and4_2
XTAP_TAPCELL_ROW_31_511 vssd1 vccd1 sky130_fd_sc_hd__tapvpwrvgnd_1
X_7481_ _7579_/B _7481_/B vssd1 vssd1 vccd1 vccd1 _7483_/B sky130_fd_sc_hd__nand2_2
X_6501_ _6405_/A _6407_/B _6405_/B vssd1 vssd1 vccd1 vccd1 _6508_/A sky130_fd_sc_hd__o21ba_2
X_4693_ _4695_/A _4695_/B vssd1 vssd1 vccd1 vccd1 _4694_/B sky130_fd_sc_hd__or2_4
X_6432_ _6432_/A _6432_/B vssd1 vssd1 vccd1 vccd1 _6434_/A sky130_fd_sc_hd__nor2_2
XANTENNA__8110__B _8110_/B vssd1 vssd1 vccd1 vccd1 sky130_fd_sc_hd__diode_2
X_8102_ _8110_/A _8103_/D _7997_/X _7999_/X vssd1 vssd1 vccd1 vccd1 _8106_/A sky130_fd_sc_hd__a31o_2
X_6363_ _6363_/A vssd1 vssd1 vccd1 vccd1 _6364_/B sky130_fd_sc_hd__inv_2
XFILLER_0_409 vssd1 vssd1 vccd1 vccd1 sky130_fd_sc_hd__fill_2
XFILLER_88_505 vssd1 vccd1 vssd1 vccd1 sky130_ef_sc_hd__decap_40_12
X_6294_ _6294_/A _6712_/B vssd1 vssd1 vccd1 vccd1 _6295_/B sky130_fd_sc_hd__and2_2
X_5314_ _8179_/A _5647_/A _5521_/C _5559_/C vssd1 vssd1 vccd1 vccd1 _5317_/A sky130_fd_sc_hd__and4_2
X_8033_ _8033_/A _8033_/B vssd1 vssd1 vccd1 vccd1 _8035_/A sky130_fd_sc_hd__xor2_2
X_5245_ _8407_/D _5780_/B _5899_/B _8408_/D vssd1 vssd1 vccd1 vccd1 _5246_/D sky130_fd_sc_hd__a22oi_2
XFILLER_68_273 vssd1 vssd1 vccd1 vccd1 sky130_fd_sc_hd__fill_1
X_5176_ _5177_/A _5177_/B vssd1 vssd1 vccd1 vccd1 _5176_/X sky130_fd_sc_hd__and2b_2
XANTENNA_fanout371_A fanout379/X vssd1 vssd1 vccd1 vccd1 sky130_fd_sc_hd__diode_2
XFILLER_45_27 vssd1 vssd1 vccd1 vccd1 sky130_fd_sc_hd__fill_1
XFILLER_71_427 vssd1 vssd1 vccd1 vccd1 sky130_fd_sc_hd__fill_4
XFILLER_71_449 vssd1 vssd1 vccd1 vccd1 sky130_fd_sc_hd__fill_8
XTAP_TAPCELL_ROW_19_390 vssd1 vccd1 sky130_fd_sc_hd__tapvpwrvgnd_1
XANTENNA__7753__A1 _8103_/A vssd1 vssd1 vccd1 vccd1 sky130_fd_sc_hd__diode_2
XANTENNA__7753__B2 _7754_/B vssd1 vssd1 vccd1 vccd1 sky130_fd_sc_hd__diode_2
X_7817_ _7817_/A _7817_/B vssd1 vssd1 vccd1 vccd1 _7835_/A sky130_fd_sc_hd__xor2_2
XFILLER_8_509 vssd1 vssd1 vccd1 vccd1 sky130_fd_sc_hd__fill_8
X_7748_ _7889_/A _7897_/B _8103_/D _7889_/B vssd1 vssd1 vccd1 vccd1 _7750_/A sky130_fd_sc_hd__a22oi_2
XANTENNA_wire72_X wire72/X vssd1 vssd1 vccd1 vccd1 sky130_fd_sc_hd__diode_2
X_7679_ _7679_/A _7679_/B vssd1 vssd1 vccd1 vccd1 _7698_/A sky130_fd_sc_hd__xor2_2
XFILLER_3_269 vssd1 vssd1 vccd1 vccd1 sky130_fd_sc_hd__fill_1
XANTENNA__6475__B _6476_/B vssd1 vssd1 vccd1 vccd1 sky130_fd_sc_hd__diode_2
XFILLER_86_67 vssd1 vssd1 vccd1 vccd1 sky130_fd_sc_hd__fill_8
XFILLER_86_89 vssd1 vssd1 vccd1 vccd1 sky130_fd_sc_hd__fill_1
XANTENNA__4276__A _5020_/A vssd1 vssd1 vccd1 vccd1 sky130_fd_sc_hd__diode_2
XFILLER_19_115 vssd1 vssd1 vccd1 vccd1 sky130_fd_sc_hd__fill_2
XANTENNA__7992__A1 _7889_/A vssd1 vssd1 vccd1 vccd1 sky130_fd_sc_hd__diode_2
XANTENNA__7992__B2 _7889_/B vssd1 vssd1 vccd1 vccd1 sky130_fd_sc_hd__diode_2
XTAP_TAPCELL_ROW_73_934 vssd1 vccd1 sky130_fd_sc_hd__tapvpwrvgnd_1
XANTENNA__6922__C _7723_/D vssd1 vssd1 vccd1 vccd1 sky130_fd_sc_hd__diode_2
XTAP_TAPCELL_ROW_45_647 vssd1 vccd1 sky130_fd_sc_hd__tapvpwrvgnd_1
XANTENNA__6547__A2 _8264_/A vssd1 vssd1 vccd1 vccd1 sky130_fd_sc_hd__diode_2
XFILLER_70_471 vssd1 vssd1 vccd1 vccd1 sky130_fd_sc_hd__fill_1
XPHY_EDGE_ROW_29_Left_122 vssd1 vssd1 vccd1 vccd1 sky130_fd_sc_hd__decap_3
XANTENNA__6483__A1 _6795_/A vssd1 vssd1 vccd1 vccd1 sky130_fd_sc_hd__diode_2
XANTENNA__6483__B2 _8337_/Q vssd1 vssd1 vccd1 vccd1 sky130_fd_sc_hd__diode_2
X_5030_ _5031_/B _5030_/B vssd1 vssd1 vccd1 vccd1 _5030_/Y sky130_fd_sc_hd__nand2b_2
XFILLER_25_3 vssd1 vssd1 vccd1 vccd1 sky130_fd_sc_hd__fill_1
XFILLER_65_221 vssd1 vssd1 vccd1 vccd1 sky130_fd_sc_hd__fill_1
X_6981_ _6981_/A _6981_/B vssd1 vssd1 vccd1 vccd1 _6983_/B sky130_fd_sc_hd__xor2_2
XFILLER_65_287 vssd1 vssd1 vccd1 vccd1 sky130_fd_sc_hd__fill_1
XFILLER_65_298 vssd1 vssd1 vccd1 vccd1 sky130_fd_sc_hd__fill_1
X_5932_ _5933_/A _5933_/B _5933_/C vssd1 vssd1 vccd1 vccd1 _5934_/A sky130_fd_sc_hd__o21a_2
XANTENNA__7735__A1 _8016_/A vssd1 vssd1 vccd1 vccd1 sky130_fd_sc_hd__diode_2
X_5863_ _5864_/A _5864_/B _5862_/X vssd1 vssd1 vccd1 vccd1 _5863_/X sky130_fd_sc_hd__o21ba_2
XPHY_EDGE_ROW_38_Left_131 vssd1 vssd1 vccd1 vccd1 sky130_fd_sc_hd__decap_3
XFILLER_61_493 vssd1 vssd1 vccd1 vccd1 sky130_fd_sc_hd__fill_8
X_7602_ _7602_/A _7602_/B vssd1 vssd1 vccd1 vccd1 _7605_/A sky130_fd_sc_hd__xor2_2
X_5794_ _5795_/A _5795_/B vssd1 vssd1 vccd1 vccd1 _5907_/B sky130_fd_sc_hd__or2_2
X_4814_ _5020_/A _4895_/B _4895_/C vssd1 vssd1 vccd1 vccd1 _4816_/C sky130_fd_sc_hd__nand3_2
XTAP_TAPCELL_ROW_16_360 vssd1 vccd1 sky130_fd_sc_hd__tapvpwrvgnd_1
X_7533_ _7448_/B _7450_/B _7448_/A vssd1 vssd1 vccd1 vccd1 _7543_/A sky130_fd_sc_hd__o21ba_2
X_4745_ _4902_/A _6701_/B vssd1 vssd1 vccd1 vccd1 _4750_/A sky130_fd_sc_hd__nand2_2
XANTENNA__8121__A _8121_/A vssd1 vssd1 vccd1 vccd1 sky130_fd_sc_hd__diode_2
XANTENNA__8437__RESET_B wire362/X vssd1 vssd1 vccd1 vccd1 sky130_fd_sc_hd__diode_2
X_7464_ _7464_/A _7464_/B vssd1 vssd1 vccd1 vccd1 _7474_/A sky130_fd_sc_hd__xnor2_2
X_4676_ _4676_/A _4676_/B _4682_/A vssd1 vssd1 vccd1 vccd1 _4690_/A sky130_fd_sc_hd__and3_2
X_7395_ _7395_/A _7395_/B vssd1 vssd1 vccd1 vccd1 _7397_/B sky130_fd_sc_hd__nor2_2
X_6415_ _7140_/A _6892_/C _6892_/D _8126_/A vssd1 vssd1 vccd1 vccd1 _6416_/B sky130_fd_sc_hd__a22oi_2
Xoutput29 _8328_/Q vssd1 vssd1 vccd1 vccd1 gpio_out[26] sky130_fd_sc_hd__clkdlybuf4s25_1
X_6346_ _8419_/D wire77/X vssd1 vssd1 vccd1 vccd1 _6651_/A sky130_fd_sc_hd__nand2_2
XPHY_EDGE_ROW_47_Left_140 vssd1 vssd1 vccd1 vccd1 sky130_fd_sc_hd__decap_3
XANTENNA__6576__A _6576_/A vssd1 vssd1 vccd1 vccd1 sky130_fd_sc_hd__diode_2
X_8016_ _8016_/A _8126_/A _8264_/A _8266_/A vssd1 vssd1 vccd1 vccd1 _8017_/B sky130_fd_sc_hd__and4_2
X_6277_ _6277_/A _6277_/B _6277_/C vssd1 vssd1 vccd1 vccd1 _6278_/B sky130_fd_sc_hd__or3_2
X_5228_ _5219_/A _5219_/B _5227_/X vssd1 vssd1 vccd1 vccd1 _5230_/B sky130_fd_sc_hd__a21o_2
X_5159_ _5159_/A _5159_/B vssd1 vssd1 vccd1 vccd1 _5160_/B sky130_fd_sc_hd__nor2_2
XFILLER_56_276 vssd1 vssd1 vccd1 vccd1 sky130_fd_sc_hd__fill_2
XFILLER_71_213 vssd1 vssd1 vccd1 vccd1 sky130_fd_sc_hd__fill_1
XTAP_TAPCELL_ROW_70_904 vssd1 vccd1 sky130_fd_sc_hd__tapvpwrvgnd_1
XANTENNA__8015__B _8266_/A vssd1 vssd1 vccd1 vccd1 sky130_fd_sc_hd__diode_2
XTAP_TAPCELL_ROW_42_617 vssd1 vccd1 sky130_fd_sc_hd__tapvpwrvgnd_1
XFILLER_72_69 vssd1 vssd1 vccd1 vccd1 sky130_fd_sc_hd__fill_4
XFILLER_4_567 vssd1 vssd1 vccd1 vccd1 sky130_fd_sc_hd__fill_2
XANTENNA__4293__X _5163_/C vssd1 vssd1 vccd1 vccd1 sky130_fd_sc_hd__diode_2
XTAP_TAPCELL_ROW_58_783 vssd1 vccd1 sky130_fd_sc_hd__tapvpwrvgnd_1
XTAP_TAPCELL_ROW_83_1030 vssd1 vccd1 sky130_fd_sc_hd__tapvpwrvgnd_1
XFILLER_43_482 vssd1 vssd1 vccd1 vccd1 sky130_fd_sc_hd__fill_2
XTAP_TAPCELL_ROW_13_330 vssd1 vccd1 sky130_fd_sc_hd__tapvpwrvgnd_1
X_4530_ _4530_/A1 _4521_/A _4554_/B vssd1 vssd1 vccd1 vccd1 _4541_/B sky130_fd_sc_hd__a21oi_2
XANTENNA_wire387_A wire387/A vssd1 vssd1 vccd1 vccd1 sky130_fd_sc_hd__diode_2
X_4461_ _4461_/A _4461_/B vssd1 vssd1 vccd1 vccd1 _4462_/B sky130_fd_sc_hd__xor2_2
XANTENNA__4703__A1 _8425_/D vssd1 vssd1 vccd1 vccd1 sky130_fd_sc_hd__diode_2
XANTENNA__4703__B2 _4709_/A vssd1 vssd1 vccd1 vccd1 sky130_fd_sc_hd__diode_2
X_7180_ _7179_/A _7179_/B _7179_/C vssd1 vssd1 vccd1 vccd1 _7188_/B sky130_fd_sc_hd__o21ai_2
X_6200_ _6401_/A _6199_/Y _6397_/C _6482_/A vssd1 vssd1 vccd1 vccd1 _6401_/B sky130_fd_sc_hd__and4bb_2
X_6131_ _6132_/A _6132_/B vssd1 vssd1 vccd1 vccd1 _6131_/X sky130_fd_sc_hd__or2_2
X_4392_ _4393_/B _4393_/C _4393_/A vssd1 vssd1 vccd1 vccd1 _4506_/A sky130_fd_sc_hd__o21a_2
X_6062_ _6062_/A vssd1 vssd1 vccd1 vccd1 _6062_/Y sky130_fd_sc_hd__inv_2
X_5013_ _5930_/A wire90/A _6701_/B _5747_/A vssd1 vssd1 vccd1 vccd1 _5013_/X sky130_fd_sc_hd__a22o_2
XANTENNA__4347__C _4979_/C vssd1 vssd1 vccd1 vccd1 sky130_fd_sc_hd__diode_2
XFILLER_66_541 vssd1 vssd1 vccd1 vccd1 sky130_fd_sc_hd__fill_8
XFILLER_66_552 vssd1 vssd1 vccd1 vccd1 sky130_fd_sc_hd__fill_2
XFILLER_53_202 vssd1 vssd1 vccd1 vccd1 sky130_fd_sc_hd__fill_1
X_6964_ _6964_/A _6964_/B vssd1 vssd1 vccd1 vccd1 _6965_/B sky130_fd_sc_hd__and2_2
XPHY_EDGE_ROW_5_Right_5 vssd1 vssd1 vccd1 vccd1 sky130_fd_sc_hd__decap_3
XANTENNA__4363__B _4931_/C vssd1 vssd1 vccd1 vccd1 sky130_fd_sc_hd__diode_2
X_6895_ _6895_/A _6895_/B vssd1 vssd1 vccd1 vccd1 _6897_/B sky130_fd_sc_hd__xnor2_2
X_5915_ _8409_/D _5915_/B vssd1 vssd1 vccd1 vccd1 _5916_/B sky130_fd_sc_hd__nand2_2
X_5846_ _5846_/A _5846_/B vssd1 vssd1 vccd1 vccd1 _5849_/A sky130_fd_sc_hd__xnor2_2
XANTENNA_fanout334_A _7120_/A vssd1 vssd1 vccd1 vccd1 sky130_fd_sc_hd__diode_2
X_5777_ _5775_/Y _5777_/B vssd1 vssd1 vccd1 vccd1 _5779_/A sky130_fd_sc_hd__and2b_2
X_7516_ _7714_/A _7714_/C _7714_/D _7515_/A vssd1 vssd1 vccd1 vccd1 _7517_/B sky130_fd_sc_hd__a22oi_2
Xrebuffer447 _4671_/A vssd1 vssd1 vccd1 vccd1 _4677_/A2 sky130_fd_sc_hd__buf_2
X_4728_ _4727_/A _4727_/C _4727_/B _4587_/Y vssd1 vssd1 vccd1 vccd1 _4728_/X sky130_fd_sc_hd__a31o_4
Xrebuffer469 _4616_/B vssd1 vssd1 vccd1 vccd1 _4614_/B sky130_fd_sc_hd__buf_2
Xrebuffer458 wire387/X vssd1 vssd1 vccd1 vccd1 _8179_/B sky130_fd_sc_hd__buf_2
X_7447_ _8016_/A _8136_/B _8133_/C _7875_/B vssd1 vssd1 vccd1 vccd1 _7448_/B sky130_fd_sc_hd__a22oi_2
X_4659_ _4666_/A _4666_/B _4651_/Y vssd1 vssd1 vccd1 vccd1 _4661_/A sky130_fd_sc_hd__o21a_2
X_7378_ _7378_/A _7378_/B vssd1 vssd1 vccd1 vccd1 _7381_/A sky130_fd_sc_hd__xnor2_2
X_6329_ _6330_/B _6330_/A vssd1 vssd1 vccd1 vccd1 _6609_/A sky130_fd_sc_hd__nand2b_2
XFILLER_83_57 vssd1 vssd1 vccd1 vccd1 sky130_fd_sc_hd__fill_8
XTAP_TAPCELL_ROW_55_753 vssd1 vccd1 sky130_fd_sc_hd__tapvpwrvgnd_1
XFILLER_16_51 vssd1 vssd1 vccd1 vccd1 sky130_fd_sc_hd__fill_8
XFILLER_72_566 vssd1 vssd1 vccd1 vccd1 sky130_fd_sc_hd__fill_4
XTAP_TAPCELL_ROW_27_466 vssd1 vccd1 sky130_fd_sc_hd__tapvpwrvgnd_1
XANTENNA__8359__RESET_B load_slew384/X vssd1 vssd1 vccd1 vccd1 sky130_fd_sc_hd__diode_2
XFILLER_8_136 vssd1 vssd1 vccd1 vccd1 sky130_fd_sc_hd__fill_4
XTAP_TAPCELL_ROW_10_300 vssd1 vccd1 sky130_fd_sc_hd__tapvpwrvgnd_1
XANTENNA__5816__C _6005_/B vssd1 vssd1 vccd1 vccd1 sky130_fd_sc_hd__diode_2
XFILLER_32_83 vssd1 vssd1 vccd1 vccd1 sky130_fd_sc_hd__fill_1
XANTENNA__5661__A2 _5669_/B vssd1 vssd1 vccd1 vccd1 sky130_fd_sc_hd__diode_2
XFILLER_63_555 vssd1 vssd1 vccd1 vccd1 sky130_fd_sc_hd__fill_4
XFILLER_73_90 vssd1 vssd1 vccd1 vccd1 sky130_fd_sc_hd__fill_1
X_5700_ _5141_/X _5700_/B vssd1 vssd1 vccd1 vccd1 _5759_/A sky130_fd_sc_hd__nand2b_2
X_6680_ _6681_/B vssd1 vssd1 vccd1 vccd1 _6680_/Y sky130_fd_sc_hd__inv_2
XFILLER_92_3 vssd1 vssd1 vccd1 vccd1 sky130_fd_sc_hd__fill_1
XFILLER_31_474 vssd1 vssd1 vccd1 vccd1 sky130_fd_sc_hd__fill_1
X_5631_ _5607_/A _5611_/A _8191_/A _5669_/B vssd1 vssd1 vccd1 vccd1 _5640_/A sky130_fd_sc_hd__o211a_2
X_8350_ clkload8/A _8350_/D wire377/X vssd1 vssd1 vccd1 vccd1 _8350_/Q sky130_fd_sc_hd__dfrtp_2
X_5562_ _5613_/A _5613_/B vssd1 vssd1 vccd1 vccd1 _5621_/A sky130_fd_sc_hd__and2_2
X_8281_ _8359_/Q _8360_/Q _8281_/C vssd1 vssd1 vccd1 vccd1 _8285_/B sky130_fd_sc_hd__and3_2
X_7301_ _7097_/A _7097_/B _7099_/A _7099_/B vssd1 vssd1 vccd1 vccd1 _7303_/B sky130_fd_sc_hd__a22oi_2
X_4513_ _4514_/A _4514_/B vssd1 vssd1 vccd1 vccd1 _4513_/X sky130_fd_sc_hd__and2_2
X_7232_ _7232_/A _7232_/B vssd1 vssd1 vccd1 vccd1 _7234_/A sky130_fd_sc_hd__nor2_2
X_5493_ _5493_/A _5493_/B vssd1 vssd1 vccd1 vccd1 _5494_/C sky130_fd_sc_hd__nand2_2
X_4444_ _4439_/A _4439_/B _4437_/Y vssd1 vssd1 vccd1 vccd1 _4549_/A sky130_fd_sc_hd__a21bo_2
XTAP_TAPCELL_ROW_92_1129 vssd1 vccd1 sky130_fd_sc_hd__tapvpwrvgnd_1
XTAP_TAPCELL_ROW_92_1118 vssd1 vccd1 sky130_fd_sc_hd__tapvpwrvgnd_1
X_7163_ _7163_/A _7163_/B vssd1 vssd1 vccd1 vccd1 _7166_/A sky130_fd_sc_hd__xnor2_2
X_4375_ _4375_/A _4375_/B _4375_/C vssd1 vssd1 vccd1 vccd1 _4376_/B sky130_fd_sc_hd__and3_2
X_7094_ _6994_/A _6994_/B _6992_/X vssd1 vssd1 vccd1 vccd1 _7105_/A sky130_fd_sc_hd__a21o_2
X_6114_ _6114_/A _6114_/B vssd1 vssd1 vccd1 vccd1 _6114_/Y sky130_fd_sc_hd__nand2_2
XFILLER_85_124 vssd1 vssd1 vccd1 vccd1 sky130_fd_sc_hd__fill_2
X_6045_ _6251_/B _6045_/B vssd1 vssd1 vccd1 vccd1 _6047_/C sky130_fd_sc_hd__or2_2
XFILLER_39_541 vssd1 vssd1 vccd1 vccd1 sky130_fd_sc_hd__fill_1
XANTENNA__8117__Y _8118_/B vssd1 vssd1 vccd1 vccd1 sky130_fd_sc_hd__diode_2
XANTENNA_clkbuf_4_7_0_clk_X clkload7/A vssd1 vssd1 vccd1 vccd1 sky130_fd_sc_hd__diode_2
XFILLER_54_500 vssd1 vssd1 vccd1 vccd1 sky130_fd_sc_hd__fill_2
XTAP_TAPCELL_ROW_69_889 vssd1 vccd1 sky130_fd_sc_hd__tapvpwrvgnd_1
XFILLER_54_533 vssd1 vssd1 vccd1 vccd1 sky130_fd_sc_hd__fill_4
X_7996_ _7996_/A _7996_/B vssd1 vssd1 vccd1 vccd1 _8006_/A sky130_fd_sc_hd__xnor2_2
XANTENNA__4524__D _4692_/B vssd1 vssd1 vccd1 vccd1 sky130_fd_sc_hd__diode_2
X_6947_ _6947_/A _6947_/B vssd1 vssd1 vccd1 vccd1 _6949_/A sky130_fd_sc_hd__nor2_2
XTAP_TAPCELL_ROW_52_723 vssd1 vccd1 sky130_fd_sc_hd__tapvpwrvgnd_1
XTAP_TAPCELL_ROW_24_436 vssd1 vccd1 sky130_fd_sc_hd__tapvpwrvgnd_1
X_6878_ _6688_/A _6688_/B _6684_/X vssd1 vssd1 vccd1 vccd1 _6880_/B sky130_fd_sc_hd__a21o_2
XANTENNA__4821__B _6712_/B vssd1 vssd1 vccd1 vccd1 sky130_fd_sc_hd__diode_2
X_5829_ _5829_/A _5829_/B _5829_/C vssd1 vssd1 vccd1 vccd1 _5830_/B sky130_fd_sc_hd__or3_2
XFILLER_78_35 vssd1 vssd1 vccd1 vccd1 sky130_fd_sc_hd__fill_1
XANTENNA__8290__A0 _5838_/C vssd1 vssd1 vccd1 vccd1 sky130_fd_sc_hd__diode_2
Xteam_03_420 vssd1 vssd1 vccd1 vccd1 team_03_420/HI gpio_out[17] sky130_fd_sc_hd__conb_1
Xteam_03_431 vssd1 vssd1 vccd1 vccd1 gpio_oeb[10] team_03_431/LO sky130_fd_sc_hd__conb_1
XANTENNA_input12_A gpio_in[2] vssd1 vssd1 vccd1 vccd1 sky130_fd_sc_hd__diode_2
XFILLER_27_72 vssd1 vssd1 vccd1 vccd1 sky130_fd_sc_hd__fill_1
XTAP_TAPCELL_ROW_80_1000 vssd1 vccd1 sky130_fd_sc_hd__tapvpwrvgnd_1
XFILLER_60_569 vssd1 vssd1 vccd1 vccd1 sky130_fd_sc_hd__fill_1
XFILLER_9_445 vssd1 vssd1 vccd1 vccd1 sky130_fd_sc_hd__fill_2
XANTENNA__4459__A _4674_/A vssd1 vssd1 vccd1 vccd1 sky130_fd_sc_hd__diode_2
X_4160_ _8191_/B _4160_/B vssd1 vssd1 vccd1 vccd1 _4160_/Y sky130_fd_sc_hd__nand2b_4
XFILLER_68_90 vssd1 vssd1 vccd1 vccd1 sky130_fd_sc_hd__fill_2
XFILLER_36_500 vssd1 vccd1 vssd1 vccd1 sky130_ef_sc_hd__decap_40_12
XANTENNA__4194__A _5983_/A vssd1 vssd1 vccd1 vccd1 sky130_fd_sc_hd__diode_2
X_7850_ _7850_/A _7850_/B _7850_/C vssd1 vssd1 vccd1 vccd1 _7938_/B sky130_fd_sc_hd__nand3_2
XTAP_TAPCELL_ROW_89_1091 vssd1 vccd1 sky130_fd_sc_hd__tapvpwrvgnd_1
XTAP_TAPCELL_ROW_66_859 vssd1 vccd1 sky130_fd_sc_hd__tapvpwrvgnd_1
XANTENNA__7387__A2 _8082_/C vssd1 vssd1 vccd1 vccd1 sky130_fd_sc_hd__diode_2
X_6801_ _6802_/B _6802_/A vssd1 vssd1 vccd1 vccd1 _6900_/A sky130_fd_sc_hd__nand2b_2
XFILLER_63_374 vssd1 vssd1 vccd1 vccd1 sky130_fd_sc_hd__fill_1
XFILLER_90_171 vssd1 vssd1 vccd1 vccd1 sky130_fd_sc_hd__fill_1
X_7781_ _7781_/A _7781_/B _7781_/C vssd1 vssd1 vccd1 vccd1 _7783_/A sky130_fd_sc_hd__and3_2
X_4993_ _4993_/A _4993_/B vssd1 vssd1 vccd1 vccd1 _5006_/A sky130_fd_sc_hd__xnor2_2
X_6732_ _6732_/A _6732_/B vssd1 vssd1 vccd1 vccd1 _6734_/A sky130_fd_sc_hd__xnor2_2
X_6663_ _6663_/A _6663_/B vssd1 vssd1 vccd1 vccd1 _6664_/B sky130_fd_sc_hd__nand2_2
XTAP_TAPCELL_ROW_21_406 vssd1 vccd1 sky130_fd_sc_hd__tapvpwrvgnd_1
X_8402_ _8402_/CLK _8402_/D fanout372/X vssd1 vssd1 vccd1 vccd1 _8402_/Q sky130_fd_sc_hd__dfrtp_2
X_5614_ _5621_/A _5614_/B vssd1 vssd1 vccd1 vccd1 _5634_/B sky130_fd_sc_hd__or2_2
X_6594_ _6595_/A _6595_/B vssd1 vssd1 vccd1 vccd1 _6596_/A sky130_fd_sc_hd__or2_2
X_8333_ _8334_/CLK _8333_/D load_slew381/X vssd1 vssd1 vccd1 vccd1 _8333_/Q sky130_fd_sc_hd__dfrtp_2
X_5545_ _8215_/A _5594_/B vssd1 vssd1 vccd1 vccd1 _5546_/B sky130_fd_sc_hd__nand2_2
X_8264_ _8264_/A _8264_/B vssd1 vssd1 vccd1 vccd1 _8265_/B sky130_fd_sc_hd__nor2_2
X_5476_ _5647_/A _5392_/B _5342_/B _5334_/Y vssd1 vssd1 vccd1 vccd1 _5477_/B sky130_fd_sc_hd__o2bb2a_2
XANTENNA__4369__A _5157_/A vssd1 vssd1 vccd1 vccd1 sky130_fd_sc_hd__diode_2
XANTENNA__5322__A1 _8202_/A vssd1 vssd1 vccd1 vccd1 sky130_fd_sc_hd__diode_2
XANTENNA__5322__B2 _6035_/C vssd1 vssd1 vccd1 vccd1 sky130_fd_sc_hd__diode_2
X_8195_ _8196_/A _8196_/B vssd1 vssd1 vccd1 vccd1 _8197_/A sky130_fd_sc_hd__or2_2
X_7215_ _7122_/B _7124_/B _7122_/A vssd1 vssd1 vccd1 vccd1 _7217_/B sky130_fd_sc_hd__o21ba_2
X_4427_ _4427_/A _4427_/B vssd1 vssd1 vccd1 vccd1 _4441_/B sky130_fd_sc_hd__xnor2_2
X_7146_ _7146_/A _7146_/B vssd1 vssd1 vccd1 vccd1 _7148_/B sky130_fd_sc_hd__xnor2_2
XANTENNA_input4_A gpio_in[11] vssd1 vssd1 vccd1 vccd1 sky130_fd_sc_hd__diode_2
XFILLER_48_49 vssd1 vssd1 vccd1 vccd1 sky130_fd_sc_hd__fill_1
X_4358_ _4358_/A _4358_/B vssd1 vssd1 vccd1 vccd1 _4379_/A sky130_fd_sc_hd__xnor2_2
X_7077_ _7077_/A _7077_/B vssd1 vssd1 vccd1 vccd1 _7089_/A sky130_fd_sc_hd__nor2_2
X_4289_ _4289_/A _4289_/B vssd1 vssd1 vccd1 vccd1 _4289_/Y sky130_fd_sc_hd__xnor2_2
XFILLER_86_477 vssd1 vssd1 vccd1 vccd1 sky130_fd_sc_hd__fill_1
X_6028_ _6229_/B _6027_/C _6027_/A vssd1 vssd1 vccd1 vccd1 _6029_/B sky130_fd_sc_hd__a21o_2
XANTENNA__8024__B1 _8257_/A vssd1 vssd1 vccd1 vccd1 sky130_fd_sc_hd__diode_2
XFILLER_64_15 vssd1 vssd1 vccd1 vccd1 sky130_fd_sc_hd__fill_4
XFILLER_42_514 vssd1 vssd1 vccd1 vccd1 sky130_fd_sc_hd__fill_4
X_7979_ _7980_/B vssd1 vssd1 vccd1 vccd1 _7979_/Y sky130_fd_sc_hd__inv_2
XTAP_TAPCELL_ROW_37_572 vssd1 vccd1 sky130_fd_sc_hd__tapvpwrvgnd_1
XANTENNA__4832__A _5747_/A vssd1 vssd1 vccd1 vccd1 sky130_fd_sc_hd__diode_2
XANTENNA__5928__A _5928_/A vssd1 vssd1 vccd1 vccd1 sky130_fd_sc_hd__diode_2
XANTENNA__5647__B _5669_/B vssd1 vssd1 vccd1 vccd1 sky130_fd_sc_hd__diode_2
Xfanout53 _6757_/B vssd1 vssd1 vccd1 vccd1 _6641_/B sky130_fd_sc_hd__clkdlybuf4s25_1
Xfanout42 _5981_/Y vssd1 vssd1 vccd1 vccd1 _7954_/B sky130_fd_sc_hd__clkdlybuf4s25_1
XFILLER_10_433 vssd1 vssd1 vccd1 vccd1 sky130_fd_sc_hd__fill_1
XFILLER_80_69 vssd1 vssd1 vccd1 vccd1 sky130_fd_sc_hd__fill_2
Xfanout97 _4830_/C vssd1 vssd1 vccd1 vccd1 _5147_/B sky130_fd_sc_hd__clkdlybuf4s25_1
Xfanout86 _4455_/Y vssd1 vssd1 vccd1 vccd1 _4895_/B sky130_fd_sc_hd__clkdlybuf4s25_1
XANTENNA__7862__B _7862_/B vssd1 vssd1 vccd1 vccd1 sky130_fd_sc_hd__diode_2
XFILLER_6_459 vssd1 vssd1 vccd1 vccd1 sky130_fd_sc_hd__fill_2
XFILLER_49_113 vssd1 vssd1 vccd1 vccd1 sky130_fd_sc_hd__fill_2
XTAP_TAPCELL_ROW_9_286 vssd1 vccd1 sky130_fd_sc_hd__tapvpwrvgnd_1
XANTENNA_input15_X wire387/A vssd1 vssd1 vccd1 vccd1 sky130_fd_sc_hd__diode_2
XFILLER_92_447 vssd1 vssd1 vccd1 vccd1 sky130_fd_sc_hd__fill_1
XFILLER_18_566 vssd1 vssd1 vccd1 vccd1 sky130_fd_sc_hd__fill_4
XTAP_TAPCELL_ROW_63_829 vssd1 vccd1 sky130_fd_sc_hd__tapvpwrvgnd_1
XFILLER_33_536 vssd1 vssd1 vccd1 vccd1 sky130_fd_sc_hd__fill_8
XANTENNA__8214__A _8215_/A vssd1 vssd1 vccd1 vccd1 sky130_fd_sc_hd__diode_2
XANTENNA__8318__A1 input9/X vssd1 vssd1 vccd1 vccd1 sky130_fd_sc_hd__diode_2
XANTENNA__5557__B _5657_/B vssd1 vssd1 vccd1 vccd1 sky130_fd_sc_hd__diode_2
Xclkload12 _8334_/CLK vssd1 vssd1 vccd1 vccd1 clkload12/X sky130_fd_sc_hd__clkbuf_4
XFILLER_55_3 vssd1 vssd1 vccd1 vccd1 sky130_fd_sc_hd__fill_1
X_5330_ _5348_/A _5330_/B vssd1 vssd1 vccd1 vccd1 _5458_/A sky130_fd_sc_hd__nand2_2
XFILLER_5_492 vssd1 vssd1 vccd1 vccd1 sky130_fd_sc_hd__fill_4
X_5261_ _5285_/B _5260_/C _5266_/A vssd1 vssd1 vccd1 vccd1 _5263_/B sky130_fd_sc_hd__a21o_2
XPHY_EDGE_ROW_10_Left_103 vssd1 vssd1 vccd1 vccd1 sky130_fd_sc_hd__decap_3
X_7000_ _7000_/A _7000_/B vssd1 vssd1 vccd1 vccd1 _7001_/B sky130_fd_sc_hd__xnor2_2
X_4212_ _4212_/A vssd1 vssd1 vccd1 vccd1 _7621_/A sky130_fd_sc_hd__inv_2
X_5192_ _5192_/A _5192_/B _5192_/C vssd1 vssd1 vccd1 vccd1 _5194_/A sky130_fd_sc_hd__or3_4
X_4143_ _7658_/S vssd1 vssd1 vccd1 vccd1 _6689_/A sky130_fd_sc_hd__inv_2
XFILLER_83_414 vssd1 vssd1 vccd1 vccd1 sky130_fd_sc_hd__fill_2
XTAP_TAPCELL_ROW_79_995 vssd1 vccd1 sky130_fd_sc_hd__tapvpwrvgnd_1
X_7902_ _7903_/A _7903_/B vssd1 vssd1 vccd1 vccd1 _7904_/A sky130_fd_sc_hd__and2_2
XFILLER_70_108 vssd1 vssd1 vccd1 vccd1 sky130_fd_sc_hd__fill_2
XFILLER_51_322 vssd1 vssd1 vccd1 vccd1 sky130_fd_sc_hd__fill_1
X_7833_ _7833_/A _7833_/B vssd1 vssd1 vccd1 vccd1 _7835_/B sky130_fd_sc_hd__xnor2_2
XFILLER_91_491 vssd1 vssd1 vccd1 vccd1 sky130_fd_sc_hd__fill_1
XFILLER_24_569 vssd1 vssd1 vccd1 vccd1 sky130_fd_sc_hd__fill_1
X_7764_ _7765_/A _7765_/B _7765_/C vssd1 vssd1 vccd1 vccd1 _7917_/A sky130_fd_sc_hd__a21o_2
XTAP_TAPCELL_ROW_34_542 vssd1 vccd1 sky130_fd_sc_hd__tapvpwrvgnd_1
XANTENNA__8309__A1 _8191_/B vssd1 vssd1 vccd1 vccd1 sky130_fd_sc_hd__diode_2
XANTENNA_fanout247_A _8368_/Q vssd1 vssd1 vccd1 vccd1 sky130_fd_sc_hd__diode_2
X_6715_ _6576_/A _6712_/B _6577_/A _6573_/Y vssd1 vssd1 vccd1 vccd1 _6716_/B sky130_fd_sc_hd__a31o_2
X_4976_ _4976_/A _4976_/B vssd1 vssd1 vccd1 vccd1 _4978_/B sky130_fd_sc_hd__nand2_2
X_7695_ _7696_/A _7696_/B _7696_/C vssd1 vssd1 vccd1 vccd1 _7697_/A sky130_fd_sc_hd__o21a_2
Xclkload6 clkload6/A vssd1 vssd1 vccd1 vccd1 clkload6/X sky130_fd_sc_hd__clkbuf_4
X_6646_ _8416_/D _7326_/B _6747_/A vssd1 vssd1 vccd1 vccd1 _6646_/X sky130_fd_sc_hd__a21bo_2
X_6577_ _6577_/A _6577_/B vssd1 vssd1 vccd1 vccd1 _6578_/B sky130_fd_sc_hd__xnor2_2
XANTENNA_fanout202_X _8397_/D vssd1 vssd1 vccd1 vccd1 sky130_fd_sc_hd__diode_2
X_8316_ _8450_/D input7/X _8397_/D vssd1 vssd1 vccd1 vccd1 _8391_/D sky130_fd_sc_hd__mux2_1
X_5528_ _5618_/A _5657_/B vssd1 vssd1 vccd1 vccd1 _5529_/B sky130_fd_sc_hd__nand2_2
X_8247_ _8247_/A _8247_/B vssd1 vssd1 vccd1 vccd1 _8250_/A sky130_fd_sc_hd__nand2_2
X_5459_ _5446_/A _6006_/A _5446_/C vssd1 vssd1 vccd1 vccd1 _5460_/B sky130_fd_sc_hd__a21o_2
X_8178_ _8174_/A _8177_/Y _8307_/S vssd1 vssd1 vccd1 vccd1 _8337_/D sky130_fd_sc_hd__mux2_1
Xfanout210 _8135_/A2 vssd1 vssd1 vccd1 vccd1 _7210_/C sky130_fd_sc_hd__clkdlybuf4s25_1
Xfanout221 _8374_/Q vssd1 vssd1 vccd1 vccd1 _7862_/B sky130_fd_sc_hd__clkdlybuf4s25_1
Xfanout232 _8371_/Q vssd1 vssd1 vccd1 vccd1 _6016_/B sky130_fd_sc_hd__clkdlybuf4s25_1
XANTENNA__5930__B _6712_/B vssd1 vssd1 vccd1 vccd1 sky130_fd_sc_hd__diode_2
XANTENNA_input7_X input7/X vssd1 vssd1 vccd1 vccd1 sky130_fd_sc_hd__diode_2
Xfanout243 _7998_/A vssd1 vssd1 vccd1 vccd1 _8103_/A sky130_fd_sc_hd__clkdlybuf4s25_1
Xfanout254 _8110_/A vssd1 vssd1 vccd1 vccd1 _8001_/A sky130_fd_sc_hd__clkdlybuf4s25_1
Xfanout265 _6517_/B vssd1 vssd1 vccd1 vccd1 _5838_/C sky130_fd_sc_hd__clkdlybuf4s25_1
X_7129_ _7129_/A _7862_/B _7515_/A _7714_/A vssd1 vssd1 vccd1 vccd1 _7130_/B sky130_fd_sc_hd__and4_2
XTAP_TAPCELL_ROW_6_256 vssd1 vccd1 sky130_fd_sc_hd__tapvpwrvgnd_1
Xfanout276 _6548_/A vssd1 vssd1 vccd1 vccd1 _6460_/A sky130_fd_sc_hd__clkdlybuf4s25_1
Xfanout287 _8354_/Q vssd1 vssd1 vccd1 vccd1 _8267_/B sky130_fd_sc_hd__clkdlybuf4s25_1
Xfanout298 _8350_/Q vssd1 vssd1 vccd1 vccd1 _6517_/D sky130_fd_sc_hd__clkdlybuf4s25_1
XANTENNA__8018__B _8126_/B vssd1 vssd1 vccd1 vccd1 sky130_fd_sc_hd__diode_2
XFILLER_42_311 vssd1 vssd1 vccd1 vccd1 sky130_fd_sc_hd__fill_1
XFILLER_15_547 vssd1 vssd1 vccd1 vccd1 sky130_fd_sc_hd__fill_4
XFILLER_91_57 vssd1 vssd1 vccd1 vccd1 sky130_fd_sc_hd__fill_4
XFILLER_91_79 vssd1 vssd1 vccd1 vccd1 sky130_fd_sc_hd__fill_2
XANTENNA__5837__A2 _8220_/A vssd1 vssd1 vccd1 vccd1 sky130_fd_sc_hd__diode_2
XANTENNA__5840__B _8233_/A vssd1 vssd1 vccd1 vccd1 sky130_fd_sc_hd__diode_2
XFILLER_2_495 vssd1 vssd1 vccd1 vccd1 sky130_fd_sc_hd__fill_2
XFILLER_1_22 vssd1 vssd1 vccd1 vccd1 sky130_fd_sc_hd__fill_4
XANTENNA__4456__B _6701_/B vssd1 vssd1 vccd1 vccd1 sky130_fd_sc_hd__diode_2
XTAP_TAPCELL_ROW_76_965 vssd1 vccd1 sky130_fd_sc_hd__tapvpwrvgnd_1
XTAP_TAPCELL_ROW_48_678 vssd1 vccd1 sky130_fd_sc_hd__tapvpwrvgnd_1
XFILLER_18_363 vssd1 vssd1 vccd1 vccd1 sky130_fd_sc_hd__fill_1
XFILLER_18_374 vssd1 vssd1 vccd1 vccd1 sky130_fd_sc_hd__fill_1
XFILLER_80_417 vssd1 vssd1 vccd1 vccd1 sky130_fd_sc_hd__fill_1
XTAP_TAPCELL_ROW_86_1061 vssd1 vccd1 sky130_fd_sc_hd__tapvpwrvgnd_1
XANTENNA__4472__A _4761_/A vssd1 vssd1 vccd1 vccd1 sky130_fd_sc_hd__diode_2
XANTENNA__7211__A1 _7426_/A vssd1 vssd1 vccd1 vccd1 sky130_fd_sc_hd__diode_2
XFILLER_33_333 vssd1 vssd1 vccd1 vccd1 sky130_fd_sc_hd__fill_1
X_4830_ _5928_/A _5930_/A _4830_/C _6300_/B vssd1 vssd1 vccd1 vccd1 _4831_/B sky130_fd_sc_hd__and4_2
XFILLER_21_528 vssd1 vssd1 vccd1 vccd1 sky130_fd_sc_hd__fill_4
X_4761_ _4761_/A _6300_/B vssd1 vssd1 vccd1 vccd1 _4765_/A sky130_fd_sc_hd__nand2_2
XTAP_TAPCELL_ROW_31_512 vssd1 vccd1 sky130_fd_sc_hd__tapvpwrvgnd_1
X_7480_ _7480_/A _7480_/B _7478_/Y vssd1 vssd1 vccd1 vccd1 _7481_/B sky130_fd_sc_hd__or3b_2
X_6500_ _6416_/B _6418_/B _6416_/A vssd1 vssd1 vccd1 vccd1 _6510_/A sky130_fd_sc_hd__o21ba_2
X_4692_ _8422_/D _4692_/B vssd1 vssd1 vccd1 vccd1 _4695_/B sky130_fd_sc_hd__nand2_2
X_6431_ _6517_/A _6517_/B _8241_/A _8246_/A vssd1 vssd1 vccd1 vccd1 _6432_/B sky130_fd_sc_hd__and4_2
X_6362_ _8413_/D wire66/X vssd1 vssd1 vccd1 vccd1 _6363_/A sky130_fd_sc_hd__nand2_2
X_8101_ _8101_/A _8101_/B vssd1 vssd1 vccd1 vccd1 _8144_/A sky130_fd_sc_hd__xnor2_2
X_5313_ _5313_/A _5313_/B vssd1 vssd1 vccd1 vccd1 _5319_/A sky130_fd_sc_hd__xnor2_2
XANTENNA__7007__B _7007_/B vssd1 vssd1 vccd1 vccd1 sky130_fd_sc_hd__diode_2
XFILLER_88_517 vssd1 vssd1 vccd1 vccd1 sky130_fd_sc_hd__fill_2
X_6293_ _6293_/A _6573_/A vssd1 vssd1 vccd1 vccd1 _6295_/A sky130_fd_sc_hd__xor2_2
X_8032_ _8032_/A _8136_/B vssd1 vssd1 vccd1 vccd1 _8033_/B sky130_fd_sc_hd__nand2_2
X_5244_ _8408_/D _5780_/B _5258_/A vssd1 vssd1 vccd1 vccd1 _5250_/A sky130_fd_sc_hd__and3_2
X_5175_ _4987_/A _4987_/B _4991_/B _4991_/A vssd1 vssd1 vccd1 vccd1 _5177_/B sky130_fd_sc_hd__a22o_2
XANTENNA_fanout197_A _8398_/D vssd1 vssd1 vccd1 vccd1 sky130_fd_sc_hd__diode_2
XTAP_TAPCELL_ROW_3_226 vssd1 vccd1 sky130_fd_sc_hd__tapvpwrvgnd_1
XANTENNA__6862__A _8121_/A vssd1 vssd1 vccd1 vccd1 sky130_fd_sc_hd__diode_2
XANTENNA__7958__A _7958_/A vssd1 vssd1 vccd1 vccd1 sky130_fd_sc_hd__diode_2
XFILLER_83_277 vssd1 vssd1 vccd1 vccd1 sky130_fd_sc_hd__fill_1
XFILLER_51_130 vssd1 vssd1 vccd1 vccd1 sky130_fd_sc_hd__fill_2
X_7816_ _7966_/A _8081_/B vssd1 vssd1 vccd1 vccd1 _7817_/B sky130_fd_sc_hd__nor2_2
XTAP_TAPCELL_ROW_19_391 vssd1 vccd1 sky130_fd_sc_hd__tapvpwrvgnd_1
XANTENNA__7753__A2 _7877_/B vssd1 vssd1 vccd1 vccd1 sky130_fd_sc_hd__diode_2
X_7747_ _7747_/A _7747_/B vssd1 vssd1 vccd1 vccd1 _7771_/A sky130_fd_sc_hd__xor2_2
X_4959_ _4969_/B _4958_/Y _4874_/X _4876_/Y vssd1 vssd1 vccd1 vccd1 _5037_/B sky130_fd_sc_hd__a211o_2
X_7678_ _7679_/A _7679_/B vssd1 vssd1 vccd1 vccd1 _7678_/Y sky130_fd_sc_hd__nand2_2
X_6629_ _7668_/A _7081_/B vssd1 vssd1 vccd1 vccd1 _6987_/A sky130_fd_sc_hd__nor2_2
XFILLER_10_42 vssd1 vssd1 vccd1 vccd1 sky130_fd_sc_hd__fill_1
XFILLER_86_13 vssd1 vssd1 vccd1 vccd1 sky130_fd_sc_hd__fill_2
XANTENNA__8218__A0 _8215_/A vssd1 vssd1 vccd1 vccd1 sky130_fd_sc_hd__diode_2
XFILLER_19_40 vssd1 vssd1 vccd1 vccd1 sky130_fd_sc_hd__fill_2
XFILLER_59_263 vssd1 vssd1 vccd1 vccd1 sky130_fd_sc_hd__fill_2
XANTENNA__4276__B _5147_/B vssd1 vssd1 vccd1 vccd1 sky130_fd_sc_hd__diode_2
XFILLER_59_296 vssd1 vssd1 vccd1 vccd1 sky130_fd_sc_hd__fill_4
XTAP_TAPCELL_ROW_73_935 vssd1 vccd1 sky130_fd_sc_hd__tapvpwrvgnd_1
XANTENNA__6922__D _7725_/B vssd1 vssd1 vccd1 vccd1 sky130_fd_sc_hd__diode_2
XTAP_TAPCELL_ROW_45_648 vssd1 vccd1 sky130_fd_sc_hd__tapvpwrvgnd_1
XFILLER_70_494 vssd1 vccd1 vssd1 vccd1 sky130_ef_sc_hd__decap_40_12
XFILLER_11_561 vssd1 vssd1 vccd1 vccd1 sky130_fd_sc_hd__fill_2
XFILLER_7_510 vssd1 vssd1 vccd1 vccd1 sky130_fd_sc_hd__fill_2
XFILLER_78_550 vssd1 vccd1 vssd1 vccd1 sky130_ef_sc_hd__decap_40_12
XFILLER_18_3 vssd1 vssd1 vccd1 vccd1 sky130_fd_sc_hd__fill_4
XFILLER_65_266 vssd1 vssd1 vccd1 vccd1 sky130_fd_sc_hd__fill_1
X_6980_ _6981_/B _6981_/A vssd1 vssd1 vccd1 vccd1 _7049_/A sky130_fd_sc_hd__nand2b_2
XFILLER_53_439 vssd1 vssd1 vccd1 vccd1 sky130_fd_sc_hd__fill_1
XFILLER_80_203 vssd1 vssd1 vccd1 vccd1 sky130_fd_sc_hd__fill_2
X_5931_ _5931_/A _5931_/B vssd1 vssd1 vccd1 vccd1 _5933_/C sky130_fd_sc_hd__xnor2_2
XFILLER_80_258 vssd1 vccd1 vssd1 vccd1 sky130_ef_sc_hd__decap_40_12
XANTENNA__7735__A2 _7864_/B vssd1 vssd1 vccd1 vccd1 sky130_fd_sc_hd__diode_2
X_5862_ _5404_/A _5403_/B _5403_/A vssd1 vssd1 vccd1 vccd1 _5862_/X sky130_fd_sc_hd__o21ba_2
XFILLER_33_196 vssd1 vssd1 vccd1 vccd1 sky130_fd_sc_hd__fill_1
X_7601_ _7602_/A _7602_/B vssd1 vssd1 vccd1 vccd1 _7673_/A sky130_fd_sc_hd__nand2_2
X_5793_ _5793_/A _5793_/B vssd1 vssd1 vccd1 vccd1 _5795_/B sky130_fd_sc_hd__xnor2_2
X_4813_ _5020_/A _4895_/B _4895_/C vssd1 vssd1 vccd1 vccd1 _4813_/X sky130_fd_sc_hd__and3_2
XTAP_TAPCELL_ROW_16_361 vssd1 vccd1 sky130_fd_sc_hd__tapvpwrvgnd_1
XFILLER_21_347 vssd1 vssd1 vccd1 vccd1 sky130_fd_sc_hd__fill_1
X_7532_ _7532_/A _7532_/B _7532_/C vssd1 vssd1 vccd1 vccd1 _7544_/B sky130_fd_sc_hd__nand3_2
X_4744_ _4744_/A _4897_/B vssd1 vssd1 vccd1 vccd1 _4754_/A sky130_fd_sc_hd__nand2_2
X_7463_ _8110_/B _7897_/B vssd1 vssd1 vccd1 vccd1 _7464_/B sky130_fd_sc_hd__nand2_2
X_4675_ _4676_/B _4682_/A vssd1 vssd1 vccd1 vccd1 _4683_/B sky130_fd_sc_hd__and2_2
X_7394_ _7394_/A _7394_/B vssd1 vssd1 vccd1 vccd1 _7397_/A sky130_fd_sc_hd__xnor2_2
X_6414_ _7140_/A _8126_/A _7426_/A _6892_/D vssd1 vssd1 vccd1 vccd1 _6416_/A sky130_fd_sc_hd__and4_2
X_6345_ _6345_/A _6345_/B vssd1 vssd1 vccd1 vccd1 _6384_/A sky130_fd_sc_hd__xnor2_2
XANTENNA__8406__RESET_B load_slew358/X vssd1 vssd1 vccd1 vccd1 sky130_fd_sc_hd__diode_2
X_6276_ _6277_/A _6277_/B _6277_/C vssd1 vssd1 vccd1 vccd1 _6473_/B sky130_fd_sc_hd__o21ai_2
XANTENNA__6576__B _6712_/B vssd1 vssd1 vccd1 vccd1 sky130_fd_sc_hd__diode_2
X_8015_ _8016_/A _8266_/A vssd1 vssd1 vccd1 vccd1 _8127_/A sky130_fd_sc_hd__nand2_2
X_5227_ _5229_/B _5227_/B _5237_/A vssd1 vssd1 vccd1 vccd1 _5227_/X sky130_fd_sc_hd__and3b_2
XFILLER_69_561 vssd1 vssd1 vccd1 vccd1 sky130_fd_sc_hd__fill_1
XFILLER_56_27 vssd1 vssd1 vccd1 vccd1 sky130_fd_sc_hd__fill_1
XFILLER_84_531 vssd1 vssd1 vccd1 vccd1 sky130_fd_sc_hd__fill_1
X_5158_ _5159_/A _5159_/B vssd1 vssd1 vccd1 vccd1 _5160_/A sky130_fd_sc_hd__and2_2
X_5089_ _5213_/A _5213_/B _5087_/Y vssd1 vssd1 vccd1 vccd1 _5096_/B sky130_fd_sc_hd__o21ai_2
XFILLER_71_225 vssd1 vssd1 vccd1 vccd1 sky130_fd_sc_hd__fill_4
XFILLER_71_236 vssd1 vssd1 vccd1 vccd1 sky130_fd_sc_hd__fill_4
XFILLER_24_141 vssd1 vssd1 vccd1 vccd1 sky130_fd_sc_hd__fill_2
XTAP_TAPCELL_ROW_70_905 vssd1 vccd1 sky130_fd_sc_hd__tapvpwrvgnd_1
XTAP_TAPCELL_ROW_42_618 vssd1 vccd1 sky130_fd_sc_hd__tapvpwrvgnd_1
XFILLER_12_325 vssd1 vssd1 vccd1 vccd1 sky130_fd_sc_hd__fill_1
XFILLER_21_41 vssd1 vssd1 vccd1 vccd1 sky130_fd_sc_hd__fill_2
XFILLER_67_509 vssd1 vssd1 vccd1 vccd1 sky130_fd_sc_hd__fill_2
XFILLER_46_60 vssd1 vssd1 vccd1 vccd1 sky130_fd_sc_hd__fill_4
XTAP_TAPCELL_ROW_58_784 vssd1 vccd1 sky130_fd_sc_hd__tapvpwrvgnd_1
XFILLER_90_512 vssd1 vssd1 vccd1 vccd1 sky130_fd_sc_hd__fill_2
XTAP_TAPCELL_ROW_83_1031 vssd1 vccd1 sky130_fd_sc_hd__tapvpwrvgnd_1
XTAP_TAPCELL_ROW_13_331 vssd1 vccd1 sky130_fd_sc_hd__tapvpwrvgnd_1
XFILLER_30_177 vssd1 vssd1 vccd1 vccd1 sky130_fd_sc_hd__fill_1
XFILLER_62_92 vssd1 vssd1 vccd1 vccd1 sky130_fd_sc_hd__fill_8
X_4460_ _4461_/A _4461_/B vssd1 vssd1 vccd1 vccd1 _4460_/Y sky130_fd_sc_hd__nor2_2
XFILLER_7_395 vssd1 vssd1 vccd1 vccd1 sky130_fd_sc_hd__fill_1
X_4391_ _4405_/A _4405_/B vssd1 vssd1 vccd1 vccd1 _4393_/C sky130_fd_sc_hd__nor2_2
X_6130_ _6130_/A _6130_/B vssd1 vssd1 vccd1 vccd1 _6132_/B sky130_fd_sc_hd__xnor2_2
X_6061_ _6061_/A _6061_/B _6061_/C vssd1 vssd1 vccd1 vccd1 _6062_/A sky130_fd_sc_hd__nor3_2
X_5012_ _5930_/A _6701_/B vssd1 vssd1 vccd1 vccd1 _5132_/A sky130_fd_sc_hd__nand2_2
XFILLER_38_266 vssd1 vssd1 vccd1 vccd1 sky130_fd_sc_hd__fill_1
X_6963_ _6964_/A _6964_/B vssd1 vssd1 vccd1 vccd1 _7201_/B sky130_fd_sc_hd__nor2_2
X_6894_ _7131_/A _6894_/B vssd1 vssd1 vccd1 vccd1 _6895_/B sky130_fd_sc_hd__nand2_2
X_5914_ _5914_/A _5914_/B vssd1 vssd1 vccd1 vccd1 _5916_/A sky130_fd_sc_hd__xnor2_2
XFILLER_21_111 vssd1 vssd1 vccd1 vccd1 sky130_fd_sc_hd__fill_1
XFILLER_34_483 vssd1 vssd1 vccd1 vccd1 sky130_fd_sc_hd__fill_4
X_5845_ _6438_/A _6035_/D vssd1 vssd1 vccd1 vccd1 _5846_/B sky130_fd_sc_hd__nand2_2
XFILLER_42_29 vssd1 vssd1 vccd1 vccd1 sky130_fd_sc_hd__fill_8
XFILLER_61_291 vssd1 vssd1 vccd1 vccd1 sky130_fd_sc_hd__fill_4
XANTENNA_fanout327_A _8342_/Q vssd1 vssd1 vccd1 vccd1 sky130_fd_sc_hd__diode_2
X_5776_ _5776_/A _5910_/A vssd1 vssd1 vccd1 vccd1 _5777_/B sky130_fd_sc_hd__nand2_2
X_7515_ _7515_/A _7714_/A _7714_/C _7714_/D vssd1 vssd1 vccd1 vccd1 _7517_/A sky130_fd_sc_hd__and4_2
Xrebuffer448 _4886_/X vssd1 vssd1 vccd1 vccd1 _4887_/B sky130_fd_sc_hd__buf_2
X_4727_ _4727_/A _4727_/B _4727_/C vssd1 vssd1 vccd1 vccd1 _5062_/A sky130_fd_sc_hd__and3_2
XANTENNA_fanout115_X _4487_/B vssd1 vssd1 vccd1 vccd1 sky130_fd_sc_hd__diode_2
Xrebuffer459 _4940_/A vssd1 vssd1 vccd1 vccd1 _4986_/A2 sky130_fd_sc_hd__buf_2
X_7446_ _8016_/A _7875_/B _8136_/B _8133_/C vssd1 vssd1 vccd1 vccd1 _7448_/A sky130_fd_sc_hd__and4_2
X_4658_ _4658_/A _4658_/B vssd1 vssd1 vccd1 vccd1 _4666_/B sky130_fd_sc_hd__xnor2_2
XANTENNA__6587__A _8436_/D vssd1 vssd1 vccd1 vccd1 sky130_fd_sc_hd__diode_2
X_7377_ _7378_/A _7378_/B vssd1 vssd1 vccd1 vccd1 _7636_/B sky130_fd_sc_hd__nand2_2
X_4589_ _4589_/A _4589_/B vssd1 vssd1 vccd1 vccd1 _4619_/A sky130_fd_sc_hd__xnor2_2
X_6328_ _6328_/A _6328_/B vssd1 vssd1 vccd1 vccd1 _6330_/B sky130_fd_sc_hd__xnor2_2
X_6259_ _6259_/A _6259_/B _6259_/C vssd1 vssd1 vccd1 vccd1 _6260_/B sky130_fd_sc_hd__and3_2
XFILLER_69_391 vssd1 vssd1 vccd1 vccd1 sky130_fd_sc_hd__fill_1
XTAP_TAPCELL_ROW_55_754 vssd1 vccd1 sky130_fd_sc_hd__tapvpwrvgnd_1
XTAP_TAPCELL_ROW_27_467 vssd1 vccd1 sky130_fd_sc_hd__tapvpwrvgnd_1
XFILLER_12_111 vssd1 vssd1 vccd1 vccd1 sky130_fd_sc_hd__fill_1
XFILLER_16_85 vssd1 vssd1 vccd1 vccd1 sky130_fd_sc_hd__fill_4
XPHY_EDGE_ROW_11_Right_11 vssd1 vssd1 vccd1 vccd1 sky130_fd_sc_hd__decap_3
XANTENNA__5385__B _5826_/A vssd1 vssd1 vccd1 vccd1 sky130_fd_sc_hd__diode_2
XTAP_TAPCELL_ROW_10_301 vssd1 vccd1 sky130_fd_sc_hd__tapvpwrvgnd_1
XANTENNA__8124__A2 _8263_/A vssd1 vssd1 vccd1 vccd1 sky130_fd_sc_hd__diode_2
XPHY_EDGE_ROW_20_Right_20 vssd1 vssd1 vccd1 vccd1 sky130_fd_sc_hd__decap_3
XFILLER_79_177 vssd1 vssd1 vccd1 vccd1 sky130_fd_sc_hd__fill_4
XPHY_EDGE_ROW_66_Left_159 vssd1 vssd1 vccd1 vccd1 sky130_fd_sc_hd__decap_3
XFILLER_63_512 vssd1 vssd1 vccd1 vccd1 sky130_fd_sc_hd__fill_1
XFILLER_16_472 vssd1 vssd1 vccd1 vccd1 sky130_fd_sc_hd__fill_1
XFILLER_85_3 vssd1 vssd1 vccd1 vccd1 sky130_fd_sc_hd__fill_1
X_5630_ _5638_/A _5628_/B _5629_/X vssd1 vssd1 vccd1 vccd1 _5630_/Y sky130_fd_sc_hd__o21bai_2
XPHY_EDGE_ROW_75_Left_168 vssd1 vssd1 vccd1 vccd1 sky130_fd_sc_hd__decap_3
X_5561_ _5566_/A _5561_/B vssd1 vssd1 vccd1 vccd1 _5613_/B sky130_fd_sc_hd__nor2_2
X_8280_ _8359_/Q _8281_/C vssd1 vssd1 vccd1 vccd1 _8359_/D sky130_fd_sc_hd__xor2_2
X_7300_ _7300_/A _7300_/B vssd1 vssd1 vccd1 vccd1 _7303_/A sky130_fd_sc_hd__xnor2_2
X_5492_ _5537_/A _5492_/B vssd1 vssd1 vccd1 vccd1 _5493_/B sky130_fd_sc_hd__or2_2
X_4512_ _4512_/A _4512_/B vssd1 vssd1 vccd1 vccd1 _4514_/B sky130_fd_sc_hd__xor2_2
X_7231_ _7875_/A _8136_/A _8136_/B _7875_/B vssd1 vssd1 vccd1 vccd1 _7232_/B sky130_fd_sc_hd__a22oi_2
X_4443_ _4445_/B _4445_/A vssd1 vssd1 vccd1 vccd1 _4447_/A sky130_fd_sc_hd__nand2b_2
XTAP_TAPCELL_ROW_92_1119 vssd1 vccd1 sky130_fd_sc_hd__tapvpwrvgnd_1
X_7162_ _8001_/A _8351_/Q vssd1 vssd1 vccd1 vccd1 _7163_/B sky130_fd_sc_hd__nand2_2
X_4374_ _4375_/B _4375_/C _4375_/A vssd1 vssd1 vccd1 vccd1 _4502_/A sky130_fd_sc_hd__a21oi_2
X_7093_ _6979_/A _6979_/B _6976_/Y vssd1 vssd1 vccd1 vccd1 _7107_/A sky130_fd_sc_hd__a21o_2
X_6113_ _6588_/A _6114_/B vssd1 vssd1 vccd1 vccd1 _6308_/A sky130_fd_sc_hd__nand2_2
X_6044_ _6044_/A _6044_/B vssd1 vssd1 vccd1 vccd1 _6045_/B sky130_fd_sc_hd__nor2_2
XPHY_EDGE_ROW_84_Left_177 vssd1 vssd1 vccd1 vccd1 sky130_fd_sc_hd__decap_3
XANTENNA_fanout277_A _8121_/A vssd1 vssd1 vccd1 vccd1 sky130_fd_sc_hd__diode_2
XFILLER_85_169 vssd1 vssd1 vccd1 vccd1 sky130_fd_sc_hd__fill_2
X_7995_ _8110_/B _8360_/Q vssd1 vssd1 vccd1 vccd1 _7996_/B sky130_fd_sc_hd__nand2_2
X_6946_ _6946_/A _6946_/B _6946_/C vssd1 vssd1 vccd1 vccd1 _6947_/B sky130_fd_sc_hd__and3_2
XTAP_TAPCELL_ROW_52_724 vssd1 vccd1 sky130_fd_sc_hd__tapvpwrvgnd_1
XFILLER_22_431 vssd1 vssd1 vccd1 vccd1 sky130_fd_sc_hd__fill_1
X_6877_ _6877_/A _6877_/B vssd1 vssd1 vccd1 vccd1 _6880_/A sky130_fd_sc_hd__xor2_2
XTAP_TAPCELL_ROW_24_437 vssd1 vccd1 sky130_fd_sc_hd__tapvpwrvgnd_1
X_5828_ _5829_/A _5829_/B _5829_/C vssd1 vssd1 vccd1 vccd1 _6047_/A sky130_fd_sc_hd__o21ai_2
X_5759_ _5759_/A _5759_/B vssd1 vssd1 vccd1 vccd1 _5761_/B sky130_fd_sc_hd__xnor2_2
XANTENNA__8421__RESET_B wire364/X vssd1 vssd1 vccd1 vccd1 sky130_fd_sc_hd__diode_2
X_7429_ _8133_/A _7714_/A vssd1 vssd1 vccd1 vccd1 _7430_/B sky130_fd_sc_hd__nand2_2
XFILLER_89_420 vssd1 vssd1 vccd1 vccd1 sky130_fd_sc_hd__fill_1
XFILLER_1_335 vssd1 vssd1 vccd1 vccd1 sky130_fd_sc_hd__fill_1
XFILLER_89_442 vssd1 vssd1 vccd1 vccd1 sky130_fd_sc_hd__fill_4
XFILLER_89_453 vssd1 vssd1 vccd1 vccd1 sky130_fd_sc_hd__fill_1
XANTENNA__8290__A1 _8174_/B vssd1 vssd1 vccd1 vccd1 sky130_fd_sc_hd__diode_2
XFILLER_76_103 vssd1 vssd1 vccd1 vccd1 sky130_fd_sc_hd__fill_2
XFILLER_89_475 vssd1 vssd1 vccd1 vccd1 sky130_fd_sc_hd__fill_8
Xteam_03_410 vssd1 vssd1 vccd1 vccd1 team_03_410/HI gpio_out[7] sky130_fd_sc_hd__conb_1
Xteam_03_421 vssd1 vssd1 vccd1 vccd1 gpio_oeb[0] team_03_421/LO sky130_fd_sc_hd__conb_1
Xteam_03_432 vssd1 vssd1 vccd1 vccd1 gpio_oeb[11] team_03_432/LO sky130_fd_sc_hd__conb_1
XFILLER_27_40 vssd1 vssd1 vccd1 vccd1 sky130_fd_sc_hd__fill_1
XTAP_TAPCELL_ROW_80_1001 vssd1 vccd1 sky130_fd_sc_hd__tapvpwrvgnd_1
XFILLER_40_283 vssd1 vssd1 vccd1 vccd1 sky130_fd_sc_hd__fill_4
XFILLER_9_457 vssd1 vssd1 vccd1 vccd1 sky130_fd_sc_hd__fill_1
XANTENNA__4299__X _4979_/C vssd1 vssd1 vccd1 vccd1 sky130_fd_sc_hd__diode_2
XFILLER_36_512 vssd1 vssd1 vccd1 vccd1 sky130_fd_sc_hd__fill_1
XFILLER_67_169 vssd1 vssd1 vccd1 vccd1 sky130_fd_sc_hd__fill_1
X_6800_ _6484_/B _6486_/B _6484_/A vssd1 vssd1 vccd1 vccd1 _6802_/B sky130_fd_sc_hd__o21ba_2
XTAP_TAPCELL_ROW_89_1092 vssd1 vccd1 sky130_fd_sc_hd__tapvpwrvgnd_1
XFILLER_23_206 vssd1 vssd1 vccd1 vccd1 sky130_fd_sc_hd__fill_2
XFILLER_51_515 vssd1 vssd1 vccd1 vccd1 sky130_fd_sc_hd__fill_1
X_7780_ _7780_/A _7780_/B vssd1 vssd1 vccd1 vccd1 _7781_/C sky130_fd_sc_hd__xnor2_2
X_4992_ _4944_/B _4944_/A _4942_/Y vssd1 vssd1 vccd1 vccd1 _4993_/A sky130_fd_sc_hd__o21a_2
X_6731_ _6731_/A _6731_/B vssd1 vssd1 vccd1 vccd1 _6732_/B sky130_fd_sc_hd__xor2_2
X_6662_ _6663_/A _6663_/B vssd1 vssd1 vccd1 vccd1 _6664_/A sky130_fd_sc_hd__or2_2
XTAP_TAPCELL_ROW_21_407 vssd1 vccd1 sky130_fd_sc_hd__tapvpwrvgnd_1
X_8401_ clkload3/A _8401_/D load_slew366/X vssd1 vssd1 vccd1 vccd1 _8401_/Q sky130_fd_sc_hd__dfrtp_2
X_5613_ _5613_/A _5613_/B vssd1 vssd1 vccd1 vccd1 _5614_/B sky130_fd_sc_hd__nor2_2
X_8332_ _8334_/CLK _8332_/D load_slew381/X vssd1 vssd1 vccd1 vccd1 _8332_/Q sky130_fd_sc_hd__dfrtp_2
X_6593_ _6593_/A _6593_/B vssd1 vssd1 vccd1 vccd1 _6595_/B sky130_fd_sc_hd__xnor2_2
X_5544_ _5544_/A _5544_/B vssd1 vssd1 vccd1 vccd1 _5546_/A sky130_fd_sc_hd__nor2_2
XANTENNA__8351__CLK _8405_/CLK vssd1 vssd1 vccd1 vccd1 sky130_fd_sc_hd__diode_2
X_8263_ _8263_/A _8264_/A _8263_/C vssd1 vssd1 vccd1 vccd1 _8267_/C sky130_fd_sc_hd__and3_2
X_5475_ _5475_/A _5475_/B vssd1 vssd1 vccd1 vccd1 _5491_/A sky130_fd_sc_hd__nand2_2
X_8194_ _7120_/A _8193_/Y _8307_/S vssd1 vssd1 vccd1 vccd1 _8340_/D sky130_fd_sc_hd__mux2_1
X_7214_ _7214_/A _7214_/B vssd1 vssd1 vccd1 vccd1 _7217_/A sky130_fd_sc_hd__xnor2_2
X_4426_ _4440_/A _4440_/B vssd1 vssd1 vccd1 vccd1 _4441_/A sky130_fd_sc_hd__nand2_2
XANTENNA__4369__B _4931_/C vssd1 vssd1 vccd1 vccd1 sky130_fd_sc_hd__diode_2
X_7145_ _7146_/A _7146_/B vssd1 vssd1 vccd1 vccd1 _7261_/A sky130_fd_sc_hd__nand2b_2
XFILLER_86_423 vssd1 vssd1 vccd1 vccd1 sky130_fd_sc_hd__fill_1
X_4357_ _8429_/D _4496_/D _4358_/A vssd1 vssd1 vccd1 vccd1 _4357_/X sky130_fd_sc_hd__and3_2
X_7076_ _7076_/A _7076_/B _7076_/C vssd1 vssd1 vccd1 vccd1 _7077_/B sky130_fd_sc_hd__nor3_2
X_4288_ _4235_/B _4366_/B _4233_/X vssd1 vssd1 vccd1 vccd1 _4289_/B sky130_fd_sc_hd__a21o_2
XANTENNA_fanout182_X _6712_/A vssd1 vssd1 vccd1 vccd1 sky130_fd_sc_hd__diode_2
XFILLER_58_169 vssd1 vssd1 vccd1 vccd1 sky130_fd_sc_hd__fill_1
X_6027_ _6027_/A _6229_/B _6027_/C vssd1 vssd1 vccd1 vccd1 _6029_/A sky130_fd_sc_hd__nand3_2
XFILLER_42_526 vssd1 vssd1 vccd1 vccd1 sky130_fd_sc_hd__fill_4
X_7978_ _7978_/A _7978_/B vssd1 vssd1 vccd1 vccd1 _7980_/B sky130_fd_sc_hd__or2_2
XTAP_TAPCELL_ROW_37_573 vssd1 vccd1 sky130_fd_sc_hd__tapvpwrvgnd_1
XFILLER_42_548 vssd1 vssd1 vccd1 vccd1 sky130_fd_sc_hd__fill_4
X_6929_ _6929_/A _6929_/B vssd1 vssd1 vccd1 vccd1 _6931_/B sky130_fd_sc_hd__xnor2_2
XFILLER_80_37 vssd1 vssd1 vccd1 vccd1 sky130_fd_sc_hd__fill_1
Xfanout65 _4887_/Y vssd1 vssd1 vccd1 vccd1 wire66/A sky130_fd_sc_hd__clkdlybuf4s25_1
Xfanout43 _5981_/Y vssd1 vssd1 vccd1 vccd1 _7084_/B sky130_fd_sc_hd__dlymetal6s4s_1
XFILLER_13_42 vssd1 vssd1 vccd1 vccd1 sky130_fd_sc_hd__fill_1
Xfanout98 _4919_/B vssd1 vssd1 vccd1 vccd1 wire99/A sky130_fd_sc_hd__clkdlybuf4s25_1
Xfanout87 _5149_/B vssd1 vssd1 vccd1 vccd1 _6582_/B sky130_fd_sc_hd__clkdlybuf4s25_1
XANTENNA__5010__A1 _8423_/D vssd1 vssd1 vccd1 vccd1 sky130_fd_sc_hd__diode_2
XFILLER_13_75 vssd1 vssd1 vccd1 vccd1 sky130_fd_sc_hd__fill_1
XANTENNA__7862__C _8136_/B vssd1 vssd1 vccd1 vccd1 sky130_fd_sc_hd__diode_2
XFILLER_89_57 vssd1 vssd1 vccd1 vccd1 sky130_fd_sc_hd__fill_2
XFILLER_1_165 vssd1 vssd1 vccd1 vccd1 sky130_fd_sc_hd__fill_1
XFILLER_89_272 vssd1 vssd1 vccd1 vccd1 sky130_fd_sc_hd__fill_8
XTAP_TAPCELL_ROW_9_287 vssd1 vccd1 sky130_fd_sc_hd__tapvpwrvgnd_1
XANTENNA__4295__A _5163_/B vssd1 vssd1 vccd1 vccd1 sky130_fd_sc_hd__diode_2
XFILLER_77_478 vssd1 vssd1 vccd1 vccd1 sky130_fd_sc_hd__fill_2
XFILLER_57_180 vssd1 vssd1 vccd1 vccd1 sky130_fd_sc_hd__fill_1
XFILLER_92_426 vssd1 vssd1 vccd1 vccd1 sky130_fd_sc_hd__fill_2
XANTENNA__5838__B _8220_/A vssd1 vssd1 vccd1 vccd1 sky130_fd_sc_hd__diode_2
XANTENNA__8214__B input4/X vssd1 vssd1 vccd1 vccd1 sky130_fd_sc_hd__diode_2
XFILLER_60_367 vssd1 vssd1 vccd1 vccd1 sky130_fd_sc_hd__fill_1
XFILLER_9_243 vssd1 vssd1 vccd1 vccd1 sky130_fd_sc_hd__fill_2
XFILLER_9_221 vssd1 vssd1 vccd1 vccd1 sky130_fd_sc_hd__fill_2
XFILLER_70_81 vssd1 vssd1 vccd1 vccd1 sky130_fd_sc_hd__fill_2
Xclkload13 _8405_/CLK vssd1 vssd1 vccd1 vccd1 clkload13/X sky130_fd_sc_hd__clkbuf_4
XFILLER_5_471 vssd1 vssd1 vccd1 vccd1 sky130_fd_sc_hd__fill_4
XFILLER_5_482 vssd1 vssd1 vccd1 vccd1 sky130_fd_sc_hd__fill_1
X_5260_ _5266_/A _5285_/B _5260_/C vssd1 vssd1 vccd1 vccd1 _5264_/A sky130_fd_sc_hd__nand3_2
XANTENNA_wire362_A wire362/A vssd1 vssd1 vccd1 vccd1 sky130_fd_sc_hd__diode_2
X_4211_ _4218_/S _8418_/Q _4210_/Y vssd1 vssd1 vccd1 vccd1 _4212_/A sky130_fd_sc_hd__o21ai_2
XANTENNA__6685__A _6685_/A vssd1 vssd1 vccd1 vccd1 sky130_fd_sc_hd__diode_2
X_5191_ _5191_/A _5191_/B vssd1 vssd1 vccd1 vccd1 _5192_/B sky130_fd_sc_hd__or2_2
XANTENNA__4815__A1 _5020_/A vssd1 vssd1 vccd1 vccd1 sky130_fd_sc_hd__diode_2
X_7901_ _7901_/A _7901_/B vssd1 vssd1 vccd1 vccd1 _7903_/B sky130_fd_sc_hd__xnor2_2
XANTENNA__6017__B1 _6217_/C vssd1 vssd1 vccd1 vccd1 sky130_fd_sc_hd__diode_2
X_7832_ _7833_/B _7833_/A vssd1 vssd1 vccd1 vccd1 _7962_/A sky130_fd_sc_hd__and2b_2
XFILLER_24_559 vssd1 vssd1 vccd1 vccd1 sky130_fd_sc_hd__fill_2
X_7763_ _7909_/B _7763_/B vssd1 vssd1 vccd1 vccd1 _7765_/C sky130_fd_sc_hd__or2_2
X_4975_ _4975_/A _4975_/B vssd1 vssd1 vccd1 vccd1 _4978_/A sky130_fd_sc_hd__xnor2_2
XTAP_TAPCELL_ROW_34_543 vssd1 vccd1 sky130_fd_sc_hd__tapvpwrvgnd_1
X_6714_ _6593_/A _6593_/B _6596_/A vssd1 vssd1 vccd1 vccd1 _6718_/A sky130_fd_sc_hd__o21a_2
X_7694_ _7694_/A _7694_/B vssd1 vssd1 vccd1 vccd1 _7696_/C sky130_fd_sc_hd__xor2_2
XANTENNA__5764__A _6611_/A vssd1 vssd1 vccd1 vccd1 sky130_fd_sc_hd__diode_2
XFILLER_50_29 vssd1 vssd1 vccd1 vccd1 sky130_fd_sc_hd__fill_4
Xclkload7 clkload7/A vssd1 vssd1 vccd1 vccd1 clkload7/X sky130_fd_sc_hd__clkbuf_4
X_6645_ _6645_/A _6748_/A vssd1 vssd1 vccd1 vccd1 _6761_/A sky130_fd_sc_hd__nor2_2
X_6576_ _6576_/A _6712_/B vssd1 vssd1 vccd1 vccd1 _6577_/B sky130_fd_sc_hd__nand2_2
X_8315_ _8449_/D input6/X _8397_/D vssd1 vssd1 vccd1 vccd1 _8390_/D sky130_fd_sc_hd__mux2_1
X_5527_ _5527_/A _5527_/B vssd1 vssd1 vccd1 vccd1 _5529_/A sky130_fd_sc_hd__nor2_2
X_8246_ _8246_/A input9/X vssd1 vssd1 vccd1 vccd1 _8247_/B sky130_fd_sc_hd__nand2_2
X_5458_ _5458_/A _5458_/B _5475_/A vssd1 vssd1 vccd1 vccd1 _5461_/B sky130_fd_sc_hd__nand3_2
X_8177_ _8177_/A _8177_/B vssd1 vssd1 vccd1 vccd1 _8177_/Y sky130_fd_sc_hd__nor2_2
Xfanout200 _8313_/S vssd1 vssd1 vccd1 vccd1 _8307_/S sky130_fd_sc_hd__clkdlybuf4s25_1
Xfanout211 _8377_/Q vssd1 vssd1 vccd1 vccd1 _8135_/A2 sky130_fd_sc_hd__clkdlybuf4s25_1
Xfanout222 _8374_/Q vssd1 vssd1 vccd1 vccd1 _6005_/B sky130_fd_sc_hd__clkdlybuf4s25_1
X_5389_ _5389_/A _5389_/B vssd1 vssd1 vccd1 vccd1 _5436_/A sky130_fd_sc_hd__xnor2_2
X_4409_ _4427_/A _4427_/B _4406_/Y vssd1 vssd1 vccd1 vccd1 _4411_/B sky130_fd_sc_hd__a21bo_2
XFILLER_59_445 vssd1 vssd1 vccd1 vccd1 sky130_fd_sc_hd__fill_2
XFILLER_86_231 vssd1 vssd1 vccd1 vccd1 sky130_fd_sc_hd__fill_2
Xfanout233 _8371_/Q vssd1 vssd1 vccd1 vccd1 _7875_/B sky130_fd_sc_hd__clkdlybuf4s25_1
Xfanout244 _8369_/Q vssd1 vssd1 vccd1 vccd1 _7998_/A sky130_fd_sc_hd__clkdlybuf4s25_1
Xfanout255 _8367_/Q vssd1 vssd1 vccd1 vccd1 _8110_/A sky130_fd_sc_hd__clkdlybuf4s25_1
X_7128_ _7129_/A _7515_/A _7714_/A _7862_/B vssd1 vssd1 vccd1 vccd1 _7130_/A sky130_fd_sc_hd__a22oi_2
XTAP_TAPCELL_ROW_6_257 vssd1 vccd1 sky130_fd_sc_hd__tapvpwrvgnd_1
XFILLER_46_106 vssd1 vssd1 vccd1 vccd1 sky130_fd_sc_hd__fill_4
XFILLER_75_15 vssd1 vccd1 vssd1 vccd1 sky130_ef_sc_hd__decap_40_12
XFILLER_86_253 vssd1 vssd1 vccd1 vccd1 sky130_fd_sc_hd__fill_4
Xfanout266 _6830_/B vssd1 vssd1 vccd1 vccd1 _6517_/B sky130_fd_sc_hd__clkdlybuf4s25_1
Xfanout277 _8121_/A vssd1 vssd1 vccd1 vccd1 _7990_/A sky130_fd_sc_hd__clkdlybuf4s25_1
Xfanout288 _8266_/A vssd1 vssd1 vccd1 vccd1 _7877_/B sky130_fd_sc_hd__clkdlybuf4s25_1
Xfanout299 _7725_/B vssd1 vssd1 vccd1 vccd1 _8133_/C sky130_fd_sc_hd__clkdlybuf4s25_1
X_7059_ _8418_/D wire64/X vssd1 vssd1 vccd1 vccd1 _7059_/Y sky130_fd_sc_hd__nand2_2
XFILLER_75_59 vssd1 vssd1 vccd1 vccd1 sky130_fd_sc_hd__fill_1
XANTENNA__5939__A _6712_/A vssd1 vssd1 vccd1 vccd1 sky130_fd_sc_hd__diode_2
XANTENNA_fanout55_A _6757_/B vssd1 vssd1 vccd1 vccd1 sky130_fd_sc_hd__diode_2
XFILLER_39_180 vssd1 vssd1 vccd1 vccd1 sky130_fd_sc_hd__fill_1
XFILLER_15_515 vssd1 vssd1 vccd1 vccd1 sky130_fd_sc_hd__fill_2
XFILLER_61_109 vssd1 vssd1 vccd1 vccd1 sky130_fd_sc_hd__fill_2
XFILLER_24_85 vssd1 vssd1 vccd1 vccd1 sky130_fd_sc_hd__fill_2
XFILLER_10_253 vssd1 vssd1 vccd1 vccd1 sky130_fd_sc_hd__fill_2
XFILLER_37_128 vssd1 vssd1 vccd1 vccd1 sky130_fd_sc_hd__fill_1
XFILLER_92_223 vssd1 vssd1 vccd1 vccd1 sky130_fd_sc_hd__fill_1
XFILLER_92_201 vssd1 vssd1 vccd1 vccd1 sky130_fd_sc_hd__fill_2
XFILLER_92_267 vssd1 vssd1 vccd1 vccd1 sky130_fd_sc_hd__fill_1
XTAP_TAPCELL_ROW_86_1062 vssd1 vccd1 sky130_fd_sc_hd__tapvpwrvgnd_1
XTAP_TAPCELL_ROW_48_679 vssd1 vccd1 sky130_fd_sc_hd__tapvpwrvgnd_1
XANTENNA__4472__B _5147_/B vssd1 vssd1 vccd1 vccd1 sky130_fd_sc_hd__diode_2
XANTENNA__5568__B _6433_/A vssd1 vssd1 vccd1 vccd1 sky130_fd_sc_hd__diode_2
XFILLER_60_120 vssd1 vssd1 vccd1 vccd1 sky130_fd_sc_hd__fill_2
XFILLER_60_153 vssd1 vssd1 vccd1 vccd1 sky130_fd_sc_hd__fill_1
X_4760_ _4499_/A _4499_/B _4498_/A vssd1 vssd1 vccd1 vccd1 _4767_/A sky130_fd_sc_hd__a21oi_2
XTAP_TAPCELL_ROW_31_513 vssd1 vccd1 sky130_fd_sc_hd__tapvpwrvgnd_1
X_4691_ _4691_/A _4691_/B vssd1 vssd1 vccd1 vccd1 _4695_/A sky130_fd_sc_hd__xor2_2
X_6430_ _6517_/A _8241_/A _8246_/A _6517_/B vssd1 vssd1 vccd1 vccd1 _6432_/A sky130_fd_sc_hd__a22oi_2
X_6361_ _6361_/A _6638_/A vssd1 vssd1 vccd1 vccd1 _6364_/A sky130_fd_sc_hd__xor2_2
XANTENNA__8110__D _8361_/Q vssd1 vssd1 vccd1 vccd1 sky130_fd_sc_hd__diode_2
X_8100_ _8035_/A _8035_/B _8038_/A vssd1 vssd1 vccd1 vccd1 _8101_/B sky130_fd_sc_hd__a21o_2
X_5312_ _5312_/A _5312_/B vssd1 vssd1 vccd1 vccd1 _5313_/B sky130_fd_sc_hd__nor2_2
XPHY_EDGE_ROW_49_Right_49 vssd1 vssd1 vccd1 vccd1 sky130_fd_sc_hd__decap_3
X_6292_ _6712_/A _6701_/B vssd1 vssd1 vccd1 vccd1 _6573_/A sky130_fd_sc_hd__nand2_2
XANTENNA__4928__A _5157_/A vssd1 vssd1 vccd1 vccd1 sky130_fd_sc_hd__diode_2
XFILLER_88_529 vssd1 vssd1 vccd1 vccd1 sky130_fd_sc_hd__fill_2
X_8031_ _8136_/C _8030_/X _8029_/X vssd1 vssd1 vccd1 vccd1 _8033_/A sky130_fd_sc_hd__a21bo_2
X_5243_ _8407_/D _5899_/B vssd1 vssd1 vccd1 vccd1 _5258_/A sky130_fd_sc_hd__and2_2
XANTENNA__7304__A _7304_/A vssd1 vssd1 vccd1 vccd1 sky130_fd_sc_hd__diode_2
X_5174_ _5174_/A _5174_/B vssd1 vssd1 vccd1 vccd1 _5177_/A sky130_fd_sc_hd__xnor2_2
XFILLER_68_253 vssd1 vssd1 vccd1 vccd1 sky130_fd_sc_hd__fill_4
XTAP_TAPCELL_ROW_3_227 vssd1 vccd1 sky130_fd_sc_hd__tapvpwrvgnd_1
XANTENNA__6862__B _8266_/A vssd1 vssd1 vccd1 vccd1 sky130_fd_sc_hd__diode_2
XANTENNA__7958__B _8081_/B vssd1 vssd1 vccd1 vccd1 sky130_fd_sc_hd__diode_2
XFILLER_83_267 vssd1 vssd1 vccd1 vccd1 sky130_fd_sc_hd__fill_1
XPHY_EDGE_ROW_58_Right_58 vssd1 vssd1 vccd1 vccd1 sky130_fd_sc_hd__decap_3
X_7815_ _7682_/B _7813_/Y _7814_/X vssd1 vssd1 vccd1 vccd1 _7817_/A sky130_fd_sc_hd__a21oi_2
XTAP_TAPCELL_ROW_19_392 vssd1 vccd1 sky130_fd_sc_hd__tapvpwrvgnd_1
XANTENNA__4198__A_N _8164_/B vssd1 vssd1 vccd1 vccd1 sky130_fd_sc_hd__diode_2
XFILLER_51_142 vssd1 vssd1 vccd1 vccd1 sky130_fd_sc_hd__fill_2
X_7746_ _7746_/A _7746_/B vssd1 vssd1 vccd1 vccd1 _7747_/B sky130_fd_sc_hd__nand2_2
X_4958_ _4955_/Y _4956_/X _4825_/B _4872_/A vssd1 vssd1 vccd1 vccd1 _4958_/Y sky130_fd_sc_hd__o211ai_2
XANTENNA__8141__Y _8142_/B vssd1 vssd1 vccd1 vccd1 sky130_fd_sc_hd__diode_2
X_7677_ _7677_/A _7677_/B vssd1 vssd1 vccd1 vccd1 _7679_/B sky130_fd_sc_hd__xor2_2
X_4889_ _8407_/D wire66/X vssd1 vssd1 vccd1 vccd1 _4965_/B sky130_fd_sc_hd__nand2_2
XANTENNA_fanout312_X _8220_/A vssd1 vssd1 vccd1 vccd1 sky130_fd_sc_hd__diode_2
X_6628_ _7409_/A _6986_/B vssd1 vssd1 vccd1 vccd1 _6633_/A sky130_fd_sc_hd__nor2_2
XPHY_EDGE_ROW_67_Right_67 vssd1 vssd1 vccd1 vccd1 sky130_fd_sc_hd__decap_3
X_6559_ _6559_/A _6559_/B _6559_/C vssd1 vssd1 vccd1 vccd1 _6560_/B sky130_fd_sc_hd__nor3_2
X_8229_ _8236_/A _8235_/B vssd1 vssd1 vccd1 vccd1 _8230_/B sky130_fd_sc_hd__nor2_2
XFILLER_19_106 vssd1 vssd1 vccd1 vccd1 sky130_fd_sc_hd__fill_1
XFILLER_19_117 vssd1 vssd1 vccd1 vccd1 sky130_fd_sc_hd__fill_1
XPHY_EDGE_ROW_76_Right_76 vssd1 vssd1 vccd1 vccd1 sky130_fd_sc_hd__decap_3
XFILLER_19_85 vssd1 vccd1 vssd1 vccd1 sky130_ef_sc_hd__decap_40_12
XANTENNA__6491__C _6798_/B vssd1 vssd1 vccd1 vccd1 sky130_fd_sc_hd__diode_2
XTAP_TAPCELL_ROW_45_649 vssd1 vccd1 sky130_fd_sc_hd__tapvpwrvgnd_1
XFILLER_70_440 vssd1 vssd1 vccd1 vccd1 sky130_fd_sc_hd__fill_1
XPHY_EDGE_ROW_85_Right_85 vssd1 vssd1 vccd1 vccd1 sky130_fd_sc_hd__decap_3
XANTENNA__8412__CLK clkload7/A vssd1 vssd1 vccd1 vccd1 sky130_fd_sc_hd__diode_2
XFILLER_78_562 vssd1 vssd1 vccd1 vccd1 sky130_fd_sc_hd__fill_8
XANTENNA__5579__A _5842_/B vssd1 vssd1 vccd1 vccd1 sky130_fd_sc_hd__diode_2
X_5930_ _5930_/A _6712_/B vssd1 vssd1 vccd1 vccd1 _5931_/B sky130_fd_sc_hd__nand2_2
X_7600_ _7668_/A _7966_/B vssd1 vssd1 vccd1 vccd1 _7602_/B sky130_fd_sc_hd__nor2_2
X_5861_ _5860_/A _5860_/B _5860_/C vssd1 vssd1 vccd1 vccd1 _5868_/B sky130_fd_sc_hd__a21oi_2
XFILLER_33_164 vssd1 vssd1 vccd1 vccd1 sky130_fd_sc_hd__fill_4
X_5792_ _5793_/A _5793_/B vssd1 vssd1 vccd1 vccd1 _5907_/A sky130_fd_sc_hd__or2_2
X_4812_ _4812_/A _4812_/B vssd1 vssd1 vccd1 vccd1 _4812_/Y sky130_fd_sc_hd__xnor2_2
XTAP_TAPCELL_ROW_16_362 vssd1 vccd1 sky130_fd_sc_hd__tapvpwrvgnd_1
X_7531_ _7532_/A _7532_/B _7532_/C vssd1 vssd1 vccd1 vccd1 _7746_/A sky130_fd_sc_hd__a21o_2
X_4743_ _4743_/A _4743_/B vssd1 vssd1 vccd1 vccd1 _4743_/X sky130_fd_sc_hd__xor2_2
X_7462_ _7462_/A _7462_/B vssd1 vssd1 vccd1 vccd1 _7464_/A sky130_fd_sc_hd__nor2_2
X_6413_ _6219_/B _6221_/B _6219_/A vssd1 vssd1 vccd1 vccd1 _6423_/A sky130_fd_sc_hd__o21ba_2
X_4674_ _4674_/A _5703_/B _4697_/B vssd1 vssd1 vccd1 vccd1 _4682_/A sky130_fd_sc_hd__or3_4
X_7393_ _7393_/A _7393_/B vssd1 vssd1 vccd1 vccd1 _7394_/B sky130_fd_sc_hd__xnor2_2
X_6344_ _6345_/B _6345_/A vssd1 vssd1 vccd1 vccd1 _6344_/Y sky130_fd_sc_hd__nand2b_2
X_6275_ _6473_/A _6275_/B vssd1 vssd1 vccd1 vccd1 _6277_/C sky130_fd_sc_hd__and2_2
X_8014_ _8016_/A _8264_/A _8266_/A _8126_/A vssd1 vssd1 vccd1 vccd1 _8017_/A sky130_fd_sc_hd__a22oi_2
X_5226_ _5229_/B _5227_/B vssd1 vssd1 vccd1 vccd1 _5237_/B sky130_fd_sc_hd__nand2b_2
XANTENNA__7969__A _7969_/A vssd1 vssd1 vccd1 vccd1 sky130_fd_sc_hd__diode_2
X_5157_ _5157_/A wire99/X vssd1 vssd1 vccd1 vccd1 _5159_/B sky130_fd_sc_hd__nand2_2
X_5088_ _5088_/A _5088_/B vssd1 vssd1 vccd1 vccd1 _5213_/B sky130_fd_sc_hd__xnor2_2
XANTENNA_fanout262_X _6830_/A vssd1 vssd1 vccd1 vccd1 sky130_fd_sc_hd__diode_2
XFILLER_37_481 vssd1 vssd1 vccd1 vccd1 sky130_fd_sc_hd__fill_4
XFILLER_52_462 vssd1 vssd1 vccd1 vccd1 sky130_fd_sc_hd__fill_1
XTAP_TAPCELL_ROW_42_619 vssd1 vccd1 sky130_fd_sc_hd__tapvpwrvgnd_1
XFILLER_52_495 vssd1 vssd1 vccd1 vccd1 sky130_fd_sc_hd__fill_4
X_7729_ _7870_/B _7729_/B vssd1 vssd1 vccd1 vccd1 _7731_/C sky130_fd_sc_hd__nand2_2
XANTENNA__8435__CLK clkload4/A vssd1 vssd1 vccd1 vccd1 sky130_fd_sc_hd__diode_2
XFILLER_21_20 vssd1 vccd1 vssd1 vccd1 sky130_ef_sc_hd__decap_40_12
XTAP_TAPCELL_ROW_50_696 vssd1 vccd1 sky130_fd_sc_hd__tapvpwrvgnd_1
XFILLER_4_503 vssd1 vssd1 vccd1 vccd1 sky130_fd_sc_hd__fill_1
XANTENNA__4213__A_N input8/X vssd1 vssd1 vccd1 vccd1 sky130_fd_sc_hd__diode_2
XFILLER_4_569 vssd1 vssd1 vccd1 vccd1 sky130_fd_sc_hd__fill_1
XFILLER_79_337 vssd1 vssd1 vccd1 vccd1 sky130_fd_sc_hd__fill_2
XFILLER_47_223 vssd1 vssd1 vccd1 vccd1 sky130_fd_sc_hd__fill_1
XFILLER_47_278 vssd1 vssd1 vccd1 vccd1 sky130_fd_sc_hd__fill_2
XTAP_TAPCELL_ROW_58_785 vssd1 vccd1 sky130_fd_sc_hd__tapvpwrvgnd_1
XFILLER_62_237 vssd1 vssd1 vccd1 vccd1 sky130_fd_sc_hd__fill_4
Xmax_cap40 _6609_/B vssd1 vssd1 vccd1 vccd1 _7095_/B sky130_fd_sc_hd__buf_4
XTAP_TAPCELL_ROW_83_1032 vssd1 vccd1 sky130_fd_sc_hd__tapvpwrvgnd_1
XFILLER_15_186 vssd1 vssd1 vccd1 vccd1 sky130_fd_sc_hd__fill_1
XFILLER_15_197 vssd1 vssd1 vccd1 vccd1 sky130_fd_sc_hd__fill_1
XFILLER_70_292 vssd1 vssd1 vccd1 vccd1 sky130_fd_sc_hd__fill_2
XTAP_TAPCELL_ROW_13_332 vssd1 vccd1 sky130_fd_sc_hd__tapvpwrvgnd_1
XFILLER_7_55 vssd1 vssd1 vccd1 vccd1 sky130_fd_sc_hd__fill_1
XFILLER_7_374 vssd1 vssd1 vccd1 vccd1 sky130_fd_sc_hd__fill_1
XFILLER_7_385 vssd1 vssd1 vccd1 vccd1 sky130_fd_sc_hd__fill_1
X_4390_ _4390_/A _4390_/B vssd1 vssd1 vccd1 vccd1 _4405_/B sky130_fd_sc_hd__xor2_2
XFILLER_30_3 vssd1 vssd1 vccd1 vccd1 sky130_fd_sc_hd__fill_2
X_6060_ _6060_/A _6060_/B vssd1 vssd1 vccd1 vccd1 _6061_/C sky130_fd_sc_hd__xor2_2
X_5011_ _4917_/A _4917_/B _4915_/X vssd1 vssd1 vccd1 vccd1 _5024_/A sky130_fd_sc_hd__a21oi_2
XFILLER_53_215 vssd1 vssd1 vccd1 vccd1 sky130_fd_sc_hd__fill_8
XFILLER_81_524 vssd1 vssd1 vccd1 vccd1 sky130_fd_sc_hd__fill_4
X_6962_ _6870_/A _6870_/B _6872_/B _6874_/Y vssd1 vssd1 vccd1 vccd1 _6964_/B sky130_fd_sc_hd__o31a_2
X_6893_ _6893_/A _6893_/B vssd1 vssd1 vccd1 vccd1 _6895_/A sky130_fd_sc_hd__nor2_2
X_5913_ _5914_/A _5914_/B vssd1 vssd1 vccd1 vccd1 _5913_/Y sky130_fd_sc_hd__nand2_2
X_5844_ _5844_/A _5844_/B vssd1 vssd1 vccd1 vccd1 _5846_/A sky130_fd_sc_hd__nor2_2
XFILLER_61_281 vssd1 vssd1 vccd1 vccd1 sky130_fd_sc_hd__fill_2
X_7514_ hold546/X _7513_/X _7658_/S vssd1 vssd1 vccd1 vccd1 _8329_/D sky130_fd_sc_hd__mux2_1
X_5775_ _5775_/A _5775_/B vssd1 vssd1 vccd1 vccd1 _5775_/Y sky130_fd_sc_hd__nor2_2
X_4726_ _4724_/Y _5052_/A _5054_/A _4642_/X vssd1 vssd1 vccd1 vccd1 _4727_/C sky130_fd_sc_hd__a211o_4
Xrebuffer449 _7661_/A3 vssd1 vssd1 vccd1 vccd1 _7513_/B sky130_fd_sc_hd__buf_2
X_7445_ _7220_/A _7222_/B _7220_/B vssd1 vssd1 vccd1 vccd1 _7452_/A sky130_fd_sc_hd__o21ba_2
X_4657_ _8422_/D _4657_/B _4979_/C vssd1 vssd1 vccd1 vccd1 _4658_/B sky130_fd_sc_hd__and3_2
X_7376_ _7376_/A _7376_/B vssd1 vssd1 vccd1 vccd1 _7378_/B sky130_fd_sc_hd__xor2_2
X_6327_ _6327_/A _6327_/B vssd1 vssd1 vccd1 vccd1 _6328_/B sky130_fd_sc_hd__xnor2_2
X_4588_ _4588_/A _4588_/B vssd1 vssd1 vccd1 vccd1 _4727_/A sky130_fd_sc_hd__xor2_2
XFILLER_88_123 vssd1 vssd1 vccd1 vccd1 sky130_fd_sc_hd__fill_4
XFILLER_67_16 vssd1 vssd1 vccd1 vccd1 sky130_fd_sc_hd__fill_2
X_6258_ _6259_/A _6259_/B _6259_/C vssd1 vssd1 vccd1 vccd1 _6260_/A sky130_fd_sc_hd__a21oi_2
XFILLER_67_49 vssd1 vssd1 vccd1 vccd1 sky130_fd_sc_hd__fill_2
X_6189_ _6190_/A _6190_/B vssd1 vssd1 vccd1 vccd1 _6385_/B sky130_fd_sc_hd__nand2b_2
X_5209_ _5099_/Y _5234_/A _5694_/B _5208_/X vssd1 vssd1 vccd1 vccd1 _5209_/X sky130_fd_sc_hd__o211a_2
XANTENNA__5012__A _5930_/A vssd1 vssd1 vccd1 vccd1 sky130_fd_sc_hd__diode_2
XFILLER_72_535 vssd1 vssd1 vccd1 vccd1 sky130_fd_sc_hd__fill_1
XFILLER_83_37 vssd1 vssd1 vccd1 vccd1 sky130_fd_sc_hd__fill_4
XFILLER_25_451 vssd1 vssd1 vccd1 vccd1 sky130_fd_sc_hd__fill_1
XTAP_TAPCELL_ROW_55_755 vssd1 vccd1 sky130_fd_sc_hd__tapvpwrvgnd_1
XTAP_TAPCELL_ROW_27_468 vssd1 vccd1 sky130_fd_sc_hd__tapvpwrvgnd_1
XFILLER_40_421 vssd1 vssd1 vccd1 vccd1 sky130_fd_sc_hd__fill_1
XFILLER_52_281 vssd1 vssd1 vccd1 vccd1 sky130_fd_sc_hd__fill_2
XANTENNA__8109__B1 _8361_/Q vssd1 vssd1 vccd1 vccd1 sky130_fd_sc_hd__diode_2
XTAP_TAPCELL_ROW_10_302 vssd1 vccd1 sky130_fd_sc_hd__tapvpwrvgnd_1
XANTENNA__4146__A1 _4207_/B vssd1 vssd1 vccd1 vccd1 sky130_fd_sc_hd__diode_2
XFILLER_79_101 vssd1 vssd1 vccd1 vccd1 sky130_fd_sc_hd__fill_4
XFILLER_0_550 vssd1 vssd1 vccd1 vccd1 sky130_fd_sc_hd__fill_2
XANTENNA__4745__B _6701_/B vssd1 vssd1 vccd1 vccd1 sky130_fd_sc_hd__diode_2
XFILLER_75_351 vssd1 vssd1 vccd1 vccd1 sky130_fd_sc_hd__fill_2
XFILLER_90_321 vssd1 vssd1 vccd1 vccd1 sky130_fd_sc_hd__fill_1
XANTENNA__4761__A _4761_/A vssd1 vssd1 vccd1 vccd1 sky130_fd_sc_hd__diode_2
XANTENNA__8233__A _8233_/A vssd1 vssd1 vccd1 vccd1 sky130_fd_sc_hd__diode_2
XFILLER_43_281 vssd1 vssd1 vccd1 vccd1 sky130_fd_sc_hd__fill_1
XFILLER_78_3 vssd1 vssd1 vccd1 vccd1 sky130_fd_sc_hd__fill_4
X_5560_ _5583_/A _5559_/C _5612_/B _5559_/B vssd1 vssd1 vccd1 vccd1 _5561_/B sky130_fd_sc_hd__a22oi_2
X_5491_ _5491_/A _5491_/B _5518_/A vssd1 vssd1 vccd1 vccd1 _5494_/B sky130_fd_sc_hd__and3_2
X_4511_ _4511_/A _4511_/B vssd1 vssd1 vccd1 vccd1 _4512_/B sky130_fd_sc_hd__xnor2_2
X_7230_ _7875_/A _7875_/B _8136_/A _8136_/B vssd1 vssd1 vccd1 vccd1 _7232_/A sky130_fd_sc_hd__and4_2
X_4442_ _4544_/A _4440_/X _4428_/Y vssd1 vssd1 vccd1 vccd1 _4445_/B sky130_fd_sc_hd__o21a_2
X_7161_ _7161_/A _7161_/B vssd1 vssd1 vccd1 vccd1 _7163_/A sky130_fd_sc_hd__nor2_2
X_4373_ _4386_/A _4373_/B vssd1 vssd1 vccd1 vccd1 _4375_/C sky130_fd_sc_hd__nand2b_2
X_7092_ _7092_/A _7092_/B vssd1 vssd1 vccd1 vccd1 _7108_/A sky130_fd_sc_hd__xnor2_4
X_6112_ _6112_/A _6112_/B vssd1 vssd1 vccd1 vccd1 _6123_/A sky130_fd_sc_hd__xnor2_2
XFILLER_85_115 vssd1 vssd1 vccd1 vccd1 sky130_fd_sc_hd__fill_1
X_6043_ _6044_/A _6044_/B vssd1 vssd1 vccd1 vccd1 _6251_/B sky130_fd_sc_hd__and2_2
X_7994_ _7994_/A _7994_/B vssd1 vssd1 vccd1 vccd1 _7996_/A sky130_fd_sc_hd__nor2_2
XANTENNA__7966__B _7966_/B vssd1 vssd1 vccd1 vccd1 sky130_fd_sc_hd__diode_2
X_6945_ _6946_/A _6946_/B _6946_/C vssd1 vssd1 vccd1 vccd1 _6947_/A sky130_fd_sc_hd__a21oi_2
Xteam_03 vssd1 vssd1 vccd1 vccd1 team_03/HI gpio_oeb[18] sky130_fd_sc_hd__conb_1
XTAP_TAPCELL_ROW_52_725 vssd1 vccd1 sky130_fd_sc_hd__tapvpwrvgnd_1
XANTENNA__7876__A1_N _8125_/A vssd1 vssd1 vccd1 vccd1 sky130_fd_sc_hd__diode_2
X_6876_ _6877_/A _6877_/B vssd1 vssd1 vccd1 vccd1 _6876_/X sky130_fd_sc_hd__and2_2
XTAP_TAPCELL_ROW_24_438 vssd1 vccd1 sky130_fd_sc_hd__tapvpwrvgnd_1
X_5827_ _5827_/A _5827_/B vssd1 vssd1 vccd1 vccd1 _5829_/C sky130_fd_sc_hd__xnor2_2
XANTENNA_fanout225_X _6006_/A vssd1 vssd1 vccd1 vccd1 sky130_fd_sc_hd__diode_2
X_5758_ _5758_/A _5758_/B vssd1 vssd1 vccd1 vccd1 _5759_/B sky130_fd_sc_hd__xnor2_2
X_4709_ _4709_/A _4709_/B _4709_/C _4709_/D vssd1 vssd1 vccd1 vccd1 _4713_/A sky130_fd_sc_hd__nand4_2
X_7428_ _7428_/A _7428_/B vssd1 vssd1 vccd1 vccd1 _7430_/A sky130_fd_sc_hd__nor2_2
X_5689_ _5684_/Y _5685_/Y _5687_/Y _5688_/X _5686_/X vssd1 vssd1 vccd1 vccd1 _5689_/Y
+ sky130_fd_sc_hd__o221ai_2
X_7359_ _7359_/A _7359_/B vssd1 vssd1 vccd1 vccd1 _7361_/A sky130_fd_sc_hd__xnor2_4
XFILLER_89_465 vssd1 vssd1 vccd1 vccd1 sky130_fd_sc_hd__fill_1
Xteam_03_400 vssd1 vssd1 vccd1 vccd1 team_03_400/HI gpio_oeb[31] sky130_fd_sc_hd__conb_1
Xteam_03_411 vssd1 vssd1 vccd1 vccd1 team_03_411/HI gpio_out[8] sky130_fd_sc_hd__conb_1
Xteam_03_422 vssd1 vssd1 vccd1 vccd1 gpio_oeb[1] team_03_422/LO sky130_fd_sc_hd__conb_1
Xteam_03_433 vssd1 vssd1 vccd1 vccd1 gpio_oeb[12] team_03_433/LO sky130_fd_sc_hd__conb_1
XANTENNA__4565__B _4692_/B vssd1 vssd1 vccd1 vccd1 sky130_fd_sc_hd__diode_2
XTAP_TAPCELL_ROW_68_880 vssd1 vccd1 sky130_fd_sc_hd__tapvpwrvgnd_1
XANTENNA__7250__B1 _8351_/Q vssd1 vssd1 vccd1 vccd1 sky130_fd_sc_hd__diode_2
XTAP_TAPCELL_ROW_80_1002 vssd1 vccd1 sky130_fd_sc_hd__tapvpwrvgnd_1
XFILLER_13_454 vssd1 vssd1 vccd1 vccd1 sky130_fd_sc_hd__fill_1
XFILLER_9_447 vssd1 vssd1 vccd1 vccd1 sky130_fd_sc_hd__fill_1
XFILLER_4_141 vssd1 vssd1 vccd1 vccd1 sky130_fd_sc_hd__fill_4
XANTENNA__8228__A _8228_/A vssd1 vssd1 vccd1 vccd1 sky130_fd_sc_hd__diode_2
XFILLER_67_126 vssd1 vssd1 vccd1 vccd1 sky130_fd_sc_hd__fill_1
XANTENNA__6971__A _7299_/A vssd1 vssd1 vccd1 vccd1 sky130_fd_sc_hd__diode_2
XFILLER_63_354 vssd1 vssd1 vccd1 vccd1 sky130_fd_sc_hd__fill_2
XFILLER_75_192 vssd1 vssd1 vccd1 vccd1 sky130_fd_sc_hd__fill_1
XTAP_TAPCELL_ROW_89_1093 vssd1 vccd1 sky130_fd_sc_hd__tapvpwrvgnd_1
X_6730_ _6731_/A _6731_/B vssd1 vssd1 vccd1 vccd1 _6730_/Y sky130_fd_sc_hd__nand2b_2
X_4991_ _4991_/A _4991_/B vssd1 vssd1 vccd1 vccd1 _4993_/B sky130_fd_sc_hd__xnor2_2
X_6661_ _6661_/A _6661_/B vssd1 vssd1 vccd1 vccd1 _6663_/B sky130_fd_sc_hd__xor2_2
XTAP_TAPCELL_ROW_21_408 vssd1 vccd1 sky130_fd_sc_hd__tapvpwrvgnd_1
X_8400_ _8405_/CLK _8400_/D fanout378/X vssd1 vssd1 vccd1 vccd1 _8400_/Q sky130_fd_sc_hd__dfrtp_2
X_6592_ _6312_/A _6312_/B _6315_/A vssd1 vssd1 vccd1 vccd1 _6593_/B sky130_fd_sc_hd__o21ba_2
X_5612_ _8165_/A _5612_/B _5671_/D vssd1 vssd1 vccd1 vccd1 _5651_/A sky130_fd_sc_hd__nand3_2
X_8331_ _8334_/CLK _8331_/D load_slew381/X vssd1 vssd1 vccd1 vccd1 _8331_/Q sky130_fd_sc_hd__dfrtp_2
X_5543_ _5542_/B _5543_/B vssd1 vssd1 vccd1 vccd1 _5544_/B sky130_fd_sc_hd__and2b_2
X_8262_ _8263_/A _8263_/C vssd1 vssd1 vccd1 vccd1 _8351_/D sky130_fd_sc_hd__xor2_2
X_5474_ _5474_/A _5474_/B vssd1 vssd1 vccd1 vccd1 _5475_/B sky130_fd_sc_hd__or2_2
X_8193_ _8193_/A _8193_/B vssd1 vssd1 vccd1 vccd1 _8193_/Y sky130_fd_sc_hd__xnor2_2
X_7213_ _8133_/A _7515_/A vssd1 vssd1 vccd1 vccd1 _7214_/B sky130_fd_sc_hd__nand2_2
X_4425_ _4515_/A _4425_/B vssd1 vssd1 vccd1 vccd1 _4440_/B sky130_fd_sc_hd__nand2_2
X_7144_ _7144_/A _7144_/B vssd1 vssd1 vccd1 vccd1 _7146_/B sky130_fd_sc_hd__xnor2_2
X_4356_ _8429_/D _4496_/D vssd1 vssd1 vccd1 vccd1 _4358_/B sky130_fd_sc_hd__nand2_2
XANTENNA__7042__A _7042_/A vssd1 vssd1 vccd1 vccd1 sky130_fd_sc_hd__diode_2
XFILLER_58_148 vssd1 vssd1 vccd1 vccd1 sky130_fd_sc_hd__fill_4
X_7075_ _7076_/A _7076_/B _7076_/C vssd1 vssd1 vccd1 vccd1 _7077_/A sky130_fd_sc_hd__o21a_2
X_4287_ _4744_/A _5149_/B _4435_/B _4278_/Y vssd1 vssd1 vccd1 vccd1 _4337_/A sky130_fd_sc_hd__a31o_2
XFILLER_86_468 vssd1 vssd1 vccd1 vccd1 sky130_fd_sc_hd__fill_8
X_6026_ _6026_/A _6026_/B vssd1 vssd1 vccd1 vccd1 _6027_/C sky130_fd_sc_hd__or2_2
XTAP_TAPCELL_ROW_65_850 vssd1 vccd1 sky130_fd_sc_hd__tapvpwrvgnd_1
X_7977_ _7977_/A _7977_/B _7977_/C vssd1 vssd1 vccd1 vccd1 _7978_/B sky130_fd_sc_hd__and3_2
XTAP_TAPCELL_ROW_37_574 vssd1 vccd1 sky130_fd_sc_hd__tapvpwrvgnd_1
X_6928_ _6929_/B _6929_/A vssd1 vssd1 vccd1 vccd1 _7174_/A sky130_fd_sc_hd__and2b_2
Xfanout55 _6757_/B vssd1 vssd1 vccd1 vccd1 _6156_/B sky130_fd_sc_hd__buf_4
Xfanout44 _5763_/Y vssd1 vssd1 vccd1 vccd1 _7080_/B sky130_fd_sc_hd__clkdlybuf4s25_1
X_6859_ _6859_/A _6859_/B _6859_/C vssd1 vssd1 vccd1 vccd1 _6860_/B sky130_fd_sc_hd__and3_2
XFILLER_13_32 vssd1 vssd1 vccd1 vccd1 sky130_fd_sc_hd__fill_8
Xfanout88 _4284_/Y vssd1 vssd1 vccd1 vccd1 _5149_/B sky130_fd_sc_hd__clkdlybuf4s25_1
XFILLER_6_406 vssd1 vssd1 vccd1 vccd1 sky130_fd_sc_hd__fill_1
XTAP_TAPCELL_ROW_9_288 vssd1 vccd1 sky130_fd_sc_hd__tapvpwrvgnd_1
XANTENNA__5077__A2 _5780_/B vssd1 vssd1 vccd1 vccd1 sky130_fd_sc_hd__diode_2
XFILLER_49_115 vssd1 vssd1 vccd1 vccd1 sky130_fd_sc_hd__fill_1
XFILLER_77_424 vssd1 vssd1 vccd1 vccd1 sky130_fd_sc_hd__fill_1
XANTENNA__4295__B _5163_/C vssd1 vssd1 vccd1 vccd1 sky130_fd_sc_hd__diode_2
XFILLER_92_449 vssd1 vssd1 vccd1 vccd1 sky130_fd_sc_hd__fill_4
XFILLER_33_527 vssd1 vssd1 vccd1 vccd1 sky130_fd_sc_hd__fill_2
XFILLER_60_313 vssd1 vssd1 vccd1 vccd1 sky130_fd_sc_hd__fill_2
XANTENNA__5838__C _5838_/C vssd1 vssd1 vccd1 vccd1 sky130_fd_sc_hd__diode_2
XFILLER_54_83 vssd1 vssd1 vccd1 vccd1 sky130_fd_sc_hd__fill_1
Xclkload14 _8361_/CLK vssd1 vssd1 vccd1 vccd1 clkload14/X sky130_fd_sc_hd__clkbuf_4
XANTENNA__6031__A _6517_/A vssd1 vssd1 vccd1 vccd1 sky130_fd_sc_hd__diode_2
XFILLER_5_461 vssd1 vssd1 vccd1 vccd1 sky130_fd_sc_hd__fill_2
X_4210_ input7/X _4218_/S vssd1 vssd1 vccd1 vccd1 _4210_/Y sky130_fd_sc_hd__nand2b_2
XFILLER_79_91 vssd1 vssd1 vccd1 vccd1 sky130_fd_sc_hd__fill_1
X_5190_ _5191_/B vssd1 vssd1 vccd1 vccd1 _5190_/Y sky130_fd_sc_hd__inv_2
XTAP_TAPCELL_ROW_79_986 vssd1 vccd1 sky130_fd_sc_hd__tapvpwrvgnd_1
X_7900_ _7901_/B _7901_/A vssd1 vssd1 vccd1 vccd1 _7900_/X sky130_fd_sc_hd__and2b_2
XANTENNA__6017__A1 _6016_/A vssd1 vssd1 vccd1 vccd1 sky130_fd_sc_hd__diode_2
XFILLER_63_162 vssd1 vssd1 vccd1 vccd1 sky130_fd_sc_hd__fill_1
X_7831_ _7694_/A _7694_/B _7693_/A vssd1 vssd1 vccd1 vccd1 _7833_/B sky130_fd_sc_hd__o21a_2
X_7762_ _7762_/A _7762_/B vssd1 vssd1 vccd1 vccd1 _7763_/B sky130_fd_sc_hd__nor2_2
X_4974_ _5710_/A _5163_/B _5163_/C vssd1 vssd1 vccd1 vccd1 _4975_/B sky130_fd_sc_hd__and3_2
XTAP_TAPCELL_ROW_62_820 vssd1 vccd1 sky130_fd_sc_hd__tapvpwrvgnd_1
X_7693_ _7693_/A _7693_/B vssd1 vssd1 vccd1 vccd1 _7694_/B sky130_fd_sc_hd__nand2_2
X_6713_ _6713_/A _6713_/B vssd1 vssd1 vccd1 vccd1 _6716_/A sky130_fd_sc_hd__xor2_2
XTAP_TAPCELL_ROW_34_544 vssd1 vccd1 sky130_fd_sc_hd__tapvpwrvgnd_1
X_6644_ _8417_/D wire72/X vssd1 vssd1 vccd1 vccd1 _6747_/A sky130_fd_sc_hd__nand2_2
XANTENNA__5764__B _7080_/B vssd1 vssd1 vccd1 vccd1 sky130_fd_sc_hd__diode_2
Xclkload8 clkload8/A vssd1 vssd1 vccd1 vccd1 clkload8/X sky130_fd_sc_hd__clkbuf_4
X_6575_ _6573_/A _6708_/A _6574_/X vssd1 vssd1 vccd1 vccd1 _6577_/A sky130_fd_sc_hd__o21a_2
XANTENNA_fanout302_A _7723_/D vssd1 vssd1 vccd1 vccd1 sky130_fd_sc_hd__diode_2
X_8314_ _8389_/Q input5/X _8397_/D vssd1 vssd1 vccd1 vccd1 _8389_/D sky130_fd_sc_hd__mux2_1
X_5526_ _5647_/A _5568_/A _5569_/C _5569_/D vssd1 vssd1 vccd1 vccd1 _5527_/B sky130_fd_sc_hd__and4_2
X_8245_ _8246_/A input9/X vssd1 vssd1 vccd1 vccd1 _8247_/A sky130_fd_sc_hd__or2_2
X_5457_ _5451_/A _5451_/C _5451_/B vssd1 vssd1 vccd1 vccd1 _5462_/B sky130_fd_sc_hd__a21o_2
X_4408_ _4408_/A _4408_/B vssd1 vssd1 vccd1 vccd1 _4427_/B sky130_fd_sc_hd__xnor2_2
XFILLER_59_402 vssd1 vssd1 vccd1 vccd1 sky130_fd_sc_hd__fill_1
X_8176_ _8167_/Y _8171_/C _8173_/X _8174_/Y vssd1 vssd1 vccd1 vccd1 _8177_/B sky130_fd_sc_hd__a211oi_2
Xfanout201 _8400_/Q vssd1 vssd1 vccd1 vccd1 _8313_/S sky130_fd_sc_hd__clkdlybuf4s25_1
Xfanout212 _6397_/C vssd1 vssd1 vccd1 vccd1 _8032_/A sky130_fd_sc_hd__clkdlybuf4s25_1
Xfanout223 _7131_/A vssd1 vssd1 vccd1 vccd1 _8133_/B sky130_fd_sc_hd__clkdlybuf4s25_1
X_5388_ _5388_/A _5388_/B vssd1 vssd1 vccd1 vccd1 _5389_/B sky130_fd_sc_hd__nor2_2
XANTENNA_fanout292_X _8264_/A vssd1 vssd1 vccd1 vccd1 sky130_fd_sc_hd__diode_2
XFILLER_86_210 vssd1 vssd1 vccd1 vccd1 sky130_fd_sc_hd__fill_1
Xfanout234 _8126_/A vssd1 vssd1 vccd1 vccd1 _7140_/B sky130_fd_sc_hd__clkdlybuf4s25_1
Xfanout245 _5393_/D vssd1 vssd1 vccd1 vccd1 _5559_/C sky130_fd_sc_hd__clkdlybuf4s25_1
Xfanout256 _5367_/C vssd1 vssd1 vccd1 vccd1 _5838_/A sky130_fd_sc_hd__clkdlybuf4s25_1
X_7127_ _7127_/A _7127_/B vssd1 vssd1 vccd1 vccd1 _7134_/A sky130_fd_sc_hd__xnor2_2
X_4339_ _8430_/D _4700_/B _4339_/C vssd1 vssd1 vccd1 vccd1 _4341_/A sky130_fd_sc_hd__and3_2
XTAP_TAPCELL_ROW_6_258 vssd1 vccd1 sky130_fd_sc_hd__tapvpwrvgnd_1
XANTENNA__7203__C _7203_/C vssd1 vssd1 vccd1 vccd1 sky130_fd_sc_hd__diode_2
XFILLER_75_27 vssd1 vccd1 vssd1 vccd1 sky130_ef_sc_hd__decap_40_12
Xfanout267 _6830_/B vssd1 vssd1 vccd1 vccd1 _7889_/B sky130_fd_sc_hd__clkdlybuf4s25_1
Xfanout278 _6548_/A vssd1 vssd1 vccd1 vccd1 _8121_/A sky130_fd_sc_hd__clkdlybuf4s25_1
Xfanout289 _8266_/A vssd1 vssd1 vccd1 vccd1 _8267_/A sky130_fd_sc_hd__clkdlybuf4s25_1
X_7058_ _7058_/A vssd1 vssd1 vccd1 vccd1 _7065_/A sky130_fd_sc_hd__inv_2
X_6009_ _6010_/B _6223_/B vssd1 vssd1 vccd1 vccd1 _6011_/B sky130_fd_sc_hd__nor2_2
XANTENNA__5020__A _5020_/A vssd1 vssd1 vccd1 vccd1 sky130_fd_sc_hd__diode_2
XFILLER_24_53 vssd1 vssd1 vccd1 vccd1 sky130_fd_sc_hd__fill_2
XFILLER_10_232 vssd1 vssd1 vccd1 vccd1 sky130_fd_sc_hd__fill_2
XANTENNA__5393__C _8202_/A vssd1 vssd1 vccd1 vccd1 sky130_fd_sc_hd__diode_2
XFILLER_40_52 vssd1 vssd1 vccd1 vccd1 sky130_fd_sc_hd__fill_4
XFILLER_40_85 vssd1 vssd1 vccd1 vccd1 sky130_fd_sc_hd__fill_1
XFILLER_2_475 vssd1 vssd1 vccd1 vccd1 sky130_fd_sc_hd__fill_1
XFILLER_2_497 vssd1 vssd1 vccd1 vccd1 sky130_fd_sc_hd__fill_1
XFILLER_37_118 vssd1 vssd1 vccd1 vccd1 sky130_fd_sc_hd__fill_8
XANTENNA__8506__A _8506_/A vssd1 vssd1 vccd1 vccd1 sky130_fd_sc_hd__diode_2
XTAP_TAPCELL_ROW_76_956 vssd1 vccd1 sky130_fd_sc_hd__tapvpwrvgnd_1
XFILLER_92_235 vssd1 vssd1 vccd1 vccd1 sky130_fd_sc_hd__fill_1
XFILLER_45_140 vssd1 vssd1 vccd1 vccd1 sky130_fd_sc_hd__fill_1
XFILLER_73_471 vssd1 vssd1 vccd1 vccd1 sky130_fd_sc_hd__fill_1
XTAP_TAPCELL_ROW_86_1063 vssd1 vccd1 sky130_fd_sc_hd__tapvpwrvgnd_1
XTAP_TAPCELL_ROW_31_514 vssd1 vccd1 sky130_fd_sc_hd__tapvpwrvgnd_1
XANTENNA__8241__A _8241_/A vssd1 vssd1 vccd1 vccd1 sky130_fd_sc_hd__diode_2
X_4690_ _4690_/A _4690_/B _4691_/B vssd1 vssd1 vccd1 vccd1 _4694_/A sky130_fd_sc_hd__or3b_2
X_6360_ _8414_/D _6360_/B vssd1 vssd1 vccd1 vccd1 _6638_/A sky130_fd_sc_hd__nand2_2
X_5311_ _8184_/A _5521_/C _5559_/C _8191_/A vssd1 vssd1 vccd1 vccd1 _5312_/B sky130_fd_sc_hd__a22oi_2
X_8030_ _8030_/A _8136_/A _8136_/D vssd1 vssd1 vccd1 vccd1 _8030_/X sky130_fd_sc_hd__and3_2
X_6291_ _6712_/A wire90/X _6106_/B _6105_/A vssd1 vssd1 vccd1 vccd1 _6297_/A sky130_fd_sc_hd__a31o_2
X_5242_ _5241_/A _5241_/C _5256_/C vssd1 vssd1 vccd1 vccd1 _5246_/B sky130_fd_sc_hd__a21oi_2
XANTENNA__7304__B _8077_/B vssd1 vssd1 vccd1 vccd1 sky130_fd_sc_hd__diode_2
XFILLER_68_210 vssd1 vssd1 vccd1 vccd1 sky130_fd_sc_hd__fill_1
X_5173_ _5173_/A _5173_/B vssd1 vssd1 vccd1 vccd1 _5174_/B sky130_fd_sc_hd__nor2_2
Xinput1 en vssd1 vssd1 vccd1 vccd1 input1/X sky130_fd_sc_hd__clkdlybuf4s25_1
XTAP_TAPCELL_ROW_3_228 vssd1 vccd1 sky130_fd_sc_hd__tapvpwrvgnd_1
XANTENNA_fanout252_A _6438_/A vssd1 vssd1 vccd1 vccd1 sky130_fd_sc_hd__diode_2
X_7814_ _7958_/A _7954_/B _7680_/Y vssd1 vssd1 vccd1 vccd1 _7814_/X sky130_fd_sc_hd__o21ba_2
XFILLER_51_132 vssd1 vssd1 vccd1 vccd1 sky130_fd_sc_hd__fill_1
XTAP_TAPCELL_ROW_19_393 vssd1 vccd1 sky130_fd_sc_hd__tapvpwrvgnd_1
XFILLER_51_165 vssd1 vssd1 vccd1 vccd1 sky130_fd_sc_hd__fill_1
X_7745_ _7887_/B _7745_/B vssd1 vssd1 vccd1 vccd1 _7747_/A sky130_fd_sc_hd__nand2_2
X_4957_ _4825_/B _4872_/A _4955_/Y _4956_/X vssd1 vssd1 vccd1 vccd1 _4969_/B sky130_fd_sc_hd__a211o_2
XANTENNA__8163__B2 _6689_/A vssd1 vssd1 vccd1 vccd1 sky130_fd_sc_hd__diode_2
X_7676_ _7614_/A _7614_/B _7615_/Y _7616_/A vssd1 vssd1 vccd1 vccd1 _7677_/B sky130_fd_sc_hd__a22o_2
X_4888_ _8407_/D wire64/A vssd1 vssd1 vccd1 vccd1 _5092_/A sky130_fd_sc_hd__and2_2
X_6627_ _6361_/A _6638_/A _6364_/A _6364_/B vssd1 vssd1 vccd1 vccd1 _6635_/A sky130_fd_sc_hd__a2bb2o_2
XANTENNA__7990__A _7990_/A vssd1 vssd1 vccd1 vccd1 sky130_fd_sc_hd__diode_2
XANTENNA_fanout305_X _8233_/A vssd1 vssd1 vccd1 vccd1 sky130_fd_sc_hd__diode_2
X_6558_ _6559_/A _6559_/B _6559_/C vssd1 vssd1 vccd1 vccd1 _6873_/A sky130_fd_sc_hd__o21a_2
X_6489_ _6812_/A _6489_/B vssd1 vssd1 vccd1 vccd1 _6496_/A sky130_fd_sc_hd__and2_2
X_5509_ _5509_/A _5514_/A vssd1 vssd1 vccd1 vccd1 _5509_/Y sky130_fd_sc_hd__nand2_2
X_8228_ _8228_/A input6/X vssd1 vssd1 vccd1 vccd1 _8235_/B sky130_fd_sc_hd__nor2_2
XFILLER_10_99 vssd1 vssd1 vccd1 vccd1 sky130_fd_sc_hd__fill_1
X_8159_ _8159_/A _8159_/B vssd1 vssd1 vccd1 vccd1 _8160_/B sky130_fd_sc_hd__xnor2_2
XANTENNA__5015__A _8425_/D vssd1 vssd1 vccd1 vccd1 sky130_fd_sc_hd__diode_2
XFILLER_19_31 vssd1 vssd1 vccd1 vccd1 sky130_fd_sc_hd__fill_2
XFILLER_19_42 vssd1 vssd1 vccd1 vccd1 sky130_fd_sc_hd__fill_1
XANTENNA__7230__A _7875_/A vssd1 vssd1 vccd1 vccd1 sky130_fd_sc_hd__diode_2
XANTENNA__5669__B _5669_/B vssd1 vssd1 vccd1 vccd1 sky130_fd_sc_hd__diode_2
XTAP_TAPCELL_ROW_73_926 vssd1 vccd1 sky130_fd_sc_hd__tapvpwrvgnd_1
XFILLER_11_541 vssd1 vccd1 vssd1 vccd1 sky130_ef_sc_hd__decap_40_12
XFILLER_51_62 vssd1 vssd1 vccd1 vccd1 sky130_fd_sc_hd__fill_4
XFILLER_7_523 vssd1 vssd1 vccd1 vccd1 sky130_fd_sc_hd__fill_1
XFILLER_51_84 vssd1 vssd1 vccd1 vccd1 sky130_fd_sc_hd__fill_2
XFILLER_7_556 vssd1 vssd1 vccd1 vccd1 sky130_fd_sc_hd__fill_4
XPHY_EDGE_ROW_2_Left_95 vssd1 vssd1 vccd1 vccd1 sky130_fd_sc_hd__decap_3
XANTENNA__7140__A _7140_/A vssd1 vssd1 vccd1 vccd1 sky130_fd_sc_hd__diode_2
XFILLER_65_279 vssd1 vssd1 vccd1 vccd1 sky130_fd_sc_hd__fill_1
X_5860_ _5860_/A _5860_/B _5860_/C vssd1 vssd1 vccd1 vccd1 _5868_/A sky130_fd_sc_hd__and3_2
XFILLER_61_463 vssd1 vssd1 vccd1 vccd1 sky130_fd_sc_hd__fill_4
X_4811_ _8394_/Q _8453_/Q vssd1 vssd1 vccd1 vccd1 _4812_/B sky130_fd_sc_hd__xnor2_2
XFILLER_61_485 vssd1 vssd1 vccd1 vccd1 sky130_fd_sc_hd__fill_1
X_5791_ _5791_/A _5791_/B vssd1 vssd1 vccd1 vccd1 _5793_/B sky130_fd_sc_hd__xnor2_2
XTAP_TAPCELL_ROW_16_363 vssd1 vccd1 sky130_fd_sc_hd__tapvpwrvgnd_1
XFILLER_92_91 vssd1 vssd1 vccd1 vccd1 sky130_fd_sc_hd__fill_4
X_7530_ _7731_/B _7530_/B vssd1 vssd1 vccd1 vccd1 _7532_/C sky130_fd_sc_hd__nand2_2
X_4742_ _4740_/X _4742_/B vssd1 vssd1 vccd1 vccd1 _4743_/B sky130_fd_sc_hd__and2b_2
X_7461_ _7889_/A _7889_/B _8126_/B _8125_/B vssd1 vssd1 vccd1 vccd1 _7462_/B sky130_fd_sc_hd__and4_2
X_4673_ _4709_/B _4707_/B vssd1 vssd1 vccd1 vccd1 _4697_/B sky130_fd_sc_hd__nand2_2
X_6412_ _6412_/A _6412_/B _6412_/C vssd1 vssd1 vccd1 vccd1 _6424_/B sky130_fd_sc_hd__nand3_2
X_7392_ _7393_/B _7393_/A vssd1 vssd1 vccd1 vccd1 _7392_/Y sky130_fd_sc_hd__nand2b_2
X_6343_ _6343_/A _6343_/B vssd1 vssd1 vccd1 vccd1 _6345_/B sky130_fd_sc_hd__xnor2_2
X_6274_ _6274_/A _6274_/B _6274_/C vssd1 vssd1 vccd1 vccd1 _6275_/B sky130_fd_sc_hd__or3_2
X_8013_ _7131_/A _7864_/B _7864_/D _7862_/X vssd1 vssd1 vccd1 vccd1 _8021_/A sky130_fd_sc_hd__a31o_2
X_5225_ _5229_/A _5224_/B _5223_/X vssd1 vssd1 vccd1 vccd1 _5227_/B sky130_fd_sc_hd__o21bai_2
XANTENNA__7969__B _8077_/B vssd1 vssd1 vccd1 vccd1 sky130_fd_sc_hd__diode_2
XFILLER_56_29 vssd1 vssd1 vccd1 vccd1 sky130_fd_sc_hd__fill_1
X_5156_ _5711_/A _5156_/B vssd1 vssd1 vccd1 vccd1 _5159_/A sky130_fd_sc_hd__xnor2_2
XANTENNA__4674__A _4674_/A vssd1 vssd1 vccd1 vccd1 sky130_fd_sc_hd__diode_2
X_5087_ _5088_/A _5088_/B vssd1 vssd1 vccd1 vccd1 _5087_/Y sky130_fd_sc_hd__nand2_2
XFILLER_71_249 vssd1 vssd1 vccd1 vccd1 sky130_fd_sc_hd__fill_2
XANTENNA__8415__RESET_B wire364/X vssd1 vssd1 vccd1 vccd1 sky130_fd_sc_hd__diode_2
XANTENNA_fanout255_X _8110_/A vssd1 vssd1 vccd1 vccd1 sky130_fd_sc_hd__diode_2
XFILLER_24_143 vssd1 vssd1 vccd1 vccd1 sky130_fd_sc_hd__fill_1
XFILLER_24_187 vssd1 vssd1 vccd1 vccd1 sky130_fd_sc_hd__fill_2
X_5989_ _5989_/A _5989_/B vssd1 vssd1 vccd1 vccd1 _5990_/B sky130_fd_sc_hd__xnor2_2
XFILLER_8_309 vssd1 vssd1 vccd1 vccd1 sky130_fd_sc_hd__fill_4
X_7728_ _7728_/A _7728_/B vssd1 vssd1 vccd1 vccd1 _7729_/B sky130_fd_sc_hd__or2_2
XANTENNA__6113__B _6114_/B vssd1 vssd1 vccd1 vccd1 sky130_fd_sc_hd__diode_2
X_7659_ _7655_/A _7654_/A _7654_/B _7509_/B _7509_/A vssd1 vssd1 vccd1 vccd1 _7659_/X
+ sky130_fd_sc_hd__o311a_2
XTAP_TAPCELL_ROW_50_697 vssd1 vccd1 sky130_fd_sc_hd__tapvpwrvgnd_1
XFILLER_21_32 vssd1 vssd1 vccd1 vccd1 sky130_fd_sc_hd__fill_2
XANTENNA__4849__A _5157_/A vssd1 vssd1 vccd1 vccd1 sky130_fd_sc_hd__diode_2
XFILLER_79_349 vssd1 vssd1 vccd1 vccd1 sky130_fd_sc_hd__fill_4
XFILLER_47_213 vssd1 vssd1 vccd1 vccd1 sky130_fd_sc_hd__fill_2
XFILLER_75_533 vssd1 vssd1 vccd1 vccd1 sky130_fd_sc_hd__fill_4
XFILLER_46_51 vssd1 vssd1 vccd1 vccd1 sky130_fd_sc_hd__fill_2
XFILLER_90_514 vssd1 vssd1 vccd1 vccd1 sky130_fd_sc_hd__fill_1
XFILLER_62_227 vssd1 vssd1 vccd1 vccd1 sky130_fd_sc_hd__fill_1
XTAP_TAPCELL_ROW_83_1033 vssd1 vccd1 sky130_fd_sc_hd__tapvpwrvgnd_1
XFILLER_43_496 vssd1 vssd1 vccd1 vccd1 sky130_fd_sc_hd__fill_2
XTAP_TAPCELL_ROW_13_333 vssd1 vccd1 sky130_fd_sc_hd__tapvpwrvgnd_1
X_5010_ _8423_/D _5138_/B _4902_/D _4899_/X vssd1 vssd1 vccd1 vccd1 _5026_/A sky130_fd_sc_hd__a31o_2
XANTENNA__6861__A1 _8121_/A vssd1 vssd1 vccd1 vccd1 sky130_fd_sc_hd__diode_2
XFILLER_23_3 vssd1 vssd1 vccd1 vccd1 sky130_fd_sc_hd__fill_4
XFILLER_85_319 vssd1 vssd1 vccd1 vccd1 sky130_fd_sc_hd__fill_1
XFILLER_81_503 vssd1 vssd1 vccd1 vccd1 sky130_fd_sc_hd__fill_1
X_6961_ _7201_/A _6961_/B vssd1 vssd1 vccd1 vccd1 _6964_/A sky130_fd_sc_hd__or2_2
XFILLER_81_569 vssd1 vssd1 vccd1 vccd1 sky130_fd_sc_hd__fill_1
X_6892_ _7129_/A _6892_/B _6892_/C _6892_/D vssd1 vssd1 vccd1 vccd1 _6893_/B sky130_fd_sc_hd__and4_2
X_5912_ _5910_/A _5910_/B _5911_/X vssd1 vssd1 vccd1 vccd1 _5914_/B sky130_fd_sc_hd__o21a_2
X_5843_ _6435_/A _5842_/B _6238_/B _6035_/C vssd1 vssd1 vccd1 vccd1 _5844_/B sky130_fd_sc_hd__a22oi_2
X_7513_ _7513_/A _7513_/B vssd1 vssd1 vccd1 vccd1 _7513_/X sky130_fd_sc_hd__xor2_2
X_5774_ _8410_/D wire66/X vssd1 vssd1 vccd1 vccd1 _5910_/A sky130_fd_sc_hd__nand2_2
Xrebuffer439 _7356_/B vssd1 vssd1 vccd1 vccd1 _7423_/A2 sky130_fd_sc_hd__buf_2
X_4725_ _5052_/A _5052_/B _4642_/X vssd1 vssd1 vccd1 vccd1 _5055_/A sky130_fd_sc_hd__a21oi_2
X_7444_ _7232_/B _7234_/B _7232_/A vssd1 vssd1 vccd1 vccd1 _7454_/A sky130_fd_sc_hd__o21ba_2
X_4656_ _4654_/X _4656_/B vssd1 vssd1 vccd1 vccd1 _4658_/A sky130_fd_sc_hd__and2b_2
X_7375_ _8417_/D _7820_/B vssd1 vssd1 vccd1 vccd1 _7376_/B sky130_fd_sc_hd__nand2_2
X_4587_ _4588_/A _4588_/B vssd1 vssd1 vccd1 vccd1 _4587_/Y sky130_fd_sc_hd__nor2_2
X_6326_ _6327_/B _6327_/A vssd1 vssd1 vccd1 vccd1 _6326_/Y sky130_fd_sc_hd__nand2b_2
X_6257_ _6032_/A _6034_/B _6032_/B vssd1 vssd1 vccd1 vccd1 _6259_/C sky130_fd_sc_hd__o21ba_2
X_6188_ _6188_/A _6188_/B vssd1 vssd1 vccd1 vccd1 _6190_/B sky130_fd_sc_hd__xnor2_2
X_5208_ _5207_/C _5205_/X _5207_/A vssd1 vssd1 vccd1 vccd1 _5208_/X sky130_fd_sc_hd__a21o_4
X_5139_ _5140_/A _5140_/B vssd1 vssd1 vccd1 vccd1 _5752_/B sky130_fd_sc_hd__nor2_2
XFILLER_29_246 vssd1 vssd1 vccd1 vccd1 sky130_fd_sc_hd__fill_1
XANTENNA__5012__B _6701_/B vssd1 vssd1 vccd1 vccd1 sky130_fd_sc_hd__diode_2
XFILLER_83_27 vssd1 vssd1 vccd1 vccd1 sky130_fd_sc_hd__fill_2
XANTENNA__8402__CLK _8402_/CLK vssd1 vssd1 vccd1 vccd1 sky130_fd_sc_hd__diode_2
XFILLER_16_43 vssd1 vssd1 vccd1 vccd1 sky130_fd_sc_hd__fill_2
XFILLER_72_558 vssd1 vssd1 vccd1 vccd1 sky130_fd_sc_hd__fill_2
XTAP_TAPCELL_ROW_27_469 vssd1 vccd1 sky130_fd_sc_hd__tapvpwrvgnd_1
XANTENNA__4918__A1 _5157_/A vssd1 vssd1 vccd1 vccd1 sky130_fd_sc_hd__diode_2
XANTENNA__8109__A1 _8110_/A vssd1 vssd1 vccd1 vccd1 sky130_fd_sc_hd__diode_2
XANTENNA__8109__B2 _8110_/B vssd1 vssd1 vccd1 vccd1 sky130_fd_sc_hd__diode_2
XFILLER_32_20 vssd1 vssd1 vccd1 vccd1 sky130_fd_sc_hd__fill_2
XFILLER_40_488 vssd1 vssd1 vccd1 vccd1 sky130_fd_sc_hd__fill_2
XFILLER_40_499 vssd1 vssd1 vccd1 vccd1 sky130_fd_sc_hd__fill_4
XTAP_TAPCELL_ROW_10_303 vssd1 vccd1 sky130_fd_sc_hd__tapvpwrvgnd_1
XANTENNA__4579__A _4709_/B vssd1 vssd1 vccd1 vccd1 sky130_fd_sc_hd__diode_2
XANTENNA__8293__A0 _6238_/B vssd1 vssd1 vccd1 vccd1 sky130_fd_sc_hd__diode_2
XFILLER_79_113 vssd1 vssd1 vccd1 vccd1 sky130_fd_sc_hd__fill_1
XFILLER_79_146 vssd1 vssd1 vccd1 vccd1 sky130_fd_sc_hd__fill_4
XFILLER_63_503 vssd1 vssd1 vccd1 vccd1 sky130_fd_sc_hd__fill_1
XFILLER_90_300 vssd1 vssd1 vccd1 vccd1 sky130_fd_sc_hd__fill_4
XFILLER_63_569 vssd1 vssd1 vccd1 vccd1 sky130_fd_sc_hd__fill_1
XFILLER_50_208 vssd1 vssd1 vccd1 vccd1 sky130_fd_sc_hd__fill_2
XANTENNA__8233__B input7/X vssd1 vssd1 vccd1 vccd1 sky130_fd_sc_hd__diode_2
X_5490_ _5491_/B _5518_/A _5491_/A vssd1 vssd1 vccd1 vccd1 _5498_/A sky130_fd_sc_hd__a21oi_2
X_4510_ _4511_/A _4511_/B vssd1 vssd1 vccd1 vccd1 _4510_/X sky130_fd_sc_hd__and2b_2
X_4441_ _4441_/A _4441_/B vssd1 vssd1 vccd1 vccd1 _4544_/B sky130_fd_sc_hd__xnor2_2
X_7160_ _7895_/A _7725_/B _7249_/C _7998_/B vssd1 vssd1 vccd1 vccd1 _7161_/B sky130_fd_sc_hd__a22oi_2
XPHY_EDGE_ROW_9_Right_9 vssd1 vssd1 vccd1 vccd1 sky130_fd_sc_hd__decap_3
XANTENNA__6200__C _6397_/C vssd1 vssd1 vccd1 vccd1 sky130_fd_sc_hd__diode_2
X_6111_ _6572_/A _6582_/B vssd1 vssd1 vccd1 vccd1 _6112_/B sky130_fd_sc_hd__nand2_2
X_4372_ _4372_/A _4372_/B vssd1 vssd1 vccd1 vccd1 _4373_/B sky130_fd_sc_hd__xor2_2
X_7091_ _7092_/B _7092_/A vssd1 vssd1 vccd1 vccd1 _7091_/X sky130_fd_sc_hd__and2b_2
X_6042_ _6042_/A _6042_/B vssd1 vssd1 vccd1 vccd1 _6044_/B sky130_fd_sc_hd__xnor2_2
XFILLER_66_352 vssd1 vssd1 vccd1 vccd1 sky130_fd_sc_hd__fill_1
XFILLER_66_363 vssd1 vssd1 vccd1 vccd1 sky130_fd_sc_hd__fill_1
X_7993_ _8108_/A _8108_/B _8277_/A _8359_/Q vssd1 vssd1 vccd1 vccd1 _7994_/B sky130_fd_sc_hd__and4_2
XANTENNA_fanout165_A _4821_/A vssd1 vssd1 vccd1 vccd1 sky130_fd_sc_hd__diode_2
XFILLER_54_569 vssd1 vssd1 vccd1 vccd1 sky130_fd_sc_hd__fill_1
X_6944_ _6831_/A _6833_/B _6831_/B vssd1 vssd1 vccd1 vccd1 _6946_/C sky130_fd_sc_hd__o21ba_2
XANTENNA__4163__S _4227_/S vssd1 vssd1 vccd1 vccd1 sky130_fd_sc_hd__diode_2
X_6875_ _6875_/A _6875_/B vssd1 vssd1 vccd1 vccd1 _6877_/B sky130_fd_sc_hd__xnor2_2
XTAP_TAPCELL_ROW_24_439 vssd1 vccd1 sky130_fd_sc_hd__tapvpwrvgnd_1
XANTENNA_fanout332_A _7120_/A vssd1 vssd1 vccd1 vccd1 sky130_fd_sc_hd__diode_2
X_5826_ _5826_/A _6217_/C vssd1 vssd1 vccd1 vccd1 _5827_/B sky130_fd_sc_hd__nand2_2
X_5757_ _5758_/B _5758_/A vssd1 vssd1 vccd1 vccd1 _5757_/X sky130_fd_sc_hd__and2b_2
X_4708_ _4708_/A _4708_/B vssd1 vssd1 vccd1 vccd1 _4708_/Y sky130_fd_sc_hd__xnor2_2
XANTENNA__4399__A _8430_/D vssd1 vssd1 vccd1 vccd1 sky130_fd_sc_hd__diode_2
X_7427_ _7515_/A _7210_/C _7427_/B1 _7426_/A vssd1 vssd1 vccd1 vccd1 _7428_/B sky130_fd_sc_hd__a22oi_2
X_5688_ _5680_/A _5680_/B _5682_/B _5683_/X vssd1 vssd1 vccd1 vccd1 _5688_/X sky130_fd_sc_hd__a31o_2
XANTENNA__6522__B1 _7723_/C vssd1 vssd1 vccd1 vccd1 sky130_fd_sc_hd__diode_2
X_4639_ _4638_/X _4664_/A vssd1 vssd1 vccd1 vccd1 _4640_/A sky130_fd_sc_hd__and2b_2
XFILLER_78_49 vssd1 vssd1 vccd1 vccd1 sky130_fd_sc_hd__fill_4
X_7358_ _7358_/A _7358_/B vssd1 vssd1 vccd1 vccd1 _7359_/B sky130_fd_sc_hd__or2_4
XANTENNA__7078__A1 _7603_/A vssd1 vssd1 vccd1 vccd1 sky130_fd_sc_hd__diode_2
XFILLER_89_433 vssd1 vssd1 vccd1 vccd1 sky130_fd_sc_hd__fill_1
X_7289_ _7290_/A _7290_/B _7290_/C vssd1 vssd1 vccd1 vccd1 _7506_/B sky130_fd_sc_hd__o21a_2
X_6309_ _6310_/A _6310_/B vssd1 vssd1 vccd1 vccd1 _6309_/X sky130_fd_sc_hd__or2_2
Xteam_03_401 vssd1 vssd1 vccd1 vccd1 team_03_401/HI gpio_oeb[32] sky130_fd_sc_hd__conb_1
Xteam_03_412 vssd1 vssd1 vccd1 vccd1 team_03_412/HI gpio_out[9] sky130_fd_sc_hd__conb_1
Xteam_03_423 vssd1 vssd1 vccd1 vccd1 gpio_oeb[2] team_03_423/LO sky130_fd_sc_hd__conb_1
XANTENNA__4846__B _4972_/B vssd1 vssd1 vccd1 vccd1 sky130_fd_sc_hd__diode_2
XANTENNA_fanout78_A _5052_/X vssd1 vssd1 vccd1 vccd1 sky130_fd_sc_hd__diode_2
Xteam_03_434 vssd1 vssd1 vccd1 vccd1 gpio_oeb[13] team_03_434/LO sky130_fd_sc_hd__conb_1
XANTENNA__8430__RESET_B wire362/X vssd1 vssd1 vccd1 vccd1 sky130_fd_sc_hd__diode_2
XFILLER_27_53 vssd1 vssd1 vccd1 vccd1 sky130_fd_sc_hd__fill_2
XTAP_TAPCELL_ROW_68_881 vssd1 vccd1 sky130_fd_sc_hd__tapvpwrvgnd_1
XANTENNA__7250__B2 _7754_/B vssd1 vssd1 vccd1 vccd1 sky130_fd_sc_hd__diode_2
XFILLER_45_569 vssd1 vssd1 vccd1 vccd1 sky130_fd_sc_hd__fill_1
XFILLER_13_411 vssd1 vssd1 vccd1 vccd1 sky130_fd_sc_hd__fill_1
XFILLER_72_399 vssd1 vssd1 vccd1 vccd1 sky130_fd_sc_hd__fill_1
XTAP_TAPCELL_ROW_80_1003 vssd1 vccd1 sky130_fd_sc_hd__tapvpwrvgnd_1
XANTENNA__5013__B1 _6701_/B vssd1 vssd1 vccd1 vccd1 sky130_fd_sc_hd__diode_2
XFILLER_13_477 vssd1 vssd1 vccd1 vccd1 sky130_fd_sc_hd__fill_1
XFILLER_4_175 vssd1 vssd1 vccd1 vccd1 sky130_fd_sc_hd__fill_1
XTAP_TAPCELL_ROW_91_1110 vssd1 vccd1 sky130_fd_sc_hd__tapvpwrvgnd_1
XANTENNA__6816__A1 _7140_/A vssd1 vssd1 vccd1 vccd1 sky130_fd_sc_hd__diode_2
XANTENNA__8228__B input6/X vssd1 vssd1 vccd1 vccd1 sky130_fd_sc_hd__diode_2
XFILLER_67_138 vssd1 vssd1 vccd1 vccd1 sky130_fd_sc_hd__fill_2
XANTENNA__6971__B _7095_/B vssd1 vssd1 vccd1 vccd1 sky130_fd_sc_hd__diode_2
XTAP_TAPCELL_ROW_89_1094 vssd1 vccd1 sky130_fd_sc_hd__tapvpwrvgnd_1
XFILLER_90_163 vssd1 vssd1 vccd1 vccd1 sky130_fd_sc_hd__fill_8
X_4990_ _4989_/Y _4989_/B _4990_/S vssd1 vssd1 vccd1 vccd1 _4991_/A sky130_fd_sc_hd__mux2_1
XFILLER_16_271 vssd1 vssd1 vccd1 vccd1 sky130_fd_sc_hd__fill_1
XFILLER_90_185 vssd1 vssd1 vccd1 vccd1 sky130_fd_sc_hd__fill_4
X_6660_ _6661_/A _6661_/B vssd1 vssd1 vccd1 vccd1 _6660_/Y sky130_fd_sc_hd__nand2b_2
XTAP_TAPCELL_ROW_21_409 vssd1 vccd1 sky130_fd_sc_hd__tapvpwrvgnd_1
X_6591_ _6591_/A _6591_/B vssd1 vssd1 vccd1 vccd1 _6593_/A sky130_fd_sc_hd__xnor2_2
X_5611_ _5611_/A _5611_/B vssd1 vssd1 vccd1 vccd1 _5671_/D sky130_fd_sc_hd__nor2_2
X_8330_ _8402_/CLK _8330_/D load_slew381/X vssd1 vssd1 vccd1 vccd1 _8330_/Q sky130_fd_sc_hd__dfrtp_2
X_5542_ _5543_/B _5542_/B vssd1 vssd1 vccd1 vccd1 _5544_/A sky130_fd_sc_hd__and2b_2
X_8261_ _8263_/A _8263_/C vssd1 vssd1 vccd1 vccd1 _8264_/B sky130_fd_sc_hd__and2_2
X_5473_ _5461_/A _5461_/B _5461_/C vssd1 vssd1 vccd1 vccd1 _5495_/B sky130_fd_sc_hd__a21oi_2
X_8192_ _8192_/A _8192_/B vssd1 vssd1 vccd1 vccd1 _8193_/B sky130_fd_sc_hd__nor2_2
X_7212_ _7212_/A _7212_/B vssd1 vssd1 vccd1 vccd1 _7214_/A sky130_fd_sc_hd__nor2_2
X_4424_ _4424_/A _4424_/B vssd1 vssd1 vccd1 vccd1 _4515_/B sky130_fd_sc_hd__xor2_2
X_7143_ _7233_/A _7723_/D vssd1 vssd1 vccd1 vccd1 _7144_/B sky130_fd_sc_hd__nand2_2
X_4355_ _4355_/A _4355_/B vssd1 vssd1 vccd1 vccd1 _4358_/A sky130_fd_sc_hd__xnor2_2
X_7074_ _7074_/A _7074_/B vssd1 vssd1 vccd1 vccd1 _7076_/C sky130_fd_sc_hd__xor2_2
XFILLER_58_127 vssd1 vccd1 vssd1 vccd1 sky130_ef_sc_hd__decap_40_12
XFILLER_86_436 vssd1 vssd1 vccd1 vccd1 sky130_fd_sc_hd__fill_4
X_4286_ _4328_/A _4286_/B vssd1 vssd1 vccd1 vccd1 _4435_/B sky130_fd_sc_hd__xor2_2
X_6025_ _6026_/A _6026_/B vssd1 vssd1 vccd1 vccd1 _6229_/B sky130_fd_sc_hd__nand2_2
XFILLER_27_569 vssd1 vssd1 vccd1 vccd1 sky130_fd_sc_hd__fill_1
XFILLER_64_29 vssd1 vssd1 vccd1 vccd1 sky130_fd_sc_hd__fill_2
XFILLER_66_182 vssd1 vssd1 vccd1 vccd1 sky130_fd_sc_hd__fill_4
XTAP_TAPCELL_ROW_65_851 vssd1 vccd1 sky130_fd_sc_hd__tapvpwrvgnd_1
XFILLER_54_377 vssd1 vssd1 vccd1 vccd1 sky130_fd_sc_hd__fill_1
X_7976_ _7977_/A _7977_/B _7977_/C vssd1 vssd1 vccd1 vccd1 _7978_/A sky130_fd_sc_hd__a21oi_2
XTAP_TAPCELL_ROW_37_575 vssd1 vccd1 sky130_fd_sc_hd__tapvpwrvgnd_1
X_6927_ _6836_/B _6838_/B _6836_/A vssd1 vssd1 vccd1 vccd1 _6929_/B sky130_fd_sc_hd__o21ba_2
XANTENNA_fanout335_X _7120_/A vssd1 vssd1 vccd1 vccd1 sky130_fd_sc_hd__diode_2
X_6858_ _6859_/A _6859_/B _6859_/C vssd1 vssd1 vccd1 vccd1 _6957_/A sky130_fd_sc_hd__a21oi_2
XFILLER_22_285 vssd1 vssd1 vccd1 vccd1 sky130_fd_sc_hd__fill_1
Xfanout89 wire92/X vssd1 vssd1 vccd1 vccd1 wire90/A sky130_fd_sc_hd__clkdlybuf4s25_1
Xfanout78 _5052_/X vssd1 vssd1 vccd1 vccd1 _6738_/B sky130_fd_sc_hd__clkdlybuf4s25_1
Xfanout67 _4731_/X vssd1 vssd1 vccd1 vccd1 _7326_/B sky130_fd_sc_hd__dlymetal6s4s_1
X_5809_ _5809_/A _5809_/B vssd1 vssd1 vccd1 vccd1 _5811_/B sky130_fd_sc_hd__xnor2_2
X_6789_ _6790_/A _6789_/B vssd1 vssd1 vccd1 vccd1 _7035_/B sky130_fd_sc_hd__nand2_2
XFILLER_89_15 vssd1 vssd1 vccd1 vccd1 sky130_fd_sc_hd__fill_4
XANTENNA__4857__A _8429_/D vssd1 vssd1 vccd1 vccd1 sky130_fd_sc_hd__diode_2
XPHY_EDGE_ROW_8_Left_101 vssd1 vssd1 vccd1 vccd1 sky130_fd_sc_hd__decap_3
XANTENNA__7233__A _7233_/A vssd1 vssd1 vccd1 vccd1 sky130_fd_sc_hd__diode_2
XTAP_TAPCELL_ROW_9_289 vssd1 vccd1 sky130_fd_sc_hd__tapvpwrvgnd_1
XFILLER_77_447 vssd1 vssd1 vccd1 vccd1 sky130_fd_sc_hd__fill_1
XFILLER_57_160 vssd1 vssd1 vccd1 vccd1 sky130_fd_sc_hd__fill_2
XFILLER_92_417 vssd1 vssd1 vccd1 vccd1 sky130_fd_sc_hd__fill_2
XANTENNA_input10_A gpio_in[17] vssd1 vssd1 vccd1 vccd1 sky130_fd_sc_hd__diode_2
XFILLER_72_141 vssd1 vssd1 vccd1 vccd1 sky130_fd_sc_hd__fill_2
XANTENNA__5838__D _8228_/A vssd1 vssd1 vccd1 vccd1 sky130_fd_sc_hd__diode_2
XFILLER_72_185 vssd1 vssd1 vccd1 vccd1 sky130_fd_sc_hd__fill_1
XFILLER_41_561 vssd1 vssd1 vccd1 vccd1 sky130_fd_sc_hd__fill_1
XFILLER_9_223 vssd1 vssd1 vccd1 vccd1 sky130_fd_sc_hd__fill_1
XFILLER_70_50 vssd1 vssd1 vccd1 vccd1 sky130_fd_sc_hd__fill_8
XFILLER_9_245 vssd1 vssd1 vccd1 vccd1 sky130_fd_sc_hd__fill_1
XFILLER_70_83 vssd1 vssd1 vccd1 vccd1 sky130_fd_sc_hd__fill_1
XANTENNA__6031__B _6517_/B vssd1 vssd1 vccd1 vccd1 sky130_fd_sc_hd__diode_2
XANTENNA__7143__A _7233_/A vssd1 vssd1 vccd1 vccd1 sky130_fd_sc_hd__diode_2
XFILLER_68_469 vssd1 vssd1 vccd1 vccd1 sky130_fd_sc_hd__fill_2
XTAP_TAPCELL_ROW_79_987 vssd1 vccd1 sky130_fd_sc_hd__tapvpwrvgnd_1
XANTENNA__6017__A2 _6798_/B vssd1 vssd1 vccd1 vccd1 sky130_fd_sc_hd__diode_2
X_7830_ _7830_/A _7830_/B vssd1 vssd1 vccd1 vccd1 _7833_/A sky130_fd_sc_hd__xnor2_2
X_7761_ _7762_/A _7762_/B vssd1 vssd1 vccd1 vccd1 _7909_/B sky130_fd_sc_hd__and2_2
X_4973_ _4973_/A _4973_/B vssd1 vssd1 vccd1 vccd1 _4975_/A sky130_fd_sc_hd__xor2_2
XTAP_TAPCELL_ROW_62_821 vssd1 vccd1 sky130_fd_sc_hd__tapvpwrvgnd_1
X_7692_ _7692_/A _7692_/B vssd1 vssd1 vccd1 vccd1 _7693_/B sky130_fd_sc_hd__or2_2
X_6712_ _6712_/A _6712_/B vssd1 vssd1 vccd1 vccd1 _6713_/B sky130_fd_sc_hd__nand2_2
XTAP_TAPCELL_ROW_34_545 vssd1 vccd1 sky130_fd_sc_hd__tapvpwrvgnd_1
X_6643_ _8417_/D _7326_/B vssd1 vssd1 vccd1 vccd1 _6748_/A sky130_fd_sc_hd__nand2_2
Xclkload9 clkload9/A vssd1 vssd1 vccd1 vccd1 clkload9/X sky130_fd_sc_hd__clkbuf_4
X_6574_ _6572_/A _6701_/B _6572_/B _6712_/A vssd1 vssd1 vccd1 vccd1 _6574_/X sky130_fd_sc_hd__a22o_2
XANTENNA__4751__A2 wire92/X vssd1 vssd1 vccd1 vccd1 sky130_fd_sc_hd__diode_2
X_8313_ _8388_/Q input4/X _8313_/S vssd1 vssd1 vccd1 vccd1 _8388_/D sky130_fd_sc_hd__mux2_1
X_5525_ _5647_/A _5569_/C _5569_/D _5568_/A vssd1 vssd1 vccd1 vccd1 _5527_/A sky130_fd_sc_hd__a22oi_2
X_8244_ _8241_/A _8243_/Y _8259_/A vssd1 vssd1 vccd1 vccd1 _8348_/D sky130_fd_sc_hd__mux2_1
X_5456_ _5456_/A _5456_/B vssd1 vssd1 vccd1 vccd1 _5468_/A sky130_fd_sc_hd__nor2_2
XANTENNA__5780__B _5780_/B vssd1 vssd1 vccd1 vccd1 sky130_fd_sc_hd__diode_2
XANTENNA__6876__B _6877_/B vssd1 vssd1 vccd1 vccd1 sky130_fd_sc_hd__diode_2
X_4407_ _4407_/A _4407_/B vssd1 vssd1 vccd1 vccd1 _4427_/A sky130_fd_sc_hd__xor2_2
X_8175_ _8173_/X _8174_/Y _8167_/Y _8171_/C vssd1 vssd1 vccd1 vccd1 _8177_/A sky130_fd_sc_hd__o211a_2
Xfanout202 _8400_/Q vssd1 vssd1 vccd1 vccd1 _8397_/D sky130_fd_sc_hd__clkdlybuf4s25_1
Xfanout213 _6397_/C vssd1 vssd1 vccd1 vccd1 _8133_/A sky130_fd_sc_hd__clkdlybuf4s25_1
X_5387_ _5386_/A _5386_/C _5417_/D _5386_/B vssd1 vssd1 vccd1 vccd1 _5388_/B sky130_fd_sc_hd__a22oi_2
XFILLER_59_447 vssd1 vssd1 vccd1 vccd1 sky130_fd_sc_hd__fill_1
Xfanout224 _6006_/A vssd1 vssd1 vccd1 vccd1 _7131_/A sky130_fd_sc_hd__clkdlybuf4s25_1
Xfanout235 _8371_/Q vssd1 vssd1 vccd1 vccd1 _8126_/A sky130_fd_sc_hd__clkdlybuf4s25_1
Xfanout246 _6238_/B vssd1 vssd1 vccd1 vccd1 _5393_/D sky130_fd_sc_hd__clkdlybuf4s25_1
X_7126_ _7127_/B _7127_/A vssd1 vssd1 vccd1 vccd1 _7227_/A sky130_fd_sc_hd__nand2b_2
X_4338_ _4770_/A _5703_/B vssd1 vssd1 vccd1 vccd1 _4355_/A sky130_fd_sc_hd__nor2_2
XTAP_TAPCELL_ROW_6_259 vssd1 vccd1 sky130_fd_sc_hd__tapvpwrvgnd_1
XANTENNA_input2_A gpio_in[0] vssd1 vssd1 vccd1 vccd1 sky130_fd_sc_hd__diode_2
Xfanout257 _5367_/C vssd1 vssd1 vccd1 vccd1 _5569_/C sky130_fd_sc_hd__clkdlybuf4s25_1
Xfanout268 _6830_/B vssd1 vssd1 vccd1 vccd1 _8108_/B sky130_fd_sc_hd__clkdlybuf4s25_1
Xfanout279 _8363_/Q vssd1 vssd1 vccd1 vccd1 _6548_/A sky130_fd_sc_hd__clkdlybuf4s25_1
X_7057_ _7057_/A _7057_/B vssd1 vssd1 vccd1 vccd1 _7058_/A sky130_fd_sc_hd__xnor2_2
X_4269_ _4282_/A _4269_/B vssd1 vssd1 vccd1 vccd1 _4274_/A sky130_fd_sc_hd__nand2_2
XFILLER_46_119 vssd1 vccd1 vssd1 vccd1 sky130_ef_sc_hd__decap_40_12
XFILLER_86_299 vssd1 vssd1 vccd1 vccd1 sky130_fd_sc_hd__fill_1
X_6008_ _6008_/A _6223_/A _6008_/C vssd1 vssd1 vccd1 vccd1 _6223_/B sky130_fd_sc_hd__nor3_2
XFILLER_54_141 vssd1 vssd1 vccd1 vccd1 sky130_fd_sc_hd__fill_2
XFILLER_15_539 vssd1 vssd1 vccd1 vccd1 sky130_fd_sc_hd__fill_1
X_7959_ _7959_/A _7959_/B vssd1 vssd1 vccd1 vccd1 _7960_/B sky130_fd_sc_hd__xor2_2
XFILLER_24_87 vssd1 vssd1 vccd1 vccd1 sky130_fd_sc_hd__fill_1
XFILLER_10_255 vssd1 vssd1 vccd1 vccd1 sky130_fd_sc_hd__fill_1
XFILLER_40_31 vssd1 vssd1 vccd1 vccd1 sky130_fd_sc_hd__fill_8
XANTENNA__7141__B1 _7140_/D vssd1 vssd1 vccd1 vccd1 sky130_fd_sc_hd__diode_2
XFILLER_2_487 vssd1 vssd1 vccd1 vccd1 sky130_fd_sc_hd__fill_8
XFILLER_49_40 vssd1 vssd1 vccd1 vccd1 sky130_fd_sc_hd__fill_2
XFILLER_77_277 vssd1 vssd1 vccd1 vccd1 sky130_fd_sc_hd__fill_2
XFILLER_92_203 vssd1 vssd1 vccd1 vccd1 sky130_fd_sc_hd__fill_1
XANTENNA_input13_X _8168_/B vssd1 vssd1 vccd1 vccd1 sky130_fd_sc_hd__diode_2
XTAP_TAPCELL_ROW_76_957 vssd1 vccd1 sky130_fd_sc_hd__tapvpwrvgnd_1
XFILLER_92_225 vssd1 vssd1 vccd1 vccd1 sky130_fd_sc_hd__fill_4
XANTENNA__6307__A _8436_/D vssd1 vssd1 vccd1 vccd1 sky130_fd_sc_hd__diode_2
XFILLER_65_83 vssd1 vssd1 vccd1 vccd1 sky130_fd_sc_hd__fill_4
XFILLER_80_409 vssd1 vssd1 vccd1 vccd1 sky130_fd_sc_hd__fill_1
XTAP_TAPCELL_ROW_86_1064 vssd1 vccd1 sky130_fd_sc_hd__tapvpwrvgnd_1
XFILLER_14_561 vssd1 vssd1 vccd1 vccd1 sky130_fd_sc_hd__fill_8
XFILLER_60_177 vssd1 vssd1 vccd1 vccd1 sky130_fd_sc_hd__fill_4
XTAP_TAPCELL_ROW_31_515 vssd1 vccd1 sky130_fd_sc_hd__tapvpwrvgnd_1
XANTENNA__8172__A2 _4144_/Y vssd1 vssd1 vccd1 vccd1 sky130_fd_sc_hd__diode_2
XANTENNA__8241__B input8/X vssd1 vssd1 vccd1 vccd1 sky130_fd_sc_hd__diode_2
X_6290_ _5943_/A _6293_/A _6095_/A _6095_/B vssd1 vssd1 vccd1 vccd1 _6298_/A sky130_fd_sc_hd__o22ai_2
X_5310_ _8184_/A _8191_/A _5521_/C _5559_/C vssd1 vssd1 vccd1 vccd1 _5312_/A sky130_fd_sc_hd__and4_2
XANTENNA__6696__B _7299_/B vssd1 vssd1 vccd1 vccd1 sky130_fd_sc_hd__diode_2
XFILLER_5_281 vssd1 vssd1 vccd1 vccd1 sky130_fd_sc_hd__fill_1
XANTENNA__4497__A1 _4919_/A vssd1 vssd1 vccd1 vccd1 sky130_fd_sc_hd__diode_2
XANTENNA__4497__B2 _6091_/A vssd1 vssd1 vccd1 vccd1 sky130_fd_sc_hd__diode_2
XANTENNA__4928__C _4979_/C vssd1 vssd1 vccd1 vccd1 sky130_fd_sc_hd__diode_2
X_5241_ _5241_/A _5256_/C _5241_/C vssd1 vssd1 vccd1 vccd1 _5246_/A sky130_fd_sc_hd__and3_2
X_5172_ _5171_/B _5172_/B vssd1 vssd1 vccd1 vccd1 _5173_/B sky130_fd_sc_hd__and2b_2
XFILLER_68_233 vssd1 vssd1 vccd1 vccd1 sky130_fd_sc_hd__fill_1
Xinput2 gpio_in[0] vssd1 vssd1 vccd1 vccd1 input2/X sky130_fd_sc_hd__clkdlybuf4s25_1
XTAP_TAPCELL_ROW_3_229 vssd1 vccd1 sky130_fd_sc_hd__tapvpwrvgnd_1
XFILLER_83_225 vssd1 vssd1 vccd1 vccd1 sky130_fd_sc_hd__fill_4
XFILLER_83_258 vssd1 vssd1 vccd1 vccd1 sky130_fd_sc_hd__fill_2
XANTENNA__6217__A _8016_/A vssd1 vssd1 vccd1 vccd1 sky130_fd_sc_hd__diode_2
XFILLER_64_461 vssd1 vssd1 vccd1 vccd1 sky130_fd_sc_hd__fill_1
X_7813_ _8081_/A _7954_/B vssd1 vssd1 vccd1 vccd1 _7813_/Y sky130_fd_sc_hd__nor2_2
XTAP_TAPCELL_ROW_47_670 vssd1 vccd1 sky130_fd_sc_hd__tapvpwrvgnd_1
XFILLER_51_144 vssd1 vssd1 vccd1 vccd1 sky130_fd_sc_hd__fill_1
X_7744_ _7887_/A _7743_/B _7743_/C vssd1 vssd1 vccd1 vccd1 _7745_/B sky130_fd_sc_hd__a21o_2
XTAP_TAPCELL_ROW_19_394 vssd1 vccd1 sky130_fd_sc_hd__tapvpwrvgnd_1
X_4956_ _5029_/B _4954_/Y _4870_/Y _4872_/Y vssd1 vssd1 vccd1 vccd1 _4956_/X sky130_fd_sc_hd__o211a_2
X_7675_ _7376_/B _7682_/A _7624_/B _7624_/A vssd1 vssd1 vccd1 vccd1 _7677_/A sky130_fd_sc_hd__a2bb2o_2
X_4887_ _4887_/A _4887_/B vssd1 vssd1 vccd1 vccd1 _4887_/Y sky130_fd_sc_hd__xnor2_2
X_6626_ _5910_/B _6632_/A _6375_/A _6375_/B vssd1 vssd1 vccd1 vccd1 _6636_/A sky130_fd_sc_hd__a2bb2o_2
XANTENNA__5921__A1 _6978_/A vssd1 vssd1 vccd1 vccd1 sky130_fd_sc_hd__diode_2
XANTENNA__7990__B _8361_/Q vssd1 vssd1 vccd1 vccd1 sky130_fd_sc_hd__diode_2
X_6557_ _6557_/A _6557_/B vssd1 vssd1 vccd1 vccd1 _6559_/C sky130_fd_sc_hd__xnor2_2
X_5508_ _5513_/A _5513_/B _5513_/C vssd1 vssd1 vccd1 vccd1 _5514_/A sky130_fd_sc_hd__o21ai_2
X_6488_ _6488_/A _6488_/B _6488_/C vssd1 vssd1 vccd1 vccd1 _6489_/B sky130_fd_sc_hd__or3_2
X_8227_ _8228_/A input6/X vssd1 vssd1 vccd1 vccd1 _8236_/A sky130_fd_sc_hd__and2_2
X_5439_ _5440_/A _5444_/A vssd1 vssd1 vccd1 vccd1 _5441_/A sky130_fd_sc_hd__nand2_2
XANTENNA__4200__A _6611_/A vssd1 vssd1 vccd1 vccd1 sky130_fd_sc_hd__diode_2
XFILLER_59_222 vssd1 vssd1 vccd1 vccd1 sky130_fd_sc_hd__fill_2
XFILLER_86_27 vssd1 vssd1 vccd1 vccd1 sky130_fd_sc_hd__fill_1
X_8158_ _8158_/A _8158_/B vssd1 vssd1 vccd1 vccd1 _8159_/B sky130_fd_sc_hd__xnor2_2
XANTENNA_input5_X input5/X vssd1 vssd1 vccd1 vccd1 sky130_fd_sc_hd__diode_2
XFILLER_19_21 vssd1 vssd1 vccd1 vccd1 sky130_fd_sc_hd__fill_2
X_7109_ _7030_/A _7030_/B _7028_/Y vssd1 vssd1 vccd1 vccd1 _7111_/B sky130_fd_sc_hd__a21oi_2
XANTENNA__5437__B1 _6006_/A vssd1 vssd1 vccd1 vccd1 sky130_fd_sc_hd__diode_2
XFILLER_74_203 vssd1 vssd1 vccd1 vccd1 sky130_fd_sc_hd__fill_1
X_8089_ _4209_/Y _7095_/B _7095_/C _8087_/X _8088_/X vssd1 vssd1 vccd1 vccd1 _8090_/B
+ sky130_fd_sc_hd__a41o_2
XANTENNA_fanout60_A _6360_/B vssd1 vssd1 vccd1 vccd1 sky130_fd_sc_hd__diode_2
XTAP_TAPCELL_ROW_73_927 vssd1 vccd1 sky130_fd_sc_hd__tapvpwrvgnd_1
XFILLER_35_64 vssd1 vssd1 vccd1 vccd1 sky130_fd_sc_hd__fill_4
XFILLER_35_86 vssd1 vssd1 vccd1 vccd1 sky130_fd_sc_hd__fill_1
XFILLER_11_553 vssd1 vssd1 vccd1 vccd1 sky130_fd_sc_hd__fill_1
XFILLER_2_273 vssd1 vssd1 vccd1 vccd1 sky130_fd_sc_hd__fill_2
XFILLER_78_531 vssd1 vssd1 vccd1 vccd1 sky130_fd_sc_hd__fill_1
XFILLER_65_225 vssd1 vssd1 vccd1 vccd1 sky130_fd_sc_hd__fill_1
XFILLER_65_247 vssd1 vssd1 vccd1 vccd1 sky130_fd_sc_hd__fill_4
XFILLER_61_420 vssd1 vssd1 vccd1 vccd1 sky130_fd_sc_hd__fill_1
X_4810_ _4743_/A _4742_/B _4740_/X vssd1 vssd1 vccd1 vccd1 _4812_/A sky130_fd_sc_hd__a21o_2
XTAP_TAPCELL_ROW_44_640 vssd1 vccd1 sky130_fd_sc_hd__tapvpwrvgnd_1
X_5790_ _5791_/A _5791_/B vssd1 vssd1 vccd1 vccd1 _5896_/B sky130_fd_sc_hd__and2_2
XTAP_TAPCELL_ROW_16_364 vssd1 vccd1 sky130_fd_sc_hd__tapvpwrvgnd_1
X_4741_ _8393_/Q _8452_/Q vssd1 vssd1 vccd1 vccd1 _4742_/B sky130_fd_sc_hd__or2_2
X_7460_ _8108_/A _8267_/B _8125_/B _8108_/B vssd1 vssd1 vccd1 vccd1 _7462_/A sky130_fd_sc_hd__a22oi_2
X_4672_ _4709_/A _4598_/B _4654_/C _4709_/B vssd1 vssd1 vccd1 vccd1 _4676_/B sky130_fd_sc_hd__a22o_2
X_6411_ _6412_/A _6412_/B _6412_/C vssd1 vssd1 vccd1 vccd1 _6424_/A sky130_fd_sc_hd__a21o_2
X_7391_ _7391_/A _7391_/B vssd1 vssd1 vccd1 vccd1 _7393_/B sky130_fd_sc_hd__xnor2_2
X_6342_ _6342_/A _6342_/B vssd1 vssd1 vccd1 vccd1 _6343_/B sky130_fd_sc_hd__xor2_2
XFILLER_88_306 vssd1 vssd1 vccd1 vccd1 sky130_fd_sc_hd__fill_2
X_6273_ _6274_/A _6274_/B _6274_/C vssd1 vssd1 vccd1 vccd1 _6473_/A sky130_fd_sc_hd__o21ai_2
X_8012_ _8125_/A _7877_/B _7877_/D _7875_/X vssd1 vssd1 vccd1 vccd1 _8023_/A sky130_fd_sc_hd__a31o_2
X_5224_ _5229_/A _5224_/B _5223_/X vssd1 vssd1 vccd1 vccd1 _5229_/B sky130_fd_sc_hd__nor3b_2
XANTENNA_fanout195_A _8071_/S vssd1 vssd1 vccd1 vccd1 sky130_fd_sc_hd__diode_2
X_5155_ _5155_/A _5710_/B _5710_/C vssd1 vssd1 vccd1 vccd1 _5156_/B sky130_fd_sc_hd__and3_2
XANTENNA__4674__B _5703_/B vssd1 vssd1 vccd1 vccd1 sky130_fd_sc_hd__diode_2
X_5086_ _6374_/A _5267_/B vssd1 vssd1 vccd1 vccd1 _5088_/B sky130_fd_sc_hd__nor2_2
XANTENNA__7050__B wire72/X vssd1 vssd1 vccd1 vccd1 sky130_fd_sc_hd__diode_2
XFILLER_72_29 vssd1 vccd1 vssd1 vccd1 sky130_ef_sc_hd__decap_40_12
XANTENNA_fanout248_X _7998_/B vssd1 vssd1 vccd1 vccd1 sky130_fd_sc_hd__diode_2
X_5988_ _5988_/A _5988_/B vssd1 vssd1 vccd1 vccd1 _5989_/B sky130_fd_sc_hd__xor2_2
X_7727_ _7728_/A _7728_/B vssd1 vssd1 vccd1 vccd1 _7870_/B sky130_fd_sc_hd__nand2_2
X_4939_ _4939_/A _4939_/B vssd1 vssd1 vccd1 vccd1 _4940_/A sky130_fd_sc_hd__xor2_2
XANTENNA__6147__A1 _6970_/A vssd1 vssd1 vccd1 vccd1 sky130_fd_sc_hd__diode_2
X_7658_ hold543/X _7657_/Y _7658_/S vssd1 vssd1 vccd1 vccd1 _8330_/D sky130_fd_sc_hd__mux2_1
X_6609_ _6609_/A _6609_/B _6609_/C vssd1 vssd1 vccd1 vccd1 _7299_/C sky130_fd_sc_hd__nand3_2
XTAP_TAPCELL_ROW_50_698 vssd1 vccd1 sky130_fd_sc_hd__tapvpwrvgnd_1
X_7589_ _7589_/A _7589_/B _7587_/Y vssd1 vssd1 vccd1 vccd1 _7590_/B sky130_fd_sc_hd__nor3b_2
XFILLER_75_501 vssd1 vssd1 vccd1 vccd1 sky130_fd_sc_hd__fill_2
XANTENNA_fanout63_X wire64/A vssd1 vssd1 vccd1 vccd1 sky130_fd_sc_hd__diode_2
XFILLER_47_225 vssd1 vssd1 vccd1 vccd1 sky130_fd_sc_hd__fill_2
XTAP_TAPCELL_ROW_58_776 vssd1 vccd1 sky130_fd_sc_hd__tapvpwrvgnd_1
XANTENNA__7895__B _7998_/B vssd1 vssd1 vccd1 vccd1 sky130_fd_sc_hd__diode_2
XFILLER_28_494 vssd1 vssd1 vccd1 vccd1 sky130_fd_sc_hd__fill_1
XFILLER_46_85 vssd1 vssd1 vccd1 vccd1 sky130_fd_sc_hd__fill_1
XTAP_TAPCELL_ROW_83_1034 vssd1 vccd1 sky130_fd_sc_hd__tapvpwrvgnd_1
XFILLER_70_294 vssd1 vssd1 vccd1 vccd1 sky130_fd_sc_hd__fill_1
XTAP_TAPCELL_ROW_41_610 vssd1 vccd1 sky130_fd_sc_hd__tapvpwrvgnd_1
XTAP_TAPCELL_ROW_13_334 vssd1 vccd1 sky130_fd_sc_hd__tapvpwrvgnd_1
XFILLER_7_57 vssd1 vssd1 vccd1 vccd1 sky130_fd_sc_hd__fill_4
XFILLER_30_5 vssd1 vssd1 vccd1 vccd1 sky130_fd_sc_hd__fill_1
XANTENNA__6861__A2 _8266_/A vssd1 vssd1 vccd1 vccd1 sky130_fd_sc_hd__diode_2
XFILLER_85_309 vssd1 vssd1 vccd1 vccd1 sky130_fd_sc_hd__fill_1
XANTENNA__4494__B _4770_/B vssd1 vssd1 vccd1 vccd1 sky130_fd_sc_hd__diode_2
XFILLER_16_3 vssd1 vssd1 vccd1 vccd1 sky130_fd_sc_hd__fill_4
XANTENNA__6990__A _7603_/A vssd1 vssd1 vccd1 vccd1 sky130_fd_sc_hd__diode_2
X_6960_ _7198_/B _6959_/B _6959_/C vssd1 vssd1 vccd1 vccd1 _6961_/B sky130_fd_sc_hd__o21a_2
X_5911_ _8410_/D _6757_/B _5775_/B vssd1 vssd1 vccd1 vccd1 _5911_/X sky130_fd_sc_hd__a21bo_2
X_6891_ _7129_/A _6892_/C _7515_/A _6892_/B vssd1 vssd1 vccd1 vccd1 _6893_/A sky130_fd_sc_hd__a22oi_2
XFILLER_34_475 vssd1 vssd1 vccd1 vccd1 sky130_fd_sc_hd__fill_1
X_5842_ _6435_/A _5842_/B _6238_/B _6035_/C vssd1 vssd1 vccd1 vccd1 _5844_/A sky130_fd_sc_hd__and4_2
XFILLER_34_497 vssd1 vssd1 vccd1 vccd1 sky130_fd_sc_hd__fill_8
XFILLER_61_283 vssd1 vssd1 vccd1 vccd1 sky130_fd_sc_hd__fill_1
X_5773_ _8411_/D wire66/X vssd1 vssd1 vccd1 vccd1 _5775_/B sky130_fd_sc_hd__nand2_2
XANTENNA_clkbuf_4_8_0_clk_A clkbuf_0_clk/X vssd1 vssd1 vccd1 vccd1 sky130_fd_sc_hd__diode_2
X_7512_ _7206_/Y _7208_/B _7361_/A _7511_/Y vssd1 vssd1 vccd1 vccd1 _7512_/Y sky130_fd_sc_hd__o31ai_2
X_4724_ _4663_/X _4664_/X _4723_/X _4722_/X vssd1 vssd1 vccd1 vccd1 _4724_/Y sky130_fd_sc_hd__o22ai_4
X_7443_ _7443_/A _7443_/B _7443_/C vssd1 vssd1 vccd1 vccd1 _7455_/B sky130_fd_sc_hd__nand3_2
X_4655_ _4709_/A _4654_/C _4692_/B _4709_/B vssd1 vssd1 vccd1 vccd1 _4656_/B sky130_fd_sc_hd__a22o_2
X_7374_ _7059_/Y _7629_/A _7373_/X vssd1 vssd1 vccd1 vccd1 _7376_/A sky130_fd_sc_hd__o21ai_2
X_4586_ _4589_/A _4589_/B _4583_/X vssd1 vssd1 vccd1 vccd1 _4588_/B sky130_fd_sc_hd__a21oi_2
X_6325_ _6130_/A _6130_/B _6131_/X vssd1 vssd1 vccd1 vccd1 _6327_/B sky130_fd_sc_hd__o21a_2
XFILLER_67_18 vssd1 vssd1 vccd1 vccd1 sky130_fd_sc_hd__fill_1
X_6256_ _6453_/B _6254_/X _6029_/A _6053_/A vssd1 vssd1 vccd1 vccd1 _6264_/B sky130_fd_sc_hd__o211a_2
XANTENNA_fanout198_X _4227_/S vssd1 vssd1 vccd1 vccd1 sky130_fd_sc_hd__diode_2
XFILLER_57_512 vssd1 vssd1 vccd1 vccd1 sky130_fd_sc_hd__fill_2
X_6187_ _6188_/B _6188_/A vssd1 vssd1 vccd1 vccd1 _6187_/X sky130_fd_sc_hd__and2b_2
X_5207_ _5207_/A _5694_/A _5207_/C vssd1 vssd1 vccd1 vccd1 _5694_/B sky130_fd_sc_hd__nand3_2
X_5138_ _8425_/D _5138_/B vssd1 vssd1 vccd1 vccd1 _5140_/B sky130_fd_sc_hd__nand2_2
XANTENNA__7801__B2 _6689_/A vssd1 vssd1 vccd1 vccd1 sky130_fd_sc_hd__diode_2
X_5069_ _5067_/A _5067_/B _5073_/A _5073_/B vssd1 vssd1 vccd1 vccd1 _5071_/B sky130_fd_sc_hd__a2bb2o_2
XFILLER_16_22 vssd1 vssd1 vccd1 vccd1 sky130_fd_sc_hd__fill_4
XTAP_TAPCELL_ROW_55_746 vssd1 vccd1 sky130_fd_sc_hd__tapvpwrvgnd_1
XFILLER_40_467 vssd1 vssd1 vccd1 vccd1 sky130_fd_sc_hd__fill_1
XFILLER_8_129 vssd1 vssd1 vccd1 vccd1 sky130_fd_sc_hd__fill_4
XTAP_TAPCELL_ROW_10_304 vssd1 vccd1 sky130_fd_sc_hd__tapvpwrvgnd_1
XANTENNA__7507__Y _7509_/B vssd1 vssd1 vccd1 vccd1 sky130_fd_sc_hd__diode_2
XPHY_EDGE_ROW_26_Left_119 vssd1 vssd1 vccd1 vccd1 sky130_fd_sc_hd__decap_3
XANTENNA__8293__A1 _8191_/B vssd1 vssd1 vccd1 vccd1 sky130_fd_sc_hd__diode_2
XFILLER_75_331 vssd1 vssd1 vccd1 vccd1 sky130_fd_sc_hd__fill_4
XFILLER_63_559 vssd1 vssd1 vccd1 vccd1 sky130_fd_sc_hd__fill_1
XPHY_EDGE_ROW_35_Left_128 vssd1 vssd1 vccd1 vccd1 sky130_fd_sc_hd__decap_3
XFILLER_16_453 vssd1 vssd1 vccd1 vccd1 sky130_fd_sc_hd__fill_1
XFILLER_16_475 vssd1 vssd1 vccd1 vccd1 sky130_fd_sc_hd__fill_1
XFILLER_31_456 vssd1 vssd1 vccd1 vccd1 sky130_fd_sc_hd__fill_1
X_4440_ _4440_/A _4440_/B _4441_/B vssd1 vssd1 vccd1 vccd1 _4440_/X sky130_fd_sc_hd__and3_2
XPHY_EDGE_ROW_44_Left_137 vssd1 vssd1 vccd1 vccd1 sky130_fd_sc_hd__decap_3
X_6110_ _6110_/A _6110_/B vssd1 vssd1 vccd1 vccd1 _6112_/A sky130_fd_sc_hd__nor2_2
X_4371_ _4919_/A _4384_/B vssd1 vssd1 vccd1 vccd1 _4386_/A sky130_fd_sc_hd__nand2_2
X_7090_ _7026_/A _7026_/B _7025_/A vssd1 vssd1 vccd1 vccd1 _7092_/B sky130_fd_sc_hd__o21ba_2
XFILLER_39_501 vssd1 vssd1 vccd1 vccd1 sky130_fd_sc_hd__fill_2
XFILLER_58_309 vssd1 vssd1 vccd1 vccd1 sky130_fd_sc_hd__fill_1
X_6041_ _6042_/B _6042_/A vssd1 vssd1 vccd1 vccd1 _6251_/A sky130_fd_sc_hd__and2b_2
XFILLER_39_523 vssd1 vssd1 vccd1 vccd1 sky130_fd_sc_hd__fill_1
XFILLER_54_537 vssd1 vssd1 vccd1 vccd1 sky130_fd_sc_hd__fill_2
X_7992_ _7889_/A _8277_/A _8359_/Q _7889_/B vssd1 vssd1 vccd1 vccd1 _7994_/A sky130_fd_sc_hd__a22oi_2
XPHY_EDGE_ROW_53_Left_146 vssd1 vssd1 vccd1 vccd1 sky130_fd_sc_hd__decap_3
XFILLER_54_559 vssd1 vssd1 vccd1 vccd1 sky130_fd_sc_hd__fill_1
XFILLER_81_334 vssd1 vssd1 vccd1 vccd1 sky130_fd_sc_hd__fill_2
X_6943_ _6942_/A _6942_/B _6942_/C vssd1 vssd1 vccd1 vccd1 _6950_/B sky130_fd_sc_hd__o21ai_2
X_6874_ _6873_/A _6873_/B _6875_/A vssd1 vssd1 vccd1 vccd1 _6874_/Y sky130_fd_sc_hd__o21ai_2
XTAP_TAPCELL_ROW_52_716 vssd1 vccd1 sky130_fd_sc_hd__tapvpwrvgnd_1
X_5825_ _5825_/A _5825_/B vssd1 vssd1 vccd1 vccd1 _5827_/A sky130_fd_sc_hd__nor2_2
XANTENNA_fanout325_A _8342_/Q vssd1 vssd1 vccd1 vccd1 sky130_fd_sc_hd__diode_2
X_5756_ _5756_/A _5756_/B vssd1 vssd1 vccd1 vccd1 _5758_/B sky130_fd_sc_hd__nor2_2
X_5687_ _5687_/A _5687_/B vssd1 vssd1 vccd1 vccd1 _5687_/Y sky130_fd_sc_hd__xnor2_2
X_4707_ _8422_/D _4707_/B vssd1 vssd1 vccd1 vccd1 _4708_/B sky130_fd_sc_hd__nand2_2
XPHY_EDGE_ROW_62_Left_155 vssd1 vssd1 vccd1 vccd1 sky130_fd_sc_hd__decap_3
XANTENNA__6522__A1 _7998_/A vssd1 vssd1 vccd1 vccd1 sky130_fd_sc_hd__diode_2
X_7426_ _7426_/A _7515_/A _7714_/C _7714_/D vssd1 vssd1 vccd1 vccd1 _7428_/A sky130_fd_sc_hd__and4_2
X_4638_ _4638_/A _4638_/B vssd1 vssd1 vccd1 vccd1 _4638_/X sky130_fd_sc_hd__xor2_2
XANTENNA__6522__B2 _8103_/B vssd1 vssd1 vccd1 vccd1 sky130_fd_sc_hd__diode_2
X_7357_ _7356_/A _7356_/B _7356_/C vssd1 vssd1 vccd1 vccd1 _7358_/B sky130_fd_sc_hd__a21oi_2
X_4569_ _4569_/A _4569_/B vssd1 vssd1 vccd1 vccd1 _4570_/A sky130_fd_sc_hd__or2_4
X_7288_ _7506_/A _7288_/B vssd1 vssd1 vccd1 vccd1 _7290_/C sky130_fd_sc_hd__nor2_2
X_6308_ _6308_/A _6308_/B vssd1 vssd1 vccd1 vccd1 _6310_/B sky130_fd_sc_hd__xnor2_2
Xteam_03_402 vssd1 vssd1 vccd1 vccd1 team_03_402/HI gpio_oeb[33] sky130_fd_sc_hd__conb_1
Xteam_03_413 vssd1 vssd1 vccd1 vccd1 team_03_413/HI gpio_out[10] sky130_fd_sc_hd__conb_1
Xteam_03_424 vssd1 vssd1 vccd1 vccd1 gpio_oeb[3] team_03_424/LO sky130_fd_sc_hd__conb_1
X_6239_ _6435_/A _6894_/B _6238_/D _6238_/B vssd1 vssd1 vccd1 vccd1 _6240_/B sky130_fd_sc_hd__a22oi_2
Xteam_03_435 vssd1 vssd1 vccd1 vccd1 gpio_oeb[14] team_03_435/LO sky130_fd_sc_hd__conb_1
XFILLER_57_353 vssd1 vssd1 vccd1 vccd1 sky130_fd_sc_hd__fill_1
XPHY_EDGE_ROW_71_Left_164 vssd1 vssd1 vccd1 vccd1 sky130_fd_sc_hd__decap_3
XFILLER_27_21 vssd1 vssd1 vccd1 vccd1 sky130_fd_sc_hd__fill_2
XTAP_TAPCELL_ROW_68_882 vssd1 vccd1 sky130_fd_sc_hd__tapvpwrvgnd_1
XFILLER_27_98 vssd1 vssd1 vccd1 vccd1 sky130_fd_sc_hd__fill_1
XFILLER_72_378 vssd1 vssd1 vccd1 vccd1 sky130_fd_sc_hd__fill_1
XFILLER_25_283 vssd1 vssd1 vccd1 vccd1 sky130_fd_sc_hd__fill_1
XTAP_TAPCELL_ROW_80_1004 vssd1 vccd1 sky130_fd_sc_hd__tapvpwrvgnd_1
XANTENNA__5013__A1 _5930_/A vssd1 vssd1 vccd1 vccd1 sky130_fd_sc_hd__diode_2
XANTENNA__5013__B2 _5747_/A vssd1 vssd1 vccd1 vccd1 sky130_fd_sc_hd__diode_2
XFILLER_40_253 vssd1 vssd1 vccd1 vccd1 sky130_fd_sc_hd__fill_2
XPHY_EDGE_ROW_80_Left_173 vssd1 vssd1 vccd1 vccd1 sky130_fd_sc_hd__decap_3
XTAP_TAPCELL_ROW_91_1111 vssd1 vccd1 sky130_fd_sc_hd__tapvpwrvgnd_1
XANTENNA__6816__A2 _6894_/B vssd1 vssd1 vccd1 vccd1 sky130_fd_sc_hd__diode_2
XANTENNA__4827__A1 _4761_/A vssd1 vssd1 vccd1 vccd1 sky130_fd_sc_hd__diode_2
XFILLER_68_83 vssd1 vssd1 vccd1 vccd1 sky130_fd_sc_hd__fill_1
XFILLER_48_342 vssd1 vssd1 vccd1 vccd1 sky130_fd_sc_hd__fill_1
XANTENNA__6971__C _7095_/C vssd1 vssd1 vccd1 vccd1 sky130_fd_sc_hd__diode_2
XTAP_TAPCELL_ROW_89_1095 vssd1 vccd1 sky130_fd_sc_hd__tapvpwrvgnd_1
XFILLER_51_529 vssd1 vssd1 vccd1 vccd1 sky130_fd_sc_hd__fill_1
XFILLER_63_356 vssd1 vssd1 vccd1 vccd1 sky130_fd_sc_hd__fill_1
XANTENNA__6332__X _7095_/C vssd1 vssd1 vccd1 vccd1 sky130_fd_sc_hd__diode_2
XFILLER_83_3 vssd1 vssd1 vccd1 vccd1 sky130_fd_sc_hd__fill_4
X_6590_ _6309_/X _6588_/Y _6589_/Y vssd1 vssd1 vccd1 vccd1 _6591_/B sky130_fd_sc_hd__a21oi_2
X_5610_ _5610_/A _5610_/B vssd1 vssd1 vccd1 vccd1 _5611_/B sky130_fd_sc_hd__and2_2
X_5541_ _5484_/A _5486_/B _5484_/B vssd1 vssd1 vccd1 vccd1 _5543_/B sky130_fd_sc_hd__o21ba_2
XFILLER_8_471 vssd1 vssd1 vccd1 vccd1 sky130_fd_sc_hd__fill_4
X_8260_ _8255_/A _8255_/B _8259_/Y vssd1 vssd1 vccd1 vccd1 _8263_/C sky130_fd_sc_hd__a21oi_2
X_7211_ _7426_/A _7210_/C _7427_/B1 _7210_/A vssd1 vssd1 vccd1 vccd1 _7212_/B sky130_fd_sc_hd__a22oi_2
X_5472_ _5506_/A _5506_/B vssd1 vssd1 vccd1 vccd1 _5507_/A sky130_fd_sc_hd__or2_2
X_8191_ _8191_/A _8191_/B vssd1 vssd1 vccd1 vccd1 _8192_/B sky130_fd_sc_hd__and2_2
X_4423_ _4423_/A _4423_/B vssd1 vssd1 vccd1 vccd1 _4515_/A sky130_fd_sc_hd__xor2_2
X_7142_ _7142_/A _7142_/B vssd1 vssd1 vccd1 vccd1 _7144_/A sky130_fd_sc_hd__nor2_2
X_4354_ _4919_/A _4487_/B vssd1 vssd1 vccd1 vccd1 _4355_/B sky130_fd_sc_hd__nand2_2
X_7073_ _7074_/A _7074_/B vssd1 vssd1 vccd1 vccd1 _7073_/X sky130_fd_sc_hd__and2_2
XFILLER_58_139 vssd1 vssd1 vccd1 vccd1 sky130_fd_sc_hd__fill_1
X_6024_ _6024_/A _6024_/B vssd1 vssd1 vccd1 vccd1 _6026_/B sky130_fd_sc_hd__xnor2_2
X_4285_ _4744_/A _5149_/B vssd1 vssd1 vccd1 vccd1 _4435_/A sky130_fd_sc_hd__nand2_2
XANTENNA_fanout275_A _6548_/A vssd1 vssd1 vccd1 vccd1 sky130_fd_sc_hd__diode_2
XFILLER_27_548 vssd1 vssd1 vccd1 vccd1 sky130_fd_sc_hd__fill_1
XFILLER_27_559 vssd1 vssd1 vccd1 vccd1 sky130_fd_sc_hd__fill_1
XFILLER_54_334 vssd1 vssd1 vccd1 vccd1 sky130_fd_sc_hd__fill_1
X_7975_ _7975_/A _7975_/B vssd1 vssd1 vccd1 vccd1 _7977_/C sky130_fd_sc_hd__xnor2_2
X_6926_ _6926_/A _6926_/B vssd1 vssd1 vccd1 vccd1 _6929_/A sky130_fd_sc_hd__xnor2_2
XTAP_TAPCELL_ROW_65_852 vssd1 vccd1 sky130_fd_sc_hd__tapvpwrvgnd_1
XFILLER_80_29 vssd1 vssd1 vccd1 vccd1 sky130_fd_sc_hd__fill_8
Xfanout46 _5763_/Y vssd1 vssd1 vccd1 vccd1 _6986_/B sky130_fd_sc_hd__clkdlybuf4s25_1
X_6857_ _6518_/A _6520_/B _6518_/B vssd1 vssd1 vccd1 vccd1 _6859_/C sky130_fd_sc_hd__o21ba_2
XANTENNA_fanout230_X _5386_/C vssd1 vssd1 vccd1 vccd1 sky130_fd_sc_hd__diode_2
Xfanout79 _5052_/X vssd1 vssd1 vccd1 vccd1 _5274_/B sky130_fd_sc_hd__clkdlybuf4s25_1
Xfanout68 _4731_/X vssd1 vssd1 vccd1 vccd1 _5780_/B sky130_fd_sc_hd__clkdlybuf4s25_1
X_6788_ _6788_/A _6788_/B vssd1 vssd1 vccd1 vccd1 _6790_/B sky130_fd_sc_hd__xor2_2
X_5808_ _5808_/A _5808_/B vssd1 vssd1 vccd1 vccd1 _5809_/B sky130_fd_sc_hd__xnor2_2
X_5739_ _5739_/A _5943_/A vssd1 vssd1 vccd1 vccd1 _5739_/Y sky130_fd_sc_hd__nor2_2
XFILLER_89_27 vssd1 vccd1 vssd1 vccd1 sky130_ef_sc_hd__decap_40_12
X_8389_ clkload1/A _8389_/D fanout357/X vssd1 vssd1 vccd1 vccd1 _8389_/Q sky130_fd_sc_hd__dfrtp_2
X_7409_ _7409_/A _7603_/B vssd1 vssd1 vccd1 vccd1 _7410_/B sky130_fd_sc_hd__nor2_2
XFILLER_38_75 vssd1 vssd1 vccd1 vccd1 sky130_fd_sc_hd__fill_1
XFILLER_54_63 vssd1 vssd1 vccd1 vccd1 sky130_fd_sc_hd__fill_4
XFILLER_60_315 vssd1 vssd1 vccd1 vccd1 sky130_fd_sc_hd__fill_1
XFILLER_72_197 vssd1 vssd1 vccd1 vccd1 sky130_fd_sc_hd__fill_2
XTAP_TAPCELL_ROW_0_190 vssd1 vccd1 sky130_fd_sc_hd__tapvpwrvgnd_1
XFILLER_54_85 vssd1 vssd1 vccd1 vccd1 sky130_fd_sc_hd__fill_4
XANTENNA__6031__C _8228_/A vssd1 vssd1 vccd1 vccd1 sky130_fd_sc_hd__diode_2
XANTENNA__8415__CLK clkload4/A vssd1 vssd1 vccd1 vccd1 sky130_fd_sc_hd__diode_2
XFILLER_5_496 vssd1 vssd1 vccd1 vccd1 sky130_fd_sc_hd__fill_2
XFILLER_79_71 vssd1 vssd1 vccd1 vccd1 sky130_fd_sc_hd__fill_1
XANTENNA__7143__B _7723_/D vssd1 vssd1 vccd1 vccd1 sky130_fd_sc_hd__diode_2
XANTENNA__8392__RESET_B load_slew358/X vssd1 vssd1 vccd1 vccd1 sky130_fd_sc_hd__diode_2
XFILLER_83_407 vssd1 vssd1 vccd1 vccd1 sky130_fd_sc_hd__fill_1
XTAP_TAPCELL_ROW_79_988 vssd1 vccd1 sky130_fd_sc_hd__tapvpwrvgnd_1
XFILLER_51_337 vssd1 vssd1 vccd1 vccd1 sky130_fd_sc_hd__fill_1
X_7760_ _7760_/A _7760_/B vssd1 vssd1 vccd1 vccd1 _7762_/B sky130_fd_sc_hd__xnor2_2
X_4972_ _6588_/A _4972_/B vssd1 vssd1 vccd1 vccd1 _5164_/A sky130_fd_sc_hd__nand2_2
XTAP_TAPCELL_ROW_62_822 vssd1 vccd1 sky130_fd_sc_hd__tapvpwrvgnd_1
X_7691_ _7692_/A _7692_/B vssd1 vssd1 vccd1 vccd1 _7693_/A sky130_fd_sc_hd__nand2_2
X_6711_ _8433_/D wire90/X _6584_/B _6582_/X vssd1 vssd1 vccd1 vccd1 _6713_/A sky130_fd_sc_hd__a31o_2
X_6642_ _6642_/A _6642_/B vssd1 vssd1 vccd1 vccd1 _6663_/A sky130_fd_sc_hd__xor2_2
X_8312_ _8446_/D _8208_/B _8313_/S vssd1 vssd1 vccd1 vccd1 _8387_/D sky130_fd_sc_hd__mux2_1
X_6573_ _6573_/A _6708_/A vssd1 vssd1 vccd1 vccd1 _6573_/Y sky130_fd_sc_hd__nor2_2
X_5524_ _5530_/B _5564_/A _5530_/A vssd1 vssd1 vccd1 vccd1 _5534_/B sky130_fd_sc_hd__o21ai_2
X_8243_ _8248_/A _8243_/B vssd1 vssd1 vccd1 vccd1 _8243_/Y sky130_fd_sc_hd__xnor2_2
X_5455_ _5454_/B _5454_/C _5454_/A vssd1 vssd1 vccd1 vccd1 _5456_/B sky130_fd_sc_hd__o21a_2
X_8174_ _8174_/A _8174_/B vssd1 vssd1 vccd1 vccd1 _8174_/Y sky130_fd_sc_hd__nor2_2
X_4406_ _4408_/A _4408_/B vssd1 vssd1 vccd1 vccd1 _4406_/Y sky130_fd_sc_hd__nand2b_2
XANTENNA__7053__B _7326_/B vssd1 vssd1 vccd1 vccd1 sky130_fd_sc_hd__diode_2
Xfanout203 _8400_/Q vssd1 vssd1 vccd1 vccd1 _8259_/A sky130_fd_sc_hd__clkdlybuf4s25_1
Xfanout214 _8376_/Q vssd1 vssd1 vccd1 vccd1 _6397_/C sky130_fd_sc_hd__clkdlybuf4s25_1
X_7125_ _6885_/B _6887_/B _6885_/A vssd1 vssd1 vccd1 vccd1 _7127_/B sky130_fd_sc_hd__o21ba_2
X_5386_ _5386_/A _5386_/B _5386_/C _5417_/D vssd1 vssd1 vccd1 vccd1 _5388_/A sky130_fd_sc_hd__and4_2
XANTENNA__8409__RESET_B load_slew358/X vssd1 vssd1 vccd1 vccd1 sky130_fd_sc_hd__diode_2
Xfanout225 _8373_/Q vssd1 vssd1 vccd1 vccd1 _6006_/A sky130_fd_sc_hd__clkdlybuf4s25_1
Xfanout236 _7233_/A vssd1 vssd1 vccd1 vccd1 _8125_/A sky130_fd_sc_hd__clkdlybuf4s25_1
Xfanout247 _8368_/Q vssd1 vssd1 vccd1 vccd1 _6238_/B sky130_fd_sc_hd__clkdlybuf4s25_1
X_4337_ _4337_/A _4337_/B vssd1 vssd1 vccd1 vccd1 _4412_/A sky130_fd_sc_hd__xnor2_2
Xfanout258 _6517_/A vssd1 vssd1 vccd1 vccd1 _5367_/C sky130_fd_sc_hd__clkdlybuf4s25_1
Xfanout269 _8365_/Q vssd1 vssd1 vccd1 vccd1 _6830_/B sky130_fd_sc_hd__clkdlybuf4s25_1
X_7056_ _7057_/B _7057_/A vssd1 vssd1 vccd1 vccd1 _7335_/A sky130_fd_sc_hd__nand2b_2
X_4268_ _8389_/Q _8448_/Q vssd1 vssd1 vccd1 vccd1 _4269_/B sky130_fd_sc_hd__or2_2
XANTENNA__5789__A _7969_/A vssd1 vssd1 vccd1 vccd1 sky130_fd_sc_hd__diode_2
XANTENNA_fanout180_X _5928_/A vssd1 vssd1 vccd1 vccd1 sky130_fd_sc_hd__diode_2
X_6007_ _6008_/A _6223_/A _6008_/C vssd1 vssd1 vccd1 vccd1 _6010_/B sky130_fd_sc_hd__o21a_2
XANTENNA_fanout278_X _8121_/A vssd1 vssd1 vccd1 vccd1 sky130_fd_sc_hd__diode_2
X_4199_ _4198_/B _8406_/Q _4198_/Y vssd1 vssd1 vccd1 vccd1 _6723_/A sky130_fd_sc_hd__o21ai_2
XFILLER_82_440 vssd1 vssd1 vccd1 vccd1 sky130_fd_sc_hd__fill_1
XFILLER_82_473 vssd1 vssd1 vccd1 vccd1 sky130_fd_sc_hd__fill_2
X_7958_ _7958_/A _8081_/B vssd1 vssd1 vccd1 vccd1 _7959_/B sky130_fd_sc_hd__nor2_2
XFILLER_91_28 vssd1 vssd1 vccd1 vccd1 sky130_fd_sc_hd__fill_2
XFILLER_24_22 vssd1 vssd1 vccd1 vccd1 sky130_fd_sc_hd__fill_1
X_7889_ _7889_/A _7889_/B _8103_/D _8277_/A vssd1 vssd1 vccd1 vccd1 _7890_/B sky130_fd_sc_hd__and4_2
X_6909_ _6909_/A _6909_/B vssd1 vssd1 vccd1 vccd1 _6911_/B sky130_fd_sc_hd__xnor2_2
XFILLER_10_234 vssd1 vssd1 vccd1 vccd1 sky130_fd_sc_hd__fill_1
XFILLER_50_381 vssd1 vssd1 vccd1 vccd1 sky130_fd_sc_hd__fill_1
XFILLER_10_289 vssd1 vssd1 vccd1 vccd1 sky130_fd_sc_hd__fill_2
XANTENNA__7141__A1 _7875_/A vssd1 vssd1 vccd1 vccd1 sky130_fd_sc_hd__diode_2
XFILLER_2_477 vssd1 vssd1 vccd1 vccd1 sky130_fd_sc_hd__fill_4
XFILLER_49_96 vssd1 vssd1 vccd1 vccd1 sky130_fd_sc_hd__fill_2
XFILLER_1_26 vssd1 vssd1 vccd1 vccd1 sky130_fd_sc_hd__fill_2
XFILLER_65_407 vssd1 vssd1 vccd1 vccd1 sky130_fd_sc_hd__fill_1
XFILLER_45_120 vssd1 vssd1 vccd1 vccd1 sky130_fd_sc_hd__fill_2
XFILLER_65_51 vssd1 vssd1 vccd1 vccd1 sky130_fd_sc_hd__fill_4
XTAP_TAPCELL_ROW_76_958 vssd1 vccd1 sky130_fd_sc_hd__tapvpwrvgnd_1
XTAP_TAPCELL_ROW_86_1065 vssd1 vccd1 sky130_fd_sc_hd__tapvpwrvgnd_1
XANTENNA__4981__A3 _4979_/C vssd1 vssd1 vccd1 vccd1 sky130_fd_sc_hd__diode_2
X_5240_ _5217_/A _5267_/B _5218_/A _5216_/X vssd1 vssd1 vccd1 vccd1 _5241_/C sky130_fd_sc_hd__a2bb2o_2
XANTENNA__4497__A2 _4700_/B vssd1 vssd1 vccd1 vccd1 sky130_fd_sc_hd__diode_2
XFILLER_46_3 vssd1 vssd1 vccd1 vccd1 sky130_fd_sc_hd__fill_4
XANTENNA__6891__B1 _7515_/A vssd1 vssd1 vccd1 vccd1 sky130_fd_sc_hd__diode_2
X_5171_ _5172_/B _5171_/B vssd1 vssd1 vccd1 vccd1 _5173_/A sky130_fd_sc_hd__and2b_2
XPHY_EDGE_ROW_18_Right_18 vssd1 vssd1 vccd1 vccd1 sky130_fd_sc_hd__decap_3
XFILLER_49_470 vssd1 vssd1 vccd1 vccd1 sky130_fd_sc_hd__fill_1
Xinput3 gpio_in[10] vssd1 vssd1 vccd1 vccd1 input3/X sky130_fd_sc_hd__clkbuf_2
XANTENNA__6217__B _8126_/A vssd1 vssd1 vccd1 vccd1 sky130_fd_sc_hd__diode_2
X_7812_ _7812_/A _7812_/B vssd1 vssd1 vccd1 vccd1 _7842_/A sky130_fd_sc_hd__xnor2_2
XTAP_TAPCELL_ROW_47_671 vssd1 vccd1 sky130_fd_sc_hd__tapvpwrvgnd_1
X_7743_ _7887_/A _7743_/B _7743_/C vssd1 vssd1 vccd1 vccd1 _7887_/B sky130_fd_sc_hd__nand3_2
X_4955_ _4870_/Y _4872_/Y _5029_/B _4954_/Y vssd1 vssd1 vccd1 vccd1 _4955_/Y sky130_fd_sc_hd__a211oi_4
XTAP_TAPCELL_ROW_19_395 vssd1 vccd1 sky130_fd_sc_hd__tapvpwrvgnd_1
XPHY_EDGE_ROW_27_Right_27 vssd1 vssd1 vccd1 vccd1 sky130_fd_sc_hd__decap_3
XFILLER_91_292 vssd1 vssd1 vccd1 vccd1 sky130_fd_sc_hd__fill_2
XFILLER_20_521 vssd1 vssd1 vccd1 vccd1 sky130_fd_sc_hd__fill_1
X_7674_ _7674_/A _7674_/B vssd1 vssd1 vccd1 vccd1 _7703_/A sky130_fd_sc_hd__and2_2
X_4886_ _4731_/A _5049_/A _4730_/X _4885_/X _4883_/X vssd1 vssd1 vccd1 vccd1 _4886_/X
+ sky130_fd_sc_hd__a32o_2
X_6625_ _6625_/A _6625_/B vssd1 vssd1 vccd1 vccd1 _6673_/A sky130_fd_sc_hd__xnor2_2
X_6556_ _6557_/B _6557_/A vssd1 vssd1 vccd1 vccd1 _6556_/X sky130_fd_sc_hd__and2b_2
X_5507_ _5507_/A _5507_/B vssd1 vssd1 vccd1 vccd1 _5513_/C sky130_fd_sc_hd__xnor2_2
X_8226_ _8221_/A _8224_/B _8221_/B vssd1 vssd1 vccd1 vccd1 _8235_/A sky130_fd_sc_hd__a21boi_2
X_6487_ _6488_/A _6488_/B _6488_/C vssd1 vssd1 vccd1 vccd1 _6812_/A sky130_fd_sc_hd__o21ai_2
X_5438_ _5438_/A _5438_/B _5438_/C vssd1 vssd1 vccd1 vccd1 _5444_/A sky130_fd_sc_hd__and3_2
XPHY_EDGE_ROW_36_Right_36 vssd1 vssd1 vccd1 vccd1 sky130_fd_sc_hd__decap_3
X_8157_ _8157_/A _8157_/B vssd1 vssd1 vccd1 vccd1 _8158_/B sky130_fd_sc_hd__xnor2_2
X_5369_ _5369_/A _5369_/B vssd1 vssd1 vccd1 vccd1 _5370_/B sky130_fd_sc_hd__nor2_2
X_8088_ _7958_/A _7806_/B _8087_/X vssd1 vssd1 vccd1 vccd1 _8088_/X sky130_fd_sc_hd__o21ba_2
X_7108_ _7108_/A _7108_/B vssd1 vssd1 vccd1 vccd1 _7111_/A sky130_fd_sc_hd__xnor2_2
X_7039_ _7039_/A _7039_/B vssd1 vssd1 vccd1 vccd1 _7040_/B sky130_fd_sc_hd__nor2_2
XFILLER_74_237 vssd1 vssd1 vccd1 vccd1 sky130_fd_sc_hd__fill_2
XANTENNA__7230__C _8136_/A vssd1 vssd1 vccd1 vccd1 sky130_fd_sc_hd__diode_2
XANTENNA_fanout53_A _6757_/B vssd1 vssd1 vccd1 vccd1 sky130_fd_sc_hd__diode_2
XFILLER_55_462 vssd1 vssd1 vccd1 vccd1 sky130_fd_sc_hd__fill_4
XFILLER_27_164 vssd1 vssd1 vccd1 vccd1 sky130_fd_sc_hd__fill_4
XFILLER_35_10 vssd1 vssd1 vccd1 vccd1 sky130_fd_sc_hd__fill_8
XFILLER_82_270 vssd1 vssd1 vccd1 vccd1 sky130_fd_sc_hd__fill_2
XTAP_TAPCELL_ROW_73_928 vssd1 vccd1 sky130_fd_sc_hd__tapvpwrvgnd_1
XPHY_EDGE_ROW_45_Right_45 vssd1 vssd1 vccd1 vccd1 sky130_fd_sc_hd__decap_3
XFILLER_15_337 vssd1 vssd1 vccd1 vccd1 sky130_fd_sc_hd__fill_1
XFILLER_42_156 vssd1 vssd1 vccd1 vccd1 sky130_fd_sc_hd__fill_1
XANTENNA__6143__A _6611_/A vssd1 vssd1 vccd1 vccd1 sky130_fd_sc_hd__diode_2
XFILLER_11_521 vssd1 vssd1 vccd1 vccd1 sky130_fd_sc_hd__fill_1
XFILLER_7_503 vssd1 vssd1 vccd1 vccd1 sky130_fd_sc_hd__fill_1
XANTENNA__5982__A _6611_/A vssd1 vssd1 vccd1 vccd1 sky130_fd_sc_hd__diode_2
XFILLER_7_569 vssd1 vssd1 vccd1 vccd1 sky130_fd_sc_hd__fill_1
XPHY_EDGE_ROW_54_Right_54 vssd1 vssd1 vccd1 vccd1 sky130_fd_sc_hd__decap_3
XANTENNA__7140__C _7140_/C vssd1 vssd1 vccd1 vccd1 sky130_fd_sc_hd__diode_2
XPHY_EDGE_ROW_63_Right_63 vssd1 vssd1 vccd1 vccd1 sky130_fd_sc_hd__decap_3
XFILLER_33_145 vssd1 vssd1 vccd1 vccd1 sky130_fd_sc_hd__fill_2
XFILLER_73_281 vssd1 vssd1 vccd1 vccd1 sky130_fd_sc_hd__fill_4
XTAP_TAPCELL_ROW_44_641 vssd1 vccd1 sky130_fd_sc_hd__tapvpwrvgnd_1
XTAP_TAPCELL_ROW_16_365 vssd1 vccd1 sky130_fd_sc_hd__tapvpwrvgnd_1
XFILLER_92_82 vssd1 vssd1 vccd1 vccd1 sky130_fd_sc_hd__fill_2
X_4740_ _8393_/Q _8452_/Q vssd1 vssd1 vccd1 vccd1 _4740_/X sky130_fd_sc_hd__and2_2
X_4671_ _4671_/A _4671_/B vssd1 vssd1 vccd1 vccd1 _4676_/A sky130_fd_sc_hd__xnor2_2
X_7390_ _7390_/A _7390_/B vssd1 vssd1 vccd1 vccd1 _7391_/B sky130_fd_sc_hd__xnor2_2
X_6410_ _6499_/B _6410_/B vssd1 vssd1 vccd1 vccd1 _6412_/C sky130_fd_sc_hd__nand2_2
X_6341_ _6341_/A _6341_/B vssd1 vssd1 vccd1 vccd1 _6342_/B sky130_fd_sc_hd__xor2_2
XPHY_EDGE_ROW_72_Right_72 vssd1 vssd1 vccd1 vccd1 sky130_fd_sc_hd__decap_3
X_6272_ _6272_/A _6272_/B vssd1 vssd1 vccd1 vccd1 _6274_/C sky130_fd_sc_hd__xnor2_2
X_8011_ _8147_/A _8009_/Y _7900_/X _7904_/A vssd1 vssd1 vccd1 vccd1 _8046_/B sky130_fd_sc_hd__a211o_2
X_5223_ _8406_/D wire66/A vssd1 vssd1 vccd1 vccd1 _5223_/X sky130_fd_sc_hd__and2_2
X_5154_ _5154_/A _5154_/B vssd1 vssd1 vccd1 vccd1 _5178_/A sky130_fd_sc_hd__xnor2_2
XANTENNA_clkbuf_4_4_0_clk_A clkbuf_0_clk/X vssd1 vssd1 vccd1 vccd1 sky130_fd_sc_hd__diode_2
XANTENNA__6092__A1 _6576_/A vssd1 vssd1 vccd1 vccd1 sky130_fd_sc_hd__diode_2
X_5085_ _5085_/A _5085_/B vssd1 vssd1 vccd1 vccd1 _5088_/A sky130_fd_sc_hd__xor2_2
XPHY_EDGE_ROW_81_Right_81 vssd1 vssd1 vccd1 vccd1 sky130_fd_sc_hd__decap_3
XFILLER_71_207 vssd1 vssd1 vccd1 vccd1 sky130_fd_sc_hd__fill_4
XANTENNA__5786__B _6738_/B vssd1 vssd1 vccd1 vccd1 sky130_fd_sc_hd__diode_2
XANTENNA_fanout355_A _6198_/A vssd1 vssd1 vccd1 vccd1 sky130_fd_sc_hd__diode_2
XFILLER_37_495 vssd1 vssd1 vccd1 vccd1 sky130_fd_sc_hd__fill_2
X_5987_ _5988_/B _5988_/A vssd1 vssd1 vccd1 vccd1 _5987_/X sky130_fd_sc_hd__and2b_2
XANTENNA_fanout143_X _8430_/D vssd1 vssd1 vccd1 vccd1 sky130_fd_sc_hd__diode_2
X_7726_ _7726_/A _7726_/B vssd1 vssd1 vccd1 vccd1 _7728_/B sky130_fd_sc_hd__xnor2_2
X_4938_ _4939_/A _4939_/B vssd1 vssd1 vccd1 vccd1 _4938_/X sky130_fd_sc_hd__and2b_2
X_7657_ _7657_/A _7657_/B vssd1 vssd1 vccd1 vccd1 _7657_/Y sky130_fd_sc_hd__xnor2_2
X_4869_ _4797_/A _4797_/B _4796_/A vssd1 vssd1 vccd1 vccd1 _4871_/B sky130_fd_sc_hd__o21ba_4
X_6608_ _6609_/A _6609_/B _6609_/C vssd1 vssd1 vccd1 vccd1 _7299_/B sky130_fd_sc_hd__a21o_2
XTAP_TAPCELL_ROW_50_699 vssd1 vccd1 sky130_fd_sc_hd__tapvpwrvgnd_1
XPHY_EDGE_ROW_90_Right_90 vssd1 vssd1 vccd1 vccd1 sky130_fd_sc_hd__decap_3
X_7588_ _7589_/A _7589_/B _7587_/Y vssd1 vssd1 vccd1 vccd1 _7590_/A sky130_fd_sc_hd__o21ba_2
X_6539_ _6539_/A _6539_/B vssd1 vssd1 vccd1 vccd1 _6541_/B sky130_fd_sc_hd__and2_2
X_8209_ _8207_/Y _8209_/B vssd1 vssd1 vccd1 vccd1 _8211_/A sky130_fd_sc_hd__and2b_2
XFILLER_47_215 vssd1 vssd1 vccd1 vccd1 sky130_fd_sc_hd__fill_1
XFILLER_46_64 vssd1 vssd1 vccd1 vccd1 sky130_fd_sc_hd__fill_1
XFILLER_62_218 vssd1 vssd1 vccd1 vccd1 sky130_fd_sc_hd__fill_2
XTAP_TAPCELL_ROW_58_777 vssd1 vccd1 sky130_fd_sc_hd__tapvpwrvgnd_1
XFILLER_55_281 vssd1 vssd1 vccd1 vccd1 sky130_fd_sc_hd__fill_1
XTAP_TAPCELL_ROW_83_1035 vssd1 vccd1 sky130_fd_sc_hd__tapvpwrvgnd_1
XFILLER_30_137 vssd1 vssd1 vccd1 vccd1 sky130_fd_sc_hd__fill_2
XTAP_TAPCELL_ROW_41_611 vssd1 vccd1 sky130_fd_sc_hd__tapvpwrvgnd_1
XTAP_TAPCELL_ROW_13_335 vssd1 vccd1 sky130_fd_sc_hd__tapvpwrvgnd_1
XANTENNA__4149__A1 input6/X vssd1 vssd1 vccd1 vccd1 sky130_fd_sc_hd__diode_2
XFILLER_11_373 vssd1 vssd1 vccd1 vccd1 sky130_fd_sc_hd__fill_1
XFILLER_3_561 vssd1 vssd1 vccd1 vccd1 sky130_fd_sc_hd__fill_8
XFILLER_78_351 vssd1 vssd1 vccd1 vccd1 sky130_fd_sc_hd__fill_1
XFILLER_66_568 vssd1 vssd1 vccd1 vccd1 sky130_fd_sc_hd__fill_2
X_5910_ _5910_/A _5910_/B vssd1 vssd1 vccd1 vccd1 _6164_/A sky130_fd_sc_hd__or2_2
XANTENNA__8263__A _8263_/A vssd1 vssd1 vccd1 vccd1 sky130_fd_sc_hd__diode_2
XFILLER_46_292 vssd1 vssd1 vccd1 vccd1 sky130_fd_sc_hd__fill_1
X_6890_ _6890_/A _6890_/B vssd1 vssd1 vccd1 vccd1 _6897_/A sky130_fd_sc_hd__xnor2_2
XTAP_TAPCELL_ROW_29_490 vssd1 vccd1 sky130_fd_sc_hd__tapvpwrvgnd_1
X_5841_ _5841_/A _5841_/B vssd1 vssd1 vccd1 vccd1 _5851_/A sky130_fd_sc_hd__xnor2_2
XFILLER_34_487 vssd1 vssd1 vccd1 vccd1 sky130_fd_sc_hd__fill_2
XFILLER_61_295 vssd1 vssd1 vccd1 vccd1 sky130_fd_sc_hd__fill_2
X_5772_ _5772_/A _5772_/B vssd1 vssd1 vccd1 vccd1 _5805_/A sky130_fd_sc_hd__xor2_2
X_7511_ _7359_/A _7359_/B _7510_/X vssd1 vssd1 vccd1 vccd1 _7511_/Y sky130_fd_sc_hd__a21oi_2
X_4723_ _4663_/X _4664_/X _4665_/X _4681_/X vssd1 vssd1 vccd1 vccd1 _4723_/X sky130_fd_sc_hd__a22o_2
X_7442_ _7443_/A _7443_/B _7443_/C vssd1 vssd1 vccd1 vccd1 _7547_/A sky130_fd_sc_hd__a21o_2
X_4654_ _4709_/A _4709_/B _4654_/C _4692_/B vssd1 vssd1 vccd1 vccd1 _4654_/X sky130_fd_sc_hd__and4_2
XANTENNA__7326__B _7326_/B vssd1 vssd1 vccd1 vccd1 sky130_fd_sc_hd__diode_2
X_7373_ _8419_/D wire64/X _7685_/B _8418_/D vssd1 vssd1 vccd1 vccd1 _7373_/X sky130_fd_sc_hd__a22o_2
X_4585_ _4585_/A _4585_/B vssd1 vssd1 vccd1 vccd1 _4589_/B sky130_fd_sc_hd__xor2_2
XANTENNA__5127__A _6970_/A vssd1 vssd1 vccd1 vccd1 sky130_fd_sc_hd__diode_2
X_6324_ _6324_/A _6324_/B vssd1 vssd1 vccd1 vccd1 _6327_/A sky130_fd_sc_hd__xor2_2
X_6255_ _6029_/A _6053_/A _6453_/B _6254_/X vssd1 vssd1 vccd1 vccd1 _6264_/A sky130_fd_sc_hd__a211oi_2
X_5206_ _5806_/B _5205_/B _5205_/A vssd1 vssd1 vccd1 vccd1 _5207_/C sky130_fd_sc_hd__o21ai_2
XANTENNA__8157__B _8157_/B vssd1 vssd1 vccd1 vccd1 sky130_fd_sc_hd__diode_2
X_6186_ _5917_/A _5917_/B _5908_/A vssd1 vssd1 vccd1 vccd1 _6188_/B sky130_fd_sc_hd__o21ba_2
X_5137_ _5137_/A _5137_/B vssd1 vssd1 vccd1 vccd1 _5140_/A sky130_fd_sc_hd__xor2_2
XFILLER_57_568 vssd1 vssd1 vccd1 vccd1 sky130_fd_sc_hd__fill_2
X_5068_ _7603_/A _5267_/B vssd1 vssd1 vccd1 vccd1 _5073_/B sky130_fd_sc_hd__nor2_2
XFILLER_44_218 vssd1 vssd1 vccd1 vccd1 sky130_fd_sc_hd__fill_1
XFILLER_83_29 vssd1 vssd1 vccd1 vccd1 sky130_fd_sc_hd__fill_1
XANTENNA_fanout260_X _7889_/A vssd1 vssd1 vccd1 vccd1 sky130_fd_sc_hd__diode_2
XTAP_TAPCELL_ROW_55_747 vssd1 vccd1 sky130_fd_sc_hd__tapvpwrvgnd_1
XFILLER_52_251 vssd1 vssd1 vccd1 vccd1 sky130_fd_sc_hd__fill_1
XPHY_EDGE_ROW_0_Right_0 vssd1 vssd1 vccd1 vccd1 sky130_fd_sc_hd__decap_3
XFILLER_16_89 vssd1 vssd1 vccd1 vccd1 sky130_fd_sc_hd__fill_2
XFILLER_32_22 vssd1 vssd1 vccd1 vccd1 sky130_fd_sc_hd__fill_1
X_7709_ _7662_/A _7662_/B _7710_/B vssd1 vssd1 vccd1 vccd1 _7850_/A sky130_fd_sc_hd__a21o_2
XFILLER_8_119 vssd1 vssd1 vccd1 vccd1 sky130_fd_sc_hd__fill_2
XTAP_TAPCELL_ROW_10_305 vssd1 vccd1 sky130_fd_sc_hd__tapvpwrvgnd_1
XANTENNA__7252__A _8001_/A vssd1 vssd1 vccd1 vccd1 sky130_fd_sc_hd__diode_2
XFILLER_63_527 vssd1 vssd1 vccd1 vccd1 sky130_fd_sc_hd__fill_4
XFILLER_43_251 vssd1 vssd1 vccd1 vccd1 sky130_fd_sc_hd__fill_4
XFILLER_73_51 vssd1 vssd1 vccd1 vccd1 sky130_fd_sc_hd__fill_4
XFILLER_16_487 vssd1 vccd1 vssd1 vccd1 sky130_ef_sc_hd__decap_40_12
XTAP_TAPCELL_ROW_26_460 vssd1 vccd1 sky130_fd_sc_hd__tapvpwrvgnd_1
XFILLER_7_196 vssd1 vssd1 vccd1 vccd1 sky130_fd_sc_hd__fill_4
X_4370_ _4372_/B _4372_/A vssd1 vssd1 vccd1 vccd1 _4375_/B sky130_fd_sc_hd__or2_2
XANTENNA__7162__A _8001_/A vssd1 vssd1 vccd1 vccd1 sky130_fd_sc_hd__diode_2
XFILLER_3_391 vssd1 vssd1 vccd1 vccd1 sky130_fd_sc_hd__fill_1
X_6040_ _5844_/B _5846_/B _5844_/A vssd1 vssd1 vccd1 vccd1 _6042_/B sky130_fd_sc_hd__o21ba_2
XANTENNA__7244__B1 _8126_/B vssd1 vssd1 vccd1 vccd1 sky130_fd_sc_hd__diode_2
X_7991_ _7991_/A _7991_/B vssd1 vssd1 vccd1 vccd1 _8051_/A sky130_fd_sc_hd__xnor2_2
X_6942_ _6942_/A _6942_/B _6942_/C vssd1 vssd1 vccd1 vccd1 _6950_/A sky130_fd_sc_hd__or3_2
X_6873_ _6873_/A _6873_/B vssd1 vssd1 vccd1 vccd1 _6875_/B sky130_fd_sc_hd__nor2_2
XTAP_TAPCELL_ROW_52_717 vssd1 vccd1 sky130_fd_sc_hd__tapvpwrvgnd_1
X_5824_ _6016_/A _6485_/B _6016_/B _6798_/B vssd1 vssd1 vccd1 vccd1 _5825_/B sky130_fd_sc_hd__a22oi_2
XFILLER_22_479 vssd1 vssd1 vccd1 vccd1 sky130_fd_sc_hd__fill_1
X_5755_ _5971_/B _5755_/B vssd1 vssd1 vccd1 vccd1 _5758_/A sky130_fd_sc_hd__nor2_2
XANTENNA__6241__A _6438_/A vssd1 vssd1 vccd1 vccd1 sky130_fd_sc_hd__diode_2
XANTENNA_fanout220_A _7862_/B vssd1 vssd1 vccd1 vccd1 sky130_fd_sc_hd__diode_2
XANTENNA_fanout318_A _6035_/D vssd1 vssd1 vccd1 vccd1 sky130_fd_sc_hd__diode_2
X_5686_ _5604_/Y _5630_/Y _5684_/Y _5685_/Y _5677_/X vssd1 vssd1 vccd1 vccd1 _5686_/X
+ sky130_fd_sc_hd__a221o_2
X_4706_ _4704_/X _4706_/B vssd1 vssd1 vccd1 vccd1 _4708_/A sky130_fd_sc_hd__and2b_2
X_7425_ _7425_/A _7425_/B vssd1 vssd1 vccd1 vccd1 _7509_/A sky130_fd_sc_hd__xnor2_2
X_4637_ _4633_/A _4633_/B _4630_/X vssd1 vssd1 vccd1 vccd1 _4664_/A sky130_fd_sc_hd__o21ai_2
XANTENNA__6522__A2 _7140_/C vssd1 vssd1 vccd1 vccd1 sky130_fd_sc_hd__diode_2
XFILLER_78_29 vssd1 vssd1 vccd1 vccd1 sky130_fd_sc_hd__fill_4
X_7356_ _7356_/A _7356_/B _7356_/C vssd1 vssd1 vccd1 vccd1 _7358_/A sky130_fd_sc_hd__and3_2
X_4568_ _4568_/A _4568_/B _4593_/A vssd1 vssd1 vccd1 vccd1 _4569_/B sky130_fd_sc_hd__and3_2
XANTENNA__4696__A _8425_/D vssd1 vssd1 vccd1 vccd1 sky130_fd_sc_hd__diode_2
XFILLER_89_446 vssd1 vssd1 vccd1 vccd1 sky130_fd_sc_hd__fill_2
X_7287_ _7287_/A _7287_/B _7287_/C vssd1 vssd1 vccd1 vccd1 _7288_/B sky130_fd_sc_hd__nor3_2
X_6307_ _8436_/D wire99/X vssd1 vssd1 vccd1 vccd1 _6308_/B sky130_fd_sc_hd__nand2_2
X_4499_ _4499_/A _4499_/B vssd1 vssd1 vccd1 vccd1 _4500_/B sky130_fd_sc_hd__xnor2_2
Xteam_03_403 vssd1 vssd1 vccd1 vccd1 team_03_403/HI gpio_out[0] sky130_fd_sc_hd__conb_1
Xteam_03_414 vssd1 vssd1 vccd1 vccd1 team_03_414/HI gpio_out[11] sky130_fd_sc_hd__conb_1
X_6238_ _6435_/A _6238_/B _7714_/A _6238_/D vssd1 vssd1 vccd1 vccd1 _6240_/A sky130_fd_sc_hd__and4_2
Xteam_03_425 vssd1 vssd1 vccd1 vccd1 gpio_oeb[4] team_03_425/LO sky130_fd_sc_hd__conb_1
Xteam_03_436 vssd1 vssd1 vccd1 vccd1 gpio_oeb[15] team_03_436/LO sky130_fd_sc_hd__conb_1
X_6169_ _8413_/D wire59/A _6170_/A vssd1 vssd1 vccd1 vccd1 _6169_/X sky130_fd_sc_hd__and3_2
XFILLER_17_207 vssd1 vssd1 vccd1 vccd1 sky130_fd_sc_hd__fill_1
XFILLER_45_516 vssd1 vssd1 vccd1 vccd1 sky130_fd_sc_hd__fill_4
XFILLER_84_162 vssd1 vssd1 vccd1 vccd1 sky130_fd_sc_hd__fill_1
XTAP_TAPCELL_ROW_68_883 vssd1 vccd1 sky130_fd_sc_hd__tapvpwrvgnd_1
XANTENNA__5320__A _8215_/A vssd1 vssd1 vccd1 vccd1 sky130_fd_sc_hd__diode_2
XFILLER_27_55 vssd1 vssd1 vccd1 vccd1 sky130_fd_sc_hd__fill_1
XFILLER_57_398 vssd1 vssd1 vccd1 vccd1 sky130_fd_sc_hd__fill_1
XTAP_TAPCELL_ROW_80_1005 vssd1 vccd1 sky130_fd_sc_hd__tapvpwrvgnd_1
XTAP_TAPCELL_ROW_23_430 vssd1 vccd1 sky130_fd_sc_hd__tapvpwrvgnd_1
XANTENNA__4223__X _8506_/A vssd1 vssd1 vccd1 vccd1 sky130_fd_sc_hd__diode_2
XANTENNA__7247__A _8110_/B vssd1 vssd1 vccd1 vccd1 sky130_fd_sc_hd__diode_2
XFILLER_4_133 vssd1 vssd1 vccd1 vccd1 sky130_fd_sc_hd__fill_4
XANTENNA_clkbuf_4_12_0_clk_A clkbuf_0_clk/X vssd1 vssd1 vccd1 vccd1 sky130_fd_sc_hd__diode_2
XTAP_TAPCELL_ROW_91_1112 vssd1 vccd1 sky130_fd_sc_hd__tapvpwrvgnd_1
XFILLER_48_387 vssd1 vssd1 vccd1 vccd1 sky130_fd_sc_hd__fill_1
XANTENNA__7157__A _8110_/B vssd1 vssd1 vccd1 vccd1 sky130_fd_sc_hd__diode_2
XFILLER_76_3 vssd1 vssd1 vccd1 vccd1 sky130_fd_sc_hd__fill_4
X_5540_ _5540_/A _5540_/B _5540_/C vssd1 vssd1 vccd1 vccd1 _5548_/A sky130_fd_sc_hd__and3_2
X_5471_ _5468_/B _5466_/C _5466_/B vssd1 vssd1 vccd1 vccd1 _5506_/B sky130_fd_sc_hd__o21a_2
X_7210_ _7210_/A _7426_/A _7210_/C _7714_/D vssd1 vssd1 vccd1 vccd1 _7212_/A sky130_fd_sc_hd__and4_2
X_4422_ _4649_/A _6114_/B vssd1 vssd1 vccd1 vccd1 _4423_/B sky130_fd_sc_hd__nand2_2
XANTENNA__5712__B1 _6114_/B vssd1 vssd1 vccd1 vccd1 sky130_fd_sc_hd__diode_2
X_8190_ _8191_/A _8191_/B vssd1 vssd1 vccd1 vccd1 _8192_/A sky130_fd_sc_hd__nor2_2
X_7141_ _7875_/A _7140_/C _7140_/D _7140_/B vssd1 vssd1 vccd1 vccd1 _7142_/B sky130_fd_sc_hd__a22oi_2
X_4353_ _4353_/A _4353_/B vssd1 vssd1 vccd1 vccd1 _4396_/A sky130_fd_sc_hd__xnor2_2
X_7072_ _6997_/Y _7071_/C _7316_/A _7071_/X vssd1 vssd1 vccd1 vccd1 _7074_/B sky130_fd_sc_hd__a22oi_2
X_4284_ _4459_/B _4459_/C vssd1 vssd1 vccd1 vccd1 _4284_/Y sky130_fd_sc_hd__nor2_2
X_6023_ _6024_/A _6024_/B vssd1 vssd1 vccd1 vccd1 _6248_/B sky130_fd_sc_hd__nand2b_2
XFILLER_27_505 vssd1 vccd1 vssd1 vccd1 sky130_ef_sc_hd__decap_40_12
XANTENNA__6236__A _6433_/A vssd1 vssd1 vccd1 vccd1 sky130_fd_sc_hd__diode_2
X_7974_ _7974_/A _7974_/B vssd1 vssd1 vccd1 vccd1 _7975_/B sky130_fd_sc_hd__xnor2_2
XANTENNA_fanout268_A _6830_/B vssd1 vssd1 vccd1 vccd1 sky130_fd_sc_hd__diode_2
X_6925_ _8001_/A _7249_/C vssd1 vssd1 vccd1 vccd1 _6926_/B sky130_fd_sc_hd__nand2_2
XTAP_TAPCELL_ROW_65_853 vssd1 vccd1 sky130_fd_sc_hd__tapvpwrvgnd_1
XTAP_TAPCELL_ROW_37_566 vssd1 vccd1 sky130_fd_sc_hd__tapvpwrvgnd_1
XFILLER_50_541 vssd1 vssd1 vccd1 vccd1 sky130_fd_sc_hd__fill_2
Xfanout47 fanout48/X vssd1 vssd1 vccd1 vccd1 _6631_/B sky130_fd_sc_hd__buf_8
X_6856_ _6954_/A _6856_/B vssd1 vssd1 vccd1 vccd1 _6865_/A sky130_fd_sc_hd__nand2_2
Xfanout69 _7007_/B vssd1 vssd1 vccd1 vccd1 _5267_/B sky130_fd_sc_hd__buf_4
Xfanout58 _6360_/B vssd1 vssd1 vccd1 vccd1 wire59/A sky130_fd_sc_hd__clkdlybuf4s25_1
X_6787_ _6788_/B _6788_/A vssd1 vssd1 vccd1 vccd1 _7035_/A sky130_fd_sc_hd__or2_2
X_5807_ _5808_/B _5808_/A vssd1 vssd1 vccd1 vccd1 _5807_/X sky130_fd_sc_hd__and2b_2
XFILLER_13_57 vssd1 vssd1 vccd1 vccd1 sky130_fd_sc_hd__fill_2
X_5738_ _6294_/A _6701_/B vssd1 vssd1 vccd1 vccd1 _5943_/A sky130_fd_sc_hd__nand2_2
XTAP_TAPCELL_ROW_20_400 vssd1 vccd1 sky130_fd_sc_hd__tapvpwrvgnd_1
XFILLER_13_68 vssd1 vssd1 vccd1 vccd1 sky130_fd_sc_hd__fill_1
XFILLER_89_39 vssd1 vssd1 vccd1 vccd1 sky130_fd_sc_hd__fill_4
X_5669_ _8165_/A _5669_/B _5669_/C vssd1 vssd1 vccd1 vccd1 _5671_/B sky130_fd_sc_hd__and3_2
X_8388_ clkload1/A _8388_/D load_slew360/X vssd1 vssd1 vccd1 vccd1 _8388_/Q sky130_fd_sc_hd__dfrtp_2
X_7408_ _7408_/A _7408_/B vssd1 vssd1 vccd1 vccd1 _7410_/A sky130_fd_sc_hd__xnor2_2
XFILLER_89_210 vssd1 vssd1 vccd1 vccd1 sky130_fd_sc_hd__fill_2
X_7339_ _7379_/B _7337_/Y _7067_/X _7073_/X vssd1 vssd1 vccd1 vccd1 _7340_/C sky130_fd_sc_hd__a211oi_2
XFILLER_1_169 vssd1 vssd1 vccd1 vccd1 sky130_fd_sc_hd__fill_1
XFILLER_77_416 vssd1 vssd1 vccd1 vccd1 sky130_fd_sc_hd__fill_8
XFILLER_89_298 vssd1 vssd1 vccd1 vccd1 sky130_fd_sc_hd__fill_2
XFILLER_38_32 vssd1 vssd1 vccd1 vccd1 sky130_fd_sc_hd__fill_1
XFILLER_77_449 vssd1 vssd1 vccd1 vccd1 sky130_fd_sc_hd__fill_4
XFILLER_18_516 vssd1 vssd1 vccd1 vccd1 sky130_fd_sc_hd__fill_1
XFILLER_45_302 vssd1 vssd1 vccd1 vccd1 sky130_fd_sc_hd__fill_2
XFILLER_57_162 vssd1 vssd1 vccd1 vccd1 sky130_fd_sc_hd__fill_1
XFILLER_92_419 vssd1 vssd1 vccd1 vccd1 sky130_fd_sc_hd__fill_1
XANTENNA__4145__A_N input19/X vssd1 vssd1 vccd1 vccd1 sky130_fd_sc_hd__diode_2
XFILLER_33_519 vssd1 vssd1 vccd1 vccd1 sky130_fd_sc_hd__fill_8
XFILLER_72_132 vssd1 vssd1 vccd1 vccd1 sky130_fd_sc_hd__fill_8
XFILLER_54_75 vssd1 vssd1 vccd1 vccd1 sky130_fd_sc_hd__fill_8
XFILLER_41_530 vssd1 vssd1 vccd1 vccd1 sky130_fd_sc_hd__fill_2
XFILLER_41_552 vssd1 vssd1 vccd1 vccd1 sky130_fd_sc_hd__fill_2
XTAP_TAPCELL_ROW_0_191 vssd1 vccd1 sky130_fd_sc_hd__tapvpwrvgnd_1
XANTENNA__6031__D _8233_/A vssd1 vssd1 vccd1 vccd1 sky130_fd_sc_hd__diode_2
XTAP_TAPCELL_ROW_8_280 vssd1 vccd1 sky130_fd_sc_hd__tapvpwrvgnd_1
XANTENNA__6608__X _7299_/B vssd1 vssd1 vccd1 vccd1 sky130_fd_sc_hd__diode_2
XFILLER_76_471 vssd1 vssd1 vccd1 vccd1 sky130_fd_sc_hd__fill_4
XTAP_TAPCELL_ROW_79_989 vssd1 vccd1 sky130_fd_sc_hd__tapvpwrvgnd_1
XANTENNA__8361__RESET_B load_slew384/X vssd1 vssd1 vccd1 vccd1 sky130_fd_sc_hd__diode_2
X_4971_ _5163_/A _4972_/B vssd1 vssd1 vccd1 vccd1 _4973_/B sky130_fd_sc_hd__nand2_2
XTAP_TAPCELL_ROW_62_823 vssd1 vccd1 sky130_fd_sc_hd__tapvpwrvgnd_1
X_7690_ _4215_/Y _7685_/B _7627_/X _7626_/Y vssd1 vssd1 vccd1 vccd1 _7692_/B sky130_fd_sc_hd__a31o_2
X_6710_ _6710_/A _6710_/B vssd1 vssd1 vccd1 vccd1 _6717_/A sky130_fd_sc_hd__xnor2_2
XTAP_TAPCELL_ROW_34_536 vssd1 vccd1 sky130_fd_sc_hd__tapvpwrvgnd_1
X_6641_ _8413_/D _6641_/B vssd1 vssd1 vccd1 vccd1 _6642_/B sky130_fd_sc_hd__nand2_2
X_8311_ _8445_/D _8202_/B _8313_/S vssd1 vssd1 vccd1 vccd1 _8386_/D sky130_fd_sc_hd__mux2_1
X_6572_ _6572_/A _6572_/B vssd1 vssd1 vccd1 vccd1 _6708_/A sky130_fd_sc_hd__nand2_2
X_5523_ _5530_/B _5522_/Y _5555_/A _5612_/B vssd1 vssd1 vccd1 vccd1 _5564_/A sky130_fd_sc_hd__and4bb_2
X_8242_ _8249_/A _8248_/B vssd1 vssd1 vccd1 vccd1 _8243_/B sky130_fd_sc_hd__nor2_2
X_5454_ _5454_/A _5454_/B _5454_/C vssd1 vssd1 vccd1 vccd1 _5456_/A sky130_fd_sc_hd__nor3_2
X_8173_ _8174_/A _8174_/B vssd1 vssd1 vccd1 vccd1 _8173_/X sky130_fd_sc_hd__and2_2
X_5385_ _8184_/A _5826_/A vssd1 vssd1 vccd1 vccd1 _5389_/A sky130_fd_sc_hd__nand2_2
X_4405_ _4405_/A _4405_/B vssd1 vssd1 vccd1 vccd1 _4408_/B sky130_fd_sc_hd__xor2_2
Xfanout204 _7427_/B1 vssd1 vssd1 vccd1 vccd1 _8136_/D sky130_fd_sc_hd__clkdlybuf4s25_1
X_7124_ _7124_/A _7124_/B vssd1 vssd1 vccd1 vccd1 _7127_/A sky130_fd_sc_hd__xnor2_2
X_4336_ _4336_/A _4336_/B vssd1 vssd1 vccd1 vccd1 _4337_/B sky130_fd_sc_hd__xnor2_2
Xfanout215 _7219_/A vssd1 vssd1 vccd1 vccd1 _7129_/A sky130_fd_sc_hd__clkdlybuf4s25_1
Xfanout226 _5386_/C vssd1 vssd1 vccd1 vccd1 _6016_/A sky130_fd_sc_hd__clkdlybuf4s25_1
Xfanout237 _8370_/Q vssd1 vssd1 vccd1 vccd1 _7233_/A sky130_fd_sc_hd__clkdlybuf4s25_1
XFILLER_59_449 vssd1 vssd1 vccd1 vccd1 sky130_fd_sc_hd__fill_2
XFILLER_86_257 vssd1 vssd1 vccd1 vccd1 sky130_fd_sc_hd__fill_2
Xfanout248 _7754_/B vssd1 vssd1 vccd1 vccd1 _7998_/B sky130_fd_sc_hd__clkdlybuf4s25_1
Xfanout259 _6830_/A vssd1 vssd1 vccd1 vccd1 _6517_/A sky130_fd_sc_hd__clkdlybuf4s25_1
X_7055_ _6739_/A _7051_/A _7012_/A _7011_/Y vssd1 vssd1 vccd1 vccd1 _7057_/B sky130_fd_sc_hd__a2bb2oi_2
X_4267_ _8389_/Q _8448_/Q vssd1 vssd1 vccd1 vccd1 _4267_/Y sky130_fd_sc_hd__nor2_2
XANTENNA__5789__B _7007_/B vssd1 vssd1 vccd1 vccd1 sky130_fd_sc_hd__diode_2
X_6006_ _6006_/A _6485_/B vssd1 vssd1 vccd1 vccd1 _6008_/C sky130_fd_sc_hd__nand2_2
X_4198_ _8164_/B _4198_/B vssd1 vssd1 vccd1 vccd1 _4198_/Y sky130_fd_sc_hd__nand2b_2
XFILLER_54_143 vssd1 vssd1 vccd1 vccd1 sky130_fd_sc_hd__fill_1
XFILLER_54_154 vssd1 vssd1 vccd1 vccd1 sky130_fd_sc_hd__fill_1
XFILLER_82_496 vssd1 vssd1 vccd1 vccd1 sky130_fd_sc_hd__fill_2
X_7957_ _7959_/A vssd1 vssd1 vccd1 vccd1 _7957_/Y sky130_fd_sc_hd__inv_2
X_7888_ _7889_/A _8103_/D _8277_/A _7889_/B vssd1 vssd1 vccd1 vccd1 _7890_/A sky130_fd_sc_hd__a22oi_2
X_6908_ _6909_/A _6909_/B vssd1 vssd1 vccd1 vccd1 _7171_/A sky130_fd_sc_hd__nand2b_2
XANTENNA__7509__B _7509_/B vssd1 vssd1 vccd1 vccd1 sky130_fd_sc_hd__diode_2
X_6839_ _6523_/B _6525_/B _6523_/A vssd1 vssd1 vccd1 vccd1 _6841_/B sky130_fd_sc_hd__o21ba_2
XFILLER_10_213 vssd1 vssd1 vccd1 vccd1 sky130_fd_sc_hd__fill_4
XFILLER_40_22 vssd1 vssd1 vccd1 vccd1 sky130_fd_sc_hd__fill_1
XANTENNA__7141__A2 _7140_/C vssd1 vssd1 vccd1 vccd1 sky130_fd_sc_hd__diode_2
XFILLER_2_456 vssd1 vssd1 vccd1 vccd1 sky130_fd_sc_hd__fill_4
XFILLER_6_3 vssd1 vssd1 vccd1 vccd1 sky130_fd_sc_hd__fill_2
XFILLER_2_467 vssd1 vssd1 vccd1 vccd1 sky130_fd_sc_hd__fill_2
XFILLER_49_42 vssd1 vssd1 vccd1 vccd1 sky130_fd_sc_hd__fill_1
XFILLER_1_16 vssd1 vssd1 vccd1 vccd1 sky130_fd_sc_hd__fill_1
XFILLER_77_279 vssd1 vssd1 vccd1 vccd1 sky130_fd_sc_hd__fill_1
XTAP_TAPCELL_ROW_5_250 vssd1 vccd1 sky130_fd_sc_hd__tapvpwrvgnd_1
XTAP_TAPCELL_ROW_76_959 vssd1 vccd1 sky130_fd_sc_hd__tapvpwrvgnd_1
XFILLER_60_146 vssd1 vssd1 vccd1 vccd1 sky130_fd_sc_hd__fill_2
XFILLER_81_51 vssd1 vssd1 vccd1 vccd1 sky130_fd_sc_hd__fill_1
XTAP_TAPCELL_ROW_31_506 vssd1 vccd1 sky130_fd_sc_hd__tapvpwrvgnd_1
XFILLER_81_95 vssd1 vssd1 vccd1 vccd1 sky130_fd_sc_hd__fill_1
XANTENNA__6610__Y _7966_/B vssd1 vssd1 vccd1 vccd1 sky130_fd_sc_hd__diode_2
XFILLER_53_5 vssd1 vssd1 vccd1 vccd1 sky130_fd_sc_hd__fill_2
X_5170_ _4985_/A _4985_/B _4977_/Y vssd1 vssd1 vccd1 vccd1 _5172_/B sky130_fd_sc_hd__o21a_2
XANTENNA__8266__A _8266_/A vssd1 vssd1 vccd1 vccd1 sky130_fd_sc_hd__diode_2
XFILLER_68_257 vssd1 vssd1 vccd1 vccd1 sky130_fd_sc_hd__fill_2
XFILLER_68_279 vssd1 vccd1 vssd1 vccd1 sky130_ef_sc_hd__decap_40_12
Xinput4 gpio_in[11] vssd1 vssd1 vccd1 vccd1 input4/X sky130_fd_sc_hd__buf_4
XANTENNA__6217__C _6217_/C vssd1 vssd1 vccd1 vccd1 sky130_fd_sc_hd__diode_2
XFILLER_64_496 vssd1 vssd1 vccd1 vccd1 sky130_fd_sc_hd__fill_4
X_7811_ _7812_/B _7812_/A vssd1 vssd1 vccd1 vccd1 _7811_/Y sky130_fd_sc_hd__nand2b_2
XTAP_TAPCELL_ROW_47_672 vssd1 vccd1 sky130_fd_sc_hd__tapvpwrvgnd_1
X_7742_ _7742_/A _7742_/B vssd1 vssd1 vccd1 vccd1 _7743_/C sky130_fd_sc_hd__xnor2_2
X_4954_ _4970_/B _4953_/B _4953_/C vssd1 vssd1 vccd1 vccd1 _4954_/Y sky130_fd_sc_hd__a21oi_2
XFILLER_20_511 vssd1 vssd1 vccd1 vccd1 sky130_fd_sc_hd__fill_2
XFILLER_20_533 vssd1 vssd1 vccd1 vccd1 sky130_fd_sc_hd__fill_1
X_7673_ _7673_/A _7673_/B _7673_/C vssd1 vssd1 vccd1 vccd1 _7674_/B sky130_fd_sc_hd__nand3_2
X_4885_ _4514_/A _4514_/B _4884_/A _4884_/B vssd1 vssd1 vccd1 vccd1 _4885_/X sky130_fd_sc_hd__a22o_2
XANTENNA_clkbuf_4_0_0_clk_A clkbuf_0_clk/X vssd1 vssd1 vccd1 vccd1 sky130_fd_sc_hd__diode_2
XFILLER_20_566 vssd1 vssd1 vccd1 vccd1 sky130_fd_sc_hd__fill_4
X_6624_ _6625_/B _6625_/A vssd1 vssd1 vccd1 vccd1 _6693_/B sky130_fd_sc_hd__nand2b_2
XANTENNA__5382__A1 _8233_/A vssd1 vssd1 vccd1 vccd1 sky130_fd_sc_hd__diode_2
X_6555_ _6459_/B _6461_/B _6459_/A vssd1 vssd1 vccd1 vccd1 _6557_/B sky130_fd_sc_hd__o21ba_2
XANTENNA__5921__A3 _6631_/B vssd1 vssd1 vccd1 vccd1 sky130_fd_sc_hd__diode_2
XANTENNA__7659__B1 _7509_/B vssd1 vssd1 vccd1 vccd1 sky130_fd_sc_hd__diode_2
XANTENNA_fanout300_A _8246_/A vssd1 vssd1 vccd1 vccd1 sky130_fd_sc_hd__diode_2
X_5506_ _5506_/A _5506_/B _5507_/B vssd1 vssd1 vccd1 vccd1 _5509_/A sky130_fd_sc_hd__or3b_2
X_8225_ _8220_/A _8224_/Y _8397_/D vssd1 vssd1 vccd1 vccd1 _8345_/D sky130_fd_sc_hd__mux2_1
X_6486_ _6486_/A _6486_/B vssd1 vssd1 vccd1 vccd1 _6488_/C sky130_fd_sc_hd__xnor2_2
X_5437_ _5446_/A _6005_/B _6006_/A _5415_/B vssd1 vssd1 vccd1 vccd1 _5438_/C sky130_fd_sc_hd__a22o_2
XANTENNA__6882__A1 _6689_/A vssd1 vssd1 vccd1 vccd1 sky130_fd_sc_hd__diode_2
XFILLER_87_500 vssd1 vssd1 vccd1 vccd1 sky130_fd_sc_hd__fill_4
X_8156_ _8156_/A _8156_/B vssd1 vssd1 vccd1 vccd1 _8157_/B sky130_fd_sc_hd__nor2_2
X_5368_ _6035_/C _5367_/C _5838_/C _8215_/A vssd1 vssd1 vccd1 vccd1 _5369_/B sky130_fd_sc_hd__a22oi_2
XANTENNA_fanout290_X _8266_/A vssd1 vssd1 vccd1 vccd1 sky130_fd_sc_hd__diode_2
X_8087_ _7948_/B _7950_/B _7946_/Y vssd1 vssd1 vccd1 vccd1 _8087_/X sky130_fd_sc_hd__a21o_2
X_7107_ _7107_/A _7107_/B vssd1 vssd1 vccd1 vccd1 _7108_/B sky130_fd_sc_hd__xnor2_2
X_5299_ _5295_/X _5296_/Y _5298_/Y _5297_/Y vssd1 vssd1 vccd1 vccd1 _5299_/X sky130_fd_sc_hd__a31o_2
X_4319_ _8391_/Q _8450_/Q vssd1 vssd1 vccd1 vccd1 _4321_/A sky130_fd_sc_hd__nand2_2
XANTENNA__5437__A2 _6005_/B vssd1 vssd1 vccd1 vccd1 sky130_fd_sc_hd__diode_2
XANTENNA__7080__A _7969_/A vssd1 vssd1 vccd1 vccd1 sky130_fd_sc_hd__diode_2
XFILLER_19_23 vssd1 vssd1 vccd1 vccd1 sky130_fd_sc_hd__fill_1
X_7038_ _7038_/A _7117_/B vssd1 vssd1 vccd1 vccd1 _7040_/A sky130_fd_sc_hd__and2_2
XTAP_TAPCELL_ROW_2_220 vssd1 vccd1 sky130_fd_sc_hd__tapvpwrvgnd_1
XANTENNA__7230__D _8136_/B vssd1 vssd1 vccd1 vccd1 sky130_fd_sc_hd__diode_2
XANTENNA__8405__CLK _8405_/CLK vssd1 vssd1 vccd1 vccd1 sky130_fd_sc_hd__diode_2
XANTENNA_fanout46_A _5763_/Y vssd1 vssd1 vccd1 vccd1 sky130_fd_sc_hd__diode_2
XFILLER_15_327 vssd1 vssd1 vccd1 vccd1 sky130_fd_sc_hd__fill_1
XTAP_TAPCELL_ROW_73_929 vssd1 vccd1 sky130_fd_sc_hd__tapvpwrvgnd_1
XFILLER_42_113 vssd1 vssd1 vccd1 vccd1 sky130_fd_sc_hd__fill_2
XFILLER_35_99 vssd1 vssd1 vccd1 vccd1 sky130_fd_sc_hd__fill_1
XANTENNA__6143__B _8081_/B vssd1 vssd1 vccd1 vccd1 sky130_fd_sc_hd__diode_2
XFILLER_11_511 vssd1 vssd1 vccd1 vccd1 sky130_fd_sc_hd__fill_1
XFILLER_51_54 vssd1 vssd1 vccd1 vccd1 sky130_fd_sc_hd__fill_2
XANTENNA__8311__A1 _8202_/B vssd1 vssd1 vccd1 vccd1 sky130_fd_sc_hd__diode_2
XANTENNA__5062__X _7007_/B vssd1 vssd1 vccd1 vccd1 sky130_fd_sc_hd__diode_2
XANTENNA__7140__D _7140_/D vssd1 vssd1 vccd1 vccd1 sky130_fd_sc_hd__diode_2
XANTENNA__6334__A _6611_/A vssd1 vssd1 vccd1 vccd1 sky130_fd_sc_hd__diode_2
XTAP_TAPCELL_ROW_44_642 vssd1 vccd1 sky130_fd_sc_hd__tapvpwrvgnd_1
X_4670_ _4670_/A _4670_/B vssd1 vssd1 vccd1 vccd1 _4671_/A sky130_fd_sc_hd__xnor2_2
XANTENNA__5892__B _7007_/B vssd1 vssd1 vccd1 vccd1 sky130_fd_sc_hd__diode_2
X_6340_ _6341_/A _6341_/B vssd1 vssd1 vccd1 vccd1 _6340_/Y sky130_fd_sc_hd__nor2_2
XANTENNA__8302__A1 input9/X vssd1 vssd1 vccd1 vccd1 sky130_fd_sc_hd__diode_2
XANTENNA__4301__B _4979_/C vssd1 vssd1 vccd1 vccd1 sky130_fd_sc_hd__diode_2
X_6271_ _6272_/B _6272_/A vssd1 vssd1 vccd1 vccd1 _6471_/B sky130_fd_sc_hd__and2b_2
XFILLER_88_319 vssd1 vssd1 vccd1 vccd1 sky130_fd_sc_hd__fill_1
X_8010_ _7900_/X _7904_/A _8147_/A _8009_/Y vssd1 vssd1 vccd1 vccd1 _8147_/B sky130_fd_sc_hd__o211ai_2
X_5222_ _8407_/D _5289_/B _5221_/C vssd1 vssd1 vccd1 vccd1 _5224_/B sky130_fd_sc_hd__a21oi_2
XFILLER_69_544 vssd1 vccd1 vssd1 vccd1 sky130_ef_sc_hd__decap_40_12
X_5153_ _5153_/A _5153_/B vssd1 vssd1 vccd1 vccd1 _5154_/B sky130_fd_sc_hd__xor2_2
XANTENNA__8428__CLK clkload6/A vssd1 vssd1 vccd1 vccd1 sky130_fd_sc_hd__diode_2
XFILLER_84_503 vssd1 vssd1 vccd1 vccd1 sky130_fd_sc_hd__fill_2
X_5084_ _5084_/A _5084_/B vssd1 vssd1 vccd1 vccd1 _5096_/A sky130_fd_sc_hd__xnor2_2
XANTENNA__6092__A2 _6701_/B vssd1 vssd1 vccd1 vccd1 sky130_fd_sc_hd__diode_2
XFILLER_2_81 vssd1 vssd1 vccd1 vccd1 sky130_fd_sc_hd__fill_2
XANTENNA__4971__B _4972_/B vssd1 vssd1 vccd1 vccd1 sky130_fd_sc_hd__diode_2
XFILLER_37_485 vssd1 vssd1 vccd1 vccd1 sky130_fd_sc_hd__fill_2
XANTENNA_fanout250_A _8368_/Q vssd1 vssd1 vccd1 vccd1 sky130_fd_sc_hd__diode_2
XFILLER_24_135 vssd1 vssd1 vccd1 vccd1 sky130_fd_sc_hd__fill_4
XFILLER_64_293 vssd1 vssd1 vccd1 vccd1 sky130_fd_sc_hd__fill_2
XANTENNA_fanout348_A _8337_/Q vssd1 vssd1 vccd1 vccd1 sky130_fd_sc_hd__diode_2
XFILLER_52_477 vssd1 vssd1 vccd1 vccd1 sky130_fd_sc_hd__fill_4
X_5986_ _5986_/A _5986_/B vssd1 vssd1 vccd1 vccd1 _5988_/B sky130_fd_sc_hd__xnor2_2
X_7725_ _8133_/B _7725_/B vssd1 vssd1 vccd1 vccd1 _7726_/B sky130_fd_sc_hd__nand2_2
X_4937_ _4842_/A _4842_/B _4840_/A vssd1 vssd1 vccd1 vccd1 _4939_/B sky130_fd_sc_hd__o21ai_2
X_7656_ _7513_/A _7512_/Y _7508_/Y vssd1 vssd1 vccd1 vccd1 _7657_/B sky130_fd_sc_hd__a21boi_2
X_4868_ _4868_/A _4868_/B vssd1 vssd1 vccd1 vccd1 _4871_/A sky130_fd_sc_hd__xor2_2
X_6607_ _6607_/A _6607_/B vssd1 vssd1 vccd1 vccd1 _6609_/C sky130_fd_sc_hd__xor2_2
X_7587_ _7587_/A _7587_/B vssd1 vssd1 vccd1 vccd1 _7587_/Y sky130_fd_sc_hd__xnor2_2
X_4799_ _4800_/B _4800_/A vssd1 vssd1 vccd1 vccd1 _4799_/X sky130_fd_sc_hd__and2b_2
XANTENNA_fanout303_X _7723_/D vssd1 vssd1 vccd1 vccd1 sky130_fd_sc_hd__diode_2
XFILLER_4_518 vssd1 vssd1 vccd1 vccd1 sky130_fd_sc_hd__fill_1
X_6538_ _6539_/A _6539_/B vssd1 vssd1 vccd1 vccd1 _6541_/A sky130_fd_sc_hd__nor2_2
X_6469_ _6559_/B _6469_/B vssd1 vssd1 vccd1 vccd1 _6471_/C sky130_fd_sc_hd__nor2_2
X_8208_ _8208_/A _8208_/B vssd1 vssd1 vccd1 vccd1 _8209_/B sky130_fd_sc_hd__nand2_2
XFILLER_87_330 vssd1 vssd1 vccd1 vccd1 sky130_fd_sc_hd__fill_1
X_8139_ _8137_/X _8139_/B vssd1 vssd1 vccd1 vccd1 _8140_/B sky130_fd_sc_hd__and2b_2
XFILLER_75_503 vssd1 vssd1 vccd1 vccd1 sky130_fd_sc_hd__fill_1
XFILLER_46_21 vssd1 vssd1 vccd1 vccd1 sky130_fd_sc_hd__fill_2
XFILLER_28_452 vssd1 vssd1 vccd1 vccd1 sky130_fd_sc_hd__fill_1
XFILLER_28_485 vssd1 vssd1 vccd1 vccd1 sky130_fd_sc_hd__fill_2
XTAP_TAPCELL_ROW_58_778 vssd1 vccd1 sky130_fd_sc_hd__tapvpwrvgnd_1
XPHY_EDGE_ROW_6_Left_99 vssd1 vssd1 vccd1 vccd1 sky130_fd_sc_hd__decap_3
XANTENNA__4226__X _4226_/X vssd1 vssd1 vccd1 vccd1 sky130_fd_sc_hd__diode_2
XANTENNA__7895__D _8125_/B vssd1 vssd1 vccd1 vccd1 sky130_fd_sc_hd__diode_2
XANTENNA_fanout49_X _6997_/B vssd1 vssd1 vccd1 vccd1 sky130_fd_sc_hd__diode_2
XFILLER_70_230 vssd1 vssd1 vccd1 vccd1 sky130_fd_sc_hd__fill_2
XFILLER_62_64 vssd1 vssd1 vccd1 vccd1 sky130_fd_sc_hd__fill_4
XTAP_TAPCELL_ROW_41_612 vssd1 vccd1 sky130_fd_sc_hd__tapvpwrvgnd_1
XFILLER_23_190 vssd1 vssd1 vccd1 vccd1 sky130_fd_sc_hd__fill_2
XFILLER_11_385 vssd1 vssd1 vccd1 vccd1 sky130_fd_sc_hd__fill_1
XANTENNA__5217__B _5267_/B vssd1 vssd1 vccd1 vccd1 sky130_fd_sc_hd__diode_2
XFILLER_78_363 vssd1 vssd1 vccd1 vccd1 sky130_fd_sc_hd__fill_1
XFILLER_87_72 vssd1 vssd1 vccd1 vccd1 sky130_fd_sc_hd__fill_4
XFILLER_46_260 vssd1 vssd1 vccd1 vccd1 sky130_fd_sc_hd__fill_4
XANTENNA__8263__B _8264_/A vssd1 vssd1 vccd1 vccd1 sky130_fd_sc_hd__diode_2
X_5840_ _6433_/A _8233_/A vssd1 vssd1 vccd1 vccd1 _5841_/B sky130_fd_sc_hd__nand2_2
XTAP_TAPCELL_ROW_29_491 vssd1 vccd1 sky130_fd_sc_hd__tapvpwrvgnd_1
X_5771_ _5771_/A _5771_/B vssd1 vssd1 vccd1 vccd1 _5772_/B sky130_fd_sc_hd__xnor2_2
X_7510_ _7359_/A _7358_/A _7358_/B _7205_/A vssd1 vssd1 vccd1 vccd1 _7510_/X sky130_fd_sc_hd__o31a_2
X_4722_ _4721_/X _4720_/X _4665_/X _4681_/X vssd1 vssd1 vccd1 vccd1 _4722_/X sky130_fd_sc_hd__o2bb2a_4
X_7441_ _7532_/B _7441_/B vssd1 vssd1 vccd1 vccd1 _7443_/C sky130_fd_sc_hd__nand2_2
XANTENNA__5337__B2 _8202_/A vssd1 vssd1 vccd1 vccd1 sky130_fd_sc_hd__diode_2
X_4653_ _4653_/A vssd1 vssd1 vccd1 vccd1 _4666_/A sky130_fd_sc_hd__inv_2
X_7372_ _8419_/D _7685_/B vssd1 vssd1 vccd1 vccd1 _7629_/A sky130_fd_sc_hd__nand2_2
X_4584_ _4581_/A _4581_/B _4577_/Y vssd1 vssd1 vccd1 vccd1 _4589_/A sky130_fd_sc_hd__o21ai_2
X_6323_ _6323_/A _6323_/B vssd1 vssd1 vccd1 vccd1 _6324_/B sky130_fd_sc_hd__xnor2_2
X_6254_ _6254_/A _6254_/B vssd1 vssd1 vccd1 vccd1 _6254_/X sky130_fd_sc_hd__and2_2
XFILLER_88_127 vssd1 vssd1 vccd1 vccd1 sky130_fd_sc_hd__fill_1
X_5205_ _5205_/A _5205_/B _5205_/C vssd1 vssd1 vccd1 vccd1 _5205_/X sky130_fd_sc_hd__or3_4
X_6185_ _6185_/A _6185_/B vssd1 vssd1 vccd1 vccd1 _6188_/A sky130_fd_sc_hd__xnor2_2
XFILLER_57_514 vssd1 vssd1 vccd1 vccd1 sky130_fd_sc_hd__fill_1
XFILLER_57_525 vssd1 vssd1 vccd1 vccd1 sky130_fd_sc_hd__fill_1
X_5136_ _5137_/A _5137_/B vssd1 vssd1 vccd1 vccd1 _5752_/A sky130_fd_sc_hd__and2b_2
XFILLER_57_547 vssd1 vssd1 vccd1 vccd1 sky130_fd_sc_hd__fill_4
X_5067_ _5067_/A _5067_/B vssd1 vssd1 vccd1 vccd1 _5073_/A sky130_fd_sc_hd__xor2_2
XANTENNA__8173__B _8174_/B vssd1 vssd1 vccd1 vccd1 sky130_fd_sc_hd__diode_2
XFILLER_84_399 vssd1 vssd1 vccd1 vccd1 sky130_fd_sc_hd__fill_4
XTAP_TAPCELL_ROW_55_748 vssd1 vccd1 sky130_fd_sc_hd__tapvpwrvgnd_1
XANTENNA_fanout253_X _6438_/A vssd1 vssd1 vccd1 vccd1 sky130_fd_sc_hd__diode_2
XFILLER_12_127 vssd1 vssd1 vccd1 vccd1 sky130_fd_sc_hd__fill_4
XFILLER_25_499 vssd1 vssd1 vccd1 vccd1 sky130_fd_sc_hd__fill_4
X_5969_ _5969_/A _5969_/B vssd1 vssd1 vccd1 vccd1 _5970_/B sky130_fd_sc_hd__xnor2_2
XFILLER_32_12 vssd1 vssd1 vccd1 vccd1 sky130_fd_sc_hd__fill_8
X_7708_ _7708_/A _7708_/B vssd1 vssd1 vccd1 vccd1 _7710_/B sky130_fd_sc_hd__nand2_2
XFILLER_20_182 vssd1 vssd1 vccd1 vccd1 sky130_fd_sc_hd__fill_1
X_7639_ _7382_/B _7394_/B _7382_/A vssd1 vssd1 vccd1 vccd1 _7641_/B sky130_fd_sc_hd__a21boi_2
XANTENNA__4839__B1 _4931_/C vssd1 vssd1 vccd1 vccd1 sky130_fd_sc_hd__diode_2
XANTENNA__7252__B _8352_/Q vssd1 vssd1 vccd1 vccd1 sky130_fd_sc_hd__diode_2
XANTENNA__6149__A _6978_/A vssd1 vssd1 vccd1 vccd1 sky130_fd_sc_hd__diode_2
XFILLER_48_503 vssd1 vccd1 vssd1 vccd1 sky130_ef_sc_hd__decap_40_12
XFILLER_48_547 vssd1 vssd1 vccd1 vccd1 sky130_fd_sc_hd__fill_2
XFILLER_57_64 vssd1 vssd1 vccd1 vccd1 sky130_fd_sc_hd__fill_1
XFILLER_35_208 vssd1 vssd1 vccd1 vccd1 sky130_fd_sc_hd__fill_1
XFILLER_73_63 vssd1 vssd1 vccd1 vccd1 sky130_fd_sc_hd__fill_4
XFILLER_16_499 vssd1 vssd1 vccd1 vccd1 sky130_fd_sc_hd__fill_2
XFILLER_43_274 vssd1 vssd1 vccd1 vccd1 sky130_fd_sc_hd__fill_4
XFILLER_73_96 vssd1 vssd1 vccd1 vccd1 sky130_fd_sc_hd__fill_2
XTAP_TAPCELL_ROW_26_461 vssd1 vccd1 sky130_fd_sc_hd__tapvpwrvgnd_1
XANTENNA__6612__A _6724_/A vssd1 vssd1 vccd1 vccd1 sky130_fd_sc_hd__diode_2
XANTENNA__6516__B1 _6517_/D vssd1 vssd1 vccd1 vccd1 sky130_fd_sc_hd__diode_2
XANTENNA__7162__B _8351_/Q vssd1 vssd1 vccd1 vccd1 sky130_fd_sc_hd__diode_2
XANTENNA__6059__A _6460_/A vssd1 vssd1 vccd1 vccd1 sky130_fd_sc_hd__diode_2
XFILLER_21_3 vssd1 vssd1 vccd1 vccd1 sky130_fd_sc_hd__fill_2
XFILLER_39_503 vssd1 vssd1 vccd1 vccd1 sky130_fd_sc_hd__fill_1
XFILLER_39_569 vssd1 vssd1 vccd1 vccd1 sky130_fd_sc_hd__fill_1
XFILLER_54_517 vssd1 vssd1 vccd1 vccd1 sky130_fd_sc_hd__fill_1
X_7990_ _7990_/A _8361_/Q vssd1 vssd1 vccd1 vccd1 _7991_/B sky130_fd_sc_hd__nand2_2
XFILLER_54_539 vssd1 vssd1 vccd1 vccd1 sky130_fd_sc_hd__fill_1
X_6941_ _6915_/B _6826_/B _6828_/B _6854_/A vssd1 vssd1 vccd1 vccd1 _6942_/C sky130_fd_sc_hd__a31oi_2
X_6872_ _6872_/A _6872_/B vssd1 vssd1 vccd1 vccd1 _6875_/A sky130_fd_sc_hd__xnor2_2
X_5823_ _6016_/A _6485_/B _6016_/B _6798_/B vssd1 vssd1 vccd1 vccd1 _5825_/A sky130_fd_sc_hd__and4_2
XTAP_TAPCELL_ROW_52_718 vssd1 vccd1 sky130_fd_sc_hd__tapvpwrvgnd_1
X_5754_ _5924_/B _5753_/B _5736_/Y vssd1 vssd1 vccd1 vccd1 _5755_/B sky130_fd_sc_hd__o21ba_2
XANTENNA__6241__B _8346_/Q vssd1 vssd1 vccd1 vccd1 sky130_fd_sc_hd__diode_2
X_5685_ _5626_/A _5602_/B _5603_/Y vssd1 vssd1 vccd1 vccd1 _5685_/Y sky130_fd_sc_hd__o21ai_2
X_4705_ _4709_/B _4366_/X _4704_/C _4704_/D vssd1 vssd1 vccd1 vccd1 _4706_/B sky130_fd_sc_hd__a22o_2
XANTENNA__5138__A _8425_/D vssd1 vssd1 vccd1 vccd1 sky130_fd_sc_hd__diode_2
XANTENNA_fanout213_A _6397_/C vssd1 vssd1 vccd1 vccd1 sky130_fd_sc_hd__diode_2
X_7424_ _7356_/B _7356_/A _7354_/Y _7422_/Y _7355_/A vssd1 vssd1 vccd1 vccd1 _7652_/B
+ sky130_fd_sc_hd__a311o_2
X_4636_ _4638_/B _4638_/A vssd1 vssd1 vccd1 vccd1 _4640_/B sky130_fd_sc_hd__and2b_2
X_7355_ _7355_/A _7355_/B vssd1 vssd1 vccd1 vccd1 _7356_/C sky130_fd_sc_hd__nor2_2
XFILLER_78_19 vssd1 vssd1 vccd1 vccd1 sky130_fd_sc_hd__fill_4
X_6306_ _8435_/D _6704_/B vssd1 vssd1 vccd1 vccd1 _6310_/A sky130_fd_sc_hd__nand2_2
X_4567_ _4567_/A _4567_/B vssd1 vssd1 vccd1 vccd1 _4591_/A sky130_fd_sc_hd__xor2_2
XANTENNA__4696__B _4709_/A vssd1 vssd1 vccd1 vccd1 sky130_fd_sc_hd__diode_2
XANTENNA__8168__B _8168_/B vssd1 vssd1 vccd1 vccd1 sky130_fd_sc_hd__diode_2
X_7286_ _7287_/A _7287_/B _7287_/C vssd1 vssd1 vccd1 vccd1 _7506_/A sky130_fd_sc_hd__o21a_2
X_4498_ _4498_/A _4498_/B vssd1 vssd1 vccd1 vccd1 _4499_/B sky130_fd_sc_hd__nor2_2
Xteam_03_404 vssd1 vssd1 vccd1 vccd1 team_03_404/HI gpio_out[1] sky130_fd_sc_hd__conb_1
Xteam_03_415 vssd1 vssd1 vccd1 vccd1 team_03_415/HI gpio_out[12] sky130_fd_sc_hd__conb_1
X_6237_ _6237_/A _6237_/B vssd1 vssd1 vccd1 vccd1 _6246_/A sky130_fd_sc_hd__xnor2_2
XANTENNA__5304__C _6016_/A vssd1 vssd1 vccd1 vccd1 sky130_fd_sc_hd__diode_2
Xteam_03_426 vssd1 vssd1 vccd1 vccd1 gpio_oeb[5] team_03_426/LO sky130_fd_sc_hd__conb_1
Xteam_03_437 vssd1 vssd1 vccd1 vccd1 gpio_oeb[16] team_03_437/LO sky130_fd_sc_hd__conb_1
X_6168_ _8413_/D wire59/A vssd1 vssd1 vccd1 vccd1 _6170_/B sky130_fd_sc_hd__nand2_2
X_5119_ _5119_/A _5775_/A vssd1 vssd1 vccd1 vccd1 _5121_/A sky130_fd_sc_hd__xnor2_2
XFILLER_45_528 vssd1 vssd1 vccd1 vccd1 sky130_fd_sc_hd__fill_8
XFILLER_84_141 vssd1 vccd1 vssd1 vccd1 sky130_ef_sc_hd__decap_40_12
X_6099_ _6099_/A _6099_/B vssd1 vssd1 vccd1 vccd1 _6132_/A sky130_fd_sc_hd__xnor2_2
XTAP_TAPCELL_ROW_68_884 vssd1 vccd1 sky130_fd_sc_hd__tapvpwrvgnd_1
XANTENNA__5320__B _5657_/B vssd1 vssd1 vccd1 vccd1 sky130_fd_sc_hd__diode_2
XFILLER_40_244 vssd1 vssd1 vccd1 vccd1 sky130_fd_sc_hd__fill_1
XFILLER_80_391 vssd1 vssd1 vccd1 vccd1 sky130_fd_sc_hd__fill_2
XTAP_TAPCELL_ROW_23_431 vssd1 vccd1 sky130_fd_sc_hd__tapvpwrvgnd_1
XFILLER_40_255 vssd1 vssd1 vccd1 vccd1 sky130_fd_sc_hd__fill_1
XANTENNA__5721__A1 _6091_/A vssd1 vssd1 vccd1 vccd1 sky130_fd_sc_hd__diode_2
XFILLER_4_145 vssd1 vssd1 vccd1 vccd1 sky130_fd_sc_hd__fill_1
XTAP_TAPCELL_ROW_91_1113 vssd1 vccd1 sky130_fd_sc_hd__tapvpwrvgnd_1
XFILLER_4_49 vssd1 vssd1 vccd1 vccd1 sky130_fd_sc_hd__fill_2
XFILLER_68_52 vssd1 vssd1 vccd1 vccd1 sky130_fd_sc_hd__fill_4
XFILLER_0_395 vssd1 vssd1 vccd1 vccd1 sky130_fd_sc_hd__fill_1
XFILLER_75_152 vssd1 vssd1 vccd1 vccd1 sky130_fd_sc_hd__fill_4
XFILLER_90_100 vssd1 vssd1 vccd1 vccd1 sky130_fd_sc_hd__fill_2
XTAP_TAPCELL_ROW_89_1086 vssd1 vccd1 sky130_fd_sc_hd__tapvpwrvgnd_1
XFILLER_90_177 vssd1 vssd1 vccd1 vccd1 sky130_fd_sc_hd__fill_2
XANTENNA__7157__B _8126_/B vssd1 vssd1 vccd1 vccd1 sky130_fd_sc_hd__diode_2
X_5470_ _5876_/A _5468_/Y _5349_/A _5464_/A vssd1 vssd1 vccd1 vccd1 _5510_/B sky130_fd_sc_hd__o211a_2
XFILLER_69_3 vssd1 vssd1 vccd1 vccd1 sky130_fd_sc_hd__fill_4
X_4421_ _4421_/A _4421_/B vssd1 vssd1 vccd1 vccd1 _4423_/A sky130_fd_sc_hd__xnor2_2
X_7140_ _7140_/A _7140_/B _7140_/C _7140_/D vssd1 vssd1 vccd1 vccd1 _7142_/A sky130_fd_sc_hd__and4_2
X_4352_ _4352_/A _4352_/B vssd1 vssd1 vccd1 vccd1 _4353_/B sky130_fd_sc_hd__xnor2_2
X_7071_ _7071_/A _7071_/B _7071_/C vssd1 vssd1 vccd1 vccd1 _7071_/X sky130_fd_sc_hd__or3_2
X_4283_ _4282_/A _4282_/B _4282_/C vssd1 vssd1 vccd1 vccd1 _4459_/C sky130_fd_sc_hd__a21oi_2
X_6022_ _6022_/A _6022_/B vssd1 vssd1 vccd1 vccd1 _6024_/B sky130_fd_sc_hd__xnor2_2
XANTENNA__7620__B _8082_/C vssd1 vssd1 vccd1 vccd1 sky130_fd_sc_hd__diode_2
XANTENNA__6076__X _6078_/B vssd1 vssd1 vccd1 vccd1 sky130_fd_sc_hd__diode_2
XANTENNA__6517__A _6517_/A vssd1 vssd1 vccd1 vccd1 sky130_fd_sc_hd__diode_2
XFILLER_27_517 vssd1 vssd1 vccd1 vccd1 sky130_fd_sc_hd__fill_2
XFILLER_66_141 vssd1 vssd1 vccd1 vccd1 sky130_fd_sc_hd__fill_2
XANTENNA__6236__B _8246_/A vssd1 vssd1 vccd1 vccd1 sky130_fd_sc_hd__diode_2
XFILLER_27_528 vssd1 vssd1 vccd1 vccd1 sky130_fd_sc_hd__fill_4
XFILLER_39_399 vssd1 vssd1 vccd1 vccd1 sky130_fd_sc_hd__fill_1
X_7973_ _7974_/B _7974_/A vssd1 vssd1 vccd1 vccd1 _7973_/X sky130_fd_sc_hd__and2b_2
X_6924_ _6924_/A _6924_/B vssd1 vssd1 vccd1 vccd1 _6926_/A sky130_fd_sc_hd__nor2_2
XTAP_TAPCELL_ROW_65_854 vssd1 vccd1 sky130_fd_sc_hd__tapvpwrvgnd_1
XTAP_TAPCELL_ROW_37_567 vssd1 vccd1 sky130_fd_sc_hd__tapvpwrvgnd_1
X_6855_ _6854_/A _6854_/B _6854_/C vssd1 vssd1 vccd1 vccd1 _6856_/B sky130_fd_sc_hd__o21ai_2
XANTENNA_fanout330_A _6217_/C vssd1 vssd1 vccd1 vccd1 sky130_fd_sc_hd__diode_2
Xfanout48 _5194_/X vssd1 vssd1 vccd1 vccd1 fanout48/X sky130_fd_sc_hd__buf_8
X_6786_ _6673_/A _6673_/B _6671_/X vssd1 vssd1 vccd1 vccd1 _6788_/A sky130_fd_sc_hd__a21oi_2
X_5806_ _5806_/A _5806_/B vssd1 vssd1 vccd1 vccd1 _5808_/B sky130_fd_sc_hd__nor2_2
X_5737_ _5154_/A _5154_/B _5152_/Y vssd1 vssd1 vccd1 vccd1 _5750_/A sky130_fd_sc_hd__a21boi_2
XTAP_TAPCELL_ROW_20_401 vssd1 vccd1 sky130_fd_sc_hd__tapvpwrvgnd_1
X_7407_ _7408_/A _7408_/B vssd1 vssd1 vccd1 vccd1 _7407_/Y sky130_fd_sc_hd__nand2b_2
X_5668_ _5662_/X _5668_/B _5668_/C vssd1 vssd1 vccd1 vccd1 _5668_/X sky130_fd_sc_hd__and3b_2
X_8387_ clkload0/A _8387_/D load_slew366/X vssd1 vssd1 vccd1 vccd1 _8387_/Q sky130_fd_sc_hd__dfrtp_2
X_5599_ _5600_/A _5600_/B vssd1 vssd1 vccd1 vccd1 _5601_/A sky130_fd_sc_hd__and2_2
X_4619_ _4619_/A _4619_/B _4619_/C vssd1 vssd1 vccd1 vccd1 _5054_/B sky130_fd_sc_hd__and3_2
X_7338_ _7067_/X _7073_/X _7379_/B _7337_/Y vssd1 vssd1 vccd1 vccd1 _7395_/A sky130_fd_sc_hd__o211a_2
X_7269_ _7269_/A _7269_/B _7269_/C vssd1 vssd1 vccd1 vccd1 _7277_/A sky130_fd_sc_hd__or3_2
XFILLER_49_108 vssd1 vssd1 vccd1 vccd1 sky130_fd_sc_hd__fill_4
XFILLER_18_506 vssd1 vssd1 vccd1 vccd1 sky130_fd_sc_hd__fill_2
XFILLER_72_122 vssd1 vssd1 vccd1 vccd1 sky130_fd_sc_hd__fill_2
XANTENNA__5050__B _5902_/B vssd1 vssd1 vccd1 vccd1 sky130_fd_sc_hd__diode_2
XFILLER_33_509 vssd1 vssd1 vccd1 vccd1 sky130_fd_sc_hd__fill_2
XFILLER_72_155 vssd1 vssd1 vccd1 vccd1 sky130_fd_sc_hd__fill_1
XFILLER_60_306 vssd1 vssd1 vccd1 vccd1 sky130_fd_sc_hd__fill_2
XFILLER_72_199 vssd1 vssd1 vccd1 vccd1 sky130_fd_sc_hd__fill_1
XTAP_TAPCELL_ROW_0_192 vssd1 vccd1 sky130_fd_sc_hd__tapvpwrvgnd_1
XFILLER_13_255 vssd1 vssd1 vccd1 vccd1 sky130_fd_sc_hd__fill_2
XANTENNA__5049__Y _6360_/B vssd1 vssd1 vccd1 vccd1 sky130_fd_sc_hd__diode_2
XFILLER_70_31 vssd1 vssd1 vccd1 vccd1 sky130_fd_sc_hd__fill_4
XANTENNA__7447__A1 _8016_/A vssd1 vssd1 vccd1 vccd1 sky130_fd_sc_hd__diode_2
XTAP_TAPCELL_ROW_8_281 vssd1 vccd1 sky130_fd_sc_hd__tapvpwrvgnd_1
XFILLER_68_439 vssd1 vssd1 vccd1 vccd1 sky130_fd_sc_hd__fill_1
XANTENNA__6337__A _6970_/A vssd1 vssd1 vccd1 vccd1 sky130_fd_sc_hd__diode_2
XFILLER_63_133 vssd1 vssd1 vccd1 vccd1 sky130_fd_sc_hd__fill_2
XFILLER_17_561 vssd1 vssd1 vccd1 vccd1 sky130_fd_sc_hd__fill_8
X_4970_ _4970_/A _4970_/B vssd1 vssd1 vccd1 vccd1 _5033_/A sky130_fd_sc_hd__nand2_2
XTAP_TAPCELL_ROW_62_824 vssd1 vccd1 sky130_fd_sc_hd__tapvpwrvgnd_1
XTAP_TAPCELL_ROW_34_537 vssd1 vccd1 sky130_fd_sc_hd__tapvpwrvgnd_1
X_6640_ _6638_/A _6759_/A _6639_/X vssd1 vssd1 vccd1 vccd1 _6642_/A sky130_fd_sc_hd__o21a_2
X_6571_ _6572_/A wire90/X _6304_/A _6302_/A vssd1 vssd1 vccd1 vccd1 _6578_/A sky130_fd_sc_hd__a31o_2
X_8310_ _8444_/D _8196_/B _8313_/S vssd1 vssd1 vccd1 vccd1 _8385_/D sky130_fd_sc_hd__mux2_1
X_5522_ _5583_/A _5393_/B _5559_/C _5559_/B vssd1 vssd1 vccd1 vccd1 _5522_/Y sky130_fd_sc_hd__a22oi_2
X_8241_ _8241_/A input8/X vssd1 vssd1 vccd1 vccd1 _8248_/B sky130_fd_sc_hd__nor2_2
X_5453_ _5453_/A _5453_/B _5462_/A vssd1 vssd1 vccd1 vccd1 _5454_/C sky130_fd_sc_hd__and3_2
XANTENNA__5416__A _7120_/A vssd1 vssd1 vccd1 vccd1 sky130_fd_sc_hd__diode_2
X_8172_ _8168_/A _4144_/Y _8171_/X vssd1 vssd1 vccd1 vccd1 _8336_/D sky130_fd_sc_hd__a21o_2
X_5384_ _5384_/A _5384_/B vssd1 vssd1 vccd1 vccd1 _5454_/A sky130_fd_sc_hd__or2_2
X_4404_ _4402_/A _4402_/B _4403_/X vssd1 vssd1 vccd1 vccd1 _4408_/A sky130_fd_sc_hd__a21oi_2
Xfanout205 _7427_/B1 vssd1 vssd1 vccd1 vccd1 _6795_/D sky130_fd_sc_hd__clkdlybuf4s25_1
X_7123_ _8133_/A _7426_/A vssd1 vssd1 vccd1 vccd1 _7124_/B sky130_fd_sc_hd__nand2_2
X_4335_ _4336_/A _4336_/B vssd1 vssd1 vccd1 vccd1 _4335_/Y sky130_fd_sc_hd__nand2b_2
Xfanout216 _7219_/A vssd1 vssd1 vccd1 vccd1 _8131_/A sky130_fd_sc_hd__clkdlybuf4s25_1
Xfanout227 _7875_/A vssd1 vssd1 vccd1 vccd1 _8016_/A sky130_fd_sc_hd__clkdlybuf4s25_1
Xfanout238 _8370_/Q vssd1 vssd1 vccd1 vccd1 _5826_/A sky130_fd_sc_hd__clkdlybuf4s25_1
XANTENNA__4974__B _5163_/B vssd1 vssd1 vccd1 vccd1 sky130_fd_sc_hd__diode_2
Xfanout249 _8103_/B vssd1 vssd1 vccd1 vccd1 _7754_/B sky130_fd_sc_hd__clkdlybuf4s25_1
X_7054_ _7054_/A _7054_/B vssd1 vssd1 vccd1 vccd1 _7057_/A sky130_fd_sc_hd__xnor2_2
X_4266_ _8389_/Q _8448_/Q vssd1 vssd1 vccd1 vccd1 _4282_/A sky130_fd_sc_hd__nand2_2
XANTENNA__4672__A1 _4709_/A vssd1 vssd1 vccd1 vccd1 sky130_fd_sc_hd__diode_2
X_6005_ _6207_/A _6005_/B _6482_/A _6482_/B vssd1 vssd1 vccd1 vccd1 _6223_/A sky130_fd_sc_hd__and4_2
X_4197_ _5267_/A vssd1 vssd1 vccd1 vccd1 _6724_/A sky130_fd_sc_hd__inv_2
XANTENNA__4672__B2 _4709_/B vssd1 vssd1 vccd1 vccd1 sky130_fd_sc_hd__diode_2
XANTENNA_fanout378_A fanout379/X vssd1 vssd1 vccd1 vccd1 sky130_fd_sc_hd__diode_2
XFILLER_54_122 vssd1 vssd1 vccd1 vccd1 sky130_fd_sc_hd__fill_2
XFILLER_82_475 vssd1 vssd1 vccd1 vccd1 sky130_fd_sc_hd__fill_1
X_7956_ _7680_/Y _8085_/A _7955_/X vssd1 vssd1 vccd1 vccd1 _7959_/A sky130_fd_sc_hd__a21o_2
X_7887_ _7887_/A _7887_/B _7887_/C vssd1 vssd1 vccd1 vccd1 _7910_/B sky130_fd_sc_hd__and3_2
X_6907_ _6907_/A _6907_/B vssd1 vssd1 vccd1 vccd1 _6909_/B sky130_fd_sc_hd__xnor2_2
XPHY_EDGE_ROW_59_Left_152 vssd1 vssd1 vccd1 vccd1 sky130_fd_sc_hd__decap_3
XANTENNA__8418__RESET_B wire364/X vssd1 vssd1 vccd1 vccd1 sky130_fd_sc_hd__diode_2
X_6838_ _6838_/A _6838_/B vssd1 vssd1 vccd1 vccd1 _6841_/A sky130_fd_sc_hd__xnor2_2
X_6769_ _4147_/Y _6757_/B _6639_/X _6638_/Y vssd1 vssd1 vccd1 vccd1 _6776_/A sky130_fd_sc_hd__a31o_2
XFILLER_40_56 vssd1 vssd1 vccd1 vccd1 sky130_fd_sc_hd__fill_2
X_8439_ clkload2/A _8439_/D fanout369/X vssd1 vssd1 vccd1 vccd1 _8439_/Q sky130_fd_sc_hd__dfrtp_2
XPHY_EDGE_ROW_68_Left_161 vssd1 vssd1 vccd1 vccd1 sky130_fd_sc_hd__decap_3
XFILLER_49_32 vssd1 vssd1 vccd1 vccd1 sky130_fd_sc_hd__fill_2
XFILLER_49_65 vssd1 vssd1 vccd1 vccd1 sky130_fd_sc_hd__fill_2
XFILLER_77_225 vssd1 vssd1 vccd1 vccd1 sky130_fd_sc_hd__fill_4
XTAP_TAPCELL_ROW_5_251 vssd1 vccd1 sky130_fd_sc_hd__tapvpwrvgnd_1
XFILLER_73_420 vssd1 vssd1 vccd1 vccd1 sky130_fd_sc_hd__fill_1
XFILLER_45_122 vssd1 vssd1 vccd1 vccd1 sky130_fd_sc_hd__fill_1
XFILLER_65_75 vssd1 vssd1 vccd1 vccd1 sky130_fd_sc_hd__fill_1
XFILLER_60_103 vssd1 vssd1 vccd1 vccd1 sky130_fd_sc_hd__fill_2
XTAP_TAPCELL_ROW_86_1056 vssd1 vccd1 sky130_fd_sc_hd__tapvpwrvgnd_1
XPHY_EDGE_ROW_77_Left_170 vssd1 vssd1 vccd1 vccd1 sky130_fd_sc_hd__decap_3
XFILLER_14_531 vssd1 vssd1 vccd1 vccd1 sky130_fd_sc_hd__fill_1
XFILLER_60_114 vssd1 vssd1 vccd1 vccd1 sky130_fd_sc_hd__fill_1
XFILLER_81_63 vssd1 vssd1 vccd1 vccd1 sky130_fd_sc_hd__fill_2
XTAP_TAPCELL_ROW_31_507 vssd1 vccd1 sky130_fd_sc_hd__tapvpwrvgnd_1
XANTENNA__8311__S _8313_/S vssd1 vssd1 vccd1 vccd1 sky130_fd_sc_hd__diode_2
XFILLER_5_251 vssd1 vssd1 vccd1 vccd1 sky130_fd_sc_hd__fill_1
XANTENNA__8266__B _8267_/C vssd1 vssd1 vccd1 vccd1 sky130_fd_sc_hd__diode_2
Xinput5 gpio_in[12] vssd1 vssd1 vccd1 vccd1 input5/X sky130_fd_sc_hd__clkbuf_4
XANTENNA__6217__D _7426_/A vssd1 vssd1 vccd1 vccd1 sky130_fd_sc_hd__diode_2
X_7810_ _7810_/A _7810_/B vssd1 vssd1 vccd1 vccd1 _7812_/B sky130_fd_sc_hd__xnor2_2
XFILLER_36_177 vssd1 vssd1 vccd1 vccd1 sky130_fd_sc_hd__fill_4
XTAP_TAPCELL_ROW_47_673 vssd1 vccd1 sky130_fd_sc_hd__tapvpwrvgnd_1
X_7741_ _7742_/A _7742_/B vssd1 vssd1 vccd1 vccd1 _7906_/B sky130_fd_sc_hd__nand2b_2
X_4953_ _4970_/B _4953_/B _4953_/C vssd1 vssd1 vccd1 vccd1 _5029_/B sky130_fd_sc_hd__and3_4
XTAP_TAPCELL_ROW_19_386 vssd1 vccd1 sky130_fd_sc_hd__tapvpwrvgnd_1
XFILLER_51_169 vssd1 vssd1 vccd1 vccd1 sky130_fd_sc_hd__fill_1
X_7672_ _7673_/A _7673_/B _7673_/C vssd1 vssd1 vccd1 vccd1 _7674_/A sky130_fd_sc_hd__a21o_2
XFILLER_20_501 vssd1 vssd1 vccd1 vccd1 sky130_fd_sc_hd__fill_1
X_6623_ _6623_/A _6623_/B vssd1 vssd1 vccd1 vccd1 _6625_/B sky130_fd_sc_hd__xor2_2
X_4884_ _4884_/A _4884_/B vssd1 vssd1 vccd1 vccd1 _5049_/A sky130_fd_sc_hd__xor2_2
XANTENNA__5382__A2 _6460_/A vssd1 vssd1 vccd1 vccd1 sky130_fd_sc_hd__diode_2
X_6554_ _6554_/A _6554_/B vssd1 vssd1 vccd1 vccd1 _6557_/A sky130_fd_sc_hd__xnor2_2
XANTENNA__7659__A1 _7655_/A vssd1 vssd1 vccd1 vccd1 sky130_fd_sc_hd__diode_2
X_6485_ _8032_/A _6485_/B vssd1 vssd1 vccd1 vccd1 _6486_/B sky130_fd_sc_hd__nand2_2
X_5505_ _5505_/A _5516_/A vssd1 vssd1 vccd1 vccd1 _5507_/B sky130_fd_sc_hd__nand2_2
X_8224_ _8224_/A _8224_/B vssd1 vssd1 vccd1 vccd1 _8224_/Y sky130_fd_sc_hd__xnor2_2
X_5436_ _5436_/A _5436_/B vssd1 vssd1 vccd1 vccd1 _5438_/B sky130_fd_sc_hd__xnor2_2
X_8155_ _7975_/A _7975_/B _7963_/A vssd1 vssd1 vccd1 vccd1 _8157_/A sky130_fd_sc_hd__a21o_2
X_5367_ _6035_/C _8215_/A _5367_/C _5838_/C vssd1 vssd1 vccd1 vccd1 _5369_/A sky130_fd_sc_hd__and4_2
XFILLER_59_225 vssd1 vccd1 vssd1 vccd1 sky130_ef_sc_hd__decap_40_12
X_8086_ _8086_/A _8086_/B vssd1 vssd1 vccd1 vccd1 _8091_/A sky130_fd_sc_hd__xnor2_2
X_7106_ _7107_/B _7107_/A vssd1 vssd1 vccd1 vccd1 _7106_/Y sky130_fd_sc_hd__nand2b_2
X_5298_ _5298_/A _5298_/B vssd1 vssd1 vccd1 vccd1 _5298_/Y sky130_fd_sc_hd__nand2_2
X_4318_ _4772_/A _4516_/B _5703_/B _4316_/B _4317_/X vssd1 vssd1 vccd1 vccd1 _4336_/A
+ sky130_fd_sc_hd__o41a_2
XANTENNA__7080__B _7080_/B vssd1 vssd1 vccd1 vccd1 sky130_fd_sc_hd__diode_2
XFILLER_87_556 vssd1 vssd1 vccd1 vccd1 sky130_fd_sc_hd__fill_1
X_7037_ _7117_/B vssd1 vssd1 vccd1 vccd1 _7037_/Y sky130_fd_sc_hd__inv_2
X_4249_ _4292_/A _4292_/B _4249_/C vssd1 vssd1 vccd1 vccd1 _4249_/Y sky130_fd_sc_hd__nand3_2
XTAP_TAPCELL_ROW_2_221 vssd1 vccd1 sky130_fd_sc_hd__tapvpwrvgnd_1
XFILLER_70_434 vssd1 vssd1 vccd1 vccd1 sky130_fd_sc_hd__fill_4
X_7939_ _7939_/A _7939_/B vssd1 vssd1 vccd1 vccd1 _7941_/A sky130_fd_sc_hd__nor2_2
XANTENNA_fanout39_A _7603_/B vssd1 vssd1 vccd1 vccd1 sky130_fd_sc_hd__diode_2
XFILLER_51_66 vssd1 vssd1 vccd1 vccd1 sky130_fd_sc_hd__fill_1
XANTENNA__4895__A _5747_/A vssd1 vssd1 vccd1 vccd1 sky130_fd_sc_hd__diode_2
XFILLER_76_85 vssd1 vccd1 vssd1 vccd1 sky130_ef_sc_hd__decap_40_12
XANTENNA__8306__S _8313_/S vssd1 vssd1 vccd1 vccd1 sky130_fd_sc_hd__diode_2
XFILLER_73_261 vssd1 vssd1 vccd1 vccd1 sky130_fd_sc_hd__fill_2
XFILLER_61_434 vssd1 vssd1 vccd1 vccd1 sky130_fd_sc_hd__fill_1
XANTENNA__6334__B _7806_/B vssd1 vssd1 vccd1 vccd1 sky130_fd_sc_hd__diode_2
XFILLER_33_147 vssd1 vssd1 vccd1 vccd1 sky130_fd_sc_hd__fill_1
XFILLER_33_169 vssd1 vssd1 vccd1 vccd1 sky130_fd_sc_hd__fill_1
XTAP_TAPCELL_ROW_44_643 vssd1 vccd1 sky130_fd_sc_hd__tapvpwrvgnd_1
XTAP_TAPCELL_ROW_16_356 vssd1 vccd1 sky130_fd_sc_hd__tapvpwrvgnd_1
XFILLER_92_95 vssd1 vssd1 vccd1 vccd1 sky130_fd_sc_hd__fill_2
XANTENNA__6350__A _7958_/A vssd1 vssd1 vccd1 vccd1 sky130_fd_sc_hd__diode_2
XANTENNA__7446__A _8016_/A vssd1 vssd1 vccd1 vccd1 sky130_fd_sc_hd__diode_2
X_6270_ _6058_/B _6060_/B _6058_/A vssd1 vssd1 vccd1 vccd1 _6272_/B sky130_fd_sc_hd__o21ba_2
XFILLER_88_309 vssd1 vssd1 vccd1 vccd1 sky130_fd_sc_hd__fill_1
X_5221_ _8407_/D _5902_/B _5221_/C vssd1 vssd1 vccd1 vccd1 _5229_/A sky130_fd_sc_hd__and3_2
X_5152_ _5153_/A _5153_/B vssd1 vssd1 vccd1 vccd1 _5152_/Y sky130_fd_sc_hd__nand2_2
XFILLER_69_556 vssd1 vssd1 vccd1 vccd1 sky130_fd_sc_hd__fill_4
XFILLER_69_567 vssd1 vssd1 vccd1 vccd1 sky130_fd_sc_hd__fill_2
X_5083_ _5103_/B _5082_/B _5082_/C vssd1 vssd1 vccd1 vccd1 _5083_/Y sky130_fd_sc_hd__a21oi_2
XFILLER_37_497 vssd1 vssd1 vccd1 vccd1 sky130_fd_sc_hd__fill_1
X_7724_ _7724_/A _7724_/B vssd1 vssd1 vccd1 vccd1 _7726_/A sky130_fd_sc_hd__nor2_2
X_5985_ _5767_/B _5983_/Y _5984_/X vssd1 vssd1 vccd1 vccd1 _5986_/B sky130_fd_sc_hd__a21oi_2
XANTENNA_fanout243_A _7998_/A vssd1 vssd1 vccd1 vccd1 sky130_fd_sc_hd__diode_2
X_4936_ _4976_/B _4936_/B vssd1 vssd1 vccd1 vccd1 _4939_/A sky130_fd_sc_hd__nand2_2
X_7655_ _7655_/A _7655_/B vssd1 vssd1 vccd1 vccd1 _7657_/A sky130_fd_sc_hd__xor2_2
X_4867_ _4867_/A _4867_/B vssd1 vssd1 vccd1 vccd1 _4868_/B sky130_fd_sc_hd__xor2_2
X_7586_ _7586_/A _7586_/B vssd1 vssd1 vccd1 vccd1 _7587_/B sky130_fd_sc_hd__nand2_2
X_6606_ _6607_/B _6607_/A vssd1 vssd1 vccd1 vccd1 _6696_/A sky130_fd_sc_hd__nand2b_2
X_6537_ _6859_/B _6537_/B vssd1 vssd1 vccd1 vccd1 _6539_/B sky130_fd_sc_hd__nand2_2
X_4798_ _4504_/A _4504_/B _4503_/A vssd1 vssd1 vccd1 vccd1 _4800_/B sky130_fd_sc_hd__o21ba_2
X_6468_ _6465_/Y _6466_/X _6260_/A _6263_/B vssd1 vssd1 vccd1 vccd1 _6469_/B sky130_fd_sc_hd__a211oi_2
X_8207_ _8208_/A _8208_/B vssd1 vssd1 vccd1 vccd1 _8207_/Y sky130_fd_sc_hd__nor2_2
X_6399_ _6488_/B _6399_/B vssd1 vssd1 vccd1 vccd1 _6401_/C sky130_fd_sc_hd__nor2_2
X_5419_ _5419_/A _5419_/B vssd1 vssd1 vccd1 vccd1 _5420_/B sky130_fd_sc_hd__nor2_2
XFILLER_87_320 vssd1 vssd1 vccd1 vccd1 sky130_fd_sc_hd__fill_2
X_8138_ _8138_/A _8138_/B _8138_/C _8138_/D vssd1 vssd1 vccd1 vccd1 _8139_/B sky130_fd_sc_hd__or4_2
XANTENNA__5815__B1 _6005_/B vssd1 vssd1 vccd1 vccd1 sky130_fd_sc_hd__diode_2
XFILLER_75_537 vssd1 vssd1 vccd1 vccd1 sky130_fd_sc_hd__fill_2
X_8069_ _7661_/X _7799_/B _7941_/A _8068_/X vssd1 vssd1 vccd1 vccd1 _8070_/B sky130_fd_sc_hd__a31o_4
XFILLER_46_33 vssd1 vssd1 vccd1 vccd1 sky130_fd_sc_hd__fill_4
XANTENNA__6435__A _6435_/A vssd1 vssd1 vccd1 vccd1 sky130_fd_sc_hd__diode_2
XANTENNA__8433__RESET_B wire362/A vssd1 vssd1 vccd1 vccd1 sky130_fd_sc_hd__diode_2
XFILLER_62_209 vssd1 vssd1 vccd1 vccd1 sky130_fd_sc_hd__fill_1
XTAP_TAPCELL_ROW_58_779 vssd1 vccd1 sky130_fd_sc_hd__tapvpwrvgnd_1
XTAP_TAPCELL_ROW_83_1026 vssd1 vccd1 sky130_fd_sc_hd__tapvpwrvgnd_1
XFILLER_15_169 vssd1 vssd1 vccd1 vccd1 sky130_fd_sc_hd__fill_1
XFILLER_70_253 vssd1 vssd1 vccd1 vccd1 sky130_fd_sc_hd__fill_2
XANTENNA__6722__X _7603_/B vssd1 vssd1 vccd1 vccd1 sky130_fd_sc_hd__diode_2
XTAP_TAPCELL_ROW_41_613 vssd1 vccd1 sky130_fd_sc_hd__tapvpwrvgnd_1
XFILLER_30_139 vssd1 vssd1 vccd1 vccd1 sky130_fd_sc_hd__fill_1
XFILLER_62_76 vssd1 vssd1 vccd1 vccd1 sky130_fd_sc_hd__fill_8
XTAP_TAPCELL_ROW_13_326 vssd1 vccd1 sky130_fd_sc_hd__tapvpwrvgnd_1
XANTENNA__8296__A1 _8208_/B vssd1 vssd1 vccd1 vccd1 sky130_fd_sc_hd__diode_2
Xclkbuf_4_9_0_clk clkbuf_0_clk/X vssd1 vssd1 vccd1 vccd1 clkload9/A sky130_fd_sc_hd__clkbuf_8
XFILLER_23_7 vssd1 vssd1 vccd1 vccd1 sky130_fd_sc_hd__fill_1
XFILLER_66_515 vssd1 vssd1 vccd1 vccd1 sky130_fd_sc_hd__fill_2
XFILLER_46_272 vssd1 vssd1 vccd1 vccd1 sky130_fd_sc_hd__fill_2
XTAP_TAPCELL_ROW_29_492 vssd1 vccd1 sky130_fd_sc_hd__tapvpwrvgnd_1
X_5770_ _5770_/A _5770_/B vssd1 vssd1 vccd1 vccd1 _5771_/B sky130_fd_sc_hd__xnor2_2
X_4721_ _4721_/A _4721_/B vssd1 vssd1 vccd1 vccd1 _4721_/X sky130_fd_sc_hd__or2_2
X_7440_ _7440_/A _7440_/B vssd1 vssd1 vccd1 vccd1 _7441_/B sky130_fd_sc_hd__or2_2
X_4652_ _4652_/A _4652_/B vssd1 vssd1 vccd1 vccd1 _4653_/A sky130_fd_sc_hd__xor2_2
X_7371_ _7371_/A _7371_/B vssd1 vssd1 vccd1 vccd1 _7378_/A sky130_fd_sc_hd__xnor2_2
X_4583_ _4585_/B _4585_/A vssd1 vssd1 vccd1 vccd1 _4583_/X sky130_fd_sc_hd__and2_2
X_6322_ _6323_/A _6323_/B vssd1 vssd1 vccd1 vccd1 _6322_/X sky130_fd_sc_hd__or2_2
X_6253_ _6254_/A _6254_/B vssd1 vssd1 vccd1 vccd1 _6453_/B sky130_fd_sc_hd__nor2_2
XFILLER_88_139 vssd1 vssd1 vccd1 vccd1 sky130_fd_sc_hd__fill_1
X_5204_ _5081_/A _5081_/B _5082_/X vssd1 vssd1 vccd1 vccd1 _5205_/A sky130_fd_sc_hd__a21oi_2
XFILLER_69_353 vssd1 vssd1 vccd1 vccd1 sky130_fd_sc_hd__fill_4
X_6184_ _6184_/A _6184_/B vssd1 vssd1 vccd1 vccd1 _6185_/B sky130_fd_sc_hd__nor2_2
XANTENNA_fanout193_A _4223_/B vssd1 vssd1 vccd1 vccd1 sky130_fd_sc_hd__diode_2
X_5135_ _4894_/Y _5132_/A _5016_/A _5016_/B vssd1 vssd1 vccd1 vccd1 _5137_/B sky130_fd_sc_hd__o22ai_2
X_5066_ _8412_/D wire77/A vssd1 vssd1 vccd1 vccd1 _5067_/B sky130_fd_sc_hd__nand2_2
XFILLER_84_378 vssd1 vssd1 vccd1 vccd1 sky130_fd_sc_hd__fill_2
XFILLER_37_283 vssd1 vssd1 vccd1 vccd1 sky130_fd_sc_hd__fill_2
XTAP_TAPCELL_ROW_55_749 vssd1 vccd1 sky130_fd_sc_hd__tapvpwrvgnd_1
XFILLER_52_231 vssd1 vssd1 vccd1 vccd1 sky130_fd_sc_hd__fill_2
XFILLER_52_253 vssd1 vssd1 vccd1 vccd1 sky130_fd_sc_hd__fill_1
X_5968_ _5969_/B _5969_/A vssd1 vssd1 vccd1 vccd1 _5968_/X sky130_fd_sc_hd__and2b_2
X_7707_ _7706_/B _7707_/B vssd1 vssd1 vccd1 vccd1 _7708_/B sky130_fd_sc_hd__nand2b_2
X_4919_ _4919_/A _4919_/B vssd1 vssd1 vccd1 vccd1 _4990_/S sky130_fd_sc_hd__nand2_2
X_5899_ _8414_/D _5899_/B vssd1 vssd1 vccd1 vccd1 _5901_/B sky130_fd_sc_hd__nand2_2
XANTENNA__7722__B1 _7723_/D vssd1 vssd1 vccd1 vccd1 sky130_fd_sc_hd__diode_2
X_7638_ _7638_/A _7638_/B vssd1 vssd1 vccd1 vccd1 _7640_/B sky130_fd_sc_hd__xor2_2
X_7569_ _7569_/A _7569_/B _7567_/Y vssd1 vssd1 vccd1 vccd1 _7570_/B sky130_fd_sc_hd__or3b_2
XFILLER_4_338 vssd1 vssd1 vccd1 vccd1 sky130_fd_sc_hd__fill_1
XFILLER_0_511 vssd1 vssd1 vccd1 vccd1 sky130_fd_sc_hd__fill_2
XANTENNA__5053__B _6738_/B vssd1 vssd1 vccd1 vccd1 sky130_fd_sc_hd__diode_2
XFILLER_0_533 vssd1 vssd1 vccd1 vccd1 sky130_fd_sc_hd__fill_4
XFILLER_48_515 vssd1 vssd1 vccd1 vccd1 sky130_fd_sc_hd__fill_4
XFILLER_75_323 vssd1 vssd1 vccd1 vccd1 sky130_fd_sc_hd__fill_1
XFILLER_87_183 vssd1 vssd1 vccd1 vccd1 sky130_fd_sc_hd__fill_1
XANTENNA_input19_A gpio_in[9] vssd1 vssd1 vccd1 vccd1 sky130_fd_sc_hd__diode_2
XTAP_TAPCELL_ROW_26_462 vssd1 vccd1 sky130_fd_sc_hd__tapvpwrvgnd_1
XANTENNA__4775__B1 _4700_/B vssd1 vssd1 vccd1 vccd1 sky130_fd_sc_hd__diode_2
XANTENNA__6612__B _7095_/B vssd1 vssd1 vccd1 vccd1 sky130_fd_sc_hd__diode_2
XANTENNA__6516__A1 _6517_/A vssd1 vssd1 vccd1 vccd1 sky130_fd_sc_hd__diode_2
XANTENNA__6516__B2 _6517_/B vssd1 vssd1 vccd1 vccd1 sky130_fd_sc_hd__diode_2
XANTENNA__6059__B _8246_/A vssd1 vssd1 vccd1 vccd1 sky130_fd_sc_hd__diode_2
XPHY_EDGE_ROW_13_Left_106 vssd1 vssd1 vccd1 vccd1 sky130_fd_sc_hd__decap_3
XANTENNA__8355__RESET_B load_slew384/X vssd1 vssd1 vccd1 vccd1 sky130_fd_sc_hd__diode_2
XFILLER_39_515 vssd1 vssd1 vccd1 vccd1 sky130_fd_sc_hd__fill_8
XANTENNA__5898__B _7326_/B vssd1 vssd1 vccd1 vccd1 sky130_fd_sc_hd__diode_2
XFILLER_14_3 vssd1 vssd1 vccd1 vccd1 sky130_fd_sc_hd__fill_2
XFILLER_39_559 vssd1 vssd1 vccd1 vccd1 sky130_fd_sc_hd__fill_1
XFILLER_78_172 vssd1 vssd1 vccd1 vccd1 sky130_fd_sc_hd__fill_4
X_6940_ _6940_/A _6940_/B vssd1 vssd1 vccd1 vccd1 _6942_/B sky130_fd_sc_hd__and2_2
XFILLER_81_337 vssd1 vssd1 vccd1 vccd1 sky130_fd_sc_hd__fill_1
XFILLER_62_540 vssd1 vssd1 vccd1 vccd1 sky130_fd_sc_hd__fill_1
X_6871_ _6866_/B _6552_/B _6554_/B _6556_/X vssd1 vssd1 vccd1 vccd1 _6872_/B sky130_fd_sc_hd__a31oi_2
X_5822_ _5420_/A _5419_/B _5419_/A vssd1 vssd1 vccd1 vccd1 _5832_/A sky130_fd_sc_hd__o21ba_2
XTAP_TAPCELL_ROW_52_719 vssd1 vccd1 sky130_fd_sc_hd__tapvpwrvgnd_1
XPHY_EDGE_ROW_22_Left_115 vssd1 vssd1 vccd1 vccd1 sky130_fd_sc_hd__decap_3
X_5753_ _5924_/B _5753_/B _5736_/Y vssd1 vssd1 vccd1 vccd1 _5971_/B sky130_fd_sc_hd__nor3b_2
X_4704_ _4709_/B _4704_/B _4704_/C _4704_/D vssd1 vssd1 vccd1 vccd1 _4704_/X sky130_fd_sc_hd__and4_2
X_5684_ _5684_/A _5684_/B vssd1 vssd1 vccd1 vccd1 _5684_/Y sky130_fd_sc_hd__xnor2_2
XTAP_TAPCELL_ROW_60_796 vssd1 vccd1 sky130_fd_sc_hd__tapvpwrvgnd_1
X_7423_ _7356_/A _7423_/A2 _7354_/Y _7355_/A vssd1 vssd1 vccd1 vccd1 _7425_/B sky130_fd_sc_hd__a31o_2
X_4635_ _4644_/A _4635_/A2 _4628_/X vssd1 vssd1 vccd1 vccd1 _4638_/A sky130_fd_sc_hd__a21o_2
X_7354_ _7355_/B vssd1 vssd1 vccd1 vccd1 _7354_/Y sky130_fd_sc_hd__inv_2
X_4566_ _4567_/A _4567_/B vssd1 vssd1 vccd1 vccd1 _4566_/X sky130_fd_sc_hd__or2_2
X_6305_ _6110_/B _6112_/B _6110_/A vssd1 vssd1 vccd1 vccd1 _6313_/B sky130_fd_sc_hd__o21bai_2
XPHY_EDGE_ROW_31_Left_124 vssd1 vssd1 vccd1 vccd1 sky130_fd_sc_hd__decap_3
X_7285_ _7503_/B _7285_/B vssd1 vssd1 vccd1 vccd1 _7287_/C sky130_fd_sc_hd__nor2_2
X_4497_ _4919_/A _4700_/B _4496_/D _6091_/A vssd1 vssd1 vccd1 vccd1 _4498_/B sky130_fd_sc_hd__a22oi_2
Xteam_03_405 vssd1 vssd1 vccd1 vccd1 team_03_405/HI gpio_out[2] sky130_fd_sc_hd__conb_1
X_6236_ _6433_/A _8246_/A vssd1 vssd1 vccd1 vccd1 _6237_/B sky130_fd_sc_hd__nand2_2
XANTENNA_fanout196_X _8071_/S vssd1 vssd1 vccd1 vccd1 sky130_fd_sc_hd__diode_2
Xteam_03_416 vssd1 vssd1 vccd1 vccd1 team_03_416/HI gpio_out[13] sky130_fd_sc_hd__conb_1
Xteam_03_427 vssd1 vssd1 vccd1 vccd1 gpio_oeb[6] team_03_427/LO sky130_fd_sc_hd__conb_1
Xteam_03_438 vssd1 vssd1 vccd1 vccd1 gpio_oeb[17] team_03_438/LO sky130_fd_sc_hd__conb_1
X_6167_ _6167_/A _6167_/B vssd1 vssd1 vccd1 vccd1 _6170_/A sky130_fd_sc_hd__xor2_2
X_5118_ _8410_/D _5902_/B vssd1 vssd1 vccd1 vccd1 _5775_/A sky130_fd_sc_hd__nand2_2
XANTENNA__8184__B _8184_/B vssd1 vssd1 vccd1 vccd1 sky130_fd_sc_hd__diode_2
XFILLER_84_153 vssd1 vssd1 vccd1 vccd1 sky130_fd_sc_hd__fill_2
X_6098_ _6098_/A _6098_/B vssd1 vssd1 vccd1 vccd1 _6099_/B sky130_fd_sc_hd__nor2_2
XANTENNA_fanout363_X wire364/A vssd1 vssd1 vccd1 vccd1 sky130_fd_sc_hd__diode_2
XFILLER_72_326 vssd1 vssd1 vccd1 vccd1 sky130_fd_sc_hd__fill_4
XFILLER_84_197 vssd1 vssd1 vccd1 vccd1 sky130_fd_sc_hd__fill_8
X_5049_ _5049_/A _5049_/B vssd1 vssd1 vccd1 vccd1 _6360_/B sky130_fd_sc_hd__xnor2_2
XTAP_TAPCELL_ROW_68_885 vssd1 vccd1 sky130_fd_sc_hd__tapvpwrvgnd_1
XFILLER_53_540 vssd1 vssd1 vccd1 vccd1 sky130_fd_sc_hd__fill_1
XPHY_EDGE_ROW_40_Left_133 vssd1 vssd1 vccd1 vccd1 sky130_fd_sc_hd__decap_3
XFILLER_80_370 vssd1 vssd1 vccd1 vccd1 sky130_fd_sc_hd__fill_4
XFILLER_40_223 vssd1 vssd1 vccd1 vccd1 sky130_fd_sc_hd__fill_1
XTAP_TAPCELL_ROW_23_432 vssd1 vccd1 sky130_fd_sc_hd__tapvpwrvgnd_1
XFILLER_4_168 vssd1 vssd1 vccd1 vccd1 sky130_fd_sc_hd__fill_1
XTAP_TAPCELL_ROW_91_1114 vssd1 vccd1 sky130_fd_sc_hd__tapvpwrvgnd_1
XFILLER_0_363 vssd1 vssd1 vccd1 vccd1 sky130_fd_sc_hd__fill_1
XFILLER_75_120 vssd1 vssd1 vccd1 vccd1 sky130_fd_sc_hd__fill_4
XFILLER_63_315 vssd1 vssd1 vccd1 vccd1 sky130_fd_sc_hd__fill_2
XTAP_TAPCELL_ROW_89_1087 vssd1 vccd1 sky130_fd_sc_hd__tapvpwrvgnd_1
XANTENNA__8314__S _8397_/D vssd1 vssd1 vccd1 vccd1 sky130_fd_sc_hd__diode_2
XFILLER_8_496 vssd1 vssd1 vccd1 vccd1 sky130_fd_sc_hd__fill_2
X_4420_ _4623_/A _4692_/B vssd1 vssd1 vccd1 vccd1 _4421_/B sky130_fd_sc_hd__nand2_2
X_4351_ _4352_/A _4352_/B vssd1 vssd1 vccd1 vccd1 _4351_/Y sky130_fd_sc_hd__nand2_2
X_7070_ _6759_/B _7071_/C _6997_/Y vssd1 vssd1 vccd1 vccd1 _7316_/A sky130_fd_sc_hd__a21oi_2
X_4282_ _4282_/A _4282_/B _4282_/C vssd1 vssd1 vccd1 vccd1 _4459_/B sky130_fd_sc_hd__and3_2
XANTENNA__8285__A _8361_/Q vssd1 vssd1 vccd1 vccd1 sky130_fd_sc_hd__diode_2
X_6021_ _6022_/A _6022_/B vssd1 vssd1 vccd1 vccd1 _6248_/A sky130_fd_sc_hd__nand2b_2
XFILLER_79_492 vssd1 vssd1 vccd1 vccd1 sky130_fd_sc_hd__fill_4
XANTENNA__6517__B _6517_/B vssd1 vssd1 vccd1 vccd1 sky130_fd_sc_hd__diode_2
XFILLER_66_186 vssd1 vssd1 vccd1 vccd1 sky130_fd_sc_hd__fill_2
X_7972_ _7972_/A _7972_/B vssd1 vssd1 vccd1 vccd1 _7974_/B sky130_fd_sc_hd__xnor2_2
XFILLER_66_197 vssd1 vssd1 vccd1 vccd1 sky130_fd_sc_hd__fill_1
XFILLER_81_134 vssd1 vccd1 vssd1 vccd1 sky130_ef_sc_hd__decap_40_12
X_6923_ _7895_/A _7723_/D _7725_/B _7998_/B vssd1 vssd1 vccd1 vccd1 _6924_/B sky130_fd_sc_hd__a22oi_2
XTAP_TAPCELL_ROW_65_855 vssd1 vccd1 sky130_fd_sc_hd__tapvpwrvgnd_1
XTAP_TAPCELL_ROW_37_568 vssd1 vccd1 sky130_fd_sc_hd__tapvpwrvgnd_1
XANTENNA_fanout156_A _7103_/A vssd1 vssd1 vccd1 vccd1 sky130_fd_sc_hd__diode_2
X_6854_ _6854_/A _6854_/B _6854_/C vssd1 vssd1 vccd1 vccd1 _6954_/A sky130_fd_sc_hd__or3_2
Xfanout49 _5040_/X vssd1 vssd1 vccd1 vccd1 _6997_/B sky130_fd_sc_hd__clkbuf_2
X_6785_ _6785_/A _6785_/B vssd1 vssd1 vccd1 vccd1 _6788_/B sky130_fd_sc_hd__xnor2_2
X_5805_ _5805_/A _5805_/B vssd1 vssd1 vccd1 vccd1 _5808_/A sky130_fd_sc_hd__xor2_2
XANTENNA_fanout323_A _8343_/Q vssd1 vssd1 vccd1 vccd1 sky130_fd_sc_hd__diode_2
XFILLER_13_26 vssd1 vssd1 vccd1 vccd1 sky130_fd_sc_hd__fill_1
X_5736_ _5736_/A _5736_/B vssd1 vssd1 vccd1 vccd1 _5736_/Y sky130_fd_sc_hd__xnor2_2
XTAP_TAPCELL_ROW_20_402 vssd1 vccd1 sky130_fd_sc_hd__tapvpwrvgnd_1
XFILLER_13_59 vssd1 vssd1 vccd1 vccd1 sky130_fd_sc_hd__fill_1
X_5667_ _5659_/C _5667_/B _8174_/A _5669_/B vssd1 vssd1 vccd1 vccd1 _5668_/C sky130_fd_sc_hd__and4b_2
XFILLER_89_19 vssd1 vssd1 vccd1 vccd1 sky130_fd_sc_hd__fill_1
X_7406_ _7097_/B _7295_/Y _7297_/X _7300_/B vssd1 vssd1 vccd1 vccd1 _7408_/B sky130_fd_sc_hd__a22o_2
X_4618_ _4619_/B _4619_/C _4619_/A vssd1 vssd1 vccd1 vccd1 _5054_/A sky130_fd_sc_hd__a21oi_2
XANTENNA__8179__B _8179_/B vssd1 vssd1 vccd1 vccd1 sky130_fd_sc_hd__diode_2
X_8386_ clkload0/A _8386_/D load_slew366/X vssd1 vssd1 vccd1 vccd1 _8386_/Q sky130_fd_sc_hd__dfrtp_2
X_5598_ _5598_/A _5598_/B vssd1 vssd1 vccd1 vccd1 _5600_/B sky130_fd_sc_hd__xnor2_2
X_7337_ _7336_/B _7336_/C _7336_/A vssd1 vssd1 vccd1 vccd1 _7337_/Y sky130_fd_sc_hd__o21ai_2
X_4549_ _4549_/A _4549_/B vssd1 vssd1 vccd1 vccd1 _4729_/B sky130_fd_sc_hd__xnor2_2
XFILLER_89_256 vssd1 vssd1 vccd1 vccd1 sky130_fd_sc_hd__fill_4
X_7268_ _7242_/B _7151_/B _7153_/B _7179_/A vssd1 vssd1 vccd1 vccd1 _7269_/C sky130_fd_sc_hd__a31oi_2
X_6219_ _6219_/A _6219_/B vssd1 vssd1 vccd1 vccd1 _6221_/A sky130_fd_sc_hd__nor2_2
XFILLER_38_23 vssd1 vssd1 vccd1 vccd1 sky130_fd_sc_hd__fill_4
X_7199_ _7290_/A _7199_/B vssd1 vssd1 vccd1 vccd1 _7201_/C sky130_fd_sc_hd__nor2_2
XANTENNA_fanout69_A _7007_/B vssd1 vssd1 vccd1 vccd1 sky130_fd_sc_hd__diode_2
XFILLER_85_440 vssd1 vssd1 vccd1 vccd1 sky130_fd_sc_hd__fill_2
XTAP_TAPCELL_ROW_0_193 vssd1 vccd1 sky130_fd_sc_hd__tapvpwrvgnd_1
XFILLER_41_554 vssd1 vssd1 vccd1 vccd1 sky130_fd_sc_hd__fill_1
XFILLER_70_21 vssd1 vssd1 vccd1 vccd1 sky130_fd_sc_hd__fill_1
XFILLER_70_65 vssd1 vssd1 vccd1 vccd1 sky130_fd_sc_hd__fill_4
XANTENNA__7447__A2 _8136_/B vssd1 vssd1 vccd1 vccd1 sky130_fd_sc_hd__diode_2
XFILLER_48_9 vssd1 vssd1 vccd1 vccd1 sky130_fd_sc_hd__fill_4
XFILLER_79_85 vssd1 vssd1 vccd1 vccd1 sky130_fd_sc_hd__fill_4
XANTENNA__8309__S _8313_/S vssd1 vssd1 vccd1 vccd1 sky130_fd_sc_hd__diode_2
XTAP_TAPCELL_ROW_8_282 vssd1 vccd1 sky130_fd_sc_hd__tapvpwrvgnd_1
XFILLER_76_462 vssd1 vssd1 vccd1 vccd1 sky130_fd_sc_hd__fill_2
XFILLER_48_197 vssd1 vssd1 vccd1 vccd1 sky130_fd_sc_hd__fill_1
XANTENNA__7449__A _8125_/A vssd1 vssd1 vccd1 vccd1 sky130_fd_sc_hd__diode_2
XTAP_TAPCELL_ROW_62_825 vssd1 vccd1 sky130_fd_sc_hd__tapvpwrvgnd_1
XTAP_TAPCELL_ROW_34_538 vssd1 vccd1 sky130_fd_sc_hd__tapvpwrvgnd_1
XANTENNA__4144__Y _4144_/Y vssd1 vssd1 vccd1 vccd1 sky130_fd_sc_hd__diode_2
XANTENNA__5394__B1 _8202_/A vssd1 vssd1 vccd1 vccd1 sky130_fd_sc_hd__diode_2
XFILLER_81_3 vssd1 vssd1 vccd1 vccd1 sky130_fd_sc_hd__fill_2
X_6570_ _6293_/A _6573_/A _6295_/A _6295_/B vssd1 vssd1 vccd1 vccd1 _6580_/A sky130_fd_sc_hd__a2bb2o_2
X_5521_ _8165_/A _8168_/A _5521_/C _5559_/C vssd1 vssd1 vccd1 vccd1 _5530_/B sky130_fd_sc_hd__and4_2
X_8240_ _8241_/A input8/X vssd1 vssd1 vccd1 vccd1 _8249_/A sky130_fd_sc_hd__and2_2
X_5452_ _5453_/B _5462_/A _5453_/A vssd1 vssd1 vccd1 vccd1 _5454_/B sky130_fd_sc_hd__a21oi_2
XANTENNA__5416__B _5826_/A vssd1 vssd1 vccd1 vccd1 sky130_fd_sc_hd__diode_2
X_8171_ _8307_/S _8171_/B _8171_/C vssd1 vssd1 vccd1 vccd1 _8171_/X sky130_fd_sc_hd__and3_2
X_5383_ _8233_/A _6460_/A _5383_/C vssd1 vssd1 vccd1 vccd1 _5384_/B sky130_fd_sc_hd__and3_2
X_4403_ _4413_/A _4413_/B vssd1 vssd1 vccd1 vccd1 _4403_/X sky130_fd_sc_hd__and2b_2
X_7122_ _7122_/A _7122_/B vssd1 vssd1 vccd1 vccd1 _7124_/A sky130_fd_sc_hd__nor2_2
X_4334_ _4334_/A _4334_/B vssd1 vssd1 vccd1 vccd1 _4336_/B sky130_fd_sc_hd__xor2_2
Xfanout206 _7427_/B1 vssd1 vssd1 vccd1 vccd1 _7714_/D sky130_fd_sc_hd__clkdlybuf4s25_1
Xfanout217 _8375_/Q vssd1 vssd1 vccd1 vccd1 _6207_/A sky130_fd_sc_hd__clkdlybuf4s25_1
Xfanout228 _7875_/A vssd1 vssd1 vccd1 vccd1 _7140_/A sky130_fd_sc_hd__clkdlybuf4s25_1
X_7053_ _8419_/D _7326_/B _7054_/A vssd1 vssd1 vccd1 vccd1 _7053_/X sky130_fd_sc_hd__and3_2
XANTENNA__4974__C _5163_/C vssd1 vssd1 vccd1 vccd1 sky130_fd_sc_hd__diode_2
Xfanout239 _5393_/B vssd1 vssd1 vccd1 vccd1 _5521_/C sky130_fd_sc_hd__clkdlybuf4s25_1
X_6004_ _6207_/A _6482_/A _6482_/B _6005_/B vssd1 vssd1 vccd1 vccd1 _6008_/A sky130_fd_sc_hd__a22oi_2
X_4265_ _4265_/A _4265_/B _4265_/C vssd1 vssd1 vccd1 vccd1 _4433_/A sky130_fd_sc_hd__or3_2
X_4196_ _4198_/B _8407_/Q _4195_/Y vssd1 vssd1 vccd1 vccd1 _5267_/A sky130_fd_sc_hd__o21ai_4
XTAP_TAPCELL_ROW_78_980 vssd1 vccd1 sky130_fd_sc_hd__tapvpwrvgnd_1
XFILLER_82_421 vssd1 vssd1 vccd1 vccd1 sky130_fd_sc_hd__fill_1
XFILLER_82_454 vssd1 vssd1 vccd1 vccd1 sky130_fd_sc_hd__fill_2
XANTENNA__7359__A _7359_/A vssd1 vssd1 vccd1 vccd1 sky130_fd_sc_hd__diode_2
X_7955_ _7954_/A _8082_/D _7954_/B _8081_/A vssd1 vssd1 vccd1 vccd1 _7955_/X sky130_fd_sc_hd__o22a_2
X_7886_ _7887_/A _7887_/B _7887_/C vssd1 vssd1 vccd1 vccd1 _8050_/A sky130_fd_sc_hd__a21oi_2
X_6906_ _7233_/A _7723_/C vssd1 vssd1 vccd1 vccd1 _6907_/B sky130_fd_sc_hd__nand2_2
X_6837_ _8110_/A _7725_/B vssd1 vssd1 vccd1 vccd1 _6838_/B sky130_fd_sc_hd__nand2_2
XANTENNA_fanout326_X _7426_/A vssd1 vssd1 vccd1 vccd1 sky130_fd_sc_hd__diode_2
XFILLER_24_69 vssd1 vssd1 vccd1 vccd1 sky130_fd_sc_hd__fill_1
XANTENNA__7806__B _7806_/B vssd1 vssd1 vccd1 vccd1 sky130_fd_sc_hd__diode_2
X_6768_ _6633_/A _6633_/B _6631_/X vssd1 vssd1 vccd1 vccd1 _6778_/A sky130_fd_sc_hd__a21bo_2
X_6699_ _6578_/A _6578_/B _6579_/X vssd1 vssd1 vccd1 vccd1 _6719_/A sky130_fd_sc_hd__a21oi_2
X_5719_ _5720_/A _5720_/B vssd1 vssd1 vccd1 vccd1 _5719_/X sky130_fd_sc_hd__and2b_2
X_8438_ clkload2/A _8438_/D load_slew370/X vssd1 vssd1 vccd1 vccd1 _8438_/Q sky130_fd_sc_hd__dfrtp_2
X_8369_ _8369_/CLK _8369_/D fanout371/X vssd1 vssd1 vccd1 vccd1 _8369_/Q sky130_fd_sc_hd__dfrtp_2
XANTENNA__6438__A _6438_/A vssd1 vssd1 vccd1 vccd1 sky130_fd_sc_hd__diode_2
XTAP_TAPCELL_ROW_5_252 vssd1 vccd1 sky130_fd_sc_hd__tapvpwrvgnd_1
XFILLER_92_229 vssd1 vssd1 vccd1 vccd1 sky130_fd_sc_hd__fill_1
XFILLER_65_43 vssd1 vssd1 vccd1 vccd1 sky130_fd_sc_hd__fill_2
XFILLER_85_281 vssd1 vssd1 vccd1 vccd1 sky130_fd_sc_hd__fill_1
XFILLER_65_87 vssd1 vssd1 vccd1 vccd1 sky130_fd_sc_hd__fill_2
XTAP_TAPCELL_ROW_86_1057 vssd1 vccd1 sky130_fd_sc_hd__tapvpwrvgnd_1
XFILLER_60_137 vssd1 vssd1 vccd1 vccd1 sky130_fd_sc_hd__fill_2
XTAP_TAPCELL_ROW_31_508 vssd1 vccd1 sky130_fd_sc_hd__tapvpwrvgnd_1
XANTENNA__4179__A1 input8/X vssd1 vssd1 vccd1 vccd1 sky130_fd_sc_hd__diode_2
XFILLER_14_91 vssd1 vssd1 vccd1 vccd1 sky130_fd_sc_hd__fill_2
XFILLER_30_90 vssd1 vssd1 vccd1 vccd1 sky130_fd_sc_hd__fill_2
XFILLER_1_480 vssd1 vssd1 vccd1 vccd1 sky130_fd_sc_hd__fill_2
XFILLER_68_248 vssd1 vssd1 vccd1 vccd1 sky130_fd_sc_hd__fill_4
XFILLER_36_101 vssd1 vssd1 vccd1 vccd1 sky130_fd_sc_hd__fill_1
XFILLER_49_484 vssd1 vssd1 vccd1 vccd1 sky130_fd_sc_hd__fill_8
XFILLER_83_229 vssd1 vssd1 vccd1 vccd1 sky130_fd_sc_hd__fill_1
Xinput6 gpio_in[13] vssd1 vssd1 vccd1 vccd1 input6/X sky130_fd_sc_hd__clkbuf_2
XTAP_TAPCELL_ROW_75_950 vssd1 vccd1 sky130_fd_sc_hd__tapvpwrvgnd_1
XTAP_TAPCELL_ROW_47_674 vssd1 vccd1 sky130_fd_sc_hd__tapvpwrvgnd_1
XFILLER_36_189 vssd1 vssd1 vccd1 vccd1 sky130_fd_sc_hd__fill_1
XFILLER_51_126 vssd1 vssd1 vccd1 vccd1 sky130_fd_sc_hd__fill_4
X_7740_ _7740_/A _7740_/B vssd1 vssd1 vccd1 vccd1 _7742_/B sky130_fd_sc_hd__xnor2_2
X_4952_ _4952_/A _4952_/B vssd1 vssd1 vccd1 vccd1 _4953_/C sky130_fd_sc_hd__xnor2_2
XTAP_TAPCELL_ROW_19_387 vssd1 vccd1 sky130_fd_sc_hd__tapvpwrvgnd_1
X_7671_ _7671_/A _7671_/B vssd1 vssd1 vccd1 vccd1 _7673_/C sky130_fd_sc_hd__xnor2_2
X_4883_ _4884_/A _4884_/B vssd1 vssd1 vccd1 vccd1 _4883_/X sky130_fd_sc_hd__or2_2
XFILLER_20_513 vssd1 vssd1 vccd1 vccd1 sky130_fd_sc_hd__fill_1
X_6622_ _6623_/B _6623_/A vssd1 vssd1 vccd1 vccd1 _6693_/A sky130_fd_sc_hd__nand2b_2
X_6553_ _6553_/A _6553_/B vssd1 vssd1 vccd1 vccd1 _6554_/B sky130_fd_sc_hd__nand2_2
X_6484_ _6484_/A _6484_/B vssd1 vssd1 vccd1 vccd1 _6486_/A sky130_fd_sc_hd__nor2_2
X_5504_ _5505_/A _5504_/B _5504_/C vssd1 vssd1 vccd1 vccd1 _5516_/A sky130_fd_sc_hd__nand3_2
X_8223_ _8223_/A _8223_/B vssd1 vssd1 vccd1 vccd1 _8224_/B sky130_fd_sc_hd__or2_2
X_5435_ _5435_/A _5435_/B vssd1 vssd1 vccd1 vccd1 _5440_/A sky130_fd_sc_hd__xnor2_2
X_8154_ _8154_/A _8154_/B vssd1 vssd1 vccd1 vccd1 _8158_/A sky130_fd_sc_hd__xnor2_2
X_5366_ _8220_/A _5657_/B vssd1 vssd1 vccd1 vccd1 _5370_/A sky130_fd_sc_hd__nand2_2
XFILLER_59_237 vssd1 vssd1 vccd1 vccd1 sky130_fd_sc_hd__fill_4
X_8085_ _8085_/A _8085_/B vssd1 vssd1 vccd1 vccd1 _8086_/B sky130_fd_sc_hd__xnor2_2
X_7105_ _7105_/A _7105_/B vssd1 vssd1 vccd1 vccd1 _7107_/B sky130_fd_sc_hd__xnor2_2
X_5297_ _5298_/A _5298_/B vssd1 vssd1 vccd1 vccd1 _5297_/Y sky130_fd_sc_hd__nor2_2
X_4317_ _4407_/A _4407_/B vssd1 vssd1 vccd1 vccd1 _4317_/X sky130_fd_sc_hd__or2_2
XFILLER_59_248 vssd1 vssd1 vccd1 vccd1 sky130_fd_sc_hd__fill_2
XFILLER_59_259 vssd1 vssd1 vccd1 vccd1 sky130_fd_sc_hd__fill_4
X_7036_ _7035_/A _7035_/B _7035_/C vssd1 vssd1 vccd1 vccd1 _7117_/B sky130_fd_sc_hd__a21o_2
X_4248_ _4292_/A _4292_/B _4249_/C vssd1 vssd1 vccd1 vccd1 _4299_/A sky130_fd_sc_hd__and3_2
XTAP_TAPCELL_ROW_2_222 vssd1 vccd1 sky130_fd_sc_hd__tapvpwrvgnd_1
XANTENNA_fanout276_X _6460_/A vssd1 vssd1 vccd1 vccd1 sky130_fd_sc_hd__diode_2
XFILLER_67_281 vssd1 vssd1 vccd1 vccd1 sky130_fd_sc_hd__fill_4
X_4179_ _8435_/Q input8/X _8398_/D vssd1 vssd1 vccd1 vccd1 _4179_/X sky130_fd_sc_hd__mux2_4
X_7938_ _7938_/A _7938_/B _7938_/C vssd1 vssd1 vccd1 vccd1 _7939_/B sky130_fd_sc_hd__and3_2
XFILLER_11_502 vssd1 vssd1 vccd1 vccd1 sky130_fd_sc_hd__fill_2
X_7869_ _7870_/A _7870_/B _7870_/C vssd1 vssd1 vccd1 vccd1 _7883_/A sky130_fd_sc_hd__a21o_2
XFILLER_50_192 vssd1 vssd1 vccd1 vccd1 sky130_fd_sc_hd__fill_4
XFILLER_51_23 vssd1 vssd1 vccd1 vccd1 sky130_fd_sc_hd__fill_4
XPHY_EDGE_ROW_14_Right_14 vssd1 vssd1 vccd1 vccd1 sky130_fd_sc_hd__decap_3
XFILLER_11_568 vssd1 vssd1 vccd1 vccd1 sky130_fd_sc_hd__fill_2
XANTENNA__8451__CLK clkload6/A vssd1 vssd1 vccd1 vccd1 sky130_fd_sc_hd__diode_2
XANTENNA__7552__A _8110_/B vssd1 vssd1 vccd1 vccd1 sky130_fd_sc_hd__diode_2
XPHY_EDGE_ROW_23_Right_23 vssd1 vssd1 vccd1 vccd1 sky130_fd_sc_hd__decap_3
XFILLER_76_53 vssd1 vssd1 vccd1 vccd1 sky130_fd_sc_hd__fill_1
XFILLER_46_443 vssd1 vssd1 vccd1 vccd1 sky130_fd_sc_hd__fill_1
XFILLER_73_251 vssd1 vssd1 vccd1 vccd1 sky130_fd_sc_hd__fill_1
XANTENNA__4416__A _8429_/D vssd1 vssd1 vccd1 vccd1 sky130_fd_sc_hd__diode_2
XFILLER_46_487 vssd1 vssd1 vccd1 vccd1 sky130_fd_sc_hd__fill_1
XTAP_TAPCELL_ROW_72_920 vssd1 vccd1 sky130_fd_sc_hd__tapvpwrvgnd_1
XFILLER_33_137 vssd1 vssd1 vccd1 vccd1 sky130_fd_sc_hd__fill_8
XTAP_TAPCELL_ROW_44_644 vssd1 vccd1 sky130_fd_sc_hd__tapvpwrvgnd_1
XTAP_TAPCELL_ROW_16_357 vssd1 vccd1 sky130_fd_sc_hd__tapvpwrvgnd_1
XPHY_EDGE_ROW_32_Right_32 vssd1 vssd1 vccd1 vccd1 sky130_fd_sc_hd__decap_3
XFILLER_92_85 vssd1 vssd1 vccd1 vccd1 sky130_fd_sc_hd__fill_1
XANTENNA__6631__A _6631_/A vssd1 vssd1 vccd1 vccd1 sky130_fd_sc_hd__diode_2
XANTENNA__6350__B _7007_/B vssd1 vssd1 vccd1 vccd1 sky130_fd_sc_hd__diode_2
XANTENNA__7510__A1 _7359_/A vssd1 vssd1 vccd1 vccd1 sky130_fd_sc_hd__diode_2
X_5220_ _8408_/D _5780_/B vssd1 vssd1 vccd1 vccd1 _5221_/C sky130_fd_sc_hd__and2_2
XPHY_EDGE_ROW_41_Right_41 vssd1 vssd1 vccd1 vccd1 sky130_fd_sc_hd__decap_3
X_5151_ _5151_/A _5151_/B vssd1 vssd1 vccd1 vccd1 _5153_/B sky130_fd_sc_hd__nor2_2
X_5082_ _5103_/B _5082_/B _5082_/C vssd1 vssd1 vccd1 vccd1 _5082_/X sky130_fd_sc_hd__and3_2
XANTENNA__5824__A1 _6016_/A vssd1 vssd1 vccd1 vccd1 sky130_fd_sc_hd__diode_2
XANTENNA__5824__B2 _6798_/B vssd1 vssd1 vccd1 vccd1 sky130_fd_sc_hd__diode_2
XFILLER_84_505 vssd1 vssd1 vccd1 vccd1 sky130_fd_sc_hd__fill_1
XFILLER_84_527 vssd1 vssd1 vccd1 vccd1 sky130_fd_sc_hd__fill_4
XANTENNA__6806__A _7131_/A vssd1 vssd1 vccd1 vccd1 sky130_fd_sc_hd__diode_2
XFILLER_2_83 vssd1 vssd1 vccd1 vccd1 sky130_fd_sc_hd__fill_1
XFILLER_49_281 vssd1 vssd1 vccd1 vccd1 sky130_fd_sc_hd__fill_4
XFILLER_52_435 vssd1 vssd1 vccd1 vccd1 sky130_fd_sc_hd__fill_1
XPHY_EDGE_ROW_50_Right_50 vssd1 vssd1 vccd1 vccd1 sky130_fd_sc_hd__decap_3
XFILLER_52_468 vssd1 vssd1 vccd1 vccd1 sky130_fd_sc_hd__fill_1
X_7723_ _8131_/A _7862_/B _7723_/C _7723_/D vssd1 vssd1 vccd1 vccd1 _7724_/B sky130_fd_sc_hd__and4_2
X_5984_ _5983_/A _6631_/B _6986_/B _6978_/A vssd1 vssd1 vccd1 vccd1 _5984_/X sky130_fd_sc_hd__o22a_2
X_4935_ _5710_/A _4972_/B _4934_/C vssd1 vssd1 vccd1 vccd1 _4936_/B sky130_fd_sc_hd__a21o_2
XANTENNA_fanout236_A _7233_/A vssd1 vssd1 vccd1 vccd1 sky130_fd_sc_hd__diode_2
X_7654_ _7654_/A _7654_/B vssd1 vssd1 vccd1 vccd1 _7655_/B sky130_fd_sc_hd__or2_4
X_4866_ _4867_/A _4867_/B vssd1 vssd1 vccd1 vccd1 _4866_/Y sky130_fd_sc_hd__nand2b_2
X_7585_ _7585_/A _7585_/B vssd1 vssd1 vccd1 vccd1 _7587_/A sky130_fd_sc_hd__xnor2_2
X_6605_ _6605_/A _6605_/B vssd1 vssd1 vccd1 vccd1 _6607_/B sky130_fd_sc_hd__xnor2_2
X_4797_ _4797_/A _4797_/B vssd1 vssd1 vccd1 vccd1 _4800_/A sky130_fd_sc_hd__xor2_2
XANTENNA__5157__A _5157_/A vssd1 vssd1 vccd1 vccd1 sky130_fd_sc_hd__diode_2
X_6536_ _6536_/A _6536_/B _6534_/Y vssd1 vssd1 vccd1 vccd1 _6537_/B sky130_fd_sc_hd__or3b_2
XANTENNA__4996__A _6091_/A vssd1 vssd1 vccd1 vccd1 sky130_fd_sc_hd__diode_2
X_6467_ _6260_/A _6263_/B _6465_/Y _6466_/X vssd1 vssd1 vccd1 vccd1 _6559_/B sky130_fd_sc_hd__o211a_2
X_8206_ _8202_/A _8205_/Y _8307_/S vssd1 vssd1 vccd1 vccd1 _8342_/D sky130_fd_sc_hd__mux2_1
X_6398_ _6397_/C _6482_/B _6488_/A _6396_/Y vssd1 vssd1 vccd1 vccd1 _6399_/B sky130_fd_sc_hd__o2bb2a_2
X_5418_ _6482_/B _6016_/A _6485_/B _5417_/D vssd1 vssd1 vccd1 vccd1 _5419_/B sky130_fd_sc_hd__a22oi_2
X_8137_ _8138_/A _8138_/B _8138_/C _8138_/D vssd1 vssd1 vccd1 vccd1 _8137_/X sky130_fd_sc_hd__o22a_2
X_5349_ _5349_/A _5349_/B vssd1 vssd1 vccd1 vccd1 _5350_/C sky130_fd_sc_hd__and2_2
XANTENNA__5276__C1 _6611_/A vssd1 vssd1 vccd1 vccd1 sky130_fd_sc_hd__diode_2
XANTENNA__5815__A1 _6207_/A vssd1 vssd1 vccd1 vccd1 sky130_fd_sc_hd__diode_2
XFILLER_75_505 vssd1 vssd1 vccd1 vccd1 sky130_fd_sc_hd__fill_8
X_8068_ _7797_/X _7937_/X _7939_/B vssd1 vssd1 vccd1 vccd1 _8068_/X sky130_fd_sc_hd__a21o_2
XFILLER_46_23 vssd1 vssd1 vccd1 vccd1 sky130_fd_sc_hd__fill_1
X_7019_ _7019_/A _7019_/B _7019_/C vssd1 vssd1 vccd1 vccd1 _7021_/C sky130_fd_sc_hd__nor3_2
XANTENNA__6435__B _8103_/B vssd1 vssd1 vccd1 vccd1 sky130_fd_sc_hd__diode_2
XTAP_TAPCELL_ROW_83_1027 vssd1 vccd1 sky130_fd_sc_hd__tapvpwrvgnd_1
XTAP_TAPCELL_ROW_41_614 vssd1 vccd1 sky130_fd_sc_hd__tapvpwrvgnd_1
XFILLER_23_192 vssd1 vssd1 vccd1 vccd1 sky130_fd_sc_hd__fill_1
XTAP_TAPCELL_ROW_13_327 vssd1 vccd1 sky130_fd_sc_hd__tapvpwrvgnd_1
XFILLER_78_365 vssd1 vssd1 vccd1 vccd1 sky130_fd_sc_hd__fill_4
XFILLER_78_387 vssd1 vssd1 vccd1 vccd1 sky130_fd_sc_hd__fill_1
XANTENNA__8317__S _8397_/D vssd1 vssd1 vccd1 vccd1 sky130_fd_sc_hd__diode_2
XFILLER_16_7 vssd1 vssd1 vccd1 vccd1 sky130_fd_sc_hd__fill_2
XFILLER_66_549 vssd1 vssd1 vccd1 vccd1 sky130_fd_sc_hd__fill_1
XFILLER_34_468 vssd1 vssd1 vccd1 vccd1 sky130_fd_sc_hd__fill_2
XTAP_TAPCELL_ROW_29_493 vssd1 vccd1 sky130_fd_sc_hd__tapvpwrvgnd_1
X_4720_ _4721_/A _4721_/B _4701_/X _4720_/B2 _4719_/X vssd1 vssd1 vccd1 vccd1 _4720_/X
+ sky130_fd_sc_hd__a221o_2
X_4651_ _4651_/A _4652_/A vssd1 vssd1 vccd1 vccd1 _4651_/Y sky130_fd_sc_hd__nand2_2
Xinput20 nrst vssd1 vssd1 vccd1 vccd1 _4226_/A sky130_fd_sc_hd__clkdlybuf4s25_1
X_7370_ _7371_/B _7371_/A vssd1 vssd1 vccd1 vccd1 _7636_/A sky130_fd_sc_hd__nand2b_2
X_4582_ _4573_/Y _4590_/A _4572_/Y vssd1 vssd1 vccd1 vccd1 _4585_/A sky130_fd_sc_hd__a21o_2
X_6321_ _6128_/A _6127_/Y _6126_/A vssd1 vssd1 vccd1 vccd1 _6323_/B sky130_fd_sc_hd__a21oi_2
X_6252_ _6458_/B _6252_/B vssd1 vssd1 vccd1 vccd1 _6254_/B sky130_fd_sc_hd__nand2_2
X_6183_ _6183_/A _6183_/B _6183_/C vssd1 vssd1 vccd1 vccd1 _6184_/B sky130_fd_sc_hd__nor3_2
X_5203_ _5695_/B _5202_/C _5202_/A vssd1 vssd1 vccd1 vccd1 _5205_/B sky130_fd_sc_hd__a21oi_2
XANTENNA_rebuffer441_X _8425_/D vssd1 vssd1 vccd1 vccd1 sky130_fd_sc_hd__diode_2
X_5134_ _5134_/A _5134_/B vssd1 vssd1 vccd1 vccd1 _5137_/A sky130_fd_sc_hd__xnor2_2
X_5065_ _8412_/D _6738_/B vssd1 vssd1 vccd1 vccd1 _5085_/A sky130_fd_sc_hd__nand2_2
XFILLER_84_368 vssd1 vssd1 vccd1 vccd1 sky130_fd_sc_hd__fill_1
XANTENNA__4481__B1 _4931_/C vssd1 vssd1 vccd1 vccd1 sky130_fd_sc_hd__diode_2
XFILLER_16_26 vssd1 vssd1 vccd1 vccd1 sky130_fd_sc_hd__fill_2
XANTENNA__7970__A1 _4177_/Y vssd1 vssd1 vccd1 vccd1 sky130_fd_sc_hd__diode_2
X_5967_ _5733_/A _5733_/B _5719_/X vssd1 vssd1 vccd1 vccd1 _5969_/B sky130_fd_sc_hd__o21ba_2
XANTENNA_fanout141_X _8429_/D vssd1 vssd1 vccd1 vccd1 sky130_fd_sc_hd__diode_2
X_7706_ _7707_/B _7706_/B vssd1 vssd1 vccd1 vccd1 _7708_/A sky130_fd_sc_hd__nand2b_2
X_4918_ _5157_/A _5953_/B _4850_/A _4847_/X vssd1 vssd1 vccd1 vccd1 _4923_/A sky130_fd_sc_hd__a31o_2
X_7637_ _7637_/A _7637_/B vssd1 vssd1 vccd1 vccd1 _7638_/B sky130_fd_sc_hd__nor2_2
X_5898_ _8414_/D _7326_/B vssd1 vssd1 vccd1 vccd1 _6167_/A sky130_fd_sc_hd__nand2_2
XFILLER_32_69 vssd1 vssd1 vccd1 vccd1 sky130_fd_sc_hd__fill_1
X_4849_ _5157_/A _5953_/B vssd1 vssd1 vccd1 vccd1 _4850_/B sky130_fd_sc_hd__nand2_2
XANTENNA__4222__C _4227_/S vssd1 vssd1 vccd1 vccd1 sky130_fd_sc_hd__diode_2
X_7568_ _7569_/A _7569_/B _7567_/Y vssd1 vssd1 vccd1 vccd1 _7777_/B sky130_fd_sc_hd__o21bai_2
X_7499_ _7274_/B _7276_/B _7274_/A vssd1 vssd1 vccd1 vccd1 _7501_/B sky130_fd_sc_hd__o21ba_2
X_6519_ _6832_/A _8263_/A vssd1 vssd1 vccd1 vccd1 _6520_/B sky130_fd_sc_hd__nand2_2
XFILLER_75_335 vssd1 vssd1 vccd1 vccd1 sky130_fd_sc_hd__fill_1
XANTENNA__5350__A _8228_/A vssd1 vssd1 vccd1 vccd1 sky130_fd_sc_hd__diode_2
XANTENNA__6165__B _7326_/B vssd1 vssd1 vccd1 vccd1 sky130_fd_sc_hd__diode_2
XFILLER_73_98 vssd1 vssd1 vccd1 vccd1 sky130_fd_sc_hd__fill_1
XTAP_TAPCELL_ROW_26_463 vssd1 vccd1 sky130_fd_sc_hd__tapvpwrvgnd_1
XANTENNA__4775__B2 _6572_/A vssd1 vssd1 vccd1 vccd1 sky130_fd_sc_hd__diode_2
XANTENNA__6612__C _7095_/C vssd1 vssd1 vccd1 vccd1 sky130_fd_sc_hd__diode_2
XANTENNA__6516__A2 _8246_/A vssd1 vssd1 vccd1 vccd1 sky130_fd_sc_hd__diode_2
XANTENNA__5244__B _5780_/B vssd1 vssd1 vccd1 vccd1 sky130_fd_sc_hd__diode_2
XFILLER_21_5 vssd1 vssd1 vccd1 vccd1 sky130_fd_sc_hd__fill_1
XFILLER_39_505 vssd1 vssd1 vccd1 vccd1 sky130_fd_sc_hd__fill_2
XFILLER_66_313 vssd1 vssd1 vccd1 vccd1 sky130_fd_sc_hd__fill_1
X_6870_ _6870_/A _6870_/B vssd1 vssd1 vccd1 vccd1 _6872_/A sky130_fd_sc_hd__nor2_2
XANTENNA__5197__A2_N _6631_/B vssd1 vssd1 vccd1 vccd1 sky130_fd_sc_hd__diode_2
XANTENNA__7401__B1 _7806_/B vssd1 vssd1 vccd1 vccd1 sky130_fd_sc_hd__diode_2
X_5821_ _5821_/A _5821_/B vssd1 vssd1 vccd1 vccd1 _5834_/A sky130_fd_sc_hd__xnor2_2
XANTENNA__6091__A _6091_/A vssd1 vssd1 vccd1 vccd1 sky130_fd_sc_hd__diode_2
X_5752_ _5752_/A _5752_/B _5752_/C vssd1 vssd1 vccd1 vccd1 _5753_/B sky130_fd_sc_hd__nor3_2
X_4703_ _8425_/D _4709_/C _4709_/D _4709_/A vssd1 vssd1 vccd1 vccd1 _4704_/D sky130_fd_sc_hd__a22o_2
XFILLER_8_60 vssd1 vssd1 vccd1 vccd1 sky130_fd_sc_hd__fill_1
X_5683_ _5684_/A _5684_/B vssd1 vssd1 vccd1 vccd1 _5683_/X sky130_fd_sc_hd__and2b_2
XTAP_TAPCELL_ROW_60_797 vssd1 vccd1 sky130_fd_sc_hd__tapvpwrvgnd_1
X_7422_ _7425_/A vssd1 vssd1 vccd1 vccd1 _7422_/Y sky130_fd_sc_hd__inv_2
X_4634_ _4634_/A _4634_/B vssd1 vssd1 vccd1 vccd1 _4644_/B sky130_fd_sc_hd__xor2_2
X_7353_ _7352_/A _7352_/B _7352_/C vssd1 vssd1 vccd1 vccd1 _7355_/B sky130_fd_sc_hd__a21oi_2
X_4565_ _4649_/A _4692_/B vssd1 vssd1 vccd1 vccd1 _4567_/B sky130_fd_sc_hd__nand2_2
X_6304_ _6304_/A _6304_/B vssd1 vssd1 vccd1 vccd1 _6320_/A sky130_fd_sc_hd__xnor2_2
Xmax_cap386 input19/X vssd1 vssd1 vccd1 vccd1 _8202_/B sky130_fd_sc_hd__clkbuf_2
X_7284_ _7284_/A _7284_/B _7282_/X vssd1 vssd1 vccd1 vccd1 _7285_/B sky130_fd_sc_hd__nor3b_2
X_4496_ _4919_/A _8430_/D _4700_/B _4496_/D vssd1 vssd1 vccd1 vccd1 _4498_/A sky130_fd_sc_hd__and4_2
XPHY_EDGE_ROW_4_Right_4 vssd1 vssd1 vccd1 vccd1 sky130_fd_sc_hd__decap_3
XFILLER_89_449 vssd1 vssd1 vccd1 vccd1 sky130_fd_sc_hd__fill_4
Xteam_03_406 vssd1 vssd1 vccd1 vccd1 team_03_406/HI gpio_out[3] sky130_fd_sc_hd__conb_1
X_6235_ _6235_/A _6235_/B vssd1 vssd1 vccd1 vccd1 _6237_/A sky130_fd_sc_hd__nor2_2
Xteam_03_417 vssd1 vssd1 vccd1 vccd1 team_03_417/HI gpio_out[14] sky130_fd_sc_hd__conb_1
Xteam_03_428 vssd1 vssd1 vccd1 vccd1 gpio_oeb[7] team_03_428/LO sky130_fd_sc_hd__conb_1
X_6166_ _8415_/D wire72/X vssd1 vssd1 vccd1 vccd1 _6167_/B sky130_fd_sc_hd__nand2_2
XFILLER_57_324 vssd1 vssd1 vccd1 vccd1 sky130_fd_sc_hd__fill_1
X_6097_ _6097_/A _6097_/B _6097_/C vssd1 vssd1 vccd1 vccd1 _6098_/B sky130_fd_sc_hd__and3_2
X_5117_ _8411_/D _5902_/B vssd1 vssd1 vccd1 vccd1 _5776_/A sky130_fd_sc_hd__nand2_2
X_5048_ _4731_/A _4731_/B _4513_/X vssd1 vssd1 vccd1 vccd1 _5049_/B sky130_fd_sc_hd__a21oi_2
XFILLER_72_305 vssd1 vssd1 vccd1 vccd1 sky130_fd_sc_hd__fill_2
XANTENNA_fanout356_X _6198_/A vssd1 vssd1 vccd1 vccd1 sky130_fd_sc_hd__diode_2
XFILLER_43_24 vssd1 vssd1 vccd1 vccd1 sky130_fd_sc_hd__fill_1
XFILLER_43_46 vssd1 vssd1 vccd1 vccd1 sky130_fd_sc_hd__fill_1
Xclkbuf_4_8_0_clk clkbuf_0_clk/X vssd1 vssd1 vccd1 vccd1 clkload8/A sky130_fd_sc_hd__clkbuf_8
X_6999_ _7000_/A _7000_/B vssd1 vssd1 vccd1 vccd1 _6999_/Y sky130_fd_sc_hd__nand2_2
XFILLER_43_57 vssd1 vssd1 vccd1 vccd1 sky130_fd_sc_hd__fill_2
XTAP_TAPCELL_ROW_23_433 vssd1 vccd1 sky130_fd_sc_hd__tapvpwrvgnd_1
XFILLER_21_482 vssd1 vssd1 vccd1 vccd1 sky130_fd_sc_hd__fill_1
XFILLER_21_493 vssd1 vssd1 vccd1 vccd1 sky130_fd_sc_hd__fill_1
XANTENNA__8120__A1 _6832_/A vssd1 vssd1 vccd1 vccd1 sky130_fd_sc_hd__diode_2
XFILLER_4_29 vssd1 vssd1 vccd1 vccd1 sky130_fd_sc_hd__fill_2
XTAP_TAPCELL_ROW_91_1115 vssd1 vccd1 sky130_fd_sc_hd__tapvpwrvgnd_1
XTAP_TAPCELL_ROW_89_1088 vssd1 vccd1 sky130_fd_sc_hd__tapvpwrvgnd_1
XFILLER_44_530 vssd1 vssd1 vccd1 vccd1 sky130_fd_sc_hd__fill_2
XFILLER_90_146 vssd1 vssd1 vccd1 vccd1 sky130_fd_sc_hd__fill_4
XFILLER_31_279 vssd1 vssd1 vccd1 vccd1 sky130_fd_sc_hd__fill_1
XANTENNA__7854__A2_N _8136_/A vssd1 vssd1 vccd1 vccd1 sky130_fd_sc_hd__diode_2
XFILLER_8_475 vssd1 vssd1 vccd1 vccd1 sky130_fd_sc_hd__fill_1
X_4350_ _4350_/A _4350_/B vssd1 vssd1 vccd1 vccd1 _4352_/B sky130_fd_sc_hd__xnor2_2
XANTENNA__4920__A1 _6712_/A vssd1 vssd1 vccd1 vccd1 sky130_fd_sc_hd__diode_2
XANTENNA__4920__B2 _8430_/D vssd1 vssd1 vccd1 vccd1 sky130_fd_sc_hd__diode_2
X_4281_ _4279_/Y _4281_/B vssd1 vssd1 vccd1 vccd1 _4282_/C sky130_fd_sc_hd__nand2b_2
XFILLER_3_191 vssd1 vssd1 vccd1 vccd1 sky130_fd_sc_hd__fill_1
X_6020_ _6020_/A _6020_/B vssd1 vssd1 vccd1 vccd1 _6022_/B sky130_fd_sc_hd__xnor2_2
XANTENNA_load_slew107_X _4692_/B vssd1 vssd1 vccd1 vccd1 sky130_fd_sc_hd__diode_2
XANTENNA__6517__C _8246_/A vssd1 vssd1 vccd1 vccd1 sky130_fd_sc_hd__diode_2
XFILLER_66_143 vssd1 vssd1 vccd1 vccd1 sky130_fd_sc_hd__fill_1
XFILLER_27_519 vssd1 vssd1 vccd1 vccd1 sky130_fd_sc_hd__fill_1
XFILLER_54_316 vssd1 vssd1 vccd1 vccd1 sky130_fd_sc_hd__fill_1
X_7971_ _7971_/A _7971_/B vssd1 vssd1 vccd1 vccd1 _7972_/B sky130_fd_sc_hd__and2_2
X_6922_ _7895_/A _7998_/B _7723_/D _7725_/B vssd1 vssd1 vccd1 vccd1 _6924_/A sky130_fd_sc_hd__and4_2
XFILLER_35_552 vssd1 vssd1 vccd1 vccd1 sky130_fd_sc_hd__fill_1
X_6853_ _6827_/B _6513_/B _6515_/B _6541_/A vssd1 vssd1 vccd1 vccd1 _6854_/C sky130_fd_sc_hd__a31oi_2
XTAP_TAPCELL_ROW_37_569 vssd1 vccd1 sky130_fd_sc_hd__tapvpwrvgnd_1
X_5804_ _5805_/A _5805_/B vssd1 vssd1 vccd1 vccd1 _5993_/B sky130_fd_sc_hd__nand2_2
XANTENNA_fanout149_A _4360_/X vssd1 vssd1 vccd1 vccd1 sky130_fd_sc_hd__diode_2
XFILLER_22_235 vssd1 vssd1 vccd1 vccd1 sky130_fd_sc_hd__fill_1
Xfanout39 _7603_/B vssd1 vssd1 vccd1 vccd1 _8077_/B sky130_fd_sc_hd__clkbuf_2
X_6784_ _6784_/A _6784_/B vssd1 vssd1 vccd1 vccd1 _6785_/B sky130_fd_sc_hd__xnor2_2
X_5735_ _5736_/B _5736_/A vssd1 vssd1 vccd1 vccd1 _5971_/A sky130_fd_sc_hd__and2b_2
XTAP_TAPCELL_ROW_20_403 vssd1 vccd1 sky130_fd_sc_hd__tapvpwrvgnd_1
XANTENNA_fanout316_A _6035_/D vssd1 vssd1 vccd1 vccd1 sky130_fd_sc_hd__diode_2
X_5666_ _8165_/A _5670_/B _5669_/C vssd1 vssd1 vccd1 vccd1 _5667_/B sky130_fd_sc_hd__a21o_2
X_7405_ _7405_/A _7405_/B vssd1 vssd1 vccd1 vccd1 _7408_/A sky130_fd_sc_hd__xor2_2
X_4617_ _4641_/B _4617_/B vssd1 vssd1 vccd1 vccd1 _4619_/C sky130_fd_sc_hd__nand2b_2
X_8385_ clkload0/A _8385_/D load_slew366/X vssd1 vssd1 vccd1 vccd1 _8385_/Q sky130_fd_sc_hd__dfrtp_2
X_5597_ _5597_/A _5597_/B vssd1 vssd1 vccd1 vccd1 _5598_/B sky130_fd_sc_hd__xnor2_2
XANTENNA__4911__A1 _8429_/D vssd1 vssd1 vccd1 vccd1 sky130_fd_sc_hd__diode_2
XANTENNA__4911__B2 _5928_/A vssd1 vssd1 vccd1 vccd1 sky130_fd_sc_hd__diode_2
XANTENNA__8102__A1 _8110_/A vssd1 vssd1 vccd1 vccd1 sky130_fd_sc_hd__diode_2
X_7336_ _7336_/A _7336_/B _7336_/C vssd1 vssd1 vccd1 vccd1 _7379_/B sky130_fd_sc_hd__or3_2
X_4548_ _4546_/A _4546_/B _4547_/Y vssd1 vssd1 vccd1 vccd1 _4729_/A sky130_fd_sc_hd__a21bo_2
X_7267_ _7267_/A _7267_/B vssd1 vssd1 vccd1 vccd1 _7269_/B sky130_fd_sc_hd__and2_2
X_4479_ _4480_/B _4480_/A vssd1 vssd1 vccd1 vccd1 _4479_/Y sky130_fd_sc_hd__nand2b_2
X_6218_ _7140_/A _7210_/A _7426_/A _8126_/A vssd1 vssd1 vccd1 vccd1 _6219_/B sky130_fd_sc_hd__a22oi_2
XANTENNA__8195__B _8196_/B vssd1 vssd1 vccd1 vccd1 sky130_fd_sc_hd__diode_2
X_7198_ _7198_/A _7198_/B _7198_/C vssd1 vssd1 vccd1 vccd1 _7199_/B sky130_fd_sc_hd__nor3_2
XANTENNA__8408__CLK clkload6/A vssd1 vssd1 vccd1 vccd1 sky130_fd_sc_hd__diode_2
XFILLER_18_508 vssd1 vssd1 vccd1 vccd1 sky130_fd_sc_hd__fill_1
X_6149_ _6978_/A _7084_/B _6150_/A vssd1 vssd1 vccd1 vccd1 _6149_/X sky130_fd_sc_hd__or3_2
XPHY_EDGE_ROW_79_Right_79 vssd1 vssd1 vccd1 vccd1 sky130_fd_sc_hd__decap_3
XANTENNA__6724__A _6724_/A vssd1 vssd1 vccd1 vccd1 sky130_fd_sc_hd__diode_2
XFILLER_72_124 vssd1 vssd1 vccd1 vccd1 sky130_fd_sc_hd__fill_1
XANTENNA__8169__B2 _8164_/B vssd1 vssd1 vccd1 vccd1 sky130_fd_sc_hd__diode_2
XFILLER_54_67 vssd1 vssd1 vccd1 vccd1 sky130_fd_sc_hd__fill_1
XTAP_TAPCELL_ROW_0_194 vssd1 vccd1 sky130_fd_sc_hd__tapvpwrvgnd_1
XFILLER_13_257 vssd1 vssd1 vccd1 vccd1 sky130_fd_sc_hd__fill_1
XFILLER_41_544 vssd1 vssd1 vccd1 vccd1 sky130_fd_sc_hd__fill_1
XPHY_EDGE_ROW_88_Right_88 vssd1 vssd1 vccd1 vccd1 sky130_fd_sc_hd__decap_3
XFILLER_5_445 vssd1 vssd1 vccd1 vccd1 sky130_fd_sc_hd__fill_2
XFILLER_48_110 vssd1 vssd1 vccd1 vccd1 sky130_fd_sc_hd__fill_4
XTAP_TAPCELL_ROW_8_283 vssd1 vccd1 sky130_fd_sc_hd__tapvpwrvgnd_1
XFILLER_36_316 vssd1 vssd1 vccd1 vccd1 sky130_fd_sc_hd__fill_1
XFILLER_36_327 vssd1 vssd1 vccd1 vccd1 sky130_fd_sc_hd__fill_1
XFILLER_63_102 vssd1 vssd1 vccd1 vccd1 sky130_fd_sc_hd__fill_2
XFILLER_63_135 vssd1 vssd1 vccd1 vccd1 sky130_fd_sc_hd__fill_1
XANTENNA__7449__B _7864_/B vssd1 vssd1 vccd1 vccd1 sky130_fd_sc_hd__diode_2
XTAP_TAPCELL_ROW_34_539 vssd1 vccd1 sky130_fd_sc_hd__tapvpwrvgnd_1
XANTENNA__7465__A _8103_/A vssd1 vssd1 vccd1 vccd1 sky130_fd_sc_hd__diode_2
XFILLER_74_3 vssd1 vssd1 vccd1 vccd1 sky130_fd_sc_hd__fill_4
X_5520_ _5520_/A _5520_/B vssd1 vssd1 vccd1 vccd1 _5530_/A sky130_fd_sc_hd__nor2_2
X_5451_ _5451_/A _5451_/B _5451_/C vssd1 vssd1 vccd1 vccd1 _5462_/A sky130_fd_sc_hd__nand3_2
X_8170_ _8170_/A _8170_/B _5583_/A _8164_/B vssd1 vssd1 vccd1 vccd1 _8171_/C sky130_fd_sc_hd__or4bb_2
X_5382_ _8233_/A _6460_/A _5383_/C vssd1 vssd1 vccd1 vccd1 _5384_/A sky130_fd_sc_hd__a21oi_2
X_4402_ _4402_/A _4402_/B vssd1 vssd1 vccd1 vccd1 _4413_/B sky130_fd_sc_hd__xor2_2
X_7121_ _6217_/C _7210_/C _7714_/D _7120_/A vssd1 vssd1 vccd1 vccd1 _7122_/B sky130_fd_sc_hd__a22oi_2
X_4333_ _4334_/A _4334_/B vssd1 vssd1 vccd1 vccd1 _4333_/Y sky130_fd_sc_hd__nor2_2
XFILLER_59_419 vssd1 vssd1 vccd1 vccd1 sky130_fd_sc_hd__fill_1
XFILLER_5_94 vssd1 vssd1 vccd1 vccd1 sky130_fd_sc_hd__fill_1
Xfanout207 _8378_/Q vssd1 vssd1 vccd1 vccd1 _7427_/B1 sky130_fd_sc_hd__clkdlybuf4s25_1
Xfanout218 _8375_/Q vssd1 vssd1 vccd1 vccd1 _7219_/A sky130_fd_sc_hd__clkdlybuf4s25_1
Xfanout229 _5386_/C vssd1 vssd1 vccd1 vccd1 _7875_/A sky130_fd_sc_hd__clkdlybuf4s25_1
X_7052_ _8419_/D _7326_/B vssd1 vssd1 vccd1 vccd1 _7054_/B sky130_fd_sc_hd__nand2_2
X_4264_ _4265_/B _4265_/C vssd1 vssd1 vccd1 vccd1 _4830_/C sky130_fd_sc_hd__nor2_2
X_6003_ _6003_/A _6204_/A vssd1 vssd1 vccd1 vccd1 _6011_/A sky130_fd_sc_hd__or2_2
XFILLER_79_290 vssd1 vssd1 vccd1 vccd1 sky130_fd_sc_hd__fill_2
X_4195_ _8168_/B _4198_/B vssd1 vssd1 vccd1 vccd1 _4195_/Y sky130_fd_sc_hd__nand2b_2
XFILLER_39_154 vssd1 vssd1 vccd1 vccd1 sky130_fd_sc_hd__fill_1
XTAP_TAPCELL_ROW_78_981 vssd1 vccd1 sky130_fd_sc_hd__tapvpwrvgnd_1
X_7954_ _7954_/A _7954_/B vssd1 vssd1 vccd1 vccd1 _8085_/A sky130_fd_sc_hd__nor2_2
XANTENNA_fanout266_A _6830_/B vssd1 vssd1 vccd1 vccd1 sky130_fd_sc_hd__diode_2
X_6905_ _6905_/A _6905_/B vssd1 vssd1 vccd1 vccd1 _6907_/A sky130_fd_sc_hd__nor2_2
XFILLER_23_522 vssd1 vssd1 vccd1 vccd1 sky130_fd_sc_hd__fill_1
XFILLER_35_360 vssd1 vssd1 vccd1 vccd1 sky130_fd_sc_hd__fill_1
X_7885_ _7885_/A _7885_/B vssd1 vssd1 vccd1 vccd1 _7887_/C sky130_fd_sc_hd__or2_2
XFILLER_23_555 vssd1 vssd1 vccd1 vccd1 sky130_fd_sc_hd__fill_4
XFILLER_62_190 vssd1 vssd1 vccd1 vccd1 sky130_fd_sc_hd__fill_1
X_6836_ _6836_/A _6836_/B vssd1 vssd1 vccd1 vccd1 _6838_/A sky130_fd_sc_hd__nor2_2
X_6767_ _6764_/Y _6765_/X _6660_/Y _6664_/A vssd1 vssd1 vccd1 vccd1 _6779_/B sky130_fd_sc_hd__o211a_2
XANTENNA_fanout221_X _7862_/B vssd1 vssd1 vccd1 vccd1 sky130_fd_sc_hd__diode_2
X_8506_ _8506_/A vssd1 vssd1 vccd1 vccd1 _8506_/X sky130_fd_sc_hd__buf_2
X_5718_ _5174_/A _5174_/B _5173_/A vssd1 vssd1 vccd1 vccd1 _5720_/B sky130_fd_sc_hd__a21o_2
XANTENNA_fanout319_X _6035_/D vssd1 vssd1 vccd1 vccd1 sky130_fd_sc_hd__diode_2
X_6698_ _6601_/A _6600_/B _6600_/A vssd1 vssd1 vccd1 vccd1 _6720_/A sky130_fd_sc_hd__o21bai_2
X_8437_ clkload5/A _8437_/D wire362/X vssd1 vssd1 vccd1 vccd1 _8437_/Q sky130_fd_sc_hd__dfrtp_2
X_5649_ _5649_/A _5656_/A _5649_/C vssd1 vssd1 vccd1 vccd1 _5652_/B sky130_fd_sc_hd__or3_2
X_8368_ clkload8/A _8368_/D wire377/X vssd1 vssd1 vccd1 vccd1 _8368_/Q sky130_fd_sc_hd__dfrtp_2
XANTENNA__6278__X _6280_/B vssd1 vssd1 vccd1 vccd1 sky130_fd_sc_hd__diode_2
XANTENNA__7822__B _8082_/C vssd1 vssd1 vccd1 vccd1 sky130_fd_sc_hd__diode_2
XANTENNA__8427__RESET_B load_slew360/X vssd1 vssd1 vccd1 vccd1 sky130_fd_sc_hd__diode_2
X_7319_ _8417_/D _7685_/B _7059_/Y vssd1 vssd1 vccd1 vccd1 _7320_/B sky130_fd_sc_hd__a21boi_2
XFILLER_49_34 vssd1 vssd1 vccd1 vccd1 sky130_fd_sc_hd__fill_1
X_8299_ _6005_/B input6/X _8303_/S vssd1 vssd1 vccd1 vccd1 _8374_/D sky130_fd_sc_hd__mux2_1
XANTENNA__6438__B _7140_/D vssd1 vssd1 vccd1 vccd1 sky130_fd_sc_hd__diode_2
XFILLER_77_216 vssd1 vssd1 vccd1 vccd1 sky130_fd_sc_hd__fill_1
XFILLER_58_430 vssd1 vssd1 vccd1 vccd1 sky130_fd_sc_hd__fill_2
XTAP_TAPCELL_ROW_5_253 vssd1 vccd1 sky130_fd_sc_hd__tapvpwrvgnd_1
XFILLER_58_485 vssd1 vssd1 vccd1 vccd1 sky130_fd_sc_hd__fill_1
XFILLER_65_22 vssd1 vssd1 vccd1 vccd1 sky130_fd_sc_hd__fill_2
XFILLER_92_219 vssd1 vssd1 vccd1 vccd1 sky130_fd_sc_hd__fill_4
XFILLER_65_55 vssd1 vssd1 vccd1 vccd1 sky130_fd_sc_hd__fill_1
XANTENNA__4415__A3 _6091_/A vssd1 vssd1 vccd1 vccd1 sky130_fd_sc_hd__diode_2
XTAP_TAPCELL_ROW_86_1058 vssd1 vccd1 sky130_fd_sc_hd__tapvpwrvgnd_1
XFILLER_81_54 vssd1 vssd1 vccd1 vccd1 sky130_fd_sc_hd__fill_2
XFILLER_81_65 vssd1 vssd1 vccd1 vccd1 sky130_fd_sc_hd__fill_1
XFILLER_81_87 vssd1 vssd1 vccd1 vccd1 sky130_fd_sc_hd__fill_1
XTAP_TAPCELL_ROW_31_509 vssd1 vccd1 sky130_fd_sc_hd__tapvpwrvgnd_1
XANTENNA__8314__A1 input5/X vssd1 vssd1 vccd1 vccd1 sky130_fd_sc_hd__diode_2
XANTENNA__7291__Y _7359_/A vssd1 vssd1 vccd1 vccd1 sky130_fd_sc_hd__diode_2
XFILLER_46_7 vssd1 vssd1 vccd1 vccd1 sky130_fd_sc_hd__fill_1
Xinput7 gpio_in[14] vssd1 vssd1 vccd1 vccd1 input7/X sky130_fd_sc_hd__clkbuf_4
XFILLER_64_433 vssd1 vssd1 vccd1 vccd1 sky130_fd_sc_hd__fill_2
XFILLER_36_146 vssd1 vssd1 vccd1 vccd1 sky130_fd_sc_hd__fill_1
XFILLER_36_157 vssd1 vssd1 vccd1 vccd1 sky130_fd_sc_hd__fill_2
XFILLER_64_477 vssd1 vssd1 vccd1 vccd1 sky130_fd_sc_hd__fill_4
XTAP_TAPCELL_ROW_75_951 vssd1 vccd1 sky130_fd_sc_hd__tapvpwrvgnd_1
XANTENNA__8352__Q _8352_/Q vssd1 vssd1 vccd1 vccd1 sky130_fd_sc_hd__diode_2
X_4951_ _4952_/B _4952_/A vssd1 vssd1 vccd1 vccd1 _5029_/A sky130_fd_sc_hd__and2b_2
XTAP_TAPCELL_ROW_47_675 vssd1 vccd1 sky130_fd_sc_hd__tapvpwrvgnd_1
XTAP_TAPCELL_ROW_19_388 vssd1 vccd1 sky130_fd_sc_hd__tapvpwrvgnd_1
X_7670_ _7670_/A _7670_/B vssd1 vssd1 vccd1 vccd1 _7671_/B sky130_fd_sc_hd__and2_2
X_4882_ _4882_/A _4882_/B vssd1 vssd1 vccd1 vccd1 _4884_/B sky130_fd_sc_hd__xnor2_2
XANTENNA_load_slew174_X _4761_/A vssd1 vssd1 vccd1 vccd1 sky130_fd_sc_hd__diode_2
X_6621_ _6621_/A _6621_/B vssd1 vssd1 vccd1 vccd1 _6623_/B sky130_fd_sc_hd__xnor2_2
XANTENNA__8305__A1 _8168_/B vssd1 vssd1 vccd1 vccd1 sky130_fd_sc_hd__diode_2
X_6552_ _6866_/B _6552_/B vssd1 vssd1 vccd1 vccd1 _6554_/A sky130_fd_sc_hd__nand2_2
XANTENNA__5427__B _6006_/A vssd1 vssd1 vccd1 vccd1 sky130_fd_sc_hd__diode_2
X_6483_ _6795_/A _8135_/A2 _6795_/D _8337_/Q vssd1 vssd1 vccd1 vccd1 _6484_/B sky130_fd_sc_hd__a22oi_2
X_5503_ _5495_/A _5495_/B _5540_/A vssd1 vssd1 vccd1 vccd1 _5504_/C sky130_fd_sc_hd__o21ai_2
X_8222_ _8222_/A _8222_/B vssd1 vssd1 vccd1 vccd1 _8223_/B sky130_fd_sc_hd__nor2_2
X_5434_ _5435_/A _5435_/B vssd1 vssd1 vccd1 vccd1 _5836_/A sky130_fd_sc_hd__and2b_2
X_8153_ _8153_/A _8153_/B vssd1 vssd1 vccd1 vccd1 _8154_/B sky130_fd_sc_hd__xnor2_2
X_7104_ _7104_/A _7104_/B vssd1 vssd1 vccd1 vccd1 _7105_/B sky130_fd_sc_hd__xor2_2
X_5365_ _5365_/A _5365_/B vssd1 vssd1 vccd1 vccd1 _5372_/A sky130_fd_sc_hd__xnor2_2
X_8084_ _8084_/A _8084_/B vssd1 vssd1 vccd1 vccd1 _8085_/B sky130_fd_sc_hd__nor2_2
X_5296_ _5296_/A _5296_/B vssd1 vssd1 vccd1 vccd1 _5296_/Y sky130_fd_sc_hd__nand2_2
X_4316_ _4401_/A _4316_/B vssd1 vssd1 vccd1 vccd1 _4407_/B sky130_fd_sc_hd__xor2_2
XANTENNA_fanout383_A _4226_/X vssd1 vssd1 vccd1 vccd1 sky130_fd_sc_hd__diode_2
XFILLER_87_569 vssd1 vssd1 vccd1 vccd1 sky130_fd_sc_hd__fill_1
X_7035_ _7035_/A _7035_/B _7035_/C vssd1 vssd1 vccd1 vccd1 _7038_/A sky130_fd_sc_hd__nand3_2
X_4247_ _4342_/A _4292_/C vssd1 vssd1 vccd1 vccd1 _4249_/C sky130_fd_sc_hd__and2_2
X_4178_ _7969_/A vssd1 vssd1 vccd1 vccd1 _8414_/D sky130_fd_sc_hd__inv_2
XTAP_TAPCELL_ROW_2_223 vssd1 vccd1 sky130_fd_sc_hd__tapvpwrvgnd_1
XANTENNA_fanout269_X _6830_/B vssd1 vssd1 vccd1 vccd1 sky130_fd_sc_hd__diode_2
XFILLER_55_466 vssd1 vssd1 vccd1 vccd1 sky130_fd_sc_hd__fill_1
XFILLER_42_127 vssd1 vssd1 vccd1 vccd1 sky130_fd_sc_hd__fill_1
X_7937_ _7938_/A _7938_/B _7938_/C vssd1 vssd1 vccd1 vccd1 _7937_/X sky130_fd_sc_hd__a21o_2
X_7868_ _8040_/B _7868_/B vssd1 vssd1 vccd1 vccd1 _7870_/C sky130_fd_sc_hd__nand2_2
X_6819_ _6819_/A _6819_/B vssd1 vssd1 vccd1 vccd1 _6821_/B sky130_fd_sc_hd__xnor2_2
X_7799_ _7799_/A _7799_/B vssd1 vssd1 vccd1 vccd1 _7799_/Y sky130_fd_sc_hd__nor2_2
XANTENNA__7552__B _8103_/D vssd1 vssd1 vccd1 vccd1 sky130_fd_sc_hd__diode_2
XFILLER_4_3 vssd1 vssd1 vccd1 vccd1 sky130_fd_sc_hd__fill_2
XANTENNA__4416__B _4686_/B vssd1 vssd1 vccd1 vccd1 sky130_fd_sc_hd__diode_2
XFILLER_73_285 vssd1 vssd1 vccd1 vccd1 sky130_fd_sc_hd__fill_2
XTAP_TAPCELL_ROW_72_921 vssd1 vccd1 sky130_fd_sc_hd__tapvpwrvgnd_1
XTAP_TAPCELL_ROW_44_645 vssd1 vccd1 sky130_fd_sc_hd__tapvpwrvgnd_1
XFILLER_92_97 vssd1 vssd1 vccd1 vccd1 sky130_fd_sc_hd__fill_1
XFILLER_14_363 vssd1 vssd1 vccd1 vccd1 sky130_fd_sc_hd__fill_1
XTAP_TAPCELL_ROW_16_358 vssd1 vccd1 sky130_fd_sc_hd__tapvpwrvgnd_1
XANTENNA__6631__B _6631_/B vssd1 vssd1 vccd1 vccd1 sky130_fd_sc_hd__diode_2
XANTENNA__7446__C _8136_/B vssd1 vssd1 vccd1 vccd1 sky130_fd_sc_hd__diode_2
XANTENNA__8299__A0 _6005_/B vssd1 vssd1 vccd1 vccd1 sky130_fd_sc_hd__diode_2
XANTENNA__6078__B _6078_/B vssd1 vssd1 vccd1 vccd1 sky130_fd_sc_hd__diode_2
XFILLER_37_3 vssd1 vssd1 vccd1 vccd1 sky130_fd_sc_hd__fill_8
X_5150_ _6294_/A _5149_/B _5149_/C vssd1 vssd1 vccd1 vccd1 _5151_/B sky130_fd_sc_hd__a21oi_2
XFILLER_69_569 vssd1 vssd1 vccd1 vccd1 sky130_fd_sc_hd__fill_1
X_5081_ _5081_/A _5081_/B vssd1 vssd1 vccd1 vccd1 _5082_/C sky130_fd_sc_hd__xor2_2
XANTENNA__5824__A2 _6485_/B vssd1 vssd1 vccd1 vccd1 sky130_fd_sc_hd__diode_2
XFILLER_56_208 vssd1 vssd1 vccd1 vccd1 sky130_fd_sc_hd__fill_1
XANTENNA__6806__B _7515_/A vssd1 vssd1 vccd1 vccd1 sky130_fd_sc_hd__diode_2
XANTENNA__6094__A _8428_/D vssd1 vssd1 vccd1 vccd1 sky130_fd_sc_hd__diode_2
XFILLER_64_230 vssd1 vssd1 vccd1 vccd1 sky130_fd_sc_hd__fill_1
XANTENNA__4326__B wire92/X vssd1 vssd1 vccd1 vccd1 sky130_fd_sc_hd__diode_2
X_5983_ _5983_/A _7080_/B vssd1 vssd1 vccd1 vccd1 _5983_/Y sky130_fd_sc_hd__nor2_2
XFILLER_52_458 vssd1 vssd1 vccd1 vccd1 sky130_fd_sc_hd__fill_4
X_7722_ _8131_/A _7723_/C _7723_/D _8131_/B vssd1 vssd1 vccd1 vccd1 _7724_/A sky130_fd_sc_hd__a22oi_2
X_4934_ _5710_/A _4972_/B _4934_/C vssd1 vssd1 vccd1 vccd1 _4976_/B sky130_fd_sc_hd__nand3_2
XFILLER_20_322 vssd1 vssd1 vccd1 vccd1 sky130_fd_sc_hd__fill_1
X_7653_ _7652_/B _7652_/A _7652_/C vssd1 vssd1 vccd1 vccd1 _7654_/B sky130_fd_sc_hd__a21oi_2
X_4865_ _4792_/A _4792_/B _4790_/Y vssd1 vssd1 vccd1 vccd1 _4867_/B sky130_fd_sc_hd__o21ai_2
XANTENNA_fanout131_A _8423_/D vssd1 vssd1 vccd1 vccd1 sky130_fd_sc_hd__diode_2
XANTENNA_fanout229_A _5386_/C vssd1 vssd1 vccd1 vccd1 sky130_fd_sc_hd__diode_2
X_7584_ _7585_/A _7585_/B vssd1 vssd1 vccd1 vccd1 _7785_/B sky130_fd_sc_hd__nand2b_2
X_6604_ _6604_/A _6604_/B vssd1 vssd1 vccd1 vccd1 _6605_/B sky130_fd_sc_hd__xnor2_2
X_4796_ _4796_/A _4796_/B vssd1 vssd1 vccd1 vccd1 _4797_/B sky130_fd_sc_hd__or2_4
X_6535_ _6536_/A _6536_/B _6534_/Y vssd1 vssd1 vccd1 vccd1 _6859_/B sky130_fd_sc_hd__o21bai_2
X_8205_ _8205_/A _8205_/B vssd1 vssd1 vccd1 vccd1 _8205_/Y sky130_fd_sc_hd__xnor2_2
X_6466_ _6553_/B _6463_/X _6264_/A _6265_/A vssd1 vssd1 vccd1 vccd1 _6466_/X sky130_fd_sc_hd__a211o_2
X_6397_ _6488_/A _6396_/Y _6397_/C _6482_/B vssd1 vssd1 vccd1 vccd1 _6488_/B sky130_fd_sc_hd__and4bb_2
X_5417_ _6482_/B _6016_/A _6485_/B _5417_/D vssd1 vssd1 vccd1 vccd1 _5419_/A sky130_fd_sc_hd__and4_2
X_8136_ _8136_/A _8136_/B _8136_/C _8136_/D vssd1 vssd1 vccd1 vccd1 _8138_/D sky130_fd_sc_hd__and4_2
X_5348_ _5348_/A _5461_/A _5348_/C vssd1 vssd1 vccd1 vccd1 _5349_/B sky130_fd_sc_hd__nand3_2
X_8067_ _8065_/Y _8067_/B vssd1 vssd1 vccd1 vccd1 _8070_/A sky130_fd_sc_hd__nand2b_2
XANTENNA__5815__A2 _6001_/A vssd1 vssd1 vccd1 vccd1 sky130_fd_sc_hd__diode_2
X_7018_ _7019_/A _7019_/B _7019_/C vssd1 vssd1 vccd1 vccd1 _7076_/A sky130_fd_sc_hd__o21a_2
X_5279_ _5273_/X _5277_/X _5278_/Y _5276_/X vssd1 vssd1 vccd1 vccd1 _5281_/B sky130_fd_sc_hd__a22oi_2
XANTENNA__4517__A _8429_/D vssd1 vssd1 vccd1 vccd1 sky130_fd_sc_hd__diode_2
XANTENNA_fanout44_A _5763_/Y vssd1 vssd1 vccd1 vccd1 sky130_fd_sc_hd__diode_2
XFILLER_43_447 vssd1 vssd1 vccd1 vccd1 sky130_fd_sc_hd__fill_1
XTAP_TAPCELL_ROW_83_1028 vssd1 vccd1 sky130_fd_sc_hd__tapvpwrvgnd_1
XTAP_TAPCELL_ROW_41_615 vssd1 vccd1 sky130_fd_sc_hd__tapvpwrvgnd_1
XTAP_TAPCELL_ROW_13_328 vssd1 vccd1 sky130_fd_sc_hd__tapvpwrvgnd_1
XFILLER_7_337 vssd1 vssd1 vccd1 vccd1 sky130_fd_sc_hd__fill_1
XFILLER_87_20 vssd1 vssd1 vccd1 vccd1 sky130_fd_sc_hd__fill_1
XFILLER_87_86 vssd1 vssd1 vccd1 vccd1 sky130_fd_sc_hd__fill_1
XFILLER_66_517 vssd1 vssd1 vccd1 vccd1 sky130_fd_sc_hd__fill_1
XANTENNA_clkload7_A clkload7/A vssd1 vssd1 vccd1 vccd1 sky130_fd_sc_hd__diode_2
XFILLER_19_499 vssd1 vssd1 vccd1 vccd1 sky130_fd_sc_hd__fill_4
XFILLER_46_274 vssd1 vssd1 vccd1 vccd1 sky130_fd_sc_hd__fill_1
XFILLER_46_285 vssd1 vssd1 vccd1 vccd1 sky130_fd_sc_hd__fill_1
XTAP_TAPCELL_ROW_57_770 vssd1 vccd1 sky130_fd_sc_hd__tapvpwrvgnd_1
XTAP_TAPCELL_ROW_29_494 vssd1 vccd1 sky130_fd_sc_hd__tapvpwrvgnd_1
XFILLER_14_193 vssd1 vssd1 vccd1 vccd1 sky130_fd_sc_hd__fill_1
X_4650_ _4649_/A _4686_/B _4650_/A3 _4647_/Y _4596_/B vssd1 vssd1 vccd1 vccd1 _4652_/A
+ sky130_fd_sc_hd__a32o_2
Xinput10 gpio_in[17] vssd1 vssd1 vccd1 vccd1 _8254_/B sky130_fd_sc_hd__buf_2
X_6320_ _6320_/A _6320_/B vssd1 vssd1 vccd1 vccd1 _6323_/A sky130_fd_sc_hd__xnor2_2
X_4581_ _4581_/A _4581_/B vssd1 vssd1 vccd1 vccd1 _4590_/A sky130_fd_sc_hd__xor2_2
XFILLER_6_370 vssd1 vssd1 vccd1 vccd1 sky130_fd_sc_hd__fill_1
X_6251_ _6251_/A _6251_/B _6249_/Y vssd1 vssd1 vccd1 vccd1 _6252_/B sky130_fd_sc_hd__or3b_2
XFILLER_88_108 vssd1 vssd1 vccd1 vccd1 sky130_fd_sc_hd__fill_2
X_6182_ _6183_/A _6183_/B _6183_/C vssd1 vssd1 vccd1 vccd1 _6184_/A sky130_fd_sc_hd__o21a_2
X_5202_ _5202_/A _5202_/B _5202_/C vssd1 vssd1 vccd1 vccd1 _5205_/C sky130_fd_sc_hd__and3_4
XFILLER_69_333 vssd1 vssd1 vccd1 vccd1 sky130_fd_sc_hd__fill_2
X_5133_ _5747_/A _6572_/B vssd1 vssd1 vccd1 vccd1 _5134_/B sky130_fd_sc_hd__nand2_2
XFILLER_69_399 vssd1 vssd1 vccd1 vccd1 sky130_fd_sc_hd__fill_1
X_5064_ _5064_/A _5064_/B vssd1 vssd1 vccd1 vccd1 _5071_/A sky130_fd_sc_hd__xor2_2
XFILLER_37_252 vssd1 vssd1 vccd1 vccd1 sky130_fd_sc_hd__fill_1
XFILLER_25_447 vssd1 vssd1 vccd1 vccd1 sky130_fd_sc_hd__fill_1
XFILLER_92_391 vssd1 vssd1 vccd1 vccd1 sky130_fd_sc_hd__fill_1
XANTENNA__7970__A2 _8077_/B vssd1 vssd1 vccd1 vccd1 sky130_fd_sc_hd__diode_2
X_5966_ _5966_/A _5966_/B vssd1 vssd1 vccd1 vccd1 _5969_/A sky130_fd_sc_hd__xor2_2
X_7705_ _7705_/A _7705_/B vssd1 vssd1 vccd1 vccd1 _7707_/B sky130_fd_sc_hd__xnor2_2
X_5897_ _6183_/A _5897_/B vssd1 vssd1 vccd1 vccd1 _5905_/A sky130_fd_sc_hd__or2_2
X_4917_ _4917_/A _4917_/B vssd1 vssd1 vccd1 vccd1 _4949_/B sky130_fd_sc_hd__xnor2_2
XANTENNA_fanout134_X _5020_/A vssd1 vssd1 vccd1 vccd1 sky130_fd_sc_hd__diode_2
XFILLER_20_130 vssd1 vssd1 vccd1 vccd1 sky130_fd_sc_hd__fill_1
X_7636_ _7636_/A _7636_/B _7636_/C vssd1 vssd1 vccd1 vccd1 _7637_/B sky130_fd_sc_hd__and3_2
X_4848_ _4925_/C _4848_/B vssd1 vssd1 vccd1 vccd1 _4850_/A sky130_fd_sc_hd__xnor2_2
XANTENNA__7722__A2 _7723_/C vssd1 vssd1 vccd1 vccd1 sky130_fd_sc_hd__diode_2
XANTENNA__4222__D _8397_/D vssd1 vssd1 vccd1 vccd1 sky130_fd_sc_hd__diode_2
X_7567_ _7777_/A _7567_/B vssd1 vssd1 vccd1 vccd1 _7567_/Y sky130_fd_sc_hd__nand2_2
X_4779_ _4779_/A _4779_/B vssd1 vssd1 vccd1 vccd1 _4788_/A sky130_fd_sc_hd__or2_4
XANTENNA_fanout301_X _8246_/A vssd1 vssd1 vccd1 vccd1 sky130_fd_sc_hd__diode_2
X_7498_ _7498_/A _7498_/B vssd1 vssd1 vccd1 vccd1 _7501_/A sky130_fd_sc_hd__xnor2_2
X_6518_ _6518_/A _6518_/B vssd1 vssd1 vccd1 vccd1 _6520_/A sky130_fd_sc_hd__nor2_2
X_6449_ _6450_/A _6450_/B vssd1 vssd1 vccd1 vccd1 _6545_/B sky130_fd_sc_hd__or2_2
X_8119_ _8041_/A _8041_/C _8041_/B vssd1 vssd1 vccd1 vccd1 _8144_/B sky130_fd_sc_hd__a21bo_2
XFILLER_57_34 vssd1 vssd1 vccd1 vccd1 sky130_fd_sc_hd__fill_1
XANTENNA__5350__B _5669_/B vssd1 vssd1 vccd1 vccd1 sky130_fd_sc_hd__diode_2
XANTENNA_fanout47_X _6631_/B vssd1 vssd1 vccd1 vccd1 sky130_fd_sc_hd__diode_2
XFILLER_71_531 vssd1 vssd1 vccd1 vccd1 sky130_fd_sc_hd__fill_1
XFILLER_73_55 vssd1 vssd1 vccd1 vccd1 sky130_fd_sc_hd__fill_1
XTAP_TAPCELL_ROW_54_740 vssd1 vccd1 sky130_fd_sc_hd__tapvpwrvgnd_1
XFILLER_43_255 vssd1 vssd1 vccd1 vccd1 sky130_fd_sc_hd__fill_1
XTAP_TAPCELL_ROW_26_464 vssd1 vccd1 sky130_fd_sc_hd__tapvpwrvgnd_1
XANTENNA__4775__A2 _4487_/B vssd1 vssd1 vccd1 vccd1 sky130_fd_sc_hd__diode_2
XFILLER_7_134 vssd1 vssd1 vccd1 vccd1 sky130_fd_sc_hd__fill_2
XFILLER_7_167 vssd1 vssd1 vccd1 vccd1 sky130_fd_sc_hd__fill_1
XFILLER_47_561 vssd1 vssd1 vccd1 vccd1 sky130_fd_sc_hd__fill_1
XANTENNA__7468__A _8001_/A vssd1 vssd1 vccd1 vccd1 sky130_fd_sc_hd__diode_2
XFILLER_62_531 vssd1 vssd1 vccd1 vccd1 sky130_fd_sc_hd__fill_1
XANTENNA__6372__A _7095_/A vssd1 vssd1 vccd1 vccd1 sky130_fd_sc_hd__diode_2
X_5820_ _5821_/A _5821_/B vssd1 vssd1 vccd1 vccd1 _6013_/A sky130_fd_sc_hd__nand2b_2
X_5751_ _5752_/A _5752_/B _5752_/C vssd1 vssd1 vccd1 vccd1 _5924_/B sky130_fd_sc_hd__o21a_2
X_4702_ _8422_/D _4700_/B _4702_/B1 vssd1 vssd1 vccd1 vccd1 _4702_/Y sky130_fd_sc_hd__a21oi_2
X_7421_ _7421_/A _7421_/B vssd1 vssd1 vccd1 vccd1 _7425_/A sky130_fd_sc_hd__xnor2_2
X_5682_ _5682_/A _5682_/B vssd1 vssd1 vccd1 vccd1 _5684_/B sky130_fd_sc_hd__xnor2_2
XTAP_TAPCELL_ROW_60_798 vssd1 vccd1 sky130_fd_sc_hd__tapvpwrvgnd_1
XFILLER_30_494 vssd1 vssd1 vccd1 vccd1 sky130_fd_sc_hd__fill_2
X_4633_ _4633_/A _4633_/B vssd1 vssd1 vccd1 vccd1 _4644_/A sky130_fd_sc_hd__xor2_2
X_7352_ _7352_/A _7352_/B _7352_/C vssd1 vssd1 vccd1 vccd1 _7355_/A sky130_fd_sc_hd__and3_2
X_4564_ _4564_/A _4564_/B vssd1 vssd1 vccd1 vccd1 _4567_/A sky130_fd_sc_hd__xnor2_2
X_7283_ _7284_/A _7284_/B _7282_/X vssd1 vssd1 vccd1 vccd1 _7503_/B sky130_fd_sc_hd__o21ba_2
X_6303_ _6572_/A wire90/X vssd1 vssd1 vccd1 vccd1 _6304_/B sky130_fd_sc_hd__nand2_2
XANTENNA__5479__B1 _6238_/B vssd1 vssd1 vccd1 vccd1 sky130_fd_sc_hd__diode_2
XFILLER_89_428 vssd1 vssd1 vccd1 vccd1 sky130_fd_sc_hd__fill_1
X_6234_ _6517_/A _6517_/B _8233_/A _8241_/A vssd1 vssd1 vccd1 vccd1 _6235_/B sky130_fd_sc_hd__and4_2
X_4495_ _4919_/A _4496_/D vssd1 vssd1 vccd1 vccd1 _4771_/A sky130_fd_sc_hd__nand2_2
XANTENNA_fanout296_A _6517_/D vssd1 vssd1 vccd1 vccd1 sky130_fd_sc_hd__diode_2
Xteam_03_407 vssd1 vssd1 vccd1 vccd1 team_03_407/HI gpio_out[4] sky130_fd_sc_hd__conb_1
Xteam_03_418 vssd1 vssd1 vccd1 vccd1 team_03_418/HI gpio_out[15] sky130_fd_sc_hd__conb_1
Xteam_03_429 vssd1 vssd1 vccd1 vccd1 gpio_oeb[8] team_03_429/LO sky130_fd_sc_hd__conb_1
X_6165_ _8415_/D _7326_/B vssd1 vssd1 vccd1 vccd1 _6361_/A sky130_fd_sc_hd__nand2_2
X_6096_ _6097_/A _6097_/B _6097_/C vssd1 vssd1 vccd1 vccd1 _6098_/A sky130_fd_sc_hd__a21oi_2
X_5116_ _5116_/A vssd1 vssd1 vccd1 vccd1 _5122_/A sky130_fd_sc_hd__inv_2
X_5047_ _5047_/A _5047_/B vssd1 vssd1 vccd1 vccd1 _5051_/A sky130_fd_sc_hd__xor2_2
XTAP_TAPCELL_ROW_68_876 vssd1 vccd1 sky130_fd_sc_hd__tapvpwrvgnd_1
XANTENNA__5724__C_N _5147_/B vssd1 vssd1 vccd1 vccd1 sky130_fd_sc_hd__diode_2
X_6998_ _7071_/B _7071_/A vssd1 vssd1 vccd1 vccd1 _7000_/B sky130_fd_sc_hd__xor2_2
X_5949_ _8434_/D wire99/X _6108_/A vssd1 vssd1 vccd1 vccd1 _5949_/X sky130_fd_sc_hd__and3_2
XTAP_TAPCELL_ROW_51_710 vssd1 vccd1 sky130_fd_sc_hd__tapvpwrvgnd_1
XTAP_TAPCELL_ROW_23_434 vssd1 vccd1 sky130_fd_sc_hd__tapvpwrvgnd_1
XFILLER_21_461 vssd1 vssd1 vccd1 vccd1 sky130_fd_sc_hd__fill_1
X_7619_ _7619_/A _7619_/B vssd1 vssd1 vccd1 vccd1 _7638_/A sky130_fd_sc_hd__xor2_2
XFILLER_4_137 vssd1 vssd1 vccd1 vccd1 sky130_fd_sc_hd__fill_2
XFILLER_4_159 vssd1 vssd1 vccd1 vccd1 sky130_fd_sc_hd__fill_1
XFILLER_68_22 vssd1 vssd1 vccd1 vccd1 sky130_fd_sc_hd__fill_4
XFILLER_68_66 vssd1 vssd1 vccd1 vccd1 sky130_fd_sc_hd__fill_8
XFILLER_88_461 vssd1 vssd1 vccd1 vccd1 sky130_fd_sc_hd__fill_2
XFILLER_0_376 vssd1 vssd1 vccd1 vccd1 sky130_fd_sc_hd__fill_1
XFILLER_48_314 vssd1 vssd1 vccd1 vccd1 sky130_fd_sc_hd__fill_1
XFILLER_75_111 vssd1 vssd1 vccd1 vccd1 sky130_fd_sc_hd__fill_1
XFILLER_75_133 vssd1 vssd1 vccd1 vccd1 sky130_fd_sc_hd__fill_4
XFILLER_29_561 vssd1 vssd1 vccd1 vccd1 sky130_fd_sc_hd__fill_1
XTAP_TAPCELL_ROW_89_1089 vssd1 vccd1 sky130_fd_sc_hd__tapvpwrvgnd_1
XFILLER_44_520 vssd1 vssd1 vccd1 vccd1 sky130_fd_sc_hd__fill_1
XFILLER_84_87 vssd1 vssd1 vccd1 vccd1 sky130_fd_sc_hd__fill_1
XFILLER_90_125 vssd1 vssd1 vccd1 vccd1 sky130_fd_sc_hd__fill_2
XFILLER_71_372 vssd1 vssd1 vccd1 vccd1 sky130_fd_sc_hd__fill_1
XANTENNA__6920__A _8110_/B vssd1 vssd1 vccd1 vccd1 sky130_fd_sc_hd__diode_2
XANTENNA__7751__A _8110_/B vssd1 vssd1 vccd1 vccd1 sky130_fd_sc_hd__diode_2
X_4280_ _8390_/Q _8449_/Q vssd1 vssd1 vccd1 vccd1 _4281_/B sky130_fd_sc_hd__nand2_2
XFILLER_79_472 vssd1 vssd1 vccd1 vccd1 sky130_fd_sc_hd__fill_4
XANTENNA__6517__D _6517_/D vssd1 vssd1 vccd1 vccd1 sky130_fd_sc_hd__diode_2
XFILLER_66_133 vssd1 vssd1 vccd1 vccd1 sky130_fd_sc_hd__fill_2
X_7970_ _4177_/Y _8077_/B _7969_/C vssd1 vssd1 vccd1 vccd1 _7971_/B sky130_fd_sc_hd__o21ai_2
X_6921_ _6921_/A _6921_/B vssd1 vssd1 vccd1 vccd1 _6931_/A sky130_fd_sc_hd__xnor2_2
XTAP_TAPCELL_ROW_65_846 vssd1 vccd1 sky130_fd_sc_hd__tapvpwrvgnd_1
XFILLER_81_169 vssd1 vssd1 vccd1 vccd1 sky130_fd_sc_hd__fill_4
X_6852_ _6852_/A _6852_/B vssd1 vssd1 vccd1 vccd1 _6854_/B sky130_fd_sc_hd__and2_2
XFILLER_50_523 vssd1 vssd1 vccd1 vccd1 sky130_fd_sc_hd__fill_2
XFILLER_62_361 vssd1 vssd1 vccd1 vccd1 sky130_fd_sc_hd__fill_1
X_5803_ _5803_/A _5803_/B vssd1 vssd1 vccd1 vccd1 _5805_/B sky130_fd_sc_hd__xor2_2
X_6783_ _6784_/A _6784_/B vssd1 vssd1 vccd1 vccd1 _6783_/X sky130_fd_sc_hd__and2b_2
XANTENNA__6830__A _6830_/A vssd1 vssd1 vccd1 vccd1 sky130_fd_sc_hd__diode_2
X_5734_ _5178_/A _5178_/B _5176_/X vssd1 vssd1 vccd1 vccd1 _5736_/B sky130_fd_sc_hd__o21ba_2
XTAP_TAPCELL_ROW_20_404 vssd1 vccd1 sky130_fd_sc_hd__tapvpwrvgnd_1
X_8453_ clkload7/A _8453_/D load_slew373/X vssd1 vssd1 vccd1 vccd1 _8453_/Q sky130_fd_sc_hd__dfrtp_2
X_5665_ _5662_/B _5662_/C _5662_/A vssd1 vssd1 vccd1 vccd1 _5668_/B sky130_fd_sc_hd__a21o_2
X_8384_ clkload0/A _8384_/D wire368/X vssd1 vssd1 vccd1 vccd1 _8384_/Q sky130_fd_sc_hd__dfrtp_2
X_7404_ _7405_/A _7405_/B vssd1 vssd1 vccd1 vccd1 _7404_/X sky130_fd_sc_hd__and2b_2
X_4616_ _4616_/A _4616_/B vssd1 vssd1 vccd1 vccd1 _4641_/A sky130_fd_sc_hd__xnor2_4
XANTENNA_fanout309_A _8346_/Q vssd1 vssd1 vccd1 vccd1 sky130_fd_sc_hd__diode_2
X_7335_ _7335_/A _7335_/B _7335_/C vssd1 vssd1 vccd1 vccd1 _7336_/C sky130_fd_sc_hd__and3_2
X_5596_ _5597_/A _5597_/B vssd1 vssd1 vccd1 vccd1 _5596_/X sky130_fd_sc_hd__and2b_2
XANTENNA__8102__A2 _8103_/D vssd1 vssd1 vccd1 vccd1 sky130_fd_sc_hd__diode_2
XANTENNA_clkbuf_4_6_0_clk_X clkload6/A vssd1 vssd1 vccd1 vccd1 sky130_fd_sc_hd__diode_2
Xmax_cap151 _4209_/A vssd1 vssd1 vccd1 vccd1 _7958_/A sky130_fd_sc_hd__buf_2
X_4547_ _4551_/B _4551_/A vssd1 vssd1 vccd1 vccd1 _4547_/Y sky130_fd_sc_hd__nand2b_2
XFILLER_89_225 vssd1 vssd1 vccd1 vccd1 sky130_fd_sc_hd__fill_4
X_7266_ _7267_/A _7267_/B vssd1 vssd1 vccd1 vccd1 _7269_/A sky130_fd_sc_hd__nor2_2
X_4478_ _4478_/A _4478_/B vssd1 vssd1 vccd1 vccd1 _4480_/B sky130_fd_sc_hd__xnor2_2
X_7197_ _7198_/A _7198_/B _7198_/C vssd1 vssd1 vccd1 vccd1 _7290_/A sky130_fd_sc_hd__o21a_2
X_6217_ _8016_/A _8126_/A _6217_/C _7426_/A vssd1 vssd1 vccd1 vccd1 _6219_/A sky130_fd_sc_hd__and4_2
X_6148_ _6978_/A _7084_/B vssd1 vssd1 vccd1 vccd1 _6150_/B sky130_fd_sc_hd__nor2_2
XFILLER_85_442 vssd1 vssd1 vccd1 vccd1 sky130_fd_sc_hd__fill_1
XFILLER_85_453 vssd1 vssd1 vccd1 vccd1 sky130_fd_sc_hd__fill_2
X_6079_ _5884_/A _5884_/B _5882_/X vssd1 vssd1 vccd1 vccd1 _6080_/B sky130_fd_sc_hd__a21oi_4
XANTENNA__6724__B _7299_/B vssd1 vssd1 vccd1 vccd1 sky130_fd_sc_hd__diode_2
XFILLER_54_13 vssd1 vssd1 vccd1 vccd1 sky130_fd_sc_hd__fill_2
XFILLER_57_188 vssd1 vssd1 vccd1 vccd1 sky130_fd_sc_hd__fill_4
XFILLER_60_309 vssd1 vssd1 vccd1 vccd1 sky130_fd_sc_hd__fill_4
XFILLER_41_501 vssd1 vssd1 vccd1 vccd1 sky130_fd_sc_hd__fill_2
XTAP_TAPCELL_ROW_0_195 vssd1 vccd1 sky130_fd_sc_hd__tapvpwrvgnd_1
XFILLER_5_457 vssd1 vssd1 vccd1 vccd1 sky130_fd_sc_hd__fill_4
XTAP_TAPCELL_ROW_8_284 vssd1 vccd1 sky130_fd_sc_hd__tapvpwrvgnd_1
XANTENNA__6474__X _6476_/B vssd1 vssd1 vccd1 vccd1 sky130_fd_sc_hd__diode_2
XFILLER_76_475 vssd1 vssd1 vccd1 vccd1 sky130_fd_sc_hd__fill_1
XFILLER_91_401 vssd1 vssd1 vccd1 vccd1 sky130_fd_sc_hd__fill_2
XFILLER_17_553 vssd1 vssd1 vccd1 vccd1 sky130_fd_sc_hd__fill_4
XTAP_TAPCELL_ROW_62_816 vssd1 vccd1 sky130_fd_sc_hd__tapvpwrvgnd_1
XFILLER_81_5 vssd1 vssd1 vccd1 vccd1 sky130_fd_sc_hd__fill_1
XANTENNA__7465__B _7754_/B vssd1 vssd1 vccd1 vccd1 sky130_fd_sc_hd__diode_2
X_5450_ _5450_/A _5450_/B _5450_/C vssd1 vssd1 vccd1 vccd1 _5451_/C sky130_fd_sc_hd__or3_2
XFILLER_67_3 vssd1 vssd1 vccd1 vccd1 sky130_fd_sc_hd__fill_4
X_4401_ _4401_/A _4401_/B vssd1 vssd1 vccd1 vccd1 _4413_/A sky130_fd_sc_hd__or2_2
X_5381_ _5381_/A _5381_/B vssd1 vssd1 vccd1 vccd1 _5383_/C sky130_fd_sc_hd__nor2_2
X_7120_ _7120_/A _7210_/A _7210_/C _7714_/D vssd1 vssd1 vccd1 vccd1 _7122_/A sky130_fd_sc_hd__and4_2
X_4332_ _4332_/A _4332_/B vssd1 vssd1 vccd1 vccd1 _4334_/B sky130_fd_sc_hd__xnor2_2
XANTENNA__6646__A2 _7326_/B vssd1 vssd1 vccd1 vccd1 sky130_fd_sc_hd__diode_2
Xfanout208 _8135_/A2 vssd1 vssd1 vccd1 vccd1 _8136_/C sky130_fd_sc_hd__clkdlybuf4s25_1
Xfanout219 _7862_/B vssd1 vssd1 vccd1 vccd1 _8131_/B sky130_fd_sc_hd__clkdlybuf4s25_1
X_7051_ _7051_/A _7051_/B vssd1 vssd1 vccd1 vccd1 _7054_/A sky130_fd_sc_hd__xor2_2
X_4263_ _4262_/B _4262_/C _4262_/A vssd1 vssd1 vccd1 vccd1 _4265_/C sky130_fd_sc_hd__a21oi_2
Xclkbuf_4_7_0_clk clkbuf_0_clk/X vssd1 vssd1 vccd1 vccd1 clkload7/A sky130_fd_sc_hd__clkbuf_8
X_6002_ _6397_/C _6198_/A _6395_/C vssd1 vssd1 vccd1 vccd1 _6204_/A sky130_fd_sc_hd__and3_2
X_4194_ _5983_/A vssd1 vssd1 vccd1 vccd1 _4194_/Y sky130_fd_sc_hd__inv_2
XTAP_TAPCELL_ROW_78_982 vssd1 vccd1 sky130_fd_sc_hd__tapvpwrvgnd_1
XPHY_EDGE_ROW_19_Left_112 vssd1 vssd1 vccd1 vccd1 sky130_fd_sc_hd__decap_3
XFILLER_82_412 vssd1 vssd1 vccd1 vccd1 sky130_fd_sc_hd__fill_1
X_7953_ _7953_/A _7953_/B vssd1 vssd1 vccd1 vccd1 _7960_/A sky130_fd_sc_hd__or2_2
XFILLER_42_309 vssd1 vssd1 vccd1 vccd1 sky130_fd_sc_hd__fill_2
XFILLER_82_456 vssd1 vssd1 vccd1 vccd1 sky130_fd_sc_hd__fill_1
X_6904_ _7140_/A _6903_/C _7140_/C _7140_/B vssd1 vssd1 vccd1 vccd1 _6905_/B sky130_fd_sc_hd__a22oi_2
XANTENNA_fanout161_A _6631_/A vssd1 vssd1 vccd1 vccd1 sky130_fd_sc_hd__diode_2
XANTENNA_fanout259_A _6830_/A vssd1 vssd1 vccd1 vccd1 sky130_fd_sc_hd__diode_2
XFILLER_23_501 vssd1 vssd1 vccd1 vccd1 sky130_fd_sc_hd__fill_2
X_7884_ _7883_/A _7883_/B _7883_/C vssd1 vssd1 vccd1 vccd1 _7885_/B sky130_fd_sc_hd__a21oi_2
XFILLER_23_534 vssd1 vssd1 vccd1 vccd1 sky130_fd_sc_hd__fill_2
XFILLER_24_49 vssd1 vssd1 vccd1 vccd1 sky130_fd_sc_hd__fill_4
XFILLER_62_180 vssd1 vssd1 vccd1 vccd1 sky130_fd_sc_hd__fill_1
X_6835_ _7895_/A _7723_/C _7723_/D _7998_/B vssd1 vssd1 vccd1 vccd1 _6836_/B sky130_fd_sc_hd__a22oi_2
X_6766_ _6660_/Y _6664_/A _6764_/Y _6765_/X vssd1 vssd1 vccd1 vccd1 _7027_/A sky130_fd_sc_hd__a211oi_2
XFILLER_10_217 vssd1 vssd1 vccd1 vccd1 sky130_fd_sc_hd__fill_2
X_5717_ _5717_/A _5717_/B vssd1 vssd1 vccd1 vccd1 _5720_/A sky130_fd_sc_hd__xnor2_2
XPHY_EDGE_ROW_28_Left_121 vssd1 vssd1 vccd1 vccd1 sky130_fd_sc_hd__decap_3
X_6697_ _6605_/A _6605_/B _6603_/X vssd1 vssd1 vccd1 vccd1 _6721_/A sky130_fd_sc_hd__a21oi_2
XANTENNA_fanout214_X _6397_/C vssd1 vssd1 vccd1 vccd1 sky130_fd_sc_hd__diode_2
X_8436_ clkload5/A _8436_/D wire362/X vssd1 vssd1 vccd1 vccd1 _8436_/Q sky130_fd_sc_hd__dfrtp_2
X_5648_ _5649_/A _5656_/A _5649_/C vssd1 vssd1 vccd1 vccd1 _5652_/A sky130_fd_sc_hd__o21ai_2
XANTENNA__4896__A1 _8425_/D vssd1 vssd1 vccd1 vccd1 sky130_fd_sc_hd__diode_2
X_8367_ _8369_/CLK _8367_/D fanout371/X vssd1 vssd1 vccd1 vccd1 _8367_/Q sky130_fd_sc_hd__dfrtp_2
X_5579_ _5842_/B _5594_/B _5579_/C vssd1 vssd1 vccd1 vccd1 _5582_/A sky130_fd_sc_hd__nand3_2
X_8298_ _6006_/A input5/X _8396_/D vssd1 vssd1 vccd1 vccd1 _8373_/D sky130_fd_sc_hd__mux2_1
X_7318_ _8417_/D _8418_/D wire64/X _7685_/B vssd1 vssd1 vccd1 vccd1 _7320_/A sky130_fd_sc_hd__and4_2
X_7249_ _8103_/A _7754_/B _7249_/C _8351_/Q vssd1 vssd1 vccd1 vccd1 _7251_/A sky130_fd_sc_hd__and4_2
XANTENNA_fanout74_A wire77/A vssd1 vssd1 vccd1 vccd1 sky130_fd_sc_hd__diode_2
XTAP_TAPCELL_ROW_5_254 vssd1 vccd1 sky130_fd_sc_hd__tapvpwrvgnd_1
XPHY_EDGE_ROW_37_Left_130 vssd1 vssd1 vccd1 vccd1 sky130_fd_sc_hd__decap_3
XFILLER_65_67 vssd1 vssd1 vccd1 vccd1 sky130_fd_sc_hd__fill_8
XFILLER_65_89 vssd1 vssd1 vccd1 vccd1 sky130_fd_sc_hd__fill_1
XFILLER_73_467 vssd1 vssd1 vccd1 vccd1 sky130_fd_sc_hd__fill_4
XTAP_TAPCELL_ROW_86_1059 vssd1 vccd1 sky130_fd_sc_hd__tapvpwrvgnd_1
XFILLER_60_139 vssd1 vssd1 vccd1 vccd1 sky130_fd_sc_hd__fill_1
XFILLER_41_353 vssd1 vssd1 vccd1 vccd1 sky130_fd_sc_hd__fill_1
XFILLER_14_93 vssd1 vssd1 vccd1 vccd1 sky130_fd_sc_hd__fill_1
XANTENNA__5814__A _6397_/C vssd1 vssd1 vccd1 vccd1 sky130_fd_sc_hd__diode_2
Xinput8 gpio_in[15] vssd1 vssd1 vccd1 vccd1 input8/X sky130_fd_sc_hd__buf_4
XFILLER_64_423 vssd1 vssd1 vccd1 vccd1 sky130_fd_sc_hd__fill_4
XFILLER_64_467 vssd1 vssd1 vccd1 vccd1 sky130_fd_sc_hd__fill_1
XTAP_TAPCELL_ROW_75_952 vssd1 vccd1 sky130_fd_sc_hd__tapvpwrvgnd_1
X_4950_ _4868_/A _4868_/B _4866_/Y vssd1 vssd1 vccd1 vccd1 _4952_/B sky130_fd_sc_hd__o21a_2
XTAP_TAPCELL_ROW_19_389 vssd1 vccd1 sky130_fd_sc_hd__tapvpwrvgnd_1
XFILLER_17_383 vssd1 vssd1 vccd1 vccd1 sky130_fd_sc_hd__fill_1
X_4881_ _4512_/A _4512_/B _4510_/X vssd1 vssd1 vccd1 vccd1 _4884_/A sky130_fd_sc_hd__a21o_2
XANTENNA__8071__S _8071_/S vssd1 vssd1 vccd1 vccd1 sky130_fd_sc_hd__diode_2
X_6620_ _6620_/A _6620_/B vssd1 vssd1 vccd1 vccd1 _6621_/B sky130_fd_sc_hd__xnor2_2
X_6551_ _6866_/A _6550_/B _6550_/C vssd1 vssd1 vccd1 vccd1 _6552_/B sky130_fd_sc_hd__a21o_2
X_5502_ _5502_/A _5513_/B vssd1 vssd1 vccd1 vccd1 _5504_/B sky130_fd_sc_hd__nor2_2
X_6482_ _6482_/A _6482_/B _8136_/C _6795_/D vssd1 vssd1 vccd1 vccd1 _6484_/A sky130_fd_sc_hd__and4_2
X_8221_ _8221_/A _8221_/B vssd1 vssd1 vccd1 vccd1 _8224_/A sky130_fd_sc_hd__nand2_2
X_5433_ _5829_/B _5433_/B vssd1 vssd1 vccd1 vccd1 _5435_/B sky130_fd_sc_hd__nor2_2
XANTENNA_rebuffer464_X _8436_/D vssd1 vssd1 vccd1 vccd1 sky130_fd_sc_hd__diode_2
X_8152_ _8152_/A _8152_/B vssd1 vssd1 vccd1 vccd1 _8153_/B sky130_fd_sc_hd__xnor2_2
X_5364_ _5365_/B _5365_/A vssd1 vssd1 vccd1 vccd1 _5412_/A sky130_fd_sc_hd__and2b_2
X_7103_ _7103_/A _8077_/B vssd1 vssd1 vccd1 vccd1 _7104_/B sky130_fd_sc_hd__nor2_2
X_4315_ _4649_/A _4919_/B vssd1 vssd1 vccd1 vccd1 _4407_/A sky130_fd_sc_hd__nand2_2
X_8083_ _8082_/B _8082_/C _8082_/D _8082_/A vssd1 vssd1 vccd1 vccd1 _8084_/B sky130_fd_sc_hd__o22a_2
X_5295_ _5295_/A _5295_/B _5295_/C vssd1 vssd1 vccd1 vccd1 _5295_/X sky130_fd_sc_hd__or3_2
X_7034_ _7034_/A _7034_/B vssd1 vssd1 vccd1 vccd1 _7035_/C sky130_fd_sc_hd__xnor2_2
X_4246_ _4246_/A _4342_/B vssd1 vssd1 vccd1 vccd1 _4292_/C sky130_fd_sc_hd__nor2_2
X_4177_ _4218_/S _8414_/Q _4176_/Y vssd1 vssd1 vccd1 vccd1 _4177_/Y sky130_fd_sc_hd__o21ai_2
XANTENNA_fanout376_A fanout379/X vssd1 vssd1 vccd1 vccd1 sky130_fd_sc_hd__diode_2
XFILLER_67_272 vssd1 vssd1 vccd1 vccd1 sky130_fd_sc_hd__fill_1
XTAP_TAPCELL_ROW_2_224 vssd1 vccd1 sky130_fd_sc_hd__tapvpwrvgnd_1
XFILLER_27_147 vssd1 vssd1 vccd1 vccd1 sky130_fd_sc_hd__fill_4
XFILLER_27_169 vssd1 vssd1 vccd1 vccd1 sky130_fd_sc_hd__fill_2
X_7936_ _7938_/A _7938_/B _7938_/C vssd1 vssd1 vccd1 vccd1 _7939_/A sky130_fd_sc_hd__a21oi_2
XFILLER_42_139 vssd1 vssd1 vccd1 vccd1 sky130_fd_sc_hd__fill_1
XFILLER_70_448 vssd1 vssd1 vccd1 vccd1 sky130_fd_sc_hd__fill_2
X_7867_ _7867_/A _7867_/B vssd1 vssd1 vccd1 vccd1 _7868_/B sky130_fd_sc_hd__or2_2
XANTENNA_fanout331_X _6217_/C vssd1 vssd1 vccd1 vccd1 sky130_fd_sc_hd__diode_2
X_6818_ _8125_/A _7140_/C vssd1 vssd1 vccd1 vccd1 _6819_/B sky130_fd_sc_hd__nand2_2
XANTENNA__5618__B _5669_/B vssd1 vssd1 vccd1 vccd1 sky130_fd_sc_hd__diode_2
X_7798_ _7798_/A _7798_/B vssd1 vssd1 vccd1 vccd1 _7799_/B sky130_fd_sc_hd__xnor2_2
XFILLER_11_559 vssd1 vssd1 vccd1 vccd1 sky130_fd_sc_hd__fill_1
XFILLER_7_519 vssd1 vssd1 vccd1 vccd1 sky130_fd_sc_hd__fill_4
X_6749_ _8416_/D wire59/X vssd1 vssd1 vccd1 vccd1 _6750_/B sky130_fd_sc_hd__nand2_2
X_8419_ clkload5/A _8419_/D wire364/X vssd1 vssd1 vccd1 vccd1 _8419_/Q sky130_fd_sc_hd__dfrtp_2
XFILLER_73_242 vssd1 vssd1 vccd1 vccd1 sky130_fd_sc_hd__fill_2
XTAP_TAPCELL_ROW_72_922 vssd1 vccd1 sky130_fd_sc_hd__tapvpwrvgnd_1
XFILLER_73_297 vssd1 vssd1 vccd1 vccd1 sky130_fd_sc_hd__fill_2
XFILLER_92_65 vssd1 vssd1 vccd1 vccd1 sky130_fd_sc_hd__fill_2
XTAP_TAPCELL_ROW_16_359 vssd1 vccd1 sky130_fd_sc_hd__tapvpwrvgnd_1
XANTENNA__5528__B _5657_/B vssd1 vssd1 vccd1 vccd1 sky130_fd_sc_hd__diode_2
XANTENNA_clkbuf_4_14_0_clk_X _8405_/CLK vssd1 vssd1 vccd1 vccd1 sky130_fd_sc_hd__diode_2
XANTENNA__8299__A1 input6/X vssd1 vssd1 vccd1 vccd1 sky130_fd_sc_hd__diode_2
XFILLER_44_5 vssd1 vssd1 vccd1 vccd1 sky130_fd_sc_hd__fill_1
X_5080_ _5084_/A _5084_/B _5076_/Y vssd1 vssd1 vccd1 vccd1 _5081_/B sky130_fd_sc_hd__a21o_2
XFILLER_2_41 vssd1 vssd1 vccd1 vccd1 sky130_fd_sc_hd__fill_4
XFILLER_2_85 vssd1 vssd1 vccd1 vccd1 sky130_fd_sc_hd__fill_1
XFILLER_49_272 vssd1 vssd1 vccd1 vccd1 sky130_fd_sc_hd__fill_1
XANTENNA__6094__B _6712_/B vssd1 vssd1 vccd1 vccd1 sky130_fd_sc_hd__diode_2
XFILLER_37_467 vssd1 vssd1 vccd1 vccd1 sky130_fd_sc_hd__fill_8
XFILLER_64_253 vssd1 vssd1 vccd1 vccd1 sky130_fd_sc_hd__fill_2
XFILLER_64_286 vssd1 vssd1 vccd1 vccd1 sky130_fd_sc_hd__fill_2
X_5982_ _6611_/A _7084_/B vssd1 vssd1 vccd1 vccd1 _5986_/A sky130_fd_sc_hd__nor2_2
XFILLER_24_139 vssd1 vssd1 vccd1 vccd1 sky130_fd_sc_hd__fill_1
X_7721_ _7721_/A _7721_/B vssd1 vssd1 vccd1 vccd1 _7728_/A sky130_fd_sc_hd__xnor2_2
X_4933_ _4976_/A _4933_/B vssd1 vssd1 vccd1 vccd1 _4934_/C sky130_fd_sc_hd__and2_2
X_7652_ _7652_/A _7652_/B _7652_/C vssd1 vssd1 vccd1 vccd1 _7654_/A sky130_fd_sc_hd__and3_2
X_4864_ _4864_/A _4864_/B vssd1 vssd1 vccd1 vccd1 _4867_/A sky130_fd_sc_hd__xnor2_2
X_7583_ _7583_/A _7788_/B vssd1 vssd1 vccd1 vccd1 _7585_/B sky130_fd_sc_hd__nor2_2
X_6603_ _6604_/B _6604_/A vssd1 vssd1 vccd1 vccd1 _6603_/X sky130_fd_sc_hd__and2b_2
X_4795_ _4795_/A _4795_/B vssd1 vssd1 vccd1 vccd1 _4796_/B sky130_fd_sc_hd__nor2_2
XANTENNA_fanout124_A _6724_/A vssd1 vssd1 vccd1 vccd1 sky130_fd_sc_hd__diode_2
X_6534_ _6859_/A _6534_/B vssd1 vssd1 vccd1 vccd1 _6534_/Y sky130_fd_sc_hd__nand2_2
X_6465_ _6559_/A vssd1 vssd1 vccd1 vccd1 _6465_/Y sky130_fd_sc_hd__inv_2
X_8204_ _8199_/A _8199_/B _8197_/B vssd1 vssd1 vccd1 vccd1 _8205_/B sky130_fd_sc_hd__o21a_2
X_5416_ _7120_/A _5826_/A vssd1 vssd1 vccd1 vccd1 _5420_/A sky130_fd_sc_hd__nand2_2
X_6396_ _6482_/A _8136_/C _8136_/D _6001_/A vssd1 vssd1 vccd1 vccd1 _6396_/Y sky130_fd_sc_hd__a22oi_2
X_8135_ _8136_/B _8135_/A2 _6795_/D _8136_/A vssd1 vssd1 vccd1 vccd1 _8138_/C sky130_fd_sc_hd__a22oi_2
X_5347_ _5348_/A _5461_/A _5348_/C vssd1 vssd1 vccd1 vccd1 _5349_/A sky130_fd_sc_hd__a21o_2
X_8066_ _8066_/A _8066_/B vssd1 vssd1 vccd1 vccd1 _8067_/B sky130_fd_sc_hd__nand2_2
X_5278_ _5278_/A _5278_/B vssd1 vssd1 vccd1 vccd1 _5278_/Y sky130_fd_sc_hd__xnor2_2
XANTENNA__5276__A1 _5267_/B vssd1 vssd1 vccd1 vccd1 sky130_fd_sc_hd__diode_2
X_7017_ _7017_/A _7017_/B vssd1 vssd1 vccd1 vccd1 _7019_/C sky130_fd_sc_hd__xor2_2
X_4229_ _8387_/Q _8446_/Q vssd1 vssd1 vccd1 vccd1 _4262_/B sky130_fd_sc_hd__nand2_2
XANTENNA_fanout281_X _8103_/D vssd1 vssd1 vccd1 vccd1 sky130_fd_sc_hd__diode_2
XANTENNA_fanout379_X fanout379/X vssd1 vssd1 vccd1 vccd1 sky130_fd_sc_hd__diode_2
XANTENNA__4517__B _4931_/C vssd1 vssd1 vccd1 vccd1 sky130_fd_sc_hd__diode_2
Xmax_cap37 _7512_/Y vssd1 vssd1 vccd1 vccd1 _7661_/A3 sky130_fd_sc_hd__clkbuf_2
XANTENNA__6435__D _7140_/C vssd1 vssd1 vccd1 vccd1 sky130_fd_sc_hd__diode_2
X_7919_ _7990_/A _8360_/Q vssd1 vssd1 vccd1 vccd1 _7920_/B sky130_fd_sc_hd__nand2_2
XTAP_TAPCELL_ROW_83_1029 vssd1 vccd1 sky130_fd_sc_hd__tapvpwrvgnd_1
XFILLER_11_323 vssd1 vssd1 vccd1 vccd1 sky130_fd_sc_hd__fill_1
XFILLER_62_68 vssd1 vssd1 vccd1 vccd1 sky130_fd_sc_hd__fill_1
XTAP_TAPCELL_ROW_13_329 vssd1 vccd1 sky130_fd_sc_hd__tapvpwrvgnd_1
XFILLER_11_345 vssd1 vssd1 vccd1 vccd1 sky130_fd_sc_hd__fill_1
XFILLER_3_533 vssd1 vssd1 vccd1 vccd1 sky130_fd_sc_hd__fill_2
XANTENNA__8411__RESET_B load_slew358/X vssd1 vssd1 vccd1 vccd1 sky130_fd_sc_hd__diode_2
XFILLER_87_10 vssd1 vssd1 vccd1 vccd1 sky130_fd_sc_hd__fill_8
XFILLER_87_76 vssd1 vssd1 vccd1 vccd1 sky130_fd_sc_hd__fill_2
XANTENNA_load_slew45_A _7080_/B vssd1 vssd1 vccd1 vccd1 sky130_fd_sc_hd__diode_2
XFILLER_16_9 vssd1 vssd1 vccd1 vccd1 sky130_fd_sc_hd__fill_1
Xfanout380 fanout382/X vssd1 vssd1 vccd1 vccd1 fanout380/X sky130_fd_sc_hd__clkdlybuf4s25_1
XANTENNA__7008__A2 _7007_/B vssd1 vssd1 vccd1 vccd1 sky130_fd_sc_hd__diode_2
XFILLER_46_253 vssd1 vssd1 vccd1 vccd1 sky130_fd_sc_hd__fill_4
XFILLER_46_264 vssd1 vssd1 vccd1 vccd1 sky130_fd_sc_hd__fill_1
XTAP_TAPCELL_ROW_57_771 vssd1 vccd1 sky130_fd_sc_hd__tapvpwrvgnd_1
XTAP_TAPCELL_ROW_29_495 vssd1 vccd1 sky130_fd_sc_hd__tapvpwrvgnd_1
XANTENNA__8393__CLK clkload7/A vssd1 vssd1 vccd1 vccd1 sky130_fd_sc_hd__diode_2
XANTENNA__7754__A _8103_/A vssd1 vssd1 vccd1 vccd1 sky130_fd_sc_hd__diode_2
Xinput11 gpio_in[1] vssd1 vssd1 vccd1 vccd1 _4224_/A sky130_fd_sc_hd__clkdlybuf4s25_1
X_4580_ _4580_/A _4631_/A vssd1 vssd1 vccd1 vccd1 _4581_/B sky130_fd_sc_hd__or2_2
XANTENNA__5274__A _5983_/A vssd1 vssd1 vccd1 vccd1 sky130_fd_sc_hd__diode_2
X_6250_ _6251_/A _6251_/B _6249_/Y vssd1 vssd1 vccd1 vccd1 _6458_/B sky130_fd_sc_hd__o21bai_2
XFILLER_69_301 vssd1 vssd1 vccd1 vccd1 sky130_fd_sc_hd__fill_2
X_6181_ _6367_/B _6181_/B vssd1 vssd1 vccd1 vccd1 _6183_/C sky130_fd_sc_hd__and2_2
X_5201_ _5201_/A1 _5200_/C _5200_/B vssd1 vssd1 vccd1 vccd1 _5202_/C sky130_fd_sc_hd__o21ai_2
X_5132_ _5132_/A _5739_/A vssd1 vssd1 vccd1 vccd1 _5134_/A sky130_fd_sc_hd__xnor2_2
X_5063_ _6631_/A _5267_/B vssd1 vssd1 vccd1 vccd1 _5064_/B sky130_fd_sc_hd__nor2_2
XFILLER_52_201 vssd1 vssd1 vccd1 vccd1 sky130_fd_sc_hd__fill_1
XFILLER_52_267 vssd1 vssd1 vccd1 vccd1 sky130_fd_sc_hd__fill_1
X_5965_ _5965_/A _5965_/B vssd1 vssd1 vccd1 vccd1 _5966_/B sky130_fd_sc_hd__or2_2
XANTENNA_fanout241_A _7998_/A vssd1 vssd1 vccd1 vccd1 sky130_fd_sc_hd__diode_2
X_7704_ _7643_/A _7643_/B _7642_/A vssd1 vssd1 vccd1 vccd1 _7705_/B sky130_fd_sc_hd__a21oi_2
X_5896_ _5896_/A _5896_/B _5896_/C vssd1 vssd1 vccd1 vccd1 _5897_/B sky130_fd_sc_hd__nor3_2
X_4916_ _4916_/A _4916_/B vssd1 vssd1 vccd1 vccd1 _4917_/B sky130_fd_sc_hd__xnor2_2
X_7635_ _7636_/A _7636_/B _7636_/C vssd1 vssd1 vccd1 vccd1 _7637_/A sky130_fd_sc_hd__a21oi_2
X_4847_ _4979_/A _4972_/B _4925_/C vssd1 vssd1 vccd1 vccd1 _4847_/X sky130_fd_sc_hd__and3_2
X_7566_ _7566_/A _7566_/B _7566_/C vssd1 vssd1 vccd1 vccd1 _7567_/B sky130_fd_sc_hd__nand3_2
X_4778_ _4779_/B vssd1 vssd1 vccd1 vccd1 _4862_/A sky130_fd_sc_hd__inv_2
XANTENNA__8132__B1 _8264_/A vssd1 vssd1 vccd1 vccd1 sky130_fd_sc_hd__diode_2
X_7497_ _7277_/B _7277_/C _7277_/A vssd1 vssd1 vccd1 vccd1 _7498_/B sky130_fd_sc_hd__a21bo_2
X_6517_ _6517_/A _6517_/B _8246_/A _6517_/D vssd1 vssd1 vccd1 vccd1 _6518_/B sky130_fd_sc_hd__and4_2
X_6448_ _6545_/A _6448_/B vssd1 vssd1 vccd1 vccd1 _6450_/B sky130_fd_sc_hd__nand2_2
X_6379_ _6379_/A _6379_/B vssd1 vssd1 vccd1 vccd1 _6380_/B sky130_fd_sc_hd__xnor2_2
X_8118_ _8118_/A _8118_/B vssd1 vssd1 vccd1 vccd1 _8145_/A sky130_fd_sc_hd__xnor2_2
X_8049_ _8050_/A _8050_/B _8050_/C vssd1 vssd1 vccd1 vccd1 _8051_/B sky130_fd_sc_hd__o21ai_2
XFILLER_87_197 vssd1 vssd1 vccd1 vccd1 sky130_fd_sc_hd__fill_8
Xwire90 wire90/A vssd1 vssd1 vccd1 vccd1 wire90/X sky130_fd_sc_hd__clkbuf_4
XTAP_TAPCELL_ROW_54_741 vssd1 vccd1 sky130_fd_sc_hd__tapvpwrvgnd_1
XFILLER_24_481 vssd1 vssd1 vccd1 vccd1 sky130_fd_sc_hd__fill_1
XFILLER_43_278 vssd1 vssd1 vccd1 vccd1 sky130_fd_sc_hd__fill_2
XFILLER_43_289 vssd1 vssd1 vccd1 vccd1 sky130_fd_sc_hd__fill_1
XTAP_TAPCELL_ROW_26_465 vssd1 vccd1 sky130_fd_sc_hd__tapvpwrvgnd_1
XFILLER_22_93 vssd1 vssd1 vccd1 vccd1 sky130_fd_sc_hd__fill_4
XANTENNA__6918__A _7889_/A vssd1 vssd1 vccd1 vccd1 sky130_fd_sc_hd__diode_2
XFILLER_39_507 vssd1 vssd1 vccd1 vccd1 sky130_fd_sc_hd__fill_1
XFILLER_78_197 vssd1 vssd1 vccd1 vccd1 sky130_fd_sc_hd__fill_1
XANTENNA__7749__A _7889_/A vssd1 vssd1 vccd1 vccd1 sky130_fd_sc_hd__diode_2
XANTENNA__7401__A2 _7296_/B vssd1 vssd1 vccd1 vccd1 sky130_fd_sc_hd__diode_2
XANTENNA__7468__B _7877_/B vssd1 vssd1 vccd1 vccd1 sky130_fd_sc_hd__diode_2
XFILLER_62_565 vssd1 vssd1 vccd1 vccd1 sky130_fd_sc_hd__fill_4
X_5750_ _5750_/A _5750_/B vssd1 vssd1 vccd1 vccd1 _5752_/C sky130_fd_sc_hd__xnor2_2
X_5681_ _5593_/A _5593_/B _5601_/A vssd1 vssd1 vccd1 vccd1 _5682_/B sky130_fd_sc_hd__o21bai_2
X_4701_ _4701_/A _4701_/B vssd1 vssd1 vccd1 vccd1 _4701_/X sky130_fd_sc_hd__or2_2
X_7420_ _7421_/B _7421_/A vssd1 vssd1 vccd1 vccd1 _7652_/A sky130_fd_sc_hd__nand2b_2
X_4632_ _8422_/D _6114_/B vssd1 vssd1 vccd1 vccd1 _4633_/B sky130_fd_sc_hd__nand2_2
XTAP_TAPCELL_ROW_60_799 vssd1 vccd1 sky130_fd_sc_hd__tapvpwrvgnd_1
X_7351_ _7351_/A _7351_/B vssd1 vssd1 vccd1 vccd1 _7352_/C sky130_fd_sc_hd__xnor2_2
X_4563_ _4623_/A _4598_/B vssd1 vssd1 vccd1 vccd1 _4564_/B sky130_fd_sc_hd__nand2_2
X_7282_ _7503_/A _7282_/B vssd1 vssd1 vccd1 vccd1 _7282_/X sky130_fd_sc_hd__or2_2
X_6302_ _6302_/A _6302_/B vssd1 vssd1 vccd1 vccd1 _6304_/A sky130_fd_sc_hd__nor2_2
X_4494_ _4772_/A _4770_/B vssd1 vssd1 vccd1 vccd1 _4499_/A sky130_fd_sc_hd__nor2_2
XFILLER_89_418 vssd1 vssd1 vccd1 vccd1 sky130_fd_sc_hd__fill_2
X_6233_ _6517_/A _8233_/A _8241_/A _6517_/B vssd1 vssd1 vccd1 vccd1 _6235_/A sky130_fd_sc_hd__a22oi_2
XANTENNA__4151__A1 input4/X vssd1 vssd1 vccd1 vccd1 sky130_fd_sc_hd__diode_2
Xteam_03_408 vssd1 vssd1 vccd1 vccd1 team_03_408/HI gpio_out[5] sky130_fd_sc_hd__conb_1
Xteam_03_419 vssd1 vssd1 vccd1 vccd1 team_03_419/HI gpio_out[16] sky130_fd_sc_hd__conb_1
X_6164_ _6164_/A _6164_/B vssd1 vssd1 vccd1 vccd1 _6185_/A sky130_fd_sc_hd__xnor2_2
XANTENNA_fanout191_A _4207_/B vssd1 vssd1 vccd1 vccd1 sky130_fd_sc_hd__diode_2
X_6095_ _6095_/A _6095_/B vssd1 vssd1 vccd1 vccd1 _6097_/C sky130_fd_sc_hd__xnor2_2
X_5115_ _5115_/A _5115_/B vssd1 vssd1 vccd1 vccd1 _5116_/A sky130_fd_sc_hd__xnor2_2
XANTENNA_fanout289_A _8266_/A vssd1 vssd1 vccd1 vccd1 sky130_fd_sc_hd__diode_2
XFILLER_38_540 vssd1 vssd1 vccd1 vccd1 sky130_fd_sc_hd__fill_1
X_5046_ _5046_/A _5119_/A vssd1 vssd1 vccd1 vccd1 _5046_/Y sky130_fd_sc_hd__nor2_2
XFILLER_72_307 vssd1 vssd1 vccd1 vccd1 sky130_fd_sc_hd__fill_1
XTAP_TAPCELL_ROW_68_877 vssd1 vccd1 sky130_fd_sc_hd__tapvpwrvgnd_1
X_6997_ _8415_/D _6997_/B vssd1 vssd1 vccd1 vccd1 _6997_/Y sky130_fd_sc_hd__nand2_2
XANTENNA_fanout244_X _7998_/A vssd1 vssd1 vccd1 vccd1 sky130_fd_sc_hd__diode_2
X_5948_ _8433_/D _6704_/B vssd1 vssd1 vccd1 vccd1 _6108_/A sky130_fd_sc_hd__and2_2
XTAP_TAPCELL_ROW_51_711 vssd1 vccd1 sky130_fd_sc_hd__tapvpwrvgnd_1
XTAP_TAPCELL_ROW_23_435 vssd1 vccd1 sky130_fd_sc_hd__tapvpwrvgnd_1
X_5879_ _5879_/A _5879_/B vssd1 vssd1 vccd1 vccd1 _5881_/A sky130_fd_sc_hd__and2_2
X_7618_ _7618_/A _7618_/B vssd1 vssd1 vccd1 vccd1 _7619_/B sky130_fd_sc_hd__xnor2_2
X_7549_ _7889_/A _8125_/B _7897_/B _7889_/B vssd1 vssd1 vccd1 vccd1 _7551_/A sky130_fd_sc_hd__a22oi_2
XTAP_TAPCELL_ROW_91_1106 vssd1 vccd1 sky130_fd_sc_hd__tapvpwrvgnd_1
XFILLER_0_322 vssd1 vssd1 vccd1 vccd1 sky130_fd_sc_hd__fill_1
XFILLER_68_56 vssd1 vssd1 vccd1 vccd1 sky130_fd_sc_hd__fill_2
XANTENNA_input17_A gpio_in[7] vssd1 vssd1 vccd1 vccd1 sky130_fd_sc_hd__diode_2
XFILLER_63_307 vssd1 vssd1 vccd1 vccd1 sky130_fd_sc_hd__fill_4
XFILLER_75_178 vssd1 vssd1 vccd1 vccd1 sky130_fd_sc_hd__fill_1
XFILLER_84_33 vssd1 vssd1 vccd1 vccd1 sky130_fd_sc_hd__fill_1
XFILLER_90_115 vssd1 vssd1 vccd1 vccd1 sky130_fd_sc_hd__fill_2
XTAP_TAPCELL_ROW_39_590 vssd1 vccd1 sky130_fd_sc_hd__tapvpwrvgnd_1
XFILLER_71_362 vssd1 vssd1 vccd1 vccd1 sky130_fd_sc_hd__fill_1
XANTENNA__6920__B _7877_/B vssd1 vssd1 vccd1 vccd1 sky130_fd_sc_hd__diode_2
XFILLER_8_477 vssd1 vccd1 vssd1 vccd1 sky130_ef_sc_hd__decap_40_12
XANTENNA__8431__CLK clkload4/A vssd1 vssd1 vccd1 vccd1 sky130_fd_sc_hd__diode_2
XFILLER_79_451 vssd1 vssd1 vccd1 vccd1 sky130_fd_sc_hd__fill_1
XFILLER_66_101 vssd1 vssd1 vccd1 vccd1 sky130_fd_sc_hd__fill_4
XFILLER_35_521 vssd1 vssd1 vccd1 vccd1 sky130_fd_sc_hd__fill_2
X_6920_ _8110_/B _7877_/B vssd1 vssd1 vccd1 vccd1 _6921_/B sky130_fd_sc_hd__nand2_2
XTAP_TAPCELL_ROW_65_847 vssd1 vccd1 sky130_fd_sc_hd__tapvpwrvgnd_1
XFILLER_81_159 vssd1 vssd1 vccd1 vccd1 sky130_fd_sc_hd__fill_2
X_6851_ _6852_/A _6852_/B vssd1 vssd1 vccd1 vccd1 _6854_/A sky130_fd_sc_hd__nor2_2
XANTENNA__8371__Q _8371_/Q vssd1 vssd1 vccd1 vccd1 sky130_fd_sc_hd__diode_2
X_5802_ _5803_/A _5803_/B vssd1 vssd1 vccd1 vccd1 _5993_/A sky130_fd_sc_hd__nand2_2
XFILLER_62_395 vssd1 vssd1 vccd1 vccd1 sky130_fd_sc_hd__fill_1
X_6782_ _6669_/A _6668_/B _6668_/A vssd1 vssd1 vccd1 vccd1 _6784_/B sky130_fd_sc_hd__o21bai_2
XANTENNA__5727__A _6091_/A vssd1 vssd1 vccd1 vccd1 sky130_fd_sc_hd__diode_2
XANTENNA__6830__B _6830_/B vssd1 vssd1 vccd1 vccd1 sky130_fd_sc_hd__diode_2
X_5733_ _5733_/A _5733_/B vssd1 vssd1 vccd1 vccd1 _5736_/A sky130_fd_sc_hd__xor2_2
XTAP_TAPCELL_ROW_20_405 vssd1 vccd1 sky130_fd_sc_hd__tapvpwrvgnd_1
XANTENNA__8103__A _8103_/A vssd1 vssd1 vccd1 vccd1 sky130_fd_sc_hd__diode_2
X_8452_ clkload3/A _8452_/D fanout372/A vssd1 vssd1 vccd1 vccd1 _8452_/Q sky130_fd_sc_hd__dfrtp_2
X_5664_ _5664_/A _5664_/B vssd1 vssd1 vccd1 vccd1 _5664_/Y sky130_fd_sc_hd__nor2_2
XANTENNA__5446__B _6006_/A vssd1 vssd1 vccd1 vccd1 sky130_fd_sc_hd__diode_2
X_8383_ clkload2/A _8383_/D wire368/X vssd1 vssd1 vccd1 vccd1 _8383_/Q sky130_fd_sc_hd__dfrtp_2
X_7403_ _7603_/A _7966_/B vssd1 vssd1 vccd1 vccd1 _7405_/B sky130_fd_sc_hd__nor2_2
X_5595_ _5618_/A _6433_/A _5529_/A _5527_/B vssd1 vssd1 vccd1 vccd1 _5597_/B sky130_fd_sc_hd__a31o_2
X_4615_ _4607_/A _4607_/B _4609_/Y vssd1 vssd1 vccd1 vccd1 _4641_/B sky130_fd_sc_hd__a21oi_2
X_7334_ _7335_/A _7335_/B _7335_/C vssd1 vssd1 vccd1 vccd1 _7336_/B sky130_fd_sc_hd__a21oi_2
X_4546_ _4546_/A _4546_/B vssd1 vssd1 vccd1 vccd1 _4551_/B sky130_fd_sc_hd__xnor2_2
X_7265_ _7489_/B _7265_/B vssd1 vssd1 vccd1 vccd1 _7267_/B sky130_fd_sc_hd__nand2_2
X_4477_ _4477_/A _4477_/B vssd1 vssd1 vccd1 vccd1 _4478_/B sky130_fd_sc_hd__xnor2_2
X_7196_ _7196_/A _7196_/B vssd1 vssd1 vccd1 vccd1 _7198_/C sky130_fd_sc_hd__xnor2_2
X_6216_ _6018_/B _6020_/B _6018_/A vssd1 vssd1 vccd1 vccd1 _6226_/A sky130_fd_sc_hd__o21ba_2
XANTENNA_input9_A gpio_in[16] vssd1 vssd1 vccd1 vccd1 sky130_fd_sc_hd__diode_2
X_6147_ _6970_/A _5195_/Y _6338_/A _6146_/X vssd1 vssd1 vccd1 vccd1 _6150_/A sky130_fd_sc_hd__a31o_2
XANTENNA_fanout194_X _4223_/B vssd1 vssd1 vccd1 vccd1 sky130_fd_sc_hd__diode_2
XANTENNA__6564__Y _6685_/A vssd1 vssd1 vccd1 vccd1 sky130_fd_sc_hd__diode_2
XANTENNA__7389__A _7969_/A vssd1 vssd1 vccd1 vccd1 sky130_fd_sc_hd__diode_2
XFILLER_57_178 vssd1 vssd1 vccd1 vccd1 sky130_fd_sc_hd__fill_2
XFILLER_85_487 vssd1 vssd1 vccd1 vccd1 sky130_fd_sc_hd__fill_2
X_6078_ _6078_/A _6078_/B vssd1 vssd1 vccd1 vccd1 _6080_/A sky130_fd_sc_hd__xnor2_2
XANTENNA_fanout361_X wire362/A vssd1 vssd1 vccd1 vccd1 sky130_fd_sc_hd__diode_2
X_5029_ _5029_/A _5029_/B vssd1 vssd1 vccd1 vccd1 _5031_/B sky130_fd_sc_hd__nor2_2
XANTENNA__6724__C _7299_/C vssd1 vssd1 vccd1 vccd1 sky130_fd_sc_hd__diode_2
XTAP_TAPCELL_ROW_36_560 vssd1 vccd1 sky130_fd_sc_hd__tapvpwrvgnd_1
XTAP_TAPCELL_ROW_0_196 vssd1 vccd1 sky130_fd_sc_hd__tapvpwrvgnd_1
XANTENNA__6740__B _7007_/B vssd1 vssd1 vccd1 vccd1 sky130_fd_sc_hd__diode_2
XFILLER_41_568 vssd1 vssd1 vccd1 vccd1 sky130_fd_sc_hd__fill_2
XFILLER_70_35 vssd1 vssd1 vccd1 vccd1 sky130_fd_sc_hd__fill_1
XFILLER_5_447 vssd1 vssd1 vccd1 vccd1 sky130_fd_sc_hd__fill_1
XFILLER_79_55 vssd1 vssd1 vccd1 vccd1 sky130_fd_sc_hd__fill_1
XANTENNA__5091__B _5902_/B vssd1 vssd1 vccd1 vccd1 sky130_fd_sc_hd__diode_2
XTAP_TAPCELL_ROW_8_285 vssd1 vccd1 sky130_fd_sc_hd__tapvpwrvgnd_1
XANTENNA__7299__A _7299_/A vssd1 vssd1 vccd1 vccd1 sky130_fd_sc_hd__diode_2
XFILLER_28_70 vssd1 vssd1 vccd1 vccd1 sky130_fd_sc_hd__fill_1
XFILLER_17_532 vssd1 vssd1 vccd1 vccd1 sky130_fd_sc_hd__fill_4
XTAP_TAPCELL_ROW_62_817 vssd1 vccd1 sky130_fd_sc_hd__tapvpwrvgnd_1
XFILLER_44_80 vssd1 vssd1 vccd1 vccd1 sky130_fd_sc_hd__fill_4
XANTENNA__7465__C _7875_/C vssd1 vssd1 vccd1 vccd1 sky130_fd_sc_hd__diode_2
XANTENNA__4170__B _4227_/S vssd1 vssd1 vccd1 vccd1 sky130_fd_sc_hd__diode_2
XFILLER_8_285 vssd1 vssd1 vccd1 vccd1 sky130_fd_sc_hd__fill_1
X_4400_ _4557_/A _4654_/C _4339_/C vssd1 vssd1 vccd1 vccd1 _4401_/B sky130_fd_sc_hd__a21oi_2
X_5380_ _5380_/A _5451_/A _5380_/C vssd1 vssd1 vccd1 vccd1 _5381_/B sky130_fd_sc_hd__and3_2
X_4331_ _4902_/A _5149_/B vssd1 vssd1 vccd1 vccd1 _4332_/B sky130_fd_sc_hd__and2_2
Xfanout209 _8135_/A2 vssd1 vssd1 vccd1 vccd1 _7714_/C sky130_fd_sc_hd__clkdlybuf4s25_1
X_7050_ _7685_/A wire72/X vssd1 vssd1 vccd1 vccd1 _7051_/B sky130_fd_sc_hd__nand2_2
X_4262_ _4262_/A _4262_/B _4262_/C vssd1 vssd1 vccd1 vccd1 _4265_/B sky130_fd_sc_hd__and3_2
XANTENNA_load_slew112_X _4972_/B vssd1 vssd1 vccd1 vccd1 sky130_fd_sc_hd__diode_2
X_6001_ _6001_/A _8136_/C vssd1 vssd1 vccd1 vccd1 _6395_/C sky130_fd_sc_hd__and2_2
X_4193_ _4198_/B _8408_/Q _4192_/Y vssd1 vssd1 vccd1 vccd1 _7103_/A sky130_fd_sc_hd__o21ai_2
XANTENNA__8327__CLK _8405_/CLK vssd1 vssd1 vccd1 vccd1 sky130_fd_sc_hd__diode_2
XFILLER_39_145 vssd1 vssd1 vccd1 vccd1 sky130_fd_sc_hd__fill_1
XFILLER_39_167 vssd1 vssd1 vccd1 vccd1 sky130_fd_sc_hd__fill_1
XFILLER_54_126 vssd1 vssd1 vccd1 vccd1 sky130_fd_sc_hd__fill_1
X_7952_ _7952_/A _7952_/B _7952_/C vssd1 vssd1 vccd1 vccd1 _7953_/B sky130_fd_sc_hd__and3_2
XTAP_TAPCELL_ROW_78_983 vssd1 vccd1 sky130_fd_sc_hd__tapvpwrvgnd_1
XFILLER_82_446 vssd1 vssd1 vccd1 vccd1 sky130_fd_sc_hd__fill_8
X_6903_ _7140_/A _7140_/B _6903_/C _7140_/C vssd1 vssd1 vccd1 vccd1 _6905_/A sky130_fd_sc_hd__and4_2
X_7883_ _7883_/A _7883_/B _7883_/C vssd1 vssd1 vccd1 vccd1 _7885_/A sky130_fd_sc_hd__and3_2
XANTENNA_fanout154_A _6723_/A vssd1 vssd1 vccd1 vccd1 sky130_fd_sc_hd__diode_2
X_6834_ _7895_/A _7998_/B _7723_/C _7723_/D vssd1 vssd1 vccd1 vccd1 _6836_/A sky130_fd_sc_hd__and4_2
XTAP_TAPCELL_ROW_33_530 vssd1 vccd1 sky130_fd_sc_hd__tapvpwrvgnd_1
X_6765_ _6764_/A _6764_/B _6764_/C vssd1 vssd1 vccd1 vccd1 _6765_/X sky130_fd_sc_hd__o21a_2
XANTENNA_fanout321_A _8343_/Q vssd1 vssd1 vccd1 vccd1 sky130_fd_sc_hd__diode_2
X_5716_ _5717_/A _5717_/B vssd1 vssd1 vccd1 vccd1 _5964_/B sky130_fd_sc_hd__nand2_2
X_8435_ clkload4/A _8435_/D wire362/X vssd1 vssd1 vccd1 vccd1 _8435_/Q sky130_fd_sc_hd__dfrtp_2
X_6696_ _6696_/A _7299_/B vssd1 vssd1 vccd1 vccd1 _6722_/A sky130_fd_sc_hd__nand2_2
X_5647_ _5647_/A _5669_/B vssd1 vssd1 vccd1 vccd1 _5649_/C sky130_fd_sc_hd__and2_2
X_8366_ _8369_/CLK _8366_/D fanout371/X vssd1 vssd1 vccd1 vccd1 _8366_/Q sky130_fd_sc_hd__dfrtp_2
X_5578_ _5622_/A _5578_/B vssd1 vssd1 vccd1 vccd1 _5579_/C sky130_fd_sc_hd__xnor2_2
X_8297_ _6016_/A input4/X _8396_/D vssd1 vssd1 vccd1 vccd1 _8372_/D sky130_fd_sc_hd__mux2_1
X_7317_ _7317_/A _7317_/B vssd1 vssd1 vccd1 vccd1 _7340_/A sky130_fd_sc_hd__xnor2_2
X_4529_ _4553_/A _4553_/B vssd1 vssd1 vccd1 vccd1 _4554_/B sky130_fd_sc_hd__nor2_2
X_7248_ _7248_/A _7248_/B vssd1 vssd1 vccd1 vccd1 _7258_/A sky130_fd_sc_hd__xnor2_2
X_7179_ _7179_/A _7179_/B _7179_/C vssd1 vssd1 vccd1 vccd1 _7281_/A sky130_fd_sc_hd__or3_2
XTAP_TAPCELL_ROW_5_255 vssd1 vccd1 sky130_fd_sc_hd__tapvpwrvgnd_1
XFILLER_45_148 vssd1 vssd1 vccd1 vccd1 sky130_fd_sc_hd__fill_1
XANTENNA__8436__RESET_B wire362/X vssd1 vssd1 vccd1 vccd1 sky130_fd_sc_hd__diode_2
XFILLER_14_513 vssd1 vssd1 vccd1 vccd1 sky130_fd_sc_hd__fill_1
XANTENNA__5367__A _6035_/C vssd1 vssd1 vccd1 vccd1 sky130_fd_sc_hd__diode_2
XANTENNA__5086__B _5267_/B vssd1 vssd1 vccd1 vccd1 sky130_fd_sc_hd__diode_2
XANTENNA__7582__A _8121_/A vssd1 vssd1 vccd1 vccd1 sky130_fd_sc_hd__diode_2
XANTENNA__5814__B _6198_/A vssd1 vssd1 vccd1 vccd1 sky130_fd_sc_hd__diode_2
XANTENNA__6198__A _6198_/A vssd1 vssd1 vccd1 vccd1 sky130_fd_sc_hd__diode_2
XFILLER_64_435 vssd1 vssd1 vccd1 vccd1 sky130_fd_sc_hd__fill_1
Xinput9 gpio_in[16] vssd1 vssd1 vccd1 vccd1 input9/X sky130_fd_sc_hd__buf_4
XANTENNA__6261__A1 _6460_/A vssd1 vssd1 vccd1 vccd1 sky130_fd_sc_hd__diode_2
XFILLER_36_159 vssd1 vssd1 vccd1 vccd1 sky130_fd_sc_hd__fill_1
XFILLER_64_457 vssd1 vssd1 vccd1 vccd1 sky130_fd_sc_hd__fill_4
XTAP_TAPCELL_ROW_75_953 vssd1 vccd1 sky130_fd_sc_hd__tapvpwrvgnd_1
XTAP_TAPCELL_ROW_47_666 vssd1 vccd1 sky130_fd_sc_hd__tapvpwrvgnd_1
X_4880_ _4878_/Y _4880_/B vssd1 vssd1 vccd1 vccd1 _4887_/A sky130_fd_sc_hd__nand2b_2
X_6550_ _6866_/A _6550_/B _6550_/C vssd1 vssd1 vccd1 vccd1 _6866_/B sky130_fd_sc_hd__nand3_2
XTAP_TAPCELL_ROW_30_500 vssd1 vccd1 sky130_fd_sc_hd__tapvpwrvgnd_1
X_5501_ _5501_/A _5501_/B vssd1 vssd1 vccd1 vccd1 _5513_/B sky130_fd_sc_hd__and2_2
XANTENNA__7492__A _7990_/A vssd1 vssd1 vccd1 vccd1 sky130_fd_sc_hd__diode_2
X_6481_ _6689_/A hold539/X _6480_/X vssd1 vssd1 vccd1 vccd1 _8323_/D sky130_fd_sc_hd__a21bo_2
XFILLER_10_19 vssd1 vssd1 vccd1 vccd1 sky130_fd_sc_hd__fill_1
X_8220_ _8220_/A input5/X vssd1 vssd1 vccd1 vccd1 _8221_/B sky130_fd_sc_hd__nand2_2
X_5432_ _5432_/A _5432_/B vssd1 vssd1 vccd1 vccd1 _5433_/B sky130_fd_sc_hd__and2_2
X_8151_ _8151_/A _8151_/B vssd1 vssd1 vccd1 vccd1 _8152_/B sky130_fd_sc_hd__xnor2_2
X_5363_ _5313_/A _5312_/B _5312_/A vssd1 vssd1 vccd1 vccd1 _5365_/B sky130_fd_sc_hd__o21ba_2
X_7102_ _7102_/A _7102_/B vssd1 vssd1 vccd1 vccd1 _7104_/A sky130_fd_sc_hd__xor2_2
X_4314_ _4314_/A _4314_/B vssd1 vssd1 vccd1 vccd1 _4608_/B sky130_fd_sc_hd__xnor2_2
XFILLER_87_505 vssd1 vccd1 vssd1 vccd1 sky130_ef_sc_hd__decap_40_12
X_8082_ _8082_/A _8082_/B _8082_/C _8082_/D vssd1 vssd1 vccd1 vccd1 _8084_/A sky130_fd_sc_hd__nor4_2
X_5294_ _5296_/A _5296_/B vssd1 vssd1 vccd1 vccd1 _5295_/C sky130_fd_sc_hd__nor2_2
X_7033_ _7033_/A _7033_/B vssd1 vssd1 vccd1 vccd1 _7034_/B sky130_fd_sc_hd__xor2_2
X_4245_ _8383_/Q _8442_/Q vssd1 vssd1 vccd1 vccd1 _4342_/B sky130_fd_sc_hd__and2_2
X_4176_ input3/X _4207_/B vssd1 vssd1 vccd1 vccd1 _4176_/Y sky130_fd_sc_hd__nand2b_2
XANTENNA__4356__A _8429_/D vssd1 vssd1 vccd1 vccd1 sky130_fd_sc_hd__diode_2
XANTENNA_fanout271_A _6832_/A vssd1 vssd1 vccd1 vccd1 sky130_fd_sc_hd__diode_2
XFILLER_82_210 vssd1 vssd1 vccd1 vccd1 sky130_fd_sc_hd__fill_8
XTAP_TAPCELL_ROW_2_225 vssd1 vccd1 sky130_fd_sc_hd__tapvpwrvgnd_1
XANTENNA_fanout369_A fanout379/X vssd1 vssd1 vccd1 vccd1 sky130_fd_sc_hd__diode_2
X_7935_ _8062_/B _7935_/B vssd1 vssd1 vccd1 vccd1 _7938_/C sky130_fd_sc_hd__nor2_2
XANTENNA__6004__A1 _6207_/A vssd1 vssd1 vccd1 vccd1 sky130_fd_sc_hd__diode_2
XFILLER_70_438 vssd1 vssd1 vccd1 vccd1 sky130_fd_sc_hd__fill_2
X_7866_ _7867_/A _7867_/B vssd1 vssd1 vccd1 vccd1 _8040_/B sky130_fd_sc_hd__nand2_2
XANTENNA__6004__B2 _6005_/B vssd1 vssd1 vccd1 vccd1 sky130_fd_sc_hd__diode_2
XFILLER_11_505 vssd1 vssd1 vccd1 vccd1 sky130_fd_sc_hd__fill_4
X_6817_ _6817_/A _6817_/B vssd1 vssd1 vccd1 vccd1 _6819_/A sky130_fd_sc_hd__nor2_2
X_7797_ _7798_/A _7798_/B vssd1 vssd1 vccd1 vccd1 _7797_/X sky130_fd_sc_hd__and2b_2
XANTENNA_fanout324_X _8202_/A vssd1 vssd1 vccd1 vccd1 sky130_fd_sc_hd__diode_2
X_6748_ _6748_/A _6748_/B vssd1 vssd1 vccd1 vccd1 _6750_/A sky130_fd_sc_hd__xor2_2
X_6679_ _6678_/A _6678_/B _6678_/C vssd1 vssd1 vccd1 vccd1 _6681_/B sky130_fd_sc_hd__a21o_2
X_8418_ clkload5/A _8418_/D wire364/X vssd1 vssd1 vccd1 vccd1 _8418_/Q sky130_fd_sc_hd__dfrtp_2
X_8349_ clkload8/A _8349_/D wire377/X vssd1 vssd1 vccd1 vccd1 _8349_/Q sky130_fd_sc_hd__dfrtp_2
XFILLER_78_527 vssd1 vssd1 vccd1 vccd1 sky130_fd_sc_hd__fill_4
XFILLER_76_45 vssd1 vssd1 vccd1 vccd1 sky130_fd_sc_hd__fill_8
XFILLER_18_148 vssd1 vssd1 vccd1 vccd1 sky130_fd_sc_hd__fill_1
XFILLER_46_479 vssd1 vssd1 vccd1 vccd1 sky130_fd_sc_hd__fill_1
XFILLER_73_276 vssd1 vssd1 vccd1 vccd1 sky130_fd_sc_hd__fill_4
XTAP_TAPCELL_ROW_72_923 vssd1 vccd1 sky130_fd_sc_hd__tapvpwrvgnd_1
XFILLER_61_449 vssd1 vssd1 vccd1 vccd1 sky130_fd_sc_hd__fill_2
XTAP_TAPCELL_ROW_44_636 vssd1 vccd1 sky130_fd_sc_hd__tapvpwrvgnd_1
XANTENNA__7296__B _7296_/B vssd1 vssd1 vccd1 vccd1 sky130_fd_sc_hd__diode_2
XFILLER_41_151 vssd1 vssd1 vccd1 vccd1 sky130_fd_sc_hd__fill_1
Xclkbuf_4_6_0_clk clkbuf_0_clk/X vssd1 vssd1 vccd1 vccd1 clkload6/A sky130_fd_sc_hd__clkbuf_8
XANTENNA__8201__A _8202_/A vssd1 vssd1 vccd1 vccd1 sky130_fd_sc_hd__diode_2
XFILLER_6_531 vssd1 vssd1 vccd1 vccd1 sky130_fd_sc_hd__fill_1
XANTENNA__8358__RESET_B load_slew384/X vssd1 vssd1 vccd1 vccd1 sky130_fd_sc_hd__diode_2
XPHY_EDGE_ROW_10_Right_10 vssd1 vssd1 vccd1 vccd1 sky130_fd_sc_hd__decap_3
X_5981_ _6337_/B _6337_/C vssd1 vssd1 vccd1 vccd1 _5981_/Y sky130_fd_sc_hd__nand2_2
XPHY_EDGE_ROW_56_Left_149 vssd1 vssd1 vccd1 vccd1 sky130_fd_sc_hd__decap_3
X_7720_ _7721_/B _7721_/A vssd1 vssd1 vccd1 vccd1 _7870_/A sky130_fd_sc_hd__nand2b_2
X_4932_ _5163_/A _4931_/D _4838_/B vssd1 vssd1 vccd1 vccd1 _4933_/B sky130_fd_sc_hd__a21bo_2
XANTENNA__4182__Y _7095_/A vssd1 vssd1 vccd1 vccd1 sky130_fd_sc_hd__diode_2
X_7651_ _7649_/Y _7651_/B vssd1 vssd1 vccd1 vccd1 _7652_/C sky130_fd_sc_hd__and2b_2
XFILLER_60_460 vssd1 vssd1 vccd1 vccd1 sky130_fd_sc_hd__fill_4
X_6602_ _6324_/A _6324_/B _6322_/X vssd1 vssd1 vccd1 vccd1 _6604_/B sky130_fd_sc_hd__o21a_2
X_4863_ _4863_/A _4863_/B vssd1 vssd1 vccd1 vccd1 _4864_/B sky130_fd_sc_hd__xor2_2
X_7582_ _8121_/A _8277_/A _7582_/C vssd1 vssd1 vccd1 vccd1 _7788_/B sky130_fd_sc_hd__and3_2
X_4794_ _4795_/A _4795_/B vssd1 vssd1 vccd1 vccd1 _4796_/A sky130_fd_sc_hd__and2_2
X_6533_ _6533_/A _6533_/B _6533_/C vssd1 vssd1 vccd1 vccd1 _6534_/B sky130_fd_sc_hd__nand3_2
X_6464_ _6264_/A _6265_/A _6553_/B _6463_/X vssd1 vssd1 vccd1 vccd1 _6559_/A sky130_fd_sc_hd__o211a_2
X_8203_ _8201_/Y _8203_/B vssd1 vssd1 vccd1 vccd1 _8205_/A sky130_fd_sc_hd__and2b_2
X_5415_ _5446_/A _5415_/B _6005_/B _6006_/A vssd1 vssd1 vccd1 vccd1 _5438_/A sky130_fd_sc_hd__nand4_2
XPHY_EDGE_ROW_65_Left_158 vssd1 vssd1 vccd1 vccd1 sky130_fd_sc_hd__decap_3
X_6395_ _6482_/A _8136_/D _6395_/C vssd1 vssd1 vccd1 vccd1 _6488_/A sky130_fd_sc_hd__and3_2
X_8134_ _8134_/A _8134_/B vssd1 vssd1 vccd1 vccd1 _8140_/A sky130_fd_sc_hd__nor2_2
X_5346_ _5324_/A _5323_/B _5323_/A vssd1 vssd1 vccd1 vccd1 _5348_/C sky130_fd_sc_hd__o21ba_2
X_8065_ _8066_/B _8066_/A vssd1 vssd1 vccd1 vccd1 _8065_/Y sky130_fd_sc_hd__nor2_2
X_5277_ _5273_/A _5273_/B _5275_/Y _5267_/B _6611_/A vssd1 vssd1 vccd1 vccd1 _5277_/X
+ sky130_fd_sc_hd__a221o_2
X_7016_ _7016_/A _7016_/B vssd1 vssd1 vccd1 vccd1 _7017_/B sky130_fd_sc_hd__nand2_2
X_4228_ _8388_/Q _8447_/Q vssd1 vssd1 vccd1 vccd1 _4262_/A sky130_fd_sc_hd__xnor2_2
XFILLER_28_413 vssd1 vssd1 vccd1 vccd1 sky130_fd_sc_hd__fill_1
XANTENNA_fanout274_X _5669_/B vssd1 vssd1 vccd1 vccd1 sky130_fd_sc_hd__diode_2
XFILLER_46_37 vssd1 vssd1 vccd1 vccd1 sky130_fd_sc_hd__fill_1
X_4159_ _8428_/Q _8196_/B _4227_/S vssd1 vssd1 vccd1 vccd1 _4159_/X sky130_fd_sc_hd__mux2_4
XPHY_EDGE_ROW_74_Left_167 vssd1 vssd1 vccd1 vccd1 sky130_fd_sc_hd__decap_3
Xmax_cap38 _7203_/A vssd1 vssd1 vccd1 vccd1 _7356_/B sky130_fd_sc_hd__buf_6
XANTENNA__4814__A _5020_/A vssd1 vssd1 vccd1 vccd1 sky130_fd_sc_hd__diode_2
XANTENNA__5984__B1 _6986_/B vssd1 vssd1 vccd1 vccd1 sky130_fd_sc_hd__diode_2
X_7918_ _7918_/A _7918_/B vssd1 vssd1 vccd1 vccd1 _7920_/A sky130_fd_sc_hd__nor2_2
XTAP_TAPCELL_ROW_41_606 vssd1 vccd1 sky130_fd_sc_hd__tapvpwrvgnd_1
XANTENNA__4533__B _5147_/B vssd1 vssd1 vccd1 vccd1 sky130_fd_sc_hd__diode_2
X_7849_ _7850_/A _7850_/B _7850_/C vssd1 vssd1 vccd1 vccd1 _7938_/A sky130_fd_sc_hd__a21o_2
XPHY_EDGE_ROW_83_Left_176 vssd1 vssd1 vccd1 vccd1 sky130_fd_sc_hd__decap_3
XFILLER_3_501 vssd1 vssd1 vccd1 vccd1 sky130_fd_sc_hd__fill_2
XPHY_EDGE_ROW_92_Left_185 vssd1 vssd1 vccd1 vccd1 sky130_fd_sc_hd__decap_3
XTAP_TAPCELL_ROW_57_772 vssd1 vccd1 sky130_fd_sc_hd__tapvpwrvgnd_1
XPHY_EDGE_ROW_1_Left_94 vssd1 vssd1 vccd1 vccd1 sky130_fd_sc_hd__decap_3
XANTENNA__7754__B _7754_/B vssd1 vssd1 vccd1 vccd1 sky130_fd_sc_hd__diode_2
Xinput12 gpio_in[2] vssd1 vssd1 vccd1 vccd1 _8164_/B sky130_fd_sc_hd__clkdlybuf4s25_1
XANTENNA__4702__A1 _8422_/D vssd1 vssd1 vccd1 vccd1 sky130_fd_sc_hd__diode_2
X_6180_ _6180_/A _6180_/B vssd1 vssd1 vccd1 vccd1 _6181_/B sky130_fd_sc_hd__nand2_2
X_5200_ _5200_/A _5200_/B _5200_/C vssd1 vssd1 vccd1 vccd1 _5202_/B sky130_fd_sc_hd__or3_4
XFILLER_69_335 vssd1 vssd1 vccd1 vccd1 sky130_fd_sc_hd__fill_1
X_5131_ _5928_/A wire92/X vssd1 vssd1 vccd1 vccd1 _5739_/A sky130_fd_sc_hd__nand2_2
X_5062_ _5062_/A _5062_/B vssd1 vssd1 vccd1 vccd1 _7007_/B sky130_fd_sc_hd__or2_4
XANTENNA__4177__Y _4177_/Y vssd1 vssd1 vccd1 vccd1 sky130_fd_sc_hd__diode_2
XFILLER_16_29 vssd1 vssd1 vccd1 vccd1 sky130_fd_sc_hd__fill_1
XFILLER_80_533 vssd1 vssd1 vccd1 vccd1 sky130_fd_sc_hd__fill_1
X_7703_ _7703_/A _7703_/B vssd1 vssd1 vccd1 vccd1 _7705_/A sky130_fd_sc_hd__xnor2_2
X_5964_ _5964_/A _5964_/B _5964_/C vssd1 vssd1 vccd1 vccd1 _5965_/B sky130_fd_sc_hd__and3_2
XFILLER_40_419 vssd1 vssd1 vccd1 vccd1 sky130_fd_sc_hd__fill_1
X_5895_ _5896_/A _5896_/B _5896_/C vssd1 vssd1 vccd1 vccd1 _6183_/A sky130_fd_sc_hd__o21a_2
X_4915_ _4916_/A _4916_/B vssd1 vssd1 vccd1 vccd1 _4915_/X sky130_fd_sc_hd__and2b_2
XANTENNA_fanout234_A _8126_/A vssd1 vssd1 vccd1 vccd1 sky130_fd_sc_hd__diode_2
X_7634_ _7634_/A _7634_/B vssd1 vssd1 vccd1 vccd1 _7636_/C sky130_fd_sc_hd__xor2_2
X_4846_ _4979_/A _4972_/B vssd1 vssd1 vccd1 vccd1 _4848_/B sky130_fd_sc_hd__nand2_2
X_7565_ _7566_/A _7566_/B _7566_/C vssd1 vssd1 vccd1 vccd1 _7777_/A sky130_fd_sc_hd__a21o_2
X_6516_ _6517_/A _8246_/A _6517_/D _6517_/B vssd1 vssd1 vccd1 vccd1 _6518_/A sky130_fd_sc_hd__a22oi_2
X_4777_ _5157_/A _4972_/B _4925_/C vssd1 vssd1 vccd1 vccd1 _4779_/B sky130_fd_sc_hd__and3_2
XFILLER_4_309 vssd1 vssd1 vccd1 vccd1 sky130_fd_sc_hd__fill_1
X_7496_ _7586_/B _7496_/B vssd1 vssd1 vccd1 vccd1 _7498_/A sky130_fd_sc_hd__nand2_2
X_6447_ _6447_/A _6447_/B _6447_/C vssd1 vssd1 vccd1 vccd1 _6448_/B sky130_fd_sc_hd__nand3_2
X_6378_ _6378_/A _6378_/B vssd1 vssd1 vccd1 vccd1 _6379_/B sky130_fd_sc_hd__nand2_2
XFILLER_0_537 vssd1 vssd1 vccd1 vccd1 sky130_fd_sc_hd__fill_2
X_8117_ _8117_/A _8117_/B vssd1 vssd1 vccd1 vccd1 _8118_/B sky130_fd_sc_hd__xnor2_2
X_5329_ _5493_/A _5329_/B vssd1 vssd1 vccd1 vccd1 _5330_/B sky130_fd_sc_hd__nand2_2
XFILLER_0_559 vssd1 vssd1 vccd1 vccd1 sky130_fd_sc_hd__fill_1
X_8048_ _8048_/A _8048_/B vssd1 vssd1 vccd1 vccd1 _8050_/C sky130_fd_sc_hd__nor2_2
XFILLER_71_511 vssd1 vssd1 vccd1 vccd1 sky130_fd_sc_hd__fill_1
XFILLER_73_24 vssd1 vssd1 vccd1 vccd1 sky130_fd_sc_hd__fill_4
XFILLER_83_393 vssd1 vssd1 vccd1 vccd1 sky130_fd_sc_hd__fill_2
XANTENNA__8016__A _8016_/A vssd1 vssd1 vccd1 vccd1 sky130_fd_sc_hd__diode_2
XFILLER_73_57 vssd1 vssd1 vccd1 vccd1 sky130_fd_sc_hd__fill_1
XTAP_TAPCELL_ROW_54_742 vssd1 vccd1 sky130_fd_sc_hd__tapvpwrvgnd_1
XFILLER_11_154 vssd1 vssd1 vccd1 vccd1 sky130_fd_sc_hd__fill_2
XFILLER_7_136 vssd1 vssd1 vccd1 vccd1 sky130_fd_sc_hd__fill_1
XFILLER_22_83 vssd1 vssd1 vccd1 vccd1 sky130_fd_sc_hd__fill_1
XFILLER_7_158 vssd1 vssd1 vccd1 vccd1 sky130_fd_sc_hd__fill_1
XFILLER_7_169 vssd1 vssd1 vccd1 vccd1 sky130_fd_sc_hd__fill_1
XANTENNA__6918__B _7889_/B vssd1 vssd1 vccd1 vccd1 sky130_fd_sc_hd__diode_2
XFILLER_78_176 vssd1 vssd1 vccd1 vccd1 sky130_fd_sc_hd__fill_1
XANTENNA__7749__B _7889_/B vssd1 vssd1 vccd1 vccd1 sky130_fd_sc_hd__diode_2
XFILLER_74_382 vssd1 vssd1 vccd1 vccd1 sky130_fd_sc_hd__fill_1
XANTENNA__4173__B _4207_/B vssd1 vssd1 vccd1 vccd1 sky130_fd_sc_hd__diode_2
X_5680_ _5680_/A _5680_/B vssd1 vssd1 vccd1 vccd1 _5682_/A sky130_fd_sc_hd__nand2_2
X_4700_ _8422_/D _4700_/B _4700_/C vssd1 vssd1 vccd1 vccd1 _4701_/B sky130_fd_sc_hd__and3_4
X_4631_ _4631_/A _4631_/B vssd1 vssd1 vccd1 vccd1 _4633_/A sky130_fd_sc_hd__xnor2_2
XFILLER_30_496 vssd1 vssd1 vccd1 vccd1 sky130_fd_sc_hd__fill_1
XFILLER_8_85 vssd1 vssd1 vccd1 vccd1 sky130_fd_sc_hd__fill_1
X_7350_ _7348_/Y _7350_/B vssd1 vssd1 vccd1 vccd1 _7351_/B sky130_fd_sc_hd__and2b_2
X_4562_ _4625_/A _4598_/B vssd1 vssd1 vccd1 vccd1 _4562_/Y sky130_fd_sc_hd__nand2_2
X_7281_ _7281_/A _7281_/B _7281_/C vssd1 vssd1 vccd1 vccd1 _7282_/B sky130_fd_sc_hd__and3_2
X_6301_ _8433_/D _6582_/B _6582_/C vssd1 vssd1 vccd1 vccd1 _6302_/B sky130_fd_sc_hd__a21oi_2
X_4493_ _4493_/A _4493_/B vssd1 vssd1 vccd1 vccd1 _4500_/A sky130_fd_sc_hd__and2_2
XANTENNA__7873__B1 _7875_/D vssd1 vssd1 vccd1 vccd1 sky130_fd_sc_hd__diode_2
X_6232_ _6453_/A _6232_/B vssd1 vssd1 vccd1 vccd1 _6254_/A sky130_fd_sc_hd__or2_2
XANTENNA__4629__A _4709_/A vssd1 vssd1 vccd1 vccd1 sky130_fd_sc_hd__diode_2
Xteam_03_409 vssd1 vssd1 vccd1 vccd1 team_03_409/HI gpio_out[6] sky130_fd_sc_hd__conb_1
X_6163_ _6163_/A _6163_/B vssd1 vssd1 vccd1 vccd1 _6164_/B sky130_fd_sc_hd__xor2_2
X_6094_ _8428_/D _6712_/B vssd1 vssd1 vccd1 vccd1 _6095_/B sky130_fd_sc_hd__nand2_2
X_5114_ _5115_/B _5115_/A vssd1 vssd1 vccd1 vccd1 _5114_/X sky130_fd_sc_hd__and2b_2
X_5045_ _8411_/D wire72/A vssd1 vssd1 vccd1 vccd1 _5047_/B sky130_fd_sc_hd__nand2_2
XFILLER_27_28 vssd1 vccd1 vssd1 vccd1 sky130_ef_sc_hd__decap_40_12
XTAP_TAPCELL_ROW_68_878 vssd1 vccd1 sky130_fd_sc_hd__tapvpwrvgnd_1
XANTENNA_fanout351_A _6001_/A vssd1 vssd1 vccd1 vccd1 sky130_fd_sc_hd__diode_2
X_6996_ _8414_/D _7820_/B vssd1 vssd1 vccd1 vccd1 _7071_/B sky130_fd_sc_hd__nand2_2
XFILLER_80_374 vssd1 vssd1 vccd1 vccd1 sky130_fd_sc_hd__fill_1
X_5947_ _5947_/A _5947_/B vssd1 vssd1 vccd1 vccd1 _5966_/A sky130_fd_sc_hd__xor2_2
XTAP_TAPCELL_ROW_51_712 vssd1 vccd1 sky130_fd_sc_hd__tapvpwrvgnd_1
XANTENNA_fanout237_X _7233_/A vssd1 vssd1 vccd1 vccd1 sky130_fd_sc_hd__diode_2
X_7617_ _7618_/B _7618_/A vssd1 vssd1 vccd1 vccd1 _7617_/X sky130_fd_sc_hd__and2b_2
X_5878_ _6071_/B _5877_/B _5877_/C vssd1 vssd1 vccd1 vccd1 _5879_/B sky130_fd_sc_hd__o21ai_2
XANTENNA__5195__A _6631_/B vssd1 vssd1 vccd1 vccd1 sky130_fd_sc_hd__diode_2
X_4829_ _5928_/A _4830_/C _6300_/B _5930_/A vssd1 vssd1 vccd1 vccd1 _4831_/A sky130_fd_sc_hd__a22oi_2
X_7548_ _7548_/A _7548_/B vssd1 vssd1 vccd1 vccd1 _7572_/A sky130_fd_sc_hd__xor2_2
XFILLER_4_139 vssd1 vssd1 vccd1 vccd1 sky130_fd_sc_hd__fill_1
X_7479_ _7480_/A _7480_/B _7478_/Y vssd1 vssd1 vccd1 vccd1 _7579_/B sky130_fd_sc_hd__o21bai_2
XTAP_TAPCELL_ROW_91_1107 vssd1 vccd1 sky130_fd_sc_hd__tapvpwrvgnd_1
XANTENNA__6738__B _6738_/B vssd1 vssd1 vccd1 vccd1 sky130_fd_sc_hd__diode_2
XFILLER_68_35 vssd1 vssd1 vccd1 vccd1 sky130_fd_sc_hd__fill_2
XFILLER_88_430 vssd1 vssd1 vccd1 vccd1 sky130_fd_sc_hd__fill_4
XFILLER_88_441 vssd1 vssd1 vccd1 vccd1 sky130_fd_sc_hd__fill_2
XFILLER_68_79 vssd1 vssd1 vccd1 vccd1 sky130_fd_sc_hd__fill_4
XFILLER_88_474 vssd1 vssd1 vccd1 vccd1 sky130_fd_sc_hd__fill_2
XFILLER_75_113 vssd1 vssd1 vccd1 vccd1 sky130_fd_sc_hd__fill_1
XFILLER_75_124 vssd1 vssd1 vccd1 vccd1 sky130_fd_sc_hd__fill_2
XFILLER_44_533 vssd1 vssd1 vccd1 vccd1 sky130_fd_sc_hd__fill_1
XFILLER_71_341 vssd1 vssd1 vccd1 vccd1 sky130_fd_sc_hd__fill_1
XTAP_TAPCELL_ROW_39_591 vssd1 vccd1 sky130_fd_sc_hd__tapvpwrvgnd_1
XFILLER_33_60 vssd1 vssd1 vccd1 vccd1 sky130_fd_sc_hd__fill_4
XFILLER_8_423 vssd1 vssd1 vccd1 vccd1 sky130_fd_sc_hd__fill_1
XFILLER_3_150 vssd1 vssd1 vccd1 vccd1 sky130_fd_sc_hd__fill_1
XFILLER_39_349 vssd1 vssd1 vccd1 vccd1 sky130_fd_sc_hd__fill_1
XTAP_TAPCELL_ROW_65_848 vssd1 vccd1 sky130_fd_sc_hd__tapvpwrvgnd_1
X_6850_ _6946_/B _6850_/B vssd1 vssd1 vccd1 vccd1 _6852_/B sky130_fd_sc_hd__nand2_2
XFILLER_50_525 vssd1 vssd1 vccd1 vccd1 sky130_fd_sc_hd__fill_1
X_6781_ _7027_/B _6781_/B vssd1 vssd1 vccd1 vccd1 _6784_/A sky130_fd_sc_hd__or2_2
X_5801_ _5122_/A _5122_/B _5114_/X vssd1 vssd1 vccd1 vccd1 _5803_/B sky130_fd_sc_hd__o21bai_2
XPHY_EDGE_ROW_8_Right_8 vssd1 vssd1 vccd1 vccd1 sky130_fd_sc_hd__decap_3
X_5732_ _5732_/A _5732_/B vssd1 vssd1 vccd1 vccd1 _5733_/B sky130_fd_sc_hd__xnor2_2
XANTENNA__6830__C _7864_/B vssd1 vssd1 vccd1 vccd1 sky130_fd_sc_hd__diode_2
XANTENNA__8103__B _8103_/B vssd1 vssd1 vccd1 vccd1 sky130_fd_sc_hd__diode_2
X_8451_ clkload6/A _8451_/D fanout359/X vssd1 vssd1 vccd1 vccd1 _8451_/Q sky130_fd_sc_hd__dfrtp_2
X_5663_ _5652_/A _5652_/B _5652_/C vssd1 vssd1 vccd1 vccd1 _5664_/B sky130_fd_sc_hd__a21oi_2
X_8382_ _8382_/CLK _8382_/D wire368/X vssd1 vssd1 vccd1 vccd1 _8382_/Q sky130_fd_sc_hd__dfrtp_2
X_7402_ _7298_/B _7616_/A _7401_/X vssd1 vssd1 vccd1 vccd1 _7405_/A sky130_fd_sc_hd__a21o_2
X_5594_ _6035_/C _5594_/B vssd1 vssd1 vccd1 vccd1 _5598_/A sky130_fd_sc_hd__nand2_2
X_4614_ _4616_/A _4614_/B vssd1 vssd1 vccd1 vccd1 _4619_/B sky130_fd_sc_hd__nand2b_2
X_7333_ _7333_/A _7333_/B vssd1 vssd1 vccd1 vccd1 _7335_/C sky130_fd_sc_hd__xnor2_2
X_4545_ _4540_/A _4540_/B _4538_/Y vssd1 vssd1 vccd1 vccd1 _4551_/A sky130_fd_sc_hd__a21bo_2
X_7264_ _7264_/A _7264_/B _7262_/Y vssd1 vssd1 vccd1 vccd1 _7265_/B sky130_fd_sc_hd__or3b_2
X_4476_ _4761_/A _5147_/B _4477_/B vssd1 vssd1 vccd1 vccd1 _4476_/X sky130_fd_sc_hd__and3_2
X_7195_ _7196_/B _7196_/A vssd1 vssd1 vccd1 vccd1 _7287_/B sky130_fd_sc_hd__and2b_2
X_6215_ _6215_/A _6215_/B vssd1 vssd1 vccd1 vccd1 _6228_/A sky130_fd_sc_hd__xnor2_2
XPHY_EDGE_ROW_39_Right_39 vssd1 vssd1 vccd1 vccd1 sky130_fd_sc_hd__decap_3
XFILLER_38_27 vssd1 vssd1 vccd1 vccd1 sky130_fd_sc_hd__fill_1
X_6146_ _7304_/A _6631_/B _6986_/B _5983_/A vssd1 vssd1 vccd1 vccd1 _6146_/X sky130_fd_sc_hd__o22a_2
XANTENNA__4184__A_N _8184_/B vssd1 vssd1 vccd1 vccd1 sky130_fd_sc_hd__diode_2
Xload_slew381 fanout380/X vssd1 vssd1 vccd1 vccd1 load_slew381/X sky130_fd_sc_hd__clkbuf_4
Xload_slew370 fanout369/X vssd1 vssd1 vccd1 vccd1 load_slew370/X sky130_fd_sc_hd__buf_2
XFILLER_85_455 vssd1 vssd1 vccd1 vccd1 sky130_fd_sc_hd__fill_1
XFILLER_85_477 vssd1 vssd1 vccd1 vccd1 sky130_fd_sc_hd__fill_1
X_6077_ _6078_/A _6078_/B vssd1 vssd1 vccd1 vccd1 _6077_/Y sky130_fd_sc_hd__nand2_2
X_5028_ _5028_/A _5028_/B vssd1 vssd1 vccd1 vccd1 _5031_/A sky130_fd_sc_hd__xnor2_4
XTAP_TAPCELL_ROW_88_1080 vssd1 vccd1 sky130_fd_sc_hd__tapvpwrvgnd_1
XFILLER_41_503 vssd1 vssd1 vccd1 vccd1 sky130_fd_sc_hd__fill_1
XTAP_TAPCELL_ROW_36_561 vssd1 vccd1 sky130_fd_sc_hd__tapvpwrvgnd_1
XTAP_TAPCELL_ROW_0_197 vssd1 vccd1 sky130_fd_sc_hd__tapvpwrvgnd_1
XTAP_TAPCELL_ROW_0_186 vssd1 vccd1 sky130_fd_sc_hd__tapvpwrvgnd_1
XFILLER_13_227 vssd1 vssd1 vccd1 vccd1 sky130_fd_sc_hd__fill_2
X_6979_ _6979_/A _6979_/B vssd1 vssd1 vccd1 vccd1 _6981_/B sky130_fd_sc_hd__xnor2_2
XPHY_EDGE_ROW_48_Right_48 vssd1 vssd1 vccd1 vccd1 sky130_fd_sc_hd__decap_3
XFILLER_70_58 vssd1 vssd1 vccd1 vccd1 sky130_fd_sc_hd__fill_2
XFILLER_70_69 vssd1 vssd1 vccd1 vccd1 sky130_fd_sc_hd__fill_1
XFILLER_79_45 vssd1 vssd1 vccd1 vccd1 sky130_fd_sc_hd__fill_2
XFILLER_79_67 vssd1 vssd1 vccd1 vccd1 sky130_fd_sc_hd__fill_4
XPHY_EDGE_ROW_57_Right_57 vssd1 vssd1 vccd1 vccd1 sky130_fd_sc_hd__decap_3
XFILLER_79_89 vssd1 vssd1 vccd1 vccd1 sky130_fd_sc_hd__fill_2
XFILLER_91_403 vssd1 vssd1 vccd1 vccd1 sky130_fd_sc_hd__fill_1
XANTENNA__7299__B _7299_/B vssd1 vssd1 vccd1 vccd1 sky130_fd_sc_hd__diode_2
XANTENNA__8014__B1 _8266_/A vssd1 vssd1 vccd1 vccd1 sky130_fd_sc_hd__diode_2
XFILLER_91_469 vssd1 vssd1 vccd1 vccd1 sky130_fd_sc_hd__fill_1
XFILLER_91_447 vssd1 vssd1 vccd1 vccd1 sky130_fd_sc_hd__fill_1
XTAP_TAPCELL_ROW_62_818 vssd1 vccd1 sky130_fd_sc_hd__tapvpwrvgnd_1
XPHY_EDGE_ROW_66_Right_66 vssd1 vssd1 vccd1 vccd1 sky130_fd_sc_hd__decap_3
XANTENNA__8317__A1 input8/X vssd1 vssd1 vccd1 vccd1 sky130_fd_sc_hd__diode_2
XFILLER_44_92 vssd1 vssd1 vccd1 vccd1 sky130_fd_sc_hd__fill_4
XANTENNA__7465__D _7875_/D vssd1 vssd1 vccd1 vccd1 sky130_fd_sc_hd__diode_2
XPHY_EDGE_ROW_75_Right_75 vssd1 vssd1 vccd1 vccd1 sky130_fd_sc_hd__decap_3
XFILLER_5_42 vssd1 vssd1 vccd1 vccd1 sky130_fd_sc_hd__fill_4
X_4330_ _4328_/A _4461_/A _4329_/X vssd1 vssd1 vccd1 vccd1 _4332_/A sky130_fd_sc_hd__o21a_2
XFILLER_5_86 vssd1 vssd1 vccd1 vccd1 sky130_fd_sc_hd__fill_2
X_4261_ _4249_/Y _4255_/Y _4259_/Y _4314_/A vssd1 vssd1 vccd1 vccd1 _4262_/C sky130_fd_sc_hd__a211o_2
X_6000_ _6397_/C _6001_/A _8136_/C _6198_/A vssd1 vssd1 vccd1 vccd1 _6003_/A sky130_fd_sc_hd__a22oi_2
XFILLER_39_113 vssd1 vssd1 vccd1 vccd1 sky130_fd_sc_hd__fill_4
XFILLER_67_411 vssd1 vssd1 vccd1 vccd1 sky130_fd_sc_hd__fill_1
XFILLER_67_422 vssd1 vssd1 vccd1 vccd1 sky130_fd_sc_hd__fill_1
X_4192_ _8174_/B _4198_/B vssd1 vssd1 vccd1 vccd1 _4192_/Y sky130_fd_sc_hd__nand2b_2
X_7951_ _7952_/A _7952_/B _7952_/C vssd1 vssd1 vccd1 vccd1 _7953_/A sky130_fd_sc_hd__a21oi_2
XTAP_TAPCELL_ROW_78_984 vssd1 vccd1 sky130_fd_sc_hd__tapvpwrvgnd_1
XPHY_EDGE_ROW_84_Right_84 vssd1 vssd1 vccd1 vccd1 sky130_fd_sc_hd__decap_3
XFILLER_82_469 vssd1 vssd1 vccd1 vccd1 sky130_fd_sc_hd__fill_4
X_7882_ _7882_/A _7882_/B vssd1 vssd1 vccd1 vccd1 _7883_/C sky130_fd_sc_hd__xnor2_2
X_6902_ _6805_/A _6807_/B _6805_/B vssd1 vssd1 vccd1 vccd1 _6909_/A sky130_fd_sc_hd__o21ba_2
XFILLER_23_503 vssd1 vssd1 vccd1 vccd1 sky130_fd_sc_hd__fill_1
X_6833_ _6833_/A _6833_/B vssd1 vssd1 vccd1 vccd1 _6843_/A sky130_fd_sc_hd__xnor2_2
XFILLER_23_525 vssd1 vssd1 vccd1 vccd1 sky130_fd_sc_hd__fill_4
XFILLER_23_536 vssd1 vssd1 vccd1 vccd1 sky130_fd_sc_hd__fill_1
XFILLER_24_29 vssd1 vssd1 vccd1 vccd1 sky130_fd_sc_hd__fill_8
XANTENNA__8308__A1 _8184_/B vssd1 vssd1 vccd1 vccd1 sky130_fd_sc_hd__diode_2
X_6764_ _6764_/A _6764_/B _6764_/C vssd1 vssd1 vccd1 vccd1 _6764_/Y sky130_fd_sc_hd__nor3_2
XTAP_TAPCELL_ROW_33_531 vssd1 vccd1 sky130_fd_sc_hd__tapvpwrvgnd_1
X_6695_ _6636_/A _6636_/B _6634_/Y vssd1 vssd1 vccd1 vccd1 _6734_/B sky130_fd_sc_hd__a21bo_2
X_5715_ _5715_/A _5715_/B vssd1 vssd1 vccd1 vccd1 _5717_/B sky130_fd_sc_hd__xnor2_2
XANTENNA_fanout314_A _6238_/D vssd1 vssd1 vccd1 vccd1 sky130_fd_sc_hd__diode_2
X_8434_ clkload4/A _8434_/D wire362/X vssd1 vssd1 vccd1 vccd1 _8434_/Q sky130_fd_sc_hd__dfrtp_2
X_5646_ _5655_/A _5655_/B vssd1 vssd1 vccd1 vccd1 _5656_/A sky130_fd_sc_hd__nor2_2
X_8365_ _8369_/CLK _8365_/D fanout371/X vssd1 vssd1 vccd1 vccd1 _8365_/Q sky130_fd_sc_hd__dfrtp_2
X_5577_ _5578_/B _5622_/A vssd1 vssd1 vccd1 vccd1 _5580_/A sky130_fd_sc_hd__nand2b_2
X_8296_ _6016_/B _8208_/B _8303_/S vssd1 vssd1 vccd1 vccd1 _8371_/D sky130_fd_sc_hd__mux2_1
X_7316_ _7316_/A _7316_/B vssd1 vssd1 vccd1 vccd1 _7317_/B sky130_fd_sc_hd__xor2_2
X_4528_ _4528_/A _4528_/B vssd1 vssd1 vccd1 vccd1 _4553_/B sky130_fd_sc_hd__xnor2_2
X_7247_ _8110_/B _8271_/A vssd1 vssd1 vccd1 vccd1 _7248_/B sky130_fd_sc_hd__nand2_2
X_4459_ _4674_/A _4459_/B _4459_/C vssd1 vssd1 vccd1 vccd1 _4461_/B sky130_fd_sc_hd__or3_2
XFILLER_58_400 vssd1 vssd1 vccd1 vccd1 sky130_fd_sc_hd__fill_1
XANTENNA__7047__A1 _6689_/A vssd1 vssd1 vccd1 vccd1 sky130_fd_sc_hd__diode_2
XANTENNA__8244__A0 _8241_/A vssd1 vssd1 vccd1 vccd1 sky130_fd_sc_hd__diode_2
XFILLER_58_411 vssd1 vssd1 vccd1 vccd1 sky130_fd_sc_hd__fill_1
X_7178_ _7152_/B _6914_/B _6916_/B _6942_/A vssd1 vssd1 vccd1 vccd1 _7179_/C sky130_fd_sc_hd__a31oi_2
XFILLER_58_466 vssd1 vssd1 vccd1 vccd1 sky130_fd_sc_hd__fill_2
XFILLER_65_14 vssd1 vssd1 vccd1 vccd1 sky130_fd_sc_hd__fill_8
X_6129_ _5966_/A _5966_/B _5965_/A vssd1 vssd1 vccd1 vccd1 _6130_/B sky130_fd_sc_hd__o21ba_2
XFILLER_58_499 vssd1 vssd1 vccd1 vccd1 sky130_fd_sc_hd__fill_4
XFILLER_65_36 vssd1 vssd1 vccd1 vccd1 sky130_fd_sc_hd__fill_2
XFILLER_45_138 vssd1 vssd1 vccd1 vccd1 sky130_fd_sc_hd__fill_2
XFILLER_14_525 vssd1 vssd1 vccd1 vccd1 sky130_fd_sc_hd__fill_4
XFILLER_14_547 vssd1 vssd1 vccd1 vccd1 sky130_fd_sc_hd__fill_2
XFILLER_14_569 vssd1 vssd1 vccd1 vccd1 sky130_fd_sc_hd__fill_1
XANTENNA__5367__B _8215_/A vssd1 vssd1 vccd1 vccd1 sky130_fd_sc_hd__diode_2
XFILLER_14_73 vssd1 vssd1 vccd1 vccd1 sky130_fd_sc_hd__fill_2
XANTENNA__5383__A _8233_/A vssd1 vssd1 vccd1 vccd1 sky130_fd_sc_hd__diode_2
XFILLER_1_462 vssd1 vssd1 vccd1 vccd1 sky130_fd_sc_hd__fill_2
XFILLER_68_208 vssd1 vssd1 vccd1 vccd1 sky130_fd_sc_hd__fill_2
XFILLER_49_422 vssd1 vssd1 vccd1 vccd1 sky130_fd_sc_hd__fill_1
XANTENNA__7103__A _7103_/A vssd1 vssd1 vccd1 vccd1 sky130_fd_sc_hd__diode_2
XFILLER_64_414 vssd1 vssd1 vccd1 vccd1 sky130_fd_sc_hd__fill_1
XANTENNA__6261__A2 _8257_/A vssd1 vssd1 vccd1 vccd1 sky130_fd_sc_hd__diode_2
XFILLER_29_190 vssd1 vssd1 vccd1 vccd1 sky130_fd_sc_hd__fill_1
XTAP_TAPCELL_ROW_75_954 vssd1 vccd1 sky130_fd_sc_hd__tapvpwrvgnd_1
XTAP_TAPCELL_ROW_47_667 vssd1 vccd1 sky130_fd_sc_hd__tapvpwrvgnd_1
XFILLER_91_277 vssd1 vssd1 vccd1 vccd1 sky130_fd_sc_hd__fill_2
XFILLER_20_528 vssd1 vssd1 vccd1 vccd1 sky130_fd_sc_hd__fill_4
XFILLER_32_388 vssd1 vssd1 vccd1 vccd1 sky130_fd_sc_hd__fill_1
XTAP_TAPCELL_ROW_30_501 vssd1 vccd1 sky130_fd_sc_hd__tapvpwrvgnd_1
X_5500_ _5501_/A _5501_/B vssd1 vssd1 vccd1 vccd1 _5502_/A sky130_fd_sc_hd__nor2_2
XFILLER_9_551 vssd1 vssd1 vccd1 vccd1 sky130_fd_sc_hd__fill_2
XANTENNA__7492__B _8103_/D vssd1 vssd1 vccd1 vccd1 sky130_fd_sc_hd__diode_2
XFILLER_72_3 vssd1 vssd1 vccd1 vccd1 sky130_fd_sc_hd__fill_2
X_6480_ _6689_/A _6480_/B _6480_/C vssd1 vssd1 vccd1 vccd1 _6480_/X sky130_fd_sc_hd__or3_2
X_5431_ _5432_/A _5432_/B vssd1 vssd1 vccd1 vccd1 _5829_/B sky130_fd_sc_hd__nor2_2
X_8150_ _8150_/A _8150_/B vssd1 vssd1 vccd1 vccd1 _8151_/B sky130_fd_sc_hd__xnor2_2
X_5362_ _5362_/A _5362_/B vssd1 vssd1 vccd1 vccd1 _5365_/A sky130_fd_sc_hd__xnor2_2
X_8081_ _8081_/A _8081_/B vssd1 vssd1 vccd1 vccd1 _8086_/A sky130_fd_sc_hd__nor2_2
X_7101_ _7102_/A _7102_/B vssd1 vssd1 vccd1 vccd1 _7101_/Y sky130_fd_sc_hd__nor2_2
X_4313_ _4421_/A _4348_/A _4308_/X vssd1 vssd1 vccd1 vccd1 _4316_/B sky130_fd_sc_hd__o21ai_2
XFILLER_87_517 vssd1 vssd1 vccd1 vccd1 sky130_fd_sc_hd__fill_2
X_7032_ _7033_/A _7033_/B vssd1 vssd1 vccd1 vccd1 _7032_/Y sky130_fd_sc_hd__nor2_2
X_5293_ _8406_/D _5289_/B _5288_/B _5286_/X vssd1 vssd1 vccd1 vccd1 _5296_/B sky130_fd_sc_hd__a31o_2
X_4244_ _8383_/Q _8442_/Q vssd1 vssd1 vccd1 vccd1 _4246_/A sky130_fd_sc_hd__nor2_2
X_4175_ _6631_/A vssd1 vssd1 vccd1 vccd1 _8412_/D sky130_fd_sc_hd__inv_2
XFILLER_55_447 vssd1 vssd1 vccd1 vccd1 sky130_fd_sc_hd__fill_1
XFILLER_82_233 vssd1 vssd1 vccd1 vccd1 sky130_fd_sc_hd__fill_4
XANTENNA_fanout264_A _5838_/C vssd1 vssd1 vccd1 vccd1 sky130_fd_sc_hd__diode_2
XFILLER_82_266 vssd1 vssd1 vccd1 vccd1 sky130_fd_sc_hd__fill_4
X_7934_ _7934_/A _7934_/B _7934_/C vssd1 vssd1 vccd1 vccd1 _7935_/B sky130_fd_sc_hd__nor3_2
XTAP_TAPCELL_ROW_85_1050 vssd1 vccd1 sky130_fd_sc_hd__tapvpwrvgnd_1
XFILLER_35_171 vssd1 vssd1 vccd1 vccd1 sky130_fd_sc_hd__fill_2
X_7865_ _7865_/A _7865_/B vssd1 vssd1 vccd1 vccd1 _7867_/B sky130_fd_sc_hd__nor2_2
X_7796_ _7934_/B _7796_/B vssd1 vssd1 vccd1 vccd1 _7798_/B sky130_fd_sc_hd__nor2_2
X_6816_ _7140_/A _6894_/B _6903_/C _7140_/B vssd1 vssd1 vccd1 vccd1 _6817_/B sky130_fd_sc_hd__a22oi_2
XTAP_TAPCELL_ROW_18_380 vssd1 vccd1 sky130_fd_sc_hd__tapvpwrvgnd_1
XFILLER_11_517 vssd1 vssd1 vccd1 vccd1 sky130_fd_sc_hd__fill_4
X_6747_ _6747_/A _7004_/A vssd1 vssd1 vccd1 vccd1 _6747_/Y sky130_fd_sc_hd__nor2_2
XANTENNA_fanout317_X _7714_/A vssd1 vssd1 vccd1 vccd1 sky130_fd_sc_hd__diode_2
X_6678_ _6678_/A _6678_/B _6678_/C vssd1 vssd1 vccd1 vccd1 _6681_/A sky130_fd_sc_hd__nand3_2
X_8417_ clkload5/A _8417_/D wire364/X vssd1 vssd1 vccd1 vccd1 _8417_/Q sky130_fd_sc_hd__dfrtp_2
X_5629_ _5676_/B _5676_/A vssd1 vssd1 vccd1 vccd1 _5629_/X sky130_fd_sc_hd__and2b_2
X_8348_ clkload8/A _8348_/D fanout372/A vssd1 vssd1 vccd1 vccd1 _8348_/Q sky130_fd_sc_hd__dfrtp_2
X_8279_ _8281_/C _8279_/B vssd1 vssd1 vccd1 vccd1 _8358_/D sky130_fd_sc_hd__nor2_2
XANTENNA__6746__B wire72/X vssd1 vssd1 vccd1 vccd1 sky130_fd_sc_hd__diode_2
XFILLER_58_296 vssd1 vccd1 vssd1 vccd1 sky130_ef_sc_hd__decap_40_12
XTAP_TAPCELL_ROW_72_924 vssd1 vccd1 sky130_fd_sc_hd__tapvpwrvgnd_1
XTAP_TAPCELL_ROW_44_637 vssd1 vccd1 sky130_fd_sc_hd__tapvpwrvgnd_1
XFILLER_92_78 vssd1 vssd1 vccd1 vccd1 sky130_fd_sc_hd__fill_4
XFILLER_92_67 vssd1 vssd1 vccd1 vccd1 sky130_fd_sc_hd__fill_1
XFILLER_25_72 vssd1 vssd1 vccd1 vccd1 sky130_fd_sc_hd__fill_1
XANTENNA__8201__B _8202_/B vssd1 vssd1 vccd1 vccd1 sky130_fd_sc_hd__diode_2
XFILLER_6_521 vssd1 vssd1 vccd1 vccd1 sky130_fd_sc_hd__fill_2
XANTENNA__6002__A _6397_/C vssd1 vssd1 vccd1 vccd1 sky130_fd_sc_hd__diode_2
XANTENNA__5240__A2_N _5267_/B vssd1 vssd1 vccd1 vccd1 sky130_fd_sc_hd__diode_2
XFILLER_49_230 vssd1 vssd1 vccd1 vccd1 sky130_fd_sc_hd__fill_4
XANTENNA__4176__B _4207_/B vssd1 vssd1 vccd1 vccd1 sky130_fd_sc_hd__diode_2
XFILLER_49_285 vssd1 vssd1 vccd1 vccd1 sky130_fd_sc_hd__fill_2
XFILLER_92_520 vssd1 vssd1 vccd1 vccd1 sky130_fd_sc_hd__fill_2
XANTENNA_load_slew384_A fanout383/X vssd1 vssd1 vccd1 vccd1 sky130_fd_sc_hd__diode_2
X_5980_ _6139_/A _5979_/B _5979_/C vssd1 vssd1 vccd1 vccd1 _6337_/C sky130_fd_sc_hd__o21ai_2
X_4931_ _5163_/A _6588_/A _4931_/C _4931_/D vssd1 vssd1 vccd1 vccd1 _4976_/A sky130_fd_sc_hd__nand4_2
X_7650_ _7649_/A _7649_/B _7649_/C vssd1 vssd1 vccd1 vccd1 _7651_/B sky130_fd_sc_hd__o21ai_2
X_4862_ _4862_/A _4862_/B vssd1 vssd1 vccd1 vccd1 _4863_/B sky130_fd_sc_hd__xnor2_2
X_6601_ _6601_/A _6601_/B vssd1 vssd1 vccd1 vccd1 _6604_/A sky130_fd_sc_hd__xnor2_2
XTAP_TAPCELL_ROW_15_350 vssd1 vccd1 sky130_fd_sc_hd__tapvpwrvgnd_1
X_7581_ _7990_/A _8277_/A _7582_/C vssd1 vssd1 vccd1 vccd1 _7583_/A sky130_fd_sc_hd__a21oi_2
X_4793_ _4491_/Y _4500_/B _4493_/A vssd1 vssd1 vccd1 vccd1 _4795_/B sky130_fd_sc_hd__o21ai_2
X_6532_ _6533_/A _6533_/B _6533_/C vssd1 vssd1 vccd1 vccd1 _6859_/A sky130_fd_sc_hd__a21o_2
XFILLER_9_370 vssd1 vssd1 vccd1 vccd1 sky130_fd_sc_hd__fill_1
X_6463_ _6553_/A _6462_/B _6462_/C vssd1 vssd1 vccd1 vccd1 _6463_/X sky130_fd_sc_hd__a21o_2
X_8202_ _8202_/A _8202_/B vssd1 vssd1 vccd1 vccd1 _8203_/B sky130_fd_sc_hd__nand2_2
X_5414_ _6198_/A _5415_/B _6005_/B _6006_/A vssd1 vssd1 vccd1 vccd1 _5422_/A sky130_fd_sc_hd__and4_2
X_8133_ _8133_/A _8133_/B _8133_/C _8264_/A vssd1 vssd1 vccd1 vccd1 _8134_/B sky130_fd_sc_hd__and4_2
X_6394_ _6394_/A _6394_/B vssd1 vssd1 vccd1 vccd1 _6476_/A sky130_fd_sc_hd__xor2_2
X_5345_ _5458_/B _5475_/A _5458_/A vssd1 vssd1 vccd1 vccd1 _5461_/A sky130_fd_sc_hd__a21o_2
X_8064_ _8064_/A vssd1 vssd1 vccd1 vccd1 _8066_/B sky130_fd_sc_hd__inv_2
X_5276_ _5267_/B _5275_/Y _5273_/X _6611_/A vssd1 vssd1 vccd1 vccd1 _5276_/X sky130_fd_sc_hd__a211o_2
XANTENNA__4367__A _5157_/A vssd1 vssd1 vccd1 vccd1 sky130_fd_sc_hd__diode_2
X_7015_ _7014_/B _7015_/B vssd1 vssd1 vccd1 vccd1 _7016_/B sky130_fd_sc_hd__nand2b_2
X_4227_ _8422_/Q _8164_/B _4227_/S vssd1 vssd1 vccd1 vccd1 _4821_/A sky130_fd_sc_hd__mux2_1
XFILLER_83_520 vssd1 vssd1 vccd1 vccd1 sky130_fd_sc_hd__fill_2
X_4158_ _4158_/A vssd1 vssd1 vccd1 vccd1 _4158_/Y sky130_fd_sc_hd__inv_2
XANTENNA_fanout267_X _7889_/B vssd1 vssd1 vccd1 vccd1 sky130_fd_sc_hd__diode_2
XFILLER_55_277 vssd1 vssd1 vccd1 vccd1 sky130_fd_sc_hd__fill_2
XANTENNA__5984__A1 _5983_/A vssd1 vssd1 vccd1 vccd1 sky130_fd_sc_hd__diode_2
X_7917_ _7917_/A _7917_/B _7917_/C vssd1 vssd1 vccd1 vccd1 _7918_/B sky130_fd_sc_hd__and3_2
XANTENNA__5984__B2 _6978_/A vssd1 vssd1 vccd1 vccd1 sky130_fd_sc_hd__diode_2
XFILLER_51_483 vssd1 vssd1 vccd1 vccd1 sky130_fd_sc_hd__fill_2
X_7848_ _7848_/A _7848_/B vssd1 vssd1 vccd1 vccd1 _7850_/C sky130_fd_sc_hd__xnor2_2
XTAP_TAPCELL_ROW_41_607 vssd1 vccd1 sky130_fd_sc_hd__tapvpwrvgnd_1
X_7779_ _7990_/A _8359_/Q vssd1 vssd1 vccd1 vccd1 _7780_/B sky130_fd_sc_hd__nand2_2
XANTENNA__4830__A _5928_/A vssd1 vssd1 vccd1 vccd1 sky130_fd_sc_hd__diode_2
XFILLER_11_85 vssd1 vssd1 vccd1 vccd1 sky130_fd_sc_hd__fill_4
XANTENNA__6476__B _6476_/B vssd1 vssd1 vccd1 vccd1 sky130_fd_sc_hd__diode_2
XFILLER_78_336 vssd1 vssd1 vccd1 vccd1 sky130_fd_sc_hd__fill_2
XFILLER_87_78 vssd1 vssd1 vccd1 vccd1 sky130_fd_sc_hd__fill_1
Xfanout382 fanout383/X vssd1 vssd1 vccd1 vccd1 fanout382/X sky130_fd_sc_hd__clkdlybuf4s25_1
Xfanout371 fanout379/X vssd1 vssd1 vccd1 vccd1 fanout371/X sky130_fd_sc_hd__clkdlybuf4s25_1
XFILLER_19_447 vssd1 vssd1 vccd1 vccd1 sky130_fd_sc_hd__fill_1
XANTENNA__4227__A1 _8164_/B vssd1 vssd1 vccd1 vccd1 sky130_fd_sc_hd__diode_2
XANTENNA__8420__RESET_B wire364/X vssd1 vssd1 vccd1 vccd1 sky130_fd_sc_hd__diode_2
XTAP_TAPCELL_ROW_57_773 vssd1 vccd1 sky130_fd_sc_hd__tapvpwrvgnd_1
XTAP_TAPCELL_ROW_29_486 vssd1 vccd1 sky130_fd_sc_hd__tapvpwrvgnd_1
XTAP_TAPCELL_ROW_12_320 vssd1 vccd1 sky130_fd_sc_hd__tapvpwrvgnd_1
XANTENNA__7754__C _7877_/B vssd1 vssd1 vccd1 vccd1 sky130_fd_sc_hd__diode_2
Xinput13 gpio_in[3] vssd1 vssd1 vccd1 vccd1 _8168_/B sky130_fd_sc_hd__clkbuf_2
XANTENNA__4702__A2 _4700_/B vssd1 vssd1 vccd1 vccd1 sky130_fd_sc_hd__diode_2
XFILLER_35_3 vssd1 vssd1 vccd1 vccd1 sky130_fd_sc_hd__fill_2
X_5130_ _5004_/A _5004_/B _5002_/X vssd1 vssd1 vccd1 vccd1 _5142_/A sky130_fd_sc_hd__a21oi_2
X_5061_ _4727_/B _4727_/C _4727_/A vssd1 vssd1 vccd1 vccd1 _5062_/B sky130_fd_sc_hd__a21oi_2
XANTENNA__4218__A1 _8254_/B vssd1 vssd1 vccd1 vccd1 sky130_fd_sc_hd__diode_2
XANTENNA__4193__Y _7103_/A vssd1 vssd1 vccd1 vccd1 sky130_fd_sc_hd__diode_2
XANTENNA__7955__A2 _8082_/D vssd1 vssd1 vccd1 vccd1 sky130_fd_sc_hd__diode_2
X_5963_ _5964_/A _5964_/B _5964_/C vssd1 vssd1 vccd1 vccd1 _5965_/A sky130_fd_sc_hd__a21oi_2
XANTENNA__7010__B wire72/X vssd1 vssd1 vccd1 vccd1 sky130_fd_sc_hd__diode_2
XFILLER_40_409 vssd1 vssd1 vccd1 vccd1 sky130_fd_sc_hd__fill_1
X_7702_ _7702_/A _7702_/B vssd1 vssd1 vccd1 vccd1 _7703_/B sky130_fd_sc_hd__nor2_2
X_4914_ _4914_/A _4914_/B vssd1 vssd1 vccd1 vccd1 _4916_/B sky130_fd_sc_hd__xnor2_2
XTAP_TAPCELL_ROW_82_1020 vssd1 vccd1 sky130_fd_sc_hd__tapvpwrvgnd_1
X_5894_ _5894_/A _5894_/B vssd1 vssd1 vccd1 vccd1 _5896_/C sky130_fd_sc_hd__xor2_2
XFILLER_20_100 vssd1 vssd1 vccd1 vccd1 sky130_fd_sc_hd__fill_4
XFILLER_33_483 vssd1 vssd1 vccd1 vccd1 sky130_fd_sc_hd__fill_1
X_7633_ _7634_/A _7634_/B vssd1 vssd1 vccd1 vccd1 _7696_/B sky130_fd_sc_hd__and2b_2
X_4845_ _4845_/A _4845_/B vssd1 vssd1 vccd1 vccd1 _4852_/A sky130_fd_sc_hd__xor2_2
X_7564_ _7768_/B _7564_/B vssd1 vssd1 vccd1 vccd1 _7566_/C sky130_fd_sc_hd__or2_2
X_4776_ _5155_/A _5163_/B _5163_/C vssd1 vssd1 vccd1 vccd1 _4925_/C sky130_fd_sc_hd__and3_2
XANTENNA_fanout227_A _7875_/A vssd1 vssd1 vccd1 vccd1 sky130_fd_sc_hd__diode_2
X_6515_ _6515_/A _6515_/B vssd1 vssd1 vccd1 vccd1 _6539_/A sky130_fd_sc_hd__xor2_2
X_7495_ _7586_/A _7494_/B _7494_/C vssd1 vssd1 vccd1 vccd1 _7496_/B sky130_fd_sc_hd__a21o_2
X_6446_ _6447_/A _6447_/B _6447_/C vssd1 vssd1 vccd1 vccd1 _6545_/A sky130_fd_sc_hd__a21o_2
XANTENNA__7680__B _8082_/D vssd1 vssd1 vccd1 vccd1 sky130_fd_sc_hd__diode_2
X_6377_ _6377_/A _6377_/B vssd1 vssd1 vccd1 vccd1 _6378_/B sky130_fd_sc_hd__nand2_2
X_8116_ _8125_/A _8126_/B _8019_/A _8017_/B vssd1 vssd1 vccd1 vccd1 _8117_/B sky130_fd_sc_hd__a31o_2
X_5328_ _5493_/A _5329_/B vssd1 vssd1 vccd1 vccd1 _5348_/A sky130_fd_sc_hd__or2_2
X_8047_ _8147_/B _8046_/B _8046_/C vssd1 vssd1 vccd1 vccd1 _8048_/B sky130_fd_sc_hd__a21oi_2
XFILLER_87_166 vssd1 vssd1 vccd1 vccd1 sky130_fd_sc_hd__fill_2
Xclkbuf_4_5_0_clk clkbuf_0_clk/X vssd1 vssd1 vccd1 vccd1 clkload5/A sky130_fd_sc_hd__clkbuf_8
X_5259_ _5285_/A _5258_/C _5258_/A vssd1 vssd1 vccd1 vccd1 _5260_/C sky130_fd_sc_hd__a21o_2
XFILLER_28_211 vssd1 vssd1 vccd1 vccd1 sky130_fd_sc_hd__fill_1
XFILLER_73_36 vssd1 vssd1 vccd1 vccd1 sky130_fd_sc_hd__fill_8
XANTENNA__8016__B _8126_/A vssd1 vssd1 vccd1 vccd1 sky130_fd_sc_hd__diode_2
XTAP_TAPCELL_ROW_54_743 vssd1 vccd1 sky130_fd_sc_hd__tapvpwrvgnd_1
Xwire92 wire92/A vssd1 vssd1 vccd1 vccd1 wire92/X sky130_fd_sc_hd__clkbuf_4
XTAP_TAPCELL_ROW_26_456 vssd1 vccd1 sky130_fd_sc_hd__tapvpwrvgnd_1
XANTENNA__7855__B _8136_/A vssd1 vssd1 vccd1 vccd1 sky130_fd_sc_hd__diode_2
XFILLER_11_122 vssd1 vssd1 vccd1 vccd1 sky130_fd_sc_hd__fill_4
XANTENNA__6918__C _8351_/Q vssd1 vssd1 vccd1 vccd1 sky130_fd_sc_hd__diode_2
XFILLER_78_111 vssd1 vssd1 vccd1 vccd1 sky130_fd_sc_hd__fill_1
XANTENNA_load_slew50_A _6997_/B vssd1 vssd1 vccd1 vccd1 sky130_fd_sc_hd__diode_2
Xfanout190 _8405_/Q vssd1 vssd1 vccd1 vccd1 _8303_/S sky130_fd_sc_hd__clkdlybuf4s25_1
XANTENNA__7749__C _7897_/B vssd1 vssd1 vccd1 vccd1 sky130_fd_sc_hd__diode_2
XANTENNA__8207__A _8208_/A vssd1 vssd1 vccd1 vccd1 sky130_fd_sc_hd__diode_2
XFILLER_47_70 vssd1 vssd1 vccd1 vccd1 sky130_fd_sc_hd__fill_1
XFILLER_62_512 vssd1 vssd1 vccd1 vccd1 sky130_fd_sc_hd__fill_4
XFILLER_74_361 vssd1 vssd1 vccd1 vccd1 sky130_fd_sc_hd__fill_2
X_4630_ _4631_/A _4631_/B vssd1 vssd1 vccd1 vccd1 _4630_/X sky130_fd_sc_hd__or2_2
X_6300_ _8433_/D _6300_/B _6300_/C vssd1 vssd1 vccd1 vccd1 _6302_/A sky130_fd_sc_hd__and3_2
X_4561_ _4568_/B _4593_/A _4568_/A vssd1 vssd1 vccd1 vccd1 _4569_/A sky130_fd_sc_hd__a21oi_2
X_7280_ _7281_/A _7281_/B _7281_/C vssd1 vssd1 vccd1 vccd1 _7503_/A sky130_fd_sc_hd__a21oi_2
X_4492_ _4492_/A _4492_/B vssd1 vssd1 vccd1 vccd1 _4493_/B sky130_fd_sc_hd__or2_2
XANTENNA__7873__A1 _7875_/A vssd1 vssd1 vccd1 vccd1 sky130_fd_sc_hd__diode_2
X_6231_ _6428_/B _6230_/B _6230_/C vssd1 vssd1 vccd1 vccd1 _6232_/B sky130_fd_sc_hd__a21oi_2
XANTENNA__4687__A1 _4709_/A vssd1 vssd1 vccd1 vccd1 sky130_fd_sc_hd__diode_2
X_6162_ _6163_/B _6163_/A vssd1 vssd1 vccd1 vccd1 _6162_/X sky130_fd_sc_hd__and2b_2
XFILLER_69_111 vssd1 vssd1 vccd1 vccd1 sky130_fd_sc_hd__fill_1
X_5113_ _5107_/A _5059_/B _5064_/A _5064_/B vssd1 vssd1 vccd1 vccd1 _5115_/B sky130_fd_sc_hd__a2bb2oi_2
XFILLER_84_103 vssd1 vssd1 vccd1 vccd1 sky130_fd_sc_hd__fill_8
X_6093_ _5943_/A _6293_/A _6092_/X vssd1 vssd1 vccd1 vccd1 _6095_/A sky130_fd_sc_hd__o21ai_2
X_5044_ _8411_/D _5780_/B vssd1 vssd1 vccd1 vccd1 _5119_/A sky130_fd_sc_hd__nand2_2
XTAP_TAPCELL_ROW_68_879 vssd1 vccd1 sky130_fd_sc_hd__tapvpwrvgnd_1
XFILLER_53_501 vssd1 vssd1 vccd1 vccd1 sky130_fd_sc_hd__fill_2
XFILLER_65_372 vssd1 vssd1 vccd1 vccd1 sky130_fd_sc_hd__fill_4
XFILLER_25_225 vssd1 vssd1 vccd1 vccd1 sky130_fd_sc_hd__fill_1
XFILLER_25_258 vssd1 vssd1 vccd1 vccd1 sky130_fd_sc_hd__fill_1
X_6995_ _8416_/D wire59/X _6750_/A _6747_/Y vssd1 vssd1 vccd1 vccd1 _7000_/A sky130_fd_sc_hd__a31o_2
X_5946_ _5947_/B _5947_/A vssd1 vssd1 vccd1 vccd1 _6097_/B sky130_fd_sc_hd__nand2b_2
XTAP_TAPCELL_ROW_51_713 vssd1 vccd1 sky130_fd_sc_hd__tapvpwrvgnd_1
X_5877_ _6071_/B _5877_/B _5877_/C vssd1 vssd1 vccd1 vccd1 _5879_/A sky130_fd_sc_hd__or3_2
XTAP_TAPCELL_ROW_23_426 vssd1 vccd1 sky130_fd_sc_hd__tapvpwrvgnd_1
XANTENNA__4380__A _4919_/A vssd1 vssd1 vccd1 vccd1 sky130_fd_sc_hd__diode_2
X_7616_ _7616_/A _7616_/B vssd1 vssd1 vccd1 vccd1 _7618_/B sky130_fd_sc_hd__xor2_2
X_4828_ _4770_/A _4770_/B _4771_/A _4773_/Y vssd1 vssd1 vccd1 vccd1 _4835_/A sky130_fd_sc_hd__o31a_2
X_7547_ _7547_/A _7547_/B vssd1 vssd1 vccd1 vccd1 _7548_/B sky130_fd_sc_hd__nand2_2
X_4759_ _4762_/A _4310_/Y _4608_/B _4476_/X vssd1 vssd1 vccd1 vccd1 _4768_/A sky130_fd_sc_hd__a31o_2
X_7478_ _7579_/A _7478_/B vssd1 vssd1 vccd1 vccd1 _7478_/Y sky130_fd_sc_hd__nand2_2
X_6429_ _6246_/A _6246_/B _6244_/X vssd1 vssd1 vccd1 vccd1 _6450_/A sky130_fd_sc_hd__a21oi_2
XTAP_TAPCELL_ROW_91_1108 vssd1 vccd1 sky130_fd_sc_hd__tapvpwrvgnd_1
XFILLER_84_13 vssd1 vccd1 vssd1 vccd1 sky130_ef_sc_hd__decap_40_12
XANTENNA__7202__Y _7203_/C vssd1 vssd1 vccd1 vccd1 sky130_fd_sc_hd__diode_2
XFILLER_75_169 vssd1 vssd1 vccd1 vccd1 sky130_fd_sc_hd__fill_1
XFILLER_90_117 vssd1 vssd1 vccd1 vccd1 sky130_fd_sc_hd__fill_1
XFILLER_16_236 vssd1 vssd1 vccd1 vccd1 sky130_fd_sc_hd__fill_1
XFILLER_17_51 vssd1 vssd1 vccd1 vccd1 sky130_fd_sc_hd__fill_4
XTAP_TAPCELL_ROW_39_592 vssd1 vccd1 sky130_fd_sc_hd__tapvpwrvgnd_1
XFILLER_12_464 vssd1 vssd1 vccd1 vccd1 sky130_fd_sc_hd__fill_2
XFILLER_33_50 vssd1 vssd1 vccd1 vccd1 sky130_fd_sc_hd__fill_4
XFILLER_12_486 vssd1 vssd1 vccd1 vccd1 sky130_fd_sc_hd__fill_2
XFILLER_79_442 vssd1 vssd1 vccd1 vccd1 sky130_fd_sc_hd__fill_2
XTAP_TAPCELL_ROW_65_849 vssd1 vccd1 sky130_fd_sc_hd__tapvpwrvgnd_1
XFILLER_50_504 vssd1 vssd1 vccd1 vccd1 sky130_fd_sc_hd__fill_8
X_6780_ _7027_/A _6779_/B _6779_/C vssd1 vssd1 vccd1 vccd1 _6781_/B sky130_fd_sc_hd__o21a_2
X_5800_ _5800_/A _5800_/B vssd1 vssd1 vccd1 vccd1 _5803_/A sky130_fd_sc_hd__xor2_2
XFILLER_50_537 vssd1 vssd1 vccd1 vccd1 sky130_fd_sc_hd__fill_4
X_5731_ _5732_/A _5732_/B vssd1 vssd1 vccd1 vccd1 _5933_/B sky130_fd_sc_hd__and2_2
XANTENNA__6830__D _7875_/C vssd1 vssd1 vccd1 vccd1 sky130_fd_sc_hd__diode_2
X_8450_ clkload3/A _8450_/D fanout372/A vssd1 vssd1 vccd1 vccd1 _8450_/Q sky130_fd_sc_hd__dfrtp_2
X_5662_ _5662_/A _5662_/B _5662_/C vssd1 vssd1 vccd1 vccd1 _5662_/X sky130_fd_sc_hd__and3_2
X_8381_ clkload2/A _8381_/D wire368/X vssd1 vssd1 vccd1 vccd1 _8381_/Q sky130_fd_sc_hd__dfrtp_2
X_7401_ _7808_/A _7296_/B _7806_/B _7668_/A vssd1 vssd1 vccd1 vccd1 _7401_/X sky130_fd_sc_hd__o22a_2
X_5593_ _5593_/A _5593_/B vssd1 vssd1 vccd1 vccd1 _5600_/A sky130_fd_sc_hd__xor2_2
X_4613_ _4611_/B _4613_/A2 _4612_/X vssd1 vssd1 vccd1 vccd1 _4616_/A sky130_fd_sc_hd__o21a_4
X_7332_ _7332_/A _7332_/B vssd1 vssd1 vccd1 vccd1 _7333_/B sky130_fd_sc_hd__xnor2_2
X_4544_ _4544_/A _4544_/B vssd1 vssd1 vccd1 vccd1 _4546_/B sky130_fd_sc_hd__xnor2_2
X_7263_ _7264_/A _7264_/B _7262_/Y vssd1 vssd1 vccd1 vccd1 _7489_/B sky130_fd_sc_hd__o21bai_2
X_6214_ _6215_/A _6215_/B vssd1 vssd1 vccd1 vccd1 _6428_/A sky130_fd_sc_hd__nand2b_2
X_4475_ _4348_/A _4473_/Y _4474_/X vssd1 vssd1 vccd1 vccd1 _4477_/B sky130_fd_sc_hd__o21a_2
X_7194_ _6947_/B _6949_/B _6947_/A vssd1 vssd1 vccd1 vccd1 _7196_/B sky130_fd_sc_hd__o21ba_2
XANTENNA_fanout294_A _8351_/Q vssd1 vssd1 vccd1 vccd1 sky130_fd_sc_hd__diode_2
X_6145_ _7304_/A _6986_/B _6145_/C vssd1 vssd1 vccd1 vccd1 _6341_/A sky130_fd_sc_hd__or3_2
Xload_slew360 fanout359/X vssd1 vssd1 vccd1 vccd1 load_slew360/X sky130_fd_sc_hd__clkbuf_4
X_6076_ _6277_/B _6076_/B vssd1 vssd1 vccd1 vccd1 _6078_/B sky130_fd_sc_hd__and2b_2
XFILLER_57_169 vssd1 vssd1 vccd1 vccd1 sky130_fd_sc_hd__fill_2
X_5027_ _5028_/A _5027_/B _5027_/C vssd1 vssd1 vccd1 vccd1 _5027_/Y sky130_fd_sc_hd__nand3b_2
XFILLER_26_501 vssd1 vssd1 vccd1 vccd1 sky130_fd_sc_hd__fill_2
XFILLER_26_523 vssd1 vssd1 vccd1 vccd1 sky130_fd_sc_hd__fill_4
XFILLER_72_106 vssd1 vccd1 vssd1 vccd1 sky130_ef_sc_hd__decap_40_12
XFILLER_26_556 vssd1 vssd1 vccd1 vccd1 sky130_fd_sc_hd__fill_1
XTAP_TAPCELL_ROW_88_1081 vssd1 vccd1 sky130_fd_sc_hd__tapvpwrvgnd_1
XTAP_TAPCELL_ROW_36_562 vssd1 vccd1 sky130_fd_sc_hd__tapvpwrvgnd_1
XTAP_TAPCELL_ROW_0_187 vssd1 vccd1 sky130_fd_sc_hd__tapvpwrvgnd_1
XFILLER_41_526 vssd1 vssd1 vccd1 vccd1 sky130_fd_sc_hd__fill_4
X_6978_ _6978_/A _8077_/B vssd1 vssd1 vccd1 vccd1 _6979_/B sky130_fd_sc_hd__nor2_2
XTAP_TAPCELL_ROW_0_198 vssd1 vccd1 sky130_fd_sc_hd__tapvpwrvgnd_1
X_5929_ _5929_/A _5929_/B vssd1 vssd1 vccd1 vccd1 _5931_/A sky130_fd_sc_hd__xnor2_2
Xrebuffer510 _4555_/B vssd1 vssd1 vccd1 vccd1 _4520_/B1 sky130_fd_sc_hd__buf_2
XTAP_TAPCELL_ROW_8_276 vssd1 vccd1 sky130_fd_sc_hd__tapvpwrvgnd_1
XFILLER_76_434 vssd1 vssd1 vccd1 vccd1 sky130_fd_sc_hd__fill_2
XFILLER_88_283 vssd1 vssd1 vccd1 vccd1 sky130_fd_sc_hd__fill_4
XANTENNA__7299__C _7299_/C vssd1 vssd1 vccd1 vccd1 sky130_fd_sc_hd__diode_2
XANTENNA__8014__A1 _8016_/A vssd1 vssd1 vccd1 vccd1 sky130_fd_sc_hd__diode_2
XANTENNA__8014__B2 _8126_/A vssd1 vssd1 vccd1 vccd1 sky130_fd_sc_hd__diode_2
XTAP_TAPCELL_ROW_62_819 vssd1 vccd1 sky130_fd_sc_hd__tapvpwrvgnd_1
XANTENNA__4732__B _7326_/B vssd1 vssd1 vccd1 vccd1 sky130_fd_sc_hd__diode_2
XANTENNA__6005__A _6207_/A vssd1 vssd1 vccd1 vccd1 sky130_fd_sc_hd__diode_2
XFILLER_8_221 vssd1 vssd1 vccd1 vccd1 sky130_fd_sc_hd__fill_1
XTAP_TAPCELL_ROW_70_896 vssd1 vccd1 sky130_fd_sc_hd__tapvpwrvgnd_1
XFILLER_74_7 vssd1 vssd1 vccd1 vccd1 sky130_fd_sc_hd__fill_1
XANTENNA__8220__A _8220_/A vssd1 vssd1 vccd1 vccd1 sky130_fd_sc_hd__diode_2
XFILLER_8_265 vssd1 vssd1 vccd1 vccd1 sky130_fd_sc_hd__fill_1
XFILLER_5_76 vssd1 vssd1 vccd1 vccd1 sky130_fd_sc_hd__fill_2
X_4260_ _4249_/Y _4255_/Y _4259_/Y vssd1 vssd1 vccd1 vccd1 _4314_/B sky130_fd_sc_hd__a21oi_2
XFILLER_79_250 vssd1 vssd1 vccd1 vccd1 sky130_fd_sc_hd__fill_1
X_4191_ _5217_/A vssd1 vssd1 vccd1 vccd1 _4191_/Y sky130_fd_sc_hd__inv_2
X_7950_ _7950_/A _7950_/B vssd1 vssd1 vccd1 vccd1 _7952_/C sky130_fd_sc_hd__xor2_2
XTAP_TAPCELL_ROW_78_985 vssd1 vccd1 sky130_fd_sc_hd__tapvpwrvgnd_1
XFILLER_54_139 vssd1 vssd1 vccd1 vccd1 sky130_fd_sc_hd__fill_1
X_7881_ _7882_/A _7882_/B vssd1 vssd1 vccd1 vccd1 _8009_/B sky130_fd_sc_hd__nand2b_2
X_6901_ _6817_/B _6819_/B _6817_/A vssd1 vssd1 vccd1 vccd1 _6911_/A sky130_fd_sc_hd__o21ba_2
X_6832_ _6832_/A _8264_/A vssd1 vssd1 vccd1 vccd1 _6833_/B sky130_fd_sc_hd__nand2_2
XANTENNA__5738__B _6701_/B vssd1 vssd1 vccd1 vccd1 sky130_fd_sc_hd__diode_2
XFILLER_23_559 vssd1 vssd1 vccd1 vccd1 sky130_fd_sc_hd__fill_1
X_6763_ _6763_/A _6763_/B vssd1 vssd1 vccd1 vccd1 _6764_/C sky130_fd_sc_hd__xnor2_2
XTAP_TAPCELL_ROW_33_532 vssd1 vccd1 sky130_fd_sc_hd__tapvpwrvgnd_1
X_6694_ _6621_/A _6621_/B _6619_/Y vssd1 vssd1 vccd1 vccd1 _6736_/A sky130_fd_sc_hd__o21ai_2
X_5714_ _8433_/D wire99/X vssd1 vssd1 vccd1 vccd1 _5715_/B sky130_fd_sc_hd__nand2_2
XFILLER_40_18 vssd1 vssd1 vccd1 vccd1 sky130_fd_sc_hd__fill_4
X_8433_ clkload4/A _8433_/D wire362/A vssd1 vssd1 vccd1 vccd1 _8433_/Q sky130_fd_sc_hd__dfrtp_2
X_5645_ _5649_/A _5645_/B vssd1 vssd1 vccd1 vccd1 _5655_/B sky130_fd_sc_hd__or2_2
XANTENNA_fanout307_A _7140_/D vssd1 vssd1 vccd1 vccd1 sky130_fd_sc_hd__diode_2
X_8364_ _8369_/CLK _8364_/D wire377/A vssd1 vssd1 vccd1 vccd1 _8364_/Q sky130_fd_sc_hd__dfrtp_2
X_5576_ _5572_/A _5571_/B _5571_/A vssd1 vssd1 vccd1 vccd1 _5578_/B sky130_fd_sc_hd__o21ba_2
X_8295_ _5826_/A _8202_/B _8303_/S vssd1 vssd1 vccd1 vccd1 _8370_/D sky130_fd_sc_hd__mux2_1
X_7315_ _7316_/A _7316_/B vssd1 vssd1 vccd1 vccd1 _7315_/X sky130_fd_sc_hd__and2_2
X_4527_ _4527_/A _4770_/B vssd1 vssd1 vccd1 vccd1 _4528_/B sky130_fd_sc_hd__nor2_2
X_7246_ _7246_/A _7246_/B vssd1 vssd1 vccd1 vccd1 _7248_/A sky130_fd_sc_hd__nor2_2
X_4458_ _4527_/A _4459_/B _4459_/C vssd1 vssd1 vccd1 vccd1 _4749_/A sky130_fd_sc_hd__or3_2
X_7177_ _7177_/A _7177_/B vssd1 vssd1 vccd1 vccd1 _7179_/B sky130_fd_sc_hd__and2_2
X_6128_ _6128_/A _6128_/B vssd1 vssd1 vccd1 vccd1 _6130_/A sky130_fd_sc_hd__xor2_2
X_4389_ _4393_/B _4389_/B vssd1 vssd1 vccd1 vccd1 _4405_/A sky130_fd_sc_hd__or2_4
XTAP_TAPCELL_ROW_5_246 vssd1 vccd1 sky130_fd_sc_hd__tapvpwrvgnd_1
XFILLER_85_253 vssd1 vssd1 vccd1 vccd1 sky130_fd_sc_hd__fill_2
XFILLER_18_309 vssd1 vssd1 vccd1 vccd1 sky130_fd_sc_hd__fill_1
X_6059_ _6460_/A _8246_/A vssd1 vssd1 vccd1 vccd1 _6060_/B sky130_fd_sc_hd__nand2_2
XFILLER_65_59 vssd1 vssd1 vccd1 vccd1 sky130_fd_sc_hd__fill_1
XFILLER_81_36 vssd1 vssd1 vccd1 vccd1 sky130_fd_sc_hd__fill_2
XFILLER_81_470 vssd1 vssd1 vccd1 vccd1 sky130_fd_sc_hd__fill_4
XFILLER_81_492 vssd1 vssd1 vccd1 vccd1 sky130_fd_sc_hd__fill_2
XFILLER_53_194 vssd1 vssd1 vccd1 vccd1 sky130_fd_sc_hd__fill_2
XFILLER_14_85 vssd1 vssd1 vccd1 vccd1 sky130_fd_sc_hd__fill_4
XANTENNA__5383__B _6460_/A vssd1 vssd1 vccd1 vccd1 sky130_fd_sc_hd__diode_2
XANTENNA__8445__RESET_B fanout379/X vssd1 vssd1 vccd1 vccd1 sky130_fd_sc_hd__diode_2
XANTENNA__8397__D _8397_/D vssd1 vssd1 vccd1 vccd1 sky130_fd_sc_hd__diode_2
XFILLER_76_220 vssd1 vssd1 vccd1 vccd1 sky130_fd_sc_hd__fill_1
XFILLER_76_242 vssd1 vssd1 vccd1 vccd1 sky130_fd_sc_hd__fill_2
XANTENNA__7103__B _8077_/B vssd1 vssd1 vccd1 vccd1 sky130_fd_sc_hd__diode_2
XFILLER_76_253 vssd1 vssd1 vccd1 vccd1 sky130_fd_sc_hd__fill_4
XFILLER_76_275 vssd1 vccd1 vssd1 vccd1 sky130_ef_sc_hd__decap_40_12
XTAP_TAPCELL_ROW_75_955 vssd1 vccd1 sky130_fd_sc_hd__tapvpwrvgnd_1
XTAP_TAPCELL_ROW_47_668 vssd1 vccd1 sky130_fd_sc_hd__tapvpwrvgnd_1
XANTENNA__8215__A _8215_/A vssd1 vssd1 vccd1 vccd1 sky130_fd_sc_hd__diode_2
XFILLER_20_507 vssd1 vssd1 vccd1 vccd1 sky130_fd_sc_hd__fill_4
XTAP_TAPCELL_ROW_30_502 vssd1 vccd1 sky130_fd_sc_hd__tapvpwrvgnd_1
X_5430_ _5829_/A _5430_/B vssd1 vssd1 vccd1 vccd1 _5432_/B sky130_fd_sc_hd__or2_2
XFILLER_65_3 vssd1 vssd1 vccd1 vccd1 sky130_fd_sc_hd__fill_2
X_5361_ _5361_/A _5361_/B vssd1 vssd1 vccd1 vccd1 _5362_/B sky130_fd_sc_hd__nor2_2
X_8080_ _7807_/B _8090_/A _7971_/A vssd1 vssd1 vccd1 vccd1 _8093_/B sky130_fd_sc_hd__a21bo_2
X_7100_ _5983_/A _7966_/B _6975_/B _6973_/Y vssd1 vssd1 vccd1 vccd1 _7102_/B sky130_fd_sc_hd__o31a_2
X_5292_ _5283_/X _5291_/Y _5290_/X vssd1 vssd1 vccd1 vccd1 _5296_/A sky130_fd_sc_hd__o21a_2
X_4312_ _4421_/A _4348_/A vssd1 vssd1 vccd1 vccd1 _4353_/A sky130_fd_sc_hd__or2_2
XFILLER_59_209 vssd1 vssd1 vccd1 vccd1 sky130_fd_sc_hd__fill_8
X_7031_ _6785_/A _6785_/B _6783_/X vssd1 vssd1 vccd1 vccd1 _7033_/B sky130_fd_sc_hd__a21oi_2
X_4243_ _8384_/Q _8443_/Q vssd1 vssd1 vccd1 vccd1 _4342_/A sky130_fd_sc_hd__xor2_2
X_4174_ _4207_/B _8412_/Q _4173_/Y vssd1 vssd1 vccd1 vccd1 _4174_/Y sky130_fd_sc_hd__o21ai_2
XFILLER_82_201 vssd1 vssd1 vccd1 vccd1 sky130_fd_sc_hd__fill_2
XTAP_TAPCELL_ROW_2_216 vssd1 vccd1 sky130_fd_sc_hd__tapvpwrvgnd_1
X_7933_ _7934_/A _7934_/B _7934_/C vssd1 vssd1 vccd1 vccd1 _8062_/B sky130_fd_sc_hd__o21a_2
XFILLER_35_18 vssd1 vssd1 vccd1 vccd1 sky130_fd_sc_hd__fill_2
XFILLER_35_29 vssd1 vssd1 vccd1 vccd1 sky130_fd_sc_hd__fill_1
XFILLER_82_278 vssd1 vssd1 vccd1 vccd1 sky130_fd_sc_hd__fill_8
XANTENNA__8125__A _8125_/A vssd1 vssd1 vccd1 vccd1 sky130_fd_sc_hd__diode_2
XFILLER_23_312 vssd1 vssd1 vccd1 vccd1 sky130_fd_sc_hd__fill_1
XFILLER_63_470 vssd1 vssd1 vccd1 vccd1 sky130_fd_sc_hd__fill_2
X_7864_ _7862_/X _7864_/B _8133_/B _7864_/D vssd1 vssd1 vccd1 vccd1 _7865_/B sky130_fd_sc_hd__and4b_2
XTAP_TAPCELL_ROW_85_1051 vssd1 vccd1 sky130_fd_sc_hd__tapvpwrvgnd_1
XFILLER_50_131 vssd1 vssd1 vccd1 vccd1 sky130_fd_sc_hd__fill_1
X_7795_ _7795_/A _7795_/B vssd1 vssd1 vccd1 vccd1 _7796_/B sky130_fd_sc_hd__and2_2
X_6815_ _7140_/A _7140_/B _6894_/B _6903_/C vssd1 vssd1 vccd1 vccd1 _6817_/A sky130_fd_sc_hd__and4_2
XTAP_TAPCELL_ROW_18_381 vssd1 vccd1 sky130_fd_sc_hd__tapvpwrvgnd_1
X_6746_ _8418_/D wire72/X vssd1 vssd1 vccd1 vccd1 _6748_/B sky130_fd_sc_hd__nand2_2
XFILLER_50_197 vssd1 vssd1 vccd1 vccd1 sky130_fd_sc_hd__fill_4
XANTENNA__8162__B1 _6689_/A vssd1 vssd1 vccd1 vccd1 sky130_fd_sc_hd__diode_2
X_6677_ _6677_/A _6677_/B vssd1 vssd1 vccd1 vccd1 _6678_/C sky130_fd_sc_hd__xnor2_2
XANTENNA__4318__A3 _5703_/B vssd1 vssd1 vccd1 vccd1 sky130_fd_sc_hd__diode_2
X_8416_ clkload5/A _8416_/D wire364/X vssd1 vssd1 vccd1 vccd1 _8416_/Q sky130_fd_sc_hd__dfrtp_2
X_5628_ _5638_/A _5628_/B vssd1 vssd1 vccd1 vccd1 _5676_/B sky130_fd_sc_hd__xnor2_2
X_8347_ clkload8/A _8347_/D fanout372/A vssd1 vssd1 vccd1 vccd1 _8347_/Q sky130_fd_sc_hd__dfrtp_2
X_5559_ _5583_/A _5559_/B _5559_/C _5612_/B vssd1 vssd1 vccd1 vccd1 _5566_/A sky130_fd_sc_hd__and4_2
X_8278_ _8278_/A _8278_/B vssd1 vssd1 vccd1 vccd1 _8279_/B sky130_fd_sc_hd__nor2_2
X_7229_ _7130_/A _7132_/B _7130_/B vssd1 vssd1 vccd1 vccd1 _7236_/A sky130_fd_sc_hd__o21ba_2
XFILLER_76_36 vssd1 vssd1 vccd1 vccd1 sky130_fd_sc_hd__fill_2
XFILLER_76_69 vssd1 vssd1 vccd1 vccd1 sky130_fd_sc_hd__fill_4
XFILLER_18_128 vssd1 vssd1 vccd1 vccd1 sky130_fd_sc_hd__fill_1
XFILLER_33_109 vssd1 vssd1 vccd1 vccd1 sky130_fd_sc_hd__fill_1
XTAP_TAPCELL_ROW_72_925 vssd1 vccd1 sky130_fd_sc_hd__tapvpwrvgnd_1
XTAP_TAPCELL_ROW_44_638 vssd1 vccd1 sky130_fd_sc_hd__tapvpwrvgnd_1
XFILLER_92_57 vssd1 vssd1 vccd1 vccd1 sky130_fd_sc_hd__fill_8
XFILLER_6_511 vssd1 vssd1 vccd1 vccd1 sky130_fd_sc_hd__fill_2
XANTENNA__6002__B _6198_/A vssd1 vssd1 vccd1 vccd1 sky130_fd_sc_hd__diode_2
XFILLER_69_518 vssd1 vssd1 vccd1 vccd1 sky130_fd_sc_hd__fill_2
XANTENNA__4457__B wire92/X vssd1 vssd1 vccd1 vccd1 sky130_fd_sc_hd__diode_2
XFILLER_2_55 vssd1 vssd1 vccd1 vccd1 sky130_fd_sc_hd__fill_8
XFILLER_2_77 vssd1 vssd1 vccd1 vccd1 sky130_fd_sc_hd__fill_4
XFILLER_49_264 vssd1 vssd1 vccd1 vccd1 sky130_fd_sc_hd__fill_8
XANTENNA__7967__B1 _7966_/B vssd1 vssd1 vccd1 vccd1 sky130_fd_sc_hd__diode_2
Xteam_03_390 vssd1 vssd1 vccd1 vccd1 team_03_390/HI gpio_oeb[21] sky130_fd_sc_hd__conb_1
XANTENNA__4473__A _4762_/A vssd1 vssd1 vccd1 vccd1 sky130_fd_sc_hd__diode_2
X_4930_ _6588_/A _4931_/D vssd1 vssd1 vccd1 vccd1 _4973_/A sky130_fd_sc_hd__nand2_2
X_4861_ _4862_/A _4862_/B vssd1 vssd1 vccd1 vccd1 _4861_/X sky130_fd_sc_hd__or2_2
X_6600_ _6600_/A _6600_/B vssd1 vssd1 vccd1 vccd1 _6601_/B sky130_fd_sc_hd__nor2_2
XTAP_TAPCELL_ROW_15_351 vssd1 vccd1 sky130_fd_sc_hd__tapvpwrvgnd_1
X_7580_ _7788_/A _7580_/B vssd1 vssd1 vccd1 vccd1 _7582_/C sky130_fd_sc_hd__nor2_2
X_4792_ _4792_/A _4792_/B vssd1 vssd1 vccd1 vccd1 _4795_/A sky130_fd_sc_hd__xor2_2
X_6531_ _6849_/B _6531_/B vssd1 vssd1 vccd1 vccd1 _6533_/C sky130_fd_sc_hd__or2_2
X_6462_ _6553_/A _6462_/B _6462_/C vssd1 vssd1 vccd1 vccd1 _6553_/B sky130_fd_sc_hd__nand3_2
X_8201_ _8202_/A _8202_/B vssd1 vssd1 vccd1 vccd1 _8201_/Y sky130_fd_sc_hd__nor2_2
X_6393_ _6394_/A _6393_/B vssd1 vssd1 vccd1 vccd1 _6393_/X sky130_fd_sc_hd__and2_4
X_5413_ _5864_/B _5413_/B vssd1 vssd1 vccd1 vccd1 _5442_/A sky130_fd_sc_hd__or2_2
XANTENNA__4181__A1 _4207_/B vssd1 vssd1 vccd1 vccd1 sky130_fd_sc_hd__diode_2
XANTENNA__8411__CLK clkload7/A vssd1 vssd1 vccd1 vccd1 sky130_fd_sc_hd__diode_2
XANTENNA_rebuffer462_X _8208_/B vssd1 vssd1 vccd1 vccd1 sky130_fd_sc_hd__diode_2
X_8132_ _8133_/A _8133_/C _8264_/A _8133_/B vssd1 vssd1 vccd1 vccd1 _8134_/A sky130_fd_sc_hd__a22oi_2
X_5344_ _5474_/A _5474_/B vssd1 vssd1 vccd1 vccd1 _5475_/A sky130_fd_sc_hd__nand2_2
X_8063_ _8156_/B _8063_/B vssd1 vssd1 vccd1 vccd1 _8064_/A sky130_fd_sc_hd__nor2_2
X_5275_ _5275_/A vssd1 vssd1 vccd1 vccd1 _5275_/Y sky130_fd_sc_hd__inv_2
X_7014_ _7015_/B _7014_/B vssd1 vssd1 vccd1 vccd1 _7016_/A sky130_fd_sc_hd__nand2b_2
X_4226_ _4226_/A input1/X vssd1 vssd1 vccd1 vccd1 _4226_/X sky130_fd_sc_hd__and2_2
X_4157_ _4160_/B _8429_/Q _4156_/Y vssd1 vssd1 vccd1 vccd1 _4158_/A sky130_fd_sc_hd__o21ai_4
XANTENNA_fanout374_A fanout379/X vssd1 vssd1 vccd1 vccd1 sky130_fd_sc_hd__diode_2
XANTENNA__5984__A2 _6631_/B vssd1 vssd1 vccd1 vccd1 sky130_fd_sc_hd__diode_2
XANTENNA_fanout162_X _6631_/A vssd1 vssd1 vccd1 vccd1 sky130_fd_sc_hd__diode_2
XFILLER_70_226 vssd1 vssd1 vccd1 vccd1 sky130_fd_sc_hd__fill_4
X_7916_ _7917_/A _7917_/B _7917_/C vssd1 vssd1 vccd1 vccd1 _7918_/A sky130_fd_sc_hd__a21oi_2
XFILLER_70_248 vssd1 vssd1 vccd1 vccd1 sky130_fd_sc_hd__fill_4
X_7847_ _7847_/A _7847_/B vssd1 vssd1 vccd1 vccd1 _7848_/B sky130_fd_sc_hd__xnor2_2
XTAP_TAPCELL_ROW_41_608 vssd1 vccd1 sky130_fd_sc_hd__tapvpwrvgnd_1
X_7778_ _7778_/A _7778_/B vssd1 vssd1 vccd1 vccd1 _7780_/A sky130_fd_sc_hd__nor2_2
XANTENNA__4830__B _5930_/A vssd1 vssd1 vccd1 vccd1 sky130_fd_sc_hd__diode_2
X_6729_ _6338_/B _6973_/A _6616_/X vssd1 vssd1 vccd1 vccd1 _6731_/B sky130_fd_sc_hd__a21bo_2
XFILLER_11_31 vssd1 vssd1 vccd1 vccd1 sky130_fd_sc_hd__fill_1
XFILLER_3_503 vssd1 vssd1 vccd1 vccd1 sky130_fd_sc_hd__fill_1
XFILLER_11_53 vssd1 vssd1 vccd1 vccd1 sky130_fd_sc_hd__fill_1
XFILLER_11_75 vssd1 vssd1 vccd1 vccd1 sky130_fd_sc_hd__fill_1
XFILLER_3_525 vssd1 vssd1 vccd1 vccd1 sky130_fd_sc_hd__fill_8
XANTENNA__6757__B _6757_/B vssd1 vssd1 vccd1 vccd1 sky130_fd_sc_hd__diode_2
XFILLER_3_569 vssd1 vssd1 vccd1 vccd1 sky130_fd_sc_hd__fill_1
XFILLER_78_359 vssd1 vssd1 vccd1 vccd1 sky130_fd_sc_hd__fill_4
Xfanout350 _5415_/B vssd1 vssd1 vccd1 vccd1 _5559_/B sky130_fd_sc_hd__clkdlybuf4s25_1
Xfanout383 _4226_/X vssd1 vssd1 vccd1 vccd1 fanout383/X sky130_fd_sc_hd__clkdlybuf4s25_1
Xfanout372 fanout372/A vssd1 vssd1 vccd1 vccd1 fanout372/X sky130_fd_sc_hd__clkdlybuf4s25_1
Xfanout361 wire364/A vssd1 vssd1 vccd1 vccd1 wire362/A sky130_fd_sc_hd__clkdlybuf4s25_1
XFILLER_34_429 vssd1 vssd1 vccd1 vccd1 sky130_fd_sc_hd__fill_1
XTAP_TAPCELL_ROW_57_774 vssd1 vccd1 sky130_fd_sc_hd__tapvpwrvgnd_1
XTAP_TAPCELL_ROW_29_487 vssd1 vccd1 sky130_fd_sc_hd__tapvpwrvgnd_1
XANTENNA__7754__D _8126_/B vssd1 vssd1 vccd1 vccd1 sky130_fd_sc_hd__diode_2
XTAP_TAPCELL_ROW_12_321 vssd1 vccd1 sky130_fd_sc_hd__tapvpwrvgnd_1
XANTENNA__8434__CLK clkload4/A vssd1 vssd1 vccd1 vccd1 sky130_fd_sc_hd__diode_2
Xinput14 gpio_in[4] vssd1 vssd1 vccd1 vccd1 _8174_/B sky130_fd_sc_hd__clkbuf_2
XANTENNA__4163__A1 _8184_/B vssd1 vssd1 vccd1 vccd1 sky130_fd_sc_hd__diode_2
XANTENNA__6948__A _8121_/A vssd1 vssd1 vccd1 vccd1 sky130_fd_sc_hd__diode_2
XFILLER_69_337 vssd1 vccd1 vssd1 vccd1 sky130_ef_sc_hd__decap_40_12
X_5060_ _5067_/A _5108_/A _5059_/Y vssd1 vssd1 vccd1 vccd1 _5064_/A sky130_fd_sc_hd__o21a_2
XANTENNA__7779__A _7990_/A vssd1 vssd1 vccd1 vccd1 sky130_fd_sc_hd__diode_2
XFILLER_28_3 vssd1 vssd1 vccd1 vccd1 sky130_fd_sc_hd__fill_2
XFILLER_52_215 vssd1 vssd1 vccd1 vccd1 sky130_fd_sc_hd__fill_2
X_5962_ _5962_/A _5962_/B vssd1 vssd1 vccd1 vccd1 _5964_/C sky130_fd_sc_hd__xor2_2
X_7701_ _7701_/A _7701_/B vssd1 vssd1 vccd1 vccd1 _7702_/B sky130_fd_sc_hd__and2_2
X_4913_ _5930_/A _6582_/B vssd1 vssd1 vccd1 vccd1 _4914_/B sky130_fd_sc_hd__nand2_2
XTAP_TAPCELL_ROW_82_1021 vssd1 vccd1 sky130_fd_sc_hd__tapvpwrvgnd_1
X_5893_ _5894_/A _5894_/B vssd1 vssd1 vccd1 vccd1 _6177_/B sky130_fd_sc_hd__and2_2
X_7632_ _7632_/A _7632_/B vssd1 vssd1 vccd1 vccd1 _7634_/B sky130_fd_sc_hd__xor2_2
X_4844_ _4845_/A _4845_/B vssd1 vssd1 vccd1 vccd1 _4941_/A sky130_fd_sc_hd__and2b_2
X_7563_ _7563_/A _7563_/B vssd1 vssd1 vccd1 vccd1 _7564_/B sky130_fd_sc_hd__nor2_2
X_4775_ _5155_/A _4487_/B _4700_/B _6572_/A vssd1 vssd1 vccd1 vccd1 _4779_/A sky130_fd_sc_hd__a22oi_2
X_6514_ _6424_/B _6424_/C _6424_/A vssd1 vssd1 vccd1 vccd1 _6515_/B sky130_fd_sc_hd__a21bo_2
X_7494_ _7586_/A _7494_/B _7494_/C vssd1 vssd1 vccd1 vccd1 _7586_/B sky130_fd_sc_hd__nand3_2
X_6445_ _6536_/B _6445_/B vssd1 vssd1 vccd1 vccd1 _6447_/C sky130_fd_sc_hd__or2_2
XANTENNA__4154__A1 _4160_/B vssd1 vssd1 vccd1 vccd1 sky130_fd_sc_hd__diode_2
X_6376_ _6377_/A _6377_/B vssd1 vssd1 vccd1 vccd1 _6378_/A sky130_fd_sc_hd__or2_2
XFILLER_87_101 vssd1 vssd1 vccd1 vccd1 sky130_fd_sc_hd__fill_1
X_8115_ _8023_/A _8023_/B _8022_/A vssd1 vssd1 vccd1 vccd1 _8117_/A sky130_fd_sc_hd__a21oi_2
X_5327_ _5450_/B _5327_/B vssd1 vssd1 vccd1 vccd1 _5329_/B sky130_fd_sc_hd__or2_2
X_8046_ _8147_/B _8046_/B _8046_/C vssd1 vssd1 vccd1 vccd1 _8048_/A sky130_fd_sc_hd__and3_2
XFILLER_75_307 vssd1 vssd1 vccd1 vccd1 sky130_fd_sc_hd__fill_4
X_5258_ _5258_/A _5285_/A _5258_/C vssd1 vssd1 vccd1 vccd1 _5285_/B sky130_fd_sc_hd__nand3_2
XFILLER_56_521 vssd1 vssd1 vccd1 vccd1 sky130_fd_sc_hd__fill_2
X_5189_ _5699_/B _5187_/X _5030_/Y _5032_/Y vssd1 vssd1 vccd1 vccd1 _5191_/B sky130_fd_sc_hd__o211a_2
X_4209_ _4209_/A vssd1 vssd1 vccd1 vccd1 _4209_/Y sky130_fd_sc_hd__inv_2
XFILLER_83_384 vssd1 vssd1 vccd1 vccd1 sky130_fd_sc_hd__fill_2
XANTENNA__8016__C _8264_/A vssd1 vssd1 vccd1 vccd1 sky130_fd_sc_hd__diode_2
XFILLER_71_568 vssd1 vssd1 vccd1 vccd1 sky130_fd_sc_hd__fill_2
XTAP_TAPCELL_ROW_54_744 vssd1 vccd1 sky130_fd_sc_hd__tapvpwrvgnd_1
XTAP_TAPCELL_ROW_26_457 vssd1 vccd1 sky130_fd_sc_hd__tapvpwrvgnd_1
XANTENNA__4560__B _4686_/B vssd1 vssd1 vccd1 vccd1 sky130_fd_sc_hd__diode_2
XANTENNA__8032__B _8136_/B vssd1 vssd1 vccd1 vccd1 sky130_fd_sc_hd__diode_2
XFILLER_22_41 vssd1 vssd1 vccd1 vccd1 sky130_fd_sc_hd__fill_1
XFILLER_22_85 vssd1 vssd1 vccd1 vccd1 sky130_fd_sc_hd__fill_1
XANTENNA__6918__D _7875_/D vssd1 vssd1 vccd1 vccd1 sky130_fd_sc_hd__diode_2
XFILLER_3_399 vssd1 vssd1 vccd1 vccd1 sky130_fd_sc_hd__fill_1
Xfanout180 _8428_/D vssd1 vssd1 vccd1 vccd1 _5928_/A sky130_fd_sc_hd__clkdlybuf4s25_1
Xfanout191 _4207_/B vssd1 vssd1 vccd1 vccd1 _4218_/S sky130_fd_sc_hd__clkdlybuf4s25_1
XANTENNA__4227__S _4227_/S vssd1 vssd1 vccd1 vccd1 sky130_fd_sc_hd__diode_2
XANTENNA__7749__D _8103_/D vssd1 vssd1 vccd1 vccd1 sky130_fd_sc_hd__diode_2
XANTENNA__8207__B _8208_/B vssd1 vssd1 vccd1 vccd1 sky130_fd_sc_hd__diode_2
XFILLER_47_93 vssd1 vssd1 vccd1 vccd1 sky130_fd_sc_hd__fill_4
XPHY_EDGE_ROW_7_Left_100 vssd1 vssd1 vccd1 vccd1 sky130_fd_sc_hd__decap_3
XFILLER_8_54 vssd1 vssd1 vccd1 vccd1 sky130_fd_sc_hd__fill_4
XFILLER_8_76 vssd1 vssd1 vccd1 vccd1 sky130_fd_sc_hd__fill_2
X_4560_ _4623_/A _4686_/B _4568_/B _4560_/D vssd1 vssd1 vccd1 vccd1 _4593_/A sky130_fd_sc_hd__nand4_4
XFILLER_6_171 vssd1 vssd1 vccd1 vccd1 sky130_fd_sc_hd__fill_1
X_4491_ _4492_/A _4492_/B vssd1 vssd1 vccd1 vccd1 _4491_/Y sky130_fd_sc_hd__nor2_2
XANTENNA__7873__A2 _7875_/C vssd1 vssd1 vccd1 vccd1 sky130_fd_sc_hd__diode_2
XFILLER_6_193 vssd1 vssd1 vccd1 vccd1 sky130_fd_sc_hd__fill_2
X_6230_ _6428_/B _6230_/B _6230_/C vssd1 vssd1 vccd1 vccd1 _6453_/A sky130_fd_sc_hd__and3_2
XANTENNA__4687__A2 _4686_/B vssd1 vssd1 vccd1 vccd1 sky130_fd_sc_hd__diode_2
X_6161_ _6161_/A _6161_/B vssd1 vssd1 vccd1 vccd1 _6163_/B sky130_fd_sc_hd__xor2_2
X_5112_ _5112_/A _5782_/A vssd1 vssd1 vccd1 vccd1 _5115_/A sky130_fd_sc_hd__xor2_2
XFILLER_69_167 vssd1 vssd1 vccd1 vccd1 sky130_fd_sc_hd__fill_1
X_6092_ _6576_/A _6701_/B _6572_/B _6294_/A vssd1 vssd1 vccd1 vccd1 _6092_/X sky130_fd_sc_hd__a22o_2
X_5043_ _5103_/A _5042_/B _5042_/C vssd1 vssd1 vccd1 vccd1 _5082_/B sky130_fd_sc_hd__a21o_2
XANTENNA_clkbuf_4_7_0_clk_A clkbuf_0_clk/X vssd1 vssd1 vccd1 vccd1 sky130_fd_sc_hd__diode_2
XFILLER_53_513 vssd1 vssd1 vccd1 vccd1 sky130_fd_sc_hd__fill_4
X_6994_ _6994_/A _6994_/B vssd1 vssd1 vccd1 vccd1 _7026_/A sky130_fd_sc_hd__xnor2_2
X_5945_ _5945_/A _5945_/B vssd1 vssd1 vccd1 vccd1 _5947_/B sky130_fd_sc_hd__xnor2_2
XANTENNA_fanout337_A _6883_/A vssd1 vssd1 vccd1 vccd1 sky130_fd_sc_hd__diode_2
X_5876_ _5876_/A _5876_/B vssd1 vssd1 vccd1 vccd1 _5877_/C sky130_fd_sc_hd__nor2_2
XTAP_TAPCELL_ROW_51_714 vssd1 vccd1 sky130_fd_sc_hd__tapvpwrvgnd_1
XTAP_TAPCELL_ROW_23_427 vssd1 vccd1 sky130_fd_sc_hd__tapvpwrvgnd_1
X_7615_ _7616_/B vssd1 vssd1 vccd1 vccd1 _7615_/Y sky130_fd_sc_hd__inv_2
X_4827_ _4761_/A _6300_/B _4764_/B _4762_/X vssd1 vssd1 vccd1 vccd1 _4836_/A sky130_fd_sc_hd__a31o_2
XANTENNA__5763__Y _5763_/Y vssd1 vssd1 vccd1 vccd1 sky130_fd_sc_hd__diode_2
X_7546_ _7746_/B _7546_/B vssd1 vssd1 vccd1 vccd1 _7548_/A sky130_fd_sc_hd__nand2_2
X_4758_ _4758_/A _4758_/B vssd1 vssd1 vccd1 vccd1 _4802_/A sky130_fd_sc_hd__xnor2_2
XANTENNA__6116__A2 _4770_/B vssd1 vssd1 vccd1 vccd1 sky130_fd_sc_hd__diode_2
X_7477_ _7477_/A _7477_/B _7477_/C vssd1 vssd1 vccd1 vccd1 _7478_/B sky130_fd_sc_hd__nand3_2
X_4689_ _4709_/B _4707_/B _4688_/B _4689_/B1 vssd1 vssd1 vccd1 vccd1 _4691_/B sky130_fd_sc_hd__a31o_2
X_6428_ _6428_/A _6428_/B _6428_/C vssd1 vssd1 vccd1 vccd1 _6451_/B sky130_fd_sc_hd__and3_2
XTAP_TAPCELL_ROW_91_1109 vssd1 vccd1 sky130_fd_sc_hd__tapvpwrvgnd_1
XFILLER_68_26 vssd1 vssd1 vccd1 vccd1 sky130_fd_sc_hd__fill_2
XFILLER_88_421 vssd1 vssd1 vccd1 vccd1 sky130_fd_sc_hd__fill_1
XFILLER_88_443 vssd1 vssd1 vccd1 vccd1 sky130_fd_sc_hd__fill_1
X_6359_ _6365_/A vssd1 vssd1 vccd1 vccd1 _6359_/Y sky130_fd_sc_hd__inv_2
X_8029_ _8136_/A _8136_/C _8136_/D _8030_/A vssd1 vssd1 vccd1 vccd1 _8029_/X sky130_fd_sc_hd__a22o_2
XFILLER_75_137 vssd1 vssd1 vccd1 vccd1 sky130_fd_sc_hd__fill_2
XFILLER_84_25 vssd1 vssd1 vccd1 vccd1 sky130_fd_sc_hd__fill_1
XFILLER_84_47 vssd1 vssd1 vccd1 vccd1 sky130_fd_sc_hd__fill_2
XANTENNA__8027__B _8263_/A vssd1 vssd1 vccd1 vccd1 sky130_fd_sc_hd__diode_2
XFILLER_56_373 vssd1 vssd1 vccd1 vccd1 sky130_fd_sc_hd__fill_1
XFILLER_56_384 vssd1 vssd1 vccd1 vccd1 sky130_fd_sc_hd__fill_1
XFILLER_56_395 vssd1 vssd1 vccd1 vccd1 sky130_fd_sc_hd__fill_1
XTAP_TAPCELL_ROW_39_593 vssd1 vccd1 sky130_fd_sc_hd__tapvpwrvgnd_1
XANTENNA__6770__B _6986_/B vssd1 vssd1 vccd1 vccd1 sky130_fd_sc_hd__diode_2
XPHY_EDGE_ROW_89_Left_182 vssd1 vssd1 vccd1 vccd1 sky130_fd_sc_hd__decap_3
XFILLER_79_432 vssd1 vssd1 vccd1 vccd1 sky130_fd_sc_hd__fill_1
XFILLER_79_476 vssd1 vssd1 vccd1 vccd1 sky130_fd_sc_hd__fill_1
XANTENNA__4746__A _8425_/D vssd1 vssd1 vccd1 vccd1 sky130_fd_sc_hd__diode_2
XANTENNA__6291__A1 _6712_/A vssd1 vssd1 vccd1 vccd1 sky130_fd_sc_hd__diode_2
XFILLER_12_6 vssd1 vssd1 vccd1 vccd1 sky130_fd_sc_hd__fill_2
X_5730_ _5730_/A _5730_/B vssd1 vssd1 vccd1 vccd1 _5732_/B sky130_fd_sc_hd__xor2_2
XFILLER_15_281 vssd1 vssd1 vccd1 vccd1 sky130_fd_sc_hd__fill_1
XANTENNA__8103__D _8103_/D vssd1 vssd1 vccd1 vccd1 sky130_fd_sc_hd__diode_2
X_7400_ _7808_/A _7806_/B vssd1 vssd1 vccd1 vccd1 _7616_/A sky130_fd_sc_hd__nor2_2
X_5661_ _8179_/A _5669_/B _5659_/C vssd1 vssd1 vccd1 vccd1 _5662_/C sky130_fd_sc_hd__a21o_2
X_8380_ clkload2/A _8380_/D fanout369/X vssd1 vssd1 vccd1 vccd1 _8380_/Q sky130_fd_sc_hd__dfrtp_2
Xclkbuf_4_4_0_clk clkbuf_0_clk/X vssd1 vssd1 vccd1 vccd1 clkload4/A sky130_fd_sc_hd__clkbuf_8
X_5592_ _5592_/A _5592_/B vssd1 vssd1 vccd1 vccd1 _5593_/B sky130_fd_sc_hd__xor2_2
X_4612_ _4621_/B _4621_/A vssd1 vssd1 vccd1 vccd1 _4612_/X sky130_fd_sc_hd__or2_4
XANTENNA__8099__A2 _8136_/B vssd1 vssd1 vccd1 vccd1 sky130_fd_sc_hd__diode_2
X_7331_ _7332_/B _7332_/A vssd1 vssd1 vccd1 vccd1 _7331_/X sky130_fd_sc_hd__and2b_2
X_4543_ _4541_/A _4541_/B _4542_/X vssd1 vssd1 vccd1 vccd1 _4546_/A sky130_fd_sc_hd__o21ai_2
X_7262_ _7489_/A _7262_/B vssd1 vssd1 vccd1 vccd1 _7262_/Y sky130_fd_sc_hd__nand2_2
XANTENNA__4199__Y _6723_/A vssd1 vssd1 vccd1 vccd1 sky130_fd_sc_hd__diode_2
XFILLER_89_229 vssd1 vssd1 vccd1 vccd1 sky130_fd_sc_hd__fill_1
Xmax_cap166 _8421_/D vssd1 vssd1 vccd1 vccd1 _7820_/A sky130_fd_sc_hd__clkbuf_4
Xmax_cap155 _5267_/A vssd1 vssd1 vccd1 vccd1 _6978_/A sky130_fd_sc_hd__buf_4
X_6213_ _6213_/A _6213_/B vssd1 vssd1 vccd1 vccd1 _6215_/B sky130_fd_sc_hd__xnor2_2
X_4474_ _4762_/A _5710_/B _5710_/C _4919_/B _8427_/D vssd1 vssd1 vccd1 vccd1 _4474_/X
+ sky130_fd_sc_hd__a32o_2
X_7193_ _7287_/A _7193_/B vssd1 vssd1 vccd1 vccd1 _7196_/A sky130_fd_sc_hd__nor2_2
X_6144_ _7304_/A _6986_/B vssd1 vssd1 vccd1 vccd1 _6338_/A sky130_fd_sc_hd__nor2_2
X_6075_ _6075_/A _6075_/B vssd1 vssd1 vccd1 vccd1 _6076_/B sky130_fd_sc_hd__or2_2
X_5026_ _5026_/A _5026_/B vssd1 vssd1 vccd1 vccd1 _5028_/A sky130_fd_sc_hd__xnor2_2
XFILLER_72_118 vssd1 vssd1 vccd1 vccd1 sky130_fd_sc_hd__fill_4
XFILLER_65_181 vssd1 vssd1 vccd1 vccd1 sky130_fd_sc_hd__fill_2
XTAP_TAPCELL_ROW_88_1082 vssd1 vccd1 sky130_fd_sc_hd__tapvpwrvgnd_1
XANTENNA__7231__B1 _8136_/B vssd1 vssd1 vccd1 vccd1 sky130_fd_sc_hd__diode_2
XFILLER_80_151 vssd1 vssd1 vccd1 vccd1 sky130_fd_sc_hd__fill_2
X_6977_ _6977_/A _6977_/B vssd1 vssd1 vccd1 vccd1 _6979_/A sky130_fd_sc_hd__xor2_2
XTAP_TAPCELL_ROW_36_563 vssd1 vccd1 sky130_fd_sc_hd__tapvpwrvgnd_1
XTAP_TAPCELL_ROW_0_188 vssd1 vccd1 sky130_fd_sc_hd__tapvpwrvgnd_1
X_5928_ _5928_/A _6572_/B _5929_/A vssd1 vssd1 vccd1 vccd1 _5928_/X sky130_fd_sc_hd__and3_2
XTAP_TAPCELL_ROW_0_199 vssd1 vccd1 sky130_fd_sc_hd__tapvpwrvgnd_1
XFILLER_80_195 vssd1 vssd1 vccd1 vccd1 sky130_fd_sc_hd__fill_1
X_5859_ _5442_/A _5442_/B _5441_/A vssd1 vssd1 vccd1 vccd1 _5860_/C sky130_fd_sc_hd__o21ai_2
Xrebuffer500 _4686_/X vssd1 vssd1 vccd1 vccd1 _4689_/B1 sky130_fd_sc_hd__buf_2
X_7529_ _7529_/A _7529_/B vssd1 vssd1 vccd1 vccd1 _7530_/B sky130_fd_sc_hd__or2_2
XANTENNA__6111__A _6572_/A vssd1 vssd1 vccd1 vccd1 sky130_fd_sc_hd__diode_2
XFILLER_79_47 vssd1 vssd1 vccd1 vccd1 sky130_fd_sc_hd__fill_1
XFILLER_88_251 vssd1 vssd1 vccd1 vccd1 sky130_fd_sc_hd__fill_1
XTAP_TAPCELL_ROW_8_277 vssd1 vccd1 sky130_fd_sc_hd__tapvpwrvgnd_1
XANTENNA_input15_A gpio_in[5] vssd1 vssd1 vccd1 vccd1 sky130_fd_sc_hd__diode_2
XANTENNA__8014__A2 _8264_/A vssd1 vssd1 vccd1 vccd1 sky130_fd_sc_hd__diode_2
XFILLER_28_95 vssd1 vssd1 vccd1 vccd1 sky130_fd_sc_hd__fill_2
XFILLER_17_557 vssd1 vssd1 vccd1 vccd1 sky130_fd_sc_hd__fill_2
XANTENNA__6005__B _6005_/B vssd1 vssd1 vccd1 vccd1 sky130_fd_sc_hd__diode_2
XTAP_TAPCELL_ROW_70_897 vssd1 vccd1 sky130_fd_sc_hd__tapvpwrvgnd_1
XANTENNA__5536__B1 _5826_/A vssd1 vssd1 vccd1 vccd1 sky130_fd_sc_hd__diode_2
XFILLER_67_7 vssd1 vssd1 vccd1 vccd1 sky130_fd_sc_hd__fill_2
XANTENNA__8220__B input5/X vssd1 vssd1 vccd1 vccd1 sky130_fd_sc_hd__diode_2
X_4190_ _4198_/B _8409_/Q _4189_/Y vssd1 vssd1 vccd1 vccd1 _5217_/A sky130_fd_sc_hd__o21ai_2
XANTENNA__4476__A _4761_/A vssd1 vssd1 vccd1 vccd1 sky130_fd_sc_hd__diode_2
XFILLER_10_3 vssd1 vssd1 vccd1 vccd1 sky130_fd_sc_hd__fill_4
X_7880_ _7880_/A _7880_/B vssd1 vssd1 vccd1 vccd1 _7882_/B sky130_fd_sc_hd__xnor2_2
X_6900_ _6900_/A _6900_/B _6900_/C vssd1 vssd1 vccd1 vccd1 _6912_/B sky130_fd_sc_hd__nand3_2
XFILLER_23_505 vssd1 vssd1 vccd1 vccd1 sky130_fd_sc_hd__fill_4
X_6831_ _6831_/A _6831_/B vssd1 vssd1 vccd1 vccd1 _6833_/A sky130_fd_sc_hd__nor2_2
XFILLER_62_195 vssd1 vssd1 vccd1 vccd1 sky130_fd_sc_hd__fill_1
X_6762_ _8413_/D _6762_/B vssd1 vssd1 vccd1 vccd1 _6763_/B sky130_fd_sc_hd__nand2_2
XTAP_TAPCELL_ROW_33_533 vssd1 vccd1 sky130_fd_sc_hd__tapvpwrvgnd_1
XANTENNA__7516__A1 _7714_/A vssd1 vssd1 vccd1 vccd1 sky130_fd_sc_hd__diode_2
XANTENNA__7516__B2 _7515_/A vssd1 vssd1 vccd1 vccd1 sky130_fd_sc_hd__diode_2
X_6693_ _6693_/A _6693_/B vssd1 vssd1 vccd1 vccd1 _6790_/A sky130_fd_sc_hd__nand2_2
X_5713_ _5711_/X _5713_/B vssd1 vssd1 vccd1 vccd1 _5715_/A sky130_fd_sc_hd__and2b_2
X_8432_ clkload4/A _8432_/D wire362/A vssd1 vssd1 vccd1 vccd1 _8432_/Q sky130_fd_sc_hd__dfrtp_2
X_5644_ _8165_/A _5838_/A _5670_/B _8168_/A vssd1 vssd1 vccd1 vccd1 _5645_/B sky130_fd_sc_hd__a22oi_2
X_8363_ clkload8/A _8363_/D wire377/X vssd1 vssd1 vccd1 vccd1 _8363_/Q sky130_fd_sc_hd__dfrtp_2
XANTENNA__4150__S _4160_/B vssd1 vssd1 vccd1 vccd1 sky130_fd_sc_hd__diode_2
X_7314_ _7314_/A _7314_/B vssd1 vssd1 vccd1 vccd1 _7316_/B sky130_fd_sc_hd__xnor2_2
X_5575_ _5621_/A _5621_/B vssd1 vssd1 vccd1 vccd1 _5622_/A sky130_fd_sc_hd__and2_2
X_8294_ _6435_/A _8196_/B _8396_/D vssd1 vssd1 vccd1 vccd1 _8369_/D sky130_fd_sc_hd__mux2_1
X_4526_ _4526_/A _4526_/B vssd1 vssd1 vccd1 vccd1 _4528_/A sky130_fd_sc_hd__nor2_2
X_7245_ _8108_/A _8108_/B _8267_/A _8267_/B vssd1 vssd1 vccd1 vccd1 _7246_/B sky130_fd_sc_hd__and4_2
X_4457_ _4902_/A wire92/X vssd1 vssd1 vccd1 vccd1 _4462_/A sky130_fd_sc_hd__nand2_2
X_7176_ _7177_/A _7177_/B vssd1 vssd1 vccd1 vccd1 _7179_/A sky130_fd_sc_hd__nor2_2
XANTENNA_input7_A gpio_in[14] vssd1 vssd1 vccd1 vccd1 sky130_fd_sc_hd__diode_2
X_6127_ _6128_/B vssd1 vssd1 vccd1 vccd1 _6127_/Y sky130_fd_sc_hd__inv_2
X_4388_ _4388_/A _4388_/B vssd1 vssd1 vccd1 vccd1 _4389_/B sky130_fd_sc_hd__nor2_2
XANTENNA_fanout192_X _4207_/B vssd1 vssd1 vccd1 vccd1 sky130_fd_sc_hd__diode_2
XTAP_TAPCELL_ROW_5_247 vssd1 vccd1 sky130_fd_sc_hd__tapvpwrvgnd_1
XFILLER_58_468 vssd1 vssd1 vccd1 vccd1 sky130_fd_sc_hd__fill_1
X_6058_ _6058_/A _6058_/B vssd1 vssd1 vccd1 vccd1 _6060_/A sky130_fd_sc_hd__nor2_2
X_5009_ _5027_/C _5027_/B vssd1 vssd1 vccd1 vccd1 _5028_/B sky130_fd_sc_hd__and2_4
XANTENNA__7204__B1 _7203_/C vssd1 vssd1 vccd1 vccd1 sky130_fd_sc_hd__diode_2
XFILLER_14_505 vssd1 vssd1 vccd1 vccd1 sky130_fd_sc_hd__fill_8
XFILLER_53_151 vssd1 vssd1 vccd1 vccd1 sky130_fd_sc_hd__fill_2
XFILLER_53_162 vssd1 vssd1 vccd1 vccd1 sky130_fd_sc_hd__fill_4
XANTENNA__5367__D _5838_/C vssd1 vssd1 vccd1 vccd1 sky130_fd_sc_hd__diode_2
XFILLER_30_41 vssd1 vccd1 vssd1 vccd1 sky130_ef_sc_hd__decap_40_12
XFILLER_5_225 vssd1 vssd1 vccd1 vccd1 sky130_fd_sc_hd__fill_1
XFILLER_30_74 vssd1 vssd1 vccd1 vccd1 sky130_fd_sc_hd__fill_1
XANTENNA__8414__RESET_B wire364/X vssd1 vssd1 vccd1 vccd1 sky130_fd_sc_hd__diode_2
XANTENNA_clkbuf_4_15_0_clk_A clkbuf_0_clk/X vssd1 vssd1 vccd1 vccd1 sky130_fd_sc_hd__diode_2
XFILLER_1_464 vssd1 vssd1 vccd1 vccd1 sky130_fd_sc_hd__fill_1
XANTENNA__4296__A _8429_/D vssd1 vssd1 vccd1 vccd1 sky130_fd_sc_hd__diode_2
XFILLER_39_72 vssd1 vssd1 vccd1 vccd1 sky130_fd_sc_hd__fill_1
XFILLER_76_232 vssd1 vssd1 vccd1 vccd1 sky130_fd_sc_hd__fill_2
XANTENNA_input18_X _8196_/B vssd1 vssd1 vccd1 vccd1 sky130_fd_sc_hd__diode_2
XFILLER_64_427 vssd1 vssd1 vccd1 vccd1 sky130_fd_sc_hd__fill_2
XFILLER_76_287 vssd1 vssd1 vccd1 vccd1 sky130_fd_sc_hd__fill_1
XTAP_TAPCELL_ROW_47_669 vssd1 vccd1 sky130_fd_sc_hd__tapvpwrvgnd_1
XFILLER_91_279 vssd1 vssd1 vccd1 vccd1 sky130_fd_sc_hd__fill_1
XANTENNA__8215__B input4/X vssd1 vssd1 vccd1 vccd1 sky130_fd_sc_hd__diode_2
XANTENNA__6016__A _6016_/A vssd1 vssd1 vccd1 vccd1 sky130_fd_sc_hd__diode_2
XTAP_TAPCELL_ROW_30_503 vssd1 vccd1 sky130_fd_sc_hd__tapvpwrvgnd_1
XFILLER_71_70 vssd1 vssd1 vccd1 vccd1 sky130_fd_sc_hd__fill_1
XFILLER_9_520 vssd1 vssd1 vccd1 vccd1 sky130_fd_sc_hd__fill_4
X_5360_ _8191_/A _5521_/C _5393_/D _8196_/A vssd1 vssd1 vccd1 vccd1 _5361_/B sky130_fd_sc_hd__a22oi_2
X_5291_ _5291_/A _5291_/B vssd1 vssd1 vccd1 vccd1 _5291_/Y sky130_fd_sc_hd__xnor2_2
X_4311_ _4311_/A _4531_/B _4531_/C vssd1 vssd1 vccd1 vccd1 _4348_/A sky130_fd_sc_hd__or3_2
XFILLER_87_519 vssd1 vssd1 vccd1 vccd1 sky130_fd_sc_hd__fill_1
X_7030_ _7030_/A _7030_/B vssd1 vssd1 vccd1 vccd1 _7033_/A sky130_fd_sc_hd__xnor2_2
X_4242_ _4292_/A _4242_/B vssd1 vssd1 vccd1 vccd1 _4289_/A sky130_fd_sc_hd__nand2_2
XANTENNA__5693__C1 _5692_/Y vssd1 vssd1 vccd1 vccd1 sky130_fd_sc_hd__diode_2
X_4173_ _8196_/B _4207_/B vssd1 vssd1 vccd1 vccd1 _4173_/Y sky130_fd_sc_hd__nand2b_2
XFILLER_67_254 vssd1 vssd1 vccd1 vccd1 sky130_fd_sc_hd__fill_4
XTAP_TAPCELL_ROW_2_217 vssd1 vccd1 sky130_fd_sc_hd__tapvpwrvgnd_1
XFILLER_48_490 vssd1 vssd1 vccd1 vccd1 sky130_fd_sc_hd__fill_2
XFILLER_55_449 vssd1 vssd1 vccd1 vccd1 sky130_fd_sc_hd__fill_1
X_7932_ _8062_/A _7932_/B vssd1 vssd1 vccd1 vccd1 _7934_/C sky130_fd_sc_hd__nor2_2
XANTENNA__8125__B _8125_/B vssd1 vssd1 vccd1 vccd1 sky130_fd_sc_hd__diode_2
X_7863_ _8133_/B _7864_/B _7861_/Y _7862_/X vssd1 vssd1 vccd1 vccd1 _7865_/A sky130_fd_sc_hd__o2bb2a_2
XTAP_TAPCELL_ROW_85_1052 vssd1 vccd1 sky130_fd_sc_hd__tapvpwrvgnd_1
X_7794_ _7795_/A _7795_/B vssd1 vssd1 vccd1 vccd1 _7934_/B sky130_fd_sc_hd__nor2_2
X_6814_ _6492_/A _6494_/B _6492_/B vssd1 vssd1 vccd1 vccd1 _6821_/A sky130_fd_sc_hd__o21ba_2
XTAP_TAPCELL_ROW_18_382 vssd1 vccd1 sky130_fd_sc_hd__tapvpwrvgnd_1
X_6745_ _8418_/D _7326_/B vssd1 vssd1 vccd1 vccd1 _7004_/A sky130_fd_sc_hd__nand2_2
XANTENNA__5765__A _5983_/A vssd1 vssd1 vccd1 vccd1 sky130_fd_sc_hd__diode_2
X_8415_ clkload4/A _8415_/D wire364/X vssd1 vssd1 vccd1 vccd1 _8415_/Q sky130_fd_sc_hd__dfrtp_2
X_6676_ _6676_/A _6676_/B vssd1 vssd1 vccd1 vccd1 _6677_/B sky130_fd_sc_hd__xor2_2
X_5627_ _5651_/A _5634_/B _5617_/B _5620_/A vssd1 vssd1 vccd1 vccd1 _5676_/A sky130_fd_sc_hd__o31ai_2
X_8346_ clkload3/A _8346_/D wire377/X vssd1 vssd1 vccd1 vccd1 _8346_/Q sky130_fd_sc_hd__dfrtp_2
X_5558_ _5558_/A _5558_/B vssd1 vssd1 vccd1 vccd1 _5613_/A sky130_fd_sc_hd__xnor2_2
X_8277_ _8277_/A _8278_/B vssd1 vssd1 vccd1 vccd1 _8281_/C sky130_fd_sc_hd__and2_2
X_4509_ _4412_/A _4412_/B _4410_/X vssd1 vssd1 vccd1 vccd1 _4511_/A sky130_fd_sc_hd__o21ba_2
X_7228_ _7142_/B _7144_/B _7142_/A vssd1 vssd1 vccd1 vccd1 _7238_/A sky130_fd_sc_hd__o21ba_2
X_5489_ _5517_/A _5517_/B vssd1 vssd1 vccd1 vccd1 _5518_/A sky130_fd_sc_hd__nand2_2
X_7159_ _7895_/A _7998_/B _7725_/B _7249_/C vssd1 vssd1 vccd1 vccd1 _7161_/A sky130_fd_sc_hd__and4_2
XFILLER_58_287 vssd1 vssd1 vccd1 vccd1 sky130_fd_sc_hd__fill_2
XANTENNA__5659__B _5669_/B vssd1 vssd1 vccd1 vccd1 sky130_fd_sc_hd__diode_2
XFILLER_73_257 vssd1 vssd1 vccd1 vccd1 sky130_fd_sc_hd__fill_4
XTAP_TAPCELL_ROW_44_639 vssd1 vccd1 sky130_fd_sc_hd__tapvpwrvgnd_1
XFILLER_92_47 vssd1 vssd1 vccd1 vccd1 sky130_fd_sc_hd__fill_2
XFILLER_25_41 vssd1 vssd1 vccd1 vccd1 sky130_fd_sc_hd__fill_2
XFILLER_26_184 vssd1 vssd1 vccd1 vccd1 sky130_fd_sc_hd__fill_1
XFILLER_6_523 vssd1 vssd1 vccd1 vccd1 sky130_fd_sc_hd__fill_1
XANTENNA__4714__A1 _4709_/A vssd1 vssd1 vccd1 vccd1 sky130_fd_sc_hd__diode_2
XANTENNA__4714__B2 _8423_/D vssd1 vssd1 vccd1 vccd1 sky130_fd_sc_hd__diode_2
XFILLER_6_556 vssd1 vssd1 vccd1 vccd1 sky130_fd_sc_hd__fill_4
XFILLER_2_23 vssd1 vssd1 vccd1 vccd1 sky130_fd_sc_hd__fill_4
XPHY_EDGE_ROW_16_Left_109 vssd1 vssd1 vccd1 vccd1 sky130_fd_sc_hd__decap_3
XFILLER_49_243 vssd1 vssd1 vccd1 vccd1 sky130_fd_sc_hd__fill_4
XFILLER_49_254 vssd1 vssd1 vccd1 vccd1 sky130_fd_sc_hd__fill_2
XFILLER_49_287 vssd1 vssd1 vccd1 vccd1 sky130_fd_sc_hd__fill_1
Xteam_03_391 vssd1 vssd1 vccd1 vccd1 team_03_391/HI gpio_oeb[22] sky130_fd_sc_hd__conb_1
XFILLER_92_533 vssd1 vssd1 vccd1 vccd1 sky130_fd_sc_hd__fill_1
XFILLER_45_471 vssd1 vssd1 vccd1 vccd1 sky130_fd_sc_hd__fill_4
XFILLER_52_419 vssd1 vssd1 vccd1 vccd1 sky130_fd_sc_hd__fill_1
X_4860_ _4860_/A _4989_/A vssd1 vssd1 vccd1 vccd1 _4862_/B sky130_fd_sc_hd__xnor2_2
XFILLER_32_165 vssd1 vssd1 vccd1 vccd1 sky130_fd_sc_hd__fill_2
XTAP_TAPCELL_ROW_15_352 vssd1 vccd1 sky130_fd_sc_hd__tapvpwrvgnd_1
XPHY_EDGE_ROW_25_Left_118 vssd1 vssd1 vccd1 vccd1 sky130_fd_sc_hd__decap_3
X_6530_ _6530_/A _6530_/B vssd1 vssd1 vccd1 vccd1 _6531_/B sky130_fd_sc_hd__nor2_2
X_4791_ _4791_/A _4791_/B vssd1 vssd1 vccd1 vccd1 _4792_/B sky130_fd_sc_hd__xor2_2
X_6461_ _6461_/A _6461_/B vssd1 vssd1 vccd1 vccd1 _6462_/C sky130_fd_sc_hd__xnor2_2
XANTENNA__4705__A1 _4709_/B vssd1 vssd1 vccd1 vccd1 sky130_fd_sc_hd__diode_2
X_8200_ _8196_/A _8199_/X _8307_/S vssd1 vssd1 vccd1 vccd1 _8341_/D sky130_fd_sc_hd__mux2_1
X_6392_ _6197_/B _6197_/A _6195_/X vssd1 vssd1 vccd1 vccd1 _6393_/B sky130_fd_sc_hd__a21o_4
X_5412_ _5412_/A _5412_/B _5412_/C vssd1 vssd1 vccd1 vccd1 _5413_/B sky130_fd_sc_hd__nor3_2
X_8131_ _8131_/A _8131_/B _8257_/A _8263_/A vssd1 vssd1 vccd1 vccd1 _8138_/B sky130_fd_sc_hd__and4_2
X_5343_ _5458_/B _5343_/B vssd1 vssd1 vccd1 vccd1 _5474_/B sky130_fd_sc_hd__and2_2
XFILLER_87_316 vssd1 vssd1 vccd1 vccd1 sky130_fd_sc_hd__fill_4
X_8062_ _8062_/A _8062_/B _8062_/C vssd1 vssd1 vccd1 vccd1 _8063_/B sky130_fd_sc_hd__nor3_2
X_5274_ _5983_/A _5274_/B vssd1 vssd1 vccd1 vccd1 _5275_/A sky130_fd_sc_hd__and2_2
XPHY_EDGE_ROW_34_Left_127 vssd1 vssd1 vccd1 vccd1 sky130_fd_sc_hd__decap_3
X_7013_ _6651_/B _6737_/Y _6741_/A _6741_/B vssd1 vssd1 vccd1 vccd1 _7015_/B sky130_fd_sc_hd__a2bb2oi_2
X_4225_ _4224_/A input2/X _8395_/Q vssd1 vssd1 vccd1 vccd1 _8400_/D sky130_fd_sc_hd__and3b_2
X_4156_ input19/X _4160_/B vssd1 vssd1 vccd1 vccd1 _4156_/Y sky130_fd_sc_hd__nand2b_2
XFILLER_83_522 vssd1 vssd1 vccd1 vccd1 sky130_fd_sc_hd__fill_1
XANTENNA__8136__A _8136_/A vssd1 vssd1 vccd1 vccd1 sky130_fd_sc_hd__diode_2
XANTENNA_fanout367_A fanout379/X vssd1 vssd1 vccd1 vccd1 sky130_fd_sc_hd__diode_2
XFILLER_55_279 vssd1 vssd1 vccd1 vccd1 sky130_fd_sc_hd__fill_1
XFILLER_70_216 vssd1 vssd1 vccd1 vccd1 sky130_fd_sc_hd__fill_2
X_7915_ _7750_/A _7752_/B _7750_/B vssd1 vssd1 vccd1 vccd1 _7917_/C sky130_fd_sc_hd__o21ba_2
X_7846_ _7847_/B _7847_/A vssd1 vssd1 vccd1 vccd1 _7846_/Y sky130_fd_sc_hd__nand2b_2
XPHY_EDGE_ROW_43_Left_136 vssd1 vssd1 vccd1 vccd1 sky130_fd_sc_hd__decap_3
XTAP_TAPCELL_ROW_41_609 vssd1 vccd1 sky130_fd_sc_hd__tapvpwrvgnd_1
X_7777_ _7777_/A _7777_/B _7777_/C vssd1 vssd1 vccd1 vccd1 _7778_/B sky130_fd_sc_hd__and3_2
X_4989_ _4989_/A _4989_/B vssd1 vssd1 vccd1 vccd1 _4989_/Y sky130_fd_sc_hd__xnor2_2
XANTENNA__8135__A1 _8136_/B vssd1 vssd1 vccd1 vccd1 sky130_fd_sc_hd__diode_2
XANTENNA__8135__B2 _8136_/A vssd1 vssd1 vccd1 vccd1 sky130_fd_sc_hd__diode_2
XANTENNA_fanout322_X _7515_/A vssd1 vssd1 vccd1 vccd1 sky130_fd_sc_hd__diode_2
X_6728_ _6728_/A _6728_/B vssd1 vssd1 vccd1 vccd1 _6731_/A sky130_fd_sc_hd__xnor2_2
XANTENNA__6146__B1 _6986_/B vssd1 vssd1 vccd1 vccd1 sky130_fd_sc_hd__diode_2
X_6659_ _6351_/A _6351_/B _6355_/A vssd1 vssd1 vccd1 vccd1 _6661_/B sky130_fd_sc_hd__o21ai_2
XFILLER_11_21 vssd1 vssd1 vccd1 vccd1 sky130_fd_sc_hd__fill_1
X_8329_ _8402_/CLK _8329_/D load_slew381/X vssd1 vssd1 vccd1 vccd1 _8329_/Q sky130_fd_sc_hd__dfrtp_2
XPHY_EDGE_ROW_52_Left_145 vssd1 vssd1 vccd1 vccd1 sky130_fd_sc_hd__decap_3
Xfanout340 _5386_/B vssd1 vssd1 vccd1 vccd1 _8179_/A sky130_fd_sc_hd__clkdlybuf4s25_1
Xfanout351 _6001_/A vssd1 vssd1 vccd1 vccd1 _5415_/B sky130_fd_sc_hd__clkdlybuf4s25_1
XANTENNA_fanout68_X _5780_/B vssd1 vssd1 vccd1 vccd1 sky130_fd_sc_hd__diode_2
XFILLER_74_533 vssd1 vssd1 vccd1 vccd1 sky130_fd_sc_hd__fill_1
XANTENNA__5424__A2 _5826_/A vssd1 vssd1 vccd1 vccd1 sky130_fd_sc_hd__diode_2
XTAP_TAPCELL_ROW_57_775 vssd1 vccd1 sky130_fd_sc_hd__tapvpwrvgnd_1
XTAP_TAPCELL_ROW_29_488 vssd1 vccd1 sky130_fd_sc_hd__tapvpwrvgnd_1
XPHY_EDGE_ROW_61_Left_154 vssd1 vssd1 vccd1 vccd1 sky130_fd_sc_hd__decap_3
XFILLER_14_132 vssd1 vssd1 vccd1 vccd1 sky130_fd_sc_hd__fill_2
XFILLER_42_496 vssd1 vssd1 vccd1 vccd1 sky130_fd_sc_hd__fill_2
XFILLER_52_83 vssd1 vssd1 vccd1 vccd1 sky130_fd_sc_hd__fill_1
XFILLER_52_94 vssd1 vssd1 vccd1 vccd1 sky130_fd_sc_hd__fill_4
XTAP_TAPCELL_ROW_12_322 vssd1 vccd1 sky130_fd_sc_hd__tapvpwrvgnd_1
Xinput15 gpio_in[5] vssd1 vssd1 vccd1 vccd1 wire387/A sky130_fd_sc_hd__buf_8
XANTENNA__6948__B _8126_/B vssd1 vssd1 vccd1 vccd1 sky130_fd_sc_hd__diode_2
XPHY_EDGE_ROW_70_Left_163 vssd1 vssd1 vccd1 vccd1 sky130_fd_sc_hd__decap_3
XFILLER_69_349 vssd1 vssd1 vccd1 vccd1 sky130_fd_sc_hd__fill_2
XFILLER_65_566 vssd1 vssd1 vccd1 vccd1 sky130_fd_sc_hd__fill_4
X_5961_ _5962_/A _5961_/B vssd1 vssd1 vccd1 vccd1 _6125_/B sky130_fd_sc_hd__nand2_2
XFILLER_92_363 vssd1 vssd1 vccd1 vccd1 sky130_fd_sc_hd__fill_1
XFILLER_18_482 vssd1 vssd1 vccd1 vccd1 sky130_fd_sc_hd__fill_1
X_7700_ _7701_/A _7701_/B vssd1 vssd1 vccd1 vccd1 _7702_/A sky130_fd_sc_hd__nor2_2
X_4912_ _4912_/A _4912_/B vssd1 vssd1 vccd1 vccd1 _4914_/A sky130_fd_sc_hd__nor2_2
XTAP_TAPCELL_ROW_82_1022 vssd1 vccd1 sky130_fd_sc_hd__tapvpwrvgnd_1
XFILLER_80_569 vssd1 vssd1 vccd1 vccd1 sky130_fd_sc_hd__fill_1
X_7631_ _7632_/A _7632_/B vssd1 vssd1 vccd1 vccd1 _7696_/A sky130_fd_sc_hd__and2_2
X_5892_ _5892_/A _7007_/B vssd1 vssd1 vccd1 vccd1 _5894_/B sky130_fd_sc_hd__nor2_2
XFILLER_60_260 vssd1 vssd1 vccd1 vccd1 sky130_fd_sc_hd__fill_2
X_4843_ _4843_/A _4843_/B vssd1 vssd1 vccd1 vccd1 _4845_/B sky130_fd_sc_hd__nand2_2
X_7562_ _7563_/A _7563_/B vssd1 vssd1 vccd1 vccd1 _7768_/B sky130_fd_sc_hd__and2_2
X_4774_ _4774_/A _4774_/B vssd1 vssd1 vccd1 vccd1 _4792_/A sky130_fd_sc_hd__xnor2_2
X_7493_ _7493_/A _7589_/B vssd1 vssd1 vccd1 vccd1 _7494_/C sky130_fd_sc_hd__nor2_2
X_6513_ _6827_/B _6513_/B vssd1 vssd1 vccd1 vccd1 _6515_/A sky130_fd_sc_hd__nand2_2
XANTENNA_clkbuf_4_3_0_clk_A clkbuf_0_clk/X vssd1 vssd1 vccd1 vccd1 sky130_fd_sc_hd__diode_2
X_6444_ _6444_/A _6444_/B vssd1 vssd1 vccd1 vccd1 _6445_/B sky130_fd_sc_hd__nor2_2
X_6375_ _6375_/A _6375_/B vssd1 vssd1 vccd1 vccd1 _6377_/B sky130_fd_sc_hd__xnor2_2
X_8114_ _8114_/A _8114_/B vssd1 vssd1 vccd1 vccd1 _8118_/A sky130_fd_sc_hd__xnor2_2
X_5326_ _5326_/A _5326_/B vssd1 vssd1 vccd1 vccd1 _5327_/B sky130_fd_sc_hd__nor2_2
XFILLER_87_113 vssd1 vssd1 vccd1 vccd1 sky130_fd_sc_hd__fill_4
X_8045_ _8045_/A _8045_/B vssd1 vssd1 vccd1 vccd1 _8046_/C sky130_fd_sc_hd__xor2_2
X_5257_ _5983_/A _5267_/B _5256_/C _5256_/D vssd1 vssd1 vccd1 vccd1 _5258_/C sky130_fd_sc_hd__o22ai_2
X_4208_ _4207_/B _8417_/Q _4207_/Y vssd1 vssd1 vccd1 vccd1 _4209_/A sky130_fd_sc_hd__o21ai_2
X_5188_ _5030_/Y _5032_/Y _5699_/B _5187_/X vssd1 vssd1 vccd1 vccd1 _5191_/A sky130_fd_sc_hd__a211oi_2
XANTENNA_fanout272_X _8110_/B vssd1 vssd1 vccd1 vccd1 sky130_fd_sc_hd__diode_2
XANTENNA__7800__B1 _6689_/A vssd1 vssd1 vccd1 vccd1 sky130_fd_sc_hd__diode_2
XFILLER_71_514 vssd1 vssd1 vccd1 vccd1 sky130_fd_sc_hd__fill_2
XFILLER_83_352 vssd1 vssd1 vccd1 vccd1 sky130_fd_sc_hd__fill_1
XANTENNA__8016__D _8266_/A vssd1 vssd1 vccd1 vccd1 sky130_fd_sc_hd__diode_2
XFILLER_71_536 vssd1 vssd1 vccd1 vccd1 sky130_fd_sc_hd__fill_1
XFILLER_71_547 vssd1 vssd1 vccd1 vccd1 sky130_fd_sc_hd__fill_4
Xwire72 wire72/A vssd1 vssd1 vccd1 vccd1 wire72/X sky130_fd_sc_hd__buf_4
XTAP_TAPCELL_ROW_54_745 vssd1 vccd1 sky130_fd_sc_hd__tapvpwrvgnd_1
XFILLER_24_463 vssd1 vssd1 vccd1 vccd1 sky130_fd_sc_hd__fill_1
XFILLER_36_290 vssd1 vssd1 vccd1 vccd1 sky130_fd_sc_hd__fill_1
XTAP_TAPCELL_ROW_26_458 vssd1 vccd1 sky130_fd_sc_hd__tapvpwrvgnd_1
XFILLER_11_113 vssd1 vssd1 vccd1 vccd1 sky130_fd_sc_hd__fill_1
X_7829_ _7830_/B _7830_/A vssd1 vssd1 vccd1 vccd1 _7952_/B sky130_fd_sc_hd__nand2b_2
XFILLER_22_97 vssd1 vssd1 vccd1 vccd1 sky130_fd_sc_hd__fill_1
XPHY_EDGE_ROW_5_Left_98 vssd1 vssd1 vccd1 vccd1 sky130_fd_sc_hd__decap_3
XANTENNA__8292__A0 _6438_/A vssd1 vssd1 vccd1 vccd1 sky130_fd_sc_hd__diode_2
Xfanout181 _6712_/A vssd1 vssd1 vccd1 vccd1 _4919_/A sky130_fd_sc_hd__buf_8
Xfanout192 _4223_/B vssd1 vssd1 vccd1 vccd1 _4207_/B sky130_fd_sc_hd__clkdlybuf4s25_1
XFILLER_62_503 vssd1 vssd1 vccd1 vccd1 sky130_fd_sc_hd__fill_2
XFILLER_74_363 vssd1 vssd1 vccd1 vccd1 sky130_fd_sc_hd__fill_1
XANTENNA__4605__B1 _4770_/B vssd1 vssd1 vccd1 vccd1 sky130_fd_sc_hd__diode_2
XFILLER_62_569 vssd1 vssd1 vccd1 vccd1 sky130_fd_sc_hd__fill_1
XFILLER_63_93 vssd1 vssd1 vccd1 vccd1 sky130_fd_sc_hd__fill_2
XANTENNA__4908__A1 _5747_/A vssd1 vssd1 vccd1 vccd1 sky130_fd_sc_hd__diode_2
XFILLER_42_293 vssd1 vssd1 vccd1 vccd1 sky130_fd_sc_hd__fill_2
XFILLER_8_22 vssd1 vssd1 vccd1 vccd1 sky130_fd_sc_hd__fill_1
XFILLER_8_33 vssd1 vssd1 vccd1 vccd1 sky130_fd_sc_hd__fill_4
XANTENNA__5581__A1 _5842_/B vssd1 vssd1 vccd1 vccd1 sky130_fd_sc_hd__diode_2
X_4490_ _4492_/A _4492_/B vssd1 vssd1 vccd1 vccd1 _4493_/A sky130_fd_sc_hd__nand2_2
XANTENNA__6397__C _6397_/C vssd1 vssd1 vccd1 vccd1 sky130_fd_sc_hd__diode_2
X_6160_ _7299_/A _6762_/B _6161_/A vssd1 vssd1 vccd1 vccd1 _6160_/X sky130_fd_sc_hd__and3_2
XANTENNA__6965__Y _7042_/A vssd1 vssd1 vccd1 vccd1 sky130_fd_sc_hd__diode_2
X_5111_ _8412_/D _5899_/B vssd1 vssd1 vccd1 vccd1 _5782_/A sky130_fd_sc_hd__nand2_2
X_6091_ _6091_/A _6572_/B vssd1 vssd1 vccd1 vccd1 _6293_/A sky130_fd_sc_hd__nand2_2
X_5042_ _5103_/A _5042_/B _5042_/C vssd1 vssd1 vccd1 vccd1 _5103_/B sky130_fd_sc_hd__nand3_2
XFILLER_38_555 vssd1 vssd1 vccd1 vccd1 sky130_fd_sc_hd__fill_1
XFILLER_65_341 vssd1 vssd1 vccd1 vccd1 sky130_fd_sc_hd__fill_1
XFILLER_53_503 vssd1 vssd1 vccd1 vccd1 sky130_fd_sc_hd__fill_1
X_6993_ _6993_/A _6993_/B vssd1 vssd1 vccd1 vccd1 _6994_/B sky130_fd_sc_hd__xnor2_2
X_5944_ _5945_/A _5945_/B vssd1 vssd1 vccd1 vccd1 _6097_/A sky130_fd_sc_hd__nand2_2
X_5875_ _5872_/Y _5873_/X _5381_/A _5384_/B vssd1 vssd1 vccd1 vccd1 _5877_/B sky130_fd_sc_hd__a211oi_2
XTAP_TAPCELL_ROW_51_715 vssd1 vccd1 sky130_fd_sc_hd__tapvpwrvgnd_1
XTAP_TAPCELL_ROW_23_428 vssd1 vccd1 sky130_fd_sc_hd__tapvpwrvgnd_1
XANTENNA_fanout232_A _8371_/Q vssd1 vssd1 vccd1 vccd1 sky130_fd_sc_hd__diode_2
X_7614_ _7614_/A _7614_/B vssd1 vssd1 vccd1 vccd1 _7616_/B sky130_fd_sc_hd__xnor2_2
X_4826_ _4825_/B _4825_/C _4825_/A vssd1 vssd1 vccd1 vccd1 _4872_/C sky130_fd_sc_hd__a21o_2
X_7545_ _7746_/A _7544_/B _7544_/C vssd1 vssd1 vccd1 vccd1 _7546_/B sky130_fd_sc_hd__a21o_2
X_4757_ _4758_/B _4758_/A vssd1 vssd1 vccd1 vccd1 _4757_/Y sky130_fd_sc_hd__nand2b_2
X_7476_ _7477_/A _7477_/B _7477_/C vssd1 vssd1 vccd1 vccd1 _7579_/A sky130_fd_sc_hd__a21o_2
X_4688_ _4686_/X _4688_/B vssd1 vssd1 vccd1 vccd1 _4697_/A sky130_fd_sc_hd__and2b_2
X_6427_ _6428_/A _6428_/B _6428_/C vssd1 vssd1 vccd1 vccd1 _6540_/A sky130_fd_sc_hd__a21oi_2
X_6358_ _6358_/A _6358_/B vssd1 vssd1 vccd1 vccd1 _6365_/A sky130_fd_sc_hd__xnor2_2
XANTENNA__6875__Y _6877_/B vssd1 vssd1 vccd1 vccd1 sky130_fd_sc_hd__diode_2
X_5309_ _5618_/A _5392_/B vssd1 vssd1 vccd1 vccd1 _5313_/A sky130_fd_sc_hd__nand2_2
XFILLER_88_477 vssd1 vccd1 vssd1 vccd1 sky130_ef_sc_hd__decap_40_12
X_6289_ _6099_/A _6099_/B _6098_/A vssd1 vssd1 vccd1 vccd1 _6328_/A sky130_fd_sc_hd__a21o_2
X_8028_ _8028_/A _8028_/B vssd1 vssd1 vccd1 vccd1 _8037_/A sky130_fd_sc_hd__xnor2_2
XFILLER_44_514 vssd1 vssd1 vccd1 vccd1 sky130_fd_sc_hd__fill_4
XFILLER_71_300 vssd1 vssd1 vccd1 vccd1 sky130_fd_sc_hd__fill_1
XFILLER_83_160 vssd1 vssd1 vccd1 vccd1 sky130_fd_sc_hd__fill_1
XTAP_TAPCELL_ROW_67_870 vssd1 vccd1 sky130_fd_sc_hd__tapvpwrvgnd_1
XFILLER_17_42 vssd1 vssd1 vccd1 vccd1 sky130_fd_sc_hd__fill_2
XTAP_TAPCELL_ROW_39_594 vssd1 vccd1 sky130_fd_sc_hd__tapvpwrvgnd_1
XANTENNA__5386__C _5386_/C vssd1 vssd1 vccd1 vccd1 sky130_fd_sc_hd__diode_2
XFILLER_12_455 vssd1 vssd1 vccd1 vccd1 sky130_fd_sc_hd__fill_1
XFILLER_33_30 vssd1 vccd1 vssd1 vccd1 sky130_ef_sc_hd__decap_40_12
XFILLER_12_466 vssd1 vssd1 vccd1 vccd1 sky130_fd_sc_hd__fill_1
XFILLER_12_477 vssd1 vssd1 vccd1 vccd1 sky130_fd_sc_hd__fill_2
XANTENNA__7403__A _7603_/A vssd1 vssd1 vccd1 vccd1 sky130_fd_sc_hd__diode_2
XANTENNA__4746__B wire92/X vssd1 vssd1 vccd1 vccd1 sky130_fd_sc_hd__diode_2
XFILLER_66_127 vssd1 vssd1 vccd1 vccd1 sky130_fd_sc_hd__fill_1
XANTENNA__6019__A _7233_/A vssd1 vssd1 vccd1 vccd1 sky130_fd_sc_hd__diode_2
XFILLER_81_119 vssd1 vssd1 vccd1 vccd1 sky130_fd_sc_hd__fill_1
XFILLER_62_333 vssd1 vssd1 vccd1 vccd1 sky130_fd_sc_hd__fill_1
XFILLER_74_70 vssd1 vssd1 vccd1 vccd1 sky130_fd_sc_hd__fill_1
XANTENNA__4762__A _4762_/A vssd1 vssd1 vccd1 vccd1 sky130_fd_sc_hd__diode_2
XFILLER_62_344 vssd1 vssd1 vccd1 vccd1 sky130_fd_sc_hd__fill_4
X_5660_ _5662_/B vssd1 vssd1 vccd1 vccd1 _5660_/Y sky130_fd_sc_hd__inv_2
XFILLER_88_3 vssd1 vssd1 vccd1 vccd1 sky130_fd_sc_hd__fill_1
X_4611_ _4611_/A _4611_/B vssd1 vssd1 vccd1 vccd1 _4621_/A sky130_fd_sc_hd__xnor2_4
XANTENNA__6689__A _6689_/A vssd1 vssd1 vccd1 vccd1 sky130_fd_sc_hd__diode_2
X_5591_ _5625_/A _5625_/B vssd1 vssd1 vccd1 vccd1 _5626_/A sky130_fd_sc_hd__nand2_2
X_7330_ _7051_/A _7051_/B _7053_/X vssd1 vssd1 vccd1 vccd1 _7332_/B sky130_fd_sc_hd__o21ba_2
X_4542_ _4552_/A _4552_/B vssd1 vssd1 vccd1 vccd1 _4542_/X sky130_fd_sc_hd__or2_2
XANTENNA__6503__B1 _6894_/B vssd1 vssd1 vccd1 vccd1 sky130_fd_sc_hd__diode_2
X_7261_ _7261_/A _7261_/B _7261_/C vssd1 vssd1 vccd1 vccd1 _7262_/B sky130_fd_sc_hd__nand3_2
X_4473_ _4762_/A wire99/A vssd1 vssd1 vccd1 vccd1 _4473_/Y sky130_fd_sc_hd__nand2_2
Xmax_cap167 _8420_/D vssd1 vssd1 vccd1 vccd1 _7685_/A sky130_fd_sc_hd__clkbuf_4
X_6212_ _6213_/A _6212_/B _6420_/B vssd1 vssd1 vccd1 vccd1 _6412_/B sky130_fd_sc_hd__or3_2
X_7192_ _7281_/B _7191_/B _7191_/C vssd1 vssd1 vccd1 vccd1 _7193_/B sky130_fd_sc_hd__a21oi_2
X_6143_ _6611_/A _8081_/B vssd1 vssd1 vccd1 vccd1 _6151_/A sky130_fd_sc_hd__nor2_2
XFILLER_85_403 vssd1 vssd1 vccd1 vccd1 sky130_fd_sc_hd__fill_4
Xload_slew373 fanout372/X vssd1 vssd1 vccd1 vccd1 load_slew373/X sky130_fd_sc_hd__clkbuf_2
X_6074_ _6075_/A _6075_/B vssd1 vssd1 vccd1 vccd1 _6277_/B sky130_fd_sc_hd__and2_2
XANTENNA__4148__S _4160_/B vssd1 vssd1 vccd1 vccd1 sky130_fd_sc_hd__diode_2
XFILLER_85_469 vssd1 vssd1 vccd1 vccd1 sky130_fd_sc_hd__fill_4
Xload_slew384 fanout383/X vssd1 vssd1 vccd1 vccd1 load_slew384/X sky130_fd_sc_hd__buf_4
X_5025_ _5026_/A _5026_/B vssd1 vssd1 vccd1 vccd1 _5025_/Y sky130_fd_sc_hd__nand2_2
XFILLER_26_503 vssd1 vssd1 vccd1 vccd1 sky130_fd_sc_hd__fill_1
XFILLER_54_29 vssd1 vssd1 vccd1 vccd1 sky130_fd_sc_hd__fill_1
XTAP_TAPCELL_ROW_88_1083 vssd1 vccd1 sky130_fd_sc_hd__tapvpwrvgnd_1
XANTENNA__7231__A1 _7875_/A vssd1 vssd1 vccd1 vccd1 sky130_fd_sc_hd__diode_2
XFILLER_80_141 vssd1 vssd1 vccd1 vccd1 sky130_fd_sc_hd__fill_2
X_6976_ _6977_/A _6977_/B vssd1 vssd1 vccd1 vccd1 _6976_/Y sky130_fd_sc_hd__nor2_2
XTAP_TAPCELL_ROW_64_840 vssd1 vccd1 sky130_fd_sc_hd__tapvpwrvgnd_1
X_5927_ _5928_/A _6572_/B vssd1 vssd1 vccd1 vccd1 _5929_/B sky130_fd_sc_hd__nand2_2
XTAP_TAPCELL_ROW_36_564 vssd1 vccd1 sky130_fd_sc_hd__tapvpwrvgnd_1
XTAP_TAPCELL_ROW_0_189 vssd1 vccd1 sky130_fd_sc_hd__tapvpwrvgnd_1
XANTENNA_fanout235_X _8126_/A vssd1 vssd1 vccd1 vccd1 sky130_fd_sc_hd__diode_2
X_5858_ _6057_/B _5857_/C _5857_/A vssd1 vssd1 vccd1 vccd1 _5860_/B sky130_fd_sc_hd__a21o_2
Xrebuffer501 fanout140/X vssd1 vssd1 vccd1 vccd1 _5930_/A sky130_fd_sc_hd__buf_2
X_5789_ _7969_/A _7007_/B vssd1 vssd1 vccd1 vccd1 _5791_/B sky130_fd_sc_hd__nor2_2
X_4809_ _4768_/A _4768_/B _4766_/X vssd1 vssd1 vccd1 vccd1 _4823_/A sky130_fd_sc_hd__a21o_2
XPHY_EDGE_ROW_17_Right_17 vssd1 vssd1 vccd1 vccd1 sky130_fd_sc_hd__decap_3
X_7528_ _7529_/A _7529_/B vssd1 vssd1 vccd1 vccd1 _7731_/B sky130_fd_sc_hd__nand2_2
X_7459_ _7459_/A _7459_/B vssd1 vssd1 vccd1 vccd1 _7483_/A sky130_fd_sc_hd__xor2_2
XTAP_TAPCELL_ROW_8_278 vssd1 vccd1 sky130_fd_sc_hd__tapvpwrvgnd_1
XPHY_EDGE_ROW_26_Right_26 vssd1 vssd1 vccd1 vccd1 sky130_fd_sc_hd__decap_3
XFILLER_91_417 vssd1 vssd1 vccd1 vccd1 sky130_fd_sc_hd__fill_1
XANTENNA__7877__B _7877_/B vssd1 vssd1 vccd1 vccd1 sky130_fd_sc_hd__diode_2
XFILLER_17_536 vssd1 vssd1 vccd1 vccd1 sky130_fd_sc_hd__fill_2
XFILLER_56_182 vssd1 vssd1 vccd1 vccd1 sky130_fd_sc_hd__fill_2
XFILLER_84_491 vssd1 vccd1 vssd1 vccd1 sky130_ef_sc_hd__decap_40_12
XFILLER_17_569 vssd1 vssd1 vccd1 vccd1 sky130_fd_sc_hd__fill_1
XANTENNA_clkbuf_4_11_0_clk_A clkbuf_0_clk/X vssd1 vssd1 vccd1 vccd1 sky130_fd_sc_hd__diode_2
XFILLER_8_212 vssd1 vssd1 vccd1 vccd1 sky130_fd_sc_hd__fill_2
XPHY_EDGE_ROW_35_Right_35 vssd1 vssd1 vccd1 vccd1 sky130_fd_sc_hd__decap_3
XTAP_TAPCELL_ROW_70_898 vssd1 vccd1 sky130_fd_sc_hd__tapvpwrvgnd_1
XANTENNA__8238__A0 _8233_/A vssd1 vssd1 vccd1 vccd1 sky130_fd_sc_hd__diode_2
XFILLER_5_78 vssd1 vssd1 vccd1 vccd1 sky130_fd_sc_hd__fill_1
XFILLER_69_70 vssd1 vssd1 vccd1 vccd1 sky130_fd_sc_hd__fill_2
XFILLER_69_92 vssd1 vssd1 vccd1 vccd1 sky130_fd_sc_hd__fill_4
XPHY_EDGE_ROW_44_Right_44 vssd1 vssd1 vccd1 vccd1 sky130_fd_sc_hd__decap_3
XANTENNA__4476__B _5147_/B vssd1 vssd1 vccd1 vccd1 sky130_fd_sc_hd__diode_2
XTAP_TAPCELL_ROW_78_976 vssd1 vccd1 sky130_fd_sc_hd__tapvpwrvgnd_1
X_6830_ _6830_/A _6830_/B _7864_/B _7875_/C vssd1 vssd1 vccd1 vccd1 _6831_/B sky130_fd_sc_hd__and4_2
XFILLER_62_174 vssd1 vssd1 vccd1 vccd1 sky130_fd_sc_hd__fill_4
XFILLER_90_472 vssd1 vssd1 vccd1 vccd1 sky130_fd_sc_hd__fill_4
X_6761_ _6761_/A _6761_/B vssd1 vssd1 vccd1 vccd1 _6763_/A sky130_fd_sc_hd__xnor2_2
XTAP_TAPCELL_ROW_61_810 vssd1 vccd1 sky130_fd_sc_hd__tapvpwrvgnd_1
X_5712_ _8435_/D _5954_/B _6114_/B _8434_/D vssd1 vssd1 vccd1 vccd1 _5713_/B sky130_fd_sc_hd__a22o_2
XTAP_TAPCELL_ROW_33_534 vssd1 vccd1 sky130_fd_sc_hd__tapvpwrvgnd_1
XPHY_EDGE_ROW_53_Right_53 vssd1 vssd1 vccd1 vccd1 sky130_fd_sc_hd__decap_3
XFILLER_31_561 vssd1 vssd1 vccd1 vccd1 sky130_fd_sc_hd__fill_1
X_6692_ _6677_/A _6677_/B _6675_/Y vssd1 vssd1 vccd1 vccd1 _6792_/A sky130_fd_sc_hd__a21o_2
X_8431_ clkload4/A _8431_/D wire362/X vssd1 vssd1 vccd1 vccd1 _8431_/Q sky130_fd_sc_hd__dfrtp_2
X_5643_ _8174_/A _5657_/B vssd1 vssd1 vccd1 vccd1 _5655_/A sky130_fd_sc_hd__nand2_2
X_8362_ _8405_/CLK _8362_/D _4226_/X vssd1 vssd1 vccd1 vccd1 _8362_/Q sky130_fd_sc_hd__dfrtp_2
X_5574_ _5574_/A _5574_/B vssd1 vssd1 vccd1 vccd1 _5621_/B sky130_fd_sc_hd__xnor2_2
X_7313_ _7808_/A _7954_/B _7314_/A vssd1 vssd1 vccd1 vccd1 _7313_/X sky130_fd_sc_hd__or3_2
X_4525_ _4623_/A _4654_/C _4692_/B _4625_/A vssd1 vssd1 vccd1 vccd1 _4526_/B sky130_fd_sc_hd__a22oi_2
X_8293_ _6238_/B _8191_/B _8396_/D vssd1 vssd1 vccd1 vccd1 _8368_/D sky130_fd_sc_hd__mux2_1
X_7244_ _8108_/A _8267_/A _8126_/B _8108_/B vssd1 vssd1 vccd1 vccd1 _7246_/A sky130_fd_sc_hd__a22oi_2
X_4456_ _4744_/A _6701_/B vssd1 vssd1 vccd1 vccd1 _4465_/A sky130_fd_sc_hd__nand2_2
XPHY_EDGE_ROW_62_Right_62 vssd1 vssd1 vccd1 vccd1 sky130_fd_sc_hd__decap_3
X_7175_ _7273_/B _7175_/B vssd1 vssd1 vccd1 vccd1 _7177_/B sky130_fd_sc_hd__nand2_2
X_4387_ _4388_/A _4388_/B vssd1 vssd1 vccd1 vccd1 _4393_/B sky130_fd_sc_hd__and2_2
X_6126_ _6126_/A _6126_/B vssd1 vssd1 vccd1 vccd1 _6128_/B sky130_fd_sc_hd__or2_2
XFILLER_58_458 vssd1 vssd1 vccd1 vccd1 sky130_fd_sc_hd__fill_8
XTAP_TAPCELL_ROW_5_248 vssd1 vccd1 sky130_fd_sc_hd__tapvpwrvgnd_1
X_6057_ _6057_/A _6057_/B _6057_/C vssd1 vssd1 vccd1 vccd1 _6058_/B sky130_fd_sc_hd__and3_2
X_5008_ _5008_/A _5008_/B _5008_/C vssd1 vssd1 vccd1 vccd1 _5027_/B sky130_fd_sc_hd__or3_2
XANTENNA_fanout352_X _6001_/A vssd1 vssd1 vccd1 vccd1 sky130_fd_sc_hd__diode_2
XFILLER_14_539 vssd1 vssd1 vccd1 vccd1 sky130_fd_sc_hd__fill_2
XFILLER_81_16 vssd1 vccd1 vssd1 vccd1 sky130_ef_sc_hd__decap_40_12
XPHY_EDGE_ROW_71_Right_71 vssd1 vssd1 vccd1 vccd1 sky130_fd_sc_hd__decap_3
XFILLER_53_196 vssd1 vssd1 vccd1 vccd1 sky130_fd_sc_hd__fill_1
X_6959_ _7198_/B _6959_/B _6959_/C vssd1 vssd1 vccd1 vccd1 _7201_/A sky130_fd_sc_hd__nor3_2
XFILLER_5_237 vssd1 vssd1 vccd1 vccd1 sky130_fd_sc_hd__fill_1
XFILLER_30_53 vssd1 vssd1 vccd1 vccd1 sky130_fd_sc_hd__fill_1
XPHY_EDGE_ROW_80_Right_80 vssd1 vssd1 vccd1 vccd1 sky130_fd_sc_hd__decap_3
XANTENNA__4296__B _4972_/B vssd1 vssd1 vccd1 vccd1 sky130_fd_sc_hd__diode_2
XFILLER_76_244 vssd1 vssd1 vccd1 vccd1 sky130_fd_sc_hd__fill_1
Xclkbuf_4_3_0_clk clkbuf_0_clk/X vssd1 vssd1 vccd1 vccd1 clkload3/A sky130_fd_sc_hd__clkbuf_8
XTAP_TAPCELL_ROW_75_946 vssd1 vccd1 sky130_fd_sc_hd__tapvpwrvgnd_1
XANTENNA__7400__B _7806_/B vssd1 vssd1 vccd1 vccd1 sky130_fd_sc_hd__diode_2
XTAP_TAPCELL_ROW_30_504 vssd1 vccd1 sky130_fd_sc_hd__tapvpwrvgnd_1
X_5290_ _5283_/B _5283_/C _5283_/A vssd1 vssd1 vccd1 vccd1 _5290_/X sky130_fd_sc_hd__a21o_2
X_4310_ _4311_/A _4772_/B vssd1 vssd1 vccd1 vccd1 _4310_/Y sky130_fd_sc_hd__nor2_2
XANTENNA__4487__A _5157_/A vssd1 vssd1 vccd1 vccd1 sky130_fd_sc_hd__diode_2
X_4241_ _8382_/Q _8441_/Q _4235_/B _4366_/B _4233_/X vssd1 vssd1 vccd1 vccd1 _4292_/B
+ sky130_fd_sc_hd__a221o_2
X_4172_ _4265_/A vssd1 vssd1 vccd1 vccd1 _8423_/D sky130_fd_sc_hd__inv_4
XTAP_TAPCELL_ROW_2_218 vssd1 vccd1 sky130_fd_sc_hd__tapvpwrvgnd_1
XANTENNA__4934__B _4972_/B vssd1 vssd1 vccd1 vccd1 sky130_fd_sc_hd__diode_2
X_7931_ _7931_/A _7931_/B _7931_/C vssd1 vssd1 vccd1 vccd1 _7932_/B sky130_fd_sc_hd__nor3_2
XANTENNA__7310__B _8082_/C vssd1 vssd1 vccd1 vccd1 sky130_fd_sc_hd__diode_2
XANTENNA__6207__A _6207_/A vssd1 vssd1 vccd1 vccd1 sky130_fd_sc_hd__diode_2
X_7862_ _8131_/A _7862_/B _8136_/B _8133_/C vssd1 vssd1 vccd1 vccd1 _7862_/X sky130_fd_sc_hd__and4_2
XTAP_TAPCELL_ROW_85_1053 vssd1 vccd1 sky130_fd_sc_hd__tapvpwrvgnd_1
X_7793_ _7590_/A _7590_/B _7592_/B _7595_/A vssd1 vssd1 vccd1 vccd1 _7795_/B sky130_fd_sc_hd__o31a_2
X_6813_ _6504_/B _6506_/B _6504_/A vssd1 vssd1 vccd1 vccd1 _6823_/A sky130_fd_sc_hd__o21ba_2
XTAP_TAPCELL_ROW_18_383 vssd1 vccd1 sky130_fd_sc_hd__tapvpwrvgnd_1
X_6744_ _7019_/A _6744_/B vssd1 vssd1 vccd1 vccd1 _6752_/A sky130_fd_sc_hd__or2_2
XANTENNA__5765__B _6631_/B vssd1 vssd1 vccd1 vccd1 sky130_fd_sc_hd__diode_2
X_6675_ _6676_/A _6676_/B vssd1 vssd1 vccd1 vccd1 _6675_/Y sky130_fd_sc_hd__nor2_2
XFILLER_31_391 vssd1 vssd1 vccd1 vccd1 sky130_fd_sc_hd__fill_1
X_8414_ clkload4/A _8414_/D wire364/X vssd1 vssd1 vccd1 vccd1 _8414_/Q sky130_fd_sc_hd__dfrtp_2
X_5626_ _5626_/A _5626_/B vssd1 vssd1 vccd1 vccd1 _5628_/B sky130_fd_sc_hd__nand2_2
XANTENNA_fanout312_A _6238_/D vssd1 vssd1 vccd1 vccd1 sky130_fd_sc_hd__diode_2
X_8345_ clkload3/A _8345_/D fanout371/X vssd1 vssd1 vccd1 vccd1 _8345_/Q sky130_fd_sc_hd__dfrtp_2
X_5557_ _5647_/A _5657_/B vssd1 vssd1 vccd1 vccd1 _5558_/B sky130_fd_sc_hd__nand2_2
X_8276_ _8278_/B _8276_/B vssd1 vssd1 vccd1 vccd1 _8357_/D sky130_fd_sc_hd__nor2_2
X_5488_ _5491_/B _5488_/B vssd1 vssd1 vccd1 vccd1 _5517_/B sky130_fd_sc_hd__and2_2
X_4508_ _4508_/A _4508_/B vssd1 vssd1 vccd1 vccd1 _4511_/B sky130_fd_sc_hd__xor2_2
X_7227_ _7227_/A _7227_/B _7227_/C vssd1 vssd1 vccd1 vccd1 _7239_/B sky130_fd_sc_hd__nand3_2
X_4439_ _4439_/A _4439_/B vssd1 vssd1 vccd1 vccd1 _4544_/A sky130_fd_sc_hd__xnor2_2
XFILLER_86_531 vssd1 vssd1 vccd1 vccd1 sky130_fd_sc_hd__fill_1
X_7158_ _7158_/A _7158_/B vssd1 vssd1 vccd1 vccd1 _7168_/A sky130_fd_sc_hd__xnor2_2
XFILLER_58_255 vssd1 vssd1 vccd1 vccd1 sky130_fd_sc_hd__fill_4
X_7089_ _7089_/A _7089_/B vssd1 vssd1 vccd1 vccd1 _7092_/A sky130_fd_sc_hd__xnor2_2
X_6109_ _8434_/D _6704_/B _6703_/B _8433_/D vssd1 vssd1 vccd1 vccd1 _6110_/B sky130_fd_sc_hd__a22oi_2
XANTENNA_fanout58_A _6360_/B vssd1 vssd1 vccd1 vccd1 sky130_fd_sc_hd__diode_2
XFILLER_54_472 vssd1 vssd1 vccd1 vccd1 sky130_fd_sc_hd__fill_4
XTAP_TAPCELL_ROW_72_916 vssd1 vccd1 sky130_fd_sc_hd__tapvpwrvgnd_1
XFILLER_25_53 vssd1 vssd1 vccd1 vccd1 sky130_fd_sc_hd__fill_2
XFILLER_25_64 vssd1 vssd1 vccd1 vccd1 sky130_fd_sc_hd__fill_8
XFILLER_25_86 vssd1 vssd1 vccd1 vccd1 sky130_fd_sc_hd__fill_1
XANTENNA__4714__A2 _4360_/X vssd1 vssd1 vccd1 vccd1 sky130_fd_sc_hd__diode_2
XFILLER_6_546 vssd1 vssd1 vccd1 vccd1 sky130_fd_sc_hd__fill_2
XFILLER_2_13 vssd1 vssd1 vccd1 vccd1 sky130_fd_sc_hd__fill_1
XFILLER_89_391 vssd1 vssd1 vccd1 vccd1 sky130_fd_sc_hd__fill_1
XANTENNA__7967__A2 _7806_/B vssd1 vssd1 vccd1 vccd1 sky130_fd_sc_hd__diode_2
Xteam_03_392 vssd1 vssd1 vccd1 vccd1 team_03_392/HI gpio_oeb[23] sky130_fd_sc_hd__conb_1
XFILLER_92_512 vssd1 vssd1 vccd1 vccd1 sky130_fd_sc_hd__fill_8
XFILLER_17_185 vssd1 vssd1 vccd1 vccd1 sky130_fd_sc_hd__fill_1
XFILLER_72_291 vssd1 vssd1 vccd1 vccd1 sky130_fd_sc_hd__fill_2
XANTENNA__5866__A _6460_/A vssd1 vssd1 vccd1 vccd1 sky130_fd_sc_hd__diode_2
XFILLER_60_464 vssd1 vssd1 vccd1 vccd1 sky130_fd_sc_hd__fill_2
X_4790_ _4791_/A _4791_/B vssd1 vssd1 vccd1 vccd1 _4790_/Y sky130_fd_sc_hd__nand2b_2
XTAP_TAPCELL_ROW_15_353 vssd1 vccd1 sky130_fd_sc_hd__tapvpwrvgnd_1
XFILLER_60_475 vssd1 vssd1 vccd1 vccd1 sky130_fd_sc_hd__fill_1
XFILLER_60_497 vssd1 vssd1 vccd1 vccd1 sky130_fd_sc_hd__fill_2
XFILLER_70_3 vssd1 vssd1 vccd1 vccd1 sky130_fd_sc_hd__fill_4
X_6460_ _6460_/A _8263_/A vssd1 vssd1 vccd1 vccd1 _6461_/B sky130_fd_sc_hd__nand2_2
XANTENNA__4705__A2 _4366_/X vssd1 vssd1 vccd1 vccd1 sky130_fd_sc_hd__diode_2
X_6391_ _6391_/A _6391_/B vssd1 vssd1 vccd1 vccd1 _6394_/A sky130_fd_sc_hd__xor2_2
X_5411_ _5412_/A _5412_/B _5412_/C vssd1 vssd1 vccd1 vccd1 _5864_/B sky130_fd_sc_hd__o21a_2
X_8130_ _6207_/A _8257_/A _8263_/A _8131_/B vssd1 vssd1 vccd1 vccd1 _8138_/A sky130_fd_sc_hd__a22oi_2
X_5342_ _5342_/A _5342_/B _5477_/A vssd1 vssd1 vccd1 vccd1 _5343_/B sky130_fd_sc_hd__or3_2
X_8061_ _8062_/A _8062_/B _8062_/C vssd1 vssd1 vccd1 vccd1 _8156_/B sky130_fd_sc_hd__o21a_2
X_7012_ _7012_/A _7012_/B vssd1 vssd1 vccd1 vccd1 _7014_/B sky130_fd_sc_hd__xnor2_2
X_5273_ _5273_/A _5273_/B vssd1 vssd1 vccd1 vccd1 _5273_/X sky130_fd_sc_hd__or2_2
XFILLER_68_531 vssd1 vssd1 vccd1 vccd1 sky130_fd_sc_hd__fill_1
X_4224_ _4224_/A _8395_/Q vssd1 vssd1 vccd1 vccd1 _8402_/D sky130_fd_sc_hd__and2_2
X_4155_ _4155_/A vssd1 vssd1 vccd1 vccd1 _4155_/Y sky130_fd_sc_hd__inv_2
XANTENNA__5418__B1 _6485_/B vssd1 vssd1 vccd1 vccd1 sky130_fd_sc_hd__diode_2
XFILLER_55_225 vssd1 vssd1 vccd1 vccd1 sky130_fd_sc_hd__fill_1
XFILLER_83_501 vssd1 vssd1 vccd1 vccd1 sky130_fd_sc_hd__fill_2
XANTENNA__8136__B _8136_/B vssd1 vssd1 vccd1 vccd1 sky130_fd_sc_hd__diode_2
XFILLER_83_545 vssd1 vssd1 vccd1 vccd1 sky130_fd_sc_hd__fill_4
X_7914_ _7913_/A _7913_/B _7913_/C vssd1 vssd1 vccd1 vccd1 _7921_/B sky130_fd_sc_hd__o21ai_2
XFILLER_70_239 vssd1 vssd1 vccd1 vccd1 sky130_fd_sc_hd__fill_4
X_7845_ _7845_/A _7845_/B vssd1 vssd1 vccd1 vccd1 _7847_/B sky130_fd_sc_hd__xnor2_2
X_7776_ _7777_/A _7777_/B _7777_/C vssd1 vssd1 vccd1 vccd1 _7778_/A sky130_fd_sc_hd__a21oi_2
X_4988_ _4927_/B _4929_/A _4925_/X vssd1 vssd1 vccd1 vccd1 _4989_/B sky130_fd_sc_hd__a21o_2
X_6727_ _6973_/A _6727_/B vssd1 vssd1 vccd1 vccd1 _6728_/B sky130_fd_sc_hd__xor2_2
XANTENNA__6146__A1 _7304_/A vssd1 vssd1 vccd1 vccd1 sky130_fd_sc_hd__diode_2
XANTENNA__6146__B2 _5983_/A vssd1 vssd1 vccd1 vccd1 sky130_fd_sc_hd__diode_2
XANTENNA_fanout315_X _6238_/D vssd1 vssd1 vccd1 vccd1 sky130_fd_sc_hd__diode_2
X_6658_ _6658_/A _6658_/B vssd1 vssd1 vccd1 vccd1 _6661_/A sky130_fd_sc_hd__xnor2_2
X_5609_ _5610_/A _5610_/B vssd1 vssd1 vccd1 vccd1 _5611_/A sky130_fd_sc_hd__nor2_2
X_8328_ _8402_/CLK _8328_/D fanout380/X vssd1 vssd1 vccd1 vccd1 _8328_/Q sky130_fd_sc_hd__dfrtp_2
X_6589_ _6114_/Y _6309_/X _6588_/Y vssd1 vssd1 vccd1 vccd1 _6589_/Y sky130_fd_sc_hd__a21oi_2
X_8259_ _8259_/A _8259_/B vssd1 vssd1 vccd1 vccd1 _8259_/Y sky130_fd_sc_hd__nand2_2
XFILLER_59_520 vssd1 vssd1 vccd1 vccd1 sky130_fd_sc_hd__fill_2
Xfanout341 _5386_/B vssd1 vssd1 vccd1 vccd1 _5569_/A sky130_fd_sc_hd__clkdlybuf4s25_1
Xfanout330 _6217_/C vssd1 vssd1 vccd1 vccd1 _7210_/A sky130_fd_sc_hd__clkdlybuf4s25_1
Xfanout374 fanout379/X vssd1 vssd1 vccd1 vccd1 fanout374/X sky130_fd_sc_hd__clkdlybuf4s25_1
Xfanout363 _4226_/X vssd1 vssd1 vccd1 vccd1 wire364/A sky130_fd_sc_hd__clkdlybuf4s25_1
Xfanout352 _8336_/Q vssd1 vssd1 vccd1 vccd1 _6001_/A sky130_fd_sc_hd__clkdlybuf4s25_1
XFILLER_74_556 vssd1 vssd1 vccd1 vccd1 sky130_fd_sc_hd__fill_1
XFILLER_36_85 vssd1 vssd1 vccd1 vccd1 sky130_fd_sc_hd__fill_1
XTAP_TAPCELL_ROW_29_489 vssd1 vccd1 sky130_fd_sc_hd__tapvpwrvgnd_1
XFILLER_42_475 vssd1 vssd1 vccd1 vccd1 sky130_fd_sc_hd__fill_1
XANTENNA__4935__A2 _4972_/B vssd1 vssd1 vccd1 vccd1 sky130_fd_sc_hd__diode_2
XTAP_TAPCELL_ROW_12_323 vssd1 vccd1 sky130_fd_sc_hd__tapvpwrvgnd_1
Xinput16 gpio_in[6] vssd1 vssd1 vccd1 vccd1 _8184_/B sky130_fd_sc_hd__buf_6
XANTENNA__5692__Y _5692_/Y vssd1 vssd1 vccd1 vccd1 sky130_fd_sc_hd__diode_2
XANTENNA__8330__CLK _8402_/CLK vssd1 vssd1 vccd1 vccd1 sky130_fd_sc_hd__diode_2
XFILLER_28_5 vssd1 vssd1 vccd1 vccd1 sky130_fd_sc_hd__fill_1
XFILLER_77_70 vssd1 vssd1 vccd1 vccd1 sky130_fd_sc_hd__fill_1
XFILLER_80_515 vssd1 vssd1 vccd1 vccd1 sky130_fd_sc_hd__fill_2
X_5960_ _5962_/B vssd1 vssd1 vccd1 vccd1 _5961_/B sky130_fd_sc_hd__inv_2
XANTENNA__7896__A1_N _8001_/A vssd1 vssd1 vccd1 vccd1 sky130_fd_sc_hd__diode_2
X_5891_ _5891_/A _5891_/B vssd1 vssd1 vccd1 vccd1 _5894_/A sky130_fd_sc_hd__xor2_2
X_4911_ _8429_/D _6704_/B _6300_/B _5928_/A vssd1 vssd1 vccd1 vccd1 _4912_/B sky130_fd_sc_hd__a22oi_2
XFILLER_33_453 vssd1 vssd1 vccd1 vccd1 sky130_fd_sc_hd__fill_1
X_7630_ _7368_/A _7626_/A _7365_/X vssd1 vssd1 vccd1 vccd1 _7632_/B sky130_fd_sc_hd__o21ai_2
XTAP_TAPCELL_ROW_82_1023 vssd1 vccd1 sky130_fd_sc_hd__tapvpwrvgnd_1
XANTENNA__4931__C _4931_/C vssd1 vssd1 vccd1 vccd1 sky130_fd_sc_hd__diode_2
X_4842_ _4842_/A _4842_/B vssd1 vssd1 vccd1 vccd1 _4845_/A sky130_fd_sc_hd__xnor2_2
XANTENNA__4926__A2 _4700_/B vssd1 vssd1 vccd1 vccd1 sky130_fd_sc_hd__diode_2
X_7561_ _7561_/A _7561_/B vssd1 vssd1 vccd1 vccd1 _7563_/B sky130_fd_sc_hd__xnor2_2
X_4773_ _4774_/A _4774_/B vssd1 vssd1 vccd1 vccd1 _4773_/Y sky130_fd_sc_hd__nand2_2
XANTENNA__7325__B1 wire72/X vssd1 vssd1 vccd1 vccd1 sky130_fd_sc_hd__diode_2
X_7492_ _7990_/A _8103_/D _7492_/C vssd1 vssd1 vccd1 vccd1 _7589_/B sky130_fd_sc_hd__and3_2
X_6512_ _6827_/A _6511_/B _6511_/C vssd1 vssd1 vccd1 vccd1 _6513_/B sky130_fd_sc_hd__a21o_2
X_6443_ _6444_/A _6444_/B vssd1 vssd1 vccd1 vccd1 _6536_/B sky130_fd_sc_hd__and2_2
XANTENNA__6220__A _7233_/A vssd1 vssd1 vccd1 vccd1 sky130_fd_sc_hd__diode_2
X_6374_ _6374_/A _6631_/B vssd1 vssd1 vccd1 vccd1 _6375_/B sky130_fd_sc_hd__nor2_2
X_8113_ _8111_/X _8113_/B vssd1 vssd1 vccd1 vccd1 _8114_/B sky130_fd_sc_hd__and2b_2
X_5325_ _5326_/A _5326_/B vssd1 vssd1 vccd1 vccd1 _5450_/B sky130_fd_sc_hd__and2_2
X_8044_ _7883_/B _7883_/C _7883_/A vssd1 vssd1 vccd1 vccd1 _8045_/B sky130_fd_sc_hd__a21bo_2
X_5256_ _5983_/A _5267_/B _5256_/C _5256_/D vssd1 vssd1 vccd1 vccd1 _5285_/A sky130_fd_sc_hd__or4_2
XFILLER_87_158 vssd1 vssd1 vccd1 vccd1 sky130_fd_sc_hd__fill_8
XFILLER_87_169 vssd1 vssd1 vccd1 vccd1 sky130_fd_sc_hd__fill_2
X_4207_ input6/X _4207_/B vssd1 vssd1 vccd1 vccd1 _4207_/Y sky130_fd_sc_hd__nand2b_2
XFILLER_68_361 vssd1 vssd1 vccd1 vccd1 sky130_fd_sc_hd__fill_2
X_5187_ _5699_/A _5185_/X _5023_/Y _5025_/Y vssd1 vssd1 vccd1 vccd1 _5187_/X sky130_fd_sc_hd__o211a_2
XFILLER_56_545 vssd1 vssd1 vccd1 vccd1 sky130_fd_sc_hd__fill_4
XANTENNA_fanout265_X _5838_/C vssd1 vssd1 vccd1 vccd1 sky130_fd_sc_hd__diode_2
XFILLER_73_17 vssd1 vssd1 vccd1 vccd1 sky130_fd_sc_hd__fill_2
XFILLER_73_28 vssd1 vssd1 vccd1 vccd1 sky130_fd_sc_hd__fill_1
XFILLER_71_559 vssd1 vssd1 vccd1 vccd1 sky130_fd_sc_hd__fill_1
XFILLER_83_386 vssd1 vssd1 vccd1 vccd1 sky130_fd_sc_hd__fill_1
XTAP_TAPCELL_ROW_26_459 vssd1 vccd1 sky130_fd_sc_hd__tapvpwrvgnd_1
XFILLER_51_272 vssd1 vssd1 vccd1 vccd1 sky130_fd_sc_hd__fill_1
X_7828_ _7952_/A _7828_/B vssd1 vssd1 vccd1 vccd1 _7830_/B sky130_fd_sc_hd__nand2_2
XANTENNA__6114__B _6114_/B vssd1 vssd1 vccd1 vccd1 sky130_fd_sc_hd__diode_2
X_7759_ _7760_/B _7760_/A vssd1 vssd1 vccd1 vccd1 _7909_/A sky130_fd_sc_hd__and2b_2
XFILLER_11_169 vssd1 vssd1 vccd1 vccd1 sky130_fd_sc_hd__fill_1
XANTENNA__8353__CLK _8405_/CLK vssd1 vssd1 vccd1 vccd1 sky130_fd_sc_hd__diode_2
XFILLER_0_3 vssd1 vssd1 vccd1 vccd1 sky130_fd_sc_hd__fill_1
XANTENNA__8292__A1 _8184_/B vssd1 vssd1 vccd1 vccd1 sky130_fd_sc_hd__diode_2
XFILLER_78_114 vssd1 vssd1 vccd1 vccd1 sky130_fd_sc_hd__fill_1
XFILLER_66_309 vssd1 vssd1 vccd1 vccd1 sky130_fd_sc_hd__fill_4
XFILLER_59_383 vssd1 vssd1 vccd1 vccd1 sky130_fd_sc_hd__fill_1
Xfanout160 _4177_/Y vssd1 vssd1 vccd1 vccd1 _7969_/A sky130_fd_sc_hd__clkdlybuf4s25_1
Xfanout171 _4179_/X vssd1 vssd1 vccd1 vccd1 _5710_/A sky130_fd_sc_hd__buf_8
Xfanout182 _8431_/D vssd1 vssd1 vccd1 vccd1 _6712_/A sky130_fd_sc_hd__buf_8
XFILLER_74_331 vssd1 vssd1 vccd1 vccd1 sky130_fd_sc_hd__fill_8
XFILLER_86_180 vssd1 vssd1 vccd1 vccd1 sky130_fd_sc_hd__fill_2
Xfanout193 _4223_/B vssd1 vssd1 vccd1 vccd1 _4198_/B sky130_fd_sc_hd__clkdlybuf4s25_1
XANTENNA__4605__B2 _4674_/A vssd1 vssd1 vccd1 vccd1 sky130_fd_sc_hd__diode_2
XANTENNA__7555__B1 _7877_/B vssd1 vssd1 vccd1 vccd1 sky130_fd_sc_hd__diode_2
XFILLER_15_464 vssd1 vssd1 vccd1 vccd1 sky130_fd_sc_hd__fill_1
XFILLER_63_72 vssd1 vssd1 vccd1 vccd1 sky130_fd_sc_hd__fill_1
XFILLER_8_45 vssd1 vssd1 vccd1 vccd1 sky130_fd_sc_hd__fill_1
XFILLER_6_151 vssd1 vssd1 vccd1 vccd1 sky130_fd_sc_hd__fill_2
XFILLER_6_195 vssd1 vssd1 vccd1 vccd1 sky130_fd_sc_hd__fill_1
X_6090_ _6090_/A1 _6712_/B _5931_/A _5928_/X vssd1 vssd1 vccd1 vccd1 _6099_/A sky130_fd_sc_hd__a31o_2
X_5110_ _5110_/A _5110_/B vssd1 vssd1 vccd1 vccd1 _5112_/A sky130_fd_sc_hd__xnor2_2
X_5041_ _8406_/D _6997_/B vssd1 vssd1 vccd1 vccd1 _5042_/C sky130_fd_sc_hd__and2_2
XANTENNA__4495__A _4919_/A vssd1 vssd1 vccd1 vccd1 sky130_fd_sc_hd__diode_2
XFILLER_25_206 vssd1 vssd1 vccd1 vccd1 sky130_fd_sc_hd__fill_1
XFILLER_80_301 vssd1 vssd1 vccd1 vccd1 sky130_fd_sc_hd__fill_2
XFILLER_25_217 vssd1 vssd1 vccd1 vccd1 sky130_fd_sc_hd__fill_1
X_6992_ _6993_/B _6993_/A vssd1 vssd1 vccd1 vccd1 _6992_/X sky130_fd_sc_hd__and2b_2
XFILLER_92_194 vssd1 vssd1 vccd1 vccd1 sky130_fd_sc_hd__fill_2
XFILLER_92_183 vssd1 vssd1 vccd1 vccd1 sky130_fd_sc_hd__fill_4
XFILLER_80_356 vssd1 vssd1 vccd1 vccd1 sky130_fd_sc_hd__fill_1
X_5943_ _5943_/A _5943_/B vssd1 vssd1 vccd1 vccd1 _5945_/B sky130_fd_sc_hd__xor2_2
XFILLER_21_401 vssd1 vssd1 vccd1 vccd1 sky130_fd_sc_hd__fill_1
X_5874_ _5381_/A _5384_/B _5872_/Y _5873_/X vssd1 vssd1 vccd1 vccd1 _6071_/B sky130_fd_sc_hd__o211a_2
XTAP_TAPCELL_ROW_23_429 vssd1 vccd1 sky130_fd_sc_hd__tapvpwrvgnd_1
X_7613_ _7969_/A _8081_/B vssd1 vssd1 vccd1 vccd1 _7614_/B sky130_fd_sc_hd__nor2_2
X_4825_ _4825_/A _4825_/B _4825_/C vssd1 vssd1 vccd1 vccd1 _4872_/A sky130_fd_sc_hd__nand3_2
X_7544_ _7746_/A _7544_/B _7544_/C vssd1 vssd1 vccd1 vccd1 _7746_/B sky130_fd_sc_hd__nand3_2
X_4756_ _4756_/A _4756_/B vssd1 vssd1 vccd1 vccd1 _4758_/B sky130_fd_sc_hd__xor2_2
X_7475_ _7569_/B _7475_/B vssd1 vssd1 vccd1 vccd1 _7477_/C sky130_fd_sc_hd__or2_2
X_4687_ _4709_/A _4686_/B _4686_/C _4686_/D vssd1 vssd1 vccd1 vccd1 _4688_/B sky130_fd_sc_hd__a22o_2
X_6426_ _6426_/A _6426_/B vssd1 vssd1 vccd1 vccd1 _6428_/C sky130_fd_sc_hd__or2_2
X_6357_ _6358_/B _6358_/A vssd1 vssd1 vccd1 vccd1 _6357_/X sky130_fd_sc_hd__and2b_2
XFILLER_88_434 vssd1 vssd1 vccd1 vccd1 sky130_fd_sc_hd__fill_1
X_5308_ _5537_/A _5492_/B vssd1 vssd1 vccd1 vccd1 _5493_/A sky130_fd_sc_hd__nand2_2
X_6288_ _6134_/A _6134_/B _6135_/Y vssd1 vssd1 vccd1 vccd1 _6330_/A sky130_fd_sc_hd__o21ai_2
X_8027_ _8133_/B _8263_/A vssd1 vssd1 vccd1 vccd1 _8028_/B sky130_fd_sc_hd__nand2_2
X_5239_ _8410_/D _5254_/B _5254_/C vssd1 vssd1 vccd1 vccd1 _5256_/C sky130_fd_sc_hd__and3_2
XFILLER_84_49 vssd1 vssd1 vccd1 vccd1 sky130_fd_sc_hd__fill_1
XTAP_TAPCELL_ROW_67_871 vssd1 vccd1 sky130_fd_sc_hd__tapvpwrvgnd_1
XFILLER_44_526 vssd1 vssd1 vccd1 vccd1 sky130_fd_sc_hd__fill_4
XFILLER_44_548 vssd1 vssd1 vccd1 vccd1 sky130_fd_sc_hd__fill_2
XTAP_TAPCELL_ROW_39_595 vssd1 vccd1 sky130_fd_sc_hd__tapvpwrvgnd_1
XFILLER_33_42 vssd1 vssd1 vccd1 vccd1 sky130_fd_sc_hd__fill_4
XFILLER_33_64 vssd1 vssd1 vccd1 vccd1 sky130_fd_sc_hd__fill_1
XANTENNA__8408__RESET_B load_slew358/X vssd1 vssd1 vccd1 vccd1 sky130_fd_sc_hd__diode_2
XFILLER_3_110 vssd1 vssd1 vccd1 vccd1 sky130_fd_sc_hd__fill_2
XANTENNA__6795__A _6795_/A vssd1 vssd1 vccd1 vccd1 sky130_fd_sc_hd__diode_2
XFILLER_3_165 vssd1 vssd1 vccd1 vccd1 sky130_fd_sc_hd__fill_1
XANTENNA__7403__B _7966_/B vssd1 vssd1 vccd1 vccd1 sky130_fd_sc_hd__diode_2
XANTENNA__6019__B _7426_/A vssd1 vssd1 vccd1 vccd1 sky130_fd_sc_hd__diode_2
XFILLER_81_109 vssd1 vssd1 vccd1 vccd1 sky130_fd_sc_hd__fill_1
XFILLER_62_301 vssd1 vssd1 vccd1 vccd1 sky130_fd_sc_hd__fill_4
XANTENNA__8399__CLK _8402_/CLK vssd1 vssd1 vccd1 vccd1 sky130_fd_sc_hd__diode_2
XANTENNA_output21_A _8320_/Q vssd1 vssd1 vccd1 vccd1 sky130_fd_sc_hd__diode_2
XANTENNA__6035__A _6435_/A vssd1 vssd1 vccd1 vccd1 sky130_fd_sc_hd__diode_2
X_4610_ _4610_/A _4610_/B vssd1 vssd1 vccd1 vccd1 _4621_/B sky130_fd_sc_hd__xnor2_2
X_5590_ _5590_/A _5590_/B vssd1 vssd1 vccd1 vccd1 _5625_/B sky130_fd_sc_hd__xnor2_2
X_4541_ _4541_/A _4541_/B vssd1 vssd1 vccd1 vccd1 _4552_/B sky130_fd_sc_hd__xnor2_2
XANTENNA__6503__A1 _7140_/A vssd1 vssd1 vccd1 vccd1 sky130_fd_sc_hd__diode_2
XFILLER_7_471 vssd1 vssd1 vccd1 vccd1 sky130_fd_sc_hd__fill_2
X_7260_ _7261_/A _7261_/B _7261_/C vssd1 vssd1 vccd1 vccd1 _7489_/A sky130_fd_sc_hd__a21o_2
X_4472_ _4761_/A _5147_/B vssd1 vssd1 vccd1 vccd1 _4477_/A sky130_fd_sc_hd__nand2_2
XANTENNA__6503__B2 _8126_/A vssd1 vssd1 vccd1 vccd1 sky130_fd_sc_hd__diode_2
Xmax_cap157 _5217_/A vssd1 vssd1 vccd1 vccd1 _7304_/A sky130_fd_sc_hd__buf_2
X_7191_ _7281_/B _7191_/B _7191_/C vssd1 vssd1 vccd1 vccd1 _7287_/A sky130_fd_sc_hd__and3_2
X_6211_ _6212_/B _6420_/B vssd1 vssd1 vccd1 vccd1 _6213_/B sky130_fd_sc_hd__nor2_2
X_6142_ _6332_/B _6614_/B vssd1 vssd1 vccd1 vccd1 _7296_/B sky130_fd_sc_hd__nand2b_2
XTAP_TAPCELL_ROW_90_1100 vssd1 vccd1 sky130_fd_sc_hd__tapvpwrvgnd_1
X_6073_ _5881_/A _5881_/B _5879_/A vssd1 vssd1 vccd1 vccd1 _6075_/B sky130_fd_sc_hd__a21bo_2
X_5024_ _5024_/A _5024_/B vssd1 vssd1 vccd1 vccd1 _5026_/B sky130_fd_sc_hd__xnor2_2
XANTENNA_fanout175_A fanout176/X vssd1 vssd1 vccd1 vccd1 sky130_fd_sc_hd__diode_2
XFILLER_65_183 vssd1 vssd1 vccd1 vccd1 sky130_fd_sc_hd__fill_1
XTAP_TAPCELL_ROW_88_1084 vssd1 vccd1 sky130_fd_sc_hd__tapvpwrvgnd_1
XANTENNA__7231__A2 _8136_/A vssd1 vssd1 vccd1 vccd1 sky130_fd_sc_hd__diode_2
XFILLER_65_194 vssd1 vssd1 vccd1 vccd1 sky130_fd_sc_hd__fill_1
X_6975_ _6975_/A _6975_/B vssd1 vssd1 vccd1 vccd1 _6977_/B sky130_fd_sc_hd__xor2_2
XTAP_TAPCELL_ROW_64_841 vssd1 vccd1 sky130_fd_sc_hd__tapvpwrvgnd_1
XANTENNA_fanout342_A _6795_/A vssd1 vssd1 vccd1 vccd1 sky130_fd_sc_hd__diode_2
XFILLER_0_90 vssd1 vssd1 vccd1 vccd1 sky130_fd_sc_hd__fill_4
XFILLER_41_518 vssd1 vssd1 vccd1 vccd1 sky130_fd_sc_hd__fill_1
X_5926_ _5930_/A _6572_/B _5740_/X _5739_/Y vssd1 vssd1 vccd1 vccd1 _5929_/A sky130_fd_sc_hd__a31o_2
XTAP_TAPCELL_ROW_36_565 vssd1 vccd1 sky130_fd_sc_hd__tapvpwrvgnd_1
XFILLER_80_197 vssd1 vssd1 vccd1 vccd1 sky130_fd_sc_hd__fill_1
XFILLER_70_18 vssd1 vssd1 vccd1 vccd1 sky130_fd_sc_hd__fill_1
X_5857_ _5857_/A _6057_/B _5857_/C vssd1 vssd1 vccd1 vccd1 _5860_/A sky130_fd_sc_hd__nand3_2
XANTENNA_fanout228_X _7140_/A vssd1 vssd1 vccd1 vccd1 sky130_fd_sc_hd__diode_2
Xrebuffer502 _5998_/X vssd1 vssd1 vccd1 vccd1 _5999_/B sky130_fd_sc_hd__buf_2
X_5788_ _5788_/A _5890_/A vssd1 vssd1 vccd1 vccd1 _5791_/A sky130_fd_sc_hd__xor2_2
X_4808_ _4744_/A _4897_/B _4754_/B _4752_/X vssd1 vssd1 vccd1 vccd1 _4825_/A sky130_fd_sc_hd__a31o_2
X_7527_ _7527_/A _7527_/B vssd1 vssd1 vccd1 vccd1 _7529_/B sky130_fd_sc_hd__xnor2_2
X_4739_ _4453_/B _4455_/B _4453_/A vssd1 vssd1 vccd1 vccd1 _4743_/A sky130_fd_sc_hd__a21bo_2
X_7458_ _7458_/A _7458_/B vssd1 vssd1 vccd1 vccd1 _7459_/B sky130_fd_sc_hd__nand2_2
X_6409_ _6409_/A _6409_/B vssd1 vssd1 vccd1 vccd1 _6410_/B sky130_fd_sc_hd__or2_2
X_7389_ _7969_/A _7954_/B vssd1 vssd1 vccd1 vccd1 _7390_/B sky130_fd_sc_hd__nor2_2
XANTENNA__4847__B _4972_/B vssd1 vssd1 vccd1 vccd1 sky130_fd_sc_hd__diode_2
XFILLER_0_113 vssd1 vssd1 vccd1 vccd1 sky130_fd_sc_hd__fill_1
XTAP_TAPCELL_ROW_8_279 vssd1 vccd1 sky130_fd_sc_hd__tapvpwrvgnd_1
XFILLER_88_253 vssd1 vssd1 vccd1 vccd1 sky130_fd_sc_hd__fill_4
XANTENNA_hold554_A _8320_/Q vssd1 vssd1 vccd1 vccd1 sky130_fd_sc_hd__diode_2
XFILLER_28_64 vssd1 vssd1 vccd1 vccd1 sky130_fd_sc_hd__fill_4
XANTENNA__7877__C _8125_/A vssd1 vssd1 vccd1 vccd1 sky130_fd_sc_hd__diode_2
XFILLER_17_559 vssd1 vssd1 vccd1 vccd1 sky130_fd_sc_hd__fill_1
XFILLER_44_334 vssd1 vssd1 vccd1 vccd1 sky130_fd_sc_hd__fill_1
XANTENNA__6430__B1 _8246_/A vssd1 vssd1 vccd1 vccd1 sky130_fd_sc_hd__diode_2
XTAP_TAPCELL_ROW_70_899 vssd1 vccd1 sky130_fd_sc_hd__tapvpwrvgnd_1
XFILLER_5_46 vssd1 vssd1 vccd1 vccd1 sky130_fd_sc_hd__fill_2
XFILLER_5_57 vssd1 vssd1 vccd1 vccd1 sky130_fd_sc_hd__fill_4
XFILLER_5_68 vssd1 vssd1 vccd1 vccd1 sky130_fd_sc_hd__fill_1
XANTENNA__7997__B1 _7897_/B vssd1 vssd1 vccd1 vccd1 sky130_fd_sc_hd__diode_2
XFILLER_39_117 vssd1 vssd1 vccd1 vccd1 sky130_fd_sc_hd__fill_1
XFILLER_79_286 vssd1 vssd1 vccd1 vccd1 sky130_fd_sc_hd__fill_4
XANTENNA__6972__B _8081_/B vssd1 vssd1 vccd1 vccd1 sky130_fd_sc_hd__diode_2
XFILLER_85_70 vssd1 vssd1 vccd1 vccd1 sky130_fd_sc_hd__fill_2
XTAP_TAPCELL_ROW_78_977 vssd1 vccd1 sky130_fd_sc_hd__tapvpwrvgnd_1
XANTENNA__8245__A _8246_/A vssd1 vssd1 vccd1 vccd1 sky130_fd_sc_hd__diode_2
XFILLER_85_81 vssd1 vssd1 vccd1 vccd1 sky130_fd_sc_hd__fill_8
X_6760_ _6761_/A _6761_/B vssd1 vssd1 vccd1 vccd1 _6760_/Y sky130_fd_sc_hd__nand2_2
XTAP_TAPCELL_ROW_61_811 vssd1 vccd1 sky130_fd_sc_hd__tapvpwrvgnd_1
XFILLER_62_197 vssd1 vssd1 vccd1 vccd1 sky130_fd_sc_hd__fill_2
X_5711_ _5711_/A _5956_/A vssd1 vssd1 vccd1 vccd1 _5711_/X sky130_fd_sc_hd__and2_2
XTAP_TAPCELL_ROW_33_535 vssd1 vccd1 sky130_fd_sc_hd__tapvpwrvgnd_1
X_6691_ _6390_/X _6393_/X _6680_/Y _6681_/A vssd1 vssd1 vccd1 vccd1 _6794_/A sky130_fd_sc_hd__o31ai_2
X_8430_ clkload4/A _8430_/D wire362/X vssd1 vssd1 vccd1 vccd1 _8430_/Q sky130_fd_sc_hd__dfrtp_2
X_5642_ _8165_/A _8168_/A _5838_/A _5670_/B vssd1 vssd1 vccd1 vccd1 _5649_/A sky130_fd_sc_hd__and4_2
X_8361_ _8361_/CLK _8361_/D load_slew384/X vssd1 vssd1 vccd1 vccd1 _8361_/Q sky130_fd_sc_hd__dfrtp_2
X_5573_ _5574_/A _5574_/B vssd1 vssd1 vccd1 vccd1 _5587_/B sky130_fd_sc_hd__nand2b_2
XANTENNA__8414__CLK clkload4/A vssd1 vssd1 vccd1 vccd1 sky130_fd_sc_hd__diode_2
X_7312_ _7808_/A _7954_/B vssd1 vssd1 vccd1 vccd1 _7314_/B sky130_fd_sc_hd__nor2_2
X_4524_ _4623_/A _4761_/A _4654_/C _4692_/B vssd1 vssd1 vccd1 vccd1 _4526_/A sky130_fd_sc_hd__and4_2
X_8292_ _6438_/A _8184_/B _8396_/D vssd1 vssd1 vccd1 vccd1 _8367_/D sky130_fd_sc_hd__mux2_1
X_7243_ _7243_/A _7243_/B vssd1 vssd1 vccd1 vccd1 _7267_/A sky130_fd_sc_hd__xor2_2
X_4455_ _4455_/A _4455_/B vssd1 vssd1 vccd1 vccd1 _4455_/Y sky130_fd_sc_hd__xnor2_2
X_7174_ _7174_/A _7174_/B _7172_/Y vssd1 vssd1 vccd1 vccd1 _7175_/B sky130_fd_sc_hd__or3b_2
X_4386_ _4386_/A _4386_/B vssd1 vssd1 vccd1 vccd1 _4388_/B sky130_fd_sc_hd__xnor2_2
XANTENNA__4159__S _4227_/S vssd1 vssd1 vccd1 vccd1 sky130_fd_sc_hd__diode_2
X_6125_ _6125_/A _6125_/B _6125_/C vssd1 vssd1 vccd1 vccd1 _6126_/B sky130_fd_sc_hd__and3_2
XANTENNA_fanout292_A _8352_/Q vssd1 vssd1 vccd1 vccd1 sky130_fd_sc_hd__diode_2
XFILLER_85_223 vssd1 vssd1 vccd1 vccd1 sky130_fd_sc_hd__fill_1
XTAP_TAPCELL_ROW_5_249 vssd1 vccd1 sky130_fd_sc_hd__tapvpwrvgnd_1
XANTENNA__5463__A1 _8228_/A vssd1 vssd1 vccd1 vccd1 sky130_fd_sc_hd__diode_2
X_6056_ _6057_/A _6057_/B _6057_/C vssd1 vssd1 vccd1 vccd1 _6058_/A sky130_fd_sc_hd__a21oi_2
XFILLER_66_481 vssd1 vssd1 vccd1 vccd1 sky130_fd_sc_hd__fill_1
X_5007_ _5008_/A _5008_/B _5008_/C vssd1 vssd1 vccd1 vccd1 _5027_/C sky130_fd_sc_hd__o21ai_2
XFILLER_38_183 vssd1 vssd1 vccd1 vccd1 sky130_fd_sc_hd__fill_1
XTAP_TAPCELL_ROW_49_690 vssd1 vccd1 sky130_fd_sc_hd__tapvpwrvgnd_1
XFILLER_14_529 vssd1 vssd1 vccd1 vccd1 sky130_fd_sc_hd__fill_2
XFILLER_26_367 vssd1 vssd1 vccd1 vccd1 sky130_fd_sc_hd__fill_1
XFILLER_26_389 vssd1 vssd1 vccd1 vccd1 sky130_fd_sc_hd__fill_1
XFILLER_81_28 vssd1 vssd1 vccd1 vccd1 sky130_fd_sc_hd__fill_8
X_6958_ _6867_/A _6867_/B _6870_/A vssd1 vssd1 vccd1 vccd1 _6959_/C sky130_fd_sc_hd__a21oi_2
X_6889_ _6890_/B _6890_/A vssd1 vssd1 vccd1 vccd1 _7137_/A sky130_fd_sc_hd__nand2b_2
X_5909_ _8411_/D _6156_/B vssd1 vssd1 vccd1 vccd1 _5910_/B sky130_fd_sc_hd__nand2_2
XANTENNA__6715__A1 _6576_/A vssd1 vssd1 vccd1 vccd1 sky130_fd_sc_hd__diode_2
XANTENNA__4858__A _8430_/D vssd1 vssd1 vccd1 vccd1 sky130_fd_sc_hd__diode_2
XFILLER_1_422 vssd1 vssd1 vccd1 vccd1 sky130_fd_sc_hd__fill_2
XFILLER_76_234 vssd1 vssd1 vccd1 vccd1 sky130_fd_sc_hd__fill_1
XANTENNA_input20_A nrst vssd1 vssd1 vccd1 vccd1 sky130_fd_sc_hd__diode_2
XFILLER_39_96 vssd1 vssd1 vccd1 vccd1 sky130_fd_sc_hd__fill_1
XFILLER_49_459 vssd1 vssd1 vccd1 vccd1 sky130_fd_sc_hd__fill_1
XFILLER_36_109 vssd1 vssd1 vccd1 vccd1 sky130_fd_sc_hd__fill_1
XTAP_TAPCELL_ROW_75_947 vssd1 vccd1 sky130_fd_sc_hd__tapvpwrvgnd_1
XFILLER_55_51 vssd1 vssd1 vccd1 vccd1 sky130_fd_sc_hd__fill_1
XANTENNA__6403__B1 _6798_/B vssd1 vssd1 vccd1 vccd1 sky130_fd_sc_hd__diode_2
XANTENNA__6016__C _6798_/B vssd1 vssd1 vccd1 vccd1 sky130_fd_sc_hd__diode_2
XANTENNA__8423__RESET_B load_slew360/X vssd1 vssd1 vccd1 vccd1 sky130_fd_sc_hd__diode_2
XFILLER_32_315 vssd1 vssd1 vccd1 vccd1 sky130_fd_sc_hd__fill_1
XFILLER_72_495 vssd1 vssd1 vccd1 vccd1 sky130_fd_sc_hd__fill_4
XTAP_TAPCELL_ROW_30_505 vssd1 vccd1 sky130_fd_sc_hd__tapvpwrvgnd_1
XANTENNA__4487__B _4487_/B vssd1 vssd1 vccd1 vccd1 sky130_fd_sc_hd__diode_2
X_4240_ _8382_/Q _8441_/Q vssd1 vssd1 vccd1 vccd1 _4242_/B sky130_fd_sc_hd__nand2_2
X_4171_ _4227_/S _8423_/Q _4170_/Y vssd1 vssd1 vccd1 vccd1 _4265_/A sky130_fd_sc_hd__o21ai_2
XTAP_TAPCELL_ROW_2_219 vssd1 vccd1 sky130_fd_sc_hd__tapvpwrvgnd_1
XFILLER_55_429 vssd1 vssd1 vccd1 vccd1 sky130_fd_sc_hd__fill_1
X_7930_ _7931_/A _7931_/B _7931_/C vssd1 vssd1 vccd1 vccd1 _8062_/A sky130_fd_sc_hd__o21a_2
XFILLER_48_492 vssd1 vssd1 vccd1 vccd1 sky130_fd_sc_hd__fill_1
XFILLER_82_237 vssd1 vssd1 vccd1 vccd1 sky130_fd_sc_hd__fill_2
X_7861_ _7864_/D vssd1 vssd1 vccd1 vccd1 _7861_/Y sky130_fd_sc_hd__inv_2
XANTENNA__5111__B _5899_/B vssd1 vssd1 vccd1 vccd1 sky130_fd_sc_hd__diode_2
X_6812_ _6812_/A _6812_/B _6812_/C vssd1 vssd1 vccd1 vccd1 _6824_/B sky130_fd_sc_hd__nand3_2
XTAP_TAPCELL_ROW_85_1054 vssd1 vccd1 sky130_fd_sc_hd__tapvpwrvgnd_1
XTAP_TAPCELL_ROW_46_660 vssd1 vccd1 sky130_fd_sc_hd__tapvpwrvgnd_1
XFILLER_50_101 vssd1 vccd1 vssd1 vccd1 sky130_ef_sc_hd__decap_40_12
XFILLER_63_484 vssd1 vssd1 vccd1 vccd1 sky130_fd_sc_hd__fill_1
X_7792_ _7934_/A _7792_/B vssd1 vssd1 vccd1 vccd1 _7795_/A sky130_fd_sc_hd__or2_2
XTAP_TAPCELL_ROW_18_384 vssd1 vccd1 sky130_fd_sc_hd__tapvpwrvgnd_1
X_6743_ _6743_/A _6743_/B _6743_/C vssd1 vssd1 vccd1 vccd1 _6744_/B sky130_fd_sc_hd__nor3_2
X_6674_ _6384_/A _6384_/B _6382_/X vssd1 vssd1 vccd1 vccd1 _6676_/B sky130_fd_sc_hd__a21oi_2
X_8413_ clkload4/A _8413_/D wire362/X vssd1 vssd1 vccd1 vccd1 _8413_/Q sky130_fd_sc_hd__dfrtp_2
X_5625_ _5625_/A _5625_/B vssd1 vssd1 vccd1 vccd1 _5626_/B sky130_fd_sc_hd__or2_2
XANTENNA__6877__B _6877_/B vssd1 vssd1 vccd1 vccd1 sky130_fd_sc_hd__diode_2
XANTENNA_fanout305_A _7140_/D vssd1 vssd1 vccd1 vccd1 sky130_fd_sc_hd__diode_2
X_8344_ _8369_/CLK _8344_/D fanout371/X vssd1 vssd1 vccd1 vccd1 _8344_/Q sky130_fd_sc_hd__dfrtp_2
X_5556_ _5556_/A _5556_/B vssd1 vssd1 vccd1 vccd1 _5558_/A sky130_fd_sc_hd__nor2_2
XANTENNA__5781__B _5899_/B vssd1 vssd1 vccd1 vccd1 sky130_fd_sc_hd__diode_2
X_8275_ _8274_/A _8274_/C hold550/X vssd1 vssd1 vccd1 vccd1 _8276_/B sky130_fd_sc_hd__a21oi_2
X_5487_ _5487_/A _5487_/B _5520_/A vssd1 vssd1 vccd1 vccd1 _5488_/B sky130_fd_sc_hd__or3_2
X_4507_ _4507_/A _4507_/B vssd1 vssd1 vccd1 vccd1 _4508_/B sky130_fd_sc_hd__nor2_4
X_7226_ _7227_/A _7227_/B _7227_/C vssd1 vssd1 vccd1 vccd1 _7458_/A sky130_fd_sc_hd__a21o_2
X_4438_ _4438_/A _4438_/B vssd1 vssd1 vccd1 vccd1 _4439_/B sky130_fd_sc_hd__xnor2_2
XANTENNA_fanout295_X _8257_/A vssd1 vssd1 vccd1 vccd1 sky130_fd_sc_hd__diode_2
XFILLER_86_510 vssd1 vssd1 vccd1 vccd1 sky130_fd_sc_hd__fill_2
X_7157_ _8110_/B _8126_/B vssd1 vssd1 vccd1 vccd1 _7158_/B sky130_fd_sc_hd__nand2_2
X_4369_ _5157_/A _4931_/C vssd1 vssd1 vccd1 vccd1 _4372_/A sky130_fd_sc_hd__nand2_2
XANTENNA__8156__Y _8157_/B vssd1 vssd1 vccd1 vccd1 sky130_fd_sc_hd__diode_2
X_7088_ _7088_/A _7088_/B vssd1 vssd1 vccd1 vccd1 _7089_/B sky130_fd_sc_hd__xnor2_2
X_6108_ _6108_/A _6582_/C vssd1 vssd1 vccd1 vccd1 _6110_/A sky130_fd_sc_hd__and2_2
XFILLER_39_470 vssd1 vccd1 vssd1 vccd1 sky130_ef_sc_hd__decap_40_12
X_6039_ _6039_/A _6039_/B vssd1 vssd1 vccd1 vccd1 _6042_/A sky130_fd_sc_hd__xnor2_2
XTAP_TAPCELL_ROW_72_917 vssd1 vccd1 sky130_fd_sc_hd__tapvpwrvgnd_1
XFILLER_26_197 vssd1 vssd1 vccd1 vccd1 sky130_fd_sc_hd__fill_1
XFILLER_81_292 vssd1 vssd1 vccd1 vccd1 sky130_fd_sc_hd__fill_1
XANTENNA__5911__A2 _6757_/B vssd1 vssd1 vccd1 vccd1 sky130_fd_sc_hd__diode_2
XFILLER_1_252 vssd1 vssd1 vccd1 vccd1 sky130_fd_sc_hd__fill_1
XFILLER_49_223 vssd1 vssd1 vccd1 vccd1 sky130_fd_sc_hd__fill_1
XFILLER_49_256 vssd1 vssd1 vccd1 vccd1 sky130_fd_sc_hd__fill_1
Xteam_03_393 vssd1 vssd1 vccd1 vccd1 team_03_393/HI gpio_oeb[24] sky130_fd_sc_hd__conb_1
XANTENNA__4650__A2 _4686_/B vssd1 vssd1 vccd1 vccd1 sky130_fd_sc_hd__diode_2
XANTENNA__4770__B _4770_/B vssd1 vssd1 vccd1 vccd1 sky130_fd_sc_hd__diode_2
XANTENNA__5866__B _8241_/A vssd1 vssd1 vccd1 vccd1 sky130_fd_sc_hd__diode_2
XTAP_TAPCELL_ROW_43_630 vssd1 vccd1 sky130_fd_sc_hd__tapvpwrvgnd_1
XFILLER_20_307 vssd1 vssd1 vccd1 vccd1 sky130_fd_sc_hd__fill_1
XTAP_TAPCELL_ROW_15_354 vssd1 vccd1 sky130_fd_sc_hd__tapvpwrvgnd_1
XFILLER_13_381 vssd1 vssd1 vccd1 vccd1 sky130_fd_sc_hd__fill_1
XANTENNA__6155__A2 _6360_/B vssd1 vssd1 vccd1 vccd1 sky130_fd_sc_hd__diode_2
XANTENNA__6978__A _6978_/A vssd1 vssd1 vccd1 vccd1 sky130_fd_sc_hd__diode_2
X_6390_ _6391_/A _6391_/B vssd1 vssd1 vccd1 vccd1 _6390_/X sky130_fd_sc_hd__and2_2
X_5410_ _5864_/A _5410_/B vssd1 vssd1 vccd1 vccd1 _5412_/C sky130_fd_sc_hd__nor2_2
XANTENNA__8301__A0 _6397_/C vssd1 vssd1 vccd1 vccd1 sky130_fd_sc_hd__diode_2
X_5341_ _5341_/A _5341_/B vssd1 vssd1 vccd1 vccd1 _5474_/A sky130_fd_sc_hd__xnor2_2
X_8060_ _8156_/A _8060_/B vssd1 vssd1 vccd1 vccd1 _8062_/C sky130_fd_sc_hd__nor2_2
XANTENNA__5106__B _6738_/B vssd1 vssd1 vccd1 vccd1 sky130_fd_sc_hd__diode_2
X_7011_ _7012_/B vssd1 vssd1 vccd1 vccd1 _7011_/Y sky130_fd_sc_hd__inv_2
X_5272_ _8407_/D _5272_/B vssd1 vssd1 vccd1 vccd1 _5273_/B sky130_fd_sc_hd__nand2_2
X_4223_ _8071_/S _4223_/B _4223_/C vssd1 vssd1 vccd1 vccd1 _8506_/A sky130_fd_sc_hd__or3_2
X_4154_ _4160_/B _8430_/Q _4153_/Y vssd1 vssd1 vccd1 vccd1 _4155_/A sky130_fd_sc_hd__o21ai_4
X_7913_ _7913_/A _7913_/B _7913_/C vssd1 vssd1 vccd1 vccd1 _8055_/A sky130_fd_sc_hd__or3_2
XFILLER_70_218 vssd1 vssd1 vccd1 vccd1 sky130_fd_sc_hd__fill_1
XANTENNA_fanout255_A _8367_/Q vssd1 vssd1 vccd1 vccd1 sky130_fd_sc_hd__diode_2
XFILLER_23_101 vssd1 vssd1 vccd1 vccd1 sky130_fd_sc_hd__fill_1
X_7844_ _7703_/A _7703_/B _7702_/A vssd1 vssd1 vccd1 vccd1 _7845_/B sky130_fd_sc_hd__a21oi_2
XFILLER_51_454 vssd1 vssd1 vccd1 vccd1 sky130_fd_sc_hd__fill_8
X_7775_ _7551_/A _7553_/B _7551_/B vssd1 vssd1 vccd1 vccd1 _7777_/C sky130_fd_sc_hd__o21ba_2
XFILLER_51_498 vssd1 vssd1 vccd1 vccd1 sky130_fd_sc_hd__fill_1
X_6726_ _6970_/A _7095_/B _7095_/C vssd1 vssd1 vccd1 vccd1 _6727_/B sky130_fd_sc_hd__and3_2
X_4987_ _4987_/A _4987_/B vssd1 vssd1 vccd1 vccd1 _4991_/B sky130_fd_sc_hd__xor2_2
XANTENNA__6146__A2 _6631_/B vssd1 vssd1 vccd1 vccd1 sky130_fd_sc_hd__diode_2
X_6657_ _6658_/A _6658_/B vssd1 vssd1 vccd1 vccd1 _6755_/B sky130_fd_sc_hd__or2_2
XANTENNA__4157__A1 _4160_/B vssd1 vssd1 vccd1 vccd1 sky130_fd_sc_hd__diode_2
XANTENNA_fanout308_X _7140_/D vssd1 vssd1 vccd1 vccd1 sky130_fd_sc_hd__diode_2
Xclkbuf_4_2_0_clk clkbuf_0_clk/X vssd1 vssd1 vccd1 vccd1 clkload2/A sky130_fd_sc_hd__clkbuf_8
X_6588_ _6588_/A wire99/X vssd1 vssd1 vccd1 vccd1 _6588_/Y sky130_fd_sc_hd__nand2_2
X_5608_ _8179_/A _5657_/B vssd1 vssd1 vccd1 vccd1 _5610_/B sky130_fd_sc_hd__nand2_2
X_8327_ _8405_/CLK _8327_/D fanout382/X vssd1 vssd1 vccd1 vccd1 _8327_/Q sky130_fd_sc_hd__dfrtp_2
X_5539_ _5498_/A _5494_/B _5494_/C vssd1 vssd1 vccd1 vccd1 _5540_/C sky130_fd_sc_hd__o21ai_2
XFILLER_11_89 vssd1 vssd1 vccd1 vccd1 sky130_fd_sc_hd__fill_2
X_8258_ _4144_/Y _8255_/X _8256_/Y _8257_/X vssd1 vssd1 vccd1 vccd1 _8350_/D sky130_fd_sc_hd__o31a_2
XFILLER_59_510 vssd1 vssd1 vccd1 vccd1 sky130_fd_sc_hd__fill_1
X_8189_ _8183_/Y _8187_/B _8185_/B vssd1 vssd1 vccd1 vccd1 _8193_/A sky130_fd_sc_hd__o21a_2
Xfanout331 _8341_/Q vssd1 vssd1 vccd1 vccd1 _6217_/C sky130_fd_sc_hd__clkdlybuf4s25_1
Xfanout320 _8208_/A vssd1 vssd1 vccd1 vccd1 _6035_/C sky130_fd_sc_hd__clkdlybuf4s25_1
X_7209_ hold545/X _7208_/Y _7658_/S vssd1 vssd1 vccd1 vccd1 _8327_/D sky130_fd_sc_hd__mux2_1
Xfanout353 _5583_/A vssd1 vssd1 vccd1 vccd1 _8165_/A sky130_fd_sc_hd__clkdlybuf4s25_1
Xfanout342 _6795_/A vssd1 vssd1 vccd1 vccd1 _5386_/B sky130_fd_sc_hd__clkdlybuf4s25_1
XFILLER_74_524 vssd1 vssd1 vccd1 vccd1 sky130_fd_sc_hd__fill_8
XFILLER_86_373 vssd1 vssd1 vccd1 vccd1 sky130_fd_sc_hd__fill_1
XTAP_TAPCELL_ROW_57_766 vssd1 vccd1 sky130_fd_sc_hd__tapvpwrvgnd_1
XFILLER_42_498 vssd1 vssd1 vccd1 vccd1 sky130_fd_sc_hd__fill_1
XTAP_TAPCELL_ROW_40_600 vssd1 vccd1 sky130_fd_sc_hd__tapvpwrvgnd_1
XFILLER_52_85 vssd1 vssd1 vccd1 vccd1 sky130_fd_sc_hd__fill_2
XTAP_TAPCELL_ROW_12_324 vssd1 vccd1 sky130_fd_sc_hd__tapvpwrvgnd_1
Xinput17 gpio_in[7] vssd1 vssd1 vccd1 vccd1 _8191_/B sky130_fd_sc_hd__buf_6
XANTENNA__4148__A1 input7/X vssd1 vssd1 vccd1 vccd1 sky130_fd_sc_hd__diode_2
XFILLER_6_355 vssd1 vssd1 vccd1 vccd1 sky130_fd_sc_hd__fill_1
XANTENNA__7863__A2_N _7864_/B vssd1 vssd1 vccd1 vccd1 sky130_fd_sc_hd__diode_2
XANTENNA__6038__A _6438_/A vssd1 vssd1 vccd1 vccd1 sky130_fd_sc_hd__diode_2
XANTENNA__8253__A _8257_/A vssd1 vssd1 vccd1 vccd1 sky130_fd_sc_hd__diode_2
XFILLER_33_421 vssd1 vssd1 vccd1 vccd1 sky130_fd_sc_hd__fill_1
X_5890_ _5890_/A _6173_/A vssd1 vssd1 vccd1 vccd1 _6177_/A sky130_fd_sc_hd__nor2_2
X_4910_ _8429_/D _5928_/A _6704_/B _6300_/B vssd1 vssd1 vccd1 vccd1 _4912_/A sky130_fd_sc_hd__and4_2
X_4841_ _5710_/A _4931_/D vssd1 vssd1 vccd1 vccd1 _4842_/B sky130_fd_sc_hd__nand2_2
XTAP_TAPCELL_ROW_82_1024 vssd1 vccd1 sky130_fd_sc_hd__tapvpwrvgnd_1
XFILLER_20_104 vssd1 vssd1 vccd1 vccd1 sky130_fd_sc_hd__fill_2
X_7560_ _7561_/B _7561_/A vssd1 vssd1 vccd1 vccd1 _7768_/A sky130_fd_sc_hd__and2b_2
X_4772_ _4772_/A _4772_/B vssd1 vssd1 vccd1 vccd1 _4774_/B sky130_fd_sc_hd__nor2_2
X_7491_ _7990_/A _8103_/D _7492_/C vssd1 vssd1 vccd1 vccd1 _7493_/A sky130_fd_sc_hd__a21oi_2
X_6511_ _6827_/A _6511_/B _6511_/C vssd1 vssd1 vccd1 vccd1 _6827_/B sky130_fd_sc_hd__nand3_2
X_6442_ _6442_/A _6442_/B vssd1 vssd1 vccd1 vccd1 _6444_/B sky130_fd_sc_hd__xnor2_2
XANTENNA__6220__B _7515_/A vssd1 vssd1 vccd1 vccd1 sky130_fd_sc_hd__diode_2
XANTENNA_rebuffer460_X _8428_/D vssd1 vssd1 vccd1 vccd1 sky130_fd_sc_hd__diode_2
X_8112_ _8111_/A _8111_/B _8111_/C _8111_/D vssd1 vssd1 vccd1 vccd1 _8113_/B sky130_fd_sc_hd__a22o_2
X_6373_ _6373_/A _6631_/C vssd1 vssd1 vccd1 vccd1 _6375_/A sky130_fd_sc_hd__xor2_2
X_5324_ _5324_/A _5324_/B vssd1 vssd1 vccd1 vccd1 _5326_/B sky130_fd_sc_hd__xnor2_2
X_8043_ _8043_/A _8043_/B vssd1 vssd1 vccd1 vccd1 _8045_/A sky130_fd_sc_hd__nor2_2
X_5255_ _8409_/D _5254_/B _5215_/C vssd1 vssd1 vccd1 vccd1 _5256_/D sky130_fd_sc_hd__a21oi_2
X_4206_ _5892_/A vssd1 vssd1 vccd1 vccd1 _8415_/D sky130_fd_sc_hd__inv_2
XFILLER_56_513 vssd1 vssd1 vccd1 vccd1 sky130_fd_sc_hd__fill_8
X_5186_ _5023_/Y _5025_/Y _5699_/A _5185_/X vssd1 vssd1 vccd1 vccd1 _5699_/B sky130_fd_sc_hd__a211oi_2
XFILLER_71_505 vssd1 vssd1 vccd1 vccd1 sky130_fd_sc_hd__fill_4
XFILLER_71_516 vssd1 vssd1 vccd1 vccd1 sky130_fd_sc_hd__fill_1
XANTENNA_fanout160_X _7969_/A vssd1 vssd1 vccd1 vccd1 sky130_fd_sc_hd__diode_2
XTAP_TAPCELL_ROW_54_736 vssd1 vccd1 sky130_fd_sc_hd__tapvpwrvgnd_1
X_7827_ _7827_/A _7827_/B vssd1 vssd1 vccd1 vccd1 _7828_/B sky130_fd_sc_hd__nand2_2
XFILLER_11_126 vssd1 vssd1 vccd1 vccd1 sky130_fd_sc_hd__fill_2
X_7758_ _7556_/B _7558_/B _7556_/A vssd1 vssd1 vccd1 vccd1 _7760_/B sky130_fd_sc_hd__o21ba_2
X_7689_ _7689_/A _7689_/B vssd1 vssd1 vccd1 vccd1 _7692_/A sky130_fd_sc_hd__xnor2_2
X_6709_ _6709_/A _6709_/B vssd1 vssd1 vccd1 vccd1 _6710_/B sky130_fd_sc_hd__xnor2_2
XANTENNA_fanout73_X _5899_/B vssd1 vssd1 vccd1 vccd1 sky130_fd_sc_hd__diode_2
Xfanout161 _6631_/A vssd1 vssd1 vccd1 vccd1 _7668_/A sky130_fd_sc_hd__clkdlybuf4s25_1
Xfanout183 _6572_/A vssd1 vssd1 vccd1 vccd1 _5157_/A sky130_fd_sc_hd__buf_8
Xfanout194 _8404_/Q vssd1 vssd1 vccd1 vccd1 _4223_/B sky130_fd_sc_hd__clkdlybuf4s25_1
XFILLER_62_516 vssd1 vssd1 vccd1 vccd1 sky130_fd_sc_hd__fill_2
XFILLER_74_365 vssd1 vssd1 vccd1 vccd1 sky130_fd_sc_hd__fill_1
XANTENNA__7555__A1 _8103_/A vssd1 vssd1 vccd1 vccd1 sky130_fd_sc_hd__diode_2
XANTENNA__7555__B2 _7754_/B vssd1 vssd1 vccd1 vccd1 sky130_fd_sc_hd__diode_2
XFILLER_69_115 vssd1 vssd1 vccd1 vccd1 sky130_fd_sc_hd__fill_4
XFILLER_69_137 vssd1 vssd1 vccd1 vccd1 sky130_fd_sc_hd__fill_4
X_5040_ _5040_/A _5040_/B vssd1 vssd1 vccd1 vccd1 _5040_/X sky130_fd_sc_hd__xor2_2
XFILLER_26_3 vssd1 vssd1 vccd1 vccd1 sky130_fd_sc_hd__fill_4
XFILLER_38_535 vssd1 vssd1 vccd1 vccd1 sky130_fd_sc_hd__fill_1
XFILLER_38_568 vssd1 vssd1 vccd1 vccd1 sky130_fd_sc_hd__fill_2
XFILLER_53_505 vssd1 vssd1 vccd1 vccd1 sky130_fd_sc_hd__fill_2
X_6991_ _6991_/A _6991_/B vssd1 vssd1 vccd1 vccd1 _6993_/B sky130_fd_sc_hd__xor2_2
XFILLER_53_549 vssd1 vssd1 vccd1 vccd1 sky130_fd_sc_hd__fill_1
XFILLER_65_398 vssd1 vssd1 vccd1 vccd1 sky130_fd_sc_hd__fill_4
X_5942_ _5728_/B _6106_/A _5941_/Y vssd1 vssd1 vccd1 vccd1 _5943_/B sky130_fd_sc_hd__o21ai_2
XANTENNA__5400__A _8228_/A vssd1 vssd1 vccd1 vccd1 sky130_fd_sc_hd__diode_2
X_5873_ _5869_/Y _5870_/Y _5454_/B _5456_/A vssd1 vssd1 vccd1 vccd1 _5873_/X sky130_fd_sc_hd__a211o_2
XTAP_TAPCELL_ROW_51_706 vssd1 vccd1 sky130_fd_sc_hd__tapvpwrvgnd_1
XANTENNA__8133__D _8264_/A vssd1 vssd1 vccd1 vccd1 sky130_fd_sc_hd__diode_2
X_7612_ _8077_/A _7954_/B vssd1 vssd1 vccd1 vccd1 _7614_/A sky130_fd_sc_hd__nor2_2
X_4824_ _4891_/B _4823_/C _4823_/A vssd1 vssd1 vccd1 vccd1 _4825_/C sky130_fd_sc_hd__a21o_2
X_7543_ _7543_/A _7543_/B vssd1 vssd1 vccd1 vccd1 _7544_/C sky130_fd_sc_hd__xnor2_2
X_4755_ _4756_/B _4756_/A vssd1 vssd1 vccd1 vccd1 _4755_/Y sky130_fd_sc_hd__nand2b_2
X_7474_ _7474_/A _7474_/B vssd1 vssd1 vccd1 vccd1 _7475_/B sky130_fd_sc_hd__nor2_2
X_4686_ _4709_/A _4686_/B _4686_/C _4686_/D vssd1 vssd1 vccd1 vccd1 _4686_/X sky130_fd_sc_hd__and4_2
X_6425_ _6424_/A _6424_/B _6424_/C vssd1 vssd1 vccd1 vccd1 _6426_/B sky130_fd_sc_hd__a21oi_2
X_6356_ _6173_/A _6348_/A _6175_/A _6175_/B vssd1 vssd1 vccd1 vccd1 _6358_/B sky130_fd_sc_hd__a2bb2oi_2
XANTENNA__4686__A _4709_/A vssd1 vssd1 vccd1 vccd1 sky130_fd_sc_hd__diode_2
XFILLER_68_29 vssd1 vssd1 vccd1 vccd1 sky130_fd_sc_hd__fill_1
X_5307_ _5307_/A _5307_/B vssd1 vssd1 vccd1 vccd1 _5492_/B sky130_fd_sc_hd__xnor2_2
XANTENNA__8360__RESET_B load_slew384/X vssd1 vssd1 vccd1 vccd1 sky130_fd_sc_hd__diode_2
X_8026_ _8026_/A _8026_/B vssd1 vssd1 vccd1 vccd1 _8028_/A sky130_fd_sc_hd__nor2_2
X_6287_ _6164_/A _6164_/B _6162_/X vssd1 vssd1 vccd1 vccd1 _6343_/A sky130_fd_sc_hd__o21bai_2
X_5238_ _8409_/D _5274_/B vssd1 vssd1 vccd1 vccd1 _5254_/C sky130_fd_sc_hd__and2_2
XFILLER_68_170 vssd1 vssd1 vccd1 vccd1 sky130_fd_sc_hd__fill_4
XFILLER_68_181 vssd1 vssd1 vccd1 vccd1 sky130_fd_sc_hd__fill_2
X_5169_ _5169_/A _5169_/B vssd1 vssd1 vccd1 vccd1 _5171_/B sky130_fd_sc_hd__xor2_2
XFILLER_17_55 vssd1 vssd1 vccd1 vccd1 sky130_fd_sc_hd__fill_1
XFILLER_83_184 vssd1 vssd1 vccd1 vccd1 sky130_fd_sc_hd__fill_1
XTAP_TAPCELL_ROW_67_872 vssd1 vccd1 sky130_fd_sc_hd__tapvpwrvgnd_1
XANTENNA__6406__A _7131_/A vssd1 vssd1 vccd1 vccd1 sky130_fd_sc_hd__diode_2
XANTENNA__5667__D _5669_/B vssd1 vssd1 vccd1 vccd1 sky130_fd_sc_hd__diode_2
XANTENNA__8320__CLK _8402_/CLK vssd1 vssd1 vccd1 vccd1 sky130_fd_sc_hd__diode_2
XFILLER_12_479 vssd1 vssd1 vccd1 vccd1 sky130_fd_sc_hd__fill_1
XFILLER_33_54 vssd1 vssd1 vccd1 vccd1 sky130_fd_sc_hd__fill_2
XPHY_EDGE_ROW_49_Left_142 vssd1 vssd1 vccd1 vccd1 sky130_fd_sc_hd__decap_3
XFILLER_3_100 vssd1 vssd1 vccd1 vccd1 sky130_fd_sc_hd__fill_4
XANTENNA__8448__RESET_B load_slew360/X vssd1 vssd1 vccd1 vccd1 sky130_fd_sc_hd__diode_2
XANTENNA__6795__B _6883_/A vssd1 vssd1 vccd1 vccd1 sky130_fd_sc_hd__diode_2
XFILLER_3_177 vssd1 vssd1 vccd1 vccd1 sky130_fd_sc_hd__fill_1
XFILLER_79_446 vssd1 vssd1 vccd1 vccd1 sky130_fd_sc_hd__fill_2
XFILLER_58_51 vssd1 vssd1 vccd1 vccd1 sky130_fd_sc_hd__fill_1
XFILLER_58_73 vssd1 vssd1 vccd1 vccd1 sky130_fd_sc_hd__fill_1
XPHY_EDGE_ROW_58_Left_151 vssd1 vssd1 vccd1 vccd1 sky130_fd_sc_hd__decap_3
XFILLER_35_505 vssd1 vssd1 vccd1 vccd1 sky130_fd_sc_hd__fill_2
XFILLER_35_549 vssd1 vssd1 vccd1 vccd1 sky130_fd_sc_hd__fill_1
XANTENNA__6035__B _6238_/B vssd1 vssd1 vccd1 vccd1 sky130_fd_sc_hd__diode_2
XFILLER_15_295 vssd1 vssd1 vccd1 vccd1 sky130_fd_sc_hd__fill_1
XPHY_EDGE_ROW_67_Left_160 vssd1 vssd1 vccd1 vccd1 sky130_fd_sc_hd__decap_3
XFILLER_90_82 vssd1 vssd1 vccd1 vccd1 sky130_fd_sc_hd__fill_2
X_4540_ _4540_/A _4540_/B vssd1 vssd1 vccd1 vccd1 _4552_/A sky130_fd_sc_hd__xnor2_2
X_4471_ _4919_/A _4487_/B _4355_/A _4357_/X vssd1 vssd1 vccd1 vccd1 _4478_/A sky130_fd_sc_hd__a31o_2
Xmax_cap158 _6374_/A vssd1 vssd1 vccd1 vccd1 _7409_/A sky130_fd_sc_hd__buf_2
X_7190_ _6950_/B _6950_/C _6950_/A vssd1 vssd1 vccd1 vccd1 _7191_/C sky130_fd_sc_hd__a21bo_2
X_6210_ _6210_/A _6420_/A _6210_/C vssd1 vssd1 vccd1 vccd1 _6420_/B sky130_fd_sc_hd__nor3_2
X_6141_ _5979_/B _5979_/C _6139_/X _5976_/X _6138_/Y vssd1 vssd1 vccd1 vccd1 _6614_/B
+ sky130_fd_sc_hd__a221o_2
XTAP_TAPCELL_ROW_90_1101 vssd1 vccd1 sky130_fd_sc_hd__tapvpwrvgnd_1
X_6072_ _6277_/A _6072_/B vssd1 vssd1 vccd1 vccd1 _6075_/A sky130_fd_sc_hd__nor2_2
XFILLER_57_118 vssd1 vssd1 vccd1 vccd1 sky130_fd_sc_hd__fill_1
XFILLER_85_449 vssd1 vssd1 vccd1 vccd1 sky130_fd_sc_hd__fill_4
Xload_slew375 fanout374/X vssd1 vssd1 vccd1 vccd1 fanout372/A sky130_fd_sc_hd__clkbuf_4
X_5023_ _5024_/A _5024_/B vssd1 vssd1 vccd1 vccd1 _5023_/Y sky130_fd_sc_hd__nand2b_2
XFILLER_26_527 vssd1 vssd1 vccd1 vccd1 sky130_fd_sc_hd__fill_2
XFILLER_38_365 vssd1 vssd1 vccd1 vccd1 sky130_fd_sc_hd__fill_1
XFILLER_0_80 vssd1 vssd1 vccd1 vccd1 sky130_fd_sc_hd__fill_4
XFILLER_53_335 vssd1 vssd1 vccd1 vccd1 sky130_fd_sc_hd__fill_1
XFILLER_53_357 vssd1 vssd1 vccd1 vccd1 sky130_fd_sc_hd__fill_1
XFILLER_80_143 vssd1 vssd1 vccd1 vccd1 sky130_fd_sc_hd__fill_1
X_6974_ _6974_/A _6974_/B vssd1 vssd1 vccd1 vccd1 _6975_/B sky130_fd_sc_hd__xnor2_2
XTAP_TAPCELL_ROW_88_1085 vssd1 vccd1 sky130_fd_sc_hd__tapvpwrvgnd_1
XTAP_TAPCELL_ROW_64_842 vssd1 vccd1 sky130_fd_sc_hd__tapvpwrvgnd_1
X_5925_ _5747_/A _6712_/B _5748_/A _5745_/X vssd1 vssd1 vccd1 vccd1 _5935_/A sky130_fd_sc_hd__a31o_2
X_5856_ _6057_/A _5854_/Y _5398_/X _5407_/A vssd1 vssd1 vccd1 vccd1 _5857_/C sky130_fd_sc_hd__a211o_2
X_4807_ _4882_/B _4882_/A vssd1 vssd1 vccd1 vccd1 _4807_/Y sky130_fd_sc_hd__nand2b_2
XPHY_EDGE_ROW_3_Right_3 vssd1 vssd1 vccd1 vccd1 sky130_fd_sc_hd__decap_3
Xrebuffer503 _5194_/A vssd1 vssd1 vccd1 vccd1 _5766_/A1 sky130_fd_sc_hd__buf_2
X_5787_ _5787_/A _5891_/A vssd1 vssd1 vccd1 vccd1 _5896_/A sky130_fd_sc_hd__nor2_2
X_7526_ _8133_/B _7723_/D vssd1 vssd1 vccd1 vccd1 _7527_/B sky130_fd_sc_hd__nand2_2
X_4738_ _4478_/A _4478_/B _4479_/Y vssd1 vssd1 vccd1 vccd1 _4756_/A sky130_fd_sc_hd__a21bo_2
X_7457_ _7547_/B _7457_/B vssd1 vssd1 vccd1 vccd1 _7459_/A sky130_fd_sc_hd__nand2_2
X_4669_ _4669_/A _4669_/B vssd1 vssd1 vccd1 vccd1 _4686_/C sky130_fd_sc_hd__or2_4
XFILLER_79_39 vssd1 vssd1 vccd1 vccd1 sky130_fd_sc_hd__fill_1
X_6408_ _6409_/A _6409_/B vssd1 vssd1 vccd1 vccd1 _6499_/B sky130_fd_sc_hd__nand2_2
X_7388_ _7386_/A _7624_/A _7387_/X vssd1 vssd1 vccd1 vccd1 _7390_/A sky130_fd_sc_hd__a21o_2
X_6339_ _6339_/A _6339_/B vssd1 vssd1 vccd1 vccd1 _6341_/B sky130_fd_sc_hd__xnor2_2
XFILLER_88_287 vssd1 vssd1 vccd1 vccd1 sky130_fd_sc_hd__fill_2
X_8009_ _8009_/A _8009_/B _8009_/C vssd1 vssd1 vccd1 vccd1 _8009_/Y sky130_fd_sc_hd__nand3_2
XFILLER_28_43 vssd1 vccd1 vssd1 vccd1 sky130_ef_sc_hd__decap_40_12
XFILLER_17_505 vssd1 vssd1 vccd1 vccd1 sky130_fd_sc_hd__fill_4
XFILLER_56_162 vssd1 vssd1 vccd1 vccd1 sky130_fd_sc_hd__fill_4
XFILLER_71_121 vssd1 vssd1 vccd1 vccd1 sky130_fd_sc_hd__fill_1
XANTENNA__6430__A1 _6517_/A vssd1 vssd1 vccd1 vccd1 sky130_fd_sc_hd__diode_2
XANTENNA__6430__B2 _6517_/B vssd1 vssd1 vccd1 vccd1 sky130_fd_sc_hd__diode_2
XFILLER_71_165 vssd1 vssd1 vccd1 vccd1 sky130_fd_sc_hd__fill_1
XFILLER_71_187 vssd1 vssd1 vccd1 vccd1 sky130_fd_sc_hd__fill_1
XANTENNA__6142__Y _7296_/B vssd1 vssd1 vccd1 vccd1 sky130_fd_sc_hd__diode_2
XFILLER_79_232 vssd1 vssd1 vccd1 vccd1 sky130_fd_sc_hd__fill_1
XFILLER_79_265 vssd1 vssd1 vccd1 vccd1 sky130_fd_sc_hd__fill_2
XANTENNA__7997__B2 _7998_/B vssd1 vssd1 vccd1 vccd1 sky130_fd_sc_hd__diode_2
XTAP_TAPCELL_ROW_78_978 vssd1 vccd1 sky130_fd_sc_hd__tapvpwrvgnd_1
XANTENNA__8245__B input9/X vssd1 vssd1 vccd1 vccd1 sky130_fd_sc_hd__diode_2
XFILLER_62_143 vssd1 vssd1 vccd1 vccd1 sky130_fd_sc_hd__fill_1
XTAP_TAPCELL_ROW_61_812 vssd1 vccd1 sky130_fd_sc_hd__tapvpwrvgnd_1
XANTENNA__8261__A _8263_/A vssd1 vssd1 vccd1 vccd1 sky130_fd_sc_hd__diode_2
X_5710_ _5710_/A _5710_/B _5710_/C vssd1 vssd1 vccd1 vccd1 _5956_/A sky130_fd_sc_hd__and3_2
X_6690_ _6689_/A hold536/X _6689_/X vssd1 vssd1 vccd1 vccd1 _8324_/D sky130_fd_sc_hd__a21bo_2
X_5641_ _5641_/A _5641_/B vssd1 vssd1 vccd1 vccd1 _5654_/A sky130_fd_sc_hd__xnor2_2
X_8360_ _8361_/CLK _8360_/D load_slew384/X vssd1 vssd1 vccd1 vccd1 _8360_/Q sky130_fd_sc_hd__dfrtp_2
X_5572_ _5572_/A _5572_/B vssd1 vssd1 vccd1 vccd1 _5574_/B sky130_fd_sc_hd__xnor2_2
X_8291_ _5367_/C _8179_/B _8396_/D vssd1 vssd1 vccd1 vccd1 _8366_/D sky130_fd_sc_hd__mux2_1
X_7311_ _7311_/A _7386_/A vssd1 vssd1 vccd1 vccd1 _7314_/A sky130_fd_sc_hd__xnor2_2
X_4523_ _4523_/A _4654_/C vssd1 vssd1 vccd1 vccd1 _4564_/A sky130_fd_sc_hd__nand2_2
X_7242_ _7242_/A _7242_/B vssd1 vssd1 vccd1 vccd1 _7243_/B sky130_fd_sc_hd__nand2_2
X_4454_ _4321_/B _4325_/B _4321_/A vssd1 vssd1 vccd1 vccd1 _4455_/B sky130_fd_sc_hd__a21bo_2
X_7173_ _7174_/A _7174_/B _7172_/Y vssd1 vssd1 vccd1 vccd1 _7273_/B sky130_fd_sc_hd__o21bai_2
X_4385_ _4372_/A _4380_/Y _4382_/X _4397_/B vssd1 vssd1 vccd1 vccd1 _4388_/A sky130_fd_sc_hd__a2bb2o_2
X_6124_ _6125_/A _6125_/B _6125_/C vssd1 vssd1 vccd1 vccd1 _6126_/A sky130_fd_sc_hd__a21oi_2
X_6055_ _5839_/A _5841_/B _5839_/B vssd1 vssd1 vccd1 vccd1 _6057_/C sky130_fd_sc_hd__o21ba_2
XANTENNA__5463__A2 _5669_/B vssd1 vssd1 vccd1 vccd1 sky130_fd_sc_hd__diode_2
X_5006_ _5006_/A _5006_/B vssd1 vssd1 vccd1 vccd1 _5008_/C sky130_fd_sc_hd__xor2_2
XFILLER_26_302 vssd1 vssd1 vccd1 vccd1 sky130_fd_sc_hd__fill_1
XFILLER_38_162 vssd1 vssd1 vccd1 vccd1 sky130_fd_sc_hd__fill_1
XFILLER_53_132 vssd1 vssd1 vccd1 vccd1 sky130_fd_sc_hd__fill_2
XTAP_TAPCELL_ROW_49_691 vssd1 vccd1 sky130_fd_sc_hd__tapvpwrvgnd_1
XFILLER_14_519 vssd1 vssd1 vccd1 vccd1 sky130_fd_sc_hd__fill_1
XFILLER_81_474 vssd1 vssd1 vccd1 vccd1 sky130_fd_sc_hd__fill_1
X_6957_ _6957_/A _6957_/B _6955_/X vssd1 vssd1 vccd1 vccd1 _6959_/B sky130_fd_sc_hd__nor3b_2
XFILLER_53_176 vssd1 vssd1 vccd1 vccd1 sky130_fd_sc_hd__fill_2
XANTENNA_fanout338_X _6485_/B vssd1 vssd1 vccd1 vccd1 sky130_fd_sc_hd__diode_2
X_6888_ _6797_/B _6799_/B _6797_/A vssd1 vssd1 vccd1 vccd1 _6890_/B sky130_fd_sc_hd__o21ba_2
X_5908_ _5908_/A _5908_/B vssd1 vssd1 vccd1 vccd1 _5917_/A sky130_fd_sc_hd__or2_2
XANTENNA__6715__A2 _6712_/B vssd1 vssd1 vccd1 vccd1 sky130_fd_sc_hd__diode_2
XFILLER_14_56 vssd1 vssd1 vccd1 vccd1 sky130_fd_sc_hd__fill_2
X_5839_ _5839_/A _5839_/B vssd1 vssd1 vccd1 vccd1 _5841_/A sky130_fd_sc_hd__nor2_2
X_7509_ _7509_/A _7509_/B vssd1 vssd1 vccd1 vccd1 _7513_/A sky130_fd_sc_hd__xor2_2
XANTENNA__7515__A _7515_/A vssd1 vssd1 vccd1 vccd1 sky130_fd_sc_hd__diode_2
XFILLER_1_445 vssd1 vssd1 vccd1 vccd1 sky130_fd_sc_hd__fill_2
XANTENNA__4167__A_N _8174_/B vssd1 vssd1 vccd1 vccd1 sky130_fd_sc_hd__diode_2
XFILLER_76_257 vssd1 vssd1 vccd1 vccd1 sky130_fd_sc_hd__fill_1
XANTENNA_input13_A gpio_in[3] vssd1 vssd1 vccd1 vccd1 sky130_fd_sc_hd__diode_2
XTAP_TAPCELL_ROW_75_948 vssd1 vccd1 sky130_fd_sc_hd__tapvpwrvgnd_1
XFILLER_72_474 vssd1 vssd1 vccd1 vccd1 sky130_fd_sc_hd__fill_2
XANTENNA__6016__D _6217_/C vssd1 vssd1 vccd1 vccd1 sky130_fd_sc_hd__diode_2
XANTENNA__7409__B _7603_/B vssd1 vssd1 vccd1 vccd1 sky130_fd_sc_hd__diode_2
XTAP_TAPCELL_ROW_10_296 vssd1 vccd1 sky130_fd_sc_hd__tapvpwrvgnd_1
X_4170_ _8168_/B _4227_/S vssd1 vssd1 vccd1 vccd1 _4170_/Y sky130_fd_sc_hd__nand2b_2
X_7860_ _8131_/A _8136_/B _8133_/C _8131_/B vssd1 vssd1 vccd1 vccd1 _7864_/D sky130_fd_sc_hd__a22o_2
X_6811_ _6812_/A _6812_/B _6812_/C vssd1 vssd1 vccd1 vccd1 _6915_/A sky130_fd_sc_hd__a21o_2
XTAP_TAPCELL_ROW_85_1055 vssd1 vccd1 sky130_fd_sc_hd__tapvpwrvgnd_1
XTAP_TAPCELL_ROW_46_661 vssd1 vccd1 sky130_fd_sc_hd__tapvpwrvgnd_1
XFILLER_90_271 vssd1 vssd1 vccd1 vccd1 sky130_fd_sc_hd__fill_8
X_7791_ _7931_/B _7790_/B _7790_/C vssd1 vssd1 vccd1 vccd1 _7792_/B sky130_fd_sc_hd__o21a_2
XTAP_TAPCELL_ROW_18_385 vssd1 vccd1 sky130_fd_sc_hd__tapvpwrvgnd_1
XANTENNA_load_slew360_X load_slew360/X vssd1 vssd1 vccd1 vccd1 sky130_fd_sc_hd__diode_2
X_6742_ _6743_/A _6743_/B _6743_/C vssd1 vssd1 vccd1 vccd1 _7019_/A sky130_fd_sc_hd__o21a_2
X_6673_ _6673_/A _6673_/B vssd1 vssd1 vccd1 vccd1 _6676_/A sky130_fd_sc_hd__xnor2_2
X_8412_ clkload7/A _8412_/D load_slew358/X vssd1 vssd1 vccd1 vccd1 _8412_/Q sky130_fd_sc_hd__dfrtp_2
X_5624_ _5637_/A _5637_/B vssd1 vssd1 vccd1 vccd1 _5638_/A sky130_fd_sc_hd__nand2_2
X_8343_ _8369_/CLK _8343_/D fanout371/X vssd1 vssd1 vccd1 vccd1 _8343_/Q sky130_fd_sc_hd__dfrtp_2
X_5555_ _5555_/A _5569_/A _5838_/A _5670_/B vssd1 vssd1 vccd1 vccd1 _5556_/B sky130_fd_sc_hd__and4_2
XANTENNA_fanout200_A _8313_/S vssd1 vssd1 vccd1 vccd1 sky130_fd_sc_hd__diode_2
X_8274_ _8274_/A _8357_/Q _8274_/C vssd1 vssd1 vccd1 vccd1 _8278_/B sky130_fd_sc_hd__and3_2
X_5486_ _5486_/A _5486_/B vssd1 vssd1 vccd1 vccd1 _5517_/A sky130_fd_sc_hd__xnor2_2
X_4506_ _4506_/A _4506_/B _4506_/C vssd1 vssd1 vccd1 vccd1 _4507_/B sky130_fd_sc_hd__nor3_4
X_7225_ _7443_/B _7225_/B vssd1 vssd1 vccd1 vccd1 _7227_/C sky130_fd_sc_hd__nand2_2
X_4437_ _4438_/B _4438_/A vssd1 vssd1 vccd1 vccd1 _4437_/Y sky130_fd_sc_hd__nand2b_2
X_7156_ _7156_/A _7156_/B vssd1 vssd1 vccd1 vccd1 _7158_/A sky130_fd_sc_hd__nor2_2
XANTENNA_input5_A gpio_in[12] vssd1 vssd1 vccd1 vccd1 sky130_fd_sc_hd__diode_2
XFILLER_86_533 vssd1 vssd1 vccd1 vccd1 sky130_fd_sc_hd__fill_2
X_6107_ _8434_/D _6703_/B vssd1 vssd1 vccd1 vccd1 _6582_/C sky130_fd_sc_hd__and2_2
X_4368_ _4368_/A _4368_/B vssd1 vssd1 vccd1 vccd1 _4375_/A sky130_fd_sc_hd__xnor2_2
XANTENNA__8083__B1 _8082_/D vssd1 vssd1 vccd1 vccd1 sky130_fd_sc_hd__diode_2
XANTENNA_fanout288_X _7877_/B vssd1 vssd1 vccd1 vccd1 sky130_fd_sc_hd__diode_2
X_7087_ _7087_/A _7087_/B vssd1 vssd1 vccd1 vccd1 _7088_/B sky130_fd_sc_hd__xor2_2
X_4299_ _4299_/A _4299_/B _4257_/Y vssd1 vssd1 vccd1 vccd1 _4979_/C sky130_fd_sc_hd__or3b_2
XFILLER_46_419 vssd1 vssd1 vccd1 vccd1 sky130_fd_sc_hd__fill_1
X_6038_ _6438_/A _8220_/A vssd1 vssd1 vccd1 vccd1 _6039_/B sky130_fd_sc_hd__nand2_2
XFILLER_39_482 vssd1 vssd1 vccd1 vccd1 sky130_fd_sc_hd__fill_8
XFILLER_73_238 vssd1 vssd1 vccd1 vccd1 sky130_fd_sc_hd__fill_4
XFILLER_73_249 vssd1 vssd1 vccd1 vccd1 sky130_fd_sc_hd__fill_2
XFILLER_26_143 vssd1 vssd1 vccd1 vccd1 sky130_fd_sc_hd__fill_4
XTAP_TAPCELL_ROW_72_918 vssd1 vccd1 sky130_fd_sc_hd__tapvpwrvgnd_1
XFILLER_92_39 vssd1 vssd1 vccd1 vccd1 sky130_fd_sc_hd__fill_8
XFILLER_54_496 vssd1 vssd1 vccd1 vccd1 sky130_fd_sc_hd__fill_4
X_7989_ _7987_/X _7989_/B vssd1 vssd1 vccd1 vccd1 _7991_/A sky130_fd_sc_hd__and2b_2
XANTENNA__6414__A _7140_/A vssd1 vssd1 vccd1 vccd1 sky130_fd_sc_hd__diode_2
XFILLER_14_349 vssd1 vssd1 vccd1 vccd1 sky130_fd_sc_hd__fill_1
XFILLER_25_55 vssd1 vssd1 vccd1 vccd1 sky130_fd_sc_hd__fill_1
XFILLER_41_179 vssd1 vssd1 vccd1 vccd1 sky130_fd_sc_hd__fill_1
XFILLER_10_533 vssd1 vssd1 vccd1 vccd1 sky130_fd_sc_hd__fill_4
XFILLER_6_548 vssd1 vssd1 vccd1 vccd1 sky130_fd_sc_hd__fill_1
XANTENNA__8310__A1 _8196_/B vssd1 vssd1 vccd1 vccd1 sky130_fd_sc_hd__diode_2
XFILLER_49_202 vssd1 vssd1 vccd1 vccd1 sky130_fd_sc_hd__fill_1
XANTENNA__5052__X _5052_/X vssd1 vssd1 vccd1 vccd1 sky130_fd_sc_hd__diode_2
XFILLER_64_216 vssd1 vssd1 vccd1 vccd1 sky130_fd_sc_hd__fill_1
Xteam_03_394 vssd1 vssd1 vccd1 vccd1 team_03_394/HI gpio_oeb[25] sky130_fd_sc_hd__conb_1
XANTENNA_input16_X _8184_/B vssd1 vssd1 vccd1 vccd1 sky130_fd_sc_hd__diode_2
XFILLER_92_558 vssd1 vssd1 vccd1 vccd1 sky130_fd_sc_hd__fill_2
XFILLER_92_569 vssd1 vssd1 vccd1 vccd1 sky130_fd_sc_hd__fill_1
XFILLER_45_496 vssd1 vssd1 vccd1 vccd1 sky130_fd_sc_hd__fill_1
XFILLER_72_260 vssd1 vssd1 vccd1 vccd1 sky130_fd_sc_hd__fill_4
XFILLER_72_293 vssd1 vssd1 vccd1 vccd1 sky130_fd_sc_hd__fill_1
XTAP_TAPCELL_ROW_43_631 vssd1 vccd1 sky130_fd_sc_hd__tapvpwrvgnd_1
XFILLER_60_466 vssd1 vssd1 vccd1 vccd1 sky130_fd_sc_hd__fill_1
XTAP_TAPCELL_ROW_15_355 vssd1 vccd1 sky130_fd_sc_hd__tapvpwrvgnd_1
XANTENNA__5882__B _5883_/B vssd1 vssd1 vccd1 vccd1 sky130_fd_sc_hd__diode_2
XANTENNA__6978__B _8077_/B vssd1 vssd1 vccd1 vccd1 sky130_fd_sc_hd__diode_2
XANTENNA__8301__A1 input8/X vssd1 vssd1 vccd1 vccd1 sky130_fd_sc_hd__diode_2
X_5340_ _6035_/C _5657_/B vssd1 vssd1 vccd1 vccd1 _5341_/B sky130_fd_sc_hd__nand2_2
X_5271_ _5278_/A _5278_/B _5268_/Y vssd1 vssd1 vccd1 vccd1 _5281_/A sky130_fd_sc_hd__o21ai_2
X_7010_ _8419_/D wire72/X vssd1 vssd1 vccd1 vccd1 _7012_/B sky130_fd_sc_hd__nand2_2
X_4222_ _8303_/S _8402_/Q _4227_/S _8397_/D vssd1 vssd1 vccd1 vccd1 _4223_/C sky130_fd_sc_hd__or4_2
XFILLER_68_533 vssd1 vssd1 vccd1 vccd1 sky130_fd_sc_hd__fill_2
X_4153_ wire385/X _4160_/B vssd1 vssd1 vccd1 vccd1 _4153_/Y sky130_fd_sc_hd__nand2b_2
XANTENNA__5418__A2 _6016_/A vssd1 vssd1 vccd1 vccd1 sky130_fd_sc_hd__diode_2
XFILLER_83_503 vssd1 vssd1 vccd1 vccd1 sky130_fd_sc_hd__fill_1
XFILLER_83_536 vssd1 vssd1 vccd1 vccd1 sky130_fd_sc_hd__fill_1
X_7912_ _7887_/B _7745_/B _7747_/B _7773_/A vssd1 vssd1 vccd1 vccd1 _7913_/C sky130_fd_sc_hd__a31oi_2
XFILLER_70_208 vssd1 vssd1 vccd1 vccd1 sky130_fd_sc_hd__fill_8
XFILLER_83_569 vssd1 vssd1 vccd1 vccd1 sky130_fd_sc_hd__fill_1
XFILLER_23_113 vssd1 vssd1 vccd1 vccd1 sky130_fd_sc_hd__fill_1
XFILLER_36_485 vssd1 vssd1 vccd1 vccd1 sky130_fd_sc_hd__fill_4
X_7843_ _7977_/B _7843_/B vssd1 vssd1 vccd1 vccd1 _7845_/A sky130_fd_sc_hd__nand2_2
XANTENNA__6234__A _6517_/A vssd1 vssd1 vccd1 vccd1 sky130_fd_sc_hd__diode_2
X_7774_ _7773_/A _7773_/B _7773_/C vssd1 vssd1 vccd1 vccd1 _7781_/B sky130_fd_sc_hd__o21ai_2
X_4986_ _4940_/B _4986_/A2 _4938_/X vssd1 vssd1 vccd1 vccd1 _4987_/B sky130_fd_sc_hd__o21bai_2
XANTENNA_fanout248_A _7754_/B vssd1 vssd1 vccd1 vccd1 sky130_fd_sc_hd__diode_2
X_6725_ _7098_/A _7095_/B _7095_/C vssd1 vssd1 vccd1 vccd1 _6974_/A sky130_fd_sc_hd__and3_2
XPHY_EDGE_ROW_12_Left_105 vssd1 vssd1 vccd1 vccd1 sky130_fd_sc_hd__decap_3
X_6656_ _6656_/A _6656_/B vssd1 vssd1 vccd1 vccd1 _6658_/B sky130_fd_sc_hd__xnor2_2
X_6587_ _8436_/D _6704_/B vssd1 vssd1 vccd1 vccd1 _6591_/A sky130_fd_sc_hd__and2_2
X_5607_ _5607_/A _5607_/B vssd1 vssd1 vccd1 vccd1 _5610_/A sky130_fd_sc_hd__or2_2
XFILLER_11_57 vssd1 vssd1 vccd1 vccd1 sky130_fd_sc_hd__fill_1
X_8326_ _8405_/CLK _8326_/D fanout382/X vssd1 vssd1 vccd1 vccd1 _8326_/Q sky130_fd_sc_hd__dfrtp_2
X_5538_ _5592_/A _5592_/B vssd1 vssd1 vccd1 vccd1 _5540_/B sky130_fd_sc_hd__and2b_2
X_8257_ _8257_/A _8259_/A vssd1 vssd1 vccd1 vccd1 _8257_/X sky130_fd_sc_hd__or2_2
X_7208_ _7208_/A _7208_/B vssd1 vssd1 vccd1 vccd1 _7208_/Y sky130_fd_sc_hd__xnor2_2
X_5469_ _5349_/A _5464_/A _5876_/A _5468_/Y vssd1 vssd1 vccd1 vccd1 _5876_/B sky130_fd_sc_hd__a211oi_2
XFILLER_59_522 vssd1 vssd1 vccd1 vccd1 sky130_fd_sc_hd__fill_1
X_8188_ _8184_/A _8187_/Y _8307_/S vssd1 vssd1 vccd1 vccd1 _8339_/D sky130_fd_sc_hd__mux2_1
Xfanout332 _7120_/A vssd1 vssd1 vccd1 vccd1 _8191_/A sky130_fd_sc_hd__clkdlybuf4s25_1
Xfanout321 _8343_/Q vssd1 vssd1 vccd1 vccd1 _8208_/A sky130_fd_sc_hd__clkdlybuf4s25_1
Xfanout310 _8346_/Q vssd1 vssd1 vccd1 vccd1 _8030_/A sky130_fd_sc_hd__clkdlybuf4s25_1
XANTENNA_input8_X input8/X vssd1 vssd1 vccd1 vccd1 sky130_fd_sc_hd__diode_2
Xfanout365 wire368/A vssd1 vssd1 vccd1 vccd1 fanout365/X sky130_fd_sc_hd__clkdlybuf4s25_1
Xfanout354 _5446_/A vssd1 vssd1 vccd1 vccd1 _5583_/A sky130_fd_sc_hd__clkdlybuf4s25_1
Xfanout343 _6795_/A vssd1 vssd1 vccd1 vccd1 _6482_/B sky130_fd_sc_hd__clkdlybuf4s25_1
X_7139_ _6893_/A _6895_/B _6893_/B vssd1 vssd1 vccd1 vccd1 _7146_/A sky130_fd_sc_hd__o21ba_2
XPHY_EDGE_ROW_21_Left_114 vssd1 vssd1 vccd1 vccd1 sky130_fd_sc_hd__decap_3
XANTENNA__8427__CLK clkload6/A vssd1 vssd1 vccd1 vccd1 sky130_fd_sc_hd__diode_2
XFILLER_74_503 vssd1 vssd1 vccd1 vccd1 sky130_fd_sc_hd__fill_2
Xfanout376 fanout379/X vssd1 vssd1 vccd1 vccd1 wire377/A sky130_fd_sc_hd__clkdlybuf4s25_1
XANTENNA__6082__A2 _6080_/Y vssd1 vssd1 vccd1 vccd1 sky130_fd_sc_hd__diode_2
XFILLER_74_569 vssd1 vssd1 vccd1 vccd1 sky130_fd_sc_hd__fill_1
XTAP_TAPCELL_ROW_57_767 vssd1 vccd1 sky130_fd_sc_hd__tapvpwrvgnd_1
XANTENNA__6144__A _7304_/A vssd1 vssd1 vccd1 vccd1 sky130_fd_sc_hd__diode_2
XTAP_TAPCELL_ROW_40_601 vssd1 vccd1 sky130_fd_sc_hd__tapvpwrvgnd_1
XPHY_EDGE_ROW_30_Left_123 vssd1 vssd1 vccd1 vccd1 sky130_fd_sc_hd__decap_3
XANTENNA__5983__A _5983_/A vssd1 vssd1 vccd1 vccd1 sky130_fd_sc_hd__diode_2
XTAP_TAPCELL_ROW_12_325 vssd1 vccd1 sky130_fd_sc_hd__tapvpwrvgnd_1
XANTENNA__6798__B _6798_/B vssd1 vssd1 vccd1 vccd1 sky130_fd_sc_hd__diode_2
XFILLER_22_190 vssd1 vssd1 vccd1 vccd1 sky130_fd_sc_hd__fill_4
XFILLER_6_301 vssd1 vssd1 vccd1 vccd1 sky130_fd_sc_hd__fill_1
Xinput18 gpio_in[8] vssd1 vssd1 vccd1 vccd1 _8196_/B sky130_fd_sc_hd__buf_4
XANTENNA__8295__A0 _5826_/A vssd1 vssd1 vccd1 vccd1 sky130_fd_sc_hd__diode_2
XANTENNA__6038__B _8220_/A vssd1 vssd1 vccd1 vccd1 sky130_fd_sc_hd__diode_2
XFILLER_65_525 vssd1 vccd1 vssd1 vccd1 sky130_ef_sc_hd__decap_40_12
XFILLER_92_333 vssd1 vssd1 vccd1 vccd1 sky130_fd_sc_hd__fill_1
XANTENNA__8253__B _8254_/B vssd1 vssd1 vccd1 vccd1 sky130_fd_sc_hd__diode_2
X_4840_ _4840_/A _4840_/B vssd1 vssd1 vccd1 vccd1 _4842_/A sky130_fd_sc_hd__nand2_2
XTAP_TAPCELL_ROW_82_1025 vssd1 vccd1 sky130_fd_sc_hd__tapvpwrvgnd_1
XTAP_TAPCELL_ROW_28_480 vssd1 vccd1 sky130_fd_sc_hd__tapvpwrvgnd_1
X_6510_ _6510_/A _6510_/B vssd1 vssd1 vccd1 vccd1 _6511_/C sky130_fd_sc_hd__xnor2_2
X_4771_ _4771_/A _4771_/B vssd1 vssd1 vccd1 vccd1 _4774_/A sky130_fd_sc_hd__xnor2_2
XANTENNA__7325__A2 _7326_/B vssd1 vssd1 vccd1 vccd1 sky130_fd_sc_hd__diode_2
X_7490_ _7589_/A _7490_/B vssd1 vssd1 vccd1 vccd1 _7492_/C sky130_fd_sc_hd__nor2_2
X_6441_ _6442_/B _6442_/A vssd1 vssd1 vccd1 vccd1 _6536_/A sky130_fd_sc_hd__and2b_2
X_6372_ _7095_/A _6762_/B vssd1 vssd1 vccd1 vccd1 _6631_/C sky130_fd_sc_hd__nand2_2
XANTENNA__5117__B _5902_/B vssd1 vssd1 vccd1 vccd1 sky130_fd_sc_hd__diode_2
X_8111_ _8111_/A _8111_/B _8111_/C _8111_/D vssd1 vssd1 vccd1 vccd1 _8111_/X sky130_fd_sc_hd__and4_2
X_5323_ _5323_/A _5323_/B vssd1 vssd1 vccd1 vccd1 _5324_/B sky130_fd_sc_hd__nor2_2
XANTENNA__7613__A _7969_/A vssd1 vssd1 vccd1 vccd1 sky130_fd_sc_hd__diode_2
XANTENNA_rebuffer453_X _6576_/A vssd1 vssd1 vccd1 vccd1 sky130_fd_sc_hd__diode_2
X_8042_ _8041_/B _8041_/C _8041_/A vssd1 vssd1 vccd1 vccd1 _8043_/B sky130_fd_sc_hd__a21oi_2
X_5254_ _8408_/D _5254_/B _5254_/C vssd1 vssd1 vccd1 vccd1 _5266_/A sky130_fd_sc_hd__and3_2
X_5185_ _5756_/B _5183_/Y _5027_/C _5027_/Y vssd1 vssd1 vccd1 vccd1 _5185_/X sky130_fd_sc_hd__o211a_2
X_4205_ _4218_/S _8415_/Q _4204_/Y vssd1 vssd1 vccd1 vccd1 _5892_/A sky130_fd_sc_hd__o21ai_2
XANTENNA__5133__A _5747_/A vssd1 vssd1 vccd1 vccd1 sky130_fd_sc_hd__diode_2
XANTENNA_fanout198_A _8398_/D vssd1 vssd1 vccd1 vccd1 sky130_fd_sc_hd__diode_2
XFILLER_68_363 vssd1 vssd1 vccd1 vccd1 sky130_fd_sc_hd__fill_1
XFILLER_28_238 vssd1 vssd1 vccd1 vccd1 sky130_fd_sc_hd__fill_1
XTAP_TAPCELL_ROW_54_737 vssd1 vccd1 sky130_fd_sc_hd__tapvpwrvgnd_1
XANTENNA__4183__S _8398_/D vssd1 vssd1 vccd1 vccd1 sky130_fd_sc_hd__diode_2
X_7826_ _7827_/A _7827_/B vssd1 vssd1 vccd1 vccd1 _7952_/A sky130_fd_sc_hd__or2_2
Xwire64 wire64/A vssd1 vssd1 vccd1 vccd1 wire64/X sky130_fd_sc_hd__buf_4
X_7757_ _7757_/A _7757_/B vssd1 vssd1 vccd1 vccd1 _7760_/A sky130_fd_sc_hd__xnor2_2
X_4969_ _4955_/Y _4969_/B vssd1 vssd1 vccd1 vccd1 _5035_/A sky130_fd_sc_hd__nand2b_2
XANTENNA_fanout320_X _6035_/C vssd1 vssd1 vccd1 vccd1 sky130_fd_sc_hd__diode_2
XFILLER_22_34 vssd1 vssd1 vccd1 vccd1 sky130_fd_sc_hd__fill_1
X_7688_ _8419_/D _7820_/B vssd1 vssd1 vccd1 vccd1 _7689_/B sky130_fd_sc_hd__nand2_2
X_6708_ _6708_/A _6708_/B vssd1 vssd1 vccd1 vccd1 _6709_/B sky130_fd_sc_hd__xnor2_2
XFILLER_22_45 vssd1 vssd1 vccd1 vccd1 sky130_fd_sc_hd__fill_8
X_6639_ _8414_/D wire64/X _6360_/B _8415_/D vssd1 vssd1 vccd1 vccd1 _6639_/X sky130_fd_sc_hd__a22o_2
X_8309_ hold555/X _8191_/B _8313_/S vssd1 vssd1 vccd1 vccd1 _8384_/D sky130_fd_sc_hd__mux2_1
Xfanout140 _4162_/Y vssd1 vssd1 vccd1 vccd1 fanout140/X sky130_fd_sc_hd__buf_8
XFILLER_59_341 vssd1 vssd1 vccd1 vccd1 sky130_fd_sc_hd__fill_1
Xfanout162 _4174_/Y vssd1 vssd1 vccd1 vccd1 _6631_/A sky130_fd_sc_hd__clkdlybuf4s25_1
Xfanout173 fanout176/X vssd1 vssd1 vccd1 vccd1 _4523_/A sky130_fd_sc_hd__clkdlybuf4s25_1
XFILLER_47_42 vssd1 vssd1 vccd1 vccd1 sky130_fd_sc_hd__fill_1
XFILLER_86_182 vssd1 vssd1 vccd1 vccd1 sky130_fd_sc_hd__fill_1
Xfanout184 _8432_/D vssd1 vssd1 vccd1 vccd1 _6572_/A sky130_fd_sc_hd__buf_6
Xfanout195 _8071_/S vssd1 vssd1 vccd1 vccd1 _7658_/S sky130_fd_sc_hd__clkdlybuf4s25_1
XANTENNA__7555__A2 _7875_/D vssd1 vssd1 vccd1 vccd1 sky130_fd_sc_hd__diode_2
XTAP_TAPCELL_ROW_25_450 vssd1 vccd1 sky130_fd_sc_hd__tapvpwrvgnd_1
XFILLER_8_58 vssd1 vssd1 vccd1 vccd1 sky130_fd_sc_hd__fill_2
XFILLER_6_197 vssd1 vssd1 vccd1 vccd1 sky130_fd_sc_hd__fill_4
XANTENNA__4776__B _5163_/B vssd1 vssd1 vccd1 vccd1 sky130_fd_sc_hd__diode_2
XANTENNA__7491__A1 _7990_/A vssd1 vssd1 vccd1 vccd1 sky130_fd_sc_hd__diode_2
XANTENNA__8264__A _8264_/A vssd1 vssd1 vccd1 vccd1 sky130_fd_sc_hd__diode_2
Xclkbuf_4_1_0_clk clkbuf_0_clk/X vssd1 vssd1 vccd1 vccd1 clkload1/A sky130_fd_sc_hd__clkbuf_8
X_6990_ _7603_/A _7084_/B vssd1 vssd1 vccd1 vccd1 _6991_/B sky130_fd_sc_hd__nor2_2
XFILLER_53_517 vssd1 vssd1 vccd1 vccd1 sky130_fd_sc_hd__fill_2
X_5941_ _5941_/A _5941_/B vssd1 vssd1 vccd1 vccd1 _5941_/Y sky130_fd_sc_hd__nand2_2
XANTENNA__5400__B _5657_/B vssd1 vssd1 vccd1 vccd1 sky130_fd_sc_hd__diode_2
XFILLER_18_271 vssd1 vssd1 vccd1 vccd1 sky130_fd_sc_hd__fill_1
X_5872_ _6071_/A vssd1 vssd1 vccd1 vccd1 _5872_/Y sky130_fd_sc_hd__inv_2
XTAP_TAPCELL_ROW_51_707 vssd1 vccd1 sky130_fd_sc_hd__tapvpwrvgnd_1
X_7611_ _8077_/A _8081_/B vssd1 vssd1 vccd1 vccd1 _7679_/A sky130_fd_sc_hd__nor2_2
X_4823_ _4823_/A _4891_/B _4823_/C vssd1 vssd1 vccd1 vccd1 _4825_/B sky130_fd_sc_hd__nand3_2
X_7542_ _7543_/A _7543_/B vssd1 vssd1 vccd1 vccd1 _7765_/B sky130_fd_sc_hd__nand2b_2
X_4754_ _4754_/A _4754_/B vssd1 vssd1 vccd1 vccd1 _4756_/B sky130_fd_sc_hd__xor2_2
X_7473_ _7474_/A _7474_/B vssd1 vssd1 vccd1 vccd1 _7569_/B sky130_fd_sc_hd__and2_2
XANTENNA__5128__A _6970_/A vssd1 vssd1 vccd1 vccd1 sky130_fd_sc_hd__diode_2
X_4685_ _4646_/A _4709_/C _4709_/D _4667_/A vssd1 vssd1 vccd1 vccd1 _4686_/D sky130_fd_sc_hd__a22o_2
XANTENNA_fanout113_A _4487_/B vssd1 vssd1 vccd1 vccd1 sky130_fd_sc_hd__diode_2
X_6424_ _6424_/A _6424_/B _6424_/C vssd1 vssd1 vccd1 vccd1 _6426_/A sky130_fd_sc_hd__and3_2
X_6355_ _6355_/A _6355_/B vssd1 vssd1 vccd1 vccd1 _6358_/A sky130_fd_sc_hd__and2_2
X_6286_ _6151_/A _6151_/B _6149_/X vssd1 vssd1 vccd1 vccd1 _6345_/A sky130_fd_sc_hd__a21bo_2
X_5306_ _5306_/A _5306_/B vssd1 vssd1 vccd1 vccd1 _5307_/B sky130_fd_sc_hd__nor2_2
XANTENNA__4686__B _4686_/B vssd1 vssd1 vccd1 vccd1 sky130_fd_sc_hd__diode_2
X_8025_ _8131_/A _8131_/B _8133_/C _8257_/A vssd1 vssd1 vccd1 vccd1 _8026_/B sky130_fd_sc_hd__and4_2
X_5237_ _5237_/A _5237_/B vssd1 vssd1 vccd1 vccd1 _5249_/A sky130_fd_sc_hd__xnor2_2
XFILLER_29_503 vssd1 vssd1 vccd1 vccd1 sky130_fd_sc_hd__fill_1
XFILLER_84_29 vssd1 vssd1 vccd1 vccd1 sky130_fd_sc_hd__fill_4
X_5168_ _5168_/A _5168_/B vssd1 vssd1 vccd1 vccd1 _5169_/B sky130_fd_sc_hd__xor2_2
XANTENNA_fanout270_X _5657_/B vssd1 vssd1 vccd1 vccd1 sky130_fd_sc_hd__diode_2
X_5099_ _5102_/A vssd1 vssd1 vccd1 vccd1 _5099_/Y sky130_fd_sc_hd__inv_2
XANTENNA__5245__B1 _5899_/B vssd1 vssd1 vccd1 vccd1 sky130_fd_sc_hd__diode_2
XFILLER_17_34 vssd1 vssd1 vccd1 vccd1 sky130_fd_sc_hd__fill_8
XFILLER_71_325 vssd1 vssd1 vccd1 vccd1 sky130_fd_sc_hd__fill_4
XTAP_TAPCELL_ROW_67_873 vssd1 vccd1 sky130_fd_sc_hd__tapvpwrvgnd_1
XTAP_TAPCELL_ROW_39_586 vssd1 vccd1 sky130_fd_sc_hd__tapvpwrvgnd_1
XFILLER_17_67 vssd1 vssd1 vccd1 vccd1 sky130_fd_sc_hd__fill_1
X_7809_ _7809_/A _7809_/B vssd1 vssd1 vccd1 vccd1 _7810_/B sky130_fd_sc_hd__xor2_2
XTAP_TAPCELL_ROW_22_420 vssd1 vccd1 sky130_fd_sc_hd__tapvpwrvgnd_1
XANTENNA__8417__RESET_B wire364/X vssd1 vssd1 vccd1 vccd1 sky130_fd_sc_hd__diode_2
XFILLER_74_141 vssd1 vssd1 vccd1 vccd1 sky130_fd_sc_hd__fill_2
XANTENNA__5220__B _5780_/B vssd1 vssd1 vccd1 vccd1 sky130_fd_sc_hd__diode_2
XANTENNA__6035__C _6035_/C vssd1 vssd1 vccd1 vccd1 sky130_fd_sc_hd__diode_2
XFILLER_15_274 vssd1 vssd1 vccd1 vccd1 sky130_fd_sc_hd__fill_1
XFILLER_90_50 vssd1 vssd1 vccd1 vccd1 sky130_fd_sc_hd__fill_1
XFILLER_30_288 vssd1 vssd1 vccd1 vccd1 sky130_fd_sc_hd__fill_1
XANTENNA__8320__Q _8320_/Q vssd1 vssd1 vccd1 vccd1 sky130_fd_sc_hd__diode_2
XFILLER_11_491 vssd1 vssd1 vccd1 vccd1 sky130_fd_sc_hd__fill_1
XANTENNA__6986__B _6986_/B vssd1 vssd1 vccd1 vccd1 sky130_fd_sc_hd__diode_2
X_4470_ _4310_/Y _4348_/B _4349_/X vssd1 vssd1 vccd1 vccd1 _4480_/A sky130_fd_sc_hd__a21o_2
Xmax_cap159 _4182_/A vssd1 vssd1 vccd1 vccd1 _7603_/A sky130_fd_sc_hd__buf_4
X_6140_ _6139_/A _5979_/B _6139_/B _6138_/Y _5976_/X vssd1 vssd1 vccd1 vccd1 _6332_/B
+ sky130_fd_sc_hd__o311a_2
XTAP_TAPCELL_ROW_90_1102 vssd1 vccd1 sky130_fd_sc_hd__tapvpwrvgnd_1
X_6071_ _6071_/A _6071_/B _6071_/C vssd1 vssd1 vccd1 vccd1 _6072_/B sky130_fd_sc_hd__nor3_2
X_5022_ _5022_/A _5022_/B vssd1 vssd1 vccd1 vccd1 _5024_/B sky130_fd_sc_hd__xor2_2
XFILLER_0_70 vssd1 vssd1 vccd1 vccd1 sky130_fd_sc_hd__fill_2
X_6973_ _6973_/A _7097_/A vssd1 vssd1 vccd1 vccd1 _6973_/Y sky130_fd_sc_hd__nand2_2
XTAP_TAPCELL_ROW_64_843 vssd1 vccd1 sky130_fd_sc_hd__tapvpwrvgnd_1
X_5924_ _5924_/A _5924_/B vssd1 vssd1 vccd1 vccd1 _5974_/A sky130_fd_sc_hd__or2_2
XTAP_TAPCELL_ROW_36_556 vssd1 vccd1 sky130_fd_sc_hd__tapvpwrvgnd_1
X_5855_ _5398_/X _5407_/A _6057_/A _5854_/Y vssd1 vssd1 vccd1 vccd1 _6057_/B sky130_fd_sc_hd__o211ai_2
X_4806_ _4806_/A _4806_/B vssd1 vssd1 vccd1 vccd1 _4882_/B sky130_fd_sc_hd__xnor2_2
Xrebuffer504 _4718_/X vssd1 vssd1 vccd1 vccd1 _4720_/B2 sky130_fd_sc_hd__buf_2
X_5786_ _8416_/D _6738_/B vssd1 vssd1 vccd1 vccd1 _5890_/A sky130_fd_sc_hd__nand2_2
X_7525_ _7525_/A _7525_/B vssd1 vssd1 vccd1 vccd1 _7527_/A sky130_fd_sc_hd__nor2_2
X_4737_ _4465_/A _4465_/B _4463_/Y vssd1 vssd1 vccd1 vccd1 _4758_/A sky130_fd_sc_hd__o21ai_2
X_7456_ _7547_/A _7455_/B _7455_/C vssd1 vssd1 vccd1 vccd1 _7457_/B sky130_fd_sc_hd__a21o_2
X_4668_ _4669_/B _4669_/A vssd1 vssd1 vccd1 vccd1 _4668_/Y sky130_fd_sc_hd__nor2_2
X_6407_ _6407_/A _6407_/B vssd1 vssd1 vccd1 vccd1 _6409_/B sky130_fd_sc_hd__xnor2_2
XANTENNA__5702__B2 _4972_/B vssd1 vssd1 vccd1 vccd1 sky130_fd_sc_hd__diode_2
X_7387_ _7966_/A _8082_/C _8082_/D _8077_/A vssd1 vssd1 vccd1 vccd1 _7387_/X sky130_fd_sc_hd__o22a_2
X_4599_ _4625_/A _4654_/C _4599_/C vssd1 vssd1 vccd1 vccd1 _4607_/A sky130_fd_sc_hd__and3_2
X_6338_ _6338_/A _6338_/B vssd1 vssd1 vccd1 vccd1 _6339_/B sky130_fd_sc_hd__xor2_2
X_6269_ _6471_/A _6269_/B vssd1 vssd1 vccd1 vccd1 _6272_/A sky130_fd_sc_hd__and2b_2
X_8008_ _8009_/A _8009_/B _8009_/C vssd1 vssd1 vccd1 vccd1 _8147_/A sky130_fd_sc_hd__a21o_2
XFILLER_28_33 vssd1 vssd1 vccd1 vccd1 sky130_fd_sc_hd__fill_2
XFILLER_28_55 vssd1 vssd1 vccd1 vccd1 sky130_fd_sc_hd__fill_4
XANTENNA__5321__A _8202_/A vssd1 vssd1 vccd1 vccd1 sky130_fd_sc_hd__diode_2
XANTENNA__6417__A _7233_/A vssd1 vssd1 vccd1 vccd1 sky130_fd_sc_hd__diode_2
XFILLER_17_517 vssd1 vssd1 vccd1 vccd1 sky130_fd_sc_hd__fill_2
XANTENNA__6430__A2 _8241_/A vssd1 vssd1 vccd1 vccd1 sky130_fd_sc_hd__diode_2
XFILLER_25_550 vssd1 vssd1 vccd1 vccd1 sky130_fd_sc_hd__fill_8
XFILLER_44_21 vssd1 vssd1 vccd1 vccd1 sky130_fd_sc_hd__fill_1
XFILLER_44_54 vssd1 vssd1 vccd1 vccd1 sky130_fd_sc_hd__fill_2
XFILLER_12_244 vssd1 vssd1 vccd1 vccd1 sky130_fd_sc_hd__fill_1
XFILLER_12_288 vssd1 vssd1 vccd1 vccd1 sky130_fd_sc_hd__fill_1
XFILLER_5_48 vssd1 vssd1 vccd1 vccd1 sky130_fd_sc_hd__fill_1
XTAP_TAPCELL_ROW_7_270 vssd1 vccd1 sky130_fd_sc_hd__tapvpwrvgnd_1
XFILLER_85_50 vssd1 vssd1 vccd1 vccd1 sky130_fd_sc_hd__fill_1
XTAP_TAPCELL_ROW_78_979 vssd1 vccd1 sky130_fd_sc_hd__tapvpwrvgnd_1
XPHY_EDGE_ROW_13_Right_13 vssd1 vssd1 vccd1 vccd1 sky130_fd_sc_hd__decap_3
XFILLER_85_72 vssd1 vssd1 vccd1 vccd1 sky130_fd_sc_hd__fill_1
XFILLER_62_100 vssd1 vssd1 vccd1 vccd1 sky130_fd_sc_hd__fill_2
XFILLER_62_188 vssd1 vssd1 vccd1 vccd1 sky130_fd_sc_hd__fill_2
XFILLER_62_199 vssd1 vssd1 vccd1 vccd1 sky130_fd_sc_hd__fill_1
XTAP_TAPCELL_ROW_61_813 vssd1 vccd1 sky130_fd_sc_hd__tapvpwrvgnd_1
XTAP_TAPCELL_ROW_33_526 vssd1 vccd1 sky130_fd_sc_hd__tapvpwrvgnd_1
XANTENNA__6333__Y _7806_/B vssd1 vssd1 vccd1 vccd1 sky130_fd_sc_hd__diode_2
XFILLER_43_391 vssd1 vssd1 vccd1 vccd1 sky130_fd_sc_hd__fill_1
XFILLER_86_3 vssd1 vssd1 vccd1 vccd1 sky130_fd_sc_hd__fill_2
X_5640_ _5640_/A _5640_/B _5640_/C vssd1 vssd1 vccd1 vccd1 _5640_/X sky130_fd_sc_hd__or3_2
X_5571_ _5571_/A _5571_/B vssd1 vssd1 vccd1 vccd1 _5572_/B sky130_fd_sc_hd__nor2_2
XPHY_EDGE_ROW_22_Right_22 vssd1 vssd1 vccd1 vccd1 sky130_fd_sc_hd__decap_3
X_8290_ _5838_/C _8174_/B _8396_/D vssd1 vssd1 vccd1 vccd1 _8365_/D sky130_fd_sc_hd__mux2_1
X_7310_ _8077_/A _8082_/C vssd1 vssd1 vccd1 vccd1 _7386_/A sky130_fd_sc_hd__nor2_2
X_4522_ _4522_/A vssd1 vssd1 vccd1 vccd1 _4553_/A sky130_fd_sc_hd__inv_2
X_7241_ _7458_/B _7241_/B vssd1 vssd1 vccd1 vccd1 _7243_/A sky130_fd_sc_hd__nand2_2
X_4453_ _4453_/A _4453_/B vssd1 vssd1 vccd1 vccd1 _4455_/A sky130_fd_sc_hd__nand2_2
X_7172_ _7273_/A _7172_/B vssd1 vssd1 vccd1 vccd1 _7172_/Y sky130_fd_sc_hd__nand2_2
X_4384_ _8430_/D _4384_/B vssd1 vssd1 vccd1 vccd1 _4397_/B sky130_fd_sc_hd__and2_2
X_6123_ _6123_/A _6123_/B vssd1 vssd1 vccd1 vccd1 _6125_/C sky130_fd_sc_hd__xnor2_2
XFILLER_85_225 vssd1 vssd1 vccd1 vccd1 sky130_fd_sc_hd__fill_4
X_6054_ _6053_/A _6053_/B _6053_/C vssd1 vssd1 vccd1 vccd1 _6061_/B sky130_fd_sc_hd__a21oi_2
XPHY_EDGE_ROW_31_Right_31 vssd1 vssd1 vccd1 vccd1 sky130_fd_sc_hd__decap_3
X_5005_ _5006_/A _5006_/B vssd1 vssd1 vccd1 vccd1 _5005_/X sky130_fd_sc_hd__or2_4
XANTENNA_fanout180_A _8428_/D vssd1 vssd1 vccd1 vccd1 sky130_fd_sc_hd__diode_2
XANTENNA_fanout278_A _6548_/A vssd1 vssd1 vccd1 vccd1 sky130_fd_sc_hd__diode_2
XFILLER_38_141 vssd1 vssd1 vccd1 vccd1 sky130_fd_sc_hd__fill_1
XFILLER_66_461 vssd1 vssd1 vccd1 vccd1 sky130_fd_sc_hd__fill_2
XFILLER_73_409 vssd1 vssd1 vccd1 vccd1 sky130_fd_sc_hd__fill_1
XFILLER_85_269 vssd1 vssd1 vccd1 vccd1 sky130_fd_sc_hd__fill_4
XFILLER_38_174 vssd1 vssd1 vccd1 vccd1 sky130_fd_sc_hd__fill_1
XTAP_TAPCELL_ROW_49_692 vssd1 vccd1 sky130_fd_sc_hd__tapvpwrvgnd_1
XFILLER_53_166 vssd1 vssd1 vccd1 vccd1 sky130_fd_sc_hd__fill_2
X_6956_ _6957_/A _6957_/B _6955_/X vssd1 vssd1 vccd1 vccd1 _7198_/B sky130_fd_sc_hd__o21ba_2
X_5907_ _5907_/A _5907_/B _5907_/C vssd1 vssd1 vccd1 vccd1 _5908_/B sky130_fd_sc_hd__and3_2
X_6887_ _6887_/A _6887_/B vssd1 vssd1 vccd1 vccd1 _6890_/A sky130_fd_sc_hd__xnor2_2
X_5838_ _5838_/A _8220_/A _5838_/C _8228_/A vssd1 vssd1 vccd1 vccd1 _5839_/B sky130_fd_sc_hd__and4_2
XPHY_EDGE_ROW_40_Right_40 vssd1 vssd1 vccd1 vccd1 sky130_fd_sc_hd__decap_3
XANTENNA__4204__B _4223_/B vssd1 vssd1 vccd1 vccd1 sky130_fd_sc_hd__diode_2
X_5769_ _5770_/A _5770_/B vssd1 vssd1 vccd1 vccd1 _5769_/X sky130_fd_sc_hd__or2_2
X_7508_ _7509_/A _7509_/B vssd1 vssd1 vccd1 vccd1 _7508_/Y sky130_fd_sc_hd__nand2_2
XANTENNA__7515__B _7714_/A vssd1 vssd1 vccd1 vccd1 sky130_fd_sc_hd__diode_2
XPHY_EDGE_ROW_86_Left_179 vssd1 vssd1 vccd1 vccd1 sky130_fd_sc_hd__decap_3
X_7439_ _7440_/A _7440_/B vssd1 vssd1 vccd1 vccd1 _7532_/B sky130_fd_sc_hd__nand2_2
XFILLER_1_424 vssd1 vssd1 vccd1 vccd1 sky130_fd_sc_hd__fill_1
XANTENNA__6100__A1 _6572_/A vssd1 vssd1 vccd1 vccd1 sky130_fd_sc_hd__diode_2
XTAP_TAPCELL_ROW_4_240 vssd1 vccd1 sky130_fd_sc_hd__tapvpwrvgnd_1
XTAP_TAPCELL_ROW_75_949 vssd1 vccd1 sky130_fd_sc_hd__tapvpwrvgnd_1
XANTENNA__6403__A2 _6485_/B vssd1 vssd1 vccd1 vccd1 sky130_fd_sc_hd__diode_2
XANTENNA__8081__B _8081_/B vssd1 vssd1 vccd1 vccd1 sky130_fd_sc_hd__diode_2
XANTENNA__6610__A _7299_/B vssd1 vssd1 vccd1 vccd1 sky130_fd_sc_hd__diode_2
XTAP_TAPCELL_ROW_10_297 vssd1 vccd1 sky130_fd_sc_hd__tapvpwrvgnd_1
XANTENNA__8432__RESET_B wire362/A vssd1 vssd1 vccd1 vccd1 sky130_fd_sc_hd__diode_2
XFILLER_4_295 vssd1 vssd1 vccd1 vccd1 sky130_fd_sc_hd__fill_4
XFILLER_67_225 vssd1 vssd1 vccd1 vccd1 sky130_fd_sc_hd__fill_1
XFILLER_67_258 vssd1 vssd1 vccd1 vccd1 sky130_fd_sc_hd__fill_1
XANTENNA__6207__D _6485_/B vssd1 vssd1 vccd1 vccd1 sky130_fd_sc_hd__diode_2
XFILLER_63_453 vssd1 vssd1 vccd1 vccd1 sky130_fd_sc_hd__fill_2
X_6810_ _6900_/B _6810_/B vssd1 vssd1 vccd1 vccd1 _6812_/C sky130_fd_sc_hd__nand2_2
X_7790_ _7931_/B _7790_/B _7790_/C vssd1 vssd1 vccd1 vccd1 _7934_/A sky130_fd_sc_hd__nor3_2
XTAP_TAPCELL_ROW_46_662 vssd1 vccd1 sky130_fd_sc_hd__tapvpwrvgnd_1
XFILLER_50_125 vssd1 vssd1 vccd1 vccd1 sky130_fd_sc_hd__fill_1
X_6741_ _6741_/A _6741_/B vssd1 vssd1 vccd1 vccd1 _6743_/C sky130_fd_sc_hd__xor2_2
XANTENNA__8422__D _8422_/D vssd1 vssd1 vccd1 vccd1 sky130_fd_sc_hd__diode_2
XANTENNA_clkbuf_0_clk_X clkbuf_0_clk/X vssd1 vssd1 vccd1 vccd1 sky130_fd_sc_hd__diode_2
X_6672_ _6672_/A _6672_/B vssd1 vssd1 vccd1 vccd1 _6673_/B sky130_fd_sc_hd__xor2_2
X_8411_ clkload7/A _8411_/D load_slew358/X vssd1 vssd1 vccd1 vccd1 _8411_/Q sky130_fd_sc_hd__dfrtp_2
X_5623_ _5623_/A vssd1 vssd1 vccd1 vccd1 _5637_/B sky130_fd_sc_hd__inv_2
XANTENNA_rebuffer483_X _8082_/C vssd1 vssd1 vccd1 vccd1 sky130_fd_sc_hd__diode_2
X_8342_ _8369_/CLK _8342_/D fanout371/X vssd1 vssd1 vccd1 vccd1 _8342_/Q sky130_fd_sc_hd__dfrtp_2
X_5554_ _5555_/A _5838_/A _5670_/B _5569_/A vssd1 vssd1 vccd1 vccd1 _5556_/A sky130_fd_sc_hd__a22oi_2
X_8273_ _8274_/A _8274_/C vssd1 vssd1 vccd1 vccd1 _8356_/D sky130_fd_sc_hd__xor2_2
X_5485_ _5842_/B _5657_/B vssd1 vssd1 vccd1 vccd1 _5486_/B sky130_fd_sc_hd__nand2_2
X_4505_ _4506_/A _4506_/B _4506_/C vssd1 vssd1 vccd1 vccd1 _4507_/A sky130_fd_sc_hd__o21a_4
X_7224_ _7224_/A _7224_/B vssd1 vssd1 vccd1 vccd1 _7225_/B sky130_fd_sc_hd__or2_2
X_4436_ _4421_/A _4421_/B _4423_/A _4423_/B vssd1 vssd1 vccd1 vccd1 _4438_/B sky130_fd_sc_hd__o22a_2
X_7155_ _8108_/A _8108_/B _8352_/Q _8267_/A vssd1 vssd1 vccd1 vccd1 _7156_/B sky130_fd_sc_hd__and4_2
X_4367_ _5157_/A _4931_/D vssd1 vssd1 vccd1 vccd1 _4368_/B sky130_fd_sc_hd__nand2_2
XFILLER_76_19 vssd1 vssd1 vccd1 vccd1 sky130_fd_sc_hd__fill_4
XFILLER_86_512 vssd1 vssd1 vccd1 vccd1 sky130_fd_sc_hd__fill_1
X_6106_ _6106_/A _6106_/B vssd1 vssd1 vccd1 vccd1 _6128_/A sky130_fd_sc_hd__xnor2_2
XANTENNA__8166__B _8168_/B vssd1 vssd1 vccd1 vccd1 sky130_fd_sc_hd__diode_2
X_7086_ _7087_/A _7087_/B vssd1 vssd1 vccd1 vccd1 _7086_/X sky130_fd_sc_hd__and2_2
X_4298_ _4299_/A _4299_/B _4257_/Y vssd1 vssd1 vccd1 vccd1 _4657_/B sky130_fd_sc_hd__o21bai_2
XANTENNA_fanout183_X _5157_/A vssd1 vssd1 vccd1 vccd1 sky130_fd_sc_hd__diode_2
X_6037_ _6037_/A _6037_/B vssd1 vssd1 vccd1 vccd1 _6039_/A sky130_fd_sc_hd__nor2_2
XTAP_TAPCELL_ROW_1_210 vssd1 vccd1 sky130_fd_sc_hd__tapvpwrvgnd_1
XFILLER_25_12 vssd1 vssd1 vccd1 vccd1 sky130_fd_sc_hd__fill_1
XFILLER_66_291 vssd1 vssd1 vccd1 vccd1 sky130_fd_sc_hd__fill_4
XTAP_TAPCELL_ROW_72_919 vssd1 vccd1 sky130_fd_sc_hd__tapvpwrvgnd_1
XFILLER_92_29 vssd1 vssd1 vccd1 vccd1 sky130_fd_sc_hd__fill_2
X_7988_ _7988_/A _7988_/B _7986_/X vssd1 vssd1 vccd1 vccd1 _7989_/B sky130_fd_sc_hd__or3b_2
XANTENNA__6414__B _8126_/A vssd1 vssd1 vccd1 vccd1 sky130_fd_sc_hd__diode_2
XFILLER_41_125 vssd1 vssd1 vccd1 vccd1 sky130_fd_sc_hd__fill_2
X_6939_ _6940_/A _6940_/B vssd1 vssd1 vccd1 vccd1 _6942_/A sky130_fd_sc_hd__nor2_2
XTAP_TAPCELL_ROW_80_996 vssd1 vccd1 sky130_fd_sc_hd__tapvpwrvgnd_1
XFILLER_10_523 vssd1 vssd1 vccd1 vccd1 sky130_fd_sc_hd__fill_2
XFILLER_10_545 vssd1 vssd1 vccd1 vccd1 sky130_fd_sc_hd__fill_4
XFILLER_41_55 vssd1 vssd1 vccd1 vccd1 sky130_fd_sc_hd__fill_1
XFILLER_6_538 vssd1 vssd1 vccd1 vccd1 sky130_fd_sc_hd__fill_1
XFILLER_1_276 vssd1 vssd1 vccd1 vccd1 sky130_fd_sc_hd__fill_1
XFILLER_77_523 vssd1 vssd1 vccd1 vccd1 sky130_fd_sc_hd__fill_1
XFILLER_2_27 vssd1 vssd1 vccd1 vccd1 sky130_fd_sc_hd__fill_1
XFILLER_49_247 vssd1 vssd1 vccd1 vccd1 sky130_fd_sc_hd__fill_1
XFILLER_77_545 vssd1 vssd1 vccd1 vccd1 sky130_fd_sc_hd__fill_2
XFILLER_66_85 vssd1 vssd1 vccd1 vccd1 sky130_fd_sc_hd__fill_2
Xteam_03_395 vssd1 vssd1 vccd1 vccd1 team_03_395/HI gpio_oeb[26] sky130_fd_sc_hd__conb_1
XTAP_TAPCELL_ROW_43_632 vssd1 vccd1 sky130_fd_sc_hd__tapvpwrvgnd_1
XANTENNA__7888__A1 _7889_/A vssd1 vssd1 vccd1 vccd1 sky130_fd_sc_hd__diode_2
XANTENNA__7888__B2 _7889_/B vssd1 vssd1 vccd1 vccd1 sky130_fd_sc_hd__diode_2
X_5270_ _8406_/D _5899_/B vssd1 vssd1 vccd1 vccd1 _5278_/B sky130_fd_sc_hd__nand2_2
X_4221_ _8071_/S _4223_/B _4220_/X vssd1 vssd1 vccd1 vccd1 _8395_/D sky130_fd_sc_hd__or3b_2
XFILLER_68_512 vssd1 vssd1 vccd1 vccd1 sky130_fd_sc_hd__fill_4
XFILLER_68_523 vssd1 vssd1 vccd1 vccd1 sky130_fd_sc_hd__fill_2
X_4152_ _4919_/A vssd1 vssd1 vccd1 vccd1 _5724_/A sky130_fd_sc_hd__inv_2
X_7911_ _8050_/A _7910_/B _7988_/B _7910_/D vssd1 vssd1 vccd1 vccd1 _7913_/B sky130_fd_sc_hd__o22a_2
XFILLER_63_250 vssd1 vssd1 vccd1 vccd1 sky130_fd_sc_hd__fill_1
X_7842_ _7842_/A _7842_/B vssd1 vssd1 vccd1 vccd1 _7843_/B sky130_fd_sc_hd__or2_2
XANTENNA__6234__B _6517_/B vssd1 vssd1 vccd1 vccd1 sky130_fd_sc_hd__diode_2
X_7773_ _7773_/A _7773_/B _7773_/C vssd1 vssd1 vccd1 vccd1 _7781_/A sky130_fd_sc_hd__or3_2
X_4985_ _4985_/A _4985_/B vssd1 vssd1 vccd1 vccd1 _4987_/A sky130_fd_sc_hd__xor2_2
XANTENNA_fanout143_A _6091_/A vssd1 vssd1 vccd1 vccd1 sky130_fd_sc_hd__diode_2
XFILLER_23_169 vssd1 vssd1 vccd1 vccd1 sky130_fd_sc_hd__fill_2
X_6724_ _6724_/A _7299_/B _7299_/C vssd1 vssd1 vccd1 vccd1 _6728_/A sky130_fd_sc_hd__and3_2
X_6655_ _6656_/A _6656_/B vssd1 vssd1 vccd1 vccd1 _6755_/A sky130_fd_sc_hd__or2_2
XANTENNA__8354__RESET_B load_slew384/X vssd1 vssd1 vccd1 vccd1 sky130_fd_sc_hd__diode_2
XANTENNA_fanout310_A _8346_/Q vssd1 vssd1 vccd1 vccd1 sky130_fd_sc_hd__diode_2
X_6586_ _6586_/A _6586_/B vssd1 vssd1 vccd1 vccd1 _6595_/A sky130_fd_sc_hd__xnor2_2
X_5606_ _8168_/A _5838_/A _5670_/B _8174_/A vssd1 vssd1 vccd1 vccd1 _5607_/B sky130_fd_sc_hd__a22oi_2
X_8325_ _8334_/CLK _8325_/D fanout382/X vssd1 vssd1 vccd1 vccd1 _8325_/Q sky130_fd_sc_hd__dfrtp_2
X_5537_ _5537_/A _5537_/B vssd1 vssd1 vccd1 vccd1 _5592_/B sky130_fd_sc_hd__nor2_2
X_8256_ _8255_/B _8259_/B _8255_/A vssd1 vssd1 vccd1 vccd1 _8256_/Y sky130_fd_sc_hd__a21oi_2
XFILLER_2_9 vssd1 vssd1 vccd1 vccd1 sky130_fd_sc_hd__fill_2
XFILLER_78_309 vssd1 vssd1 vccd1 vccd1 sky130_fd_sc_hd__fill_1
XFILLER_87_18 vssd1 vssd1 vccd1 vccd1 sky130_fd_sc_hd__fill_2
X_7207_ _7045_/A _7045_/B _7041_/X vssd1 vssd1 vccd1 vccd1 _7208_/B sky130_fd_sc_hd__a21oi_2
X_5468_ _5468_/A _5468_/B _5506_/A vssd1 vssd1 vccd1 vccd1 _5468_/Y sky130_fd_sc_hd__nor3_2
XANTENNA__7081__A _7969_/A vssd1 vssd1 vccd1 vccd1 sky130_fd_sc_hd__diode_2
X_8187_ _8187_/A _8187_/B vssd1 vssd1 vccd1 vccd1 _8187_/Y sky130_fd_sc_hd__xnor2_2
Xfanout322 _8343_/Q vssd1 vssd1 vccd1 vccd1 _7515_/A sky130_fd_sc_hd__clkdlybuf4s25_1
Xfanout311 _8346_/Q vssd1 vssd1 vccd1 vccd1 _7140_/C sky130_fd_sc_hd__clkdlybuf4s25_1
Xfanout300 _8246_/A vssd1 vssd1 vccd1 vccd1 _7725_/B sky130_fd_sc_hd__clkdlybuf4s25_1
X_5399_ _5399_/A _5399_/B vssd1 vssd1 vccd1 vccd1 _5406_/A sky130_fd_sc_hd__xnor2_2
X_4419_ _4424_/B _4424_/A vssd1 vssd1 vccd1 vccd1 _4440_/A sky130_fd_sc_hd__nand2_2
Xfanout355 _6198_/A vssd1 vssd1 vccd1 vccd1 _5446_/A sky130_fd_sc_hd__clkdlybuf4s25_1
Xfanout344 _8338_/Q vssd1 vssd1 vccd1 vccd1 _6795_/A sky130_fd_sc_hd__clkdlybuf4s25_1
Xfanout333 _7120_/A vssd1 vssd1 vccd1 vccd1 _5568_/A sky130_fd_sc_hd__clkdlybuf4s25_1
X_7138_ _6905_/B _6907_/B _6905_/A vssd1 vssd1 vccd1 vccd1 _7148_/A sky130_fd_sc_hd__o21ba_2
XFILLER_59_567 vssd1 vssd1 vccd1 vccd1 sky130_fd_sc_hd__fill_2
X_7069_ _6748_/A _7002_/Y _7006_/A _7006_/B vssd1 vssd1 vccd1 vccd1 _7071_/C sky130_fd_sc_hd__o22a_2
XTAP_TAPCELL_ROW_57_768 vssd1 vccd1 sky130_fd_sc_hd__tapvpwrvgnd_1
XANTENNA__6144__B _6986_/B vssd1 vssd1 vccd1 vccd1 sky130_fd_sc_hd__diode_2
XTAP_TAPCELL_ROW_40_602 vssd1 vccd1 sky130_fd_sc_hd__tapvpwrvgnd_1
XANTENNA__5983__B _7080_/B vssd1 vssd1 vccd1 vccd1 sky130_fd_sc_hd__diode_2
XFILLER_52_98 vssd1 vssd1 vccd1 vccd1 sky130_fd_sc_hd__fill_2
Xinput19 gpio_in[9] vssd1 vssd1 vccd1 vccd1 input19/X sky130_fd_sc_hd__buf_1
XANTENNA__6160__A _7299_/A vssd1 vssd1 vccd1 vccd1 sky130_fd_sc_hd__diode_2
XANTENNA__8295__A1 _8202_/B vssd1 vssd1 vccd1 vccd1 sky130_fd_sc_hd__diode_2
XFILLER_2_530 vssd1 vssd1 vccd1 vccd1 sky130_fd_sc_hd__fill_2
XFILLER_2_541 vssd1 vssd1 vccd1 vccd1 sky130_fd_sc_hd__fill_2
XFILLER_69_309 vssd1 vssd1 vccd1 vccd1 sky130_fd_sc_hd__fill_1
XFILLER_65_515 vssd1 vssd1 vccd1 vccd1 sky130_fd_sc_hd__fill_4
XFILLER_65_537 vssd1 vssd1 vccd1 vccd1 sky130_fd_sc_hd__fill_1
XFILLER_65_559 vssd1 vssd1 vccd1 vccd1 sky130_fd_sc_hd__fill_1
XANTENNA__6335__A _6978_/A vssd1 vssd1 vccd1 vccd1 sky130_fd_sc_hd__diode_2
XFILLER_92_389 vssd1 vssd1 vccd1 vccd1 sky130_fd_sc_hd__fill_2
XTAP_TAPCELL_ROW_28_481 vssd1 vccd1 sky130_fd_sc_hd__tapvpwrvgnd_1
XFILLER_60_275 vssd1 vssd1 vccd1 vccd1 sky130_fd_sc_hd__fill_4
X_4770_ _4770_/A _4770_/B vssd1 vssd1 vccd1 vccd1 _4771_/B sky130_fd_sc_hd__nor2_2
X_6440_ _6240_/B _6242_/B _6240_/A vssd1 vssd1 vccd1 vccd1 _6442_/B sky130_fd_sc_hd__o21ba_2
X_6371_ _8412_/D _6762_/B vssd1 vssd1 vccd1 vccd1 _6632_/A sky130_fd_sc_hd__nand2_2
X_8110_ _8110_/A _8110_/B _8277_/A _8361_/Q vssd1 vssd1 vccd1 vccd1 _8111_/D sky130_fd_sc_hd__nand4_2
X_5322_ _8202_/A _5569_/C _5569_/D _6035_/C vssd1 vssd1 vccd1 vccd1 _5323_/B sky130_fd_sc_hd__a22oi_2
XANTENNA__7613__B _8081_/B vssd1 vssd1 vccd1 vccd1 sky130_fd_sc_hd__diode_2
X_8041_ _8041_/A _8041_/B _8041_/C vssd1 vssd1 vccd1 vccd1 _8043_/A sky130_fd_sc_hd__and3_2
X_5253_ _8408_/D _5274_/B vssd1 vssd1 vccd1 vccd1 _5273_/A sky130_fd_sc_hd__nand2_2
XANTENNA__5414__A _6198_/A vssd1 vssd1 vccd1 vccd1 sky130_fd_sc_hd__diode_2
XANTENNA_rebuffer446_X _6090_/A1 vssd1 vssd1 vccd1 vccd1 sky130_fd_sc_hd__diode_2
XFILLER_68_320 vssd1 vssd1 vccd1 vccd1 sky130_fd_sc_hd__fill_4
XFILLER_68_331 vssd1 vssd1 vccd1 vccd1 sky130_fd_sc_hd__fill_2
X_5184_ _5027_/C _5027_/Y _5756_/B _5183_/Y vssd1 vssd1 vccd1 vccd1 _5699_/A sky130_fd_sc_hd__a211oi_2
X_4204_ input4/X _4223_/B vssd1 vssd1 vccd1 vccd1 _4204_/Y sky130_fd_sc_hd__nand2b_2
XFILLER_3_70 vssd1 vssd1 vccd1 vccd1 sky130_fd_sc_hd__fill_2
XANTENNA__4972__B _4972_/B vssd1 vssd1 vccd1 vccd1 sky130_fd_sc_hd__diode_2
XANTENNA__7549__B1 _7897_/B vssd1 vssd1 vccd1 vccd1 sky130_fd_sc_hd__diode_2
XANTENNA_fanout260_A _6830_/A vssd1 vssd1 vccd1 vccd1 sky130_fd_sc_hd__diode_2
X_7825_ _7686_/A _7686_/B _7687_/Y _7689_/B vssd1 vssd1 vccd1 vccd1 _7827_/B sky130_fd_sc_hd__o22a_2
XTAP_TAPCELL_ROW_54_738 vssd1 vccd1 sky130_fd_sc_hd__tapvpwrvgnd_1
XANTENNA_fanout146_X _4931_/C vssd1 vssd1 vccd1 vccd1 sky130_fd_sc_hd__diode_2
X_7756_ _8001_/A _8125_/B vssd1 vssd1 vccd1 vccd1 _7757_/B sky130_fd_sc_hd__nand2_2
X_4968_ _4967_/A _4967_/B _4736_/Y vssd1 vssd1 vccd1 vccd1 _5042_/B sky130_fd_sc_hd__o21bai_2
XFILLER_11_139 vssd1 vssd1 vccd1 vccd1 sky130_fd_sc_hd__fill_2
X_7687_ _7689_/A vssd1 vssd1 vccd1 vccd1 _7687_/Y sky130_fd_sc_hd__inv_2
X_6707_ _6707_/A _6707_/B vssd1 vssd1 vccd1 vccd1 _6709_/A sky130_fd_sc_hd__xnor2_2
X_4899_ _4900_/A _5017_/B _4900_/C vssd1 vssd1 vccd1 vccd1 _4899_/X sky130_fd_sc_hd__and3_2
X_6638_ _6638_/A _6759_/A vssd1 vssd1 vccd1 vccd1 _6638_/Y sky130_fd_sc_hd__nor2_2
X_8308_ _8442_/D _8184_/B _8313_/S vssd1 vssd1 vccd1 vccd1 _8383_/D sky130_fd_sc_hd__mux2_1
X_6569_ _6298_/A _6298_/B _6296_/X vssd1 vssd1 vccd1 vccd1 _6605_/A sky130_fd_sc_hd__a21o_2
X_8239_ _8234_/A _8237_/B _8234_/B vssd1 vssd1 vccd1 vccd1 _8248_/A sky130_fd_sc_hd__a21boi_2
XANTENNA__8029__A1 _8136_/A vssd1 vssd1 vccd1 vccd1 sky130_fd_sc_hd__diode_2
Xfanout130 _7095_/A vssd1 vssd1 vccd1 vccd1 _8411_/D sky130_fd_sc_hd__clkdlybuf4s25_1
XFILLER_59_353 vssd1 vssd1 vccd1 vccd1 sky130_fd_sc_hd__fill_1
Xfanout141 _4158_/Y vssd1 vssd1 vccd1 vccd1 _8429_/D sky130_fd_sc_hd__buf_4
XFILLER_47_526 vssd1 vssd1 vccd1 vccd1 sky130_fd_sc_hd__fill_2
Xfanout185 _4149_/X vssd1 vssd1 vccd1 vccd1 _5155_/A sky130_fd_sc_hd__buf_4
Xfanout196 _8403_/Q vssd1 vssd1 vccd1 vccd1 _8071_/S sky130_fd_sc_hd__clkdlybuf4s25_1
XANTENNA__4227__X _4821_/A vssd1 vssd1 vccd1 vccd1 sky130_fd_sc_hd__diode_2
XFILLER_62_529 vssd1 vssd1 vccd1 vccd1 sky130_fd_sc_hd__fill_2
XFILLER_15_434 vssd1 vssd1 vccd1 vccd1 sky130_fd_sc_hd__fill_1
XFILLER_63_42 vssd1 vssd1 vccd1 vccd1 sky130_fd_sc_hd__fill_1
XFILLER_42_253 vssd1 vccd1 vssd1 vccd1 sky130_ef_sc_hd__decap_40_12
XTAP_TAPCELL_ROW_25_451 vssd1 vccd1 sky130_fd_sc_hd__tapvpwrvgnd_1
XPHY_EDGE_ROW_69_Right_69 vssd1 vssd1 vccd1 vccd1 sky130_fd_sc_hd__decap_3
XFILLER_8_37 vssd1 vssd1 vccd1 vccd1 sky130_fd_sc_hd__fill_1
XANTENNA__7714__A _7714_/A vssd1 vssd1 vccd1 vccd1 sky130_fd_sc_hd__diode_2
XFILLER_6_165 vssd1 vssd1 vccd1 vccd1 sky130_fd_sc_hd__fill_1
XPHY_EDGE_ROW_78_Right_78 vssd1 vssd1 vccd1 vccd1 sky130_fd_sc_hd__decap_3
XANTENNA__4829__A1 _5928_/A vssd1 vssd1 vccd1 vccd1 sky130_fd_sc_hd__diode_2
XANTENNA__4776__C _5163_/C vssd1 vssd1 vccd1 vccd1 sky130_fd_sc_hd__diode_2
XANTENNA__4829__B2 _5930_/A vssd1 vssd1 vccd1 vccd1 sky130_fd_sc_hd__diode_2
XANTENNA__7491__A2 _8103_/D vssd1 vssd1 vccd1 vccd1 sky130_fd_sc_hd__diode_2
XFILLER_38_526 vssd1 vssd1 vccd1 vccd1 sky130_fd_sc_hd__fill_1
XFILLER_53_507 vssd1 vssd1 vccd1 vccd1 sky130_fd_sc_hd__fill_1
X_5940_ _6091_/A wire90/X vssd1 vssd1 vccd1 vccd1 _5941_/B sky130_fd_sc_hd__nand2_2
XPHY_EDGE_ROW_87_Right_87 vssd1 vssd1 vccd1 vccd1 sky130_fd_sc_hd__decap_3
XFILLER_92_197 vssd1 vssd1 vccd1 vccd1 sky130_fd_sc_hd__fill_4
X_7610_ _7059_/Y _7629_/A _7376_/A _7376_/B vssd1 vssd1 vccd1 vccd1 _7618_/A sky130_fd_sc_hd__o22ai_2
X_5871_ _5454_/B _5456_/A _5869_/Y _5870_/Y vssd1 vssd1 vccd1 vccd1 _6071_/A sky130_fd_sc_hd__o211a_2
XTAP_TAPCELL_ROW_51_708 vssd1 vccd1 sky130_fd_sc_hd__tapvpwrvgnd_1
XFILLER_21_437 vssd1 vssd1 vccd1 vccd1 sky130_fd_sc_hd__fill_1
X_4822_ _4821_/A _5138_/B _4891_/A _4821_/D vssd1 vssd1 vccd1 vccd1 _4823_/C sky130_fd_sc_hd__a22o_2
X_7541_ _7541_/A _7541_/B vssd1 vssd1 vccd1 vccd1 _7543_/B sky130_fd_sc_hd__xnor2_2
X_4753_ _4753_/A _4753_/B vssd1 vssd1 vccd1 vccd1 _4754_/B sky130_fd_sc_hd__xor2_2
XANTENNA__8430__D _8430_/D vssd1 vssd1 vccd1 vccd1 sky130_fd_sc_hd__diode_2
X_7472_ _7472_/A _7472_/B vssd1 vssd1 vccd1 vccd1 _7474_/B sky130_fd_sc_hd__xnor2_2
X_6423_ _6423_/A _6423_/B vssd1 vssd1 vccd1 vccd1 _6424_/C sky130_fd_sc_hd__xnor2_2
X_4684_ _4690_/A _4690_/B vssd1 vssd1 vccd1 vccd1 _4691_/A sky130_fd_sc_hd__or2_4
X_6354_ _6354_/A _6645_/A vssd1 vssd1 vccd1 vccd1 _6355_/B sky130_fd_sc_hd__nand2_2
X_6285_ _6154_/A _6154_/B _6152_/X vssd1 vssd1 vccd1 vccd1 _6389_/A sky130_fd_sc_hd__a21o_2
X_5305_ _5446_/A _6016_/A _5417_/D _5559_/B vssd1 vssd1 vccd1 vccd1 _5306_/B sky130_fd_sc_hd__a22oi_2
XFILLER_88_437 vssd1 vssd1 vccd1 vccd1 sky130_fd_sc_hd__fill_4
X_8024_ _8131_/A _8133_/C _8257_/A _8131_/B vssd1 vssd1 vccd1 vccd1 _8026_/A sky130_fd_sc_hd__a22oi_2
X_5236_ _5236_/A _5236_/B vssd1 vssd1 vccd1 vccd1 _5298_/A sky130_fd_sc_hd__xnor2_2
XFILLER_75_109 vssd1 vssd1 vccd1 vccd1 sky130_fd_sc_hd__fill_2
XANTENNA__4983__A _5157_/A vssd1 vssd1 vccd1 vccd1 sky130_fd_sc_hd__diode_2
X_5167_ _5168_/A _5168_/B vssd1 vssd1 vccd1 vccd1 _5167_/Y sky130_fd_sc_hd__nand2_2
XANTENNA__8174__B _8174_/B vssd1 vssd1 vccd1 vccd1 sky130_fd_sc_hd__diode_2
X_5098_ _5090_/Y _5097_/X _5082_/X _5083_/Y vssd1 vssd1 vccd1 vccd1 _5102_/A sky130_fd_sc_hd__a211o_2
XFILLER_44_518 vssd1 vssd1 vccd1 vccd1 sky130_fd_sc_hd__fill_2
XTAP_TAPCELL_ROW_67_874 vssd1 vccd1 sky130_fd_sc_hd__tapvpwrvgnd_1
XFILLER_17_57 vssd1 vssd1 vccd1 vccd1 sky130_fd_sc_hd__fill_1
XFILLER_71_337 vssd1 vssd1 vccd1 vccd1 sky130_fd_sc_hd__fill_4
XTAP_TAPCELL_ROW_39_587 vssd1 vccd1 sky130_fd_sc_hd__tapvpwrvgnd_1
XANTENNA__4207__B _4207_/B vssd1 vssd1 vccd1 vccd1 sky130_fd_sc_hd__diode_2
XANTENNA__6703__A _8436_/D vssd1 vssd1 vccd1 vccd1 sky130_fd_sc_hd__diode_2
X_7808_ _7808_/A _8077_/B vssd1 vssd1 vccd1 vccd1 _7809_/B sky130_fd_sc_hd__or2_2
X_7739_ _7740_/A _7740_/B vssd1 vssd1 vccd1 vccd1 _7906_/A sky130_fd_sc_hd__nand2b_2
XTAP_TAPCELL_ROW_22_421 vssd1 vccd1 sky130_fd_sc_hd__tapvpwrvgnd_1
XANTENNA__4223__A _8071_/S vssd1 vssd1 vccd1 vccd1 sky130_fd_sc_hd__diode_2
XFILLER_3_113 vssd1 vssd1 vccd1 vccd1 sky130_fd_sc_hd__fill_1
XFILLER_35_507 vssd1 vssd1 vccd1 vccd1 sky130_fd_sc_hd__fill_1
XFILLER_74_197 vssd1 vssd1 vccd1 vccd1 sky130_fd_sc_hd__fill_1
XFILLER_74_85 vssd1 vssd1 vccd1 vccd1 sky130_fd_sc_hd__fill_4
XANTENNA__6035__D _6035_/D vssd1 vssd1 vccd1 vccd1 sky130_fd_sc_hd__diode_2
XANTENNA__6613__A _7304_/A vssd1 vssd1 vccd1 vccd1 sky130_fd_sc_hd__diode_2
XANTENNA_max_cap159_X _7603_/A vssd1 vssd1 vccd1 vccd1 sky130_fd_sc_hd__diode_2
XTAP_TAPCELL_ROW_90_1103 vssd1 vccd1 sky130_fd_sc_hd__tapvpwrvgnd_1
XFILLER_31_3 vssd1 vssd1 vccd1 vccd1 sky130_fd_sc_hd__fill_4
XFILLER_85_407 vssd1 vssd1 vccd1 vccd1 sky130_fd_sc_hd__fill_2
X_6070_ _6071_/A _6071_/B _6071_/C vssd1 vssd1 vccd1 vccd1 _6277_/A sky130_fd_sc_hd__o21a_2
XFILLER_78_481 vssd1 vssd1 vccd1 vccd1 sky130_fd_sc_hd__fill_1
Xload_slew366 fanout365/X vssd1 vssd1 vccd1 vccd1 load_slew366/X sky130_fd_sc_hd__clkbuf_4
X_5021_ _5022_/A _5022_/B vssd1 vssd1 vccd1 vccd1 _5144_/B sky130_fd_sc_hd__nor2_2
XANTENNA__8425__D _8425_/D vssd1 vssd1 vccd1 vccd1 sky130_fd_sc_hd__diode_2
XFILLER_80_123 vssd1 vssd1 vccd1 vccd1 sky130_fd_sc_hd__fill_4
X_6972_ _7409_/A _8081_/B vssd1 vssd1 vccd1 vccd1 _6974_/B sky130_fd_sc_hd__nor2_2
XTAP_TAPCELL_ROW_88_1076 vssd1 vccd1 sky130_fd_sc_hd__tapvpwrvgnd_1
XTAP_TAPCELL_ROW_64_844 vssd1 vccd1 sky130_fd_sc_hd__tapvpwrvgnd_1
X_5923_ _5759_/A _5759_/B _5757_/X vssd1 vssd1 vccd1 vccd1 _5977_/A sky130_fd_sc_hd__a21o_2
XTAP_TAPCELL_ROW_36_557 vssd1 vccd1 sky130_fd_sc_hd__tapvpwrvgnd_1
X_5854_ _5854_/A _5854_/B _5854_/C vssd1 vssd1 vccd1 vccd1 _5854_/Y sky130_fd_sc_hd__nand3_2
X_4805_ _4805_/A _4805_/B vssd1 vssd1 vccd1 vccd1 _4882_/A sky130_fd_sc_hd__nand2_2
X_7524_ _8131_/A _8131_/B _8030_/A _7723_/C vssd1 vssd1 vccd1 vccd1 _7525_/B sky130_fd_sc_hd__and4_2
Xrebuffer505 _7661_/X vssd1 vssd1 vccd1 vccd1 _7940_/A1 sky130_fd_sc_hd__buf_2
X_5785_ _8416_/D wire77/X vssd1 vssd1 vccd1 vccd1 _5891_/A sky130_fd_sc_hd__nand2_2
XANTENNA_fanout223_A _7131_/A vssd1 vssd1 vccd1 vccd1 sky130_fd_sc_hd__diode_2
X_4736_ _5047_/A _5213_/A vssd1 vssd1 vccd1 vccd1 _4736_/Y sky130_fd_sc_hd__nor2_2
X_7455_ _7547_/A _7455_/B _7455_/C vssd1 vssd1 vccd1 vccd1 _7547_/B sky130_fd_sc_hd__nand3_2
X_4667_ _4667_/A _4709_/C vssd1 vssd1 vccd1 vccd1 _4669_/A sky130_fd_sc_hd__nand2_2
XFILLER_79_19 vssd1 vssd1 vccd1 vccd1 sky130_fd_sc_hd__fill_1
X_7386_ _7386_/A _7624_/A vssd1 vssd1 vccd1 vccd1 _7386_/Y sky130_fd_sc_hd__nand2_2
X_6406_ _7131_/A _7210_/A vssd1 vssd1 vccd1 vccd1 _6407_/B sky130_fd_sc_hd__nand2_2
X_6337_ _6970_/A _6337_/B _6337_/C vssd1 vssd1 vccd1 vccd1 _6338_/B sky130_fd_sc_hd__and3_2
X_4598_ _4649_/A _4598_/B vssd1 vssd1 vccd1 vccd1 _4645_/B sky130_fd_sc_hd__nand2_2
X_6268_ _6265_/Y _6266_/Y _6061_/A _6062_/A vssd1 vssd1 vccd1 vccd1 _6269_/B sky130_fd_sc_hd__a211o_2
X_8007_ _8007_/A _8007_/B vssd1 vssd1 vccd1 vccd1 _8009_/C sky130_fd_sc_hd__or2_2
X_6199_ _6198_/A _8136_/D _6395_/C vssd1 vssd1 vccd1 vccd1 _6199_/Y sky130_fd_sc_hd__a21oi_2
X_5219_ _5219_/A _5219_/B vssd1 vssd1 vccd1 vccd1 _5237_/A sky130_fd_sc_hd__xor2_2
XANTENNA__5321__B _6035_/C vssd1 vssd1 vccd1 vccd1 sky130_fd_sc_hd__diode_2
XANTENNA__6417__B _6894_/B vssd1 vssd1 vccd1 vccd1 sky130_fd_sc_hd__diode_2
XANTENNA__6433__A _6433_/A vssd1 vssd1 vccd1 vccd1 sky130_fd_sc_hd__diode_2
XFILLER_12_212 vssd1 vssd1 vccd1 vccd1 sky130_fd_sc_hd__fill_2
XFILLER_44_66 vssd1 vssd1 vccd1 vccd1 sky130_fd_sc_hd__fill_1
XFILLER_4_411 vssd1 vssd1 vccd1 vccd1 sky130_fd_sc_hd__fill_1
XFILLER_5_27 vssd1 vssd1 vccd1 vccd1 sky130_fd_sc_hd__fill_2
Xclkbuf_4_0_0_clk clkbuf_0_clk/X vssd1 vssd1 vccd1 vccd1 clkload0/A sky130_fd_sc_hd__clkbuf_8
XANTENNA__5055__Y wire77/A vssd1 vssd1 vccd1 vccd1 sky130_fd_sc_hd__diode_2
XFILLER_4_466 vssd1 vssd1 vccd1 vccd1 sky130_fd_sc_hd__fill_2
XFILLER_5_38 vssd1 vssd1 vccd1 vccd1 sky130_fd_sc_hd__fill_2
XFILLER_79_223 vssd1 vssd1 vccd1 vccd1 sky130_fd_sc_hd__fill_1
XFILLER_69_96 vssd1 vssd1 vccd1 vccd1 sky130_fd_sc_hd__fill_2
XFILLER_79_267 vssd1 vssd1 vccd1 vccd1 sky130_fd_sc_hd__fill_1
XTAP_TAPCELL_ROW_7_271 vssd1 vccd1 sky130_fd_sc_hd__tapvpwrvgnd_1
XFILLER_16_551 vssd1 vssd1 vccd1 vccd1 sky130_fd_sc_hd__fill_1
XFILLER_62_178 vssd1 vssd1 vccd1 vccd1 sky130_fd_sc_hd__fill_2
XTAP_TAPCELL_ROW_61_814 vssd1 vccd1 sky130_fd_sc_hd__tapvpwrvgnd_1
XTAP_TAPCELL_ROW_33_527 vssd1 vccd1 sky130_fd_sc_hd__tapvpwrvgnd_1
XANTENNA__6997__B _6997_/B vssd1 vssd1 vccd1 vccd1 sky130_fd_sc_hd__diode_2
XFILLER_79_3 vssd1 vssd1 vccd1 vccd1 sky130_fd_sc_hd__fill_2
X_5570_ _5569_/A _5569_/C _5569_/D _5647_/A vssd1 vssd1 vccd1 vccd1 _5571_/B sky130_fd_sc_hd__a22oi_2
X_4521_ _4521_/A _4521_/B vssd1 vssd1 vccd1 vccd1 _4522_/A sky130_fd_sc_hd__xor2_2
X_7240_ _7458_/A _7239_/B _7239_/C vssd1 vssd1 vccd1 vccd1 _7241_/B sky130_fd_sc_hd__a21o_2
X_4452_ _8392_/Q _8451_/Q vssd1 vssd1 vccd1 vccd1 _4453_/B sky130_fd_sc_hd__or2_2
X_7171_ _7171_/A _7171_/B _7171_/C vssd1 vssd1 vccd1 vccd1 _7172_/B sky130_fd_sc_hd__nand3_2
X_4383_ _4372_/A _4380_/Y _4382_/X vssd1 vssd1 vccd1 vccd1 _4397_/A sky130_fd_sc_hd__o21a_2
X_6122_ _6122_/A _6122_/B vssd1 vssd1 vccd1 vccd1 _6123_/B sky130_fd_sc_hd__xnor2_2
XFILLER_85_215 vssd1 vssd1 vccd1 vccd1 sky130_fd_sc_hd__fill_8
X_6053_ _6053_/A _6053_/B _6053_/C vssd1 vssd1 vccd1 vccd1 _6061_/A sky130_fd_sc_hd__and3_2
Xload_slew174 _4523_/A vssd1 vssd1 vccd1 vccd1 _4761_/A sky130_fd_sc_hd__clkbuf_4
X_5004_ _5004_/A _5004_/B vssd1 vssd1 vccd1 vccd1 _5006_/B sky130_fd_sc_hd__xnor2_2
XANTENNA_fanout173_A fanout176/X vssd1 vssd1 vccd1 vccd1 sky130_fd_sc_hd__diode_2
XFILLER_53_101 vssd1 vssd1 vccd1 vccd1 sky130_fd_sc_hd__fill_1
XTAP_TAPCELL_ROW_49_693 vssd1 vccd1 sky130_fd_sc_hd__tapvpwrvgnd_1
X_6955_ _7198_/A _6955_/B vssd1 vssd1 vccd1 vccd1 _6955_/X sky130_fd_sc_hd__or2_2
XFILLER_53_178 vssd1 vssd1 vccd1 vccd1 sky130_fd_sc_hd__fill_1
X_5906_ _5907_/A _5907_/B _5907_/C vssd1 vssd1 vccd1 vccd1 _5908_/A sky130_fd_sc_hd__a21oi_2
XANTENNA__7876__A2_N _7877_/B vssd1 vssd1 vccd1 vccd1 sky130_fd_sc_hd__diode_2
X_6886_ _8032_/A _7210_/A vssd1 vssd1 vccd1 vccd1 _6887_/B sky130_fd_sc_hd__nand2_2
XFILLER_14_58 vssd1 vssd1 vccd1 vccd1 sky130_fd_sc_hd__fill_1
XFILLER_22_554 vssd1 vssd1 vccd1 vccd1 sky130_fd_sc_hd__fill_4
X_5837_ _5838_/A _8220_/A _5838_/C _8228_/A vssd1 vssd1 vccd1 vccd1 _5839_/A sky130_fd_sc_hd__a22oi_2
XANTENNA__4187__A1 _8254_/B vssd1 vssd1 vccd1 vccd1 sky130_fd_sc_hd__diode_2
XANTENNA_fanout226_X _6016_/A vssd1 vssd1 vccd1 vccd1 sky130_fd_sc_hd__diode_2
X_5768_ _5770_/A _5770_/B vssd1 vssd1 vccd1 vccd1 _5768_/Y sky130_fd_sc_hd__nand2_2
X_7507_ _7594_/B _7507_/B vssd1 vssd1 vccd1 vccd1 _7509_/B sky130_fd_sc_hd__nor2_2
X_4719_ _4701_/X _4718_/X _4694_/B _4695_/Y vssd1 vssd1 vccd1 vccd1 _4719_/X sky130_fd_sc_hd__o211a_2
X_7438_ _7438_/A _7438_/B vssd1 vssd1 vccd1 vccd1 _7440_/B sky130_fd_sc_hd__xnor2_2
X_5699_ _5699_/A _5699_/B vssd1 vssd1 vccd1 vccd1 _5761_/A sky130_fd_sc_hd__or2_2
X_7369_ _7333_/A _7333_/B _7331_/X vssd1 vssd1 vccd1 vccd1 _7371_/B sky130_fd_sc_hd__a21oi_2
XFILLER_1_447 vssd1 vssd1 vccd1 vccd1 sky130_fd_sc_hd__fill_1
XFILLER_39_55 vssd1 vssd1 vccd1 vccd1 sky130_fd_sc_hd__fill_1
XTAP_TAPCELL_ROW_4_241 vssd1 vccd1 sky130_fd_sc_hd__tapvpwrvgnd_1
XANTENNA_fanout41_X _8081_/B vssd1 vssd1 vccd1 vccd1 sky130_fd_sc_hd__diode_2
XFILLER_32_307 vssd1 vssd1 vccd1 vccd1 sky130_fd_sc_hd__fill_1
XFILLER_71_53 vssd1 vssd1 vccd1 vccd1 sky130_fd_sc_hd__fill_2
XFILLER_9_569 vssd1 vssd1 vccd1 vccd1 sky130_fd_sc_hd__fill_1
XANTENNA__6610__B _7299_/C vssd1 vssd1 vccd1 vccd1 sky130_fd_sc_hd__diode_2
XANTENNA__5678__A1 _6035_/C vssd1 vssd1 vccd1 vccd1 sky130_fd_sc_hd__diode_2
XTAP_TAPCELL_ROW_10_298 vssd1 vccd1 sky130_fd_sc_hd__tapvpwrvgnd_1
XANTENNA__6609__Y _7299_/C vssd1 vssd1 vccd1 vccd1 sky130_fd_sc_hd__diode_2
XFILLER_0_480 vssd1 vssd1 vccd1 vccd1 sky130_fd_sc_hd__fill_1
XFILLER_48_451 vssd1 vssd1 vccd1 vccd1 sky130_fd_sc_hd__fill_1
XFILLER_82_218 vssd1 vssd1 vccd1 vccd1 sky130_fd_sc_hd__fill_2
XFILLER_35_123 vssd1 vssd1 vccd1 vccd1 sky130_fd_sc_hd__fill_4
XFILLER_35_145 vssd1 vssd1 vccd1 vccd1 sky130_fd_sc_hd__fill_2
XTAP_TAPCELL_ROW_85_1046 vssd1 vccd1 sky130_fd_sc_hd__tapvpwrvgnd_1
X_6740_ _7954_/A _7007_/B vssd1 vssd1 vccd1 vccd1 _6741_/B sky130_fd_sc_hd__nor2_2
XTAP_TAPCELL_ROW_46_663 vssd1 vccd1 sky130_fd_sc_hd__tapvpwrvgnd_1
XTAP_TAPCELL_ROW_18_376 vssd1 vccd1 sky130_fd_sc_hd__tapvpwrvgnd_1
X_6671_ _6672_/A _6672_/B vssd1 vssd1 vccd1 vccd1 _6671_/X sky130_fd_sc_hd__and2_2
X_8410_ clkload7/A _8410_/D load_slew358/X vssd1 vssd1 vccd1 vccd1 _8410_/Q sky130_fd_sc_hd__dfrtp_2
X_5622_ _5622_/A _5622_/B vssd1 vssd1 vccd1 vccd1 _5623_/A sky130_fd_sc_hd__or2_2
X_8341_ _8382_/CLK _8341_/D fanout369/X vssd1 vssd1 vccd1 vccd1 _8341_/Q sky130_fd_sc_hd__dfrtp_2
X_5553_ _5551_/A _5551_/B _5552_/X vssd1 vssd1 vccd1 vccd1 _5553_/X sky130_fd_sc_hd__o21ba_2
X_4504_ _4504_/A _4504_/B vssd1 vssd1 vccd1 vccd1 _4506_/C sky130_fd_sc_hd__xor2_2
X_8272_ _8274_/C _8272_/B vssd1 vssd1 vccd1 vccd1 _8355_/D sky130_fd_sc_hd__nor2_2
X_5484_ _5484_/A _5484_/B vssd1 vssd1 vccd1 vccd1 _5486_/A sky130_fd_sc_hd__nor2_2
X_7223_ _7224_/A _7224_/B vssd1 vssd1 vccd1 vccd1 _7443_/B sky130_fd_sc_hd__nand2_2
X_4435_ _4435_/A _4435_/B vssd1 vssd1 vccd1 vccd1 _4438_/A sky130_fd_sc_hd__xnor2_2
X_7154_ _8108_/A _7875_/D _7877_/B _8108_/B vssd1 vssd1 vccd1 vccd1 _7156_/A sky130_fd_sc_hd__a22oi_2
X_4366_ _4366_/A _4366_/B vssd1 vssd1 vccd1 vccd1 _4366_/X sky130_fd_sc_hd__xor2_2
X_6105_ _6105_/A _6105_/B vssd1 vssd1 vccd1 vccd1 _6106_/B sky130_fd_sc_hd__nor2_2
XANTENNA__8083__A2 _8082_/C vssd1 vssd1 vccd1 vccd1 sky130_fd_sc_hd__diode_2
X_7085_ _7085_/A _7085_/B vssd1 vssd1 vccd1 vccd1 _7087_/B sky130_fd_sc_hd__xnor2_2
X_4297_ _4557_/A _4654_/C _4339_/C vssd1 vssd1 vccd1 vccd1 _4401_/A sky130_fd_sc_hd__and3_2
XFILLER_58_259 vssd1 vssd1 vccd1 vccd1 sky130_fd_sc_hd__fill_2
X_6036_ _6435_/A _8208_/A _6035_/D _6238_/B vssd1 vssd1 vccd1 vccd1 _6037_/B sky130_fd_sc_hd__a22oi_2
XANTENNA__5302__D _5826_/A vssd1 vssd1 vccd1 vccd1 sky130_fd_sc_hd__diode_2
XANTENNA_fanout176_X fanout176/X vssd1 vssd1 vccd1 vccd1 sky130_fd_sc_hd__diode_2
XTAP_TAPCELL_ROW_1_211 vssd1 vccd1 sky130_fd_sc_hd__tapvpwrvgnd_1
XFILLER_14_307 vssd1 vssd1 vccd1 vccd1 sky130_fd_sc_hd__fill_1
X_7987_ _7988_/A _7988_/B _7986_/X vssd1 vssd1 vccd1 vccd1 _7987_/X sky130_fd_sc_hd__o21ba_2
XANTENNA__6414__C _7426_/A vssd1 vssd1 vccd1 vccd1 sky130_fd_sc_hd__diode_2
XFILLER_25_57 vssd1 vssd1 vccd1 vccd1 sky130_fd_sc_hd__fill_1
XFILLER_41_115 vssd1 vssd1 vccd1 vccd1 sky130_fd_sc_hd__fill_2
XFILLER_81_284 vssd1 vssd1 vccd1 vccd1 sky130_fd_sc_hd__fill_8
X_6938_ _7183_/B _6938_/B vssd1 vssd1 vccd1 vccd1 _6940_/B sky130_fd_sc_hd__nand2_2
X_6869_ _6869_/A _6869_/B _6867_/Y vssd1 vssd1 vccd1 vccd1 _6870_/B sky130_fd_sc_hd__nor3b_2
XTAP_TAPCELL_ROW_80_997 vssd1 vccd1 sky130_fd_sc_hd__tapvpwrvgnd_1
XANTENNA__7526__B _7723_/D vssd1 vssd1 vccd1 vccd1 sky130_fd_sc_hd__diode_2
XFILLER_9_3 vssd1 vssd1 vccd1 vccd1 sky130_fd_sc_hd__fill_2
XFILLER_66_31 vssd1 vssd1 vccd1 vccd1 sky130_fd_sc_hd__fill_4
XFILLER_57_281 vssd1 vssd1 vccd1 vccd1 sky130_fd_sc_hd__fill_4
Xteam_03_396 vssd1 vssd1 vccd1 vccd1 team_03_396/HI gpio_oeb[27] sky130_fd_sc_hd__conb_1
XFILLER_17_123 vssd1 vssd1 vccd1 vccd1 sky130_fd_sc_hd__fill_1
XFILLER_17_167 vssd1 vssd1 vccd1 vccd1 sky130_fd_sc_hd__fill_1
XTAP_TAPCELL_ROW_43_633 vssd1 vccd1 sky130_fd_sc_hd__tapvpwrvgnd_1
XFILLER_82_85 vssd1 vssd1 vccd1 vccd1 sky130_fd_sc_hd__fill_1
XTAP_TAPCELL_ROW_15_346 vssd1 vccd1 sky130_fd_sc_hd__tapvpwrvgnd_1
XANTENNA__7888__A2 _8103_/D vssd1 vssd1 vccd1 vccd1 sky130_fd_sc_hd__diode_2
XANTENNA__8312__S _8313_/S vssd1 vssd1 vccd1 vccd1 sky130_fd_sc_hd__diode_2
XFILLER_70_7 vssd1 vssd1 vccd1 vccd1 sky130_fd_sc_hd__fill_1
XANTENNA__7155__C _8352_/Q vssd1 vssd1 vccd1 vccd1 sky130_fd_sc_hd__diode_2
X_4220_ _4224_/A input2/X _8395_/Q vssd1 vssd1 vccd1 vccd1 _4220_/X sky130_fd_sc_hd__or3b_2
X_4151_ hold551/X input4/X _4160_/B vssd1 vssd1 vccd1 vccd1 _8431_/D sky130_fd_sc_hd__mux2_4
XFILLER_83_549 vssd1 vssd1 vccd1 vccd1 sky130_fd_sc_hd__fill_1
X_7910_ _8050_/A _7910_/B _7988_/B _7910_/D vssd1 vssd1 vccd1 vccd1 _8050_/B sky130_fd_sc_hd__nor4_2
XFILLER_48_281 vssd1 vssd1 vccd1 vccd1 sky130_fd_sc_hd__fill_4
X_7841_ _7842_/A _7842_/B vssd1 vssd1 vccd1 vccd1 _7977_/B sky130_fd_sc_hd__nand2_2
XANTENNA__6234__C _8233_/A vssd1 vssd1 vccd1 vccd1 sky130_fd_sc_hd__diode_2
XFILLER_51_435 vssd1 vssd1 vccd1 vccd1 sky130_fd_sc_hd__fill_1
X_7772_ _7746_/B _7546_/B _7548_/B _7574_/A vssd1 vssd1 vccd1 vccd1 _7773_/C sky130_fd_sc_hd__a31oi_2
X_4984_ _4984_/A _4984_/B vssd1 vssd1 vccd1 vccd1 _4985_/B sky130_fd_sc_hd__xnor2_2
X_6723_ _6723_/A _8077_/B vssd1 vssd1 vccd1 vccd1 _6732_/A sky130_fd_sc_hd__or2_2
X_6654_ _6654_/A _6654_/B vssd1 vssd1 vccd1 vccd1 _6656_/B sky130_fd_sc_hd__xnor2_2
XANTENNA__6000__A1 _6397_/C vssd1 vssd1 vccd1 vccd1 sky130_fd_sc_hd__diode_2
XANTENNA__6000__B2 _6198_/A vssd1 vssd1 vccd1 vccd1 sky130_fd_sc_hd__diode_2
X_5605_ _8168_/A _8174_/A _5838_/A _5670_/B vssd1 vssd1 vccd1 vccd1 _5607_/A sky130_fd_sc_hd__and4_2
XANTENNA__5147__A _6712_/A vssd1 vssd1 vccd1 vccd1 sky130_fd_sc_hd__diode_2
X_6585_ _8433_/D wire90/X vssd1 vssd1 vccd1 vccd1 _6586_/B sky130_fd_sc_hd__nand2_2
X_8324_ _8334_/CLK _8324_/D load_slew381/X vssd1 vssd1 vccd1 vccd1 _8324_/Q sky130_fd_sc_hd__dfrtp_2
X_5536_ _5446_/A _5417_/D _5826_/A _5559_/B vssd1 vssd1 vccd1 vccd1 _5537_/B sky130_fd_sc_hd__a22oi_2
X_8255_ _8255_/A _8255_/B _8259_/B vssd1 vssd1 vccd1 vccd1 _8255_/X sky130_fd_sc_hd__and3_2
X_5467_ _5468_/B _5506_/A _5468_/A vssd1 vssd1 vccd1 vccd1 _5876_/A sky130_fd_sc_hd__o21a_2
X_7206_ _7208_/A vssd1 vssd1 vccd1 vccd1 _7206_/Y sky130_fd_sc_hd__inv_2
X_4418_ _4417_/A _4417_/B _4516_/A _4290_/X vssd1 vssd1 vccd1 vccd1 _4424_/A sky130_fd_sc_hd__a2bb2o_2
XFILLER_59_502 vssd1 vssd1 vccd1 vccd1 sky130_fd_sc_hd__fill_2
X_8186_ _8179_/A _8179_/B _8180_/Y vssd1 vssd1 vccd1 vccd1 _8187_/B sky130_fd_sc_hd__a21boi_2
Xfanout323 _8343_/Q vssd1 vssd1 vccd1 vccd1 _6892_/D sky130_fd_sc_hd__clkdlybuf4s25_1
Xfanout312 _6238_/D vssd1 vssd1 vccd1 vccd1 _8220_/A sky130_fd_sc_hd__clkdlybuf4s25_1
Xfanout301 _8349_/Q vssd1 vssd1 vccd1 vccd1 _8246_/A sky130_fd_sc_hd__clkdlybuf4s25_1
X_5398_ _5399_/B _5399_/A vssd1 vssd1 vccd1 vccd1 _5398_/X sky130_fd_sc_hd__and2b_2
XANTENNA__6067__A1 _6460_/A vssd1 vssd1 vccd1 vccd1 sky130_fd_sc_hd__diode_2
XANTENNA_fanout293_X _7875_/C vssd1 vssd1 vccd1 vccd1 sky130_fd_sc_hd__diode_2
Xfanout356 _8335_/Q vssd1 vssd1 vccd1 vccd1 _6198_/A sky130_fd_sc_hd__clkdlybuf4s25_1
Xfanout345 _5386_/A vssd1 vssd1 vccd1 vccd1 _8174_/A sky130_fd_sc_hd__clkdlybuf4s25_1
Xfanout334 _7120_/A vssd1 vssd1 vccd1 vccd1 _6798_/B sky130_fd_sc_hd__clkdlybuf4s25_1
X_7137_ _7137_/A _7137_/B _7137_/C vssd1 vssd1 vccd1 vccd1 _7149_/B sky130_fd_sc_hd__nand3_2
X_4349_ _4761_/A _4919_/B _4350_/B vssd1 vssd1 vccd1 vccd1 _4349_/X sky130_fd_sc_hd__and3_2
Xfanout378 fanout379/X vssd1 vssd1 vccd1 vccd1 fanout378/X sky130_fd_sc_hd__clkdlybuf4s25_1
Xfanout367 fanout379/X vssd1 vssd1 vccd1 vccd1 wire368/A sky130_fd_sc_hd__clkdlybuf4s25_1
X_7068_ _7068_/A _7068_/B vssd1 vssd1 vccd1 vccd1 _7074_/A sky130_fd_sc_hd__xnor2_2
XFILLER_36_12 vssd1 vccd1 vssd1 vccd1 sky130_ef_sc_hd__decap_40_12
XFILLER_86_398 vssd1 vssd1 vccd1 vccd1 sky130_fd_sc_hd__fill_2
X_6019_ _7233_/A _7426_/A vssd1 vssd1 vccd1 vccd1 _6020_/B sky130_fd_sc_hd__nand2_2
XFILLER_39_281 vssd1 vssd1 vccd1 vccd1 sky130_fd_sc_hd__fill_2
XTAP_TAPCELL_ROW_57_769 vssd1 vccd1 sky130_fd_sc_hd__tapvpwrvgnd_1
XANTENNA__8323__CLK _8402_/CLK vssd1 vssd1 vccd1 vccd1 sky130_fd_sc_hd__diode_2
XFILLER_14_104 vssd1 vssd1 vccd1 vccd1 sky130_fd_sc_hd__fill_1
XFILLER_42_435 vssd1 vssd1 vccd1 vccd1 sky130_fd_sc_hd__fill_1
XFILLER_42_479 vssd1 vssd1 vccd1 vccd1 sky130_fd_sc_hd__fill_4
XTAP_TAPCELL_ROW_40_603 vssd1 vccd1 sky130_fd_sc_hd__tapvpwrvgnd_1
XTAP_TAPCELL_ROW_12_316 vssd1 vccd1 sky130_fd_sc_hd__tapvpwrvgnd_1
XFILLER_77_332 vssd1 vssd1 vccd1 vccd1 sky130_fd_sc_hd__fill_4
XFILLER_77_41 vssd1 vssd1 vccd1 vccd1 sky130_fd_sc_hd__fill_4
XANTENNA__6616__A _6978_/A vssd1 vssd1 vccd1 vccd1 sky130_fd_sc_hd__diode_2
XANTENNA__6335__B _8081_/B vssd1 vssd1 vccd1 vccd1 sky130_fd_sc_hd__diode_2
XTAP_TAPCELL_ROW_82_1016 vssd1 vccd1 sky130_fd_sc_hd__tapvpwrvgnd_1
XTAP_TAPCELL_ROW_28_482 vssd1 vccd1 sky130_fd_sc_hd__tapvpwrvgnd_1
XFILLER_61_3 vssd1 vssd1 vccd1 vccd1 sky130_fd_sc_hd__fill_1
X_6370_ _5901_/B _6361_/A _6169_/X vssd1 vssd1 vccd1 vccd1 _6377_/A sky130_fd_sc_hd__o21ba_2
X_5321_ _8202_/A _6035_/C _5569_/C _5569_/D vssd1 vssd1 vccd1 vccd1 _5323_/A sky130_fd_sc_hd__and4_2
X_8040_ _8040_/A _8040_/B _8040_/C vssd1 vssd1 vccd1 vccd1 _8041_/C sky130_fd_sc_hd__nand3_2
X_5252_ _5250_/B _5250_/C _5250_/A vssd1 vssd1 vccd1 vccd1 _5295_/B sky130_fd_sc_hd__a21oi_2
XANTENNA__8428__D _8428_/D vssd1 vssd1 vccd1 vccd1 sky130_fd_sc_hd__diode_2
X_5183_ _5700_/B _5182_/B _5182_/C vssd1 vssd1 vccd1 vccd1 _5183_/Y sky130_fd_sc_hd__a21oi_2
X_4203_ _6174_/A vssd1 vssd1 vccd1 vccd1 _4203_/Y sky130_fd_sc_hd__inv_2
XFILLER_68_365 vssd1 vssd1 vccd1 vccd1 sky130_fd_sc_hd__fill_2
XFILLER_83_335 vssd1 vssd1 vccd1 vccd1 sky130_fd_sc_hd__fill_1
XANTENNA__7549__A1 _7889_/A vssd1 vssd1 vccd1 vccd1 sky130_fd_sc_hd__diode_2
XANTENNA__7549__B2 _7889_/B vssd1 vssd1 vccd1 vccd1 sky130_fd_sc_hd__diode_2
XANTENNA_fanout253_A _8367_/Q vssd1 vssd1 vccd1 vccd1 sky130_fd_sc_hd__diode_2
X_7824_ _7947_/B _7824_/B vssd1 vssd1 vccd1 vccd1 _7827_/A sky130_fd_sc_hd__nand2_2
Xwire66 wire66/A vssd1 vssd1 vccd1 vccd1 wire66/X sky130_fd_sc_hd__clkbuf_4
Xwire77 wire77/A vssd1 vssd1 vccd1 vccd1 wire77/X sky130_fd_sc_hd__clkbuf_4
XTAP_TAPCELL_ROW_54_739 vssd1 vccd1 sky130_fd_sc_hd__tapvpwrvgnd_1
XFILLER_51_232 vssd1 vssd1 vccd1 vccd1 sky130_fd_sc_hd__fill_2
Xwire99 wire99/A vssd1 vssd1 vccd1 vccd1 wire99/X sky130_fd_sc_hd__clkbuf_4
XFILLER_11_118 vssd1 vssd1 vccd1 vccd1 sky130_fd_sc_hd__fill_2
X_7755_ _7755_/A _7755_/B vssd1 vssd1 vccd1 vccd1 _7757_/A sky130_fd_sc_hd__nor2_2
X_4967_ _4967_/A _4967_/B _4736_/Y vssd1 vssd1 vccd1 vccd1 _5103_/A sky130_fd_sc_hd__or3b_4
X_7686_ _7686_/A _7686_/B vssd1 vssd1 vccd1 vccd1 _7689_/A sky130_fd_sc_hd__xor2_2
X_6706_ _6706_/A _6706_/B vssd1 vssd1 vccd1 vccd1 _6707_/B sky130_fd_sc_hd__xnor2_2
X_4898_ _5020_/A _4897_/B _5017_/A _4897_/D vssd1 vssd1 vccd1 vccd1 _4900_/C sky130_fd_sc_hd__a22o_2
X_6637_ _8415_/D wire64/X vssd1 vssd1 vccd1 vccd1 _6759_/A sky130_fd_sc_hd__nand2_2
XANTENNA_fanout306_X _8136_/A vssd1 vssd1 vccd1 vccd1 sky130_fd_sc_hd__diode_2
X_6568_ _6328_/A _6328_/B _6326_/Y vssd1 vssd1 vccd1 vccd1 _6607_/A sky130_fd_sc_hd__a21bo_2
X_8307_ _8441_/D _8179_/B _8307_/S vssd1 vssd1 vccd1 vccd1 _8382_/D sky130_fd_sc_hd__mux2_1
X_5519_ _5569_/A _5612_/B _5487_/B _5479_/Y vssd1 vssd1 vccd1 vccd1 _5520_/B sky130_fd_sc_hd__o2bb2a_2
XFILLER_3_339 vssd1 vssd1 vccd1 vccd1 sky130_fd_sc_hd__fill_1
X_6499_ _6499_/A _6499_/B _6499_/C vssd1 vssd1 vccd1 vccd1 _6511_/B sky130_fd_sc_hd__nand3_2
XFILLER_78_107 vssd1 vssd1 vccd1 vccd1 sky130_fd_sc_hd__fill_4
X_8238_ _8233_/A _8237_/Y _8259_/A vssd1 vssd1 vccd1 vccd1 _8347_/D sky130_fd_sc_hd__mux2_1
X_8169_ _8170_/A _8170_/B _8165_/A _8164_/B vssd1 vssd1 vccd1 vccd1 _8171_/B sky130_fd_sc_hd__a2bb2o_2
Xfanout120 _4215_/Y vssd1 vssd1 vccd1 vccd1 _8419_/D sky130_fd_sc_hd__clkdlybuf4s25_1
Xfanout131 _8423_/D vssd1 vssd1 vccd1 vccd1 _4709_/B sky130_fd_sc_hd__buf_6
XFILLER_47_505 vssd1 vssd1 vccd1 vccd1 sky130_fd_sc_hd__fill_1
Xfanout142 fanout142/A vssd1 vssd1 vccd1 vccd1 _6294_/A sky130_fd_sc_hd__clkdlybuf4s25_1
Xfanout164 _4821_/A vssd1 vssd1 vccd1 vccd1 _4744_/A sky130_fd_sc_hd__clkdlybuf4s25_1
Xfanout175 fanout176/X vssd1 vssd1 vccd1 vccd1 _4646_/A sky130_fd_sc_hd__buf_8
Xfanout186 _4149_/X vssd1 vssd1 vccd1 vccd1 _8433_/D sky130_fd_sc_hd__clkdlybuf4s25_1
Xfanout197 _8398_/D vssd1 vssd1 vccd1 vccd1 _4160_/B sky130_fd_sc_hd__clkdlybuf4s25_1
XANTENNA__5340__A _6035_/C vssd1 vssd1 vccd1 vccd1 sky130_fd_sc_hd__diode_2
XFILLER_74_346 vssd1 vssd1 vccd1 vccd1 sky130_fd_sc_hd__fill_8
XFILLER_47_99 vssd1 vssd1 vccd1 vccd1 sky130_fd_sc_hd__fill_2
XFILLER_82_390 vssd1 vssd1 vccd1 vccd1 sky130_fd_sc_hd__fill_1
XFILLER_42_265 vssd1 vssd1 vccd1 vccd1 sky130_fd_sc_hd__fill_4
XFILLER_63_98 vssd1 vssd1 vccd1 vccd1 sky130_fd_sc_hd__fill_4
XTAP_TAPCELL_ROW_25_452 vssd1 vccd1 sky130_fd_sc_hd__tapvpwrvgnd_1
XANTENNA__8268__A2 _8267_/C vssd1 vssd1 vccd1 vccd1 sky130_fd_sc_hd__diode_2
XPHY_EDGE_ROW_0_Left_93 vssd1 vssd1 vccd1 vccd1 sky130_fd_sc_hd__decap_3
XFILLER_65_313 vssd1 vssd1 vccd1 vccd1 sky130_fd_sc_hd__fill_1
XFILLER_65_335 vssd1 vssd1 vccd1 vccd1 sky130_fd_sc_hd__fill_1
XFILLER_80_305 vssd1 vssd1 vccd1 vccd1 sky130_fd_sc_hd__fill_2
XFILLER_92_154 vssd1 vssd1 vccd1 vccd1 sky130_fd_sc_hd__fill_1
X_5870_ _5868_/A _5868_/B _5868_/C vssd1 vssd1 vccd1 vccd1 _5870_/Y sky130_fd_sc_hd__o21ai_2
XFILLER_92_187 vssd1 vssd1 vccd1 vccd1 sky130_fd_sc_hd__fill_2
XFILLER_61_552 vssd1 vssd1 vccd1 vccd1 sky130_fd_sc_hd__fill_2
X_4821_ _4821_/A _6712_/B _4891_/A _4821_/D vssd1 vssd1 vccd1 vccd1 _4891_/B sky130_fd_sc_hd__nand4_2
XTAP_TAPCELL_ROW_51_709 vssd1 vccd1 sky130_fd_sc_hd__tapvpwrvgnd_1
X_7540_ _7541_/A _7541_/B vssd1 vssd1 vccd1 vccd1 _7765_/A sky130_fd_sc_hd__nand2b_2
X_4752_ _4753_/A _4753_/B vssd1 vssd1 vccd1 vccd1 _4752_/X sky130_fd_sc_hd__and2_2
X_7471_ _7472_/B _7472_/A vssd1 vssd1 vccd1 vccd1 _7569_/A sky130_fd_sc_hd__and2b_2
X_4683_ _4683_/A _4683_/B vssd1 vssd1 vccd1 vccd1 _4690_/B sky130_fd_sc_hd__nor2_2
X_6422_ _6423_/A _6423_/B vssd1 vssd1 vccd1 vccd1 _6533_/B sky130_fd_sc_hd__nand2b_2
X_6353_ _6354_/A _6645_/A vssd1 vssd1 vccd1 vccd1 _6355_/A sky130_fd_sc_hd__or2_2
XFILLER_88_416 vssd1 vssd1 vccd1 vccd1 sky130_fd_sc_hd__fill_4
X_6284_ _6194_/A _6194_/B _6192_/X vssd1 vssd1 vccd1 vccd1 _6391_/A sky130_fd_sc_hd__a21o_2
X_5304_ _5446_/A _5559_/B _6016_/A _5417_/D vssd1 vssd1 vccd1 vccd1 _5306_/A sky130_fd_sc_hd__and4_2
XFILLER_88_449 vssd1 vccd1 vssd1 vccd1 sky130_ef_sc_hd__decap_40_12
X_8023_ _8023_/A _8023_/B vssd1 vssd1 vccd1 vccd1 _8041_/A sky130_fd_sc_hd__xor2_2
X_5235_ _5234_/A _5234_/C _5234_/B vssd1 vssd1 vccd1 vccd1 _5235_/X sky130_fd_sc_hd__o21a_2
XANTENNA__6690__A1 _6689_/A vssd1 vssd1 vccd1 vccd1 sky130_fd_sc_hd__diode_2
XFILLER_29_505 vssd1 vssd1 vccd1 vccd1 sky130_fd_sc_hd__fill_1
XFILLER_56_302 vssd1 vssd1 vccd1 vccd1 sky130_fd_sc_hd__fill_1
X_5166_ _4973_/A _4973_/B _4975_/A _4975_/B vssd1 vssd1 vccd1 vccd1 _5168_/B sky130_fd_sc_hd__a2bb2o_2
XFILLER_68_195 vssd1 vssd1 vccd1 vccd1 sky130_fd_sc_hd__fill_1
X_5097_ _5212_/A _5212_/B vssd1 vssd1 vccd1 vccd1 _5097_/X sky130_fd_sc_hd__or2_2
XANTENNA__5245__A2 _5780_/B vssd1 vssd1 vccd1 vccd1 sky130_fd_sc_hd__diode_2
XTAP_TAPCELL_ROW_67_875 vssd1 vccd1 sky130_fd_sc_hd__tapvpwrvgnd_1
XTAP_TAPCELL_ROW_39_588 vssd1 vccd1 sky130_fd_sc_hd__tapvpwrvgnd_1
XANTENNA__8190__B _8191_/B vssd1 vssd1 vccd1 vccd1 sky130_fd_sc_hd__diode_2
X_7807_ _7807_/A _7807_/B vssd1 vssd1 vccd1 vccd1 _7809_/A sky130_fd_sc_hd__xnor2_2
X_5999_ _5999_/A _5999_/B vssd1 vssd1 vccd1 vccd1 _6078_/A sky130_fd_sc_hd__xor2_2
XFILLER_33_46 vssd1 vssd1 vccd1 vccd1 sky130_fd_sc_hd__fill_2
XFILLER_33_57 vssd1 vssd1 vccd1 vccd1 sky130_fd_sc_hd__fill_1
X_7738_ _7738_/A _7738_/B vssd1 vssd1 vccd1 vccd1 _7740_/B sky130_fd_sc_hd__xnor2_2
XTAP_TAPCELL_ROW_22_422 vssd1 vccd1 sky130_fd_sc_hd__tapvpwrvgnd_1
XANTENNA__4223__B _4223_/B vssd1 vssd1 vccd1 vccd1 sky130_fd_sc_hd__diode_2
X_7669_ _6631_/A _8077_/B _7668_/C vssd1 vssd1 vccd1 vccd1 _7670_/B sky130_fd_sc_hd__o21ai_2
XPHY_EDGE_ROW_18_Left_111 vssd1 vssd1 vccd1 vccd1 sky130_fd_sc_hd__decap_3
XFILLER_79_449 vssd1 vssd1 vccd1 vccd1 sky130_fd_sc_hd__fill_2
XANTENNA__7550__A _7889_/A vssd1 vssd1 vccd1 vccd1 sky130_fd_sc_hd__diode_2
XFILLER_59_173 vssd1 vssd1 vccd1 vccd1 sky130_fd_sc_hd__fill_2
XFILLER_87_460 vssd1 vssd1 vccd1 vccd1 sky130_fd_sc_hd__fill_2
XFILLER_62_305 vssd1 vssd1 vccd1 vccd1 sky130_fd_sc_hd__fill_2
XFILLER_74_42 vssd1 vssd1 vccd1 vccd1 sky130_fd_sc_hd__fill_4
XPHY_EDGE_ROW_27_Left_120 vssd1 vssd1 vccd1 vccd1 sky130_fd_sc_hd__decap_3
XANTENNA__6613__B _8081_/B vssd1 vssd1 vccd1 vccd1 sky130_fd_sc_hd__diode_2
XANTENNA__4414__A _8430_/D vssd1 vssd1 vccd1 vccd1 sky130_fd_sc_hd__diode_2
XFILLER_90_85 vssd1 vssd1 vccd1 vccd1 sky130_fd_sc_hd__fill_2
XFILLER_90_74 vssd1 vssd1 vccd1 vccd1 sky130_fd_sc_hd__fill_8
XFILLER_11_471 vssd1 vssd1 vccd1 vccd1 sky130_fd_sc_hd__fill_1
Xwire362 wire362/A vssd1 vssd1 vccd1 vccd1 wire362/X sky130_fd_sc_hd__clkbuf_4
XTAP_TAPCELL_ROW_90_1104 vssd1 vccd1 sky130_fd_sc_hd__tapvpwrvgnd_1
X_5020_ _5020_/A _5138_/B vssd1 vssd1 vccd1 vccd1 _5022_/B sky130_fd_sc_hd__nand2_2
XANTENNA__5899__B _5899_/B vssd1 vssd1 vccd1 vccd1 sky130_fd_sc_hd__diode_2
XFILLER_24_3 vssd1 vssd1 vccd1 vccd1 sky130_fd_sc_hd__fill_1
XFILLER_65_132 vssd1 vssd1 vccd1 vccd1 sky130_fd_sc_hd__fill_4
X_6971_ _7299_/A _7095_/B _7095_/C vssd1 vssd1 vccd1 vccd1 _7097_/A sky130_fd_sc_hd__and3_2
XTAP_TAPCELL_ROW_88_1077 vssd1 vccd1 sky130_fd_sc_hd__tapvpwrvgnd_1
XFILLER_0_94 vssd1 vssd1 vccd1 vccd1 sky130_fd_sc_hd__fill_1
X_5922_ _7098_/A _6757_/B _5779_/A _5775_/Y vssd1 vssd1 vccd1 vccd1 _5988_/A sky130_fd_sc_hd__a31o_2
XTAP_TAPCELL_ROW_64_845 vssd1 vccd1 sky130_fd_sc_hd__tapvpwrvgnd_1
XTAP_TAPCELL_ROW_36_558 vssd1 vccd1 sky130_fd_sc_hd__tapvpwrvgnd_1
XFILLER_80_168 vssd1 vssd1 vccd1 vccd1 sky130_fd_sc_hd__fill_1
X_5853_ _5854_/A _5854_/B _5854_/C vssd1 vssd1 vccd1 vccd1 _6057_/A sky130_fd_sc_hd__a21o_2
X_5784_ _5782_/A _5901_/A _5783_/X vssd1 vssd1 vccd1 vccd1 _5795_/A sky130_fd_sc_hd__o21ai_2
X_4804_ _4806_/A _4806_/B vssd1 vssd1 vccd1 vccd1 _4804_/X sky130_fd_sc_hd__or2_2
X_7523_ _8131_/A _8030_/A _7723_/C _8131_/B vssd1 vssd1 vccd1 vccd1 _7525_/A sky130_fd_sc_hd__a22oi_2
Xrebuffer506 _4574_/B vssd1 vssd1 vccd1 vccd1 _4573_/A sky130_fd_sc_hd__buf_2
X_4735_ _8410_/D wire72/A vssd1 vssd1 vccd1 vccd1 _5046_/A sky130_fd_sc_hd__nand2_2
X_7454_ _7454_/A _7454_/B vssd1 vssd1 vccd1 vccd1 _7455_/C sky130_fd_sc_hd__xnor2_2
X_4666_ _4666_/A _4666_/B vssd1 vssd1 vccd1 vccd1 _4679_/A sky130_fd_sc_hd__xnor2_2
X_7385_ _7966_/A _8082_/D vssd1 vssd1 vccd1 vccd1 _7624_/A sky130_fd_sc_hd__nor2_2
X_6405_ _6405_/A _6405_/B vssd1 vssd1 vccd1 vccd1 _6407_/A sky130_fd_sc_hd__nor2_2
X_4597_ _4649_/A _4598_/B vssd1 vssd1 vccd1 vccd1 _4599_/C sky130_fd_sc_hd__and2_2
X_6336_ _7098_/A _6337_/B _6337_/C vssd1 vssd1 vccd1 vccd1 _6615_/A sky130_fd_sc_hd__and3_2
XFILLER_88_235 vssd1 vssd1 vccd1 vccd1 sky130_fd_sc_hd__fill_8
XFILLER_88_257 vssd1 vssd1 vccd1 vccd1 sky130_fd_sc_hd__fill_2
X_6267_ _6061_/A _6062_/A _6265_/Y _6266_/Y vssd1 vssd1 vccd1 vccd1 _6471_/A sky130_fd_sc_hd__o211a_2
XFILLER_28_13 vssd1 vssd1 vccd1 vccd1 sky130_fd_sc_hd__fill_2
X_8006_ _8006_/A _8006_/B vssd1 vssd1 vccd1 vccd1 _8007_/B sky130_fd_sc_hd__nor2_2
X_6198_ _6198_/A _8136_/D _6395_/C vssd1 vssd1 vccd1 vccd1 _6401_/A sky130_fd_sc_hd__and3_2
X_5218_ _5218_/A _5241_/A vssd1 vssd1 vccd1 vccd1 _5219_/B sky130_fd_sc_hd__nand2_2
XFILLER_28_35 vssd1 vssd1 vccd1 vccd1 sky130_fd_sc_hd__fill_1
X_5149_ _6294_/A _5149_/B _5149_/C vssd1 vssd1 vccd1 vccd1 _5151_/A sky130_fd_sc_hd__and3_2
XANTENNA__6415__A1 _7140_/A vssd1 vssd1 vccd1 vccd1 sky130_fd_sc_hd__diode_2
XANTENNA__6415__B2 _8126_/A vssd1 vssd1 vccd1 vccd1 sky130_fd_sc_hd__diode_2
XFILLER_17_519 vssd1 vssd1 vccd1 vccd1 sky130_fd_sc_hd__fill_1
XFILLER_28_68 vssd1 vssd1 vccd1 vccd1 sky130_fd_sc_hd__fill_2
XFILLER_44_305 vssd1 vssd1 vccd1 vccd1 sky130_fd_sc_hd__fill_2
XFILLER_56_143 vssd1 vccd1 vssd1 vccd1 sky130_ef_sc_hd__decap_40_12
XFILLER_71_113 vssd1 vssd1 vccd1 vccd1 sky130_fd_sc_hd__fill_1
XFILLER_71_135 vssd1 vssd1 vccd1 vccd1 sky130_fd_sc_hd__fill_4
XANTENNA__6433__B _8257_/A vssd1 vssd1 vccd1 vccd1 sky130_fd_sc_hd__diode_2
XFILLER_40_533 vssd1 vssd1 vccd1 vccd1 sky130_fd_sc_hd__fill_1
XFILLER_8_239 vssd1 vssd1 vccd1 vccd1 sky130_fd_sc_hd__fill_1
XANTENNA__4888__B wire64/A vssd1 vssd1 vccd1 vccd1 sky130_fd_sc_hd__diode_2
XFILLER_79_246 vssd1 vssd1 vccd1 vccd1 sky130_fd_sc_hd__fill_4
XTAP_TAPCELL_ROW_7_272 vssd1 vccd1 sky130_fd_sc_hd__tapvpwrvgnd_1
XFILLER_47_110 vssd1 vssd1 vccd1 vccd1 sky130_fd_sc_hd__fill_2
XANTENNA__8407__CLK clkload6/A vssd1 vssd1 vccd1 vccd1 sky130_fd_sc_hd__diode_2
XFILLER_62_113 vssd1 vssd1 vccd1 vccd1 sky130_fd_sc_hd__fill_2
XANTENNA__8315__S _8397_/D vssd1 vssd1 vccd1 vccd1 sky130_fd_sc_hd__diode_2
XFILLER_90_477 vssd1 vssd1 vccd1 vccd1 sky130_fd_sc_hd__fill_2
XTAP_TAPCELL_ROW_61_815 vssd1 vccd1 sky130_fd_sc_hd__tapvpwrvgnd_1
XANTENNA__4144__A _8397_/D vssd1 vssd1 vccd1 vccd1 sky130_fd_sc_hd__diode_2
XFILLER_31_533 vssd1 vssd1 vccd1 vccd1 sky130_fd_sc_hd__fill_1
XTAP_TAPCELL_ROW_33_528 vssd1 vccd1 sky130_fd_sc_hd__tapvpwrvgnd_1
XFILLER_86_5 vssd1 vssd1 vccd1 vccd1 sky130_fd_sc_hd__fill_1
X_4520_ _4518_/B _4558_/B _4520_/B1 _4555_/A vssd1 vssd1 vccd1 vccd1 _4521_/A sky130_fd_sc_hd__o22ai_2
XANTENNA__5145__A1 _5928_/A vssd1 vssd1 vccd1 vccd1 sky130_fd_sc_hd__diode_2
X_4451_ _8392_/Q _8451_/Q vssd1 vssd1 vccd1 vccd1 _4453_/A sky130_fd_sc_hd__nand2_2
X_7170_ _7171_/A _7171_/B _7171_/C vssd1 vssd1 vccd1 vccd1 _7273_/A sky130_fd_sc_hd__a21o_2
X_6121_ _6122_/A _6122_/B vssd1 vssd1 vccd1 vccd1 _6121_/X sky130_fd_sc_hd__and2b_2
X_4382_ _5157_/A _4780_/B _4399_/C vssd1 vssd1 vccd1 vccd1 _4382_/X sky130_fd_sc_hd__a21o_2
X_6052_ _5435_/A _5829_/B _5433_/B _5836_/B _5860_/A vssd1 vssd1 vccd1 vccd1 _6053_/C
+ sky130_fd_sc_hd__o41ai_2
XPHY_EDGE_ROW_7_Right_7 vssd1 vssd1 vccd1 vccd1 sky130_fd_sc_hd__decap_3
XANTENNA__8436__D _8436_/D vssd1 vssd1 vccd1 vccd1 sky130_fd_sc_hd__diode_2
XFILLER_85_249 vssd1 vssd1 vccd1 vccd1 sky130_fd_sc_hd__fill_4
X_5003_ _5003_/A _5003_/B vssd1 vssd1 vccd1 vccd1 _5004_/B sky130_fd_sc_hd__xnor2_2
XTAP_TAPCELL_ROW_77_970 vssd1 vccd1 sky130_fd_sc_hd__tapvpwrvgnd_1
XTAP_TAPCELL_ROW_49_694 vssd1 vccd1 sky130_fd_sc_hd__tapvpwrvgnd_1
XANTENNA__8225__S _8397_/D vssd1 vssd1 vccd1 vccd1 sky130_fd_sc_hd__diode_2
XFILLER_81_455 vssd1 vssd1 vccd1 vccd1 sky130_fd_sc_hd__fill_1
X_6954_ _6954_/A _6954_/B _6954_/C vssd1 vssd1 vccd1 vccd1 _6955_/B sky130_fd_sc_hd__and3_2
X_5905_ _5905_/A _5905_/B vssd1 vssd1 vccd1 vccd1 _5907_/C sky130_fd_sc_hd__xnor2_2
XFILLER_22_533 vssd1 vssd1 vccd1 vccd1 sky130_fd_sc_hd__fill_4
X_6885_ _6885_/A _6885_/B vssd1 vssd1 vccd1 vccd1 _6887_/A sky130_fd_sc_hd__nor2_2
XANTENNA_fanout333_A _7120_/A vssd1 vssd1 vccd1 vccd1 sky130_fd_sc_hd__diode_2
X_5836_ _5836_/A _5836_/B vssd1 vssd1 vccd1 vccd1 _5857_/A sky130_fd_sc_hd__xnor2_2
X_5767_ _5767_/A _5767_/B vssd1 vssd1 vccd1 vccd1 _5770_/B sky130_fd_sc_hd__xnor2_2
X_7506_ _7506_/A _7506_/B _7506_/C vssd1 vssd1 vccd1 vccd1 _7507_/B sky130_fd_sc_hd__nor3_2
X_5698_ _5192_/A _5762_/A2 _5191_/A _5190_/Y vssd1 vssd1 vccd1 vccd1 _5763_/A sky130_fd_sc_hd__o31a_2
X_4718_ _4715_/X _4716_/X _4717_/X vssd1 vssd1 vccd1 vccd1 _4718_/X sky130_fd_sc_hd__o21a_2
X_7437_ _8133_/B _8136_/A vssd1 vssd1 vccd1 vccd1 _7438_/B sky130_fd_sc_hd__nand2_2
X_4649_ _4649_/A _4686_/B vssd1 vssd1 vccd1 vccd1 _4670_/A sky130_fd_sc_hd__nand2_2
XANTENNA__6884__A1 _7120_/A vssd1 vssd1 vccd1 vccd1 sky130_fd_sc_hd__diode_2
XANTENNA__6884__B2 _6883_/A vssd1 vssd1 vccd1 vccd1 sky130_fd_sc_hd__diode_2
X_7368_ _7368_/A _7626_/A vssd1 vssd1 vccd1 vccd1 _7371_/A sky130_fd_sc_hd__xor2_2
XFILLER_39_23 vssd1 vssd1 vccd1 vccd1 sky130_fd_sc_hd__fill_2
X_7299_ _7299_/A _7299_/B _7299_/C vssd1 vssd1 vccd1 vccd1 _7300_/B sky130_fd_sc_hd__and3_2
X_6319_ _6319_/A _6319_/B vssd1 vssd1 vccd1 vccd1 _6320_/B sky130_fd_sc_hd__nor2_2
XANTENNA_fanout79_A _5052_/X vssd1 vssd1 vccd1 vccd1 sky130_fd_sc_hd__diode_2
XTAP_TAPCELL_ROW_4_242 vssd1 vccd1 sky130_fd_sc_hd__tapvpwrvgnd_1
XFILLER_9_537 vssd1 vssd1 vccd1 vccd1 sky130_fd_sc_hd__fill_1
XANTENNA__7275__A _7990_/A vssd1 vssd1 vccd1 vccd1 sky130_fd_sc_hd__diode_2
XANTENNA__8313__A1 input4/X vssd1 vssd1 vccd1 vccd1 sky130_fd_sc_hd__diode_2
XTAP_TAPCELL_ROW_10_299 vssd1 vccd1 sky130_fd_sc_hd__tapvpwrvgnd_1
XFILLER_75_260 vssd1 vssd1 vccd1 vccd1 sky130_fd_sc_hd__fill_2
XFILLER_63_455 vssd1 vssd1 vccd1 vccd1 sky130_fd_sc_hd__fill_1
XTAP_TAPCELL_ROW_85_1047 vssd1 vccd1 sky130_fd_sc_hd__tapvpwrvgnd_1
XTAP_TAPCELL_ROW_74_940 vssd1 vccd1 sky130_fd_sc_hd__tapvpwrvgnd_1
XFILLER_63_466 vssd1 vssd1 vccd1 vccd1 sky130_fd_sc_hd__fill_4
XTAP_TAPCELL_ROW_46_664 vssd1 vccd1 sky130_fd_sc_hd__tapvpwrvgnd_1
XANTENNA__8342__Q _8342_/Q vssd1 vssd1 vccd1 vccd1 sky130_fd_sc_hd__diode_2
XTAP_TAPCELL_ROW_18_377 vssd1 vccd1 sky130_fd_sc_hd__tapvpwrvgnd_1
XANTENNA_max_cap386_X _8202_/B vssd1 vssd1 vccd1 vccd1 sky130_fd_sc_hd__diode_2
X_6670_ _6368_/B _6380_/B _6368_/A vssd1 vssd1 vccd1 vccd1 _6672_/B sky130_fd_sc_hd__o21bai_2
XFILLER_91_3 vssd1 vssd1 vccd1 vccd1 sky130_fd_sc_hd__fill_1
X_5621_ _5621_/A _5621_/B vssd1 vssd1 vccd1 vccd1 _5622_/B sky130_fd_sc_hd__nor2_2
X_8340_ _8382_/CLK _8340_/D fanout371/X vssd1 vssd1 vccd1 vccd1 _8340_/Q sky130_fd_sc_hd__dfrtp_2
X_5552_ _5687_/B _5687_/A vssd1 vssd1 vccd1 vccd1 _5552_/X sky130_fd_sc_hd__and2b_2
XANTENNA__5417__B _6016_/A vssd1 vssd1 vccd1 vccd1 sky130_fd_sc_hd__diode_2
XANTENNA__8304__A1 _4144_/Y vssd1 vssd1 vccd1 vccd1 sky130_fd_sc_hd__diode_2
X_8271_ _8271_/A _8271_/B vssd1 vssd1 vccd1 vccd1 _8272_/B sky130_fd_sc_hd__nor2_2
X_4503_ _4503_/A _4503_/B vssd1 vssd1 vccd1 vccd1 _4504_/B sky130_fd_sc_hd__or2_4
X_5483_ _5568_/A _5618_/A _5569_/C _5569_/D vssd1 vssd1 vccd1 vccd1 _5484_/B sky130_fd_sc_hd__and4_2
X_7222_ _7222_/A _7222_/B vssd1 vssd1 vccd1 vccd1 _7224_/B sky130_fd_sc_hd__xnor2_2
X_4434_ _4744_/A _4432_/B _4537_/B _4431_/Y vssd1 vssd1 vccd1 vccd1 _4439_/A sky130_fd_sc_hd__a31o_2
X_7153_ _7153_/A _7153_/B vssd1 vssd1 vccd1 vccd1 _7177_/A sky130_fd_sc_hd__xor2_2
X_4365_ _4365_/A _4483_/A vssd1 vssd1 vccd1 vccd1 _4368_/A sky130_fd_sc_hd__xnor2_2
X_7084_ _7668_/A _7084_/B _7085_/A vssd1 vssd1 vccd1 vccd1 _7084_/X sky130_fd_sc_hd__or3_2
X_6104_ _6104_/A _6104_/B vssd1 vssd1 vccd1 vccd1 _6105_/B sky130_fd_sc_hd__and2_2
X_6035_ _6435_/A _6238_/B _6035_/C _6035_/D vssd1 vssd1 vccd1 vccd1 _6037_/A sky130_fd_sc_hd__and4_2
X_4296_ _8429_/D _4972_/B vssd1 vssd1 vccd1 vccd1 _4339_/C sky130_fd_sc_hd__and2_2
XFILLER_86_569 vssd1 vssd1 vccd1 vccd1 sky130_fd_sc_hd__fill_1
XTAP_TAPCELL_ROW_1_212 vssd1 vccd1 sky130_fd_sc_hd__tapvpwrvgnd_1
XFILLER_26_135 vssd1 vssd1 vccd1 vccd1 sky130_fd_sc_hd__fill_1
XFILLER_25_25 vssd1 vccd1 vssd1 vccd1 sky130_ef_sc_hd__decap_40_12
XFILLER_54_477 vssd1 vssd1 vccd1 vccd1 sky130_fd_sc_hd__fill_2
X_7986_ _7890_/A _7892_/B _7890_/B vssd1 vssd1 vccd1 vccd1 _7986_/X sky130_fd_sc_hd__o21ba_2
X_6937_ _6937_/A _6937_/B _6935_/Y vssd1 vssd1 vccd1 vccd1 _6938_/B sky130_fd_sc_hd__or3b_2
X_6868_ _6869_/A _6869_/B _6867_/Y vssd1 vssd1 vccd1 vccd1 _6870_/A sky130_fd_sc_hd__o21ba_2
XFILLER_22_363 vssd1 vssd1 vccd1 vccd1 sky130_fd_sc_hd__fill_1
X_5819_ _5819_/A _5819_/B vssd1 vssd1 vccd1 vccd1 _5821_/B sky130_fd_sc_hd__xnor2_2
XTAP_TAPCELL_ROW_80_998 vssd1 vccd1 sky130_fd_sc_hd__tapvpwrvgnd_1
XANTENNA__7095__A _7095_/A vssd1 vssd1 vccd1 vccd1 sky130_fd_sc_hd__diode_2
XFILLER_41_57 vssd1 vssd1 vccd1 vccd1 sky130_fd_sc_hd__fill_2
X_6799_ _6799_/A _6799_/B vssd1 vssd1 vccd1 vccd1 _6802_/A sky130_fd_sc_hd__xnor2_2
XFILLER_2_29 vssd1 vssd1 vccd1 vccd1 sky130_fd_sc_hd__fill_4
XFILLER_77_569 vssd1 vssd1 vccd1 vccd1 sky130_fd_sc_hd__fill_1
XFILLER_66_87 vssd1 vssd1 vccd1 vccd1 sky130_fd_sc_hd__fill_1
Xteam_03_397 vssd1 vssd1 vccd1 vccd1 team_03_397/HI gpio_oeb[28] sky130_fd_sc_hd__conb_1
XANTENNA__4180__A_N _8191_/B vssd1 vssd1 vccd1 vccd1 sky130_fd_sc_hd__diode_2
XANTENNA__8231__A0 _8228_/A vssd1 vssd1 vccd1 vccd1 sky130_fd_sc_hd__diode_2
XANTENNA_input11_A gpio_in[1] vssd1 vssd1 vccd1 vccd1 sky130_fd_sc_hd__diode_2
XFILLER_45_488 vssd1 vssd1 vccd1 vccd1 sky130_fd_sc_hd__fill_8
XFILLER_82_20 vssd1 vssd1 vccd1 vccd1 sky130_fd_sc_hd__fill_2
XTAP_TAPCELL_ROW_71_910 vssd1 vccd1 sky130_fd_sc_hd__tapvpwrvgnd_1
XFILLER_32_138 vssd1 vssd1 vccd1 vccd1 sky130_fd_sc_hd__fill_2
XTAP_TAPCELL_ROW_43_634 vssd1 vccd1 sky130_fd_sc_hd__tapvpwrvgnd_1
XTAP_TAPCELL_ROW_15_347 vssd1 vccd1 sky130_fd_sc_hd__tapvpwrvgnd_1
XANTENNA__8298__A0 _6006_/A vssd1 vssd1 vccd1 vccd1 sky130_fd_sc_hd__diode_2
XANTENNA__8267__C _8267_/C vssd1 vssd1 vccd1 vccd1 sky130_fd_sc_hd__diode_2
X_4150_ hold553/X input5/X _4160_/B vssd1 vssd1 vccd1 vccd1 _8432_/D sky130_fd_sc_hd__mux2_2
XANTENNA__8337__Q _8337_/Q vssd1 vssd1 vccd1 vccd1 sky130_fd_sc_hd__diode_2
XFILLER_68_569 vssd1 vssd1 vccd1 vccd1 sky130_fd_sc_hd__fill_1
XFILLER_83_539 vssd1 vssd1 vccd1 vccd1 sky130_fd_sc_hd__fill_1
X_7840_ _7977_/A _7840_/B vssd1 vssd1 vccd1 vccd1 _7842_/B sky130_fd_sc_hd__and2_2
X_7771_ _7771_/A _7771_/B vssd1 vssd1 vccd1 vccd1 _7773_/B sky130_fd_sc_hd__and2_2
X_4983_ _5157_/A _5710_/B _5710_/C vssd1 vssd1 vccd1 vccd1 _4984_/B sky130_fd_sc_hd__and3_2
XANTENNA__6234__D _8241_/A vssd1 vssd1 vccd1 vccd1 sky130_fd_sc_hd__diode_2
XFILLER_51_469 vssd1 vssd1 vccd1 vccd1 sky130_fd_sc_hd__fill_4
X_6722_ _6722_/A _6722_/B vssd1 vssd1 vccd1 vccd1 _7603_/B sky130_fd_sc_hd__xor2_2
X_6653_ _6654_/A _6654_/B vssd1 vssd1 vccd1 vccd1 _6743_/B sky130_fd_sc_hd__and2_2
XANTENNA__5428__A _6198_/A vssd1 vssd1 vccd1 vccd1 sky130_fd_sc_hd__diode_2
XANTENNA__6000__A2 _6001_/A vssd1 vssd1 vccd1 vccd1 sky130_fd_sc_hd__diode_2
X_5604_ _5604_/A _5604_/B vssd1 vssd1 vccd1 vccd1 _5604_/Y sky130_fd_sc_hd__xnor2_2
XANTENNA__8289__A0 _6433_/A vssd1 vssd1 vccd1 vccd1 sky130_fd_sc_hd__diode_2
XANTENNA_fanout129_A _7299_/A vssd1 vssd1 vccd1 vccd1 sky130_fd_sc_hd__diode_2
X_6584_ _6582_/X _6584_/B vssd1 vssd1 vccd1 vccd1 _6586_/A sky130_fd_sc_hd__nand2b_2
XANTENNA__5147__B _5147_/B vssd1 vssd1 vccd1 vccd1 sky130_fd_sc_hd__diode_2
XFILLER_11_38 vssd1 vssd1 vccd1 vccd1 sky130_fd_sc_hd__fill_1
XFILLER_11_49 vssd1 vssd1 vccd1 vccd1 sky130_fd_sc_hd__fill_4
X_8323_ _8402_/CLK _8323_/D load_slew381/X vssd1 vssd1 vccd1 vccd1 _8323_/Q sky130_fd_sc_hd__dfrtp_2
X_5535_ _5542_/B _5535_/B vssd1 vssd1 vccd1 vccd1 _5592_/A sky130_fd_sc_hd__or2_2
X_8254_ _8257_/A _8254_/B vssd1 vssd1 vccd1 vccd1 _8259_/B sky130_fd_sc_hd__or2_2
X_5466_ _5468_/B _5466_/B _5466_/C vssd1 vssd1 vccd1 vccd1 _5506_/A sky130_fd_sc_hd__nor3_2
X_7205_ _7205_/A _7205_/B vssd1 vssd1 vccd1 vccd1 _7208_/A sky130_fd_sc_hd__nor2_2
X_4417_ _4417_/A _4417_/B vssd1 vssd1 vccd1 vccd1 _4516_/A sky130_fd_sc_hd__xor2_2
X_8185_ _8183_/Y _8185_/B vssd1 vssd1 vccd1 vccd1 _8187_/A sky130_fd_sc_hd__and2b_2
Xfanout313 _6238_/D vssd1 vssd1 vccd1 vccd1 _7853_/A sky130_fd_sc_hd__clkdlybuf4s25_1
Xfanout302 _7723_/D vssd1 vssd1 vccd1 vccd1 _8136_/B sky130_fd_sc_hd__clkdlybuf4s25_1
X_5397_ _5362_/A _5361_/B _5361_/A vssd1 vssd1 vccd1 vccd1 _5399_/B sky130_fd_sc_hd__o21ba_2
XANTENNA_input3_A gpio_in[10] vssd1 vssd1 vccd1 vccd1 sky130_fd_sc_hd__diode_2
Xfanout357 fanout359/X vssd1 vssd1 vccd1 vccd1 fanout357/X sky130_fd_sc_hd__clkdlybuf4s25_1
Xfanout346 _5386_/A vssd1 vssd1 vccd1 vccd1 _5555_/A sky130_fd_sc_hd__clkdlybuf4s25_1
Xfanout335 _8340_/Q vssd1 vssd1 vccd1 vccd1 _7120_/A sky130_fd_sc_hd__clkdlybuf4s25_1
Xfanout324 _8342_/Q vssd1 vssd1 vccd1 vccd1 _8202_/A sky130_fd_sc_hd__clkdlybuf4s25_1
X_7136_ _7137_/A _7137_/B _7137_/C vssd1 vssd1 vccd1 vccd1 _7242_/A sky130_fd_sc_hd__a21o_2
X_4348_ _4348_/A _4348_/B vssd1 vssd1 vccd1 vccd1 _4350_/B sky130_fd_sc_hd__xnor2_2
XANTENNA__6067__A2 _8241_/A vssd1 vssd1 vccd1 vccd1 sky130_fd_sc_hd__diode_2
XANTENNA_fanout286_X _8126_/B vssd1 vssd1 vccd1 vccd1 sky130_fd_sc_hd__diode_2
XFILLER_59_569 vssd1 vssd1 vccd1 vccd1 sky130_fd_sc_hd__fill_1
Xfanout379 _4226_/X vssd1 vssd1 vccd1 vccd1 fanout379/X sky130_fd_sc_hd__clkdlybuf4s25_1
X_7067_ _7068_/A _7068_/B vssd1 vssd1 vccd1 vccd1 _7067_/X sky130_fd_sc_hd__and2b_2
X_4279_ _8390_/Q _8449_/Q vssd1 vssd1 vccd1 vccd1 _4279_/Y sky130_fd_sc_hd__nor2_2
X_6018_ _6018_/A _6018_/B vssd1 vssd1 vccd1 vccd1 _6020_/A sky130_fd_sc_hd__nor2_2
XFILLER_36_57 vssd1 vssd1 vccd1 vccd1 sky130_fd_sc_hd__fill_1
XFILLER_54_274 vssd1 vssd1 vccd1 vccd1 sky130_fd_sc_hd__fill_2
X_7969_ _7969_/A _8077_/B _7969_/C vssd1 vssd1 vccd1 vccd1 _7971_/A sky130_fd_sc_hd__or3_2
XTAP_TAPCELL_ROW_40_604 vssd1 vccd1 sky130_fd_sc_hd__tapvpwrvgnd_1
XTAP_TAPCELL_ROW_12_317 vssd1 vccd1 sky130_fd_sc_hd__tapvpwrvgnd_1
XFILLER_10_311 vssd1 vssd1 vccd1 vccd1 sky130_fd_sc_hd__fill_1
XANTENNA__5057__B _6738_/B vssd1 vssd1 vccd1 vccd1 sky130_fd_sc_hd__diode_2
XFILLER_77_53 vssd1 vssd1 vccd1 vccd1 sky130_fd_sc_hd__fill_2
XFILLER_89_182 vssd1 vssd1 vccd1 vccd1 sky130_fd_sc_hd__fill_2
XFILLER_77_97 vssd1 vssd1 vccd1 vccd1 sky130_fd_sc_hd__fill_1
XANTENNA__6616__B _7806_/B vssd1 vssd1 vccd1 vccd1 sky130_fd_sc_hd__diode_2
XANTENNA_input14_X _8174_/B vssd1 vssd1 vccd1 vccd1 sky130_fd_sc_hd__diode_2
XFILLER_80_509 vssd1 vssd1 vccd1 vccd1 sky130_fd_sc_hd__fill_1
XTAP_TAPCELL_ROW_82_1017 vssd1 vccd1 sky130_fd_sc_hd__tapvpwrvgnd_1
XTAP_TAPCELL_ROW_28_483 vssd1 vccd1 sky130_fd_sc_hd__tapvpwrvgnd_1
XANTENNA__4152__A _4919_/A vssd1 vssd1 vccd1 vccd1 sky130_fd_sc_hd__diode_2
XANTENNA__7463__A _8110_/B vssd1 vssd1 vccd1 vccd1 sky130_fd_sc_hd__diode_2
X_5320_ _8215_/A _5657_/B vssd1 vssd1 vccd1 vccd1 _5324_/A sky130_fd_sc_hd__nand2_2
X_5251_ _5250_/A _5250_/C _5250_/B vssd1 vssd1 vccd1 vccd1 _5298_/B sky130_fd_sc_hd__a21bo_2
X_4202_ _4218_/S _8416_/Q _4201_/Y vssd1 vssd1 vccd1 vccd1 _6174_/A sky130_fd_sc_hd__o21ai_2
XANTENNA__5414__C _6005_/B vssd1 vssd1 vccd1 vccd1 sky130_fd_sc_hd__diode_2
XFILLER_68_311 vssd1 vssd1 vccd1 vccd1 sky130_fd_sc_hd__fill_2
X_5182_ _5700_/B _5182_/B _5182_/C vssd1 vssd1 vccd1 vccd1 _5756_/B sky130_fd_sc_hd__and3_4
XFILLER_3_72 vssd1 vssd1 vccd1 vccd1 sky130_fd_sc_hd__fill_1
XFILLER_56_528 vssd1 vssd1 vccd1 vccd1 sky130_fd_sc_hd__fill_4
XANTENNA__4327__A _8425_/D vssd1 vssd1 vccd1 vccd1 sky130_fd_sc_hd__diode_2
XANTENNA__7549__A2 _8125_/B vssd1 vssd1 vccd1 vccd1 sky130_fd_sc_hd__diode_2
XFILLER_71_509 vssd1 vssd1 vccd1 vccd1 sky130_fd_sc_hd__fill_2
XANTENNA_rebuffer501_X _5930_/A vssd1 vssd1 vccd1 vccd1 sky130_fd_sc_hd__diode_2
X_7823_ _7954_/A _8082_/C _7822_/C vssd1 vssd1 vccd1 vccd1 _7824_/B sky130_fd_sc_hd__o21ai_2
X_7754_ _8103_/A _7754_/B _7877_/B _8126_/B vssd1 vssd1 vccd1 vccd1 _7755_/B sky130_fd_sc_hd__and4_2
XANTENNA_fanout246_A _6238_/B vssd1 vssd1 vccd1 vccd1 sky130_fd_sc_hd__diode_2
X_6705_ _6705_/A _6705_/B vssd1 vssd1 vccd1 vccd1 _6706_/B sky130_fd_sc_hd__xor2_2
X_4966_ _8408_/D wire66/X _5128_/C _8407_/D vssd1 vssd1 vccd1 vccd1 _4967_/B sky130_fd_sc_hd__a22oi_2
XFILLER_32_491 vssd1 vssd1 vccd1 vccd1 sky130_fd_sc_hd__fill_1
X_7685_ _7685_/A _7685_/B vssd1 vssd1 vccd1 vccd1 _7686_/B sky130_fd_sc_hd__nand2_2
X_4897_ _5020_/A _4897_/B _5017_/A _4897_/D vssd1 vssd1 vccd1 vccd1 _5017_/B sky130_fd_sc_hd__nand4_2
X_6636_ _6636_/A _6636_/B vssd1 vssd1 vccd1 vccd1 _6669_/A sky130_fd_sc_hd__xnor2_2
XANTENNA__4535__A2 _5147_/B vssd1 vssd1 vccd1 vccd1 sky130_fd_sc_hd__diode_2
XANTENNA__4997__A _6091_/A vssd1 vssd1 vccd1 vccd1 sky130_fd_sc_hd__diode_2
X_6567_ _6379_/A _6379_/B _6378_/A vssd1 vssd1 vccd1 vccd1 _6623_/A sky130_fd_sc_hd__o21ai_2
XANTENNA_fanout201_X _8313_/S vssd1 vssd1 vccd1 vccd1 sky130_fd_sc_hd__diode_2
X_8306_ _8440_/D _8174_/B _8313_/S vssd1 vssd1 vccd1 vccd1 _8381_/D sky130_fd_sc_hd__mux2_1
X_5518_ _5518_/A _5518_/B vssd1 vssd1 vccd1 vccd1 _5534_/A sky130_fd_sc_hd__nand2_2
X_6498_ _6499_/A _6499_/B _6499_/C vssd1 vssd1 vccd1 vccd1 _6827_/A sky130_fd_sc_hd__a21o_2
X_8237_ _8237_/A _8237_/B vssd1 vssd1 vccd1 vccd1 _8237_/Y sky130_fd_sc_hd__xnor2_2
X_5449_ _5453_/B _5449_/B vssd1 vssd1 vccd1 vccd1 _5451_/B sky130_fd_sc_hd__and2_2
XFILLER_59_300 vssd1 vssd1 vccd1 vccd1 sky130_fd_sc_hd__fill_1
X_8168_ _8168_/A _8168_/B vssd1 vssd1 vccd1 vccd1 _8170_/B sky130_fd_sc_hd__nor2_2
Xfanout110 _4294_/X vssd1 vssd1 vccd1 vccd1 _4700_/B sky130_fd_sc_hd__clkdlybuf4s25_1
Xfanout121 _7621_/A vssd1 vssd1 vccd1 vccd1 _8418_/D sky130_fd_sc_hd__clkdlybuf4s25_1
XANTENNA_input6_X input6/X vssd1 vssd1 vccd1 vccd1 sky130_fd_sc_hd__diode_2
XFILLER_59_344 vssd1 vssd1 vccd1 vccd1 sky130_fd_sc_hd__fill_4
XFILLER_86_130 vssd1 vssd1 vccd1 vccd1 sky130_fd_sc_hd__fill_2
XFILLER_86_141 vssd1 vssd1 vccd1 vccd1 sky130_fd_sc_hd__fill_4
Xfanout132 _8423_/D vssd1 vssd1 vccd1 vccd1 _4902_/A sky130_fd_sc_hd__clkdlybuf4s25_1
Xfanout143 _6091_/A vssd1 vssd1 vccd1 vccd1 _8430_/D sky130_fd_sc_hd__buf_6
Xfanout154 _6723_/A vssd1 vssd1 vccd1 vccd1 _6611_/A sky130_fd_sc_hd__clkdlybuf4s25_1
Xfanout165 _4821_/A vssd1 vssd1 vccd1 vccd1 _8422_/D sky130_fd_sc_hd__dlymetal6s4s_1
X_7119_ _6793_/X _7040_/A _7117_/Y _7038_/A _7116_/Y vssd1 vssd1 vccd1 vccd1 _7203_/B
+ sky130_fd_sc_hd__a221o_2
XFILLER_47_528 vssd1 vssd1 vccd1 vccd1 sky130_fd_sc_hd__fill_1
X_8099_ _8032_/A _8136_/B _8029_/X _8030_/X _8136_/C vssd1 vssd1 vccd1 vccd1 _8101_/A
+ sky130_fd_sc_hd__a32o_2
Xfanout176 _8426_/D vssd1 vssd1 vccd1 vccd1 fanout176/X sky130_fd_sc_hd__buf_6
Xfanout187 _4148_/X vssd1 vssd1 vccd1 vccd1 _4979_/A sky130_fd_sc_hd__buf_4
Xfanout198 _8398_/D vssd1 vssd1 vccd1 vccd1 _4227_/S sky130_fd_sc_hd__clkdlybuf4s25_1
XANTENNA__5340__B _5657_/B vssd1 vssd1 vccd1 vccd1 sky130_fd_sc_hd__diode_2
XFILLER_47_78 vssd1 vssd1 vccd1 vccd1 sky130_fd_sc_hd__fill_8
XANTENNA__4471__A1 _4919_/A vssd1 vssd1 vccd1 vccd1 sky130_fd_sc_hd__diode_2
XFILLER_55_561 vssd1 vssd1 vccd1 vccd1 sky130_fd_sc_hd__fill_8
XFILLER_42_277 vssd1 vssd1 vccd1 vccd1 sky130_fd_sc_hd__fill_2
XTAP_TAPCELL_ROW_25_453 vssd1 vccd1 sky130_fd_sc_hd__tapvpwrvgnd_1
XANTENNA__5068__A _7603_/A vssd1 vssd1 vccd1 vccd1 sky130_fd_sc_hd__diode_2
XFILLER_6_123 vssd1 vssd1 vccd1 vccd1 sky130_fd_sc_hd__fill_4
XANTENNA__4700__A _8422_/D vssd1 vssd1 vccd1 vccd1 sky130_fd_sc_hd__diode_2
XANTENNA__8318__S _8397_/D vssd1 vssd1 vccd1 vccd1 sky130_fd_sc_hd__diode_2
XFILLER_77_130 vssd1 vssd1 vccd1 vccd1 sky130_fd_sc_hd__fill_1
XFILLER_92_177 vssd1 vssd1 vccd1 vccd1 sky130_fd_sc_hd__fill_1
XFILLER_18_296 vssd1 vssd1 vccd1 vccd1 sky130_fd_sc_hd__fill_1
X_4820_ _4819_/A _4819_/B _4819_/C vssd1 vssd1 vccd1 vccd1 _4821_/D sky130_fd_sc_hd__a21o_2
X_4751_ _4902_/A wire92/X _4462_/B _4460_/Y vssd1 vssd1 vccd1 vccd1 _4753_/B sky130_fd_sc_hd__a31o_2
X_7470_ _7251_/B _7253_/B _7251_/A vssd1 vssd1 vccd1 vccd1 _7472_/B sky130_fd_sc_hd__o21ba_2
X_4682_ _4682_/A _4682_/B vssd1 vssd1 vccd1 vccd1 _4721_/A sky130_fd_sc_hd__xor2_2
X_6421_ _6533_/A _6421_/B vssd1 vssd1 vccd1 vccd1 _6423_/B sky130_fd_sc_hd__and2_2
X_6352_ _8416_/D wire72/X vssd1 vssd1 vccd1 vccd1 _6645_/A sky130_fd_sc_hd__nand2_2
X_6283_ hold535/X _6282_/X _7658_/S vssd1 vssd1 vccd1 vccd1 _8322_/D sky130_fd_sc_hd__mux2_1
X_5303_ _8174_/A _5826_/A vssd1 vssd1 vccd1 vccd1 _5307_/A sky130_fd_sc_hd__nand2_2
X_8022_ _8022_/A _8022_/B vssd1 vssd1 vccd1 vccd1 _8023_/B sky130_fd_sc_hd__nor2_2
X_5234_ _5234_/A _5234_/B _5234_/C vssd1 vssd1 vccd1 vccd1 _5234_/X sky130_fd_sc_hd__or3_2
X_5165_ _5165_/A _5165_/B vssd1 vssd1 vccd1 vccd1 _5168_/A sky130_fd_sc_hd__xnor2_2
XFILLER_29_528 vssd1 vssd1 vccd1 vccd1 sky130_fd_sc_hd__fill_1
XFILLER_68_141 vssd1 vssd1 vccd1 vccd1 sky130_fd_sc_hd__fill_1
XFILLER_68_174 vssd1 vssd1 vccd1 vccd1 sky130_fd_sc_hd__fill_2
XFILLER_83_133 vssd1 vssd1 vccd1 vccd1 sky130_fd_sc_hd__fill_4
X_5096_ _5096_/A _5096_/B vssd1 vssd1 vccd1 vccd1 _5212_/B sky130_fd_sc_hd__xor2_2
XANTENNA_fanout363_A _4226_/X vssd1 vssd1 vccd1 vccd1 sky130_fd_sc_hd__diode_2
XTAP_TAPCELL_ROW_39_589 vssd1 vccd1 sky130_fd_sc_hd__tapvpwrvgnd_1
X_7806_ _8077_/A _7806_/B vssd1 vssd1 vccd1 vccd1 _7807_/B sky130_fd_sc_hd__nor2_2
XANTENNA__5402__B1 _8220_/A vssd1 vssd1 vccd1 vccd1 sky130_fd_sc_hd__diode_2
XANTENNA_fanout249_X _7754_/B vssd1 vssd1 vccd1 vccd1 sky130_fd_sc_hd__diode_2
X_5998_ _5812_/X _5813_/A _5810_/X vssd1 vssd1 vccd1 vccd1 _5998_/X sky130_fd_sc_hd__a21o_4
X_7737_ _8125_/A _7875_/D vssd1 vssd1 vccd1 vccd1 _7738_/B sky130_fd_sc_hd__nand2_2
X_4949_ _4949_/A _4949_/B vssd1 vssd1 vccd1 vccd1 _4952_/A sky130_fd_sc_hd__xor2_2
XTAP_TAPCELL_ROW_22_423 vssd1 vccd1 sky130_fd_sc_hd__tapvpwrvgnd_1
X_7668_ _7668_/A _8077_/B _7668_/C vssd1 vssd1 vccd1 vccd1 _7670_/A sky130_fd_sc_hd__or3_2
X_6619_ _6620_/A _6620_/B vssd1 vssd1 vccd1 vccd1 _6619_/Y sky130_fd_sc_hd__nand2_2
X_7599_ _7298_/B _7616_/A _7404_/X vssd1 vssd1 vccd1 vccd1 _7602_/A sky130_fd_sc_hd__a21o_2
XFILLER_3_126 vssd1 vssd1 vccd1 vccd1 sky130_fd_sc_hd__fill_4
XFILLER_79_406 vssd1 vssd1 vccd1 vccd1 sky130_fd_sc_hd__fill_4
XANTENNA__7550__B _7889_/B vssd1 vssd1 vccd1 vccd1 sky130_fd_sc_hd__diode_2
XANTENNA__6166__B wire72/X vssd1 vssd1 vccd1 vccd1 sky130_fd_sc_hd__diode_2
XFILLER_74_122 vssd1 vssd1 vccd1 vccd1 sky130_fd_sc_hd__fill_1
XFILLER_28_550 vssd1 vssd1 vccd1 vccd1 sky130_fd_sc_hd__fill_1
XANTENNA__8186__A2 _8179_/B vssd1 vssd1 vccd1 vccd1 sky130_fd_sc_hd__diode_2
XFILLER_55_391 vssd1 vssd1 vccd1 vccd1 sky130_fd_sc_hd__fill_1
XFILLER_74_98 vssd1 vssd1 vccd1 vccd1 sky130_fd_sc_hd__fill_2
XFILLER_90_20 vssd1 vssd1 vccd1 vccd1 sky130_fd_sc_hd__fill_1
XANTENNA__4414__B _4931_/C vssd1 vssd1 vccd1 vccd1 sky130_fd_sc_hd__diode_2
XFILLER_90_31 vssd1 vssd1 vccd1 vccd1 sky130_fd_sc_hd__fill_1
XFILLER_90_64 vssd1 vssd1 vccd1 vccd1 sky130_fd_sc_hd__fill_4
XANTENNA__7725__B _7725_/B vssd1 vssd1 vccd1 vccd1 sky130_fd_sc_hd__diode_2
XANTENNA__4430__A _5020_/A vssd1 vssd1 vccd1 vccd1 sky130_fd_sc_hd__diode_2
Xwire385 input3/X vssd1 vssd1 vccd1 vccd1 wire385/X sky130_fd_sc_hd__buf_6
XTAP_TAPCELL_ROW_90_1105 vssd1 vccd1 sky130_fd_sc_hd__tapvpwrvgnd_1
X_6970_ _6970_/A _7299_/B _7299_/C vssd1 vssd1 vccd1 vccd1 _6975_/A sky130_fd_sc_hd__and3_2
XFILLER_65_177 vssd1 vssd1 vccd1 vccd1 sky130_fd_sc_hd__fill_4
X_5921_ _6978_/A _5767_/A _6631_/B _5768_/Y vssd1 vssd1 vccd1 vccd1 _5989_/A sky130_fd_sc_hd__o31a_2
XTAP_TAPCELL_ROW_88_1078 vssd1 vccd1 sky130_fd_sc_hd__tapvpwrvgnd_1
XFILLER_34_531 vssd1 vssd1 vccd1 vccd1 sky130_fd_sc_hd__fill_1
XFILLER_80_136 vssd1 vssd1 vccd1 vccd1 sky130_fd_sc_hd__fill_4
XTAP_TAPCELL_ROW_36_559 vssd1 vccd1 sky130_fd_sc_hd__tapvpwrvgnd_1
X_5852_ _5852_/A _5852_/B vssd1 vssd1 vccd1 vccd1 _5854_/C sky130_fd_sc_hd__or2_2
XFILLER_21_225 vssd1 vssd1 vccd1 vccd1 sky130_fd_sc_hd__fill_1
X_5783_ _8412_/D _5780_/B _5900_/A vssd1 vssd1 vccd1 vccd1 _5783_/X sky130_fd_sc_hd__a21bo_2
X_4803_ _4508_/A _4508_/B _4803_/B1 vssd1 vssd1 vccd1 vccd1 _4806_/B sky130_fd_sc_hd__a21oi_2
X_7522_ _7522_/A _7522_/B vssd1 vssd1 vccd1 vccd1 _7529_/A sky130_fd_sc_hd__xnor2_2
X_4734_ _8409_/D wire72/A vssd1 vssd1 vccd1 vccd1 _5213_/A sky130_fd_sc_hd__nand2_2
Xrebuffer507 _5031_/A vssd1 vssd1 vccd1 vccd1 _5030_/B sky130_fd_sc_hd__buf_2
XFILLER_9_82 vssd1 vssd1 vccd1 vccd1 sky130_fd_sc_hd__fill_2
X_7453_ _7454_/A _7454_/B vssd1 vssd1 vccd1 vccd1 _7566_/B sky130_fd_sc_hd__nand2b_2
X_4665_ _4665_/A _4665_/B vssd1 vssd1 vccd1 vccd1 _4665_/X sky130_fd_sc_hd__xor2_2
XANTENNA_fanout111_A _4487_/B vssd1 vssd1 vccd1 vccd1 sky130_fd_sc_hd__diode_2
X_7384_ _4203_/Y _7820_/B _7322_/A _7320_/A vssd1 vssd1 vccd1 vccd1 _7391_/A sky130_fd_sc_hd__a31o_2
X_6404_ _7129_/A _6892_/B _6485_/B _6798_/B vssd1 vssd1 vccd1 vccd1 _6405_/B sky130_fd_sc_hd__and4_2
X_4596_ _4596_/A _4596_/B vssd1 vssd1 vccd1 vccd1 _4602_/A sky130_fd_sc_hd__nand2_2
X_6335_ _6978_/A _8081_/B vssd1 vssd1 vccd1 vccd1 _6339_/A sky130_fd_sc_hd__nor2_2
X_8005_ _8006_/A _8006_/B vssd1 vssd1 vccd1 vccd1 _8007_/A sky130_fd_sc_hd__and2_2
X_6266_ _6264_/A _6264_/B _6264_/C vssd1 vssd1 vccd1 vccd1 _6266_/Y sky130_fd_sc_hd__o21ai_2
XANTENNA_fanout199_X _8398_/D vssd1 vssd1 vccd1 vccd1 sky130_fd_sc_hd__diode_2
X_6197_ _6197_/A _6197_/B vssd1 vssd1 vccd1 vccd1 _6280_/A sky130_fd_sc_hd__xor2_2
X_5217_ _5217_/A _5267_/B _5218_/A _5216_/X vssd1 vssd1 vccd1 vccd1 _5241_/A sky130_fd_sc_hd__or4bb_4
X_5148_ _5148_/A _5148_/B vssd1 vssd1 vccd1 vccd1 _5149_/C sky130_fd_sc_hd__xnor2_2
XFILLER_17_509 vssd1 vssd1 vccd1 vccd1 sky130_fd_sc_hd__fill_2
XFILLER_84_453 vssd1 vssd1 vccd1 vccd1 sky130_fd_sc_hd__fill_2
XFILLER_84_464 vssd1 vssd1 vccd1 vccd1 sky130_fd_sc_hd__fill_1
X_5079_ _5079_/A _5079_/B vssd1 vssd1 vccd1 vccd1 _5084_/B sky130_fd_sc_hd__xor2_2
XFILLER_56_166 vssd1 vssd1 vccd1 vccd1 sky130_fd_sc_hd__fill_2
XFILLER_25_542 vssd1 vssd1 vccd1 vccd1 sky130_fd_sc_hd__fill_2
XFILLER_56_199 vssd1 vssd1 vccd1 vccd1 sky130_fd_sc_hd__fill_2
XFILLER_44_46 vssd1 vssd1 vccd1 vccd1 sky130_fd_sc_hd__fill_8
XANTENNA__5926__A1 _5930_/A vssd1 vssd1 vccd1 vccd1 sky130_fd_sc_hd__diode_2
XFILLER_12_214 vssd1 vssd1 vccd1 vccd1 sky130_fd_sc_hd__fill_1
XFILLER_12_236 vssd1 vssd1 vccd1 vccd1 sky130_fd_sc_hd__fill_2
XANTENNA__7128__B1 _7714_/A vssd1 vssd1 vccd1 vccd1 sky130_fd_sc_hd__diode_2
XFILLER_8_229 vssd1 vssd1 vccd1 vccd1 sky130_fd_sc_hd__fill_1
XANTENNA__5065__B _6738_/B vssd1 vssd1 vccd1 vccd1 sky130_fd_sc_hd__diode_2
XFILLER_69_32 vssd1 vssd1 vccd1 vccd1 sky130_fd_sc_hd__fill_4
XTAP_TAPCELL_ROW_7_273 vssd1 vccd1 sky130_fd_sc_hd__tapvpwrvgnd_1
XFILLER_47_144 vssd1 vssd1 vccd1 vccd1 sky130_fd_sc_hd__fill_2
XFILLER_75_453 vssd1 vssd1 vccd1 vccd1 sky130_fd_sc_hd__fill_1
XFILLER_90_401 vssd1 vssd1 vccd1 vccd1 sky130_fd_sc_hd__fill_1
XFILLER_16_531 vssd1 vssd1 vccd1 vccd1 sky130_fd_sc_hd__fill_1
XFILLER_47_199 vssd1 vssd1 vccd1 vccd1 sky130_fd_sc_hd__fill_1
XFILLER_62_158 vssd1 vssd1 vccd1 vccd1 sky130_fd_sc_hd__fill_1
XTAP_TAPCELL_ROW_33_529 vssd1 vccd1 sky130_fd_sc_hd__tapvpwrvgnd_1
XANTENNA__5256__A _5983_/A vssd1 vssd1 vccd1 vccd1 sky130_fd_sc_hd__diode_2
XFILLER_79_5 vssd1 vssd1 vccd1 vccd1 sky130_fd_sc_hd__fill_1
X_4450_ _4353_/A _4353_/B _4351_/Y vssd1 vssd1 vccd1 vccd1 _4467_/A sky130_fd_sc_hd__o21a_2
X_4381_ _4919_/A _4931_/C vssd1 vssd1 vccd1 vccd1 _4399_/C sky130_fd_sc_hd__and2_2
X_6120_ _5955_/A _6115_/A _5956_/B _5956_/A vssd1 vssd1 vccd1 vccd1 _6122_/B sky130_fd_sc_hd__a2bb2o_2
XANTENNA_load_slew117_X _4686_/B vssd1 vssd1 vccd1 vccd1 sky130_fd_sc_hd__diode_2
XANTENNA__5703__B _5703_/B vssd1 vssd1 vccd1 vccd1 sky130_fd_sc_hd__diode_2
X_6051_ _6259_/B _6050_/C _6050_/A vssd1 vssd1 vccd1 vccd1 _6053_/B sky130_fd_sc_hd__a21o_2
X_5002_ _5003_/A _5003_/B vssd1 vssd1 vccd1 vccd1 _5002_/X sky130_fd_sc_hd__and2b_2
XANTENNA__6815__A _7140_/A vssd1 vssd1 vccd1 vccd1 sky130_fd_sc_hd__diode_2
XFILLER_38_177 vssd1 vssd1 vccd1 vccd1 sky130_fd_sc_hd__fill_4
XFILLER_81_412 vssd1 vssd1 vccd1 vccd1 sky130_fd_sc_hd__fill_1
XTAP_TAPCELL_ROW_77_971 vssd1 vccd1 sky130_fd_sc_hd__tapvpwrvgnd_1
XFILLER_53_136 vssd1 vssd1 vccd1 vccd1 sky130_fd_sc_hd__fill_8
X_6953_ _6954_/A _6954_/B _6954_/C vssd1 vssd1 vccd1 vccd1 _7198_/A sky130_fd_sc_hd__a21oi_2
XTAP_TAPCELL_ROW_49_695 vssd1 vccd1 sky130_fd_sc_hd__tapvpwrvgnd_1
X_6884_ _7120_/A _7714_/C _7714_/D _6883_/A vssd1 vssd1 vccd1 vccd1 _6885_/B sky130_fd_sc_hd__a22oi_2
X_5904_ _5905_/A _5905_/B vssd1 vssd1 vccd1 vccd1 _6183_/B sky130_fd_sc_hd__nor2_2
X_5835_ _6027_/A _5835_/B vssd1 vssd1 vccd1 vccd1 _5836_/B sky130_fd_sc_hd__or2_2
XANTENNA__6030__B1 _8233_/A vssd1 vssd1 vccd1 vccd1 sky130_fd_sc_hd__diode_2
XANTENNA__8388__RESET_B load_slew360/X vssd1 vssd1 vccd1 vccd1 sky130_fd_sc_hd__diode_2
XFILLER_14_38 vssd1 vssd1 vccd1 vccd1 sky130_fd_sc_hd__fill_2
XFILLER_22_567 vssd1 vssd1 vccd1 vccd1 sky130_fd_sc_hd__fill_2
XFILLER_61_191 vssd1 vssd1 vccd1 vccd1 sky130_fd_sc_hd__fill_2
XPHY_EDGE_ROW_46_Left_139 vssd1 vssd1 vccd1 vccd1 sky130_fd_sc_hd__decap_3
XANTENNA_fanout326_A _8342_/Q vssd1 vssd1 vccd1 vccd1 sky130_fd_sc_hd__diode_2
X_5766_ _5766_/A1 _5194_/B _5267_/A vssd1 vssd1 vccd1 vccd1 _5767_/B sky130_fd_sc_hd__a21oi_2
X_7505_ _7506_/A _7506_/B _7506_/C vssd1 vssd1 vccd1 vccd1 _7594_/B sky130_fd_sc_hd__o21a_2
X_5697_ _5047_/A _5776_/A _5121_/A _5121_/B vssd1 vssd1 vccd1 vccd1 _5771_/A sky130_fd_sc_hd__o22ai_2
X_4717_ _4701_/B _4702_/Y _4715_/X _4716_/X vssd1 vssd1 vccd1 vccd1 _4717_/X sky130_fd_sc_hd__a2bb2o_4
X_7436_ _7436_/A _7436_/B vssd1 vssd1 vccd1 vccd1 _7438_/A sky130_fd_sc_hd__nor2_2
X_4648_ _4669_/B _4648_/B vssd1 vssd1 vccd1 vccd1 _4670_/B sky130_fd_sc_hd__xor2_2
X_7367_ _7685_/A wire59/X vssd1 vssd1 vccd1 vccd1 _7626_/A sky130_fd_sc_hd__nand2_2
X_4579_ _4709_/B _5954_/B vssd1 vssd1 vccd1 vccd1 _4631_/A sky130_fd_sc_hd__nand2_2
XANTENNA__8196__B _8196_/B vssd1 vssd1 vccd1 vccd1 sky130_fd_sc_hd__diode_2
XFILLER_1_438 vssd1 vssd1 vccd1 vccd1 sky130_fd_sc_hd__fill_1
XFILLER_89_534 vssd1 vssd1 vccd1 vccd1 sky130_fd_sc_hd__fill_1
X_7298_ _7298_/A _7298_/B vssd1 vssd1 vccd1 vccd1 _7300_/A sky130_fd_sc_hd__xor2_2
X_6318_ _6318_/A _6318_/B vssd1 vssd1 vccd1 vccd1 _6319_/B sky130_fd_sc_hd__and2_2
XPHY_EDGE_ROW_55_Left_148 vssd1 vssd1 vccd1 vccd1 sky130_fd_sc_hd__decap_3
X_6249_ _6458_/A _6249_/B vssd1 vssd1 vccd1 vccd1 _6249_/Y sky130_fd_sc_hd__nand2_2
XFILLER_39_68 vssd1 vssd1 vccd1 vccd1 sky130_fd_sc_hd__fill_4
XFILLER_76_228 vssd1 vssd1 vccd1 vccd1 sky130_fd_sc_hd__fill_4
XTAP_TAPCELL_ROW_4_243 vssd1 vccd1 sky130_fd_sc_hd__tapvpwrvgnd_1
XFILLER_44_103 vssd1 vssd1 vccd1 vccd1 sky130_fd_sc_hd__fill_2
XFILLER_55_34 vssd1 vssd1 vccd1 vccd1 sky130_fd_sc_hd__fill_2
XFILLER_84_272 vssd1 vssd1 vccd1 vccd1 sky130_fd_sc_hd__fill_2
XFILLER_13_501 vssd1 vssd1 vccd1 vccd1 sky130_fd_sc_hd__fill_2
XFILLER_32_309 vssd1 vssd1 vccd1 vccd1 sky130_fd_sc_hd__fill_1
XPHY_EDGE_ROW_64_Left_157 vssd1 vssd1 vccd1 vccd1 sky130_fd_sc_hd__decap_3
XFILLER_13_534 vssd1 vssd1 vccd1 vccd1 sky130_fd_sc_hd__fill_2
XFILLER_25_383 vssd1 vssd1 vccd1 vccd1 sky130_fd_sc_hd__fill_1
XFILLER_13_556 vssd1 vssd1 vccd1 vccd1 sky130_fd_sc_hd__fill_4
XFILLER_71_33 vssd1 vssd1 vccd1 vccd1 sky130_fd_sc_hd__fill_2
XFILLER_71_55 vssd1 vssd1 vccd1 vccd1 sky130_fd_sc_hd__fill_1
XANTENNA__6460__A _6460_/A vssd1 vssd1 vccd1 vccd1 sky130_fd_sc_hd__diode_2
XFILLER_71_66 vssd1 vssd1 vccd1 vccd1 sky130_fd_sc_hd__fill_4
XANTENNA__7275__B _7897_/B vssd1 vssd1 vccd1 vccd1 sky130_fd_sc_hd__diode_2
XPHY_EDGE_ROW_73_Left_166 vssd1 vssd1 vccd1 vccd1 sky130_fd_sc_hd__decap_3
XFILLER_35_147 vssd1 vssd1 vccd1 vccd1 sky130_fd_sc_hd__fill_1
XFILLER_75_294 vssd1 vssd1 vccd1 vccd1 sky130_fd_sc_hd__fill_4
XTAP_TAPCELL_ROW_74_941 vssd1 vccd1 sky130_fd_sc_hd__tapvpwrvgnd_1
XPHY_EDGE_ROW_82_Left_175 vssd1 vssd1 vccd1 vccd1 sky130_fd_sc_hd__decap_3
XFILLER_35_158 vssd1 vssd1 vccd1 vccd1 sky130_fd_sc_hd__fill_2
XTAP_TAPCELL_ROW_85_1048 vssd1 vccd1 sky130_fd_sc_hd__tapvpwrvgnd_1
XTAP_TAPCELL_ROW_46_665 vssd1 vccd1 sky130_fd_sc_hd__tapvpwrvgnd_1
XTAP_TAPCELL_ROW_18_378 vssd1 vccd1 sky130_fd_sc_hd__tapvpwrvgnd_1
XANTENNA__8410__RESET_B load_slew358/X vssd1 vssd1 vccd1 vccd1 sky130_fd_sc_hd__diode_2
XFILLER_84_3 vssd1 vssd1 vccd1 vccd1 sky130_fd_sc_hd__fill_4
X_5620_ _5620_/A _5620_/B vssd1 vssd1 vccd1 vccd1 _5637_/A sky130_fd_sc_hd__and2_2
X_5551_ _5551_/A _5551_/B vssd1 vssd1 vccd1 vccd1 _5687_/B sky130_fd_sc_hd__xnor2_2
XANTENNA__5417__C _6485_/B vssd1 vssd1 vccd1 vccd1 sky130_fd_sc_hd__diode_2
X_8270_ _8271_/A _8271_/B vssd1 vssd1 vccd1 vccd1 _8274_/C sky130_fd_sc_hd__and2_2
X_4502_ _4502_/A _4502_/B _4502_/C vssd1 vssd1 vccd1 vccd1 _4503_/B sky130_fd_sc_hd__nor3_2
X_7221_ _8133_/B _8030_/A vssd1 vssd1 vccd1 vccd1 _7222_/B sky130_fd_sc_hd__nand2_2
X_5482_ _8191_/A _5569_/C _5569_/D _5618_/A vssd1 vssd1 vccd1 vccd1 _5484_/A sky130_fd_sc_hd__a22oi_2
XPHY_EDGE_ROW_91_Left_184 vssd1 vssd1 vccd1 vccd1 sky130_fd_sc_hd__decap_3
X_4433_ _4433_/A _4433_/B vssd1 vssd1 vccd1 vccd1 _4537_/B sky130_fd_sc_hd__xor2_2
X_7152_ _7152_/A _7152_/B vssd1 vssd1 vccd1 vccd1 _7153_/B sky130_fd_sc_hd__nand2_2
X_4364_ _4979_/A _4780_/B vssd1 vssd1 vccd1 vccd1 _4483_/A sky130_fd_sc_hd__nand2_2
XANTENNA_clkload13_A _8405_/CLK vssd1 vssd1 vccd1 vccd1 sky130_fd_sc_hd__diode_2
X_7083_ _7668_/A _7084_/B vssd1 vssd1 vccd1 vccd1 _7085_/B sky130_fd_sc_hd__nor2_2
X_6103_ _6104_/A _6104_/B vssd1 vssd1 vccd1 vccd1 _6105_/A sky130_fd_sc_hd__nor2_2
X_4295_ _5163_/B _5163_/C vssd1 vssd1 vccd1 vccd1 _5703_/B sky130_fd_sc_hd__nand2_2
X_6034_ _6034_/A _6034_/B vssd1 vssd1 vccd1 vccd1 _6044_/A sky130_fd_sc_hd__xnor2_2
XANTENNA_fanout276_A _6548_/A vssd1 vssd1 vccd1 vccd1 sky130_fd_sc_hd__diode_2
XFILLER_66_261 vssd1 vssd1 vccd1 vccd1 sky130_fd_sc_hd__fill_4
XFILLER_73_209 vssd1 vssd1 vccd1 vccd1 sky130_fd_sc_hd__fill_4
XTAP_TAPCELL_ROW_1_213 vssd1 vccd1 sky130_fd_sc_hd__tapvpwrvgnd_1
XFILLER_39_497 vssd1 vssd1 vccd1 vccd1 sky130_fd_sc_hd__fill_4
X_7985_ _7918_/B _7920_/B _7918_/A vssd1 vssd1 vccd1 vccd1 _8057_/A sky130_fd_sc_hd__o21ba_2
XFILLER_26_147 vssd1 vssd1 vccd1 vccd1 sky130_fd_sc_hd__fill_1
X_6936_ _6937_/A _6937_/B _6935_/Y vssd1 vssd1 vccd1 vccd1 _7183_/B sky130_fd_sc_hd__o21bai_2
XFILLER_25_37 vssd1 vssd1 vccd1 vccd1 sky130_fd_sc_hd__fill_4
X_6867_ _6867_/A _6867_/B vssd1 vssd1 vccd1 vccd1 _6867_/Y sky130_fd_sc_hd__xnor2_2
X_6798_ _8032_/A _6798_/B vssd1 vssd1 vccd1 vccd1 _6799_/B sky130_fd_sc_hd__nand2_2
X_5818_ _6006_/A _6482_/B vssd1 vssd1 vccd1 vccd1 _5819_/B sky130_fd_sc_hd__nand2_2
XTAP_TAPCELL_ROW_80_999 vssd1 vccd1 sky130_fd_sc_hd__tapvpwrvgnd_1
XANTENNA__5608__B _5657_/B vssd1 vssd1 vccd1 vccd1 sky130_fd_sc_hd__diode_2
XANTENNA__7095__B _7095_/B vssd1 vssd1 vccd1 vccd1 sky130_fd_sc_hd__diode_2
XFILLER_10_537 vssd1 vssd1 vccd1 vccd1 sky130_fd_sc_hd__fill_1
X_5749_ _5750_/A _5750_/B vssd1 vssd1 vccd1 vccd1 _5924_/A sky130_fd_sc_hd__and2b_2
X_8399_ _8402_/CLK _8399_/D fanout378/X vssd1 vssd1 vccd1 vccd1 _8399_/Q sky130_fd_sc_hd__dfrtp_2
X_7419_ _7419_/A _7419_/B vssd1 vssd1 vccd1 vccd1 _7421_/B sky130_fd_sc_hd__xor2_2
Xteam_03_398 vssd1 vssd1 vccd1 vccd1 team_03_398/HI gpio_oeb[29] sky130_fd_sc_hd__conb_1
XANTENNA__6174__B _7007_/B vssd1 vssd1 vccd1 vccd1 sky130_fd_sc_hd__diode_2
XFILLER_17_169 vssd1 vssd1 vccd1 vccd1 sky130_fd_sc_hd__fill_1
XFILLER_72_264 vssd1 vssd1 vccd1 vccd1 sky130_fd_sc_hd__fill_1
XTAP_TAPCELL_ROW_71_911 vssd1 vccd1 sky130_fd_sc_hd__tapvpwrvgnd_1
XTAP_TAPCELL_ROW_43_635 vssd1 vccd1 sky130_fd_sc_hd__tapvpwrvgnd_1
XFILLER_60_448 vssd1 vssd1 vccd1 vccd1 sky130_fd_sc_hd__fill_4
XTAP_TAPCELL_ROW_15_348 vssd1 vccd1 sky130_fd_sc_hd__tapvpwrvgnd_1
XFILLER_9_302 vssd1 vssd1 vccd1 vccd1 sky130_fd_sc_hd__fill_1
XANTENNA__4422__B _6114_/B vssd1 vssd1 vccd1 vccd1 sky130_fd_sc_hd__diode_2
XANTENNA__8298__A1 input5/X vssd1 vssd1 vccd1 vccd1 sky130_fd_sc_hd__diode_2
XFILLER_55_209 vssd1 vssd1 vccd1 vccd1 sky130_fd_sc_hd__fill_2
XFILLER_48_272 vssd1 vssd1 vccd1 vccd1 sky130_fd_sc_hd__fill_1
XTAP_TAPCELL_ROW_59_790 vssd1 vccd1 sky130_fd_sc_hd__tapvpwrvgnd_1
XANTENNA__6233__B1 _8241_/A vssd1 vssd1 vccd1 vccd1 sky130_fd_sc_hd__diode_2
XFILLER_23_106 vssd1 vssd1 vccd1 vccd1 sky130_fd_sc_hd__fill_1
X_7770_ _7771_/A _7771_/B vssd1 vssd1 vccd1 vccd1 _7773_/A sky130_fd_sc_hd__nor2_2
X_4982_ _5155_/A _5953_/B _5711_/A _4981_/Y vssd1 vssd1 vccd1 vccd1 _4984_/A sky130_fd_sc_hd__a31oi_2
X_6721_ _6721_/A _6721_/B vssd1 vssd1 vccd1 vccd1 _6722_/B sky130_fd_sc_hd__xnor2_2
X_6652_ _8081_/A _7007_/B vssd1 vssd1 vccd1 vccd1 _6654_/B sky130_fd_sc_hd__nor2_2
XANTENNA__5428__B _6207_/A vssd1 vssd1 vccd1 vccd1 sky130_fd_sc_hd__diode_2
X_5603_ _5604_/B _5604_/A vssd1 vssd1 vccd1 vccd1 _5603_/Y sky130_fd_sc_hd__nand2b_2
XANTENNA__8289__A1 _8168_/B vssd1 vssd1 vccd1 vccd1 sky130_fd_sc_hd__diode_2
X_8322_ _8334_/CLK _8322_/D load_slew381/X vssd1 vssd1 vccd1 vccd1 _8322_/Q sky130_fd_sc_hd__dfrtp_2
X_6583_ _8435_/D _6300_/B _6300_/C vssd1 vssd1 vccd1 vccd1 _6584_/B sky130_fd_sc_hd__a21o_2
X_5534_ _5534_/A _5534_/B _5585_/A vssd1 vssd1 vccd1 vccd1 _5535_/B sky130_fd_sc_hd__and3_2
X_8253_ _8257_/A _8254_/B vssd1 vssd1 vccd1 vccd1 _8255_/B sky130_fd_sc_hd__nand2_2
X_5465_ _5462_/A _5462_/B _5495_/A vssd1 vssd1 vccd1 vccd1 _5466_/C sky130_fd_sc_hd__a21oi_2
X_8184_ _8184_/A _8184_/B vssd1 vssd1 vccd1 vccd1 _8185_/B sky130_fd_sc_hd__nand2_2
X_7204_ _7203_/A _7203_/B _7203_/C vssd1 vssd1 vccd1 vccd1 _7205_/B sky130_fd_sc_hd__a21oi_2
X_4416_ _8429_/D _4686_/B vssd1 vssd1 vccd1 vccd1 _4417_/B sky130_fd_sc_hd__nand2_2
XANTENNA__5163__B _5163_/B vssd1 vssd1 vccd1 vccd1 sky130_fd_sc_hd__diode_2
Xfanout314 _6238_/D vssd1 vssd1 vccd1 vccd1 _6903_/C sky130_fd_sc_hd__clkdlybuf4s25_1
Xfanout303 _8348_/Q vssd1 vssd1 vccd1 vccd1 _7723_/D sky130_fd_sc_hd__clkdlybuf4s25_1
X_7135_ _7227_/B _7135_/B vssd1 vssd1 vccd1 vccd1 _7137_/C sky130_fd_sc_hd__nand2_2
X_5396_ _5396_/A _5396_/B vssd1 vssd1 vccd1 vccd1 _5399_/A sky130_fd_sc_hd__xnor2_2
Xfanout347 _8337_/Q vssd1 vssd1 vccd1 vccd1 _5386_/A sky130_fd_sc_hd__clkdlybuf4s25_1
Xfanout336 _6883_/A vssd1 vssd1 vccd1 vccd1 _5647_/A sky130_fd_sc_hd__clkdlybuf4s25_1
Xfanout325 _8342_/Q vssd1 vssd1 vccd1 vccd1 _5842_/B sky130_fd_sc_hd__clkdlybuf4s25_1
X_4347_ _4557_/A _4979_/B _4979_/C vssd1 vssd1 vccd1 vccd1 _4348_/B sky130_fd_sc_hd__and3_2
Xfanout369 fanout379/X vssd1 vssd1 vccd1 vccd1 fanout369/X sky130_fd_sc_hd__clkdlybuf4s25_1
X_7066_ _7017_/A _7017_/B _7016_/A vssd1 vssd1 vccd1 vccd1 _7068_/B sky130_fd_sc_hd__o21ai_2
X_4278_ _4328_/A _4286_/B vssd1 vssd1 vccd1 vccd1 _4278_/Y sky130_fd_sc_hd__nor2_2
XANTENNA_fanout181_X _4919_/A vssd1 vssd1 vccd1 vccd1 sky130_fd_sc_hd__diode_2
XFILLER_46_209 vssd1 vssd1 vccd1 vccd1 sky130_fd_sc_hd__fill_1
X_6017_ _6016_/A _6798_/B _6217_/C _6016_/B vssd1 vssd1 vccd1 vccd1 _6018_/B sky130_fd_sc_hd__a22oi_2
XANTENNA_fanout279_X _6548_/A vssd1 vssd1 vccd1 vccd1 sky130_fd_sc_hd__diode_2
XFILLER_39_283 vssd1 vssd1 vccd1 vccd1 sky130_fd_sc_hd__fill_1
XFILLER_54_253 vssd1 vssd1 vccd1 vccd1 sky130_fd_sc_hd__fill_1
XFILLER_27_489 vssd1 vssd1 vccd1 vccd1 sky130_fd_sc_hd__fill_2
X_7968_ _7807_/B _8090_/A _7967_/X vssd1 vssd1 vccd1 vccd1 _7969_/C sky130_fd_sc_hd__a21o_2
X_7899_ _7755_/A _7757_/B _7755_/B vssd1 vssd1 vccd1 vccd1 _7901_/B sky130_fd_sc_hd__o21ba_2
X_6919_ _6919_/A _6919_/B vssd1 vssd1 vccd1 vccd1 _6921_/A sky130_fd_sc_hd__nor2_2
XTAP_TAPCELL_ROW_40_605 vssd1 vccd1 sky130_fd_sc_hd__tapvpwrvgnd_1
XTAP_TAPCELL_ROW_12_318 vssd1 vccd1 sky130_fd_sc_hd__tapvpwrvgnd_1
XANTENNA__5338__B _8202_/A vssd1 vssd1 vccd1 vccd1 sky130_fd_sc_hd__diode_2
XFILLER_52_79 vssd1 vssd1 vccd1 vccd1 sky130_fd_sc_hd__fill_4
XFILLER_10_356 vssd1 vssd1 vccd1 vccd1 sky130_fd_sc_hd__fill_1
XFILLER_10_367 vssd1 vssd1 vccd1 vccd1 sky130_fd_sc_hd__fill_1
XFILLER_2_522 vssd1 vssd1 vccd1 vccd1 sky130_fd_sc_hd__fill_1
XFILLER_2_533 vssd1 vssd1 vccd1 vccd1 sky130_fd_sc_hd__fill_8
XANTENNA__4710__B1 _4366_/X vssd1 vssd1 vccd1 vccd1 sky130_fd_sc_hd__diode_2
XFILLER_77_312 vssd1 vssd1 vccd1 vccd1 sky130_fd_sc_hd__fill_2
XFILLER_89_161 vssd1 vssd1 vccd1 vccd1 sky130_fd_sc_hd__fill_4
XFILLER_37_209 vssd1 vssd1 vccd1 vccd1 sky130_fd_sc_hd__fill_1
XFILLER_45_220 vssd1 vssd1 vccd1 vccd1 sky130_fd_sc_hd__fill_4
XFILLER_92_337 vssd1 vssd1 vccd1 vccd1 sky130_fd_sc_hd__fill_1
XFILLER_73_540 vssd1 vssd1 vccd1 vccd1 sky130_fd_sc_hd__fill_4
XTAP_TAPCELL_ROW_82_1018 vssd1 vccd1 sky130_fd_sc_hd__tapvpwrvgnd_1
XTAP_TAPCELL_ROW_56_760 vssd1 vccd1 sky130_fd_sc_hd__tapvpwrvgnd_1
XTAP_TAPCELL_ROW_28_484 vssd1 vccd1 sky130_fd_sc_hd__tapvpwrvgnd_1
XANTENNA__7463__B _7897_/B vssd1 vssd1 vccd1 vccd1 sky130_fd_sc_hd__diode_2
X_5250_ _5250_/A _5250_/B _5250_/C vssd1 vssd1 vccd1 vccd1 _5295_/A sky130_fd_sc_hd__and3_2
XFILLER_47_3 vssd1 vssd1 vccd1 vccd1 sky130_fd_sc_hd__fill_4
X_4201_ input5/X _4218_/S vssd1 vssd1 vccd1 vccd1 _4201_/Y sky130_fd_sc_hd__nand2b_2
XANTENNA__5414__D _6006_/A vssd1 vssd1 vccd1 vccd1 sky130_fd_sc_hd__diode_2
X_5181_ _5181_/A _5181_/B vssd1 vssd1 vccd1 vccd1 _5182_/C sky130_fd_sc_hd__xnor2_2
XANTENNA__4608__A _8422_/D vssd1 vssd1 vccd1 vccd1 sky130_fd_sc_hd__diode_2
XANTENNA__5257__A1 _5983_/A vssd1 vssd1 vccd1 vccd1 sky130_fd_sc_hd__diode_2
XFILLER_3_84 vssd1 vssd1 vccd1 vccd1 sky130_fd_sc_hd__fill_8
XFILLER_83_315 vssd1 vssd1 vccd1 vccd1 sky130_fd_sc_hd__fill_1
XANTENNA__6206__B1 _6485_/B vssd1 vssd1 vccd1 vccd1 sky130_fd_sc_hd__diode_2
XFILLER_64_551 vssd1 vssd1 vccd1 vccd1 sky130_fd_sc_hd__fill_1
XANTENNA__7919__A _7990_/A vssd1 vssd1 vccd1 vccd1 sky130_fd_sc_hd__diode_2
XFILLER_51_201 vssd1 vssd1 vccd1 vccd1 sky130_fd_sc_hd__fill_1
X_7822_ _7954_/A _8082_/C _7822_/C vssd1 vssd1 vccd1 vccd1 _7947_/B sky130_fd_sc_hd__or3_2
X_7753_ _8103_/A _7877_/B _8126_/B _7754_/B vssd1 vssd1 vccd1 vccd1 _7755_/A sky130_fd_sc_hd__a22oi_2
X_4965_ _5983_/A _4965_/B _5128_/C vssd1 vssd1 vccd1 vccd1 _5200_/B sky130_fd_sc_hd__or3b_2
XFILLER_11_109 vssd1 vssd1 vccd1 vccd1 sky130_fd_sc_hd__fill_1
XFILLER_51_256 vssd1 vssd1 vccd1 vccd1 sky130_fd_sc_hd__fill_4
X_6704_ _8437_/D _6704_/B vssd1 vssd1 vccd1 vccd1 _6705_/B sky130_fd_sc_hd__nand2_2
X_7684_ _7684_/A _7684_/B vssd1 vssd1 vccd1 vccd1 _7694_/A sky130_fd_sc_hd__xnor2_2
X_4896_ _8425_/D _4895_/B _4894_/Y vssd1 vssd1 vccd1 vccd1 _4897_/D sky130_fd_sc_hd__a21bo_2
XANTENNA__8392__CLK clkload7/A vssd1 vssd1 vccd1 vccd1 sky130_fd_sc_hd__diode_2
X_6635_ _6635_/A _6635_/B vssd1 vssd1 vccd1 vccd1 _6636_/B sky130_fd_sc_hd__xnor2_2
X_6566_ _6342_/A _6342_/B _6340_/Y vssd1 vssd1 vccd1 vccd1 _6625_/A sky130_fd_sc_hd__a21o_2
XANTENNA__4170__A_N _8168_/B vssd1 vssd1 vccd1 vccd1 sky130_fd_sc_hd__diode_2
X_8305_ _8439_/D _8168_/B _8307_/S vssd1 vssd1 vccd1 vccd1 _8380_/D sky130_fd_sc_hd__mux2_1
X_5517_ _5517_/A _5517_/B vssd1 vssd1 vccd1 vccd1 _5518_/B sky130_fd_sc_hd__or2_2
X_8236_ _8236_/A _8236_/B vssd1 vssd1 vccd1 vccd1 _8237_/B sky130_fd_sc_hd__or2_2
X_6497_ _6812_/B _6497_/B vssd1 vssd1 vccd1 vccd1 _6499_/C sky130_fd_sc_hd__nand2_2
X_5448_ _5448_/A _5460_/A vssd1 vssd1 vccd1 vccd1 _5449_/B sky130_fd_sc_hd__nand2_2
X_8167_ _8168_/A _8168_/B vssd1 vssd1 vccd1 vccd1 _8167_/Y sky130_fd_sc_hd__nand2_2
Xfanout100 _4608_/B vssd1 vssd1 vccd1 vccd1 _4430_/B sky130_fd_sc_hd__clkdlybuf4s25_1
Xfanout111 _4487_/B vssd1 vssd1 vccd1 vccd1 fanout111/X sky130_fd_sc_hd__clkdlybuf4s25_1
Xfanout122 _4209_/Y vssd1 vssd1 vccd1 vccd1 _8417_/D sky130_fd_sc_hd__clkdlybuf4s25_1
X_5379_ _5380_/A _5451_/A _5380_/C vssd1 vssd1 vccd1 vccd1 _5381_/A sky130_fd_sc_hd__a21oi_2
X_8098_ _8051_/A _8051_/C _8051_/B vssd1 vssd1 vccd1 vccd1 _8151_/A sky130_fd_sc_hd__a21bo_2
Xfanout144 _4155_/Y vssd1 vssd1 vccd1 vccd1 _6091_/A sky130_fd_sc_hd__buf_6
X_7118_ _7039_/A _7037_/Y _6793_/X _7116_/Y _7038_/A vssd1 vssd1 vccd1 vccd1 _7203_/A
+ sky130_fd_sc_hd__o311ai_4
Xfanout199 _8401_/Q vssd1 vssd1 vccd1 vccd1 _8398_/D sky130_fd_sc_hd__clkdlybuf4s25_1
X_7049_ _7049_/A _7049_/B vssd1 vssd1 vccd1 vccd1 _7114_/A sky130_fd_sc_hd__nand2_2
XPHY_EDGE_ROW_29_Right_29 vssd1 vssd1 vccd1 vccd1 sky130_fd_sc_hd__decap_3
XANTENNA__4471__A2 _4487_/B vssd1 vssd1 vccd1 vccd1 sky130_fd_sc_hd__diode_2
XTAP_TAPCELL_ROW_53_730 vssd1 vccd1 sky130_fd_sc_hd__tapvpwrvgnd_1
XFILLER_63_78 vssd1 vssd1 vccd1 vccd1 sky130_fd_sc_hd__fill_2
XTAP_TAPCELL_ROW_25_454 vssd1 vccd1 sky130_fd_sc_hd__tapvpwrvgnd_1
XANTENNA__5068__B _5267_/B vssd1 vssd1 vccd1 vccd1 sky130_fd_sc_hd__diode_2
XPHY_EDGE_ROW_38_Right_38 vssd1 vssd1 vccd1 vccd1 sky130_fd_sc_hd__decap_3
XANTENNA__4700__B _4700_/B vssd1 vssd1 vccd1 vccd1 sky130_fd_sc_hd__diode_2
XFILLER_88_53 vssd1 vssd1 vccd1 vccd1 sky130_fd_sc_hd__fill_1
XFILLER_2_396 vssd1 vssd1 vccd1 vccd1 sky130_fd_sc_hd__fill_1
XANTENNA__6436__B1 _7140_/C vssd1 vssd1 vccd1 vccd1 sky130_fd_sc_hd__diode_2
XPHY_EDGE_ROW_47_Right_47 vssd1 vssd1 vccd1 vccd1 sky130_fd_sc_hd__decap_3
XFILLER_80_307 vssd1 vssd1 vccd1 vccd1 sky130_fd_sc_hd__fill_1
XFILLER_33_223 vssd1 vssd1 vccd1 vccd1 sky130_fd_sc_hd__fill_1
XFILLER_61_554 vssd1 vssd1 vccd1 vccd1 sky130_fd_sc_hd__fill_1
XFILLER_33_267 vssd1 vssd1 vccd1 vccd1 sky130_fd_sc_hd__fill_1
XFILLER_14_481 vssd1 vssd1 vccd1 vccd1 sky130_fd_sc_hd__fill_2
X_4750_ _4750_/A _4750_/B vssd1 vssd1 vccd1 vccd1 _4753_/A sky130_fd_sc_hd__xnor2_2
XPHY_EDGE_ROW_56_Right_56 vssd1 vssd1 vccd1 vccd1 sky130_fd_sc_hd__decap_3
X_4681_ _4682_/A _4682_/B _4680_/A vssd1 vssd1 vccd1 vccd1 _4681_/X sky130_fd_sc_hd__o21a_2
X_6420_ _6420_/A _6420_/B _6420_/C vssd1 vssd1 vccd1 vccd1 _6421_/B sky130_fd_sc_hd__or3_2
X_6351_ _6351_/A _6351_/B vssd1 vssd1 vccd1 vccd1 _6354_/A sky130_fd_sc_hd__xnor2_2
X_5302_ _5446_/A _5559_/B _5417_/D _5826_/A vssd1 vssd1 vccd1 vccd1 _5537_/A sky130_fd_sc_hd__and4_2
XANTENNA_wire364_X wire364/X vssd1 vssd1 vccd1 vccd1 sky130_fd_sc_hd__diode_2
X_6282_ _6282_/A _6282_/B vssd1 vssd1 vccd1 vccd1 _6282_/X sky130_fd_sc_hd__xor2_2
XANTENNA__6818__A _8125_/A vssd1 vssd1 vccd1 vccd1 sky130_fd_sc_hd__diode_2
X_8021_ _8021_/A _8021_/B vssd1 vssd1 vccd1 vccd1 _8022_/B sky130_fd_sc_hd__nor2_2
X_5233_ _5102_/A _5102_/C _5102_/B vssd1 vssd1 vccd1 vccd1 _5234_/C sky130_fd_sc_hd__a21oi_2
XPHY_EDGE_ROW_65_Right_65 vssd1 vssd1 vccd1 vccd1 sky130_fd_sc_hd__decap_3
XANTENNA__4150__A1 input5/X vssd1 vssd1 vccd1 vccd1 sky130_fd_sc_hd__diode_2
XFILLER_68_120 vssd1 vssd1 vccd1 vccd1 sky130_fd_sc_hd__fill_1
X_5164_ _5164_/A _5164_/B vssd1 vssd1 vccd1 vccd1 _5165_/B sky130_fd_sc_hd__xnor2_2
XFILLER_68_197 vssd1 vssd1 vccd1 vccd1 sky130_fd_sc_hd__fill_1
X_5095_ _5095_/A _5095_/B vssd1 vssd1 vccd1 vccd1 _5212_/A sky130_fd_sc_hd__xor2_2
XFILLER_37_551 vssd1 vssd1 vccd1 vccd1 sky130_fd_sc_hd__fill_1
XFILLER_56_348 vssd1 vssd1 vccd1 vccd1 sky130_fd_sc_hd__fill_1
XTAP_TAPCELL_ROW_67_866 vssd1 vccd1 sky130_fd_sc_hd__tapvpwrvgnd_1
X_7805_ _7677_/A _7677_/B _7678_/Y vssd1 vssd1 vccd1 vccd1 _7810_/A sky130_fd_sc_hd__a21bo_2
XANTENNA__5402__A1 _8215_/A vssd1 vssd1 vccd1 vccd1 sky130_fd_sc_hd__diode_2
XANTENNA__5402__B2 _5838_/C vssd1 vssd1 vccd1 vccd1 sky130_fd_sc_hd__diode_2
X_5997_ _5997_/A _5997_/B vssd1 vssd1 vccd1 vccd1 _5999_/A sky130_fd_sc_hd__xor2_2
XTAP_TAPCELL_ROW_50_700 vssd1 vccd1 sky130_fd_sc_hd__tapvpwrvgnd_1
XPHY_EDGE_ROW_74_Right_74 vssd1 vssd1 vccd1 vccd1 sky130_fd_sc_hd__decap_3
XANTENNA_fanout144_X _6091_/A vssd1 vssd1 vccd1 vccd1 sky130_fd_sc_hd__diode_2
XFILLER_12_429 vssd1 vssd1 vccd1 vccd1 sky130_fd_sc_hd__fill_1
X_7736_ _7736_/A _7736_/B vssd1 vssd1 vccd1 vccd1 _7738_/A sky130_fd_sc_hd__nor2_2
X_4948_ _4949_/B _4949_/A vssd1 vssd1 vccd1 vccd1 _5008_/B sky130_fd_sc_hd__nor2_2
XTAP_TAPCELL_ROW_22_424 vssd1 vccd1 sky130_fd_sc_hd__tapvpwrvgnd_1
X_7667_ _7616_/A _7807_/A _7666_/X vssd1 vssd1 vccd1 vccd1 _7668_/C sky130_fd_sc_hd__a21o_2
X_4879_ _4877_/X _4876_/Y _4804_/X _4807_/Y vssd1 vssd1 vccd1 vccd1 _5037_/A sky130_fd_sc_hd__o211ai_2
XANTENNA__4360__X _4360_/X vssd1 vssd1 vccd1 vccd1 sky130_fd_sc_hd__diode_2
XANTENNA_fanout311_X _7140_/C vssd1 vssd1 vccd1 vccd1 sky130_fd_sc_hd__diode_2
X_6618_ _5983_/Y _6615_/A _6339_/B _6339_/A vssd1 vssd1 vccd1 vccd1 _6620_/B sky130_fd_sc_hd__a22o_2
X_7598_ _7391_/A _7391_/B _7392_/Y vssd1 vssd1 vccd1 vccd1 _7606_/A sky130_fd_sc_hd__a21bo_2
X_6549_ _6549_/A _6869_/B vssd1 vssd1 vccd1 vccd1 _6550_/C sky130_fd_sc_hd__nor2_2
XPHY_EDGE_ROW_83_Right_83 vssd1 vssd1 vccd1 vccd1 sky130_fd_sc_hd__decap_3
X_8219_ _8220_/A input5/X vssd1 vssd1 vccd1 vccd1 _8221_/A sky130_fd_sc_hd__or2_2
XANTENNA__7550__C _8125_/B vssd1 vssd1 vccd1 vccd1 sky130_fd_sc_hd__diode_2
XANTENNA__5351__B _5826_/A vssd1 vssd1 vccd1 vccd1 sky130_fd_sc_hd__diode_2
XFILLER_87_451 vssd1 vssd1 vccd1 vccd1 sky130_fd_sc_hd__fill_1
XFILLER_87_462 vssd1 vssd1 vccd1 vccd1 sky130_fd_sc_hd__fill_1
XFILLER_47_337 vssd1 vssd1 vccd1 vccd1 sky130_fd_sc_hd__fill_1
XFILLER_59_175 vssd1 vssd1 vccd1 vccd1 sky130_fd_sc_hd__fill_1
XFILLER_59_197 vssd1 vssd1 vccd1 vccd1 sky130_fd_sc_hd__fill_2
XFILLER_62_307 vssd1 vssd1 vccd1 vccd1 sky130_fd_sc_hd__fill_1
XFILLER_62_329 vssd1 vssd1 vccd1 vccd1 sky130_fd_sc_hd__fill_4
XFILLER_74_66 vssd1 vssd1 vccd1 vccd1 sky130_fd_sc_hd__fill_4
XFILLER_55_381 vssd1 vssd1 vccd1 vccd1 sky130_fd_sc_hd__fill_1
XPHY_EDGE_ROW_92_Right_92 vssd1 vssd1 vccd1 vccd1 sky130_fd_sc_hd__decap_3
XANTENNA__4711__A _8422_/D vssd1 vssd1 vccd1 vccd1 sky130_fd_sc_hd__diode_2
XFILLER_7_411 vssd1 vssd1 vccd1 vccd1 sky130_fd_sc_hd__fill_1
Xwire364 wire364/A vssd1 vssd1 vccd1 vccd1 wire364/X sky130_fd_sc_hd__buf_4
XFILLER_7_488 vssd1 vssd1 vccd1 vccd1 sky130_fd_sc_hd__fill_2
XANTENNA__8435__RESET_B wire362/X vssd1 vssd1 vccd1 vccd1 sky130_fd_sc_hd__diode_2
Xload_slew358 fanout357/X vssd1 vssd1 vccd1 vccd1 load_slew358/X sky130_fd_sc_hd__clkbuf_4
XFILLER_65_123 vssd1 vssd1 vccd1 vccd1 sky130_fd_sc_hd__fill_1
XFILLER_0_52 vssd1 vssd1 vccd1 vccd1 sky130_fd_sc_hd__fill_4
XFILLER_65_167 vssd1 vssd1 vccd1 vccd1 sky130_fd_sc_hd__fill_1
X_5920_ _5920_/A _5920_/B vssd1 vssd1 vccd1 vccd1 _5990_/A sky130_fd_sc_hd__xor2_2
XTAP_TAPCELL_ROW_88_1079 vssd1 vccd1 sky130_fd_sc_hd__tapvpwrvgnd_1
XTAP_TAPCELL_ROW_64_836 vssd1 vccd1 sky130_fd_sc_hd__tapvpwrvgnd_1
XANTENNA__8361__Q _8361_/Q vssd1 vssd1 vccd1 vccd1 sky130_fd_sc_hd__diode_2
X_5851_ _5851_/A _5851_/B vssd1 vssd1 vccd1 vccd1 _5852_/B sky130_fd_sc_hd__nor2_2
X_5782_ _5782_/A _5901_/A vssd1 vssd1 vccd1 vccd1 _5914_/A sky130_fd_sc_hd__nor2_2
X_4802_ _4802_/A _4802_/B vssd1 vssd1 vccd1 vccd1 _4806_/A sky130_fd_sc_hd__xnor2_2
X_7521_ _7522_/B _7522_/A vssd1 vssd1 vccd1 vccd1 _7731_/A sky130_fd_sc_hd__nand2b_2
X_4733_ _4733_/A _4733_/B vssd1 vssd1 vccd1 vccd1 _4733_/X sky130_fd_sc_hd__xor2_2
Xrebuffer508 _4611_/A vssd1 vssd1 vccd1 vccd1 _4613_/A2 sky130_fd_sc_hd__buf_2
X_7452_ _7452_/A _7452_/B vssd1 vssd1 vccd1 vccd1 _7454_/B sky130_fd_sc_hd__xnor2_2
X_6403_ _7129_/A _6485_/B _6798_/B _6892_/B vssd1 vssd1 vccd1 vccd1 _6405_/A sky130_fd_sc_hd__a22oi_2
X_4664_ _4664_/A _4664_/B vssd1 vssd1 vccd1 vccd1 _4664_/X sky130_fd_sc_hd__xor2_2
X_7383_ _7311_/A _7386_/A _7313_/X vssd1 vssd1 vccd1 vccd1 _7393_/A sky130_fd_sc_hd__a21bo_2
X_4595_ _4648_/B vssd1 vssd1 vccd1 vccd1 _4596_/B sky130_fd_sc_hd__inv_2
XANTENNA__8430__CLK clkload4/A vssd1 vssd1 vccd1 vccd1 sky130_fd_sc_hd__diode_2
XANTENNA_fanout104_A _4692_/B vssd1 vssd1 vccd1 vccd1 sky130_fd_sc_hd__diode_2
X_6334_ _6611_/A _7806_/B vssd1 vssd1 vccd1 vccd1 _6342_/A sky130_fd_sc_hd__nor2_2
X_6265_ _6265_/A vssd1 vssd1 vccd1 vccd1 _6265_/Y sky130_fd_sc_hd__inv_2
XANTENNA__6548__A _6548_/A vssd1 vssd1 vccd1 vccd1 sky130_fd_sc_hd__diode_2
X_8004_ _8004_/A _8004_/B vssd1 vssd1 vccd1 vccd1 _8006_/B sky130_fd_sc_hd__xor2_2
X_5216_ _8411_/D _5274_/B _5254_/B _8410_/D vssd1 vssd1 vccd1 vccd1 _5216_/X sky130_fd_sc_hd__a22o_2
XANTENNA__7860__A2 _8136_/B vssd1 vssd1 vccd1 vccd1 sky130_fd_sc_hd__diode_2
XFILLER_88_259 vssd1 vssd1 vccd1 vccd1 sky130_fd_sc_hd__fill_1
X_6196_ _6196_/A _6196_/B vssd1 vssd1 vccd1 vccd1 _6197_/B sky130_fd_sc_hd__xnor2_2
XFILLER_84_421 vssd1 vssd1 vccd1 vccd1 sky130_fd_sc_hd__fill_2
X_5147_ _6712_/A _5147_/B vssd1 vssd1 vccd1 vccd1 _5148_/B sky130_fd_sc_hd__and2_2
X_5078_ _5047_/A _5213_/A _5077_/X vssd1 vssd1 vccd1 vccd1 _5084_/A sky130_fd_sc_hd__o21a_2
XFILLER_44_307 vssd1 vssd1 vccd1 vccd1 sky130_fd_sc_hd__fill_1
XANTENNA__7098__B _7299_/B vssd1 vssd1 vccd1 vccd1 sky130_fd_sc_hd__diode_2
XFILLER_40_568 vssd1 vssd1 vccd1 vccd1 sky130_fd_sc_hd__fill_2
X_7719_ _7517_/B _7519_/B _7517_/A vssd1 vssd1 vccd1 vccd1 _7721_/B sky130_fd_sc_hd__o21ba_2
XANTENNA__7128__B2 _7862_/B vssd1 vssd1 vccd1 vccd1 sky130_fd_sc_hd__diode_2
XANTENNA__4531__A _4674_/A vssd1 vssd1 vccd1 vccd1 sky130_fd_sc_hd__diode_2
XFILLER_20_292 vssd1 vssd1 vccd1 vccd1 sky130_fd_sc_hd__fill_1
XANTENNA__6639__B1 _6360_/B vssd1 vssd1 vccd1 vccd1 sky130_fd_sc_hd__diode_2
XFILLER_79_204 vssd1 vssd1 vccd1 vccd1 sky130_fd_sc_hd__fill_4
XFILLER_79_215 vssd1 vssd1 vccd1 vccd1 sky130_fd_sc_hd__fill_1
XTAP_TAPCELL_ROW_7_274 vssd1 vccd1 sky130_fd_sc_hd__tapvpwrvgnd_1
XFILLER_47_101 vssd1 vssd1 vccd1 vccd1 sky130_fd_sc_hd__fill_1
XFILLER_18_81 vssd1 vssd1 vccd1 vccd1 sky130_fd_sc_hd__fill_2
XFILLER_62_115 vssd1 vssd1 vccd1 vccd1 sky130_fd_sc_hd__fill_1
XTAP_TAPCELL_ROW_61_806 vssd1 vccd1 sky130_fd_sc_hd__tapvpwrvgnd_1
XFILLER_90_479 vssd1 vssd1 vccd1 vccd1 sky130_fd_sc_hd__fill_1
XANTENNA__8453__CLK clkload7/A vssd1 vssd1 vccd1 vccd1 sky130_fd_sc_hd__diode_2
Xwire150 _4212_/A vssd1 vssd1 vccd1 vccd1 _8081_/A sky130_fd_sc_hd__buf_2
XANTENNA__4160__B _4160_/B vssd1 vssd1 vccd1 vccd1 sky130_fd_sc_hd__diode_2
XANTENNA__5256__B _5267_/B vssd1 vssd1 vccd1 vccd1 sky130_fd_sc_hd__diode_2
XANTENNA_max_cap157_X _7304_/A vssd1 vssd1 vccd1 vccd1 sky130_fd_sc_hd__diode_2
X_4380_ _4919_/A _4780_/B vssd1 vssd1 vccd1 vccd1 _4380_/Y sky130_fd_sc_hd__nand2_2
XFILLER_3_491 vssd1 vssd1 vccd1 vccd1 sky130_fd_sc_hd__fill_2
XFILLER_85_207 vssd1 vssd1 vccd1 vccd1 sky130_fd_sc_hd__fill_1
X_6050_ _6050_/A _6259_/B _6050_/C vssd1 vssd1 vccd1 vccd1 _6053_/A sky130_fd_sc_hd__nand3_2
Xload_slew177 fanout176/X vssd1 vssd1 vccd1 vccd1 _5747_/A sky130_fd_sc_hd__buf_4
X_5001_ _5001_/A _5001_/B vssd1 vssd1 vccd1 vccd1 _5003_/B sky130_fd_sc_hd__xnor2_2
XFILLER_53_104 vssd1 vssd1 vccd1 vccd1 sky130_fd_sc_hd__fill_1
XFILLER_66_465 vssd1 vssd1 vccd1 vccd1 sky130_fd_sc_hd__fill_4
XTAP_TAPCELL_ROW_77_972 vssd1 vccd1 sky130_fd_sc_hd__tapvpwrvgnd_1
XFILLER_53_115 vssd1 vssd1 vccd1 vccd1 sky130_fd_sc_hd__fill_4
X_6952_ _6952_/A _6952_/B vssd1 vssd1 vccd1 vccd1 _6954_/C sky130_fd_sc_hd__or2_2
X_6883_ _6883_/A _7120_/A _7714_/C _7714_/D vssd1 vssd1 vccd1 vccd1 _6885_/A sky130_fd_sc_hd__and4_2
X_5903_ _5903_/A _5903_/B vssd1 vssd1 vccd1 vccd1 _5905_/B sky130_fd_sc_hd__xor2_2
X_5834_ _5834_/A _5834_/B vssd1 vssd1 vccd1 vccd1 _5835_/B sky130_fd_sc_hd__nor2_2
XANTENNA__6030__A1 _6517_/A vssd1 vssd1 vccd1 vccd1 sky130_fd_sc_hd__diode_2
XANTENNA__6030__B2 _6517_/B vssd1 vssd1 vccd1 vccd1 sky130_fd_sc_hd__diode_2
X_5765_ _5983_/A _6631_/B vssd1 vssd1 vccd1 vccd1 _6145_/C sky130_fd_sc_hd__or2_2
X_7504_ _7594_/A _7504_/B vssd1 vssd1 vccd1 vccd1 _7506_/C sky130_fd_sc_hd__nor2_2
X_5696_ _5696_/A _5696_/B vssd1 vssd1 vccd1 vccd1 _5772_/A sky130_fd_sc_hd__nand2_2
X_4716_ _8422_/D _4487_/B _4706_/B _4704_/X vssd1 vssd1 vccd1 vccd1 _4716_/X sky130_fd_sc_hd__a31o_2
XFILLER_30_27 vssd1 vssd1 vccd1 vccd1 sky130_fd_sc_hd__fill_1
X_7435_ _8131_/A _8131_/B _7853_/A _8030_/A vssd1 vssd1 vccd1 vccd1 _7436_/B sky130_fd_sc_hd__and4_2
X_4647_ _4669_/B vssd1 vssd1 vccd1 vccd1 _4647_/Y sky130_fd_sc_hd__inv_2
XANTENNA__8357__RESET_B load_slew384/X vssd1 vssd1 vccd1 vccd1 sky130_fd_sc_hd__diode_2
X_7366_ _7326_/Y _7328_/Y _7365_/X vssd1 vssd1 vccd1 vccd1 _7368_/A sky130_fd_sc_hd__a21bo_2
X_6317_ _6318_/A _6318_/B vssd1 vssd1 vccd1 vccd1 _6319_/A sky130_fd_sc_hd__nor2_2
X_4578_ _4578_/A _4578_/B vssd1 vssd1 vccd1 vccd1 _4581_/A sky130_fd_sc_hd__xnor2_2
X_7297_ _7298_/A _7298_/B vssd1 vssd1 vccd1 vccd1 _7297_/X sky130_fd_sc_hd__or2_2
XFILLER_39_25 vssd1 vssd1 vccd1 vccd1 sky130_fd_sc_hd__fill_1
X_6248_ _6248_/A _6248_/B _6248_/C vssd1 vssd1 vccd1 vccd1 _6249_/B sky130_fd_sc_hd__nand3_2
X_6179_ _6180_/A _6180_/B vssd1 vssd1 vccd1 vccd1 _6367_/B sky130_fd_sc_hd__or2_2
XFILLER_29_134 vssd1 vssd1 vccd1 vccd1 sky130_fd_sc_hd__fill_2
XTAP_TAPCELL_ROW_4_244 vssd1 vccd1 sky130_fd_sc_hd__tapvpwrvgnd_1
XANTENNA__6725__B _7095_/B vssd1 vssd1 vccd1 vccd1 sky130_fd_sc_hd__diode_2
XANTENNA__8326__CLK _8405_/CLK vssd1 vssd1 vccd1 vccd1 sky130_fd_sc_hd__diode_2
XFILLER_29_167 vssd1 vssd1 vccd1 vccd1 sky130_fd_sc_hd__fill_1
XFILLER_57_476 vssd1 vssd1 vccd1 vccd1 sky130_fd_sc_hd__fill_4
XFILLER_44_137 vssd1 vssd1 vccd1 vccd1 sky130_fd_sc_hd__fill_2
XFILLER_72_446 vssd1 vssd1 vccd1 vccd1 sky130_fd_sc_hd__fill_2
XFILLER_55_79 vssd1 vssd1 vccd1 vccd1 sky130_fd_sc_hd__fill_1
XFILLER_13_568 vssd1 vssd1 vccd1 vccd1 sky130_fd_sc_hd__fill_2
XANTENNA__6460__B _8263_/A vssd1 vssd1 vccd1 vccd1 sky130_fd_sc_hd__diode_2
XFILLER_40_387 vssd1 vssd1 vccd1 vccd1 sky130_fd_sc_hd__fill_1
XFILLER_40_398 vssd1 vssd1 vccd1 vccd1 sky130_fd_sc_hd__fill_1
XFILLER_48_421 vssd1 vssd1 vccd1 vccd1 sky130_fd_sc_hd__fill_1
XTAP_TAPCELL_ROW_74_942 vssd1 vccd1 sky130_fd_sc_hd__tapvpwrvgnd_1
XTAP_TAPCELL_ROW_85_1049 vssd1 vccd1 sky130_fd_sc_hd__tapvpwrvgnd_1
XTAP_TAPCELL_ROW_18_379 vssd1 vccd1 sky130_fd_sc_hd__tapvpwrvgnd_1
XFILLER_31_321 vssd1 vssd1 vccd1 vccd1 sky130_fd_sc_hd__fill_1
XFILLER_77_3 vssd1 vssd1 vccd1 vccd1 sky130_fd_sc_hd__fill_4
X_5550_ _8215_/A _5594_/B _5546_/A _5544_/A vssd1 vssd1 vccd1 vccd1 _5687_/A sky130_fd_sc_hd__a31o_2
X_5481_ _5487_/B _5520_/A _5487_/A vssd1 vssd1 vccd1 vccd1 _5491_/B sky130_fd_sc_hd__o21ai_2
X_4501_ _4502_/A _4502_/B _4502_/C vssd1 vssd1 vccd1 vccd1 _4503_/A sky130_fd_sc_hd__o21a_2
X_7220_ _7220_/A _7220_/B vssd1 vssd1 vccd1 vccd1 _7222_/A sky130_fd_sc_hd__nor2_2
X_4432_ _4744_/A _4432_/B vssd1 vssd1 vccd1 vccd1 _4537_/A sky130_fd_sc_hd__nand2_2
X_7151_ _7242_/B _7151_/B vssd1 vssd1 vccd1 vccd1 _7153_/A sky130_fd_sc_hd__nand2_2
X_4363_ _5155_/A _4931_/C vssd1 vssd1 vccd1 vccd1 _4365_/A sky130_fd_sc_hd__nand2_2
X_7082_ _7082_/A _7082_/B vssd1 vssd1 vccd1 vccd1 _7085_/A sky130_fd_sc_hd__xnor2_2
X_6102_ _5941_/A _5941_/B _5943_/B _5943_/A vssd1 vssd1 vccd1 vccd1 _6104_/B sky130_fd_sc_hd__o22a_2
X_4294_ _5163_/B _5163_/C vssd1 vssd1 vccd1 vccd1 _4294_/X sky130_fd_sc_hd__and2_2
X_6033_ _6433_/A _8241_/A vssd1 vssd1 vccd1 vccd1 _6034_/B sky130_fd_sc_hd__nand2_2
XTAP_TAPCELL_ROW_1_214 vssd1 vccd1 sky130_fd_sc_hd__tapvpwrvgnd_1
XANTENNA__4346__A _4761_/A vssd1 vssd1 vccd1 vccd1 sky130_fd_sc_hd__diode_2
X_7984_ _7984_/A _7984_/B vssd1 vssd1 vccd1 vccd1 _8066_/A sky130_fd_sc_hd__xnor2_2
X_6935_ _7183_/A _6935_/B vssd1 vssd1 vccd1 vccd1 _6935_/Y sky130_fd_sc_hd__nand2_2
XFILLER_25_49 vssd1 vssd1 vccd1 vccd1 sky130_fd_sc_hd__fill_4
X_6866_ _6866_/A _6866_/B vssd1 vssd1 vccd1 vccd1 _6867_/B sky130_fd_sc_hd__nand2_2
XANTENNA__6280__B _6280_/B vssd1 vssd1 vccd1 vccd1 sky130_fd_sc_hd__diode_2
X_6797_ _6797_/A _6797_/B vssd1 vssd1 vccd1 vccd1 _6799_/A sky130_fd_sc_hd__nor2_2
X_5817_ _5817_/A _5817_/B vssd1 vssd1 vccd1 vccd1 _5819_/A sky130_fd_sc_hd__nor2_2
XANTENNA__7095__C _7095_/C vssd1 vssd1 vccd1 vccd1 sky130_fd_sc_hd__diode_2
XANTENNA_fanout224_X _7131_/A vssd1 vssd1 vccd1 vccd1 sky130_fd_sc_hd__diode_2
XFILLER_10_549 vssd1 vssd1 vccd1 vccd1 sky130_fd_sc_hd__fill_1
XFILLER_41_37 vssd1 vssd1 vccd1 vccd1 sky130_fd_sc_hd__fill_4
X_5748_ _5748_/A _5748_/B vssd1 vssd1 vccd1 vccd1 _5750_/B sky130_fd_sc_hd__xnor2_2
X_5679_ _5548_/A _5548_/C _5548_/B vssd1 vssd1 vccd1 vccd1 _5680_/B sky130_fd_sc_hd__o21ai_2
X_8398_ clkload9/A _8398_/D fanout372/X vssd1 vssd1 vccd1 vccd1 _8398_/Q sky130_fd_sc_hd__dfrtp_2
X_7418_ _7419_/B _7419_/A vssd1 vssd1 vccd1 vccd1 _7649_/B sky130_fd_sc_hd__and2b_2
XFILLER_1_225 vssd1 vssd1 vccd1 vccd1 sky130_fd_sc_hd__fill_1
Xhold550 _8357_/Q vssd1 vssd1 vccd1 vccd1 hold550/X sky130_fd_sc_hd__dlygate4sd3_1
X_7349_ _7349_/A _7349_/B vssd1 vssd1 vccd1 vccd1 _7350_/B sky130_fd_sc_hd__nand2_2
Xteam_03_388 vssd1 vssd1 vccd1 vccd1 team_03_388/HI gpio_oeb[19] sky130_fd_sc_hd__conb_1
Xteam_03_399 vssd1 vssd1 vccd1 vccd1 team_03_399/HI gpio_oeb[30] sky130_fd_sc_hd__conb_1
XFILLER_17_115 vssd1 vssd1 vccd1 vccd1 sky130_fd_sc_hd__fill_1
XFILLER_82_22 vssd1 vssd1 vccd1 vccd1 sky130_fd_sc_hd__fill_1
XTAP_TAPCELL_ROW_71_912 vssd1 vccd1 sky130_fd_sc_hd__tapvpwrvgnd_1
XTAP_TAPCELL_ROW_15_349 vssd1 vccd1 sky130_fd_sc_hd__tapvpwrvgnd_1
XANTENNA__4308__A1 _4761_/A vssd1 vssd1 vccd1 vccd1 sky130_fd_sc_hd__diode_2
XFILLER_5_531 vssd1 vssd1 vccd1 vccd1 sky130_fd_sc_hd__fill_4
XFILLER_31_81 vssd1 vssd1 vccd1 vccd1 sky130_fd_sc_hd__fill_1
XFILLER_68_516 vssd1 vssd1 vccd1 vccd1 sky130_fd_sc_hd__fill_2
XANTENNA__6481__A1 _6689_/A vssd1 vssd1 vccd1 vccd1 sky130_fd_sc_hd__diode_2
XFILLER_48_262 vssd1 vssd1 vccd1 vccd1 sky130_fd_sc_hd__fill_4
XFILLER_48_295 vssd1 vssd1 vccd1 vccd1 sky130_fd_sc_hd__fill_2
XTAP_TAPCELL_ROW_59_791 vssd1 vccd1 sky130_fd_sc_hd__tapvpwrvgnd_1
XANTENNA__6233__A1 _6517_/A vssd1 vssd1 vccd1 vccd1 sky130_fd_sc_hd__diode_2
XANTENNA__6233__B2 _6517_/B vssd1 vssd1 vccd1 vccd1 sky130_fd_sc_hd__diode_2
XFILLER_36_468 vssd1 vssd1 vccd1 vccd1 sky130_fd_sc_hd__fill_1
XFILLER_91_552 vssd1 vssd1 vccd1 vccd1 sky130_fd_sc_hd__fill_1
X_4981_ _5155_/A _4979_/B _4979_/C _4496_/D _4979_/A vssd1 vssd1 vccd1 vccd1 _4981_/Y
+ sky130_fd_sc_hd__a32oi_2
X_6720_ _6720_/A _6720_/B vssd1 vssd1 vccd1 vccd1 _6721_/B sky130_fd_sc_hd__xnor2_2
XANTENNA__4172__Y _8423_/D vssd1 vssd1 vccd1 vccd1 sky130_fd_sc_hd__diode_2
XANTENNA_load_slew177_X _5747_/A vssd1 vssd1 vccd1 vccd1 sky130_fd_sc_hd__diode_2
X_6651_ _6651_/A _6651_/B vssd1 vssd1 vccd1 vccd1 _6654_/A sky130_fd_sc_hd__xor2_2
XANTENNA__5428__C _6001_/A vssd1 vssd1 vccd1 vccd1 sky130_fd_sc_hd__diode_2
X_6582_ _8435_/D _6582_/B _6582_/C vssd1 vssd1 vccd1 vccd1 _6582_/X sky130_fd_sc_hd__and3_2
X_5602_ _5626_/A _5602_/B vssd1 vssd1 vccd1 vccd1 _5604_/B sky130_fd_sc_hd__xnor2_2
X_8321_ _8334_/CLK _8321_/D fanout382/X vssd1 vssd1 vccd1 vccd1 _8321_/Q sky130_fd_sc_hd__dfrtp_2
X_5533_ _5534_/B _5585_/A _5534_/A vssd1 vssd1 vccd1 vccd1 _5542_/B sky130_fd_sc_hd__a21oi_2
XFILLER_11_29 vssd1 vssd1 vccd1 vccd1 sky130_fd_sc_hd__fill_2
X_8252_ _8247_/A _8250_/B _8247_/B vssd1 vssd1 vccd1 vccd1 _8255_/A sky130_fd_sc_hd__a21boi_2
X_5464_ _5464_/A _5464_/B vssd1 vssd1 vccd1 vccd1 _5466_/B sky130_fd_sc_hd__nand2_2
X_8183_ _8184_/A _8184_/B vssd1 vssd1 vccd1 vccd1 _8183_/Y sky130_fd_sc_hd__nor2_2
X_7203_ _7203_/A _7203_/B _7203_/C vssd1 vssd1 vccd1 vccd1 _7205_/A sky130_fd_sc_hd__and3_2
X_5395_ _5395_/A _5395_/B vssd1 vssd1 vccd1 vccd1 _5396_/B sky130_fd_sc_hd__nor2_2
X_4415_ _4399_/C _4780_/B _6091_/A _4414_/Y _4380_/Y vssd1 vssd1 vccd1 vccd1 _4417_/A
+ sky130_fd_sc_hd__a32o_2
XANTENNA__5163__C _5163_/C vssd1 vssd1 vccd1 vccd1 sky130_fd_sc_hd__diode_2
Xfanout304 _8348_/Q vssd1 vssd1 vccd1 vccd1 _8241_/A sky130_fd_sc_hd__clkdlybuf4s25_1
X_7134_ _7134_/A _7134_/B vssd1 vssd1 vccd1 vccd1 _7135_/B sky130_fd_sc_hd__or2_2
X_4346_ _4761_/A _4919_/B vssd1 vssd1 vccd1 vccd1 _4350_/A sky130_fd_sc_hd__nand2_2
XFILLER_59_516 vssd1 vssd1 vccd1 vccd1 sky130_fd_sc_hd__fill_4
Xfanout348 _8337_/Q vssd1 vssd1 vccd1 vccd1 _6482_/A sky130_fd_sc_hd__clkdlybuf4s25_1
Xfanout337 _6883_/A vssd1 vssd1 vccd1 vccd1 _8184_/A sky130_fd_sc_hd__clkdlybuf4s25_1
Xfanout326 _8342_/Q vssd1 vssd1 vccd1 vccd1 _7426_/A sky130_fd_sc_hd__clkdlybuf4s25_1
Xfanout315 _8345_/Q vssd1 vssd1 vccd1 vccd1 _6238_/D sky130_fd_sc_hd__clkdlybuf4s25_1
Xfanout359 wire362/A vssd1 vssd1 vccd1 vccd1 fanout359/X sky130_fd_sc_hd__clkdlybuf4s25_1
X_7065_ _7065_/A _7065_/B vssd1 vssd1 vccd1 vccd1 _7068_/A sky130_fd_sc_hd__xnor2_2
X_4277_ _4902_/A _4432_/B vssd1 vssd1 vccd1 vccd1 _4286_/B sky130_fd_sc_hd__nand2_2
X_6016_ _6016_/A _6016_/B _6798_/B _6217_/C vssd1 vssd1 vccd1 vccd1 _6018_/A sky130_fd_sc_hd__and4_2
X_7967_ _7966_/A _7806_/B _7966_/B _8077_/A vssd1 vssd1 vccd1 vccd1 _7967_/X sky130_fd_sc_hd__o22a_2
X_7898_ _7898_/A _7898_/B vssd1 vssd1 vccd1 vccd1 _7901_/A sky130_fd_sc_hd__nor2_2
X_6918_ _7889_/A _7889_/B _8351_/Q _7875_/D vssd1 vssd1 vccd1 vccd1 _6919_/B sky130_fd_sc_hd__and4_2
X_6849_ _6849_/A _6849_/B _6847_/Y vssd1 vssd1 vccd1 vccd1 _6850_/B sky130_fd_sc_hd__or3b_2
XFILLER_22_173 vssd1 vssd1 vccd1 vccd1 sky130_fd_sc_hd__fill_2
XTAP_TAPCELL_ROW_12_319 vssd1 vccd1 sky130_fd_sc_hd__tapvpwrvgnd_1
XTAP_TAPCELL_ROW_20_396 vssd1 vccd1 sky130_fd_sc_hd__tapvpwrvgnd_1
XANTENNA__4710__A1 _4674_/A vssd1 vssd1 vccd1 vccd1 sky130_fd_sc_hd__diode_2
XFILLER_2_556 vssd1 vssd1 vccd1 vccd1 sky130_fd_sc_hd__fill_2
XFILLER_7_3 vssd1 vssd1 vccd1 vccd1 sky130_fd_sc_hd__fill_2
XFILLER_77_55 vssd1 vssd1 vccd1 vccd1 sky130_fd_sc_hd__fill_1
XFILLER_89_173 vssd1 vssd1 vccd1 vccd1 sky130_fd_sc_hd__fill_2
XFILLER_77_346 vssd1 vssd1 vccd1 vccd1 sky130_fd_sc_hd__fill_8
XFILLER_89_184 vssd1 vssd1 vccd1 vccd1 sky130_fd_sc_hd__fill_1
XFILLER_45_254 vssd1 vssd1 vccd1 vccd1 sky130_fd_sc_hd__fill_2
XFILLER_45_276 vssd1 vssd1 vccd1 vccd1 sky130_fd_sc_hd__fill_4
XTAP_TAPCELL_ROW_82_1019 vssd1 vccd1 sky130_fd_sc_hd__tapvpwrvgnd_1
XTAP_TAPCELL_ROW_56_761 vssd1 vccd1 sky130_fd_sc_hd__tapvpwrvgnd_1
XFILLER_26_70 vssd1 vssd1 vccd1 vccd1 sky130_fd_sc_hd__fill_1
XTAP_TAPCELL_ROW_28_485 vssd1 vccd1 sky130_fd_sc_hd__tapvpwrvgnd_1
XFILLER_60_279 vssd1 vssd1 vccd1 vccd1 sky130_fd_sc_hd__fill_1
XANTENNA__7715__B2 _7714_/A vssd1 vssd1 vccd1 vccd1 sky130_fd_sc_hd__diode_2
XFILLER_41_482 vssd1 vssd1 vccd1 vccd1 sky130_fd_sc_hd__fill_1
XFILLER_41_493 vssd1 vssd1 vccd1 vccd1 sky130_fd_sc_hd__fill_8
XFILLER_9_111 vssd1 vssd1 vccd1 vccd1 sky130_fd_sc_hd__fill_1
XANTENNA__5545__A _8215_/A vssd1 vssd1 vccd1 vccd1 sky130_fd_sc_hd__diode_2
XFILLER_5_350 vssd1 vssd1 vccd1 vccd1 sky130_fd_sc_hd__fill_1
X_4200_ _6611_/A vssd1 vssd1 vccd1 vccd1 _8406_/D sky130_fd_sc_hd__inv_2
XFILLER_3_30 vssd1 vssd1 vccd1 vccd1 sky130_fd_sc_hd__fill_1
X_5180_ _5181_/B _5181_/A vssd1 vssd1 vccd1 vccd1 _5756_/A sky130_fd_sc_hd__and2b_2
XFILLER_3_41 vssd1 vssd1 vccd1 vccd1 sky130_fd_sc_hd__fill_2
XFILLER_68_324 vssd1 vssd1 vccd1 vccd1 sky130_fd_sc_hd__fill_1
XANTENNA__5257__A2 _5267_/B vssd1 vssd1 vccd1 vccd1 sky130_fd_sc_hd__diode_2
XANTENNA__6206__A1 _6207_/A vssd1 vssd1 vccd1 vccd1 sky130_fd_sc_hd__diode_2
X_7821_ _7686_/B _7947_/A _7819_/X vssd1 vssd1 vccd1 vccd1 _7822_/C sky130_fd_sc_hd__o21ai_2
XANTENNA__4183__X _4183_/X vssd1 vssd1 vccd1 vccd1 sky130_fd_sc_hd__diode_2
XFILLER_36_298 vssd1 vssd1 vccd1 vccd1 sky130_fd_sc_hd__fill_1
XFILLER_51_246 vssd1 vssd1 vccd1 vccd1 sky130_fd_sc_hd__fill_1
X_7752_ _7752_/A _7752_/B vssd1 vssd1 vccd1 vccd1 _7762_/A sky130_fd_sc_hd__xnor2_2
X_4964_ _8408_/D _5092_/A _5128_/C vssd1 vssd1 vccd1 vccd1 _4967_/A sky130_fd_sc_hd__and3_2
X_6703_ _8436_/D _6703_/B vssd1 vssd1 vccd1 vccd1 _6705_/A sky130_fd_sc_hd__nand2_2
X_7683_ _7966_/A _7954_/B vssd1 vssd1 vccd1 vccd1 _7684_/B sky130_fd_sc_hd__nor2_2
X_4895_ _5747_/A _4895_/B _4895_/C vssd1 vssd1 vccd1 vccd1 _5017_/A sky130_fd_sc_hd__nand3_2
X_6634_ _6635_/B _6635_/A vssd1 vssd1 vccd1 vccd1 _6634_/Y sky130_fd_sc_hd__nand2b_2
X_6565_ _6343_/A _6343_/B _6344_/Y vssd1 vssd1 vccd1 vccd1 _6677_/A sky130_fd_sc_hd__a21bo_2
XFILLER_3_309 vssd1 vssd1 vccd1 vccd1 sky130_fd_sc_hd__fill_1
X_8304_ _4144_/Y _8438_/D _8165_/B vssd1 vssd1 vccd1 vccd1 _8379_/D sky130_fd_sc_hd__a21bo_2
X_6496_ _6496_/A _6496_/B vssd1 vssd1 vccd1 vccd1 _6497_/B sky130_fd_sc_hd__or2_2
X_5516_ _5516_/A _5516_/B vssd1 vssd1 vccd1 vccd1 _5551_/A sky130_fd_sc_hd__nand2_2
X_8235_ _8235_/A _8235_/B vssd1 vssd1 vccd1 vccd1 _8236_/B sky130_fd_sc_hd__nor2_2
X_5447_ _5448_/A _5460_/A vssd1 vssd1 vccd1 vccd1 _5453_/B sky130_fd_sc_hd__or2_2
X_8166_ _8168_/A _8168_/B vssd1 vssd1 vccd1 vccd1 _8170_/A sky130_fd_sc_hd__and2_2
X_5378_ _5370_/A _5369_/B _5369_/A vssd1 vssd1 vccd1 vccd1 _5380_/C sky130_fd_sc_hd__o21ba_2
XANTENNA__5902__B _5902_/B vssd1 vssd1 vccd1 vccd1 sky130_fd_sc_hd__diode_2
XANTENNA_fanout291_X _7875_/D vssd1 vssd1 vccd1 vccd1 sky130_fd_sc_hd__diode_2
XFILLER_59_335 vssd1 vssd1 vccd1 vccd1 sky130_fd_sc_hd__fill_1
XFILLER_86_132 vssd1 vssd1 vccd1 vccd1 sky130_fd_sc_hd__fill_1
X_8097_ _7990_/A _8361_/Q _7991_/A _7987_/X vssd1 vssd1 vccd1 vccd1 _8152_/A sky130_fd_sc_hd__a31o_2
Xfanout123 _4203_/Y vssd1 vssd1 vccd1 vccd1 _8416_/D sky130_fd_sc_hd__clkdlybuf4s25_1
Xfanout134 _8424_/D vssd1 vssd1 vccd1 vccd1 _5020_/A sky130_fd_sc_hd__clkdlybuf4s25_1
Xfanout145 _4147_/Y vssd1 vssd1 vccd1 vccd1 _8413_/D sky130_fd_sc_hd__clkdlybuf4s25_1
Xfanout156 _7103_/A vssd1 vssd1 vccd1 vccd1 _5983_/A sky130_fd_sc_hd__clkdlybuf4s25_1
X_7117_ _7039_/A _7117_/B vssd1 vssd1 vccd1 vccd1 _7117_/Y sky130_fd_sc_hd__nand2b_2
X_4329_ _8425_/D _5147_/B _4432_/B _5020_/A vssd1 vssd1 vccd1 vccd1 _4329_/X sky130_fd_sc_hd__a22o_2
XFILLER_86_154 vssd1 vssd1 vccd1 vccd1 sky130_fd_sc_hd__fill_8
Xfanout178 _4762_/A vssd1 vssd1 vccd1 vccd1 _4557_/A sky130_fd_sc_hd__buf_6
Xfanout189 _8405_/Q vssd1 vssd1 vccd1 vccd1 _8396_/D sky130_fd_sc_hd__clkdlybuf4s25_1
X_7048_ _7034_/A _7034_/B _7032_/Y vssd1 vssd1 vccd1 vccd1 _7116_/A sky130_fd_sc_hd__a21o_2
XFILLER_27_232 vssd1 vssd1 vccd1 vccd1 sky130_fd_sc_hd__fill_1
XFILLER_82_371 vssd1 vssd1 vccd1 vccd1 sky130_fd_sc_hd__fill_2
XANTENNA__4759__A1 _4762_/A vssd1 vssd1 vccd1 vccd1 sky130_fd_sc_hd__diode_2
XTAP_TAPCELL_ROW_53_731 vssd1 vccd1 sky130_fd_sc_hd__tapvpwrvgnd_1
XFILLER_30_419 vssd1 vssd1 vccd1 vccd1 sky130_fd_sc_hd__fill_1
XFILLER_42_279 vssd1 vssd1 vccd1 vccd1 sky130_fd_sc_hd__fill_1
XTAP_TAPCELL_ROW_25_455 vssd1 vccd1 sky130_fd_sc_hd__tapvpwrvgnd_1
XFILLER_12_83 vssd1 vssd1 vccd1 vccd1 sky130_fd_sc_hd__fill_1
XANTENNA__4709__A _4709_/A vssd1 vssd1 vccd1 vccd1 sky130_fd_sc_hd__diode_2
XFILLER_77_110 vssd1 vssd1 vccd1 vccd1 sky130_fd_sc_hd__fill_2
XANTENNA__6436__A1 _6435_/A vssd1 vssd1 vccd1 vccd1 sky130_fd_sc_hd__diode_2
XANTENNA__6436__B2 _8103_/B vssd1 vssd1 vccd1 vccd1 sky130_fd_sc_hd__diode_2
XFILLER_18_210 vssd1 vssd1 vccd1 vccd1 sky130_fd_sc_hd__fill_2
XFILLER_92_113 vssd1 vssd1 vccd1 vccd1 sky130_fd_sc_hd__fill_2
XANTENNA__4998__A1 _6091_/A vssd1 vssd1 vccd1 vccd1 sky130_fd_sc_hd__diode_2
XFILLER_92_146 vssd1 vssd1 vccd1 vccd1 sky130_fd_sc_hd__fill_8
XANTENNA__6643__B _7326_/B vssd1 vssd1 vccd1 vccd1 sky130_fd_sc_hd__diode_2
XFILLER_18_265 vssd1 vssd1 vccd1 vccd1 sky130_fd_sc_hd__fill_1
XFILLER_80_319 vssd1 vssd1 vccd1 vccd1 sky130_fd_sc_hd__fill_1
XFILLER_73_393 vssd1 vssd1 vccd1 vccd1 sky130_fd_sc_hd__fill_1
X_4680_ _4680_/A _4680_/B vssd1 vssd1 vccd1 vccd1 _4682_/B sky130_fd_sc_hd__nand2_2
X_6350_ _7958_/A _7007_/B vssd1 vssd1 vccd1 vccd1 _6351_/B sky130_fd_sc_hd__or2_2
X_5301_ _5301_/A _5301_/B vssd1 vssd1 vccd1 vccd1 _5301_/Y sky130_fd_sc_hd__nor2_2
X_6281_ _6080_/A _6080_/B _6077_/Y vssd1 vssd1 vccd1 vccd1 _6282_/B sky130_fd_sc_hd__o21ai_2
XANTENNA__6818__B _7140_/C vssd1 vssd1 vccd1 vccd1 sky130_fd_sc_hd__diode_2
X_8020_ _8021_/A _8021_/B vssd1 vssd1 vccd1 vccd1 _8022_/A sky130_fd_sc_hd__and2_2
X_5232_ _5230_/A _5230_/B _5231_/X vssd1 vssd1 vccd1 vccd1 _5234_/B sky130_fd_sc_hd__a21oi_2
XFILLER_68_110 vssd1 vssd1 vccd1 vccd1 sky130_fd_sc_hd__fill_1
X_5163_ _5163_/A _5163_/B _5163_/C vssd1 vssd1 vccd1 vccd1 _5164_/B sky130_fd_sc_hd__and3_2
XANTENNA__4338__B _5703_/B vssd1 vssd1 vccd1 vccd1 sky130_fd_sc_hd__diode_2
XFILLER_83_102 vssd1 vssd1 vccd1 vccd1 sky130_fd_sc_hd__fill_2
XFILLER_83_113 vssd1 vssd1 vccd1 vccd1 sky130_fd_sc_hd__fill_4
X_5094_ _5095_/B vssd1 vssd1 vccd1 vccd1 _5094_/Y sky130_fd_sc_hd__inv_2
XTAP_TAPCELL_ROW_67_867 vssd1 vccd1 sky130_fd_sc_hd__tapvpwrvgnd_1
XANTENNA__4354__A _4919_/A vssd1 vssd1 vccd1 vccd1 sky130_fd_sc_hd__diode_2
X_7804_ _7616_/A _7807_/A _7670_/A vssd1 vssd1 vccd1 vccd1 _7812_/A sky130_fd_sc_hd__a21bo_2
X_5996_ _5997_/A _5997_/B vssd1 vssd1 vccd1 vccd1 _5996_/Y sky130_fd_sc_hd__nand2_2
XANTENNA__7665__A _7969_/A vssd1 vssd1 vccd1 vccd1 sky130_fd_sc_hd__diode_2
X_7735_ _8016_/A _7864_/B _7875_/C _7875_/B vssd1 vssd1 vccd1 vccd1 _7736_/B sky130_fd_sc_hd__a22oi_2
X_4947_ _4947_/A _4947_/B vssd1 vssd1 vccd1 vccd1 _4949_/A sky130_fd_sc_hd__xnor2_2
XTAP_TAPCELL_ROW_50_701 vssd1 vccd1 sky130_fd_sc_hd__tapvpwrvgnd_1
XTAP_TAPCELL_ROW_22_425 vssd1 vccd1 sky130_fd_sc_hd__tapvpwrvgnd_1
X_7666_ _7969_/A _7806_/B _7966_/B _7808_/A vssd1 vssd1 vccd1 vccd1 _7666_/X sky130_fd_sc_hd__o22a_2
X_4878_ _4804_/X _4807_/Y _4876_/Y _4877_/X vssd1 vssd1 vccd1 vccd1 _4878_/Y sky130_fd_sc_hd__a211oi_2
X_6617_ _6617_/A _6617_/B vssd1 vssd1 vccd1 vccd1 _6620_/A sky130_fd_sc_hd__xnor2_2
XANTENNA_fanout304_X _8241_/A vssd1 vssd1 vccd1 vccd1 sky130_fd_sc_hd__diode_2
X_7597_ _7410_/A _7410_/B _7407_/Y vssd1 vssd1 vccd1 vccd1 _7608_/A sky130_fd_sc_hd__a21bo_2
XANTENNA__8104__A1 _8103_/A vssd1 vssd1 vccd1 vccd1 sky130_fd_sc_hd__diode_2
XANTENNA__8104__B2 _7754_/B vssd1 vssd1 vccd1 vccd1 sky130_fd_sc_hd__diode_2
XFILLER_3_106 vssd1 vssd1 vccd1 vccd1 sky130_fd_sc_hd__fill_4
X_6548_ _6548_/A _8264_/A _6548_/C vssd1 vssd1 vccd1 vccd1 _6869_/B sky130_fd_sc_hd__and3_2
X_6479_ _6479_/A _6479_/B vssd1 vssd1 vccd1 vccd1 _6480_/C sky130_fd_sc_hd__nor2_2
X_8218_ _8215_/A _8217_/Y _8313_/S vssd1 vssd1 vccd1 vccd1 _8344_/D sky130_fd_sc_hd__mux2_1
XANTENNA__7550__D _7897_/B vssd1 vssd1 vccd1 vccd1 sky130_fd_sc_hd__diode_2
XFILLER_58_24 vssd1 vssd1 vccd1 vccd1 sky130_fd_sc_hd__fill_1
X_8149_ _8149_/A _8149_/B vssd1 vssd1 vccd1 vccd1 _8150_/B sky130_fd_sc_hd__xnor2_2
XFILLER_43_500 vssd1 vssd1 vccd1 vccd1 sky130_fd_sc_hd__fill_4
XFILLER_74_89 vssd1 vssd1 vccd1 vccd1 sky130_fd_sc_hd__fill_2
XTAP_TAPCELL_ROW_38_580 vssd1 vccd1 sky130_fd_sc_hd__tapvpwrvgnd_1
XPHY_EDGE_ROW_4_Left_97 vssd1 vssd1 vccd1 vccd1 sky130_fd_sc_hd__decap_3
XFILLER_23_290 vssd1 vssd1 vccd1 vccd1 sky130_fd_sc_hd__fill_1
XFILLER_30_249 vssd1 vssd1 vccd1 vccd1 sky130_fd_sc_hd__fill_1
XFILLER_7_467 vssd1 vssd1 vccd1 vccd1 sky130_fd_sc_hd__fill_4
Xwire387 wire387/A vssd1 vssd1 vccd1 vccd1 wire387/X sky130_fd_sc_hd__buf_6
XANTENNA__5823__A _6016_/A vssd1 vssd1 vccd1 vccd1 sky130_fd_sc_hd__diode_2
XFILLER_31_7 vssd1 vssd1 vccd1 vccd1 sky130_fd_sc_hd__fill_2
XANTENNA__5632__A2 _5669_/B vssd1 vssd1 vccd1 vccd1 sky130_fd_sc_hd__diode_2
XFILLER_19_552 vssd1 vssd1 vccd1 vccd1 sky130_fd_sc_hd__fill_8
XANTENNA__4160__A_N _8191_/B vssd1 vssd1 vccd1 vccd1 sky130_fd_sc_hd__diode_2
XANTENNA__6804__D _7426_/A vssd1 vssd1 vccd1 vccd1 sky130_fd_sc_hd__diode_2
XFILLER_34_522 vssd1 vssd1 vccd1 vccd1 sky130_fd_sc_hd__fill_2
XFILLER_80_127 vssd1 vssd1 vccd1 vccd1 sky130_fd_sc_hd__fill_2
XTAP_TAPCELL_ROW_64_837 vssd1 vccd1 sky130_fd_sc_hd__tapvpwrvgnd_1
X_5850_ _5851_/A _5851_/B vssd1 vssd1 vccd1 vccd1 _5852_/A sky130_fd_sc_hd__and2_2
X_5781_ _8413_/D _5899_/B vssd1 vssd1 vccd1 vccd1 _5900_/A sky130_fd_sc_hd__nand2_2
X_4801_ _4802_/A _4802_/B vssd1 vssd1 vccd1 vccd1 _4801_/X sky130_fd_sc_hd__and2_2
X_7520_ _7428_/B _7430_/B _7428_/A vssd1 vssd1 vccd1 vccd1 _7522_/B sky130_fd_sc_hd__o21ba_2
X_4732_ _8410_/D _7326_/B vssd1 vssd1 vccd1 vccd1 _5047_/A sky130_fd_sc_hd__nand2_2
Xrebuffer509 _4591_/B vssd1 vssd1 vccd1 vccd1 _4571_/A2 sky130_fd_sc_hd__buf_2
X_7451_ _7452_/A _7452_/B vssd1 vssd1 vccd1 vccd1 _7566_/A sky130_fd_sc_hd__nand2b_2
X_4663_ _4661_/B _4661_/A _4662_/X vssd1 vssd1 vccd1 vccd1 _4663_/X sky130_fd_sc_hd__o21ba_2
X_6402_ _6499_/A _6402_/B vssd1 vssd1 vccd1 vccd1 _6409_/A sky130_fd_sc_hd__and2_2
X_7382_ _7382_/A _7382_/B vssd1 vssd1 vccd1 vccd1 _7394_/A sky130_fd_sc_hd__nand2_2
X_4594_ _4623_/A _4709_/C vssd1 vssd1 vccd1 vccd1 _4648_/B sky130_fd_sc_hd__nand2_2
XANTENNA_clkbuf_4_6_0_clk_A clkbuf_0_clk/X vssd1 vssd1 vccd1 vccd1 sky130_fd_sc_hd__diode_2
X_6333_ _7095_/B _7095_/C vssd1 vssd1 vccd1 vccd1 _7806_/B sky130_fd_sc_hd__nand2_4
XFILLER_88_205 vssd1 vssd1 vccd1 vccd1 sky130_fd_sc_hd__fill_2
X_6264_ _6264_/A _6264_/B _6264_/C vssd1 vssd1 vccd1 vccd1 _6265_/A sky130_fd_sc_hd__nor3_2
XANTENNA__6548__B _8264_/A vssd1 vssd1 vccd1 vccd1 sky130_fd_sc_hd__diode_2
X_8003_ _8001_/A _7897_/B _7897_/D _7895_/X vssd1 vssd1 vccd1 vccd1 _8004_/B sky130_fd_sc_hd__a31o_2
X_5215_ _8411_/D _5254_/B _5215_/C vssd1 vssd1 vccd1 vccd1 _5218_/A sky130_fd_sc_hd__nand3_2
XANTENNA__4349__A _4761_/A vssd1 vssd1 vccd1 vccd1 sky130_fd_sc_hd__diode_2
XANTENNA_fanout299_A _7725_/B vssd1 vssd1 vccd1 vccd1 sky130_fd_sc_hd__diode_2
XFILLER_69_430 vssd1 vssd1 vccd1 vccd1 sky130_fd_sc_hd__fill_1
Xclkbuf_4_15_0_clk clkbuf_0_clk/X vssd1 vssd1 vccd1 vccd1 _8361_/CLK sky130_fd_sc_hd__clkbuf_8
X_6195_ _6196_/A _6196_/B vssd1 vssd1 vccd1 vccd1 _6195_/X sky130_fd_sc_hd__and2b_2
X_5146_ _4989_/A _4989_/B _4990_/S vssd1 vssd1 vccd1 vccd1 _5153_/A sky130_fd_sc_hd__o21ba_2
X_5077_ _8409_/D _5780_/B _5046_/A vssd1 vssd1 vccd1 vccd1 _5077_/X sky130_fd_sc_hd__a21bo_2
XFILLER_56_168 vssd1 vssd1 vccd1 vccd1 sky130_fd_sc_hd__fill_1
XFILLER_25_522 vssd1 vssd1 vccd1 vccd1 sky130_fd_sc_hd__fill_4
XANTENNA__7098__C _7299_/C vssd1 vssd1 vccd1 vccd1 sky130_fd_sc_hd__diode_2
XANTENNA_fanout254_X _8001_/A vssd1 vssd1 vccd1 vccd1 sky130_fd_sc_hd__diode_2
XFILLER_40_503 vssd1 vssd1 vccd1 vccd1 sky130_fd_sc_hd__fill_2
X_5979_ _6139_/A _5979_/B _5979_/C vssd1 vssd1 vccd1 vccd1 _6337_/B sky130_fd_sc_hd__or3_4
XTAP_TAPCELL_ROW_35_550 vssd1 vccd1 sky130_fd_sc_hd__tapvpwrvgnd_1
XFILLER_12_238 vssd1 vssd1 vccd1 vccd1 sky130_fd_sc_hd__fill_1
X_7718_ _7718_/A _7718_/B vssd1 vssd1 vccd1 vccd1 _7721_/A sky130_fd_sc_hd__xnor2_2
XANTENNA__7128__A2 _7515_/A vssd1 vssd1 vccd1 vccd1 sky130_fd_sc_hd__diode_2
XFILLER_20_282 vssd1 vssd1 vccd1 vccd1 sky130_fd_sc_hd__fill_1
X_7649_ _7649_/A _7649_/B _7649_/C vssd1 vssd1 vccd1 vccd1 _7649_/Y sky130_fd_sc_hd__nor3_2
XTAP_TAPCELL_ROW_7_275 vssd1 vccd1 sky130_fd_sc_hd__tapvpwrvgnd_1
XFILLER_16_533 vssd1 vssd1 vccd1 vccd1 sky130_fd_sc_hd__fill_4
XTAP_TAPCELL_ROW_61_807 vssd1 vccd1 sky130_fd_sc_hd__tapvpwrvgnd_1
XANTENNA__5818__A _6006_/A vssd1 vssd1 vccd1 vccd1 sky130_fd_sc_hd__diode_2
XFILLER_70_182 vssd1 vssd1 vccd1 vccd1 sky130_fd_sc_hd__fill_1
XFILLER_70_193 vssd1 vssd1 vccd1 vccd1 sky130_fd_sc_hd__fill_2
XANTENNA__8316__A1 input7/X vssd1 vssd1 vccd1 vccd1 sky130_fd_sc_hd__diode_2
XANTENNA__5550__A1 _8215_/A vssd1 vssd1 vccd1 vccd1 sky130_fd_sc_hd__diode_2
Xload_slew112 fanout111/X vssd1 vssd1 vccd1 vccd1 _4972_/B sky130_fd_sc_hd__clkbuf_4
Xload_slew101 _4430_/B vssd1 vssd1 vccd1 vccd1 _4919_/B sky130_fd_sc_hd__clkbuf_4
XANTENNA__4169__A _4674_/A vssd1 vssd1 vccd1 vccd1 sky130_fd_sc_hd__diode_2
X_5000_ _5928_/A _5149_/B vssd1 vssd1 vccd1 vccd1 _5001_/B sky130_fd_sc_hd__nand2_2
XFILLER_22_3 vssd1 vssd1 vccd1 vccd1 sky130_fd_sc_hd__fill_2
XFILLER_78_260 vssd1 vssd1 vccd1 vccd1 sky130_fd_sc_hd__fill_1
XANTENNA__6815__C _6894_/B vssd1 vssd1 vccd1 vccd1 sky130_fd_sc_hd__diode_2
XFILLER_66_477 vssd1 vssd1 vccd1 vccd1 sky130_fd_sc_hd__fill_4
XTAP_TAPCELL_ROW_77_973 vssd1 vccd1 sky130_fd_sc_hd__tapvpwrvgnd_1
X_6951_ _6950_/A _6950_/B _6950_/C vssd1 vssd1 vccd1 vccd1 _6952_/B sky130_fd_sc_hd__a21oi_2
XTAP_TAPCELL_ROW_49_686 vssd1 vccd1 sky130_fd_sc_hd__tapvpwrvgnd_1
XFILLER_81_458 vssd1 vssd1 vccd1 vccd1 sky130_fd_sc_hd__fill_1
X_6882_ _6689_/A hold540/X _6881_/X vssd1 vssd1 vccd1 vccd1 _8325_/D sky130_fd_sc_hd__a21o_2
X_5902_ _8412_/D _5902_/B vssd1 vssd1 vccd1 vccd1 _5903_/B sky130_fd_sc_hd__nand2_2
XFILLER_61_171 vssd1 vssd1 vccd1 vccd1 sky130_fd_sc_hd__fill_4
X_5833_ _5834_/A _5834_/B vssd1 vssd1 vccd1 vccd1 _6027_/A sky130_fd_sc_hd__and2_2
XANTENNA__4632__A _8422_/D vssd1 vssd1 vccd1 vccd1 sky130_fd_sc_hd__diode_2
XANTENNA__6030__A2 _8228_/A vssd1 vssd1 vccd1 vccd1 sky130_fd_sc_hd__diode_2
XFILLER_22_558 vssd1 vssd1 vccd1 vccd1 sky130_fd_sc_hd__fill_2
XFILLER_22_569 vssd1 vssd1 vccd1 vccd1 sky130_fd_sc_hd__fill_1
XTAP_TAPCELL_ROW_32_520 vssd1 vccd1 sky130_fd_sc_hd__tapvpwrvgnd_1
XANTENNA__8307__A1 _8179_/B vssd1 vssd1 vccd1 vccd1 sky130_fd_sc_hd__diode_2
X_7503_ _7503_/A _7503_/B _7503_/C vssd1 vssd1 vccd1 vccd1 _7504_/B sky130_fd_sc_hd__nor3_2
X_5764_ _6611_/A _7080_/B vssd1 vssd1 vccd1 vccd1 _5770_/A sky130_fd_sc_hd__nor2_2
XANTENNA__4592__A2 _4686_/B vssd1 vssd1 vccd1 vccd1 sky130_fd_sc_hd__diode_2
X_5695_ _5201_/A1 _5695_/B vssd1 vssd1 vccd1 vccd1 _5809_/A sky130_fd_sc_hd__nand2b_2
X_4715_ _4708_/Y _4712_/Y _4713_/Y _4714_/X vssd1 vssd1 vccd1 vccd1 _4715_/X sky130_fd_sc_hd__o211a_2
X_7434_ _7219_/A _7853_/A _8030_/A _8131_/B vssd1 vssd1 vccd1 vccd1 _7436_/A sky130_fd_sc_hd__a22oi_2
X_4646_ _4646_/A _4709_/D vssd1 vssd1 vccd1 vccd1 _4669_/B sky130_fd_sc_hd__nand2_8
X_7365_ _7051_/B _7328_/Y _7326_/Y vssd1 vssd1 vccd1 vccd1 _7365_/X sky130_fd_sc_hd__a21o_2
X_4577_ _4578_/A _4578_/B vssd1 vssd1 vccd1 vccd1 _4577_/Y sky130_fd_sc_hd__nand2_2
X_6316_ _6123_/A _6123_/B _6121_/X vssd1 vssd1 vccd1 vccd1 _6318_/B sky130_fd_sc_hd__a21oi_2
X_7296_ _7668_/A _7296_/B vssd1 vssd1 vccd1 vccd1 _7298_/B sky130_fd_sc_hd__nor2_2
XFILLER_39_37 vssd1 vssd1 vccd1 vccd1 sky130_fd_sc_hd__fill_1
XFILLER_89_569 vssd1 vssd1 vccd1 vccd1 sky130_fd_sc_hd__fill_1
X_6247_ _6248_/A _6248_/B _6248_/C vssd1 vssd1 vccd1 vccd1 _6458_/A sky130_fd_sc_hd__a21o_2
X_6178_ _6367_/A _6178_/B vssd1 vssd1 vccd1 vccd1 _6180_/B sky130_fd_sc_hd__nand2_2
XANTENNA__4366__X _4366_/X vssd1 vssd1 vccd1 vccd1 sky130_fd_sc_hd__diode_2
X_5129_ _6970_/A _5128_/C _5915_/B _6724_/A vssd1 vssd1 vccd1 vccd1 _5129_/X sky130_fd_sc_hd__a22o_2
XTAP_TAPCELL_ROW_4_245 vssd1 vccd1 sky130_fd_sc_hd__tapvpwrvgnd_1
XANTENNA__6725__C _7095_/C vssd1 vssd1 vccd1 vccd1 sky130_fd_sc_hd__diode_2
XFILLER_44_105 vssd1 vssd1 vccd1 vccd1 sky130_fd_sc_hd__fill_1
XFILLER_44_127 vssd1 vssd1 vccd1 vccd1 sky130_fd_sc_hd__fill_2
XFILLER_13_503 vssd1 vssd1 vccd1 vccd1 sky130_fd_sc_hd__fill_1
XFILLER_13_536 vssd1 vssd1 vccd1 vccd1 sky130_fd_sc_hd__fill_1
XFILLER_71_35 vssd1 vssd1 vccd1 vccd1 sky130_fd_sc_hd__fill_1
XFILLER_71_57 vssd1 vssd1 vccd1 vccd1 sky130_fd_sc_hd__fill_2
XFILLER_75_252 vssd1 vssd1 vccd1 vccd1 sky130_fd_sc_hd__fill_1
XFILLER_35_127 vssd1 vssd1 vccd1 vccd1 sky130_fd_sc_hd__fill_2
XFILLER_90_200 vssd1 vssd1 vccd1 vccd1 sky130_fd_sc_hd__fill_8
XFILLER_90_222 vssd1 vssd1 vccd1 vccd1 sky130_fd_sc_hd__fill_1
XTAP_TAPCELL_ROW_74_943 vssd1 vccd1 sky130_fd_sc_hd__tapvpwrvgnd_1
XTAP_TAPCELL_ROW_46_656 vssd1 vccd1 sky130_fd_sc_hd__tapvpwrvgnd_1
XANTENNA__5267__B _5267_/B vssd1 vssd1 vccd1 vccd1 sky130_fd_sc_hd__diode_2
X_5480_ _5487_/B _5479_/Y _5569_/A _5612_/B vssd1 vssd1 vccd1 vccd1 _5520_/A sky130_fd_sc_hd__and4bb_2
X_4500_ _4500_/A _4500_/B vssd1 vssd1 vccd1 vccd1 _4502_/C sky130_fd_sc_hd__xnor2_2
X_4431_ _4433_/A _4433_/B vssd1 vssd1 vccd1 vccd1 _4431_/Y sky130_fd_sc_hd__nor2_2
XFILLER_6_85 vssd1 vssd1 vccd1 vccd1 sky130_fd_sc_hd__fill_1
XANTENNA__8367__Q _8367_/Q vssd1 vssd1 vccd1 vccd1 sky130_fd_sc_hd__diode_2
XANTENNA_rebuffer464_A _4183_/X vssd1 vssd1 vccd1 vccd1 sky130_fd_sc_hd__diode_2
X_7150_ _7242_/A _7149_/B _7149_/C vssd1 vssd1 vccd1 vccd1 _7151_/B sky130_fd_sc_hd__a21o_2
X_4362_ _4362_/A _4362_/B vssd1 vssd1 vccd1 vccd1 _4362_/Y sky130_fd_sc_hd__xnor2_2
X_7081_ _7969_/A _7081_/B vssd1 vssd1 vccd1 vccd1 _7082_/B sky130_fd_sc_hd__nor2_2
X_6101_ _6101_/A vssd1 vssd1 vccd1 vccd1 _6104_/A sky130_fd_sc_hd__inv_2
X_4293_ _4292_/A _4292_/B _4292_/C vssd1 vssd1 vccd1 vccd1 _5163_/C sky130_fd_sc_hd__a21o_2
X_6032_ _6032_/A _6032_/B vssd1 vssd1 vccd1 vccd1 _6034_/A sky130_fd_sc_hd__nor2_2
XANTENNA__8225__A0 _8220_/A vssd1 vssd1 vccd1 vccd1 sky130_fd_sc_hd__diode_2
XTAP_TAPCELL_ROW_1_215 vssd1 vccd1 sky130_fd_sc_hd__tapvpwrvgnd_1
XFILLER_81_222 vssd1 vssd1 vccd1 vccd1 sky130_fd_sc_hd__fill_2
X_7983_ _7981_/Y _7983_/B vssd1 vssd1 vccd1 vccd1 _7984_/A sky130_fd_sc_hd__and2b_2
XANTENNA_fanout164_A _4821_/A vssd1 vssd1 vccd1 vccd1 sky130_fd_sc_hd__diode_2
XFILLER_81_233 vssd1 vssd1 vccd1 vccd1 sky130_fd_sc_hd__fill_4
XFILLER_81_244 vssd1 vssd1 vccd1 vccd1 sky130_fd_sc_hd__fill_4
X_6934_ _6934_/A _6934_/B _6934_/C vssd1 vssd1 vccd1 vccd1 _6935_/B sky130_fd_sc_hd__nand3_2
XFILLER_34_160 vssd1 vssd1 vccd1 vccd1 sky130_fd_sc_hd__fill_1
XFILLER_62_480 vssd1 vssd1 vccd1 vccd1 sky130_fd_sc_hd__fill_1
X_6865_ _6865_/A _6865_/B vssd1 vssd1 vccd1 vccd1 _6867_/A sky130_fd_sc_hd__xnor2_2
X_6796_ _6883_/A _7714_/C _6795_/D _6795_/A vssd1 vssd1 vccd1 vccd1 _6797_/B sky130_fd_sc_hd__a22oi_2
X_5816_ _6207_/A _6001_/A _6005_/B _6482_/A vssd1 vssd1 vccd1 vccd1 _5817_/B sky130_fd_sc_hd__and4_2
XANTENNA_wire77_A wire77/A vssd1 vssd1 vccd1 vccd1 sky130_fd_sc_hd__diode_2
X_5747_ _5747_/A _6712_/B vssd1 vssd1 vccd1 vccd1 _5748_/B sky130_fd_sc_hd__nand2_2
XANTENNA_fanout217_X _6207_/A vssd1 vssd1 vccd1 vccd1 sky130_fd_sc_hd__diode_2
X_7417_ _7417_/A _7417_/B vssd1 vssd1 vccd1 vccd1 _7419_/B sky130_fd_sc_hd__xor2_2
X_5678_ _6035_/C _5594_/B _5598_/B _5596_/X vssd1 vssd1 vccd1 vccd1 _5684_/A sky130_fd_sc_hd__a31oi_2
X_8397_ clkload9/A _8397_/D load_slew373/X vssd1 vssd1 vccd1 vccd1 _8397_/Q sky130_fd_sc_hd__dfrtp_2
X_4629_ _4709_/A _4629_/B vssd1 vssd1 vccd1 vccd1 _4631_/B sky130_fd_sc_hd__nand2_2
XFILLER_89_300 vssd1 vssd1 vccd1 vccd1 sky130_fd_sc_hd__fill_1
Xhold551 _8431_/Q vssd1 vssd1 vccd1 vccd1 hold551/X sky130_fd_sc_hd__dlygate4sd3_1
Xhold540 _8325_/Q vssd1 vssd1 vccd1 vccd1 hold540/X sky130_fd_sc_hd__dlygate4sd3_1
X_7348_ _7349_/A _7349_/B vssd1 vssd1 vccd1 vccd1 _7348_/Y sky130_fd_sc_hd__nor2_2
X_7279_ _7279_/A _7279_/B vssd1 vssd1 vccd1 vccd1 _7281_/C sky130_fd_sc_hd__or2_2
XANTENNA__6490__A2 _6798_/B vssd1 vssd1 vccd1 vccd1 sky130_fd_sc_hd__diode_2
Xteam_03_389 vssd1 vssd1 vccd1 vccd1 team_03_389/HI gpio_oeb[20] sky130_fd_sc_hd__conb_1
XFILLER_17_138 vssd1 vssd1 vccd1 vccd1 sky130_fd_sc_hd__fill_1
XFILLER_25_160 vssd1 vssd1 vccd1 vccd1 sky130_fd_sc_hd__fill_8
XTAP_TAPCELL_ROW_71_913 vssd1 vccd1 sky130_fd_sc_hd__tapvpwrvgnd_1
XTAP_TAPCELL_ROW_43_626 vssd1 vccd1 sky130_fd_sc_hd__tapvpwrvgnd_1
XFILLER_82_67 vssd1 vssd1 vccd1 vccd1 sky130_fd_sc_hd__fill_2
XANTENNA_clkbuf_4_14_0_clk_A clkbuf_0_clk/X vssd1 vssd1 vccd1 vccd1 sky130_fd_sc_hd__diode_2
XFILLER_63_211 vssd1 vssd1 vccd1 vccd1 sky130_fd_sc_hd__fill_1
XTAP_TAPCELL_ROW_59_792 vssd1 vccd1 sky130_fd_sc_hd__tapvpwrvgnd_1
XANTENNA__6233__A2 _8233_/A vssd1 vssd1 vccd1 vccd1 sky130_fd_sc_hd__diode_2
XFILLER_51_417 vssd1 vssd1 vccd1 vccd1 sky130_fd_sc_hd__fill_1
X_4980_ _5155_/A _5953_/B _5711_/A vssd1 vssd1 vccd1 vccd1 _4980_/X sky130_fd_sc_hd__and3_2
X_6650_ _6650_/A _6739_/A vssd1 vssd1 vccd1 vccd1 _6743_/A sky130_fd_sc_hd__nor2_2
X_6581_ _8435_/D _6582_/B vssd1 vssd1 vccd1 vccd1 _6708_/B sky130_fd_sc_hd__nand2_2
X_5601_ _5601_/A _5601_/B vssd1 vssd1 vccd1 vccd1 _5602_/B sky130_fd_sc_hd__or2_2
XANTENNA__4910__A _8429_/D vssd1 vssd1 vccd1 vccd1 sky130_fd_sc_hd__diode_2
XANTENNA__5428__D _6005_/B vssd1 vssd1 vccd1 vccd1 sky130_fd_sc_hd__diode_2
X_8320_ _8402_/CLK _8320_/D wire377/X vssd1 vssd1 vccd1 vccd1 _8320_/Q sky130_fd_sc_hd__dfrtp_2
X_5532_ _5584_/A _5584_/B vssd1 vssd1 vccd1 vccd1 _5585_/A sky130_fd_sc_hd__nand2_2
X_8251_ _8246_/A _8250_/Y _8259_/A vssd1 vssd1 vccd1 vccd1 _8349_/D sky130_fd_sc_hd__mux2_1
X_5463_ _8228_/A _5669_/B _5350_/C vssd1 vssd1 vccd1 vccd1 _5464_/B sky130_fd_sc_hd__a21o_2
X_8182_ _8179_/A _4144_/Y _8180_/Y _8181_/X vssd1 vssd1 vccd1 vccd1 _8338_/D sky130_fd_sc_hd__a22o_2
X_7202_ _7290_/B _7202_/B vssd1 vssd1 vccd1 vccd1 _7203_/C sky130_fd_sc_hd__nor2_2
X_5394_ _8196_/A _5393_/B _8202_/A _5393_/D vssd1 vssd1 vccd1 vccd1 _5395_/B sky130_fd_sc_hd__a22oi_2
X_4414_ _8430_/D _4931_/C vssd1 vssd1 vccd1 vccd1 _4414_/Y sky130_fd_sc_hd__nand2_2
Xfanout305 _7140_/D vssd1 vssd1 vccd1 vccd1 _8233_/A sky130_fd_sc_hd__clkdlybuf4s25_1
X_7133_ _7134_/A _7134_/B vssd1 vssd1 vccd1 vccd1 _7227_/B sky130_fd_sc_hd__nand2_2
X_4345_ _4557_/A _4390_/A wire105/A _4341_/A vssd1 vssd1 vccd1 vccd1 _4352_/A sky130_fd_sc_hd__a31o_2
XANTENNA__6837__A _8110_/A vssd1 vssd1 vccd1 vccd1 sky130_fd_sc_hd__diode_2
Xfanout338 _6883_/A vssd1 vssd1 vccd1 vccd1 _6485_/B sky130_fd_sc_hd__clkdlybuf4s25_1
Xfanout327 _8342_/Q vssd1 vssd1 vccd1 vccd1 _6892_/C sky130_fd_sc_hd__clkdlybuf4s25_1
Xfanout316 _6035_/D vssd1 vssd1 vccd1 vccd1 _8215_/A sky130_fd_sc_hd__clkdlybuf4s25_1
Xfanout349 _5415_/B vssd1 vssd1 vccd1 vccd1 _8168_/A sky130_fd_sc_hd__clkdlybuf4s25_1
X_7064_ _7065_/A _7065_/B vssd1 vssd1 vccd1 vccd1 _7335_/B sky130_fd_sc_hd__or2_2
X_4276_ _5020_/A _5147_/B vssd1 vssd1 vccd1 vccd1 _4328_/A sky130_fd_sc_hd__nand2_2
XANTENNA__4357__A _8429_/D vssd1 vssd1 vccd1 vccd1 sky130_fd_sc_hd__diode_2
XANTENNA_fanout379_A _4226_/X vssd1 vssd1 vccd1 vccd1 sky130_fd_sc_hd__diode_2
XFILLER_67_561 vssd1 vssd1 vccd1 vccd1 sky130_fd_sc_hd__fill_1
X_6015_ _5817_/A _5819_/B _5817_/B vssd1 vssd1 vccd1 vccd1 _6022_/A sky130_fd_sc_hd__o21ba_2
XFILLER_82_520 vssd1 vssd1 vccd1 vccd1 sky130_fd_sc_hd__fill_2
XANTENNA__6572__A _6572_/A vssd1 vssd1 vccd1 vccd1 sky130_fd_sc_hd__diode_2
X_7966_ _7966_/A _7966_/B vssd1 vssd1 vccd1 vccd1 _8090_/A sky130_fd_sc_hd__nor2_2
X_7897_ _7895_/X _7897_/B _8001_/A _7897_/D vssd1 vssd1 vccd1 vccd1 _7898_/B sky130_fd_sc_hd__and4b_2
X_6917_ _7889_/A _7875_/C _7875_/D _7889_/B vssd1 vssd1 vccd1 vccd1 _6919_/A sky130_fd_sc_hd__a22oi_2
XANTENNA_fanout334_X _6798_/B vssd1 vssd1 vccd1 vccd1 sky130_fd_sc_hd__diode_2
XFILLER_22_141 vssd1 vssd1 vccd1 vccd1 sky130_fd_sc_hd__fill_2
XFILLER_52_37 vssd1 vssd1 vccd1 vccd1 sky130_fd_sc_hd__fill_2
X_6848_ _6849_/A _6849_/B _6847_/Y vssd1 vssd1 vccd1 vccd1 _6946_/B sky130_fd_sc_hd__o21bai_2
XFILLER_6_307 vssd1 vssd1 vccd1 vccd1 sky130_fd_sc_hd__fill_1
X_6779_ _7027_/A _6779_/B _6779_/C vssd1 vssd1 vccd1 vccd1 _7027_/B sky130_fd_sc_hd__nor3_2
X_8449_ clkload3/A _8449_/D fanout365/X vssd1 vssd1 vccd1 vccd1 _8449_/Q sky130_fd_sc_hd__dfrtp_2
XTAP_TAPCELL_ROW_20_397 vssd1 vccd1 sky130_fd_sc_hd__tapvpwrvgnd_1
XFILLER_77_45 vssd1 vssd1 vccd1 vccd1 sky130_fd_sc_hd__fill_2
XANTENNA__4474__A1 _4762_/A vssd1 vssd1 vccd1 vccd1 sky130_fd_sc_hd__diode_2
XANTENNA__7660__A1 _7655_/A vssd1 vssd1 vccd1 vccd1 sky130_fd_sc_hd__diode_2
XFILLER_73_531 vssd1 vssd1 vccd1 vccd1 sky130_fd_sc_hd__fill_2
XFILLER_85_391 vssd1 vssd1 vccd1 vccd1 sky130_fd_sc_hd__fill_1
XTAP_TAPCELL_ROW_56_762 vssd1 vccd1 sky130_fd_sc_hd__tapvpwrvgnd_1
XFILLER_45_288 vssd1 vssd1 vccd1 vccd1 sky130_fd_sc_hd__fill_1
XFILLER_60_225 vssd1 vssd1 vccd1 vccd1 sky130_fd_sc_hd__fill_1
XFILLER_13_130 vssd1 vssd1 vccd1 vccd1 sky130_fd_sc_hd__fill_2
XANTENNA__5826__A _5826_/A vssd1 vssd1 vccd1 vccd1 sky130_fd_sc_hd__diode_2
XANTENNA__6923__B1 _7725_/B vssd1 vssd1 vccd1 vccd1 sky130_fd_sc_hd__diode_2
XANTENNA__8429__RESET_B load_slew360/X vssd1 vssd1 vccd1 vccd1 sky130_fd_sc_hd__diode_2
XANTENNA__8202__A _8202_/A vssd1 vssd1 vccd1 vccd1 sky130_fd_sc_hd__diode_2
XPHY_EDGE_ROW_79_Left_172 vssd1 vssd1 vccd1 vccd1 sky130_fd_sc_hd__decap_3
XFILLER_49_561 vssd1 vssd1 vccd1 vccd1 sky130_fd_sc_hd__fill_1
XFILLER_64_520 vssd1 vssd1 vccd1 vccd1 sky130_fd_sc_hd__fill_1
XFILLER_64_531 vssd1 vssd1 vccd1 vccd1 sky130_fd_sc_hd__fill_1
XFILLER_64_542 vssd1 vssd1 vccd1 vccd1 sky130_fd_sc_hd__fill_1
X_7820_ _7820_/A _7820_/B vssd1 vssd1 vccd1 vccd1 _7947_/A sky130_fd_sc_hd__nand2_2
Xwire59 wire59/A vssd1 vssd1 vccd1 vccd1 wire59/X sky130_fd_sc_hd__clkbuf_4
XFILLER_51_214 vssd1 vssd1 vccd1 vccd1 sky130_fd_sc_hd__fill_2
X_7751_ _8110_/B _8277_/A vssd1 vssd1 vccd1 vccd1 _7752_/B sky130_fd_sc_hd__nand2_2
X_4963_ _4963_/A _4963_/B vssd1 vssd1 vccd1 vccd1 _6757_/B sky130_fd_sc_hd__xnor2_2
X_7682_ _7682_/A _7682_/B vssd1 vssd1 vccd1 vccd1 _7684_/A sky130_fd_sc_hd__xnor2_2
X_6702_ _8434_/D wire90/X vssd1 vssd1 vccd1 vccd1 _6706_/A sky130_fd_sc_hd__nand2_2
X_6633_ _6633_/A _6633_/B vssd1 vssd1 vccd1 vccd1 _6635_/B sky130_fd_sc_hd__xnor2_2
X_4894_ _5747_/A wire92/X vssd1 vssd1 vccd1 vccd1 _4894_/Y sky130_fd_sc_hd__nand2_2
XPHY_EDGE_ROW_88_Left_181 vssd1 vssd1 vccd1 vccd1 sky130_fd_sc_hd__decap_3
X_6564_ _6873_/B _6564_/B vssd1 vssd1 vccd1 vccd1 _6685_/A sky130_fd_sc_hd__nor2_2
X_8303_ _8136_/D _8254_/B _8303_/S vssd1 vssd1 vccd1 vccd1 _8378_/D sky130_fd_sc_hd__mux2_1
X_6495_ _6496_/A _6496_/B vssd1 vssd1 vccd1 vccd1 _6812_/B sky130_fd_sc_hd__nand2_2
X_5515_ _5505_/A _5504_/C _5504_/B vssd1 vssd1 vccd1 vccd1 _5516_/B sky130_fd_sc_hd__a21o_2
X_8234_ _8234_/A _8234_/B vssd1 vssd1 vccd1 vccd1 _8237_/A sky130_fd_sc_hd__nand2_2
X_5446_ _5446_/A _6006_/A _5446_/C vssd1 vssd1 vccd1 vccd1 _5460_/A sky130_fd_sc_hd__nand3_2
X_8165_ _8165_/A _8165_/B vssd1 vssd1 vccd1 vccd1 _8335_/D sky130_fd_sc_hd__xnor2_2
Xfanout102 _4496_/D vssd1 vssd1 vccd1 vccd1 wire103/A sky130_fd_sc_hd__clkdlybuf4s25_1
Xfanout113 _4487_/B vssd1 vssd1 vccd1 vccd1 _4707_/B sky130_fd_sc_hd__clkdlybuf4s25_1
X_5377_ _5450_/A _5450_/B _5450_/C vssd1 vssd1 vccd1 vccd1 _5451_/A sky130_fd_sc_hd__o21ai_2
X_8096_ _8057_/A _8056_/B _8056_/A vssd1 vssd1 vccd1 vccd1 _8153_/A sky130_fd_sc_hd__o21ba_2
Xfanout124 _6724_/A vssd1 vssd1 vccd1 vccd1 _8407_/D sky130_fd_sc_hd__clkdlybuf4s25_1
Xfanout135 _4169_/Y vssd1 vssd1 vccd1 vccd1 _4709_/A sky130_fd_sc_hd__buf_2
Xfanout146 _4362_/Y vssd1 vssd1 vccd1 vccd1 _4931_/C sky130_fd_sc_hd__clkdlybuf4s25_1
X_7116_ _7116_/A _7116_/B vssd1 vssd1 vccd1 vccd1 _7116_/Y sky130_fd_sc_hd__xnor2_2
X_4328_ _4328_/A _4461_/A vssd1 vssd1 vccd1 vccd1 _4464_/A sky130_fd_sc_hd__nor2_2
XANTENNA_fanout284_X _8125_/B vssd1 vssd1 vccd1 vccd1 sky130_fd_sc_hd__diode_2
XANTENNA_input1_A en vssd1 vssd1 vccd1 vccd1 sky130_fd_sc_hd__diode_2
XFILLER_74_306 vssd1 vssd1 vccd1 vccd1 sky130_fd_sc_hd__fill_2
Xfanout168 _4187_/X vssd1 vssd1 vccd1 vccd1 _6588_/A sky130_fd_sc_hd__buf_6
Xfanout179 _4159_/X vssd1 vssd1 vccd1 vccd1 _4762_/A sky130_fd_sc_hd__buf_6
X_7047_ _6689_/A hold544/X _7046_/X vssd1 vssd1 vccd1 vccd1 _8326_/D sky130_fd_sc_hd__a21o_2
X_4259_ _4252_/X _4257_/B _4258_/B vssd1 vssd1 vccd1 vccd1 _4259_/Y sky130_fd_sc_hd__o21ai_2
XFILLER_74_328 vssd1 vssd1 vccd1 vccd1 sky130_fd_sc_hd__fill_1
XANTENNA__4208__A1 _4207_/B vssd1 vssd1 vccd1 vccd1 sky130_fd_sc_hd__diode_2
XFILLER_42_236 vssd1 vssd1 vccd1 vccd1 sky130_fd_sc_hd__fill_1
X_7949_ _8082_/A _8082_/C vssd1 vssd1 vccd1 vccd1 _7950_/B sky130_fd_sc_hd__nor2_2
XTAP_TAPCELL_ROW_53_732 vssd1 vccd1 sky130_fd_sc_hd__tapvpwrvgnd_1
XFILLER_42_269 vssd1 vssd1 vccd1 vccd1 sky130_fd_sc_hd__fill_2
XFILLER_70_567 vssd1 vssd1 vccd1 vccd1 sky130_fd_sc_hd__fill_2
XFILLER_6_104 vssd1 vssd1 vccd1 vccd1 sky130_fd_sc_hd__fill_1
XFILLER_88_22 vssd1 vssd1 vccd1 vccd1 sky130_fd_sc_hd__fill_4
XANTENNA__4709__B _4709_/B vssd1 vssd1 vccd1 vccd1 sky130_fd_sc_hd__diode_2
XFILLER_77_177 vssd1 vssd1 vccd1 vccd1 sky130_fd_sc_hd__fill_2
XANTENNA__4998__A2 _5147_/B vssd1 vssd1 vccd1 vccd1 sky130_fd_sc_hd__diode_2
XANTENNA_input12_X _8164_/B vssd1 vssd1 vccd1 vccd1 sky130_fd_sc_hd__diode_2
XFILLER_61_501 vssd1 vssd1 vccd1 vccd1 sky130_fd_sc_hd__fill_2
XFILLER_92_169 vssd1 vssd1 vccd1 vccd1 sky130_fd_sc_hd__fill_8
XANTENNA__7595__X _7655_/A vssd1 vssd1 vccd1 vccd1 sky130_fd_sc_hd__diode_2
XFILLER_41_291 vssd1 vssd1 vccd1 vccd1 sky130_fd_sc_hd__fill_1
X_5300_ _5299_/X _5234_/X _5235_/X vssd1 vssd1 vccd1 vccd1 _5300_/Y sky130_fd_sc_hd__a21oi_4
X_6280_ _6280_/A _6280_/B vssd1 vssd1 vccd1 vccd1 _6282_/A sky130_fd_sc_hd__xor2_2
X_5231_ _5236_/A _5236_/B vssd1 vssd1 vccd1 vccd1 _5231_/X sky130_fd_sc_hd__and2b_2
X_5162_ _5710_/A _5953_/B vssd1 vssd1 vccd1 vccd1 _5165_/A sky130_fd_sc_hd__nand2_2
X_5093_ _8406_/D _5128_/C vssd1 vssd1 vccd1 vccd1 _5095_/B sky130_fd_sc_hd__nand2_2
XANTENNA__6834__B _7998_/B vssd1 vssd1 vccd1 vccd1 sky130_fd_sc_hd__diode_2
XTAP_TAPCELL_ROW_67_868 vssd1 vccd1 sky130_fd_sc_hd__tapvpwrvgnd_1
XFILLER_83_158 vssd1 vssd1 vccd1 vccd1 sky130_fd_sc_hd__fill_2
XFILLER_83_169 vssd1 vssd1 vccd1 vccd1 sky130_fd_sc_hd__fill_2
XANTENNA__4354__B _4487_/B vssd1 vssd1 vccd1 vccd1 sky130_fd_sc_hd__diode_2
XANTENNA_clkbuf_4_2_0_clk_A clkbuf_0_clk/X vssd1 vssd1 vccd1 vccd1 sky130_fd_sc_hd__diode_2
XFILLER_52_545 vssd1 vssd1 vccd1 vccd1 sky130_fd_sc_hd__fill_1
X_7803_ _7671_/A _7671_/B _7674_/A vssd1 vssd1 vccd1 vccd1 _7847_/A sky130_fd_sc_hd__a21bo_2
X_7734_ _8016_/A _7875_/B _7864_/B _7875_/C vssd1 vssd1 vccd1 vccd1 _7736_/A sky130_fd_sc_hd__and4_2
X_5995_ _5995_/A _5995_/B vssd1 vssd1 vccd1 vccd1 _5997_/B sky130_fd_sc_hd__xnor2_2
X_4946_ _4947_/B _4947_/A vssd1 vssd1 vccd1 vccd1 _5008_/A sky130_fd_sc_hd__nor2_2
XTAP_TAPCELL_ROW_50_702 vssd1 vccd1 sky130_fd_sc_hd__tapvpwrvgnd_1
XANTENNA__7665__B _7966_/B vssd1 vssd1 vccd1 vccd1 sky130_fd_sc_hd__diode_2
X_7665_ _7969_/A _7966_/B vssd1 vssd1 vccd1 vccd1 _7807_/A sky130_fd_sc_hd__nor2_2
X_4877_ _4874_/X _4875_/Y _4755_/Y _4757_/Y vssd1 vssd1 vccd1 vccd1 _4877_/X sky130_fd_sc_hd__o211a_2
X_7596_ _7413_/A _7413_/B _7411_/Y vssd1 vssd1 vccd1 vccd1 _7648_/A sky130_fd_sc_hd__o21a_2
X_6616_ _6978_/A _7806_/B _6617_/B vssd1 vssd1 vccd1 vccd1 _6616_/X sky130_fd_sc_hd__or3_2
X_6547_ _6460_/A _8264_/A _6548_/C vssd1 vssd1 vccd1 vccd1 _6549_/A sky130_fd_sc_hd__a21oi_2
XANTENNA__7681__A _7958_/A vssd1 vssd1 vccd1 vccd1 sky130_fd_sc_hd__diode_2
X_6478_ _6479_/A _6479_/B vssd1 vssd1 vccd1 vccd1 _6480_/B sky130_fd_sc_hd__and2_2
X_8217_ _8222_/A _8217_/B vssd1 vssd1 vccd1 vccd1 _8217_/Y sky130_fd_sc_hd__xnor2_2
X_5429_ _6198_/A _6207_/A _6001_/A _6005_/B vssd1 vssd1 vccd1 vccd1 _5430_/B sky130_fd_sc_hd__a22oi_2
XFILLER_58_36 vssd1 vssd1 vccd1 vccd1 sky130_fd_sc_hd__fill_1
XFILLER_87_420 vssd1 vssd1 vccd1 vccd1 sky130_fd_sc_hd__fill_1
X_8148_ _8045_/A _8045_/B _8048_/A vssd1 vssd1 vccd1 vccd1 _8149_/B sky130_fd_sc_hd__a21oi_2
XANTENNA_input4_X input4/X vssd1 vssd1 vccd1 vccd1 sky130_fd_sc_hd__diode_2
XFILLER_59_188 vssd1 vssd1 vccd1 vccd1 sky130_fd_sc_hd__fill_4
X_8079_ _7953_/B _7960_/B _7953_/A vssd1 vssd1 vccd1 vccd1 _8092_/A sky130_fd_sc_hd__o21ba_2
XFILLER_28_531 vssd1 vssd1 vccd1 vccd1 sky130_fd_sc_hd__fill_1
XFILLER_28_553 vssd1 vssd1 vccd1 vccd1 sky130_fd_sc_hd__fill_1
XFILLER_74_46 vssd1 vssd1 vccd1 vccd1 sky130_fd_sc_hd__fill_2
XTAP_TAPCELL_ROW_38_581 vssd1 vccd1 sky130_fd_sc_hd__tapvpwrvgnd_1
XFILLER_70_331 vssd1 vssd1 vccd1 vccd1 sky130_fd_sc_hd__fill_2
XFILLER_70_353 vssd1 vssd1 vccd1 vccd1 sky130_fd_sc_hd__fill_2
XFILLER_90_12 vssd1 vssd1 vccd1 vccd1 sky130_fd_sc_hd__fill_8
XFILLER_23_50 vssd1 vssd1 vccd1 vccd1 sky130_fd_sc_hd__fill_4
XFILLER_7_457 vssd1 vssd1 vccd1 vccd1 sky130_fd_sc_hd__fill_4
Xwire377 wire377/A vssd1 vssd1 vccd1 vccd1 wire377/X sky130_fd_sc_hd__clkbuf_4
XANTENNA__5823__B _6485_/B vssd1 vssd1 vccd1 vccd1 sky130_fd_sc_hd__diode_2
XFILLER_2_195 vssd1 vssd1 vccd1 vccd1 sky130_fd_sc_hd__fill_1
XFILLER_65_136 vssd1 vssd1 vccd1 vccd1 sky130_fd_sc_hd__fill_1
XFILLER_65_147 vssd1 vssd1 vccd1 vccd1 sky130_fd_sc_hd__fill_1
XTAP_TAPCELL_ROW_64_838 vssd1 vccd1 sky130_fd_sc_hd__tapvpwrvgnd_1
XFILLER_34_567 vssd1 vssd1 vccd1 vccd1 sky130_fd_sc_hd__fill_2
XFILLER_61_331 vssd1 vssd1 vccd1 vccd1 sky130_fd_sc_hd__fill_4
X_4800_ _4800_/A _4800_/B vssd1 vssd1 vccd1 vccd1 _4802_/B sky130_fd_sc_hd__xnor2_2
X_5780_ _8413_/D _5780_/B vssd1 vssd1 vccd1 vccd1 _5901_/A sky130_fd_sc_hd__nand2_2
X_4731_ _4731_/A _4731_/B vssd1 vssd1 vccd1 vccd1 _4731_/X sky130_fd_sc_hd__xor2_2
X_7450_ _7450_/A _7450_/B vssd1 vssd1 vccd1 vccd1 _7452_/B sky130_fd_sc_hd__xnor2_2
X_4662_ _4661_/Y _4665_/A vssd1 vssd1 vccd1 vccd1 _4662_/X sky130_fd_sc_hd__and2b_2
X_6401_ _6401_/A _6401_/B _6401_/C vssd1 vssd1 vccd1 vccd1 _6402_/B sky130_fd_sc_hd__or3_2
X_7381_ _7381_/A _7381_/B vssd1 vssd1 vccd1 vccd1 _7382_/B sky130_fd_sc_hd__nand2_2
X_4593_ _4593_/A _4593_/B vssd1 vssd1 vccd1 vccd1 _4602_/B sky130_fd_sc_hd__nand2_4
X_6332_ _6332_/A _6332_/B _6330_/X vssd1 vssd1 vccd1 vccd1 _7095_/C sky130_fd_sc_hd__or3b_4
X_6263_ _6263_/A _6263_/B vssd1 vssd1 vccd1 vccd1 _6264_/C sky130_fd_sc_hd__or2_2
X_8002_ _8002_/A _8002_/B vssd1 vssd1 vccd1 vccd1 _8004_/A sky130_fd_sc_hd__xor2_2
X_5214_ _8410_/D _5274_/B vssd1 vssd1 vccd1 vccd1 _5215_/C sky130_fd_sc_hd__and2_2
X_6194_ _6194_/A _6194_/B vssd1 vssd1 vccd1 vccd1 _6196_/B sky130_fd_sc_hd__xor2_2
X_5145_ _5928_/A _5149_/B _4999_/B _4997_/X vssd1 vssd1 vccd1 vccd1 _5154_/A sky130_fd_sc_hd__a31o_2
X_5076_ _5079_/A _5079_/B vssd1 vssd1 vccd1 vccd1 _5076_/Y sky130_fd_sc_hd__nor2_2
XANTENNA_fanout361_A wire364/A vssd1 vssd1 vccd1 vccd1 sky130_fd_sc_hd__diode_2
XFILLER_44_309 vssd1 vssd1 vccd1 vccd1 sky130_fd_sc_hd__fill_2
XANTENNA__5387__A2 _5386_/C vssd1 vssd1 vccd1 vccd1 sky130_fd_sc_hd__diode_2
XANTENNA_fanout247_X _6238_/B vssd1 vssd1 vccd1 vccd1 sky130_fd_sc_hd__diode_2
X_5978_ _5978_/A _6139_/B vssd1 vssd1 vccd1 vccd1 _5979_/C sky130_fd_sc_hd__nor2_2
XTAP_TAPCELL_ROW_35_551 vssd1 vccd1 sky130_fd_sc_hd__tapvpwrvgnd_1
X_7717_ _8032_/A _8030_/A vssd1 vssd1 vccd1 vccd1 _7718_/B sky130_fd_sc_hd__nand2_2
X_4929_ _4929_/A _4929_/B vssd1 vssd1 vccd1 vccd1 _4940_/B sky130_fd_sc_hd__xor2_2
XANTENNA__5196__A _6631_/B vssd1 vssd1 vccd1 vccd1 sky130_fd_sc_hd__diode_2
X_7648_ _7648_/A _7648_/B vssd1 vssd1 vccd1 vccd1 _7649_/C sky130_fd_sc_hd__xnor2_2
XANTENNA__4898__A1 _5020_/A vssd1 vssd1 vccd1 vccd1 sky130_fd_sc_hd__diode_2
X_7579_ _7579_/A _7579_/B _7579_/C vssd1 vssd1 vccd1 vccd1 _7580_/B sky130_fd_sc_hd__and3_2
XFILLER_4_449 vssd1 vssd1 vccd1 vccd1 sky130_fd_sc_hd__fill_1
XANTENNA__5643__B _5657_/B vssd1 vssd1 vccd1 vccd1 sky130_fd_sc_hd__diode_2
XFILLER_69_79 vssd1 vssd1 vccd1 vccd1 sky130_fd_sc_hd__fill_2
XFILLER_75_401 vssd1 vssd1 vccd1 vccd1 sky130_fd_sc_hd__fill_1
XFILLER_85_34 vssd1 vssd1 vccd1 vccd1 sky130_fd_sc_hd__fill_1
XFILLER_87_272 vssd1 vssd1 vccd1 vccd1 sky130_fd_sc_hd__fill_8
XFILLER_85_89 vssd1 vssd1 vccd1 vccd1 sky130_fd_sc_hd__fill_1
XANTENNA__4822__A1 _4821_/A vssd1 vssd1 vccd1 vccd1 sky130_fd_sc_hd__diode_2
XANTENNA__8013__A1 _7131_/A vssd1 vssd1 vccd1 vccd1 sky130_fd_sc_hd__diode_2
XFILLER_16_501 vssd1 vssd1 vccd1 vccd1 sky130_fd_sc_hd__fill_1
XFILLER_16_523 vssd1 vssd1 vccd1 vccd1 sky130_fd_sc_hd__fill_8
XFILLER_18_83 vssd1 vssd1 vccd1 vccd1 sky130_fd_sc_hd__fill_1
XFILLER_62_139 vssd1 vssd1 vccd1 vccd1 sky130_fd_sc_hd__fill_1
XFILLER_90_415 vssd1 vssd1 vccd1 vccd1 sky130_fd_sc_hd__fill_4
XTAP_TAPCELL_ROW_87_1070 vssd1 vccd1 sky130_fd_sc_hd__tapvpwrvgnd_1
XTAP_TAPCELL_ROW_61_808 vssd1 vccd1 sky130_fd_sc_hd__tapvpwrvgnd_1
XFILLER_34_82 vssd1 vssd1 vccd1 vccd1 sky130_fd_sc_hd__fill_2
XFILLER_11_283 vssd1 vssd1 vccd1 vccd1 sky130_fd_sc_hd__fill_4
Xwire152 _5892_/A vssd1 vssd1 vccd1 vccd1 _8077_/A sky130_fd_sc_hd__buf_2
Xwire163 _5104_/A vssd1 vssd1 vccd1 vccd1 _7808_/A sky130_fd_sc_hd__buf_2
XANTENNA__6649__B _6738_/B vssd1 vssd1 vccd1 vccd1 sky130_fd_sc_hd__diode_2
XFILLER_3_493 vssd1 vssd1 vccd1 vccd1 sky130_fd_sc_hd__fill_1
X_6950_ _6950_/A _6950_/B _6950_/C vssd1 vssd1 vccd1 vccd1 _6952_/A sky130_fd_sc_hd__and3_2
XTAP_TAPCELL_ROW_77_974 vssd1 vccd1 sky130_fd_sc_hd__tapvpwrvgnd_1
XFILLER_53_128 vssd1 vssd1 vccd1 vccd1 sky130_fd_sc_hd__fill_4
X_5901_ _5901_/A _5901_/B vssd1 vssd1 vccd1 vccd1 _5903_/A sky130_fd_sc_hd__xor2_2
XTAP_TAPCELL_ROW_49_687 vssd1 vccd1 sky130_fd_sc_hd__tapvpwrvgnd_1
X_6881_ _7658_/S _6881_/B _6881_/C vssd1 vssd1 vccd1 vccd1 _6881_/X sky130_fd_sc_hd__and3_2
XANTENNA__4913__A _5930_/A vssd1 vssd1 vccd1 vccd1 sky130_fd_sc_hd__diode_2
XFILLER_22_515 vssd1 vccd1 vssd1 vccd1 sky130_ef_sc_hd__decap_40_12
X_5832_ _5832_/A _5832_/B vssd1 vssd1 vccd1 vccd1 _5834_/B sky130_fd_sc_hd__xnor2_2
XFILLER_22_537 vssd1 vssd1 vccd1 vccd1 sky130_fd_sc_hd__fill_2
X_5763_ _5763_/A _5763_/B vssd1 vssd1 vccd1 vccd1 _5763_/Y sky130_fd_sc_hd__xnor2_2
XTAP_TAPCELL_ROW_32_521 vssd1 vccd1 sky130_fd_sc_hd__tapvpwrvgnd_1
XANTENNA__4632__B _6114_/B vssd1 vssd1 vccd1 vccd1 sky130_fd_sc_hd__diode_2
X_7502_ _7503_/A _7503_/B _7503_/C vssd1 vssd1 vccd1 vccd1 _7594_/A sky130_fd_sc_hd__o21a_2
X_4714_ _4709_/A _4360_/X _4709_/D _8423_/D vssd1 vssd1 vccd1 vccd1 _4714_/X sky130_fd_sc_hd__a22o_2
X_5694_ _5694_/A _5694_/B vssd1 vssd1 vccd1 vccd1 _5811_/A sky130_fd_sc_hd__nand2_2
XFILLER_30_29 vssd1 vccd1 vssd1 vccd1 sky130_ef_sc_hd__decap_40_12
X_7433_ _7433_/A _7433_/B vssd1 vssd1 vccd1 vccd1 _7440_/A sky130_fd_sc_hd__xnor2_2
X_4645_ _4645_/A _4645_/B vssd1 vssd1 vccd1 vccd1 _4652_/B sky130_fd_sc_hd__xnor2_2
XPHY_EDGE_ROW_15_Left_108 vssd1 vssd1 vccd1 vccd1 sky130_fd_sc_hd__decap_3
X_7364_ _7308_/A _7308_/B _7306_/X vssd1 vssd1 vccd1 vccd1 _7419_/A sky130_fd_sc_hd__a21o_2
X_4576_ _4576_/A _4576_/B vssd1 vssd1 vccd1 vccd1 _4578_/B sky130_fd_sc_hd__xnor2_2
X_6315_ _6315_/A _6315_/B vssd1 vssd1 vccd1 vccd1 _6318_/A sky130_fd_sc_hd__or2_2
X_7295_ _7668_/A _7806_/B vssd1 vssd1 vccd1 vccd1 _7295_/Y sky130_fd_sc_hd__nor2_2
X_6246_ _6246_/A _6246_/B vssd1 vssd1 vccd1 vccd1 _6248_/C sky130_fd_sc_hd__xnor2_2
XANTENNA_fanout197_X _4160_/B vssd1 vssd1 vccd1 vccd1 sky130_fd_sc_hd__diode_2
XFILLER_57_412 vssd1 vssd1 vccd1 vccd1 sky130_fd_sc_hd__fill_1
X_6177_ _6177_/A _6177_/B _6177_/C vssd1 vssd1 vccd1 vccd1 _6178_/B sky130_fd_sc_hd__or3_2
XFILLER_57_434 vssd1 vssd1 vccd1 vccd1 sky130_fd_sc_hd__fill_2
X_5128_ _6970_/A _8407_/D _5128_/C _5915_/B vssd1 vssd1 vccd1 vccd1 _5696_/A sky130_fd_sc_hd__nand4_2
XPHY_EDGE_ROW_24_Left_117 vssd1 vssd1 vccd1 vccd1 sky130_fd_sc_hd__decap_3
XANTENNA__6294__B _6712_/B vssd1 vssd1 vccd1 vccd1 sky130_fd_sc_hd__diode_2
XFILLER_29_169 vssd1 vssd1 vccd1 vccd1 sky130_fd_sc_hd__fill_8
XFILLER_57_467 vssd1 vssd1 vccd1 vccd1 sky130_fd_sc_hd__fill_4
XFILLER_84_253 vssd1 vssd1 vccd1 vccd1 sky130_fd_sc_hd__fill_2
X_5059_ _5107_/A _5059_/B vssd1 vssd1 vccd1 vccd1 _5059_/Y sky130_fd_sc_hd__nand2_2
XFILLER_44_139 vssd1 vssd1 vccd1 vccd1 sky130_fd_sc_hd__fill_1
XFILLER_13_526 vssd1 vssd1 vccd1 vccd1 sky130_fd_sc_hd__fill_8
XFILLER_80_481 vssd1 vssd1 vccd1 vccd1 sky130_fd_sc_hd__fill_1
XFILLER_40_367 vssd1 vssd1 vccd1 vccd1 sky130_fd_sc_hd__fill_1
XFILLER_40_378 vssd1 vssd1 vccd1 vccd1 sky130_fd_sc_hd__fill_1
XPHY_EDGE_ROW_33_Left_126 vssd1 vssd1 vccd1 vccd1 sky130_fd_sc_hd__decap_3
XFILLER_20_51 vssd1 vssd1 vccd1 vccd1 sky130_fd_sc_hd__fill_1
XPHY_EDGE_ROW_42_Left_135 vssd1 vssd1 vccd1 vccd1 sky130_fd_sc_hd__decap_3
XANTENNA_clkbuf_4_10_0_clk_A clkbuf_0_clk/X vssd1 vssd1 vccd1 vccd1 sky130_fd_sc_hd__diode_2
XFILLER_0_496 vssd1 vssd1 vccd1 vccd1 sky130_fd_sc_hd__fill_2
XANTENNA__6796__A1 _6883_/A vssd1 vssd1 vccd1 vccd1 sky130_fd_sc_hd__diode_2
XANTENNA__6796__B2 _6795_/A vssd1 vssd1 vccd1 vccd1 sky130_fd_sc_hd__diode_2
XTAP_TAPCELL_ROW_74_944 vssd1 vccd1 sky130_fd_sc_hd__tapvpwrvgnd_1
XTAP_TAPCELL_ROW_46_657 vssd1 vccd1 sky130_fd_sc_hd__tapvpwrvgnd_1
XPHY_EDGE_ROW_51_Left_144 vssd1 vssd1 vccd1 vccd1 sky130_fd_sc_hd__decap_3
Xclkbuf_4_14_0_clk clkbuf_0_clk/X vssd1 vssd1 vccd1 vccd1 _8405_/CLK sky130_fd_sc_hd__clkbuf_8
XFILLER_8_552 vssd1 vssd1 vccd1 vccd1 sky130_fd_sc_hd__fill_2
XFILLER_6_20 vssd1 vssd1 vccd1 vccd1 sky130_fd_sc_hd__fill_2
X_4430_ _5020_/A _4430_/B vssd1 vssd1 vccd1 vccd1 _4433_/B sky130_fd_sc_hd__nand2_2
X_6100_ _6572_/A _6703_/B _5951_/B _5949_/X vssd1 vssd1 vccd1 vccd1 _6101_/A sky130_fd_sc_hd__a31o_2
X_4361_ _5155_/A _4780_/B vssd1 vssd1 vccd1 vccd1 _4372_/B sky130_fd_sc_hd__nand2_2
X_7080_ _7969_/A _7080_/B vssd1 vssd1 vccd1 vccd1 _7311_/A sky130_fd_sc_hd__nor2_2
X_4292_ _4292_/A _4292_/B _4292_/C vssd1 vssd1 vccd1 vccd1 _5163_/B sky130_fd_sc_hd__nand3_2
XPHY_EDGE_ROW_60_Left_153 vssd1 vssd1 vccd1 vccd1 sky130_fd_sc_hd__decap_3
XFILLER_86_529 vssd1 vssd1 vccd1 vccd1 sky130_fd_sc_hd__fill_2
X_6031_ _6517_/A _6517_/B _8228_/A _8233_/A vssd1 vssd1 vccd1 vccd1 _6032_/B sky130_fd_sc_hd__and4_2
XANTENNA__4186__Y _7299_/A vssd1 vssd1 vccd1 vccd1 sky130_fd_sc_hd__diode_2
XFILLER_66_253 vssd1 vssd1 vccd1 vccd1 sky130_fd_sc_hd__fill_2
X_7982_ _7982_/A _7982_/B vssd1 vssd1 vccd1 vccd1 _7983_/B sky130_fd_sc_hd__nand2_2
XFILLER_81_256 vssd1 vssd1 vccd1 vccd1 sky130_fd_sc_hd__fill_4
X_6933_ _6934_/A _6934_/B _6934_/C vssd1 vssd1 vccd1 vccd1 _7183_/A sky130_fd_sc_hd__a21o_2
X_6864_ _6865_/A _6865_/B vssd1 vssd1 vccd1 vccd1 _6954_/B sky130_fd_sc_hd__nand2b_2
X_5815_ _6207_/A _6001_/A _6005_/B _6482_/A vssd1 vssd1 vccd1 vccd1 _5817_/A sky130_fd_sc_hd__a22oi_2
XTAP_TAPCELL_ROW_17_370 vssd1 vccd1 sky130_fd_sc_hd__tapvpwrvgnd_1
XANTENNA__8395__CLK _8402_/CLK vssd1 vssd1 vccd1 vccd1 sky130_fd_sc_hd__diode_2
X_6795_ _6795_/A _6883_/A _7714_/C _6795_/D vssd1 vssd1 vccd1 vccd1 _6797_/A sky130_fd_sc_hd__and4_2
XANTENNA_fanout324_A _8342_/Q vssd1 vssd1 vccd1 vccd1 sky130_fd_sc_hd__diode_2
X_5746_ _5746_/A _5746_/B vssd1 vssd1 vccd1 vccd1 _5748_/A sky130_fd_sc_hd__xnor2_2
XANTENNA__4173__A_N _8196_/B vssd1 vssd1 vccd1 vccd1 sky130_fd_sc_hd__diode_2
X_5677_ _5604_/Y _5630_/Y _5675_/X _5676_/Y vssd1 vssd1 vccd1 vccd1 _5677_/X sky130_fd_sc_hd__o211a_2
X_7416_ _7417_/A _7417_/B vssd1 vssd1 vccd1 vccd1 _7649_/A sky130_fd_sc_hd__and2b_2
X_4628_ _4634_/B _4634_/A vssd1 vssd1 vccd1 vccd1 _4628_/X sky130_fd_sc_hd__and2_2
X_8396_ clkload0/A _8396_/D load_slew366/X vssd1 vssd1 vccd1 vccd1 _8396_/Q sky130_fd_sc_hd__dfrtp_2
Xhold530 _8384_/Q vssd1 vssd1 vccd1 vccd1 _8443_/D sky130_fd_sc_hd__dlygate4sd3_1
XFILLER_1_205 vssd1 vssd1 vccd1 vccd1 sky130_fd_sc_hd__fill_1
Xhold552 _8426_/Q vssd1 vssd1 vccd1 vccd1 hold552/X sky130_fd_sc_hd__dlygate4sd3_1
Xhold541 _8358_/Q vssd1 vssd1 vccd1 vccd1 _8278_/A sky130_fd_sc_hd__dlygate4sd3_1
X_7347_ _7108_/A _7108_/B _7091_/X vssd1 vssd1 vccd1 vccd1 _7349_/B sky130_fd_sc_hd__a21oi_2
X_4559_ _8429_/D _4709_/C _4596_/A vssd1 vssd1 vccd1 vccd1 _4560_/D sky130_fd_sc_hd__a21o_4
X_7278_ _7277_/A _7277_/B _7277_/C vssd1 vssd1 vccd1 vccd1 _7279_/B sky130_fd_sc_hd__a21oi_2
XFILLER_89_389 vssd1 vssd1 vccd1 vccd1 sky130_fd_sc_hd__fill_2
X_6229_ _6229_/A _6229_/B vssd1 vssd1 vccd1 vccd1 _6230_/C sky130_fd_sc_hd__nand2_2
XFILLER_57_253 vssd1 vssd1 vccd1 vccd1 sky130_fd_sc_hd__fill_1
XTAP_TAPCELL_ROW_84_1040 vssd1 vccd1 sky130_fd_sc_hd__tapvpwrvgnd_1
XTAP_TAPCELL_ROW_71_914 vssd1 vccd1 sky130_fd_sc_hd__tapvpwrvgnd_1
XFILLER_15_40 vssd1 vssd1 vccd1 vccd1 sky130_fd_sc_hd__fill_4
XTAP_TAPCELL_ROW_43_627 vssd1 vccd1 sky130_fd_sc_hd__tapvpwrvgnd_1
XFILLER_68_529 vssd1 vssd1 vccd1 vccd1 sky130_fd_sc_hd__fill_2
XFILLER_0_271 vssd1 vssd1 vccd1 vccd1 sky130_fd_sc_hd__fill_1
XANTENNA__6218__B1 _7426_/A vssd1 vssd1 vccd1 vccd1 sky130_fd_sc_hd__diode_2
XTAP_TAPCELL_ROW_59_793 vssd1 vccd1 sky130_fd_sc_hd__tapvpwrvgnd_1
XFILLER_63_278 vssd1 vssd1 vccd1 vccd1 sky130_fd_sc_hd__fill_2
XFILLER_16_172 vssd1 vssd1 vccd1 vccd1 sky130_fd_sc_hd__fill_1
XTAP_TAPCELL_ROW_14_340 vssd1 vccd1 sky130_fd_sc_hd__tapvpwrvgnd_1
XFILLER_82_3 vssd1 vssd1 vccd1 vccd1 sky130_fd_sc_hd__fill_4
X_6580_ _6580_/A _6580_/B vssd1 vssd1 vccd1 vccd1 _6601_/A sky130_fd_sc_hd__xor2_2
X_5600_ _5600_/A _5600_/B vssd1 vssd1 vccd1 vccd1 _5601_/B sky130_fd_sc_hd__nor2_2
X_5531_ _5534_/B _5531_/B vssd1 vssd1 vccd1 vccd1 _5584_/B sky130_fd_sc_hd__and2_2
XANTENNA__4910__B _5928_/A vssd1 vssd1 vccd1 vccd1 sky130_fd_sc_hd__diode_2
X_8250_ _8250_/A _8250_/B vssd1 vssd1 vccd1 vccd1 _8250_/Y sky130_fd_sc_hd__xnor2_2
X_7201_ _7201_/A _7201_/B _7201_/C vssd1 vssd1 vccd1 vccd1 _7202_/B sky130_fd_sc_hd__nor3_2
X_5462_ _5462_/A _5462_/B _5495_/A vssd1 vssd1 vccd1 vccd1 _5468_/B sky130_fd_sc_hd__and3_2
X_8181_ _8173_/X _8177_/B _8179_/X _8307_/S vssd1 vssd1 vccd1 vccd1 _8181_/X sky130_fd_sc_hd__o31a_2
X_5393_ _8196_/A _5393_/B _8202_/A _5393_/D vssd1 vssd1 vccd1 vccd1 _5395_/A sky130_fd_sc_hd__and4_2
X_4413_ _4413_/A _4413_/B vssd1 vssd1 vccd1 vccd1 _4424_/B sky130_fd_sc_hd__xnor2_2
X_7132_ _7132_/A _7132_/B vssd1 vssd1 vccd1 vccd1 _7134_/B sky130_fd_sc_hd__xnor2_2
X_4344_ _4557_/A _4496_/D vssd1 vssd1 vccd1 vccd1 _4390_/B sky130_fd_sc_hd__nand2_2
XANTENNA__6837__B _7725_/B vssd1 vssd1 vccd1 vccd1 sky130_fd_sc_hd__diode_2
Xfanout339 _8339_/Q vssd1 vssd1 vccd1 vccd1 _6883_/A sky130_fd_sc_hd__clkdlybuf4s25_1
Xfanout328 _8341_/Q vssd1 vssd1 vccd1 vccd1 _5618_/A sky130_fd_sc_hd__clkdlybuf4s25_1
Xfanout317 _6035_/D vssd1 vssd1 vccd1 vccd1 _7714_/A sky130_fd_sc_hd__clkdlybuf4s25_1
Xfanout306 _7723_/C vssd1 vssd1 vccd1 vccd1 _8136_/A sky130_fd_sc_hd__clkdlybuf4s25_1
X_7063_ _7063_/A _7063_/B vssd1 vssd1 vccd1 vccd1 _7065_/B sky130_fd_sc_hd__xnor2_2
X_6014_ _5825_/B _5827_/B _5825_/A vssd1 vssd1 vccd1 vccd1 _6024_/A sky130_fd_sc_hd__o21ba_2
X_4275_ _4282_/B _4275_/B vssd1 vssd1 vccd1 vccd1 _4275_/X sky130_fd_sc_hd__and2_2
XANTENNA_fanout274_A _6548_/A vssd1 vssd1 vccd1 vccd1 sky130_fd_sc_hd__diode_2
XFILLER_39_275 vssd1 vssd1 vccd1 vccd1 sky130_fd_sc_hd__fill_4
XANTENNA__7668__B _8077_/B vssd1 vssd1 vccd1 vccd1 sky130_fd_sc_hd__diode_2
X_7965_ _7682_/B _7813_/Y _7817_/A _7817_/B vssd1 vssd1 vccd1 vccd1 _7972_/A sky130_fd_sc_hd__a22o_2
XFILLER_54_289 vssd1 vssd1 vccd1 vccd1 sky130_fd_sc_hd__fill_1
X_7896_ _8001_/A _7897_/B _7894_/Y _7895_/X vssd1 vssd1 vccd1 vccd1 _7898_/A sky130_fd_sc_hd__o2bb2a_2
X_6916_ _6916_/A _6916_/B vssd1 vssd1 vccd1 vccd1 _6940_/A sky130_fd_sc_hd__xor2_2
XANTENNA__7185__A1 _7990_/A vssd1 vssd1 vccd1 vccd1 sky130_fd_sc_hd__diode_2
X_6847_ _6946_/A _6847_/B vssd1 vssd1 vccd1 vccd1 _6847_/Y sky130_fd_sc_hd__nand2_2
XFILLER_10_304 vssd1 vssd1 vccd1 vccd1 sky130_fd_sc_hd__fill_4
X_6778_ _6778_/A _6778_/B vssd1 vssd1 vccd1 vccd1 _6779_/C sky130_fd_sc_hd__xor2_2
X_5729_ _5730_/A _5730_/B vssd1 vssd1 vccd1 vccd1 _5933_/A sky130_fd_sc_hd__and2_2
XFILLER_6_319 vssd1 vssd1 vccd1 vccd1 sky130_fd_sc_hd__fill_1
X_8448_ clkload1/A _8448_/D load_slew360/X vssd1 vssd1 vccd1 vccd1 _8448_/Q sky130_fd_sc_hd__dfrtp_2
XTAP_TAPCELL_ROW_20_398 vssd1 vccd1 sky130_fd_sc_hd__tapvpwrvgnd_1
XFILLER_2_514 vssd1 vssd1 vccd1 vccd1 sky130_fd_sc_hd__fill_8
X_8379_ _8382_/CLK _8379_/D load_slew370/X vssd1 vssd1 vccd1 vccd1 _8379_/Q sky130_fd_sc_hd__dfrtp_2
XANTENNA__4171__A1 _4227_/S vssd1 vssd1 vccd1 vccd1 sky130_fd_sc_hd__diode_2
XANTENNA__8410__CLK clkload7/A vssd1 vssd1 vccd1 vccd1 sky130_fd_sc_hd__diode_2
XFILLER_7_5 vssd1 vssd1 vccd1 vccd1 sky130_fd_sc_hd__fill_1
XFILLER_89_131 vssd1 vssd1 vccd1 vccd1 sky130_fd_sc_hd__fill_2
XFILLER_89_153 vssd1 vssd1 vccd1 vccd1 sky130_fd_sc_hd__fill_2
XFILLER_77_337 vssd1 vssd1 vccd1 vccd1 sky130_fd_sc_hd__fill_1
XFILLER_77_57 vssd1 vssd1 vccd1 vccd1 sky130_fd_sc_hd__fill_4
XFILLER_89_175 vssd1 vssd1 vccd1 vccd1 sky130_fd_sc_hd__fill_1
XFILLER_58_551 vssd1 vssd1 vccd1 vccd1 sky130_fd_sc_hd__fill_4
XTAP_TAPCELL_ROW_56_763 vssd1 vccd1 sky130_fd_sc_hd__tapvpwrvgnd_1
XFILLER_26_83 vssd1 vssd1 vccd1 vccd1 sky130_fd_sc_hd__fill_1
XTAP_TAPCELL_ROW_28_476 vssd1 vccd1 sky130_fd_sc_hd__tapvpwrvgnd_1
XFILLER_9_124 vssd1 vssd1 vccd1 vccd1 sky130_fd_sc_hd__fill_4
XFILLER_9_113 vssd1 vssd1 vccd1 vccd1 sky130_fd_sc_hd__fill_2
XANTENNA__5826__B _6217_/C vssd1 vssd1 vccd1 vccd1 sky130_fd_sc_hd__diode_2
XANTENNA__6923__B2 _7998_/B vssd1 vssd1 vccd1 vccd1 sky130_fd_sc_hd__diode_2
XTAP_TAPCELL_ROW_11_310 vssd1 vccd1 sky130_fd_sc_hd__tapvpwrvgnd_1
XANTENNA__8202__B _8202_/B vssd1 vssd1 vccd1 vccd1 sky130_fd_sc_hd__diode_2
Xrebuffer490 _7797_/X vssd1 vssd1 vccd1 vccd1 _7940_/B1 sky130_fd_sc_hd__buf_2
XANTENNA__5842__A _6435_/A vssd1 vssd1 vccd1 vccd1 sky130_fd_sc_hd__diode_2
XANTENNA__7100__A1 _5983_/A vssd1 vssd1 vccd1 vccd1 sky130_fd_sc_hd__diode_2
XFILLER_3_43 vssd1 vssd1 vccd1 vccd1 sky130_fd_sc_hd__fill_1
XFILLER_64_554 vssd1 vssd1 vccd1 vccd1 sky130_fd_sc_hd__fill_2
X_7750_ _7750_/A _7750_/B vssd1 vssd1 vccd1 vccd1 _7752_/A sky130_fd_sc_hd__nor2_2
X_4962_ _4962_/A _4962_/B vssd1 vssd1 vccd1 vccd1 _4963_/B sky130_fd_sc_hd__nor2_2
X_7681_ _7958_/A _8082_/D vssd1 vssd1 vccd1 vccd1 _7682_/B sky130_fd_sc_hd__nor2_2
X_6701_ _8433_/D _6701_/B vssd1 vssd1 vccd1 vccd1 _6707_/A sky130_fd_sc_hd__nand2_2
X_4893_ _4902_/A _4897_/B _4816_/D _4813_/X vssd1 vssd1 vccd1 vccd1 _4900_/A sky130_fd_sc_hd__a31o_2
X_6632_ _6632_/A _6632_/B vssd1 vssd1 vccd1 vccd1 _6633_/B sky130_fd_sc_hd__xnor2_2
X_6563_ _6563_/A _6563_/B vssd1 vssd1 vccd1 vccd1 _6564_/B sky130_fd_sc_hd__and2_2
XANTENNA__8433__CLK clkload4/A vssd1 vssd1 vccd1 vccd1 sky130_fd_sc_hd__diode_2
X_8302_ _8136_/C input9/X _8303_/S vssd1 vssd1 vccd1 vccd1 _8377_/D sky130_fd_sc_hd__mux2_1
X_6494_ _6494_/A _6494_/B vssd1 vssd1 vccd1 vccd1 _6496_/B sky130_fd_sc_hd__xnor2_2
X_5514_ _5514_/A _5514_/B vssd1 vssd1 vccd1 vccd1 _5514_/Y sky130_fd_sc_hd__nand2_2
X_8233_ _8233_/A input7/X vssd1 vssd1 vccd1 vccd1 _8234_/B sky130_fd_sc_hd__nand2_2
X_5445_ _5445_/A _5445_/B vssd1 vssd1 vccd1 vccd1 _5446_/C sky130_fd_sc_hd__xnor2_2
X_8164_ _8307_/S _8164_/B vssd1 vssd1 vccd1 vccd1 _8165_/B sky130_fd_sc_hd__nand2_2
X_7115_ _7116_/B _7116_/A vssd1 vssd1 vccd1 vccd1 _7356_/A sky130_fd_sc_hd__nand2b_2
X_5376_ _5380_/A _5376_/B vssd1 vssd1 vccd1 vccd1 _5450_/C sky130_fd_sc_hd__and2_2
XFILLER_59_337 vssd1 vssd1 vccd1 vccd1 sky130_fd_sc_hd__fill_4
XFILLER_86_123 vssd1 vssd1 vccd1 vccd1 sky130_fd_sc_hd__fill_2
X_8095_ _8095_/A _8095_/B vssd1 vssd1 vccd1 vccd1 _8154_/A sky130_fd_sc_hd__xnor2_2
Xfanout125 _4194_/Y vssd1 vssd1 vccd1 vccd1 _8408_/D sky130_fd_sc_hd__clkdlybuf4s25_1
Xfanout136 _4166_/Y vssd1 vssd1 vccd1 vccd1 _4667_/A sky130_fd_sc_hd__buf_8
Xfanout147 _4362_/Y vssd1 vssd1 vccd1 vccd1 _4709_/D sky130_fd_sc_hd__clkdlybuf4s25_1
X_4327_ _8425_/D _4432_/B vssd1 vssd1 vccd1 vccd1 _4461_/A sky130_fd_sc_hd__nand2_2
XFILLER_86_145 vssd1 vssd1 vccd1 vccd1 sky130_fd_sc_hd__fill_2
Xfanout169 _4183_/X vssd1 vssd1 vccd1 vccd1 _4780_/A sky130_fd_sc_hd__buf_8
X_7046_ _7658_/S _7046_/B _7046_/C vssd1 vssd1 vccd1 vccd1 _7046_/X sky130_fd_sc_hd__and3_2
X_4258_ _4252_/X _4258_/B vssd1 vssd1 vccd1 vccd1 _4303_/B sky130_fd_sc_hd__nand2b_2
XFILLER_67_370 vssd1 vssd1 vccd1 vccd1 sky130_fd_sc_hd__fill_2
XANTENNA_fanout277_X _7990_/A vssd1 vssd1 vccd1 vccd1 sky130_fd_sc_hd__diode_2
X_4189_ wire387/A _4198_/B vssd1 vssd1 vccd1 vccd1 _4189_/Y sky130_fd_sc_hd__nand2b_2
XFILLER_15_407 vssd1 vssd1 vccd1 vccd1 sky130_fd_sc_hd__fill_1
X_7948_ _7946_/Y _7948_/B vssd1 vssd1 vccd1 vccd1 _7950_/A sky130_fd_sc_hd__nand2b_2
XTAP_TAPCELL_ROW_53_733 vssd1 vccd1 sky130_fd_sc_hd__tapvpwrvgnd_1
XANTENNA_wire92_X wire92/X vssd1 vssd1 vccd1 vccd1 sky130_fd_sc_hd__diode_2
XFILLER_42_248 vssd1 vssd1 vccd1 vccd1 sky130_fd_sc_hd__fill_4
XTAP_TAPCELL_ROW_81_1010 vssd1 vccd1 sky130_fd_sc_hd__tapvpwrvgnd_1
XTAP_TAPCELL_ROW_25_446 vssd1 vccd1 sky130_fd_sc_hd__tapvpwrvgnd_1
XANTENNA__5927__A _5928_/A vssd1 vssd1 vccd1 vccd1 sky130_fd_sc_hd__diode_2
X_7879_ _7880_/A _7880_/B vssd1 vssd1 vccd1 vccd1 _8009_/A sky130_fd_sc_hd__nand2b_2
XANTENNA__6493__A _7131_/A vssd1 vssd1 vccd1 vccd1 sky130_fd_sc_hd__diode_2
XFILLER_92_104 vssd1 vssd1 vccd1 vccd1 sky130_fd_sc_hd__fill_1
XFILLER_18_212 vssd1 vssd1 vccd1 vccd1 sky130_fd_sc_hd__fill_1
XPHY_EDGE_ROW_16_Right_16 vssd1 vssd1 vccd1 vccd1 sky130_fd_sc_hd__decap_3
XFILLER_61_535 vssd1 vssd1 vccd1 vccd1 sky130_fd_sc_hd__fill_4
XFILLER_61_568 vssd1 vssd1 vccd1 vccd1 sky130_fd_sc_hd__fill_2
XFILLER_14_495 vssd1 vssd1 vccd1 vccd1 sky130_fd_sc_hd__fill_4
XFILLER_41_281 vssd1 vssd1 vccd1 vccd1 sky130_fd_sc_hd__fill_2
XPHY_EDGE_ROW_25_Right_25 vssd1 vssd1 vccd1 vccd1 sky130_fd_sc_hd__decap_3
X_5230_ _5230_/A _5230_/B vssd1 vssd1 vccd1 vccd1 _5236_/B sky130_fd_sc_hd__xor2_2
X_5161_ _4984_/A _4984_/B _4980_/X vssd1 vssd1 vccd1 vccd1 _5169_/A sky130_fd_sc_hd__a21o_2
X_5092_ _5092_/A _5092_/B vssd1 vssd1 vccd1 vccd1 _5095_/A sky130_fd_sc_hd__xnor2_2
XFILLER_83_104 vssd1 vssd1 vccd1 vccd1 sky130_fd_sc_hd__fill_1
XANTENNA__6834__C _7723_/C vssd1 vssd1 vccd1 vccd1 sky130_fd_sc_hd__diode_2
XFILLER_83_137 vssd1 vssd1 vccd1 vccd1 sky130_fd_sc_hd__fill_1
XPHY_EDGE_ROW_34_Right_34 vssd1 vssd1 vccd1 vccd1 sky130_fd_sc_hd__decap_3
XTAP_TAPCELL_ROW_67_869 vssd1 vccd1 sky130_fd_sc_hd__tapvpwrvgnd_1
X_7802_ _7705_/A _7705_/B _7708_/A vssd1 vssd1 vccd1 vccd1 _7848_/A sky130_fd_sc_hd__o21ai_2
X_5994_ _5994_/A _5994_/B vssd1 vssd1 vccd1 vccd1 _5995_/B sky130_fd_sc_hd__xnor2_2
X_7733_ _7525_/A _7527_/B _7525_/B vssd1 vssd1 vccd1 vccd1 _7740_/A sky130_fd_sc_hd__o21ba_2
X_4945_ _4864_/A _4864_/B _4855_/X vssd1 vssd1 vccd1 vccd1 _4947_/A sky130_fd_sc_hd__a21oi_2
XANTENNA__5747__A _5747_/A vssd1 vssd1 vccd1 vccd1 sky130_fd_sc_hd__diode_2
XTAP_TAPCELL_ROW_50_703 vssd1 vccd1 sky130_fd_sc_hd__tapvpwrvgnd_1
XTAP_TAPCELL_ROW_22_416 vssd1 vccd1 sky130_fd_sc_hd__tapvpwrvgnd_1
X_7664_ _7619_/A _7619_/B _7617_/X vssd1 vssd1 vccd1 vccd1 _7671_/A sky130_fd_sc_hd__a21o_2
X_4876_ _4755_/Y _4757_/Y _4875_/Y _4874_/X vssd1 vssd1 vccd1 vccd1 _4876_/Y sky130_fd_sc_hd__a211oi_4
XFILLER_20_465 vssd1 vssd1 vccd1 vccd1 sky130_fd_sc_hd__fill_1
X_7595_ _7595_/A _7595_/B vssd1 vssd1 vccd1 vccd1 _7655_/A sky130_fd_sc_hd__and2_2
X_6615_ _6615_/A _6615_/B vssd1 vssd1 vccd1 vccd1 _6617_/B sky130_fd_sc_hd__xnor2_2
XPHY_EDGE_ROW_43_Right_43 vssd1 vssd1 vccd1 vccd1 sky130_fd_sc_hd__decap_3
X_6546_ _6869_/A _6546_/B vssd1 vssd1 vccd1 vccd1 _6548_/C sky130_fd_sc_hd__nor2_2
XANTENNA__7681__B _8082_/D vssd1 vssd1 vccd1 vccd1 sky130_fd_sc_hd__diode_2
X_6477_ _6282_/A _6282_/B _6279_/X vssd1 vssd1 vccd1 vccd1 _6479_/B sky130_fd_sc_hd__a21o_2
X_8216_ _8223_/A _8222_/B vssd1 vssd1 vccd1 vccd1 _8217_/B sky130_fd_sc_hd__nor2_2
X_5428_ _6198_/A _6207_/A _6001_/A _6005_/B vssd1 vssd1 vccd1 vccd1 _5829_/A sky130_fd_sc_hd__and4_2
X_8147_ _8147_/A _8147_/B vssd1 vssd1 vccd1 vccd1 _8149_/A sky130_fd_sc_hd__nand2_2
X_5359_ _8191_/A _5618_/A _5521_/C _5393_/D vssd1 vssd1 vccd1 vccd1 _5361_/A sky130_fd_sc_hd__and4_2
XFILLER_59_134 vssd1 vssd1 vccd1 vccd1 sky130_fd_sc_hd__fill_1
X_8078_ _8078_/A _8078_/B vssd1 vssd1 vccd1 vccd1 _8093_/A sky130_fd_sc_hd__xnor2_2
XANTENNA__8329__CLK _8402_/CLK vssd1 vssd1 vccd1 vccd1 sky130_fd_sc_hd__diode_2
XFILLER_59_167 vssd1 vssd1 vccd1 vccd1 sky130_fd_sc_hd__fill_1
X_7029_ _7029_/A _7029_/B vssd1 vssd1 vccd1 vccd1 _7030_/B sky130_fd_sc_hd__xor2_2
XPHY_EDGE_ROW_52_Right_52 vssd1 vssd1 vccd1 vccd1 sky130_fd_sc_hd__decap_3
XFILLER_43_513 vssd1 vssd1 vccd1 vccd1 sky130_fd_sc_hd__fill_2
XFILLER_55_362 vssd1 vssd1 vccd1 vccd1 sky130_fd_sc_hd__fill_1
XTAP_TAPCELL_ROW_38_582 vssd1 vccd1 sky130_fd_sc_hd__tapvpwrvgnd_1
XPHY_EDGE_ROW_61_Right_61 vssd1 vssd1 vccd1 vccd1 sky130_fd_sc_hd__decap_3
XFILLER_7_447 vssd1 vssd1 vccd1 vccd1 sky130_fd_sc_hd__fill_1
XANTENNA__5392__A _8208_/A vssd1 vssd1 vccd1 vccd1 sky130_fd_sc_hd__diode_2
XFILLER_2_141 vssd1 vssd1 vccd1 vccd1 sky130_fd_sc_hd__fill_1
XFILLER_78_421 vssd1 vssd1 vccd1 vccd1 sky130_fd_sc_hd__fill_8
XPHY_EDGE_ROW_70_Right_70 vssd1 vssd1 vccd1 vccd1 sky130_fd_sc_hd__decap_3
XANTENNA__8208__A _8208_/A vssd1 vssd1 vccd1 vccd1 sky130_fd_sc_hd__diode_2
XFILLER_34_535 vssd1 vssd1 vccd1 vccd1 sky130_fd_sc_hd__fill_1
XTAP_TAPCELL_ROW_64_839 vssd1 vccd1 sky130_fd_sc_hd__tapvpwrvgnd_1
XFILLER_64_91 vssd1 vssd1 vccd1 vccd1 sky130_fd_sc_hd__fill_1
X_4730_ _4733_/B _4728_/X _4550_/Y vssd1 vssd1 vccd1 vccd1 _4730_/X sky130_fd_sc_hd__a21bo_4
X_4661_ _4661_/A _4661_/B vssd1 vssd1 vccd1 vccd1 _4661_/Y sky130_fd_sc_hd__xnor2_2
XANTENNA__8413__RESET_B wire362/X vssd1 vssd1 vccd1 vccd1 sky130_fd_sc_hd__diode_2
X_7380_ _7381_/A _7381_/B vssd1 vssd1 vccd1 vccd1 _7382_/A sky130_fd_sc_hd__or2_2
X_6400_ _6401_/A _6401_/B _6401_/C vssd1 vssd1 vccd1 vccd1 _6499_/A sky130_fd_sc_hd__o21ai_2
X_6331_ _6332_/A _6332_/B _6330_/X vssd1 vssd1 vccd1 vccd1 _6609_/B sky130_fd_sc_hd__o21bai_2
X_4592_ _4623_/A _4686_/B _4568_/B _4560_/D vssd1 vssd1 vccd1 vccd1 _4593_/B sky130_fd_sc_hd__a22o_2
XFILLER_88_207 vssd1 vssd1 vccd1 vccd1 sky130_fd_sc_hd__fill_1
X_6262_ _6460_/A _8257_/A _6262_/C vssd1 vssd1 vccd1 vccd1 _6263_/B sky130_fd_sc_hd__and3_2
XANTENNA_wire362_X wire362/X vssd1 vssd1 vccd1 vccd1 sky130_fd_sc_hd__diode_2
X_8001_ _8001_/A _8103_/D vssd1 vssd1 vccd1 vccd1 _8002_/B sky130_fd_sc_hd__nand2_2
X_6193_ _6193_/A _6193_/B vssd1 vssd1 vccd1 vccd1 _6194_/B sky130_fd_sc_hd__xnor2_2
X_5213_ _5213_/A _5213_/B vssd1 vssd1 vccd1 vccd1 _5219_/A sky130_fd_sc_hd__xor2_2
X_5144_ _5144_/A _5144_/B _5144_/C vssd1 vssd1 vccd1 vccd1 _5182_/B sky130_fd_sc_hd__or3_2
XFILLER_28_29 vssd1 vssd1 vccd1 vccd1 sky130_fd_sc_hd__fill_4
XFILLER_69_498 vssd1 vssd1 vccd1 vccd1 sky130_fd_sc_hd__fill_1
X_5075_ _5085_/A _5085_/B vssd1 vssd1 vccd1 vccd1 _5079_/B sky130_fd_sc_hd__or2_2
XFILLER_64_181 vssd1 vssd1 vccd1 vccd1 sky130_fd_sc_hd__fill_1
XFILLER_52_365 vssd1 vssd1 vccd1 vccd1 sky130_fd_sc_hd__fill_1
X_5977_ _5977_/A _5977_/B vssd1 vssd1 vccd1 vccd1 _6139_/B sky130_fd_sc_hd__and2_2
XTAP_TAPCELL_ROW_35_552 vssd1 vccd1 sky130_fd_sc_hd__tapvpwrvgnd_1
XANTENNA__4381__A _4919_/A vssd1 vssd1 vccd1 vccd1 sky130_fd_sc_hd__diode_2
X_7716_ _7716_/A _7716_/B vssd1 vssd1 vccd1 vccd1 _7718_/A sky130_fd_sc_hd__nor2_2
X_4928_ _5157_/A _4979_/B _4979_/C vssd1 vssd1 vccd1 vccd1 _4929_/A sky130_fd_sc_hd__and3_2
XANTENNA__5196__B _6611_/A vssd1 vssd1 vccd1 vccd1 sky130_fd_sc_hd__diode_2
X_7647_ _7648_/A _7648_/B vssd1 vssd1 vccd1 vccd1 _7662_/B sky130_fd_sc_hd__nand2b_2
X_4859_ _4860_/A _4989_/A vssd1 vssd1 vccd1 vccd1 _4924_/A sky130_fd_sc_hd__nand2_2
X_7578_ _7579_/A _7579_/B _7579_/C vssd1 vssd1 vccd1 vccd1 _7788_/A sky130_fd_sc_hd__a21oi_2
XANTENNA__8089__A2 _7095_/B vssd1 vssd1 vccd1 vccd1 sky130_fd_sc_hd__diode_2
X_6529_ _6530_/A _6530_/B vssd1 vssd1 vccd1 vccd1 _6849_/B sky130_fd_sc_hd__and2_2
XANTENNA__5940__A _6091_/A vssd1 vssd1 vccd1 vccd1 sky130_fd_sc_hd__diode_2
XTAP_TAPCELL_ROW_7_266 vssd1 vccd1 sky130_fd_sc_hd__tapvpwrvgnd_1
XFILLER_47_126 vssd1 vssd1 vccd1 vccd1 sky130_fd_sc_hd__fill_1
XANTENNA__8013__A2 _7864_/B vssd1 vssd1 vccd1 vccd1 sky130_fd_sc_hd__diode_2
XTAP_TAPCELL_ROW_87_1071 vssd1 vccd1 sky130_fd_sc_hd__tapvpwrvgnd_1
XTAP_TAPCELL_ROW_61_809 vssd1 vccd1 sky130_fd_sc_hd__tapvpwrvgnd_1
XFILLER_70_195 vssd1 vssd1 vccd1 vccd1 sky130_fd_sc_hd__fill_1
XFILLER_11_295 vssd1 vssd1 vccd1 vccd1 sky130_fd_sc_hd__fill_4
Xwire153 _6174_/A vssd1 vssd1 vccd1 vccd1 _7966_/A sky130_fd_sc_hd__buf_2
Xload_slew114 _4707_/B vssd1 vssd1 vccd1 vccd1 _4598_/B sky130_fd_sc_hd__buf_4
XFILLER_22_5 vssd1 vssd1 vccd1 vccd1 sky130_fd_sc_hd__fill_1
XANTENNA__7460__B1 _8125_/B vssd1 vssd1 vccd1 vccd1 sky130_fd_sc_hd__diode_2
XFILLER_81_405 vssd1 vssd1 vccd1 vccd1 sky130_fd_sc_hd__fill_1
XTAP_TAPCELL_ROW_77_975 vssd1 vccd1 sky130_fd_sc_hd__tapvpwrvgnd_1
Xload_slew50 _6997_/B vssd1 vssd1 vccd1 vccd1 _7820_/B sky130_fd_sc_hd__buf_4
X_5900_ _5900_/A _6167_/A vssd1 vssd1 vccd1 vccd1 _5900_/Y sky130_fd_sc_hd__nor2_2
XTAP_TAPCELL_ROW_49_688 vssd1 vccd1 sky130_fd_sc_hd__tapvpwrvgnd_1
Xload_slew61 _5289_/B vssd1 vssd1 vccd1 vccd1 _5902_/B sky130_fd_sc_hd__clkbuf_4
X_6880_ _6880_/A _6880_/B vssd1 vssd1 vccd1 vccd1 _6881_/C sky130_fd_sc_hd__or2_2
X_5831_ _5832_/A _5832_/B vssd1 vssd1 vccd1 vccd1 _6047_/B sky130_fd_sc_hd__nand2b_2
X_5762_ _5192_/A _5762_/A2 _5191_/A _5190_/Y _5763_/B vssd1 vssd1 vccd1 vccd1 _5979_/B
+ sky130_fd_sc_hd__o311a_2
XTAP_TAPCELL_ROW_32_522 vssd1 vccd1 sky130_fd_sc_hd__tapvpwrvgnd_1
X_7501_ _7501_/A _7501_/B vssd1 vssd1 vccd1 vccd1 _7503_/C sky130_fd_sc_hd__xnor2_2
X_4713_ _4713_/A _4713_/B vssd1 vssd1 vccd1 vccd1 _4713_/Y sky130_fd_sc_hd__nand2_2
XANTENNA__4329__A1 _8425_/D vssd1 vssd1 vccd1 vccd1 sky130_fd_sc_hd__diode_2
X_5693_ _5301_/A _5301_/B _5301_/Y _5692_/Y vssd1 vssd1 vccd1 vccd1 _5884_/A sky130_fd_sc_hd__a211oi_2
XANTENNA__4329__B2 _5020_/A vssd1 vssd1 vccd1 vccd1 sky130_fd_sc_hd__diode_2
XFILLER_30_19 vssd1 vssd1 vccd1 vccd1 sky130_fd_sc_hd__fill_8
X_7432_ _7433_/B _7433_/A vssd1 vssd1 vccd1 vccd1 _7532_/A sky130_fd_sc_hd__nand2b_2
X_4644_ _4644_/A _4644_/B vssd1 vssd1 vccd1 vccd1 _4661_/B sky130_fd_sc_hd__xnor2_2
X_7363_ _7351_/A _7350_/B _7348_/Y vssd1 vssd1 vccd1 vccd1 _7421_/A sky130_fd_sc_hd__a21o_2
X_4575_ _4564_/A _4564_/B _4566_/X vssd1 vssd1 vccd1 vccd1 _4578_/A sky130_fd_sc_hd__o21ai_2
X_7294_ _7088_/A _7088_/B _7086_/X vssd1 vssd1 vccd1 vccd1 _7307_/A sky130_fd_sc_hd__a21o_2
X_6314_ _6313_/B _6314_/B vssd1 vssd1 vccd1 vccd1 _6315_/B sky130_fd_sc_hd__and2b_2
X_6245_ _6245_/A _6245_/B vssd1 vssd1 vccd1 vccd1 _6246_/B sky130_fd_sc_hd__xnor2_2
X_6176_ _6177_/A _6177_/B _6177_/C vssd1 vssd1 vccd1 vccd1 _6367_/A sky130_fd_sc_hd__o21ai_2
XFILLER_29_104 vssd1 vssd1 vccd1 vccd1 sky130_fd_sc_hd__fill_1
X_5127_ _6970_/A _5915_/B vssd1 vssd1 vccd1 vccd1 _5767_/A sky130_fd_sc_hd__nand2_2
XTAP_TAPCELL_ROW_4_236 vssd1 vccd1 sky130_fd_sc_hd__tapvpwrvgnd_1
X_5058_ _8413_/D _5254_/B vssd1 vssd1 vccd1 vccd1 _5059_/B sky130_fd_sc_hd__nand2_2
XPHY_EDGE_ROW_2_Right_2 vssd1 vssd1 vccd1 vccd1 sky130_fd_sc_hd__decap_3
XFILLER_13_505 vssd1 vssd1 vccd1 vccd1 sky130_fd_sc_hd__fill_2
XFILLER_52_195 vssd1 vssd1 vccd1 vccd1 sky130_fd_sc_hd__fill_1
XANTENNA__5000__A _5928_/A vssd1 vssd1 vccd1 vccd1 sky130_fd_sc_hd__diode_2
XANTENNA__8030__B _8136_/A vssd1 vssd1 vccd1 vccd1 sky130_fd_sc_hd__diode_2
XANTENNA__6485__B _6485_/B vssd1 vssd1 vccd1 vccd1 sky130_fd_sc_hd__diode_2
XFILLER_0_453 vssd1 vssd1 vccd1 vccd1 sky130_fd_sc_hd__fill_1
XFILLER_0_475 vssd1 vssd1 vccd1 vccd1 sky130_fd_sc_hd__fill_1
XFILLER_0_486 vssd1 vssd1 vccd1 vccd1 sky130_fd_sc_hd__fill_2
XFILLER_48_435 vssd1 vssd1 vccd1 vccd1 sky130_fd_sc_hd__fill_1
XFILLER_75_210 vssd1 vssd1 vccd1 vccd1 sky130_fd_sc_hd__fill_1
XFILLER_48_468 vssd1 vssd1 vccd1 vccd1 sky130_fd_sc_hd__fill_1
XFILLER_35_129 vssd1 vssd1 vccd1 vccd1 sky130_fd_sc_hd__fill_1
XFILLER_63_449 vssd1 vssd1 vccd1 vccd1 sky130_fd_sc_hd__fill_4
XTAP_TAPCELL_ROW_74_945 vssd1 vccd1 sky130_fd_sc_hd__tapvpwrvgnd_1
XTAP_TAPCELL_ROW_46_658 vssd1 vccd1 sky130_fd_sc_hd__tapvpwrvgnd_1
XANTENNA__4292__Y _5163_/B vssd1 vssd1 vccd1 vccd1 sky130_fd_sc_hd__diode_2
XANTENNA__4559__A1 _8429_/D vssd1 vssd1 vccd1 vccd1 sky130_fd_sc_hd__diode_2
XANTENNA__6006__A _6006_/A vssd1 vssd1 vccd1 vccd1 sky130_fd_sc_hd__diode_2
XFILLER_31_324 vssd1 vssd1 vccd1 vccd1 sky130_fd_sc_hd__fill_1
XANTENNA__5845__A _6438_/A vssd1 vssd1 vccd1 vccd1 sky130_fd_sc_hd__diode_2
XFILLER_84_7 vssd1 vssd1 vccd1 vccd1 sky130_fd_sc_hd__fill_1
XFILLER_8_531 vssd1 vssd1 vccd1 vccd1 sky130_fd_sc_hd__fill_1
XFILLER_6_43 vssd1 vssd1 vccd1 vccd1 sky130_fd_sc_hd__fill_2
XANTENNA_max_cap155_X _6978_/A vssd1 vssd1 vccd1 vccd1 sky130_fd_sc_hd__diode_2
X_4360_ _4362_/A _4360_/B vssd1 vssd1 vccd1 vccd1 _4360_/X sky130_fd_sc_hd__and2_2
X_4291_ _4557_/A _4598_/B vssd1 vssd1 vccd1 vccd1 _4516_/B sky130_fd_sc_hd__nand2_2
X_6030_ _6517_/A _8228_/A _8233_/A _6517_/B vssd1 vssd1 vccd1 vccd1 _6032_/A sky130_fd_sc_hd__a22oi_2
XTAP_TAPCELL_ROW_1_206 vssd1 vccd1 sky130_fd_sc_hd__tapvpwrvgnd_1
X_7981_ _7982_/A _7982_/B vssd1 vssd1 vccd1 vccd1 _7981_/Y sky130_fd_sc_hd__nor2_2
XFILLER_47_490 vssd1 vssd1 vccd1 vccd1 sky130_fd_sc_hd__fill_2
X_6932_ _7174_/B _6932_/B vssd1 vssd1 vccd1 vccd1 _6934_/C sky130_fd_sc_hd__or2_2
X_6863_ _6863_/A _6957_/B vssd1 vssd1 vccd1 vccd1 _6865_/B sky130_fd_sc_hd__nor2_2
X_5814_ _6397_/C _6198_/A vssd1 vssd1 vccd1 vccd1 _5821_/A sky130_fd_sc_hd__nand2_2
XTAP_TAPCELL_ROW_17_371 vssd1 vccd1 sky130_fd_sc_hd__tapvpwrvgnd_1
X_6794_ _6794_/A _6794_/B vssd1 vssd1 vccd1 vccd1 _6877_/A sky130_fd_sc_hd__xnor2_2
XFILLER_10_519 vssd1 vssd1 vccd1 vccd1 sky130_fd_sc_hd__fill_4
XFILLER_41_29 vssd1 vssd1 vccd1 vccd1 sky130_fd_sc_hd__fill_1
X_5745_ _5746_/A _5746_/B vssd1 vssd1 vccd1 vccd1 _5745_/X sky130_fd_sc_hd__and2b_2
XANTENNA_fanout317_A _6035_/D vssd1 vssd1 vccd1 vccd1 sky130_fd_sc_hd__diode_2
X_5676_ _5676_/A _5676_/B vssd1 vssd1 vccd1 vccd1 _5676_/Y sky130_fd_sc_hd__xnor2_2
X_7415_ _7346_/A _7346_/B _7345_/A vssd1 vssd1 vccd1 vccd1 _7417_/B sky130_fd_sc_hd__a21o_2
X_4627_ _4626_/A _4626_/B _4645_/A _4599_/C vssd1 vssd1 vccd1 vccd1 _4634_/A sky130_fd_sc_hd__a2bb2o_2
X_8395_ _8402_/CLK _8395_/D fanout378/X vssd1 vssd1 vccd1 vccd1 _8395_/Q sky130_fd_sc_hd__dfstp_2
Xhold520 _8391_/Q vssd1 vssd1 vccd1 vccd1 _8450_/D sky130_fd_sc_hd__dlygate4sd3_1
Xhold553 _8432_/Q vssd1 vssd1 vccd1 vccd1 hold553/X sky130_fd_sc_hd__dlygate4sd3_1
Xhold542 _8332_/Q vssd1 vssd1 vccd1 vccd1 hold542/X sky130_fd_sc_hd__dlygate4sd3_1
Xhold531 _8388_/Q vssd1 vssd1 vccd1 vccd1 _8447_/D sky130_fd_sc_hd__dlygate4sd3_1
X_7346_ _7346_/A _7346_/B vssd1 vssd1 vccd1 vccd1 _7349_/A sky130_fd_sc_hd__xnor2_2
X_4558_ _4558_/A _4558_/B vssd1 vssd1 vccd1 vccd1 _4568_/B sky130_fd_sc_hd__or2_4
X_7277_ _7277_/A _7277_/B _7277_/C vssd1 vssd1 vccd1 vccd1 _7279_/A sky130_fd_sc_hd__and3_2
X_4489_ _4365_/A _4483_/A _4368_/A _4368_/B vssd1 vssd1 vccd1 vccd1 _4492_/B sky130_fd_sc_hd__o22ai_2
X_6228_ _6228_/A _6228_/B vssd1 vssd1 vccd1 vccd1 _6230_/B sky130_fd_sc_hd__or2_2
XFILLER_66_15 vssd1 vssd1 vccd1 vccd1 sky130_fd_sc_hd__fill_4
X_6159_ _8410_/D _6762_/B vssd1 vssd1 vccd1 vccd1 _6161_/B sky130_fd_sc_hd__nand2_2
XTAP_TAPCELL_ROW_84_1041 vssd1 vccd1 sky130_fd_sc_hd__tapvpwrvgnd_1
XTAP_TAPCELL_ROW_71_915 vssd1 vccd1 sky130_fd_sc_hd__tapvpwrvgnd_1
XFILLER_53_493 vssd1 vssd1 vccd1 vccd1 sky130_fd_sc_hd__fill_8
XFILLER_82_69 vssd1 vssd1 vccd1 vccd1 sky130_fd_sc_hd__fill_1
XTAP_TAPCELL_ROW_43_628 vssd1 vccd1 sky130_fd_sc_hd__tapvpwrvgnd_1
XFILLER_40_121 vssd1 vssd1 vccd1 vccd1 sky130_fd_sc_hd__fill_2
XANTENNA__7864__B _7864_/B vssd1 vssd1 vccd1 vccd1 sky130_fd_sc_hd__diode_2
XFILLER_9_328 vssd1 vssd1 vccd1 vccd1 sky130_fd_sc_hd__fill_1
XANTENNA__8398__D _8398_/D vssd1 vssd1 vccd1 vccd1 sky130_fd_sc_hd__diode_2
XFILLER_5_545 vssd1 vssd1 vccd1 vccd1 sky130_fd_sc_hd__fill_2
XFILLER_48_210 vssd1 vssd1 vccd1 vccd1 sky130_fd_sc_hd__fill_2
XANTENNA__6218__A1 _7140_/A vssd1 vssd1 vccd1 vccd1 sky130_fd_sc_hd__diode_2
XANTENNA__6218__B2 _8126_/A vssd1 vssd1 vccd1 vccd1 sky130_fd_sc_hd__diode_2
XFILLER_48_232 vssd1 vssd1 vccd1 vccd1 sky130_fd_sc_hd__fill_1
XANTENNA__6769__A2 _6757_/B vssd1 vssd1 vccd1 vccd1 sky130_fd_sc_hd__diode_2
XFILLER_63_246 vssd1 vssd1 vccd1 vccd1 sky130_fd_sc_hd__fill_4
XTAP_TAPCELL_ROW_59_794 vssd1 vccd1 sky130_fd_sc_hd__tapvpwrvgnd_1
XANTENNA__7120__A _7120_/A vssd1 vssd1 vccd1 vccd1 sky130_fd_sc_hd__diode_2
XFILLER_16_195 vssd1 vssd1 vccd1 vccd1 sky130_fd_sc_hd__fill_1
XTAP_TAPCELL_ROW_14_341 vssd1 vccd1 sky130_fd_sc_hd__tapvpwrvgnd_1
XFILLER_75_3 vssd1 vssd1 vccd1 vccd1 sky130_fd_sc_hd__fill_4
X_5530_ _5530_/A _5530_/B _5564_/A vssd1 vssd1 vccd1 vccd1 _5531_/B sky130_fd_sc_hd__or3_2
X_5461_ _5461_/A _5461_/B _5461_/C vssd1 vssd1 vccd1 vccd1 _5495_/A sky130_fd_sc_hd__and3_2
X_7200_ _7201_/A _7201_/B _7201_/C vssd1 vssd1 vccd1 vccd1 _7290_/B sky130_fd_sc_hd__o21a_2
X_4412_ _4412_/A _4412_/B vssd1 vssd1 vccd1 vccd1 _4445_/A sky130_fd_sc_hd__xor2_2
X_8180_ _8173_/X _8177_/B _8179_/X vssd1 vssd1 vccd1 vccd1 _8180_/Y sky130_fd_sc_hd__o21ai_2
X_5392_ _8208_/A _5392_/B vssd1 vssd1 vccd1 vccd1 _5396_/A sky130_fd_sc_hd__nand2_2
XANTENNA__4919__A _4919_/A vssd1 vssd1 vccd1 vccd1 sky130_fd_sc_hd__diode_2
X_7131_ _7131_/A _7853_/A vssd1 vssd1 vccd1 vccd1 _7132_/B sky130_fd_sc_hd__nand2_2
X_4343_ _5163_/B _4342_/Y _4299_/A _4250_/X vssd1 vssd1 vccd1 vccd1 _4343_/Y sky130_fd_sc_hd__a211oi_2
XANTENNA__4197__Y _6724_/A vssd1 vssd1 vccd1 vccd1 sky130_fd_sc_hd__diode_2
Xfanout329 _8341_/Q vssd1 vssd1 vccd1 vccd1 _8196_/A sky130_fd_sc_hd__clkdlybuf4s25_1
Xfanout318 _6035_/D vssd1 vssd1 vccd1 vccd1 _6894_/B sky130_fd_sc_hd__clkdlybuf4s25_1
Xfanout307 _7140_/D vssd1 vssd1 vccd1 vccd1 _7723_/C sky130_fd_sc_hd__clkdlybuf4s25_1
X_7062_ _8416_/D _7685_/B vssd1 vssd1 vccd1 vccd1 _7063_/B sky130_fd_sc_hd__and2_2
X_4274_ _4274_/A _4274_/B _4274_/C vssd1 vssd1 vccd1 vccd1 _4275_/B sky130_fd_sc_hd__nand3_2
X_6013_ _6013_/A _6013_/B vssd1 vssd1 vccd1 vccd1 _6026_/A sky130_fd_sc_hd__xnor2_2
XANTENNA__7949__B _8082_/C vssd1 vssd1 vccd1 vccd1 sky130_fd_sc_hd__diode_2
XANTENNA__8362__CLK _8405_/CLK vssd1 vssd1 vccd1 vccd1 sky130_fd_sc_hd__diode_2
XANTENNA__4654__A _4709_/A vssd1 vssd1 vccd1 vccd1 sky130_fd_sc_hd__diode_2
XANTENNA__8126__A _8126_/A vssd1 vssd1 vccd1 vccd1 sky130_fd_sc_hd__diode_2
X_7964_ _7807_/A _7807_/B _7809_/A _7809_/B vssd1 vssd1 vccd1 vccd1 _7974_/A sky130_fd_sc_hd__o2bb2ai_2
XANTENNA_fanout267_A _6830_/B vssd1 vssd1 vccd1 vccd1 sky130_fd_sc_hd__diode_2
X_6915_ _6915_/A _6915_/B vssd1 vssd1 vccd1 vccd1 _6916_/B sky130_fd_sc_hd__nand2_2
X_7895_ _7895_/A _7998_/B _8267_/B _8125_/B vssd1 vssd1 vccd1 vccd1 _7895_/X sky130_fd_sc_hd__and4_2
XANTENNA__7185__A2 _8125_/B vssd1 vssd1 vccd1 vccd1 sky130_fd_sc_hd__diode_2
XFILLER_52_39 vssd1 vssd1 vccd1 vccd1 sky130_fd_sc_hd__fill_1
XFILLER_62_290 vssd1 vssd1 vccd1 vccd1 sky130_fd_sc_hd__fill_4
X_6846_ _6846_/A _6846_/B _6846_/C vssd1 vssd1 vccd1 vccd1 _6847_/B sky130_fd_sc_hd__nand3_2
X_6777_ _6778_/B _6778_/A vssd1 vssd1 vccd1 vccd1 _6777_/Y sky130_fd_sc_hd__nand2b_2
XANTENNA__5485__A _5842_/B vssd1 vssd1 vccd1 vccd1 sky130_fd_sc_hd__diode_2
XANTENNA_fanout222_X _6005_/B vssd1 vssd1 vccd1 vccd1 sky130_fd_sc_hd__diode_2
X_5728_ _5728_/A _5728_/B vssd1 vssd1 vccd1 vccd1 _5730_/B sky130_fd_sc_hd__xor2_2
X_8447_ clkload1/A _8447_/D load_slew360/X vssd1 vssd1 vccd1 vccd1 _8447_/Q sky130_fd_sc_hd__dfrtp_2
X_5659_ _8179_/A _5669_/B _5659_/C vssd1 vssd1 vccd1 vccd1 _5662_/B sky130_fd_sc_hd__nand3_2
XTAP_TAPCELL_ROW_20_399 vssd1 vccd1 sky130_fd_sc_hd__tapvpwrvgnd_1
XANTENNA__7893__B1 _8125_/B vssd1 vssd1 vccd1 vccd1 sky130_fd_sc_hd__diode_2
X_8378_ _8402_/CLK _8378_/D fanout372/X vssd1 vssd1 vccd1 vccd1 _8378_/Q sky130_fd_sc_hd__dfrtp_2
X_7329_ _7329_/A _7329_/B vssd1 vssd1 vccd1 vccd1 _7332_/A sky130_fd_sc_hd__xnor2_2
XFILLER_77_316 vssd1 vssd1 vccd1 vccd1 sky130_fd_sc_hd__fill_2
XFILLER_77_47 vssd1 vssd1 vccd1 vccd1 sky130_fd_sc_hd__fill_1
XFILLER_89_165 vssd1 vssd1 vccd1 vccd1 sky130_fd_sc_hd__fill_2
Xclkbuf_4_13_0_clk clkbuf_0_clk/X vssd1 vssd1 vccd1 vccd1 _8334_/CLK sky130_fd_sc_hd__clkbuf_8
XFILLER_73_544 vssd1 vssd1 vccd1 vccd1 sky130_fd_sc_hd__fill_2
XTAP_TAPCELL_ROW_56_764 vssd1 vccd1 sky130_fd_sc_hd__tapvpwrvgnd_1
XANTENNA__7875__A _7875_/A vssd1 vssd1 vccd1 vccd1 sky130_fd_sc_hd__diode_2
XFILLER_26_62 vssd1 vssd1 vccd1 vccd1 sky130_fd_sc_hd__fill_8
XTAP_TAPCELL_ROW_28_477 vssd1 vccd1 sky130_fd_sc_hd__tapvpwrvgnd_1
XFILLER_13_154 vssd1 vssd1 vccd1 vccd1 sky130_fd_sc_hd__fill_1
XFILLER_9_103 vssd1 vssd1 vccd1 vccd1 sky130_fd_sc_hd__fill_1
XANTENNA__6923__A2 _7723_/D vssd1 vssd1 vccd1 vccd1 sky130_fd_sc_hd__diode_2
XTAP_TAPCELL_ROW_11_311 vssd1 vccd1 sky130_fd_sc_hd__tapvpwrvgnd_1
XFILLER_42_72 vssd1 vssd1 vccd1 vccd1 sky130_fd_sc_hd__fill_2
Xrebuffer491 _8065_/Y vssd1 vssd1 vccd1 vccd1 _8072_/B1 sky130_fd_sc_hd__buf_2
Xrebuffer480 _5812_/X vssd1 vssd1 vccd1 vccd1 _5813_/B sky130_fd_sc_hd__buf_2
XANTENNA__5842__B _5842_/B vssd1 vssd1 vccd1 vccd1 sky130_fd_sc_hd__diode_2
XANTENNA__7100__A2 _7966_/B vssd1 vssd1 vccd1 vccd1 sky130_fd_sc_hd__diode_2
XFILLER_68_327 vssd1 vssd1 vccd1 vccd1 sky130_fd_sc_hd__fill_4
XFILLER_17_460 vssd1 vssd1 vccd1 vccd1 sky130_fd_sc_hd__fill_1
X_4961_ _4874_/X _4876_/Y _4969_/B _4958_/Y vssd1 vssd1 vccd1 vccd1 _4962_/B sky130_fd_sc_hd__o211a_2
X_7680_ _8081_/A _8082_/D vssd1 vssd1 vccd1 vccd1 _7680_/Y sky130_fd_sc_hd__nor2_2
X_6700_ _6591_/A _6591_/B _6589_/Y vssd1 vssd1 vccd1 vccd1 _6710_/A sky130_fd_sc_hd__a21o_2
X_4892_ _4836_/A _4836_/B _4834_/Y vssd1 vssd1 vccd1 vccd1 _4904_/A sky130_fd_sc_hd__a21o_2
X_6631_ _6631_/A _6631_/B _6631_/C vssd1 vssd1 vccd1 vccd1 _6631_/X sky130_fd_sc_hd__or3_2
XFILLER_32_485 vssd1 vssd1 vccd1 vccd1 sky130_fd_sc_hd__fill_4
XANTENNA__8116__A1 _8125_/A vssd1 vssd1 vccd1 vccd1 sky130_fd_sc_hd__diode_2
X_8301_ _6397_/C input8/X _8303_/S vssd1 vssd1 vccd1 vccd1 _8376_/D sky130_fd_sc_hd__mux2_1
X_6562_ _6563_/A _6563_/B vssd1 vssd1 vccd1 vccd1 _6873_/B sky130_fd_sc_hd__nor2_2
XFILLER_8_180 vssd1 vssd1 vccd1 vccd1 sky130_fd_sc_hd__fill_8
X_6493_ _7131_/A _6892_/C vssd1 vssd1 vccd1 vccd1 _6494_/B sky130_fd_sc_hd__nand2_2
X_5513_ _5513_/A _5513_/B _5513_/C vssd1 vssd1 vccd1 vccd1 _5514_/B sky130_fd_sc_hd__or3_2
X_8232_ _8233_/A input7/X vssd1 vssd1 vccd1 vccd1 _8234_/A sky130_fd_sc_hd__or2_2
X_5444_ _5444_/A _5444_/B vssd1 vssd1 vccd1 vccd1 _5448_/A sky130_fd_sc_hd__or2_2
X_8163_ _8162_/X _8161_/Y hold547/X _6689_/A vssd1 vssd1 vccd1 vccd1 _8334_/D sky130_fd_sc_hd__a2bb2o_2
Xfanout104 _4692_/B vssd1 vssd1 vccd1 vccd1 wire105/A sky130_fd_sc_hd__clkdlybuf4s25_1
X_7114_ _7114_/A _7114_/B vssd1 vssd1 vccd1 vccd1 _7116_/B sky130_fd_sc_hd__xor2_2
X_5375_ _5375_/A _5375_/B vssd1 vssd1 vccd1 vccd1 _5376_/B sky130_fd_sc_hd__nand2_2
XFILLER_59_327 vssd1 vssd1 vccd1 vccd1 sky130_fd_sc_hd__fill_8
XFILLER_86_113 vssd1 vssd1 vccd1 vccd1 sky130_fd_sc_hd__fill_2
X_8094_ _8094_/A _8094_/B vssd1 vssd1 vccd1 vccd1 _8095_/B sky130_fd_sc_hd__xnor2_2
Xfanout115 _4289_/Y vssd1 vssd1 vccd1 vccd1 _4487_/B sky130_fd_sc_hd__clkdlybuf4s25_1
Xfanout126 _4194_/Y vssd1 vssd1 vccd1 vccd1 _6970_/A sky130_fd_sc_hd__clkdlybuf4s25_1
X_4326_ _4744_/A wire92/X vssd1 vssd1 vccd1 vccd1 _4334_/A sky130_fd_sc_hd__nand2_2
Xfanout148 _4360_/X vssd1 vssd1 vccd1 vccd1 _4709_/C sky130_fd_sc_hd__clkdlybuf4s25_1
X_7045_ _7045_/A _7045_/B vssd1 vssd1 vccd1 vccd1 _7046_/C sky130_fd_sc_hd__nand2_2
X_4257_ _4303_/A _4257_/B vssd1 vssd1 vccd1 vccd1 _4257_/Y sky130_fd_sc_hd__nand2_2
X_4188_ _6588_/A vssd1 vssd1 vccd1 vccd1 _5703_/A sky130_fd_sc_hd__inv_2
XANTENNA__4384__A _8430_/D vssd1 vssd1 vccd1 vccd1 sky130_fd_sc_hd__diode_2
XFILLER_67_393 vssd1 vssd1 vccd1 vccd1 sky130_fd_sc_hd__fill_1
XFILLER_82_352 vssd1 vssd1 vccd1 vccd1 sky130_fd_sc_hd__fill_1
XFILLER_82_363 vssd1 vssd1 vccd1 vccd1 sky130_fd_sc_hd__fill_1
XFILLER_27_279 vssd1 vssd1 vccd1 vccd1 sky130_fd_sc_hd__fill_1
XFILLER_63_38 vssd1 vssd1 vccd1 vccd1 sky130_fd_sc_hd__fill_4
X_7947_ _7947_/A _7947_/B vssd1 vssd1 vccd1 vccd1 _7948_/B sky130_fd_sc_hd__nand2_2
XFILLER_70_569 vssd1 vssd1 vccd1 vccd1 sky130_fd_sc_hd__fill_1
X_7878_ _7878_/A _7878_/B vssd1 vssd1 vccd1 vccd1 _7880_/B sky130_fd_sc_hd__nor2_2
XTAP_TAPCELL_ROW_81_1011 vssd1 vccd1 sky130_fd_sc_hd__tapvpwrvgnd_1
XTAP_TAPCELL_ROW_53_734 vssd1 vccd1 sky130_fd_sc_hd__tapvpwrvgnd_1
XTAP_TAPCELL_ROW_25_447 vssd1 vccd1 sky130_fd_sc_hd__tapvpwrvgnd_1
X_6829_ _6830_/A _7864_/B _7875_/C _6830_/B vssd1 vssd1 vccd1 vccd1 _6831_/A sky130_fd_sc_hd__a22oi_2
XFILLER_10_113 vssd1 vssd1 vccd1 vccd1 sky130_fd_sc_hd__fill_2
XFILLER_10_135 vssd1 vssd1 vccd1 vccd1 sky130_fd_sc_hd__fill_2
XFILLER_5_3 vssd1 vssd1 vccd1 vccd1 sky130_fd_sc_hd__fill_1
XANTENNA_fanout85_X _6701_/B vssd1 vssd1 vccd1 vccd1 sky130_fd_sc_hd__diode_2
XFILLER_77_113 vssd1 vssd1 vccd1 vccd1 sky130_fd_sc_hd__fill_2
XFILLER_58_360 vssd1 vssd1 vccd1 vccd1 sky130_fd_sc_hd__fill_1
XFILLER_77_157 vssd1 vssd1 vccd1 vccd1 sky130_fd_sc_hd__fill_2
XANTENNA__4294__A _5163_/B vssd1 vssd1 vccd1 vccd1 sky130_fd_sc_hd__diode_2
XFILLER_46_544 vssd1 vssd1 vccd1 vccd1 sky130_fd_sc_hd__fill_1
XFILLER_46_555 vssd1 vssd1 vccd1 vccd1 sky130_fd_sc_hd__fill_1
XFILLER_61_503 vssd1 vssd1 vccd1 vccd1 sky130_fd_sc_hd__fill_1
XFILLER_73_363 vssd1 vssd1 vccd1 vccd1 sky130_fd_sc_hd__fill_2
X_5160_ _5160_/A _5160_/B vssd1 vssd1 vccd1 vccd1 _5174_/A sky130_fd_sc_hd__nor2_2
XANTENNA__6684__A _6685_/A vssd1 vssd1 vccd1 vccd1 sky130_fd_sc_hd__diode_2
X_5091_ _8408_/D _5902_/B vssd1 vssd1 vccd1 vccd1 _5092_/B sky130_fd_sc_hd__nand2_2
XANTENNA__6834__D _7723_/D vssd1 vssd1 vccd1 vccd1 sky130_fd_sc_hd__diode_2
X_7801_ _7800_/X _7799_/Y hold549/X _6689_/A vssd1 vssd1 vccd1 vccd1 _8331_/D sky130_fd_sc_hd__a2bb2o_2
X_5993_ _5993_/A _5993_/B _5994_/A vssd1 vssd1 vccd1 vccd1 _5993_/X sky130_fd_sc_hd__and3_2
XFILLER_91_171 vssd1 vssd1 vccd1 vccd1 sky130_fd_sc_hd__fill_1
X_7732_ _7537_/B _7539_/B _7537_/A vssd1 vssd1 vccd1 vccd1 _7742_/A sky130_fd_sc_hd__o21ba_2
X_4944_ _4944_/A _4944_/B vssd1 vssd1 vccd1 vccd1 _4947_/B sky130_fd_sc_hd__xnor2_2
XANTENNA__5747__B _6712_/B vssd1 vssd1 vccd1 vccd1 sky130_fd_sc_hd__diode_2
XANTENNA__8400__CLK _8405_/CLK vssd1 vssd1 vccd1 vccd1 sky130_fd_sc_hd__diode_2
XTAP_TAPCELL_ROW_50_704 vssd1 vccd1 sky130_fd_sc_hd__tapvpwrvgnd_1
X_7663_ _7606_/A _7606_/B _7607_/Y vssd1 vssd1 vccd1 vccd1 _7706_/B sky130_fd_sc_hd__a21bo_2
X_4875_ _4873_/X _4875_/A2 _4799_/X _4801_/X vssd1 vssd1 vccd1 vccd1 _4875_/Y sky130_fd_sc_hd__a211oi_4
XTAP_TAPCELL_ROW_22_417 vssd1 vccd1 sky130_fd_sc_hd__tapvpwrvgnd_1
XANTENNA_fanout132_A _8423_/D vssd1 vssd1 vccd1 vccd1 sky130_fd_sc_hd__diode_2
X_7594_ _7594_/A _7594_/B _7594_/C vssd1 vssd1 vccd1 vccd1 _7595_/B sky130_fd_sc_hd__or3_2
X_6614_ _6332_/B _6614_/B _6970_/A vssd1 vssd1 vccd1 vccd1 _6615_/B sky130_fd_sc_hd__and3b_2
X_6545_ _6545_/A _6545_/B _6545_/C vssd1 vssd1 vccd1 vccd1 _6546_/B sky130_fd_sc_hd__and3_2
X_8215_ _8215_/A input4/X vssd1 vssd1 vccd1 vccd1 _8222_/B sky130_fd_sc_hd__nor2_2
X_6476_ _6476_/A _6476_/B vssd1 vssd1 vccd1 vccd1 _6479_/A sky130_fd_sc_hd__xor2_2
X_5427_ _6482_/A _6006_/A vssd1 vssd1 vccd1 vccd1 _5432_/A sky130_fd_sc_hd__nand2_2
XFILLER_87_400 vssd1 vccd1 vssd1 vccd1 sky130_ef_sc_hd__decap_40_12
X_8146_ _8146_/A _8146_/B vssd1 vssd1 vccd1 vccd1 _8150_/A sky130_fd_sc_hd__xnor2_2
X_5358_ _8202_/A _5392_/B vssd1 vssd1 vccd1 vccd1 _5362_/A sky130_fd_sc_hd__nand2_2
XFILLER_59_113 vssd1 vssd1 vccd1 vccd1 sky130_fd_sc_hd__fill_1
X_8077_ _8077_/A _8077_/B vssd1 vssd1 vccd1 vccd1 _8078_/B sky130_fd_sc_hd__or2_2
X_4309_ _4761_/A _5954_/B vssd1 vssd1 vccd1 vccd1 _4421_/A sky130_fd_sc_hd__nand2_2
XFILLER_87_488 vssd1 vccd1 vssd1 vccd1 sky130_ef_sc_hd__decap_40_12
X_7028_ _7029_/A _7029_/B vssd1 vssd1 vccd1 vccd1 _7028_/Y sky130_fd_sc_hd__nor2_2
X_5289_ _8406_/D _5289_/B vssd1 vssd1 vccd1 vccd1 _5291_/B sky130_fd_sc_hd__nand2_2
XFILLER_74_138 vssd1 vssd1 vccd1 vccd1 sky130_fd_sc_hd__fill_2
XANTENNA__5938__A _6712_/A vssd1 vssd1 vccd1 vccd1 sky130_fd_sc_hd__diode_2
XFILLER_43_547 vssd1 vssd1 vccd1 vccd1 sky130_fd_sc_hd__fill_1
XFILLER_70_333 vssd1 vssd1 vccd1 vccd1 sky130_fd_sc_hd__fill_1
XTAP_TAPCELL_ROW_38_583 vssd1 vccd1 sky130_fd_sc_hd__tapvpwrvgnd_1
XANTENNA__5657__B _5657_/B vssd1 vssd1 vccd1 vccd1 sky130_fd_sc_hd__diode_2
XFILLER_70_355 vssd1 vssd1 vccd1 vccd1 sky130_fd_sc_hd__fill_1
XFILLER_70_377 vssd1 vssd1 vccd1 vccd1 sky130_fd_sc_hd__fill_1
XFILLER_70_399 vssd1 vssd1 vccd1 vccd1 sky130_fd_sc_hd__fill_1
XFILLER_11_477 vssd1 vccd1 vssd1 vccd1 sky130_ef_sc_hd__decap_40_12
XFILLER_23_74 vssd1 vssd1 vccd1 vccd1 sky130_fd_sc_hd__fill_1
Xwire368 wire368/A vssd1 vssd1 vccd1 vccd1 wire368/X sky130_fd_sc_hd__clkbuf_4
XANTENNA__5823__D _6798_/B vssd1 vssd1 vccd1 vccd1 sky130_fd_sc_hd__diode_2
XFILLER_65_105 vssd1 vssd1 vccd1 vccd1 sky130_fd_sc_hd__fill_2
XFILLER_78_477 vssd1 vssd1 vccd1 vccd1 sky130_fd_sc_hd__fill_4
XANTENNA__4295__Y _5703_/B vssd1 vssd1 vccd1 vccd1 sky130_fd_sc_hd__diode_2
XANTENNA__8208__B _8208_/B vssd1 vssd1 vccd1 vccd1 sky130_fd_sc_hd__diode_2
XFILLER_19_566 vssd1 vssd1 vccd1 vccd1 sky130_fd_sc_hd__fill_4
XFILLER_0_45 vssd1 vssd1 vccd1 vccd1 sky130_fd_sc_hd__fill_2
XFILLER_34_514 vssd1 vssd1 vccd1 vccd1 sky130_fd_sc_hd__fill_8
XFILLER_64_70 vssd1 vssd1 vccd1 vccd1 sky130_fd_sc_hd__fill_1
XANTENNA__4201__A_N input5/X vssd1 vssd1 vccd1 vccd1 sky130_fd_sc_hd__diode_2
XANTENNA__8319__A1 _8254_/B vssd1 vssd1 vccd1 vccd1 sky130_fd_sc_hd__diode_2
XFILLER_34_569 vssd1 vssd1 vccd1 vccd1 sky130_fd_sc_hd__fill_1
X_4660_ _4656_/B _4658_/B _4654_/X vssd1 vssd1 vccd1 vccd1 _4665_/A sky130_fd_sc_hd__a21o_2
X_6330_ _6330_/A _6330_/B vssd1 vssd1 vccd1 vccd1 _6330_/X sky130_fd_sc_hd__xor2_2
X_4591_ _4591_/A _4591_/B vssd1 vssd1 vccd1 vccd1 _4611_/B sky130_fd_sc_hd__xnor2_4
X_6261_ _6460_/A _8257_/A _6262_/C vssd1 vssd1 vccd1 vccd1 _6263_/A sky130_fd_sc_hd__a21oi_2
X_8000_ _8274_/A _7999_/B _7997_/X vssd1 vssd1 vccd1 vccd1 _8002_/A sky130_fd_sc_hd__a21bo_2
X_6192_ _6193_/B _6193_/A vssd1 vssd1 vccd1 vccd1 _6192_/X sky130_fd_sc_hd__and2b_2
X_5212_ _5212_/A _5212_/B vssd1 vssd1 vccd1 vccd1 _5230_/A sky130_fd_sc_hd__xor2_2
XFILLER_69_444 vssd1 vssd1 vccd1 vccd1 sky130_fd_sc_hd__fill_4
X_5143_ _5144_/A _5144_/B _5144_/C vssd1 vssd1 vccd1 vccd1 _5700_/B sky130_fd_sc_hd__o21ai_2
XFILLER_69_466 vssd1 vssd1 vccd1 vccd1 sky130_fd_sc_hd__fill_1
XANTENNA__8118__B _8118_/B vssd1 vssd1 vccd1 vccd1 sky130_fd_sc_hd__diode_2
XFILLER_84_436 vssd1 vssd1 vccd1 vccd1 sky130_fd_sc_hd__fill_2
X_5074_ _8411_/D _5254_/B vssd1 vssd1 vccd1 vccd1 _5085_/B sky130_fd_sc_hd__nand2_2
XFILLER_25_503 vssd1 vssd1 vccd1 vccd1 sky130_fd_sc_hd__fill_1
XFILLER_71_119 vssd1 vssd1 vccd1 vccd1 sky130_fd_sc_hd__fill_2
XFILLER_25_558 vssd1 vssd1 vccd1 vccd1 sky130_fd_sc_hd__fill_2
XANTENNA_fanout347_A _8337_/Q vssd1 vssd1 vccd1 vccd1 sky130_fd_sc_hd__diode_2
XFILLER_25_569 vssd1 vssd1 vccd1 vccd1 sky130_fd_sc_hd__fill_1
X_5976_ _5977_/A _5977_/B vssd1 vssd1 vccd1 vccd1 _5976_/X sky130_fd_sc_hd__or2_2
XTAP_TAPCELL_ROW_35_553 vssd1 vccd1 sky130_fd_sc_hd__tapvpwrvgnd_1
XANTENNA__4381__B _4931_/C vssd1 vssd1 vccd1 vccd1 sky130_fd_sc_hd__diode_2
X_7715_ _7853_/A _7714_/C _7714_/D _7714_/A vssd1 vssd1 vccd1 vccd1 _7716_/B sky130_fd_sc_hd__a22oi_2
X_4927_ _4925_/X _4927_/B vssd1 vssd1 vccd1 vccd1 _4929_/B sky130_fd_sc_hd__nand2b_2
XANTENNA_fanout135_X _4709_/A vssd1 vssd1 vccd1 vccd1 sky130_fd_sc_hd__diode_2
X_7646_ _7646_/A _7646_/B vssd1 vssd1 vccd1 vccd1 _7648_/B sky130_fd_sc_hd__xnor2_2
X_4858_ _8430_/D _5710_/B _5710_/C vssd1 vssd1 vccd1 vccd1 _4989_/A sky130_fd_sc_hd__and3_2
X_7577_ _7462_/A _7464_/B _7462_/B vssd1 vssd1 vccd1 vccd1 _7579_/C sky130_fd_sc_hd__o21ba_2
X_4789_ _4486_/B _4486_/A _4789_/B1 _4488_/B vssd1 vssd1 vccd1 vccd1 _4791_/B sky130_fd_sc_hd__o22ai_2
XANTENNA__8089__A3 _7095_/C vssd1 vssd1 vccd1 vccd1 sky130_fd_sc_hd__diode_2
XANTENNA_fanout302_X _8136_/B vssd1 vssd1 vccd1 vccd1 sky130_fd_sc_hd__diode_2
X_6528_ _6528_/A _6528_/B vssd1 vssd1 vccd1 vccd1 _6530_/B sky130_fd_sc_hd__xnor2_2
X_6459_ _6459_/A _6459_/B vssd1 vssd1 vccd1 vccd1 _6461_/A sky130_fd_sc_hd__nor2_2
XFILLER_79_208 vssd1 vssd1 vccd1 vccd1 sky130_fd_sc_hd__fill_2
X_8129_ _8129_/A _8129_/B vssd1 vssd1 vccd1 vccd1 _8141_/A sky130_fd_sc_hd__xnor2_2
XTAP_TAPCELL_ROW_7_267 vssd1 vccd1 sky130_fd_sc_hd__tapvpwrvgnd_1
XFILLER_18_85 vssd1 vssd1 vccd1 vccd1 sky130_fd_sc_hd__fill_4
XFILLER_43_333 vssd1 vssd1 vccd1 vccd1 sky130_fd_sc_hd__fill_1
XTAP_TAPCELL_ROW_87_1072 vssd1 vccd1 sky130_fd_sc_hd__tapvpwrvgnd_1
XFILLER_70_141 vssd1 vssd1 vccd1 vccd1 sky130_fd_sc_hd__fill_4
XFILLER_70_152 vssd1 vssd1 vccd1 vccd1 sky130_fd_sc_hd__fill_2
XANTENNA__4747__A _5020_/A vssd1 vssd1 vccd1 vccd1 sky130_fd_sc_hd__diode_2
XANTENNA__8219__A _8220_/A vssd1 vssd1 vccd1 vccd1 sky130_fd_sc_hd__diode_2
XFILLER_66_425 vssd1 vssd1 vccd1 vccd1 sky130_fd_sc_hd__fill_4
XTAP_TAPCELL_ROW_49_689 vssd1 vccd1 sky130_fd_sc_hd__tapvpwrvgnd_1
X_5830_ _6047_/A _5830_/B vssd1 vssd1 vccd1 vccd1 _5832_/B sky130_fd_sc_hd__and2_2
X_5761_ _5761_/A _5761_/B vssd1 vssd1 vccd1 vccd1 _5763_/B sky130_fd_sc_hd__xnor2_2
XTAP_TAPCELL_ROW_32_523 vssd1 vccd1 sky130_fd_sc_hd__tapvpwrvgnd_1
X_7500_ _7501_/B _7501_/A vssd1 vssd1 vccd1 vccd1 _7500_/X sky130_fd_sc_hd__and2b_2
X_4712_ _4713_/A _4713_/B vssd1 vssd1 vccd1 vccd1 _4712_/Y sky130_fd_sc_hd__nor2_2
X_7431_ _7212_/B _7214_/B _7212_/A vssd1 vssd1 vccd1 vccd1 _7433_/B sky130_fd_sc_hd__o21ba_2
X_5692_ _5692_/A _5692_/B vssd1 vssd1 vccd1 vccd1 _5692_/Y sky130_fd_sc_hd__xnor2_2
XANTENNA__4329__A2 _5147_/B vssd1 vssd1 vccd1 vccd1 sky130_fd_sc_hd__diode_2
X_4643_ _4643_/A _4643_/B vssd1 vssd1 vccd1 vccd1 _5052_/A sky130_fd_sc_hd__xnor2_4
X_7362_ hold548/X _7361_/X _7658_/S vssd1 vssd1 vccd1 vccd1 _8328_/D sky130_fd_sc_hd__mux2_1
X_4574_ _4574_/A _4574_/B vssd1 vssd1 vccd1 vccd1 _4590_/B sky130_fd_sc_hd__xnor2_4
X_7293_ _7104_/A _7104_/B _7101_/Y vssd1 vssd1 vccd1 vccd1 _7308_/A sky130_fd_sc_hd__a21o_2
X_6313_ _6314_/B _6313_/B vssd1 vssd1 vccd1 vccd1 _6315_/A sky130_fd_sc_hd__and2b_2
X_6244_ _6245_/B _6245_/A vssd1 vssd1 vccd1 vccd1 _6244_/X sky130_fd_sc_hd__and2b_2
XANTENNA__4657__A _8422_/D vssd1 vssd1 vccd1 vccd1 sky130_fd_sc_hd__diode_2
XANTENNA_fanout297_A _6517_/D vssd1 vssd1 vccd1 vccd1 sky130_fd_sc_hd__diode_2
X_6175_ _6175_/A _6175_/B vssd1 vssd1 vccd1 vccd1 _6177_/C sky130_fd_sc_hd__xor2_2
XFILLER_57_436 vssd1 vssd1 vccd1 vccd1 sky130_fd_sc_hd__fill_1
X_5126_ _8409_/D _5051_/A _5902_/B _5046_/Y vssd1 vssd1 vccd1 vccd1 _5198_/A sky130_fd_sc_hd__a31o_2
XTAP_TAPCELL_ROW_4_237 vssd1 vccd1 sky130_fd_sc_hd__tapvpwrvgnd_1
XFILLER_84_244 vssd1 vssd1 vccd1 vccd1 sky130_fd_sc_hd__fill_1
XFILLER_84_255 vssd1 vssd1 vccd1 vccd1 sky130_fd_sc_hd__fill_1
X_5057_ _8414_/D _6738_/B vssd1 vssd1 vccd1 vccd1 _5107_/A sky130_fd_sc_hd__nand2_2
XFILLER_72_417 vssd1 vssd1 vccd1 vccd1 sky130_fd_sc_hd__fill_1
XFILLER_72_439 vssd1 vssd1 vccd1 vccd1 sky130_fd_sc_hd__fill_2
XFILLER_52_141 vssd1 vssd1 vccd1 vccd1 sky130_fd_sc_hd__fill_2
X_5959_ _5959_/A _5959_/B vssd1 vssd1 vccd1 vccd1 _5962_/B sky130_fd_sc_hd__xor2_2
XFILLER_71_49 vssd1 vssd1 vccd1 vccd1 sky130_fd_sc_hd__fill_4
XFILLER_21_550 vssd1 vssd1 vccd1 vccd1 sky130_fd_sc_hd__fill_4
X_7629_ _7629_/A _7629_/B vssd1 vssd1 vccd1 vccd1 _7632_/A sky130_fd_sc_hd__xnor2_2
XFILLER_4_226 vssd1 vssd1 vccd1 vccd1 sky130_fd_sc_hd__fill_1
XFILLER_4_237 vssd1 vssd1 vccd1 vccd1 sky130_fd_sc_hd__fill_1
XFILLER_0_421 vssd1 vssd1 vccd1 vccd1 sky130_fd_sc_hd__fill_1
XFILLER_0_498 vssd1 vssd1 vccd1 vccd1 sky130_fd_sc_hd__fill_1
XFILLER_90_236 vssd1 vssd1 vccd1 vccd1 sky130_fd_sc_hd__fill_2
XFILLER_16_355 vssd1 vssd1 vccd1 vccd1 sky130_fd_sc_hd__fill_1
XTAP_TAPCELL_ROW_46_659 vssd1 vccd1 sky130_fd_sc_hd__tapvpwrvgnd_1
XANTENNA__6006__B _6485_/B vssd1 vssd1 vccd1 vccd1 sky130_fd_sc_hd__diode_2
XFILLER_12_550 vssd1 vssd1 vccd1 vccd1 sky130_fd_sc_hd__fill_1
XANTENNA__5845__B _6035_/D vssd1 vssd1 vccd1 vccd1 sky130_fd_sc_hd__diode_2
XFILLER_3_281 vssd1 vssd1 vccd1 vccd1 sky130_fd_sc_hd__fill_1
X_4290_ _4557_/A _4598_/B vssd1 vssd1 vccd1 vccd1 _4290_/X sky130_fd_sc_hd__and2_2
XFILLER_20_3 vssd1 vssd1 vccd1 vccd1 sky130_fd_sc_hd__fill_4
XTAP_TAPCELL_ROW_1_207 vssd1 vccd1 sky130_fd_sc_hd__tapvpwrvgnd_1
X_7980_ _7980_/A _7980_/B vssd1 vssd1 vccd1 vccd1 _7982_/B sky130_fd_sc_hd__xor2_2
X_6931_ _6931_/A _6931_/B vssd1 vssd1 vccd1 vccd1 _6932_/B sky130_fd_sc_hd__nor2_2
XFILLER_34_130 vssd1 vssd1 vccd1 vccd1 sky130_fd_sc_hd__fill_1
XFILLER_34_141 vssd1 vssd1 vccd1 vccd1 sky130_fd_sc_hd__fill_8
X_6862_ _8121_/A _8266_/A _6862_/C vssd1 vssd1 vccd1 vccd1 _6957_/B sky130_fd_sc_hd__and3_2
XFILLER_62_472 vssd1 vssd1 vccd1 vccd1 sky130_fd_sc_hd__fill_4
X_5813_ _5813_/A _5813_/B vssd1 vssd1 vccd1 vccd1 _5883_/A sky130_fd_sc_hd__xor2_2
XTAP_TAPCELL_ROW_17_372 vssd1 vccd1 sky130_fd_sc_hd__tapvpwrvgnd_1
X_6793_ _6390_/X _6680_/Y _6393_/X _6794_/B _6681_/A vssd1 vssd1 vccd1 vccd1 _6793_/X
+ sky130_fd_sc_hd__o311a_4
X_5744_ _5132_/A _5739_/A _5134_/A _5134_/B vssd1 vssd1 vccd1 vccd1 _5746_/B sky130_fd_sc_hd__o22ai_2
X_5675_ _5640_/X _5654_/X _5674_/X _5639_/X vssd1 vssd1 vccd1 vccd1 _5675_/X sky130_fd_sc_hd__a31o_2
XANTENNA__4151__S _4160_/B vssd1 vssd1 vccd1 vccd1 sky130_fd_sc_hd__diode_2
XANTENNA_fanout212_A _6397_/C vssd1 vssd1 vccd1 vccd1 sky130_fd_sc_hd__diode_2
X_8394_ clkload7/A _8394_/D load_slew373/X vssd1 vssd1 vccd1 vccd1 _8394_/Q sky130_fd_sc_hd__dfrtp_2
X_7414_ _7414_/A _7414_/B vssd1 vssd1 vccd1 vccd1 _7417_/A sky130_fd_sc_hd__xnor2_2
X_4626_ _4626_/A _4626_/B vssd1 vssd1 vccd1 vccd1 _4645_/A sky130_fd_sc_hd__xor2_2
X_7345_ _7345_/A _7345_/B vssd1 vssd1 vccd1 vccd1 _7346_/B sky130_fd_sc_hd__nor2_2
Xhold554 _8320_/Q vssd1 vssd1 vccd1 vccd1 hold554/X sky130_fd_sc_hd__dlygate4sd3_1
Xhold543 _8330_/Q vssd1 vssd1 vccd1 vccd1 hold543/X sky130_fd_sc_hd__dlygate4sd3_1
Xhold532 _8321_/Q vssd1 vssd1 vccd1 vccd1 _6081_/B sky130_fd_sc_hd__dlygate4sd3_1
Xhold521 _8392_/Q vssd1 vssd1 vccd1 vccd1 _8451_/D sky130_fd_sc_hd__dlygate4sd3_1
X_4557_ _4557_/A _4709_/D vssd1 vssd1 vccd1 vccd1 _4596_/A sky130_fd_sc_hd__and2_4
X_7276_ _7276_/A _7276_/B vssd1 vssd1 vccd1 vccd1 _7277_/C sky130_fd_sc_hd__xnor2_2
X_4488_ _4488_/A _4488_/B vssd1 vssd1 vccd1 vccd1 _4492_/A sky130_fd_sc_hd__xor2_2
X_6227_ _6228_/A _6228_/B vssd1 vssd1 vccd1 vccd1 _6428_/B sky130_fd_sc_hd__nand2_2
XFILLER_57_211 vssd1 vssd1 vccd1 vccd1 sky130_fd_sc_hd__fill_4
X_6158_ _5775_/B _6373_/A _6157_/Y vssd1 vssd1 vccd1 vccd1 _6161_/A sky130_fd_sc_hd__o21ba_2
XFILLER_57_244 vssd1 vssd1 vccd1 vccd1 sky130_fd_sc_hd__fill_1
X_5109_ _5110_/A _5110_/B vssd1 vssd1 vccd1 vccd1 _5109_/X sky130_fd_sc_hd__or2_2
X_6089_ _5935_/A _5935_/B _5934_/A vssd1 vssd1 vccd1 vccd1 _6136_/A sky130_fd_sc_hd__a21o_2
XANTENNA__7210__B _7426_/A vssd1 vssd1 vccd1 vccd1 sky130_fd_sc_hd__diode_2
XTAP_TAPCELL_ROW_84_1042 vssd1 vccd1 sky130_fd_sc_hd__tapvpwrvgnd_1
XFILLER_25_174 vssd1 vssd1 vccd1 vccd1 sky130_fd_sc_hd__fill_1
XTAP_TAPCELL_ROW_43_629 vssd1 vccd1 sky130_fd_sc_hd__tapvpwrvgnd_1
XFILLER_80_291 vssd1 vssd1 vccd1 vccd1 sky130_fd_sc_hd__fill_1
XFILLER_40_188 vssd1 vssd1 vccd1 vccd1 sky130_fd_sc_hd__fill_1
XFILLER_5_535 vssd1 vssd1 vccd1 vccd1 sky130_fd_sc_hd__fill_1
Xoutput30 _8329_/Q vssd1 vssd1 vccd1 vccd1 gpio_out[27] sky130_fd_sc_hd__clkdlybuf4s25_1
XFILLER_76_531 vssd1 vssd1 vccd1 vccd1 sky130_fd_sc_hd__fill_1
XFILLER_88_391 vssd1 vssd1 vccd1 vccd1 sky130_fd_sc_hd__fill_2
XFILLER_48_266 vssd1 vssd1 vccd1 vccd1 sky130_fd_sc_hd__fill_1
XFILLER_63_225 vssd1 vssd1 vccd1 vccd1 sky130_fd_sc_hd__fill_1
XTAP_TAPCELL_ROW_59_795 vssd1 vccd1 sky130_fd_sc_hd__tapvpwrvgnd_1
XFILLER_91_556 vssd1 vssd1 vccd1 vccd1 sky130_fd_sc_hd__fill_1
XFILLER_44_483 vssd1 vssd1 vccd1 vccd1 sky130_fd_sc_hd__fill_2
XANTENNA__8232__A _8233_/A vssd1 vssd1 vccd1 vccd1 sky130_fd_sc_hd__diode_2
XTAP_TAPCELL_ROW_14_342 vssd1 vccd1 sky130_fd_sc_hd__tapvpwrvgnd_1
X_5460_ _5460_/A _5460_/B vssd1 vssd1 vccd1 vccd1 _5461_/C sky130_fd_sc_hd__and2_2
XFILLER_68_3 vssd1 vssd1 vccd1 vccd1 sky130_fd_sc_hd__fill_2
X_4411_ _4411_/A _4411_/B vssd1 vssd1 vccd1 vccd1 _4412_/B sky130_fd_sc_hd__xor2_2
X_5391_ _5436_/B _5436_/A vssd1 vssd1 vccd1 vccd1 _5409_/A sky130_fd_sc_hd__nand2b_2
X_7130_ _7130_/A _7130_/B vssd1 vssd1 vccd1 vccd1 _7132_/A sky130_fd_sc_hd__nor2_2
X_4342_ _4342_/A _4342_/B vssd1 vssd1 vccd1 vccd1 _4342_/Y sky130_fd_sc_hd__nor2_2
Xfanout319 _8344_/Q vssd1 vssd1 vccd1 vccd1 _6035_/D sky130_fd_sc_hd__clkdlybuf4s25_1
Xfanout308 _8347_/Q vssd1 vssd1 vccd1 vccd1 _7140_/D sky130_fd_sc_hd__clkdlybuf4s25_1
X_7061_ _7004_/B _7059_/Y _7060_/Y vssd1 vssd1 vccd1 vccd1 _7063_/A sky130_fd_sc_hd__o21ba_2
X_4273_ _4274_/B _4274_/C _4274_/A vssd1 vssd1 vccd1 vccd1 _4282_/B sky130_fd_sc_hd__a21o_2
X_6012_ _6013_/A _6013_/B vssd1 vssd1 vccd1 vccd1 _6229_/A sky130_fd_sc_hd__nand2b_2
.ends
