* NGSPICE file created from fpgacell.ext - technology: sky130A

* Black-box entry subcircuit for sky130_fd_sc_hd__o22a_2 abstract view
.subckt sky130_fd_sc_hd__o22a_2 A1 A2 B1 B2 VGND VNB VPB VPWR X
.ends

* Black-box entry subcircuit for sky130_fd_sc_hd__a31o_1 abstract view
.subckt sky130_fd_sc_hd__a31o_1 A1 A2 A3 B1 VGND VNB VPB VPWR X
.ends

* Black-box entry subcircuit for sky130_fd_sc_hd__mux2_1 abstract view
.subckt sky130_fd_sc_hd__mux2_1 A0 A1 S VGND VNB VPB VPWR X
.ends

* Black-box entry subcircuit for sky130_fd_sc_hd__and2_1 abstract view
.subckt sky130_fd_sc_hd__and2_1 A B VGND VNB VPB VPWR X
.ends

* Black-box entry subcircuit for sky130_fd_sc_hd__fill_4 abstract view
.subckt sky130_fd_sc_hd__fill_4 VGND VNB VPB VPWR
.ends

* Black-box entry subcircuit for sky130_fd_sc_hd__fill_8 abstract view
.subckt sky130_fd_sc_hd__fill_8 VGND VNB VPB VPWR
.ends

* Black-box entry subcircuit for sky130_fd_sc_hd__fill_1 abstract view
.subckt sky130_fd_sc_hd__fill_1 VGND VNB VPB VPWR
.ends

* Black-box entry subcircuit for sky130_fd_sc_hd__tapvpwrvgnd_1 abstract view
.subckt sky130_fd_sc_hd__tapvpwrvgnd_1 VGND VPWR
.ends

* Black-box entry subcircuit for sky130_fd_sc_hd__fill_2 abstract view
.subckt sky130_fd_sc_hd__fill_2 VGND VNB VPB VPWR
.ends

* Black-box entry subcircuit for sky130_fd_sc_hd__a21oi_1 abstract view
.subckt sky130_fd_sc_hd__a21oi_1 A1 A2 B1 VGND VNB VPB VPWR Y
.ends

* Black-box entry subcircuit for sky130_fd_sc_hd__mux4_1 abstract view
.subckt sky130_fd_sc_hd__mux4_1 A0 A1 A2 A3 S0 S1 VGND VNB VPB VPWR X
.ends

* Black-box entry subcircuit for sky130_fd_sc_hd__buf_2 abstract view
.subckt sky130_fd_sc_hd__buf_2 A VGND VNB VPB VPWR X
.ends

* Black-box entry subcircuit for sky130_fd_sc_hd__clkbuf_4 abstract view
.subckt sky130_fd_sc_hd__clkbuf_4 A VGND VNB VPB VPWR X
.ends

* Black-box entry subcircuit for sky130_fd_sc_hd__o21ai_1 abstract view
.subckt sky130_fd_sc_hd__o21ai_1 A1 A2 B1 VGND VNB VPB VPWR Y
.ends

* Black-box entry subcircuit for sky130_fd_sc_hd__o221a_1 abstract view
.subckt sky130_fd_sc_hd__o221a_1 A1 A2 B1 B2 C1 VGND VNB VPB VPWR X
.ends

* Black-box entry subcircuit for sky130_fd_sc_hd__and4_2 abstract view
.subckt sky130_fd_sc_hd__and4_2 A B C D VGND VNB VPB VPWR X
.ends

* Black-box entry subcircuit for sky130_fd_sc_hd__o211a_1 abstract view
.subckt sky130_fd_sc_hd__o211a_1 A1 A2 B1 C1 VGND VNB VPB VPWR X
.ends

* Black-box entry subcircuit for sky130_fd_sc_hd__dfstp_2 abstract view
.subckt sky130_fd_sc_hd__dfstp_2 CLK D SET_B VGND VNB VPB VPWR Q
.ends

* Black-box entry subcircuit for sky130_fd_sc_hd__or3b_1 abstract view
.subckt sky130_fd_sc_hd__or3b_1 A B C_N VGND VNB VPB VPWR X
.ends

* Black-box entry subcircuit for sky130_fd_sc_hd__nand2_1 abstract view
.subckt sky130_fd_sc_hd__nand2_1 A B VGND VNB VPB VPWR Y
.ends

* Black-box entry subcircuit for sky130_fd_sc_hd__dfstp_1 abstract view
.subckt sky130_fd_sc_hd__dfstp_1 CLK D SET_B VGND VNB VPB VPWR Q
.ends

* Black-box entry subcircuit for sky130_fd_sc_hd__nor2_1 abstract view
.subckt sky130_fd_sc_hd__nor2_1 A B VGND VNB VPB VPWR Y
.ends

* Black-box entry subcircuit for sky130_fd_sc_hd__a21o_1 abstract view
.subckt sky130_fd_sc_hd__a21o_1 A1 A2 B1 VGND VNB VPB VPWR X
.ends

* Black-box entry subcircuit for sky130_ef_sc_hd__decap_40_12 abstract view
.subckt sky130_ef_sc_hd__decap_40_12 VPWR VGND VPB VNB
.ends

* Black-box entry subcircuit for sky130_fd_sc_hd__a41o_1 abstract view
.subckt sky130_fd_sc_hd__a41o_1 A1 A2 A3 A4 B1 VGND VNB VPB VPWR X
.ends

* Black-box entry subcircuit for sky130_fd_sc_hd__decap_3 abstract view
.subckt sky130_fd_sc_hd__decap_3 VGND VNB VPB VPWR
.ends

* Black-box entry subcircuit for sky130_fd_sc_hd__a31oi_2 abstract view
.subckt sky130_fd_sc_hd__a31oi_2 A1 A2 A3 B1 VGND VNB VPB VPWR Y
.ends

* Black-box entry subcircuit for sky130_fd_sc_hd__dfrtp_1 abstract view
.subckt sky130_fd_sc_hd__dfrtp_1 CLK D RESET_B VGND VNB VPB VPWR Q
.ends

* Black-box entry subcircuit for sky130_fd_sc_hd__or2_1 abstract view
.subckt sky130_fd_sc_hd__or2_1 A B VGND VNB VPB VPWR X
.ends

* Black-box entry subcircuit for sky130_fd_sc_hd__o21a_1 abstract view
.subckt sky130_fd_sc_hd__o21a_1 A1 A2 B1 VGND VNB VPB VPWR X
.ends

* Black-box entry subcircuit for sky130_fd_sc_hd__dlygate4sd3_1 abstract view
.subckt sky130_fd_sc_hd__dlygate4sd3_1 A VGND VNB VPB VPWR X
.ends

* Black-box entry subcircuit for sky130_fd_sc_hd__diode_2 abstract view
.subckt sky130_fd_sc_hd__diode_2 DIODE VGND VNB VPB VPWR
.ends

* Black-box entry subcircuit for sky130_fd_sc_hd__a211o_1 abstract view
.subckt sky130_fd_sc_hd__a211o_1 A1 A2 B1 C1 VGND VNB VPB VPWR X
.ends

* Black-box entry subcircuit for sky130_fd_sc_hd__a21boi_1 abstract view
.subckt sky130_fd_sc_hd__a21boi_1 A1 A2 B1_N VGND VNB VPB VPWR Y
.ends

* Black-box entry subcircuit for sky130_fd_sc_hd__nand2b_1 abstract view
.subckt sky130_fd_sc_hd__nand2b_1 A_N B VGND VNB VPB VPWR Y
.ends

* Black-box entry subcircuit for sky130_fd_sc_hd__nand2b_2 abstract view
.subckt sky130_fd_sc_hd__nand2b_2 A_N B VGND VNB VPB VPWR Y
.ends

* Black-box entry subcircuit for sky130_fd_sc_hd__inv_2 abstract view
.subckt sky130_fd_sc_hd__inv_2 A VGND VNB VPB VPWR Y
.ends

* Black-box entry subcircuit for sky130_fd_sc_hd__clkbuf_2 abstract view
.subckt sky130_fd_sc_hd__clkbuf_2 A VGND VNB VPB VPWR X
.ends

* Black-box entry subcircuit for sky130_fd_sc_hd__a32o_1 abstract view
.subckt sky130_fd_sc_hd__a32o_1 A1 A2 A3 B1 B2 VGND VNB VPB VPWR X
.ends

* Black-box entry subcircuit for sky130_fd_sc_hd__a221o_1 abstract view
.subckt sky130_fd_sc_hd__a221o_1 A1 A2 B1 B2 C1 VGND VNB VPB VPWR X
.ends

* Black-box entry subcircuit for sky130_fd_sc_hd__or3_1 abstract view
.subckt sky130_fd_sc_hd__or3_1 A B C VGND VNB VPB VPWR X
.ends

* Black-box entry subcircuit for sky130_fd_sc_hd__or4b_2 abstract view
.subckt sky130_fd_sc_hd__or4b_2 A B C D_N VGND VNB VPB VPWR X
.ends

* Black-box entry subcircuit for sky130_fd_sc_hd__o221ai_1 abstract view
.subckt sky130_fd_sc_hd__o221ai_1 A1 A2 B1 B2 C1 VGND VNB VPB VPWR Y
.ends

* Black-box entry subcircuit for sky130_fd_sc_hd__and3_1 abstract view
.subckt sky130_fd_sc_hd__and3_1 A B C VGND VNB VPB VPWR X
.ends

* Black-box entry subcircuit for sky130_fd_sc_hd__o311a_1 abstract view
.subckt sky130_fd_sc_hd__o311a_1 A1 A2 A3 B1 C1 VGND VNB VPB VPWR X
.ends

* Black-box entry subcircuit for sky130_fd_sc_hd__a31o_2 abstract view
.subckt sky130_fd_sc_hd__a31o_2 A1 A2 A3 B1 VGND VNB VPB VPWR X
.ends

* Black-box entry subcircuit for sky130_fd_sc_hd__nor2_4 abstract view
.subckt sky130_fd_sc_hd__nor2_4 A B VGND VNB VPB VPWR Y
.ends

* Black-box entry subcircuit for sky130_fd_sc_hd__a21bo_1 abstract view
.subckt sky130_fd_sc_hd__a21bo_1 A1 A2 B1_N VGND VNB VPB VPWR X
.ends

* Black-box entry subcircuit for sky130_fd_sc_hd__and3b_1 abstract view
.subckt sky130_fd_sc_hd__and3b_1 A_N B C VGND VNB VPB VPWR X
.ends

* Black-box entry subcircuit for sky130_fd_sc_hd__and2b_1 abstract view
.subckt sky130_fd_sc_hd__and2b_1 A_N B VGND VNB VPB VPWR X
.ends

* Black-box entry subcircuit for sky130_fd_sc_hd__o21ba_1 abstract view
.subckt sky130_fd_sc_hd__o21ba_1 A1 A2 B1_N VGND VNB VPB VPWR X
.ends

* Black-box entry subcircuit for sky130_fd_sc_hd__o32a_1 abstract view
.subckt sky130_fd_sc_hd__o32a_1 A1 A2 A3 B1 B2 VGND VNB VPB VPWR X
.ends

* Black-box entry subcircuit for sky130_fd_sc_hd__o21bai_2 abstract view
.subckt sky130_fd_sc_hd__o21bai_2 A1 A2 B1_N VGND VNB VPB VPWR Y
.ends

* Black-box entry subcircuit for sky130_fd_sc_hd__a221o_2 abstract view
.subckt sky130_fd_sc_hd__a221o_2 A1 A2 B1 B2 C1 VGND VNB VPB VPWR X
.ends

* Black-box entry subcircuit for sky130_fd_sc_hd__a211oi_2 abstract view
.subckt sky130_fd_sc_hd__a211oi_2 A1 A2 B1 C1 VGND VNB VPB VPWR Y
.ends

* Black-box entry subcircuit for sky130_fd_sc_hd__clkbuf_8 abstract view
.subckt sky130_fd_sc_hd__clkbuf_8 A VGND VNB VPB VPWR X
.ends

* Black-box entry subcircuit for sky130_fd_sc_hd__a221oi_1 abstract view
.subckt sky130_fd_sc_hd__a221oi_1 A1 A2 B1 B2 C1 VGND VNB VPB VPWR Y
.ends

* Black-box entry subcircuit for sky130_fd_sc_hd__o22a_1 abstract view
.subckt sky130_fd_sc_hd__o22a_1 A1 A2 B1 B2 VGND VNB VPB VPWR X
.ends

* Black-box entry subcircuit for sky130_fd_sc_hd__dfrtp_2 abstract view
.subckt sky130_fd_sc_hd__dfrtp_2 CLK D RESET_B VGND VNB VPB VPWR Q
.ends

* Black-box entry subcircuit for sky130_fd_sc_hd__inv_6 abstract view
.subckt sky130_fd_sc_hd__inv_6 A VGND VNB VPB VPWR Y
.ends

* Black-box entry subcircuit for sky130_fd_sc_hd__o32ai_2 abstract view
.subckt sky130_fd_sc_hd__o32ai_2 A1 A2 A3 B1 B2 VGND VNB VPB VPWR Y
.ends

* Black-box entry subcircuit for sky130_fd_sc_hd__o32ai_1 abstract view
.subckt sky130_fd_sc_hd__o32ai_1 A1 A2 A3 B1 B2 VGND VNB VPB VPWR Y
.ends

* Black-box entry subcircuit for sky130_fd_sc_hd__nand3b_1 abstract view
.subckt sky130_fd_sc_hd__nand3b_1 A_N B C VGND VNB VPB VPWR Y
.ends

* Black-box entry subcircuit for sky130_fd_sc_hd__o31a_1 abstract view
.subckt sky130_fd_sc_hd__o31a_1 A1 A2 A3 B1 VGND VNB VPB VPWR X
.ends

* Black-box entry subcircuit for sky130_fd_sc_hd__or2_2 abstract view
.subckt sky130_fd_sc_hd__or2_2 A B VGND VNB VPB VPWR X
.ends

* Black-box entry subcircuit for sky130_fd_sc_hd__nor3b_4 abstract view
.subckt sky130_fd_sc_hd__nor3b_4 A B C_N VGND VNB VPB VPWR Y
.ends

* Black-box entry subcircuit for sky130_fd_sc_hd__clkinvlp_4 abstract view
.subckt sky130_fd_sc_hd__clkinvlp_4 A VGND VNB VPB VPWR Y
.ends

* Black-box entry subcircuit for sky130_fd_sc_hd__or3_2 abstract view
.subckt sky130_fd_sc_hd__or3_2 A B C VGND VNB VPB VPWR X
.ends

* Black-box entry subcircuit for sky130_fd_sc_hd__and3b_2 abstract view
.subckt sky130_fd_sc_hd__and3b_2 A_N B C VGND VNB VPB VPWR X
.ends

* Black-box entry subcircuit for sky130_fd_sc_hd__nand2_2 abstract view
.subckt sky130_fd_sc_hd__nand2_2 A B VGND VNB VPB VPWR Y
.ends

* Black-box entry subcircuit for sky130_fd_sc_hd__inv_8 abstract view
.subckt sky130_fd_sc_hd__inv_8 A VGND VNB VPB VPWR Y
.ends

* Black-box entry subcircuit for sky130_fd_sc_hd__or4b_1 abstract view
.subckt sky130_fd_sc_hd__or4b_1 A B C D_N VGND VNB VPB VPWR X
.ends

* Black-box entry subcircuit for sky130_fd_sc_hd__o21ai_4 abstract view
.subckt sky130_fd_sc_hd__o21ai_4 A1 A2 B1 VGND VNB VPB VPWR Y
.ends

* Black-box entry subcircuit for sky130_fd_sc_hd__nor3_1 abstract view
.subckt sky130_fd_sc_hd__nor3_1 A B C VGND VNB VPB VPWR Y
.ends

* Black-box entry subcircuit for sky130_fd_sc_hd__a311o_1 abstract view
.subckt sky130_fd_sc_hd__a311o_1 A1 A2 A3 B1 C1 VGND VNB VPB VPWR X
.ends

* Black-box entry subcircuit for sky130_fd_sc_hd__or3b_2 abstract view
.subckt sky130_fd_sc_hd__or3b_2 A B C_N VGND VNB VPB VPWR X
.ends

* Black-box entry subcircuit for sky130_fd_sc_hd__a21oi_2 abstract view
.subckt sky130_fd_sc_hd__a21oi_2 A1 A2 B1 VGND VNB VPB VPWR Y
.ends

* Black-box entry subcircuit for sky130_fd_sc_hd__nand3b_2 abstract view
.subckt sky130_fd_sc_hd__nand3b_2 A_N B C VGND VNB VPB VPWR Y
.ends

* Black-box entry subcircuit for sky130_fd_sc_hd__clkbuf_16 abstract view
.subckt sky130_fd_sc_hd__clkbuf_16 A VGND VNB VPB VPWR X
.ends

* Black-box entry subcircuit for sky130_fd_sc_hd__a2bb2o_1 abstract view
.subckt sky130_fd_sc_hd__a2bb2o_1 A1_N A2_N B1 B2 VGND VNB VPB VPWR X
.ends

* Black-box entry subcircuit for sky130_fd_sc_hd__xnor2_1 abstract view
.subckt sky130_fd_sc_hd__xnor2_1 A B VGND VNB VPB VPWR Y
.ends

* Black-box entry subcircuit for sky130_fd_sc_hd__nor3b_2 abstract view
.subckt sky130_fd_sc_hd__nor3b_2 A B C_N VGND VNB VPB VPWR Y
.ends

* Black-box entry subcircuit for sky130_fd_sc_hd__or3_4 abstract view
.subckt sky130_fd_sc_hd__or3_4 A B C VGND VNB VPB VPWR X
.ends

* Black-box entry subcircuit for sky130_fd_sc_hd__bufinv_16 abstract view
.subckt sky130_fd_sc_hd__bufinv_16 A VGND VNB VPB VPWR Y
.ends

* Black-box entry subcircuit for sky130_fd_sc_hd__clkinv_2 abstract view
.subckt sky130_fd_sc_hd__clkinv_2 A VGND VNB VPB VPWR Y
.ends

* Black-box entry subcircuit for sky130_fd_sc_hd__clkinv_4 abstract view
.subckt sky130_fd_sc_hd__clkinv_4 A VGND VNB VPB VPWR Y
.ends

* Black-box entry subcircuit for sky130_fd_sc_hd__o31a_4 abstract view
.subckt sky130_fd_sc_hd__o31a_4 A1 A2 A3 B1 VGND VNB VPB VPWR X
.ends

* Black-box entry subcircuit for sky130_fd_sc_hd__xor2_2 abstract view
.subckt sky130_fd_sc_hd__xor2_2 A B VGND VNB VPB VPWR X
.ends

* Black-box entry subcircuit for sky130_fd_sc_hd__clkinv_8 abstract view
.subckt sky130_fd_sc_hd__clkinv_8 A VGND VNB VPB VPWR Y
.ends

* Black-box entry subcircuit for sky130_fd_sc_hd__nand2_4 abstract view
.subckt sky130_fd_sc_hd__nand2_4 A B VGND VNB VPB VPWR Y
.ends

* Black-box entry subcircuit for sky130_fd_sc_hd__dlymetal6s2s_1 abstract view
.subckt sky130_fd_sc_hd__dlymetal6s2s_1 A VGND VNB VPB VPWR X
.ends

* Black-box entry subcircuit for sky130_fd_sc_hd__o21bai_1 abstract view
.subckt sky130_fd_sc_hd__o21bai_1 A1 A2 B1_N VGND VNB VPB VPWR Y
.ends

* Black-box entry subcircuit for sky130_fd_sc_hd__inv_4 abstract view
.subckt sky130_fd_sc_hd__inv_4 A VGND VNB VPB VPWR Y
.ends

* Black-box entry subcircuit for sky130_fd_sc_hd__o2111a_1 abstract view
.subckt sky130_fd_sc_hd__o2111a_1 A1 A2 B1 C1 D1 VGND VNB VPB VPWR X
.ends

* Black-box entry subcircuit for sky130_fd_sc_hd__a311oi_2 abstract view
.subckt sky130_fd_sc_hd__a311oi_2 A1 A2 A3 B1 C1 VGND VNB VPB VPWR Y
.ends

* Black-box entry subcircuit for sky130_fd_sc_hd__o2bb2a_1 abstract view
.subckt sky130_fd_sc_hd__o2bb2a_1 A1_N A2_N B1 B2 VGND VNB VPB VPWR X
.ends

* Black-box entry subcircuit for sky130_fd_sc_hd__a311oi_1 abstract view
.subckt sky130_fd_sc_hd__a311oi_1 A1 A2 A3 B1 C1 VGND VNB VPB VPWR Y
.ends

* Black-box entry subcircuit for sky130_fd_sc_hd__buf_1 abstract view
.subckt sky130_fd_sc_hd__buf_1 A VGND VNB VPB VPWR X
.ends

* Black-box entry subcircuit for sky130_fd_sc_hd__o22ai_1 abstract view
.subckt sky130_fd_sc_hd__o22ai_1 A1 A2 B1 B2 VGND VNB VPB VPWR Y
.ends

* Black-box entry subcircuit for sky130_fd_sc_hd__o31ai_4 abstract view
.subckt sky130_fd_sc_hd__o31ai_4 A1 A2 A3 B1 VGND VNB VPB VPWR Y
.ends

* Black-box entry subcircuit for sky130_fd_sc_hd__nor3b_1 abstract view
.subckt sky130_fd_sc_hd__nor3b_1 A B C_N VGND VNB VPB VPWR Y
.ends

* Black-box entry subcircuit for sky130_fd_sc_hd__clkbuf_1 abstract view
.subckt sky130_fd_sc_hd__clkbuf_1 A VGND VNB VPB VPWR X
.ends

* Black-box entry subcircuit for sky130_fd_sc_hd__o31a_2 abstract view
.subckt sky130_fd_sc_hd__o31a_2 A1 A2 A3 B1 VGND VNB VPB VPWR X
.ends

* Black-box entry subcircuit for sky130_fd_sc_hd__a22oi_1 abstract view
.subckt sky130_fd_sc_hd__a22oi_1 A1 A2 B1 B2 VGND VNB VPB VPWR Y
.ends

* Black-box entry subcircuit for sky130_fd_sc_hd__and2_4 abstract view
.subckt sky130_fd_sc_hd__and2_4 A B VGND VNB VPB VPWR X
.ends

* Black-box entry subcircuit for sky130_fd_sc_hd__o311ai_1 abstract view
.subckt sky130_fd_sc_hd__o311ai_1 A1 A2 A3 B1 C1 VGND VNB VPB VPWR Y
.ends

* Black-box entry subcircuit for sky130_fd_sc_hd__inv_12 abstract view
.subckt sky130_fd_sc_hd__inv_12 A VGND VNB VPB VPWR Y
.ends

* Black-box entry subcircuit for sky130_fd_sc_hd__and4b_1 abstract view
.subckt sky130_fd_sc_hd__and4b_1 A_N B C D VGND VNB VPB VPWR X
.ends

* Black-box entry subcircuit for sky130_fd_sc_hd__and2b_2 abstract view
.subckt sky130_fd_sc_hd__and2b_2 A_N B VGND VNB VPB VPWR X
.ends

* Black-box entry subcircuit for sky130_fd_sc_hd__clkinv_1 abstract view
.subckt sky130_fd_sc_hd__clkinv_1 A VGND VNB VPB VPWR Y
.ends

* Black-box entry subcircuit for sky130_fd_sc_hd__a211o_2 abstract view
.subckt sky130_fd_sc_hd__a211o_2 A1 A2 B1 C1 VGND VNB VPB VPWR X
.ends

* Black-box entry subcircuit for sky130_fd_sc_hd__nor4_1 abstract view
.subckt sky130_fd_sc_hd__nor4_1 A B C D VGND VNB VPB VPWR Y
.ends

* Black-box entry subcircuit for sky130_fd_sc_hd__nor2_2 abstract view
.subckt sky130_fd_sc_hd__nor2_2 A B VGND VNB VPB VPWR Y
.ends

* Black-box entry subcircuit for sky130_fd_sc_hd__and4_1 abstract view
.subckt sky130_fd_sc_hd__and4_1 A B C D VGND VNB VPB VPWR X
.ends

* Black-box entry subcircuit for sky130_fd_sc_hd__and2_2 abstract view
.subckt sky130_fd_sc_hd__and2_2 A B VGND VNB VPB VPWR X
.ends

* Black-box entry subcircuit for sky130_fd_sc_hd__o31ai_1 abstract view
.subckt sky130_fd_sc_hd__o31ai_1 A1 A2 A3 B1 VGND VNB VPB VPWR Y
.ends

* Black-box entry subcircuit for sky130_fd_sc_hd__nor3_4 abstract view
.subckt sky130_fd_sc_hd__nor3_4 A B C VGND VNB VPB VPWR Y
.ends

* Black-box entry subcircuit for sky130_fd_sc_hd__o31ai_2 abstract view
.subckt sky130_fd_sc_hd__o31ai_2 A1 A2 A3 B1 VGND VNB VPB VPWR Y
.ends

* Black-box entry subcircuit for sky130_fd_sc_hd__o311a_2 abstract view
.subckt sky130_fd_sc_hd__o311a_2 A1 A2 A3 B1 C1 VGND VNB VPB VPWR X
.ends

* Black-box entry subcircuit for sky130_fd_sc_hd__o211a_2 abstract view
.subckt sky130_fd_sc_hd__o211a_2 A1 A2 B1 C1 VGND VNB VPB VPWR X
.ends

* Black-box entry subcircuit for sky130_fd_sc_hd__a311o_4 abstract view
.subckt sky130_fd_sc_hd__a311o_4 A1 A2 A3 B1 C1 VGND VNB VPB VPWR X
.ends

* Black-box entry subcircuit for sky130_fd_sc_hd__and4bb_1 abstract view
.subckt sky130_fd_sc_hd__and4bb_1 A_N B_N C D VGND VNB VPB VPWR X
.ends

* Black-box entry subcircuit for sky130_fd_sc_hd__nand3_1 abstract view
.subckt sky130_fd_sc_hd__nand3_1 A B C VGND VNB VPB VPWR Y
.ends

* Black-box entry subcircuit for sky130_fd_sc_hd__or3b_4 abstract view
.subckt sky130_fd_sc_hd__or3b_4 A B C_N VGND VNB VPB VPWR X
.ends

* Black-box entry subcircuit for sky130_fd_sc_hd__a31oi_1 abstract view
.subckt sky130_fd_sc_hd__a31oi_1 A1 A2 A3 B1 VGND VNB VPB VPWR Y
.ends

* Black-box entry subcircuit for sky130_fd_sc_hd__and3b_4 abstract view
.subckt sky130_fd_sc_hd__and3b_4 A_N B C VGND VNB VPB VPWR X
.ends

* Black-box entry subcircuit for sky130_fd_sc_hd__a32oi_2 abstract view
.subckt sky130_fd_sc_hd__a32oi_2 A1 A2 A3 B1 B2 VGND VNB VPB VPWR Y
.ends

* Black-box entry subcircuit for sky130_fd_sc_hd__o32a_2 abstract view
.subckt sky130_fd_sc_hd__o32a_2 A1 A2 A3 B1 B2 VGND VNB VPB VPWR X
.ends

* Black-box entry subcircuit for sky130_fd_sc_hd__and3_2 abstract view
.subckt sky130_fd_sc_hd__and3_2 A B C VGND VNB VPB VPWR X
.ends

* Black-box entry subcircuit for sky130_fd_sc_hd__o311a_4 abstract view
.subckt sky130_fd_sc_hd__o311a_4 A1 A2 A3 B1 C1 VGND VNB VPB VPWR X
.ends

* Black-box entry subcircuit for sky130_fd_sc_hd__or2_4 abstract view
.subckt sky130_fd_sc_hd__or2_4 A B VGND VNB VPB VPWR X
.ends

* Black-box entry subcircuit for sky130_fd_sc_hd__o211ai_1 abstract view
.subckt sky130_fd_sc_hd__o211ai_1 A1 A2 B1 C1 VGND VNB VPB VPWR Y
.ends

* Black-box entry subcircuit for sky130_fd_sc_hd__o221a_2 abstract view
.subckt sky130_fd_sc_hd__o221a_2 A1 A2 B1 B2 C1 VGND VNB VPB VPWR X
.ends

* Black-box entry subcircuit for sky130_fd_sc_hd__o41a_1 abstract view
.subckt sky130_fd_sc_hd__o41a_1 A1 A2 A3 A4 B1 VGND VNB VPB VPWR X
.ends

* Black-box entry subcircuit for sky130_fd_sc_hd__and2b_4 abstract view
.subckt sky130_fd_sc_hd__and2b_4 A_N B VGND VNB VPB VPWR X
.ends

* Black-box entry subcircuit for sky130_fd_sc_hd__o211ai_2 abstract view
.subckt sky130_fd_sc_hd__o211ai_2 A1 A2 B1 C1 VGND VNB VPB VPWR Y
.ends

* Black-box entry subcircuit for sky130_fd_sc_hd__and3_4 abstract view
.subckt sky130_fd_sc_hd__and3_4 A B C VGND VNB VPB VPWR X
.ends

.subckt fpgacell CBeast_in[0] CBeast_in[10] CBeast_in[11] CBeast_in[12] CBeast_in[13]
+ CBeast_in[14] CBeast_in[15] CBeast_in[1] CBeast_in[2] CBeast_in[3] CBeast_in[4]
+ CBeast_in[5] CBeast_in[6] CBeast_in[7] CBeast_in[8] CBeast_in[9] CBeast_out[0] CBeast_out[10]
+ CBeast_out[11] CBeast_out[12] CBeast_out[13] CBeast_out[14] CBeast_out[15] CBeast_out[1]
+ CBeast_out[2] CBeast_out[3] CBeast_out[4] CBeast_out[5] CBeast_out[6] CBeast_out[7]
+ CBeast_out[8] CBeast_out[9] CBnorth_in[0] CBnorth_in[10] CBnorth_in[11] CBnorth_in[12]
+ CBnorth_in[13] CBnorth_in[14] CBnorth_in[15] CBnorth_in[1] CBnorth_in[2] CBnorth_in[3]
+ CBnorth_in[4] CBnorth_in[5] CBnorth_in[6] CBnorth_in[7] CBnorth_in[8] CBnorth_in[9]
+ CBnorth_out[0] CBnorth_out[10] CBnorth_out[11] CBnorth_out[12] CBnorth_out[13] CBnorth_out[14]
+ CBnorth_out[15] CBnorth_out[1] CBnorth_out[2] CBnorth_out[3] CBnorth_out[4] CBnorth_out[5]
+ CBnorth_out[6] CBnorth_out[7] CBnorth_out[8] CBnorth_out[9] SBsouth_in[0] SBsouth_in[10]
+ SBsouth_in[11] SBsouth_in[12] SBsouth_in[13] SBsouth_in[14] SBsouth_in[15] SBsouth_in[1]
+ SBsouth_in[2] SBsouth_in[3] SBsouth_in[4] SBsouth_in[5] SBsouth_in[6] SBsouth_in[7]
+ SBsouth_in[8] SBsouth_in[9] SBsouth_out[0] SBsouth_out[10] SBsouth_out[11] SBsouth_out[12]
+ SBsouth_out[13] SBsouth_out[14] SBsouth_out[15] SBsouth_out[1] SBsouth_out[2] SBsouth_out[3]
+ SBsouth_out[4] SBsouth_out[5] SBsouth_out[6] SBsouth_out[7] SBsouth_out[8] SBsouth_out[9]
+ SBwest_in[0] SBwest_in[10] SBwest_in[11] SBwest_in[12] SBwest_in[13] SBwest_in[14]
+ SBwest_in[15] SBwest_in[1] SBwest_in[2] SBwest_in[3] SBwest_in[4] SBwest_in[5] SBwest_in[6]
+ SBwest_in[7] SBwest_in[8] SBwest_in[9] SBwest_out[0] SBwest_out[10] SBwest_out[11]
+ SBwest_out[12] SBwest_out[13] SBwest_out[14] SBwest_out[15] SBwest_out[1] SBwest_out[2]
+ SBwest_out[3] SBwest_out[4] SBwest_out[5] SBwest_out[6] SBwest_out[7] SBwest_out[8]
+ SBwest_out[9] clk config_data_in config_data_out config_en le_clk le_en le_nrst
+ nrst vccd1 vssd1
X_2106_ _0464_ _0737_ _0739_ LEI0.config_data\[2\] vssd1 vssd1 vccd1 vccd1 _0740_
+ sky130_fd_sc_hd__o22a_2
X_2037_ _0664_ _0668_ _0669_ _0670_ vssd1 vssd1 vccd1 vccd1 _0671_ sky130_fd_sc_hd__a31o_1
X_3086_ SB0.route_sel\[5\] SB0.route_sel\[4\] net265 vssd1 vssd1 vccd1 vccd1 _0146_
+ sky130_fd_sc_hd__mux2_1
X_3155_ SB0.route_sel\[74\] SB0.route_sel\[73\] net272 vssd1 vssd1 vccd1 vccd1 _0215_
+ sky130_fd_sc_hd__mux2_1
X_2939_ _0458_ _1493_ vssd1 vssd1 vccd1 vccd1 net107 sky130_fd_sc_hd__and2_1
XFILLER_22_133 vssd1 vssd1 vccd1 vccd1 sky130_fd_sc_hd__fill_4
XFILLER_22_177 vssd1 vssd1 vccd1 vccd1 sky130_fd_sc_hd__fill_8
XFILLER_45_269 vssd1 vssd1 vccd1 vccd1 sky130_fd_sc_hd__fill_1
XTAP_TAPCELL_ROW_43_448 vssd1 vccd1 sky130_fd_sc_hd__tapvpwrvgnd_1
XFILLER_9_104 vssd1 vssd1 vccd1 vccd1 sky130_fd_sc_hd__fill_8
XFILLER_3_23 vssd1 vssd1 vccd1 vccd1 sky130_fd_sc_hd__fill_2
X_2724_ _1599_ _1349_ _1351_ vssd1 vssd1 vccd1 vccd1 _1352_ sky130_fd_sc_hd__a21oi_1
X_2655_ net4 net5 net6 net7 net210 CB_1.config_dataB\[6\] vssd1 vssd1 vccd1 vccd1
+ _1283_ sky130_fd_sc_hd__mux4_1
Xfanout149 net150 vssd1 vssd1 vccd1 vccd1 net149 sky130_fd_sc_hd__buf_2
X_3207_ SB0.route_sel\[126\] SB0.route_sel\[125\] net298 vssd1 vssd1 vccd1 vccd1 _0267_
+ sky130_fd_sc_hd__mux2_1
X_2586_ net167 _1213_ _1214_ _1215_ vssd1 vssd1 vccd1 vccd1 _1216_ sky130_fd_sc_hd__a31o_1
Xfanout138 _1604_ vssd1 vssd1 vccd1 vccd1 net138 sky130_fd_sc_hd__clkbuf_4
XFILLER_27_225 vssd1 vssd1 vccd1 vccd1 sky130_fd_sc_hd__fill_4
X_3138_ SB0.route_sel\[57\] SB0.route_sel\[56\] net267 vssd1 vssd1 vccd1 vccd1 _0198_
+ sky130_fd_sc_hd__mux2_1
X_3069_ CB_1.config_dataB\[13\] CB_1.config_dataB\[12\] net285 vssd1 vssd1 vccd1 vccd1
+ _0129_ sky130_fd_sc_hd__mux2_1
XTAP_TAPCELL_ROW_40_429 vssd1 vccd1 sky130_fd_sc_hd__tapvpwrvgnd_1
XFILLER_10_136 vssd1 vssd1 vccd1 vccd1 sky130_fd_sc_hd__fill_4
XTAP_TAPCELL_ROW_56_540 vssd1 vccd1 sky130_fd_sc_hd__tapvpwrvgnd_1
XTAP_TAPCELL_ROW_5_184 vssd1 vccd1 sky130_fd_sc_hd__tapvpwrvgnd_1
X_2440_ SB0.route_sel\[63\] _1533_ _1069_ vssd1 vssd1 vccd1 vccd1 _1070_ sky130_fd_sc_hd__o21ai_1
X_2371_ _0461_ _0985_ _1000_ _1001_ _1002_ vssd1 vssd1 vccd1 vccd1 _1003_ sky130_fd_sc_hd__o221a_1
X_2569_ _1592_ _1196_ CB_1.config_dataA\[18\] vssd1 vssd1 vccd1 vccd1 _1199_ sky130_fd_sc_hd__a21oi_1
X_2638_ CB_1.config_dataB\[3\] _1257_ _1261_ _1265_ vssd1 vssd1 vccd1 vccd1 _1266_
+ sky130_fd_sc_hd__and4_2
X_2707_ net206 _1096_ _1334_ net205 vssd1 vssd1 vccd1 vccd1 _1335_ sky130_fd_sc_hd__o211a_1
XFILLER_23_250 vssd1 vssd1 vccd1 vccd1 sky130_fd_sc_hd__fill_4
XFILLER_23_283 vssd1 vssd1 vccd1 vccd1 sky130_fd_sc_hd__fill_1
XFILLER_38_309 vssd1 vssd1 vccd1 vccd1 sky130_fd_sc_hd__fill_2
XFILLER_48_83 vssd1 vssd1 vccd1 vccd1 sky130_fd_sc_hd__fill_1
X_3610_ clknet_leaf_7_clk _0306_ net232 vssd1 vssd1 vccd1 vccd1 CB_0.config_dataB\[12\]
+ sky130_fd_sc_hd__dfstp_2
X_1940_ _0571_ net147 net163 vssd1 vssd1 vccd1 vccd1 _0574_ sky130_fd_sc_hd__or3b_1
X_1871_ SB0.route_sel\[87\] SB0.route_sel\[86\] vssd1 vssd1 vccd1 vccd1 _0505_ sky130_fd_sc_hd__nand2_1
XTAP_TAPCELL_ROW_16_256 vssd1 vccd1 sky130_fd_sc_hd__tapvpwrvgnd_1
X_3541_ clknet_leaf_1_clk _0237_ net219 vssd1 vssd1 vccd1 vccd1 SB0.route_sel\[96\]
+ sky130_fd_sc_hd__dfstp_2
X_2423_ SB0.route_sel\[92\] SB0.route_sel\[93\] _1552_ SB0.route_sel\[88\] _1052_
+ vssd1 vssd1 vccd1 vccd1 _1053_ sky130_fd_sc_hd__o221a_1
X_3472_ clknet_leaf_30_clk _0168_ net222 vssd1 vssd1 vccd1 vccd1 SB0.route_sel\[27\]
+ sky130_fd_sc_hd__dfstp_1
XTAP_TAPCELL_ROW_67_624 vssd1 vccd1 sky130_fd_sc_hd__tapvpwrvgnd_1
XTAP_TAPCELL_ROW_67_613 vssd1 vccd1 sky130_fd_sc_hd__tapvpwrvgnd_1
X_2354_ net181 CB_0.config_dataB\[16\] vssd1 vssd1 vccd1 vccd1 _0986_ sky130_fd_sc_hd__nor2_1
X_2285_ _0730_ _0732_ _0906_ vssd1 vssd1 vccd1 vccd1 _0917_ sky130_fd_sc_hd__a21o_1
XFILLER_20_253 vssd1 vssd1 vccd1 vccd1 sky130_fd_sc_hd__fill_2
XFILLER_55_150 vccd1 vssd1 vccd1 vssd1 sky130_ef_sc_hd__decap_40_12
XTAP_TAPCELL_ROW_13_237 vssd1 vccd1 sky130_fd_sc_hd__tapvpwrvgnd_1
XTAP_TAPCELL_ROW_21_292 vssd1 vccd1 sky130_fd_sc_hd__tapvpwrvgnd_1
XFILLER_38_139 vssd1 vssd1 vccd1 vccd1 sky130_fd_sc_hd__fill_1
X_2070_ SB0.route_sel\[12\] SB0.route_sel\[13\] net56 _0703_ _0702_ vssd1 vssd1 vccd1
+ vccd1 _0704_ sky130_fd_sc_hd__a41o_1
X_2972_ LEI0.config_data\[31\] LEI0.config_data\[30\] net306 vssd1 vssd1 vccd1 vccd1
+ _0032_ sky130_fd_sc_hd__mux2_1
XFILLER_46_194 vssd1 vssd1 vccd1 vccd1 sky130_fd_sc_hd__fill_2
XFILLER_46_161 vssd1 vssd1 vccd1 vccd1 sky130_fd_sc_hd__fill_2
XPHY_EDGE_ROW_28_Left_96 vssd1 vssd1 vccd1 vccd1 sky130_fd_sc_hd__decap_3
X_1854_ _0481_ _0485_ _0486_ _0487_ vssd1 vssd1 vccd1 vccd1 _0488_ sky130_fd_sc_hd__a31oi_2
X_1785_ SB0.route_sel\[103\] SB0.route_sel\[102\] vssd1 vssd1 vccd1 vccd1 _0419_ sky130_fd_sc_hd__nand2_1
X_1923_ net162 net157 vssd1 vssd1 vccd1 vccd1 _0557_ sky130_fd_sc_hd__nor2_1
X_3386_ clknet_leaf_5_clk net343 net228 vssd1 vssd1 vccd1 vccd1 LE_0B.config_data\[9\]
+ sky130_fd_sc_hd__dfrtp_1
X_2406_ SB0.route_sel\[100\] SB0.route_sel\[101\] vssd1 vssd1 vccd1 vccd1 _1036_ sky130_fd_sc_hd__or2_1
X_3524_ clknet_leaf_0_clk _0220_ net218 vssd1 vssd1 vccd1 vccd1 SB0.route_sel\[79\]
+ sky130_fd_sc_hd__dfstp_1
X_3455_ clknet_leaf_33_clk _0151_ net216 vssd1 vssd1 vccd1 vccd1 SB0.route_sel\[10\]
+ sky130_fd_sc_hd__dfstp_1
X_2337_ LEI0.config_data\[27\] net143 _0968_ LEI0.config_data\[28\] vssd1 vssd1 vccd1
+ vccd1 _0969_ sky130_fd_sc_hd__o211a_1
X_2199_ _0830_ _0831_ _0832_ vssd1 vssd1 vccd1 vccd1 _0833_ sky130_fd_sc_hd__o21a_1
X_2268_ net153 net149 LEI0.config_data\[3\] vssd1 vssd1 vccd1 vccd1 _0900_ sky130_fd_sc_hd__mux2_1
XFILLER_29_106 vssd1 vssd1 vccd1 vccd1 sky130_fd_sc_hd__fill_4
XFILLER_52_186 vssd1 vssd1 vccd1 vccd1 sky130_fd_sc_hd__fill_4
XFILLER_40_304 vssd1 vssd1 vccd1 vccd1 sky130_fd_sc_hd__fill_1
XTAP_TAPCELL_ROW_10_218 vssd1 vccd1 sky130_fd_sc_hd__tapvpwrvgnd_1
XFILLER_20_10 vssd1 vssd1 vccd1 vccd1 sky130_fd_sc_hd__fill_1
XFILLER_20_65 vssd1 vssd1 vccd1 vccd1 sky130_fd_sc_hd__fill_1
Xhold30 _0016_ vssd1 vssd1 vccd1 vccd1 net340 sky130_fd_sc_hd__dlygate4sd3_1
Xhold63 _0017_ vssd1 vssd1 vccd1 vccd1 net373 sky130_fd_sc_hd__dlygate4sd3_1
Xhold74 LE_0A.config_data\[12\] vssd1 vssd1 vccd1 vccd1 net384 sky130_fd_sc_hd__dlygate4sd3_1
Xhold41 LE_0B.config_data\[4\] vssd1 vssd1 vccd1 vccd1 net351 sky130_fd_sc_hd__dlygate4sd3_1
Xhold52 _0100_ vssd1 vssd1 vccd1 vccd1 net362 sky130_fd_sc_hd__dlygate4sd3_1
XFILLER_20_98 vssd1 vssd1 vccd1 vccd1 sky130_fd_sc_hd__fill_1
Xhold85 LEI0.config_data\[11\] vssd1 vssd1 vccd1 vccd1 net395 sky130_fd_sc_hd__dlygate4sd3_1
XFILLER_45_51 vssd1 vssd1 vccd1 vccd1 sky130_fd_sc_hd__fill_2
XFILLER_43_120 vssd1 vssd1 vccd1 vccd1 sky130_fd_sc_hd__fill_1
Xhold96 _0108_ vssd1 vssd1 vccd1 vccd1 net406 sky130_fd_sc_hd__dlygate4sd3_1
XFILLER_43_197 vccd1 vssd1 vccd1 vssd1 sky130_ef_sc_hd__decap_40_12
XANTENNA_5 CBeast_in[15] vssd1 vssd1 vccd1 vccd1 sky130_fd_sc_hd__diode_2
X_3240_ CB_0.config_dataB\[6\] net186 net289 vssd1 vssd1 vccd1 vccd1 _0300_ sky130_fd_sc_hd__mux2_1
XFILLER_66_245 vssd1 vssd1 vccd1 vccd1 sky130_fd_sc_hd__fill_1
X_2122_ _0549_ _0744_ _0755_ CB_0.config_dataA\[7\] vssd1 vssd1 vccd1 vccd1 _0756_
+ sky130_fd_sc_hd__a211o_1
XTAP_TAPCELL_ROW_49_487 vssd1 vccd1 sky130_fd_sc_hd__tapvpwrvgnd_1
X_2053_ SB0.route_sel\[20\] SB0.route_sel\[21\] net41 vssd1 vssd1 vccd1 vccd1 _0687_
+ sky130_fd_sc_hd__a21boi_1
XFILLER_19_161 vssd1 vssd1 vccd1 vccd1 sky130_fd_sc_hd__fill_4
X_3171_ SB0.route_sel\[90\] SB0.route_sel\[89\] net269 vssd1 vssd1 vccd1 vccd1 _0231_
+ sky130_fd_sc_hd__mux2_1
X_2955_ net339 net354 net301 vssd1 vssd1 vccd1 vccd1 _0015_ sky130_fd_sc_hd__mux2_1
XFILLER_34_197 vssd1 vssd1 vccd1 vccd1 sky130_fd_sc_hd__fill_2
XFILLER_34_186 vssd1 vssd1 vccd1 vccd1 sky130_fd_sc_hd__fill_1
XFILLER_34_153 vssd1 vssd1 vccd1 vccd1 sky130_fd_sc_hd__fill_4
X_1768_ SB0.route_sel\[124\] SB0.route_sel\[125\] net39 vssd1 vssd1 vccd1 vccd1 _0402_
+ sky130_fd_sc_hd__a21boi_1
X_2886_ SB0.route_sel\[44\] SB0.route_sel\[45\] vssd1 vssd1 vccd1 vccd1 _1458_ sky130_fd_sc_hd__nand2b_1
X_3507_ clknet_leaf_2_clk _0203_ net225 vssd1 vssd1 vccd1 vccd1 SB0.route_sel\[62\]
+ sky130_fd_sc_hd__dfstp_1
X_1906_ SB0.route_sel\[67\] SB0.route_sel\[66\] _0539_ _1541_ vssd1 vssd1 vccd1 vccd1
+ _0540_ sky130_fd_sc_hd__a31o_1
X_1837_ CB_1.config_dataA\[22\] CB_1.config_dataA\[23\] vssd1 vssd1 vccd1 vccd1 _0471_
+ sky130_fd_sc_hd__nand2b_2
X_1699_ net183 vssd1 vssd1 vccd1 vccd1 _1581_ sky130_fd_sc_hd__inv_2
X_3369_ clknet_leaf_6_clk _0065_ net230 vssd1 vssd1 vccd1 vccd1 LE_0A.config_data\[14\]
+ sky130_fd_sc_hd__dfrtp_1
X_3438_ clknet_leaf_20_clk _0134_ net241 vssd1 vssd1 vccd1 vccd1 CB_1.config_dataB\[18\]
+ sky130_fd_sc_hd__dfstp_1
XFILLER_40_178 vssd1 vssd1 vccd1 vccd1 sky130_fd_sc_hd__fill_1
XFILLER_15_54 vssd1 vssd1 vccd1 vccd1 sky130_fd_sc_hd__fill_2
XTAP_TAPCELL_ROW_23_310 vssd1 vccd1 sky130_fd_sc_hd__tapvpwrvgnd_1
Xoutput75 net75 vssd1 vssd1 vccd1 vccd1 CBeast_out[13] sky130_fd_sc_hd__buf_2
Xoutput97 net97 vssd1 vssd1 vccd1 vccd1 CBnorth_out[4] sky130_fd_sc_hd__buf_2
Xoutput86 net86 vssd1 vssd1 vccd1 vccd1 CBeast_out[9] sky130_fd_sc_hd__buf_2
XTAP_TAPCELL_ROW_46_468 vssd1 vccd1 sky130_fd_sc_hd__tapvpwrvgnd_1
XFILLER_31_134 vssd1 vssd1 vccd1 vccd1 sky130_fd_sc_hd__fill_4
XFILLER_16_186 vssd1 vssd1 vccd1 vccd1 sky130_fd_sc_hd__fill_2
X_2740_ net202 _1365_ _1366_ _1367_ vssd1 vssd1 vccd1 vccd1 _1368_ sky130_fd_sc_hd__a31o_1
X_1622_ SB0.route_sel\[13\] vssd1 vssd1 vccd1 vccd1 _1504_ sky130_fd_sc_hd__inv_2
X_2671_ net209 _1096_ _1298_ net208 vssd1 vssd1 vccd1 vccd1 _1299_ sky130_fd_sc_hd__o211a_1
X_3223_ CB_0.config_dataA\[14\] CB_0.config_dataA\[13\] net302 vssd1 vssd1 vccd1 vccd1
+ _0283_ sky130_fd_sc_hd__mux2_1
Xfanout309 net310 vssd1 vssd1 vccd1 vccd1 net309 sky130_fd_sc_hd__clkbuf_2
XFILLER_39_234 vssd1 vssd1 vccd1 vccd1 sky130_fd_sc_hd__fill_1
X_2105_ _0738_ vssd1 vssd1 vccd1 vccd1 _0739_ sky130_fd_sc_hd__inv_2
XFILLER_39_278 vssd1 vssd1 vccd1 vccd1 sky130_fd_sc_hd__fill_2
XTAP_TAPCELL_ROW_37_402 vssd1 vccd1 sky130_fd_sc_hd__tapvpwrvgnd_1
X_3085_ SB0.route_sel\[4\] SB0.route_sel\[3\] net265 vssd1 vssd1 vccd1 vccd1 _0145_
+ sky130_fd_sc_hd__mux2_1
X_2036_ net155 _0387_ _0662_ SB0.route_sel\[24\] SB0.route_sel\[25\] vssd1 vssd1 vccd1
+ vccd1 _0670_ sky130_fd_sc_hd__a32o_1
X_3154_ SB0.route_sel\[73\] SB0.route_sel\[72\] net269 vssd1 vssd1 vccd1 vccd1 _0214_
+ sky130_fd_sc_hd__mux2_1
X_2938_ _1560_ SB0.route_sel\[107\] SB0.route_sel\[104\] _1564_ _1492_ vssd1 vssd1
+ vccd1 vccd1 _1493_ sky130_fd_sc_hd__a221o_1
X_2869_ SB0.route_sel\[67\] _1536_ SB0.route_sel\[68\] _1537_ _1446_ vssd1 vssd1 vccd1
+ vccd1 _1447_ sky130_fd_sc_hd__o221a_1
XPHY_EDGE_ROW_15_Left_83 vssd1 vssd1 vccd1 vccd1 sky130_fd_sc_hd__decap_3
XTAP_TAPCELL_ROW_43_449 vssd1 vccd1 sky130_fd_sc_hd__tapvpwrvgnd_1
XFILLER_13_145 vssd1 vssd1 vccd1 vccd1 sky130_fd_sc_hd__fill_2
XFILLER_13_167 vssd1 vssd1 vccd1 vccd1 sky130_fd_sc_hd__fill_1
XFILLER_42_85 vccd1 vssd1 vccd1 vssd1 sky130_ef_sc_hd__decap_40_12
XFILLER_67_82 vssd1 vssd1 vccd1 vccd1 sky130_fd_sc_hd__fill_2
XTAP_TAPCELL_ROW_59_560 vssd1 vccd1 sky130_fd_sc_hd__tapvpwrvgnd_1
X_2723_ CB_1.config_dataB\[17\] _1350_ CB_1.config_dataB\[18\] vssd1 vssd1 vccd1 vccd1
+ _1351_ sky130_fd_sc_hd__a21o_1
X_2585_ _1062_ _1193_ _1194_ _1065_ CB_1.config_dataA\[17\] vssd1 vssd1 vccd1 vccd1
+ _1215_ sky130_fd_sc_hd__a221o_1
X_2654_ _1275_ _1276_ _1281_ vssd1 vssd1 vccd1 vccd1 _1282_ sky130_fd_sc_hd__a21oi_1
Xfanout139 net141 vssd1 vssd1 vccd1 vccd1 net139 sky130_fd_sc_hd__buf_2
XFILLER_47_19 vssd1 vssd1 vccd1 vccd1 sky130_fd_sc_hd__fill_2
X_3206_ SB0.route_sel\[125\] SB0.route_sel\[124\] net296 vssd1 vssd1 vccd1 vccd1 _0266_
+ sky130_fd_sc_hd__mux2_1
X_3137_ SB0.route_sel\[56\] SB0.route_sel\[55\] net265 vssd1 vssd1 vccd1 vccd1 _0197_
+ sky130_fd_sc_hd__mux2_1
X_2019_ CB_1.config_dataA\[23\] CB_1.config_dataA\[22\] vssd1 vssd1 vccd1 vccd1 _0653_
+ sky130_fd_sc_hd__nor2_1
X_3068_ CB_1.config_dataB\[12\] net205 net281 vssd1 vssd1 vccd1 vccd1 _0128_ sky130_fd_sc_hd__mux2_1
XPHY_EDGE_ROW_0_Left_68 vssd1 vssd1 vccd1 vccd1 sky130_fd_sc_hd__decap_3
XTAP_TAPCELL_ROW_56_541 vssd1 vccd1 sky130_fd_sc_hd__tapvpwrvgnd_1
XFILLER_37_63 vssd1 vssd1 vccd1 vccd1 sky130_fd_sc_hd__fill_1
XFILLER_26_281 vssd1 vssd1 vccd1 vccd1 sky130_fd_sc_hd__fill_4
X_2370_ net181 CB_0.config_dataB\[16\] _0435_ vssd1 vssd1 vccd1 vccd1 _1002_ sky130_fd_sc_hd__or3_1
XFILLER_1_391 vssd1 vssd1 vccd1 vccd1 sky130_fd_sc_hd__fill_1
XFILLER_64_365 vssd1 vssd1 vccd1 vccd1 sky130_fd_sc_hd__fill_2
XTAP_TAPCELL_ROW_19_276 vssd1 vccd1 sky130_fd_sc_hd__tapvpwrvgnd_1
XTAP_TAPCELL_ROW_62_577 vssd1 vccd1 sky130_fd_sc_hd__tapvpwrvgnd_1
X_2706_ net206 _1092_ vssd1 vssd1 vccd1 vccd1 _1334_ sky130_fd_sc_hd__nand2_1
XFILLER_59_137 vssd1 vssd1 vccd1 vccd1 sky130_fd_sc_hd__fill_2
X_2499_ net173 _1126_ _1127_ _1128_ vssd1 vssd1 vccd1 vccd1 _1129_ sky130_fd_sc_hd__a31o_1
X_2568_ CB_1.config_dataA\[17\] _1197_ vssd1 vssd1 vccd1 vccd1 _1198_ sky130_fd_sc_hd__nand2_1
X_2637_ net211 _1262_ _1263_ _1264_ vssd1 vssd1 vccd1 vccd1 _1265_ sky130_fd_sc_hd__a31o_1
XPHY_EDGE_ROW_12_Right_12 vssd1 vssd1 vccd1 vccd1 sky130_fd_sc_hd__decap_3
XPHY_EDGE_ROW_21_Right_21 vssd1 vssd1 vccd1 vccd1 sky130_fd_sc_hd__decap_3
XFILLER_11_402 vssd1 vssd1 vccd1 vccd1 sky130_fd_sc_hd__fill_1
XPHY_EDGE_ROW_36_Left_104 vssd1 vssd1 vccd1 vccd1 sky130_fd_sc_hd__decap_3
XPHY_EDGE_ROW_30_Right_30 vssd1 vssd1 vccd1 vccd1 sky130_fd_sc_hd__decap_3
XPHY_EDGE_ROW_45_Left_113 vssd1 vssd1 vccd1 vccd1 sky130_fd_sc_hd__decap_3
XFILLER_46_321 vssd1 vssd1 vccd1 vccd1 sky130_fd_sc_hd__fill_1
XFILLER_0_25 vssd1 vssd1 vccd1 vccd1 sky130_fd_sc_hd__fill_2
XFILLER_0_36 vssd1 vssd1 vccd1 vccd1 sky130_fd_sc_hd__fill_8
XTAP_TAPCELL_ROW_16_257 vssd1 vccd1 sky130_fd_sc_hd__tapvpwrvgnd_1
XPHY_EDGE_ROW_54_Left_122 vssd1 vssd1 vccd1 vccd1 sky130_fd_sc_hd__decap_3
X_3540_ clknet_leaf_1_clk _0236_ net219 vssd1 vssd1 vccd1 vccd1 SB0.route_sel\[95\]
+ sky130_fd_sc_hd__dfstp_1
X_1870_ SB0.route_sel\[84\] SB0.route_sel\[85\] net34 vssd1 vssd1 vccd1 vccd1 _0504_
+ sky130_fd_sc_hd__a21boi_1
XFILLER_14_251 vssd1 vssd1 vccd1 vccd1 sky130_fd_sc_hd__fill_1
XPHY_EDGE_ROW_63_Left_131 vssd1 vssd1 vccd1 vccd1 sky130_fd_sc_hd__decap_3
X_2353_ net181 _1584_ vssd1 vssd1 vccd1 vccd1 _0985_ sky130_fd_sc_hd__nand2_1
X_2422_ SB0.route_sel\[95\] SB0.route_sel\[94\] vssd1 vssd1 vccd1 vccd1 _1052_ sky130_fd_sc_hd__nand2b_1
X_3471_ clknet_leaf_30_clk _0167_ net222 vssd1 vssd1 vccd1 vccd1 SB0.route_sel\[26\]
+ sky130_fd_sc_hd__dfstp_1
XTAP_TAPCELL_ROW_67_625 vssd1 vccd1 sky130_fd_sc_hd__tapvpwrvgnd_1
XTAP_TAPCELL_ROW_67_614 vssd1 vccd1 sky130_fd_sc_hd__tapvpwrvgnd_1
XFILLER_49_192 vssd1 vssd1 vccd1 vccd1 sky130_fd_sc_hd__fill_4
XFILLER_49_181 vssd1 vssd1 vccd1 vccd1 sky130_fd_sc_hd__fill_4
XFILLER_37_321 vssd1 vssd1 vccd1 vccd1 sky130_fd_sc_hd__fill_1
X_2284_ net186 _0672_ _0674_ _1579_ vssd1 vssd1 vccd1 vccd1 _0916_ sky130_fd_sc_hd__a31o_1
X_1999_ SB0.route_sel\[44\] SB0.route_sel\[45\] net60 _0632_ _0631_ vssd1 vssd1 vccd1
+ vccd1 _0633_ sky130_fd_sc_hd__a41o_1
XFILLER_55_162 vssd1 vssd1 vccd1 vccd1 sky130_fd_sc_hd__fill_4
XFILLER_47_129 vssd1 vssd1 vccd1 vccd1 sky130_fd_sc_hd__fill_1
XFILLER_28_321 vssd1 vssd1 vccd1 vccd1 sky130_fd_sc_hd__fill_1
XFILLER_7_225 vssd1 vssd1 vccd1 vccd1 sky130_fd_sc_hd__fill_2
XTAP_TAPCELL_ROW_13_238 vssd1 vccd1 sky130_fd_sc_hd__tapvpwrvgnd_1
XFILLER_50_85 vssd1 vssd1 vccd1 vccd1 sky130_fd_sc_hd__fill_2
XTAP_TAPCELL_ROW_21_293 vssd1 vccd1 sky130_fd_sc_hd__tapvpwrvgnd_1
XPHY_EDGE_ROW_3_Left_71 vssd1 vssd1 vccd1 vccd1 sky130_fd_sc_hd__decap_3
XFILLER_19_310 vssd1 vssd1 vccd1 vccd1 sky130_fd_sc_hd__fill_2
X_2971_ LEI0.config_data\[30\] LEI0.config_data\[29\] net306 vssd1 vssd1 vccd1 vccd1
+ _0031_ sky130_fd_sc_hd__mux2_1
X_1922_ CB_1.config_dataB\[23\] CB_1.config_dataB\[22\] vssd1 vssd1 vccd1 vccd1 _0556_
+ sky130_fd_sc_hd__nand2b_1
X_1853_ net155 _0387_ _0479_ SB0.route_sel\[88\] SB0.route_sel\[89\] vssd1 vssd1 vccd1
+ vccd1 _0487_ sky130_fd_sc_hd__a32o_1
X_1784_ SB0.route_sel\[100\] SB0.route_sel\[101\] net36 vssd1 vssd1 vccd1 vccd1 _0418_
+ sky130_fd_sc_hd__a21boi_1
X_3523_ clknet_leaf_0_clk _0219_ net218 vssd1 vssd1 vccd1 vccd1 SB0.route_sel\[78\]
+ sky130_fd_sc_hd__dfstp_1
X_2336_ LEI0.config_data\[27\] net139 vssd1 vssd1 vccd1 vccd1 _0968_ sky130_fd_sc_hd__nand2_1
X_3385_ clknet_leaf_6_clk net369 net228 vssd1 vssd1 vccd1 vccd1 LE_0B.config_data\[8\]
+ sky130_fd_sc_hd__dfrtp_1
X_2405_ net177 _1034_ vssd1 vssd1 vccd1 vccd1 _1035_ sky130_fd_sc_hd__nand2_1
X_3454_ clknet_leaf_33_clk _0150_ net216 vssd1 vssd1 vccd1 vccd1 SB0.route_sel\[9\]
+ sky130_fd_sc_hd__dfstp_2
X_2198_ _0435_ _0822_ _0824_ _0461_ CB_0.config_dataA\[17\] vssd1 vssd1 vccd1 vccd1
+ _0832_ sky130_fd_sc_hd__o221a_1
X_2267_ CB_0.config_dataB\[3\] _0874_ CB_0.config_dataB\[2\] CB_0.config_dataB\[4\]
+ vssd1 vssd1 vccd1 vccd1 _0899_ sky130_fd_sc_hd__or4b_2
XFILLER_37_151 vssd1 vssd1 vccd1 vccd1 sky130_fd_sc_hd__fill_8
XFILLER_37_140 vssd1 vssd1 vccd1 vccd1 sky130_fd_sc_hd__fill_4
XFILLER_40_327 vccd1 vssd1 vccd1 vssd1 sky130_ef_sc_hd__decap_40_12
XTAP_TAPCELL_ROW_10_219 vssd1 vccd1 sky130_fd_sc_hd__tapvpwrvgnd_1
Xhold86 _0012_ vssd1 vssd1 vccd1 vccd1 net396 sky130_fd_sc_hd__dlygate4sd3_1
Xhold31 LE_0A.config_data\[4\] vssd1 vssd1 vccd1 vccd1 net341 sky130_fd_sc_hd__dlygate4sd3_1
Xhold20 LEI0.config_data\[23\] vssd1 vssd1 vccd1 vccd1 net330 sky130_fd_sc_hd__dlygate4sd3_1
Xhold97 LE_0B.config_data\[6\] vssd1 vssd1 vccd1 vccd1 net407 sky130_fd_sc_hd__dlygate4sd3_1
Xhold42 _0078_ vssd1 vssd1 vccd1 vccd1 net352 sky130_fd_sc_hd__dlygate4sd3_1
Xhold53 LE_1A.config_data\[7\] vssd1 vssd1 vccd1 vccd1 net363 sky130_fd_sc_hd__dlygate4sd3_1
Xhold64 LE_1A.config_data\[10\] vssd1 vssd1 vccd1 vccd1 net374 sky130_fd_sc_hd__dlygate4sd3_1
Xhold75 LE_1A.config_data\[9\] vssd1 vssd1 vccd1 vccd1 net385 sky130_fd_sc_hd__dlygate4sd3_1
XFILLER_31_327 vssd1 vssd1 vccd1 vccd1 sky130_fd_sc_hd__fill_8
XTAP_TAPCELL_ROW_26_330 vssd1 vccd1 sky130_fd_sc_hd__tapvpwrvgnd_1
XANTENNA_6 CBeast_in[7] vssd1 vssd1 vccd1 vccd1 sky130_fd_sc_hd__diode_2
X_3170_ SB0.route_sel\[89\] SB0.route_sel\[88\] net270 vssd1 vssd1 vccd1 vccd1 _0230_
+ sky130_fd_sc_hd__mux2_1
X_2121_ _0528_ _0530_ _0746_ vssd1 vssd1 vccd1 vccd1 _0755_ sky130_fd_sc_hd__a21oi_1
XTAP_TAPCELL_ROW_49_488 vssd1 vccd1 sky130_fd_sc_hd__tapvpwrvgnd_1
XFILLER_34_132 vssd1 vssd1 vccd1 vccd1 sky130_fd_sc_hd__fill_8
XFILLER_34_121 vssd1 vssd1 vccd1 vccd1 sky130_fd_sc_hd__fill_8
X_2052_ SB0.route_sel\[18\] SB0.route_sel\[19\] _0683_ _0684_ _0685_ vssd1 vssd1 vccd1
+ vccd1 _0686_ sky130_fd_sc_hd__a221o_1
X_2954_ net354 LEI0.config_data\[12\] net301 vssd1 vssd1 vccd1 vccd1 _0014_ sky130_fd_sc_hd__mux2_1
XFILLER_30_371 vssd1 vssd1 vccd1 vccd1 sky130_fd_sc_hd__fill_2
X_2885_ _0599_ _1457_ vssd1 vssd1 vccd1 vccd1 net115 sky130_fd_sc_hd__and2_1
X_1905_ SB0.route_sel\[68\] SB0.route_sel\[69\] net63 _0538_ _0537_ vssd1 vssd1 vccd1
+ vccd1 _0539_ sky130_fd_sc_hd__a41o_1
X_1698_ CB_0.config_dataB\[12\] vssd1 vssd1 vccd1 vccd1 _1580_ sky130_fd_sc_hd__inv_2
X_1767_ SB0.route_sel\[122\] SB0.route_sel\[123\] _0396_ _0399_ _0400_ vssd1 vssd1
+ vccd1 vccd1 _0401_ sky130_fd_sc_hd__a221o_1
X_1836_ net162 _0469_ net3 vssd1 vssd1 vccd1 vccd1 _0470_ sky130_fd_sc_hd__o21ai_1
XPHY_EDGE_ROW_6_Right_6 vssd1 vssd1 vccd1 vccd1 sky130_fd_sc_hd__decap_3
X_3506_ clknet_leaf_33_clk _0202_ net224 vssd1 vssd1 vccd1 vccd1 SB0.route_sel\[61\]
+ sky130_fd_sc_hd__dfstp_1
X_2319_ _0949_ _0950_ CB_0.config_dataB\[12\] vssd1 vssd1 vccd1 vccd1 _0951_ sky130_fd_sc_hd__mux2_1
X_3368_ clknet_leaf_6_clk _0064_ net230 vssd1 vssd1 vccd1 vccd1 LE_0A.config_data\[13\]
+ sky130_fd_sc_hd__dfrtp_1
X_3437_ clknet_leaf_19_clk _0133_ net248 vssd1 vssd1 vccd1 vccd1 CB_1.config_dataB\[17\]
+ sky130_fd_sc_hd__dfstp_2
X_3299_ net333 net315 net279 vssd1 vssd1 vccd1 vccd1 _0359_ sky130_fd_sc_hd__mux2_1
XFILLER_57_279 vssd1 vssd1 vccd1 vccd1 sky130_fd_sc_hd__fill_1
XFILLER_25_165 vssd1 vssd1 vccd1 vccd1 sky130_fd_sc_hd__fill_2
XFILLER_25_143 vssd1 vssd1 vccd1 vccd1 sky130_fd_sc_hd__fill_2
Xoutput87 net87 vssd1 vssd1 vccd1 vccd1 CBnorth_out[0] sky130_fd_sc_hd__buf_2
Xoutput98 net98 vssd1 vssd1 vccd1 vccd1 CBnorth_out[5] sky130_fd_sc_hd__buf_2
Xoutput76 net76 vssd1 vssd1 vccd1 vccd1 CBeast_out[14] sky130_fd_sc_hd__buf_2
XPHY_EDGE_ROW_59_Right_59 vssd1 vssd1 vccd1 vccd1 sky130_fd_sc_hd__decap_3
XTAP_TAPCELL_ROW_46_469 vssd1 vccd1 sky130_fd_sc_hd__tapvpwrvgnd_1
XFILLER_12_382 vssd1 vssd1 vccd1 vccd1 sky130_fd_sc_hd__fill_1
X_1621_ SB0.route_sel\[10\] vssd1 vssd1 vccd1 vccd1 _1503_ sky130_fd_sc_hd__inv_2
X_2670_ net209 _1092_ vssd1 vssd1 vccd1 vccd1 _1298_ sky130_fd_sc_hd__nand2_1
X_3222_ CB_0.config_dataA\[13\] CB_0.config_dataA\[12\] net302 vssd1 vssd1 vccd1 vccd1
+ _0282_ sky130_fd_sc_hd__mux2_1
X_2104_ net152 net148 net144 net139 LEI0.config_data\[0\] LEI0.config_data\[1\] vssd1
+ vssd1 vccd1 vccd1 _0738_ sky130_fd_sc_hd__mux4_1
X_3153_ SB0.route_sel\[72\] SB0.route_sel\[71\] net273 vssd1 vssd1 vccd1 vccd1 _0213_
+ sky130_fd_sc_hd__mux2_1
XFILLER_54_205 vssd1 vssd1 vccd1 vccd1 sky130_fd_sc_hd__fill_2
X_2035_ _0666_ net147 net163 vssd1 vssd1 vccd1 vccd1 _0669_ sky130_fd_sc_hd__or3b_1
XTAP_TAPCELL_ROW_37_403 vssd1 vccd1 sky130_fd_sc_hd__tapvpwrvgnd_1
X_3084_ SB0.route_sel\[3\] SB0.route_sel\[2\] net276 vssd1 vssd1 vccd1 vccd1 _0144_
+ sky130_fd_sc_hd__mux2_1
X_2937_ SB0.route_sel\[111\] SB0.route_sel\[110\] vssd1 vssd1 vccd1 vccd1 _1492_ sky130_fd_sc_hd__nor2_1
X_2868_ SB0.route_sel\[65\] SB0.route_sel\[64\] vssd1 vssd1 vccd1 vccd1 _1446_ sky130_fd_sc_hd__or2_1
XFILLER_22_146 vssd1 vssd1 vccd1 vccd1 sky130_fd_sc_hd__fill_1
X_2799_ net152 _1406_ _0635_ vssd1 vssd1 vccd1 vccd1 net98 sky130_fd_sc_hd__mux2_1
X_1819_ CB_0.config_dataB\[21\] CB_0.config_dataB\[24\] CB_0.config_dataB\[20\] vssd1
+ vssd1 vccd1 vccd1 _0453_ sky130_fd_sc_hd__or3b_1
XFILLER_26_21 vssd1 vssd1 vccd1 vccd1 sky130_fd_sc_hd__fill_4
XFILLER_26_76 vssd1 vssd1 vccd1 vccd1 sky130_fd_sc_hd__fill_2
XFILLER_9_139 vssd1 vssd1 vccd1 vccd1 sky130_fd_sc_hd__fill_2
XFILLER_13_102 vssd1 vssd1 vccd1 vccd1 sky130_fd_sc_hd__fill_2
XTAP_TAPCELL_ROW_59_561 vssd1 vccd1 sky130_fd_sc_hd__tapvpwrvgnd_1
X_2722_ net11 net12 net13 net14 net204 CB_1.config_dataB\[16\] vssd1 vssd1 vccd1 vccd1
+ _1350_ sky130_fd_sc_hd__mux4_1
X_2584_ net168 _1058_ vssd1 vssd1 vccd1 vccd1 _1214_ sky130_fd_sc_hd__or2_1
X_2653_ _1062_ _1277_ _1279_ _1065_ CB_1.config_dataB\[7\] vssd1 vssd1 vccd1 vccd1
+ _1281_ sky130_fd_sc_hd__a221o_1
X_3205_ SB0.route_sel\[124\] SB0.route_sel\[123\] net296 vssd1 vssd1 vccd1 vccd1 _0265_
+ sky130_fd_sc_hd__mux2_1
X_3136_ SB0.route_sel\[55\] SB0.route_sel\[54\] net265 vssd1 vssd1 vccd1 vccd1 _0196_
+ sky130_fd_sc_hd__mux2_1
X_3067_ net205 net206 net281 vssd1 vssd1 vccd1 vccd1 _0127_ sky130_fd_sc_hd__mux2_1
XFILLER_35_293 vccd1 vssd1 vccd1 vssd1 sky130_ef_sc_hd__decap_40_12
X_2018_ net162 net156 net10 vssd1 vssd1 vccd1 vccd1 _0652_ sky130_fd_sc_hd__o21ai_1
XFILLER_37_97 vssd1 vssd1 vccd1 vccd1 sky130_fd_sc_hd__fill_2
XFILLER_18_205 vssd1 vssd1 vccd1 vccd1 sky130_fd_sc_hd__fill_2
XFILLER_41_285 vssd1 vssd1 vccd1 vccd1 sky130_fd_sc_hd__fill_1
XTAP_TAPCELL_ROW_62_578 vssd1 vccd1 sky130_fd_sc_hd__tapvpwrvgnd_1
XTAP_TAPCELL_ROW_19_277 vssd1 vccd1 sky130_fd_sc_hd__tapvpwrvgnd_1
X_2636_ _1038_ _1241_ _1243_ _1043_ CB_1.config_dataB\[2\] vssd1 vssd1 vccd1 vccd1
+ _1264_ sky130_fd_sc_hd__o221ai_1
X_2705_ _1598_ _1329_ _1332_ vssd1 vssd1 vccd1 vccd1 _1333_ sky130_fd_sc_hd__a21oi_1
X_2498_ _1065_ _1116_ _1118_ _1062_ CB_1.config_dataA\[7\] vssd1 vssd1 vccd1 vccd1
+ _1128_ sky130_fd_sc_hd__a221o_1
X_2567_ net11 net12 net13 net14 net168 net167 vssd1 vssd1 vccd1 vccd1 _1197_ sky130_fd_sc_hd__mux4_1
X_3119_ SB0.route_sel\[38\] SB0.route_sel\[37\] net262 vssd1 vssd1 vccd1 vccd1 _0179_
+ sky130_fd_sc_hd__mux2_1
XFILLER_15_219 vssd1 vssd1 vccd1 vccd1 sky130_fd_sc_hd__fill_4
XFILLER_23_22 vssd1 vssd1 vccd1 vccd1 sky130_fd_sc_hd__fill_4
XFILLER_58_171 vssd1 vssd1 vccd1 vccd1 sky130_fd_sc_hd__fill_2
XFILLER_48_96 vssd1 vssd1 vccd1 vccd1 sky130_fd_sc_hd__fill_8
XFILLER_9_24 vssd1 vssd1 vccd1 vccd1 sky130_fd_sc_hd__fill_8
XTAP_TAPCELL_ROW_16_258 vssd1 vccd1 sky130_fd_sc_hd__tapvpwrvgnd_1
X_2352_ net182 _1584_ vssd1 vssd1 vccd1 vccd1 _0984_ sky130_fd_sc_hd__and2_1
X_2421_ _1050_ vssd1 vssd1 vccd1 vccd1 _1051_ sky130_fd_sc_hd__inv_2
X_2283_ _1578_ net136 _0693_ vssd1 vssd1 vccd1 vccd1 _0915_ sky130_fd_sc_hd__and3_1
X_3470_ clknet_leaf_35_clk _0166_ net216 vssd1 vssd1 vccd1 vccd1 SB0.route_sel\[25\]
+ sky130_fd_sc_hd__dfstp_1
XTAP_TAPCELL_ROW_67_615 vssd1 vccd1 sky130_fd_sc_hd__tapvpwrvgnd_1
XFILLER_64_141 vssd1 vssd1 vccd1 vccd1 sky130_fd_sc_hd__fill_2
XFILLER_37_377 vssd1 vssd1 vccd1 vccd1 sky130_fd_sc_hd__fill_2
XFILLER_20_211 vssd1 vssd1 vccd1 vccd1 sky130_fd_sc_hd__fill_1
XFILLER_20_255 vssd1 vssd1 vccd1 vccd1 sky130_fd_sc_hd__fill_1
X_3599_ clknet_leaf_4_clk _0295_ net227 vssd1 vssd1 vccd1 vccd1 CB_0.config_dataB\[1\]
+ sky130_fd_sc_hd__dfstp_1
X_1998_ SB0.route_sel\[47\] SB0.route_sel\[46\] vssd1 vssd1 vccd1 vccd1 _0632_ sky130_fd_sc_hd__nand2_1
X_2619_ net11 net12 net13 net14 net212 net211 vssd1 vssd1 vccd1 vccd1 _1247_ sky130_fd_sc_hd__mux4_1
XFILLER_11_244 vssd1 vssd1 vccd1 vccd1 sky130_fd_sc_hd__fill_2
XTAP_TAPCELL_ROW_13_239 vssd1 vccd1 sky130_fd_sc_hd__tapvpwrvgnd_1
XTAP_TAPCELL_ROW_21_294 vssd1 vccd1 sky130_fd_sc_hd__tapvpwrvgnd_1
Xfanout290 net291 vssd1 vssd1 vccd1 vccd1 net290 sky130_fd_sc_hd__clkbuf_4
XFILLER_46_163 vssd1 vssd1 vccd1 vccd1 sky130_fd_sc_hd__fill_1
XFILLER_46_141 vccd1 vssd1 vccd1 vssd1 sky130_ef_sc_hd__decap_40_12
XFILLER_38_119 vssd1 vssd1 vccd1 vccd1 sky130_fd_sc_hd__fill_2
XTAP_TAPCELL_ROW_29_350 vssd1 vccd1 sky130_fd_sc_hd__tapvpwrvgnd_1
X_2970_ LEI0.config_data\[29\] LEI0.config_data\[28\] net301 vssd1 vssd1 vccd1 vccd1
+ _0030_ sky130_fd_sc_hd__mux2_1
XFILLER_61_177 vssd1 vssd1 vccd1 vccd1 sky130_fd_sc_hd__fill_2
X_1852_ _0483_ CB_0.le_outB net163 vssd1 vssd1 vccd1 vccd1 _0486_ sky130_fd_sc_hd__or3b_1
X_1921_ _0397_ _0553_ vssd1 vssd1 vccd1 vccd1 _0555_ sky130_fd_sc_hd__nand2_1
X_1783_ _1554_ _1555_ _0412_ _0415_ _0416_ vssd1 vssd1 vccd1 vccd1 _0417_ sky130_fd_sc_hd__o221a_1
X_3453_ clknet_leaf_31_clk _0149_ net223 vssd1 vssd1 vccd1 vccd1 SB0.route_sel\[8\]
+ sky130_fd_sc_hd__dfstp_1
X_3522_ clknet_leaf_0_clk _0218_ net220 vssd1 vssd1 vccd1 vccd1 SB0.route_sel\[77\]
+ sky130_fd_sc_hd__dfstp_1
X_2335_ _1580_ _0958_ _0959_ _0963_ _0966_ vssd1 vssd1 vccd1 vccd1 _0967_ sky130_fd_sc_hd__o311a_1
X_3384_ clknet_leaf_6_clk _0080_ net228 vssd1 vssd1 vccd1 vccd1 LE_0B.config_data\[7\]
+ sky130_fd_sc_hd__dfrtp_1
X_2266_ _0876_ _0880_ _0883_ CB_0.config_dataB\[4\] vssd1 vssd1 vccd1 vccd1 _0898_
+ sky130_fd_sc_hd__a31o_2
X_2404_ _0406_ _1033_ vssd1 vssd1 vccd1 vccd1 _1034_ sky130_fd_sc_hd__nor2_4
X_2197_ net191 _0409_ net190 vssd1 vssd1 vccd1 vccd1 _0831_ sky130_fd_sc_hd__a21bo_1
XFILLER_52_144 vssd1 vssd1 vccd1 vccd1 sky130_fd_sc_hd__fill_2
XFILLER_40_339 vssd1 vssd1 vccd1 vccd1 sky130_fd_sc_hd__fill_2
XFILLER_0_402 vssd1 vssd1 vccd1 vccd1 sky130_fd_sc_hd__fill_1
Xhold87 LE_0A.config_data\[13\] vssd1 vssd1 vccd1 vccd1 net397 sky130_fd_sc_hd__dlygate4sd3_1
Xhold21 _0024_ vssd1 vssd1 vccd1 vccd1 net331 sky130_fd_sc_hd__dlygate4sd3_1
Xhold76 LEI0.config_data\[20\] vssd1 vssd1 vccd1 vccd1 net386 sky130_fd_sc_hd__dlygate4sd3_1
Xhold98 _0079_ vssd1 vssd1 vccd1 vccd1 net408 sky130_fd_sc_hd__dlygate4sd3_1
Xhold32 LE_0B.config_data\[9\] vssd1 vssd1 vccd1 vccd1 net342 sky130_fd_sc_hd__dlygate4sd3_1
Xhold43 LE_0B.config_data\[3\] vssd1 vssd1 vccd1 vccd1 net353 sky130_fd_sc_hd__dlygate4sd3_1
Xhold10 _0087_ vssd1 vssd1 vccd1 vccd1 net320 sky130_fd_sc_hd__dlygate4sd3_1
XFILLER_28_141 vssd1 vssd1 vccd1 vccd1 sky130_fd_sc_hd__fill_1
Xhold54 LE_1A.config_data\[3\] vssd1 vssd1 vccd1 vccd1 net364 sky130_fd_sc_hd__dlygate4sd3_1
Xhold65 _0105_ vssd1 vssd1 vccd1 vccd1 net375 sky130_fd_sc_hd__dlygate4sd3_1
XFILLER_43_177 vssd1 vssd1 vccd1 vccd1 sky130_fd_sc_hd__fill_2
XFILLER_43_166 vssd1 vssd1 vccd1 vccd1 sky130_fd_sc_hd__fill_2
XFILLER_43_111 vssd1 vssd1 vccd1 vccd1 sky130_fd_sc_hd__fill_1
XTAP_TAPCELL_ROW_26_331 vssd1 vccd1 sky130_fd_sc_hd__tapvpwrvgnd_1
XANTENNA_7 CBeast_in[8] vssd1 vssd1 vccd1 vccd1 sky130_fd_sc_hd__diode_2
X_2120_ net197 _0511_ vssd1 vssd1 vccd1 vccd1 _0754_ sky130_fd_sc_hd__or2_1
XFILLER_20_6 vssd1 vssd1 vccd1 vccd1 sky130_fd_sc_hd__fill_4
XTAP_TAPCELL_ROW_49_489 vssd1 vccd1 sky130_fd_sc_hd__tapvpwrvgnd_1
XFILLER_34_166 vccd1 vssd1 vccd1 vssd1 sky130_ef_sc_hd__decap_40_12
X_2051_ net142 _1609_ _0653_ vssd1 vssd1 vccd1 vccd1 _0685_ sky130_fd_sc_hd__and3_1
XFILLER_19_130 vssd1 vssd1 vccd1 vccd1 sky130_fd_sc_hd__fill_2
X_2953_ LEI0.config_data\[12\] net395 net307 vssd1 vssd1 vccd1 vccd1 _0013_ sky130_fd_sc_hd__mux2_1
XTAP_TAPCELL_ROW_32_367 vssd1 vccd1 sky130_fd_sc_hd__tapvpwrvgnd_1
X_1835_ CB_1.config_dataB\[22\] CB_1.config_dataB\[23\] vssd1 vssd1 vccd1 vccd1 _0469_
+ sky130_fd_sc_hd__nand2b_1
X_2884_ _1525_ SB0.route_sel\[51\] _1529_ SB0.route_sel\[48\] _1456_ vssd1 vssd1 vccd1
+ vccd1 _1457_ sky130_fd_sc_hd__a221o_1
X_1904_ SB0.route_sel\[71\] SB0.route_sel\[70\] vssd1 vssd1 vccd1 vccd1 _0538_ sky130_fd_sc_hd__nand2_1
X_3436_ clknet_leaf_18_clk _0132_ net259 vssd1 vssd1 vccd1 vccd1 CB_1.config_dataB\[16\]
+ sky130_fd_sc_hd__dfstp_1
X_1697_ CB_0.config_dataB\[6\] vssd1 vssd1 vccd1 vccd1 _1579_ sky130_fd_sc_hd__inv_2
X_1766_ _1611_ _0397_ net142 vssd1 vssd1 vccd1 vccd1 _0400_ sky130_fd_sc_hd__and3b_1
X_3505_ clknet_leaf_30_clk _0201_ net224 vssd1 vssd1 vccd1 vccd1 SB0.route_sel\[60\]
+ sky130_fd_sc_hd__dfstp_1
X_2318_ net20 net21 net22 net23 net185 net183 vssd1 vssd1 vccd1 vccd1 _0950_ sky130_fd_sc_hd__mux4_1
X_3367_ clknet_leaf_6_clk _0063_ net230 vssd1 vssd1 vccd1 vccd1 LE_0A.config_data\[12\]
+ sky130_fd_sc_hd__dfrtp_1
X_2249_ _0694_ _0675_ net188 vssd1 vssd1 vccd1 vccd1 _0881_ sky130_fd_sc_hd__mux2_1
X_3298_ net315 LE_1B.config_data\[13\] net279 vssd1 vssd1 vccd1 vccd1 _0358_ sky130_fd_sc_hd__mux2_1
XFILLER_25_177 vssd1 vssd1 vccd1 vccd1 sky130_fd_sc_hd__fill_4
XFILLER_25_111 vssd1 vssd1 vccd1 vccd1 sky130_fd_sc_hd__fill_1
XFILLER_15_34 vssd1 vssd1 vccd1 vccd1 sky130_fd_sc_hd__fill_4
Xoutput88 net88 vssd1 vssd1 vccd1 vccd1 CBnorth_out[10] sky130_fd_sc_hd__buf_2
Xoutput99 net99 vssd1 vssd1 vccd1 vccd1 CBnorth_out[6] sky130_fd_sc_hd__buf_2
Xoutput77 net77 vssd1 vssd1 vccd1 vccd1 CBeast_out[15] sky130_fd_sc_hd__buf_2
XFILLER_31_169 vssd1 vssd1 vccd1 vccd1 sky130_fd_sc_hd__fill_8
XFILLER_31_147 vssd1 vssd1 vccd1 vccd1 sky130_fd_sc_hd__fill_1
XFILLER_8_354 vssd1 vssd1 vccd1 vccd1 sky130_fd_sc_hd__fill_1
XFILLER_16_188 vssd1 vssd1 vccd1 vccd1 sky130_fd_sc_hd__fill_1
X_1620_ net273 vssd1 vssd1 vccd1 vccd1 _1502_ sky130_fd_sc_hd__inv_2
X_3221_ CB_0.config_dataA\[12\] CB_0.config_dataA\[11\] net302 vssd1 vssd1 vccd1 vccd1
+ _0281_ sky130_fd_sc_hd__mux2_1
X_2103_ CB_0.config_dataA\[3\] CB_0.config_dataA\[2\] CB_0.config_dataA\[4\] vssd1
+ vssd1 vccd1 vccd1 _0737_ sky130_fd_sc_hd__or3b_1
XTAP_TAPCELL_ROW_37_404 vssd1 vccd1 sky130_fd_sc_hd__tapvpwrvgnd_1
X_3083_ SB0.route_sel\[2\] SB0.route_sel\[1\] net276 vssd1 vssd1 vccd1 vccd1 _0143_
+ sky130_fd_sc_hd__mux2_1
X_3152_ SB0.route_sel\[71\] SB0.route_sel\[70\] net273 vssd1 vssd1 vccd1 vccd1 _0212_
+ sky130_fd_sc_hd__mux2_1
X_2034_ net163 _0665_ net26 vssd1 vssd1 vccd1 vccd1 _0668_ sky130_fd_sc_hd__a21o_1
X_2798_ net148 _0645_ _0636_ vssd1 vssd1 vccd1 vccd1 _1406_ sky130_fd_sc_hd__mux2_1
X_1818_ _0372_ _0450_ vssd1 vssd1 vccd1 vccd1 _0452_ sky130_fd_sc_hd__nand2_1
X_2936_ _1491_ _0458_ vssd1 vssd1 vccd1 vccd1 net123 sky130_fd_sc_hd__and2b_1
X_2867_ _1445_ _0528_ vssd1 vssd1 vccd1 vccd1 net118 sky130_fd_sc_hd__and2b_1
X_1749_ SB0.route_sel\[114\] SB0.route_sel\[115\] vssd1 vssd1 vccd1 vccd1 _0383_ sky130_fd_sc_hd__nor2_1
X_3419_ LE_1B.sel_clk _0115_ net69 vssd1 vssd1 vccd1 vccd1 LE_1B.dff0_out sky130_fd_sc_hd__dfrtp_1
XFILLER_45_206 vssd1 vssd1 vccd1 vccd1 sky130_fd_sc_hd__fill_4
XFILLER_26_33 vssd1 vssd1 vccd1 vccd1 sky130_fd_sc_hd__fill_1
XFILLER_42_76 vssd1 vssd1 vccd1 vccd1 sky130_fd_sc_hd__fill_8
XFILLER_5_335 vssd1 vssd1 vccd1 vccd1 sky130_fd_sc_hd__fill_1
XTAP_TAPCELL_ROW_59_562 vssd1 vccd1 sky130_fd_sc_hd__tapvpwrvgnd_1
XFILLER_36_206 vssd1 vssd1 vccd1 vccd1 sky130_fd_sc_hd__fill_4
XFILLER_44_250 vssd1 vssd1 vccd1 vccd1 sky130_fd_sc_hd__fill_2
XFILLER_29_291 vssd1 vssd1 vccd1 vccd1 sky130_fd_sc_hd__fill_1
XTAP_TAPCELL_ROW_42_440 vssd1 vccd1 sky130_fd_sc_hd__tapvpwrvgnd_1
X_2721_ net1 net8 net9 net10 net204 net202 vssd1 vssd1 vccd1 vccd1 _1349_ sky130_fd_sc_hd__mux4_1
X_2652_ _1279_ vssd1 vssd1 vccd1 vccd1 _1280_ sky130_fd_sc_hd__inv_2
X_3204_ SB0.route_sel\[123\] SB0.route_sel\[122\] net296 vssd1 vssd1 vccd1 vccd1 _0264_
+ sky130_fd_sc_hd__mux2_1
X_2583_ net168 _1054_ vssd1 vssd1 vccd1 vccd1 _1213_ sky130_fd_sc_hd__nand2_1
XFILLER_27_217 vssd1 vssd1 vccd1 vccd1 sky130_fd_sc_hd__fill_1
X_3135_ SB0.route_sel\[54\] SB0.route_sel\[53\] net265 vssd1 vssd1 vccd1 vccd1 _0195_
+ sky130_fd_sc_hd__mux2_1
X_3066_ net206 CB_1.config_dataB\[9\] net286 vssd1 vssd1 vccd1 vccd1 _0126_ sky130_fd_sc_hd__mux2_1
X_2017_ CB_1.config_dataB\[23\] CB_1.config_dataB\[22\] vssd1 vssd1 vccd1 vccd1 _0651_
+ sky130_fd_sc_hd__or2_1
XTAP_TAPCELL_ROW_65_598 vssd1 vccd1 sky130_fd_sc_hd__tapvpwrvgnd_1
XFILLER_23_401 vssd1 vssd1 vccd1 vccd1 sky130_fd_sc_hd__fill_2
X_2919_ SB0.route_sel\[2\] SB0.route_sel\[3\] vssd1 vssd1 vccd1 vccd1 _1480_ sky130_fd_sc_hd__nand2b_1
XFILLER_58_386 vssd1 vssd1 vccd1 vccd1 sky130_fd_sc_hd__fill_2
XFILLER_18_228 vccd1 vssd1 vccd1 vssd1 sky130_ef_sc_hd__decap_40_12
XFILLER_38_7 vssd1 vssd1 vccd1 vccd1 sky130_fd_sc_hd__fill_1
XTAP_TAPCELL_ROW_62_579 vssd1 vccd1 sky130_fd_sc_hd__tapvpwrvgnd_1
XTAP_TAPCELL_ROW_19_278 vssd1 vccd1 sky130_fd_sc_hd__tapvpwrvgnd_1
X_2635_ net213 _1034_ vssd1 vssd1 vccd1 vccd1 _1263_ sky130_fd_sc_hd__nand2_1
X_2704_ CB_1.config_dataB\[12\] _1331_ CB_1.config_dataB\[13\] vssd1 vssd1 vccd1 vccd1
+ _1332_ sky130_fd_sc_hd__a21o_1
X_2497_ net174 _1058_ vssd1 vssd1 vccd1 vccd1 _1127_ sky130_fd_sc_hd__or2_1
X_2566_ net1 net8 net9 net10 net169 CB_1.config_dataA\[16\] vssd1 vssd1 vccd1 vccd1
+ _1196_ sky130_fd_sc_hd__mux4_1
XTAP_TAPCELL_ROW_2_157 vssd1 vccd1 sky130_fd_sc_hd__tapvpwrvgnd_1
X_3049_ net401 LE_1A.config_data\[13\] net280 vssd1 vssd1 vccd1 vccd1 _0109_ sky130_fd_sc_hd__mux2_1
X_3118_ SB0.route_sel\[37\] SB0.route_sel\[36\] net262 vssd1 vssd1 vccd1 vccd1 _0178_
+ sky130_fd_sc_hd__mux2_1
XFILLER_23_45 vssd1 vssd1 vccd1 vccd1 sky130_fd_sc_hd__fill_2
XFILLER_48_75 vssd1 vssd1 vccd1 vccd1 sky130_fd_sc_hd__fill_8
XFILLER_0_27 vssd1 vssd1 vccd1 vccd1 sky130_fd_sc_hd__fill_1
XFILLER_64_85 vssd1 vssd1 vccd1 vccd1 sky130_fd_sc_hd__fill_1
XFILLER_14_231 vccd1 vssd1 vccd1 vssd1 sky130_ef_sc_hd__decap_40_12
XFILLER_14_253 vssd1 vssd1 vccd1 vccd1 sky130_fd_sc_hd__fill_2
XTAP_TAPCELL_ROW_16_259 vssd1 vccd1 sky130_fd_sc_hd__tapvpwrvgnd_1
X_2420_ _1048_ _1049_ CB_1.config_dataA\[2\] vssd1 vssd1 vccd1 vccd1 _1050_ sky130_fd_sc_hd__mux2_1
XTAP_TAPCELL_ROW_67_616 vssd1 vccd1 sky130_fd_sc_hd__tapvpwrvgnd_1
X_2351_ net181 _0603_ _0982_ vssd1 vssd1 vccd1 vccd1 _0983_ sky130_fd_sc_hd__o21ba_1
X_2282_ CB_0.config_dataB\[7\] _0912_ _0913_ vssd1 vssd1 vccd1 vccd1 _0914_ sky130_fd_sc_hd__a21oi_1
XFILLER_64_197 vssd1 vssd1 vccd1 vccd1 sky130_fd_sc_hd__fill_1
XFILLER_37_345 vssd1 vssd1 vccd1 vccd1 sky130_fd_sc_hd__fill_1
XFILLER_37_334 vssd1 vssd1 vccd1 vccd1 sky130_fd_sc_hd__fill_2
X_1997_ SB0.route_sel\[44\] SB0.route_sel\[45\] net44 vssd1 vssd1 vccd1 vccd1 _0631_
+ sky130_fd_sc_hd__a21boi_1
XFILLER_20_278 vssd1 vssd1 vccd1 vccd1 sky130_fd_sc_hd__fill_4
X_2549_ _1173_ _1174_ _1178_ vssd1 vssd1 vccd1 vccd1 _1179_ sky130_fd_sc_hd__and3_1
X_3598_ clknet_leaf_3_clk _0294_ net233 vssd1 vssd1 vccd1 vccd1 CB_0.config_dataB\[0\]
+ sky130_fd_sc_hd__dfstp_1
X_3667_ clknet_leaf_34_clk _0363_ net215 vssd1 vssd1 vccd1 vccd1 LE_1B.reset_mode
+ sky130_fd_sc_hd__dfrtp_1
X_2618_ net1 net8 net9 net10 net212 net211 vssd1 vssd1 vccd1 vccd1 _1246_ sky130_fd_sc_hd__mux4_1
XFILLER_43_337 vssd1 vssd1 vccd1 vccd1 sky130_fd_sc_hd__fill_2
XFILLER_43_326 vssd1 vssd1 vccd1 vccd1 sky130_fd_sc_hd__fill_1
XFILLER_18_78 vssd1 vssd1 vccd1 vccd1 sky130_fd_sc_hd__fill_4
XTAP_TAPCELL_ROW_21_295 vssd1 vccd1 sky130_fd_sc_hd__tapvpwrvgnd_1
XFILLER_61_134 vssd1 vssd1 vccd1 vccd1 sky130_fd_sc_hd__fill_1
Xfanout291 net310 vssd1 vssd1 vccd1 vccd1 net291 sky130_fd_sc_hd__clkbuf_4
XFILLER_46_153 vssd1 vssd1 vccd1 vccd1 sky130_fd_sc_hd__fill_8
XFILLER_34_348 vssd1 vssd1 vccd1 vccd1 sky130_fd_sc_hd__fill_8
XTAP_TAPCELL_ROW_29_351 vssd1 vccd1 sky130_fd_sc_hd__tapvpwrvgnd_1
Xfanout280 net283 vssd1 vssd1 vccd1 vccd1 net280 sky130_fd_sc_hd__buf_2
X_1851_ net163 _0482_ net19 vssd1 vssd1 vccd1 vccd1 _0485_ sky130_fd_sc_hd__a21o_1
X_1920_ CB_1.config_dataA\[23\] CB_1.config_dataA\[22\] vssd1 vssd1 vccd1 vccd1 _0554_
+ sky130_fd_sc_hd__nand2b_1
X_3383_ clknet_leaf_6_clk net408 net228 vssd1 vssd1 vccd1 vccd1 LE_0B.config_data\[6\]
+ sky130_fd_sc_hd__dfrtp_1
X_2403_ SB0.route_sel\[124\] SB0.route_sel\[125\] SB0.route_sel\[120\] _1571_ _1032_
+ vssd1 vssd1 vccd1 vccd1 _1033_ sky130_fd_sc_hd__o221a_1
X_1782_ net144 _1611_ _0414_ vssd1 vssd1 vccd1 vccd1 _0416_ sky130_fd_sc_hd__or3_1
X_3452_ clknet_leaf_31_clk _0148_ net223 vssd1 vssd1 vccd1 vccd1 SB0.route_sel\[7\]
+ sky130_fd_sc_hd__dfstp_1
X_3521_ clknet_leaf_0_clk _0217_ net220 vssd1 vssd1 vccd1 vccd1 SB0.route_sel\[76\]
+ sky130_fd_sc_hd__dfstp_1
X_2334_ _1581_ _0964_ _0965_ vssd1 vssd1 vccd1 vccd1 _0966_ sky130_fd_sc_hd__o21ai_1
X_2196_ net191 _0385_ vssd1 vssd1 vccd1 vccd1 _0830_ sky130_fd_sc_hd__nor2_1
X_2265_ CB_0.config_dataB\[3\] _0888_ _0892_ _0896_ vssd1 vssd1 vccd1 vccd1 _0897_
+ sky130_fd_sc_hd__and4_2
XFILLER_52_167 vccd1 vssd1 vccd1 vssd1 sky130_ef_sc_hd__decap_40_12
Xhold22 LE_1B.config_data\[11\] vssd1 vssd1 vccd1 vccd1 net332 sky130_fd_sc_hd__dlygate4sd3_1
Xhold11 LE_1B.config_data\[9\] vssd1 vssd1 vccd1 vccd1 net321 sky130_fd_sc_hd__dlygate4sd3_1
Xhold44 LEI0.config_data\[13\] vssd1 vssd1 vccd1 vccd1 net354 sky130_fd_sc_hd__dlygate4sd3_1
Xhold66 LE_0A.config_data\[0\] vssd1 vssd1 vccd1 vccd1 net376 sky130_fd_sc_hd__dlygate4sd3_1
Xhold99 LEI0.config_data\[46\] vssd1 vssd1 vccd1 vccd1 net409 sky130_fd_sc_hd__dlygate4sd3_1
Xhold77 _0021_ vssd1 vssd1 vccd1 vccd1 net387 sky130_fd_sc_hd__dlygate4sd3_1
Xhold33 _0082_ vssd1 vssd1 vccd1 vccd1 net343 sky130_fd_sc_hd__dlygate4sd3_1
Xhold88 LEI0.config_data\[43\] vssd1 vssd1 vccd1 vccd1 net398 sky130_fd_sc_hd__dlygate4sd3_1
XFILLER_28_197 vssd1 vssd1 vccd1 vccd1 sky130_fd_sc_hd__fill_1
XFILLER_28_175 vssd1 vssd1 vccd1 vccd1 sky130_fd_sc_hd__fill_4
Xhold55 _0099_ vssd1 vssd1 vccd1 vccd1 net365 sky130_fd_sc_hd__dlygate4sd3_1
XFILLER_24_381 vssd1 vssd1 vccd1 vccd1 sky130_fd_sc_hd__fill_1
XANTENNA_8 CBnorth_in[5] vssd1 vssd1 vccd1 vccd1 sky130_fd_sc_hd__diode_2
X_2050_ net138 net166 net156 _0654_ _1610_ vssd1 vssd1 vccd1 vccd1 _0684_ sky130_fd_sc_hd__o32a_1
X_2952_ net395 LEI0.config_data\[10\] net307 vssd1 vssd1 vccd1 vccd1 _0012_ sky130_fd_sc_hd__mux2_1
XFILLER_34_178 vssd1 vssd1 vccd1 vccd1 sky130_fd_sc_hd__fill_8
X_1834_ _0465_ _0467_ _1495_ vssd1 vssd1 vccd1 vccd1 _0468_ sky130_fd_sc_hd__a21o_1
XTAP_TAPCELL_ROW_32_368 vssd1 vccd1 sky130_fd_sc_hd__tapvpwrvgnd_1
XFILLER_30_362 vssd1 vssd1 vccd1 vccd1 sky130_fd_sc_hd__fill_2
X_1765_ net138 net165 net162 _0398_ _1611_ vssd1 vssd1 vccd1 vccd1 _0399_ sky130_fd_sc_hd__o32a_1
X_2883_ SB0.route_sel\[55\] SB0.route_sel\[54\] vssd1 vssd1 vccd1 vccd1 _1456_ sky130_fd_sc_hd__nor2_1
X_1903_ SB0.route_sel\[68\] SB0.route_sel\[69\] net47 vssd1 vssd1 vccd1 vccd1 _0537_
+ sky130_fd_sc_hd__a21boi_1
X_3366_ clknet_leaf_6_clk _0062_ net230 vssd1 vssd1 vccd1 vccd1 LE_0A.config_data\[11\]
+ sky130_fd_sc_hd__dfrtp_1
X_1696_ net186 vssd1 vssd1 vccd1 vccd1 _1578_ sky130_fd_sc_hd__inv_2
X_3435_ clknet_leaf_21_clk _0131_ net246 vssd1 vssd1 vccd1 vccd1 CB_1.config_dataB\[15\]
+ sky130_fd_sc_hd__dfstp_1
X_3504_ clknet_leaf_28_clk _0200_ net240 vssd1 vssd1 vccd1 vccd1 SB0.route_sel\[59\]
+ sky130_fd_sc_hd__dfstp_1
X_2317_ net31 net32 net18 net19 net185 net183 vssd1 vssd1 vccd1 vccd1 _0949_ sky130_fd_sc_hd__mux4_1
X_2179_ _0796_ _0809_ _0811_ vssd1 vssd1 vccd1 vccd1 _0813_ sky130_fd_sc_hd__o21bai_2
X_2248_ _1576_ _0879_ _0878_ vssd1 vssd1 vccd1 vccd1 _0880_ sky130_fd_sc_hd__a21oi_1
X_3297_ net378 net345 net279 vssd1 vssd1 vccd1 vccd1 _0357_ sky130_fd_sc_hd__mux2_1
XFILLER_25_167 vssd1 vssd1 vccd1 vccd1 sky130_fd_sc_hd__fill_1
XFILLER_21_362 vssd1 vssd1 vccd1 vccd1 sky130_fd_sc_hd__fill_1
Xoutput89 net89 vssd1 vssd1 vccd1 vccd1 CBnorth_out[11] sky130_fd_sc_hd__buf_2
Xoutput78 net78 vssd1 vssd1 vccd1 vccd1 CBeast_out[1] sky130_fd_sc_hd__buf_2
X_3220_ CB_0.config_dataA\[11\] net195 net302 vssd1 vssd1 vccd1 vccd1 _0280_ sky130_fd_sc_hd__mux2_1
X_2102_ _0468_ _0552_ _0647_ _0735_ CB_0.config_dataA\[4\] vssd1 vssd1 vccd1 vccd1
+ _0736_ sky130_fd_sc_hd__a221o_2
X_2033_ net163 _0665_ vssd1 vssd1 vccd1 vccd1 _0667_ sky130_fd_sc_hd__and2_1
XFILLER_39_259 vssd1 vssd1 vccd1 vccd1 sky130_fd_sc_hd__fill_1
XTAP_TAPCELL_ROW_37_405 vssd1 vccd1 sky130_fd_sc_hd__tapvpwrvgnd_1
X_3082_ SB0.route_sel\[1\] SB0.route_sel\[0\] net267 vssd1 vssd1 vccd1 vccd1 _0142_
+ sky130_fd_sc_hd__mux2_1
XFILLER_11_3 vssd1 vssd1 vccd1 vccd1 sky130_fd_sc_hd__fill_2
X_3151_ SB0.route_sel\[70\] SB0.route_sel\[69\] net273 vssd1 vssd1 vccd1 vccd1 _0211_
+ sky130_fd_sc_hd__mux2_1
XTAP_TAPCELL_ROW_45_460 vssd1 vccd1 sky130_fd_sc_hd__tapvpwrvgnd_1
X_2935_ _1560_ SB0.route_sel\[107\] SB0.route_sel\[108\] _1562_ _1490_ vssd1 vssd1
+ vccd1 vccd1 _1491_ sky130_fd_sc_hd__o221a_1
XFILLER_22_137 vssd1 vssd1 vccd1 vccd1 sky130_fd_sc_hd__fill_2
X_2797_ _1405_ net152 _0593_ vssd1 vssd1 vccd1 vccd1 net99 sky130_fd_sc_hd__mux2_1
X_1748_ _0368_ _0370_ _0381_ net297 vssd1 vssd1 vccd1 vccd1 _0382_ sky130_fd_sc_hd__a211oi_2
X_1817_ CB_0.config_dataA\[24\] CB_0.config_dataA\[21\] CB_0.config_dataA\[20\] vssd1
+ vssd1 vccd1 vccd1 _0451_ sky130_fd_sc_hd__or3b_1
X_2866_ SB0.route_sel\[79\] SB0.route_sel\[78\] SB0.route_sel\[73\] _1546_ _1444_
+ vssd1 vssd1 vccd1 vccd1 _1445_ sky130_fd_sc_hd__o221a_1
X_3349_ clknet_leaf_16_clk net399 net258 vssd1 vssd1 vccd1 vccd1 LEI0.config_data\[44\]
+ sky130_fd_sc_hd__dfrtp_1
X_1679_ SB0.route_sel\[107\] vssd1 vssd1 vccd1 vccd1 _1561_ sky130_fd_sc_hd__inv_2
X_3418_ clknet_leaf_25_clk _0114_ net242 vssd1 vssd1 vccd1 vccd1 LE_1A.reset_mode
+ sky130_fd_sc_hd__dfrtp_1
XFILLER_41_402 vssd1 vssd1 vccd1 vccd1 sky130_fd_sc_hd__fill_1
XFILLER_42_33 vssd1 vssd1 vccd1 vccd1 sky130_fd_sc_hd__fill_1
XFILLER_13_137 vssd1 vssd1 vccd1 vccd1 sky130_fd_sc_hd__fill_8
XFILLER_29_281 vssd1 vssd1 vccd1 vccd1 sky130_fd_sc_hd__fill_8
XTAP_TAPCELL_ROW_42_441 vssd1 vccd1 sky130_fd_sc_hd__tapvpwrvgnd_1
X_2720_ _1079_ _1345_ _1346_ _1083_ _1599_ vssd1 vssd1 vccd1 vccd1 _1348_ sky130_fd_sc_hd__a221o_1
X_2582_ _1210_ _1211_ _1592_ vssd1 vssd1 vccd1 vccd1 _1212_ sky130_fd_sc_hd__mux2_1
X_2651_ net208 net210 vssd1 vssd1 vccd1 vccd1 _1279_ sky130_fd_sc_hd__and2b_1
XFILLER_67_343 vssd1 vssd1 vccd1 vccd1 sky130_fd_sc_hd__fill_1
X_3203_ SB0.route_sel\[122\] SB0.route_sel\[121\] net296 vssd1 vssd1 vccd1 vccd1 _0263_
+ sky130_fd_sc_hd__mux2_1
XTAP_TAPCELL_ROW_65_599 vssd1 vccd1 sky130_fd_sc_hd__tapvpwrvgnd_1
X_2016_ net17 net24 net25 net26 net200 net199 vssd1 vssd1 vccd1 vccd1 _0650_ sky130_fd_sc_hd__mux4_1
XFILLER_27_229 vssd1 vssd1 vccd1 vccd1 sky130_fd_sc_hd__fill_1
X_3134_ SB0.route_sel\[53\] SB0.route_sel\[52\] net265 vssd1 vssd1 vccd1 vccd1 _0194_
+ sky130_fd_sc_hd__mux2_1
X_3065_ CB_1.config_dataB\[9\] CB_1.config_dataB\[8\] net285 vssd1 vssd1 vccd1 vccd1
+ _0125_ sky130_fd_sc_hd__mux2_1
XPHY_EDGE_ROW_19_Left_87 vssd1 vssd1 vccd1 vccd1 sky130_fd_sc_hd__decap_3
X_2918_ _1479_ _0730_ vssd1 vssd1 vccd1 vccd1 net119 sky130_fd_sc_hd__and2b_1
Xclkbuf_leaf_30_clk clknet_2_0__leaf_clk vssd1 vssd1 vccd1 vccd1 clknet_leaf_30_clk
+ sky130_fd_sc_hd__clkbuf_8
X_2849_ _0432_ _1433_ vssd1 vssd1 vccd1 vccd1 net106 sky130_fd_sc_hd__and2_1
XFILLER_37_99 vssd1 vssd1 vccd1 vccd1 sky130_fd_sc_hd__fill_1
XFILLER_26_240 vccd1 vssd1 vccd1 vssd1 sky130_ef_sc_hd__decap_40_12
XFILLER_5_111 vssd1 vssd1 vccd1 vccd1 sky130_fd_sc_hd__fill_1
Xclkbuf_leaf_21_clk clknet_2_2__leaf_clk vssd1 vssd1 vccd1 vccd1 clknet_leaf_21_clk
+ sky130_fd_sc_hd__clkbuf_8
XFILLER_5_166 vssd1 vssd1 vccd1 vccd1 sky130_fd_sc_hd__fill_2
XFILLER_17_240 vssd1 vssd1 vccd1 vccd1 sky130_fd_sc_hd__fill_2
XTAP_TAPCELL_ROW_19_279 vssd1 vccd1 sky130_fd_sc_hd__tapvpwrvgnd_1
Xclkbuf_leaf_12_clk clknet_2_3__leaf_clk vssd1 vssd1 vccd1 vccd1 clknet_leaf_12_clk
+ sky130_fd_sc_hd__clkbuf_8
X_2565_ _1079_ _1193_ _1194_ _1083_ _1592_ vssd1 vssd1 vccd1 vccd1 _1195_ sky130_fd_sc_hd__a221o_1
X_2634_ net212 _1030_ vssd1 vssd1 vccd1 vccd1 _1262_ sky130_fd_sc_hd__or2_1
X_2703_ net11 net12 net13 net14 net206 net205 vssd1 vssd1 vccd1 vccd1 _1331_ sky130_fd_sc_hd__mux4_1
X_2496_ net174 _1054_ vssd1 vssd1 vccd1 vccd1 _1126_ sky130_fd_sc_hd__nand2_1
X_3117_ SB0.route_sel\[36\] SB0.route_sel\[35\] net269 vssd1 vssd1 vccd1 vccd1 _0177_
+ sky130_fd_sc_hd__mux2_1
XFILLER_55_335 vssd1 vssd1 vccd1 vccd1 sky130_fd_sc_hd__fill_1
XTAP_TAPCELL_ROW_53_514 vssd1 vccd1 sky130_fd_sc_hd__tapvpwrvgnd_1
XTAP_TAPCELL_ROW_2_158 vssd1 vccd1 sky130_fd_sc_hd__tapvpwrvgnd_1
X_3048_ LE_1A.config_data\[13\] net405 net282 vssd1 vssd1 vccd1 vccd1 _0108_ sky130_fd_sc_hd__mux2_1
XFILLER_14_243 vssd1 vssd1 vccd1 vccd1 sky130_fd_sc_hd__fill_8
XTAP_TAPCELL_ROW_67_617 vssd1 vccd1 sky130_fd_sc_hd__tapvpwrvgnd_1
X_2350_ net182 _0566_ _0577_ _0580_ _1584_ vssd1 vssd1 vccd1 vccd1 _0982_ sky130_fd_sc_hd__a41o_1
X_2281_ CB_0.config_dataB\[7\] _0908_ CB_0.config_dataB\[8\] vssd1 vssd1 vccd1 vccd1
+ _0913_ sky130_fd_sc_hd__a21o_1
XPHY_EDGE_ROW_32_Left_100 vssd1 vssd1 vccd1 vccd1 sky130_fd_sc_hd__decap_3
Xclkbuf_leaf_1_clk clknet_2_0__leaf_clk vssd1 vssd1 vccd1 vccd1 clknet_leaf_1_clk
+ sky130_fd_sc_hd__clkbuf_8
X_1996_ SB0.route_sel\[43\] SB0.route_sel\[42\] _0627_ _0628_ _0629_ vssd1 vssd1 vccd1
+ vccd1 _0630_ sky130_fd_sc_hd__a221oi_1
X_2548_ _1169_ _1170_ _1176_ _1177_ vssd1 vssd1 vccd1 vccd1 _1178_ sky130_fd_sc_hd__o22a_1
X_3597_ clknet_leaf_11_clk _0293_ net233 vssd1 vssd1 vccd1 vccd1 CB_0.config_dataA\[24\]
+ sky130_fd_sc_hd__dfstp_2
X_3666_ clknet_leaf_26_clk _0362_ net237 vssd1 vssd1 vccd1 vccd1 LE_1B.reset_val sky130_fd_sc_hd__dfrtp_2
X_2617_ net211 _1238_ _1239_ _1244_ vssd1 vssd1 vccd1 vccd1 _1245_ sky130_fd_sc_hd__a31o_1
X_2479_ LEI0.config_data\[7\] _1108_ vssd1 vssd1 vccd1 vccd1 _1109_ sky130_fd_sc_hd__nor2_1
XFILLER_43_305 vssd1 vssd1 vccd1 vccd1 sky130_fd_sc_hd__fill_2
XFILLER_34_78 vssd1 vssd1 vccd1 vccd1 sky130_fd_sc_hd__fill_4
XFILLER_11_246 vssd1 vssd1 vccd1 vccd1 sky130_fd_sc_hd__fill_1
Xclkload0 clknet_2_1__leaf_clk vssd1 vssd1 vccd1 vccd1 clkload0/Y sky130_fd_sc_hd__inv_6
XFILLER_50_99 vssd1 vssd1 vccd1 vccd1 sky130_fd_sc_hd__fill_2
XTAP_TAPCELL_ROW_21_296 vssd1 vccd1 sky130_fd_sc_hd__tapvpwrvgnd_1
XFILLER_59_53 vssd1 vssd1 vccd1 vccd1 sky130_fd_sc_hd__fill_2
Xfanout292 net295 vssd1 vssd1 vccd1 vccd1 net292 sky130_fd_sc_hd__clkbuf_4
Xfanout270 net272 vssd1 vssd1 vccd1 vccd1 net270 sky130_fd_sc_hd__clkbuf_4
Xfanout281 net283 vssd1 vssd1 vccd1 vccd1 net281 sky130_fd_sc_hd__clkbuf_4
XFILLER_61_113 vssd1 vssd1 vccd1 vccd1 sky130_fd_sc_hd__fill_1
XTAP_TAPCELL_ROW_29_352 vssd1 vccd1 sky130_fd_sc_hd__tapvpwrvgnd_1
X_1850_ net163 _0482_ vssd1 vssd1 vccd1 vccd1 _0484_ sky130_fd_sc_hd__and2_1
X_1781_ net138 net165 net161 _0414_ _1611_ vssd1 vssd1 vccd1 vccd1 _0415_ sky130_fd_sc_hd__o32ai_2
XTAP_TAPCELL_ROW_12_230 vssd1 vccd1 sky130_fd_sc_hd__tapvpwrvgnd_1
X_3520_ clknet_leaf_0_clk _0216_ net220 vssd1 vssd1 vccd1 vccd1 SB0.route_sel\[75\]
+ sky130_fd_sc_hd__dfstp_1
X_2333_ _0733_ _0945_ _0946_ _0715_ _1580_ vssd1 vssd1 vccd1 vccd1 _0965_ sky130_fd_sc_hd__o221a_1
X_3382_ clknet_leaf_5_clk net352 net228 vssd1 vssd1 vccd1 vccd1 LE_0B.config_data\[5\]
+ sky130_fd_sc_hd__dfrtp_1
X_2402_ net135 SB0.route_sel\[126\] vssd1 vssd1 vccd1 vccd1 _1032_ sky130_fd_sc_hd__nand2b_1
X_3451_ clknet_leaf_31_clk _0147_ net223 vssd1 vssd1 vccd1 vccd1 SB0.route_sel\[6\]
+ sky130_fd_sc_hd__dfstp_1
X_2195_ _0826_ _0827_ _0828_ vssd1 vssd1 vccd1 vccd1 _0829_ sky130_fd_sc_hd__a21oi_1
X_2264_ net187 _0893_ _0894_ _0895_ vssd1 vssd1 vccd1 vccd1 _0896_ sky130_fd_sc_hd__a31o_1
XFILLER_37_121 vssd1 vssd1 vccd1 vccd1 sky130_fd_sc_hd__fill_1
XTAP_TAPCELL_ROW_35_388 vssd1 vccd1 sky130_fd_sc_hd__tapvpwrvgnd_1
X_3649_ clknet_leaf_26_clk _0345_ net237 vssd1 vssd1 vccd1 vccd1 LE_1B.config_data\[1\]
+ sky130_fd_sc_hd__dfrtp_1
X_1979_ net141 net161 net157 _0554_ _0414_ vssd1 vssd1 vccd1 vccd1 _0613_ sky130_fd_sc_hd__o32ai_1
XFILLER_20_25 vssd1 vssd1 vccd1 vccd1 sky130_fd_sc_hd__fill_2
Xhold56 LE_0A.config_data\[10\] vssd1 vssd1 vccd1 vccd1 net366 sky130_fd_sc_hd__dlygate4sd3_1
Xhold45 LE_0B.config_data\[10\] vssd1 vssd1 vccd1 vccd1 net355 sky130_fd_sc_hd__dlygate4sd3_1
Xhold34 LE_0B.config_data\[15\] vssd1 vssd1 vccd1 vccd1 net344 sky130_fd_sc_hd__dlygate4sd3_1
Xhold23 LE_1B.config_data\[15\] vssd1 vssd1 vccd1 vccd1 net333 sky130_fd_sc_hd__dlygate4sd3_1
Xhold12 _0353_ vssd1 vssd1 vccd1 vccd1 net322 sky130_fd_sc_hd__dlygate4sd3_1
Xhold89 _0045_ vssd1 vssd1 vccd1 vccd1 net399 sky130_fd_sc_hd__dlygate4sd3_1
XFILLER_45_77 vssd1 vssd1 vccd1 vccd1 sky130_fd_sc_hd__fill_4
Xhold67 LE_1A.config_data\[2\] vssd1 vssd1 vccd1 vccd1 net377 sky130_fd_sc_hd__dlygate4sd3_1
Xhold78 LE_1B.config_data\[3\] vssd1 vssd1 vccd1 vccd1 net388 sky130_fd_sc_hd__dlygate4sd3_1
XFILLER_61_54 vssd1 vssd1 vccd1 vccd1 sky130_fd_sc_hd__fill_2
XFILLER_43_179 vssd1 vssd1 vccd1 vccd1 sky130_fd_sc_hd__fill_1
XPHY_EDGE_ROW_7_Left_75 vssd1 vssd1 vccd1 vccd1 sky130_fd_sc_hd__decap_3
XFILLER_6_27 vssd1 vssd1 vccd1 vccd1 sky130_fd_sc_hd__fill_1
XANTENNA_9 SBsouth_in[14] vssd1 vssd1 vccd1 vccd1 sky130_fd_sc_hd__diode_2
XFILLER_19_165 vssd1 vssd1 vccd1 vccd1 sky130_fd_sc_hd__fill_2
X_2951_ net428 LEI0.config_data\[9\] net307 vssd1 vssd1 vccd1 vccd1 _0011_ sky130_fd_sc_hd__mux2_1
X_1902_ SB0.route_sel\[67\] SB0.route_sel\[66\] _0533_ _0534_ _0535_ vssd1 vssd1 vccd1
+ vccd1 _0536_ sky130_fd_sc_hd__a221oi_1
X_1833_ _0466_ vssd1 vssd1 vccd1 vccd1 _0467_ sky130_fd_sc_hd__inv_2
XTAP_TAPCELL_ROW_32_369 vssd1 vccd1 sky130_fd_sc_hd__tapvpwrvgnd_1
X_2882_ _1455_ _0599_ vssd1 vssd1 vccd1 vccd1 net131 sky130_fd_sc_hd__and2b_1
X_1764_ CB_1.config_dataA\[24\] CB_1.config_dataA\[21\] CB_1.config_dataA\[20\] vssd1
+ vssd1 vccd1 vccd1 _0398_ sky130_fd_sc_hd__nand3b_1
X_3503_ clknet_leaf_30_clk _0199_ net226 vssd1 vssd1 vccd1 vccd1 SB0.route_sel\[58\]
+ sky130_fd_sc_hd__dfstp_1
X_2316_ _1581_ _0942_ _0943_ _0947_ vssd1 vssd1 vccd1 vccd1 _0948_ sky130_fd_sc_hd__o31a_1
X_3365_ clknet_leaf_6_clk net367 net230 vssd1 vssd1 vccd1 vccd1 LE_0A.config_data\[10\]
+ sky130_fd_sc_hd__dfrtp_1
XFILLER_57_216 vssd1 vssd1 vccd1 vccd1 sky130_fd_sc_hd__fill_2
X_1695_ net187 vssd1 vssd1 vccd1 vccd1 _1577_ sky130_fd_sc_hd__inv_2
X_3296_ net345 net332 net279 vssd1 vssd1 vccd1 vccd1 _0356_ sky130_fd_sc_hd__mux2_1
X_3434_ clknet_leaf_23_clk _0130_ net246 vssd1 vssd1 vccd1 vccd1 CB_1.config_dataB\[14\]
+ sky130_fd_sc_hd__dfstp_1
X_2178_ _0796_ _0809_ _0811_ vssd1 vssd1 vccd1 vccd1 _0812_ sky130_fd_sc_hd__o21ba_1
XTAP_TAPCELL_ROW_48_480 vssd1 vccd1 sky130_fd_sc_hd__tapvpwrvgnd_1
X_2247_ net17 net24 net25 net26 net188 net187 vssd1 vssd1 vccd1 vccd1 _0879_ sky130_fd_sc_hd__mux4_1
XFILLER_25_102 vssd1 vssd1 vccd1 vccd1 sky130_fd_sc_hd__fill_2
XFILLER_31_24 vssd1 vssd1 vccd1 vccd1 sky130_fd_sc_hd__fill_4
XFILLER_31_68 vssd1 vssd1 vccd1 vccd1 sky130_fd_sc_hd__fill_2
XFILLER_0_212 vssd1 vssd1 vccd1 vccd1 sky130_fd_sc_hd__fill_2
XFILLER_0_223 vssd1 vssd1 vccd1 vccd1 sky130_fd_sc_hd__fill_1
Xoutput79 net79 vssd1 vssd1 vccd1 vccd1 CBeast_out[2] sky130_fd_sc_hd__buf_2
XFILLER_31_138 vssd1 vssd1 vccd1 vccd1 sky130_fd_sc_hd__fill_2
XFILLER_16_135 vssd1 vssd1 vccd1 vccd1 sky130_fd_sc_hd__fill_4
XPHY_EDGE_ROW_19_Right_19 vssd1 vssd1 vccd1 vccd1 sky130_fd_sc_hd__decap_3
XPHY_EDGE_ROW_28_Right_28 vssd1 vssd1 vccd1 vccd1 sky130_fd_sc_hd__decap_3
X_3150_ SB0.route_sel\[69\] SB0.route_sel\[68\] net273 vssd1 vssd1 vccd1 vccd1 _0210_
+ sky130_fd_sc_hd__mux2_1
X_2032_ net179 net180 vssd1 vssd1 vccd1 vccd1 _0666_ sky130_fd_sc_hd__or2_2
X_2101_ _1495_ _0650_ _0697_ _0734_ _0649_ vssd1 vssd1 vccd1 vccd1 _0735_ sky130_fd_sc_hd__a221oi_1
XPHY_EDGE_ROW_37_Right_37 vssd1 vssd1 vccd1 vccd1 sky130_fd_sc_hd__decap_3
XTAP_TAPCELL_ROW_37_406 vssd1 vccd1 sky130_fd_sc_hd__tapvpwrvgnd_1
X_3081_ SB0.route_sel\[0\] CB_1.config_dataB\[24\] net278 vssd1 vssd1 vccd1 vccd1
+ _0141_ sky130_fd_sc_hd__mux2_1
XTAP_TAPCELL_ROW_45_461 vssd1 vccd1 sky130_fd_sc_hd__tapvpwrvgnd_1
X_2934_ SB0.route_sel\[104\] SB0.route_sel\[105\] vssd1 vssd1 vccd1 vccd1 _1490_ sky130_fd_sc_hd__or2_1
X_2865_ SB0.route_sel\[75\] _1542_ vssd1 vssd1 vccd1 vccd1 _1444_ sky130_fd_sc_hd__nand2_1
X_2796_ _0594_ _0603_ _0595_ vssd1 vssd1 vccd1 vccd1 _1405_ sky130_fd_sc_hd__a21oi_1
XPHY_EDGE_ROW_46_Right_46 vssd1 vssd1 vccd1 vccd1 sky130_fd_sc_hd__decap_3
X_1747_ _0374_ _0378_ _0379_ _0380_ _1605_ vssd1 vssd1 vccd1 vccd1 _0381_ sky130_fd_sc_hd__o311a_1
X_1816_ CB_0.config_dataA\[24\] CB_0.config_dataA\[21\] CB_0.config_dataA\[20\] vssd1
+ vssd1 vccd1 vccd1 _0450_ sky130_fd_sc_hd__nor3b_4
X_1678_ SB0.route_sel\[106\] vssd1 vssd1 vccd1 vccd1 _1560_ sky130_fd_sc_hd__inv_2
XFILLER_30_193 vssd1 vssd1 vccd1 vccd1 sky130_fd_sc_hd__fill_2
X_3348_ clknet_leaf_16_clk _0044_ net258 vssd1 vssd1 vccd1 vccd1 LEI0.config_data\[43\]
+ sky130_fd_sc_hd__dfrtp_1
XPHY_EDGE_ROW_55_Right_55 vssd1 vssd1 vccd1 vccd1 sky130_fd_sc_hd__decap_3
X_3417_ clknet_leaf_25_clk _0113_ net242 vssd1 vssd1 vccd1 vccd1 LE_1A.reset_val sky130_fd_sc_hd__dfrtp_1
X_3279_ CB_1.config_dataA\[20\] CB_1.config_dataA\[19\] net282 vssd1 vssd1 vccd1 vccd1
+ _0339_ sky130_fd_sc_hd__mux2_1
XPHY_EDGE_ROW_64_Right_64 vssd1 vssd1 vccd1 vccd1 sky130_fd_sc_hd__decap_3
XTAP_TAPCELL_ROW_42_442 vssd1 vccd1 sky130_fd_sc_hd__tapvpwrvgnd_1
X_2581_ net15 net16 net2 net3 net169 net167 vssd1 vssd1 vccd1 vccd1 _1211_ sky130_fd_sc_hd__mux4_1
X_2650_ _1277_ vssd1 vssd1 vccd1 vccd1 _1278_ sky130_fd_sc_hd__inv_2
X_3202_ SB0.route_sel\[121\] SB0.route_sel\[120\] net297 vssd1 vssd1 vccd1 vccd1 _0262_
+ sky130_fd_sc_hd__mux2_1
X_3133_ SB0.route_sel\[52\] SB0.route_sel\[51\] net265 vssd1 vssd1 vccd1 vccd1 _0193_
+ sky130_fd_sc_hd__mux2_1
X_2015_ CB_0.config_dataA\[2\] _0648_ CB_0.config_dataA\[3\] vssd1 vssd1 vccd1 vccd1
+ _0649_ sky130_fd_sc_hd__a21o_1
X_3064_ CB_1.config_dataB\[8\] CB_1.config_dataB\[7\] net285 vssd1 vssd1 vccd1 vccd1
+ _0124_ sky130_fd_sc_hd__mux2_1
XFILLER_50_244 vssd1 vssd1 vccd1 vccd1 sky130_fd_sc_hd__fill_4
X_2848_ _1554_ SB0.route_sel\[99\] SB0.route_sel\[96\] _1559_ _1432_ vssd1 vssd1 vccd1
+ vccd1 _1433_ sky130_fd_sc_hd__a221o_1
X_2917_ SB0.route_sel\[4\] _1498_ SB0.route_sel\[1\] SB0.route_sel\[0\] _1478_ vssd1
+ vssd1 vccd1 vccd1 _1479_ sky130_fd_sc_hd__o221a_1
Xhold120 LEI0.config_data\[7\] vssd1 vssd1 vccd1 vccd1 net430 sky130_fd_sc_hd__dlygate4sd3_1
X_2779_ _0377_ _0385_ _0379_ vssd1 vssd1 vccd1 vccd1 _1396_ sky130_fd_sc_hd__a21oi_1
XFILLER_37_23 vssd1 vssd1 vccd1 vccd1 sky130_fd_sc_hd__fill_2
XTAP_TAPCELL_ROW_5_178 vssd1 vccd1 sky130_fd_sc_hd__tapvpwrvgnd_1
XFILLER_17_263 vssd1 vssd1 vccd1 vccd1 sky130_fd_sc_hd__fill_1
XPHY_EDGE_ROW_20_Left_88 vssd1 vssd1 vccd1 vccd1 sky130_fd_sc_hd__decap_3
X_2702_ CB_1.config_dataB\[13\] CB_1.config_dataB\[12\] vssd1 vssd1 vccd1 vccd1 _1330_
+ sky130_fd_sc_hd__nor2_1
X_2495_ _1124_ vssd1 vssd1 vccd1 vccd1 _1125_ sky130_fd_sc_hd__inv_2
X_2564_ CB_1.config_dataA\[16\] net169 vssd1 vssd1 vccd1 vccd1 _1194_ sky130_fd_sc_hd__and2b_1
X_2633_ _1260_ vssd1 vssd1 vccd1 vccd1 _1261_ sky130_fd_sc_hd__inv_2
XTAP_TAPCELL_ROW_2_159 vssd1 vccd1 sky130_fd_sc_hd__tapvpwrvgnd_1
X_3116_ SB0.route_sel\[35\] SB0.route_sel\[34\] net269 vssd1 vssd1 vccd1 vccd1 _0176_
+ sky130_fd_sc_hd__mux2_1
XTAP_TAPCELL_ROW_61_570 vssd1 vccd1 sky130_fd_sc_hd__tapvpwrvgnd_1
XTAP_TAPCELL_ROW_53_515 vssd1 vccd1 sky130_fd_sc_hd__tapvpwrvgnd_1
X_3047_ net405 net358 net282 vssd1 vssd1 vccd1 vccd1 _0107_ sky130_fd_sc_hd__mux2_1
XFILLER_23_222 vssd1 vssd1 vccd1 vccd1 sky130_fd_sc_hd__fill_2
XFILLER_58_185 vssd1 vssd1 vccd1 vccd1 sky130_fd_sc_hd__fill_2
XFILLER_58_163 vssd1 vssd1 vccd1 vccd1 sky130_fd_sc_hd__fill_1
XFILLER_58_152 vssd1 vssd1 vccd1 vccd1 sky130_fd_sc_hd__fill_2
XFILLER_14_266 vssd1 vssd1 vccd1 vccd1 sky130_fd_sc_hd__fill_2
XTAP_TAPCELL_ROW_67_618 vssd1 vccd1 sky130_fd_sc_hd__tapvpwrvgnd_1
XFILLER_49_185 vssd1 vssd1 vccd1 vccd1 sky130_fd_sc_hd__fill_1
X_2280_ _0645_ _0907_ _0909_ _0910_ _0911_ vssd1 vssd1 vccd1 vccd1 _0912_ sky130_fd_sc_hd__o221a_1
XFILLER_45_391 vssd1 vssd1 vccd1 vccd1 sky130_fd_sc_hd__fill_1
XTAP_TAPCELL_ROW_15_250 vssd1 vccd1 sky130_fd_sc_hd__tapvpwrvgnd_1
X_3665_ clknet_leaf_27_clk _0361_ net237 vssd1 vssd1 vccd1 vccd1 LE_1B.edge_mode sky130_fd_sc_hd__dfstp_1
XFILLER_9_281 vssd1 vssd1 vccd1 vccd1 sky130_fd_sc_hd__fill_1
X_1995_ _0441_ _0553_ net142 vssd1 vssd1 vccd1 vccd1 _0629_ sky130_fd_sc_hd__and3b_1
X_2616_ _1079_ _1240_ _1242_ _1083_ _1594_ vssd1 vssd1 vccd1 vccd1 _1244_ sky130_fd_sc_hd__a221o_1
X_2478_ net153 net150 LEI0.config_data\[6\] vssd1 vssd1 vccd1 vccd1 _1108_ sky130_fd_sc_hd__mux2_1
X_2547_ _1100_ _1155_ _1157_ _1103_ CB_1.config_dataA\[12\] vssd1 vssd1 vccd1 vccd1
+ _1177_ sky130_fd_sc_hd__a221o_1
X_3596_ clknet_leaf_3_clk _0292_ net233 vssd1 vssd1 vccd1 vccd1 CB_0.config_dataA\[23\]
+ sky130_fd_sc_hd__dfstp_2
XFILLER_55_166 vssd1 vssd1 vccd1 vccd1 sky130_fd_sc_hd__fill_2
XFILLER_55_100 vssd1 vssd1 vccd1 vccd1 sky130_fd_sc_hd__fill_2
XFILLER_36_380 vssd1 vssd1 vccd1 vccd1 sky130_fd_sc_hd__fill_2
XFILLER_11_236 vssd1 vssd1 vccd1 vccd1 sky130_fd_sc_hd__fill_8
Xclkload1 clknet_2_2__leaf_clk vssd1 vssd1 vccd1 vccd1 clkload1/Y sky130_fd_sc_hd__clkinvlp_4
XFILLER_3_402 vssd1 vssd1 vccd1 vccd1 sky130_fd_sc_hd__fill_1
XFILLER_1_3 vssd1 vssd1 vccd1 vccd1 sky130_fd_sc_hd__fill_4
Xfanout260 net70 vssd1 vssd1 vccd1 vccd1 net260 sky130_fd_sc_hd__clkbuf_2
Xfanout293 net294 vssd1 vssd1 vccd1 vccd1 net293 sky130_fd_sc_hd__clkbuf_4
Xfanout271 net272 vssd1 vssd1 vccd1 vccd1 net271 sky130_fd_sc_hd__clkbuf_2
Xfanout282 net283 vssd1 vssd1 vccd1 vccd1 net282 sky130_fd_sc_hd__clkbuf_2
X_1780_ CB_1.config_dataA\[24\] CB_1.config_dataA\[21\] CB_1.config_dataA\[20\] vssd1
+ vssd1 vccd1 vccd1 _0414_ sky130_fd_sc_hd__or3_2
XTAP_TAPCELL_ROW_12_231 vssd1 vccd1 sky130_fd_sc_hd__tapvpwrvgnd_1
X_2332_ _0694_ _0675_ net184 vssd1 vssd1 vccd1 vccd1 _0964_ sky130_fd_sc_hd__mux2_1
X_3381_ clknet_leaf_5_clk _0077_ net228 vssd1 vssd1 vccd1 vccd1 LE_0B.config_data\[4\]
+ sky130_fd_sc_hd__dfrtp_1
X_2401_ net177 _1030_ vssd1 vssd1 vccd1 vccd1 _1031_ sky130_fd_sc_hd__or2_1
X_3450_ clknet_leaf_31_clk _0146_ net223 vssd1 vssd1 vccd1 vccd1 SB0.route_sel\[5\]
+ sky130_fd_sc_hd__dfstp_1
X_2194_ _0549_ _0821_ _0823_ _0531_ CB_0.config_dataA\[17\] vssd1 vssd1 vccd1 vccd1
+ _0828_ sky130_fd_sc_hd__a221o_1
X_2263_ _0435_ _0873_ _0874_ _0461_ CB_0.config_dataB\[2\] vssd1 vssd1 vccd1 vccd1
+ _0895_ sky130_fd_sc_hd__o221ai_1
XFILLER_37_144 vssd1 vssd1 vccd1 vccd1 sky130_fd_sc_hd__fill_1
XFILLER_37_111 vssd1 vssd1 vccd1 vccd1 sky130_fd_sc_hd__fill_1
XFILLER_40_309 vssd1 vssd1 vccd1 vccd1 sky130_fd_sc_hd__fill_2
XTAP_TAPCELL_ROW_35_389 vssd1 vccd1 sky130_fd_sc_hd__tapvpwrvgnd_1
XPHY_EDGE_ROW_23_Left_91 vssd1 vssd1 vccd1 vccd1 sky130_fd_sc_hd__decap_3
X_3579_ clknet_leaf_7_clk _0275_ net232 vssd1 vssd1 vccd1 vccd1 CB_0.config_dataA\[6\]
+ sky130_fd_sc_hd__dfstp_1
X_3648_ clknet_leaf_27_clk _0344_ net236 vssd1 vssd1 vccd1 vccd1 LE_1B.config_data\[0\]
+ sky130_fd_sc_hd__dfrtp_1
X_1978_ net161 net157 vssd1 vssd1 vccd1 vccd1 _0612_ sky130_fd_sc_hd__or2_1
Xhold24 LE_0A.config_data\[6\] vssd1 vssd1 vccd1 vccd1 net334 sky130_fd_sc_hd__dlygate4sd3_1
Xhold13 LE_0A.config_data\[8\] vssd1 vssd1 vccd1 vccd1 net323 sky130_fd_sc_hd__dlygate4sd3_1
Xhold79 LEI0.config_data\[17\] vssd1 vssd1 vccd1 vccd1 net389 sky130_fd_sc_hd__dlygate4sd3_1
Xhold46 LE_0A.config_data\[5\] vssd1 vssd1 vccd1 vccd1 net356 sky130_fd_sc_hd__dlygate4sd3_1
Xhold57 _0061_ vssd1 vssd1 vccd1 vccd1 net367 sky130_fd_sc_hd__dlygate4sd3_1
XFILLER_29_24 vssd1 vssd1 vccd1 vccd1 sky130_fd_sc_hd__fill_4
XFILLER_28_111 vssd1 vssd1 vccd1 vccd1 sky130_fd_sc_hd__fill_8
Xhold35 LE_1B.config_data\[12\] vssd1 vssd1 vccd1 vccd1 net345 sky130_fd_sc_hd__dlygate4sd3_1
Xhold68 LE_1B.config_data\[13\] vssd1 vssd1 vccd1 vccd1 net378 sky130_fd_sc_hd__dlygate4sd3_1
XPHY_EDGE_ROW_51_Left_119 vssd1 vssd1 vccd1 vccd1 sky130_fd_sc_hd__decap_3
XFILLER_43_169 vssd1 vssd1 vccd1 vccd1 sky130_fd_sc_hd__fill_8
XFILLER_28_144 vssd1 vssd1 vccd1 vccd1 sky130_fd_sc_hd__fill_1
XPHY_EDGE_ROW_60_Left_128 vssd1 vssd1 vccd1 vccd1 sky130_fd_sc_hd__decap_3
XFILLER_19_100 vccd1 vssd1 vccd1 vssd1 sky130_ef_sc_hd__decap_40_12
X_2950_ LEI0.config_data\[9\] net418 net307 vssd1 vssd1 vccd1 vccd1 _0010_ sky130_fd_sc_hd__mux2_1
X_1832_ net20 net21 net22 net23 net200 CB_0.config_dataA\[1\] vssd1 vssd1 vccd1 vccd1
+ _0466_ sky130_fd_sc_hd__mux4_1
X_2881_ _1525_ SB0.route_sel\[51\] SB0.route_sel\[52\] _1526_ _1454_ vssd1 vssd1 vccd1
+ vccd1 _1455_ sky130_fd_sc_hd__o221a_1
X_1901_ _0471_ net142 _0413_ vssd1 vssd1 vccd1 vccd1 _0535_ sky130_fd_sc_hd__and3b_1
X_1694_ CB_0.config_dataB\[2\] vssd1 vssd1 vccd1 vccd1 _1576_ sky130_fd_sc_hd__inv_2
X_1763_ CB_1.config_dataA\[24\] CB_1.config_dataA\[21\] CB_1.config_dataA\[20\] vssd1
+ vssd1 vccd1 vccd1 _0397_ sky130_fd_sc_hd__and3b_2
X_3502_ clknet_leaf_30_clk _0198_ net224 vssd1 vssd1 vccd1 vccd1 SB0.route_sel\[57\]
+ sky130_fd_sc_hd__dfstp_1
X_3433_ clknet_leaf_23_clk _0129_ net246 vssd1 vssd1 vccd1 vccd1 CB_1.config_dataB\[13\]
+ sky130_fd_sc_hd__dfstp_1
X_2315_ _0435_ _0945_ _0946_ _0461_ CB_0.config_dataB\[12\] vssd1 vssd1 vccd1 vccd1
+ _0947_ sky130_fd_sc_hd__o221a_1
X_3364_ clknet_leaf_6_clk net324 net231 vssd1 vssd1 vccd1 vccd1 LE_0A.config_data\[9\]
+ sky130_fd_sc_hd__dfrtp_1
X_2246_ CB_0.config_dataB\[2\] _0877_ CB_0.config_dataB\[3\] vssd1 vssd1 vccd1 vccd1
+ _0878_ sky130_fd_sc_hd__a21o_1
X_3295_ net332 net317 net279 vssd1 vssd1 vccd1 vccd1 _0355_ sky130_fd_sc_hd__mux2_1
X_2177_ CB_0.config_dataA\[14\] _0785_ _0803_ _0810_ _1572_ vssd1 vssd1 vccd1 vccd1
+ _0811_ sky130_fd_sc_hd__a32o_1
XTAP_TAPCELL_ROW_48_481 vssd1 vccd1 sky130_fd_sc_hd__tapvpwrvgnd_1
XTAP_TAPCELL_ROW_23_304 vssd1 vccd1 sky130_fd_sc_hd__tapvpwrvgnd_1
XFILLER_48_217 vssd1 vssd1 vccd1 vccd1 sky130_fd_sc_hd__fill_2
XFILLER_16_103 vssd1 vssd1 vccd1 vccd1 sky130_fd_sc_hd__fill_1
X_2100_ _0464_ _0715_ _0733_ _0437_ _1495_ vssd1 vssd1 vccd1 vccd1 _0734_ sky130_fd_sc_hd__o221a_1
X_3080_ CB_1.config_dataB\[24\] CB_1.config_dataB\[23\] net278 vssd1 vssd1 vccd1 vccd1
+ _0140_ sky130_fd_sc_hd__mux2_1
X_2031_ net179 net180 vssd1 vssd1 vccd1 vccd1 _0665_ sky130_fd_sc_hd__nor2_1
XTAP_TAPCELL_ROW_45_462 vssd1 vccd1 sky130_fd_sc_hd__tapvpwrvgnd_1
XTAP_TAPCELL_ROW_37_407 vssd1 vccd1 sky130_fd_sc_hd__tapvpwrvgnd_1
X_2795_ net151 _1404_ _0569_ vssd1 vssd1 vccd1 vccd1 net100 sky130_fd_sc_hd__mux2_1
X_2933_ _1489_ net137 vssd1 vssd1 vccd1 vccd1 net108 sky130_fd_sc_hd__and2b_1
X_2864_ _1443_ _0528_ vssd1 vssd1 vccd1 vccd1 net134 sky130_fd_sc_hd__and2b_1
X_1815_ SB0.route_sel\[106\] SB0.route_sel\[107\] _0447_ _0448_ vssd1 vssd1 vccd1
+ vccd1 _0449_ sky130_fd_sc_hd__a31o_1
XFILLER_22_139 vssd1 vssd1 vccd1 vccd1 sky130_fd_sc_hd__fill_1
X_1746_ _1602_ _0371_ _0373_ vssd1 vssd1 vccd1 vccd1 _0380_ sky130_fd_sc_hd__or3_1
X_1677_ SB0.route_sel\[97\] vssd1 vssd1 vccd1 vccd1 _1559_ sky130_fd_sc_hd__inv_2
X_3416_ clknet_leaf_25_clk _0112_ net242 vssd1 vssd1 vccd1 vccd1 LE_1A.edge_mode sky130_fd_sc_hd__dfstp_1
X_3347_ clknet_leaf_15_clk _0043_ net258 vssd1 vssd1 vccd1 vccd1 LEI0.config_data\[42\]
+ sky130_fd_sc_hd__dfrtp_1
X_2229_ LE_0A.config_data\[2\] LE_0A.config_data\[3\] _0741_ vssd1 vssd1 vccd1 vccd1
+ _0863_ sky130_fd_sc_hd__mux2_1
X_3278_ CB_1.config_dataA\[19\] CB_1.config_dataA\[18\] net286 vssd1 vssd1 vccd1 vccd1
+ _0338_ sky130_fd_sc_hd__mux2_1
XFILLER_26_47 vssd1 vssd1 vccd1 vccd1 sky130_fd_sc_hd__fill_2
XFILLER_26_25 vssd1 vssd1 vccd1 vccd1 sky130_fd_sc_hd__fill_2
XFILLER_42_57 vccd1 vssd1 vccd1 vssd1 sky130_ef_sc_hd__decap_40_12
XFILLER_17_401 vssd1 vssd1 vccd1 vccd1 sky130_fd_sc_hd__fill_2
XFILLER_44_275 vssd1 vssd1 vccd1 vccd1 sky130_fd_sc_hd__fill_1
XTAP_TAPCELL_ROW_42_443 vssd1 vccd1 sky130_fd_sc_hd__tapvpwrvgnd_1
X_2580_ net4 net5 net6 net7 net169 net167 vssd1 vssd1 vccd1 vccd1 _1210_ sky130_fd_sc_hd__mux4_1
X_3201_ SB0.route_sel\[120\] SB0.route_sel\[119\] net297 vssd1 vssd1 vccd1 vccd1 _0261_
+ sky130_fd_sc_hd__mux2_1
X_3132_ SB0.route_sel\[51\] SB0.route_sel\[50\] net276 vssd1 vssd1 vccd1 vccd1 _0192_
+ sky130_fd_sc_hd__mux2_1
X_3063_ CB_1.config_dataB\[7\] net208 net285 vssd1 vssd1 vccd1 vccd1 _0123_ sky130_fd_sc_hd__mux2_1
XFILLER_50_212 vssd1 vssd1 vccd1 vccd1 sky130_fd_sc_hd__fill_8
X_2014_ net27 net28 net29 net30 net201 net199 vssd1 vssd1 vccd1 vccd1 _0648_ sky130_fd_sc_hd__mux4_1
XFILLER_35_275 vssd1 vssd1 vccd1 vccd1 sky130_fd_sc_hd__fill_4
XFILLER_35_231 vssd1 vssd1 vccd1 vccd1 sky130_fd_sc_hd__fill_2
Xhold110 LEI0.config_data\[38\] vssd1 vssd1 vccd1 vccd1 net420 sky130_fd_sc_hd__dlygate4sd3_1
X_2778_ net151 _1395_ _0388_ vssd1 vssd1 vccd1 vccd1 net93 sky130_fd_sc_hd__mux2_1
X_2847_ SB0.route_sel\[103\] SB0.route_sel\[102\] vssd1 vssd1 vccd1 vccd1 _1432_ sky130_fd_sc_hd__nor2_1
X_2916_ SB0.route_sel\[3\] SB0.route_sel\[2\] vssd1 vssd1 vccd1 vccd1 _1478_ sky130_fd_sc_hd__nand2b_1
X_1729_ CB_1.config_dataA\[23\] CB_1.config_dataA\[22\] vssd1 vssd1 vccd1 vccd1 _1611_
+ sky130_fd_sc_hd__nand2_2
XTAP_TAPCELL_ROW_56_535 vssd1 vccd1 sky130_fd_sc_hd__tapvpwrvgnd_1
XFILLER_26_253 vssd1 vssd1 vccd1 vccd1 sky130_fd_sc_hd__fill_4
XTAP_TAPCELL_ROW_5_179 vssd1 vccd1 sky130_fd_sc_hd__tapvpwrvgnd_1
XFILLER_41_278 vssd1 vssd1 vccd1 vccd1 sky130_fd_sc_hd__fill_2
XFILLER_5_113 vssd1 vssd1 vccd1 vccd1 sky130_fd_sc_hd__fill_4
XFILLER_49_334 vssd1 vssd1 vccd1 vccd1 sky130_fd_sc_hd__fill_2
XFILLER_49_323 vssd1 vssd1 vccd1 vccd1 sky130_fd_sc_hd__fill_2
XFILLER_17_231 vssd1 vssd1 vccd1 vccd1 sky130_fd_sc_hd__fill_2
X_2632_ _1258_ _1259_ CB_1.config_dataB\[2\] vssd1 vssd1 vccd1 vccd1 _1260_ sky130_fd_sc_hd__mux2_1
X_2701_ net1 net8 net9 net10 net206 net205 vssd1 vssd1 vccd1 vccd1 _1329_ sky130_fd_sc_hd__mux4_1
X_2494_ _1122_ _1123_ _1589_ vssd1 vssd1 vccd1 vccd1 _1124_ sky130_fd_sc_hd__mux2_1
X_2563_ net168 net167 vssd1 vssd1 vccd1 vccd1 _1193_ sky130_fd_sc_hd__nor2_1
X_3046_ net358 LE_1A.config_data\[10\] net282 vssd1 vssd1 vccd1 vccd1 _0106_ sky130_fd_sc_hd__mux2_1
X_3115_ SB0.route_sel\[34\] SB0.route_sel\[33\] net269 vssd1 vssd1 vccd1 vccd1 _0175_
+ sky130_fd_sc_hd__mux2_1
XTAP_TAPCELL_ROW_61_571 vssd1 vccd1 sky130_fd_sc_hd__tapvpwrvgnd_1
XTAP_TAPCELL_ROW_53_516 vssd1 vccd1 sky130_fd_sc_hd__tapvpwrvgnd_1
XTAP_TAPCELL_ROW_18_270 vssd1 vccd1 sky130_fd_sc_hd__tapvpwrvgnd_1
XFILLER_23_26 vssd1 vssd1 vccd1 vccd1 sky130_fd_sc_hd__fill_2
XFILLER_23_37 vssd1 vssd1 vccd1 vccd1 sky130_fd_sc_hd__fill_8
XTAP_TAPCELL_ROW_67_619 vssd1 vccd1 sky130_fd_sc_hd__tapvpwrvgnd_1
XFILLER_52_307 vssd1 vssd1 vccd1 vccd1 sky130_fd_sc_hd__fill_1
XFILLER_49_164 vssd1 vssd1 vccd1 vccd1 sky130_fd_sc_hd__fill_1
XFILLER_37_359 vssd1 vssd1 vccd1 vccd1 sky130_fd_sc_hd__fill_1
XFILLER_37_315 vssd1 vssd1 vccd1 vccd1 sky130_fd_sc_hd__fill_4
XTAP_TAPCELL_ROW_15_251 vssd1 vccd1 sky130_fd_sc_hd__tapvpwrvgnd_1
X_1994_ net138 net160 net157 _0554_ _0441_ vssd1 vssd1 vccd1 vccd1 _0628_ sky130_fd_sc_hd__o32a_1
Xclkload30 clknet_leaf_19_clk vssd1 vssd1 vccd1 vccd1 clkload30/Y sky130_fd_sc_hd__inv_8
X_3595_ clknet_leaf_11_clk _0291_ net233 vssd1 vssd1 vccd1 vccd1 CB_0.config_dataA\[22\]
+ sky130_fd_sc_hd__dfstp_2
X_2615_ net211 net212 vssd1 vssd1 vccd1 vccd1 _1243_ sky130_fd_sc_hd__nand2b_1
X_3664_ clknet_leaf_25_clk _0360_ net242 vssd1 vssd1 vccd1 vccd1 LE_1B.config_data\[16\]
+ sky130_fd_sc_hd__dfrtp_1
X_2477_ CB_1.config_dataA\[3\] _1045_ CB_1.config_dataA\[2\] CB_1.config_dataA\[4\]
+ vssd1 vssd1 vccd1 vccd1 _1107_ sky130_fd_sc_hd__or4b_1
X_2546_ net171 _1096_ _1175_ net170 vssd1 vssd1 vccd1 vccd1 _1176_ sky130_fd_sc_hd__o211a_1
XFILLER_55_189 vssd1 vssd1 vccd1 vccd1 sky130_fd_sc_hd__fill_2
X_3029_ LE_0B.config_data\[16\] net344 net270 vssd1 vssd1 vccd1 vccd1 _0089_ sky130_fd_sc_hd__mux2_1
Xclkload2 clknet_leaf_0_clk vssd1 vssd1 vccd1 vccd1 clkload2/X sky130_fd_sc_hd__clkbuf_8
XFILLER_59_55 vssd1 vssd1 vccd1 vccd1 sky130_fd_sc_hd__fill_1
Xfanout250 net253 vssd1 vssd1 vccd1 vccd1 net250 sky130_fd_sc_hd__clkbuf_4
Xfanout294 net295 vssd1 vssd1 vccd1 vccd1 net294 sky130_fd_sc_hd__buf_2
Xfanout272 net275 vssd1 vssd1 vccd1 vccd1 net272 sky130_fd_sc_hd__clkbuf_2
Xfanout261 net264 vssd1 vssd1 vccd1 vccd1 net261 sky130_fd_sc_hd__clkbuf_4
Xfanout283 net310 vssd1 vssd1 vccd1 vccd1 net283 sky130_fd_sc_hd__clkbuf_2
XFILLER_19_304 vssd1 vssd1 vccd1 vccd1 sky130_fd_sc_hd__fill_1
X_2400_ _1028_ _1029_ _0382_ vssd1 vssd1 vccd1 vccd1 _1030_ sky130_fd_sc_hd__o21ai_4
XTAP_TAPCELL_ROW_12_232 vssd1 vccd1 sky130_fd_sc_hd__tapvpwrvgnd_1
X_2331_ _1580_ _0962_ _0961_ vssd1 vssd1 vccd1 vccd1 _0963_ sky130_fd_sc_hd__a21oi_1
X_2262_ net189 _0409_ vssd1 vssd1 vccd1 vccd1 _0894_ sky130_fd_sc_hd__nand2_1
X_3380_ clknet_leaf_5_clk _0076_ net227 vssd1 vssd1 vccd1 vccd1 LE_0B.config_data\[3\]
+ sky130_fd_sc_hd__dfrtp_1
XFILLER_41_5 vssd1 vssd1 vccd1 vccd1 sky130_fd_sc_hd__fill_4
X_2193_ net191 _0511_ net190 vssd1 vssd1 vccd1 vccd1 _0827_ sky130_fd_sc_hd__o21a_1
X_1977_ _0413_ _0553_ vssd1 vssd1 vccd1 vccd1 _0611_ sky130_fd_sc_hd__nand2_1
X_3578_ clknet_leaf_8_clk _0274_ net232 vssd1 vssd1 vccd1 vccd1 CB_0.config_dataA\[5\]
+ sky130_fd_sc_hd__dfstp_1
X_2529_ _1043_ _1156_ _1158_ _1154_ vssd1 vssd1 vccd1 vccd1 _1159_ sky130_fd_sc_hd__o211a_1
X_3647_ clknet_leaf_27_clk _0343_ net237 vssd1 vssd1 vccd1 vccd1 CB_1.config_dataA\[24\]
+ sky130_fd_sc_hd__dfstp_2
XFILLER_20_27 vssd1 vssd1 vccd1 vccd1 sky130_fd_sc_hd__fill_1
Xhold14 _0060_ vssd1 vssd1 vccd1 vccd1 net324 sky130_fd_sc_hd__dlygate4sd3_1
Xhold69 LE_0A.config_data\[11\] vssd1 vssd1 vccd1 vccd1 net379 sky130_fd_sc_hd__dlygate4sd3_1
Xhold25 _0057_ vssd1 vssd1 vccd1 vccd1 net335 sky130_fd_sc_hd__dlygate4sd3_1
Xhold58 LE_0B.config_data\[8\] vssd1 vssd1 vccd1 vccd1 net368 sky130_fd_sc_hd__dlygate4sd3_1
Xhold47 LE_1B.config_data\[5\] vssd1 vssd1 vccd1 vccd1 net357 sky130_fd_sc_hd__dlygate4sd3_1
Xhold36 LE_1B.config_data\[7\] vssd1 vssd1 vccd1 vccd1 net346 sky130_fd_sc_hd__dlygate4sd3_1
XFILLER_43_159 vssd1 vssd1 vccd1 vccd1 sky130_fd_sc_hd__fill_2
XFILLER_24_351 vssd1 vssd1 vccd1 vccd1 sky130_fd_sc_hd__fill_2
XFILLER_51_192 vssd1 vssd1 vccd1 vccd1 sky130_fd_sc_hd__fill_4
XFILLER_59_281 vssd1 vssd1 vccd1 vccd1 sky130_fd_sc_hd__fill_1
XFILLER_19_145 vssd1 vssd1 vccd1 vccd1 sky130_fd_sc_hd__fill_1
XFILLER_19_167 vssd1 vssd1 vccd1 vccd1 sky130_fd_sc_hd__fill_1
X_1831_ _0386_ _0410_ _0462_ _0463_ _0438_ vssd1 vssd1 vccd1 vccd1 _0465_ sky130_fd_sc_hd__a221o_1
X_1900_ net138 net161 net158 _0471_ _0414_ vssd1 vssd1 vccd1 vccd1 _0534_ sky130_fd_sc_hd__o32a_1
X_2880_ SB0.route_sel\[49\] SB0.route_sel\[48\] vssd1 vssd1 vccd1 vccd1 _1454_ sky130_fd_sc_hd__or2_1
X_3363_ clknet_leaf_6_clk _0059_ net231 vssd1 vssd1 vccd1 vccd1 LE_0A.config_data\[8\]
+ sky130_fd_sc_hd__dfrtp_1
X_1762_ _1607_ net162 net7 vssd1 vssd1 vccd1 vccd1 _0396_ sky130_fd_sc_hd__o21ai_1
X_1693_ LE_0A.config_data\[16\] vssd1 vssd1 vccd1 vccd1 _1575_ sky130_fd_sc_hd__inv_2
X_3501_ clknet_leaf_32_clk _0197_ net222 vssd1 vssd1 vccd1 vccd1 SB0.route_sel\[56\]
+ sky130_fd_sc_hd__dfstp_1
X_3432_ clknet_leaf_23_clk _0128_ net243 vssd1 vssd1 vccd1 vccd1 CB_1.config_dataB\[12\]
+ sky130_fd_sc_hd__dfstp_2
X_2176_ net152 net148 net144 net139 LEI0.config_data\[24\] LEI0.config_data\[25\]
+ vssd1 vssd1 vccd1 vccd1 _0810_ sky130_fd_sc_hd__mux4_1
X_2314_ _1581_ net185 vssd1 vssd1 vccd1 vccd1 _0946_ sky130_fd_sc_hd__nand2_1
X_2245_ net27 net28 net29 net30 net189 net187 vssd1 vssd1 vccd1 vccd1 _0877_ sky130_fd_sc_hd__mux4_1
X_3294_ net317 LE_1B.config_data\[9\] net279 vssd1 vssd1 vccd1 vccd1 _0354_ sky130_fd_sc_hd__mux2_1
XFILLER_53_402 vssd1 vssd1 vccd1 vccd1 sky130_fd_sc_hd__fill_1
XTAP_TAPCELL_ROW_48_482 vssd1 vccd1 sky130_fd_sc_hd__tapvpwrvgnd_1
XFILLER_15_38 vssd1 vssd1 vccd1 vccd1 sky130_fd_sc_hd__fill_2
XTAP_TAPCELL_ROW_23_305 vssd1 vccd1 sky130_fd_sc_hd__tapvpwrvgnd_1
XTAP_TAPCELL_ROW_31_360 vssd1 vccd1 sky130_fd_sc_hd__tapvpwrvgnd_1
XPHY_EDGE_ROW_1_Right_1 vssd1 vssd1 vccd1 vccd1 sky130_fd_sc_hd__decap_3
XFILLER_8_325 vssd1 vssd1 vccd1 vccd1 sky130_fd_sc_hd__fill_2
X_2030_ _0387_ _0662_ vssd1 vssd1 vccd1 vccd1 _0664_ sky130_fd_sc_hd__nand2_1
XFILLER_62_243 vssd1 vssd1 vccd1 vccd1 sky130_fd_sc_hd__fill_1
XTAP_TAPCELL_ROW_45_463 vssd1 vccd1 sky130_fd_sc_hd__tapvpwrvgnd_1
X_2932_ SB0.route_sel\[119\] SB0.route_sel\[118\] _1568_ SB0.route_sel\[113\] _1488_
+ vssd1 vssd1 vccd1 vccd1 _1489_ sky130_fd_sc_hd__o221a_1
XTAP_TAPCELL_ROW_37_408 vssd1 vccd1 sky130_fd_sc_hd__tapvpwrvgnd_1
XFILLER_22_118 vssd1 vssd1 vccd1 vccd1 sky130_fd_sc_hd__fill_2
XFILLER_22_129 vssd1 vssd1 vccd1 vccd1 sky130_fd_sc_hd__fill_1
X_2794_ _0572_ _0581_ _0574_ vssd1 vssd1 vccd1 vccd1 _1404_ sky130_fd_sc_hd__o21a_1
X_1745_ net147 net164 _0376_ vssd1 vssd1 vccd1 vccd1 _0379_ sky130_fd_sc_hd__nor3_1
X_1814_ SB0.route_sel\[104\] SB0.route_sel\[105\] vssd1 vssd1 vccd1 vccd1 _0448_ sky130_fd_sc_hd__nand2_1
XFILLER_30_195 vssd1 vssd1 vccd1 vccd1 sky130_fd_sc_hd__fill_1
X_2863_ SB0.route_sel\[75\] _1542_ SB0.route_sel\[76\] _1543_ _1442_ vssd1 vssd1 vccd1
+ vccd1 _1443_ sky130_fd_sc_hd__o221a_1
X_3346_ clknet_leaf_15_clk _0042_ net257 vssd1 vssd1 vccd1 vccd1 LEI0.config_data\[41\]
+ sky130_fd_sc_hd__dfrtp_1
X_1676_ SB0.route_sel\[96\] vssd1 vssd1 vccd1 vccd1 _1558_ sky130_fd_sc_hd__inv_2
X_3415_ clknet_leaf_25_clk _0111_ net244 vssd1 vssd1 vccd1 vccd1 LE_1A.config_data\[16\]
+ sky130_fd_sc_hd__dfrtp_1
X_2228_ _0778_ _0859_ _0861_ _0813_ vssd1 vssd1 vccd1 vccd1 _0862_ sky130_fd_sc_hd__o211a_1
X_2159_ net195 _0511_ vssd1 vssd1 vccd1 vccd1 _0793_ sky130_fd_sc_hd__or2_1
X_3277_ CB_1.config_dataA\[18\] CB_1.config_dataA\[17\] net286 vssd1 vssd1 vccd1 vccd1
+ _0337_ sky130_fd_sc_hd__mux2_1
XFILLER_42_69 vssd1 vssd1 vccd1 vccd1 sky130_fd_sc_hd__fill_2
Xclkbuf_leaf_33_clk clknet_2_0__leaf_clk vssd1 vssd1 vccd1 vccd1 clknet_leaf_33_clk
+ sky130_fd_sc_hd__clkbuf_8
XTAP_TAPCELL_ROW_8_199 vssd1 vccd1 sky130_fd_sc_hd__tapvpwrvgnd_1
Xclkbuf_leaf_24_clk clknet_2_2__leaf_clk vssd1 vssd1 vccd1 vccd1 clknet_leaf_24_clk
+ sky130_fd_sc_hd__clkbuf_8
XFILLER_12_162 vssd1 vssd1 vccd1 vccd1 sky130_fd_sc_hd__fill_4
XFILLER_12_195 vssd1 vssd1 vccd1 vccd1 sky130_fd_sc_hd__fill_1
X_3200_ SB0.route_sel\[119\] SB0.route_sel\[118\] net297 vssd1 vssd1 vccd1 vccd1 _0260_
+ sky130_fd_sc_hd__mux2_1
XFILLER_67_335 vssd1 vssd1 vccd1 vccd1 sky130_fd_sc_hd__fill_1
X_2013_ net199 _0582_ _0604_ _0646_ _1495_ vssd1 vssd1 vccd1 vccd1 _0647_ sky130_fd_sc_hd__a311o_1
X_3131_ SB0.route_sel\[50\] SB0.route_sel\[49\] net266 vssd1 vssd1 vccd1 vccd1 _0191_
+ sky130_fd_sc_hd__mux2_1
X_3062_ net208 net209 net285 vssd1 vssd1 vccd1 vccd1 _0122_ sky130_fd_sc_hd__mux2_1
Xclkbuf_leaf_15_clk clknet_2_3__leaf_clk vssd1 vssd1 vccd1 vccd1 clknet_leaf_15_clk
+ sky130_fd_sc_hd__clkbuf_8
X_2915_ _1477_ _0712_ vssd1 vssd1 vccd1 vccd1 net110 sky130_fd_sc_hd__and2b_1
Xhold111 _0039_ vssd1 vssd1 vccd1 vccd1 net421 sky130_fd_sc_hd__dlygate4sd3_1
Xhold100 LEI0.config_data\[32\] vssd1 vssd1 vccd1 vccd1 net410 sky130_fd_sc_hd__dlygate4sd3_1
X_2777_ _0390_ _0409_ _0392_ vssd1 vssd1 vccd1 vccd1 _1395_ sky130_fd_sc_hd__o21a_1
X_2846_ _1431_ _0432_ vssd1 vssd1 vccd1 vccd1 net122 sky130_fd_sc_hd__and2b_1
X_1728_ CB_1.config_dataA\[24\] CB_1.config_dataA\[20\] CB_1.config_dataA\[21\] vssd1
+ vssd1 vccd1 vccd1 _1610_ sky130_fd_sc_hd__or3b_2
X_3329_ clknet_leaf_15_clk _0025_ net257 vssd1 vssd1 vccd1 vccd1 LEI0.config_data\[24\]
+ sky130_fd_sc_hd__dfrtp_1
X_1659_ SB0.route_sel\[64\] vssd1 vssd1 vccd1 vccd1 _1541_ sky130_fd_sc_hd__inv_2
XTAP_TAPCELL_ROW_56_536 vssd1 vccd1 sky130_fd_sc_hd__tapvpwrvgnd_1
XFILLER_37_25 vssd1 vssd1 vccd1 vccd1 sky130_fd_sc_hd__fill_1
XFILLER_26_232 vssd1 vssd1 vccd1 vccd1 sky130_fd_sc_hd__fill_4
XFILLER_26_210 vssd1 vssd1 vccd1 vccd1 sky130_fd_sc_hd__fill_1
XTAP_TAPCELL_ROW_64_591 vssd1 vccd1 sky130_fd_sc_hd__tapvpwrvgnd_1
XFILLER_40_290 vccd1 vssd1 vccd1 vssd1 sky130_ef_sc_hd__decap_40_12
X_2562_ net169 _1075_ _1191_ net167 vssd1 vssd1 vccd1 vccd1 _1192_ sky130_fd_sc_hd__o211a_1
X_2631_ net4 net5 net6 net7 net212 net211 vssd1 vssd1 vccd1 vccd1 _1259_ sky130_fd_sc_hd__mux4_1
X_2700_ net205 _1325_ _1326_ _1327_ vssd1 vssd1 vccd1 vccd1 _1328_ sky130_fd_sc_hd__a31o_1
X_2493_ net15 net16 net2 net3 net175 CB_1.config_dataA\[6\] vssd1 vssd1 vccd1 vccd1
+ _1123_ sky130_fd_sc_hd__mux4_1
Xclkbuf_leaf_4_clk clknet_2_1__leaf_clk vssd1 vssd1 vccd1 vccd1 clknet_leaf_4_clk
+ sky130_fd_sc_hd__clkbuf_8
XTAP_TAPCELL_ROW_53_517 vssd1 vccd1 sky130_fd_sc_hd__tapvpwrvgnd_1
X_3045_ net374 LE_1A.config_data\[9\] net282 vssd1 vssd1 vccd1 vccd1 _0105_ sky130_fd_sc_hd__mux2_1
X_3114_ SB0.route_sel\[33\] SB0.route_sel\[32\] net263 vssd1 vssd1 vccd1 vccd1 _0174_
+ sky130_fd_sc_hd__mux2_1
XTAP_TAPCELL_ROW_61_572 vssd1 vccd1 sky130_fd_sc_hd__tapvpwrvgnd_1
XTAP_TAPCELL_ROW_18_271 vssd1 vccd1 sky130_fd_sc_hd__tapvpwrvgnd_1
X_2829_ net166 net157 _1075_ vssd1 vssd1 vccd1 vccd1 _1422_ sky130_fd_sc_hd__o21ai_1
XFILLER_58_154 vssd1 vssd1 vccd1 vccd1 sky130_fd_sc_hd__fill_1
XTAP_TAPCELL_ROW_1_150 vssd1 vccd1 sky130_fd_sc_hd__tapvpwrvgnd_1
XFILLER_14_268 vssd1 vssd1 vccd1 vccd1 sky130_fd_sc_hd__fill_1
XFILLER_60_363 vssd1 vssd1 vccd1 vccd1 sky130_fd_sc_hd__fill_1
XTAP_TAPCELL_ROW_15_252 vssd1 vccd1 sky130_fd_sc_hd__tapvpwrvgnd_1
X_1993_ _0439_ net157 net12 vssd1 vssd1 vccd1 vccd1 _0627_ sky130_fd_sc_hd__o21ai_1
X_3594_ clknet_leaf_11_clk _0290_ net249 vssd1 vssd1 vccd1 vccd1 CB_0.config_dataA\[21\]
+ sky130_fd_sc_hd__dfstp_2
X_2545_ net171 _1092_ vssd1 vssd1 vccd1 vccd1 _1175_ sky130_fd_sc_hd__nand2_1
Xclkload31 clknet_leaf_20_clk vssd1 vssd1 vccd1 vccd1 clkload31/Y sky130_fd_sc_hd__inv_8
X_2614_ CB_1.config_dataB\[1\] net212 vssd1 vssd1 vccd1 vccd1 _1242_ sky130_fd_sc_hd__and2b_1
X_3663_ clknet_leaf_25_clk _0359_ net242 vssd1 vssd1 vccd1 vccd1 LE_1B.config_data\[15\]
+ sky130_fd_sc_hd__dfrtp_1
Xclkload20 clknet_leaf_26_clk vssd1 vssd1 vccd1 vccd1 clkload20/Y sky130_fd_sc_hd__inv_6
XFILLER_55_102 vssd1 vssd1 vccd1 vccd1 sky130_fd_sc_hd__fill_1
X_2476_ _1085_ _1089_ _1105_ CB_1.config_dataA\[4\] vssd1 vssd1 vccd1 vccd1 _1106_
+ sky130_fd_sc_hd__a31o_2
X_3028_ net344 net319 net288 vssd1 vssd1 vccd1 vccd1 _0088_ sky130_fd_sc_hd__mux2_1
XFILLER_34_26 vssd1 vssd1 vccd1 vccd1 sky130_fd_sc_hd__fill_2
XFILLER_50_25 vssd1 vssd1 vccd1 vccd1 sky130_fd_sc_hd__fill_2
Xclkload3 clknet_leaf_1_clk vssd1 vssd1 vccd1 vccd1 clkload3/X sky130_fd_sc_hd__clkbuf_4
XFILLER_11_216 vssd1 vssd1 vccd1 vccd1 sky130_fd_sc_hd__fill_8
Xfanout240 net241 vssd1 vssd1 vccd1 vccd1 net240 sky130_fd_sc_hd__clkbuf_4
Xfanout251 net252 vssd1 vssd1 vccd1 vccd1 net251 sky130_fd_sc_hd__clkbuf_4
Xfanout295 net310 vssd1 vssd1 vccd1 vccd1 net295 sky130_fd_sc_hd__clkbuf_4
XFILLER_27_360 vssd1 vssd1 vccd1 vccd1 sky130_fd_sc_hd__fill_2
Xfanout284 net287 vssd1 vssd1 vccd1 vccd1 net284 sky130_fd_sc_hd__clkbuf_4
Xfanout273 net275 vssd1 vssd1 vccd1 vccd1 net273 sky130_fd_sc_hd__clkbuf_4
Xfanout262 net263 vssd1 vssd1 vccd1 vccd1 net262 sky130_fd_sc_hd__clkbuf_4
XTAP_TAPCELL_ROW_12_233 vssd1 vccd1 sky130_fd_sc_hd__tapvpwrvgnd_1
X_2330_ net17 net24 net25 net26 net185 net183 vssd1 vssd1 vccd1 vccd1 _0962_ sky130_fd_sc_hd__mux4_1
X_2192_ net191 _0492_ vssd1 vssd1 vccd1 vccd1 _0826_ sky130_fd_sc_hd__nand2_1
X_2261_ net189 _0385_ vssd1 vssd1 vccd1 vccd1 _0893_ sky130_fd_sc_hd__or2_1
XFILLER_37_113 vssd1 vssd1 vccd1 vccd1 sky130_fd_sc_hd__fill_8
XFILLER_45_190 vssd1 vssd1 vccd1 vccd1 sky130_fd_sc_hd__fill_2
X_1976_ _0607_ _0608_ _0609_ vssd1 vssd1 vccd1 vccd1 _0610_ sky130_fd_sc_hd__a21oi_2
X_3577_ clknet_leaf_8_clk _0273_ net233 vssd1 vssd1 vccd1 vccd1 CB_0.config_dataA\[4\]
+ sky130_fd_sc_hd__dfstp_1
X_2528_ net172 CB_1.config_dataA\[11\] _1038_ CB_1.config_dataA\[12\] vssd1 vssd1
+ vccd1 vccd1 _1158_ sky130_fd_sc_hd__o31a_1
X_3646_ clknet_leaf_27_clk _0342_ net237 vssd1 vssd1 vccd1 vccd1 CB_1.config_dataA\[23\]
+ sky130_fd_sc_hd__dfstp_2
XFILLER_20_17 vssd1 vssd1 vccd1 vccd1 sky130_fd_sc_hd__fill_8
Xhold15 LE_0A.config_data\[3\] vssd1 vssd1 vccd1 vccd1 net325 sky130_fd_sc_hd__dlygate4sd3_1
Xhold59 _0081_ vssd1 vssd1 vccd1 vccd1 net369 sky130_fd_sc_hd__dlygate4sd3_1
X_2459_ _1588_ _1088_ _1087_ vssd1 vssd1 vccd1 vccd1 _1089_ sky130_fd_sc_hd__a21oi_1
XFILLER_28_179 vssd1 vssd1 vccd1 vccd1 sky130_fd_sc_hd__fill_1
Xhold37 LE_1B.config_data\[4\] vssd1 vssd1 vccd1 vccd1 net347 sky130_fd_sc_hd__dlygate4sd3_1
Xhold26 LE_1A.config_data\[6\] vssd1 vssd1 vccd1 vccd1 net336 sky130_fd_sc_hd__dlygate4sd3_1
Xhold48 LE_1A.config_data\[11\] vssd1 vssd1 vccd1 vccd1 net358 sky130_fd_sc_hd__dlygate4sd3_1
XFILLER_51_160 vssd1 vssd1 vccd1 vccd1 sky130_fd_sc_hd__fill_2
XFILLER_43_127 vssd1 vssd1 vccd1 vccd1 sky130_fd_sc_hd__fill_2
XTAP_TAPCELL_ROW_26_325 vssd1 vccd1 sky130_fd_sc_hd__tapvpwrvgnd_1
XFILLER_10_83 vssd1 vssd1 vccd1 vccd1 sky130_fd_sc_hd__fill_1
XFILLER_19_179 vssd1 vssd1 vccd1 vccd1 sky130_fd_sc_hd__fill_1
X_1830_ net200 _1497_ vssd1 vssd1 vccd1 vccd1 _0464_ sky130_fd_sc_hd__nand2_1
X_3500_ clknet_leaf_32_clk _0196_ net222 vssd1 vssd1 vccd1 vccd1 SB0.route_sel\[55\]
+ sky130_fd_sc_hd__dfstp_1
X_1761_ CB_1.config_dataB\[24\] CB_1.config_dataB\[20\] CB_1.config_dataB\[21\] vssd1
+ vssd1 vccd1 vccd1 _0395_ sky130_fd_sc_hd__nand3b_2
X_1692_ CB_0.config_dataA\[19\] vssd1 vssd1 vccd1 vccd1 _1574_ sky130_fd_sc_hd__inv_2
X_3362_ clknet_leaf_6_clk _0058_ net231 vssd1 vssd1 vccd1 vccd1 LE_0A.config_data\[7\]
+ sky130_fd_sc_hd__dfrtp_1
X_2313_ net183 net184 vssd1 vssd1 vccd1 vccd1 _0945_ sky130_fd_sc_hd__or2_1
X_3431_ clknet_leaf_23_clk _0127_ net243 vssd1 vssd1 vccd1 vccd1 CB_1.config_dataB\[11\]
+ sky130_fd_sc_hd__dfstp_1
X_2175_ _0800_ _0802_ _0808_ CB_0.config_dataA\[14\] vssd1 vssd1 vccd1 vccd1 _0809_
+ sky130_fd_sc_hd__a31o_1
X_2244_ CB_0.config_dataB\[1\] _0870_ _0871_ _0875_ _1576_ vssd1 vssd1 vccd1 vccd1
+ _0876_ sky130_fd_sc_hd__a311o_1
X_3293_ net321 LE_1B.config_data\[8\] net281 vssd1 vssd1 vccd1 vccd1 _0353_ sky130_fd_sc_hd__mux2_1
XTAP_TAPCELL_ROW_48_483 vssd1 vccd1 sky130_fd_sc_hd__tapvpwrvgnd_1
XTAP_TAPCELL_ROW_23_306 vssd1 vccd1 sky130_fd_sc_hd__tapvpwrvgnd_1
X_3629_ clknet_leaf_16_clk _0325_ net255 vssd1 vssd1 vccd1 vccd1 CB_1.config_dataA\[6\]
+ sky130_fd_sc_hd__dfstp_1
X_1959_ _0371_ _0568_ vssd1 vssd1 vccd1 vccd1 _0593_ sky130_fd_sc_hd__nor2_1
XTAP_TAPCELL_ROW_31_361 vssd1 vccd1 sky130_fd_sc_hd__tapvpwrvgnd_1
XFILLER_39_208 vssd1 vssd1 vccd1 vccd1 sky130_fd_sc_hd__fill_1
XTAP_TAPCELL_ROW_45_464 vssd1 vccd1 sky130_fd_sc_hd__tapvpwrvgnd_1
X_2931_ _1565_ SB0.route_sel\[115\] vssd1 vssd1 vccd1 vccd1 _1488_ sky130_fd_sc_hd__nand2_1
Xclkbuf_0_clk clk vssd1 vssd1 vccd1 vccd1 clknet_0_clk sky130_fd_sc_hd__clkbuf_16
X_2793_ net152 _1403_ _0541_ vssd1 vssd1 vccd1 vccd1 net101 sky130_fd_sc_hd__mux2_1
X_1744_ net164 _0376_ net22 vssd1 vssd1 vccd1 vccd1 _0378_ sky130_fd_sc_hd__o21ba_1
X_1813_ SB0.route_sel\[108\] SB0.route_sel\[109\] net53 _0446_ _0445_ vssd1 vssd1
+ vccd1 vccd1 _0447_ sky130_fd_sc_hd__a41o_1
XFILLER_30_152 vccd1 vssd1 vccd1 vssd1 sky130_ef_sc_hd__decap_40_12
XFILLER_30_141 vssd1 vssd1 vccd1 vccd1 sky130_fd_sc_hd__fill_2
X_2862_ SB0.route_sel\[73\] SB0.route_sel\[72\] vssd1 vssd1 vccd1 vccd1 _1442_ sky130_fd_sc_hd__or2_1
X_3345_ clknet_leaf_15_clk _0041_ net257 vssd1 vssd1 vccd1 vccd1 LEI0.config_data\[40\]
+ sky130_fd_sc_hd__dfrtp_1
X_1675_ SB0.route_sel\[102\] vssd1 vssd1 vccd1 vccd1 _1557_ sky130_fd_sc_hd__inv_2
X_3276_ CB_1.config_dataA\[17\] net167 net286 vssd1 vssd1 vccd1 vccd1 _0336_ sky130_fd_sc_hd__mux2_1
X_3414_ clknet_leaf_24_clk _0110_ net244 vssd1 vssd1 vccd1 vccd1 LE_1A.config_data\[15\]
+ sky130_fd_sc_hd__dfrtp_1
XPHY_EDGE_ROW_15_Right_15 vssd1 vssd1 vccd1 vccd1 sky130_fd_sc_hd__decap_3
X_2227_ LE_0A.config_data\[5\] _0741_ _0779_ _0860_ vssd1 vssd1 vccd1 vccd1 _0861_
+ sky130_fd_sc_hd__a211o_1
X_2158_ net194 _0492_ vssd1 vssd1 vccd1 vccd1 _0792_ sky130_fd_sc_hd__nand2_1
XFILLER_53_255 vssd1 vssd1 vccd1 vccd1 sky130_fd_sc_hd__fill_2
XFILLER_38_241 vssd1 vssd1 vccd1 vccd1 sky130_fd_sc_hd__fill_2
XFILLER_38_230 vssd1 vssd1 vccd1 vccd1 sky130_fd_sc_hd__fill_2
XFILLER_26_27 vssd1 vssd1 vccd1 vccd1 sky130_fd_sc_hd__fill_1
XPHY_EDGE_ROW_24_Right_24 vssd1 vssd1 vccd1 vccd1 sky130_fd_sc_hd__decap_3
X_2089_ SB0.route_sel\[3\] SB0.route_sel\[2\] _0722_ _1501_ vssd1 vssd1 vccd1 vccd1
+ _0723_ sky130_fd_sc_hd__a31o_1
XPHY_EDGE_ROW_39_Left_107 vssd1 vssd1 vccd1 vccd1 sky130_fd_sc_hd__decap_3
XPHY_EDGE_ROW_33_Right_33 vssd1 vssd1 vccd1 vccd1 sky130_fd_sc_hd__decap_3
XTAP_TAPCELL_ROW_59_556 vssd1 vccd1 sky130_fd_sc_hd__tapvpwrvgnd_1
XPHY_EDGE_ROW_48_Left_116 vssd1 vssd1 vccd1 vccd1 sky130_fd_sc_hd__decap_3
XFILLER_44_211 vssd1 vssd1 vccd1 vccd1 sky130_fd_sc_hd__fill_1
XPHY_EDGE_ROW_42_Right_42 vssd1 vssd1 vccd1 vccd1 sky130_fd_sc_hd__decap_3
XFILLER_29_274 vssd1 vssd1 vccd1 vccd1 sky130_fd_sc_hd__fill_4
XPHY_EDGE_ROW_57_Left_125 vssd1 vssd1 vccd1 vccd1 sky130_fd_sc_hd__decap_3
XPHY_EDGE_ROW_51_Right_51 vssd1 vssd1 vccd1 vccd1 sky130_fd_sc_hd__decap_3
XFILLER_8_156 vssd1 vssd1 vccd1 vccd1 sky130_fd_sc_hd__fill_2
XFILLER_12_130 vssd1 vssd1 vccd1 vccd1 sky130_fd_sc_hd__fill_1
X_3130_ SB0.route_sel\[49\] SB0.route_sel\[48\] net265 vssd1 vssd1 vccd1 vccd1 _0190_
+ sky130_fd_sc_hd__mux2_1
XPHY_EDGE_ROW_66_Left_134 vssd1 vssd1 vccd1 vccd1 sky130_fd_sc_hd__decap_3
XPHY_EDGE_ROW_60_Right_60 vssd1 vssd1 vccd1 vccd1 sky130_fd_sc_hd__decap_3
X_2012_ _0645_ _0464_ _0436_ _0626_ vssd1 vssd1 vccd1 vccd1 _0646_ sky130_fd_sc_hd__a2bb2o_1
X_3061_ net209 CB_1.config_dataB\[4\] net285 vssd1 vssd1 vccd1 vccd1 _0121_ sky130_fd_sc_hd__mux2_1
X_2845_ _1554_ SB0.route_sel\[99\] SB0.route_sel\[100\] _1556_ _1430_ vssd1 vssd1
+ vccd1 vccd1 _1431_ sky130_fd_sc_hd__o221a_1
X_2914_ SB0.route_sel\[15\] SB0.route_sel\[14\] SB0.route_sel\[9\] _1508_ _1476_ vssd1
+ vssd1 vccd1 vccd1 _1477_ sky130_fd_sc_hd__o221a_1
Xhold101 LE_0B.config_data\[7\] vssd1 vssd1 vccd1 vccd1 net411 sky130_fd_sc_hd__dlygate4sd3_1
X_1658_ SB0.route_sel\[65\] vssd1 vssd1 vccd1 vccd1 _1540_ sky130_fd_sc_hd__inv_2
X_2776_ net67 LE_1B.edge_mode vssd1 vssd1 vccd1 vccd1 LE_1B.sel_clk sky130_fd_sc_hd__xnor2_1
Xhold112 LE_1B.config_data\[0\] vssd1 vssd1 vccd1 vccd1 net422 sky130_fd_sc_hd__dlygate4sd3_1
X_1727_ CB_1.config_dataA\[24\] CB_1.config_dataA\[20\] CB_1.config_dataA\[21\] vssd1
+ vssd1 vccd1 vccd1 _1609_ sky130_fd_sc_hd__nor3b_2
X_3328_ clknet_leaf_15_clk net331 net257 vssd1 vssd1 vccd1 vccd1 LEI0.config_data\[23\]
+ sky130_fd_sc_hd__dfrtp_1
X_3259_ net178 CB_0.config_dataB\[24\] net303 vssd1 vssd1 vccd1 vccd1 _0319_ sky130_fd_sc_hd__mux2_1
XTAP_TAPCELL_ROW_64_592 vssd1 vccd1 sky130_fd_sc_hd__tapvpwrvgnd_1
XTAP_TAPCELL_ROW_56_537 vssd1 vccd1 sky130_fd_sc_hd__tapvpwrvgnd_1
XFILLER_41_258 vssd1 vssd1 vccd1 vccd1 sky130_fd_sc_hd__fill_2
XFILLER_49_358 vssd1 vssd1 vccd1 vccd1 sky130_fd_sc_hd__fill_2
XFILLER_17_233 vssd1 vssd1 vccd1 vccd1 sky130_fd_sc_hd__fill_1
XFILLER_40_280 vssd1 vssd1 vccd1 vccd1 sky130_fd_sc_hd__fill_1
XFILLER_32_247 vssd1 vssd1 vccd1 vccd1 sky130_fd_sc_hd__fill_2
XFILLER_17_288 vssd1 vssd1 vccd1 vccd1 sky130_fd_sc_hd__fill_1
X_2492_ net4 net5 net6 net7 net175 net173 vssd1 vssd1 vccd1 vccd1 _1122_ sky130_fd_sc_hd__mux4_1
X_2561_ net168 _1071_ vssd1 vssd1 vccd1 vccd1 _1191_ sky130_fd_sc_hd__nand2_1
X_2630_ net15 net16 net2 net3 net212 CB_1.config_dataB\[1\] vssd1 vssd1 vccd1 vccd1
+ _1258_ sky130_fd_sc_hd__mux4_1
XFILLER_67_155 vssd1 vssd1 vccd1 vccd1 sky130_fd_sc_hd__fill_4
XFILLER_4_85 vssd1 vssd1 vccd1 vccd1 sky130_fd_sc_hd__fill_1
XFILLER_4_63 vssd1 vssd1 vccd1 vccd1 sky130_fd_sc_hd__fill_1
X_3113_ SB0.route_sel\[32\] SB0.route_sel\[31\] net263 vssd1 vssd1 vccd1 vccd1 _0173_
+ sky130_fd_sc_hd__mux2_1
XTAP_TAPCELL_ROW_53_518 vssd1 vccd1 sky130_fd_sc_hd__tapvpwrvgnd_1
X_3044_ net385 net383 net281 vssd1 vssd1 vccd1 vccd1 _0104_ sky130_fd_sc_hd__mux2_1
XTAP_TAPCELL_ROW_18_272 vssd1 vccd1 sky130_fd_sc_hd__tapvpwrvgnd_1
XFILLER_23_225 vccd1 vssd1 vccd1 vssd1 sky130_ef_sc_hd__decap_40_12
XTAP_TAPCELL_ROW_61_573 vssd1 vccd1 sky130_fd_sc_hd__tapvpwrvgnd_1
X_2828_ net144 _1421_ _0555_ vssd1 vssd1 vccd1 vccd1 net84 sky130_fd_sc_hd__mux2_1
XFILLER_48_25 vssd1 vssd1 vccd1 vccd1 sky130_fd_sc_hd__fill_2
X_2759_ LE_1B.config_data\[13\] _1274_ _1307_ _1386_ vssd1 vssd1 vccd1 vccd1 _1387_
+ sky130_fd_sc_hd__a211o_1
XFILLER_58_111 vssd1 vssd1 vccd1 vccd1 sky130_fd_sc_hd__fill_1
XFILLER_58_100 vssd1 vssd1 vccd1 vccd1 sky130_fd_sc_hd__fill_2
XTAP_TAPCELL_ROW_1_151 vssd1 vccd1 sky130_fd_sc_hd__tapvpwrvgnd_1
XFILLER_6_402 vssd1 vssd1 vccd1 vccd1 sky130_fd_sc_hd__fill_1
XFILLER_49_155 vssd1 vssd1 vccd1 vccd1 sky130_fd_sc_hd__fill_2
XFILLER_49_111 vssd1 vssd1 vccd1 vccd1 sky130_fd_sc_hd__fill_1
X_1992_ net291 _0621_ _0625_ vssd1 vssd1 vccd1 vccd1 _0626_ sky130_fd_sc_hd__or3_4
X_3662_ clknet_leaf_25_clk net316 net242 vssd1 vssd1 vccd1 vccd1 LE_1B.config_data\[14\]
+ sky130_fd_sc_hd__dfrtp_1
Xclkload10 clknet_leaf_35_clk vssd1 vssd1 vccd1 vccd1 clkload10/Y sky130_fd_sc_hd__bufinv_16
XTAP_TAPCELL_ROW_15_253 vssd1 vccd1 sky130_fd_sc_hd__tapvpwrvgnd_1
X_3593_ clknet_leaf_12_clk _0289_ net250 vssd1 vssd1 vccd1 vccd1 CB_0.config_dataA\[20\]
+ sky130_fd_sc_hd__dfstp_2
X_2544_ _1590_ _1171_ CB_1.config_dataA\[13\] vssd1 vssd1 vccd1 vccd1 _1174_ sky130_fd_sc_hd__a21oi_1
X_2475_ net176 _1093_ _1097_ _1104_ vssd1 vssd1 vccd1 vccd1 _1105_ sky130_fd_sc_hd__a31o_1
X_2613_ _1240_ vssd1 vssd1 vccd1 vccd1 _1241_ sky130_fd_sc_hd__inv_2
Xclkload21 clknet_leaf_27_clk vssd1 vssd1 vccd1 vccd1 clkload21/Y sky130_fd_sc_hd__clkinv_2
XTAP_TAPCELL_ROW_66_610 vssd1 vccd1 sky130_fd_sc_hd__tapvpwrvgnd_1
XFILLER_55_169 vccd1 vssd1 vccd1 vssd1 sky130_ef_sc_hd__decap_40_12
X_3027_ net319 LE_0B.config_data\[13\] net288 vssd1 vssd1 vccd1 vccd1 _0087_ sky130_fd_sc_hd__mux2_1
XFILLER_34_38 vssd1 vssd1 vccd1 vccd1 sky130_fd_sc_hd__fill_2
Xclkload4 clknet_leaf_2_clk vssd1 vssd1 vccd1 vccd1 clkload4/Y sky130_fd_sc_hd__clkinv_4
Xfanout252 net253 vssd1 vssd1 vccd1 vccd1 net252 sky130_fd_sc_hd__clkbuf_4
Xfanout230 net232 vssd1 vssd1 vccd1 vccd1 net230 sky130_fd_sc_hd__clkbuf_4
Xfanout274 net275 vssd1 vssd1 vccd1 vccd1 net274 sky130_fd_sc_hd__clkbuf_4
Xfanout241 net70 vssd1 vssd1 vccd1 vccd1 net241 sky130_fd_sc_hd__buf_2
Xfanout263 net264 vssd1 vssd1 vccd1 vccd1 net263 sky130_fd_sc_hd__buf_2
Xfanout296 net298 vssd1 vssd1 vccd1 vccd1 net296 sky130_fd_sc_hd__clkbuf_4
Xfanout285 net286 vssd1 vssd1 vccd1 vccd1 net285 sky130_fd_sc_hd__clkbuf_4
XFILLER_24_82 vssd1 vssd1 vccd1 vccd1 sky130_fd_sc_hd__fill_2
X_2191_ net31 net32 net18 net19 net192 net190 vssd1 vssd1 vccd1 vccd1 _0825_ sky130_fd_sc_hd__mux4_1
X_2260_ _0891_ vssd1 vssd1 vccd1 vccd1 _0892_ sky130_fd_sc_hd__inv_2
XFILLER_52_117 vccd1 vssd1 vccd1 vssd1 sky130_ef_sc_hd__decap_40_12
X_1975_ net151 _0422_ _0567_ vssd1 vssd1 vccd1 vccd1 _0609_ sky130_fd_sc_hd__and3_1
X_3645_ clknet_leaf_27_clk _0341_ net237 vssd1 vssd1 vccd1 vccd1 CB_1.config_dataA\[22\]
+ sky130_fd_sc_hd__dfstp_2
X_3576_ clknet_2_1__leaf_clk _0272_ net233 vssd1 vssd1 vccd1 vccd1 CB_0.config_dataA\[3\]
+ sky130_fd_sc_hd__dfstp_1
X_2458_ net1 net8 net9 net10 net177 net176 vssd1 vssd1 vccd1 vccd1 _1088_ sky130_fd_sc_hd__mux4_1
X_2527_ net171 net170 vssd1 vssd1 vccd1 vccd1 _1157_ sky130_fd_sc_hd__nor2_1
Xhold38 _0348_ vssd1 vssd1 vccd1 vccd1 net348 sky130_fd_sc_hd__dlygate4sd3_1
Xhold27 _0101_ vssd1 vssd1 vccd1 vccd1 net337 sky130_fd_sc_hd__dlygate4sd3_1
Xhold16 LE_1B.config_data\[6\] vssd1 vssd1 vccd1 vccd1 net326 sky130_fd_sc_hd__dlygate4sd3_1
X_2389_ _0939_ _1020_ _1019_ _0974_ vssd1 vssd1 vccd1 vccd1 _1021_ sky130_fd_sc_hd__o211a_1
XTAP_TAPCELL_ROW_26_326 vssd1 vccd1 sky130_fd_sc_hd__tapvpwrvgnd_1
XFILLER_16_309 vssd1 vssd1 vccd1 vccd1 sky130_fd_sc_hd__fill_2
Xhold49 _0106_ vssd1 vssd1 vccd1 vccd1 net359 sky130_fd_sc_hd__dlygate4sd3_1
XTAP_TAPCELL_ROW_34_381 vssd1 vccd1 sky130_fd_sc_hd__tapvpwrvgnd_1
XFILLER_34_106 vssd1 vssd1 vccd1 vccd1 sky130_fd_sc_hd__fill_8
XFILLER_30_301 vssd1 vssd1 vccd1 vccd1 sky130_fd_sc_hd__fill_4
XFILLER_19_169 vssd1 vssd1 vccd1 vccd1 sky130_fd_sc_hd__fill_1
X_1691_ CB_0.config_dataA\[12\] vssd1 vssd1 vccd1 vccd1 _1573_ sky130_fd_sc_hd__inv_2
X_1760_ _0388_ _0391_ _0392_ _0393_ vssd1 vssd1 vccd1 vccd1 _0394_ sky130_fd_sc_hd__a31oi_2
X_3361_ clknet_leaf_7_clk net335 net231 vssd1 vssd1 vccd1 vccd1 LE_0A.config_data\[6\]
+ sky130_fd_sc_hd__dfrtp_1
X_2312_ net183 net184 vssd1 vssd1 vccd1 vccd1 _0944_ sky130_fd_sc_hd__nor2_1
XPHY_EDGE_ROW_27_Left_95 vssd1 vssd1 vccd1 vccd1 sky130_fd_sc_hd__decap_3
X_3292_ net360 net346 net281 vssd1 vssd1 vccd1 vccd1 _0352_ sky130_fd_sc_hd__mux2_1
X_3430_ clknet_leaf_23_clk _0126_ net246 vssd1 vssd1 vccd1 vccd1 CB_1.config_dataB\[10\]
+ sky130_fd_sc_hd__dfstp_1
X_2174_ CB_0.config_dataA\[12\] _0804_ _0806_ _0807_ CB_0.config_dataA\[13\] vssd1
+ vssd1 vccd1 vccd1 _0808_ sky130_fd_sc_hd__a221oi_1
XTAP_TAPCELL_ROW_48_484 vssd1 vccd1 sky130_fd_sc_hd__tapvpwrvgnd_1
X_2243_ _0874_ _0645_ _0626_ _0872_ vssd1 vssd1 vccd1 vccd1 _0875_ sky130_fd_sc_hd__a2bb2o_1
XFILLER_25_139 vssd1 vssd1 vccd1 vccd1 sky130_fd_sc_hd__fill_4
XPHY_EDGE_ROW_11_Left_79 vssd1 vssd1 vccd1 vccd1 sky130_fd_sc_hd__decap_3
XFILLER_21_323 vssd1 vssd1 vccd1 vccd1 sky130_fd_sc_hd__fill_1
XTAP_TAPCELL_ROW_23_307 vssd1 vccd1 sky130_fd_sc_hd__tapvpwrvgnd_1
X_1889_ net159 _0483_ vssd1 vssd1 vccd1 vccd1 _0523_ sky130_fd_sc_hd__or2_1
X_3628_ clknet_leaf_17_clk _0324_ net259 vssd1 vssd1 vccd1 vccd1 CB_1.config_dataA\[5\]
+ sky130_fd_sc_hd__dfstp_1
XTAP_TAPCELL_ROW_31_362 vssd1 vccd1 sky130_fd_sc_hd__tapvpwrvgnd_1
XFILLER_31_28 vssd1 vssd1 vccd1 vccd1 sky130_fd_sc_hd__fill_1
X_1958_ _0588_ _0591_ _0583_ vssd1 vssd1 vccd1 vccd1 _0592_ sky130_fd_sc_hd__a21oi_2
X_3559_ clknet_leaf_11_clk _0255_ net249 vssd1 vssd1 vccd1 vccd1 SB0.route_sel\[114\]
+ sky130_fd_sc_hd__dfstp_1
XFILLER_56_253 vssd1 vssd1 vccd1 vccd1 sky130_fd_sc_hd__fill_1
XFILLER_24_161 vssd1 vssd1 vccd1 vccd1 sky130_fd_sc_hd__fill_2
XFILLER_16_139 vssd1 vssd1 vccd1 vccd1 sky130_fd_sc_hd__fill_1
XFILLER_24_194 vssd1 vssd1 vccd1 vccd1 sky130_fd_sc_hd__fill_2
X_2930_ _1487_ net137 vssd1 vssd1 vccd1 vccd1 net124 sky130_fd_sc_hd__and2b_1
XFILLER_30_164 vccd1 vssd1 vccd1 vssd1 sky130_ef_sc_hd__decap_40_12
X_2861_ _0508_ _1441_ vssd1 vssd1 vccd1 vccd1 net104 sky130_fd_sc_hd__and2b_1
XFILLER_15_161 vssd1 vssd1 vccd1 vccd1 sky130_fd_sc_hd__fill_1
X_2792_ net148 _0425_ _0482_ _1402_ vssd1 vssd1 vccd1 vccd1 _1403_ sky130_fd_sc_hd__a31o_1
X_1743_ net164 _0376_ vssd1 vssd1 vccd1 vccd1 _0377_ sky130_fd_sc_hd__or2_1
X_1812_ SB0.route_sel\[111\] SB0.route_sel\[110\] vssd1 vssd1 vccd1 vccd1 _0446_ sky130_fd_sc_hd__nand2_1
X_1674_ SB0.route_sel\[101\] vssd1 vssd1 vccd1 vccd1 _1556_ sky130_fd_sc_hd__inv_2
X_3413_ clknet_leaf_24_clk _0109_ net244 vssd1 vssd1 vccd1 vccd1 LE_1A.config_data\[14\]
+ sky130_fd_sc_hd__dfrtp_1
X_2226_ LE_0A.config_data\[4\] _0736_ _0740_ vssd1 vssd1 vccd1 vccd1 _0860_ sky130_fd_sc_hd__and3_1
X_3344_ clknet_leaf_15_clk _0040_ net257 vssd1 vssd1 vccd1 vccd1 LEI0.config_data\[39\]
+ sky130_fd_sc_hd__dfrtp_1
X_3275_ CB_1.config_dataA\[16\] CB_1.config_dataA\[15\] net299 vssd1 vssd1 vccd1 vccd1
+ _0335_ sky130_fd_sc_hd__mux2_1
X_2157_ _0789_ _0790_ _1573_ vssd1 vssd1 vccd1 vccd1 _0791_ sky130_fd_sc_hd__mux2_1
XFILLER_38_253 vssd1 vssd1 vccd1 vccd1 sky130_fd_sc_hd__fill_1
X_2088_ _0720_ net33 _0721_ vssd1 vssd1 vccd1 vccd1 _0722_ sky130_fd_sc_hd__mux2_1
XTAP_TAPCELL_ROW_59_557 vssd1 vccd1 sky130_fd_sc_hd__tapvpwrvgnd_1
XFILLER_44_256 vssd1 vssd1 vccd1 vccd1 sky130_fd_sc_hd__fill_2
XFILLER_32_82 vssd1 vssd1 vccd1 vccd1 sky130_fd_sc_hd__fill_2
X_3060_ CB_1.config_dataB\[4\] CB_1.config_dataB\[3\] net285 vssd1 vssd1 vccd1 vccd1
+ _0120_ sky130_fd_sc_hd__mux2_1
XFILLER_35_223 vssd1 vssd1 vccd1 vccd1 sky130_fd_sc_hd__fill_1
X_2011_ _0642_ _0643_ _0644_ _0641_ vssd1 vssd1 vccd1 vccd1 _0645_ sky130_fd_sc_hd__o31a_4
X_2844_ SB0.route_sel\[96\] SB0.route_sel\[97\] vssd1 vssd1 vccd1 vccd1 _1430_ sky130_fd_sc_hd__or2_1
X_2913_ SB0.route_sel\[11\] _1503_ vssd1 vssd1 vccd1 vccd1 _1476_ sky130_fd_sc_hd__nand2_1
Xhold113 LEI0.config_data\[19\] vssd1 vssd1 vccd1 vccd1 net423 sky130_fd_sc_hd__dlygate4sd3_1
Xhold102 CB_0.config_data_inA vssd1 vssd1 vccd1 vccd1 net412 sky130_fd_sc_hd__dlygate4sd3_1
X_1726_ net166 net165 net6 vssd1 vssd1 vccd1 vccd1 _1608_ sky130_fd_sc_hd__o21ai_1
X_2775_ net215 LE_1B.reset_mode vssd1 vssd1 vccd1 vccd1 _2775_/X sky130_fd_sc_hd__xor2_2
X_1657_ SB0.route_sel\[70\] vssd1 vssd1 vccd1 vccd1 _1539_ sky130_fd_sc_hd__inv_2
X_2209_ CB_0.config_dataA\[18\] CB_0.config_dataA\[17\] vssd1 vssd1 vccd1 vccd1 _0843_
+ sky130_fd_sc_hd__nor2_1
X_3327_ clknet_leaf_15_clk _0023_ net257 vssd1 vssd1 vccd1 vccd1 LEI0.config_data\[22\]
+ sky130_fd_sc_hd__dfrtp_1
XTAP_TAPCELL_ROW_56_538 vssd1 vccd1 sky130_fd_sc_hd__tapvpwrvgnd_1
X_3258_ CB_0.config_dataB\[24\] CB_0.config_dataB\[23\] net303 vssd1 vssd1 vccd1 vccd1
+ _0318_ sky130_fd_sc_hd__mux2_1
X_3189_ SB0.route_sel\[108\] SB0.route_sel\[107\] net287 vssd1 vssd1 vccd1 vccd1 _0249_
+ sky130_fd_sc_hd__mux2_1
XTAP_TAPCELL_ROW_64_593 vssd1 vccd1 sky130_fd_sc_hd__tapvpwrvgnd_1
XFILLER_53_48 vssd1 vssd1 vccd1 vccd1 sky130_fd_sc_hd__fill_1
XPHY_EDGE_ROW_14_Left_82 vssd1 vssd1 vccd1 vccd1 sky130_fd_sc_hd__decap_3
XFILLER_5_105 vssd1 vssd1 vccd1 vccd1 sky130_fd_sc_hd__fill_4
XFILLER_64_307 vssd1 vssd1 vccd1 vccd1 sky130_fd_sc_hd__fill_1
XTAP_TAPCELL_ROW_4_171 vssd1 vccd1 sky130_fd_sc_hd__tapvpwrvgnd_1
Xclkbuf_2_0__f_clk clknet_0_clk vssd1 vssd1 vccd1 vccd1 clknet_2_0__leaf_clk sky130_fd_sc_hd__clkbuf_16
X_2491_ net173 _1114_ _1115_ _1120_ vssd1 vssd1 vccd1 vccd1 _1121_ sky130_fd_sc_hd__a31o_1
X_2560_ _1150_ _1152_ _1187_ _1189_ vssd1 vssd1 vccd1 vccd1 _1190_ sky130_fd_sc_hd__o211a_1
X_3043_ net383 net363 net281 vssd1 vssd1 vccd1 vccd1 _0103_ sky130_fd_sc_hd__mux2_1
X_3112_ SB0.route_sel\[31\] SB0.route_sel\[30\] net263 vssd1 vssd1 vccd1 vccd1 _0172_
+ sky130_fd_sc_hd__mux2_1
XTAP_TAPCELL_ROW_53_519 vssd1 vccd1 sky130_fd_sc_hd__tapvpwrvgnd_1
XTAP_TAPCELL_ROW_18_273 vssd1 vccd1 sky130_fd_sc_hd__tapvpwrvgnd_1
XFILLER_23_237 vssd1 vssd1 vccd1 vccd1 sky130_fd_sc_hd__fill_2
XTAP_TAPCELL_ROW_61_574 vssd1 vccd1 sky130_fd_sc_hd__tapvpwrvgnd_1
XFILLER_31_281 vssd1 vssd1 vccd1 vccd1 sky130_fd_sc_hd__fill_2
X_2758_ _1266_ _1267_ _1273_ LE_1B.config_data\[12\] vssd1 vssd1 vccd1 vccd1 _1386_
+ sky130_fd_sc_hd__o211a_1
X_2827_ _0557_ _1071_ _0559_ vssd1 vssd1 vccd1 vccd1 _1421_ sky130_fd_sc_hd__o21a_1
X_1709_ LEI0.config_data\[44\] vssd1 vssd1 vccd1 vccd1 _1591_ sky130_fd_sc_hd__inv_2
X_2689_ net15 net16 net2 net3 net207 CB_1.config_dataB\[11\] vssd1 vssd1 vccd1 vccd1
+ _1317_ sky130_fd_sc_hd__mux4_1
XFILLER_64_58 vssd1 vssd1 vccd1 vccd1 sky130_fd_sc_hd__fill_1
XFILLER_58_145 vssd1 vssd1 vccd1 vccd1 sky130_fd_sc_hd__fill_4
XFILLER_46_307 vssd1 vssd1 vccd1 vccd1 sky130_fd_sc_hd__fill_1
XTAP_TAPCELL_ROW_1_152 vssd1 vccd1 sky130_fd_sc_hd__tapvpwrvgnd_1
XFILLER_49_101 vssd1 vssd1 vccd1 vccd1 sky130_fd_sc_hd__fill_8
XFILLER_1_141 vssd1 vssd1 vccd1 vccd1 sky130_fd_sc_hd__fill_2
X_3592_ clknet_leaf_13_clk _0288_ net253 vssd1 vssd1 vccd1 vccd1 CB_0.config_dataA\[19\]
+ sky130_fd_sc_hd__dfstp_1
Xclkload11 clknet_leaf_3_clk vssd1 vssd1 vccd1 vccd1 clkload11/Y sky130_fd_sc_hd__clkinv_8
X_2612_ net212 CB_1.config_dataB\[1\] vssd1 vssd1 vccd1 vccd1 _1240_ sky130_fd_sc_hd__nor2_1
X_3661_ clknet_leaf_25_clk _0357_ net242 vssd1 vssd1 vccd1 vccd1 LE_1B.config_data\[13\]
+ sky130_fd_sc_hd__dfrtp_1
XFILLER_13_281 vssd1 vssd1 vccd1 vccd1 sky130_fd_sc_hd__fill_1
XTAP_TAPCELL_ROW_15_254 vssd1 vccd1 sky130_fd_sc_hd__tapvpwrvgnd_1
X_1991_ _0624_ vssd1 vssd1 vccd1 vccd1 _0625_ sky130_fd_sc_hd__inv_2
Xclkload22 clknet_leaf_28_clk vssd1 vssd1 vccd1 vccd1 clkload22/Y sky130_fd_sc_hd__inv_8
X_2543_ CB_1.config_dataA\[12\] _1172_ vssd1 vssd1 vccd1 vccd1 _1173_ sky130_fd_sc_hd__nand2_1
X_2474_ _1044_ _1100_ _1103_ _1039_ CB_1.config_dataA\[2\] vssd1 vssd1 vccd1 vccd1
+ _1104_ sky130_fd_sc_hd__a221o_1
XTAP_TAPCELL_ROW_66_611 vssd1 vccd1 sky130_fd_sc_hd__tapvpwrvgnd_1
X_3026_ net370 LE_0B.config_data\[12\] net288 vssd1 vssd1 vccd1 vccd1 _0086_ sky130_fd_sc_hd__mux2_1
Xclkload5 clknet_leaf_29_clk vssd1 vssd1 vccd1 vccd1 clkload5/Y sky130_fd_sc_hd__inv_8
XFILLER_50_27 vssd1 vssd1 vccd1 vccd1 sky130_fd_sc_hd__fill_1
Xfanout253 net254 vssd1 vssd1 vccd1 vccd1 net253 sky130_fd_sc_hd__clkbuf_2
Xfanout231 net232 vssd1 vssd1 vccd1 vccd1 net231 sky130_fd_sc_hd__clkbuf_4
Xfanout297 net298 vssd1 vssd1 vccd1 vccd1 net297 sky130_fd_sc_hd__clkbuf_4
Xfanout275 net310 vssd1 vssd1 vccd1 vccd1 net275 sky130_fd_sc_hd__clkbuf_2
Xfanout220 net221 vssd1 vssd1 vccd1 vccd1 net220 sky130_fd_sc_hd__clkbuf_4
Xfanout286 net287 vssd1 vssd1 vccd1 vccd1 net286 sky130_fd_sc_hd__clkbuf_2
XFILLER_1_7 vssd1 vssd1 vccd1 vccd1 sky130_fd_sc_hd__fill_2
Xfanout242 net243 vssd1 vssd1 vccd1 vccd1 net242 sky130_fd_sc_hd__clkbuf_4
Xfanout264 net275 vssd1 vssd1 vccd1 vccd1 net264 sky130_fd_sc_hd__clkbuf_2
XTAP_TAPCELL_ROW_29_346 vssd1 vccd1 sky130_fd_sc_hd__tapvpwrvgnd_1
XFILLER_24_72 vssd1 vssd1 vccd1 vccd1 sky130_fd_sc_hd__fill_1
XFILLER_10_240 vssd1 vssd1 vccd1 vccd1 sky130_fd_sc_hd__fill_1
X_2190_ _0823_ vssd1 vssd1 vccd1 vccd1 _0824_ sky130_fd_sc_hd__inv_2
XFILLER_27_6 vccd1 vssd1 vccd1 vssd1 sky130_ef_sc_hd__decap_40_12
XFILLER_18_362 vssd1 vssd1 vccd1 vccd1 sky130_fd_sc_hd__fill_2
XFILLER_60_184 vssd1 vssd1 vccd1 vccd1 sky130_fd_sc_hd__fill_1
XFILLER_52_129 vssd1 vssd1 vccd1 vccd1 sky130_fd_sc_hd__fill_1
X_1974_ _0425_ _0570_ net27 vssd1 vssd1 vccd1 vccd1 _0608_ sky130_fd_sc_hd__a21o_1
XFILLER_45_192 vssd1 vssd1 vccd1 vccd1 sky130_fd_sc_hd__fill_1
X_3575_ clknet_leaf_8_clk _0271_ net233 vssd1 vssd1 vccd1 vccd1 CB_0.config_dataA\[2\]
+ sky130_fd_sc_hd__dfstp_1
X_3644_ clknet_leaf_26_clk _0340_ net237 vssd1 vssd1 vccd1 vccd1 CB_1.config_dataA\[21\]
+ sky130_fd_sc_hd__dfstp_1
Xhold28 LEI0.config_data\[34\] vssd1 vssd1 vccd1 vccd1 net338 sky130_fd_sc_hd__dlygate4sd3_1
XFILLER_56_402 vssd1 vssd1 vccd1 vccd1 sky130_fd_sc_hd__fill_1
X_2526_ CB_1.config_dataA\[11\] net172 vssd1 vssd1 vccd1 vccd1 _1156_ sky130_fd_sc_hd__nand2b_1
X_2457_ CB_1.config_dataA\[2\] _1086_ CB_1.config_dataA\[3\] vssd1 vssd1 vccd1 vccd1
+ _1087_ sky130_fd_sc_hd__a21o_1
X_2388_ LE_0B.config_data\[8\] LE_0B.config_data\[9\] _0905_ vssd1 vssd1 vccd1 vccd1
+ _1020_ sky130_fd_sc_hd__mux2_1
XFILLER_29_28 vssd1 vssd1 vccd1 vccd1 sky130_fd_sc_hd__fill_2
Xhold39 LE_1B.config_data\[2\] vssd1 vssd1 vccd1 vccd1 net349 sky130_fd_sc_hd__dlygate4sd3_1
Xhold17 _0350_ vssd1 vssd1 vccd1 vccd1 net327 sky130_fd_sc_hd__dlygate4sd3_1
XFILLER_43_118 vssd1 vssd1 vccd1 vccd1 sky130_fd_sc_hd__fill_2
XTAP_TAPCELL_ROW_26_327 vssd1 vccd1 sky130_fd_sc_hd__tapvpwrvgnd_1
X_3009_ LE_0A.reset_val LE_0A.edge_mode net261 vssd1 vssd1 vccd1 vccd1 _0069_ sky130_fd_sc_hd__mux2_1
XFILLER_51_162 vssd1 vssd1 vccd1 vccd1 sky130_fd_sc_hd__fill_1
XTAP_TAPCELL_ROW_34_382 vssd1 vccd1 sky130_fd_sc_hd__tapvpwrvgnd_1
XFILLER_3_258 vssd1 vssd1 vccd1 vccd1 sky130_fd_sc_hd__fill_1
XFILLER_47_402 vssd1 vssd1 vccd1 vccd1 sky130_fd_sc_hd__fill_1
XFILLER_42_195 vssd1 vssd1 vccd1 vccd1 sky130_fd_sc_hd__fill_1
XFILLER_15_387 vssd1 vssd1 vccd1 vccd1 sky130_fd_sc_hd__fill_1
X_1690_ LEI0.config_data\[26\] vssd1 vssd1 vccd1 vccd1 _1572_ sky130_fd_sc_hd__inv_2
XPHY_EDGE_ROW_2_Left_70 vssd1 vssd1 vccd1 vccd1 sky130_fd_sc_hd__decap_3
X_3360_ clknet_leaf_7_clk _0056_ net231 vssd1 vssd1 vccd1 vccd1 LE_0A.config_data\[5\]
+ sky130_fd_sc_hd__dfrtp_1
X_2311_ net184 _0409_ vssd1 vssd1 vccd1 vccd1 _0943_ sky130_fd_sc_hd__and2_1
X_2242_ net188 _1577_ vssd1 vssd1 vccd1 vccd1 _0874_ sky130_fd_sc_hd__nand2_1
X_3291_ net346 net326 net281 vssd1 vssd1 vccd1 vccd1 _0351_ sky130_fd_sc_hd__mux2_1
X_2173_ _0733_ _0784_ _0786_ _0715_ _1573_ vssd1 vssd1 vccd1 vccd1 _0807_ sky130_fd_sc_hd__o221a_1
XTAP_TAPCELL_ROW_48_485 vssd1 vccd1 sky130_fd_sc_hd__tapvpwrvgnd_1
XTAP_TAPCELL_ROW_31_363 vssd1 vccd1 sky130_fd_sc_hd__tapvpwrvgnd_1
X_1957_ _1525_ _0589_ _0590_ SB0.route_sel\[51\] vssd1 vssd1 vccd1 vccd1 _0591_ sky130_fd_sc_hd__or4b_1
XFILLER_21_302 vssd1 vssd1 vccd1 vccd1 sky130_fd_sc_hd__fill_2
XTAP_TAPCELL_ROW_23_308 vssd1 vccd1 sky130_fd_sc_hd__tapvpwrvgnd_1
X_1888_ _0450_ _0479_ vssd1 vssd1 vccd1 vccd1 _0522_ sky130_fd_sc_hd__nand2_1
X_3627_ clknet_leaf_19_clk _0323_ net259 vssd1 vssd1 vccd1 vccd1 CB_1.config_dataA\[4\]
+ sky130_fd_sc_hd__dfstp_1
X_3558_ clknet_leaf_11_clk _0254_ net249 vssd1 vssd1 vccd1 vccd1 SB0.route_sel\[113\]
+ sky130_fd_sc_hd__dfstp_1
X_2509_ net174 _1092_ vssd1 vssd1 vccd1 vccd1 _1139_ sky130_fd_sc_hd__nand2_1
X_3489_ clknet_leaf_31_clk _0185_ net224 vssd1 vssd1 vccd1 vccd1 SB0.route_sel\[44\]
+ sky130_fd_sc_hd__dfstp_1
XFILLER_56_287 vssd1 vssd1 vccd1 vccd1 sky130_fd_sc_hd__fill_1
XFILLER_24_184 vssd1 vssd1 vccd1 vccd1 sky130_fd_sc_hd__fill_2
XFILLER_21_51 vssd1 vssd1 vccd1 vccd1 sky130_fd_sc_hd__fill_4
XFILLER_47_276 vssd1 vssd1 vccd1 vccd1 sky130_fd_sc_hd__fill_4
Xclkbuf_leaf_27_clk clknet_2_2__leaf_clk vssd1 vssd1 vccd1 vccd1 clknet_leaf_27_clk
+ sky130_fd_sc_hd__clkbuf_8
X_2791_ _0425_ _0482_ _0549_ vssd1 vssd1 vccd1 vccd1 _1402_ sky130_fd_sc_hd__a21oi_1
X_1811_ SB0.route_sel\[108\] SB0.route_sel\[109\] net37 vssd1 vssd1 vccd1 vccd1 _0445_
+ sky130_fd_sc_hd__a21boi_1
XFILLER_30_176 vssd1 vssd1 vccd1 vccd1 sky130_fd_sc_hd__fill_8
XFILLER_30_143 vssd1 vssd1 vccd1 vccd1 sky130_fd_sc_hd__fill_1
XFILLER_30_132 vssd1 vssd1 vccd1 vccd1 sky130_fd_sc_hd__fill_8
XFILLER_30_121 vssd1 vssd1 vccd1 vccd1 sky130_fd_sc_hd__fill_2
X_2860_ SB0.route_sel\[83\] _1547_ _1549_ SB0.route_sel\[80\] _1440_ vssd1 vssd1 vccd1
+ vccd1 _1441_ sky130_fd_sc_hd__a221o_1
X_1742_ net179 net180 vssd1 vssd1 vccd1 vccd1 _0376_ sky130_fd_sc_hd__nand2_2
X_1673_ SB0.route_sel\[99\] vssd1 vssd1 vccd1 vccd1 _1555_ sky130_fd_sc_hd__inv_2
X_3412_ clknet_leaf_24_clk net406 net245 vssd1 vssd1 vccd1 vccd1 LE_1A.config_data\[13\]
+ sky130_fd_sc_hd__dfrtp_1
X_3343_ clknet_leaf_15_clk net421 net256 vssd1 vssd1 vccd1 vccd1 LEI0.config_data\[38\]
+ sky130_fd_sc_hd__dfrtp_1
X_2225_ LE_0A.config_data\[6\] LE_0A.config_data\[7\] _0741_ vssd1 vssd1 vccd1 vccd1
+ _0859_ sky130_fd_sc_hd__mux2_1
X_3274_ CB_1.config_dataA\[15\] CB_1.config_dataA\[14\] net299 vssd1 vssd1 vccd1 vccd1
+ _0334_ sky130_fd_sc_hd__mux2_1
X_2156_ net31 net32 net18 net19 net194 net193 vssd1 vssd1 vccd1 vccd1 _0790_ sky130_fd_sc_hd__mux4_1
XFILLER_53_279 vssd1 vssd1 vccd1 vccd1 sky130_fd_sc_hd__fill_1
Xclkbuf_leaf_18_clk clknet_2_3__leaf_clk vssd1 vssd1 vccd1 vccd1 clknet_leaf_18_clk
+ sky130_fd_sc_hd__clkbuf_8
XTAP_TAPCELL_ROW_36_400 vssd1 vccd1 sky130_fd_sc_hd__tapvpwrvgnd_1
XFILLER_26_29 vssd1 vssd1 vccd1 vccd1 sky130_fd_sc_hd__fill_1
XPHY_EDGE_ROW_5_Right_5 vssd1 vssd1 vccd1 vccd1 sky130_fd_sc_hd__decap_3
X_2087_ SB0.route_sel\[4\] SB0.route_sel\[5\] vssd1 vssd1 vccd1 vccd1 _0721_ sky130_fd_sc_hd__nand2_1
XFILLER_21_110 vssd1 vssd1 vccd1 vccd1 sky130_fd_sc_hd__fill_2
X_2989_ LE_0A.dff0_out _0867_ net68 vssd1 vssd1 vccd1 vccd1 _0049_ sky130_fd_sc_hd__mux2_1
XTAP_TAPCELL_ROW_59_558 vssd1 vccd1 sky130_fd_sc_hd__tapvpwrvgnd_1
XFILLER_29_254 vssd1 vssd1 vccd1 vccd1 sky130_fd_sc_hd__fill_1
XFILLER_12_187 vssd1 vssd1 vccd1 vccd1 sky130_fd_sc_hd__fill_8
XFILLER_32_94 vssd1 vssd1 vccd1 vccd1 sky130_fd_sc_hd__fill_1
XFILLER_32_50 vssd1 vssd1 vccd1 vccd1 sky130_fd_sc_hd__fill_2
XFILLER_4_331 vssd1 vssd1 vccd1 vccd1 sky130_fd_sc_hd__fill_2
X_2010_ SB0.route_sel\[45\] SB0.route_sel\[44\] vssd1 vssd1 vccd1 vccd1 _0644_ sky130_fd_sc_hd__and2b_1
XFILLER_35_279 vssd1 vssd1 vccd1 vccd1 sky130_fd_sc_hd__fill_1
X_2912_ _1475_ _0712_ vssd1 vssd1 vccd1 vccd1 net126 sky130_fd_sc_hd__and2b_1
X_1725_ CB_1.config_dataB\[23\] CB_1.config_dataB\[22\] vssd1 vssd1 vccd1 vccd1 _1607_
+ sky130_fd_sc_hd__nand2_1
X_2774_ net67 LE_1A.edge_mode vssd1 vssd1 vccd1 vccd1 LE_1A.sel_clk sky130_fd_sc_hd__xnor2_1
X_2843_ _0717_ _1429_ _0718_ vssd1 vssd1 vccd1 vccd1 net71 sky130_fd_sc_hd__a21oi_1
Xclkbuf_leaf_7_clk clknet_2_1__leaf_clk vssd1 vssd1 vccd1 vccd1 clknet_leaf_7_clk
+ sky130_fd_sc_hd__clkbuf_8
X_3326_ clknet_leaf_15_clk _0022_ net258 vssd1 vssd1 vccd1 vccd1 LEI0.config_data\[21\]
+ sky130_fd_sc_hd__dfrtp_1
Xhold103 LEI0.config_data\[5\] vssd1 vssd1 vccd1 vccd1 net413 sky130_fd_sc_hd__dlygate4sd3_1
Xhold114 LE_1A.reset_val vssd1 vssd1 vccd1 vccd1 net424 sky130_fd_sc_hd__dlygate4sd3_1
X_1656_ SB0.route_sel\[71\] vssd1 vssd1 vccd1 vccd1 _1538_ sky130_fd_sc_hd__inv_2
X_2208_ CB_0.config_dataA\[17\] _0841_ vssd1 vssd1 vccd1 vccd1 _0842_ sky130_fd_sc_hd__and2b_1
X_2139_ net153 net149 LEI0.config_data\[12\] vssd1 vssd1 vccd1 vccd1 _0773_ sky130_fd_sc_hd__mux2_1
XTAP_TAPCELL_ROW_56_539 vssd1 vccd1 sky130_fd_sc_hd__tapvpwrvgnd_1
X_3257_ CB_0.config_dataB\[23\] CB_0.config_dataB\[22\] net303 vssd1 vssd1 vccd1 vccd1
+ _0317_ sky130_fd_sc_hd__mux2_1
X_3188_ SB0.route_sel\[107\] SB0.route_sel\[106\] net287 vssd1 vssd1 vccd1 vccd1 _0248_
+ sky130_fd_sc_hd__mux2_1
XTAP_TAPCELL_ROW_64_594 vssd1 vccd1 sky130_fd_sc_hd__tapvpwrvgnd_1
XTAP_TAPCELL_ROW_4_172 vssd1 vccd1 sky130_fd_sc_hd__tapvpwrvgnd_1
X_2490_ _1043_ _1117_ _1119_ _1038_ CB_1.config_dataA\[7\] vssd1 vssd1 vccd1 vccd1
+ _1120_ sky130_fd_sc_hd__o221ai_1
XFILLER_4_76 vssd1 vssd1 vccd1 vccd1 sky130_fd_sc_hd__fill_2
X_3042_ net363 net336 net280 vssd1 vssd1 vccd1 vccd1 _0102_ sky130_fd_sc_hd__mux2_1
X_3111_ SB0.route_sel\[30\] SB0.route_sel\[29\] net263 vssd1 vssd1 vccd1 vccd1 _0171_
+ sky130_fd_sc_hd__mux2_1
XTAP_TAPCELL_ROW_61_575 vssd1 vccd1 sky130_fd_sc_hd__tapvpwrvgnd_1
XTAP_TAPCELL_ROW_18_274 vssd1 vccd1 sky130_fd_sc_hd__tapvpwrvgnd_1
X_1708_ CB_1.config_dataA\[12\] vssd1 vssd1 vccd1 vccd1 _1590_ sky130_fd_sc_hd__inv_2
X_2688_ net4 net5 net6 net7 net207 CB_1.config_dataB\[11\] vssd1 vssd1 vccd1 vccd1
+ _1316_ sky130_fd_sc_hd__mux4_1
X_2757_ LE_1B.config_data\[14\] LE_1B.config_data\[15\] _1274_ vssd1 vssd1 vccd1 vccd1
+ _1385_ sky130_fd_sc_hd__mux2_1
X_2826_ _0534_ _1420_ _0535_ vssd1 vssd1 vccd1 vccd1 net85 sky130_fd_sc_hd__a21oi_1
X_3309_ clknet_leaf_12_clk _0005_ net252 vssd1 vssd1 vccd1 vccd1 LEI0.config_data\[4\]
+ sky130_fd_sc_hd__dfrtp_1
XFILLER_48_27 vssd1 vssd1 vccd1 vccd1 sky130_fd_sc_hd__fill_1
X_1639_ SB0.route_sel\[42\] vssd1 vssd1 vccd1 vccd1 _1521_ sky130_fd_sc_hd__inv_2
XFILLER_39_393 vssd1 vssd1 vccd1 vccd1 sky130_fd_sc_hd__fill_2
XFILLER_39_360 vssd1 vssd1 vccd1 vccd1 sky130_fd_sc_hd__fill_1
XTAP_TAPCELL_ROW_1_153 vssd1 vccd1 sky130_fd_sc_hd__tapvpwrvgnd_1
XFILLER_49_113 vssd1 vssd1 vccd1 vccd1 sky130_fd_sc_hd__fill_4
XFILLER_38_71 vccd1 vssd1 vccd1 vssd1 sky130_ef_sc_hd__decap_40_12
XFILLER_37_319 vssd1 vssd1 vccd1 vccd1 sky130_fd_sc_hd__fill_2
X_1990_ SB0.route_sel\[36\] _1518_ SB0.route_sel\[39\] _1519_ _0623_ vssd1 vssd1 vccd1
+ vccd1 _0624_ sky130_fd_sc_hd__a221o_1
X_3591_ clknet_leaf_13_clk _0287_ net253 vssd1 vssd1 vccd1 vccd1 CB_0.config_dataA\[18\]
+ sky130_fd_sc_hd__dfstp_1
X_2542_ net11 net12 net13 net14 net172 net170 vssd1 vssd1 vccd1 vccd1 _1172_ sky130_fd_sc_hd__mux4_1
Xclkload23 clknet_leaf_11_clk vssd1 vssd1 vccd1 vccd1 clkload23/Y sky130_fd_sc_hd__clkinv_8
Xclkload12 clknet_leaf_4_clk vssd1 vssd1 vccd1 vccd1 clkload12/Y sky130_fd_sc_hd__inv_8
X_3660_ clknet_leaf_25_clk _0356_ net243 vssd1 vssd1 vccd1 vccd1 LE_1B.config_data\[12\]
+ sky130_fd_sc_hd__dfrtp_1
XFILLER_9_231 vssd1 vssd1 vccd1 vccd1 sky130_fd_sc_hd__fill_1
X_2611_ net213 _1071_ vssd1 vssd1 vccd1 vccd1 _1239_ sky130_fd_sc_hd__nand2_1
X_2473_ _0730_ _1102_ vssd1 vssd1 vccd1 vccd1 _1103_ sky130_fd_sc_hd__nand2_4
X_3025_ net415 net400 net288 vssd1 vssd1 vccd1 vccd1 _0085_ sky130_fd_sc_hd__mux2_1
XFILLER_36_363 vssd1 vssd1 vccd1 vccd1 sky130_fd_sc_hd__fill_1
XFILLER_36_341 vssd1 vssd1 vccd1 vccd1 sky130_fd_sc_hd__fill_2
Xclkload6 clknet_leaf_30_clk vssd1 vssd1 vccd1 vccd1 clkload6/Y sky130_fd_sc_hd__clkinvlp_4
X_2809_ net148 _0733_ _0725_ vssd1 vssd1 vccd1 vccd1 _1412_ sky130_fd_sc_hd__mux2_1
Xfanout254 net260 vssd1 vssd1 vccd1 vccd1 net254 sky130_fd_sc_hd__clkbuf_2
Xfanout232 net234 vssd1 vssd1 vccd1 vccd1 net232 sky130_fd_sc_hd__buf_2
Xfanout298 net309 vssd1 vssd1 vccd1 vccd1 net298 sky130_fd_sc_hd__clkbuf_2
Xfanout221 net235 vssd1 vssd1 vccd1 vccd1 net221 sky130_fd_sc_hd__clkbuf_2
Xfanout287 net310 vssd1 vssd1 vccd1 vccd1 net287 sky130_fd_sc_hd__clkbuf_2
Xfanout210 CB_1.config_dataB\[5\] vssd1 vssd1 vccd1 vccd1 net210 sky130_fd_sc_hd__dlymetal6s2s_1
Xfanout276 net278 vssd1 vssd1 vccd1 vccd1 net276 sky130_fd_sc_hd__clkbuf_4
Xfanout265 net268 vssd1 vssd1 vccd1 vccd1 net265 sky130_fd_sc_hd__clkbuf_4
Xfanout243 net247 vssd1 vssd1 vccd1 vccd1 net243 sky130_fd_sc_hd__clkbuf_4
XTAP_TAPCELL_ROW_29_347 vssd1 vccd1 sky130_fd_sc_hd__tapvpwrvgnd_1
XFILLER_41_9 vssd1 vssd1 vccd1 vccd1 sky130_fd_sc_hd__fill_2
XFILLER_60_174 vssd1 vssd1 vccd1 vccd1 sky130_fd_sc_hd__fill_2
XFILLER_45_182 vssd1 vssd1 vccd1 vccd1 sky130_fd_sc_hd__fill_8
X_1973_ net146 _0426_ _0571_ _0568_ _0423_ vssd1 vssd1 vccd1 vccd1 _0607_ sky130_fd_sc_hd__o32a_1
X_3574_ clknet_leaf_4_clk _0270_ net233 vssd1 vssd1 vccd1 vccd1 CB_0.config_dataA\[1\]
+ sky130_fd_sc_hd__dfstp_1
X_2525_ net170 net171 vssd1 vssd1 vccd1 vccd1 _1155_ sky130_fd_sc_hd__and2b_1
X_3643_ clknet_leaf_23_clk _0339_ net243 vssd1 vssd1 vccd1 vccd1 CB_1.config_dataA\[20\]
+ sky130_fd_sc_hd__dfstp_2
Xhold29 LEI0.config_data\[14\] vssd1 vssd1 vccd1 vccd1 net339 sky130_fd_sc_hd__dlygate4sd3_1
Xhold18 LE_0A.config_data\[7\] vssd1 vssd1 vccd1 vccd1 net328 sky130_fd_sc_hd__dlygate4sd3_1
X_2456_ net11 net12 net13 net14 net178 CB_1.config_dataA\[1\] vssd1 vssd1 vccd1 vccd1
+ _1086_ sky130_fd_sc_hd__mux4_1
X_2387_ LE_0B.config_data\[11\] _0905_ _0938_ _1018_ vssd1 vssd1 vccd1 vccd1 _1019_
+ sky130_fd_sc_hd__a211o_1
XFILLER_51_152 vssd1 vssd1 vccd1 vccd1 sky130_fd_sc_hd__fill_4
XTAP_TAPCELL_ROW_26_328 vssd1 vccd1 sky130_fd_sc_hd__tapvpwrvgnd_1
X_3008_ LE_0A.edge_mode LE_0A.config_data\[16\] net261 vssd1 vssd1 vccd1 vccd1 _0068_
+ sky130_fd_sc_hd__mux2_1
XTAP_TAPCELL_ROW_34_383 vssd1 vccd1 sky130_fd_sc_hd__tapvpwrvgnd_1
XFILLER_10_31 vssd1 vssd1 vccd1 vccd1 sky130_fd_sc_hd__fill_1
XFILLER_10_97 vssd1 vssd1 vccd1 vccd1 sky130_fd_sc_hd__fill_1
XFILLER_42_141 vccd1 vssd1 vccd1 vssd1 sky130_ef_sc_hd__decap_40_12
X_2310_ net185 _0385_ vssd1 vssd1 vccd1 vccd1 _0942_ sky130_fd_sc_hd__nor2_1
X_2172_ net194 _0675_ _0805_ vssd1 vssd1 vccd1 vccd1 _0806_ sky130_fd_sc_hd__a21o_1
X_2241_ net189 CB_0.config_dataB\[1\] vssd1 vssd1 vccd1 vccd1 _0873_ sky130_fd_sc_hd__or2_1
X_3290_ net326 LE_1B.config_data\[5\] net281 vssd1 vssd1 vccd1 vccd1 _0350_ sky130_fd_sc_hd__mux2_1
XFILLER_18_3 vssd1 vssd1 vccd1 vccd1 sky130_fd_sc_hd__fill_4
XTAP_TAPCELL_ROW_23_309 vssd1 vccd1 sky130_fd_sc_hd__tapvpwrvgnd_1
XFILLER_33_196 vssd1 vssd1 vccd1 vccd1 sky130_fd_sc_hd__fill_1
XTAP_TAPCELL_ROW_31_364 vssd1 vccd1 sky130_fd_sc_hd__tapvpwrvgnd_1
X_1887_ SB0.route_sel\[75\] SB0.route_sel\[74\] _0520_ _1546_ vssd1 vssd1 vccd1 vccd1
+ _0521_ sky130_fd_sc_hd__a31o_1
X_1956_ SB0.route_sel\[52\] SB0.route_sel\[53\] net45 vssd1 vssd1 vccd1 vccd1 _0590_
+ sky130_fd_sc_hd__a21boi_1
X_3626_ clknet_leaf_19_clk _0322_ net259 vssd1 vssd1 vccd1 vccd1 CB_1.config_dataA\[3\]
+ sky130_fd_sc_hd__dfstp_1
X_2508_ CB_1.config_dataA\[7\] _1137_ CB_1.config_dataA\[8\] vssd1 vssd1 vccd1 vccd1
+ _1138_ sky130_fd_sc_hd__a21oi_1
X_3557_ clknet_leaf_20_clk _0253_ net249 vssd1 vssd1 vccd1 vccd1 SB0.route_sel\[112\]
+ sky130_fd_sc_hd__dfstp_1
X_3488_ clknet_leaf_31_clk _0184_ net239 vssd1 vssd1 vccd1 vccd1 SB0.route_sel\[43\]
+ sky130_fd_sc_hd__dfstp_1
XFILLER_56_222 vssd1 vssd1 vccd1 vccd1 sky130_fd_sc_hd__fill_1
XTAP_TAPCELL_ROW_39_420 vssd1 vccd1 sky130_fd_sc_hd__tapvpwrvgnd_1
X_2439_ SB0.route_sel\[60\] SB0.route_sel\[61\] _1534_ SB0.route_sel\[56\] vssd1 vssd1
+ vccd1 vccd1 _1069_ sky130_fd_sc_hd__o22a_1
XFILLER_24_141 vssd1 vssd1 vccd1 vccd1 sky130_fd_sc_hd__fill_4
XFILLER_47_200 vssd1 vssd1 vccd1 vccd1 sky130_fd_sc_hd__fill_1
XFILLER_46_82 vssd1 vssd1 vccd1 vccd1 sky130_fd_sc_hd__fill_2
X_2790_ net152 _1401_ _0522_ vssd1 vssd1 vccd1 vccd1 net102 sky130_fd_sc_hd__mux2_1
X_1741_ CB_0.config_dataB\[20\] CB_0.config_dataB\[24\] CB_0.config_dataB\[21\] vssd1
+ vssd1 vccd1 vccd1 _0375_ sky130_fd_sc_hd__or3b_1
X_1810_ _1560_ _1561_ _0440_ _0442_ _0443_ vssd1 vssd1 vccd1 vccd1 _0444_ sky130_fd_sc_hd__o221a_1
X_3342_ clknet_leaf_15_clk _0038_ net256 vssd1 vssd1 vccd1 vccd1 LEI0.config_data\[37\]
+ sky130_fd_sc_hd__dfrtp_1
X_1672_ SB0.route_sel\[98\] vssd1 vssd1 vccd1 vccd1 _1554_ sky130_fd_sc_hd__inv_2
X_3411_ clknet_leaf_24_clk _0107_ net245 vssd1 vssd1 vccd1 vccd1 LE_1A.config_data\[12\]
+ sky130_fd_sc_hd__dfrtp_1
X_2155_ net20 net21 net22 net23 net195 CB_0.config_dataA\[11\] vssd1 vssd1 vccd1 vccd1
+ _0789_ sky130_fd_sc_hd__mux4_1
X_2224_ _0812_ _0818_ _0820_ _0856_ vssd1 vssd1 vccd1 vccd1 _0858_ sky130_fd_sc_hd__a31o_1
XFILLER_53_214 vssd1 vssd1 vccd1 vccd1 sky130_fd_sc_hd__fill_1
X_3273_ CB_1.config_dataA\[14\] CB_1.config_dataA\[13\] net309 vssd1 vssd1 vccd1 vccd1
+ _0333_ sky130_fd_sc_hd__mux2_1
XTAP_TAPCELL_ROW_36_401 vssd1 vccd1 sky130_fd_sc_hd__tapvpwrvgnd_1
XFILLER_42_18 vssd1 vssd1 vccd1 vccd1 sky130_fd_sc_hd__fill_1
X_2086_ SB0.route_sel\[7\] SB0.route_sel\[6\] net49 vssd1 vssd1 vccd1 vccd1 _0720_
+ sky130_fd_sc_hd__a21boi_1
XFILLER_21_122 vssd1 vssd1 vccd1 vccd1 sky130_fd_sc_hd__fill_1
X_3609_ clknet_leaf_7_clk _0305_ net232 vssd1 vssd1 vccd1 vccd1 CB_0.config_dataB\[11\]
+ sky130_fd_sc_hd__dfstp_1
X_2988_ net412 net409 net304 vssd1 vssd1 vccd1 vccd1 _0048_ sky130_fd_sc_hd__mux2_1
X_1939_ net163 _0570_ net30 vssd1 vssd1 vccd1 vccd1 _0573_ sky130_fd_sc_hd__a21o_1
XTAP_TAPCELL_ROW_59_559 vssd1 vccd1 sky130_fd_sc_hd__tapvpwrvgnd_1
XTAP_TAPCELL_ROW_42_437 vssd1 vccd1 sky130_fd_sc_hd__tapvpwrvgnd_1
XPHY_EDGE_ROW_11_Right_11 vssd1 vssd1 vccd1 vccd1 sky130_fd_sc_hd__decap_3
XFILLER_16_85 vssd1 vssd1 vccd1 vccd1 sky130_fd_sc_hd__fill_2
XPHY_EDGE_ROW_20_Right_20 vssd1 vssd1 vccd1 vccd1 sky130_fd_sc_hd__decap_3
XTAP_TAPCELL_ROW_7_192 vssd1 vccd1 sky130_fd_sc_hd__tapvpwrvgnd_1
XPHY_EDGE_ROW_35_Left_103 vssd1 vssd1 vccd1 vccd1 sky130_fd_sc_hd__decap_3
X_2911_ SB0.route_sel\[11\] _1503_ SB0.route_sel\[12\] _1504_ _1474_ vssd1 vssd1 vccd1
+ vccd1 _1475_ sky130_fd_sc_hd__o221a_1
Xhold104 _0006_ vssd1 vssd1 vccd1 vccd1 net414 sky130_fd_sc_hd__dlygate4sd3_1
XPHY_EDGE_ROW_44_Left_112 vssd1 vssd1 vccd1 vccd1 sky130_fd_sc_hd__decap_3
X_2773_ net242 LE_1A.reset_mode vssd1 vssd1 vccd1 vccd1 _2773_/X sky130_fd_sc_hd__xor2_2
X_2842_ net161 net156 _1103_ vssd1 vssd1 vccd1 vccd1 _1429_ sky130_fd_sc_hd__o21bai_1
Xhold115 LE_1B.config_data\[1\] vssd1 vssd1 vccd1 vccd1 net425 sky130_fd_sc_hd__dlygate4sd3_1
X_1724_ CB_1.config_dataB\[20\] CB_1.config_dataB\[24\] CB_1.config_dataB\[21\] vssd1
+ vssd1 vccd1 vccd1 _1606_ sky130_fd_sc_hd__or3b_2
X_3325_ clknet_leaf_16_clk net387 net258 vssd1 vssd1 vccd1 vccd1 LEI0.config_data\[20\]
+ sky130_fd_sc_hd__dfrtp_1
X_3256_ net180 CB_0.config_dataB\[21\] net300 vssd1 vssd1 vccd1 vccd1 _0316_ sky130_fd_sc_hd__mux2_1
X_1655_ SB0.route_sel\[69\] vssd1 vssd1 vccd1 vccd1 _1537_ sky130_fd_sc_hd__inv_2
X_2207_ net17 net24 net25 net26 net192 net190 vssd1 vssd1 vccd1 vccd1 _0841_ sky130_fd_sc_hd__mux4_1
X_2138_ CB_0.config_dataA\[8\] _0746_ CB_0.config_dataA\[7\] CB_0.config_dataA\[9\]
+ vssd1 vssd1 vccd1 vccd1 _0772_ sky130_fd_sc_hd__or4b_1
XPHY_EDGE_ROW_53_Left_121 vssd1 vssd1 vccd1 vccd1 sky130_fd_sc_hd__decap_3
XFILLER_53_17 vssd1 vssd1 vccd1 vccd1 sky130_fd_sc_hd__fill_1
X_3187_ SB0.route_sel\[106\] SB0.route_sel\[105\] net287 vssd1 vssd1 vccd1 vccd1 _0247_
+ sky130_fd_sc_hd__mux2_1
X_2069_ SB0.route_sel\[15\] SB0.route_sel\[14\] vssd1 vssd1 vccd1 vccd1 _0703_ sky130_fd_sc_hd__nand2_1
XTAP_TAPCELL_ROW_64_595 vssd1 vccd1 sky130_fd_sc_hd__tapvpwrvgnd_1
XPHY_EDGE_ROW_62_Left_130 vssd1 vssd1 vccd1 vccd1 sky130_fd_sc_hd__decap_3
XFILLER_64_309 vssd1 vssd1 vccd1 vccd1 sky130_fd_sc_hd__fill_1
XTAP_TAPCELL_ROW_4_173 vssd1 vccd1 sky130_fd_sc_hd__tapvpwrvgnd_1
XFILLER_1_335 vssd1 vssd1 vccd1 vccd1 sky130_fd_sc_hd__fill_1
XFILLER_43_83 vssd1 vssd1 vccd1 vccd1 sky130_fd_sc_hd__fill_4
XFILLER_9_402 vssd1 vssd1 vccd1 vccd1 sky130_fd_sc_hd__fill_1
XFILLER_4_99 vssd1 vssd1 vccd1 vccd1 sky130_fd_sc_hd__fill_1
XFILLER_4_55 vssd1 vssd1 vccd1 vccd1 sky130_fd_sc_hd__fill_8
X_3110_ SB0.route_sel\[29\] SB0.route_sel\[28\] net265 vssd1 vssd1 vccd1 vccd1 _0170_
+ sky130_fd_sc_hd__mux2_1
XFILLER_67_169 vssd1 vssd1 vccd1 vccd1 sky130_fd_sc_hd__fill_2
X_3041_ net336 LE_1A.config_data\[5\] net280 vssd1 vssd1 vccd1 vccd1 _0101_ sky130_fd_sc_hd__mux2_1
XTAP_TAPCELL_ROW_61_576 vssd1 vccd1 sky130_fd_sc_hd__tapvpwrvgnd_1
X_2825_ net161 net158 _1062_ vssd1 vssd1 vccd1 vccd1 _1420_ sky130_fd_sc_hd__o21bai_1
XTAP_TAPCELL_ROW_18_275 vssd1 vccd1 sky130_fd_sc_hd__tapvpwrvgnd_1
X_1707_ CB_1.config_dataA\[7\] vssd1 vssd1 vccd1 vccd1 _1589_ sky130_fd_sc_hd__inv_2
X_2687_ net205 _1308_ _1309_ _1314_ vssd1 vssd1 vccd1 vccd1 _1315_ sky130_fd_sc_hd__a31o_1
X_2756_ _1341_ _1381_ _1383_ _1375_ vssd1 vssd1 vccd1 vccd1 _1384_ sky130_fd_sc_hd__a31o_1
X_1638_ SB0.route_sel\[32\] vssd1 vssd1 vccd1 vccd1 _1520_ sky130_fd_sc_hd__inv_2
X_3308_ clknet_leaf_12_clk _0004_ net252 vssd1 vssd1 vccd1 vccd1 LEI0.config_data\[3\]
+ sky130_fd_sc_hd__dfrtp_1
X_3239_ net186 CB_0.config_dataB\[4\] net289 vssd1 vssd1 vccd1 vccd1 _0299_ sky130_fd_sc_hd__mux2_1
XTAP_TAPCELL_ROW_52_510 vssd1 vccd1 sky130_fd_sc_hd__tapvpwrvgnd_1
XTAP_TAPCELL_ROW_1_154 vssd1 vccd1 sky130_fd_sc_hd__tapvpwrvgnd_1
XFILLER_22_250 vssd1 vssd1 vccd1 vccd1 sky130_fd_sc_hd__fill_2
XTAP_TAPCELL_ROW_9_210 vssd1 vccd1 sky130_fd_sc_hd__tapvpwrvgnd_1
XFILLER_49_169 vccd1 vssd1 vccd1 vssd1 sky130_ef_sc_hd__decap_40_12
XFILLER_49_147 vssd1 vssd1 vccd1 vccd1 sky130_fd_sc_hd__fill_8
XFILLER_38_83 vssd1 vssd1 vccd1 vccd1 sky130_fd_sc_hd__fill_1
XFILLER_20_209 vssd1 vssd1 vccd1 vccd1 sky130_fd_sc_hd__fill_2
X_3590_ clknet_2_1__leaf_clk _0286_ net250 vssd1 vssd1 vccd1 vccd1 CB_0.config_dataA\[17\]
+ sky130_fd_sc_hd__dfstp_2
Xclkload24 clknet_leaf_13_clk vssd1 vssd1 vccd1 vccd1 clkload24/Y sky130_fd_sc_hd__inv_4
X_2541_ net1 net8 net9 net10 net171 net170 vssd1 vssd1 vccd1 vccd1 _1171_ sky130_fd_sc_hd__mux4_1
Xclkload13 clknet_leaf_5_clk vssd1 vssd1 vccd1 vccd1 clkload13/Y sky130_fd_sc_hd__clkinv_4
X_2472_ SB0.route_sel\[1\] _1501_ _1101_ vssd1 vssd1 vccd1 vccd1 _1102_ sky130_fd_sc_hd__a21bo_1
X_2610_ net213 _1075_ vssd1 vssd1 vccd1 vccd1 _1238_ sky130_fd_sc_hd__or2_1
XFILLER_51_323 vssd1 vssd1 vccd1 vccd1 sky130_fd_sc_hd__fill_1
X_3024_ net400 net355 net288 vssd1 vssd1 vccd1 vccd1 _0084_ sky130_fd_sc_hd__mux2_1
X_2808_ net152 _1411_ _0706_ vssd1 vssd1 vccd1 vccd1 net94 sky130_fd_sc_hd__mux2_1
Xclkload7 clknet_leaf_31_clk vssd1 vssd1 vccd1 vccd1 clkload7/Y sky130_fd_sc_hd__clkinv_2
XFILLER_11_209 vssd1 vssd1 vccd1 vccd1 sky130_fd_sc_hd__fill_1
XFILLER_59_401 vssd1 vssd1 vccd1 vccd1 sky130_fd_sc_hd__fill_2
Xfanout200 net201 vssd1 vssd1 vccd1 vccd1 net200 sky130_fd_sc_hd__buf_2
X_2739_ _1062_ _1345_ _1346_ _1065_ CB_1.config_dataB\[17\] vssd1 vssd1 vccd1 vccd1
+ _1367_ sky130_fd_sc_hd__a221o_1
Xfanout222 net224 vssd1 vssd1 vccd1 vccd1 net222 sky130_fd_sc_hd__clkbuf_4
Xfanout211 CB_1.config_dataB\[1\] vssd1 vssd1 vccd1 vccd1 net211 sky130_fd_sc_hd__buf_2
Xfanout233 net234 vssd1 vssd1 vccd1 vccd1 net233 sky130_fd_sc_hd__clkbuf_4
Xfanout255 net260 vssd1 vssd1 vccd1 vccd1 net255 sky130_fd_sc_hd__clkbuf_4
Xfanout299 net309 vssd1 vssd1 vccd1 vccd1 net299 sky130_fd_sc_hd__clkbuf_4
Xfanout288 net290 vssd1 vssd1 vccd1 vccd1 net288 sky130_fd_sc_hd__clkbuf_4
XTAP_TAPCELL_ROW_29_348 vssd1 vccd1 sky130_fd_sc_hd__tapvpwrvgnd_1
Xfanout277 net278 vssd1 vssd1 vccd1 vccd1 net277 sky130_fd_sc_hd__buf_2
Xfanout266 net268 vssd1 vssd1 vccd1 vccd1 net266 sky130_fd_sc_hd__buf_2
Xfanout244 net247 vssd1 vssd1 vccd1 vccd1 net244 sky130_fd_sc_hd__clkbuf_4
XFILLER_54_161 vssd1 vssd1 vccd1 vccd1 sky130_fd_sc_hd__fill_1
XFILLER_24_85 vssd1 vssd1 vccd1 vccd1 sky130_fd_sc_hd__fill_1
X_1972_ _0422_ _0567_ vssd1 vssd1 vccd1 vccd1 _0606_ sky130_fd_sc_hd__nand2_1
X_3642_ clknet_leaf_22_clk _0338_ net247 vssd1 vssd1 vccd1 vccd1 CB_1.config_dataA\[19\]
+ sky130_fd_sc_hd__dfstp_1
X_3573_ clknet_leaf_12_clk _0269_ net252 vssd1 vssd1 vccd1 vccd1 CB_0.config_dataA\[0\]
+ sky130_fd_sc_hd__dfstp_1
XPHY_EDGE_ROW_49_Right_49 vssd1 vssd1 vccd1 vccd1 sky130_fd_sc_hd__decap_3
X_2524_ net172 _1034_ _1153_ vssd1 vssd1 vccd1 vccd1 _1154_ sky130_fd_sc_hd__a21bo_1
X_2455_ net176 _1072_ _1076_ _1084_ vssd1 vssd1 vccd1 vccd1 _1085_ sky130_fd_sc_hd__a31o_1
Xhold19 LEI0.config_data\[35\] vssd1 vssd1 vccd1 vccd1 net329 sky130_fd_sc_hd__dlygate4sd3_1
XPHY_EDGE_ROW_58_Right_58 vssd1 vssd1 vccd1 vccd1 sky130_fd_sc_hd__decap_3
X_2386_ _0897_ _0898_ _0904_ LE_0B.config_data\[10\] vssd1 vssd1 vccd1 vccd1 _1018_
+ sky130_fd_sc_hd__o211a_1
XFILLER_51_175 vssd1 vssd1 vccd1 vccd1 sky130_fd_sc_hd__fill_1
XFILLER_36_194 vssd1 vssd1 vccd1 vccd1 sky130_fd_sc_hd__fill_2
XTAP_TAPCELL_ROW_34_384 vssd1 vccd1 sky130_fd_sc_hd__tapvpwrvgnd_1
XTAP_TAPCELL_ROW_26_329 vssd1 vccd1 sky130_fd_sc_hd__tapvpwrvgnd_1
X_3007_ LE_0A.config_data\[16\] LE_0A.config_data\[15\] net262 vssd1 vssd1 vccd1 vccd1
+ _0067_ sky130_fd_sc_hd__mux2_1
XPHY_EDGE_ROW_67_Right_67 vssd1 vssd1 vccd1 vccd1 sky130_fd_sc_hd__decap_3
XFILLER_19_30 vssd1 vssd1 vccd1 vccd1 sky130_fd_sc_hd__fill_2
XFILLER_42_120 vssd1 vssd1 vccd1 vccd1 sky130_fd_sc_hd__fill_2
XFILLER_42_197 vssd1 vssd1 vccd1 vccd1 sky130_fd_sc_hd__fill_4
XFILLER_42_153 vccd1 vssd1 vccd1 vssd1 sky130_ef_sc_hd__decap_40_12
XFILLER_35_84 vssd1 vssd1 vccd1 vccd1 sky130_fd_sc_hd__fill_2
XFILLER_30_348 vssd1 vssd1 vccd1 vccd1 sky130_fd_sc_hd__fill_2
X_2171_ net194 _0695_ net193 vssd1 vssd1 vccd1 vccd1 _0805_ sky130_fd_sc_hd__o21ai_1
X_2240_ net188 net187 vssd1 vssd1 vccd1 vccd1 _0872_ sky130_fd_sc_hd__nor2_1
XFILLER_33_131 vssd1 vssd1 vccd1 vccd1 sky130_fd_sc_hd__fill_1
X_3625_ clknet_leaf_12_clk _0321_ net259 vssd1 vssd1 vccd1 vccd1 CB_1.config_dataA\[2\]
+ sky130_fd_sc_hd__dfstp_2
XTAP_TAPCELL_ROW_31_365 vssd1 vccd1 sky130_fd_sc_hd__tapvpwrvgnd_1
X_1955_ _1527_ _1528_ net61 SB0.route_sel\[53\] SB0.route_sel\[52\] vssd1 vssd1 vccd1
+ vccd1 _0589_ sky130_fd_sc_hd__o2111a_1
X_1886_ SB0.route_sel\[76\] SB0.route_sel\[77\] net64 _0519_ _0518_ vssd1 vssd1 vccd1
+ vccd1 _0520_ sky130_fd_sc_hd__a41o_1
X_2507_ net11 net12 net13 net14 net175 net173 vssd1 vssd1 vccd1 vccd1 _1137_ sky130_fd_sc_hd__mux4_1
X_2438_ CB_1.config_dataA\[3\] _1047_ _1051_ _1067_ vssd1 vssd1 vccd1 vccd1 _1068_
+ sky130_fd_sc_hd__and4_2
X_3556_ clknet_leaf_20_clk _0252_ net249 vssd1 vssd1 vccd1 vccd1 SB0.route_sel\[111\]
+ sky130_fd_sc_hd__dfstp_1
X_3487_ clknet_leaf_31_clk _0183_ net239 vssd1 vssd1 vccd1 vccd1 SB0.route_sel\[42\]
+ sky130_fd_sc_hd__dfstp_1
XFILLER_56_212 vssd1 vssd1 vccd1 vccd1 sky130_fd_sc_hd__fill_1
X_2369_ net181 _0409_ _1584_ vssd1 vssd1 vccd1 vccd1 _1001_ sky130_fd_sc_hd__a21o_1
XTAP_TAPCELL_ROW_39_421 vssd1 vccd1 sky130_fd_sc_hd__tapvpwrvgnd_1
XFILLER_21_75 vccd1 vssd1 vccd1 vssd1 sky130_ef_sc_hd__decap_40_12
XFILLER_47_223 vssd1 vssd1 vccd1 vccd1 sky130_fd_sc_hd__fill_1
X_1740_ _0371_ _0373_ vssd1 vssd1 vccd1 vccd1 _0374_ sky130_fd_sc_hd__nor2_1
X_1671_ SB0.route_sel\[88\] vssd1 vssd1 vccd1 vccd1 _1553_ sky130_fd_sc_hd__inv_2
X_3341_ clknet_leaf_15_clk _0037_ net256 vssd1 vssd1 vccd1 vccd1 LEI0.config_data\[36\]
+ sky130_fd_sc_hd__dfrtp_1
X_3272_ CB_1.config_dataA\[13\] CB_1.config_dataA\[12\] net309 vssd1 vssd1 vccd1 vccd1
+ _0332_ sky130_fd_sc_hd__mux2_1
X_3410_ clknet_leaf_23_clk net359 net245 vssd1 vssd1 vccd1 vccd1 LE_1A.config_data\[11\]
+ sky130_fd_sc_hd__dfrtp_1
X_2223_ CB_0.config_dataA\[19\] _0823_ _0843_ _0850_ _0855_ vssd1 vssd1 vccd1 vccd1
+ _0857_ sky130_fd_sc_hd__a311o_1
X_2154_ _0782_ _0787_ vssd1 vssd1 vccd1 vccd1 _0788_ sky130_fd_sc_hd__and2b_1
XFILLER_38_278 vssd1 vssd1 vccd1 vccd1 sky130_fd_sc_hd__fill_1
X_2085_ SB0.route_sel\[3\] SB0.route_sel\[2\] _0716_ _0717_ _0718_ vssd1 vssd1 vccd1
+ vccd1 _0719_ sky130_fd_sc_hd__a221oi_1
X_2987_ net409 LEI0.config_data\[45\] net304 vssd1 vssd1 vccd1 vccd1 _0047_ sky130_fd_sc_hd__mux2_1
XFILLER_21_178 vssd1 vssd1 vccd1 vccd1 sky130_fd_sc_hd__fill_8
X_3608_ clknet_leaf_6_clk _0304_ net232 vssd1 vssd1 vccd1 vccd1 CB_0.config_dataB\[10\]
+ sky130_fd_sc_hd__dfstp_1
X_1938_ net163 _0570_ vssd1 vssd1 vccd1 vccd1 _0572_ sky130_fd_sc_hd__and2_1
X_1869_ SB0.route_sel\[83\] SB0.route_sel\[82\] _0500_ _0501_ _0502_ vssd1 vssd1 vccd1
+ vccd1 _0503_ sky130_fd_sc_hd__a221o_1
XFILLER_29_223 vssd1 vssd1 vccd1 vccd1 sky130_fd_sc_hd__fill_1
X_3539_ clknet_leaf_1_clk _0235_ net219 vssd1 vssd1 vccd1 vccd1 SB0.route_sel\[94\]
+ sky130_fd_sc_hd__dfstp_1
XFILLER_29_289 vssd1 vssd1 vccd1 vccd1 sky130_fd_sc_hd__fill_2
XFILLER_29_278 vssd1 vssd1 vccd1 vccd1 sky130_fd_sc_hd__fill_2
XTAP_TAPCELL_ROW_50_493 vssd1 vccd1 sky130_fd_sc_hd__tapvpwrvgnd_1
XTAP_TAPCELL_ROW_42_438 vssd1 vccd1 sky130_fd_sc_hd__tapvpwrvgnd_1
XFILLER_67_307 vssd1 vssd1 vccd1 vccd1 sky130_fd_sc_hd__fill_1
XTAP_TAPCELL_ROW_7_193 vssd1 vccd1 sky130_fd_sc_hd__tapvpwrvgnd_1
X_2910_ SB0.route_sel\[9\] SB0.route_sel\[8\] vssd1 vssd1 vccd1 vccd1 _1474_ sky130_fd_sc_hd__or2_1
X_2841_ _0699_ _1428_ _0700_ vssd1 vssd1 vccd1 vccd1 net78 sky130_fd_sc_hd__a21oi_1
Xhold116 LEI0.config_data\[4\] vssd1 vssd1 vccd1 vccd1 net426 sky130_fd_sc_hd__dlygate4sd3_1
X_1723_ SB0.route_sel\[112\] SB0.route_sel\[113\] vssd1 vssd1 vccd1 vccd1 _1605_ sky130_fd_sc_hd__nand2_1
Xhold105 LE_0B.config_data\[12\] vssd1 vssd1 vccd1 vccd1 net415 sky130_fd_sc_hd__dlygate4sd3_1
X_1654_ SB0.route_sel\[66\] vssd1 vssd1 vccd1 vccd1 _1536_ sky130_fd_sc_hd__inv_2
X_2772_ net67 LE_0B.edge_mode vssd1 vssd1 vccd1 vccd1 LE_0B.sel_clk sky130_fd_sc_hd__xnor2_1
X_2206_ _0838_ _0839_ CB_0.config_dataA\[17\] vssd1 vssd1 vccd1 vccd1 _0840_ sky130_fd_sc_hd__and3b_1
X_3324_ clknet_leaf_14_clk _0020_ net255 vssd1 vssd1 vccd1 vccd1 LEI0.config_data\[19\]
+ sky130_fd_sc_hd__dfrtp_1
X_3255_ CB_0.config_dataB\[21\] CB_0.config_dataB\[20\] net300 vssd1 vssd1 vccd1 vccd1
+ _0315_ sky130_fd_sc_hd__mux2_1
X_2137_ _0760_ _0762_ _0766_ _0770_ vssd1 vssd1 vccd1 vccd1 _0771_ sky130_fd_sc_hd__a211oi_2
X_3186_ SB0.route_sel\[105\] SB0.route_sel\[104\] net287 vssd1 vssd1 vccd1 vccd1 _0246_
+ sky130_fd_sc_hd__mux2_1
X_2068_ SB0.route_sel\[12\] SB0.route_sel\[13\] net40 vssd1 vssd1 vccd1 vccd1 _0702_
+ sky130_fd_sc_hd__a21boi_1
XTAP_TAPCELL_ROW_64_596 vssd1 vccd1 sky130_fd_sc_hd__tapvpwrvgnd_1
XFILLER_27_52 vssd1 vssd1 vccd1 vccd1 sky130_fd_sc_hd__fill_4
XTAP_TAPCELL_ROW_4_174 vssd1 vccd1 sky130_fd_sc_hd__tapvpwrvgnd_1
XFILLER_17_204 vssd1 vssd1 vccd1 vccd1 sky130_fd_sc_hd__fill_2
XTAP_TAPCELL_ROW_55_530 vssd1 vccd1 sky130_fd_sc_hd__tapvpwrvgnd_1
XFILLER_43_51 vssd1 vssd1 vccd1 vccd1 sky130_fd_sc_hd__fill_4
XFILLER_40_251 vssd1 vssd1 vccd1 vccd1 sky130_fd_sc_hd__fill_1
XFILLER_67_159 vssd1 vssd1 vccd1 vccd1 sky130_fd_sc_hd__fill_1
X_3040_ net361 LE_1A.config_data\[4\] net280 vssd1 vssd1 vccd1 vccd1 _0100_ sky130_fd_sc_hd__mux2_1
XFILLER_23_207 vssd1 vssd1 vccd1 vccd1 sky130_fd_sc_hd__fill_2
XFILLER_23_218 vssd1 vssd1 vccd1 vccd1 sky130_fd_sc_hd__fill_4
X_2824_ _0515_ _1419_ _0516_ vssd1 vssd1 vccd1 vccd1 net86 sky130_fd_sc_hd__a21oi_1
X_1706_ CB_1.config_dataA\[2\] vssd1 vssd1 vccd1 vccd1 _1588_ sky130_fd_sc_hd__inv_2
X_2686_ _1065_ _1310_ _1312_ _1062_ CB_1.config_dataB\[12\] vssd1 vssd1 vccd1 vccd1
+ _1314_ sky130_fd_sc_hd__a221o_1
X_1637_ SB0.route_sel\[38\] vssd1 vssd1 vccd1 vccd1 _1519_ sky130_fd_sc_hd__inv_2
XPHY_EDGE_ROW_18_Left_86 vssd1 vssd1 vccd1 vccd1 sky130_fd_sc_hd__decap_3
X_2755_ LE_1B.config_data\[1\] _1274_ _1307_ _1382_ vssd1 vssd1 vccd1 vccd1 _1383_
+ sky130_fd_sc_hd__a211o_1
X_3307_ clknet_leaf_12_clk _0003_ net252 vssd1 vssd1 vccd1 vccd1 LEI0.config_data\[2\]
+ sky130_fd_sc_hd__dfrtp_1
X_3238_ CB_0.config_dataB\[4\] CB_0.config_dataB\[3\] net289 vssd1 vssd1 vccd1 vccd1
+ _0298_ sky130_fd_sc_hd__mux2_1
X_3169_ SB0.route_sel\[88\] SB0.route_sel\[87\] net270 vssd1 vssd1 vccd1 vccd1 _0229_
+ sky130_fd_sc_hd__mux2_1
XFILLER_54_354 vssd1 vssd1 vccd1 vccd1 sky130_fd_sc_hd__fill_1
XTAP_TAPCELL_ROW_52_511 vssd1 vccd1 sky130_fd_sc_hd__tapvpwrvgnd_1
XTAP_TAPCELL_ROW_1_155 vssd1 vccd1 sky130_fd_sc_hd__tapvpwrvgnd_1
XFILLER_1_166 vssd1 vssd1 vccd1 vccd1 sky130_fd_sc_hd__fill_2
XTAP_TAPCELL_ROW_9_211 vssd1 vccd1 sky130_fd_sc_hd__tapvpwrvgnd_1
Xclkload14 clknet_leaf_7_clk vssd1 vssd1 vccd1 vccd1 clkload14/Y sky130_fd_sc_hd__clkinv_4
Xclkload25 clknet_leaf_14_clk vssd1 vssd1 vccd1 vccd1 clkload25/X sky130_fd_sc_hd__clkbuf_4
X_2540_ _1083_ _1155_ _1157_ _1079_ _1590_ vssd1 vssd1 vccd1 vccd1 _1170_ sky130_fd_sc_hd__a221o_1
X_2471_ SB0.route_sel\[4\] SB0.route_sel\[5\] SB0.route_sel\[7\] _1499_ vssd1 vssd1
+ vccd1 vccd1 _1101_ sky130_fd_sc_hd__o22a_1
X_3023_ net355 net342 net290 vssd1 vssd1 vccd1 vccd1 _0083_ sky130_fd_sc_hd__mux2_1
XFILLER_63_184 vssd1 vssd1 vccd1 vccd1 sky130_fd_sc_hd__fill_2
XFILLER_51_346 vssd1 vssd1 vccd1 vccd1 sky130_fd_sc_hd__fill_2
XFILLER_48_181 vssd1 vssd1 vccd1 vccd1 sky130_fd_sc_hd__fill_1
X_2807_ _0715_ net148 _0707_ vssd1 vssd1 vccd1 vccd1 _1411_ sky130_fd_sc_hd__mux2_1
X_2738_ net203 _1058_ vssd1 vssd1 vccd1 vccd1 _1366_ sky130_fd_sc_hd__or2_1
Xclkload8 clknet_leaf_32_clk vssd1 vssd1 vccd1 vccd1 clkload8/Y sky130_fd_sc_hd__clkinvlp_4
Xfanout256 net260 vssd1 vssd1 vccd1 vccd1 net256 sky130_fd_sc_hd__buf_2
Xfanout234 net235 vssd1 vssd1 vccd1 vccd1 net234 sky130_fd_sc_hd__clkbuf_2
Xfanout201 CB_0.config_dataA\[0\] vssd1 vssd1 vccd1 vccd1 net201 sky130_fd_sc_hd__clkbuf_2
X_2669_ _1596_ _1294_ _1296_ vssd1 vssd1 vccd1 vccd1 _1297_ sky130_fd_sc_hd__a21oi_1
Xfanout245 net247 vssd1 vssd1 vccd1 vccd1 net245 sky130_fd_sc_hd__clkbuf_2
Xfanout223 net224 vssd1 vssd1 vccd1 vccd1 net223 sky130_fd_sc_hd__clkbuf_4
Xfanout212 net213 vssd1 vssd1 vccd1 vccd1 net212 sky130_fd_sc_hd__buf_2
Xfanout289 net290 vssd1 vssd1 vccd1 vccd1 net289 sky130_fd_sc_hd__buf_2
XTAP_TAPCELL_ROW_29_349 vssd1 vccd1 sky130_fd_sc_hd__tapvpwrvgnd_1
Xfanout267 net268 vssd1 vssd1 vccd1 vccd1 net267 sky130_fd_sc_hd__clkbuf_4
Xfanout278 net283 vssd1 vssd1 vccd1 vccd1 net278 sky130_fd_sc_hd__buf_2
XFILLER_42_324 vssd1 vssd1 vccd1 vccd1 sky130_fd_sc_hd__fill_2
XTAP_TAPCELL_ROW_12_227 vssd1 vccd1 sky130_fd_sc_hd__tapvpwrvgnd_1
XFILLER_10_265 vssd1 vssd1 vccd1 vccd1 sky130_fd_sc_hd__fill_2
XFILLER_45_140 vssd1 vssd1 vccd1 vccd1 sky130_fd_sc_hd__fill_4
XFILLER_33_335 vssd1 vssd1 vccd1 vccd1 sky130_fd_sc_hd__fill_1
XFILLER_1_57 vssd1 vssd1 vccd1 vccd1 sky130_fd_sc_hd__fill_2
XFILLER_18_332 vssd1 vssd1 vccd1 vccd1 sky130_fd_sc_hd__fill_1
X_3572_ clknet_leaf_19_clk _0268_ net248 vssd1 vssd1 vccd1 vccd1 net135 sky130_fd_sc_hd__dfstp_2
X_3641_ clknet_leaf_22_clk _0337_ net247 vssd1 vssd1 vccd1 vccd1 CB_1.config_dataA\[18\]
+ sky130_fd_sc_hd__dfstp_1
X_1971_ SB0.route_sel\[33\] SB0.route_sel\[32\] vssd1 vssd1 vccd1 vccd1 _0605_ sky130_fd_sc_hd__and2_1
X_2523_ net172 _1030_ CB_1.config_dataA\[11\] vssd1 vssd1 vccd1 vccd1 _1153_ sky130_fd_sc_hd__o21a_1
X_2385_ _0975_ _0979_ _0981_ _1016_ vssd1 vssd1 vccd1 vccd1 _1017_ sky130_fd_sc_hd__a31o_1
X_2454_ _1039_ _1079_ _1083_ _1044_ _1588_ vssd1 vssd1 vccd1 vccd1 _1084_ sky130_fd_sc_hd__a221o_1
X_3006_ LE_0A.config_data\[15\] net403 net292 vssd1 vssd1 vccd1 vccd1 _0066_ sky130_fd_sc_hd__mux2_1
Xinput1 CBeast_in[0] vssd1 vssd1 vccd1 vccd1 net1 sky130_fd_sc_hd__buf_2
XFILLER_51_143 vssd1 vssd1 vccd1 vccd1 sky130_fd_sc_hd__fill_2
XTAP_TAPCELL_ROW_34_385 vssd1 vccd1 sky130_fd_sc_hd__tapvpwrvgnd_1
XFILLER_59_243 vssd1 vssd1 vccd1 vccd1 sky130_fd_sc_hd__fill_2
XFILLER_42_132 vssd1 vssd1 vccd1 vccd1 sky130_fd_sc_hd__fill_8
XFILLER_15_335 vssd1 vssd1 vccd1 vccd1 sky130_fd_sc_hd__fill_1
XFILLER_42_165 vssd1 vssd1 vccd1 vccd1 sky130_fd_sc_hd__fill_4
XFILLER_30_305 vssd1 vssd1 vccd1 vccd1 sky130_fd_sc_hd__fill_2
X_2170_ net27 net28 net29 net30 net194 net193 vssd1 vssd1 vccd1 vccd1 _0804_ sky130_fd_sc_hd__mux4_1
XFILLER_25_6 vssd1 vssd1 vccd1 vccd1 sky130_fd_sc_hd__fill_8
X_1954_ _0584_ _0585_ _0586_ _0587_ vssd1 vssd1 vccd1 vccd1 _0588_ sky130_fd_sc_hd__a31o_1
X_3624_ clknet_leaf_12_clk _0320_ net254 vssd1 vssd1 vccd1 vccd1 CB_1.config_dataA\[1\]
+ sky130_fd_sc_hd__dfstp_1
X_3555_ clknet_leaf_11_clk _0251_ net249 vssd1 vssd1 vccd1 vccd1 SB0.route_sel\[110\]
+ sky130_fd_sc_hd__dfstp_1
XTAP_TAPCELL_ROW_31_366 vssd1 vccd1 sky130_fd_sc_hd__tapvpwrvgnd_1
X_1885_ SB0.route_sel\[79\] SB0.route_sel\[78\] vssd1 vssd1 vccd1 vccd1 _0519_ sky130_fd_sc_hd__nand2_1
XFILLER_56_29 vssd1 vssd1 vccd1 vccd1 sky130_fd_sc_hd__fill_2
X_2368_ net182 _0385_ vssd1 vssd1 vccd1 vccd1 _1000_ sky130_fd_sc_hd__nor2_1
X_2506_ _1589_ _1135_ vssd1 vssd1 vccd1 vccd1 _1136_ sky130_fd_sc_hd__nand2_1
X_2437_ net176 _1055_ _1059_ _1066_ vssd1 vssd1 vccd1 vccd1 _1067_ sky130_fd_sc_hd__a31o_1
X_3486_ clknet_leaf_30_clk _0182_ net224 vssd1 vssd1 vccd1 vccd1 SB0.route_sel\[41\]
+ sky130_fd_sc_hd__dfstp_1
X_2299_ net20 net21 net22 net23 net186 CB_0.config_dataB\[6\] vssd1 vssd1 vccd1 vccd1
+ _0931_ sky130_fd_sc_hd__mux4_1
XTAP_TAPCELL_ROW_39_422 vssd1 vccd1 sky130_fd_sc_hd__tapvpwrvgnd_1
XTAP_TAPCELL_ROW_22_300 vssd1 vccd1 sky130_fd_sc_hd__tapvpwrvgnd_1
XFILLER_21_87 vccd1 vssd1 vccd1 vssd1 sky130_ef_sc_hd__decap_40_12
XPHY_EDGE_ROW_6_Left_74 vssd1 vssd1 vccd1 vccd1 sky130_fd_sc_hd__decap_3
XTAP_TAPCELL_ROW_45_458 vssd1 vccd1 sky130_fd_sc_hd__tapvpwrvgnd_1
XFILLER_30_113 vssd1 vssd1 vccd1 vccd1 sky130_fd_sc_hd__fill_8
X_1670_ SB0.route_sel\[89\] vssd1 vssd1 vccd1 vccd1 _1552_ sky130_fd_sc_hd__inv_2
X_2222_ CB_0.config_dataA\[19\] _0823_ _0843_ _0850_ _0855_ vssd1 vssd1 vccd1 vccd1
+ _0856_ sky130_fd_sc_hd__a311oi_2
X_3340_ clknet_leaf_15_clk _0036_ net256 vssd1 vssd1 vccd1 vccd1 LEI0.config_data\[35\]
+ sky130_fd_sc_hd__dfrtp_1
X_3271_ CB_1.config_dataA\[12\] CB_1.config_dataA\[11\] net299 vssd1 vssd1 vccd1 vccd1
+ _0331_ sky130_fd_sc_hd__mux2_1
XFILLER_23_3 vssd1 vssd1 vccd1 vccd1 sky130_fd_sc_hd__fill_1
X_2153_ _0435_ _0784_ _0786_ _0461_ CB_0.config_dataA\[12\] vssd1 vssd1 vccd1 vccd1
+ _0787_ sky130_fd_sc_hd__o221a_1
X_2084_ net142 _0413_ _0653_ vssd1 vssd1 vccd1 vccd1 _0718_ sky130_fd_sc_hd__and3_1
X_2986_ LEI0.config_data\[45\] net417 net305 vssd1 vssd1 vccd1 vccd1 _0046_ sky130_fd_sc_hd__mux2_1
X_1937_ net179 net180 vssd1 vssd1 vccd1 vccd1 _0571_ sky130_fd_sc_hd__nand2b_2
XFILLER_21_146 vssd1 vssd1 vccd1 vccd1 sky130_fd_sc_hd__fill_1
Xinput70 nrst vssd1 vssd1 vccd1 vccd1 net70 sky130_fd_sc_hd__buf_2
X_3607_ clknet_leaf_4_clk _0303_ net233 vssd1 vssd1 vccd1 vccd1 CB_0.config_dataB\[9\]
+ sky130_fd_sc_hd__dfstp_1
X_1799_ SB0.route_sel\[98\] SB0.route_sel\[99\] vssd1 vssd1 vccd1 vccd1 _0433_ sky130_fd_sc_hd__nor2_1
X_1868_ _0471_ net143 _1609_ vssd1 vssd1 vccd1 vccd1 _0502_ sky130_fd_sc_hd__and3b_1
X_3538_ clknet_leaf_0_clk _0234_ net218 vssd1 vssd1 vccd1 vccd1 SB0.route_sel\[93\]
+ sky130_fd_sc_hd__dfstp_1
XFILLER_44_205 vssd1 vssd1 vccd1 vccd1 sky130_fd_sc_hd__fill_4
XFILLER_29_246 vssd1 vssd1 vccd1 vccd1 sky130_fd_sc_hd__fill_8
XFILLER_29_213 vssd1 vssd1 vccd1 vccd1 sky130_fd_sc_hd__fill_1
X_3469_ clknet_leaf_35_clk _0165_ net216 vssd1 vssd1 vccd1 vccd1 SB0.route_sel\[24\]
+ sky130_fd_sc_hd__dfstp_1
XTAP_TAPCELL_ROW_42_439 vssd1 vccd1 sky130_fd_sc_hd__tapvpwrvgnd_1
XFILLER_16_10 vssd1 vssd1 vccd1 vccd1 sky130_fd_sc_hd__fill_2
XFILLER_16_21 vssd1 vssd1 vccd1 vccd1 sky130_fd_sc_hd__fill_4
XFILLER_16_87 vssd1 vssd1 vccd1 vccd1 sky130_fd_sc_hd__fill_1
XTAP_TAPCELL_ROW_50_494 vssd1 vccd1 sky130_fd_sc_hd__tapvpwrvgnd_1
XTAP_TAPCELL_ROW_58_550 vssd1 vccd1 sky130_fd_sc_hd__tapvpwrvgnd_1
XTAP_TAPCELL_ROW_7_194 vssd1 vccd1 sky130_fd_sc_hd__tapvpwrvgnd_1
X_2771_ net236 LE_0B.reset_mode vssd1 vssd1 vccd1 vccd1 _2771_/X sky130_fd_sc_hd__xor2_2
X_2840_ net160 net156 _1100_ vssd1 vssd1 vccd1 vccd1 _1428_ sky130_fd_sc_hd__o21bai_1
Xhold117 LEI0.config_data\[37\] vssd1 vssd1 vccd1 vccd1 net427 sky130_fd_sc_hd__dlygate4sd3_1
Xhold106 LEI0.config_data\[22\] vssd1 vssd1 vccd1 vccd1 net416 sky130_fd_sc_hd__dlygate4sd3_1
X_1722_ net141 vssd1 vssd1 vccd1 vccd1 _1604_ sky130_fd_sc_hd__inv_2
XPHY_EDGE_ROW_9_Right_9 vssd1 vssd1 vccd1 vccd1 sky130_fd_sc_hd__decap_3
X_1653_ SB0.route_sel\[56\] vssd1 vssd1 vccd1 vccd1 _1535_ sky130_fd_sc_hd__inv_2
X_3323_ clknet_leaf_14_clk _0019_ net255 vssd1 vssd1 vccd1 vccd1 LEI0.config_data\[18\]
+ sky130_fd_sc_hd__dfrtp_1
X_2205_ _0626_ _0821_ _0824_ _0645_ vssd1 vssd1 vccd1 vccd1 _0839_ sky130_fd_sc_hd__o2bb2a_1
X_3254_ CB_0.config_dataB\[20\] CB_0.config_dataB\[19\] net300 vssd1 vssd1 vccd1 vccd1
+ _0314_ sky130_fd_sc_hd__mux2_1
X_3185_ SB0.route_sel\[104\] SB0.route_sel\[103\] net274 vssd1 vssd1 vccd1 vccd1 _0245_
+ sky130_fd_sc_hd__mux2_1
XTAP_TAPCELL_ROW_64_597 vssd1 vccd1 sky130_fd_sc_hd__tapvpwrvgnd_1
X_2136_ net196 _0767_ _0768_ _0769_ CB_0.config_dataA\[7\] vssd1 vssd1 vccd1 vccd1
+ _0770_ sky130_fd_sc_hd__a311oi_1
X_2067_ SB0.route_sel\[11\] SB0.route_sel\[10\] _0698_ _0699_ _0700_ vssd1 vssd1 vccd1
+ vccd1 _0701_ sky130_fd_sc_hd__a221oi_1
XFILLER_19_290 vssd1 vssd1 vccd1 vccd1 sky130_fd_sc_hd__fill_4
X_2969_ LEI0.config_data\[28\] LEI0.config_data\[27\] net301 vssd1 vssd1 vccd1 vccd1
+ _0029_ sky130_fd_sc_hd__mux2_1
XFILLER_5_109 vssd1 vssd1 vccd1 vccd1 sky130_fd_sc_hd__fill_2
XTAP_TAPCELL_ROW_55_531 vssd1 vccd1 sky130_fd_sc_hd__tapvpwrvgnd_1
XTAP_TAPCELL_ROW_4_175 vssd1 vccd1 sky130_fd_sc_hd__tapvpwrvgnd_1
XFILLER_25_271 vssd1 vssd1 vccd1 vccd1 sky130_fd_sc_hd__fill_8
XFILLER_4_197 vssd1 vssd1 vccd1 vccd1 sky130_fd_sc_hd__fill_1
XFILLER_48_363 vssd1 vssd1 vccd1 vccd1 sky130_fd_sc_hd__fill_1
XFILLER_31_230 vssd1 vssd1 vccd1 vccd1 sky130_fd_sc_hd__fill_2
X_2823_ net160 net158 _1065_ vssd1 vssd1 vccd1 vccd1 _1419_ sky130_fd_sc_hd__o21bai_1
X_1705_ LE_0B.config_data\[16\] vssd1 vssd1 vccd1 vccd1 _1587_ sky130_fd_sc_hd__inv_2
X_2754_ _1266_ _1267_ _1273_ LE_1B.config_data\[0\] vssd1 vssd1 vccd1 vccd1 _1382_
+ sky130_fd_sc_hd__o211a_1
X_3306_ clknet_leaf_12_clk _0002_ net250 vssd1 vssd1 vccd1 vccd1 LEI0.config_data\[1\]
+ sky130_fd_sc_hd__dfrtp_1
X_2685_ _1312_ vssd1 vssd1 vccd1 vccd1 _1313_ sky130_fd_sc_hd__inv_2
X_1636_ SB0.route_sel\[37\] vssd1 vssd1 vccd1 vccd1 _1518_ sky130_fd_sc_hd__inv_2
X_2119_ net197 _0492_ vssd1 vssd1 vccd1 vccd1 _0753_ sky130_fd_sc_hd__nand2_1
X_3237_ CB_0.config_dataB\[3\] CB_0.config_dataB\[2\] net288 vssd1 vssd1 vccd1 vccd1
+ _0297_ sky130_fd_sc_hd__mux2_1
X_3168_ SB0.route_sel\[87\] SB0.route_sel\[86\] net270 vssd1 vssd1 vccd1 vccd1 _0228_
+ sky130_fd_sc_hd__mux2_1
XTAP_TAPCELL_ROW_1_156 vssd1 vccd1 sky130_fd_sc_hd__tapvpwrvgnd_1
XTAP_TAPCELL_ROW_52_512 vssd1 vccd1 sky130_fd_sc_hd__tapvpwrvgnd_1
X_3099_ SB0.route_sel\[18\] SB0.route_sel\[17\] net262 vssd1 vssd1 vccd1 vccd1 _0159_
+ sky130_fd_sc_hd__mux2_1
XFILLER_14_219 vccd1 vssd1 vccd1 vssd1 sky130_ef_sc_hd__decap_40_12
XFILLER_22_230 vccd1 vssd1 vccd1 vssd1 sky130_ef_sc_hd__decap_40_12
XTAP_TAPCELL_ROW_9_212 vssd1 vccd1 sky130_fd_sc_hd__tapvpwrvgnd_1
XFILLER_45_311 vssd1 vssd1 vccd1 vccd1 sky130_fd_sc_hd__fill_1
Xclkload26 clknet_leaf_15_clk vssd1 vssd1 vccd1 vccd1 clkload26/X sky130_fd_sc_hd__clkbuf_4
Xclkload15 clknet_leaf_8_clk vssd1 vssd1 vccd1 vccd1 clkload15/Y sky130_fd_sc_hd__clkinv_8
XFILLER_54_95 vssd1 vssd1 vccd1 vccd1 sky130_fd_sc_hd__fill_1
X_2470_ _0712_ _1099_ vssd1 vssd1 vccd1 vccd1 _1100_ sky130_fd_sc_hd__nand2_4
X_3022_ net342 LE_0B.config_data\[8\] net290 vssd1 vssd1 vccd1 vccd1 _0082_ sky130_fd_sc_hd__mux2_1
XFILLER_63_163 vssd1 vssd1 vccd1 vccd1 sky130_fd_sc_hd__fill_1
XFILLER_51_369 vssd1 vssd1 vccd1 vccd1 sky130_fd_sc_hd__fill_2
X_2806_ _1410_ net151 _0677_ vssd1 vssd1 vccd1 vccd1 net95 sky130_fd_sc_hd__mux2_1
X_2737_ net203 _1054_ vssd1 vssd1 vccd1 vccd1 _1365_ sky130_fd_sc_hd__nand2_1
X_2668_ CB_1.config_dataB\[7\] _1295_ CB_1.config_dataB\[8\] vssd1 vssd1 vccd1 vccd1
+ _1296_ sky130_fd_sc_hd__a21o_1
Xclkload9 clknet_leaf_33_clk vssd1 vssd1 vccd1 vccd1 clkload9/Y sky130_fd_sc_hd__inv_8
Xfanout257 net258 vssd1 vssd1 vccd1 vccd1 net257 sky130_fd_sc_hd__clkbuf_4
Xfanout235 net70 vssd1 vssd1 vccd1 vccd1 net235 sky130_fd_sc_hd__buf_2
Xfanout202 CB_1.config_dataB\[16\] vssd1 vssd1 vccd1 vccd1 net202 sky130_fd_sc_hd__clkbuf_2
Xfanout246 net247 vssd1 vssd1 vccd1 vccd1 net246 sky130_fd_sc_hd__clkbuf_4
Xfanout279 net283 vssd1 vssd1 vccd1 vccd1 net279 sky130_fd_sc_hd__clkbuf_4
X_1619_ SB0.route_sel\[0\] vssd1 vssd1 vccd1 vccd1 _1501_ sky130_fd_sc_hd__inv_2
Xfanout213 CB_1.config_dataB\[0\] vssd1 vssd1 vccd1 vccd1 net213 sky130_fd_sc_hd__clkbuf_2
Xfanout224 net235 vssd1 vssd1 vccd1 vccd1 net224 sky130_fd_sc_hd__buf_2
Xfanout268 net275 vssd1 vssd1 vccd1 vccd1 net268 sky130_fd_sc_hd__clkbuf_2
X_2599_ _1068_ _1106_ _1112_ LE_1A.config_data\[4\] vssd1 vssd1 vccd1 vccd1 _1229_
+ sky130_fd_sc_hd__o211a_1
XFILLER_54_152 vssd1 vssd1 vccd1 vccd1 sky130_fd_sc_hd__fill_1
XFILLER_39_171 vssd1 vssd1 vccd1 vccd1 sky130_fd_sc_hd__fill_1
XFILLER_24_32 vccd1 vssd1 vccd1 vssd1 sky130_ef_sc_hd__decap_40_12
XTAP_TAPCELL_ROW_12_228 vssd1 vccd1 sky130_fd_sc_hd__tapvpwrvgnd_1
XTAP_TAPCELL_ROW_20_283 vssd1 vccd1 sky130_fd_sc_hd__tapvpwrvgnd_1
X_1970_ net201 _0603_ vssd1 vssd1 vccd1 vccd1 _0604_ sky130_fd_sc_hd__or2_1
XFILLER_53_3 vssd1 vssd1 vccd1 vccd1 sky130_fd_sc_hd__fill_1
X_3571_ clknet_leaf_19_clk _0267_ net248 vssd1 vssd1 vccd1 vccd1 SB0.route_sel\[126\]
+ sky130_fd_sc_hd__dfstp_1
X_3640_ clknet_leaf_22_clk _0336_ net247 vssd1 vssd1 vccd1 vccd1 CB_1.config_dataA\[17\]
+ sky130_fd_sc_hd__dfstp_1
X_2522_ LE_1A.config_data\[14\] LE_1A.config_data\[15\] _1113_ vssd1 vssd1 vccd1 vccd1
+ _1152_ sky130_fd_sc_hd__mux2_1
X_2384_ _1008_ _1009_ _1014_ vssd1 vssd1 vccd1 vccd1 _1016_ sky130_fd_sc_hd__or3b_1
X_2453_ _0641_ _1082_ vssd1 vssd1 vccd1 vccd1 _1083_ sky130_fd_sc_hd__nand2_4
Xinput2 CBeast_in[10] vssd1 vssd1 vccd1 vccd1 net2 sky130_fd_sc_hd__buf_2
X_3005_ net403 net397 net292 vssd1 vssd1 vccd1 vccd1 _0065_ sky130_fd_sc_hd__mux2_1
XFILLER_36_185 vssd1 vssd1 vccd1 vccd1 sky130_fd_sc_hd__fill_2
XFILLER_36_141 vssd1 vssd1 vccd1 vccd1 sky130_fd_sc_hd__fill_1
XTAP_TAPCELL_ROW_34_386 vssd1 vccd1 sky130_fd_sc_hd__tapvpwrvgnd_1
XFILLER_59_211 vssd1 vssd1 vccd1 vccd1 sky130_fd_sc_hd__fill_2
XFILLER_19_32 vssd1 vssd1 vccd1 vccd1 sky130_fd_sc_hd__fill_1
XFILLER_42_122 vssd1 vssd1 vccd1 vccd1 sky130_fd_sc_hd__fill_1
XTAP_TAPCELL_ROW_25_320 vssd1 vccd1 sky130_fd_sc_hd__tapvpwrvgnd_1
XFILLER_2_251 vssd1 vssd1 vccd1 vccd1 sky130_fd_sc_hd__fill_1
XFILLER_33_100 vssd1 vssd1 vccd1 vccd1 sky130_fd_sc_hd__fill_4
X_1953_ net144 _1609_ _0553_ SB0.route_sel\[51\] SB0.route_sel\[50\] vssd1 vssd1 vccd1
+ vccd1 _0587_ sky130_fd_sc_hd__a32o_1
X_1884_ SB0.route_sel\[76\] SB0.route_sel\[77\] net48 vssd1 vssd1 vccd1 vccd1 _0518_
+ sky130_fd_sc_hd__a21boi_1
X_3623_ clknet_leaf_14_clk _0319_ net252 vssd1 vssd1 vccd1 vccd1 CB_1.config_dataA\[0\]
+ sky130_fd_sc_hd__dfstp_1
X_2505_ net1 net8 net9 net10 net174 net173 vssd1 vssd1 vccd1 vccd1 _1135_ sky130_fd_sc_hd__mux4_1
X_3554_ clknet_leaf_20_clk _0250_ net249 vssd1 vssd1 vccd1 vccd1 SB0.route_sel\[109\]
+ sky130_fd_sc_hd__dfstp_1
X_3485_ clknet_leaf_35_clk _0181_ net217 vssd1 vssd1 vccd1 vccd1 SB0.route_sel\[40\]
+ sky130_fd_sc_hd__dfstp_1
X_2367_ _0996_ _0997_ _0998_ vssd1 vssd1 vccd1 vccd1 _0999_ sky130_fd_sc_hd__a21o_1
X_2436_ _1039_ _1062_ _1065_ _1044_ CB_1.config_dataA\[2\] vssd1 vssd1 vccd1 vccd1
+ _1066_ sky130_fd_sc_hd__a221o_1
X_2298_ _1578_ _1579_ _0549_ _0927_ CB_0.config_dataB\[7\] vssd1 vssd1 vccd1 vccd1
+ _0930_ sky130_fd_sc_hd__a311o_1
XPHY_EDGE_ROW_22_Left_90 vssd1 vssd1 vccd1 vccd1 sky130_fd_sc_hd__decap_3
XFILLER_12_306 vssd1 vssd1 vccd1 vccd1 sky130_fd_sc_hd__fill_2
XFILLER_21_55 vssd1 vssd1 vccd1 vccd1 sky130_fd_sc_hd__fill_1
XTAP_TAPCELL_ROW_22_301 vssd1 vccd1 sky130_fd_sc_hd__tapvpwrvgnd_1
XFILLER_21_99 vssd1 vssd1 vccd1 vccd1 sky130_fd_sc_hd__fill_2
XFILLER_46_85 vssd1 vssd1 vccd1 vccd1 sky130_fd_sc_hd__fill_2
XTAP_TAPCELL_ROW_45_459 vssd1 vccd1 sky130_fd_sc_hd__tapvpwrvgnd_1
XFILLER_15_122 vssd1 vssd1 vccd1 vccd1 sky130_fd_sc_hd__fill_4
X_2221_ LEI0.config_data\[37\] _0853_ _0854_ vssd1 vssd1 vccd1 vccd1 _0855_ sky130_fd_sc_hd__o21a_1
X_2152_ net193 net195 vssd1 vssd1 vccd1 vccd1 _0786_ sky130_fd_sc_hd__nand2b_1
X_3270_ net170 net172 net305 vssd1 vssd1 vccd1 vccd1 _0330_ sky130_fd_sc_hd__mux2_1
X_2083_ net138 net161 net156 _0654_ _0414_ vssd1 vssd1 vccd1 vccd1 _0717_ sky130_fd_sc_hd__o32a_1
X_2985_ LEI0.config_data\[44\] net398 net305 vssd1 vssd1 vccd1 vccd1 _0045_ sky130_fd_sc_hd__mux2_1
X_1936_ net179 net180 vssd1 vssd1 vccd1 vccd1 _0570_ sky130_fd_sc_hd__and2b_1
X_1867_ _1604_ net166 net158 _0471_ _1610_ vssd1 vssd1 vccd1 vccd1 _0501_ sky130_fd_sc_hd__o32a_1
X_3606_ clknet_leaf_4_clk _0302_ net229 vssd1 vssd1 vccd1 vccd1 CB_0.config_dataB\[8\]
+ sky130_fd_sc_hd__dfstp_1
X_1798_ _1558_ _0417_ _0421_ _0431_ _1502_ vssd1 vssd1 vccd1 vccd1 _0432_ sky130_fd_sc_hd__o311a_1
X_3468_ clknet_leaf_34_clk _0164_ net215 vssd1 vssd1 vccd1 vccd1 SB0.route_sel\[23\]
+ sky130_fd_sc_hd__dfstp_1
Xinput60 SBwest_in[5] vssd1 vssd1 vccd1 vccd1 net60 sky130_fd_sc_hd__buf_1
X_3537_ clknet_leaf_0_clk _0233_ net218 vssd1 vssd1 vccd1 vccd1 SB0.route_sel\[92\]
+ sky130_fd_sc_hd__dfstp_1
X_2419_ net4 net5 net6 net7 net178 net176 vssd1 vssd1 vccd1 vccd1 _1049_ sky130_fd_sc_hd__mux4_1
XFILLER_44_228 vssd1 vssd1 vccd1 vccd1 sky130_fd_sc_hd__fill_1
X_3399_ clknet_leaf_27_clk _0095_ net236 vssd1 vssd1 vccd1 vccd1 LE_1A.config_data\[0\]
+ sky130_fd_sc_hd__dfrtp_1
XFILLER_16_55 vssd1 vssd1 vccd1 vccd1 sky130_fd_sc_hd__fill_2
XTAP_TAPCELL_ROW_50_495 vssd1 vccd1 sky130_fd_sc_hd__tapvpwrvgnd_1
XFILLER_32_98 vssd1 vssd1 vccd1 vccd1 sky130_fd_sc_hd__fill_8
XFILLER_8_129 vssd1 vssd1 vccd1 vccd1 sky130_fd_sc_hd__fill_2
XTAP_TAPCELL_ROW_7_195 vssd1 vccd1 sky130_fd_sc_hd__tapvpwrvgnd_1
XTAP_TAPCELL_ROW_58_551 vssd1 vccd1 sky130_fd_sc_hd__tapvpwrvgnd_1
X_1721_ net145 vssd1 vssd1 vccd1 vccd1 _1603_ sky130_fd_sc_hd__inv_2
X_2770_ LE_0A.edge_mode net67 vssd1 vssd1 vccd1 vccd1 LE_0A.sel_clk sky130_fd_sc_hd__xnor2_1
Xhold118 LEI0.config_data\[10\] vssd1 vssd1 vccd1 vccd1 net428 sky130_fd_sc_hd__dlygate4sd3_1
X_3322_ clknet_leaf_14_clk _0018_ net251 vssd1 vssd1 vccd1 vccd1 LEI0.config_data\[17\]
+ sky130_fd_sc_hd__dfrtp_1
Xhold107 LEI0.config_data\[44\] vssd1 vssd1 vccd1 vccd1 net417 sky130_fd_sc_hd__dlygate4sd3_1
XFILLER_7_162 vssd1 vssd1 vccd1 vccd1 sky130_fd_sc_hd__fill_2
X_1652_ SB0.route_sel\[57\] vssd1 vssd1 vccd1 vccd1 _1534_ sky130_fd_sc_hd__inv_2
X_2135_ _0733_ _0745_ _0746_ _0715_ vssd1 vssd1 vccd1 vccd1 _0769_ sky130_fd_sc_hd__o22ai_1
X_2204_ net191 _0603_ _0837_ net190 vssd1 vssd1 vccd1 vccd1 _0838_ sky130_fd_sc_hd__o211a_1
X_3253_ CB_0.config_dataB\[19\] CB_0.config_dataB\[18\] net292 vssd1 vssd1 vccd1 vccd1
+ _0313_ sky130_fd_sc_hd__mux2_1
X_3184_ SB0.route_sel\[103\] SB0.route_sel\[102\] net274 vssd1 vssd1 vccd1 vccd1 _0244_
+ sky130_fd_sc_hd__mux2_1
X_2066_ _0441_ _0653_ net142 vssd1 vssd1 vccd1 vccd1 _0700_ sky130_fd_sc_hd__and3b_1
X_2968_ LEI0.config_data\[27\] net429 net301 vssd1 vssd1 vccd1 vccd1 _0028_ sky130_fd_sc_hd__mux2_1
X_1919_ CB_1.config_dataA\[23\] CB_1.config_dataA\[22\] vssd1 vssd1 vccd1 vccd1 _0553_
+ sky130_fd_sc_hd__and2b_1
X_2899_ SB0.route_sel\[27\] _1512_ SB0.route_sel\[28\] _1513_ _1466_ vssd1 vssd1 vccd1
+ vccd1 _1467_ sky130_fd_sc_hd__o221a_1
XTAP_TAPCELL_ROW_55_532 vssd1 vccd1 sky130_fd_sc_hd__tapvpwrvgnd_1
XFILLER_27_98 vccd1 vssd1 vccd1 vssd1 sky130_ef_sc_hd__decap_40_12
XFILLER_25_250 vccd1 vssd1 vccd1 vssd1 sky130_ef_sc_hd__decap_40_12
XTAP_TAPCELL_ROW_4_176 vssd1 vccd1 sky130_fd_sc_hd__tapvpwrvgnd_1
XFILLER_17_206 vssd1 vssd1 vccd1 vccd1 sky130_fd_sc_hd__fill_1
XFILLER_40_253 vssd1 vssd1 vccd1 vccd1 sky130_fd_sc_hd__fill_2
XFILLER_4_36 vssd1 vssd1 vccd1 vccd1 sky130_fd_sc_hd__fill_1
XFILLER_31_253 vssd1 vssd1 vccd1 vccd1 sky130_fd_sc_hd__fill_4
XFILLER_16_250 vssd1 vssd1 vccd1 vccd1 sky130_fd_sc_hd__fill_2
X_1704_ LE_0B.config_data\[12\] vssd1 vssd1 vccd1 vccd1 _1586_ sky130_fd_sc_hd__inv_2
XFILLER_31_275 vssd1 vssd1 vccd1 vccd1 sky130_fd_sc_hd__fill_1
X_2822_ _0501_ _1418_ _0502_ vssd1 vssd1 vccd1 vccd1 net72 sky130_fd_sc_hd__a21oi_1
X_2753_ LE_1B.config_data\[3\] _1274_ _1306_ _1380_ vssd1 vssd1 vccd1 vccd1 _1381_
+ sky130_fd_sc_hd__a211o_1
X_2684_ net207 net205 vssd1 vssd1 vccd1 vccd1 _1312_ sky130_fd_sc_hd__nor2_1
X_3305_ clknet_leaf_27_clk _0001_ net237 vssd1 vssd1 vccd1 vccd1 LEI0.config_data\[0\]
+ sky130_fd_sc_hd__dfrtp_2
X_1635_ SB0.route_sel\[24\] vssd1 vssd1 vccd1 vccd1 _1517_ sky130_fd_sc_hd__inv_2
XFILLER_66_150 vssd1 vssd1 vccd1 vccd1 sky130_fd_sc_hd__fill_1
X_2118_ _0751_ vssd1 vssd1 vccd1 vccd1 _0752_ sky130_fd_sc_hd__inv_2
X_3236_ CB_0.config_dataB\[2\] net187 net288 vssd1 vssd1 vccd1 vccd1 _0296_ sky130_fd_sc_hd__mux2_1
X_3167_ SB0.route_sel\[86\] SB0.route_sel\[85\] net271 vssd1 vssd1 vccd1 vccd1 _0227_
+ sky130_fd_sc_hd__mux2_1
X_3098_ SB0.route_sel\[17\] SB0.route_sel\[16\] net262 vssd1 vssd1 vccd1 vccd1 _0158_
+ sky130_fd_sc_hd__mux2_1
X_2049_ net166 net156 net9 vssd1 vssd1 vccd1 vccd1 _0683_ sky130_fd_sc_hd__o21ai_1
XTAP_TAPCELL_ROW_52_513 vssd1 vccd1 sky130_fd_sc_hd__tapvpwrvgnd_1
XFILLER_22_242 vssd1 vssd1 vccd1 vccd1 sky130_fd_sc_hd__fill_8
XFILLER_22_253 vssd1 vssd1 vccd1 vccd1 sky130_fd_sc_hd__fill_4
XFILLER_1_113 vssd1 vssd1 vccd1 vccd1 sky130_fd_sc_hd__fill_1
XFILLER_49_117 vssd1 vssd1 vccd1 vccd1 sky130_fd_sc_hd__fill_2
XFILLER_57_194 vssd1 vssd1 vccd1 vccd1 sky130_fd_sc_hd__fill_2
XFILLER_45_345 vssd1 vssd1 vccd1 vccd1 sky130_fd_sc_hd__fill_2
XTAP_TAPCELL_ROW_15_248 vssd1 vccd1 sky130_fd_sc_hd__tapvpwrvgnd_1
Xclkload27 clknet_leaf_16_clk vssd1 vssd1 vccd1 vccd1 clkload27/Y sky130_fd_sc_hd__inv_8
Xclkload16 clknet_leaf_21_clk vssd1 vssd1 vccd1 vccd1 clkload16/Y sky130_fd_sc_hd__clkinv_8
XFILLER_9_202 vccd1 vssd1 vccd1 vssd1 sky130_ef_sc_hd__decap_40_12
XFILLER_55_7 vssd1 vssd1 vccd1 vccd1 sky130_fd_sc_hd__fill_2
XTAP_TAPCELL_ROW_66_605 vssd1 vccd1 sky130_fd_sc_hd__tapvpwrvgnd_1
X_3021_ net368 LE_0B.config_data\[7\] net290 vssd1 vssd1 vccd1 vccd1 _0081_ sky130_fd_sc_hd__mux2_1
XFILLER_48_150 vssd1 vssd1 vccd1 vccd1 sky130_fd_sc_hd__fill_2
X_2805_ _0678_ _0695_ _0680_ vssd1 vssd1 vccd1 vccd1 _1410_ sky130_fd_sc_hd__a21oi_1
X_2736_ _1362_ _1363_ _1599_ vssd1 vssd1 vccd1 vccd1 _1364_ sky130_fd_sc_hd__mux2_1
X_1618_ SB0.route_sel\[1\] vssd1 vssd1 vccd1 vccd1 _1500_ sky130_fd_sc_hd__inv_2
X_2667_ net11 net12 net13 net14 net209 net208 vssd1 vssd1 vccd1 vccd1 _1295_ sky130_fd_sc_hd__mux4_1
X_3219_ net194 CB_0.config_dataA\[9\] net295 vssd1 vssd1 vccd1 vccd1 _0279_ sky130_fd_sc_hd__mux2_1
Xfanout258 net260 vssd1 vssd1 vccd1 vccd1 net258 sky130_fd_sc_hd__clkbuf_4
Xfanout203 CB_1.config_dataB\[15\] vssd1 vssd1 vccd1 vccd1 net203 sky130_fd_sc_hd__buf_2
Xfanout225 net235 vssd1 vssd1 vccd1 vccd1 net225 sky130_fd_sc_hd__clkbuf_4
Xfanout247 net70 vssd1 vssd1 vccd1 vccd1 net247 sky130_fd_sc_hd__buf_2
Xfanout269 net272 vssd1 vssd1 vccd1 vccd1 net269 sky130_fd_sc_hd__clkbuf_4
X_2598_ LE_1A.config_data\[6\] LE_1A.config_data\[7\] _1113_ vssd1 vssd1 vccd1 vccd1
+ _1228_ sky130_fd_sc_hd__mux2_1
Xfanout236 net239 vssd1 vssd1 vccd1 vccd1 net236 sky130_fd_sc_hd__clkbuf_4
Xfanout214 net215 vssd1 vssd1 vccd1 vccd1 net214 sky130_fd_sc_hd__clkbuf_4
XFILLER_42_304 vssd1 vssd1 vccd1 vccd1 sky130_fd_sc_hd__fill_4
XFILLER_24_22 vssd1 vssd1 vccd1 vccd1 sky130_fd_sc_hd__fill_2
XFILLER_40_54 vssd1 vssd1 vccd1 vccd1 sky130_fd_sc_hd__fill_2
XFILLER_24_44 vssd1 vssd1 vccd1 vccd1 sky130_fd_sc_hd__fill_1
XTAP_TAPCELL_ROW_12_229 vssd1 vccd1 sky130_fd_sc_hd__tapvpwrvgnd_1
XTAP_TAPCELL_ROW_20_284 vssd1 vccd1 sky130_fd_sc_hd__tapvpwrvgnd_1
XFILLER_45_153 vssd1 vssd1 vccd1 vccd1 sky130_fd_sc_hd__fill_4
XFILLER_37_109 vssd1 vssd1 vccd1 vccd1 sky130_fd_sc_hd__fill_2
XTAP_TAPCELL_ROW_28_340 vssd1 vccd1 sky130_fd_sc_hd__tapvpwrvgnd_1
XFILLER_1_59 vssd1 vssd1 vccd1 vccd1 sky130_fd_sc_hd__fill_1
XFILLER_60_112 vssd1 vssd1 vccd1 vccd1 sky130_fd_sc_hd__fill_2
XFILLER_33_348 vssd1 vssd1 vccd1 vccd1 sky130_fd_sc_hd__fill_1
XFILLER_33_304 vssd1 vssd1 vccd1 vccd1 sky130_fd_sc_hd__fill_1
X_2521_ CB_1.config_dataA\[9\] _1130_ _1143_ _1149_ vssd1 vssd1 vccd1 vccd1 _1151_
+ sky130_fd_sc_hd__o31ai_4
X_3570_ clknet_leaf_19_clk _0266_ net248 vssd1 vssd1 vccd1 vccd1 SB0.route_sel\[125\]
+ sky130_fd_sc_hd__dfstp_1
X_2383_ _1008_ _1009_ _1014_ vssd1 vssd1 vccd1 vccd1 _1015_ sky130_fd_sc_hd__nor3b_1
X_2452_ _1522_ SB0.route_sel\[46\] SB0.route_sel\[41\] _1524_ _1081_ vssd1 vssd1 vccd1
+ vccd1 _1082_ sky130_fd_sc_hd__a221o_1
XPHY_EDGE_ROW_18_Right_18 vssd1 vssd1 vccd1 vccd1 sky130_fd_sc_hd__decap_3
Xinput3 CBeast_in[11] vssd1 vssd1 vccd1 vccd1 net3 sky130_fd_sc_hd__buf_2
X_3004_ net397 net384 net292 vssd1 vssd1 vccd1 vccd1 _0064_ sky130_fd_sc_hd__mux2_1
XFILLER_51_145 vssd1 vssd1 vccd1 vccd1 sky130_fd_sc_hd__fill_1
XFILLER_36_175 vssd1 vssd1 vccd1 vccd1 sky130_fd_sc_hd__fill_1
XPHY_EDGE_ROW_27_Right_27 vssd1 vssd1 vccd1 vccd1 sky130_fd_sc_hd__decap_3
XFILLER_51_156 vssd1 vssd1 vccd1 vccd1 sky130_fd_sc_hd__fill_1
XTAP_TAPCELL_ROW_34_387 vssd1 vccd1 sky130_fd_sc_hd__tapvpwrvgnd_1
XPHY_EDGE_ROW_36_Right_36 vssd1 vssd1 vccd1 vccd1 sky130_fd_sc_hd__decap_3
X_2719_ net202 net203 vssd1 vssd1 vccd1 vccd1 _1347_ sky130_fd_sc_hd__nand2b_1
XPHY_EDGE_ROW_45_Right_45 vssd1 vssd1 vccd1 vccd1 sky130_fd_sc_hd__decap_3
XFILLER_30_307 vssd1 vssd1 vccd1 vccd1 sky130_fd_sc_hd__fill_1
XTAP_TAPCELL_ROW_25_321 vssd1 vccd1 sky130_fd_sc_hd__tapvpwrvgnd_1
XPHY_EDGE_ROW_54_Right_54 vssd1 vssd1 vccd1 vccd1 sky130_fd_sc_hd__decap_3
XPHY_EDGE_ROW_63_Right_63 vssd1 vssd1 vccd1 vccd1 sky130_fd_sc_hd__decap_3
XTAP_TAPCELL_ROW_48_479 vssd1 vccd1 sky130_fd_sc_hd__tapvpwrvgnd_1
X_3622_ clknet_leaf_12_clk _0318_ net252 vssd1 vssd1 vccd1 vccd1 CB_0.config_dataB\[24\]
+ sky130_fd_sc_hd__dfstp_1
X_1883_ SB0.route_sel\[75\] SB0.route_sel\[74\] _0514_ _0515_ _0516_ vssd1 vssd1 vccd1
+ vccd1 _0517_ sky130_fd_sc_hd__a221oi_1
X_1952_ net141 net166 net157 vssd1 vssd1 vccd1 vccd1 _0586_ sky130_fd_sc_hd__or3_1
X_2504_ net173 _1131_ _1132_ _1133_ vssd1 vssd1 vccd1 vccd1 _1134_ sky130_fd_sc_hd__a31o_1
X_3553_ clknet_leaf_20_clk _0249_ net240 vssd1 vssd1 vccd1 vccd1 SB0.route_sel\[108\]
+ sky130_fd_sc_hd__dfstp_1
X_2435_ _0528_ _1064_ vssd1 vssd1 vccd1 vccd1 _1065_ sky130_fd_sc_hd__nand2_4
X_3484_ clknet_leaf_35_clk _0180_ net214 vssd1 vssd1 vccd1 vccd1 SB0.route_sel\[39\]
+ sky130_fd_sc_hd__dfstp_1
X_2366_ net31 net32 net18 net19 net181 CB_0.config_dataB\[16\] vssd1 vssd1 vccd1 vccd1
+ _0998_ sky130_fd_sc_hd__mux4_1
X_2297_ _0928_ vssd1 vssd1 vccd1 vccd1 _0929_ sky130_fd_sc_hd__inv_2
XFILLER_24_145 vssd1 vssd1 vccd1 vccd1 sky130_fd_sc_hd__fill_1
XTAP_TAPCELL_ROW_22_302 vssd1 vccd1 sky130_fd_sc_hd__tapvpwrvgnd_1
XFILLER_47_204 vssd1 vssd1 vccd1 vccd1 sky130_fd_sc_hd__fill_4
XFILLER_46_97 vssd1 vssd1 vccd1 vccd1 sky130_fd_sc_hd__fill_1
XFILLER_15_178 vssd1 vssd1 vccd1 vccd1 sky130_fd_sc_hd__fill_2
X_2151_ net193 net195 vssd1 vssd1 vccd1 vccd1 _0785_ sky130_fd_sc_hd__and2b_1
X_2220_ LEI0.config_data\[38\] _0852_ vssd1 vssd1 vccd1 vccd1 _0854_ sky130_fd_sc_hd__nor2_1
X_2082_ net161 _0651_ net1 vssd1 vssd1 vccd1 vccd1 _0716_ sky130_fd_sc_hd__o21ai_1
X_2984_ net398 LEI0.config_data\[42\] net305 vssd1 vssd1 vccd1 vccd1 _0044_ sky130_fd_sc_hd__mux2_1
X_1935_ _0387_ _0567_ vssd1 vssd1 vccd1 vccd1 _0569_ sky130_fd_sc_hd__nand2_1
X_3605_ clknet_leaf_4_clk _0301_ net229 vssd1 vssd1 vccd1 vccd1 CB_0.config_dataB\[7\]
+ sky130_fd_sc_hd__dfstp_1
X_1797_ _0428_ _0429_ _0430_ vssd1 vssd1 vccd1 vccd1 _0431_ sky130_fd_sc_hd__a21o_1
X_1866_ net166 net158 net2 vssd1 vssd1 vccd1 vccd1 _0500_ sky130_fd_sc_hd__o21ai_1
Xinput50 SBwest_in[10] vssd1 vssd1 vccd1 vccd1 net50 sky130_fd_sc_hd__clkbuf_1
Xinput61 SBwest_in[6] vssd1 vssd1 vccd1 vccd1 net61 sky130_fd_sc_hd__buf_1
X_2418_ net15 net16 net2 net3 net178 net176 vssd1 vssd1 vccd1 vccd1 _1048_ sky130_fd_sc_hd__mux4_1
X_3398_ LE_1B.sel_clk _0094_ net69 vssd1 vssd1 vccd1 vccd1 LE_1B.dff1_out sky130_fd_sc_hd__dfstp_1
X_3467_ clknet_leaf_34_clk _0163_ net214 vssd1 vssd1 vccd1 vccd1 SB0.route_sel\[22\]
+ sky130_fd_sc_hd__dfstp_1
X_3536_ clknet_leaf_0_clk _0232_ net218 vssd1 vssd1 vccd1 vccd1 SB0.route_sel\[91\]
+ sky130_fd_sc_hd__dfstp_2
X_2349_ LE_0B.config_data\[7\] _0905_ _0938_ _0980_ vssd1 vssd1 vccd1 vccd1 _0981_
+ sky130_fd_sc_hd__a211o_1
XPHY_EDGE_ROW_0_Right_0 vssd1 vssd1 vccd1 vccd1 sky130_fd_sc_hd__decap_3
XFILLER_16_78 vssd1 vssd1 vccd1 vccd1 sky130_fd_sc_hd__fill_1
XTAP_TAPCELL_ROW_50_496 vssd1 vccd1 sky130_fd_sc_hd__tapvpwrvgnd_1
XTAP_TAPCELL_ROW_7_196 vssd1 vccd1 sky130_fd_sc_hd__tapvpwrvgnd_1
XTAP_TAPCELL_ROW_58_552 vssd1 vccd1 sky130_fd_sc_hd__tapvpwrvgnd_1
Xhold108 LEI0.config_data\[8\] vssd1 vssd1 vccd1 vccd1 net418 sky130_fd_sc_hd__dlygate4sd3_1
X_1720_ net151 vssd1 vssd1 vccd1 vccd1 _1602_ sky130_fd_sc_hd__inv_2
XTAP_TAPCELL_ROW_41_430 vssd1 vccd1 sky130_fd_sc_hd__tapvpwrvgnd_1
X_1651_ SB0.route_sel\[62\] vssd1 vssd1 vccd1 vccd1 _1533_ sky130_fd_sc_hd__inv_2
Xhold119 LEI0.config_data\[26\] vssd1 vssd1 vccd1 vccd1 net429 sky130_fd_sc_hd__dlygate4sd3_1
X_3321_ clknet_leaf_14_clk net373 net251 vssd1 vssd1 vccd1 vccd1 LEI0.config_data\[16\]
+ sky130_fd_sc_hd__dfrtp_1
X_3252_ CB_0.config_dataB\[18\] CB_0.config_dataB\[17\] net292 vssd1 vssd1 vccd1 vccd1
+ _0312_ sky130_fd_sc_hd__mux2_1
X_2134_ net197 _0695_ vssd1 vssd1 vccd1 vccd1 _0768_ sky130_fd_sc_hd__or2_1
X_2203_ net191 _0581_ vssd1 vssd1 vccd1 vccd1 _0837_ sky130_fd_sc_hd__nand2_1
X_3183_ SB0.route_sel\[102\] SB0.route_sel\[101\] net274 vssd1 vssd1 vccd1 vccd1 _0243_
+ sky130_fd_sc_hd__mux2_1
X_2065_ net138 net160 net156 _0654_ _0441_ vssd1 vssd1 vccd1 vccd1 _0699_ sky130_fd_sc_hd__o32a_1
X_2967_ LEI0.config_data\[26\] net393 net301 vssd1 vssd1 vccd1 vccd1 _0027_ sky130_fd_sc_hd__mux2_1
X_1918_ _0513_ _0550_ _0551_ _1495_ _1494_ vssd1 vssd1 vccd1 vccd1 _0552_ sky130_fd_sc_hd__a221oi_1
X_1849_ net180 net179 vssd1 vssd1 vccd1 vccd1 _0483_ sky130_fd_sc_hd__nand2b_2
X_2898_ SB0.route_sel\[25\] SB0.route_sel\[24\] vssd1 vssd1 vccd1 vccd1 _1466_ sky130_fd_sc_hd__or2_1
X_3519_ clknet_leaf_2_clk _0215_ net225 vssd1 vssd1 vccd1 vccd1 SB0.route_sel\[74\]
+ sky130_fd_sc_hd__dfstp_1
XTAP_TAPCELL_ROW_55_533 vssd1 vccd1 sky130_fd_sc_hd__tapvpwrvgnd_1
XFILLER_43_32 vssd1 vssd1 vccd1 vccd1 sky130_fd_sc_hd__fill_4
XFILLER_25_262 vssd1 vssd1 vccd1 vccd1 sky130_fd_sc_hd__fill_4
XTAP_TAPCELL_ROW_4_177 vssd1 vccd1 sky130_fd_sc_hd__tapvpwrvgnd_1
XFILLER_13_402 vssd1 vssd1 vccd1 vccd1 sky130_fd_sc_hd__fill_1
XFILLER_43_87 vssd1 vssd1 vccd1 vccd1 sky130_fd_sc_hd__fill_2
Xclkbuf_leaf_20_clk clknet_2_3__leaf_clk vssd1 vssd1 vccd1 vccd1 clknet_leaf_20_clk
+ sky130_fd_sc_hd__clkbuf_8
X_2821_ _1606_ net158 _1058_ vssd1 vssd1 vccd1 vccd1 _1418_ sky130_fd_sc_hd__o21bai_1
XFILLER_16_262 vssd1 vssd1 vccd1 vccd1 sky130_fd_sc_hd__fill_4
X_1703_ CB_0.config_dataB\[19\] vssd1 vssd1 vccd1 vccd1 _1585_ sky130_fd_sc_hd__inv_2
Xclkbuf_leaf_11_clk clknet_2_3__leaf_clk vssd1 vssd1 vccd1 vccd1 clknet_leaf_11_clk
+ sky130_fd_sc_hd__clkbuf_8
X_2683_ net205 net206 vssd1 vssd1 vccd1 vccd1 _1311_ sky130_fd_sc_hd__nand2b_1
X_2752_ _1266_ _1267_ _1273_ LE_1B.config_data\[2\] vssd1 vssd1 vccd1 vccd1 _1380_
+ sky130_fd_sc_hd__o211a_1
X_1634_ SB0.route_sel\[25\] vssd1 vssd1 vccd1 vccd1 _1516_ sky130_fd_sc_hd__inv_2
X_3235_ net187 net188 net288 vssd1 vssd1 vccd1 vccd1 _0295_ sky130_fd_sc_hd__mux2_1
X_3304_ LE_0A.sel_clk _0000_ net69 vssd1 vssd1 vccd1 vccd1 LE_0A.dff1_out sky130_fd_sc_hd__dfstp_1
X_2117_ _0749_ _0750_ CB_0.config_dataA\[7\] vssd1 vssd1 vccd1 vccd1 _0751_ sky130_fd_sc_hd__mux2_1
X_2048_ _0677_ _0679_ _0680_ _0681_ _0676_ vssd1 vssd1 vccd1 vccd1 _0682_ sky130_fd_sc_hd__o311a_1
XFILLER_39_387 vssd1 vssd1 vccd1 vccd1 sky130_fd_sc_hd__fill_1
XFILLER_39_354 vssd1 vssd1 vccd1 vccd1 sky130_fd_sc_hd__fill_4
X_3166_ SB0.route_sel\[85\] SB0.route_sel\[84\] net271 vssd1 vssd1 vccd1 vccd1 _0226_
+ sky130_fd_sc_hd__mux2_1
X_3097_ SB0.route_sel\[16\] SB0.route_sel\[15\] net261 vssd1 vssd1 vccd1 vccd1 _0157_
+ sky130_fd_sc_hd__mux2_1
XFILLER_22_276 vssd1 vssd1 vccd1 vccd1 sky130_fd_sc_hd__fill_2
XFILLER_38_43 vssd1 vssd1 vccd1 vccd1 sky130_fd_sc_hd__fill_1
XFILLER_9_214 vssd1 vssd1 vccd1 vccd1 sky130_fd_sc_hd__fill_4
XTAP_TAPCELL_ROW_15_249 vssd1 vccd1 sky130_fd_sc_hd__tapvpwrvgnd_1
Xclkload28 clknet_leaf_17_clk vssd1 vssd1 vccd1 vccd1 clkload28/Y sky130_fd_sc_hd__clkinv_8
XPHY_EDGE_ROW_41_Left_109 vssd1 vssd1 vccd1 vccd1 sky130_fd_sc_hd__decap_3
Xclkload17 clknet_leaf_22_clk vssd1 vssd1 vccd1 vccd1 clkload17/Y sky130_fd_sc_hd__clkinv_8
XPHY_EDGE_ROW_50_Left_118 vssd1 vssd1 vccd1 vccd1 sky130_fd_sc_hd__decap_3
XTAP_TAPCELL_ROW_66_606 vssd1 vccd1 sky130_fd_sc_hd__tapvpwrvgnd_1
X_3020_ net411 net407 net290 vssd1 vssd1 vccd1 vccd1 _0080_ sky130_fd_sc_hd__mux2_1
Xclkbuf_leaf_0_clk clknet_2_0__leaf_clk vssd1 vssd1 vccd1 vccd1 clknet_leaf_0_clk
+ sky130_fd_sc_hd__clkbuf_8
X_2804_ net151 _1409_ _0664_ vssd1 vssd1 vccd1 vccd1 net96 sky130_fd_sc_hd__mux2_1
Xfanout204 CB_1.config_dataB\[15\] vssd1 vssd1 vccd1 vccd1 net204 sky130_fd_sc_hd__clkbuf_2
X_2735_ net15 net16 net2 net3 net203 CB_1.config_dataB\[16\] vssd1 vssd1 vccd1 vccd1
+ _1363_ sky130_fd_sc_hd__mux4_1
X_2666_ net1 net8 net9 net10 net209 net208 vssd1 vssd1 vccd1 vccd1 _1294_ sky130_fd_sc_hd__mux4_1
X_1617_ SB0.route_sel\[6\] vssd1 vssd1 vccd1 vccd1 _1499_ sky130_fd_sc_hd__inv_2
X_2597_ _1186_ _1224_ _1226_ _1221_ vssd1 vssd1 vccd1 vccd1 _1227_ sky130_fd_sc_hd__a31o_1
X_3218_ CB_0.config_dataA\[9\] CB_0.config_dataA\[8\] net295 vssd1 vssd1 vccd1 vccd1
+ _0278_ sky130_fd_sc_hd__mux2_1
Xfanout248 net249 vssd1 vssd1 vccd1 vccd1 net248 sky130_fd_sc_hd__clkbuf_4
Xfanout259 net260 vssd1 vssd1 vccd1 vccd1 net259 sky130_fd_sc_hd__clkbuf_4
Xfanout226 net235 vssd1 vssd1 vccd1 vccd1 net226 sky130_fd_sc_hd__clkbuf_4
Xfanout237 net239 vssd1 vssd1 vccd1 vccd1 net237 sky130_fd_sc_hd__clkbuf_4
Xfanout215 net221 vssd1 vssd1 vccd1 vccd1 net215 sky130_fd_sc_hd__clkbuf_4
X_3149_ SB0.route_sel\[68\] SB0.route_sel\[67\] net273 vssd1 vssd1 vccd1 vccd1 _0209_
+ sky130_fd_sc_hd__mux2_1
XTAP_TAPCELL_ROW_20_285 vssd1 vccd1 sky130_fd_sc_hd__tapvpwrvgnd_1
XTAP_TAPCELL_ROW_28_341 vssd1 vccd1 sky130_fd_sc_hd__tapvpwrvgnd_1
X_2520_ CB_1.config_dataA\[9\] _1130_ _1143_ _1149_ vssd1 vssd1 vccd1 vccd1 _1150_
+ sky130_fd_sc_hd__o31a_2
X_2451_ SB0.route_sel\[44\] SB0.route_sel\[45\] vssd1 vssd1 vccd1 vccd1 _1081_ sky130_fd_sc_hd__nor2_1
X_2382_ LEI0.config_data\[41\] _1011_ _1013_ vssd1 vssd1 vccd1 vccd1 _1014_ sky130_fd_sc_hd__or3_2
Xinput4 CBeast_in[12] vssd1 vssd1 vccd1 vccd1 net4 sky130_fd_sc_hd__buf_2
X_3003_ net384 net379 net292 vssd1 vssd1 vccd1 vccd1 _0063_ sky130_fd_sc_hd__mux2_1
Xclkbuf_2_1__f_clk clknet_0_clk vssd1 vssd1 vccd1 vccd1 clknet_2_1__leaf_clk sky130_fd_sc_hd__clkbuf_16
XFILLER_51_113 vssd1 vssd1 vccd1 vccd1 sky130_fd_sc_hd__fill_4
X_2718_ net202 net203 vssd1 vssd1 vccd1 vccd1 _1346_ sky130_fd_sc_hd__and2b_1
X_2649_ net210 net208 vssd1 vssd1 vccd1 vccd1 _1277_ sky130_fd_sc_hd__nor2_1
XFILLER_67_290 vssd1 vssd1 vccd1 vccd1 sky130_fd_sc_hd__fill_1
XFILLER_27_110 vssd1 vssd1 vccd1 vccd1 sky130_fd_sc_hd__fill_2
XFILLER_19_78 vssd1 vssd1 vccd1 vccd1 sky130_fd_sc_hd__fill_1
XFILLER_42_179 vssd1 vssd1 vccd1 vccd1 sky130_fd_sc_hd__fill_8
XFILLER_30_319 vssd1 vssd1 vccd1 vccd1 sky130_fd_sc_hd__fill_8
XTAP_TAPCELL_ROW_25_322 vssd1 vccd1 sky130_fd_sc_hd__tapvpwrvgnd_1
XFILLER_33_113 vssd1 vssd1 vccd1 vccd1 sky130_fd_sc_hd__fill_2
X_3621_ clknet_leaf_12_clk _0317_ net252 vssd1 vssd1 vccd1 vccd1 CB_0.config_dataB\[23\]
+ sky130_fd_sc_hd__dfstp_1
X_3552_ clknet_leaf_29_clk _0248_ net240 vssd1 vssd1 vccd1 vccd1 SB0.route_sel\[107\]
+ sky130_fd_sc_hd__dfstp_1
X_1882_ net144 _0441_ _0471_ vssd1 vssd1 vccd1 vccd1 _0516_ sky130_fd_sc_hd__nor3_1
X_1951_ net166 net157 net13 vssd1 vssd1 vccd1 vccd1 _0585_ sky130_fd_sc_hd__o21bai_1
X_2365_ _0531_ _0984_ _0986_ _0549_ vssd1 vssd1 vccd1 vccd1 _0997_ sky130_fd_sc_hd__a22oi_1
X_2503_ _1083_ _1116_ _1118_ _1079_ _1589_ vssd1 vssd1 vccd1 vccd1 _1133_ sky130_fd_sc_hd__a221o_1
X_2434_ SB0.route_sel\[73\] _1546_ _1063_ vssd1 vssd1 vccd1 vccd1 _1064_ sky130_fd_sc_hd__a21bo_1
X_3483_ clknet_leaf_35_clk _0179_ net214 vssd1 vssd1 vccd1 vccd1 SB0.route_sel\[38\]
+ sky130_fd_sc_hd__dfstp_1
X_2296_ net31 net32 net18 net19 CB_0.config_dataB\[5\] CB_0.config_dataB\[6\] vssd1
+ vssd1 vccd1 vccd1 _0928_ sky130_fd_sc_hd__mux4_1
XANTENNA_20 CBnorth_in[3] vssd1 vssd1 vccd1 vccd1 sky130_fd_sc_hd__diode_2
XFILLER_24_157 vssd1 vssd1 vccd1 vccd1 sky130_fd_sc_hd__fill_4
XTAP_TAPCELL_ROW_22_303 vssd1 vccd1 sky130_fd_sc_hd__tapvpwrvgnd_1
XFILLER_21_24 vssd1 vssd1 vccd1 vccd1 sky130_fd_sc_hd__fill_4
X_2150_ net195 net193 vssd1 vssd1 vccd1 vccd1 _0784_ sky130_fd_sc_hd__or2_1
X_2081_ _0712_ _0714_ vssd1 vssd1 vccd1 vccd1 _0715_ sky130_fd_sc_hd__and2_4
X_2983_ LEI0.config_data\[42\] net381 net308 vssd1 vssd1 vccd1 vccd1 _0043_ sky130_fd_sc_hd__mux2_1
X_1934_ CB_0.config_dataA\[23\] CB_0.config_dataA\[22\] vssd1 vssd1 vccd1 vccd1 _0568_
+ sky130_fd_sc_hd__nand2b_1
X_1865_ _0494_ _0496_ _0497_ _0498_ _0493_ vssd1 vssd1 vccd1 vccd1 _0499_ sky130_fd_sc_hd__o311a_1
X_1796_ net155 _0372_ _0422_ SB0.route_sel\[97\] SB0.route_sel\[96\] vssd1 vssd1 vccd1
+ vccd1 _0430_ sky130_fd_sc_hd__a32o_1
X_3604_ clknet_leaf_4_clk _0300_ net229 vssd1 vssd1 vccd1 vccd1 CB_0.config_dataB\[6\]
+ sky130_fd_sc_hd__dfstp_2
Xinput51 SBwest_in[11] vssd1 vssd1 vccd1 vccd1 net51 sky130_fd_sc_hd__clkbuf_1
Xinput40 SBsouth_in[1] vssd1 vssd1 vccd1 vccd1 net40 sky130_fd_sc_hd__buf_1
Xinput62 SBwest_in[7] vssd1 vssd1 vccd1 vccd1 net62 sky130_fd_sc_hd__buf_1
X_3535_ clknet_leaf_0_clk _0231_ net218 vssd1 vssd1 vccd1 vccd1 SB0.route_sel\[90\]
+ sky130_fd_sc_hd__dfstp_2
X_2348_ _0897_ _0898_ _0904_ LE_0B.config_data\[6\] vssd1 vssd1 vccd1 vccd1 _0980_
+ sky130_fd_sc_hd__o211a_1
X_2417_ net176 _1031_ _1035_ _1046_ vssd1 vssd1 vccd1 vccd1 _1047_ sky130_fd_sc_hd__a31o_1
X_3397_ LE_1A.sel_clk _0093_ net69 vssd1 vssd1 vccd1 vccd1 LE_1A.dff0_out sky130_fd_sc_hd__dfrtp_1
X_3466_ clknet_leaf_35_clk _0162_ net214 vssd1 vssd1 vccd1 vccd1 SB0.route_sel\[21\]
+ sky130_fd_sc_hd__dfstp_1
X_2279_ net291 _0621_ _0625_ _1578_ _1579_ vssd1 vssd1 vccd1 vccd1 _0911_ sky130_fd_sc_hd__o311ai_1
XTAP_TAPCELL_ROW_50_497 vssd1 vccd1 sky130_fd_sc_hd__tapvpwrvgnd_1
XFILLER_32_23 vssd1 vssd1 vccd1 vccd1 sky130_fd_sc_hd__fill_4
XFILLER_20_160 vssd1 vssd1 vccd1 vccd1 sky130_fd_sc_hd__fill_1
XFILLER_20_182 vccd1 vssd1 vccd1 vssd1 sky130_ef_sc_hd__decap_40_12
XTAP_TAPCELL_ROW_58_553 vssd1 vccd1 sky130_fd_sc_hd__tapvpwrvgnd_1
XTAP_TAPCELL_ROW_7_197 vssd1 vccd1 sky130_fd_sc_hd__tapvpwrvgnd_1
XTAP_TAPCELL_ROW_41_431 vssd1 vccd1 sky130_fd_sc_hd__tapvpwrvgnd_1
Xhold109 _0009_ vssd1 vssd1 vccd1 vccd1 net419 sky130_fd_sc_hd__dlygate4sd3_1
XFILLER_11_182 vssd1 vssd1 vccd1 vccd1 sky130_fd_sc_hd__fill_4
X_1650_ SB0.route_sel\[61\] vssd1 vssd1 vccd1 vccd1 _1532_ sky130_fd_sc_hd__inv_2
X_3320_ clknet_leaf_14_clk net340 net251 vssd1 vssd1 vccd1 vccd1 LEI0.config_data\[15\]
+ sky130_fd_sc_hd__dfrtp_1
X_2202_ _0829_ _0833_ _0835_ CB_0.config_dataA\[18\] vssd1 vssd1 vccd1 vccd1 _0836_
+ sky130_fd_sc_hd__or4b_1
X_3251_ CB_0.config_dataB\[17\] CB_0.config_dataB\[16\] net292 vssd1 vssd1 vccd1 vccd1
+ _0311_ sky130_fd_sc_hd__mux2_1
X_3182_ SB0.route_sel\[101\] SB0.route_sel\[100\] net274 vssd1 vssd1 vccd1 vccd1 _0242_
+ sky130_fd_sc_hd__mux2_1
X_2133_ net197 _0675_ vssd1 vssd1 vccd1 vccd1 _0767_ sky130_fd_sc_hd__nand2_1
XFILLER_26_208 vssd1 vssd1 vccd1 vccd1 sky130_fd_sc_hd__fill_2
X_2064_ net160 _0651_ net8 vssd1 vssd1 vccd1 vccd1 _0698_ sky130_fd_sc_hd__o21ai_1
X_2966_ net393 LEI0.config_data\[24\] net301 vssd1 vssd1 vccd1 vccd1 _0026_ sky130_fd_sc_hd__mux2_1
X_1917_ net31 net32 net18 net19 net200 CB_0.config_dataA\[1\] vssd1 vssd1 vccd1 vccd1
+ _0551_ sky130_fd_sc_hd__mux4_1
X_2897_ _1465_ _0622_ vssd1 vssd1 vccd1 vccd1 net113 sky130_fd_sc_hd__and2b_1
X_1848_ net180 net179 vssd1 vssd1 vccd1 vccd1 _0482_ sky130_fd_sc_hd__and2b_1
X_1779_ CB_1.config_dataA\[24\] CB_1.config_dataA\[21\] CB_1.config_dataA\[20\] vssd1
+ vssd1 vccd1 vccd1 _0413_ sky130_fd_sc_hd__nor3_1
X_3518_ clknet_leaf_0_clk _0214_ net220 vssd1 vssd1 vccd1 vccd1 SB0.route_sel\[73\]
+ sky130_fd_sc_hd__dfstp_2
X_3449_ clknet_leaf_31_clk _0145_ net223 vssd1 vssd1 vccd1 vccd1 SB0.route_sel\[4\]
+ sky130_fd_sc_hd__dfstp_1
XTAP_TAPCELL_ROW_55_534 vssd1 vccd1 sky130_fd_sc_hd__tapvpwrvgnd_1
XFILLER_43_55 vssd1 vssd1 vccd1 vccd1 sky130_fd_sc_hd__fill_1
XFILLER_40_266 vssd1 vssd1 vccd1 vccd1 sky130_fd_sc_hd__fill_2
XFILLER_4_27 vssd1 vssd1 vccd1 vccd1 sky130_fd_sc_hd__fill_1
X_2820_ _0472_ _1417_ _0473_ vssd1 vssd1 vccd1 vccd1 net73 sky130_fd_sc_hd__a21oi_1
X_2751_ _1306_ _1376_ _1378_ _1342_ vssd1 vssd1 vccd1 vccd1 _1379_ sky130_fd_sc_hd__o211a_1
XTAP_TAPCELL_ROW_18_269 vssd1 vccd1 sky130_fd_sc_hd__tapvpwrvgnd_1
X_1702_ CB_0.config_dataB\[16\] vssd1 vssd1 vccd1 vccd1 _1584_ sky130_fd_sc_hd__inv_2
X_1633_ SB0.route_sel\[30\] vssd1 vssd1 vccd1 vccd1 _1515_ sky130_fd_sc_hd__inv_2
X_2682_ net205 net206 vssd1 vssd1 vccd1 vccd1 _1310_ sky130_fd_sc_hd__and2b_1
X_3234_ CB_0.config_dataB\[0\] CB_0.config_dataA\[24\] net291 vssd1 vssd1 vccd1 vccd1
+ _0294_ sky130_fd_sc_hd__mux2_1
X_3165_ SB0.route_sel\[84\] SB0.route_sel\[83\] net271 vssd1 vssd1 vccd1 vccd1 _0225_
+ sky130_fd_sc_hd__mux2_1
X_3303_ LE_1B.reset_mode LE_1B.reset_val net261 vssd1 vssd1 vccd1 vccd1 _0363_ sky130_fd_sc_hd__mux2_1
X_2116_ net20 net21 net22 net23 net198 CB_0.config_dataA\[6\] vssd1 vssd1 vccd1 vccd1
+ _0750_ sky130_fd_sc_hd__mux4_1
X_2047_ _1602_ _0371_ _0663_ vssd1 vssd1 vccd1 vccd1 _0681_ sky130_fd_sc_hd__or3_1
X_3096_ SB0.route_sel\[15\] SB0.route_sel\[14\] net264 vssd1 vssd1 vccd1 vccd1 _0156_
+ sky130_fd_sc_hd__mux2_1
X_2949_ net418 LEI0.config_data\[7\] net304 vssd1 vssd1 vccd1 vccd1 _0009_ sky130_fd_sc_hd__mux2_1
XFILLER_57_141 vccd1 vssd1 vccd1 vssd1 sky130_ef_sc_hd__decap_40_12
XFILLER_57_130 vssd1 vssd1 vccd1 vccd1 sky130_fd_sc_hd__fill_1
XFILLER_13_222 vssd1 vssd1 vccd1 vccd1 sky130_fd_sc_hd__fill_2
XFILLER_13_233 vccd1 vssd1 vccd1 vssd1 sky130_ef_sc_hd__decap_40_12
Xclkload29 clknet_leaf_18_clk vssd1 vssd1 vccd1 vccd1 clkload29/Y sky130_fd_sc_hd__inv_12
Xclkload18 clknet_leaf_24_clk vssd1 vssd1 vccd1 vccd1 clkload18/Y sky130_fd_sc_hd__clkinv_4
XTAP_TAPCELL_ROW_66_607 vssd1 vccd1 sky130_fd_sc_hd__tapvpwrvgnd_1
XFILLER_48_152 vssd1 vssd1 vccd1 vccd1 sky130_fd_sc_hd__fill_1
XFILLER_63_111 vssd1 vssd1 vccd1 vccd1 sky130_fd_sc_hd__fill_1
XFILLER_36_303 vssd1 vssd1 vccd1 vccd1 sky130_fd_sc_hd__fill_4
X_2803_ _0667_ _0675_ _0669_ vssd1 vssd1 vccd1 vccd1 _1409_ sky130_fd_sc_hd__o21a_1
X_2734_ net4 net5 net6 net7 net203 CB_1.config_dataB\[16\] vssd1 vssd1 vccd1 vccd1
+ _1362_ sky130_fd_sc_hd__mux4_1
Xfanout227 net229 vssd1 vssd1 vccd1 vccd1 net227 sky130_fd_sc_hd__clkbuf_4
X_1616_ SB0.route_sel\[5\] vssd1 vssd1 vccd1 vccd1 _1498_ sky130_fd_sc_hd__inv_2
Xfanout216 net221 vssd1 vssd1 vccd1 vccd1 net216 sky130_fd_sc_hd__clkbuf_4
X_2596_ LE_1A.config_data\[9\] _1113_ _1151_ _1225_ vssd1 vssd1 vccd1 vccd1 _1226_
+ sky130_fd_sc_hd__a211o_1
Xfanout238 net239 vssd1 vssd1 vccd1 vccd1 net238 sky130_fd_sc_hd__clkbuf_2
Xfanout205 CB_1.config_dataB\[11\] vssd1 vssd1 vccd1 vccd1 net205 sky130_fd_sc_hd__buf_2
X_2665_ net208 _1290_ _1291_ _1292_ vssd1 vssd1 vccd1 vccd1 _1293_ sky130_fd_sc_hd__a31o_1
X_3217_ CB_0.config_dataA\[8\] CB_0.config_dataA\[7\] net295 vssd1 vssd1 vccd1 vccd1
+ _0277_ sky130_fd_sc_hd__mux2_1
XFILLER_54_133 vssd1 vssd1 vccd1 vccd1 sky130_fd_sc_hd__fill_4
XFILLER_54_111 vssd1 vssd1 vccd1 vccd1 sky130_fd_sc_hd__fill_1
Xfanout249 net254 vssd1 vssd1 vccd1 vccd1 net249 sky130_fd_sc_hd__clkbuf_4
XFILLER_39_163 vssd1 vssd1 vccd1 vccd1 sky130_fd_sc_hd__fill_4
XFILLER_39_152 vssd1 vssd1 vccd1 vccd1 sky130_fd_sc_hd__fill_4
X_3148_ SB0.route_sel\[67\] SB0.route_sel\[66\] net284 vssd1 vssd1 vccd1 vccd1 _0208_
+ sky130_fd_sc_hd__mux2_1
XFILLER_54_166 vssd1 vssd1 vccd1 vccd1 sky130_fd_sc_hd__fill_2
XFILLER_35_391 vssd1 vssd1 vccd1 vccd1 sky130_fd_sc_hd__fill_1
XFILLER_24_24 vssd1 vssd1 vccd1 vccd1 sky130_fd_sc_hd__fill_1
XFILLER_10_214 vccd1 vssd1 vccd1 vssd1 sky130_ef_sc_hd__decap_40_12
X_3079_ CB_1.config_dataB\[23\] CB_1.config_dataB\[22\] net284 vssd1 vssd1 vccd1 vccd1
+ _0139_ sky130_fd_sc_hd__mux2_1
XFILLER_40_56 vssd1 vssd1 vccd1 vccd1 sky130_fd_sc_hd__fill_1
XFILLER_40_23 vssd1 vssd1 vccd1 vccd1 sky130_fd_sc_hd__fill_4
XTAP_TAPCELL_ROW_20_286 vssd1 vccd1 sky130_fd_sc_hd__tapvpwrvgnd_1
XFILLER_49_54 vssd1 vssd1 vccd1 vccd1 sky130_fd_sc_hd__fill_2
XTAP_TAPCELL_ROW_28_342 vssd1 vccd1 sky130_fd_sc_hd__tapvpwrvgnd_1
XTAP_TAPCELL_ROW_11_220 vssd1 vccd1 sky130_fd_sc_hd__tapvpwrvgnd_1
X_2381_ LEI0.config_data\[40\] _1012_ vssd1 vssd1 vccd1 vccd1 _1013_ sky130_fd_sc_hd__nor2_1
X_2450_ _1079_ vssd1 vssd1 vccd1 vccd1 _1080_ sky130_fd_sc_hd__inv_2
Xinput5 CBeast_in[13] vssd1 vssd1 vccd1 vccd1 net5 sky130_fd_sc_hd__buf_2
X_3002_ net379 net366 net292 vssd1 vssd1 vccd1 vccd1 _0062_ sky130_fd_sc_hd__mux2_1
XFILLER_24_306 vssd1 vssd1 vccd1 vccd1 sky130_fd_sc_hd__fill_2
X_2717_ net204 net202 vssd1 vssd1 vccd1 vccd1 _1345_ sky130_fd_sc_hd__nor2_1
X_2579_ _1206_ _1207_ _1208_ CB_1.config_dataA\[17\] vssd1 vssd1 vccd1 vccd1 _1209_
+ sky130_fd_sc_hd__and4b_1
X_2648_ net209 _1058_ net208 vssd1 vssd1 vccd1 vccd1 _1276_ sky130_fd_sc_hd__o21a_1
XFILLER_27_188 vssd1 vssd1 vccd1 vccd1 sky130_fd_sc_hd__fill_4
XTAP_TAPCELL_ROW_25_323 vssd1 vccd1 sky130_fd_sc_hd__tapvpwrvgnd_1
XFILLER_51_77 vssd1 vssd1 vccd1 vccd1 sky130_fd_sc_hd__fill_2
XFILLER_42_169 vssd1 vssd1 vccd1 vccd1 sky130_fd_sc_hd__fill_2
XFILLER_18_144 vssd1 vssd1 vccd1 vccd1 sky130_fd_sc_hd__fill_2
X_1950_ _1609_ _0553_ vssd1 vssd1 vccd1 vccd1 _0584_ sky130_fd_sc_hd__nand2_1
X_3620_ clknet_leaf_12_clk _0316_ net252 vssd1 vssd1 vccd1 vccd1 CB_0.config_dataB\[22\]
+ sky130_fd_sc_hd__dfstp_1
X_2502_ net174 _1075_ vssd1 vssd1 vccd1 vccd1 _1132_ sky130_fd_sc_hd__or2_1
X_3551_ clknet_leaf_29_clk _0247_ net240 vssd1 vssd1 vccd1 vccd1 SB0.route_sel\[106\]
+ sky130_fd_sc_hd__dfstp_1
X_1881_ _1604_ net160 net158 _0471_ _0441_ vssd1 vssd1 vccd1 vccd1 _0515_ sky130_fd_sc_hd__o32a_1
X_2364_ net182 _0492_ _0995_ vssd1 vssd1 vccd1 vccd1 _0996_ sky130_fd_sc_hd__a21bo_1
X_3482_ clknet_leaf_35_clk _0178_ net214 vssd1 vssd1 vccd1 vccd1 SB0.route_sel\[37\]
+ sky130_fd_sc_hd__dfstp_1
X_2433_ SB0.route_sel\[76\] SB0.route_sel\[77\] SB0.route_sel\[79\] _1544_ vssd1 vssd1
+ vccd1 vccd1 _1063_ sky130_fd_sc_hd__o22a_1
X_2295_ _0528_ _0530_ _0907_ vssd1 vssd1 vccd1 vccd1 _0927_ sky130_fd_sc_hd__a21oi_1
XFILLER_2_60 vssd1 vssd1 vccd1 vccd1 sky130_fd_sc_hd__fill_2
XANTENNA_21 CBnorth_in[6] vssd1 vssd1 vccd1 vccd1 sky130_fd_sc_hd__diode_2
XFILLER_32_191 vssd1 vssd1 vccd1 vccd1 sky130_fd_sc_hd__fill_4
XANTENNA_10 SBsouth_in[15] vssd1 vssd1 vccd1 vccd1 sky130_fd_sc_hd__diode_2
XFILLER_47_239 vssd1 vssd1 vccd1 vccd1 sky130_fd_sc_hd__fill_1
XFILLER_62_209 vssd1 vssd1 vccd1 vccd1 sky130_fd_sc_hd__fill_1
XFILLER_43_401 vssd1 vssd1 vccd1 vccd1 sky130_fd_sc_hd__fill_2
X_2080_ SB0.route_sel\[12\] _1504_ SB0.route_sel\[15\] _1506_ _0713_ vssd1 vssd1 vccd1
+ vccd1 _0714_ sky130_fd_sc_hd__a221o_1
XFILLER_16_6 vssd1 vssd1 vccd1 vccd1 sky130_fd_sc_hd__fill_4
X_2982_ net381 LEI0.config_data\[40\] net306 vssd1 vssd1 vccd1 vccd1 _0042_ sky130_fd_sc_hd__mux2_1
XTAP_TAPCELL_ROW_44_451 vssd1 vccd1 sky130_fd_sc_hd__tapvpwrvgnd_1
X_1933_ CB_0.config_dataA\[23\] CB_0.config_dataA\[22\] vssd1 vssd1 vccd1 vccd1 _0567_
+ sky130_fd_sc_hd__and2b_2
XPHY_EDGE_ROW_26_Left_94 vssd1 vssd1 vccd1 vccd1 sky130_fd_sc_hd__decap_3
Xinput30 CBnorth_in[7] vssd1 vssd1 vccd1 vccd1 net30 sky130_fd_sc_hd__clkbuf_2
X_1795_ net179 net180 _0425_ net20 vssd1 vssd1 vccd1 vccd1 _0429_ sky130_fd_sc_hd__a31o_1
X_1864_ _1602_ _0371_ _0480_ vssd1 vssd1 vccd1 vccd1 _0498_ sky130_fd_sc_hd__or3_1
X_3603_ clknet_leaf_4_clk _0299_ net229 vssd1 vssd1 vccd1 vccd1 CB_0.config_dataB\[5\]
+ sky130_fd_sc_hd__dfstp_1
Xinput52 SBwest_in[12] vssd1 vssd1 vccd1 vccd1 net52 sky130_fd_sc_hd__buf_1
X_3534_ clknet_leaf_1_clk _0230_ net219 vssd1 vssd1 vccd1 vccd1 SB0.route_sel\[89\]
+ sky130_fd_sc_hd__dfstp_2
Xinput63 SBwest_in[8] vssd1 vssd1 vccd1 vccd1 net63 sky130_fd_sc_hd__buf_1
Xinput41 SBsouth_in[2] vssd1 vssd1 vccd1 vccd1 net41 sky130_fd_sc_hd__buf_1
X_3465_ clknet_leaf_34_clk _0161_ net214 vssd1 vssd1 vccd1 vccd1 SB0.route_sel\[20\]
+ sky130_fd_sc_hd__dfstp_1
X_2347_ LE_0B.config_data\[5\] _0905_ _0939_ _0978_ vssd1 vssd1 vccd1 vccd1 _0979_
+ sky130_fd_sc_hd__a211o_1
X_2416_ _1038_ _1040_ _1043_ _1045_ CB_1.config_dataA\[2\] vssd1 vssd1 vccd1 vccd1
+ _1046_ sky130_fd_sc_hd__o221ai_1
X_2278_ net186 _0566_ _0577_ _0580_ _1579_ vssd1 vssd1 vccd1 vccd1 _0910_ sky130_fd_sc_hd__a41o_1
X_3396_ clknet_leaf_27_clk _0092_ net236 vssd1 vssd1 vccd1 vccd1 LE_0B.reset_mode
+ sky130_fd_sc_hd__dfrtp_1
XPHY_EDGE_ROW_10_Left_78 vssd1 vssd1 vccd1 vccd1 sky130_fd_sc_hd__decap_3
XFILLER_44_209 vssd1 vssd1 vccd1 vccd1 sky130_fd_sc_hd__fill_2
XFILLER_25_401 vssd1 vssd1 vccd1 vccd1 sky130_fd_sc_hd__fill_2
XTAP_TAPCELL_ROW_50_498 vssd1 vccd1 sky130_fd_sc_hd__tapvpwrvgnd_1
XFILLER_20_194 vssd1 vssd1 vccd1 vccd1 sky130_fd_sc_hd__fill_2
XTAP_TAPCELL_ROW_58_554 vssd1 vccd1 sky130_fd_sc_hd__tapvpwrvgnd_1
XTAP_TAPCELL_ROW_7_198 vssd1 vccd1 sky130_fd_sc_hd__tapvpwrvgnd_1
XTAP_TAPCELL_ROW_41_432 vssd1 vccd1 sky130_fd_sc_hd__tapvpwrvgnd_1
X_2132_ CB_0.config_dataA\[7\] _0765_ _0764_ CB_0.config_dataA\[8\] vssd1 vssd1 vccd1
+ vccd1 _0766_ sky130_fd_sc_hd__a211o_1
X_2201_ _0825_ _0834_ CB_0.config_dataA\[17\] vssd1 vssd1 vccd1 vccd1 _0835_ sky130_fd_sc_hd__mux2_1
X_3250_ CB_0.config_dataB\[16\] net181 net290 vssd1 vssd1 vccd1 vccd1 _0310_ sky130_fd_sc_hd__mux2_1
X_3181_ SB0.route_sel\[100\] SB0.route_sel\[99\] net274 vssd1 vssd1 vccd1 vccd1 _0241_
+ sky130_fd_sc_hd__mux2_1
XFILLER_3_371 vssd1 vssd1 vccd1 vccd1 sky130_fd_sc_hd__fill_1
X_2063_ _1496_ _0694_ _0696_ vssd1 vssd1 vccd1 vccd1 _0697_ sky130_fd_sc_hd__a21o_1
XFILLER_34_253 vssd1 vssd1 vccd1 vccd1 sky130_fd_sc_hd__fill_2
XFILLER_19_294 vssd1 vssd1 vccd1 vccd1 sky130_fd_sc_hd__fill_2
X_2965_ LEI0.config_data\[24\] net330 net306 vssd1 vssd1 vccd1 vccd1 _0025_ sky130_fd_sc_hd__mux2_1
X_1916_ _0463_ _0531_ _0549_ _0436_ CB_0.config_dataA\[2\] vssd1 vssd1 vccd1 vccd1
+ _0550_ sky130_fd_sc_hd__a221oi_1
X_1847_ _0387_ _0479_ vssd1 vssd1 vccd1 vccd1 _0481_ sky130_fd_sc_hd__nand2_1
X_2896_ SB0.route_sel\[39\] SB0.route_sel\[38\] SB0.route_sel\[33\] _1520_ _1464_
+ vssd1 vssd1 vccd1 vccd1 _1465_ sky130_fd_sc_hd__o221a_1
X_1778_ net165 net161 net4 vssd1 vssd1 vccd1 vccd1 _0412_ sky130_fd_sc_hd__o21a_1
X_3448_ clknet_leaf_27_clk _0144_ net236 vssd1 vssd1 vccd1 vccd1 SB0.route_sel\[3\]
+ sky130_fd_sc_hd__dfstp_1
X_3517_ clknet_leaf_30_clk _0213_ net226 vssd1 vssd1 vccd1 vccd1 SB0.route_sel\[72\]
+ sky130_fd_sc_hd__dfstp_1
X_3379_ clknet_leaf_5_clk net391 net227 vssd1 vssd1 vccd1 vccd1 LE_0B.config_data\[2\]
+ sky130_fd_sc_hd__dfrtp_1
XFILLER_27_57 vssd1 vssd1 vccd1 vccd1 sky130_fd_sc_hd__fill_8
XTAP_TAPCELL_ROW_63_590 vssd1 vccd1 sky130_fd_sc_hd__tapvpwrvgnd_1
XFILLER_43_89 vssd1 vssd1 vccd1 vccd1 sky130_fd_sc_hd__fill_1
XFILLER_25_231 vssd1 vssd1 vccd1 vccd1 sky130_fd_sc_hd__fill_1
XFILLER_16_242 vssd1 vssd1 vccd1 vccd1 sky130_fd_sc_hd__fill_1
X_1701_ CB_0.config_dataB\[17\] vssd1 vssd1 vccd1 vccd1 _1583_ sky130_fd_sc_hd__inv_2
X_2681_ net207 _1058_ vssd1 vssd1 vccd1 vccd1 _1309_ sky130_fd_sc_hd__or2_1
X_2750_ LE_1B.config_data\[5\] _1274_ _1307_ _1377_ vssd1 vssd1 vccd1 vccd1 _1378_
+ sky130_fd_sc_hd__a211o_1
X_3302_ LE_1B.reset_val LE_1B.edge_mode net277 vssd1 vssd1 vccd1 vccd1 _0362_ sky130_fd_sc_hd__mux2_1
X_1632_ SB0.route_sel\[31\] vssd1 vssd1 vccd1 vccd1 _1514_ sky130_fd_sc_hd__inv_2
X_2115_ net31 net32 net18 net19 net198 CB_0.config_dataA\[6\] vssd1 vssd1 vccd1 vccd1
+ _0749_ sky130_fd_sc_hd__mux4_1
X_3233_ CB_0.config_dataA\[24\] CB_0.config_dataA\[23\] net291 vssd1 vssd1 vccd1 vccd1
+ _0293_ sky130_fd_sc_hd__mux2_1
X_3164_ SB0.route_sel\[83\] SB0.route_sel\[82\] net271 vssd1 vssd1 vccd1 vccd1 _0224_
+ sky130_fd_sc_hd__mux2_1
X_3095_ SB0.route_sel\[14\] SB0.route_sel\[13\] net264 vssd1 vssd1 vccd1 vccd1 _0155_
+ sky130_fd_sc_hd__mux2_1
X_2046_ net146 net164 _0666_ vssd1 vssd1 vccd1 vccd1 _0680_ sky130_fd_sc_hd__nor3_1
XFILLER_22_201 vssd1 vssd1 vccd1 vccd1 sky130_fd_sc_hd__fill_2
X_2948_ net430 LEI0.config_data\[6\] net304 vssd1 vssd1 vccd1 vccd1 _0008_ sky130_fd_sc_hd__mux2_1
X_2879_ _0566_ _0577_ _1453_ vssd1 vssd1 vccd1 vccd1 net116 sky130_fd_sc_hd__and3_1
XFILLER_49_109 vssd1 vssd1 vccd1 vccd1 sky130_fd_sc_hd__fill_2
XPHY_EDGE_ROW_13_Left_81 vssd1 vssd1 vccd1 vccd1 sky130_fd_sc_hd__decap_3
XFILLER_60_307 vssd1 vssd1 vccd1 vccd1 sky130_fd_sc_hd__fill_1
XFILLER_45_337 vssd1 vssd1 vccd1 vccd1 sky130_fd_sc_hd__fill_1
XFILLER_13_245 vssd1 vssd1 vccd1 vccd1 sky130_fd_sc_hd__fill_2
XFILLER_13_278 vssd1 vssd1 vccd1 vccd1 sky130_fd_sc_hd__fill_2
Xclkload19 clknet_leaf_25_clk vssd1 vssd1 vccd1 vccd1 clkload19/Y sky130_fd_sc_hd__clkinv_1
XTAP_TAPCELL_ROW_66_608 vssd1 vccd1 sky130_fd_sc_hd__tapvpwrvgnd_1
XFILLER_48_175 vssd1 vssd1 vccd1 vccd1 sky130_fd_sc_hd__fill_4
XFILLER_63_123 vssd1 vssd1 vccd1 vccd1 sky130_fd_sc_hd__fill_1
X_2802_ _0606_ _1408_ _0609_ vssd1 vssd1 vccd1 vccd1 net97 sky130_fd_sc_hd__a21o_1
X_2733_ net203 net202 _1038_ _1360_ vssd1 vssd1 vccd1 vccd1 _1361_ sky130_fd_sc_hd__o31a_1
X_2664_ _1079_ _1277_ _1279_ _1083_ _1596_ vssd1 vssd1 vccd1 vccd1 _1292_ sky130_fd_sc_hd__a221o_1
Xfanout228 net229 vssd1 vssd1 vccd1 vccd1 net228 sky130_fd_sc_hd__buf_2
X_1615_ net199 vssd1 vssd1 vccd1 vccd1 _1497_ sky130_fd_sc_hd__inv_2
Xfanout239 net241 vssd1 vssd1 vccd1 vccd1 net239 sky130_fd_sc_hd__clkbuf_2
Xfanout206 CB_1.config_dataB\[10\] vssd1 vssd1 vccd1 vccd1 net206 sky130_fd_sc_hd__buf_2
Xfanout217 net221 vssd1 vssd1 vccd1 vccd1 net217 sky130_fd_sc_hd__clkbuf_2
X_2595_ _1068_ _1106_ _1112_ LE_1A.config_data\[8\] vssd1 vssd1 vccd1 vccd1 _1225_
+ sky130_fd_sc_hd__o211a_1
X_3216_ CB_0.config_dataA\[7\] net196 net295 vssd1 vssd1 vccd1 vccd1 _0276_ sky130_fd_sc_hd__mux2_1
XFILLER_39_175 vccd1 vssd1 vccd1 vssd1 sky130_ef_sc_hd__decap_40_12
X_3147_ SB0.route_sel\[66\] SB0.route_sel\[65\] net284 vssd1 vssd1 vccd1 vccd1 _0207_
+ sky130_fd_sc_hd__mux2_1
X_3078_ CB_1.config_dataB\[22\] CB_1.config_dataB\[21\] net284 vssd1 vssd1 vccd1 vccd1
+ _0138_ sky130_fd_sc_hd__mux2_1
X_2029_ CB_0.config_dataA\[23\] CB_0.config_dataA\[22\] vssd1 vssd1 vccd1 vccd1 _0663_
+ sky130_fd_sc_hd__or2_1
XFILLER_10_226 vccd1 vssd1 vccd1 vssd1 sky130_ef_sc_hd__decap_40_12
XTAP_TAPCELL_ROW_20_287 vssd1 vccd1 sky130_fd_sc_hd__tapvpwrvgnd_1
XFILLER_49_77 vccd1 vssd1 vccd1 vssd1 sky130_ef_sc_hd__decap_40_12
XFILLER_45_167 vssd1 vssd1 vccd1 vccd1 sky130_fd_sc_hd__fill_1
XTAP_TAPCELL_ROW_28_343 vssd1 vccd1 sky130_fd_sc_hd__tapvpwrvgnd_1
XTAP_TAPCELL_ROW_11_221 vssd1 vccd1 sky130_fd_sc_hd__tapvpwrvgnd_1
XFILLER_14_80 vssd1 vssd1 vccd1 vccd1 sky130_fd_sc_hd__fill_4
X_2380_ net154 net149 LEI0.config_data\[39\] vssd1 vssd1 vccd1 vccd1 _1012_ sky130_fd_sc_hd__mux2_1
XFILLER_30_90 vssd1 vssd1 vccd1 vccd1 sky130_fd_sc_hd__fill_2
X_3001_ net366 LE_0A.config_data\[9\] net293 vssd1 vssd1 vccd1 vccd1 _0061_ sky130_fd_sc_hd__mux2_1
Xinput6 CBeast_in[14] vssd1 vssd1 vccd1 vccd1 net6 sky130_fd_sc_hd__buf_2
XFILLER_32_373 vssd1 vssd1 vccd1 vccd1 sky130_fd_sc_hd__fill_2
X_2716_ net204 _1075_ _1343_ CB_1.config_dataB\[16\] vssd1 vssd1 vccd1 vccd1 _1344_
+ sky130_fd_sc_hd__o211a_1
X_2647_ net209 _1054_ vssd1 vssd1 vccd1 vccd1 _1275_ sky130_fd_sc_hd__nand2_1
X_2578_ _1043_ _1194_ vssd1 vssd1 vccd1 vccd1 _1208_ sky130_fd_sc_hd__nand2b_1
XFILLER_19_14 vssd1 vssd1 vccd1 vccd1 sky130_fd_sc_hd__fill_2
XFILLER_19_47 vssd1 vssd1 vccd1 vccd1 sky130_fd_sc_hd__fill_2
XFILLER_42_126 vssd1 vssd1 vccd1 vccd1 sky130_fd_sc_hd__fill_2
XFILLER_42_104 vccd1 vssd1 vccd1 vssd1 sky130_ef_sc_hd__decap_40_12
XFILLER_35_57 vssd1 vssd1 vccd1 vccd1 sky130_fd_sc_hd__fill_2
XFILLER_35_46 vssd1 vssd1 vccd1 vccd1 sky130_fd_sc_hd__fill_1
XFILLER_27_167 vssd1 vssd1 vccd1 vccd1 sky130_fd_sc_hd__fill_1
XTAP_TAPCELL_ROW_25_324 vssd1 vccd1 sky130_fd_sc_hd__tapvpwrvgnd_1
XPHY_EDGE_ROW_14_Right_14 vssd1 vssd1 vccd1 vccd1 sky130_fd_sc_hd__decap_3
XPHY_EDGE_ROW_23_Right_23 vssd1 vssd1 vccd1 vccd1 sky130_fd_sc_hd__decap_3
XFILLER_61_402 vssd1 vssd1 vccd1 vccd1 sky130_fd_sc_hd__fill_1
XFILLER_18_167 vssd1 vssd1 vccd1 vccd1 sky130_fd_sc_hd__fill_8
XPHY_EDGE_ROW_38_Left_106 vssd1 vssd1 vccd1 vccd1 sky130_fd_sc_hd__decap_3
XFILLER_33_137 vccd1 vssd1 vccd1 vssd1 sky130_ef_sc_hd__decap_40_12
XFILLER_33_115 vssd1 vssd1 vccd1 vccd1 sky130_fd_sc_hd__fill_1
XFILLER_33_104 vssd1 vssd1 vccd1 vccd1 sky130_fd_sc_hd__fill_2
XPHY_EDGE_ROW_32_Right_32 vssd1 vssd1 vccd1 vccd1 sky130_fd_sc_hd__decap_3
X_1880_ net160 net158 net16 vssd1 vssd1 vccd1 vccd1 _0514_ sky130_fd_sc_hd__o21ai_1
XFILLER_25_90 vccd1 vssd1 vccd1 vssd1 sky130_ef_sc_hd__decap_40_12
XPHY_EDGE_ROW_47_Left_115 vssd1 vssd1 vccd1 vccd1 sky130_fd_sc_hd__decap_3
X_2501_ net174 _1071_ vssd1 vssd1 vccd1 vccd1 _1131_ sky130_fd_sc_hd__nand2_1
X_3550_ clknet_leaf_29_clk _0246_ net240 vssd1 vssd1 vccd1 vccd1 SB0.route_sel\[105\]
+ sky130_fd_sc_hd__dfstp_1
X_3481_ clknet_leaf_0_clk _0177_ net218 vssd1 vssd1 vccd1 vccd1 SB0.route_sel\[36\]
+ sky130_fd_sc_hd__dfstp_1
X_2363_ net182 _0508_ _0510_ CB_0.config_dataB\[16\] vssd1 vssd1 vccd1 vccd1 _0995_
+ sky130_fd_sc_hd__o31a_1
XPHY_EDGE_ROW_41_Right_41 vssd1 vssd1 vccd1 vccd1 sky130_fd_sc_hd__decap_3
X_2294_ net186 _0511_ _0925_ CB_0.config_dataB\[6\] vssd1 vssd1 vccd1 vccd1 _0926_
+ sky130_fd_sc_hd__o211a_1
XTAP_TAPCELL_ROW_39_416 vssd1 vccd1 sky130_fd_sc_hd__tapvpwrvgnd_1
X_2432_ _0546_ _1061_ vssd1 vssd1 vccd1 vccd1 _1062_ sky130_fd_sc_hd__nand2_4
XPHY_EDGE_ROW_56_Left_124 vssd1 vssd1 vccd1 vccd1 sky130_fd_sc_hd__decap_3
XPHY_EDGE_ROW_50_Right_50 vssd1 vssd1 vccd1 vccd1 sky130_fd_sc_hd__decap_3
XFILLER_24_104 vssd1 vssd1 vccd1 vccd1 sky130_fd_sc_hd__fill_4
XPHY_EDGE_ROW_65_Left_133 vssd1 vssd1 vccd1 vccd1 sky130_fd_sc_hd__decap_3
XANTENNA_22 net108 vssd1 vssd1 vccd1 vccd1 sky130_fd_sc_hd__diode_2
XANTENNA_11 le_clk vssd1 vssd1 vccd1 vccd1 sky130_fd_sc_hd__diode_2
XFILLER_15_126 vssd1 vssd1 vccd1 vccd1 sky130_fd_sc_hd__fill_2
XFILLER_15_159 vssd1 vssd1 vccd1 vccd1 sky130_fd_sc_hd__fill_2
XFILLER_46_240 vssd1 vssd1 vccd1 vccd1 sky130_fd_sc_hd__fill_4
X_2981_ LEI0.config_data\[40\] LEI0.config_data\[39\] net306 vssd1 vssd1 vccd1 vccd1
+ _0041_ sky130_fd_sc_hd__mux2_1
Xinput31 CBnorth_in[8] vssd1 vssd1 vccd1 vccd1 net31 sky130_fd_sc_hd__buf_2
Xinput20 CBnorth_in[12] vssd1 vssd1 vccd1 vccd1 net20 sky130_fd_sc_hd__buf_2
X_1863_ net146 _0375_ _0483_ vssd1 vssd1 vccd1 vccd1 _0497_ sky130_fd_sc_hd__nor3_1
XTAP_TAPCELL_ROW_44_452 vssd1 vccd1 sky130_fd_sc_hd__tapvpwrvgnd_1
X_3602_ clknet_leaf_4_clk _0298_ net229 vssd1 vssd1 vccd1 vccd1 CB_0.config_dataB\[4\]
+ sky130_fd_sc_hd__dfstp_1
X_1932_ _0561_ _0565_ _1534_ _1535_ vssd1 vssd1 vccd1 vccd1 _0566_ sky130_fd_sc_hd__a211o_2
X_2415_ _1044_ vssd1 vssd1 vccd1 vccd1 _1045_ sky130_fd_sc_hd__inv_2
X_1794_ net146 _0376_ _0426_ _0423_ _0373_ vssd1 vssd1 vccd1 vccd1 _0428_ sky130_fd_sc_hd__o32a_1
Xinput53 SBwest_in[13] vssd1 vssd1 vccd1 vccd1 net53 sky130_fd_sc_hd__buf_1
X_3533_ clknet_leaf_1_clk _0229_ net219 vssd1 vssd1 vccd1 vccd1 SB0.route_sel\[88\]
+ sky130_fd_sc_hd__dfstp_2
Xinput64 SBwest_in[9] vssd1 vssd1 vccd1 vccd1 net64 sky130_fd_sc_hd__clkbuf_1
Xinput42 SBsouth_in[3] vssd1 vssd1 vccd1 vccd1 net42 sky130_fd_sc_hd__buf_1
X_3464_ clknet_leaf_34_clk _0160_ net214 vssd1 vssd1 vccd1 vccd1 SB0.route_sel\[19\]
+ sky130_fd_sc_hd__dfstp_2
X_2346_ _0897_ _0898_ _0904_ LE_0B.config_data\[4\] vssd1 vssd1 vccd1 vccd1 _0978_
+ sky130_fd_sc_hd__o211a_1
X_2277_ net186 _0592_ _0598_ _0602_ vssd1 vssd1 vccd1 vccd1 _0909_ sky130_fd_sc_hd__nor4_1
X_3395_ clknet_leaf_34_clk _0091_ net216 vssd1 vssd1 vccd1 vccd1 LE_0B.reset_val sky130_fd_sc_hd__dfrtp_1
XFILLER_37_284 vssd1 vssd1 vccd1 vccd1 sky130_fd_sc_hd__fill_1
Xclkbuf_leaf_32_clk clknet_2_0__leaf_clk vssd1 vssd1 vccd1 vccd1 clknet_leaf_32_clk
+ sky130_fd_sc_hd__clkbuf_8
XTAP_TAPCELL_ROW_50_499 vssd1 vccd1 sky130_fd_sc_hd__tapvpwrvgnd_1
XTAP_TAPCELL_ROW_58_555 vssd1 vccd1 sky130_fd_sc_hd__tapvpwrvgnd_1
XFILLER_16_402 vssd1 vssd1 vccd1 vccd1 sky130_fd_sc_hd__fill_1
XTAP_TAPCELL_ROW_41_433 vssd1 vccd1 sky130_fd_sc_hd__tapvpwrvgnd_1
XFILLER_7_122 vssd1 vssd1 vccd1 vccd1 sky130_fd_sc_hd__fill_2
Xclkbuf_leaf_23_clk clknet_2_2__leaf_clk vssd1 vssd1 vccd1 vccd1 clknet_leaf_23_clk
+ sky130_fd_sc_hd__clkbuf_8
XFILLER_22_91 vssd1 vssd1 vccd1 vccd1 sky130_fd_sc_hd__fill_4
X_2200_ net20 net21 net22 net23 net192 net190 vssd1 vssd1 vccd1 vccd1 _0834_ sky130_fd_sc_hd__mux4_1
X_2131_ net27 net28 net29 net30 net198 CB_0.config_dataA\[6\] vssd1 vssd1 vccd1 vccd1
+ _0765_ sky130_fd_sc_hd__mux4_1
X_2062_ net200 _0672_ _0674_ _1497_ vssd1 vssd1 vccd1 vccd1 _0696_ sky130_fd_sc_hd__a31o_1
X_3180_ SB0.route_sel\[99\] SB0.route_sel\[98\] net274 vssd1 vssd1 vccd1 vccd1 _0240_
+ sky130_fd_sc_hd__mux2_1
X_2964_ net330 LEI0.config_data\[22\] net306 vssd1 vssd1 vccd1 vccd1 _0024_ sky130_fd_sc_hd__mux2_1
Xclkbuf_leaf_14_clk clknet_2_3__leaf_clk vssd1 vssd1 vccd1 vccd1 clknet_leaf_14_clk
+ sky130_fd_sc_hd__clkbuf_8
X_1846_ CB_0.config_dataA\[22\] CB_0.config_dataA\[23\] vssd1 vssd1 vccd1 vccd1 _0480_
+ sky130_fd_sc_hd__nand2b_1
X_1915_ _0546_ _0548_ vssd1 vssd1 vccd1 vccd1 _0549_ sky130_fd_sc_hd__nand2_4
X_2895_ SB0.route_sel\[34\] SB0.route_sel\[35\] vssd1 vssd1 vccd1 vccd1 _1464_ sky130_fd_sc_hd__nand2b_1
X_1777_ CB_1.config_dataB\[21\] CB_1.config_dataB\[20\] CB_1.config_dataB\[24\] vssd1
+ vssd1 vccd1 vccd1 _0411_ sky130_fd_sc_hd__or3_1
X_3378_ clknet_leaf_1_clk _0074_ net218 vssd1 vssd1 vccd1 vccd1 LE_0B.config_data\[1\]
+ sky130_fd_sc_hd__dfrtp_1
X_3516_ clknet_leaf_29_clk _0212_ net226 vssd1 vssd1 vccd1 vccd1 SB0.route_sel\[71\]
+ sky130_fd_sc_hd__dfstp_1
XPHY_EDGE_ROW_4_Right_4 vssd1 vssd1 vccd1 vccd1 sky130_fd_sc_hd__decap_3
X_3447_ clknet_leaf_27_clk _0143_ net236 vssd1 vssd1 vccd1 vccd1 SB0.route_sel\[2\]
+ sky130_fd_sc_hd__dfstp_1
X_2329_ CB_0.config_dataB\[12\] _0960_ CB_0.config_dataB\[13\] vssd1 vssd1 vccd1 vccd1
+ _0961_ sky130_fd_sc_hd__a21o_1
X_1700_ CB_0.config_dataB\[18\] vssd1 vssd1 vccd1 vccd1 _1582_ sky130_fd_sc_hd__inv_2
X_2680_ net207 _1054_ vssd1 vssd1 vccd1 vccd1 _1308_ sky130_fd_sc_hd__nand2_1
X_1631_ SB0.route_sel\[29\] vssd1 vssd1 vccd1 vccd1 _1513_ sky130_fd_sc_hd__inv_2
X_3232_ CB_0.config_dataA\[23\] CB_0.config_dataA\[22\] net291 vssd1 vssd1 vccd1 vccd1
+ _0292_ sky130_fd_sc_hd__mux2_1
Xclkbuf_leaf_3_clk clknet_2_1__leaf_clk vssd1 vssd1 vccd1 vccd1 clknet_leaf_3_clk
+ sky130_fd_sc_hd__clkbuf_8
X_3301_ LE_1B.edge_mode LE_1B.config_data\[16\] net277 vssd1 vssd1 vccd1 vccd1 _0361_
+ sky130_fd_sc_hd__mux2_1
X_2114_ net196 _0742_ _0743_ _0747_ vssd1 vssd1 vccd1 vccd1 _0748_ sky130_fd_sc_hd__a31o_1
X_2045_ net164 _0666_ net25 vssd1 vssd1 vccd1 vccd1 _0679_ sky130_fd_sc_hd__o21ba_1
XFILLER_39_302 vssd1 vssd1 vccd1 vccd1 sky130_fd_sc_hd__fill_1
X_3163_ SB0.route_sel\[82\] SB0.route_sel\[81\] net271 vssd1 vssd1 vccd1 vccd1 _0223_
+ sky130_fd_sc_hd__mux2_1
X_3094_ SB0.route_sel\[13\] SB0.route_sel\[12\] net264 vssd1 vssd1 vccd1 vccd1 _0154_
+ sky130_fd_sc_hd__mux2_1
X_2947_ LEI0.config_data\[6\] net413 net304 vssd1 vssd1 vccd1 vccd1 _0007_ sky130_fd_sc_hd__mux2_1
X_1829_ _1496_ net199 vssd1 vssd1 vccd1 vccd1 _0463_ sky130_fd_sc_hd__nor2_1
XFILLER_1_106 vssd1 vssd1 vccd1 vccd1 sky130_fd_sc_hd__fill_2
XTAP_TAPCELL_ROW_9_206 vssd1 vccd1 sky130_fd_sc_hd__tapvpwrvgnd_1
X_2878_ SB0.route_sel\[59\] _1531_ _1534_ SB0.route_sel\[56\] _1452_ vssd1 vssd1 vccd1
+ vccd1 _1453_ sky130_fd_sc_hd__a221o_1
XTAP_TAPCELL_ROW_66_609 vssd1 vccd1 sky130_fd_sc_hd__tapvpwrvgnd_1
XFILLER_63_113 vssd1 vssd1 vccd1 vccd1 sky130_fd_sc_hd__fill_1
XFILLER_29_390 vssd1 vssd1 vccd1 vccd1 sky130_fd_sc_hd__fill_2
X_2801_ net146 _0425_ _0570_ _1407_ vssd1 vssd1 vccd1 vccd1 _1408_ sky130_fd_sc_hd__a31o_1
XTAP_TAPCELL_ROW_14_241 vssd1 vccd1 sky130_fd_sc_hd__tapvpwrvgnd_1
X_1614_ net200 vssd1 vssd1 vccd1 vccd1 _1496_ sky130_fd_sc_hd__inv_2
X_2732_ _1043_ _1347_ _1358_ _1359_ CB_1.config_dataB\[17\] vssd1 vssd1 vccd1 vccd1
+ _1360_ sky130_fd_sc_hd__o221a_1
X_2594_ LE_1A.config_data\[11\] _1113_ _1150_ _1223_ vssd1 vssd1 vccd1 vccd1 _1224_
+ sky130_fd_sc_hd__a211o_1
X_2663_ net209 _1071_ vssd1 vssd1 vccd1 vccd1 _1291_ sky130_fd_sc_hd__nand2_1
X_3215_ net196 net198 net294 vssd1 vssd1 vccd1 vccd1 _0275_ sky130_fd_sc_hd__mux2_1
Xfanout229 net234 vssd1 vssd1 vccd1 vccd1 net229 sky130_fd_sc_hd__buf_2
Xfanout218 net220 vssd1 vssd1 vccd1 vccd1 net218 sky130_fd_sc_hd__clkbuf_4
Xfanout207 CB_1.config_dataB\[10\] vssd1 vssd1 vccd1 vccd1 net207 sky130_fd_sc_hd__clkbuf_2
XFILLER_54_157 vssd1 vssd1 vccd1 vccd1 sky130_fd_sc_hd__fill_4
XFILLER_39_187 vccd1 vssd1 vccd1 vssd1 sky130_ef_sc_hd__decap_40_12
X_2028_ CB_0.config_dataA\[23\] CB_0.config_dataA\[22\] vssd1 vssd1 vccd1 vccd1 _0662_
+ sky130_fd_sc_hd__nor2_2
X_3146_ SB0.route_sel\[65\] SB0.route_sel\[64\] net274 vssd1 vssd1 vccd1 vccd1 _0206_
+ sky130_fd_sc_hd__mux2_1
X_3077_ CB_1.config_dataB\[21\] CB_1.config_dataB\[20\] net278 vssd1 vssd1 vccd1 vccd1
+ _0137_ sky130_fd_sc_hd__mux2_1
XFILLER_10_238 vssd1 vssd1 vccd1 vccd1 sky130_fd_sc_hd__fill_2
XTAP_TAPCELL_ROW_20_288 vssd1 vccd1 sky130_fd_sc_hd__tapvpwrvgnd_1
XFILLER_49_89 vccd1 vssd1 vccd1 vssd1 sky130_ef_sc_hd__decap_40_12
XFILLER_18_349 vssd1 vssd1 vccd1 vccd1 sky130_fd_sc_hd__fill_1
XFILLER_45_157 vssd1 vssd1 vccd1 vccd1 sky130_fd_sc_hd__fill_2
XFILLER_41_341 vssd1 vssd1 vccd1 vccd1 sky130_fd_sc_hd__fill_1
XTAP_TAPCELL_ROW_28_344 vssd1 vccd1 sky130_fd_sc_hd__tapvpwrvgnd_1
XFILLER_26_371 vssd1 vssd1 vccd1 vccd1 sky130_fd_sc_hd__fill_1
XTAP_TAPCELL_ROW_11_222 vssd1 vccd1 sky130_fd_sc_hd__tapvpwrvgnd_1
XFILLER_46_7 vssd1 vssd1 vccd1 vccd1 sky130_fd_sc_hd__fill_1
X_3000_ LE_0A.config_data\[9\] net323 net293 vssd1 vssd1 vccd1 vccd1 _0060_ sky130_fd_sc_hd__mux2_1
Xinput7 CBeast_in[15] vssd1 vssd1 vccd1 vccd1 net7 sky130_fd_sc_hd__buf_2
X_2715_ net204 _1071_ vssd1 vssd1 vccd1 vccd1 _1343_ sky130_fd_sc_hd__nand2_1
X_2577_ net168 net167 _1038_ vssd1 vssd1 vccd1 vccd1 _1207_ sky130_fd_sc_hd__or3_1
X_2646_ _1266_ _1267_ _1273_ vssd1 vssd1 vccd1 vccd1 _1274_ sky130_fd_sc_hd__o21ai_4
XFILLER_27_113 vssd1 vssd1 vccd1 vccd1 sky130_fd_sc_hd__fill_4
XFILLER_19_26 vssd1 vssd1 vccd1 vccd1 sky130_fd_sc_hd__fill_4
XFILLER_42_116 vssd1 vssd1 vccd1 vccd1 sky130_fd_sc_hd__fill_4
X_3129_ SB0.route_sel\[48\] SB0.route_sel\[47\] net266 vssd1 vssd1 vccd1 vccd1 _0189_
+ sky130_fd_sc_hd__mux2_1
XFILLER_51_79 vssd1 vssd1 vccd1 vccd1 sky130_fd_sc_hd__fill_1
XTAP_TAPCELL_ROW_33_380 vssd1 vccd1 sky130_fd_sc_hd__tapvpwrvgnd_1
XFILLER_4_3 vssd1 vssd1 vccd1 vccd1 sky130_fd_sc_hd__fill_4
XFILLER_18_135 vssd1 vssd1 vccd1 vccd1 sky130_fd_sc_hd__fill_1
XFILLER_33_149 vssd1 vssd1 vccd1 vccd1 sky130_fd_sc_hd__fill_2
XFILLER_14_374 vssd1 vssd1 vccd1 vccd1 sky130_fd_sc_hd__fill_1
X_2500_ CB_1.config_dataA\[8\] _1121_ _1125_ _1129_ vssd1 vssd1 vccd1 vccd1 _1130_
+ sky130_fd_sc_hd__and4_1
X_3480_ clknet_leaf_0_clk _0176_ net218 vssd1 vssd1 vccd1 vccd1 SB0.route_sel\[35\]
+ sky130_fd_sc_hd__dfstp_1
X_2431_ _1538_ SB0.route_sel\[70\] SB0.route_sel\[65\] _1541_ _1060_ vssd1 vssd1 vccd1
+ vccd1 _1061_ sky130_fd_sc_hd__a221o_1
X_2362_ _0988_ _0992_ _0993_ CB_0.config_dataB\[17\] CB_0.config_dataB\[18\] vssd1
+ vssd1 vccd1 vccd1 _0994_ sky130_fd_sc_hd__a221o_1
X_2293_ _1578_ _0489_ _0491_ vssd1 vssd1 vccd1 vccd1 _0925_ sky130_fd_sc_hd__or3_1
XTAP_TAPCELL_ROW_39_417 vssd1 vccd1 sky130_fd_sc_hd__tapvpwrvgnd_1
XFILLER_2_62 vssd1 vssd1 vccd1 vccd1 sky130_fd_sc_hd__fill_1
XTAP_TAPCELL_ROW_47_472 vssd1 vccd1 sky130_fd_sc_hd__tapvpwrvgnd_1
XFILLER_24_149 vssd1 vssd1 vccd1 vccd1 sky130_fd_sc_hd__fill_1
XFILLER_24_116 vssd1 vssd1 vccd1 vccd1 sky130_fd_sc_hd__fill_2
XANTENNA_12 net36 vssd1 vssd1 vccd1 vccd1 sky130_fd_sc_hd__diode_2
XANTENNA_23 net108 vssd1 vssd1 vccd1 vccd1 sky130_fd_sc_hd__diode_2
Xoutput130 net130 vssd1 vssd1 vccd1 vccd1 SBwest_out[5] sky130_fd_sc_hd__buf_2
X_2629_ net211 _1254_ _1255_ _1256_ vssd1 vssd1 vccd1 vccd1 _1257_ sky130_fd_sc_hd__a31o_1
XFILLER_47_208 vssd1 vssd1 vccd1 vccd1 sky130_fd_sc_hd__fill_2
XFILLER_23_182 vssd1 vssd1 vccd1 vccd1 sky130_fd_sc_hd__fill_2
X_2980_ LEI0.config_data\[39\] net420 net306 vssd1 vssd1 vccd1 vccd1 _0040_ sky130_fd_sc_hd__mux2_1
XTAP_TAPCELL_ROW_44_453 vssd1 vccd1 sky130_fd_sc_hd__tapvpwrvgnd_1
Xinput21 CBnorth_in[13] vssd1 vssd1 vccd1 vccd1 net21 sky130_fd_sc_hd__buf_2
Xinput32 CBnorth_in[9] vssd1 vssd1 vccd1 vccd1 net32 sky130_fd_sc_hd__buf_2
X_1793_ _0376_ _0426_ vssd1 vssd1 vccd1 vccd1 _0427_ sky130_fd_sc_hd__or2_1
X_1862_ net164 _0483_ net18 vssd1 vssd1 vccd1 vccd1 _0496_ sky130_fd_sc_hd__o21ba_1
Xinput10 CBeast_in[3] vssd1 vssd1 vccd1 vccd1 net10 sky130_fd_sc_hd__buf_2
X_3601_ clknet_leaf_5_clk _0297_ net227 vssd1 vssd1 vccd1 vccd1 CB_0.config_dataB\[3\]
+ sky130_fd_sc_hd__dfstp_1
Xinput54 SBwest_in[14] vssd1 vssd1 vccd1 vccd1 net54 sky130_fd_sc_hd__buf_1
Xinput43 SBsouth_in[4] vssd1 vssd1 vccd1 vccd1 net43 sky130_fd_sc_hd__buf_1
X_1931_ SB0.route_sel\[60\] SB0.route_sel\[61\] net62 _0562_ _0564_ vssd1 vssd1 vccd1
+ vccd1 _0565_ sky130_fd_sc_hd__a41o_1
Xinput65 config_data_in vssd1 vssd1 vccd1 vccd1 net65 sky130_fd_sc_hd__clkbuf_1
X_2414_ net176 net178 vssd1 vssd1 vccd1 vccd1 _1044_ sky130_fd_sc_hd__and2b_1
X_3532_ clknet_leaf_1_clk _0228_ net219 vssd1 vssd1 vccd1 vccd1 SB0.route_sel\[87\]
+ sky130_fd_sc_hd__dfstp_1
X_3394_ clknet_leaf_34_clk _0090_ net215 vssd1 vssd1 vccd1 vccd1 LE_0B.edge_mode sky130_fd_sc_hd__dfstp_1
X_3463_ clknet_leaf_34_clk _0159_ net214 vssd1 vssd1 vccd1 vccd1 SB0.route_sel\[18\]
+ sky130_fd_sc_hd__dfstp_1
X_2276_ net27 net28 net29 net30 CB_0.config_dataB\[5\] CB_0.config_dataB\[6\] vssd1
+ vssd1 vccd1 vccd1 _0908_ sky130_fd_sc_hd__mux4_1
X_2345_ _0939_ _0976_ _0974_ _0941_ vssd1 vssd1 vccd1 vccd1 _0977_ sky130_fd_sc_hd__o211a_1
XFILLER_43_211 vssd1 vssd1 vccd1 vccd1 sky130_fd_sc_hd__fill_1
XFILLER_28_230 vssd1 vssd1 vccd1 vccd1 sky130_fd_sc_hd__fill_2
XTAP_TAPCELL_ROW_41_434 vssd1 vccd1 sky130_fd_sc_hd__tapvpwrvgnd_1
X_2130_ CB_0.config_dataA\[7\] _0763_ vssd1 vssd1 vccd1 vccd1 _0764_ sky130_fd_sc_hd__and2b_1
X_2061_ net136 _0693_ vssd1 vssd1 vccd1 vccd1 _0695_ sky130_fd_sc_hd__nand2_1
X_2963_ net416 net402 net306 vssd1 vssd1 vccd1 vccd1 _0023_ sky130_fd_sc_hd__mux2_1
X_1914_ SB0.route_sel\[68\] _1537_ SB0.route_sel\[71\] _1539_ _0547_ vssd1 vssd1 vccd1
+ vccd1 _0548_ sky130_fd_sc_hd__a221o_1
XFILLER_19_296 vssd1 vssd1 vccd1 vccd1 sky130_fd_sc_hd__fill_1
X_1776_ _1496_ _0406_ _0408_ net199 vssd1 vssd1 vccd1 vccd1 _0410_ sky130_fd_sc_hd__o31a_1
X_1845_ CB_0.config_dataA\[22\] CB_0.config_dataA\[23\] vssd1 vssd1 vccd1 vccd1 _0479_
+ sky130_fd_sc_hd__and2b_2
XFILLER_8_83 vssd1 vssd1 vccd1 vccd1 sky130_fd_sc_hd__fill_1
X_2894_ _1463_ _0622_ vssd1 vssd1 vccd1 vccd1 net129 sky130_fd_sc_hd__and2b_1
X_3515_ clknet_leaf_30_clk _0211_ net226 vssd1 vssd1 vccd1 vccd1 SB0.route_sel\[70\]
+ sky130_fd_sc_hd__dfstp_1
X_2328_ net27 net28 net29 net30 net185 net183 vssd1 vssd1 vccd1 vccd1 _0960_ sky130_fd_sc_hd__mux4_1
X_3377_ clknet_leaf_34_clk _0073_ net215 vssd1 vssd1 vccd1 vccd1 LE_0B.config_data\[0\]
+ sky130_fd_sc_hd__dfrtp_1
X_3446_ clknet_leaf_27_clk _0142_ net224 vssd1 vssd1 vccd1 vccd1 SB0.route_sel\[1\]
+ sky130_fd_sc_hd__dfstp_1
X_2259_ _0889_ _0890_ _1576_ vssd1 vssd1 vccd1 vccd1 _0891_ sky130_fd_sc_hd__mux2_1
XFILLER_25_266 vssd1 vssd1 vccd1 vccd1 sky130_fd_sc_hd__fill_1
XFILLER_43_36 vssd1 vssd1 vccd1 vccd1 sky130_fd_sc_hd__fill_2
XFILLER_4_137 vssd1 vssd1 vccd1 vccd1 sky130_fd_sc_hd__fill_2
XFILLER_4_104 vssd1 vssd1 vccd1 vccd1 sky130_fd_sc_hd__fill_1
XTAP_TAPCELL_ROW_3_170 vssd1 vccd1 sky130_fd_sc_hd__tapvpwrvgnd_1
X_1630_ SB0.route_sel\[26\] vssd1 vssd1 vccd1 vccd1 _1512_ sky130_fd_sc_hd__inv_2
XFILLER_39_325 vssd1 vssd1 vccd1 vccd1 sky130_fd_sc_hd__fill_8
X_3231_ CB_0.config_dataA\[22\] CB_0.config_dataA\[21\] net291 vssd1 vssd1 vccd1 vccd1
+ _0291_ sky130_fd_sc_hd__mux2_1
X_3162_ SB0.route_sel\[81\] SB0.route_sel\[80\] net270 vssd1 vssd1 vccd1 vccd1 _0222_
+ sky130_fd_sc_hd__mux2_1
X_3300_ LE_1B.config_data\[16\] net333 net279 vssd1 vssd1 vccd1 vccd1 _0360_ sky130_fd_sc_hd__mux2_1
X_2113_ _0435_ _0745_ _0746_ _0461_ CB_0.config_dataA\[7\] vssd1 vssd1 vccd1 vccd1
+ _0747_ sky130_fd_sc_hd__o221ai_1
XTAP_TAPCELL_ROW_52_507 vssd1 vccd1 sky130_fd_sc_hd__tapvpwrvgnd_1
X_2044_ net164 _0666_ vssd1 vssd1 vccd1 vccd1 _0678_ sky130_fd_sc_hd__or2_1
XFILLER_39_358 vssd1 vssd1 vccd1 vccd1 sky130_fd_sc_hd__fill_2
X_3093_ SB0.route_sel\[12\] SB0.route_sel\[11\] net264 vssd1 vssd1 vccd1 vccd1 _0153_
+ sky130_fd_sc_hd__mux2_1
X_2946_ net413 LEI0.config_data\[4\] net300 vssd1 vssd1 vccd1 vccd1 _0006_ sky130_fd_sc_hd__mux2_1
XFILLER_30_291 vssd1 vssd1 vccd1 vccd1 sky130_fd_sc_hd__fill_1
X_2877_ SB0.route_sel\[63\] SB0.route_sel\[62\] vssd1 vssd1 vccd1 vccd1 _1452_ sky130_fd_sc_hd__nor2_1
X_1759_ net151 _0372_ _0387_ SB0.route_sel\[121\] SB0.route_sel\[120\] vssd1 vssd1
+ vccd1 vccd1 _0393_ sky130_fd_sc_hd__a32o_1
X_1828_ _0458_ _0460_ vssd1 vssd1 vccd1 vccd1 _0462_ sky130_fd_sc_hd__nand2_1
XTAP_TAPCELL_ROW_9_207 vssd1 vccd1 sky130_fd_sc_hd__tapvpwrvgnd_1
XFILLER_57_111 vssd1 vssd1 vccd1 vccd1 sky130_fd_sc_hd__fill_1
X_3429_ clknet_leaf_23_clk _0125_ net246 vssd1 vssd1 vccd1 vccd1 CB_1.config_dataB\[9\]
+ sky130_fd_sc_hd__dfstp_1
XTAP_TAPCELL_ROW_0_140 vssd1 vccd1 sky130_fd_sc_hd__tapvpwrvgnd_1
XFILLER_5_402 vssd1 vssd1 vccd1 vccd1 sky130_fd_sc_hd__fill_1
XFILLER_9_229 vssd1 vssd1 vccd1 vccd1 sky130_fd_sc_hd__fill_2
XFILLER_0_162 vssd1 vssd1 vccd1 vccd1 sky130_fd_sc_hd__fill_2
XFILLER_48_188 vssd1 vssd1 vccd1 vccd1 sky130_fd_sc_hd__fill_1
X_2800_ _0425_ _0570_ _0626_ vssd1 vssd1 vccd1 vccd1 _1407_ sky130_fd_sc_hd__a21oi_1
X_2731_ net203 _1034_ net202 vssd1 vssd1 vccd1 vccd1 _1359_ sky130_fd_sc_hd__a21bo_1
XTAP_TAPCELL_ROW_14_242 vssd1 vccd1 sky130_fd_sc_hd__tapvpwrvgnd_1
X_1613_ CB_0.config_dataA\[2\] vssd1 vssd1 vccd1 vccd1 _1495_ sky130_fd_sc_hd__inv_2
X_2593_ _1068_ _1106_ _1112_ LE_1A.config_data\[10\] vssd1 vssd1 vccd1 vccd1 _1223_
+ sky130_fd_sc_hd__o211a_1
X_2662_ net209 _1075_ vssd1 vssd1 vccd1 vccd1 _1290_ sky130_fd_sc_hd__or2_1
X_3214_ net197 CB_0.config_dataA\[4\] net292 vssd1 vssd1 vccd1 vccd1 _0274_ sky130_fd_sc_hd__mux2_1
XFILLER_39_111 vssd1 vssd1 vccd1 vccd1 sky130_fd_sc_hd__fill_1
XFILLER_39_100 vssd1 vssd1 vccd1 vccd1 sky130_fd_sc_hd__fill_2
Xfanout219 net220 vssd1 vssd1 vccd1 vccd1 net219 sky130_fd_sc_hd__buf_2
Xfanout208 CB_1.config_dataB\[6\] vssd1 vssd1 vccd1 vccd1 net208 sky130_fd_sc_hd__clkbuf_2
X_3145_ SB0.route_sel\[64\] SB0.route_sel\[63\] net273 vssd1 vssd1 vccd1 vccd1 _0205_
+ sky130_fd_sc_hd__mux2_1
X_2027_ SB0.route_sel\[27\] SB0.route_sel\[26\] _0660_ _1517_ _1516_ vssd1 vssd1 vccd1
+ vccd1 _0661_ sky130_fd_sc_hd__a311o_1
X_3076_ CB_1.config_dataB\[20\] CB_1.config_dataB\[19\] net285 vssd1 vssd1 vccd1 vccd1
+ _0136_ sky130_fd_sc_hd__mux2_1
X_2929_ _1565_ SB0.route_sel\[115\] SB0.route_sel\[116\] _1566_ _1486_ vssd1 vssd1
+ vccd1 vccd1 _1487_ sky130_fd_sc_hd__o221a_1
XFILLER_10_206 vssd1 vssd1 vccd1 vccd1 sky130_fd_sc_hd__fill_2
XTAP_TAPCELL_ROW_20_289 vssd1 vccd1 sky130_fd_sc_hd__tapvpwrvgnd_1
XTAP_TAPCELL_ROW_28_345 vssd1 vccd1 sky130_fd_sc_hd__tapvpwrvgnd_1
XFILLER_60_139 vssd1 vssd1 vccd1 vccd1 sky130_fd_sc_hd__fill_1
XFILLER_53_180 vssd1 vssd1 vccd1 vccd1 sky130_fd_sc_hd__fill_1
XTAP_TAPCELL_ROW_11_223 vssd1 vccd1 sky130_fd_sc_hd__tapvpwrvgnd_1
Xinput8 CBeast_in[1] vssd1 vssd1 vccd1 vccd1 net8 sky130_fd_sc_hd__buf_2
XFILLER_51_139 vssd1 vssd1 vccd1 vccd1 sky130_fd_sc_hd__fill_4
XFILLER_51_117 vssd1 vssd1 vccd1 vccd1 sky130_fd_sc_hd__fill_1
XFILLER_36_114 vssd1 vssd1 vccd1 vccd1 sky130_fd_sc_hd__fill_2
X_2714_ CB_1.config_dataB\[14\] _1310_ _1330_ _1338_ _1340_ vssd1 vssd1 vccd1 vccd1
+ _1342_ sky130_fd_sc_hd__a311o_1
X_2645_ LEI0.config_data\[11\] _1270_ _1272_ _1268_ vssd1 vssd1 vccd1 vccd1 _1273_
+ sky130_fd_sc_hd__o31a_2
X_2576_ net168 _1030_ _1205_ net167 vssd1 vssd1 vccd1 vccd1 _1206_ sky130_fd_sc_hd__o211a_1
XFILLER_10_29 vssd1 vssd1 vccd1 vccd1 sky130_fd_sc_hd__fill_2
X_3128_ SB0.route_sel\[47\] SB0.route_sel\[46\] net266 vssd1 vssd1 vccd1 vccd1 _0188_
+ sky130_fd_sc_hd__mux2_1
XFILLER_19_16 vssd1 vssd1 vccd1 vccd1 sky130_fd_sc_hd__fill_1
XFILLER_19_49 vssd1 vssd1 vccd1 vccd1 sky130_fd_sc_hd__fill_1
XFILLER_42_128 vssd1 vssd1 vccd1 vccd1 sky130_fd_sc_hd__fill_1
X_3059_ CB_1.config_dataB\[3\] CB_1.config_dataB\[2\] net284 vssd1 vssd1 vccd1 vccd1
+ _0119_ sky130_fd_sc_hd__mux2_1
XFILLER_27_169 vssd1 vssd1 vccd1 vccd1 sky130_fd_sc_hd__fill_8
X_2361_ net27 net28 net29 net30 net182 CB_0.config_dataB\[16\] vssd1 vssd1 vccd1 vccd1
+ _0993_ sky130_fd_sc_hd__mux4_1
X_2430_ SB0.route_sel\[68\] SB0.route_sel\[69\] vssd1 vssd1 vccd1 vccd1 _1060_ sky130_fd_sc_hd__nor2_1
XTAP_TAPCELL_ROW_39_418 vssd1 vccd1 sky130_fd_sc_hd__tapvpwrvgnd_1
X_2292_ _0461_ _0907_ _0921_ _0922_ _0923_ vssd1 vssd1 vccd1 vccd1 _0924_ sky130_fd_sc_hd__o221a_1
XTAP_TAPCELL_ROW_47_473 vssd1 vccd1 sky130_fd_sc_hd__tapvpwrvgnd_1
XANTENNA_13 net37 vssd1 vssd1 vccd1 vccd1 sky130_fd_sc_hd__diode_2
XFILLER_21_28 vssd1 vssd1 vccd1 vccd1 sky130_fd_sc_hd__fill_2
Xoutput120 net120 vssd1 vssd1 vccd1 vccd1 SBwest_out[10] sky130_fd_sc_hd__buf_2
Xoutput131 net131 vssd1 vssd1 vccd1 vccd1 SBwest_out[6] sky130_fd_sc_hd__buf_2
X_2628_ _1062_ _1240_ _1242_ _1065_ CB_1.config_dataB\[2\] vssd1 vssd1 vccd1 vccd1
+ _1256_ sky130_fd_sc_hd__a221o_1
X_2559_ LE_1A.config_data\[13\] _1113_ _1151_ _1188_ vssd1 vssd1 vccd1 vccd1 _1189_
+ sky130_fd_sc_hd__a211o_1
XFILLER_15_128 vssd1 vssd1 vccd1 vccd1 sky130_fd_sc_hd__fill_1
XTAP_TAPCELL_ROW_44_454 vssd1 vccd1 sky130_fd_sc_hd__tapvpwrvgnd_1
XFILLER_36_91 vssd1 vssd1 vccd1 vccd1 sky130_fd_sc_hd__fill_2
X_1930_ _0563_ _1531_ SB0.route_sel\[59\] vssd1 vssd1 vccd1 vccd1 _0564_ sky130_fd_sc_hd__or3b_1
Xinput66 config_en vssd1 vssd1 vccd1 vccd1 net66 sky130_fd_sc_hd__clkbuf_1
Xinput22 CBnorth_in[14] vssd1 vssd1 vccd1 vccd1 net22 sky130_fd_sc_hd__buf_2
X_1792_ CB_0.config_dataB\[21\] CB_0.config_dataB\[20\] CB_0.config_dataB\[24\] vssd1
+ vssd1 vccd1 vccd1 _0426_ sky130_fd_sc_hd__or3_2
X_1861_ net164 _0483_ vssd1 vssd1 vccd1 vccd1 _0495_ sky130_fd_sc_hd__or2_1
Xinput11 CBeast_in[4] vssd1 vssd1 vccd1 vccd1 net11 sky130_fd_sc_hd__buf_2
Xinput55 SBwest_in[15] vssd1 vssd1 vccd1 vccd1 net55 sky130_fd_sc_hd__buf_1
X_3600_ clknet_leaf_5_clk _0296_ net227 vssd1 vssd1 vccd1 vccd1 CB_0.config_dataB\[2\]
+ sky130_fd_sc_hd__dfstp_1
X_3531_ clknet_leaf_1_clk _0227_ net221 vssd1 vssd1 vccd1 vccd1 SB0.route_sel\[86\]
+ sky130_fd_sc_hd__dfstp_1
Xinput44 SBsouth_in[5] vssd1 vssd1 vccd1 vccd1 net44 sky130_fd_sc_hd__buf_1
Xinput33 SBsouth_in[0] vssd1 vssd1 vccd1 vccd1 net33 sky130_fd_sc_hd__clkbuf_1
X_2344_ LE_0B.config_data\[0\] LE_0B.config_data\[1\] _0905_ vssd1 vssd1 vccd1 vccd1
+ _0976_ sky130_fd_sc_hd__mux2_1
X_2413_ _1042_ _0458_ vssd1 vssd1 vccd1 vccd1 _1043_ sky130_fd_sc_hd__and2b_2
X_3393_ clknet_leaf_1_clk _0089_ net219 vssd1 vssd1 vccd1 vccd1 LE_0B.config_data\[16\]
+ sky130_fd_sc_hd__dfrtp_2
XFILLER_29_209 vssd1 vssd1 vccd1 vccd1 sky130_fd_sc_hd__fill_4
X_3462_ clknet_leaf_35_clk _0158_ net214 vssd1 vssd1 vccd1 vccd1 SB0.route_sel\[17\]
+ sky130_fd_sc_hd__dfstp_1
XFILLER_37_253 vssd1 vssd1 vccd1 vccd1 sky130_fd_sc_hd__fill_2
X_2275_ net186 _1579_ vssd1 vssd1 vccd1 vccd1 _0907_ sky130_fd_sc_hd__nand2_1
XFILLER_32_27 vssd1 vssd1 vccd1 vccd1 sky130_fd_sc_hd__fill_1
XFILLER_20_120 vssd1 vssd1 vccd1 vccd1 sky130_fd_sc_hd__fill_2
XFILLER_20_197 vccd1 vssd1 vccd1 vssd1 sky130_ef_sc_hd__decap_40_12
XFILLER_28_253 vssd1 vssd1 vccd1 vccd1 sky130_fd_sc_hd__fill_4
XTAP_TAPCELL_ROW_41_435 vssd1 vccd1 sky130_fd_sc_hd__tapvpwrvgnd_1
XFILLER_11_186 vssd1 vssd1 vccd1 vccd1 sky130_fd_sc_hd__fill_2
X_2060_ net136 _0693_ vssd1 vssd1 vccd1 vccd1 _0694_ sky130_fd_sc_hd__and2_1
XTAP_TAPCELL_ROW_6_190 vssd1 vccd1 sky130_fd_sc_hd__tapvpwrvgnd_1
XFILLER_14_6 vssd1 vssd1 vccd1 vccd1 sky130_fd_sc_hd__fill_1
XFILLER_19_253 vssd1 vssd1 vccd1 vccd1 sky130_fd_sc_hd__fill_2
XFILLER_19_264 vssd1 vssd1 vccd1 vccd1 sky130_fd_sc_hd__fill_8
X_2962_ net402 net386 net305 vssd1 vssd1 vccd1 vccd1 _0022_ sky130_fd_sc_hd__mux2_1
X_1913_ SB0.route_sel\[67\] SB0.route_sel\[66\] vssd1 vssd1 vccd1 vccd1 _0547_ sky130_fd_sc_hd__nor2_1
X_2893_ SB0.route_sel\[36\] _1518_ SB0.route_sel\[33\] SB0.route_sel\[32\] _1462_
+ vssd1 vssd1 vccd1 vccd1 _1463_ sky130_fd_sc_hd__o221a_1
X_1775_ _0406_ _0408_ vssd1 vssd1 vccd1 vccd1 _0409_ sky130_fd_sc_hd__nor2_2
X_1844_ SB0.route_sel\[91\] SB0.route_sel\[90\] _0476_ _1553_ vssd1 vssd1 vccd1 vccd1
+ _0478_ sky130_fd_sc_hd__a31oi_2
X_3445_ clknet_leaf_28_clk _0141_ net239 vssd1 vssd1 vccd1 vccd1 SB0.route_sel\[0\]
+ sky130_fd_sc_hd__dfstp_1
X_3514_ clknet_leaf_30_clk _0210_ net226 vssd1 vssd1 vccd1 vccd1 SB0.route_sel\[69\]
+ sky130_fd_sc_hd__dfstp_1
X_2327_ _0946_ _0645_ _0626_ _0944_ vssd1 vssd1 vccd1 vccd1 _0959_ sky130_fd_sc_hd__a2bb2o_1
X_2258_ net31 net32 net18 net19 net188 net187 vssd1 vssd1 vccd1 vccd1 _0890_ sky130_fd_sc_hd__mux4_1
X_3376_ LE_1A.sel_clk _0072_ net69 vssd1 vssd1 vccd1 vccd1 LE_1A.dff1_out sky130_fd_sc_hd__dfstp_1
X_2189_ CB_0.config_dataA\[16\] net192 vssd1 vssd1 vccd1 vccd1 _0823_ sky130_fd_sc_hd__and2b_1
XFILLER_25_223 vssd1 vssd1 vccd1 vccd1 sky130_fd_sc_hd__fill_1
X_2112_ net196 net198 vssd1 vssd1 vccd1 vccd1 _0746_ sky130_fd_sc_hd__nand2b_1
X_3230_ CB_0.config_dataA\[21\] CB_0.config_dataA\[20\] net296 vssd1 vssd1 vccd1 vccd1
+ _0290_ sky130_fd_sc_hd__mux2_1
X_3161_ SB0.route_sel\[80\] SB0.route_sel\[79\] net270 vssd1 vssd1 vccd1 vccd1 _0221_
+ sky130_fd_sc_hd__mux2_1
XFILLER_12_3 vssd1 vssd1 vccd1 vccd1 sky130_fd_sc_hd__fill_1
XTAP_TAPCELL_ROW_52_508 vssd1 vccd1 sky130_fd_sc_hd__tapvpwrvgnd_1
X_2043_ _0371_ _0663_ vssd1 vssd1 vccd1 vccd1 _0677_ sky130_fd_sc_hd__nor2_1
X_3092_ SB0.route_sel\[11\] SB0.route_sel\[10\] net261 vssd1 vssd1 vccd1 vccd1 _0152_
+ sky130_fd_sc_hd__mux2_1
XTAP_TAPCELL_ROW_17_262 vssd1 vccd1 sky130_fd_sc_hd__tapvpwrvgnd_1
XTAP_TAPCELL_ROW_60_563 vssd1 vccd1 sky130_fd_sc_hd__tapvpwrvgnd_1
X_2945_ net426 LEI0.config_data\[3\] net300 vssd1 vssd1 vccd1 vccd1 _0005_ sky130_fd_sc_hd__mux2_1
X_1827_ _0458_ _0460_ vssd1 vssd1 vccd1 vccd1 _0461_ sky130_fd_sc_hd__and2_2
XFILLER_30_281 vssd1 vssd1 vccd1 vccd1 sky130_fd_sc_hd__fill_8
X_2876_ _0578_ _1451_ vssd1 vssd1 vccd1 vccd1 net132 sky130_fd_sc_hd__nor2_1
X_1758_ net147 _0376_ net163 vssd1 vssd1 vccd1 vccd1 _0392_ sky130_fd_sc_hd__or3b_1
X_1689_ SB0.route_sel\[121\] vssd1 vssd1 vccd1 vccd1 _1571_ sky130_fd_sc_hd__inv_2
XTAP_TAPCELL_ROW_9_208 vssd1 vccd1 sky130_fd_sc_hd__tapvpwrvgnd_1
X_3428_ clknet_leaf_23_clk _0124_ net246 vssd1 vssd1 vccd1 vccd1 CB_1.config_dataB\[8\]
+ sky130_fd_sc_hd__dfstp_1
X_3359_ clknet_leaf_7_clk _0055_ net231 vssd1 vssd1 vccd1 vccd1 LE_0A.config_data\[4\]
+ sky130_fd_sc_hd__dfrtp_1
XFILLER_57_167 vssd1 vssd1 vccd1 vccd1 sky130_fd_sc_hd__fill_1
XFILLER_45_329 vssd1 vssd1 vccd1 vccd1 sky130_fd_sc_hd__fill_2
XTAP_TAPCELL_ROW_0_141 vssd1 vccd1 sky130_fd_sc_hd__tapvpwrvgnd_1
XFILLER_36_307 vssd1 vssd1 vccd1 vccd1 sky130_fd_sc_hd__fill_1
X_2730_ net203 _1030_ vssd1 vssd1 vccd1 vccd1 _1358_ sky130_fd_sc_hd__nor2_1
X_2661_ _1286_ _1287_ _1288_ vssd1 vssd1 vccd1 vccd1 _1289_ sky130_fd_sc_hd__o21a_1
XTAP_TAPCELL_ROW_14_243 vssd1 vccd1 sky130_fd_sc_hd__tapvpwrvgnd_1
X_1612_ CB_0.config_dataA\[3\] vssd1 vssd1 vccd1 vccd1 _1494_ sky130_fd_sc_hd__inv_2
X_2592_ CB_1.config_dataA\[19\] _1204_ _1217_ _1220_ vssd1 vssd1 vccd1 vccd1 _1222_
+ sky130_fd_sc_hd__o31ai_1
Xfanout209 CB_1.config_dataB\[5\] vssd1 vssd1 vccd1 vccd1 net209 sky130_fd_sc_hd__buf_2
XTAP_TAPCELL_ROW_65_600 vssd1 vccd1 sky130_fd_sc_hd__tapvpwrvgnd_1
X_3213_ CB_0.config_dataA\[4\] net311 net295 vssd1 vssd1 vccd1 vccd1 _0273_ sky130_fd_sc_hd__mux2_1
XFILLER_39_167 vssd1 vssd1 vccd1 vccd1 sky130_fd_sc_hd__fill_1
XFILLER_39_156 vssd1 vssd1 vccd1 vccd1 sky130_fd_sc_hd__fill_1
X_3075_ CB_1.config_dataB\[19\] CB_1.config_dataB\[18\] net284 vssd1 vssd1 vccd1 vccd1
+ _0135_ sky130_fd_sc_hd__mux2_1
X_3144_ SB0.route_sel\[63\] SB0.route_sel\[62\] net273 vssd1 vssd1 vccd1 vccd1 _0204_
+ sky130_fd_sc_hd__mux2_1
XFILLER_54_137 vssd1 vssd1 vccd1 vccd1 sky130_fd_sc_hd__fill_2
X_2026_ SB0.route_sel\[28\] SB0.route_sel\[29\] net58 _0656_ _0657_ vssd1 vssd1 vccd1
+ vccd1 _0660_ sky130_fd_sc_hd__a41o_1
X_2928_ SB0.route_sel\[112\] SB0.route_sel\[113\] vssd1 vssd1 vccd1 vccd1 _1486_ sky130_fd_sc_hd__or2_1
XFILLER_40_27 vssd1 vssd1 vccd1 vccd1 sky130_fd_sc_hd__fill_1
X_2859_ SB0.route_sel\[87\] SB0.route_sel\[86\] vssd1 vssd1 vccd1 vccd1 _1440_ sky130_fd_sc_hd__nor2_1
XPHY_EDGE_ROW_17_Left_85 vssd1 vssd1 vccd1 vccd1 sky130_fd_sc_hd__decap_3
XFILLER_65_57 vssd1 vssd1 vccd1 vccd1 sky130_fd_sc_hd__fill_1
XFILLER_53_192 vssd1 vssd1 vccd1 vccd1 sky130_fd_sc_hd__fill_2
XTAP_TAPCELL_ROW_11_224 vssd1 vccd1 sky130_fd_sc_hd__tapvpwrvgnd_1
XFILLER_14_94 vssd1 vssd1 vccd1 vccd1 sky130_fd_sc_hd__fill_4
Xinput9 CBeast_in[2] vssd1 vssd1 vccd1 vccd1 net9 sky130_fd_sc_hd__buf_2
X_2644_ LEI0.config_data\[9\] net143 _1271_ LEI0.config_data\[10\] vssd1 vssd1 vccd1
+ vccd1 _1272_ sky130_fd_sc_hd__o211a_1
X_2713_ CB_1.config_dataB\[14\] _1310_ _1330_ _1338_ _1340_ vssd1 vssd1 vccd1 vccd1
+ _1341_ sky130_fd_sc_hd__a311oi_2
X_2575_ net168 _1034_ vssd1 vssd1 vccd1 vccd1 _1205_ sky130_fd_sc_hd__nand2_1
XFILLER_55_402 vssd1 vssd1 vccd1 vccd1 sky130_fd_sc_hd__fill_1
X_3058_ CB_1.config_dataB\[2\] net211 net284 vssd1 vssd1 vccd1 vccd1 _0118_ sky130_fd_sc_hd__mux2_1
XFILLER_27_159 vssd1 vssd1 vccd1 vccd1 sky130_fd_sc_hd__fill_8
XFILLER_27_126 vssd1 vssd1 vccd1 vccd1 sky130_fd_sc_hd__fill_4
X_3127_ SB0.route_sel\[46\] SB0.route_sel\[45\] net266 vssd1 vssd1 vccd1 vccd1 _0187_
+ sky130_fd_sc_hd__mux2_1
XFILLER_51_15 vssd1 vssd1 vccd1 vccd1 sky130_fd_sc_hd__fill_2
XFILLER_50_195 vssd1 vssd1 vccd1 vccd1 sky130_fd_sc_hd__fill_1
XFILLER_50_184 vssd1 vssd1 vccd1 vccd1 sky130_fd_sc_hd__fill_2
X_2009_ SB0.route_sel\[43\] SB0.route_sel\[42\] vssd1 vssd1 vccd1 vccd1 _0643_ sky130_fd_sc_hd__nor2_1
XFILLER_58_273 vssd1 vssd1 vccd1 vccd1 sky130_fd_sc_hd__fill_1
X_2360_ net24 _0984_ _0989_ _0991_ vssd1 vssd1 vccd1 vccd1 _0992_ sky130_fd_sc_hd__a211o_1
X_2291_ _0432_ _0434_ _0906_ vssd1 vssd1 vccd1 vccd1 _0923_ sky130_fd_sc_hd__a21o_1
XTAP_TAPCELL_ROW_39_419 vssd1 vccd1 sky130_fd_sc_hd__tapvpwrvgnd_1
XFILLER_37_402 vssd1 vssd1 vccd1 vccd1 sky130_fd_sc_hd__fill_1
XPHY_EDGE_ROW_10_Right_10 vssd1 vssd1 vccd1 vccd1 sky130_fd_sc_hd__decap_3
XTAP_TAPCELL_ROW_47_474 vssd1 vccd1 sky130_fd_sc_hd__tapvpwrvgnd_1
XFILLER_32_195 vssd1 vssd1 vccd1 vccd1 sky130_fd_sc_hd__fill_1
XFILLER_24_118 vssd1 vssd1 vccd1 vccd1 sky130_fd_sc_hd__fill_1
XANTENNA_14 net40 vssd1 vssd1 vccd1 vccd1 sky130_fd_sc_hd__diode_2
XFILLER_17_181 vssd1 vssd1 vccd1 vccd1 sky130_fd_sc_hd__fill_2
Xoutput121 net121 vssd1 vssd1 vccd1 vccd1 SBwest_out[11] sky130_fd_sc_hd__buf_2
Xoutput132 net132 vssd1 vssd1 vccd1 vccd1 SBwest_out[7] sky130_fd_sc_hd__buf_2
X_2627_ net212 _1058_ vssd1 vssd1 vccd1 vccd1 _1255_ sky130_fd_sc_hd__or2_1
Xoutput110 net110 vssd1 vssd1 vccd1 vccd1 SBsouth_out[1] sky130_fd_sc_hd__buf_2
X_2489_ _1118_ vssd1 vssd1 vccd1 vccd1 _1119_ sky130_fd_sc_hd__inv_2
XPHY_EDGE_ROW_34_Left_102 vssd1 vssd1 vccd1 vccd1 sky130_fd_sc_hd__decap_3
X_2558_ _1068_ _1106_ _1112_ LE_1A.config_data\[12\] vssd1 vssd1 vccd1 vccd1 _1188_
+ sky130_fd_sc_hd__o211a_1
XFILLER_55_221 vssd1 vssd1 vccd1 vccd1 sky130_fd_sc_hd__fill_1
XFILLER_55_210 vssd1 vssd1 vccd1 vccd1 sky130_fd_sc_hd__fill_2
XPHY_EDGE_ROW_43_Left_111 vssd1 vssd1 vccd1 vccd1 sky130_fd_sc_hd__decap_3
Xclkbuf_leaf_35_clk clknet_2_0__leaf_clk vssd1 vssd1 vccd1 vccd1 clknet_leaf_35_clk
+ sky130_fd_sc_hd__clkbuf_8
XFILLER_15_107 vssd1 vssd1 vccd1 vccd1 sky130_fd_sc_hd__fill_2
XFILLER_23_195 vssd1 vssd1 vccd1 vccd1 sky130_fd_sc_hd__fill_2
XPHY_EDGE_ROW_52_Left_120 vssd1 vssd1 vccd1 vccd1 sky130_fd_sc_hd__decap_3
XFILLER_46_210 vssd1 vssd1 vccd1 vccd1 sky130_fd_sc_hd__fill_2
XFILLER_19_402 vssd1 vssd1 vccd1 vccd1 sky130_fd_sc_hd__fill_1
XFILLER_61_279 vssd1 vssd1 vccd1 vccd1 sky130_fd_sc_hd__fill_1
XTAP_TAPCELL_ROW_44_455 vssd1 vccd1 sky130_fd_sc_hd__tapvpwrvgnd_1
X_1860_ _0371_ _0480_ vssd1 vssd1 vccd1 vccd1 _0494_ sky130_fd_sc_hd__nor2_1
Xclkbuf_leaf_26_clk clknet_2_2__leaf_clk vssd1 vssd1 vccd1 vccd1 clknet_leaf_26_clk
+ sky130_fd_sc_hd__clkbuf_8
XFILLER_14_195 vssd1 vssd1 vccd1 vccd1 sky130_fd_sc_hd__fill_1
Xinput23 CBnorth_in[15] vssd1 vssd1 vccd1 vccd1 net23 sky130_fd_sc_hd__buf_2
X_1791_ CB_0.config_dataB\[21\] CB_0.config_dataB\[20\] CB_0.config_dataB\[24\] vssd1
+ vssd1 vccd1 vccd1 _0425_ sky130_fd_sc_hd__nor3_4
Xinput12 CBeast_in[5] vssd1 vssd1 vccd1 vccd1 net12 sky130_fd_sc_hd__buf_2
X_3530_ clknet_leaf_1_clk _0226_ net221 vssd1 vssd1 vccd1 vccd1 SB0.route_sel\[85\]
+ sky130_fd_sc_hd__dfstp_1
X_3461_ clknet_leaf_34_clk _0157_ net215 vssd1 vssd1 vccd1 vccd1 SB0.route_sel\[16\]
+ sky130_fd_sc_hd__dfstp_1
Xinput56 SBwest_in[1] vssd1 vssd1 vccd1 vccd1 net56 sky130_fd_sc_hd__clkbuf_1
Xinput34 SBsouth_in[10] vssd1 vssd1 vccd1 vccd1 net34 sky130_fd_sc_hd__dlymetal6s2s_1
Xinput67 le_clk vssd1 vssd1 vccd1 vccd1 net67 sky130_fd_sc_hd__buf_2
Xinput45 SBsouth_in[6] vssd1 vssd1 vccd1 vccd1 net45 sky130_fd_sc_hd__buf_1
X_2343_ CB_0.config_dataB\[14\] _0956_ _0967_ _0973_ vssd1 vssd1 vccd1 vccd1 _0975_
+ sky130_fd_sc_hd__o31ai_2
X_2274_ net186 CB_0.config_dataB\[6\] vssd1 vssd1 vccd1 vccd1 _0906_ sky130_fd_sc_hd__or2_1
X_2412_ SB0.route_sel\[111\] _1563_ SB0.route_sel\[104\] _1564_ _1041_ vssd1 vssd1
+ vccd1 vccd1 _1042_ sky130_fd_sc_hd__o221a_1
X_3392_ clknet_leaf_1_clk _0088_ net227 vssd1 vssd1 vccd1 vccd1 LE_0B.config_data\[15\]
+ sky130_fd_sc_hd__dfrtp_1
Xclkbuf_leaf_17_clk clknet_2_3__leaf_clk vssd1 vssd1 vccd1 vccd1 clknet_leaf_17_clk
+ sky130_fd_sc_hd__clkbuf_8
XFILLER_16_29 vssd1 vssd1 vccd1 vccd1 sky130_fd_sc_hd__fill_2
X_1989_ SB0.route_sel\[35\] SB0.route_sel\[34\] vssd1 vssd1 vccd1 vccd1 _0623_ sky130_fd_sc_hd__nor2_1
X_3659_ clknet_leaf_25_clk _0355_ net242 vssd1 vssd1 vccd1 vccd1 LE_1B.config_data\[11\]
+ sky130_fd_sc_hd__dfrtp_1
XTAP_TAPCELL_ROW_41_436 vssd1 vccd1 sky130_fd_sc_hd__tapvpwrvgnd_1
XFILLER_28_276 vssd1 vssd1 vccd1 vccd1 sky130_fd_sc_hd__fill_2
XFILLER_11_110 vssd1 vssd1 vccd1 vccd1 sky130_fd_sc_hd__fill_2
XFILLER_7_158 vssd1 vssd1 vccd1 vccd1 sky130_fd_sc_hd__fill_4
XPHY_EDGE_ROW_5_Left_73 vssd1 vssd1 vccd1 vccd1 sky130_fd_sc_hd__decap_3
XTAP_TAPCELL_ROW_6_191 vssd1 vccd1 sky130_fd_sc_hd__tapvpwrvgnd_1
X_2961_ net386 LEI0.config_data\[19\] net304 vssd1 vssd1 vccd1 vccd1 _0021_ sky130_fd_sc_hd__mux2_1
X_1843_ SB0.route_sel\[91\] SB0.route_sel\[90\] _0470_ _0472_ _0473_ vssd1 vssd1 vccd1
+ vccd1 _0477_ sky130_fd_sc_hd__a221o_1
XFILLER_8_85 vssd1 vssd1 vccd1 vccd1 sky130_fd_sc_hd__fill_2
X_2892_ SB0.route_sel\[35\] SB0.route_sel\[34\] vssd1 vssd1 vccd1 vccd1 _1462_ sky130_fd_sc_hd__nand2b_1
X_1912_ _1540_ _0536_ _0540_ _0545_ _1502_ vssd1 vssd1 vccd1 vccd1 _0546_ sky130_fd_sc_hd__o311a_2
Xclkbuf_leaf_6_clk clknet_2_1__leaf_clk vssd1 vssd1 vccd1 vccd1 clknet_leaf_6_clk
+ sky130_fd_sc_hd__clkbuf_8
X_1774_ SB0.route_sel\[122\] SB0.route_sel\[123\] _1570_ SB0.route_sel\[125\] _0407_
+ vssd1 vssd1 vccd1 vccd1 _0408_ sky130_fd_sc_hd__o221a_1
X_3444_ clknet_leaf_28_clk _0140_ net238 vssd1 vssd1 vccd1 vccd1 CB_1.config_dataB\[24\]
+ sky130_fd_sc_hd__dfstp_1
X_3513_ clknet_leaf_30_clk _0209_ net226 vssd1 vssd1 vccd1 vccd1 SB0.route_sel\[68\]
+ sky130_fd_sc_hd__dfstp_1
X_2326_ net184 _0603_ _0957_ net183 vssd1 vssd1 vccd1 vccd1 _0958_ sky130_fd_sc_hd__o211a_1
X_2257_ net20 net21 net22 net23 net188 net187 vssd1 vssd1 vccd1 vccd1 _0889_ sky130_fd_sc_hd__mux4_1
X_3375_ LE_0B.sel_clk _0071_ net69 vssd1 vssd1 vccd1 vccd1 LE_0B.dff0_out sky130_fd_sc_hd__dfrtp_1
XFILLER_65_393 vssd1 vssd1 vccd1 vccd1 sky130_fd_sc_hd__fill_1
X_2188_ net191 net190 vssd1 vssd1 vccd1 vccd1 _0822_ sky130_fd_sc_hd__or2_1
XTAP_TAPCELL_ROW_55_528 vssd1 vccd1 sky130_fd_sc_hd__tapvpwrvgnd_1
XFILLER_25_279 vssd1 vssd1 vccd1 vccd1 sky130_fd_sc_hd__fill_1
XFILLER_25_202 vccd1 vssd1 vccd1 vssd1 sky130_ef_sc_hd__decap_40_12
XFILLER_4_139 vssd1 vssd1 vccd1 vccd1 sky130_fd_sc_hd__fill_1
XPHY_EDGE_ROW_31_Left_99 vssd1 vssd1 vccd1 vccd1 sky130_fd_sc_hd__decap_3
XFILLER_33_71 vssd1 vssd1 vccd1 vccd1 sky130_fd_sc_hd__fill_1
X_2111_ net197 net196 vssd1 vssd1 vccd1 vccd1 _0745_ sky130_fd_sc_hd__or2_1
Xhold1 CB_0.config_dataA\[3\] vssd1 vssd1 vccd1 vccd1 net311 sky130_fd_sc_hd__dlygate4sd3_1
X_3091_ SB0.route_sel\[10\] SB0.route_sel\[9\] net261 vssd1 vssd1 vccd1 vccd1 _0151_
+ sky130_fd_sc_hd__mux2_1
X_2042_ SB0.route_sel\[16\] SB0.route_sel\[17\] vssd1 vssd1 vccd1 vccd1 _0676_ sky130_fd_sc_hd__nand2_1
X_3160_ SB0.route_sel\[79\] SB0.route_sel\[78\] net269 vssd1 vssd1 vccd1 vccd1 _0220_
+ sky130_fd_sc_hd__mux2_1
XTAP_TAPCELL_ROW_52_509 vssd1 vccd1 sky130_fd_sc_hd__tapvpwrvgnd_1
XPHY_EDGE_ROW_8_Right_8 vssd1 vssd1 vccd1 vccd1 sky130_fd_sc_hd__decap_3
XTAP_TAPCELL_ROW_17_263 vssd1 vccd1 sky130_fd_sc_hd__tapvpwrvgnd_1
XTAP_TAPCELL_ROW_60_564 vssd1 vccd1 sky130_fd_sc_hd__tapvpwrvgnd_1
X_2944_ LEI0.config_data\[3\] LEI0.config_data\[2\] net300 vssd1 vssd1 vccd1 vccd1
+ _0004_ sky130_fd_sc_hd__mux2_1
X_1826_ SB0.route_sel\[108\] _1562_ SB0.route_sel\[111\] _1563_ _0459_ vssd1 vssd1
+ vccd1 vccd1 _0460_ sky130_fd_sc_hd__a221o_1
X_2875_ SB0.route_sel\[59\] _1531_ SB0.route_sel\[60\] _1532_ _1450_ vssd1 vssd1 vccd1
+ vccd1 _1451_ sky130_fd_sc_hd__o221a_1
X_3358_ clknet_leaf_7_clk _0054_ net231 vssd1 vssd1 vccd1 vccd1 LE_0A.config_data\[3\]
+ sky130_fd_sc_hd__dfrtp_1
X_1757_ net179 CB_0.config_dataB\[22\] _0389_ net23 vssd1 vssd1 vccd1 vccd1 _0391_
+ sky130_fd_sc_hd__a31o_1
XPHY_EDGE_ROW_39_Right_39 vssd1 vssd1 vccd1 vccd1 sky130_fd_sc_hd__decap_3
X_1688_ SB0.route_sel\[124\] vssd1 vssd1 vccd1 vccd1 _1570_ sky130_fd_sc_hd__inv_2
XTAP_TAPCELL_ROW_9_209 vssd1 vccd1 sky130_fd_sc_hd__tapvpwrvgnd_1
X_3427_ clknet_leaf_22_clk _0123_ net246 vssd1 vssd1 vccd1 vccd1 CB_1.config_dataB\[7\]
+ sky130_fd_sc_hd__dfstp_1
XFILLER_57_113 vssd1 vssd1 vccd1 vccd1 sky130_fd_sc_hd__fill_1
X_2309_ LE_0B.config_data\[3\] _0905_ _0938_ _0940_ vssd1 vssd1 vccd1 vccd1 _0941_
+ sky130_fd_sc_hd__a211o_1
XTAP_TAPCELL_ROW_0_142 vssd1 vccd1 sky130_fd_sc_hd__tapvpwrvgnd_1
X_3289_ net357 net347 net281 vssd1 vssd1 vccd1 vccd1 _0349_ sky130_fd_sc_hd__mux2_1
XPHY_EDGE_ROW_48_Right_48 vssd1 vssd1 vccd1 vccd1 sky130_fd_sc_hd__decap_3
XPHY_EDGE_ROW_57_Right_57 vssd1 vssd1 vccd1 vccd1 sky130_fd_sc_hd__decap_3
XPHY_EDGE_ROW_66_Right_66 vssd1 vssd1 vccd1 vccd1 sky130_fd_sc_hd__decap_3
XFILLER_48_179 vssd1 vssd1 vccd1 vccd1 sky130_fd_sc_hd__fill_2
XFILLER_44_330 vssd1 vssd1 vccd1 vccd1 sky130_fd_sc_hd__fill_1
XFILLER_29_393 vssd1 vssd1 vccd1 vccd1 sky130_fd_sc_hd__fill_2
X_2660_ _1038_ _1278_ _1280_ _1043_ CB_1.config_dataB\[7\] vssd1 vssd1 vccd1 vccd1
+ _1288_ sky130_fd_sc_hd__o221a_1
XTAP_TAPCELL_ROW_14_244 vssd1 vccd1 sky130_fd_sc_hd__tapvpwrvgnd_1
X_3212_ CB_0.config_dataA\[3\] CB_0.config_dataA\[2\] net295 vssd1 vssd1 vccd1 vccd1
+ _0272_ sky130_fd_sc_hd__mux2_1
X_2591_ CB_1.config_dataA\[19\] _1204_ _1217_ _1220_ vssd1 vssd1 vccd1 vccd1 _1221_
+ sky130_fd_sc_hd__o31a_1
XTAP_TAPCELL_ROW_65_601 vssd1 vccd1 sky130_fd_sc_hd__tapvpwrvgnd_1
XFILLER_54_105 vssd1 vssd1 vccd1 vccd1 sky130_fd_sc_hd__fill_4
XFILLER_39_113 vssd1 vssd1 vccd1 vccd1 sky130_fd_sc_hd__fill_2
X_3074_ CB_1.config_dataB\[18\] CB_1.config_dataB\[17\] net284 vssd1 vssd1 vccd1 vccd1
+ _0134_ sky130_fd_sc_hd__mux2_1
X_2025_ _0652_ _0655_ _0658_ vssd1 vssd1 vccd1 vccd1 _0659_ sky130_fd_sc_hd__a21oi_1
X_3143_ SB0.route_sel\[62\] SB0.route_sel\[61\] net273 vssd1 vssd1 vccd1 vccd1 _0203_
+ sky130_fd_sc_hd__mux2_1
XFILLER_62_160 vssd1 vssd1 vccd1 vccd1 sky130_fd_sc_hd__fill_1
X_2927_ _0406_ _1485_ vssd1 vssd1 vccd1 vccd1 net109 sky130_fd_sc_hd__nor2_1
XFILLER_24_18 vssd1 vssd1 vccd1 vccd1 sky130_fd_sc_hd__fill_4
X_2789_ net148 _0532_ _0523_ vssd1 vssd1 vccd1 vccd1 _1401_ sky130_fd_sc_hd__mux2_1
X_2858_ _0508_ _1439_ vssd1 vssd1 vccd1 vccd1 net120 sky130_fd_sc_hd__nor2_1
X_1809_ net144 _1611_ _0441_ vssd1 vssd1 vccd1 vccd1 _0443_ sky130_fd_sc_hd__or3_1
XFILLER_41_311 vssd1 vssd1 vccd1 vccd1 sky130_fd_sc_hd__fill_1
XTAP_TAPCELL_ROW_11_225 vssd1 vccd1 sky130_fd_sc_hd__tapvpwrvgnd_1
X_2712_ LEI0.config_data\[35\] _1339_ vssd1 vssd1 vccd1 vccd1 _1340_ sky130_fd_sc_hd__and2b_1
X_2643_ LEI0.config_data\[9\] net139 vssd1 vssd1 vccd1 vccd1 _1271_ sky130_fd_sc_hd__nand2_1
X_2574_ _1198_ _1199_ _1203_ vssd1 vssd1 vccd1 vccd1 _1204_ sky130_fd_sc_hd__and3_1
X_3126_ SB0.route_sel\[45\] SB0.route_sel\[44\] net268 vssd1 vssd1 vccd1 vccd1 _0186_
+ sky130_fd_sc_hd__mux2_1
X_2008_ _1522_ SB0.route_sel\[46\] vssd1 vssd1 vccd1 vccd1 _0642_ sky130_fd_sc_hd__nor2_1
X_3057_ net211 net213 net284 vssd1 vssd1 vccd1 vccd1 _0117_ sky130_fd_sc_hd__mux2_1
XFILLER_41_174 vssd1 vssd1 vccd1 vccd1 sky130_fd_sc_hd__fill_2
XFILLER_25_61 vssd1 vssd1 vccd1 vccd1 sky130_fd_sc_hd__fill_2
XFILLER_25_50 vssd1 vssd1 vccd1 vccd1 sky130_fd_sc_hd__fill_4
XFILLER_41_185 vssd1 vssd1 vccd1 vccd1 sky130_fd_sc_hd__fill_4
X_2290_ _1578_ _0406_ _0408_ CB_0.config_dataB\[6\] vssd1 vssd1 vccd1 vccd1 _0922_
+ sky130_fd_sc_hd__o31ai_1
XFILLER_64_277 vssd1 vssd1 vccd1 vccd1 sky130_fd_sc_hd__fill_2
XTAP_TAPCELL_ROW_47_475 vssd1 vccd1 sky130_fd_sc_hd__tapvpwrvgnd_1
XFILLER_24_108 vssd1 vssd1 vccd1 vccd1 sky130_fd_sc_hd__fill_2
XTAP_TAPCELL_ROW_30_353 vssd1 vccd1 sky130_fd_sc_hd__tapvpwrvgnd_1
XANTENNA_15 net42 vssd1 vssd1 vccd1 vccd1 sky130_fd_sc_hd__diode_2
Xoutput100 net100 vssd1 vssd1 vccd1 vccd1 CBnorth_out[7] sky130_fd_sc_hd__buf_2
Xoutput133 net133 vssd1 vssd1 vccd1 vccd1 SBwest_out[8] sky130_fd_sc_hd__buf_2
Xoutput122 net122 vssd1 vssd1 vccd1 vccd1 SBwest_out[12] sky130_fd_sc_hd__buf_2
X_2557_ CB_1.config_dataA\[14\] _1167_ _1179_ _1185_ vssd1 vssd1 vccd1 vccd1 _1187_
+ sky130_fd_sc_hd__o31ai_2
X_2626_ net212 _1054_ vssd1 vssd1 vccd1 vccd1 _1254_ sky130_fd_sc_hd__nand2_1
Xoutput111 net111 vssd1 vssd1 vccd1 vccd1 SBsouth_out[2] sky130_fd_sc_hd__buf_2
X_2488_ net174 net173 vssd1 vssd1 vccd1 vccd1 _1118_ sky130_fd_sc_hd__nor2_1
X_3109_ SB0.route_sel\[28\] SB0.route_sel\[27\] net265 vssd1 vssd1 vccd1 vccd1 _0169_
+ sky130_fd_sc_hd__mux2_1
XFILLER_11_314 vssd1 vssd1 vccd1 vccd1 sky130_fd_sc_hd__fill_2
XFILLER_7_307 vssd1 vssd1 vccd1 vccd1 sky130_fd_sc_hd__fill_1
XFILLER_2_3 vssd1 vssd1 vccd1 vccd1 sky130_fd_sc_hd__fill_2
XFILLER_46_244 vssd1 vssd1 vccd1 vccd1 sky130_fd_sc_hd__fill_2
X_1790_ _0372_ _0422_ vssd1 vssd1 vccd1 vccd1 _0424_ sky130_fd_sc_hd__nand2_1
Xinput13 CBeast_in[6] vssd1 vssd1 vccd1 vccd1 net13 sky130_fd_sc_hd__buf_2
XTAP_TAPCELL_ROW_44_456 vssd1 vccd1 sky130_fd_sc_hd__tapvpwrvgnd_1
XFILLER_14_185 vssd1 vssd1 vccd1 vccd1 sky130_fd_sc_hd__fill_1
Xinput24 CBnorth_in[1] vssd1 vssd1 vccd1 vccd1 net24 sky130_fd_sc_hd__buf_2
X_3391_ clknet_leaf_5_clk net320 net227 vssd1 vssd1 vccd1 vccd1 LE_0B.config_data\[14\]
+ sky130_fd_sc_hd__dfrtp_1
X_2411_ SB0.route_sel\[108\] SB0.route_sel\[109\] vssd1 vssd1 vccd1 vccd1 _1041_ sky130_fd_sc_hd__or2_1
X_3460_ clknet_leaf_33_clk _0156_ net216 vssd1 vssd1 vccd1 vccd1 SB0.route_sel\[15\]
+ sky130_fd_sc_hd__dfstp_1
Xinput35 SBsouth_in[11] vssd1 vssd1 vccd1 vccd1 net35 sky130_fd_sc_hd__clkbuf_2
Xinput46 SBsouth_in[7] vssd1 vssd1 vccd1 vccd1 net46 sky130_fd_sc_hd__buf_1
Xinput68 le_en vssd1 vssd1 vccd1 vccd1 net68 sky130_fd_sc_hd__clkbuf_4
Xinput57 SBwest_in[2] vssd1 vssd1 vccd1 vccd1 net57 sky130_fd_sc_hd__clkbuf_1
X_2342_ CB_0.config_dataB\[14\] _0956_ _0967_ _0973_ vssd1 vssd1 vccd1 vccd1 _0974_
+ sky130_fd_sc_hd__o31a_1
X_2273_ _0897_ _0898_ _0904_ vssd1 vssd1 vccd1 vccd1 _0905_ sky130_fd_sc_hd__o21ai_4
XFILLER_35_3 vssd1 vssd1 vccd1 vccd1 sky130_fd_sc_hd__fill_1
X_1988_ net267 _0621_ vssd1 vssd1 vccd1 vccd1 _0622_ sky130_fd_sc_hd__nor2_1
X_3589_ clknet_leaf_13_clk _0285_ net250 vssd1 vssd1 vccd1 vccd1 CB_0.config_dataA\[16\]
+ sky130_fd_sc_hd__dfstp_1
X_3658_ clknet_leaf_25_clk net318 net242 vssd1 vssd1 vccd1 vccd1 LE_1B.config_data\[10\]
+ sky130_fd_sc_hd__dfrtp_1
X_2609_ LE_1A.config_data\[16\] _1236_ _1237_ _0868_ vssd1 vssd1 vccd1 vccd1 CB_1.le_outA
+ sky130_fd_sc_hd__o211a_2
XFILLER_28_244 vssd1 vssd1 vccd1 vccd1 sky130_fd_sc_hd__fill_8
Xclkbuf_2_2__f_clk clknet_0_clk vssd1 vssd1 vccd1 vccd1 clknet_2_2__leaf_clk sky130_fd_sc_hd__clkbuf_16
XFILLER_7_148 vssd1 vssd1 vccd1 vccd1 sky130_fd_sc_hd__fill_1
XFILLER_22_95 vssd1 vssd1 vccd1 vccd1 sky130_fd_sc_hd__fill_2
Xfanout190 CB_0.config_dataA\[16\] vssd1 vssd1 vccd1 vccd1 net190 sky130_fd_sc_hd__buf_2
X_2960_ net423 LEI0.config_data\[18\] net304 vssd1 vssd1 vccd1 vccd1 _0020_ sky130_fd_sc_hd__mux2_1
XFILLER_34_236 vssd1 vssd1 vccd1 vccd1 sky130_fd_sc_hd__fill_2
XFILLER_19_277 vssd1 vssd1 vccd1 vccd1 sky130_fd_sc_hd__fill_2
X_1773_ SB0.route_sel\[126\] net135 vssd1 vssd1 vccd1 vccd1 _0407_ sky130_fd_sc_hd__nand2b_1
X_1911_ _0542_ _0543_ _0544_ vssd1 vssd1 vccd1 vccd1 _0545_ sky130_fd_sc_hd__a21o_1
X_1842_ SB0.route_sel\[92\] SB0.route_sel\[93\] net51 _0474_ _0475_ vssd1 vssd1 vccd1
+ vccd1 _0476_ sky130_fd_sc_hd__a41o_1
X_2891_ _1461_ _0641_ vssd1 vssd1 vccd1 vccd1 net114 sky130_fd_sc_hd__and2b_1
X_3374_ clknet_leaf_27_clk _0070_ net236 vssd1 vssd1 vccd1 vccd1 LE_0A.reset_mode
+ sky130_fd_sc_hd__dfrtp_1
X_3512_ clknet_leaf_28_clk _0208_ net240 vssd1 vssd1 vccd1 vccd1 SB0.route_sel\[67\]
+ sky130_fd_sc_hd__dfstp_1
X_3443_ clknet_leaf_28_clk _0139_ net241 vssd1 vssd1 vccd1 vccd1 CB_1.config_dataB\[23\]
+ sky130_fd_sc_hd__dfstp_1
X_2187_ net191 net190 vssd1 vssd1 vccd1 vccd1 _0821_ sky130_fd_sc_hd__nor2_1
X_2325_ net184 _0581_ vssd1 vssd1 vccd1 vccd1 _0957_ sky130_fd_sc_hd__nand2_1
XTAP_TAPCELL_ROW_55_529 vssd1 vccd1 sky130_fd_sc_hd__tapvpwrvgnd_1
X_2256_ net187 _0884_ _0885_ _0887_ vssd1 vssd1 vccd1 vccd1 _0888_ sky130_fd_sc_hd__a31o_1
XFILLER_27_18 vssd1 vssd1 vccd1 vccd1 sky130_fd_sc_hd__fill_4
XTAP_TAPCELL_ROW_63_584 vssd1 vccd1 sky130_fd_sc_hd__tapvpwrvgnd_1
XFILLER_25_225 vssd1 vssd1 vccd1 vccd1 sky130_fd_sc_hd__fill_4
Xhold2 CB_0.config_dataA\[17\] vssd1 vssd1 vccd1 vccd1 net312 sky130_fd_sc_hd__dlygate4sd3_1
X_2110_ net197 net196 vssd1 vssd1 vccd1 vccd1 _0744_ sky130_fd_sc_hd__nor2_1
X_2041_ _0672_ _0674_ vssd1 vssd1 vccd1 vccd1 _0675_ sky130_fd_sc_hd__and2_2
X_3090_ SB0.route_sel\[9\] SB0.route_sel\[8\] net261 vssd1 vssd1 vccd1 vccd1 _0150_
+ sky130_fd_sc_hd__mux2_1
XTAP_TAPCELL_ROW_60_565 vssd1 vccd1 sky130_fd_sc_hd__tapvpwrvgnd_1
X_2943_ LEI0.config_data\[2\] net382 net300 vssd1 vssd1 vccd1 vccd1 _0003_ sky130_fd_sc_hd__mux2_1
XTAP_TAPCELL_ROW_17_264 vssd1 vccd1 sky130_fd_sc_hd__tapvpwrvgnd_1
X_1756_ net179 net180 _0389_ vssd1 vssd1 vccd1 vccd1 _0390_ sky130_fd_sc_hd__and3_1
X_1825_ SB0.route_sel\[106\] SB0.route_sel\[107\] vssd1 vssd1 vccd1 vccd1 _0459_ sky130_fd_sc_hd__nor2_1
X_2874_ SB0.route_sel\[57\] SB0.route_sel\[56\] vssd1 vssd1 vccd1 vccd1 _1450_ sky130_fd_sc_hd__or2_1
X_3357_ clknet_leaf_7_clk net314 net231 vssd1 vssd1 vccd1 vccd1 LE_0A.config_data\[2\]
+ sky130_fd_sc_hd__dfrtp_1
X_2308_ _0897_ _0898_ _0904_ LE_0B.config_data\[2\] vssd1 vssd1 vccd1 vccd1 _0940_
+ sky130_fd_sc_hd__o211a_1
X_1687_ SB0.route_sel\[123\] vssd1 vssd1 vccd1 vccd1 _1569_ sky130_fd_sc_hd__inv_2
X_3426_ clknet_leaf_23_clk _0122_ net246 vssd1 vssd1 vccd1 vccd1 CB_1.config_dataB\[6\]
+ sky130_fd_sc_hd__dfstp_1
XFILLER_57_169 vssd1 vssd1 vccd1 vccd1 sky130_fd_sc_hd__fill_1
X_2239_ net188 _0581_ vssd1 vssd1 vccd1 vccd1 _0871_ sky130_fd_sc_hd__nand2_1
XFILLER_38_372 vssd1 vssd1 vccd1 vccd1 sky130_fd_sc_hd__fill_2
XTAP_TAPCELL_ROW_0_143 vssd1 vccd1 sky130_fd_sc_hd__tapvpwrvgnd_1
X_3288_ net347 LE_1B.config_data\[3\] net278 vssd1 vssd1 vccd1 vccd1 _0348_ sky130_fd_sc_hd__mux2_1
XFILLER_28_72 vssd1 vssd1 vccd1 vccd1 sky130_fd_sc_hd__fill_1
XFILLER_44_82 vssd1 vssd1 vccd1 vccd1 sky130_fd_sc_hd__fill_2
XTAP_TAPCELL_ROW_14_245 vssd1 vccd1 sky130_fd_sc_hd__tapvpwrvgnd_1
X_2590_ _1591_ _1219_ _1218_ vssd1 vssd1 vccd1 vccd1 _1220_ sky130_fd_sc_hd__a21oi_1
XFILLER_67_401 vssd1 vssd1 vccd1 vccd1 sky130_fd_sc_hd__fill_2
X_3211_ CB_0.config_dataA\[2\] net199 net295 vssd1 vssd1 vccd1 vccd1 _0271_ sky130_fd_sc_hd__mux2_1
X_3142_ SB0.route_sel\[61\] SB0.route_sel\[60\] net267 vssd1 vssd1 vccd1 vccd1 _0202_
+ sky130_fd_sc_hd__mux2_1
XTAP_TAPCELL_ROW_65_602 vssd1 vccd1 sky130_fd_sc_hd__tapvpwrvgnd_1
XFILLER_54_139 vssd1 vssd1 vccd1 vccd1 sky130_fd_sc_hd__fill_1
XFILLER_47_191 vssd1 vssd1 vccd1 vccd1 sky130_fd_sc_hd__fill_4
XFILLER_39_169 vssd1 vssd1 vccd1 vccd1 sky130_fd_sc_hd__fill_2
X_3073_ CB_1.config_dataB\[17\] net202 net299 vssd1 vssd1 vccd1 vccd1 _0133_ sky130_fd_sc_hd__mux2_1
X_2024_ net142 _0397_ _0653_ SB0.route_sel\[26\] SB0.route_sel\[27\] vssd1 vssd1 vccd1
+ vccd1 _0658_ sky130_fd_sc_hd__a32o_1
X_2926_ SB0.route_sel\[122\] _1569_ net135 SB0.route_sel\[126\] _1484_ vssd1 vssd1
+ vccd1 vccd1 _1485_ sky130_fd_sc_hd__o221a_1
X_2857_ SB0.route_sel\[83\] _1547_ SB0.route_sel\[81\] SB0.route_sel\[80\] _1438_
+ vssd1 vssd1 vccd1 vccd1 _1439_ sky130_fd_sc_hd__o221a_1
X_2788_ _1400_ net151 _0494_ vssd1 vssd1 vccd1 vccd1 net88 sky130_fd_sc_hd__mux2_1
X_1739_ CB_0.config_dataA\[23\] CB_0.config_dataA\[22\] vssd1 vssd1 vccd1 vccd1 _0373_
+ sky130_fd_sc_hd__nand2_1
X_1808_ net138 net165 net160 _0441_ _1611_ vssd1 vssd1 vccd1 vccd1 _0442_ sky130_fd_sc_hd__o32ai_2
X_3409_ clknet_leaf_23_clk net375 net245 vssd1 vssd1 vccd1 vccd1 LE_1A.config_data\[10\]
+ sky130_fd_sc_hd__dfrtp_1
XFILLER_18_309 vssd1 vssd1 vccd1 vccd1 sky130_fd_sc_hd__fill_2
XFILLER_41_356 vssd1 vssd1 vccd1 vccd1 sky130_fd_sc_hd__fill_1
XTAP_TAPCELL_ROW_11_226 vssd1 vccd1 sky130_fd_sc_hd__tapvpwrvgnd_1
XFILLER_36_139 vssd1 vssd1 vccd1 vccd1 sky130_fd_sc_hd__fill_1
X_2711_ net153 net150 net145 net140 LEI0.config_data\[33\] LEI0.config_data\[34\]
+ vssd1 vssd1 vccd1 vccd1 _1339_ sky130_fd_sc_hd__mux4_1
X_2642_ LEI0.config_data\[10\] _1269_ vssd1 vssd1 vccd1 vccd1 _1270_ sky130_fd_sc_hd__nor2_1
X_2573_ _1192_ _1195_ _1201_ _1202_ vssd1 vssd1 vccd1 vccd1 _1203_ sky130_fd_sc_hd__o22a_1
XFILLER_27_117 vssd1 vssd1 vccd1 vccd1 sky130_fd_sc_hd__fill_2
X_3125_ SB0.route_sel\[44\] SB0.route_sel\[43\] net268 vssd1 vssd1 vccd1 vccd1 _0185_
+ sky130_fd_sc_hd__mux2_1
XFILLER_27_139 vssd1 vssd1 vccd1 vccd1 sky130_fd_sc_hd__fill_4
XTAP_TAPCELL_ROW_25_318 vssd1 vccd1 sky130_fd_sc_hd__tapvpwrvgnd_1
X_2007_ _1523_ _0630_ _0634_ _0640_ _1502_ vssd1 vssd1 vccd1 vccd1 _0641_ sky130_fd_sc_hd__o311a_2
X_3056_ net213 CB_1.config_dataA\[24\] net278 vssd1 vssd1 vccd1 vccd1 _0116_ sky130_fd_sc_hd__mux2_1
XFILLER_23_334 vssd1 vssd1 vccd1 vccd1 sky130_fd_sc_hd__fill_2
XFILLER_51_17 vssd1 vssd1 vccd1 vccd1 sky130_fd_sc_hd__fill_1
XFILLER_50_197 vssd1 vssd1 vccd1 vccd1 sky130_fd_sc_hd__fill_2
X_2909_ _1473_ _0691_ vssd1 vssd1 vccd1 vccd1 net111 sky130_fd_sc_hd__and2b_1
XFILLER_4_7 vssd1 vssd1 vccd1 vccd1 sky130_fd_sc_hd__fill_2
XFILLER_58_242 vssd1 vssd1 vccd1 vccd1 sky130_fd_sc_hd__fill_2
XFILLER_18_139 vssd1 vssd1 vccd1 vccd1 sky130_fd_sc_hd__fill_1
XFILLER_2_33 vssd1 vssd1 vccd1 vccd1 sky130_fd_sc_hd__fill_1
XTAP_TAPCELL_ROW_47_476 vssd1 vccd1 sky130_fd_sc_hd__tapvpwrvgnd_1
XFILLER_17_150 vssd1 vssd1 vccd1 vccd1 sky130_fd_sc_hd__fill_1
XTAP_TAPCELL_ROW_30_354 vssd1 vccd1 sky130_fd_sc_hd__tapvpwrvgnd_1
XANTENNA_16 net106 vssd1 vssd1 vccd1 vccd1 sky130_fd_sc_hd__diode_2
Xoutput123 net123 vssd1 vssd1 vccd1 vccd1 SBwest_out[13] sky130_fd_sc_hd__buf_2
Xoutput101 net101 vssd1 vssd1 vccd1 vccd1 CBnorth_out[8] sky130_fd_sc_hd__buf_2
Xoutput134 net134 vssd1 vssd1 vccd1 vccd1 SBwest_out[9] sky130_fd_sc_hd__buf_2
X_2556_ CB_1.config_dataA\[14\] _1167_ _1179_ _1185_ vssd1 vssd1 vccd1 vccd1 _1186_
+ sky130_fd_sc_hd__o31a_1
X_2487_ _1116_ vssd1 vssd1 vccd1 vccd1 _1117_ sky130_fd_sc_hd__inv_2
Xoutput112 net112 vssd1 vssd1 vccd1 vccd1 SBsouth_out[3] sky130_fd_sc_hd__buf_2
X_2625_ net211 _1250_ _1251_ _1252_ vssd1 vssd1 vccd1 vccd1 _1253_ sky130_fd_sc_hd__a31o_1
XFILLER_46_17 vssd1 vssd1 vccd1 vccd1 sky130_fd_sc_hd__fill_2
XTAP_TAPCELL_ROW_38_410 vssd1 vccd1 sky130_fd_sc_hd__tapvpwrvgnd_1
X_3108_ SB0.route_sel\[27\] SB0.route_sel\[26\] net267 vssd1 vssd1 vccd1 vccd1 _0168_
+ sky130_fd_sc_hd__mux2_1
X_3039_ LE_1A.config_data\[4\] net364 net280 vssd1 vssd1 vccd1 vccd1 _0099_ sky130_fd_sc_hd__mux2_1
XFILLER_23_197 vssd1 vssd1 vccd1 vccd1 sky130_fd_sc_hd__fill_1
XFILLER_61_248 vssd1 vssd1 vccd1 vccd1 sky130_fd_sc_hd__fill_2
XFILLER_46_212 vssd1 vssd1 vccd1 vccd1 sky130_fd_sc_hd__fill_1
Xinput25 CBnorth_in[2] vssd1 vssd1 vccd1 vccd1 net25 sky130_fd_sc_hd__clkbuf_2
Xinput14 CBeast_in[7] vssd1 vssd1 vccd1 vccd1 net14 sky130_fd_sc_hd__buf_2
XFILLER_52_82 vssd1 vssd1 vccd1 vccd1 sky130_fd_sc_hd__fill_2
XTAP_TAPCELL_ROW_44_457 vssd1 vccd1 sky130_fd_sc_hd__tapvpwrvgnd_1
Xinput36 SBsouth_in[12] vssd1 vssd1 vccd1 vccd1 net36 sky130_fd_sc_hd__dlymetal6s2s_1
X_2341_ LEI0.config_data\[29\] _0969_ _0971_ _0972_ vssd1 vssd1 vccd1 vccd1 _0973_
+ sky130_fd_sc_hd__o31a_1
X_2410_ _1039_ vssd1 vssd1 vccd1 vccd1 _1040_ sky130_fd_sc_hd__inv_2
X_3390_ clknet_leaf_5_clk net371 net227 vssd1 vssd1 vccd1 vccd1 LE_0B.config_data\[13\]
+ sky130_fd_sc_hd__dfrtp_1
Xinput69 le_nrst vssd1 vssd1 vccd1 vccd1 net69 sky130_fd_sc_hd__clkbuf_4
Xinput47 SBsouth_in[8] vssd1 vssd1 vccd1 vccd1 net47 sky130_fd_sc_hd__buf_1
Xinput58 SBwest_in[3] vssd1 vssd1 vccd1 vccd1 net58 sky130_fd_sc_hd__buf_1
X_2272_ LEI0.config_data\[5\] _0901_ _0903_ _0899_ vssd1 vssd1 vccd1 vccd1 _0904_
+ sky130_fd_sc_hd__o31a_2
X_3657_ clknet_leaf_23_clk net322 net243 vssd1 vssd1 vccd1 vccd1 LE_1B.config_data\[9\]
+ sky130_fd_sc_hd__dfrtp_1
X_1987_ _0605_ _0610_ _0616_ _0620_ vssd1 vssd1 vccd1 vccd1 _0621_ sky130_fd_sc_hd__o22a_1
X_3588_ clknet_leaf_13_clk _0284_ net251 vssd1 vssd1 vccd1 vccd1 CB_0.config_dataA\[15\]
+ sky130_fd_sc_hd__dfstp_1
X_2539_ net171 _1075_ _1168_ net170 vssd1 vssd1 vccd1 vccd1 _1169_ sky130_fd_sc_hd__o211a_1
X_2608_ _1593_ LE_1A.dff_out vssd1 vssd1 vccd1 vccd1 _1237_ sky130_fd_sc_hd__or2_1
XTAP_TAPCELL_ROW_58_549 vssd1 vccd1 sky130_fd_sc_hd__tapvpwrvgnd_1
XFILLER_43_248 vssd1 vssd1 vccd1 vccd1 sky130_fd_sc_hd__fill_1
XFILLER_28_278 vssd1 vssd1 vccd1 vccd1 sky130_fd_sc_hd__fill_1
XFILLER_11_156 vccd1 vssd1 vccd1 vssd1 sky130_ef_sc_hd__decap_40_12
XFILLER_22_74 vssd1 vssd1 vccd1 vccd1 sky130_fd_sc_hd__fill_1
XFILLER_22_85 vssd1 vssd1 vccd1 vccd1 sky130_fd_sc_hd__fill_1
XFILLER_66_307 vssd1 vssd1 vccd1 vccd1 sky130_fd_sc_hd__fill_1
Xfanout191 CB_0.config_dataA\[15\] vssd1 vssd1 vccd1 vccd1 net191 sky130_fd_sc_hd__buf_2
Xfanout180 CB_0.config_dataB\[22\] vssd1 vssd1 vccd1 vccd1 net180 sky130_fd_sc_hd__buf_2
XFILLER_19_245 vssd1 vssd1 vccd1 vccd1 sky130_fd_sc_hd__fill_2
X_1910_ net155 _0422_ _0479_ SB0.route_sel\[64\] SB0.route_sel\[65\] vssd1 vssd1 vccd1
+ vccd1 _0544_ sky130_fd_sc_hd__a32o_1
X_2890_ SB0.route_sel\[47\] SB0.route_sel\[46\] SB0.route_sel\[41\] _1524_ _1460_
+ vssd1 vssd1 vccd1 vccd1 _1461_ sky130_fd_sc_hd__o221a_1
X_1772_ SB0.route_sel\[120\] _0401_ _0405_ _0394_ net296 vssd1 vssd1 vccd1 vccd1 _0406_
+ sky130_fd_sc_hd__a311o_4
X_3511_ clknet_leaf_29_clk _0207_ net240 vssd1 vssd1 vccd1 vccd1 SB0.route_sel\[66\]
+ sky130_fd_sc_hd__dfstp_1
X_1841_ SB0.route_sel\[92\] SB0.route_sel\[93\] net35 vssd1 vssd1 vccd1 vccd1 _0475_
+ sky130_fd_sc_hd__a21boi_1
X_2324_ _0948_ _0951_ _0955_ CB_0.config_dataB\[13\] vssd1 vssd1 vccd1 vccd1 _0956_
+ sky130_fd_sc_hd__and4bb_1
X_3373_ clknet_leaf_34_clk _0069_ net215 vssd1 vssd1 vccd1 vccd1 LE_0A.reset_val sky130_fd_sc_hd__dfrtp_1
XFILLER_6_193 vssd1 vssd1 vccd1 vccd1 sky130_fd_sc_hd__fill_2
X_3442_ clknet_leaf_28_clk _0138_ net241 vssd1 vssd1 vccd1 vccd1 CB_1.config_dataB\[22\]
+ sky130_fd_sc_hd__dfstp_1
X_2186_ LE_0A.config_data\[9\] _0741_ _0779_ _0819_ vssd1 vssd1 vccd1 vccd1 _0820_
+ sky130_fd_sc_hd__a211o_1
X_2255_ _0549_ _0872_ _0886_ CB_0.config_dataB\[2\] vssd1 vssd1 vccd1 vccd1 _0887_
+ sky130_fd_sc_hd__a211o_1
XTAP_TAPCELL_ROW_63_585 vssd1 vccd1 sky130_fd_sc_hd__tapvpwrvgnd_1
XFILLER_17_74 vssd1 vssd1 vccd1 vccd1 sky130_fd_sc_hd__fill_1
Xhold3 LE_0A.config_data\[2\] vssd1 vssd1 vccd1 vccd1 net313 sky130_fd_sc_hd__dlygate4sd3_1
X_2040_ SB0.route_sel\[28\] _1513_ SB0.route_sel\[31\] _1515_ _0673_ vssd1 vssd1 vccd1
+ vccd1 _0674_ sky130_fd_sc_hd__a221o_1
XTAP_TAPCELL_ROW_60_566 vssd1 vccd1 sky130_fd_sc_hd__tapvpwrvgnd_1
X_2942_ net382 LEI0.config_data\[0\] net300 vssd1 vssd1 vccd1 vccd1 _0002_ sky130_fd_sc_hd__mux2_1
X_2873_ _1449_ _0546_ vssd1 vssd1 vccd1 vccd1 net117 sky130_fd_sc_hd__and2b_1
XFILLER_15_281 vssd1 vssd1 vccd1 vccd1 sky130_fd_sc_hd__fill_2
XTAP_TAPCELL_ROW_17_265 vssd1 vccd1 sky130_fd_sc_hd__tapvpwrvgnd_1
XFILLER_22_218 vccd1 vssd1 vccd1 vssd1 sky130_ef_sc_hd__decap_40_12
X_1755_ CB_0.config_dataB\[24\] CB_0.config_dataB\[20\] CB_0.config_dataB\[21\] vssd1
+ vssd1 vccd1 vccd1 _0389_ sky130_fd_sc_hd__and3b_1
X_1686_ SB0.route_sel\[112\] vssd1 vssd1 vccd1 vccd1 _1568_ sky130_fd_sc_hd__inv_2
X_1824_ _0444_ _0449_ _0456_ _0457_ _1502_ vssd1 vssd1 vccd1 vccd1 _0458_ sky130_fd_sc_hd__o221a_1
X_3356_ clknet_leaf_7_clk _0052_ net231 vssd1 vssd1 vccd1 vccd1 LE_0A.config_data\[1\]
+ sky130_fd_sc_hd__dfrtp_1
X_2238_ net189 _0603_ vssd1 vssd1 vccd1 vccd1 _0870_ sky130_fd_sc_hd__or2_1
X_2307_ _0934_ _0935_ _0937_ vssd1 vssd1 vccd1 vccd1 _0939_ sky130_fd_sc_hd__nand3_1
X_3287_ net388 net349 net277 vssd1 vssd1 vccd1 vccd1 _0347_ sky130_fd_sc_hd__mux2_1
X_3425_ clknet_leaf_23_clk _0121_ net246 vssd1 vssd1 vccd1 vccd1 CB_1.config_dataB\[5\]
+ sky130_fd_sc_hd__dfstp_1
X_2169_ CB_0.config_dataA\[13\] CB_0.config_dataA\[12\] vssd1 vssd1 vccd1 vccd1 _0803_
+ sky130_fd_sc_hd__nor2_1
XTAP_TAPCELL_ROW_51_500 vssd1 vccd1 sky130_fd_sc_hd__tapvpwrvgnd_1
XTAP_TAPCELL_ROW_0_144 vssd1 vccd1 sky130_fd_sc_hd__tapvpwrvgnd_1
XTAP_TAPCELL_ROW_8_200 vssd1 vccd1 sky130_fd_sc_hd__tapvpwrvgnd_1
XFILLER_48_104 vssd1 vssd1 vccd1 vccd1 sky130_fd_sc_hd__fill_2
XFILLER_44_50 vssd1 vssd1 vccd1 vccd1 sky130_fd_sc_hd__fill_1
XTAP_TAPCELL_ROW_14_246 vssd1 vccd1 sky130_fd_sc_hd__tapvpwrvgnd_1
XFILLER_5_55 vssd1 vssd1 vccd1 vccd1 sky130_fd_sc_hd__fill_1
XFILLER_8_222 vssd1 vssd1 vccd1 vccd1 sky130_fd_sc_hd__fill_2
X_3210_ net199 net200 net291 vssd1 vssd1 vccd1 vccd1 _0270_ sky130_fd_sc_hd__mux2_1
XFILLER_39_115 vssd1 vssd1 vccd1 vccd1 sky130_fd_sc_hd__fill_1
X_3141_ SB0.route_sel\[60\] SB0.route_sel\[59\] net267 vssd1 vssd1 vccd1 vccd1 _0201_
+ sky130_fd_sc_hd__mux2_1
XTAP_TAPCELL_ROW_65_603 vssd1 vccd1 sky130_fd_sc_hd__tapvpwrvgnd_1
XFILLER_50_324 vssd1 vssd1 vccd1 vccd1 sky130_fd_sc_hd__fill_1
X_3072_ net202 net204 net299 vssd1 vssd1 vccd1 vccd1 _0132_ sky130_fd_sc_hd__mux2_1
X_2023_ SB0.route_sel\[28\] SB0.route_sel\[29\] net42 vssd1 vssd1 vccd1 vccd1 _0657_
+ sky130_fd_sc_hd__a21boi_1
XFILLER_50_346 vssd1 vssd1 vccd1 vccd1 sky130_fd_sc_hd__fill_1
X_2925_ SB0.route_sel\[120\] _1571_ vssd1 vssd1 vccd1 vccd1 _1484_ sky130_fd_sc_hd__nand2_1
X_2856_ _1548_ SB0.route_sel\[85\] vssd1 vssd1 vccd1 vccd1 _1438_ sky130_fd_sc_hd__nand2_1
X_1807_ CB_1.config_dataA\[24\] CB_1.config_dataA\[21\] CB_1.config_dataA\[20\] vssd1
+ vssd1 vccd1 vccd1 _0441_ sky130_fd_sc_hd__or3b_4
X_2787_ _0495_ _0511_ _0497_ vssd1 vssd1 vccd1 vccd1 _1400_ sky130_fd_sc_hd__a21oi_1
X_1738_ CB_0.config_dataA\[23\] CB_0.config_dataA\[22\] vssd1 vssd1 vccd1 vccd1 _0372_
+ sky130_fd_sc_hd__and2_1
X_1669_ SB0.route_sel\[92\] vssd1 vssd1 vccd1 vccd1 _1551_ sky130_fd_sc_hd__inv_2
X_3408_ clknet_leaf_23_clk _0104_ net245 vssd1 vssd1 vccd1 vccd1 LE_1A.config_data\[9\]
+ sky130_fd_sc_hd__dfrtp_1
X_3339_ clknet_leaf_15_clk _0035_ net256 vssd1 vssd1 vccd1 vccd1 LEI0.config_data\[34\]
+ sky130_fd_sc_hd__dfrtp_1
XFILLER_38_181 vssd1 vssd1 vccd1 vccd1 sky130_fd_sc_hd__fill_1
XFILLER_41_335 vssd1 vssd1 vccd1 vccd1 sky130_fd_sc_hd__fill_1
XFILLER_49_402 vssd1 vssd1 vccd1 vccd1 sky130_fd_sc_hd__fill_1
XFILLER_17_310 vssd1 vssd1 vccd1 vccd1 sky130_fd_sc_hd__fill_2
X_2710_ CB_1.config_dataB\[14\] _1324_ _1337_ vssd1 vssd1 vccd1 vccd1 _1338_ sky130_fd_sc_hd__nor3_1
X_2641_ net153 net149 LEI0.config_data\[9\] vssd1 vssd1 vccd1 vccd1 _1269_ sky130_fd_sc_hd__mux2_1
X_2572_ _1103_ _1193_ _1194_ _1100_ CB_1.config_dataA\[17\] vssd1 vssd1 vccd1 vccd1
+ _1202_ sky130_fd_sc_hd__a221o_1
X_3055_ LE_1B.dff0_out _1393_ net68 vssd1 vssd1 vccd1 vccd1 _0115_ sky130_fd_sc_hd__mux2_1
X_3124_ SB0.route_sel\[43\] SB0.route_sel\[42\] net278 vssd1 vssd1 vccd1 vccd1 _0184_
+ sky130_fd_sc_hd__mux2_1
X_2006_ _0637_ _0638_ _0639_ vssd1 vssd1 vccd1 vccd1 _0640_ sky130_fd_sc_hd__a21o_1
XTAP_TAPCELL_ROW_25_319 vssd1 vccd1 sky130_fd_sc_hd__tapvpwrvgnd_1
XTAP_TAPCELL_ROW_33_374 vssd1 vccd1 sky130_fd_sc_hd__tapvpwrvgnd_1
XFILLER_31_390 vssd1 vssd1 vccd1 vccd1 sky130_fd_sc_hd__fill_2
X_2908_ SB0.route_sel\[23\] SB0.route_sel\[22\] _1511_ SB0.route_sel\[17\] _1472_
+ vssd1 vssd1 vccd1 vccd1 _1473_ sky130_fd_sc_hd__o221a_1
X_2839_ _0684_ _1427_ _0685_ vssd1 vssd1 vccd1 vccd1 net79 sky130_fd_sc_hd__a21oi_1
XFILLER_26_173 vccd1 vssd1 vccd1 vssd1 sky130_ef_sc_hd__decap_40_12
XFILLER_41_176 vssd1 vssd1 vccd1 vccd1 sky130_fd_sc_hd__fill_1
XFILLER_41_143 vssd1 vssd1 vccd1 vccd1 sky130_fd_sc_hd__fill_4
XTAP_TAPCELL_ROW_47_477 vssd1 vccd1 sky130_fd_sc_hd__tapvpwrvgnd_1
Xclkbuf_leaf_29_clk clknet_2_0__leaf_clk vssd1 vssd1 vccd1 vccd1 clknet_leaf_29_clk
+ sky130_fd_sc_hd__clkbuf_8
XANTENNA_17 net126 vssd1 vssd1 vccd1 vccd1 sky130_fd_sc_hd__diode_2
XFILLER_32_176 vssd1 vssd1 vccd1 vccd1 sky130_fd_sc_hd__fill_4
XTAP_TAPCELL_ROW_30_355 vssd1 vccd1 sky130_fd_sc_hd__tapvpwrvgnd_1
X_2624_ _1103_ _1240_ _1242_ _1100_ CB_1.config_dataB\[2\] vssd1 vssd1 vccd1 vccd1
+ _1252_ sky130_fd_sc_hd__a221o_1
X_2555_ LEI0.config_data\[32\] _1182_ _1184_ _1180_ vssd1 vssd1 vccd1 vccd1 _1185_
+ sky130_fd_sc_hd__o31a_1
Xoutput102 net102 vssd1 vssd1 vccd1 vccd1 CBnorth_out[9] sky130_fd_sc_hd__buf_2
Xoutput124 net124 vssd1 vssd1 vccd1 vccd1 SBwest_out[14] sky130_fd_sc_hd__buf_2
X_2486_ net173 net174 vssd1 vssd1 vccd1 vccd1 _1116_ sky130_fd_sc_hd__and2b_1
Xoutput113 net113 vssd1 vssd1 vccd1 vccd1 SBsouth_out[4] sky130_fd_sc_hd__buf_2
Xoutput135 net135 vssd1 vssd1 vccd1 vccd1 config_data_out sky130_fd_sc_hd__buf_2
XFILLER_55_235 vssd1 vssd1 vccd1 vccd1 sky130_fd_sc_hd__fill_2
XTAP_TAPCELL_ROW_38_411 vssd1 vccd1 sky130_fd_sc_hd__tapvpwrvgnd_1
X_3038_ net364 net377 net281 vssd1 vssd1 vccd1 vccd1 _0098_ sky130_fd_sc_hd__mux2_1
X_3107_ SB0.route_sel\[26\] SB0.route_sel\[25\] net267 vssd1 vssd1 vccd1 vccd1 _0167_
+ sky130_fd_sc_hd__mux2_1
XFILLER_23_187 vssd1 vssd1 vccd1 vccd1 sky130_fd_sc_hd__fill_8
XFILLER_11_87 vssd1 vssd1 vccd1 vccd1 sky130_fd_sc_hd__fill_2
Xinput26 CBnorth_in[3] vssd1 vssd1 vccd1 vccd1 net26 sky130_fd_sc_hd__buf_2
Xinput15 CBeast_in[8] vssd1 vssd1 vccd1 vccd1 net15 sky130_fd_sc_hd__buf_2
Xinput48 SBsouth_in[9] vssd1 vssd1 vccd1 vccd1 net48 sky130_fd_sc_hd__dlymetal6s2s_1
Xinput37 SBsouth_in[13] vssd1 vssd1 vccd1 vccd1 net37 sky130_fd_sc_hd__buf_1
Xinput59 SBwest_in[4] vssd1 vssd1 vccd1 vccd1 net59 sky130_fd_sc_hd__clkbuf_1
X_2340_ CB_0.config_dataB\[13\] _0946_ CB_0.config_dataB\[12\] CB_0.config_dataB\[14\]
+ vssd1 vssd1 vccd1 vccd1 _0972_ sky130_fd_sc_hd__or4b_2
X_2271_ LEI0.config_data\[3\] net143 _0902_ LEI0.config_data\[4\] vssd1 vssd1 vccd1
+ vccd1 _0903_ sky130_fd_sc_hd__o211a_1
XFILLER_60_282 vssd1 vssd1 vccd1 vccd1 sky130_fd_sc_hd__fill_1
X_1986_ _0615_ _0619_ _0605_ vssd1 vssd1 vccd1 vccd1 _0620_ sky130_fd_sc_hd__o21ai_1
X_3587_ clknet_leaf_13_clk _0283_ net250 vssd1 vssd1 vccd1 vccd1 CB_0.config_dataA\[14\]
+ sky130_fd_sc_hd__dfstp_1
X_2607_ LE_1A.dff0_out LE_1A.dff1_out LE_1A.reset_val vssd1 vssd1 vccd1 vccd1 LE_1A.dff_out
+ sky130_fd_sc_hd__mux2_1
X_3656_ clknet_leaf_25_clk _0352_ net243 vssd1 vssd1 vccd1 vccd1 LE_1B.config_data\[8\]
+ sky130_fd_sc_hd__dfrtp_1
X_2538_ net171 _1071_ vssd1 vssd1 vccd1 vccd1 _1168_ sky130_fd_sc_hd__nand2_1
X_2469_ _1505_ SB0.route_sel\[14\] SB0.route_sel\[9\] _1508_ _1098_ vssd1 vssd1 vccd1
+ vccd1 _1099_ sky130_fd_sc_hd__a221o_1
XFILLER_28_257 vssd1 vssd1 vccd1 vccd1 sky130_fd_sc_hd__fill_2
XFILLER_11_113 vssd1 vssd1 vccd1 vccd1 sky130_fd_sc_hd__fill_2
Xfanout192 CB_0.config_dataA\[15\] vssd1 vssd1 vccd1 vccd1 net192 sky130_fd_sc_hd__clkbuf_2
Xfanout181 CB_0.config_dataB\[15\] vssd1 vssd1 vccd1 vccd1 net181 sky130_fd_sc_hd__buf_2
Xfanout170 CB_1.config_dataA\[11\] vssd1 vssd1 vccd1 vccd1 net170 sky130_fd_sc_hd__buf_2
XFILLER_19_279 vssd1 vssd1 vccd1 vccd1 sky130_fd_sc_hd__fill_1
XFILLER_34_238 vssd1 vssd1 vccd1 vccd1 sky130_fd_sc_hd__fill_1
X_1840_ SB0.route_sel\[95\] SB0.route_sel\[94\] vssd1 vssd1 vccd1 vccd1 _0474_ sky130_fd_sc_hd__nand2_1
X_1771_ SB0.route_sel\[122\] SB0.route_sel\[123\] _0404_ _1571_ vssd1 vssd1 vccd1
+ vccd1 _0405_ sky130_fd_sc_hd__a31oi_1
X_3510_ clknet_leaf_29_clk _0206_ net226 vssd1 vssd1 vccd1 vccd1 SB0.route_sel\[65\]
+ sky130_fd_sc_hd__dfstp_1
X_3441_ clknet_leaf_23_clk _0137_ net238 vssd1 vssd1 vccd1 vccd1 CB_1.config_dataB\[21\]
+ sky130_fd_sc_hd__dfstp_1
X_2323_ _0549_ _0944_ _0953_ _0954_ vssd1 vssd1 vccd1 vccd1 _0955_ sky130_fd_sc_hd__a211o_1
X_2254_ _0528_ _0530_ _0874_ vssd1 vssd1 vccd1 vccd1 _0886_ sky130_fd_sc_hd__a21oi_1
X_3372_ clknet_leaf_34_clk _0068_ net215 vssd1 vssd1 vccd1 vccd1 LE_0A.edge_mode sky130_fd_sc_hd__dfstp_1
X_2185_ LE_0A.config_data\[8\] _0736_ _0740_ vssd1 vssd1 vccd1 vccd1 _0819_ sky130_fd_sc_hd__and3_1
XTAP_TAPCELL_ROW_63_586 vssd1 vccd1 sky130_fd_sc_hd__tapvpwrvgnd_1
X_1969_ _0592_ _0598_ _0602_ vssd1 vssd1 vccd1 vccd1 _0603_ sky130_fd_sc_hd__or3_4
X_3639_ clknet_leaf_18_clk _0335_ net259 vssd1 vssd1 vccd1 vccd1 CB_1.config_dataA\[16\]
+ sky130_fd_sc_hd__dfstp_1
XTAP_TAPCELL_ROW_3_164 vssd1 vccd1 sky130_fd_sc_hd__tapvpwrvgnd_1
XPHY_EDGE_ROW_9_Left_77 vssd1 vssd1 vccd1 vccd1 sky130_fd_sc_hd__decap_3
XFILLER_16_238 vssd1 vssd1 vccd1 vccd1 sky130_fd_sc_hd__fill_4
Xhold4 _0053_ vssd1 vssd1 vccd1 vccd1 net314 sky130_fd_sc_hd__dlygate4sd3_1
XTAP_TAPCELL_ROW_60_567 vssd1 vccd1 sky130_fd_sc_hd__tapvpwrvgnd_1
X_1823_ _1602_ _0452_ _0448_ vssd1 vssd1 vccd1 vccd1 _0457_ sky130_fd_sc_hd__o21ai_1
X_2941_ LEI0.config_data\[0\] LE_1A.reset_mode net276 vssd1 vssd1 vccd1 vccd1 _0001_
+ sky130_fd_sc_hd__mux2_1
XFILLER_15_293 vssd1 vssd1 vccd1 vccd1 sky130_fd_sc_hd__fill_1
XTAP_TAPCELL_ROW_17_266 vssd1 vccd1 sky130_fd_sc_hd__tapvpwrvgnd_1
X_2872_ SB0.route_sel\[71\] SB0.route_sel\[70\] SB0.route_sel\[65\] _1541_ _1448_
+ vssd1 vssd1 vccd1 vccd1 _1449_ sky130_fd_sc_hd__o221a_1
X_1754_ _0372_ _0387_ vssd1 vssd1 vccd1 vccd1 _0388_ sky130_fd_sc_hd__nand2_1
X_1685_ SB0.route_sel\[118\] vssd1 vssd1 vccd1 vccd1 _1567_ sky130_fd_sc_hd__inv_2
X_3424_ clknet_leaf_21_clk _0120_ net246 vssd1 vssd1 vccd1 vccd1 CB_1.config_dataB\[4\]
+ sky130_fd_sc_hd__dfstp_1
X_3355_ clknet_leaf_7_clk _0051_ net231 vssd1 vssd1 vccd1 vccd1 LE_0A.config_data\[0\]
+ sky130_fd_sc_hd__dfrtp_1
X_2306_ _0934_ _0935_ _0937_ vssd1 vssd1 vccd1 vccd1 _0938_ sky130_fd_sc_hd__and3_1
X_3286_ net349 LE_1B.config_data\[1\] net277 vssd1 vssd1 vccd1 vccd1 _0346_ sky130_fd_sc_hd__mux2_1
X_2237_ LE_0A.config_data\[16\] _0867_ _0868_ _0869_ vssd1 vssd1 vccd1 vccd1 CB_0.le_outA
+ sky130_fd_sc_hd__o211a_2
X_2168_ _1573_ _0801_ vssd1 vssd1 vccd1 vccd1 _0802_ sky130_fd_sc_hd__nand2_1
XTAP_TAPCELL_ROW_51_501 vssd1 vccd1 sky130_fd_sc_hd__tapvpwrvgnd_1
XFILLER_38_374 vssd1 vssd1 vccd1 vccd1 sky130_fd_sc_hd__fill_1
X_2099_ _0730_ _0732_ vssd1 vssd1 vccd1 vccd1 _0733_ sky130_fd_sc_hd__and2_2
XTAP_TAPCELL_ROW_0_145 vssd1 vccd1 sky130_fd_sc_hd__tapvpwrvgnd_1
XPHY_EDGE_ROW_17_Right_17 vssd1 vssd1 vccd1 vccd1 sky130_fd_sc_hd__decap_3
XPHY_EDGE_ROW_26_Right_26 vssd1 vssd1 vccd1 vccd1 sky130_fd_sc_hd__decap_3
XTAP_TAPCELL_ROW_8_201 vssd1 vccd1 sky130_fd_sc_hd__tapvpwrvgnd_1
XFILLER_56_182 vssd1 vssd1 vccd1 vccd1 sky130_fd_sc_hd__fill_2
XFILLER_48_127 vccd1 vssd1 vccd1 vssd1 sky130_ef_sc_hd__decap_40_12
XFILLER_44_300 vssd1 vssd1 vccd1 vccd1 sky130_fd_sc_hd__fill_2
XFILLER_28_85 vssd1 vssd1 vccd1 vccd1 sky130_fd_sc_hd__fill_1
XPHY_EDGE_ROW_35_Right_35 vssd1 vssd1 vccd1 vccd1 sky130_fd_sc_hd__decap_3
XTAP_TAPCELL_ROW_14_247 vssd1 vccd1 sky130_fd_sc_hd__tapvpwrvgnd_1
XTAP_TAPCELL_ROW_65_604 vssd1 vccd1 sky130_fd_sc_hd__tapvpwrvgnd_1
XPHY_EDGE_ROW_44_Right_44 vssd1 vssd1 vccd1 vccd1 sky130_fd_sc_hd__decap_3
X_3140_ SB0.route_sel\[59\] SB0.route_sel\[58\] net284 vssd1 vssd1 vccd1 vccd1 _0200_
+ sky130_fd_sc_hd__mux2_1
X_3071_ CB_1.config_dataB\[15\] CB_1.config_dataB\[14\] net285 vssd1 vssd1 vccd1 vccd1
+ _0131_ sky130_fd_sc_hd__mux2_1
XPHY_EDGE_ROW_59_Left_127 vssd1 vssd1 vccd1 vccd1 sky130_fd_sc_hd__decap_3
XPHY_EDGE_ROW_53_Right_53 vssd1 vssd1 vccd1 vccd1 sky130_fd_sc_hd__decap_3
XFILLER_47_182 vssd1 vssd1 vccd1 vccd1 sky130_fd_sc_hd__fill_2
X_2022_ SB0.route_sel\[31\] SB0.route_sel\[30\] vssd1 vssd1 vccd1 vccd1 _0656_ sky130_fd_sc_hd__nand2_1
X_2786_ net152 _1399_ _0481_ vssd1 vssd1 vccd1 vccd1 net89 sky130_fd_sc_hd__mux2_1
X_2924_ _0406_ _1483_ vssd1 vssd1 vccd1 vccd1 net125 sky130_fd_sc_hd__and2b_1
X_1806_ _1607_ net160 net5 vssd1 vssd1 vccd1 vccd1 _0440_ sky130_fd_sc_hd__o21a_1
X_2855_ _0489_ _1437_ vssd1 vssd1 vccd1 vccd1 net105 sky130_fd_sc_hd__nor2_1
X_3338_ clknet_leaf_15_clk _0034_ net257 vssd1 vssd1 vccd1 vccd1 LEI0.config_data\[33\]
+ sky130_fd_sc_hd__dfrtp_1
XPHY_EDGE_ROW_62_Right_62 vssd1 vssd1 vccd1 vccd1 sky130_fd_sc_hd__decap_3
X_1737_ CB_0.config_dataA\[24\] CB_0.config_dataA\[20\] CB_0.config_dataA\[21\] vssd1
+ vssd1 vccd1 vccd1 _0371_ sky130_fd_sc_hd__or3b_2
X_1668_ SB0.route_sel\[90\] vssd1 vssd1 vccd1 vccd1 _1550_ sky130_fd_sc_hd__inv_2
X_3407_ clknet_leaf_24_clk _0103_ net245 vssd1 vssd1 vccd1 vccd1 LE_1A.config_data\[8\]
+ sky130_fd_sc_hd__dfrtp_1
X_3269_ net171 CB_1.config_dataA\[9\] net305 vssd1 vssd1 vccd1 vccd1 _0329_ sky130_fd_sc_hd__mux2_1
XFILLER_38_171 vssd1 vssd1 vccd1 vccd1 sky130_fd_sc_hd__fill_8
XTAP_TAPCELL_ROW_28_339 vssd1 vccd1 sky130_fd_sc_hd__tapvpwrvgnd_1
XFILLER_26_355 vssd1 vssd1 vccd1 vccd1 sky130_fd_sc_hd__fill_1
XFILLER_5_204 vssd1 vssd1 vccd1 vccd1 sky130_fd_sc_hd__fill_2
X_2640_ CB_1.config_dataB\[3\] _1243_ CB_1.config_dataB\[2\] CB_1.config_dataB\[4\]
+ vssd1 vssd1 vccd1 vccd1 _1268_ sky130_fd_sc_hd__or4b_2
X_2571_ net168 _1096_ _1200_ net167 vssd1 vssd1 vccd1 vccd1 _1201_ sky130_fd_sc_hd__o211a_1
XFILLER_27_119 vssd1 vssd1 vccd1 vccd1 sky130_fd_sc_hd__fill_1
X_3054_ LE_1A.reset_mode net424 net279 vssd1 vssd1 vccd1 vccd1 _0114_ sky130_fd_sc_hd__mux2_1
X_3123_ SB0.route_sel\[42\] SB0.route_sel\[41\] net268 vssd1 vssd1 vccd1 vccd1 _0183_
+ sky130_fd_sc_hd__mux2_1
X_2005_ net155 _0450_ _0567_ SB0.route_sel\[40\] SB0.route_sel\[41\] vssd1 vssd1 vccd1
+ vccd1 _0639_ sky130_fd_sc_hd__a32o_1
XFILLER_50_144 vccd1 vssd1 vccd1 vssd1 sky130_ef_sc_hd__decap_40_12
XTAP_TAPCELL_ROW_33_375 vssd1 vccd1 sky130_fd_sc_hd__tapvpwrvgnd_1
X_2907_ SB0.route_sel\[18\] SB0.route_sel\[19\] vssd1 vssd1 vccd1 vccd1 _1472_ sky130_fd_sc_hd__nand2b_1
X_2769_ net236 LE_0A.reset_mode vssd1 vssd1 vccd1 vccd1 _2769_/X sky130_fd_sc_hd__xor2_2
X_2838_ net166 net156 _1096_ vssd1 vssd1 vccd1 vccd1 _1427_ sky130_fd_sc_hd__o21bai_1
XFILLER_41_111 vssd1 vssd1 vccd1 vccd1 sky130_fd_sc_hd__fill_1
XFILLER_26_185 vssd1 vssd1 vccd1 vccd1 sky130_fd_sc_hd__fill_4
XFILLER_26_141 vccd1 vssd1 vccd1 vssd1 sky130_ef_sc_hd__decap_40_12
XFILLER_41_133 vssd1 vssd1 vccd1 vccd1 sky130_fd_sc_hd__fill_2
XFILLER_66_93 vssd1 vssd1 vccd1 vccd1 sky130_fd_sc_hd__fill_1
XFILLER_66_82 vssd1 vssd1 vccd1 vccd1 sky130_fd_sc_hd__fill_2
XANTENNA_18 net130 vssd1 vssd1 vccd1 vccd1 sky130_fd_sc_hd__diode_2
XTAP_TAPCELL_ROW_47_478 vssd1 vccd1 sky130_fd_sc_hd__tapvpwrvgnd_1
Xoutput125 net125 vssd1 vssd1 vccd1 vccd1 SBwest_out[15] sky130_fd_sc_hd__buf_2
X_2554_ LEI0.config_data\[30\] _1603_ _1183_ LEI0.config_data\[31\] vssd1 vssd1 vccd1
+ vccd1 _1184_ sky130_fd_sc_hd__o211a_1
XTAP_TAPCELL_ROW_30_356 vssd1 vccd1 sky130_fd_sc_hd__tapvpwrvgnd_1
Xoutput103 net103 vssd1 vssd1 vccd1 vccd1 SBsouth_out[0] sky130_fd_sc_hd__buf_2
Xoutput114 net114 vssd1 vssd1 vccd1 vccd1 SBsouth_out[5] sky130_fd_sc_hd__buf_2
X_2623_ net213 _1096_ vssd1 vssd1 vccd1 vccd1 _1251_ sky130_fd_sc_hd__or2_1
X_2485_ net174 _1034_ vssd1 vssd1 vccd1 vccd1 _1115_ sky130_fd_sc_hd__nand2_1
XTAP_TAPCELL_ROW_38_412 vssd1 vccd1 sky130_fd_sc_hd__tapvpwrvgnd_1
X_3037_ net377 LE_1A.config_data\[1\] net280 vssd1 vssd1 vccd1 vccd1 _0097_ sky130_fd_sc_hd__mux2_1
X_3106_ SB0.route_sel\[25\] SB0.route_sel\[24\] net263 vssd1 vssd1 vccd1 vccd1 _0166_
+ sky130_fd_sc_hd__mux2_1
XFILLER_11_66 vssd1 vssd1 vccd1 vccd1 sky130_fd_sc_hd__fill_1
XFILLER_61_239 vssd1 vssd1 vccd1 vccd1 sky130_fd_sc_hd__fill_1
Xinput27 CBnorth_in[4] vssd1 vssd1 vccd1 vccd1 net27 sky130_fd_sc_hd__clkbuf_2
Xinput16 CBeast_in[9] vssd1 vssd1 vccd1 vccd1 net16 sky130_fd_sc_hd__buf_2
Xinput49 SBwest_in[0] vssd1 vssd1 vccd1 vccd1 net49 sky130_fd_sc_hd__buf_1
Xinput38 SBsouth_in[14] vssd1 vssd1 vccd1 vccd1 net38 sky130_fd_sc_hd__buf_1
XFILLER_6_365 vssd1 vssd1 vccd1 vccd1 sky130_fd_sc_hd__fill_1
X_2270_ LEI0.config_data\[3\] net139 vssd1 vssd1 vccd1 vccd1 _0902_ sky130_fd_sc_hd__nand2_1
XFILLER_42_7 vssd1 vssd1 vccd1 vccd1 sky130_fd_sc_hd__fill_2
XFILLER_52_217 vssd1 vssd1 vccd1 vccd1 sky130_fd_sc_hd__fill_1
XFILLER_52_206 vssd1 vssd1 vccd1 vccd1 sky130_fd_sc_hd__fill_2
XFILLER_37_225 vssd1 vssd1 vccd1 vccd1 sky130_fd_sc_hd__fill_2
X_1985_ SB0.route_sel\[36\] SB0.route_sel\[37\] net59 _0617_ _0618_ vssd1 vssd1 vccd1
+ vccd1 _0619_ sky130_fd_sc_hd__a41o_1
X_3586_ clknet_leaf_13_clk _0282_ net250 vssd1 vssd1 vccd1 vccd1 CB_0.config_dataA\[13\]
+ sky130_fd_sc_hd__dfstp_1
X_2537_ _1159_ _1162_ _1166_ CB_1.config_dataA\[13\] vssd1 vssd1 vccd1 vccd1 _1167_
+ sky130_fd_sc_hd__and4bb_1
X_2606_ _1222_ _1231_ _1235_ _1227_ _1190_ vssd1 vssd1 vccd1 vccd1 _1236_ sky130_fd_sc_hd__o32a_1
X_3655_ clknet_leaf_26_clk _0351_ net243 vssd1 vssd1 vccd1 vccd1 LE_1B.config_data\[7\]
+ sky130_fd_sc_hd__dfrtp_1
X_2399_ SB0.route_sel\[116\] SB0.route_sel\[117\] _1568_ SB0.route_sel\[113\] vssd1
+ vssd1 vccd1 vccd1 _1029_ sky130_fd_sc_hd__a2bb2o_1
X_2468_ SB0.route_sel\[12\] SB0.route_sel\[13\] vssd1 vssd1 vccd1 vccd1 _1098_ sky130_fd_sc_hd__nor2_1
XFILLER_22_43 vssd1 vssd1 vccd1 vccd1 sky130_fd_sc_hd__fill_2
XFILLER_0_3 vssd1 vssd1 vccd1 vccd1 sky130_fd_sc_hd__fill_8
Xfanout193 CB_0.config_dataA\[11\] vssd1 vssd1 vccd1 vccd1 net193 sky130_fd_sc_hd__buf_2
Xfanout182 CB_0.config_dataB\[15\] vssd1 vssd1 vccd1 vccd1 net182 sky130_fd_sc_hd__clkbuf_2
Xfanout171 CB_1.config_dataA\[10\] vssd1 vssd1 vccd1 vccd1 net171 sky130_fd_sc_hd__buf_2
XFILLER_47_51 vssd1 vssd1 vccd1 vccd1 sky130_fd_sc_hd__fill_1
Xfanout160 _0439_ vssd1 vssd1 vccd1 vccd1 net160 sky130_fd_sc_hd__clkbuf_4
XFILLER_19_225 vssd1 vssd1 vccd1 vccd1 sky130_fd_sc_hd__fill_4
XFILLER_19_247 vssd1 vssd1 vccd1 vccd1 sky130_fd_sc_hd__fill_1
X_1770_ SB0.route_sel\[124\] SB0.route_sel\[125\] net55 _0403_ _0402_ vssd1 vssd1
+ vccd1 vccd1 _0404_ sky130_fd_sc_hd__a41o_1
XFILLER_6_195 vssd1 vssd1 vccd1 vccd1 sky130_fd_sc_hd__fill_1
X_3371_ clknet_leaf_35_clk _0067_ net214 vssd1 vssd1 vccd1 vccd1 LE_0A.config_data\[16\]
+ sky130_fd_sc_hd__dfrtp_1
X_3440_ clknet_leaf_23_clk _0136_ net238 vssd1 vssd1 vccd1 vccd1 CB_1.config_dataB\[20\]
+ sky130_fd_sc_hd__dfstp_1
X_2322_ _1581_ net184 _0531_ CB_0.config_dataB\[12\] vssd1 vssd1 vccd1 vccd1 _0954_
+ sky130_fd_sc_hd__a31o_1
X_2184_ LE_0A.config_data\[11\] _0741_ _0778_ _0817_ vssd1 vssd1 vccd1 vccd1 _0818_
+ sky130_fd_sc_hd__a211o_1
X_2253_ net188 _0511_ vssd1 vssd1 vccd1 vccd1 _0885_ sky130_fd_sc_hd__or2_1
XTAP_TAPCELL_ROW_63_587 vssd1 vccd1 sky130_fd_sc_hd__tapvpwrvgnd_1
XPHY_EDGE_ROW_40_Left_108 vssd1 vssd1 vccd1 vccd1 sky130_fd_sc_hd__decap_3
XPHY_EDGE_ROW_25_Left_93 vssd1 vssd1 vccd1 vccd1 sky130_fd_sc_hd__decap_3
XFILLER_33_294 vssd1 vssd1 vccd1 vccd1 sky130_fd_sc_hd__fill_1
X_1899_ _0411_ net158 net15 vssd1 vssd1 vccd1 vccd1 _0533_ sky130_fd_sc_hd__o21ai_1
X_1968_ _0601_ vssd1 vssd1 vccd1 vccd1 _0602_ sky130_fd_sc_hd__inv_2
X_3638_ clknet_leaf_17_clk _0334_ net259 vssd1 vssd1 vccd1 vccd1 CB_1.config_dataA\[15\]
+ sky130_fd_sc_hd__dfstp_1
X_3569_ clknet_leaf_20_clk _0265_ net248 vssd1 vssd1 vccd1 vccd1 SB0.route_sel\[124\]
+ sky130_fd_sc_hd__dfstp_1
XTAP_TAPCELL_ROW_54_521 vssd1 vccd1 sky130_fd_sc_hd__tapvpwrvgnd_1
XTAP_TAPCELL_ROW_3_165 vssd1 vccd1 sky130_fd_sc_hd__tapvpwrvgnd_1
XFILLER_33_53 vssd1 vssd1 vccd1 vccd1 sky130_fd_sc_hd__fill_2
Xhold5 LE_1B.config_data\[14\] vssd1 vssd1 vccd1 vccd1 net315 sky130_fd_sc_hd__dlygate4sd3_1
X_2940_ LE_0A.dff1_out _0867_ net68 vssd1 vssd1 vccd1 vccd1 _0000_ sky130_fd_sc_hd__mux2_1
XTAP_TAPCELL_ROW_17_267 vssd1 vccd1 sky130_fd_sc_hd__tapvpwrvgnd_1
XTAP_TAPCELL_ROW_60_568 vssd1 vccd1 sky130_fd_sc_hd__tapvpwrvgnd_1
X_1822_ net21 _0454_ _0455_ _0452_ vssd1 vssd1 vccd1 vccd1 _0456_ sky130_fd_sc_hd__o211a_1
X_1753_ CB_0.config_dataA\[24\] CB_0.config_dataA\[21\] CB_0.config_dataA\[20\] vssd1
+ vssd1 vccd1 vccd1 _0387_ sky130_fd_sc_hd__and3b_4
XFILLER_30_253 vssd1 vssd1 vccd1 vccd1 sky130_fd_sc_hd__fill_2
X_2871_ SB0.route_sel\[67\] _1536_ vssd1 vssd1 vccd1 vccd1 _1448_ sky130_fd_sc_hd__nand2_1
XFILLER_15_283 vssd1 vssd1 vccd1 vccd1 sky130_fd_sc_hd__fill_1
X_1684_ SB0.route_sel\[117\] vssd1 vssd1 vccd1 vccd1 _1566_ sky130_fd_sc_hd__inv_2
X_3423_ clknet_leaf_21_clk _0119_ net240 vssd1 vssd1 vccd1 vccd1 CB_1.config_dataB\[3\]
+ sky130_fd_sc_hd__dfstp_1
X_3354_ LE_0B.sel_clk _0050_ net69 vssd1 vssd1 vccd1 vccd1 LE_0B.dff1_out sky130_fd_sc_hd__dfstp_1
X_2167_ net17 net24 net25 net26 net194 net193 vssd1 vssd1 vccd1 vccd1 _0801_ sky130_fd_sc_hd__mux4_1
X_2305_ LEI0.config_data\[17\] _0936_ vssd1 vssd1 vccd1 vccd1 _0937_ sky130_fd_sc_hd__nand2b_1
XFILLER_38_331 vssd1 vssd1 vccd1 vccd1 sky130_fd_sc_hd__fill_4
X_3285_ net425 net422 net277 vssd1 vssd1 vccd1 vccd1 _0345_ sky130_fd_sc_hd__mux2_1
X_2236_ _1575_ LE_0A.dff_out vssd1 vssd1 vccd1 vccd1 _0869_ sky130_fd_sc_hd__or2_1
XTAP_TAPCELL_ROW_51_502 vssd1 vccd1 sky130_fd_sc_hd__tapvpwrvgnd_1
X_2098_ SB0.route_sel\[4\] _1498_ SB0.route_sel\[7\] _1499_ _0731_ vssd1 vssd1 vccd1
+ vccd1 _0732_ sky130_fd_sc_hd__a221o_1
XTAP_TAPCELL_ROW_0_146 vssd1 vccd1 sky130_fd_sc_hd__tapvpwrvgnd_1
XFILLER_21_220 vssd1 vssd1 vccd1 vccd1 sky130_fd_sc_hd__fill_4
XTAP_TAPCELL_ROW_8_202 vssd1 vccd1 sky130_fd_sc_hd__tapvpwrvgnd_1
XFILLER_48_139 vssd1 vssd1 vccd1 vccd1 sky130_fd_sc_hd__fill_1
XFILLER_0_113 vssd1 vssd1 vccd1 vccd1 sky130_fd_sc_hd__fill_2
XFILLER_56_194 vssd1 vssd1 vccd1 vccd1 sky130_fd_sc_hd__fill_2
XFILLER_44_356 vssd1 vssd1 vccd1 vccd1 sky130_fd_sc_hd__fill_2
XFILLER_29_331 vssd1 vssd1 vccd1 vccd1 sky130_fd_sc_hd__fill_4
XFILLER_44_85 vssd1 vssd1 vccd1 vccd1 sky130_fd_sc_hd__fill_2
XFILLER_8_213 vssd1 vssd1 vccd1 vccd1 sky130_fd_sc_hd__fill_2
XFILLER_12_253 vssd1 vssd1 vccd1 vccd1 sky130_fd_sc_hd__fill_2
XFILLER_5_57 vssd1 vssd1 vccd1 vccd1 sky130_fd_sc_hd__fill_2
XFILLER_54_109 vssd1 vssd1 vccd1 vccd1 sky130_fd_sc_hd__fill_2
X_2021_ net138 net162 net156 _0654_ _0398_ vssd1 vssd1 vccd1 vccd1 _0655_ sky130_fd_sc_hd__o32a_1
X_3070_ CB_1.config_dataB\[14\] CB_1.config_dataB\[13\] net285 vssd1 vssd1 vccd1 vccd1
+ _0130_ sky130_fd_sc_hd__mux2_1
XFILLER_62_197 vssd1 vssd1 vccd1 vccd1 sky130_fd_sc_hd__fill_2
X_2923_ SB0.route_sel\[122\] _1569_ _1570_ SB0.route_sel\[125\] _1482_ vssd1 vssd1
+ vccd1 vccd1 _1483_ sky130_fd_sc_hd__a221o_1
X_2785_ _0484_ _0492_ _0486_ vssd1 vssd1 vccd1 vccd1 _1399_ sky130_fd_sc_hd__o21a_1
X_1736_ SB0.route_sel\[114\] SB0.route_sel\[115\] _0369_ _1605_ vssd1 vssd1 vccd1
+ vccd1 _0370_ sky130_fd_sc_hd__a31oi_1
X_2854_ SB0.route_sel\[95\] SB0.route_sel\[94\] SB0.route_sel\[89\] _1553_ _1436_
+ vssd1 vssd1 vccd1 vccd1 _1437_ sky130_fd_sc_hd__o221a_1
X_1805_ CB_1.config_dataB\[21\] CB_1.config_dataB\[24\] CB_1.config_dataB\[20\] vssd1
+ vssd1 vccd1 vccd1 _0439_ sky130_fd_sc_hd__or3b_2
X_3337_ clknet_leaf_15_clk _0033_ net257 vssd1 vssd1 vccd1 vccd1 LEI0.config_data\[32\]
+ sky130_fd_sc_hd__dfrtp_1
X_1667_ SB0.route_sel\[81\] vssd1 vssd1 vccd1 vccd1 _1549_ sky130_fd_sc_hd__inv_2
X_3406_ clknet_leaf_24_clk _0102_ net244 vssd1 vssd1 vccd1 vccd1 LE_1A.config_data\[7\]
+ sky130_fd_sc_hd__dfrtp_1
X_2219_ net153 net149 LEI0.config_data\[36\] vssd1 vssd1 vccd1 vccd1 _0853_ sky130_fd_sc_hd__mux2_1
X_3268_ CB_1.config_dataA\[9\] CB_1.config_dataA\[8\] net305 vssd1 vssd1 vccd1 vccd1
+ _0328_ sky130_fd_sc_hd__mux2_1
X_3199_ SB0.route_sel\[118\] SB0.route_sel\[117\] net297 vssd1 vssd1 vccd1 vccd1 _0259_
+ sky130_fd_sc_hd__mux2_1
XFILLER_38_194 vssd1 vssd1 vccd1 vccd1 sky130_fd_sc_hd__fill_2
XFILLER_38_150 vssd1 vssd1 vccd1 vccd1 sky130_fd_sc_hd__fill_2
XFILLER_41_337 vssd1 vssd1 vccd1 vccd1 sky130_fd_sc_hd__fill_4
XTAP_TAPCELL_ROW_36_395 vssd1 vccd1 sky130_fd_sc_hd__tapvpwrvgnd_1
XPHY_EDGE_ROW_12_Left_80 vssd1 vssd1 vccd1 vccd1 sky130_fd_sc_hd__decap_3
XFILLER_17_312 vssd1 vssd1 vccd1 vccd1 sky130_fd_sc_hd__fill_1
XFILLER_32_304 vssd1 vssd1 vccd1 vccd1 sky130_fd_sc_hd__fill_4
XFILLER_17_334 vssd1 vssd1 vccd1 vccd1 sky130_fd_sc_hd__fill_2
X_2570_ net168 _1092_ vssd1 vssd1 vccd1 vccd1 _1200_ sky130_fd_sc_hd__nand2_1
X_3122_ SB0.route_sel\[41\] SB0.route_sel\[40\] net267 vssd1 vssd1 vccd1 vccd1 _0182_
+ sky130_fd_sc_hd__mux2_1
X_2004_ net159 _0571_ net28 vssd1 vssd1 vccd1 vccd1 _0638_ sky130_fd_sc_hd__o21bai_1
X_3053_ net424 LE_1A.edge_mode net279 vssd1 vssd1 vccd1 vccd1 _0113_ sky130_fd_sc_hd__mux2_1
XFILLER_50_156 vssd1 vssd1 vccd1 vccd1 sky130_fd_sc_hd__fill_2
XFILLER_50_123 vssd1 vssd1 vccd1 vccd1 sky130_fd_sc_hd__fill_8
XFILLER_50_101 vssd1 vssd1 vccd1 vccd1 sky130_fd_sc_hd__fill_1
X_2906_ _1471_ net136 vssd1 vssd1 vccd1 vccd1 net127 sky130_fd_sc_hd__and2b_1
XFILLER_35_175 vssd1 vssd1 vccd1 vccd1 sky130_fd_sc_hd__fill_4
XTAP_TAPCELL_ROW_33_376 vssd1 vccd1 sky130_fd_sc_hd__tapvpwrvgnd_1
X_2768_ LE_1B.config_data\[16\] _1393_ _1394_ _0868_ vssd1 vssd1 vccd1 vccd1 CB_1.le_outB
+ sky130_fd_sc_hd__o211a_1
X_1719_ LE_1B.config_data\[16\] vssd1 vssd1 vccd1 vccd1 _1601_ sky130_fd_sc_hd__inv_2
X_2837_ net142 _0397_ _0653_ _0655_ _1426_ vssd1 vssd1 vccd1 vccd1 net80 sky130_fd_sc_hd__a32oi_2
X_2699_ _1083_ _1310_ _1312_ _1079_ _1598_ vssd1 vssd1 vccd1 vccd1 _1327_ sky130_fd_sc_hd__a221o_1
XFILLER_26_197 vssd1 vssd1 vccd1 vccd1 sky130_fd_sc_hd__fill_2
XFILLER_26_153 vccd1 vssd1 vccd1 vssd1 sky130_ef_sc_hd__decap_40_12
XFILLER_25_54 vssd1 vssd1 vccd1 vccd1 sky130_fd_sc_hd__fill_2
XFILLER_41_189 vssd1 vssd1 vccd1 vccd1 sky130_fd_sc_hd__fill_1
XFILLER_41_167 vssd1 vssd1 vccd1 vccd1 sky130_fd_sc_hd__fill_1
XFILLER_41_97 vssd1 vssd1 vccd1 vccd1 sky130_fd_sc_hd__fill_1
XFILLER_41_31 vssd1 vssd1 vccd1 vccd1 sky130_fd_sc_hd__fill_4
XFILLER_2_25 vssd1 vssd1 vccd1 vccd1 sky130_fd_sc_hd__fill_2
XANTENNA_19 net131 vssd1 vssd1 vccd1 vccd1 sky130_fd_sc_hd__diode_2
XFILLER_32_167 vssd1 vssd1 vccd1 vccd1 sky130_fd_sc_hd__fill_1
Xoutput126 net126 vssd1 vssd1 vccd1 vccd1 SBwest_out[1] sky130_fd_sc_hd__buf_2
X_2553_ LEI0.config_data\[30\] net140 vssd1 vssd1 vccd1 vccd1 _1183_ sky130_fd_sc_hd__nand2_1
XTAP_TAPCELL_ROW_30_357 vssd1 vccd1 sky130_fd_sc_hd__tapvpwrvgnd_1
Xoutput104 net104 vssd1 vssd1 vccd1 vccd1 SBsouth_out[10] sky130_fd_sc_hd__buf_2
Xoutput115 net115 vssd1 vssd1 vccd1 vccd1 SBsouth_out[6] sky130_fd_sc_hd__buf_2
X_2622_ net213 _1092_ vssd1 vssd1 vccd1 vccd1 _1250_ sky130_fd_sc_hd__nand2_1
X_2484_ net175 _1030_ vssd1 vssd1 vccd1 vccd1 _1114_ sky130_fd_sc_hd__or2_1
X_3105_ SB0.route_sel\[24\] SB0.route_sel\[23\] net263 vssd1 vssd1 vccd1 vccd1 _0165_
+ sky130_fd_sc_hd__mux2_1
XTAP_TAPCELL_ROW_38_413 vssd1 vccd1 sky130_fd_sc_hd__tapvpwrvgnd_1
X_3036_ LE_1A.config_data\[1\] LE_1A.config_data\[0\] net280 vssd1 vssd1 vccd1 vccd1
+ _0096_ sky130_fd_sc_hd__mux2_1
XFILLER_23_167 vssd1 vssd1 vccd1 vccd1 sky130_fd_sc_hd__fill_1
XFILLER_23_178 vssd1 vssd1 vccd1 vccd1 sky130_fd_sc_hd__fill_4
Xinput28 CBnorth_in[5] vssd1 vssd1 vccd1 vccd1 net28 sky130_fd_sc_hd__clkbuf_2
Xinput17 CBnorth_in[0] vssd1 vssd1 vccd1 vccd1 net17 sky130_fd_sc_hd__buf_2
Xinput39 SBsouth_in[15] vssd1 vssd1 vccd1 vccd1 net39 sky130_fd_sc_hd__buf_1
XFILLER_28_6 vssd1 vssd1 vccd1 vccd1 sky130_fd_sc_hd__fill_2
XFILLER_60_251 vssd1 vssd1 vccd1 vccd1 sky130_fd_sc_hd__fill_1
X_1984_ SB0.route_sel\[36\] SB0.route_sel\[37\] net43 vssd1 vssd1 vccd1 vccd1 _0618_
+ sky130_fd_sc_hd__a21boi_1
X_3654_ clknet_leaf_26_clk net327 net243 vssd1 vssd1 vccd1 vccd1 LE_1B.config_data\[6\]
+ sky130_fd_sc_hd__dfrtp_1
X_3585_ clknet_leaf_13_clk _0281_ net250 vssd1 vssd1 vccd1 vccd1 CB_0.config_dataA\[12\]
+ sky130_fd_sc_hd__dfstp_1
X_2536_ net170 _1163_ _1164_ _1165_ vssd1 vssd1 vccd1 vccd1 _1166_ sky130_fd_sc_hd__a31o_1
X_2467_ net177 _1096_ vssd1 vssd1 vccd1 vccd1 _1097_ sky130_fd_sc_hd__or2_1
X_2605_ _1151_ _1234_ _1233_ _1186_ vssd1 vssd1 vccd1 vccd1 _1235_ sky130_fd_sc_hd__o211a_1
X_2398_ SB0.route_sel\[119\] _1567_ vssd1 vssd1 vccd1 vccd1 _1028_ sky130_fd_sc_hd__nor2_1
XFILLER_28_259 vssd1 vssd1 vccd1 vccd1 sky130_fd_sc_hd__fill_1
X_3019_ net407 LE_0B.config_data\[5\] net290 vssd1 vssd1 vccd1 vccd1 _0079_ sky130_fd_sc_hd__mux2_1
XFILLER_22_33 vssd1 vssd1 vccd1 vccd1 sky130_fd_sc_hd__fill_1
XFILLER_22_66 vssd1 vssd1 vccd1 vccd1 sky130_fd_sc_hd__fill_1
Xfanout183 CB_0.config_dataB\[11\] vssd1 vssd1 vccd1 vccd1 net183 sky130_fd_sc_hd__buf_2
Xfanout150 CB_0.le_outB vssd1 vssd1 vccd1 vccd1 net150 sky130_fd_sc_hd__buf_1
Xfanout172 CB_1.config_dataA\[10\] vssd1 vssd1 vccd1 vccd1 net172 sky130_fd_sc_hd__buf_2
XTAP_TAPCELL_ROW_6_185 vssd1 vccd1 sky130_fd_sc_hd__tapvpwrvgnd_1
XFILLER_19_204 vccd1 vssd1 vccd1 vssd1 sky130_ef_sc_hd__decap_40_12
Xfanout161 _0411_ vssd1 vssd1 vccd1 vccd1 net161 sky130_fd_sc_hd__buf_2
Xfanout194 CB_0.config_dataA\[10\] vssd1 vssd1 vccd1 vccd1 net194 sky130_fd_sc_hd__buf_2
XFILLER_47_41 vssd1 vssd1 vccd1 vccd1 sky130_fd_sc_hd__fill_1
XFILLER_8_24 vssd1 vssd1 vccd1 vccd1 sky130_fd_sc_hd__fill_4
XFILLER_8_79 vssd1 vssd1 vccd1 vccd1 sky130_fd_sc_hd__fill_1
X_2321_ net184 _0511_ _0952_ net183 vssd1 vssd1 vccd1 vccd1 _0953_ sky130_fd_sc_hd__o211a_1
X_3370_ clknet_leaf_6_clk _0066_ net230 vssd1 vssd1 vccd1 vccd1 LE_0A.config_data\[15\]
+ sky130_fd_sc_hd__dfrtp_1
X_2183_ LE_0A.config_data\[10\] _0736_ _0740_ vssd1 vssd1 vccd1 vccd1 _0817_ sky130_fd_sc_hd__and3_1
X_2252_ net188 _0492_ vssd1 vssd1 vccd1 vccd1 _0884_ sky130_fd_sc_hd__nand2_1
XFILLER_26_3 vssd1 vssd1 vccd1 vccd1 sky130_fd_sc_hd__fill_2
XTAP_TAPCELL_ROW_63_588 vssd1 vccd1 sky130_fd_sc_hd__tapvpwrvgnd_1
XFILLER_25_229 vssd1 vssd1 vccd1 vccd1 sky130_fd_sc_hd__fill_2
XFILLER_21_402 vssd1 vssd1 vccd1 vccd1 sky130_fd_sc_hd__fill_1
X_1898_ _0531_ vssd1 vssd1 vccd1 vccd1 _0532_ sky130_fd_sc_hd__inv_2
X_3637_ clknet_leaf_17_clk _0333_ net259 vssd1 vssd1 vccd1 vccd1 CB_1.config_dataA\[14\]
+ sky130_fd_sc_hd__dfstp_1
X_1967_ SB0.route_sel\[52\] _1526_ SB0.route_sel\[55\] _1528_ _0600_ vssd1 vssd1 vccd1
+ vccd1 _0601_ sky130_fd_sc_hd__a221o_1
X_2519_ LEI0.config_data\[20\] _1146_ _1148_ _1117_ _1144_ vssd1 vssd1 vccd1 vccd1
+ _1149_ sky130_fd_sc_hd__o32a_1
X_3568_ clknet_leaf_20_clk _0264_ net249 vssd1 vssd1 vccd1 vccd1 SB0.route_sel\[123\]
+ sky130_fd_sc_hd__dfstp_1
X_3499_ clknet_leaf_32_clk _0195_ net222 vssd1 vssd1 vccd1 vccd1 SB0.route_sel\[54\]
+ sky130_fd_sc_hd__dfstp_1
XFILLER_56_354 vssd1 vssd1 vccd1 vccd1 sky130_fd_sc_hd__fill_1
XFILLER_56_332 vssd1 vssd1 vccd1 vccd1 sky130_fd_sc_hd__fill_2
XTAP_TAPCELL_ROW_54_522 vssd1 vccd1 sky130_fd_sc_hd__tapvpwrvgnd_1
XTAP_TAPCELL_ROW_3_166 vssd1 vccd1 sky130_fd_sc_hd__tapvpwrvgnd_1
XFILLER_16_229 vssd1 vssd1 vccd1 vccd1 sky130_fd_sc_hd__fill_1
XFILLER_33_87 vssd1 vssd1 vccd1 vccd1 sky130_fd_sc_hd__fill_4
XFILLER_24_251 vssd1 vssd1 vccd1 vccd1 sky130_fd_sc_hd__fill_1
Xhold6 _0358_ vssd1 vssd1 vccd1 vccd1 net316 sky130_fd_sc_hd__dlygate4sd3_1
X_2870_ _1447_ _0546_ vssd1 vssd1 vccd1 vccd1 net133 sky130_fd_sc_hd__and2b_1
XTAP_TAPCELL_ROW_17_268 vssd1 vccd1 sky130_fd_sc_hd__tapvpwrvgnd_1
XTAP_TAPCELL_ROW_60_569 vssd1 vccd1 sky130_fd_sc_hd__tapvpwrvgnd_1
X_1821_ net147 _0376_ _0453_ vssd1 vssd1 vccd1 vccd1 _0455_ sky130_fd_sc_hd__or3_1
X_1683_ SB0.route_sel\[114\] vssd1 vssd1 vccd1 vccd1 _1565_ sky130_fd_sc_hd__inv_2
X_1752_ _1496_ net137 _0384_ vssd1 vssd1 vccd1 vccd1 _0386_ sky130_fd_sc_hd__nand3_1
X_2304_ net153 net149 net145 net139 LEI0.config_data\[15\] LEI0.config_data\[16\]
+ vssd1 vssd1 vccd1 vccd1 _0936_ sky130_fd_sc_hd__mux4_1
X_3422_ clknet_leaf_21_clk _0118_ net240 vssd1 vssd1 vccd1 vccd1 CB_1.config_dataB\[2\]
+ sky130_fd_sc_hd__dfstp_2
X_3353_ LE_0A.sel_clk _0049_ net69 vssd1 vssd1 vccd1 vccd1 LE_0A.dff0_out sky130_fd_sc_hd__dfrtp_1
X_3284_ net422 LE_0A.reset_mode net276 vssd1 vssd1 vccd1 vccd1 _0344_ sky130_fd_sc_hd__mux2_1
Xmax_cap136 _0691_ vssd1 vssd1 vccd1 vccd1 net136 sky130_fd_sc_hd__clkbuf_2
X_2166_ _1573_ _0798_ _0799_ vssd1 vssd1 vccd1 vccd1 _0800_ sky130_fd_sc_hd__or3_1
XFILLER_53_335 vssd1 vssd1 vccd1 vccd1 sky130_fd_sc_hd__fill_1
X_2235_ LE_0A.dff0_out LE_0A.dff1_out LE_0A.reset_val vssd1 vssd1 vccd1 vccd1 LE_0A.dff_out
+ sky130_fd_sc_hd__mux2_1
X_2097_ SB0.route_sel\[3\] SB0.route_sel\[2\] vssd1 vssd1 vccd1 vccd1 _0731_ sky130_fd_sc_hd__nor2_1
XTAP_TAPCELL_ROW_0_147 vssd1 vccd1 sky130_fd_sc_hd__tapvpwrvgnd_1
XTAP_TAPCELL_ROW_0_136 vssd1 vccd1 sky130_fd_sc_hd__tapvpwrvgnd_1
X_2999_ net323 net328 net293 vssd1 vssd1 vccd1 vccd1 _0059_ sky130_fd_sc_hd__mux2_1
XTAP_TAPCELL_ROW_51_503 vssd1 vccd1 sky130_fd_sc_hd__tapvpwrvgnd_1
XPHY_EDGE_ROW_3_Right_3 vssd1 vssd1 vccd1 vccd1 sky130_fd_sc_hd__decap_3
XTAP_TAPCELL_ROW_8_203 vssd1 vccd1 sky130_fd_sc_hd__tapvpwrvgnd_1
XFILLER_0_169 vssd1 vssd1 vccd1 vccd1 sky130_fd_sc_hd__fill_2
XFILLER_56_184 vssd1 vssd1 vccd1 vccd1 sky130_fd_sc_hd__fill_1
XFILLER_56_151 vccd1 vssd1 vccd1 vssd1 sky130_ef_sc_hd__decap_40_12
XFILLER_44_302 vssd1 vssd1 vccd1 vccd1 sky130_fd_sc_hd__fill_1
XFILLER_5_47 vssd1 vssd1 vccd1 vccd1 sky130_fd_sc_hd__fill_8
XFILLER_47_151 vssd1 vssd1 vccd1 vccd1 sky130_fd_sc_hd__fill_1
XFILLER_10_6 vssd1 vssd1 vccd1 vccd1 sky130_fd_sc_hd__fill_1
X_2020_ CB_1.config_dataA\[23\] CB_1.config_dataA\[22\] vssd1 vssd1 vccd1 vccd1 _0654_
+ sky130_fd_sc_hd__or2_1
XFILLER_62_187 vssd1 vssd1 vccd1 vccd1 sky130_fd_sc_hd__fill_1
X_2922_ SB0.route_sel\[120\] SB0.route_sel\[121\] vssd1 vssd1 vccd1 vccd1 _1482_ sky130_fd_sc_hd__nor2_1
X_2853_ SB0.route_sel\[91\] _1550_ vssd1 vssd1 vccd1 vccd1 _1436_ sky130_fd_sc_hd__nand2_1
X_2784_ net152 _1398_ _0424_ vssd1 vssd1 vccd1 vccd1 net90 sky130_fd_sc_hd__mux2_1
X_1735_ SB0.route_sel\[116\] SB0.route_sel\[117\] net54 _0366_ _0367_ vssd1 vssd1
+ vccd1 vccd1 _0369_ sky130_fd_sc_hd__a41o_1
X_1804_ _0432_ _0434_ _0437_ vssd1 vssd1 vccd1 vccd1 _0438_ sky130_fd_sc_hd__a21oi_1
X_1666_ SB0.route_sel\[84\] vssd1 vssd1 vccd1 vccd1 _1548_ sky130_fd_sc_hd__inv_2
X_3336_ clknet_leaf_15_clk _0032_ net257 vssd1 vssd1 vccd1 vccd1 LEI0.config_data\[31\]
+ sky130_fd_sc_hd__dfrtp_1
X_3267_ CB_1.config_dataA\[8\] CB_1.config_dataA\[7\] net304 vssd1 vssd1 vccd1 vccd1
+ _0327_ sky130_fd_sc_hd__mux2_1
X_3405_ clknet_leaf_24_clk net337 net244 vssd1 vssd1 vccd1 vccd1 LE_1A.config_data\[6\]
+ sky130_fd_sc_hd__dfrtp_1
X_2149_ net195 net193 vssd1 vssd1 vccd1 vccd1 _0783_ sky130_fd_sc_hd__nor2_1
X_2218_ LEI0.config_data\[36\] net143 _0851_ LEI0.config_data\[37\] vssd1 vssd1 vccd1
+ vccd1 _0852_ sky130_fd_sc_hd__o211a_1
X_3198_ SB0.route_sel\[117\] SB0.route_sel\[116\] net297 vssd1 vssd1 vccd1 vccd1 _0258_
+ sky130_fd_sc_hd__mux2_1
XFILLER_41_327 vssd1 vssd1 vccd1 vccd1 sky130_fd_sc_hd__fill_8
XTAP_TAPCELL_ROW_36_396 vssd1 vccd1 sky130_fd_sc_hd__tapvpwrvgnd_1
XFILLER_55_63 vssd1 vssd1 vccd1 vccd1 sky130_fd_sc_hd__fill_2
XFILLER_44_187 vssd1 vssd1 vccd1 vccd1 sky130_fd_sc_hd__fill_1
XFILLER_44_154 vssd1 vssd1 vccd1 vccd1 sky130_fd_sc_hd__fill_4
X_3121_ SB0.route_sel\[40\] SB0.route_sel\[39\] net263 vssd1 vssd1 vccd1 vccd1 _0181_
+ sky130_fd_sc_hd__mux2_1
X_2003_ net146 net159 _0571_ _0568_ _0451_ vssd1 vssd1 vccd1 vccd1 _0637_ sky130_fd_sc_hd__o32a_1
X_3052_ LE_1A.edge_mode LE_1A.config_data\[16\] net279 vssd1 vssd1 vccd1 vccd1 _0112_
+ sky130_fd_sc_hd__mux2_1
XTAP_TAPCELL_ROW_33_377 vssd1 vccd1 sky130_fd_sc_hd__tapvpwrvgnd_1
XFILLER_31_393 vssd1 vssd1 vccd1 vccd1 sky130_fd_sc_hd__fill_2
X_2905_ SB0.route_sel\[20\] _1509_ SB0.route_sel\[16\] SB0.route_sel\[17\] _1470_
+ vssd1 vssd1 vccd1 vccd1 _1471_ sky130_fd_sc_hd__o221a_1
X_2836_ net162 net156 _1092_ vssd1 vssd1 vccd1 vccd1 _1426_ sky130_fd_sc_hd__o21ai_1
X_2767_ _1601_ LE_1B.dff_out vssd1 vssd1 vccd1 vccd1 _1394_ sky130_fd_sc_hd__or2_1
X_1718_ LE_1B.config_data\[8\] vssd1 vssd1 vccd1 vccd1 _1600_ sky130_fd_sc_hd__inv_2
X_1649_ SB0.route_sel\[58\] vssd1 vssd1 vccd1 vccd1 _1531_ sky130_fd_sc_hd__inv_2
X_2698_ net206 _1071_ vssd1 vssd1 vccd1 vccd1 _1326_ sky130_fd_sc_hd__nand2_1
X_3319_ clknet_leaf_13_clk _0015_ net251 vssd1 vssd1 vccd1 vccd1 LEI0.config_data\[14\]
+ sky130_fd_sc_hd__dfrtp_1
XFILLER_58_213 vssd1 vssd1 vccd1 vccd1 sky130_fd_sc_hd__fill_1
XFILLER_41_135 vssd1 vssd1 vccd1 vccd1 sky130_fd_sc_hd__fill_1
XFILLER_41_113 vssd1 vssd1 vccd1 vccd1 sky130_fd_sc_hd__fill_2
XFILLER_26_165 vssd1 vssd1 vccd1 vccd1 sky130_fd_sc_hd__fill_2
XFILLER_25_66 vccd1 vssd1 vccd1 vssd1 sky130_ef_sc_hd__decap_40_12
XTAP_TAPCELL_ROW_24_311 vssd1 vccd1 sky130_fd_sc_hd__tapvpwrvgnd_1
XFILLER_41_54 vssd1 vssd1 vccd1 vccd1 sky130_fd_sc_hd__fill_2
XFILLER_49_213 vssd1 vssd1 vccd1 vccd1 sky130_fd_sc_hd__fill_2
XFILLER_1_220 vssd1 vssd1 vccd1 vccd1 sky130_fd_sc_hd__fill_1
XTAP_TAPCELL_ROW_30_358 vssd1 vccd1 sky130_fd_sc_hd__tapvpwrvgnd_1
XFILLER_20_319 vssd1 vssd1 vccd1 vccd1 sky130_fd_sc_hd__fill_2
X_2552_ LEI0.config_data\[31\] _1181_ vssd1 vssd1 vccd1 vccd1 _1182_ sky130_fd_sc_hd__nor2_1
Xoutput127 net127 vssd1 vssd1 vccd1 vccd1 SBwest_out[2] sky130_fd_sc_hd__buf_2
Xoutput116 net116 vssd1 vssd1 vccd1 vccd1 SBsouth_out[7] sky130_fd_sc_hd__buf_2
Xoutput105 net105 vssd1 vssd1 vccd1 vccd1 SBsouth_out[11] sky130_fd_sc_hd__buf_2
X_2483_ _1068_ _1106_ _1112_ vssd1 vssd1 vccd1 vccd1 _1113_ sky130_fd_sc_hd__o21ai_4
X_2621_ _1594_ _1246_ _1248_ vssd1 vssd1 vccd1 vccd1 _1249_ sky130_fd_sc_hd__a21oi_1
XTAP_TAPCELL_ROW_38_414 vssd1 vccd1 sky130_fd_sc_hd__tapvpwrvgnd_1
X_3035_ LE_1A.config_data\[0\] LE_0B.reset_mode net276 vssd1 vssd1 vccd1 vccd1 _0095_
+ sky130_fd_sc_hd__mux2_1
X_3104_ SB0.route_sel\[23\] SB0.route_sel\[22\] net262 vssd1 vssd1 vccd1 vccd1 _0164_
+ sky130_fd_sc_hd__mux2_1
XFILLER_23_113 vccd1 vssd1 vccd1 vssd1 sky130_ef_sc_hd__decap_40_12
XFILLER_23_135 vccd1 vssd1 vccd1 vssd1 sky130_ef_sc_hd__decap_40_12
X_2819_ _0395_ _0469_ _1054_ vssd1 vssd1 vccd1 vccd1 _1417_ sky130_fd_sc_hd__o21ai_1
Xfanout310 net66 vssd1 vssd1 vccd1 vccd1 net310 sky130_fd_sc_hd__clkbuf_4
Xinput18 CBnorth_in[10] vssd1 vssd1 vccd1 vccd1 net18 sky130_fd_sc_hd__buf_2
XFILLER_22_190 vssd1 vssd1 vccd1 vccd1 sky130_fd_sc_hd__fill_4
Xinput29 CBnorth_in[6] vssd1 vssd1 vccd1 vccd1 net29 sky130_fd_sc_hd__buf_2
XFILLER_37_227 vssd1 vssd1 vccd1 vccd1 sky130_fd_sc_hd__fill_1
XFILLER_37_216 vssd1 vssd1 vccd1 vccd1 sky130_fd_sc_hd__fill_2
XTAP_TAPCELL_ROW_43_450 vssd1 vccd1 sky130_fd_sc_hd__tapvpwrvgnd_1
XFILLER_37_249 vssd1 vssd1 vccd1 vccd1 sky130_fd_sc_hd__fill_4
X_2604_ LE_1A.config_data\[0\] LE_1A.config_data\[1\] _1113_ vssd1 vssd1 vccd1 vccd1
+ _1234_ sky130_fd_sc_hd__mux2_1
X_1983_ SB0.route_sel\[39\] SB0.route_sel\[38\] vssd1 vssd1 vccd1 vccd1 _0617_ sky130_fd_sc_hd__nand2_1
X_3653_ clknet_leaf_26_clk _0349_ net243 vssd1 vssd1 vccd1 vccd1 LE_1B.config_data\[5\]
+ sky130_fd_sc_hd__dfrtp_1
XFILLER_20_149 vssd1 vssd1 vccd1 vccd1 sky130_fd_sc_hd__fill_2
X_3584_ clknet_leaf_13_clk _0280_ net250 vssd1 vssd1 vccd1 vccd1 CB_0.config_dataA\[11\]
+ sky130_fd_sc_hd__dfstp_1
X_2535_ _1065_ _1155_ _1157_ _1062_ CB_1.config_dataA\[12\] vssd1 vssd1 vccd1 vccd1
+ _1165_ sky130_fd_sc_hd__a221o_1
X_2466_ _0691_ _1095_ vssd1 vssd1 vccd1 vccd1 _1096_ sky130_fd_sc_hd__nand2_4
X_3018_ LE_0B.config_data\[5\] net351 net290 vssd1 vssd1 vccd1 vccd1 _0078_ sky130_fd_sc_hd__mux2_1
X_2397_ LE_0B.config_data\[16\] _1026_ _1027_ _0868_ vssd1 vssd1 vccd1 vccd1 CB_0.le_outB
+ sky130_fd_sc_hd__o211a_2
Xfanout195 CB_0.config_dataA\[10\] vssd1 vssd1 vccd1 vccd1 net195 sky130_fd_sc_hd__clkbuf_2
Xfanout184 net185 vssd1 vssd1 vccd1 vccd1 net184 sky130_fd_sc_hd__clkbuf_2
Xfanout140 net141 vssd1 vssd1 vccd1 vccd1 net140 sky130_fd_sc_hd__dlymetal6s2s_1
Xfanout173 CB_1.config_dataA\[6\] vssd1 vssd1 vccd1 vccd1 net173 sky130_fd_sc_hd__buf_2
Xfanout151 CB_0.le_outA vssd1 vssd1 vccd1 vccd1 net151 sky130_fd_sc_hd__buf_2
XTAP_TAPCELL_ROW_6_186 vssd1 vccd1 sky130_fd_sc_hd__tapvpwrvgnd_1
Xfanout162 _0395_ vssd1 vssd1 vccd1 vccd1 net162 sky130_fd_sc_hd__buf_2
XFILLER_19_216 vssd1 vssd1 vccd1 vccd1 sky130_fd_sc_hd__fill_8
XTAP_TAPCELL_ROW_57_542 vssd1 vccd1 sky130_fd_sc_hd__tapvpwrvgnd_1
XFILLER_10_182 vssd1 vssd1 vccd1 vccd1 sky130_fd_sc_hd__fill_4
X_2320_ net184 _0492_ vssd1 vssd1 vccd1 vccd1 _0952_ sky130_fd_sc_hd__nand2_1
X_2251_ _1577_ _0881_ _0882_ vssd1 vssd1 vccd1 vccd1 _0883_ sky130_fd_sc_hd__o21ai_1
X_2182_ _0778_ _0780_ _0813_ _0815_ vssd1 vssd1 vccd1 vccd1 _0816_ sky130_fd_sc_hd__o211a_1
XTAP_TAPCELL_ROW_63_589 vssd1 vccd1 sky130_fd_sc_hd__tapvpwrvgnd_1
X_1966_ SB0.route_sel\[50\] SB0.route_sel\[51\] vssd1 vssd1 vccd1 vccd1 _0600_ sky130_fd_sc_hd__nor2_1
X_1897_ _0528_ _0530_ vssd1 vssd1 vccd1 vccd1 _0531_ sky130_fd_sc_hd__nand2_2
X_3636_ clknet_leaf_17_clk _0332_ net259 vssd1 vssd1 vccd1 vccd1 CB_1.config_dataA\[13\]
+ sky130_fd_sc_hd__dfstp_1
X_3567_ clknet_leaf_11_clk _0263_ net249 vssd1 vssd1 vccd1 vccd1 SB0.route_sel\[122\]
+ sky130_fd_sc_hd__dfstp_1
X_2518_ LEI0.config_data\[18\] _1603_ _1147_ LEI0.config_data\[19\] vssd1 vssd1 vccd1
+ vccd1 _1148_ sky130_fd_sc_hd__o211a_1
X_3498_ clknet_leaf_32_clk _0194_ net222 vssd1 vssd1 vccd1 vccd1 SB0.route_sel\[53\]
+ sky130_fd_sc_hd__dfstp_1
X_2449_ net267 _0621_ _1078_ vssd1 vssd1 vccd1 vccd1 _1079_ sky130_fd_sc_hd__or3_4
XTAP_TAPCELL_ROW_54_523 vssd1 vccd1 sky130_fd_sc_hd__tapvpwrvgnd_1
XTAP_TAPCELL_ROW_3_167 vssd1 vccd1 sky130_fd_sc_hd__tapvpwrvgnd_1
XFILLER_33_55 vssd1 vssd1 vccd1 vccd1 sky130_fd_sc_hd__fill_1
Xhold7 LE_1B.config_data\[10\] vssd1 vssd1 vccd1 vccd1 net317 sky130_fd_sc_hd__dlygate4sd3_1
X_1820_ _0376_ net159 vssd1 vssd1 vccd1 vccd1 _0454_ sky130_fd_sc_hd__nor2_1
XFILLER_30_255 vssd1 vssd1 vccd1 vccd1 sky130_fd_sc_hd__fill_1
XFILLER_30_244 vssd1 vssd1 vccd1 vccd1 sky130_fd_sc_hd__fill_2
Xmax_cap137 _0382_ vssd1 vssd1 vccd1 vccd1 net137 sky130_fd_sc_hd__clkbuf_2
X_1751_ net137 _0384_ vssd1 vssd1 vccd1 vccd1 _0385_ sky130_fd_sc_hd__nand2_4
X_1682_ SB0.route_sel\[105\] vssd1 vssd1 vccd1 vccd1 _1564_ sky130_fd_sc_hd__inv_2
X_3421_ clknet_leaf_21_clk _0117_ net240 vssd1 vssd1 vccd1 vccd1 CB_1.config_dataB\[1\]
+ sky130_fd_sc_hd__dfstp_1
X_3352_ clknet_leaf_14_clk _0048_ net255 vssd1 vssd1 vccd1 vccd1 CB_0.config_data_inA
+ sky130_fd_sc_hd__dfrtp_1
X_2303_ CB_0.config_dataB\[8\] _0907_ CB_0.config_dataB\[7\] CB_0.config_dataB\[9\]
+ vssd1 vssd1 vccd1 vccd1 _0935_ sky130_fd_sc_hd__or4b_1
XFILLER_38_300 vssd1 vssd1 vccd1 vccd1 sky130_fd_sc_hd__fill_8
X_3283_ CB_1.config_dataA\[24\] CB_1.config_dataA\[23\] net277 vssd1 vssd1 vccd1 vccd1
+ _0343_ sky130_fd_sc_hd__mux2_1
X_2234_ _1502_ net236 vssd1 vssd1 vccd1 vccd1 _0868_ sky130_fd_sc_hd__and2_2
X_2165_ _0786_ _0645_ _0626_ _0783_ vssd1 vssd1 vccd1 vccd1 _0799_ sky130_fd_sc_hd__a2bb2o_1
XTAP_TAPCELL_ROW_51_504 vssd1 vccd1 sky130_fd_sc_hd__tapvpwrvgnd_1
XTAP_TAPCELL_ROW_0_148 vssd1 vccd1 sky130_fd_sc_hd__tapvpwrvgnd_1
XTAP_TAPCELL_ROW_0_137 vssd1 vccd1 sky130_fd_sc_hd__tapvpwrvgnd_1
X_2096_ _1500_ _0719_ _0723_ _0729_ _1502_ vssd1 vssd1 vccd1 vccd1 _0730_ sky130_fd_sc_hd__o311a_2
X_2998_ net328 net334 net294 vssd1 vssd1 vccd1 vccd1 _0058_ sky130_fd_sc_hd__mux2_1
X_1949_ SB0.route_sel\[49\] SB0.route_sel\[48\] vssd1 vssd1 vccd1 vccd1 _0583_ sky130_fd_sc_hd__nand2_1
XFILLER_21_200 vssd1 vssd1 vccd1 vccd1 sky130_fd_sc_hd__fill_4
X_3619_ clknet_leaf_12_clk _0315_ net250 vssd1 vssd1 vccd1 vccd1 CB_0.config_dataB\[21\]
+ sky130_fd_sc_hd__dfstp_1
XTAP_TAPCELL_ROW_8_204 vssd1 vccd1 sky130_fd_sc_hd__tapvpwrvgnd_1
XFILLER_56_163 vssd1 vssd1 vccd1 vccd1 sky130_fd_sc_hd__fill_4
XFILLER_56_141 vssd1 vssd1 vccd1 vccd1 sky130_fd_sc_hd__fill_2
XFILLER_28_22 vssd1 vssd1 vccd1 vccd1 sky130_fd_sc_hd__fill_4
XFILLER_0_137 vssd1 vssd1 vccd1 vccd1 sky130_fd_sc_hd__fill_2
XFILLER_44_87 vssd1 vssd1 vccd1 vccd1 sky130_fd_sc_hd__fill_1
XFILLER_12_222 vssd1 vssd1 vccd1 vccd1 sky130_fd_sc_hd__fill_2
XFILLER_5_26 vssd1 vssd1 vccd1 vccd1 sky130_fd_sc_hd__fill_1
XFILLER_12_255 vssd1 vssd1 vccd1 vccd1 sky130_fd_sc_hd__fill_1
XFILLER_47_174 vssd1 vssd1 vccd1 vccd1 sky130_fd_sc_hd__fill_8
XPHY_EDGE_ROW_13_Right_13 vssd1 vssd1 vccd1 vccd1 sky130_fd_sc_hd__decap_3
X_2783_ net148 _0435_ _0427_ vssd1 vssd1 vccd1 vccd1 _1398_ sky130_fd_sc_hd__mux2_1
X_1803_ net200 net199 vssd1 vssd1 vccd1 vccd1 _0437_ sky130_fd_sc_hd__or2_1
X_2852_ _0489_ _1435_ vssd1 vssd1 vccd1 vccd1 net121 sky130_fd_sc_hd__nor2_1
X_2921_ _1481_ _0730_ vssd1 vssd1 vccd1 vccd1 net103 sky130_fd_sc_hd__and2b_1
XPHY_EDGE_ROW_22_Right_22 vssd1 vssd1 vccd1 vccd1 sky130_fd_sc_hd__decap_3
X_1734_ SB0.route_sel\[114\] SB0.route_sel\[115\] _1608_ _0364_ _0365_ vssd1 vssd1
+ vccd1 vccd1 _0368_ sky130_fd_sc_hd__a221o_1
X_1665_ SB0.route_sel\[82\] vssd1 vssd1 vccd1 vccd1 _1547_ sky130_fd_sc_hd__inv_2
X_3404_ clknet_leaf_25_clk net362 net244 vssd1 vssd1 vccd1 vccd1 LE_1A.config_data\[5\]
+ sky130_fd_sc_hd__dfrtp_1
X_3335_ clknet_leaf_15_clk _0031_ net257 vssd1 vssd1 vccd1 vccd1 LEI0.config_data\[30\]
+ sky130_fd_sc_hd__dfrtp_1
X_2217_ LEI0.config_data\[36\] net139 vssd1 vssd1 vccd1 vccd1 _0851_ sky130_fd_sc_hd__nand2_1
X_3266_ CB_1.config_dataA\[7\] net173 net304 vssd1 vssd1 vccd1 vccd1 _0326_ sky130_fd_sc_hd__mux2_1
X_3197_ SB0.route_sel\[116\] SB0.route_sel\[115\] net297 vssd1 vssd1 vccd1 vccd1 _0257_
+ sky130_fd_sc_hd__mux2_1
XFILLER_38_152 vssd1 vssd1 vccd1 vccd1 sky130_fd_sc_hd__fill_1
XFILLER_38_141 vssd1 vssd1 vccd1 vccd1 sky130_fd_sc_hd__fill_2
XPHY_EDGE_ROW_37_Left_105 vssd1 vssd1 vccd1 vccd1 sky130_fd_sc_hd__decap_3
XPHY_EDGE_ROW_31_Right_31 vssd1 vssd1 vccd1 vccd1 sky130_fd_sc_hd__decap_3
X_2148_ net194 _0385_ _0781_ net193 vssd1 vssd1 vccd1 vccd1 _0782_ sky130_fd_sc_hd__o211a_1
XPHY_EDGE_ROW_46_Left_114 vssd1 vssd1 vccd1 vccd1 sky130_fd_sc_hd__decap_3
XTAP_TAPCELL_ROW_36_397 vssd1 vccd1 sky130_fd_sc_hd__tapvpwrvgnd_1
X_2079_ SB0.route_sel\[11\] SB0.route_sel\[10\] vssd1 vssd1 vccd1 vccd1 _0713_ sky130_fd_sc_hd__nor2_1
XPHY_EDGE_ROW_40_Right_40 vssd1 vssd1 vccd1 vccd1 sky130_fd_sc_hd__decap_3
XPHY_EDGE_ROW_55_Left_123 vssd1 vssd1 vccd1 vccd1 sky130_fd_sc_hd__decap_3
XFILLER_1_402 vssd1 vssd1 vccd1 vccd1 sky130_fd_sc_hd__fill_1
XPHY_EDGE_ROW_64_Left_132 vssd1 vssd1 vccd1 vccd1 sky130_fd_sc_hd__decap_3
XFILLER_39_76 vssd1 vssd1 vccd1 vccd1 sky130_fd_sc_hd__fill_2
XFILLER_29_141 vssd1 vssd1 vccd1 vccd1 sky130_fd_sc_hd__fill_1
XFILLER_4_251 vssd1 vssd1 vccd1 vccd1 sky130_fd_sc_hd__fill_1
X_3051_ LE_1A.config_data\[16\] net404 net280 vssd1 vssd1 vccd1 vccd1 _0111_ sky130_fd_sc_hd__mux2_1
X_3120_ SB0.route_sel\[39\] SB0.route_sel\[38\] net263 vssd1 vssd1 vccd1 vccd1 _0180_
+ sky130_fd_sc_hd__mux2_1
X_2002_ net159 _0571_ vssd1 vssd1 vccd1 vccd1 _0636_ sky130_fd_sc_hd__or2_1
XFILLER_35_166 vssd1 vssd1 vccd1 vccd1 sky130_fd_sc_hd__fill_2
XFILLER_35_111 vssd1 vssd1 vccd1 vccd1 sky130_fd_sc_hd__fill_1
XFILLER_50_158 vssd1 vssd1 vccd1 vccd1 sky130_fd_sc_hd__fill_1
XTAP_TAPCELL_ROW_33_378 vssd1 vccd1 sky130_fd_sc_hd__tapvpwrvgnd_1
XFILLER_31_350 vssd1 vssd1 vccd1 vccd1 sky130_fd_sc_hd__fill_1
X_2766_ LE_1B.dff0_out LE_1B.dff1_out LE_1B.reset_val vssd1 vssd1 vccd1 vccd1 LE_1B.dff_out
+ sky130_fd_sc_hd__mux2_1
X_2904_ SB0.route_sel\[19\] SB0.route_sel\[18\] vssd1 vssd1 vccd1 vccd1 _1470_ sky130_fd_sc_hd__nand2b_1
X_2835_ net144 _1425_ _0611_ vssd1 vssd1 vccd1 vccd1 net81 sky130_fd_sc_hd__mux2_1
X_3318_ clknet_leaf_13_clk _0014_ net251 vssd1 vssd1 vccd1 vccd1 LEI0.config_data\[13\]
+ sky130_fd_sc_hd__dfrtp_1
X_1648_ net29 vssd1 vssd1 vccd1 vccd1 _1530_ sky130_fd_sc_hd__inv_2
X_1717_ CB_1.config_dataB\[17\] vssd1 vssd1 vccd1 vccd1 _1599_ sky130_fd_sc_hd__inv_2
X_2697_ net206 _1075_ vssd1 vssd1 vccd1 vccd1 _1325_ sky130_fd_sc_hd__or2_1
X_3249_ net181 CB_0.config_dataB\[14\] net292 vssd1 vssd1 vccd1 vccd1 _0309_ sky130_fd_sc_hd__mux2_1
XFILLER_41_169 vssd1 vssd1 vccd1 vccd1 sky130_fd_sc_hd__fill_1
XFILLER_25_78 vccd1 vssd1 vccd1 vssd1 sky130_ef_sc_hd__decap_40_12
XFILLER_25_34 vssd1 vssd1 vccd1 vccd1 sky130_fd_sc_hd__fill_1
XTAP_TAPCELL_ROW_24_312 vssd1 vccd1 sky130_fd_sc_hd__tapvpwrvgnd_1
XFILLER_41_77 vssd1 vssd1 vccd1 vccd1 sky130_fd_sc_hd__fill_2
XFILLER_1_210 vssd1 vssd1 vccd1 vccd1 sky130_fd_sc_hd__fill_1
XFILLER_49_225 vssd1 vssd1 vccd1 vccd1 sky130_fd_sc_hd__fill_2
XFILLER_2_27 vssd1 vssd1 vccd1 vccd1 sky130_fd_sc_hd__fill_1
XFILLER_17_100 vssd1 vssd1 vccd1 vccd1 sky130_fd_sc_hd__fill_4
XFILLER_17_177 vssd1 vssd1 vccd1 vccd1 sky130_fd_sc_hd__fill_4
XTAP_TAPCELL_ROW_30_359 vssd1 vccd1 sky130_fd_sc_hd__tapvpwrvgnd_1
X_2620_ CB_1.config_dataB\[2\] _1247_ CB_1.config_dataB\[3\] vssd1 vssd1 vccd1 vccd1
+ _1248_ sky130_fd_sc_hd__a21o_1
X_2551_ net154 net149 LEI0.config_data\[30\] vssd1 vssd1 vccd1 vccd1 _1181_ sky130_fd_sc_hd__mux2_1
X_2482_ LEI0.config_data\[8\] _1109_ _1111_ _1107_ vssd1 vssd1 vccd1 vccd1 _1112_
+ sky130_fd_sc_hd__o31a_4
Xoutput128 net128 vssd1 vssd1 vccd1 vccd1 SBwest_out[3] sky130_fd_sc_hd__buf_2
Xoutput117 net117 vssd1 vssd1 vccd1 vccd1 SBsouth_out[8] sky130_fd_sc_hd__buf_2
Xoutput106 net106 vssd1 vssd1 vccd1 vccd1 SBsouth_out[12] sky130_fd_sc_hd__buf_2
XTAP_TAPCELL_ROW_38_415 vssd1 vccd1 sky130_fd_sc_hd__tapvpwrvgnd_1
X_3034_ LE_1B.dff1_out _1393_ net68 vssd1 vssd1 vccd1 vccd1 _0094_ sky130_fd_sc_hd__mux2_1
X_3103_ SB0.route_sel\[22\] SB0.route_sel\[21\] net262 vssd1 vssd1 vccd1 vccd1 _0163_
+ sky130_fd_sc_hd__mux2_1
XFILLER_51_401 vssd1 vssd1 vccd1 vccd1 sky130_fd_sc_hd__fill_2
XTAP_TAPCELL_ROW_46_470 vssd1 vccd1 sky130_fd_sc_hd__tapvpwrvgnd_1
XFILLER_23_125 vssd1 vssd1 vccd1 vccd1 sky130_fd_sc_hd__fill_1
XFILLER_23_147 vccd1 vssd1 vccd1 vssd1 sky130_ef_sc_hd__decap_40_12
X_2818_ _0415_ _1416_ _0416_ vssd1 vssd1 vccd1 vccd1 net74 sky130_fd_sc_hd__o21a_1
X_2749_ _1266_ _1267_ _1273_ LE_1B.config_data\[4\] vssd1 vssd1 vccd1 vccd1 _1377_
+ sky130_fd_sc_hd__o211a_1
Xfanout300 net303 vssd1 vssd1 vccd1 vccd1 net300 sky130_fd_sc_hd__clkbuf_4
XFILLER_46_206 vssd1 vssd1 vccd1 vccd1 sky130_fd_sc_hd__fill_4
XFILLER_46_228 vccd1 vssd1 vccd1 vssd1 sky130_ef_sc_hd__decap_40_12
Xinput19 CBnorth_in[11] vssd1 vssd1 vccd1 vccd1 net19 sky130_fd_sc_hd__buf_2
X_1982_ net142 _0611_ _0613_ _0614_ _0615_ vssd1 vssd1 vccd1 vccd1 _0616_ sky130_fd_sc_hd__o221a_1
XFILLER_20_139 vssd1 vssd1 vccd1 vccd1 sky130_fd_sc_hd__fill_1
X_3583_ clknet_leaf_8_clk _0279_ net234 vssd1 vssd1 vccd1 vccd1 CB_0.config_dataA\[10\]
+ sky130_fd_sc_hd__dfstp_1
X_2534_ net171 _1058_ vssd1 vssd1 vccd1 vccd1 _1164_ sky130_fd_sc_hd__or2_1
X_2603_ LE_1A.config_data\[3\] _1113_ _1150_ _1232_ vssd1 vssd1 vccd1 vccd1 _1233_
+ sky130_fd_sc_hd__a211o_1
X_3652_ clknet_leaf_26_clk net348 net238 vssd1 vssd1 vccd1 vccd1 LE_1B.config_data\[4\]
+ sky130_fd_sc_hd__dfrtp_1
X_2396_ _1587_ LE_0B.dff_out vssd1 vssd1 vccd1 vccd1 _1027_ sky130_fd_sc_hd__or2_1
X_2465_ _1511_ SB0.route_sel\[17\] _1094_ vssd1 vssd1 vccd1 vccd1 _1095_ sky130_fd_sc_hd__a21bo_1
X_3017_ net351 net353 net290 vssd1 vssd1 vccd1 vccd1 _0077_ sky130_fd_sc_hd__mux2_1
XFILLER_43_209 vssd1 vssd1 vccd1 vccd1 sky130_fd_sc_hd__fill_2
XFILLER_22_24 vssd1 vssd1 vccd1 vccd1 sky130_fd_sc_hd__fill_4
Xfanout196 CB_0.config_dataA\[6\] vssd1 vssd1 vccd1 vccd1 net196 sky130_fd_sc_hd__clkbuf_2
XTAP_TAPCELL_ROW_57_543 vssd1 vccd1 sky130_fd_sc_hd__tapvpwrvgnd_1
Xfanout185 CB_0.config_dataB\[10\] vssd1 vssd1 vccd1 vccd1 net185 sky130_fd_sc_hd__buf_2
Xfanout152 CB_0.le_outA vssd1 vssd1 vccd1 vccd1 net152 sky130_fd_sc_hd__clkbuf_2
Xfanout163 _0389_ vssd1 vssd1 vccd1 vccd1 net163 sky130_fd_sc_hd__clkbuf_2
Xfanout174 CB_1.config_dataA\[5\] vssd1 vssd1 vccd1 vccd1 net174 sky130_fd_sc_hd__clkbuf_2
XTAP_TAPCELL_ROW_6_187 vssd1 vccd1 sky130_fd_sc_hd__tapvpwrvgnd_1
Xfanout141 CB_1.le_outB vssd1 vssd1 vccd1 vccd1 net141 sky130_fd_sc_hd__buf_2
XFILLER_10_150 vssd1 vssd1 vccd1 vccd1 sky130_fd_sc_hd__fill_4
X_2250_ _0733_ _0873_ _0874_ _0715_ _1576_ vssd1 vssd1 vccd1 vccd1 _0882_ sky130_fd_sc_hd__o221a_1
X_2181_ LE_0A.config_data\[13\] _0741_ _0779_ _0814_ vssd1 vssd1 vccd1 vccd1 _0815_
+ sky130_fd_sc_hd__a211o_1
XFILLER_33_242 vssd1 vssd1 vccd1 vccd1 sky130_fd_sc_hd__fill_4
X_1965_ _0592_ _0598_ vssd1 vssd1 vccd1 vccd1 _0599_ sky130_fd_sc_hd__nor2_1
X_3635_ clknet_leaf_17_clk _0331_ net259 vssd1 vssd1 vccd1 vccd1 CB_1.config_dataA\[12\]
+ sky130_fd_sc_hd__dfstp_2
X_3566_ clknet_leaf_12_clk _0262_ net254 vssd1 vssd1 vccd1 vccd1 SB0.route_sel\[121\]
+ sky130_fd_sc_hd__dfstp_1
X_2517_ LEI0.config_data\[18\] net139 vssd1 vssd1 vccd1 vccd1 _1147_ sky130_fd_sc_hd__nand2_1
X_1896_ SB0.route_sel\[76\] _1543_ SB0.route_sel\[79\] _1544_ _0529_ vssd1 vssd1 vccd1
+ vccd1 _0530_ sky130_fd_sc_hd__a221o_2
X_3497_ clknet_leaf_32_clk _0193_ net222 vssd1 vssd1 vccd1 vccd1 SB0.route_sel\[52\]
+ sky130_fd_sc_hd__dfstp_1
X_2379_ LEI0.config_data\[39\] net143 _1010_ LEI0.config_data\[40\] vssd1 vssd1 vccd1
+ vccd1 _1011_ sky130_fd_sc_hd__o211a_1
XTAP_TAPCELL_ROW_3_168 vssd1 vccd1 sky130_fd_sc_hd__tapvpwrvgnd_1
X_2448_ SB0.route_sel\[36\] SB0.route_sel\[37\] SB0.route_sel\[39\] _1519_ _1077_
+ vssd1 vssd1 vccd1 vccd1 _1078_ sky130_fd_sc_hd__o221a_1
XTAP_TAPCELL_ROW_54_524 vssd1 vccd1 sky130_fd_sc_hd__tapvpwrvgnd_1
XFILLER_24_253 vccd1 vssd1 vccd1 vssd1 sky130_ef_sc_hd__decap_40_12
Xhold8 _0354_ vssd1 vssd1 vccd1 vccd1 net318 sky130_fd_sc_hd__dlygate4sd3_1
X_1750_ SB0.route_sel\[116\] _1566_ SB0.route_sel\[119\] _1567_ _0383_ vssd1 vssd1
+ vccd1 vccd1 _0384_ sky130_fd_sc_hd__a221o_2
XFILLER_30_289 vssd1 vssd1 vccd1 vccd1 sky130_fd_sc_hd__fill_2
X_3351_ clknet_leaf_14_clk _0047_ net255 vssd1 vssd1 vccd1 vccd1 LEI0.config_data\[46\]
+ sky130_fd_sc_hd__dfrtp_1
X_1681_ SB0.route_sel\[110\] vssd1 vssd1 vccd1 vccd1 _1563_ sky130_fd_sc_hd__inv_2
XPHY_EDGE_ROW_29_Left_97 vssd1 vssd1 vccd1 vccd1 sky130_fd_sc_hd__decap_3
X_3420_ clknet_leaf_28_clk _0116_ net238 vssd1 vssd1 vccd1 vccd1 CB_1.config_dataB\[0\]
+ sky130_fd_sc_hd__dfstp_1
X_2233_ _0857_ _0862_ _0866_ _0858_ _0816_ vssd1 vssd1 vccd1 vccd1 _0867_ sky130_fd_sc_hd__o32a_2
X_2164_ net194 _0603_ _0797_ net193 vssd1 vssd1 vccd1 vccd1 _0798_ sky130_fd_sc_hd__o211a_1
X_2302_ _0914_ _0920_ _0932_ _0933_ CB_0.config_dataB\[9\] vssd1 vssd1 vccd1 vccd1
+ _0934_ sky130_fd_sc_hd__a221o_1
X_3282_ CB_1.config_dataA\[23\] CB_1.config_dataA\[22\] net277 vssd1 vssd1 vccd1 vccd1
+ _0342_ sky130_fd_sc_hd__mux2_1
XTAP_TAPCELL_ROW_51_505 vssd1 vccd1 sky130_fd_sc_hd__tapvpwrvgnd_1
X_2095_ _0726_ _0727_ _0728_ vssd1 vssd1 vccd1 vccd1 _0729_ sky130_fd_sc_hd__a21o_1
XTAP_TAPCELL_ROW_0_149 vssd1 vccd1 sky130_fd_sc_hd__tapvpwrvgnd_1
XTAP_TAPCELL_ROW_0_138 vssd1 vccd1 sky130_fd_sc_hd__tapvpwrvgnd_1
X_2997_ net334 LE_0A.config_data\[5\] net293 vssd1 vssd1 vccd1 vccd1 _0057_ sky130_fd_sc_hd__mux2_1
X_1948_ net201 _0581_ vssd1 vssd1 vccd1 vccd1 _0582_ sky130_fd_sc_hd__nand2_1
X_1879_ net200 _0511_ _0512_ vssd1 vssd1 vccd1 vccd1 _0513_ sky130_fd_sc_hd__o21ai_1
XFILLER_21_245 vssd1 vssd1 vccd1 vccd1 sky130_fd_sc_hd__fill_2
X_3618_ clknet_leaf_12_clk _0314_ net250 vssd1 vssd1 vccd1 vccd1 CB_0.config_dataB\[20\]
+ sky130_fd_sc_hd__dfstp_1
X_3549_ clknet_leaf_3_clk _0245_ net226 vssd1 vssd1 vccd1 vccd1 SB0.route_sel\[104\]
+ sky130_fd_sc_hd__dfstp_1
XFILLER_0_105 vssd1 vssd1 vccd1 vccd1 sky130_fd_sc_hd__fill_2
XTAP_TAPCELL_ROW_8_205 vssd1 vccd1 sky130_fd_sc_hd__tapvpwrvgnd_1
XFILLER_29_301 vssd1 vssd1 vccd1 vccd1 sky130_fd_sc_hd__fill_2
XFILLER_44_33 vssd1 vssd1 vccd1 vccd1 sky130_fd_sc_hd__fill_1
Xclkbuf_2_3__f_clk clknet_0_clk vssd1 vssd1 vccd1 vccd1 clknet_2_3__leaf_clk sky130_fd_sc_hd__clkbuf_16
X_2920_ SB0.route_sel\[7\] SB0.route_sel\[6\] SB0.route_sel\[1\] _1501_ _1480_ vssd1
+ vssd1 vccd1 vccd1 _1481_ sky130_fd_sc_hd__o221a_1
X_1802_ net200 CB_0.config_dataA\[1\] vssd1 vssd1 vccd1 vccd1 _0436_ sky130_fd_sc_hd__nor2_1
X_2782_ net151 _1397_ _0452_ vssd1 vssd1 vccd1 vccd1 net91 sky130_fd_sc_hd__mux2_1
X_1733_ SB0.route_sel\[116\] SB0.route_sel\[117\] net38 vssd1 vssd1 vccd1 vccd1 _0367_
+ sky130_fd_sc_hd__a21boi_1
X_2851_ SB0.route_sel\[91\] _1550_ SB0.route_sel\[89\] SB0.route_sel\[88\] _1434_
+ vssd1 vssd1 vccd1 vccd1 _1435_ sky130_fd_sc_hd__o221a_1
XTAP_TAPCELL_ROW_13_240 vssd1 vccd1 sky130_fd_sc_hd__tapvpwrvgnd_1
X_3334_ clknet_leaf_13_clk _0030_ net253 vssd1 vssd1 vccd1 vccd1 LEI0.config_data\[29\]
+ sky130_fd_sc_hd__dfrtp_1
X_1664_ SB0.route_sel\[72\] vssd1 vssd1 vccd1 vccd1 _1546_ sky130_fd_sc_hd__inv_2
X_3403_ clknet_leaf_25_clk net365 net244 vssd1 vssd1 vccd1 vccd1 LE_1A.config_data\[4\]
+ sky130_fd_sc_hd__dfrtp_1
X_2216_ _0840_ _0845_ _0849_ _0836_ _1574_ vssd1 vssd1 vccd1 vccd1 _0850_ sky130_fd_sc_hd__o311a_1
X_2147_ net195 _0409_ vssd1 vssd1 vccd1 vccd1 _0781_ sky130_fd_sc_hd__nand2_1
X_3265_ CB_1.config_dataA\[6\] net175 net299 vssd1 vssd1 vccd1 vccd1 _0325_ sky130_fd_sc_hd__mux2_1
X_3196_ SB0.route_sel\[115\] SB0.route_sel\[114\] net297 vssd1 vssd1 vccd1 vccd1 _0256_
+ sky130_fd_sc_hd__mux2_1
XFILLER_53_178 vssd1 vssd1 vccd1 vccd1 sky130_fd_sc_hd__fill_2
XTAP_TAPCELL_ROW_36_398 vssd1 vccd1 sky130_fd_sc_hd__tapvpwrvgnd_1
XFILLER_34_381 vssd1 vssd1 vccd1 vccd1 sky130_fd_sc_hd__fill_1
X_2078_ _1507_ _0701_ _0705_ _0711_ _1502_ vssd1 vssd1 vccd1 vccd1 _0712_ sky130_fd_sc_hd__o311a_2
XFILLER_30_46 vssd1 vssd1 vccd1 vccd1 sky130_fd_sc_hd__fill_2
XFILLER_55_65 vssd1 vssd1 vccd1 vccd1 sky130_fd_sc_hd__fill_1
XTAP_TAPCELL_ROW_27_332 vssd1 vccd1 sky130_fd_sc_hd__tapvpwrvgnd_1
X_2001_ _0450_ _0567_ vssd1 vssd1 vccd1 vccd1 _0635_ sky130_fd_sc_hd__nand2_1
X_3050_ net404 net401 net280 vssd1 vssd1 vccd1 vccd1 _0110_ sky130_fd_sc_hd__mux2_1
XFILLER_50_137 vssd1 vssd1 vccd1 vccd1 sky130_fd_sc_hd__fill_2
X_2903_ _1469_ _0672_ vssd1 vssd1 vccd1 vccd1 net112 sky130_fd_sc_hd__and2b_1
XTAP_TAPCELL_ROW_33_379 vssd1 vccd1 sky130_fd_sc_hd__tapvpwrvgnd_1
X_2696_ CB_1.config_dataB\[13\] _1315_ _1319_ _1323_ vssd1 vssd1 vccd1 vccd1 _1324_
+ sky130_fd_sc_hd__and4_1
X_1716_ CB_1.config_dataB\[12\] vssd1 vssd1 vccd1 vccd1 _1598_ sky130_fd_sc_hd__inv_2
X_2765_ _1374_ _1388_ _1392_ _1379_ _1384_ vssd1 vssd1 vccd1 vccd1 _1393_ sky130_fd_sc_hd__o32a_1
X_2834_ net141 _1080_ _0612_ vssd1 vssd1 vccd1 vccd1 _1425_ sky130_fd_sc_hd__mux2_1
X_3317_ clknet_leaf_14_clk _0013_ net256 vssd1 vssd1 vccd1 vccd1 LEI0.config_data\[12\]
+ sky130_fd_sc_hd__dfrtp_1
X_1647_ SB0.route_sel\[49\] vssd1 vssd1 vccd1 vccd1 _1529_ sky130_fd_sc_hd__inv_2
X_3248_ CB_0.config_dataB\[14\] CB_0.config_dataB\[13\] net294 vssd1 vssd1 vccd1 vccd1
+ _0308_ sky130_fd_sc_hd__mux2_1
XTAP_TAPCELL_ROW_49_490 vssd1 vccd1 sky130_fd_sc_hd__tapvpwrvgnd_1
X_3179_ SB0.route_sel\[98\] SB0.route_sel\[97\] net274 vssd1 vssd1 vccd1 vccd1 _0239_
+ sky130_fd_sc_hd__mux2_1
XFILLER_26_189 vssd1 vssd1 vccd1 vccd1 sky130_fd_sc_hd__fill_1
XFILLER_14_307 vssd1 vssd1 vccd1 vccd1 sky130_fd_sc_hd__fill_1
XFILLER_14_329 vssd1 vssd1 vccd1 vccd1 sky130_fd_sc_hd__fill_1
XPHY_EDGE_ROW_16_Left_84 vssd1 vssd1 vccd1 vccd1 sky130_fd_sc_hd__decap_3
XFILLER_41_159 vssd1 vssd1 vccd1 vccd1 sky130_fd_sc_hd__fill_2
XFILLER_41_115 vssd1 vssd1 vccd1 vccd1 sky130_fd_sc_hd__fill_1
XFILLER_25_57 vssd1 vssd1 vccd1 vccd1 sky130_fd_sc_hd__fill_4
XTAP_TAPCELL_ROW_24_313 vssd1 vccd1 sky130_fd_sc_hd__tapvpwrvgnd_1
XFILLER_22_351 vssd1 vssd1 vccd1 vccd1 sky130_fd_sc_hd__fill_1
XFILLER_22_373 vssd1 vssd1 vccd1 vccd1 sky130_fd_sc_hd__fill_1
XFILLER_57_281 vssd1 vssd1 vccd1 vccd1 sky130_fd_sc_hd__fill_2
X_2550_ CB_1.config_dataA\[13\] _1156_ CB_1.config_dataA\[12\] CB_1.config_dataA\[14\]
+ vssd1 vssd1 vccd1 vccd1 _1180_ sky130_fd_sc_hd__or4b_1
Xoutput107 net107 vssd1 vssd1 vccd1 vccd1 SBsouth_out[13] sky130_fd_sc_hd__buf_2
X_2481_ LEI0.config_data\[6\] net143 _1110_ LEI0.config_data\[7\] vssd1 vssd1 vccd1
+ vccd1 _1111_ sky130_fd_sc_hd__o211a_1
Xoutput129 net129 vssd1 vssd1 vccd1 vccd1 SBwest_out[4] sky130_fd_sc_hd__buf_2
Xoutput118 net118 vssd1 vssd1 vccd1 vccd1 SBsouth_out[9] sky130_fd_sc_hd__buf_2
X_3102_ SB0.route_sel\[21\] SB0.route_sel\[20\] net262 vssd1 vssd1 vccd1 vccd1 _0162_
+ sky130_fd_sc_hd__mux2_1
X_3033_ LE_1A.dff0_out _1236_ net68 vssd1 vssd1 vccd1 vccd1 _0093_ sky130_fd_sc_hd__mux2_1
XTAP_TAPCELL_ROW_46_471 vssd1 vccd1 sky130_fd_sc_hd__tapvpwrvgnd_1
XFILLER_23_159 vssd1 vssd1 vccd1 vccd1 sky130_fd_sc_hd__fill_8
X_2817_ net165 net161 _1038_ vssd1 vssd1 vccd1 vccd1 _1416_ sky130_fd_sc_hd__o21a_1
X_2748_ LE_1B.config_data\[6\] LE_1B.config_data\[7\] _1274_ vssd1 vssd1 vccd1 vccd1
+ _1376_ sky130_fd_sc_hd__mux2_1
X_2679_ _1301_ _1302_ _1305_ vssd1 vssd1 vccd1 vccd1 _1307_ sky130_fd_sc_hd__a21o_1
Xfanout301 net302 vssd1 vssd1 vccd1 vccd1 net301 sky130_fd_sc_hd__clkbuf_4
XPHY_EDGE_ROW_1_Left_69 vssd1 vssd1 vccd1 vccd1 sky130_fd_sc_hd__decap_3
XFILLER_33_402 vssd1 vssd1 vccd1 vccd1 sky130_fd_sc_hd__fill_1
XFILLER_9_141 vssd1 vssd1 vccd1 vccd1 sky130_fd_sc_hd__fill_1
X_1981_ SB0.route_sel\[35\] SB0.route_sel\[34\] vssd1 vssd1 vccd1 vccd1 _0615_ sky130_fd_sc_hd__nand2_1
X_3582_ clknet_leaf_8_clk _0278_ net234 vssd1 vssd1 vccd1 vccd1 CB_0.config_dataA\[9\]
+ sky130_fd_sc_hd__dfstp_1
X_2533_ net171 _1054_ vssd1 vssd1 vccd1 vccd1 _1163_ sky130_fd_sc_hd__nand2_1
XFILLER_9_196 vssd1 vssd1 vccd1 vccd1 sky130_fd_sc_hd__fill_2
X_3651_ clknet_leaf_26_clk _0347_ net237 vssd1 vssd1 vccd1 vccd1 LE_1B.config_data\[3\]
+ sky130_fd_sc_hd__dfrtp_1
X_2602_ _1068_ _1106_ _1112_ LE_1A.config_data\[2\] vssd1 vssd1 vccd1 vccd1 _1232_
+ sky130_fd_sc_hd__o211a_1
X_2395_ LE_0B.dff0_out LE_0B.dff1_out LE_0B.reset_val vssd1 vssd1 vccd1 vccd1 LE_0B.dff_out
+ sky130_fd_sc_hd__mux2_1
X_2464_ SB0.route_sel\[20\] SB0.route_sel\[21\] SB0.route_sel\[23\] _1510_ vssd1 vssd1
+ vccd1 vccd1 _1094_ sky130_fd_sc_hd__o22a_1
X_3016_ net353 net392 net288 vssd1 vssd1 vccd1 vccd1 _0076_ sky130_fd_sc_hd__mux2_1
XFILLER_36_251 vssd1 vssd1 vccd1 vccd1 sky130_fd_sc_hd__fill_1
Xclkbuf_leaf_31_clk clknet_2_0__leaf_clk vssd1 vssd1 vccd1 vccd1 clknet_leaf_31_clk
+ sky130_fd_sc_hd__clkbuf_8
XTAP_TAPCELL_ROW_57_544 vssd1 vccd1 sky130_fd_sc_hd__tapvpwrvgnd_1
Xfanout197 net198 vssd1 vssd1 vccd1 vccd1 net197 sky130_fd_sc_hd__clkbuf_2
Xfanout153 net154 vssd1 vssd1 vccd1 vccd1 net153 sky130_fd_sc_hd__clkbuf_2
Xfanout175 CB_1.config_dataA\[5\] vssd1 vssd1 vccd1 vccd1 net175 sky130_fd_sc_hd__clkbuf_2
Xfanout164 _0375_ vssd1 vssd1 vccd1 vccd1 net164 sky130_fd_sc_hd__clkbuf_2
XFILLER_47_66 vssd1 vssd1 vccd1 vccd1 sky130_fd_sc_hd__fill_4
Xfanout186 CB_0.config_dataB\[5\] vssd1 vssd1 vccd1 vccd1 net186 sky130_fd_sc_hd__buf_2
Xfanout142 net143 vssd1 vssd1 vccd1 vccd1 net142 sky130_fd_sc_hd__buf_2
XFILLER_27_251 vssd1 vssd1 vccd1 vccd1 sky130_fd_sc_hd__fill_1
XTAP_TAPCELL_ROW_6_188 vssd1 vccd1 sky130_fd_sc_hd__tapvpwrvgnd_1
XFILLER_15_402 vssd1 vssd1 vccd1 vccd1 sky130_fd_sc_hd__fill_1
Xclkbuf_leaf_22_clk clknet_2_2__leaf_clk vssd1 vssd1 vccd1 vccd1 clknet_leaf_22_clk
+ sky130_fd_sc_hd__clkbuf_8
X_2180_ LE_0A.config_data\[12\] _0736_ _0740_ vssd1 vssd1 vccd1 vccd1 _0814_ sky130_fd_sc_hd__and3_1
XFILLER_18_240 vssd1 vssd1 vccd1 vccd1 sky130_fd_sc_hd__fill_2
XFILLER_18_295 vssd1 vssd1 vccd1 vccd1 sky130_fd_sc_hd__fill_1
Xclkbuf_leaf_13_clk clknet_2_3__leaf_clk vssd1 vssd1 vccd1 vccd1 clknet_leaf_13_clk
+ sky130_fd_sc_hd__clkbuf_8
X_3634_ clknet_leaf_16_clk _0330_ net258 vssd1 vssd1 vccd1 vccd1 CB_1.config_dataA\[11\]
+ sky130_fd_sc_hd__dfstp_1
X_1964_ _0583_ _0596_ _0597_ net291 vssd1 vssd1 vccd1 vccd1 _0598_ sky130_fd_sc_hd__a31o_1
X_1895_ SB0.route_sel\[75\] SB0.route_sel\[74\] vssd1 vssd1 vccd1 vccd1 _0529_ sky130_fd_sc_hd__nor2_1
X_3565_ clknet_leaf_12_clk _0261_ net254 vssd1 vssd1 vccd1 vccd1 SB0.route_sel\[120\]
+ sky130_fd_sc_hd__dfstp_1
X_2516_ LEI0.config_data\[19\] _1145_ vssd1 vssd1 vccd1 vccd1 _1146_ sky130_fd_sc_hd__nor2_1
X_3496_ clknet_leaf_27_clk _0192_ net236 vssd1 vssd1 vccd1 vccd1 SB0.route_sel\[51\]
+ sky130_fd_sc_hd__dfstp_1
XFILLER_0_309 vssd1 vssd1 vccd1 vccd1 sky130_fd_sc_hd__fill_1
X_2447_ SB0.route_sel\[33\] _1520_ vssd1 vssd1 vccd1 vccd1 _1077_ sky130_fd_sc_hd__nand2_1
X_2378_ LEI0.config_data\[39\] net140 vssd1 vssd1 vccd1 vccd1 _1010_ sky130_fd_sc_hd__nand2_1
XTAP_TAPCELL_ROW_3_169 vssd1 vccd1 sky130_fd_sc_hd__tapvpwrvgnd_1
XTAP_TAPCELL_ROW_62_580 vssd1 vccd1 sky130_fd_sc_hd__tapvpwrvgnd_1
XTAP_TAPCELL_ROW_54_525 vssd1 vccd1 sky130_fd_sc_hd__tapvpwrvgnd_1
XFILLER_24_276 vssd1 vssd1 vccd1 vccd1 sky130_fd_sc_hd__fill_2
XFILLER_24_265 vssd1 vssd1 vccd1 vccd1 sky130_fd_sc_hd__fill_2
XFILLER_24_210 vssd1 vssd1 vccd1 vccd1 sky130_fd_sc_hd__fill_2
XFILLER_58_54 vssd1 vssd1 vccd1 vccd1 sky130_fd_sc_hd__fill_2
Xhold9 LE_0B.config_data\[14\] vssd1 vssd1 vccd1 vccd1 net319 sky130_fd_sc_hd__dlygate4sd3_1
XFILLER_15_232 vccd1 vssd1 vccd1 vssd1 sky130_ef_sc_hd__decap_40_12
XFILLER_30_246 vssd1 vssd1 vccd1 vccd1 sky130_fd_sc_hd__fill_1
XFILLER_30_224 vssd1 vssd1 vccd1 vccd1 sky130_fd_sc_hd__fill_2
XPHY_EDGE_ROW_4_Left_72 vssd1 vssd1 vccd1 vccd1 sky130_fd_sc_hd__decap_3
X_3350_ clknet_leaf_16_clk _0046_ net258 vssd1 vssd1 vccd1 vccd1 LEI0.config_data\[45\]
+ sky130_fd_sc_hd__dfrtp_1
X_2301_ CB_0.config_dataB\[7\] _0929_ _0930_ _0926_ CB_0.config_dataB\[8\] vssd1 vssd1
+ vccd1 vccd1 _0933_ sky130_fd_sc_hd__o221a_1
X_1680_ SB0.route_sel\[109\] vssd1 vssd1 vccd1 vccd1 _1562_ sky130_fd_sc_hd__inv_2
XFILLER_65_121 vssd1 vssd1 vccd1 vccd1 sky130_fd_sc_hd__fill_1
X_2232_ _0778_ _0863_ _0865_ _0812_ vssd1 vssd1 vccd1 vccd1 _0866_ sky130_fd_sc_hd__o211a_1
X_2163_ net194 _0581_ vssd1 vssd1 vccd1 vccd1 _0797_ sky130_fd_sc_hd__nand2_1
XFILLER_38_368 vssd1 vssd1 vccd1 vccd1 sky130_fd_sc_hd__fill_4
XFILLER_38_335 vssd1 vssd1 vccd1 vccd1 sky130_fd_sc_hd__fill_2
Xclkbuf_leaf_2_clk clknet_2_0__leaf_clk vssd1 vssd1 vccd1 vccd1 clknet_leaf_2_clk
+ sky130_fd_sc_hd__clkbuf_8
X_3281_ CB_1.config_dataA\[22\] CB_1.config_dataA\[21\] net276 vssd1 vssd1 vccd1 vccd1
+ _0341_ sky130_fd_sc_hd__mux2_1
XTAP_TAPCELL_ROW_51_506 vssd1 vccd1 sky130_fd_sc_hd__tapvpwrvgnd_1
XFILLER_0_83 vssd1 vssd1 vccd1 vccd1 sky130_fd_sc_hd__fill_1
XTAP_TAPCELL_ROW_0_139 vssd1 vccd1 sky130_fd_sc_hd__tapvpwrvgnd_1
XTAP_TAPCELL_ROW_16_260 vssd1 vccd1 sky130_fd_sc_hd__tapvpwrvgnd_1
X_2094_ net155 _0422_ _0662_ SB0.route_sel\[0\] SB0.route_sel\[1\] vssd1 vssd1 vccd1
+ vccd1 _0728_ sky130_fd_sc_hd__a32o_1
X_2996_ net356 net341 net293 vssd1 vssd1 vccd1 vccd1 _0056_ sky130_fd_sc_hd__mux2_1
X_3617_ clknet_leaf_6_clk _0313_ net230 vssd1 vssd1 vccd1 vccd1 CB_0.config_dataB\[19\]
+ sky130_fd_sc_hd__dfstp_1
X_1947_ _0566_ _0577_ _0580_ vssd1 vssd1 vccd1 vccd1 _0581_ sky130_fd_sc_hd__and3_2
X_1878_ _1496_ _0489_ _0491_ net199 vssd1 vssd1 vccd1 vccd1 _0512_ sky130_fd_sc_hd__o31a_1
XFILLER_21_279 vssd1 vssd1 vccd1 vccd1 sky130_fd_sc_hd__fill_1
X_3548_ clknet_leaf_3_clk _0244_ net226 vssd1 vssd1 vccd1 vccd1 SB0.route_sel\[103\]
+ sky130_fd_sc_hd__dfstp_1
XFILLER_0_139 vssd1 vssd1 vccd1 vccd1 sky130_fd_sc_hd__fill_1
X_3479_ clknet_leaf_0_clk _0175_ net218 vssd1 vssd1 vccd1 vccd1 SB0.route_sel\[34\]
+ sky130_fd_sc_hd__dfstp_1
XFILLER_29_335 vssd1 vssd1 vccd1 vccd1 sky130_fd_sc_hd__fill_1
XPHY_EDGE_ROW_30_Left_98 vssd1 vssd1 vccd1 vccd1 sky130_fd_sc_hd__decap_3
XFILLER_35_305 vssd1 vssd1 vccd1 vccd1 sky130_fd_sc_hd__fill_2
X_2850_ _1551_ SB0.route_sel\[93\] vssd1 vssd1 vccd1 vccd1 _1434_ sky130_fd_sc_hd__nand2_1
X_2781_ _0461_ net147 _0454_ vssd1 vssd1 vccd1 vccd1 _1397_ sky130_fd_sc_hd__mux2_1
X_1732_ SB0.route_sel\[119\] SB0.route_sel\[118\] vssd1 vssd1 vccd1 vccd1 _0366_ sky130_fd_sc_hd__nand2_1
X_1801_ _0432_ _0434_ vssd1 vssd1 vccd1 vccd1 _0435_ sky130_fd_sc_hd__and2_2
X_1663_ SB0.route_sel\[73\] vssd1 vssd1 vccd1 vccd1 _1545_ sky130_fd_sc_hd__inv_2
X_3333_ clknet_leaf_13_clk _0029_ net251 vssd1 vssd1 vccd1 vccd1 LEI0.config_data\[28\]
+ sky130_fd_sc_hd__dfrtp_1
X_3264_ net175 CB_1.config_dataA\[4\] net299 vssd1 vssd1 vccd1 vccd1 _0324_ sky130_fd_sc_hd__mux2_1
XPHY_EDGE_ROW_7_Right_7 vssd1 vssd1 vccd1 vccd1 sky130_fd_sc_hd__decap_3
X_3402_ clknet_leaf_24_clk _0098_ net244 vssd1 vssd1 vccd1 vccd1 LE_1A.config_data\[3\]
+ sky130_fd_sc_hd__dfrtp_1
X_2215_ CB_0.config_dataA\[17\] _0847_ _0848_ vssd1 vssd1 vccd1 vccd1 _0849_ sky130_fd_sc_hd__and3b_1
X_2146_ LE_0A.config_data\[14\] LE_0A.config_data\[15\] _0741_ vssd1 vssd1 vccd1 vccd1
+ _0780_ sky130_fd_sc_hd__mux2_1
XFILLER_53_113 vssd1 vssd1 vccd1 vccd1 sky130_fd_sc_hd__fill_4
X_3195_ SB0.route_sel\[114\] SB0.route_sel\[113\] net297 vssd1 vssd1 vccd1 vccd1 _0255_
+ sky130_fd_sc_hd__mux2_1
X_2077_ _0708_ _0709_ _0710_ vssd1 vssd1 vccd1 vccd1 _0711_ sky130_fd_sc_hd__a21o_1
XFILLER_38_143 vssd1 vssd1 vccd1 vccd1 sky130_fd_sc_hd__fill_1
XFILLER_38_121 vssd1 vssd1 vccd1 vccd1 sky130_fd_sc_hd__fill_1
X_2979_ net420 LEI0.config_data\[37\] net307 vssd1 vssd1 vccd1 vccd1 _0039_ sky130_fd_sc_hd__mux2_1
XTAP_TAPCELL_ROW_36_399 vssd1 vccd1 sky130_fd_sc_hd__tapvpwrvgnd_1
XFILLER_39_89 vssd1 vssd1 vccd1 vccd1 sky130_fd_sc_hd__fill_2
XFILLER_39_78 vssd1 vssd1 vccd1 vccd1 sky130_fd_sc_hd__fill_1
XFILLER_29_110 vssd1 vssd1 vccd1 vccd1 sky130_fd_sc_hd__fill_2
XFILLER_44_179 vssd1 vssd1 vccd1 vccd1 sky130_fd_sc_hd__fill_8
XFILLER_44_113 vssd1 vssd1 vccd1 vccd1 sky130_fd_sc_hd__fill_2
XFILLER_29_198 vssd1 vssd1 vccd1 vccd1 sky130_fd_sc_hd__fill_2
XTAP_TAPCELL_ROW_27_333 vssd1 vccd1 sky130_fd_sc_hd__tapvpwrvgnd_1
XFILLER_52_190 vssd1 vssd1 vccd1 vccd1 sky130_fd_sc_hd__fill_2
XFILLER_40_341 vssd1 vssd1 vccd1 vccd1 sky130_fd_sc_hd__fill_1
XFILLER_35_124 vssd1 vssd1 vccd1 vccd1 sky130_fd_sc_hd__fill_1
XFILLER_35_113 vssd1 vssd1 vccd1 vccd1 sky130_fd_sc_hd__fill_2
X_2000_ SB0.route_sel\[43\] SB0.route_sel\[42\] _0633_ _1524_ vssd1 vssd1 vccd1 vccd1
+ _0634_ sky130_fd_sc_hd__a31o_1
XFILLER_31_385 vssd1 vssd1 vccd1 vccd1 sky130_fd_sc_hd__fill_1
X_2902_ SB0.route_sel\[31\] SB0.route_sel\[30\] SB0.route_sel\[25\] _1517_ _1468_
+ vssd1 vssd1 vccd1 vccd1 _1469_ sky130_fd_sc_hd__o221a_1
X_2833_ _0628_ _1424_ _0629_ vssd1 vssd1 vccd1 vccd1 net82 sky130_fd_sc_hd__a21oi_1
X_1715_ CB_1.config_dataB\[9\] vssd1 vssd1 vccd1 vccd1 _1597_ sky130_fd_sc_hd__inv_2
X_2695_ CB_1.config_dataB\[11\] _1320_ _1321_ _1322_ vssd1 vssd1 vccd1 vccd1 _1323_
+ sky130_fd_sc_hd__a31o_1
X_1646_ SB0.route_sel\[54\] vssd1 vssd1 vccd1 vccd1 _1528_ sky130_fd_sc_hd__inv_2
X_2764_ _1306_ _1389_ _1390_ _1391_ _1341_ vssd1 vssd1 vccd1 vccd1 _1392_ sky130_fd_sc_hd__o221a_1
X_3316_ clknet_leaf_14_clk net396 net256 vssd1 vssd1 vccd1 vccd1 LEI0.config_data\[11\]
+ sky130_fd_sc_hd__dfrtp_1
X_3247_ CB_0.config_dataB\[13\] CB_0.config_dataB\[12\] net294 vssd1 vssd1 vccd1 vccd1
+ _0307_ sky130_fd_sc_hd__mux2_1
X_2129_ net17 net24 net25 net26 net198 net196 vssd1 vssd1 vccd1 vccd1 _0763_ sky130_fd_sc_hd__mux4_1
XTAP_TAPCELL_ROW_49_491 vssd1 vccd1 sky130_fd_sc_hd__tapvpwrvgnd_1
XFILLER_41_105 vssd1 vssd1 vccd1 vccd1 sky130_fd_sc_hd__fill_4
X_3178_ SB0.route_sel\[97\] SB0.route_sel\[96\] net289 vssd1 vssd1 vccd1 vccd1 _0238_
+ sky130_fd_sc_hd__mux2_1
XFILLER_26_135 vssd1 vssd1 vccd1 vccd1 sky130_fd_sc_hd__fill_4
XFILLER_25_14 vssd1 vssd1 vccd1 vccd1 sky130_fd_sc_hd__fill_2
XTAP_TAPCELL_ROW_24_314 vssd1 vccd1 sky130_fd_sc_hd__tapvpwrvgnd_1
XFILLER_41_57 vccd1 vssd1 vccd1 vssd1 sky130_ef_sc_hd__decap_40_12
XFILLER_2_29 vssd1 vssd1 vccd1 vccd1 sky130_fd_sc_hd__fill_4
XFILLER_17_135 vssd1 vssd1 vccd1 vccd1 sky130_fd_sc_hd__fill_4
XFILLER_9_334 vssd1 vssd1 vccd1 vccd1 sky130_fd_sc_hd__fill_2
X_2480_ LEI0.config_data\[6\] net139 vssd1 vssd1 vccd1 vccd1 _1110_ sky130_fd_sc_hd__nand2_1
Xoutput119 net119 vssd1 vssd1 vccd1 vccd1 SBwest_out[0] sky130_fd_sc_hd__buf_2
Xoutput108 net108 vssd1 vssd1 vccd1 vccd1 SBsouth_out[14] sky130_fd_sc_hd__buf_2
Xoutput90 net90 vssd1 vssd1 vccd1 vccd1 CBnorth_out[12] sky130_fd_sc_hd__buf_2
X_3101_ SB0.route_sel\[20\] SB0.route_sel\[19\] net262 vssd1 vssd1 vccd1 vccd1 _0161_
+ sky130_fd_sc_hd__mux2_1
XFILLER_63_296 vssd1 vssd1 vccd1 vccd1 sky130_fd_sc_hd__fill_1
X_3032_ LE_0B.reset_mode LE_0B.reset_val net276 vssd1 vssd1 vccd1 vccd1 _0092_ sky130_fd_sc_hd__mux2_1
X_2816_ _0442_ _1415_ _0443_ vssd1 vssd1 vccd1 vccd1 net75 sky130_fd_sc_hd__o21a_1
XFILLER_31_160 vssd1 vssd1 vccd1 vccd1 sky130_fd_sc_hd__fill_4
Xfanout302 net303 vssd1 vssd1 vccd1 vccd1 net302 sky130_fd_sc_hd__clkbuf_4
X_2747_ CB_1.config_dataB\[19\] _1357_ _1369_ _1373_ vssd1 vssd1 vccd1 vccd1 _1375_
+ sky130_fd_sc_hd__o31ai_1
X_1629_ SB0.route_sel\[16\] vssd1 vssd1 vccd1 vccd1 _1511_ sky130_fd_sc_hd__inv_2
X_2678_ _1301_ _1302_ _1305_ vssd1 vssd1 vccd1 vccd1 _1306_ sky130_fd_sc_hd__a21oi_2
X_3650_ clknet_leaf_26_clk net350 net237 vssd1 vssd1 vccd1 vccd1 LE_1B.config_data\[2\]
+ sky130_fd_sc_hd__dfrtp_1
XFILLER_9_131 vssd1 vssd1 vccd1 vccd1 sky130_fd_sc_hd__fill_8
X_1980_ _0411_ net157 net11 vssd1 vssd1 vccd1 vccd1 _0614_ sky130_fd_sc_hd__o21ba_1
X_3581_ clknet_leaf_8_clk _0277_ net234 vssd1 vssd1 vccd1 vccd1 CB_0.config_dataA\[8\]
+ sky130_fd_sc_hd__dfstp_1
X_2532_ _1160_ _1161_ CB_1.config_dataA\[12\] vssd1 vssd1 vccd1 vccd1 _1162_ sky130_fd_sc_hd__mux2_1
X_2463_ net177 _1092_ vssd1 vssd1 vccd1 vccd1 _1093_ sky130_fd_sc_hd__nand2_1
X_2601_ _1150_ _1228_ _1229_ _1230_ _1187_ vssd1 vssd1 vccd1 vccd1 _1231_ sky130_fd_sc_hd__o221a_1
X_2394_ _1015_ _1021_ _1025_ _1017_ _0977_ vssd1 vssd1 vccd1 vccd1 _1026_ sky130_fd_sc_hd__o32a_2
X_3015_ LE_0B.config_data\[2\] net390 net288 vssd1 vssd1 vccd1 vccd1 _0075_ sky130_fd_sc_hd__mux2_1
Xfanout143 _1603_ vssd1 vssd1 vccd1 vccd1 net143 sky130_fd_sc_hd__clkbuf_4
Xfanout154 CB_0.le_outA vssd1 vssd1 vccd1 vccd1 net154 sky130_fd_sc_hd__buf_1
Xfanout165 _1607_ vssd1 vssd1 vccd1 vccd1 net165 sky130_fd_sc_hd__buf_2
XTAP_TAPCELL_ROW_57_545 vssd1 vccd1 sky130_fd_sc_hd__tapvpwrvgnd_1
Xfanout198 CB_0.config_dataA\[5\] vssd1 vssd1 vccd1 vccd1 net198 sky130_fd_sc_hd__buf_2
Xfanout176 CB_1.config_dataA\[1\] vssd1 vssd1 vccd1 vccd1 net176 sky130_fd_sc_hd__buf_2
Xfanout187 CB_0.config_dataB\[1\] vssd1 vssd1 vccd1 vccd1 net187 sky130_fd_sc_hd__buf_2
XTAP_TAPCELL_ROW_6_189 vssd1 vccd1 sky130_fd_sc_hd__tapvpwrvgnd_1
XTAP_TAPCELL_ROW_40_423 vssd1 vccd1 sky130_fd_sc_hd__tapvpwrvgnd_1
XFILLER_2_362 vssd1 vssd1 vccd1 vccd1 sky130_fd_sc_hd__fill_2
XFILLER_19_6 vssd1 vssd1 vccd1 vccd1 sky130_fd_sc_hd__fill_8
XFILLER_33_255 vssd1 vssd1 vccd1 vccd1 sky130_fd_sc_hd__fill_2
X_3633_ clknet_leaf_17_clk _0329_ net258 vssd1 vssd1 vccd1 vccd1 CB_1.config_dataA\[10\]
+ sky130_fd_sc_hd__dfstp_1
X_1963_ net155 _0593_ vssd1 vssd1 vccd1 vccd1 _0597_ sky130_fd_sc_hd__nand2_1
X_1894_ _1545_ _0517_ _0521_ _0527_ _1502_ vssd1 vssd1 vccd1 vccd1 _0528_ sky130_fd_sc_hd__o311a_4
X_2515_ net153 net149 LEI0.config_data\[18\] vssd1 vssd1 vccd1 vccd1 _1145_ sky130_fd_sc_hd__mux2_1
X_3564_ clknet_leaf_12_clk _0260_ net248 vssd1 vssd1 vccd1 vccd1 SB0.route_sel\[119\]
+ sky130_fd_sc_hd__dfstp_1
X_2446_ net177 _1075_ vssd1 vssd1 vccd1 vccd1 _1076_ sky130_fd_sc_hd__or2_1
X_3495_ clknet_leaf_32_clk _0191_ net223 vssd1 vssd1 vccd1 vccd1 SB0.route_sel\[50\]
+ sky130_fd_sc_hd__dfstp_1
XTAP_TAPCELL_ROW_54_526 vssd1 vccd1 sky130_fd_sc_hd__tapvpwrvgnd_1
X_2377_ CB_0.config_dataB\[18\] _1583_ CB_0.config_dataB\[19\] _0984_ vssd1 vssd1
+ vccd1 vccd1 _1009_ sky130_fd_sc_hd__and4b_1
XFILLER_24_200 vssd1 vssd1 vccd1 vccd1 sky130_fd_sc_hd__fill_1
XTAP_TAPCELL_ROW_62_581 vssd1 vccd1 sky130_fd_sc_hd__tapvpwrvgnd_1
XTAP_TAPCELL_ROW_19_280 vssd1 vccd1 sky130_fd_sc_hd__tapvpwrvgnd_1
XFILLER_59_196 vssd1 vssd1 vccd1 vccd1 sky130_fd_sc_hd__fill_1
XFILLER_59_185 vssd1 vssd1 vccd1 vccd1 sky130_fd_sc_hd__fill_1
XFILLER_58_66 vssd1 vssd1 vccd1 vccd1 sky130_fd_sc_hd__fill_1
XFILLER_62_306 vssd1 vssd1 vccd1 vccd1 sky130_fd_sc_hd__fill_2
XFILLER_15_244 vssd1 vssd1 vccd1 vccd1 sky130_fd_sc_hd__fill_2
XFILLER_15_255 vssd1 vssd1 vccd1 vccd1 sky130_fd_sc_hd__fill_8
X_2231_ LE_0A.config_data\[1\] _0741_ _0779_ _0864_ vssd1 vssd1 vccd1 vccd1 _0865_
+ sky130_fd_sc_hd__a211o_1
X_2300_ _0924_ _0931_ CB_0.config_dataB\[7\] vssd1 vssd1 vccd1 vccd1 _0932_ sky130_fd_sc_hd__o21ai_1
X_3280_ CB_1.config_dataA\[21\] CB_1.config_dataA\[20\] net276 vssd1 vssd1 vccd1 vccd1
+ _0340_ sky130_fd_sc_hd__mux2_1
X_2162_ _0788_ _0791_ _0795_ CB_0.config_dataA\[13\] vssd1 vssd1 vccd1 vccd1 _0796_
+ sky130_fd_sc_hd__and4bb_1
X_2093_ _0425_ _0665_ net17 vssd1 vssd1 vccd1 vccd1 _0727_ sky130_fd_sc_hd__a21o_1
XFILLER_38_347 vccd1 vssd1 vccd1 vssd1 sky130_ef_sc_hd__decap_40_12
X_2995_ net341 net325 net293 vssd1 vssd1 vccd1 vccd1 _0055_ sky130_fd_sc_hd__mux2_1
XTAP_TAPCELL_ROW_16_261 vssd1 vccd1 sky130_fd_sc_hd__tapvpwrvgnd_1
XFILLER_21_247 vssd1 vssd1 vccd1 vccd1 sky130_fd_sc_hd__fill_1
X_3616_ clknet_leaf_6_clk _0312_ net230 vssd1 vssd1 vccd1 vccd1 CB_0.config_dataB\[18\]
+ sky130_fd_sc_hd__dfstp_1
X_1877_ _0508_ _0510_ vssd1 vssd1 vccd1 vccd1 _0511_ sky130_fd_sc_hd__or2_4
X_3547_ clknet_leaf_3_clk _0243_ net225 vssd1 vssd1 vccd1 vccd1 SB0.route_sel\[102\]
+ sky130_fd_sc_hd__dfstp_1
X_1946_ SB0.route_sel\[60\] _1532_ SB0.route_sel\[63\] _1533_ _0579_ vssd1 vssd1 vccd1
+ vccd1 _0580_ sky130_fd_sc_hd__a221o_1
X_2429_ net177 _1058_ vssd1 vssd1 vccd1 vccd1 _1059_ sky130_fd_sc_hd__or2_1
XFILLER_0_107 vssd1 vssd1 vccd1 vccd1 sky130_fd_sc_hd__fill_1
X_3478_ clknet_leaf_35_clk _0174_ net217 vssd1 vssd1 vccd1 vccd1 SB0.route_sel\[33\]
+ sky130_fd_sc_hd__dfstp_1
XTAP_TAPCELL_ROW_22_297 vssd1 vccd1 sky130_fd_sc_hd__tapvpwrvgnd_1
XFILLER_4_402 vssd1 vssd1 vccd1 vccd1 sky130_fd_sc_hd__fill_1
XFILLER_50_309 vssd1 vssd1 vccd1 vccd1 sky130_fd_sc_hd__fill_2
X_1800_ SB0.route_sel\[100\] _1556_ SB0.route_sel\[103\] _1557_ _0433_ vssd1 vssd1
+ vccd1 vccd1 _0434_ sky130_fd_sc_hd__a221o_1
X_2780_ _1396_ net151 _0374_ vssd1 vssd1 vccd1 vccd1 net92 sky130_fd_sc_hd__mux2_1
X_1731_ _1611_ net142 _1609_ vssd1 vssd1 vccd1 vccd1 _0365_ sky130_fd_sc_hd__and3b_1
X_3401_ clknet_leaf_24_clk _0097_ net244 vssd1 vssd1 vccd1 vccd1 LE_1A.config_data\[2\]
+ sky130_fd_sc_hd__dfrtp_1
X_1662_ SB0.route_sel\[78\] vssd1 vssd1 vccd1 vccd1 _1544_ sky130_fd_sc_hd__inv_2
X_3332_ clknet_leaf_13_clk _0028_ net251 vssd1 vssd1 vccd1 vccd1 LEI0.config_data\[27\]
+ sky130_fd_sc_hd__dfrtp_1
X_2214_ _0733_ _0822_ _0824_ _0715_ vssd1 vssd1 vccd1 vccd1 _0848_ sky130_fd_sc_hd__o22a_1
X_3263_ CB_1.config_dataA\[4\] CB_1.config_dataA\[3\] net299 vssd1 vssd1 vccd1 vccd1
+ _0323_ sky130_fd_sc_hd__mux2_1
X_3194_ SB0.route_sel\[113\] SB0.route_sel\[112\] net297 vssd1 vssd1 vccd1 vccd1 _0254_
+ sky130_fd_sc_hd__mux2_1
X_2145_ CB_0.config_dataA\[9\] _0758_ _0771_ _0777_ vssd1 vssd1 vccd1 vccd1 _0779_
+ sky130_fd_sc_hd__o31ai_4
X_2076_ net155 _0450_ _0662_ SB0.route_sel\[8\] SB0.route_sel\[9\] vssd1 vssd1 vccd1
+ vccd1 _0710_ sky130_fd_sc_hd__a32o_1
X_2978_ net427 LEI0.config_data\[36\] net307 vssd1 vssd1 vccd1 vccd1 _0038_ sky130_fd_sc_hd__mux2_1
X_1929_ SB0.route_sel\[60\] SB0.route_sel\[61\] net46 vssd1 vssd1 vccd1 vccd1 _0563_
+ sky130_fd_sc_hd__a21boi_1
XFILLER_30_48 vssd1 vssd1 vccd1 vccd1 sky130_fd_sc_hd__fill_1
XFILLER_30_26 vssd1 vssd1 vccd1 vccd1 sky130_fd_sc_hd__fill_2
XFILLER_44_103 vssd1 vssd1 vccd1 vccd1 sky130_fd_sc_hd__fill_1
XFILLER_39_68 vssd1 vssd1 vccd1 vccd1 sky130_fd_sc_hd__fill_8
XFILLER_44_158 vssd1 vssd1 vccd1 vccd1 sky130_fd_sc_hd__fill_1
XTAP_TAPCELL_ROW_27_334 vssd1 vccd1 sky130_fd_sc_hd__tapvpwrvgnd_1
XPHY_EDGE_ROW_33_Left_101 vssd1 vssd1 vccd1 vccd1 sky130_fd_sc_hd__decap_3
XPHY_EDGE_ROW_42_Left_110 vssd1 vssd1 vccd1 vccd1 sky130_fd_sc_hd__decap_3
Xhold90 LE_0B.config_data\[11\] vssd1 vssd1 vccd1 vccd1 net400 sky130_fd_sc_hd__dlygate4sd3_1
XFILLER_50_139 vssd1 vssd1 vccd1 vccd1 sky130_fd_sc_hd__fill_1
XFILLER_31_375 vssd1 vssd1 vccd1 vccd1 sky130_fd_sc_hd__fill_1
X_2763_ _1600_ _1274_ _1306_ vssd1 vssd1 vccd1 vccd1 _1391_ sky130_fd_sc_hd__o21ai_1
X_2901_ SB0.route_sel\[27\] _1512_ vssd1 vssd1 vccd1 vccd1 _1468_ sky130_fd_sc_hd__nand2_1
X_2832_ net160 net157 _1083_ vssd1 vssd1 vccd1 vccd1 _1424_ sky130_fd_sc_hd__o21bai_1
X_1714_ CB_1.config_dataB\[7\] vssd1 vssd1 vccd1 vccd1 _1596_ sky130_fd_sc_hd__inv_2
X_2694_ _1043_ _1311_ _1313_ _1038_ CB_1.config_dataB\[12\] vssd1 vssd1 vccd1 vccd1
+ _1322_ sky130_fd_sc_hd__o221ai_1
X_1645_ SB0.route_sel\[55\] vssd1 vssd1 vccd1 vccd1 _1527_ sky130_fd_sc_hd__inv_2
X_3246_ CB_0.config_dataB\[12\] net183 net294 vssd1 vssd1 vccd1 vccd1 _0306_ sky130_fd_sc_hd__mux2_1
X_3315_ clknet_leaf_14_clk _0011_ net256 vssd1 vssd1 vccd1 vccd1 LEI0.config_data\[10\]
+ sky130_fd_sc_hd__dfrtp_1
X_3177_ SB0.route_sel\[96\] SB0.route_sel\[95\] net270 vssd1 vssd1 vccd1 vccd1 _0237_
+ sky130_fd_sc_hd__mux2_1
X_2128_ _0626_ _0744_ _0761_ vssd1 vssd1 vccd1 vccd1 _0762_ sky130_fd_sc_hd__a21oi_1
XTAP_TAPCELL_ROW_49_492 vssd1 vccd1 sky130_fd_sc_hd__tapvpwrvgnd_1
XTAP_TAPCELL_ROW_24_315 vssd1 vccd1 sky130_fd_sc_hd__tapvpwrvgnd_1
X_2059_ SB0.route_sel\[20\] _1509_ SB0.route_sel\[23\] _1510_ _0692_ vssd1 vssd1 vccd1
+ vccd1 _0693_ sky130_fd_sc_hd__a221o_1
XFILLER_41_69 vssd1 vssd1 vccd1 vccd1 sky130_fd_sc_hd__fill_8
XTAP_TAPCELL_ROW_32_370 vssd1 vccd1 sky130_fd_sc_hd__tapvpwrvgnd_1
XFILLER_1_279 vssd1 vssd1 vccd1 vccd1 sky130_fd_sc_hd__fill_1
XFILLER_40_161 vssd1 vssd1 vccd1 vccd1 sky130_fd_sc_hd__fill_1
XFILLER_32_106 vssd1 vssd1 vccd1 vccd1 sky130_fd_sc_hd__fill_1
XFILLER_9_346 vssd1 vssd1 vccd1 vccd1 sky130_fd_sc_hd__fill_2
Xoutput109 net109 vssd1 vssd1 vccd1 vccd1 SBsouth_out[15] sky130_fd_sc_hd__buf_2
Xoutput91 net91 vssd1 vssd1 vccd1 vccd1 CBnorth_out[13] sky130_fd_sc_hd__buf_2
XFILLER_48_250 vssd1 vssd1 vccd1 vccd1 sky130_fd_sc_hd__fill_2
X_3031_ LE_0B.reset_val LE_0B.edge_mode net261 vssd1 vssd1 vccd1 vccd1 _0091_ sky130_fd_sc_hd__mux2_1
Xoutput80 net80 vssd1 vssd1 vccd1 vccd1 CBeast_out[3] sky130_fd_sc_hd__buf_2
X_3100_ SB0.route_sel\[19\] SB0.route_sel\[18\] net262 vssd1 vssd1 vccd1 vccd1 _0160_
+ sky130_fd_sc_hd__mux2_1
XFILLER_48_283 vssd1 vssd1 vccd1 vccd1 sky130_fd_sc_hd__fill_1
X_2815_ net165 _0439_ _1043_ vssd1 vssd1 vccd1 vccd1 _1415_ sky130_fd_sc_hd__o21a_1
X_2746_ CB_1.config_dataB\[19\] _1357_ _1369_ _1373_ vssd1 vssd1 vccd1 vccd1 _1374_
+ sky130_fd_sc_hd__o31a_1
Xfanout303 net308 vssd1 vssd1 vccd1 vccd1 net303 sky130_fd_sc_hd__clkbuf_2
X_2677_ _1595_ _1596_ CB_1.config_dataB\[9\] _1279_ _1304_ vssd1 vssd1 vccd1 vccd1
+ _1305_ sky130_fd_sc_hd__a41o_1
X_1628_ SB0.route_sel\[22\] vssd1 vssd1 vccd1 vccd1 _1510_ sky130_fd_sc_hd__inv_2
X_3229_ CB_0.config_dataA\[20\] CB_0.config_dataA\[19\] net300 vssd1 vssd1 vccd1 vccd1
+ _0289_ sky130_fd_sc_hd__mux2_1
XFILLER_14_128 vccd1 vssd1 vccd1 vssd1 sky130_ef_sc_hd__decap_40_12
XFILLER_22_194 vssd1 vssd1 vccd1 vccd1 sky130_fd_sc_hd__fill_2
X_3580_ clknet_leaf_8_clk _0276_ net233 vssd1 vssd1 vccd1 vccd1 CB_0.config_dataA\[7\]
+ sky130_fd_sc_hd__dfstp_2
X_2600_ LE_1A.config_data\[5\] _1113_ _1151_ vssd1 vssd1 vccd1 vccd1 _1230_ sky130_fd_sc_hd__a21o_1
XFILLER_9_198 vssd1 vssd1 vccd1 vccd1 sky130_fd_sc_hd__fill_1
X_2531_ net4 net5 net6 net7 net172 net170 vssd1 vssd1 vccd1 vccd1 _1161_ sky130_fd_sc_hd__mux4_1
XFILLER_47_3 vssd1 vssd1 vccd1 vccd1 sky130_fd_sc_hd__fill_2
X_2393_ _1022_ _1023_ _1024_ _0938_ _0975_ vssd1 vssd1 vccd1 vccd1 _1025_ sky130_fd_sc_hd__o221a_1
X_2462_ _0672_ _1091_ vssd1 vssd1 vccd1 vccd1 _1092_ sky130_fd_sc_hd__and2_4
X_3014_ net390 LE_0B.config_data\[0\] net270 vssd1 vssd1 vccd1 vccd1 _0074_ sky130_fd_sc_hd__mux2_1
XFILLER_3_84 vssd1 vssd1 vccd1 vccd1 sky130_fd_sc_hd__fill_2
X_2729_ _1344_ _1348_ _1352_ _1356_ vssd1 vssd1 vccd1 vccd1 _1357_ sky130_fd_sc_hd__o211a_1
XFILLER_59_334 vssd1 vssd1 vccd1 vccd1 sky130_fd_sc_hd__fill_2
Xfanout199 CB_0.config_dataA\[1\] vssd1 vssd1 vccd1 vccd1 net199 sky130_fd_sc_hd__buf_2
Xfanout177 net178 vssd1 vssd1 vccd1 vccd1 net177 sky130_fd_sc_hd__clkbuf_2
Xfanout188 CB_0.config_dataB\[0\] vssd1 vssd1 vccd1 vccd1 net188 sky130_fd_sc_hd__buf_2
Xfanout144 CB_1.le_outA vssd1 vssd1 vccd1 vccd1 net144 sky130_fd_sc_hd__buf_2
Xfanout166 _1606_ vssd1 vssd1 vccd1 vccd1 net166 sky130_fd_sc_hd__buf_2
Xfanout155 CB_0.le_outA vssd1 vssd1 vccd1 vccd1 net155 sky130_fd_sc_hd__buf_2
XTAP_TAPCELL_ROW_57_546 vssd1 vccd1 sky130_fd_sc_hd__tapvpwrvgnd_1
XFILLER_42_234 vssd1 vssd1 vccd1 vccd1 sky130_fd_sc_hd__fill_4
XFILLER_42_212 vssd1 vssd1 vccd1 vccd1 sky130_fd_sc_hd__fill_4
XPHY_EDGE_ROW_29_Right_29 vssd1 vssd1 vccd1 vccd1 sky130_fd_sc_hd__decap_3
XTAP_TAPCELL_ROW_40_424 vssd1 vccd1 sky130_fd_sc_hd__tapvpwrvgnd_1
XPHY_EDGE_ROW_38_Right_38 vssd1 vssd1 vccd1 vccd1 sky130_fd_sc_hd__decap_3
XFILLER_8_29 vssd1 vssd1 vccd1 vccd1 sky130_fd_sc_hd__fill_2
XFILLER_10_186 vssd1 vssd1 vccd1 vccd1 sky130_fd_sc_hd__fill_2
XFILLER_2_374 vssd1 vssd1 vccd1 vccd1 sky130_fd_sc_hd__fill_1
XFILLER_12_82 vssd1 vssd1 vccd1 vccd1 sky130_fd_sc_hd__fill_2
XPHY_EDGE_ROW_47_Right_47 vssd1 vssd1 vccd1 vccd1 sky130_fd_sc_hd__decap_3
XFILLER_18_242 vssd1 vssd1 vccd1 vccd1 sky130_fd_sc_hd__fill_1
XPHY_EDGE_ROW_56_Right_56 vssd1 vssd1 vccd1 vccd1 sky130_fd_sc_hd__decap_3
X_1962_ _1530_ _0594_ _0595_ _0593_ vssd1 vssd1 vccd1 vccd1 _0596_ sky130_fd_sc_hd__a211o_1
XFILLER_18_264 vssd1 vssd1 vccd1 vccd1 sky130_fd_sc_hd__fill_1
X_3632_ clknet_leaf_16_clk _0328_ net258 vssd1 vssd1 vccd1 vccd1 CB_1.config_dataA\[9\]
+ sky130_fd_sc_hd__dfstp_1
X_3563_ clknet_leaf_12_clk _0259_ net248 vssd1 vssd1 vccd1 vccd1 SB0.route_sel\[118\]
+ sky130_fd_sc_hd__dfstp_1
X_1893_ _0524_ _0525_ _0526_ vssd1 vssd1 vccd1 vccd1 _0527_ sky130_fd_sc_hd__a21o_1
XPHY_EDGE_ROW_65_Right_65 vssd1 vssd1 vccd1 vccd1 sky130_fd_sc_hd__decap_3
X_2514_ CB_1.config_dataA\[8\] CB_1.config_dataA\[7\] CB_1.config_dataA\[9\] vssd1
+ vssd1 vccd1 vccd1 _1144_ sky130_fd_sc_hd__or3b_1
X_2376_ _1582_ _1007_ _0994_ _1585_ vssd1 vssd1 vccd1 vccd1 _1008_ sky130_fd_sc_hd__o211a_1
X_3494_ clknet_leaf_32_clk _0190_ net222 vssd1 vssd1 vccd1 vccd1 SB0.route_sel\[49\]
+ sky130_fd_sc_hd__dfstp_1
X_2445_ _0592_ _0598_ _1074_ vssd1 vssd1 vccd1 vccd1 _1075_ sky130_fd_sc_hd__or3_4
XTAP_TAPCELL_ROW_54_527 vssd1 vccd1 sky130_fd_sc_hd__tapvpwrvgnd_1
XFILLER_24_234 vssd1 vssd1 vccd1 vccd1 sky130_fd_sc_hd__fill_2
XFILLER_17_38 vssd1 vssd1 vccd1 vccd1 sky130_fd_sc_hd__fill_1
XTAP_TAPCELL_ROW_19_281 vssd1 vccd1 sky130_fd_sc_hd__tapvpwrvgnd_1
XTAP_TAPCELL_ROW_62_582 vssd1 vccd1 sky130_fd_sc_hd__tapvpwrvgnd_1
XFILLER_24_278 vssd1 vssd1 vccd1 vccd1 sky130_fd_sc_hd__fill_1
XFILLER_24_267 vssd1 vssd1 vccd1 vccd1 sky130_fd_sc_hd__fill_1
XFILLER_58_56 vssd1 vssd1 vccd1 vccd1 sky130_fd_sc_hd__fill_1
XFILLER_47_337 vssd1 vssd1 vccd1 vccd1 sky130_fd_sc_hd__fill_1
XTAP_TAPCELL_ROW_2_160 vssd1 vccd1 sky130_fd_sc_hd__tapvpwrvgnd_1
XFILLER_15_223 vssd1 vssd1 vccd1 vccd1 sky130_fd_sc_hd__fill_1
X_2230_ LE_0A.config_data\[0\] _0736_ _0740_ vssd1 vssd1 vccd1 vccd1 _0864_ sky130_fd_sc_hd__and3_1
XFILLER_2_193 vssd1 vssd1 vccd1 vccd1 sky130_fd_sc_hd__fill_2
X_2161_ CB_0.config_dataA\[11\] _0792_ _0793_ _0794_ vssd1 vssd1 vccd1 vccd1 _0795_
+ sky130_fd_sc_hd__a31o_1
X_2092_ net146 _0426_ _0666_ _0663_ _0423_ vssd1 vssd1 vccd1 vccd1 _0726_ sky130_fd_sc_hd__o32a_1
XFILLER_38_359 vssd1 vssd1 vccd1 vccd1 sky130_fd_sc_hd__fill_2
X_2994_ net325 net313 net293 vssd1 vssd1 vccd1 vccd1 _0054_ sky130_fd_sc_hd__mux2_1
X_1945_ SB0.route_sel\[59\] SB0.route_sel\[58\] vssd1 vssd1 vccd1 vccd1 _0579_ sky130_fd_sc_hd__nor2_1
XFILLER_21_204 vssd1 vssd1 vccd1 vccd1 sky130_fd_sc_hd__fill_1
X_3615_ clknet_leaf_6_clk _0311_ net230 vssd1 vssd1 vccd1 vccd1 CB_0.config_dataB\[17\]
+ sky130_fd_sc_hd__dfstp_1
X_1876_ SB0.route_sel\[83\] SB0.route_sel\[82\] _1548_ SB0.route_sel\[85\] _0509_
+ vssd1 vssd1 vccd1 vccd1 _0510_ sky130_fd_sc_hd__o221a_1
X_3546_ clknet_leaf_2_clk _0242_ net225 vssd1 vssd1 vccd1 vccd1 SB0.route_sel\[101\]
+ sky130_fd_sc_hd__dfstp_1
X_2359_ net17 _0986_ _0990_ CB_0.config_dataB\[16\] CB_0.config_dataB\[17\] vssd1
+ vssd1 vccd1 vccd1 _0991_ sky130_fd_sc_hd__a221o_1
XFILLER_29_337 vssd1 vssd1 vccd1 vccd1 sky130_fd_sc_hd__fill_2
XFILLER_28_26 vssd1 vssd1 vccd1 vccd1 sky130_fd_sc_hd__fill_2
X_2428_ _0508_ _1057_ vssd1 vssd1 vccd1 vccd1 _1058_ sky130_fd_sc_hd__or2_2
X_3477_ clknet_leaf_35_clk _0173_ net217 vssd1 vssd1 vccd1 vccd1 SB0.route_sel\[32\]
+ sky130_fd_sc_hd__dfstp_1
XFILLER_56_178 vssd1 vssd1 vccd1 vccd1 sky130_fd_sc_hd__fill_1
XFILLER_56_167 vssd1 vssd1 vccd1 vccd1 sky130_fd_sc_hd__fill_2
XFILLER_12_248 vssd1 vssd1 vccd1 vccd1 sky130_fd_sc_hd__fill_4
XTAP_TAPCELL_ROW_22_298 vssd1 vccd1 sky130_fd_sc_hd__tapvpwrvgnd_1
XFILLER_35_307 vssd1 vssd1 vccd1 vccd1 sky130_fd_sc_hd__fill_1
X_3331_ clknet_leaf_14_clk net394 net251 vssd1 vssd1 vccd1 vccd1 LEI0.config_data\[26\]
+ sky130_fd_sc_hd__dfrtp_1
X_1730_ net138 net166 net165 _1610_ _1611_ vssd1 vssd1 vccd1 vccd1 _0364_ sky130_fd_sc_hd__o32a_1
X_3400_ clknet_leaf_24_clk _0096_ net244 vssd1 vssd1 vccd1 vccd1 LE_1A.config_data\[1\]
+ sky130_fd_sc_hd__dfrtp_1
XFILLER_11_281 vssd1 vssd1 vccd1 vccd1 sky130_fd_sc_hd__fill_2
X_1661_ SB0.route_sel\[77\] vssd1 vssd1 vccd1 vccd1 _1543_ sky130_fd_sc_hd__inv_2
X_2144_ CB_0.config_dataA\[9\] _0758_ _0771_ _0777_ vssd1 vssd1 vccd1 vccd1 _0778_
+ sky130_fd_sc_hd__o31a_1
X_2213_ net191 _0675_ _0846_ vssd1 vssd1 vccd1 vccd1 _0847_ sky130_fd_sc_hd__a21o_1
X_3262_ CB_1.config_dataA\[3\] CB_1.config_dataA\[2\] net299 vssd1 vssd1 vccd1 vccd1
+ _0322_ sky130_fd_sc_hd__mux2_1
X_3193_ SB0.route_sel\[112\] SB0.route_sel\[111\] net296 vssd1 vssd1 vccd1 vccd1 _0253_
+ sky130_fd_sc_hd__mux2_1
X_2075_ net159 _0666_ net24 vssd1 vssd1 vccd1 vccd1 _0709_ sky130_fd_sc_hd__o21bai_1
XFILLER_19_370 vssd1 vssd1 vccd1 vccd1 sky130_fd_sc_hd__fill_1
X_2977_ LEI0.config_data\[36\] net329 net307 vssd1 vssd1 vccd1 vccd1 _0037_ sky130_fd_sc_hd__mux2_1
X_1859_ SB0.route_sel\[81\] SB0.route_sel\[80\] vssd1 vssd1 vccd1 vccd1 _0493_ sky130_fd_sc_hd__nand2_1
XFILLER_14_39 vssd1 vssd1 vccd1 vccd1 sky130_fd_sc_hd__fill_1
X_1928_ SB0.route_sel\[63\] SB0.route_sel\[62\] vssd1 vssd1 vccd1 vccd1 _0562_ sky130_fd_sc_hd__nand2_1
X_3529_ clknet_leaf_1_clk _0225_ net220 vssd1 vssd1 vccd1 vccd1 SB0.route_sel\[84\]
+ sky130_fd_sc_hd__dfstp_1
XFILLER_52_192 vssd1 vssd1 vccd1 vccd1 sky130_fd_sc_hd__fill_1
XFILLER_40_365 vssd1 vssd1 vccd1 vccd1 sky130_fd_sc_hd__fill_1
XTAP_TAPCELL_ROW_35_390 vssd1 vccd1 sky130_fd_sc_hd__tapvpwrvgnd_1
XTAP_TAPCELL_ROW_27_335 vssd1 vccd1 sky130_fd_sc_hd__tapvpwrvgnd_1
XTAP_TAPCELL_ROW_10_213 vssd1 vccd1 sky130_fd_sc_hd__tapvpwrvgnd_1
XFILLER_63_402 vssd1 vssd1 vccd1 vccd1 sky130_fd_sc_hd__fill_1
X_2900_ _1467_ _0672_ vssd1 vssd1 vccd1 vccd1 net128 sky130_fd_sc_hd__and2b_1
XFILLER_35_137 vssd1 vssd1 vccd1 vccd1 sky130_fd_sc_hd__fill_2
Xhold80 LE_0B.config_data\[1\] vssd1 vssd1 vccd1 vccd1 net390 sky130_fd_sc_hd__dlygate4sd3_1
Xhold91 LE_1A.config_data\[14\] vssd1 vssd1 vccd1 vccd1 net401 sky130_fd_sc_hd__dlygate4sd3_1
X_2762_ LE_1B.config_data\[9\] _1274_ vssd1 vssd1 vccd1 vccd1 _1390_ sky130_fd_sc_hd__and2_1
X_1713_ CB_1.config_dataB\[8\] vssd1 vssd1 vccd1 vccd1 _1595_ sky130_fd_sc_hd__inv_2
X_2831_ net144 _1423_ _0584_ vssd1 vssd1 vccd1 vccd1 net83 sky130_fd_sc_hd__mux2_1
X_3314_ clknet_leaf_14_clk _0010_ net256 vssd1 vssd1 vccd1 vccd1 LEI0.config_data\[9\]
+ sky130_fd_sc_hd__dfrtp_1
X_2693_ net207 _1034_ vssd1 vssd1 vccd1 vccd1 _1321_ sky130_fd_sc_hd__nand2_1
X_1644_ SB0.route_sel\[53\] vssd1 vssd1 vccd1 vccd1 _1526_ sky130_fd_sc_hd__inv_2
X_3245_ CB_0.config_dataB\[11\] net185 net294 vssd1 vssd1 vccd1 vccd1 _0305_ sky130_fd_sc_hd__mux2_1
X_2127_ _0645_ _0746_ CB_0.config_dataA\[7\] vssd1 vssd1 vccd1 vccd1 _0761_ sky130_fd_sc_hd__o21ai_1
X_3176_ SB0.route_sel\[95\] SB0.route_sel\[94\] net270 vssd1 vssd1 vccd1 vccd1 _0236_
+ sky130_fd_sc_hd__mux2_1
XTAP_TAPCELL_ROW_24_316 vssd1 vccd1 sky130_fd_sc_hd__tapvpwrvgnd_1
X_2058_ SB0.route_sel\[18\] SB0.route_sel\[19\] vssd1 vssd1 vccd1 vccd1 _0692_ sky130_fd_sc_hd__nor2_1
XFILLER_22_321 vssd1 vssd1 vccd1 vccd1 sky130_fd_sc_hd__fill_1
XTAP_TAPCELL_ROW_32_371 vssd1 vccd1 sky130_fd_sc_hd__tapvpwrvgnd_1
XFILLER_66_23 vssd1 vssd1 vccd1 vccd1 sky130_fd_sc_hd__fill_1
XFILLER_1_203 vssd1 vssd1 vccd1 vccd1 sky130_fd_sc_hd__fill_2
XFILLER_45_402 vssd1 vssd1 vccd1 vccd1 sky130_fd_sc_hd__fill_1
XFILLER_17_104 vssd1 vssd1 vccd1 vccd1 sky130_fd_sc_hd__fill_1
XFILLER_25_181 vssd1 vssd1 vccd1 vccd1 sky130_fd_sc_hd__fill_1
XFILLER_13_387 vssd1 vssd1 vccd1 vccd1 sky130_fd_sc_hd__fill_1
XFILLER_49_7 vssd1 vssd1 vccd1 vccd1 sky130_fd_sc_hd__fill_2
XFILLER_31_70 vssd1 vssd1 vccd1 vccd1 sky130_fd_sc_hd__fill_1
Xoutput92 net92 vssd1 vssd1 vccd1 vccd1 CBnorth_out[14] sky130_fd_sc_hd__buf_2
X_3030_ LE_0B.edge_mode LE_0B.config_data\[16\] net261 vssd1 vssd1 vccd1 vccd1 _0090_
+ sky130_fd_sc_hd__mux2_1
Xoutput81 net81 vssd1 vssd1 vccd1 vccd1 CBeast_out[4] sky130_fd_sc_hd__buf_2
XFILLER_31_140 vssd1 vssd1 vccd1 vccd1 sky130_fd_sc_hd__fill_1
XFILLER_16_170 vssd1 vssd1 vccd1 vccd1 sky130_fd_sc_hd__fill_1
XFILLER_16_192 vssd1 vssd1 vccd1 vccd1 sky130_fd_sc_hd__fill_4
X_2676_ LEI0.config_data\[23\] _1303_ vssd1 vssd1 vccd1 vccd1 _1304_ sky130_fd_sc_hd__and2b_1
X_2745_ CB_0.config_data_inA _1372_ _1370_ vssd1 vssd1 vccd1 vccd1 _1373_ sky130_fd_sc_hd__o21a_1
X_2814_ _0364_ _1414_ _0365_ vssd1 vssd1 vccd1 vccd1 net76 sky130_fd_sc_hd__a21oi_1
Xfanout304 net308 vssd1 vssd1 vccd1 vccd1 net304 sky130_fd_sc_hd__clkbuf_4
X_1627_ SB0.route_sel\[21\] vssd1 vssd1 vccd1 vccd1 _1509_ sky130_fd_sc_hd__inv_2
X_3228_ CB_0.config_dataA\[19\] CB_0.config_dataA\[18\] net302 vssd1 vssd1 vccd1 vccd1
+ _0288_ sky130_fd_sc_hd__mux2_1
XPHY_EDGE_ROW_61_Left_129 vssd1 vssd1 vccd1 vccd1 sky130_fd_sc_hd__decap_3
XFILLER_27_402 vssd1 vssd1 vccd1 vccd1 sky130_fd_sc_hd__fill_1
X_3159_ SB0.route_sel\[78\] SB0.route_sel\[77\] net269 vssd1 vssd1 vccd1 vccd1 _0219_
+ sky130_fd_sc_hd__mux2_1
Xclkbuf_leaf_34_clk clknet_2_0__leaf_clk vssd1 vssd1 vccd1 vccd1 clknet_leaf_34_clk
+ sky130_fd_sc_hd__clkbuf_8
XFILLER_6_306 vssd1 vssd1 vccd1 vccd1 sky130_fd_sc_hd__fill_2
XFILLER_45_210 vssd1 vssd1 vccd1 vccd1 sky130_fd_sc_hd__fill_1
XTAP_TAPCELL_ROW_43_444 vssd1 vccd1 sky130_fd_sc_hd__tapvpwrvgnd_1
Xclkbuf_leaf_25_clk clknet_2_2__leaf_clk vssd1 vssd1 vccd1 vccd1 clknet_leaf_25_clk
+ sky130_fd_sc_hd__clkbuf_8
X_2530_ net15 net16 net2 net3 net172 net170 vssd1 vssd1 vccd1 vccd1 _1160_ sky130_fd_sc_hd__mux4_1
XFILLER_9_166 vssd1 vssd1 vccd1 vccd1 sky130_fd_sc_hd__fill_2
X_2392_ LE_0B.config_data\[14\] LE_0B.config_data\[15\] _0905_ vssd1 vssd1 vccd1 vccd1
+ _1024_ sky130_fd_sc_hd__mux2_1
X_2461_ _1514_ SB0.route_sel\[30\] SB0.route_sel\[25\] _1517_ _1090_ vssd1 vssd1 vccd1
+ vccd1 _1091_ sky130_fd_sc_hd__a221o_1
XFILLER_36_276 vssd1 vssd1 vccd1 vccd1 sky130_fd_sc_hd__fill_2
XFILLER_36_243 vssd1 vssd1 vccd1 vccd1 sky130_fd_sc_hd__fill_8
XFILLER_36_210 vssd1 vssd1 vccd1 vccd1 sky130_fd_sc_hd__fill_2
X_3013_ LE_0B.config_data\[0\] LE_1B.reset_mode net261 vssd1 vssd1 vccd1 vccd1 _0073_
+ sky130_fd_sc_hd__mux2_1
Xclkbuf_leaf_16_clk clknet_2_3__leaf_clk vssd1 vssd1 vccd1 vccd1 clknet_leaf_16_clk
+ sky130_fd_sc_hd__clkbuf_8
X_2728_ net202 _1353_ _1354_ _1355_ vssd1 vssd1 vccd1 vccd1 _1356_ sky130_fd_sc_hd__a31o_1
X_2659_ net210 _1030_ net208 vssd1 vssd1 vccd1 vccd1 _1287_ sky130_fd_sc_hd__o21ai_1
Xfanout145 CB_1.le_outA vssd1 vssd1 vccd1 vccd1 net145 sky130_fd_sc_hd__clkbuf_2
Xfanout178 CB_1.config_dataA\[0\] vssd1 vssd1 vccd1 vccd1 net178 sky130_fd_sc_hd__clkbuf_2
Xfanout189 CB_0.config_dataB\[0\] vssd1 vssd1 vccd1 vccd1 net189 sky130_fd_sc_hd__buf_1
Xfanout167 CB_1.config_dataA\[16\] vssd1 vssd1 vccd1 vccd1 net167 sky130_fd_sc_hd__buf_2
Xfanout156 _0651_ vssd1 vssd1 vccd1 vccd1 net156 sky130_fd_sc_hd__buf_2
XTAP_TAPCELL_ROW_57_547 vssd1 vccd1 sky130_fd_sc_hd__tapvpwrvgnd_1
XTAP_TAPCELL_ROW_40_425 vssd1 vccd1 sky130_fd_sc_hd__tapvpwrvgnd_1
XFILLER_10_154 vssd1 vssd1 vccd1 vccd1 sky130_fd_sc_hd__fill_1
XTAP_TAPCELL_ROW_5_180 vssd1 vccd1 sky130_fd_sc_hd__tapvpwrvgnd_1
X_1961_ net148 net164 _0571_ vssd1 vssd1 vccd1 vccd1 _0595_ sky130_fd_sc_hd__nor3_1
XFILLER_33_279 vssd1 vssd1 vccd1 vccd1 sky130_fd_sc_hd__fill_1
XFILLER_33_246 vssd1 vssd1 vccd1 vccd1 sky130_fd_sc_hd__fill_1
X_1892_ net155 _0450_ _0479_ SB0.route_sel\[72\] SB0.route_sel\[73\] vssd1 vssd1 vccd1
+ vccd1 _0526_ sky130_fd_sc_hd__a32o_1
X_3631_ clknet_leaf_16_clk _0327_ net255 vssd1 vssd1 vccd1 vccd1 CB_1.config_dataA\[8\]
+ sky130_fd_sc_hd__dfstp_1
X_3562_ clknet_leaf_19_clk _0258_ net248 vssd1 vssd1 vccd1 vccd1 SB0.route_sel\[117\]
+ sky130_fd_sc_hd__dfstp_1
X_2513_ _1134_ _1136_ _1138_ _1142_ vssd1 vssd1 vccd1 vccd1 _1143_ sky130_fd_sc_hd__and4_1
X_3493_ clknet_leaf_31_clk _0189_ net223 vssd1 vssd1 vccd1 vccd1 SB0.route_sel\[48\]
+ sky130_fd_sc_hd__dfstp_1
X_2375_ CB_0.config_dataB\[17\] _0999_ _1003_ _1006_ vssd1 vssd1 vccd1 vccd1 _1007_
+ sky130_fd_sc_hd__o22a_1
Xclkbuf_leaf_5_clk clknet_2_1__leaf_clk vssd1 vssd1 vccd1 vccd1 clknet_leaf_5_clk
+ sky130_fd_sc_hd__clkbuf_8
X_2444_ SB0.route_sel\[55\] _1528_ _1529_ SB0.route_sel\[48\] _1073_ vssd1 vssd1 vccd1
+ vccd1 _1074_ sky130_fd_sc_hd__o221a_1
XFILLER_64_382 vssd1 vssd1 vccd1 vccd1 sky130_fd_sc_hd__fill_1
XFILLER_24_224 vssd1 vssd1 vccd1 vccd1 sky130_fd_sc_hd__fill_2
XTAP_TAPCELL_ROW_19_282 vssd1 vccd1 sky130_fd_sc_hd__tapvpwrvgnd_1
XTAP_TAPCELL_ROW_62_583 vssd1 vccd1 sky130_fd_sc_hd__tapvpwrvgnd_1
XFILLER_33_49 vssd1 vssd1 vccd1 vccd1 sky130_fd_sc_hd__fill_4
XTAP_TAPCELL_ROW_2_161 vssd1 vccd1 sky130_fd_sc_hd__tapvpwrvgnd_1
XFILLER_15_246 vssd1 vssd1 vccd1 vccd1 sky130_fd_sc_hd__fill_1
X_2160_ _0549_ _0783_ _0785_ _0531_ CB_0.config_dataA\[12\] vssd1 vssd1 vccd1 vccd1
+ _0794_ sky130_fd_sc_hd__a221o_1
XFILLER_24_6 vccd1 vssd1 vccd1 vssd1 sky130_ef_sc_hd__decap_40_12
X_2091_ _0425_ _0665_ vssd1 vssd1 vccd1 vccd1 _0725_ sky130_fd_sc_hd__nand2_1
X_2993_ net313 LE_0A.config_data\[1\] net293 vssd1 vssd1 vccd1 vccd1 _0053_ sky130_fd_sc_hd__mux2_1
X_3614_ clknet_leaf_6_clk _0310_ net228 vssd1 vssd1 vccd1 vccd1 CB_0.config_dataB\[16\]
+ sky130_fd_sc_hd__dfstp_2
X_1875_ SB0.route_sel\[86\] SB0.route_sel\[87\] vssd1 vssd1 vccd1 vccd1 _0509_ sky130_fd_sc_hd__nand2b_1
X_1944_ _0566_ _0577_ vssd1 vssd1 vccd1 vccd1 _0578_ sky130_fd_sc_hd__nand2_1
XFILLER_9_95 vssd1 vssd1 vccd1 vccd1 sky130_fd_sc_hd__fill_2
X_3545_ clknet_leaf_2_clk _0241_ net225 vssd1 vssd1 vccd1 vccd1 SB0.route_sel\[100\]
+ sky130_fd_sc_hd__dfstp_1
X_2427_ SB0.route_sel\[84\] SB0.route_sel\[85\] _1549_ SB0.route_sel\[80\] _1056_
+ vssd1 vssd1 vccd1 vccd1 _1057_ sky130_fd_sc_hd__o221a_1
X_3476_ clknet_leaf_33_clk _0172_ net217 vssd1 vssd1 vccd1 vccd1 SB0.route_sel\[31\]
+ sky130_fd_sc_hd__dfstp_1
XTAP_TAPCELL_ROW_67_620 vssd1 vccd1 sky130_fd_sc_hd__tapvpwrvgnd_1
X_2358_ net25 net26 net181 vssd1 vssd1 vccd1 vccd1 _0990_ sky130_fd_sc_hd__mux2_1
X_2289_ _1578_ net137 _0384_ vssd1 vssd1 vccd1 vccd1 _0921_ sky130_fd_sc_hd__and3_1
XFILLER_28_38 vssd1 vssd1 vccd1 vccd1 sky130_fd_sc_hd__fill_4
XFILLER_37_382 vssd1 vssd1 vccd1 vccd1 sky130_fd_sc_hd__fill_2
XFILLER_37_371 vssd1 vssd1 vccd1 vccd1 sky130_fd_sc_hd__fill_2
XFILLER_8_209 vssd1 vssd1 vccd1 vccd1 sky130_fd_sc_hd__fill_4
XFILLER_20_282 vssd1 vssd1 vccd1 vccd1 sky130_fd_sc_hd__fill_2
XTAP_TAPCELL_ROW_22_299 vssd1 vccd1 sky130_fd_sc_hd__tapvpwrvgnd_1
XFILLER_47_113 vccd1 vssd1 vccd1 vssd1 sky130_ef_sc_hd__decap_40_12
XPHY_EDGE_ROW_8_Left_76 vssd1 vssd1 vccd1 vccd1 sky130_fd_sc_hd__decap_3
XFILLER_18_82 vssd1 vssd1 vccd1 vccd1 sky130_fd_sc_hd__fill_2
X_3330_ clknet_leaf_12_clk _0026_ net251 vssd1 vssd1 vccd1 vccd1 LEI0.config_data\[25\]
+ sky130_fd_sc_hd__dfrtp_1
XFILLER_50_91 vssd1 vssd1 vccd1 vccd1 sky130_fd_sc_hd__fill_8
X_1660_ SB0.route_sel\[74\] vssd1 vssd1 vccd1 vccd1 _1542_ sky130_fd_sc_hd__inv_2
X_2143_ LEI0.config_data\[14\] _0774_ _0776_ _0772_ vssd1 vssd1 vccd1 vccd1 _0777_
+ sky130_fd_sc_hd__o31a_2
X_2212_ net191 _0695_ net190 vssd1 vssd1 vccd1 vccd1 _0846_ sky130_fd_sc_hd__o21ai_1
X_3261_ CB_1.config_dataA\[2\] net176 net299 vssd1 vssd1 vccd1 vccd1 _0321_ sky130_fd_sc_hd__mux2_1
XFILLER_38_179 vssd1 vssd1 vccd1 vccd1 sky130_fd_sc_hd__fill_2
X_3192_ SB0.route_sel\[111\] SB0.route_sel\[110\] net296 vssd1 vssd1 vccd1 vccd1 _0252_
+ sky130_fd_sc_hd__mux2_1
XFILLER_61_193 vssd1 vssd1 vccd1 vccd1 sky130_fd_sc_hd__fill_1
XFILLER_46_190 vssd1 vssd1 vccd1 vccd1 sky130_fd_sc_hd__fill_4
X_2074_ net146 net159 _0666_ _0663_ _0451_ vssd1 vssd1 vccd1 vccd1 _0708_ sky130_fd_sc_hd__o32a_1
XFILLER_34_330 vssd1 vssd1 vccd1 vccd1 sky130_fd_sc_hd__fill_2
XFILLER_14_29 vssd1 vssd1 vccd1 vccd1 sky130_fd_sc_hd__fill_1
XFILLER_19_360 vssd1 vssd1 vccd1 vccd1 sky130_fd_sc_hd__fill_1
X_2976_ net329 net338 net307 vssd1 vssd1 vccd1 vccd1 _0036_ sky130_fd_sc_hd__mux2_1
X_1858_ _0489_ _0491_ vssd1 vssd1 vccd1 vccd1 _0492_ sky130_fd_sc_hd__nor2_2
X_1927_ _0555_ _0558_ _0559_ _0560_ vssd1 vssd1 vccd1 vccd1 _0561_ sky130_fd_sc_hd__a31o_1
X_1789_ CB_0.config_dataA\[24\] CB_0.config_dataA\[21\] CB_0.config_dataA\[20\] vssd1
+ vssd1 vccd1 vccd1 _0423_ sky130_fd_sc_hd__or3_1
X_3528_ clknet_leaf_2_clk _0224_ net225 vssd1 vssd1 vccd1 vccd1 SB0.route_sel\[83\]
+ sky130_fd_sc_hd__dfstp_2
X_3459_ clknet_leaf_34_clk _0155_ net216 vssd1 vssd1 vccd1 vccd1 SB0.route_sel\[14\]
+ sky130_fd_sc_hd__dfstp_1
XFILLER_29_113 vssd1 vssd1 vccd1 vccd1 sky130_fd_sc_hd__fill_2
XTAP_TAPCELL_ROW_27_336 vssd1 vccd1 sky130_fd_sc_hd__tapvpwrvgnd_1
XTAP_TAPCELL_ROW_35_391 vssd1 vccd1 sky130_fd_sc_hd__tapvpwrvgnd_1
XTAP_TAPCELL_ROW_10_214 vssd1 vccd1 sky130_fd_sc_hd__tapvpwrvgnd_1
XFILLER_20_61 vssd1 vssd1 vccd1 vccd1 sky130_fd_sc_hd__fill_4
XFILLER_20_83 vssd1 vssd1 vccd1 vccd1 sky130_fd_sc_hd__fill_1
XFILLER_20_94 vssd1 vssd1 vccd1 vccd1 sky130_fd_sc_hd__fill_4
Xhold70 LE_0A.config_data\[1\] vssd1 vssd1 vccd1 vccd1 net380 sky130_fd_sc_hd__dlygate4sd3_1
Xhold92 LEI0.config_data\[21\] vssd1 vssd1 vccd1 vccd1 net402 sky130_fd_sc_hd__dlygate4sd3_1
Xhold81 _0075_ vssd1 vssd1 vccd1 vccd1 net391 sky130_fd_sc_hd__dlygate4sd3_1
XFILLER_29_92 vssd1 vssd1 vccd1 vccd1 sky130_fd_sc_hd__fill_2
XFILLER_29_81 vssd1 vssd1 vccd1 vccd1 sky130_fd_sc_hd__fill_2
XFILLER_35_149 vssd1 vssd1 vccd1 vccd1 sky130_fd_sc_hd__fill_1
X_2830_ _0586_ _1422_ vssd1 vssd1 vccd1 vccd1 _1423_ sky130_fd_sc_hd__and2_1
XANTENNA_1 CBeast_in[11] vssd1 vssd1 vccd1 vccd1 sky130_fd_sc_hd__diode_2
X_2692_ net207 _1030_ vssd1 vssd1 vccd1 vccd1 _1320_ sky130_fd_sc_hd__or2_1
X_1643_ SB0.route_sel\[50\] vssd1 vssd1 vccd1 vccd1 _1525_ sky130_fd_sc_hd__inv_2
X_2761_ LE_1B.config_data\[10\] LE_1B.config_data\[11\] _1274_ vssd1 vssd1 vccd1 vccd1
+ _1389_ sky130_fd_sc_hd__mux2_1
X_1712_ CB_1.config_dataB\[2\] vssd1 vssd1 vccd1 vccd1 _1594_ sky130_fd_sc_hd__inv_2
X_3313_ clknet_leaf_14_clk net419 net255 vssd1 vssd1 vccd1 vccd1 LEI0.config_data\[8\]
+ sky130_fd_sc_hd__dfrtp_1
X_3244_ net184 CB_0.config_dataB\[9\] net295 vssd1 vssd1 vccd1 vccd1 _0304_ sky130_fd_sc_hd__mux2_1
XFILLER_6_96 vssd1 vssd1 vccd1 vccd1 sky130_fd_sc_hd__fill_1
XFILLER_6_85 vssd1 vssd1 vccd1 vccd1 sky130_fd_sc_hd__fill_2
X_2126_ net197 _0603_ _0759_ net196 vssd1 vssd1 vccd1 vccd1 _0760_ sky130_fd_sc_hd__o211ai_1
X_3175_ SB0.route_sel\[94\] SB0.route_sel\[93\] net270 vssd1 vssd1 vccd1 vccd1 _0235_
+ sky130_fd_sc_hd__mux2_1
XFILLER_26_127 vssd1 vssd1 vccd1 vccd1 sky130_fd_sc_hd__fill_2
X_2057_ _0686_ _0690_ net267 _0682_ vssd1 vssd1 vccd1 vccd1 _0691_ sky130_fd_sc_hd__a211oi_2
X_2959_ LEI0.config_data\[18\] net389 net304 vssd1 vssd1 vccd1 vccd1 _0019_ sky130_fd_sc_hd__mux2_1
XFILLER_34_193 vssd1 vssd1 vccd1 vccd1 sky130_fd_sc_hd__fill_2
XFILLER_34_160 vssd1 vssd1 vccd1 vccd1 sky130_fd_sc_hd__fill_2
XTAP_TAPCELL_ROW_32_372 vssd1 vccd1 sky130_fd_sc_hd__tapvpwrvgnd_1
XTAP_TAPCELL_ROW_24_317 vssd1 vccd1 sky130_fd_sc_hd__tapvpwrvgnd_1
XFILLER_40_141 vssd1 vssd1 vccd1 vccd1 sky130_fd_sc_hd__fill_2
Xoutput93 net93 vssd1 vssd1 vccd1 vccd1 CBnorth_out[15] sky130_fd_sc_hd__buf_2
Xoutput71 net71 vssd1 vssd1 vccd1 vccd1 CBeast_out[0] sky130_fd_sc_hd__buf_2
Xoutput82 net82 vssd1 vssd1 vccd1 vccd1 CBeast_out[5] sky130_fd_sc_hd__buf_2
XTAP_TAPCELL_ROW_38_409 vssd1 vccd1 sky130_fd_sc_hd__tapvpwrvgnd_1
X_2813_ _1606_ net165 _1030_ vssd1 vssd1 vccd1 vccd1 _1414_ sky130_fd_sc_hd__o21bai_1
XFILLER_23_108 vssd1 vssd1 vccd1 vccd1 sky130_fd_sc_hd__fill_4
X_2675_ net154 net150 net145 net140 LEI0.config_data\[21\] LEI0.config_data\[22\]
+ vssd1 vssd1 vccd1 vccd1 _1303_ sky130_fd_sc_hd__mux4_1
X_2744_ _1371_ vssd1 vssd1 vccd1 vccd1 _1372_ sky130_fd_sc_hd__inv_2
X_1626_ SB0.route_sel\[8\] vssd1 vssd1 vccd1 vccd1 _1508_ sky130_fd_sc_hd__inv_2
X_3227_ CB_0.config_dataA\[18\] net312 net302 vssd1 vssd1 vccd1 vccd1 _0287_ sky130_fd_sc_hd__mux2_1
Xfanout305 net308 vssd1 vssd1 vccd1 vccd1 net305 sky130_fd_sc_hd__buf_2
X_2109_ net198 _0409_ vssd1 vssd1 vccd1 vccd1 _0743_ sky130_fd_sc_hd__nand2_1
XFILLER_54_233 vssd1 vssd1 vccd1 vccd1 sky130_fd_sc_hd__fill_1
XFILLER_36_38 vssd1 vssd1 vccd1 vccd1 sky130_fd_sc_hd__fill_4
X_3089_ SB0.route_sel\[8\] SB0.route_sel\[7\] net266 vssd1 vssd1 vccd1 vccd1 _0149_
+ sky130_fd_sc_hd__mux2_1
X_3158_ SB0.route_sel\[77\] SB0.route_sel\[76\] net272 vssd1 vssd1 vccd1 vccd1 _0218_
+ sky130_fd_sc_hd__mux2_1
XFILLER_22_185 vssd1 vssd1 vccd1 vccd1 sky130_fd_sc_hd__fill_2
XTAP_TAPCELL_ROW_43_445 vssd1 vccd1 sky130_fd_sc_hd__tapvpwrvgnd_1
X_2460_ SB0.route_sel\[28\] SB0.route_sel\[29\] vssd1 vssd1 vccd1 vccd1 _1090_ sky130_fd_sc_hd__nor2_1
XPHY_EDGE_ROW_21_Left_89 vssd1 vssd1 vccd1 vccd1 sky130_fd_sc_hd__decap_3
XFILLER_47_5 vssd1 vssd1 vccd1 vccd1 sky130_fd_sc_hd__fill_1
X_2391_ _1586_ _0905_ _0938_ vssd1 vssd1 vccd1 vccd1 _1023_ sky130_fd_sc_hd__o21ai_1
X_3012_ LE_1A.dff1_out _1236_ net68 vssd1 vssd1 vccd1 vccd1 _0072_ sky130_fd_sc_hd__mux2_1
XFILLER_22_29 vssd1 vssd1 vccd1 vccd1 sky130_fd_sc_hd__fill_4
X_2589_ net154 net150 net145 net140 LEI0.config_data\[42\] LEI0.config_data\[43\]
+ vssd1 vssd1 vccd1 vccd1 _1219_ sky130_fd_sc_hd__mux4_1
X_2727_ _1103_ _1345_ _1346_ _1100_ CB_1.config_dataB\[17\] vssd1 vssd1 vccd1 vccd1
+ _1355_ sky130_fd_sc_hd__a221o_1
X_2658_ net210 _1034_ vssd1 vssd1 vccd1 vccd1 _1286_ sky130_fd_sc_hd__and2_1
XTAP_TAPCELL_ROW_57_548 vssd1 vccd1 sky130_fd_sc_hd__tapvpwrvgnd_1
Xfanout179 CB_0.config_dataB\[23\] vssd1 vssd1 vccd1 vccd1 net179 sky130_fd_sc_hd__clkbuf_2
Xfanout146 net147 vssd1 vssd1 vccd1 vccd1 net146 sky130_fd_sc_hd__buf_2
Xfanout168 net169 vssd1 vssd1 vccd1 vccd1 net168 sky130_fd_sc_hd__clkbuf_2
Xfanout157 _0556_ vssd1 vssd1 vccd1 vccd1 net157 sky130_fd_sc_hd__buf_2
XTAP_TAPCELL_ROW_40_426 vssd1 vccd1 sky130_fd_sc_hd__tapvpwrvgnd_1
XFILLER_33_203 vssd1 vssd1 vccd1 vccd1 sky130_fd_sc_hd__fill_4
XTAP_TAPCELL_ROW_5_181 vssd1 vccd1 sky130_fd_sc_hd__tapvpwrvgnd_1
X_3630_ clknet_leaf_16_clk _0326_ net255 vssd1 vssd1 vccd1 vccd1 CB_1.config_dataA\[7\]
+ sky130_fd_sc_hd__dfstp_2
X_1960_ net164 _0571_ vssd1 vssd1 vccd1 vccd1 _0594_ sky130_fd_sc_hd__or2_1
X_1891_ net159 _0483_ net32 vssd1 vssd1 vccd1 vccd1 _0525_ sky130_fd_sc_hd__o21bai_1
X_3561_ clknet_leaf_19_clk _0257_ net248 vssd1 vssd1 vccd1 vccd1 SB0.route_sel\[116\]
+ sky130_fd_sc_hd__dfstp_1
X_2512_ net173 _1139_ _1140_ _1141_ vssd1 vssd1 vccd1 vccd1 _1142_ sky130_fd_sc_hd__a31o_1
X_2443_ SB0.route_sel\[52\] SB0.route_sel\[53\] vssd1 vssd1 vccd1 vccd1 _1073_ sky130_fd_sc_hd__or2_1
X_3492_ clknet_leaf_31_clk _0188_ net223 vssd1 vssd1 vccd1 vccd1 SB0.route_sel\[47\]
+ sky130_fd_sc_hd__dfstp_1
X_2374_ CB_0.config_dataB\[16\] _1005_ _1004_ vssd1 vssd1 vccd1 vccd1 _1006_ sky130_fd_sc_hd__a21o_1
XFILLER_24_236 vssd1 vssd1 vccd1 vccd1 sky130_fd_sc_hd__fill_1
XFILLER_32_280 vssd1 vssd1 vccd1 vccd1 sky130_fd_sc_hd__fill_2
XFILLER_3_107 vssd1 vssd1 vccd1 vccd1 sky130_fd_sc_hd__fill_1
XFILLER_59_111 vssd1 vssd1 vccd1 vccd1 sky130_fd_sc_hd__fill_1
XFILLER_62_309 vssd1 vssd1 vccd1 vccd1 sky130_fd_sc_hd__fill_1
XTAP_TAPCELL_ROW_2_162 vssd1 vccd1 sky130_fd_sc_hd__tapvpwrvgnd_1
XFILLER_15_203 vssd1 vssd1 vccd1 vccd1 sky130_fd_sc_hd__fill_2
XFILLER_7_402 vssd1 vssd1 vccd1 vccd1 sky130_fd_sc_hd__fill_1
X_2090_ _0422_ _0662_ vssd1 vssd1 vccd1 vccd1 _0724_ sky130_fd_sc_hd__nand2_1
XFILLER_2_195 vssd1 vssd1 vccd1 vccd1 sky130_fd_sc_hd__fill_1
XFILLER_65_169 vssd1 vssd1 vccd1 vccd1 sky130_fd_sc_hd__fill_1
X_2992_ net380 net376 net293 vssd1 vssd1 vccd1 vccd1 _0052_ sky130_fd_sc_hd__mux2_1
XFILLER_0_21 vssd1 vssd1 vccd1 vccd1 sky130_fd_sc_hd__fill_4
X_3613_ clknet_leaf_6_clk _0309_ net230 vssd1 vssd1 vccd1 vccd1 CB_0.config_dataB\[15\]
+ sky130_fd_sc_hd__dfstp_1
X_1943_ _1502_ _0576_ vssd1 vssd1 vccd1 vccd1 _0577_ sky130_fd_sc_hd__and2_2
X_1874_ _0503_ _0507_ net274 _0499_ vssd1 vssd1 vccd1 vccd1 _0508_ sky130_fd_sc_hd__a211o_1
X_3544_ clknet_leaf_2_clk _0240_ net225 vssd1 vssd1 vccd1 vccd1 SB0.route_sel\[99\]
+ sky130_fd_sc_hd__dfstp_1
X_2426_ SB0.route_sel\[87\] SB0.route_sel\[86\] vssd1 vssd1 vccd1 vccd1 _1056_ sky130_fd_sc_hd__nand2b_1
XPHY_EDGE_ROW_24_Left_92 vssd1 vssd1 vccd1 vccd1 sky130_fd_sc_hd__decap_3
X_3475_ clknet_leaf_33_clk _0171_ net217 vssd1 vssd1 vccd1 vccd1 SB0.route_sel\[30\]
+ sky130_fd_sc_hd__dfstp_1
XTAP_TAPCELL_ROW_67_621 vssd1 vccd1 sky130_fd_sc_hd__tapvpwrvgnd_1
XFILLER_56_169 vssd1 vssd1 vccd1 vccd1 sky130_fd_sc_hd__fill_1
X_2357_ _0694_ _0733_ _0675_ _0715_ _1584_ net182 vssd1 vssd1 vccd1 vccd1 _0989_ sky130_fd_sc_hd__mux4_1
X_2288_ _0918_ _0919_ CB_0.config_dataB\[7\] vssd1 vssd1 vccd1 vccd1 _0920_ sky130_fd_sc_hd__o21bai_1
XFILLER_29_339 vssd1 vssd1 vccd1 vccd1 sky130_fd_sc_hd__fill_1
XFILLER_29_306 vssd1 vssd1 vccd1 vccd1 sky130_fd_sc_hd__fill_1
XFILLER_44_27 vssd1 vssd1 vccd1 vccd1 sky130_fd_sc_hd__fill_1
XFILLER_47_125 vssd1 vssd1 vccd1 vccd1 sky130_fd_sc_hd__fill_4
XFILLER_55_191 vssd1 vssd1 vccd1 vccd1 sky130_fd_sc_hd__fill_1
XFILLER_18_94 vssd1 vssd1 vccd1 vccd1 sky130_fd_sc_hd__fill_4
XFILLER_34_82 vssd1 vssd1 vccd1 vccd1 sky130_fd_sc_hd__fill_2
XTAP_TAPCELL_ROW_13_234 vssd1 vccd1 sky130_fd_sc_hd__tapvpwrvgnd_1
XFILLER_50_81 vssd1 vssd1 vccd1 vccd1 sky130_fd_sc_hd__fill_2
X_3260_ CB_1.config_dataA\[1\] net178 net298 vssd1 vssd1 vccd1 vccd1 _0320_ sky130_fd_sc_hd__mux2_1
X_2211_ CB_0.config_dataA\[17\] _0844_ _0842_ CB_0.config_dataA\[18\] vssd1 vssd1
+ vccd1 vccd1 _0845_ sky130_fd_sc_hd__a211o_1
X_2142_ LEI0.config_data\[12\] net143 _0775_ LEI0.config_data\[13\] vssd1 vssd1 vccd1
+ vccd1 _0776_ sky130_fd_sc_hd__o211a_1
X_2073_ net159 _0666_ vssd1 vssd1 vccd1 vccd1 _0707_ sky130_fd_sc_hd__nor2_1
XFILLER_53_117 vssd1 vssd1 vccd1 vccd1 sky130_fd_sc_hd__fill_2
X_3191_ SB0.route_sel\[110\] SB0.route_sel\[109\] net296 vssd1 vssd1 vccd1 vccd1 _0251_
+ sky130_fd_sc_hd__mux2_1
XFILLER_15_3 vssd1 vssd1 vccd1 vccd1 sky130_fd_sc_hd__fill_1
X_2975_ net338 LEI0.config_data\[33\] net307 vssd1 vssd1 vccd1 vccd1 _0035_ sky130_fd_sc_hd__mux2_1
XFILLER_46_180 vssd1 vssd1 vccd1 vccd1 sky130_fd_sc_hd__fill_2
X_1788_ CB_0.config_dataA\[24\] CB_0.config_dataA\[21\] CB_0.config_dataA\[20\] vssd1
+ vssd1 vccd1 vccd1 _0422_ sky130_fd_sc_hd__nor3_4
X_3527_ clknet_leaf_1_clk _0223_ net220 vssd1 vssd1 vccd1 vccd1 SB0.route_sel\[82\]
+ sky130_fd_sc_hd__dfstp_2
XFILLER_30_29 vssd1 vssd1 vccd1 vccd1 sky130_fd_sc_hd__fill_8
XFILLER_30_18 vssd1 vssd1 vccd1 vccd1 sky130_fd_sc_hd__fill_8
X_1857_ SB0.route_sel\[91\] SB0.route_sel\[90\] _1551_ SB0.route_sel\[93\] _0490_
+ vssd1 vssd1 vccd1 vccd1 _0491_ sky130_fd_sc_hd__o221a_2
X_1926_ net144 _0397_ _0553_ SB0.route_sel\[58\] SB0.route_sel\[59\] vssd1 vssd1 vccd1
+ vccd1 _0560_ sky130_fd_sc_hd__a32o_1
XFILLER_57_401 vssd1 vssd1 vccd1 vccd1 sky130_fd_sc_hd__fill_2
X_2409_ net177 net176 vssd1 vssd1 vccd1 vccd1 _1039_ sky130_fd_sc_hd__nor2_1
X_3389_ clknet_leaf_5_clk _0085_ net227 vssd1 vssd1 vccd1 vccd1 LE_0B.config_data\[12\]
+ sky130_fd_sc_hd__dfrtp_1
X_3458_ clknet_leaf_34_clk _0154_ net216 vssd1 vssd1 vccd1 vccd1 SB0.route_sel\[13\]
+ sky130_fd_sc_hd__dfstp_1
XTAP_TAPCELL_ROW_27_337 vssd1 vccd1 sky130_fd_sc_hd__tapvpwrvgnd_1
XTAP_TAPCELL_ROW_35_392 vssd1 vccd1 sky130_fd_sc_hd__tapvpwrvgnd_1
XTAP_TAPCELL_ROW_10_215 vssd1 vccd1 sky130_fd_sc_hd__tapvpwrvgnd_1
Xhold71 LEI0.config_data\[41\] vssd1 vssd1 vccd1 vccd1 net381 sky130_fd_sc_hd__dlygate4sd3_1
Xhold93 LE_0A.config_data\[14\] vssd1 vssd1 vccd1 vccd1 net403 sky130_fd_sc_hd__dlygate4sd3_1
Xhold82 LE_0B.config_data\[2\] vssd1 vssd1 vccd1 vccd1 net392 sky130_fd_sc_hd__dlygate4sd3_1
Xhold60 LE_0B.config_data\[13\] vssd1 vssd1 vccd1 vccd1 net370 sky130_fd_sc_hd__dlygate4sd3_1
XFILLER_45_81 vssd1 vssd1 vccd1 vccd1 sky130_fd_sc_hd__fill_2
XFILLER_43_161 vssd1 vssd1 vccd1 vccd1 sky130_fd_sc_hd__fill_1
XANTENNA_2 CBeast_in[12] vssd1 vssd1 vccd1 vccd1 sky130_fd_sc_hd__diode_2
X_2691_ _1318_ vssd1 vssd1 vccd1 vccd1 _1319_ sky130_fd_sc_hd__inv_2
XFILLER_6_53 vssd1 vssd1 vccd1 vccd1 sky130_fd_sc_hd__fill_1
X_1711_ LE_1A.config_data\[16\] vssd1 vssd1 vccd1 vccd1 _1593_ sky130_fd_sc_hd__inv_2
X_2760_ _1306_ _1385_ _1387_ _1342_ vssd1 vssd1 vccd1 vccd1 _1388_ sky130_fd_sc_hd__o211a_1
X_1642_ SB0.route_sel\[40\] vssd1 vssd1 vccd1 vccd1 _1524_ sky130_fd_sc_hd__inv_2
X_3312_ clknet_leaf_14_clk _0008_ net255 vssd1 vssd1 vccd1 vccd1 LEI0.config_data\[7\]
+ sky130_fd_sc_hd__dfrtp_1
X_3243_ CB_0.config_dataB\[9\] CB_0.config_dataB\[8\] net289 vssd1 vssd1 vccd1 vccd1
+ _0303_ sky130_fd_sc_hd__mux2_1
X_2125_ net197 _0581_ vssd1 vssd1 vccd1 vccd1 _0759_ sky130_fd_sc_hd__nand2_1
XFILLER_41_109 vssd1 vssd1 vccd1 vccd1 sky130_fd_sc_hd__fill_2
XFILLER_26_139 vssd1 vssd1 vccd1 vccd1 sky130_fd_sc_hd__fill_1
X_2056_ SB0.route_sel\[18\] SB0.route_sel\[19\] _0689_ _0676_ vssd1 vssd1 vccd1 vccd1
+ _0690_ sky130_fd_sc_hd__a31oi_1
X_3174_ SB0.route_sel\[93\] SB0.route_sel\[92\] net269 vssd1 vssd1 vccd1 vccd1 _0234_
+ sky130_fd_sc_hd__mux2_1
X_2958_ net389 net372 net301 vssd1 vssd1 vccd1 vccd1 _0018_ sky130_fd_sc_hd__mux2_1
X_1909_ _0425_ _0482_ net31 vssd1 vssd1 vccd1 vccd1 _0543_ sky130_fd_sc_hd__a21o_1
XTAP_TAPCELL_ROW_32_373 vssd1 vccd1 sky130_fd_sc_hd__tapvpwrvgnd_1
X_2889_ SB0.route_sel\[43\] _1521_ vssd1 vssd1 vccd1 vccd1 _1460_ sky130_fd_sc_hd__nand2_1
XFILLER_49_209 vssd1 vssd1 vccd1 vccd1 sky130_fd_sc_hd__fill_4
XFILLER_17_139 vssd1 vssd1 vccd1 vccd1 sky130_fd_sc_hd__fill_2
Xoutput94 net94 vssd1 vssd1 vccd1 vccd1 CBnorth_out[1] sky130_fd_sc_hd__buf_2
Xoutput72 net72 vssd1 vssd1 vccd1 vccd1 CBeast_out[10] sky130_fd_sc_hd__buf_2
Xoutput83 net83 vssd1 vssd1 vccd1 vccd1 CBeast_out[6] sky130_fd_sc_hd__buf_2
XTAP_TAPCELL_ROW_46_465 vssd1 vccd1 sky130_fd_sc_hd__tapvpwrvgnd_1
X_2743_ net153 net149 net145 net140 LEI0.config_data\[45\] LEI0.config_data\[46\]
+ vssd1 vssd1 vccd1 vccd1 _1371_ sky130_fd_sc_hd__mux4_1
X_2812_ _0399_ _1413_ _0400_ vssd1 vssd1 vccd1 vccd1 net77 sky130_fd_sc_hd__a21oi_1
XFILLER_31_164 vssd1 vssd1 vccd1 vccd1 sky130_fd_sc_hd__fill_1
X_2674_ _1595_ _1282_ _1285_ _1289_ _1597_ vssd1 vssd1 vccd1 vccd1 _1302_ sky130_fd_sc_hd__o41a_1
X_1625_ SB0.route_sel\[9\] vssd1 vssd1 vccd1 vccd1 _1507_ sky130_fd_sc_hd__inv_2
X_3226_ CB_0.config_dataA\[17\] CB_0.config_dataA\[16\] net302 vssd1 vssd1 vccd1 vccd1
+ _0286_ sky130_fd_sc_hd__mux2_1
Xfanout306 net307 vssd1 vssd1 vccd1 vccd1 net306 sky130_fd_sc_hd__clkbuf_4
X_3157_ SB0.route_sel\[76\] SB0.route_sel\[75\] net272 vssd1 vssd1 vccd1 vccd1 _0217_
+ sky130_fd_sc_hd__mux2_1
X_2108_ net197 _0385_ vssd1 vssd1 vccd1 vccd1 _0742_ sky130_fd_sc_hd__or2_1
XFILLER_52_27 vssd1 vssd1 vccd1 vccd1 sky130_fd_sc_hd__fill_1
X_3088_ SB0.route_sel\[7\] SB0.route_sel\[6\] net266 vssd1 vssd1 vccd1 vccd1 _0148_
+ sky130_fd_sc_hd__mux2_1
X_2039_ SB0.route_sel\[27\] SB0.route_sel\[26\] vssd1 vssd1 vccd1 vccd1 _0673_ sky130_fd_sc_hd__nor2_1
XFILLER_10_326 vssd1 vssd1 vccd1 vccd1 sky130_fd_sc_hd__fill_2
XFILLER_22_153 vccd1 vssd1 vccd1 vssd1 sky130_ef_sc_hd__decap_40_12
XFILLER_22_197 vssd1 vssd1 vccd1 vccd1 sky130_fd_sc_hd__fill_4
XFILLER_45_234 vccd1 vssd1 vccd1 vssd1 sky130_ef_sc_hd__decap_40_12
XTAP_TAPCELL_ROW_43_446 vssd1 vccd1 sky130_fd_sc_hd__tapvpwrvgnd_1
XFILLER_26_94 vssd1 vssd1 vccd1 vccd1 sky130_fd_sc_hd__fill_4
XFILLER_13_197 vssd1 vssd1 vccd1 vccd1 sky130_fd_sc_hd__fill_4
XFILLER_54_7 vssd1 vssd1 vccd1 vccd1 sky130_fd_sc_hd__fill_1
X_2390_ LE_0B.config_data\[13\] _0905_ vssd1 vssd1 vccd1 vccd1 _1022_ sky130_fd_sc_hd__and2_1
X_3011_ LE_0B.dff0_out _1026_ net68 vssd1 vssd1 vccd1 vccd1 _0071_ sky130_fd_sc_hd__mux2_1
XFILLER_3_54 vssd1 vssd1 vccd1 vccd1 sky130_fd_sc_hd__fill_2
XFILLER_51_204 vccd1 vssd1 vccd1 vssd1 sky130_ef_sc_hd__decap_40_12
XFILLER_36_278 vssd1 vssd1 vccd1 vccd1 sky130_fd_sc_hd__fill_1
XFILLER_36_212 vssd1 vssd1 vccd1 vccd1 sky130_fd_sc_hd__fill_1
X_2726_ net204 _1096_ vssd1 vssd1 vccd1 vccd1 _1354_ sky130_fd_sc_hd__or2_1
Xfanout147 net148 vssd1 vssd1 vccd1 vccd1 net147 sky130_fd_sc_hd__clkbuf_2
X_2588_ CB_1.config_dataA\[18\] _1592_ CB_1.config_dataA\[19\] _1194_ vssd1 vssd1
+ vccd1 vccd1 _1218_ sky130_fd_sc_hd__and4b_1
X_2657_ _1283_ _1284_ _1596_ vssd1 vssd1 vccd1 vccd1 _1285_ sky130_fd_sc_hd__mux2_1
X_3209_ net201 net412 net300 vssd1 vssd1 vccd1 vccd1 _0269_ sky130_fd_sc_hd__mux2_1
Xfanout169 CB_1.config_dataA\[15\] vssd1 vssd1 vccd1 vccd1 net169 sky130_fd_sc_hd__clkbuf_2
Xfanout158 _0469_ vssd1 vssd1 vccd1 vccd1 net158 sky130_fd_sc_hd__buf_2
XFILLER_42_248 vssd1 vssd1 vccd1 vccd1 sky130_fd_sc_hd__fill_1
XTAP_TAPCELL_ROW_40_427 vssd1 vccd1 sky130_fd_sc_hd__tapvpwrvgnd_1
XFILLER_6_138 vssd1 vssd1 vccd1 vccd1 sky130_fd_sc_hd__fill_2
XFILLER_12_41 vssd1 vssd1 vccd1 vccd1 sky130_fd_sc_hd__fill_1
XFILLER_12_63 vssd1 vssd1 vccd1 vccd1 sky130_fd_sc_hd__fill_2
XFILLER_12_85 vssd1 vssd1 vccd1 vccd1 sky130_fd_sc_hd__fill_1
XTAP_TAPCELL_ROW_5_182 vssd1 vccd1 sky130_fd_sc_hd__tapvpwrvgnd_1
XFILLER_37_93 vssd1 vssd1 vccd1 vccd1 sky130_fd_sc_hd__fill_4
XPHY_EDGE_ROW_16_Right_16 vssd1 vssd1 vccd1 vccd1 sky130_fd_sc_hd__decap_3
X_3560_ clknet_leaf_19_clk _0256_ net248 vssd1 vssd1 vccd1 vccd1 SB0.route_sel\[115\]
+ sky130_fd_sc_hd__dfstp_1
XFILLER_41_281 vssd1 vssd1 vccd1 vccd1 sky130_fd_sc_hd__fill_4
X_1890_ net146 net159 _0483_ _0480_ _0451_ vssd1 vssd1 vccd1 vccd1 _0524_ sky130_fd_sc_hd__o32a_1
XPHY_EDGE_ROW_25_Right_25 vssd1 vssd1 vccd1 vccd1 sky130_fd_sc_hd__decap_3
X_2373_ net22 net23 net181 vssd1 vssd1 vccd1 vccd1 _1005_ sky130_fd_sc_hd__mux2_1
XFILLER_45_3 vssd1 vssd1 vccd1 vccd1 sky130_fd_sc_hd__fill_2
X_2511_ _1100_ _1116_ _1118_ _1103_ CB_1.config_dataA\[7\] vssd1 vssd1 vccd1 vccd1
+ _1141_ sky130_fd_sc_hd__a221o_1
X_2442_ net177 _1071_ vssd1 vssd1 vccd1 vccd1 _1072_ sky130_fd_sc_hd__nand2_1
X_3491_ clknet_leaf_31_clk _0187_ net223 vssd1 vssd1 vccd1 vccd1 SB0.route_sel\[46\]
+ sky130_fd_sc_hd__dfstp_1
XPHY_EDGE_ROW_34_Right_34 vssd1 vssd1 vccd1 vccd1 sky130_fd_sc_hd__decap_3
XPHY_EDGE_ROW_49_Left_117 vssd1 vssd1 vccd1 vccd1 sky130_fd_sc_hd__decap_3
XFILLER_24_226 vssd1 vssd1 vccd1 vccd1 sky130_fd_sc_hd__fill_1
XPHY_EDGE_ROW_43_Right_43 vssd1 vssd1 vccd1 vccd1 sky130_fd_sc_hd__decap_3
X_2709_ _1335_ _1336_ _1328_ _1333_ vssd1 vssd1 vccd1 vccd1 _1337_ sky130_fd_sc_hd__o211a_1
XFILLER_59_167 vssd1 vssd1 vccd1 vccd1 sky130_fd_sc_hd__fill_1
XFILLER_59_156 vssd1 vssd1 vccd1 vccd1 sky130_fd_sc_hd__fill_1
XPHY_EDGE_ROW_58_Left_126 vssd1 vssd1 vccd1 vccd1 sky130_fd_sc_hd__decap_3
XPHY_EDGE_ROW_52_Right_52 vssd1 vssd1 vccd1 vccd1 sky130_fd_sc_hd__decap_3
XTAP_TAPCELL_ROW_2_163 vssd1 vccd1 sky130_fd_sc_hd__tapvpwrvgnd_1
XPHY_EDGE_ROW_67_Left_135 vssd1 vssd1 vccd1 vccd1 sky130_fd_sc_hd__decap_3
XPHY_EDGE_ROW_61_Right_61 vssd1 vssd1 vccd1 vccd1 sky130_fd_sc_hd__decap_3
XFILLER_23_281 vssd1 vssd1 vccd1 vccd1 sky130_fd_sc_hd__fill_2
XFILLER_2_141 vssd1 vssd1 vccd1 vccd1 sky130_fd_sc_hd__fill_1
XFILLER_0_11 vssd1 vssd1 vccd1 vccd1 sky130_fd_sc_hd__fill_1
X_2991_ net376 net65 net293 vssd1 vssd1 vccd1 vccd1 _0051_ sky130_fd_sc_hd__mux2_1
XFILLER_61_310 vssd1 vssd1 vccd1 vccd1 sky130_fd_sc_hd__fill_2
X_1942_ _0569_ _0573_ _0574_ _0575_ vssd1 vssd1 vccd1 vccd1 _0576_ sky130_fd_sc_hd__a31o_1
X_3612_ clknet_leaf_7_clk _0308_ net232 vssd1 vssd1 vccd1 vccd1 CB_0.config_dataB\[14\]
+ sky130_fd_sc_hd__dfstp_1
X_3543_ clknet_leaf_3_clk _0239_ net225 vssd1 vssd1 vccd1 vccd1 SB0.route_sel\[98\]
+ sky130_fd_sc_hd__dfstp_1
X_1873_ SB0.route_sel\[83\] SB0.route_sel\[82\] _0506_ _0493_ vssd1 vssd1 vccd1 vccd1
+ _0507_ sky130_fd_sc_hd__a31oi_1
X_2356_ _0983_ _0987_ CB_0.config_dataB\[17\] vssd1 vssd1 vccd1 vccd1 _0988_ sky130_fd_sc_hd__o21ai_1
X_2425_ net177 _1054_ vssd1 vssd1 vccd1 vccd1 _1055_ sky130_fd_sc_hd__nand2_1
X_3474_ clknet_leaf_32_clk _0170_ net222 vssd1 vssd1 vccd1 vccd1 SB0.route_sel\[29\]
+ sky130_fd_sc_hd__dfstp_1
XTAP_TAPCELL_ROW_67_622 vssd1 vccd1 sky130_fd_sc_hd__tapvpwrvgnd_1
X_2287_ net17 net24 net25 net26 CB_0.config_dataB\[5\] CB_0.config_dataB\[6\] vssd1
+ vssd1 vccd1 vccd1 _0919_ sky130_fd_sc_hd__mux4_1
XFILLER_37_373 vssd1 vssd1 vccd1 vccd1 sky130_fd_sc_hd__fill_1
XFILLER_12_218 vssd1 vssd1 vccd1 vccd1 sky130_fd_sc_hd__fill_4
XFILLER_55_181 vssd1 vssd1 vccd1 vccd1 sky130_fd_sc_hd__fill_8
XTAP_TAPCELL_ROW_13_235 vssd1 vccd1 sky130_fd_sc_hd__tapvpwrvgnd_1
XTAP_TAPCELL_ROW_21_290 vssd1 vccd1 sky130_fd_sc_hd__tapvpwrvgnd_1
X_2210_ net27 net28 net29 net30 net192 net190 vssd1 vssd1 vccd1 vccd1 _0844_ sky130_fd_sc_hd__mux4_1
X_3190_ SB0.route_sel\[109\] SB0.route_sel\[108\] net296 vssd1 vssd1 vccd1 vccd1 _0250_
+ sky130_fd_sc_hd__mux2_1
X_2141_ LEI0.config_data\[12\] net139 vssd1 vssd1 vccd1 vccd1 _0775_ sky130_fd_sc_hd__nand2_1
X_2072_ _0450_ _0662_ vssd1 vssd1 vccd1 vccd1 _0706_ sky130_fd_sc_hd__nand2_1
XFILLER_46_170 vssd1 vssd1 vccd1 vccd1 sky130_fd_sc_hd__fill_4
XFILLER_38_159 vccd1 vssd1 vccd1 vssd1 sky130_ef_sc_hd__decap_40_12
XFILLER_38_115 vssd1 vssd1 vccd1 vccd1 sky130_fd_sc_hd__fill_4
X_2974_ LEI0.config_data\[33\] net410 net306 vssd1 vssd1 vccd1 vccd1 _0034_ sky130_fd_sc_hd__mux2_1
XFILLER_34_365 vssd1 vssd1 vccd1 vccd1 sky130_fd_sc_hd__fill_2
X_1925_ net141 net162 _0556_ vssd1 vssd1 vccd1 vccd1 _0559_ sky130_fd_sc_hd__or3_1
X_1787_ SB0.route_sel\[98\] SB0.route_sel\[99\] _0420_ _1559_ vssd1 vssd1 vccd1 vccd1
+ _0421_ sky130_fd_sc_hd__a31o_1
X_3526_ clknet_leaf_1_clk _0222_ net220 vssd1 vssd1 vccd1 vccd1 SB0.route_sel\[81\]
+ sky130_fd_sc_hd__dfstp_1
X_1856_ SB0.route_sel\[94\] SB0.route_sel\[95\] vssd1 vssd1 vccd1 vccd1 _0490_ sky130_fd_sc_hd__nand2b_1
X_2339_ LEI0.config_data\[28\] _0970_ vssd1 vssd1 vccd1 vccd1 _0971_ sky130_fd_sc_hd__nor2_1
X_3388_ clknet_leaf_5_clk _0084_ net227 vssd1 vssd1 vccd1 vccd1 LE_0B.config_data\[11\]
+ sky130_fd_sc_hd__dfrtp_1
X_2408_ _1037_ _0432_ vssd1 vssd1 vccd1 vccd1 _1038_ sky130_fd_sc_hd__and2b_4
XFILLER_29_137 vssd1 vssd1 vccd1 vccd1 sky130_fd_sc_hd__fill_4
XFILLER_29_115 vssd1 vssd1 vccd1 vccd1 sky130_fd_sc_hd__fill_1
XPHY_EDGE_ROW_2_Right_2 vssd1 vssd1 vccd1 vccd1 sky130_fd_sc_hd__decap_3
X_3457_ clknet_leaf_34_clk _0153_ net216 vssd1 vssd1 vccd1 vccd1 SB0.route_sel\[12\]
+ sky130_fd_sc_hd__dfstp_1
XFILLER_40_302 vssd1 vssd1 vccd1 vccd1 sky130_fd_sc_hd__fill_2
XTAP_TAPCELL_ROW_27_338 vssd1 vccd1 sky130_fd_sc_hd__tapvpwrvgnd_1
XTAP_TAPCELL_ROW_35_393 vssd1 vccd1 sky130_fd_sc_hd__tapvpwrvgnd_1
XTAP_TAPCELL_ROW_10_216 vssd1 vccd1 sky130_fd_sc_hd__tapvpwrvgnd_1
Xhold83 LEI0.config_data\[25\] vssd1 vssd1 vccd1 vccd1 net393 sky130_fd_sc_hd__dlygate4sd3_1
Xhold72 LEI0.config_data\[1\] vssd1 vssd1 vccd1 vccd1 net382 sky130_fd_sc_hd__dlygate4sd3_1
XFILLER_35_107 vssd1 vssd1 vccd1 vccd1 sky130_fd_sc_hd__fill_4
Xhold61 _0086_ vssd1 vssd1 vccd1 vccd1 net371 sky130_fd_sc_hd__dlygate4sd3_1
Xhold50 LE_1B.config_data\[8\] vssd1 vssd1 vccd1 vccd1 net360 sky130_fd_sc_hd__dlygate4sd3_1
Xhold94 LE_1A.config_data\[15\] vssd1 vssd1 vccd1 vccd1 net404 sky130_fd_sc_hd__dlygate4sd3_1
XFILLER_43_151 vssd1 vssd1 vccd1 vccd1 sky130_fd_sc_hd__fill_8
XFILLER_31_346 vssd1 vssd1 vccd1 vccd1 sky130_fd_sc_hd__fill_4
XFILLER_31_335 vssd1 vssd1 vccd1 vccd1 sky130_fd_sc_hd__fill_1
XANTENNA_3 CBeast_in[13] vssd1 vssd1 vccd1 vccd1 sky130_fd_sc_hd__diode_2
X_3311_ clknet_leaf_14_clk _0007_ net255 vssd1 vssd1 vccd1 vccd1 LEI0.config_data\[6\]
+ sky130_fd_sc_hd__dfrtp_1
X_1710_ CB_1.config_dataA\[17\] vssd1 vssd1 vccd1 vccd1 _1592_ sky130_fd_sc_hd__inv_2
X_2690_ _1316_ _1317_ _1598_ vssd1 vssd1 vccd1 vccd1 _1318_ sky130_fd_sc_hd__mux2_1
X_1641_ SB0.route_sel\[41\] vssd1 vssd1 vccd1 vccd1 _1523_ sky130_fd_sc_hd__inv_2
X_2124_ CB_0.config_dataA\[8\] _0748_ _0752_ _0757_ vssd1 vssd1 vccd1 vccd1 _0758_
+ sky130_fd_sc_hd__and4_1
X_3242_ CB_0.config_dataB\[8\] CB_0.config_dataB\[7\] net289 vssd1 vssd1 vccd1 vccd1
+ _0302_ sky130_fd_sc_hd__mux2_1
X_3173_ SB0.route_sel\[92\] SB0.route_sel\[91\] net269 vssd1 vssd1 vccd1 vccd1 _0233_
+ sky130_fd_sc_hd__mux2_1
XFILLER_34_162 vssd1 vssd1 vccd1 vccd1 sky130_fd_sc_hd__fill_1
X_2055_ SB0.route_sel\[20\] SB0.route_sel\[21\] net57 _0688_ _0687_ vssd1 vssd1 vccd1
+ vccd1 _0689_ sky130_fd_sc_hd__a41o_1
X_2957_ net372 LEI0.config_data\[15\] net301 vssd1 vssd1 vccd1 vccd1 _0017_ sky130_fd_sc_hd__mux2_1
X_1908_ net146 _0426_ _0483_ _0480_ _0423_ vssd1 vssd1 vccd1 vccd1 _0542_ sky130_fd_sc_hd__o32a_1
XFILLER_34_195 vssd1 vssd1 vccd1 vccd1 sky130_fd_sc_hd__fill_1
X_1839_ _0471_ net143 _0397_ vssd1 vssd1 vccd1 vccd1 _0473_ sky130_fd_sc_hd__and3b_1
X_2888_ _1459_ _0641_ vssd1 vssd1 vccd1 vccd1 net130 sky130_fd_sc_hd__and2b_1
X_3509_ clknet_leaf_2_clk _0205_ net225 vssd1 vssd1 vccd1 vccd1 SB0.route_sel\[64\]
+ sky130_fd_sc_hd__dfstp_1
XFILLER_13_335 vssd1 vssd1 vccd1 vccd1 sky130_fd_sc_hd__fill_1
Xoutput95 net95 vssd1 vssd1 vccd1 vccd1 CBnorth_out[2] sky130_fd_sc_hd__buf_2
Xoutput73 net73 vssd1 vssd1 vccd1 vccd1 CBeast_out[11] sky130_fd_sc_hd__buf_2
Xoutput84 net84 vssd1 vssd1 vccd1 vccd1 CBeast_out[7] sky130_fd_sc_hd__buf_2
XFILLER_63_279 vssd1 vssd1 vccd1 vccd1 sky130_fd_sc_hd__fill_1
XTAP_TAPCELL_ROW_46_466 vssd1 vccd1 sky130_fd_sc_hd__tapvpwrvgnd_1
XFILLER_31_110 vssd1 vssd1 vccd1 vccd1 sky130_fd_sc_hd__fill_2
Xclkbuf_leaf_28_clk clknet_2_2__leaf_clk vssd1 vssd1 vccd1 vccd1 clknet_leaf_28_clk
+ sky130_fd_sc_hd__clkbuf_8
X_2811_ net165 _0395_ _1034_ vssd1 vssd1 vccd1 vccd1 _1413_ sky130_fd_sc_hd__o21ai_1
X_2742_ CB_1.config_dataB\[18\] _1347_ CB_1.config_dataB\[17\] CB_1.config_dataB\[19\]
+ vssd1 vssd1 vccd1 vccd1 _1370_ sky130_fd_sc_hd__or4b_1
Xfanout307 net308 vssd1 vssd1 vccd1 vccd1 net307 sky130_fd_sc_hd__clkbuf_4
X_1624_ SB0.route_sel\[14\] vssd1 vssd1 vccd1 vccd1 _1506_ sky130_fd_sc_hd__inv_2
X_2673_ _1299_ _1300_ _1293_ _1297_ vssd1 vssd1 vccd1 vccd1 _1301_ sky130_fd_sc_hd__o211ai_2
X_3225_ CB_0.config_dataA\[16\] CB_0.config_dataA\[15\] net302 vssd1 vssd1 vccd1 vccd1
+ _0285_ sky130_fd_sc_hd__mux2_1
X_2107_ _0736_ _0740_ vssd1 vssd1 vccd1 vccd1 _0741_ sky130_fd_sc_hd__nand2_2
Xclkbuf_leaf_19_clk clknet_2_3__leaf_clk vssd1 vssd1 vccd1 vccd1 clknet_leaf_19_clk
+ sky130_fd_sc_hd__clkbuf_8
X_3087_ SB0.route_sel\[6\] SB0.route_sel\[5\] net266 vssd1 vssd1 vccd1 vccd1 _0147_
+ sky130_fd_sc_hd__mux2_1
X_3156_ SB0.route_sel\[75\] SB0.route_sel\[74\] net272 vssd1 vssd1 vccd1 vccd1 _0216_
+ sky130_fd_sc_hd__mux2_1
X_2038_ _0659_ _0661_ _0671_ _1502_ vssd1 vssd1 vccd1 vccd1 _0672_ sky130_fd_sc_hd__o211a_2
XFILLER_22_165 vccd1 vssd1 vccd1 vssd1 sky130_ef_sc_hd__decap_40_12
XFILLER_45_279 vssd1 vssd1 vccd1 vccd1 sky130_fd_sc_hd__fill_1
XTAP_TAPCELL_ROW_43_447 vssd1 vccd1 sky130_fd_sc_hd__tapvpwrvgnd_1
XFILLER_9_158 vssd1 vssd1 vccd1 vccd1 sky130_fd_sc_hd__fill_8
X_3010_ LE_0A.reset_mode LE_0A.reset_val net276 vssd1 vssd1 vccd1 vccd1 _0070_ sky130_fd_sc_hd__mux2_1
XFILLER_51_216 vssd1 vssd1 vccd1 vccd1 sky130_fd_sc_hd__fill_2
Xclkbuf_leaf_8_clk clknet_2_1__leaf_clk vssd1 vssd1 vccd1 vccd1 clknet_leaf_8_clk
+ sky130_fd_sc_hd__clkbuf_8
X_2725_ net203 _1092_ vssd1 vssd1 vccd1 vccd1 _1353_ sky130_fd_sc_hd__nand2_1
X_2656_ net15 net16 net2 net3 net210 CB_1.config_dataB\[6\] vssd1 vssd1 vccd1 vccd1
+ _1284_ sky130_fd_sc_hd__mux4_1
Xfanout159 _0453_ vssd1 vssd1 vccd1 vccd1 net159 sky130_fd_sc_hd__buf_2
Xfanout148 CB_0.le_outB vssd1 vssd1 vccd1 vccd1 net148 sky130_fd_sc_hd__buf_2
X_2587_ _1209_ _1212_ _1216_ CB_1.config_dataA\[18\] vssd1 vssd1 vccd1 vccd1 _1217_
+ sky130_fd_sc_hd__and4bb_1
XFILLER_67_371 vssd1 vssd1 vccd1 vccd1 sky130_fd_sc_hd__fill_1
XFILLER_42_216 vssd1 vssd1 vccd1 vccd1 sky130_fd_sc_hd__fill_1
X_3208_ net135 SB0.route_sel\[126\] net298 vssd1 vssd1 vccd1 vccd1 _0268_ sky130_fd_sc_hd__mux2_1
XFILLER_27_279 vssd1 vssd1 vccd1 vccd1 sky130_fd_sc_hd__fill_1
XFILLER_27_213 vssd1 vssd1 vccd1 vccd1 sky130_fd_sc_hd__fill_4
X_3139_ SB0.route_sel\[58\] SB0.route_sel\[57\] net273 vssd1 vssd1 vccd1 vccd1 _0199_
+ sky130_fd_sc_hd__mux2_1
XFILLER_42_238 vssd1 vssd1 vccd1 vccd1 sky130_fd_sc_hd__fill_1
XTAP_TAPCELL_ROW_40_428 vssd1 vccd1 sky130_fd_sc_hd__tapvpwrvgnd_1
XTAP_TAPCELL_ROW_5_183 vssd1 vccd1 sky130_fd_sc_hd__tapvpwrvgnd_1
XFILLER_41_260 vssd1 vssd1 vccd1 vccd1 sky130_fd_sc_hd__fill_1
XFILLER_53_93 vssd1 vssd1 vccd1 vccd1 sky130_fd_sc_hd__fill_1
X_2510_ net174 _1096_ vssd1 vssd1 vccd1 vccd1 _1140_ sky130_fd_sc_hd__or2_1
X_3490_ clknet_leaf_31_clk _0186_ net223 vssd1 vssd1 vccd1 vccd1 SB0.route_sel\[45\]
+ sky130_fd_sc_hd__dfstp_1
X_2372_ net21 _0984_ _0986_ net20 _1583_ vssd1 vssd1 vccd1 vccd1 _1004_ sky130_fd_sc_hd__a221o_1
X_2441_ _0566_ _0577_ _1070_ vssd1 vssd1 vccd1 vccd1 _1071_ sky130_fd_sc_hd__and3_4
XFILLER_64_363 vssd1 vssd1 vccd1 vccd1 sky130_fd_sc_hd__fill_1
XFILLER_32_282 vssd1 vssd1 vccd1 vccd1 sky130_fd_sc_hd__fill_1
X_2639_ _1245_ _1249_ _1253_ CB_1.config_dataB\[4\] vssd1 vssd1 vccd1 vccd1 _1267_
+ sky130_fd_sc_hd__a31o_2
X_2708_ _1100_ _1310_ _1312_ _1103_ CB_1.config_dataB\[12\] vssd1 vssd1 vccd1 vccd1
+ _1336_ sky130_fd_sc_hd__a221o_1
XFILLER_59_113 vssd1 vssd1 vccd1 vccd1 sky130_fd_sc_hd__fill_2
XTAP_TAPCELL_ROW_53_520 vssd1 vccd1 sky130_fd_sc_hd__tapvpwrvgnd_1
XFILLER_15_205 vssd1 vssd1 vccd1 vccd1 sky130_fd_sc_hd__fill_1
XFILLER_23_74 vssd1 vssd1 vccd1 vccd1 sky130_fd_sc_hd__fill_1
XFILLER_23_96 vccd1 vssd1 vccd1 vssd1 sky130_ef_sc_hd__decap_40_12
XFILLER_38_319 vccd1 vssd1 vccd1 vssd1 sky130_ef_sc_hd__decap_40_12
X_1872_ SB0.route_sel\[84\] SB0.route_sel\[85\] net50 _0505_ _0504_ vssd1 vssd1 vccd1
+ vccd1 _0506_ sky130_fd_sc_hd__a41o_1
X_2990_ LE_0B.dff1_out _1026_ net68 vssd1 vssd1 vccd1 vccd1 _0050_ sky130_fd_sc_hd__mux2_1
XTAP_TAPCELL_ROW_16_255 vssd1 vccd1 sky130_fd_sc_hd__tapvpwrvgnd_1
X_1941_ net155 _0387_ _0567_ SB0.route_sel\[56\] SB0.route_sel\[57\] vssd1 vssd1 vccd1
+ vccd1 _0575_ sky130_fd_sc_hd__a32o_1
XFILLER_21_208 vccd1 vssd1 vccd1 vssd1 sky130_ef_sc_hd__decap_40_12
X_3611_ clknet_leaf_7_clk _0307_ net232 vssd1 vssd1 vccd1 vccd1 CB_0.config_dataB\[13\]
+ sky130_fd_sc_hd__dfstp_1
X_3542_ clknet_leaf_4_clk _0238_ net229 vssd1 vssd1 vccd1 vccd1 SB0.route_sel\[97\]
+ sky130_fd_sc_hd__dfstp_1
X_3473_ clknet_leaf_32_clk _0169_ net222 vssd1 vssd1 vccd1 vccd1 SB0.route_sel\[28\]
+ sky130_fd_sc_hd__dfstp_1
XTAP_TAPCELL_ROW_67_623 vssd1 vccd1 sky130_fd_sc_hd__tapvpwrvgnd_1
XTAP_TAPCELL_ROW_67_612 vssd1 vccd1 sky130_fd_sc_hd__tapvpwrvgnd_1
X_2355_ _0645_ _0985_ _0986_ _0626_ vssd1 vssd1 vccd1 vccd1 _0987_ sky130_fd_sc_hd__a2bb2o_1
X_2286_ _0715_ _0907_ _0915_ _0916_ _0917_ vssd1 vssd1 vccd1 vccd1 _0918_ sky130_fd_sc_hd__o221a_1
XFILLER_29_319 vccd1 vssd1 vccd1 vssd1 sky130_ef_sc_hd__decap_40_12
X_2424_ _0489_ _1053_ vssd1 vssd1 vccd1 vccd1 _1054_ sky130_fd_sc_hd__nor2_4
XFILLER_44_29 vssd1 vssd1 vccd1 vccd1 sky130_fd_sc_hd__fill_4
XFILLER_37_363 vssd1 vssd1 vccd1 vccd1 sky130_fd_sc_hd__fill_8
XFILLER_37_330 vssd1 vssd1 vccd1 vccd1 sky130_fd_sc_hd__fill_4
XFILLER_34_40 vssd1 vssd1 vccd1 vccd1 sky130_fd_sc_hd__fill_1
XTAP_TAPCELL_ROW_13_236 vssd1 vccd1 sky130_fd_sc_hd__tapvpwrvgnd_1
XFILLER_50_83 vssd1 vssd1 vccd1 vccd1 sky130_fd_sc_hd__fill_1
XFILLER_7_223 vssd1 vssd1 vccd1 vccd1 sky130_fd_sc_hd__fill_1
XTAP_TAPCELL_ROW_21_291 vssd1 vccd1 sky130_fd_sc_hd__tapvpwrvgnd_1
X_2140_ LEI0.config_data\[13\] _0773_ vssd1 vssd1 vccd1 vccd1 _0774_ sky130_fd_sc_hd__nor2_1
XFILLER_38_127 vccd1 vssd1 vccd1 vssd1 sky130_ef_sc_hd__decap_40_12
XFILLER_53_119 vssd1 vssd1 vccd1 vccd1 sky130_fd_sc_hd__fill_1
X_2071_ SB0.route_sel\[11\] SB0.route_sel\[10\] _0704_ _1508_ vssd1 vssd1 vccd1 vccd1
+ _0705_ sky130_fd_sc_hd__a31o_1
X_2973_ net410 LEI0.config_data\[31\] net306 vssd1 vssd1 vccd1 vccd1 _0033_ sky130_fd_sc_hd__mux2_1
X_1855_ SB0.route_sel\[89\] _0477_ _0478_ _0488_ net274 vssd1 vssd1 vccd1 vccd1 _0489_
+ sky130_fd_sc_hd__a311o_4
X_1924_ net162 _0556_ net14 vssd1 vssd1 vccd1 vccd1 _0558_ sky130_fd_sc_hd__o21bai_1
X_1786_ SB0.route_sel\[100\] SB0.route_sel\[101\] net52 _0419_ _0418_ vssd1 vssd1
+ vccd1 vccd1 _0420_ sky130_fd_sc_hd__a41o_1
X_3525_ clknet_leaf_2_clk _0221_ net220 vssd1 vssd1 vccd1 vccd1 SB0.route_sel\[80\]
+ sky130_fd_sc_hd__dfstp_1
X_3456_ clknet_leaf_32_clk _0152_ net216 vssd1 vssd1 vccd1 vccd1 SB0.route_sel\[11\]
+ sky130_fd_sc_hd__dfstp_1
X_2338_ net153 net149 LEI0.config_data\[27\] vssd1 vssd1 vccd1 vccd1 _0970_ sky130_fd_sc_hd__mux2_1
X_2269_ LEI0.config_data\[4\] _0900_ vssd1 vssd1 vccd1 vccd1 _0901_ sky130_fd_sc_hd__nor2_1
X_3387_ clknet_leaf_5_clk _0083_ net228 vssd1 vssd1 vccd1 vccd1 LE_0B.config_data\[10\]
+ sky130_fd_sc_hd__dfrtp_1
X_2407_ SB0.route_sel\[103\] _1557_ SB0.route_sel\[96\] _1559_ _1036_ vssd1 vssd1
+ vccd1 vccd1 _1037_ sky130_fd_sc_hd__o221a_1
XFILLER_40_358 vssd1 vssd1 vccd1 vccd1 sky130_fd_sc_hd__fill_2
XTAP_TAPCELL_ROW_35_394 vssd1 vccd1 sky130_fd_sc_hd__tapvpwrvgnd_1
XTAP_TAPCELL_ROW_10_217 vssd1 vccd1 sky130_fd_sc_hd__tapvpwrvgnd_1
XFILLER_29_51 vssd1 vssd1 vccd1 vccd1 sky130_fd_sc_hd__fill_1
Xhold40 _0346_ vssd1 vssd1 vccd1 vccd1 net350 sky130_fd_sc_hd__dlygate4sd3_1
XFILLER_20_75 vssd1 vssd1 vccd1 vccd1 sky130_fd_sc_hd__fill_8
Xhold84 _0027_ vssd1 vssd1 vccd1 vccd1 net394 sky130_fd_sc_hd__dlygate4sd3_1
Xhold62 LEI0.config_data\[16\] vssd1 vssd1 vccd1 vccd1 net372 sky130_fd_sc_hd__dlygate4sd3_1
XFILLER_45_83 vssd1 vssd1 vccd1 vccd1 sky130_fd_sc_hd__fill_1
XFILLER_43_141 vssd1 vssd1 vccd1 vccd1 sky130_fd_sc_hd__fill_2
Xhold73 LE_1A.config_data\[8\] vssd1 vssd1 vccd1 vccd1 net383 sky130_fd_sc_hd__dlygate4sd3_1
Xhold51 LE_1A.config_data\[5\] vssd1 vssd1 vccd1 vccd1 net361 sky130_fd_sc_hd__dlygate4sd3_1
Xhold95 LE_1A.config_data\[12\] vssd1 vssd1 vccd1 vccd1 net405 sky130_fd_sc_hd__dlygate4sd3_1
XFILLER_43_185 vccd1 vssd1 vccd1 vssd1 sky130_ef_sc_hd__decap_40_12
X_3310_ clknet_leaf_14_clk net414 net252 vssd1 vssd1 vccd1 vccd1 LEI0.config_data\[5\]
+ sky130_fd_sc_hd__dfrtp_1
XANTENNA_4 CBeast_in[14] vssd1 vssd1 vccd1 vccd1 sky130_fd_sc_hd__diode_2
X_1640_ SB0.route_sel\[47\] vssd1 vssd1 vccd1 vccd1 _1522_ sky130_fd_sc_hd__inv_2
X_2123_ net196 _0753_ _0754_ _0756_ vssd1 vssd1 vccd1 vccd1 _0757_ sky130_fd_sc_hd__a31o_1
X_3241_ CB_0.config_dataB\[7\] CB_0.config_dataB\[6\] net289 vssd1 vssd1 vccd1 vccd1
+ _0301_ sky130_fd_sc_hd__mux2_1
XFILLER_26_119 vssd1 vssd1 vccd1 vccd1 sky130_fd_sc_hd__fill_8
X_3172_ SB0.route_sel\[91\] SB0.route_sel\[90\] net269 vssd1 vssd1 vccd1 vccd1 _0232_
+ sky130_fd_sc_hd__mux2_1
XTAP_TAPCELL_ROW_49_486 vssd1 vccd1 sky130_fd_sc_hd__tapvpwrvgnd_1
XFILLER_34_141 vccd1 vssd1 vccd1 vssd1 sky130_ef_sc_hd__decap_40_12
X_2054_ SB0.route_sel\[23\] SB0.route_sel\[22\] vssd1 vssd1 vccd1 vccd1 _0688_ sky130_fd_sc_hd__nand2_1
X_2956_ LEI0.config_data\[15\] net339 net301 vssd1 vssd1 vccd1 vccd1 _0016_ sky130_fd_sc_hd__mux2_1
X_1907_ _0422_ _0479_ vssd1 vssd1 vccd1 vccd1 _0541_ sky130_fd_sc_hd__nand2_1
X_1838_ _1604_ net162 net158 _0471_ _0398_ vssd1 vssd1 vccd1 vccd1 _0472_ sky130_fd_sc_hd__o32a_1
X_2887_ SB0.route_sel\[43\] _1521_ SB0.route_sel\[41\] SB0.route_sel\[40\] _1458_
+ vssd1 vssd1 vccd1 vccd1 _1459_ sky130_fd_sc_hd__o221a_1
X_1769_ net135 SB0.route_sel\[126\] vssd1 vssd1 vccd1 vccd1 _0403_ sky130_fd_sc_hd__nand2_1
X_3439_ clknet_leaf_20_clk _0135_ net241 vssd1 vssd1 vccd1 vccd1 CB_1.config_dataB\[19\]
+ sky130_fd_sc_hd__dfstp_1
XFILLER_1_229 vssd1 vssd1 vccd1 vccd1 sky130_fd_sc_hd__fill_1
X_3508_ clknet_leaf_2_clk _0204_ net225 vssd1 vssd1 vccd1 vccd1 SB0.route_sel\[63\]
+ sky130_fd_sc_hd__dfstp_1
XFILLER_13_314 vssd1 vssd1 vccd1 vccd1 sky130_fd_sc_hd__fill_1
Xoutput96 net96 vssd1 vssd1 vccd1 vccd1 CBnorth_out[3] sky130_fd_sc_hd__buf_2
Xoutput74 net74 vssd1 vssd1 vccd1 vccd1 CBeast_out[12] sky130_fd_sc_hd__buf_2
XFILLER_0_262 vssd1 vssd1 vccd1 vccd1 sky130_fd_sc_hd__fill_2
Xoutput85 net85 vssd1 vssd1 vccd1 vccd1 CBeast_out[8] sky130_fd_sc_hd__buf_2
XFILLER_56_93 vssd1 vssd1 vccd1 vccd1 sky130_fd_sc_hd__fill_1
XFILLER_56_82 vssd1 vssd1 vccd1 vccd1 sky130_fd_sc_hd__fill_2
XTAP_TAPCELL_ROW_46_467 vssd1 vccd1 sky130_fd_sc_hd__tapvpwrvgnd_1
X_2810_ net152 _1412_ _0724_ vssd1 vssd1 vccd1 vccd1 net87 sky130_fd_sc_hd__mux2_1
X_2741_ _1361_ _1364_ _1368_ CB_1.config_dataB\[18\] vssd1 vssd1 vccd1 vccd1 _1369_
+ sky130_fd_sc_hd__and4bb_1
XFILLER_31_177 vssd1 vssd1 vccd1 vccd1 sky130_fd_sc_hd__fill_1
X_2672_ _1103_ _1277_ _1279_ _1100_ CB_1.config_dataB\[7\] vssd1 vssd1 vccd1 vccd1
+ _1300_ sky130_fd_sc_hd__a221o_1
X_3224_ CB_0.config_dataA\[15\] CB_0.config_dataA\[14\] net302 vssd1 vssd1 vccd1 vccd1
+ _0284_ sky130_fd_sc_hd__mux2_1
Xfanout308 net309 vssd1 vssd1 vccd1 vccd1 net308 sky130_fd_sc_hd__clkbuf_2
X_1623_ SB0.route_sel\[15\] vssd1 vssd1 vccd1 vccd1 _1505_ sky130_fd_sc_hd__inv_2
.ends
