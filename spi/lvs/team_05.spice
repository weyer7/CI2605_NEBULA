* NGSPICE file created from team_05.ext - technology: sky130A

* Black-box entry subcircuit for sky130_fd_sc_hd__tapvpwrvgnd_1 abstract view
.subckt sky130_fd_sc_hd__tapvpwrvgnd_1 VGND VPWR
.ends

* Black-box entry subcircuit for sky130_fd_sc_hd__fill_1 abstract view
.subckt sky130_fd_sc_hd__fill_1 VGND VNB VPB VPWR
.ends

* Black-box entry subcircuit for sky130_fd_sc_hd__dfrtp_1 abstract view
.subckt sky130_fd_sc_hd__dfrtp_1 CLK D RESET_B VGND VNB VPB VPWR Q
.ends

* Black-box entry subcircuit for sky130_ef_sc_hd__decap_40_12 abstract view
.subckt sky130_ef_sc_hd__decap_40_12 VPWR VGND VPB VNB
.ends

* Black-box entry subcircuit for sky130_fd_sc_hd__a21o_1 abstract view
.subckt sky130_fd_sc_hd__a21o_1 A1 A2 B1 VGND VNB VPB VPWR X
.ends

* Black-box entry subcircuit for sky130_fd_sc_hd__fill_2 abstract view
.subckt sky130_fd_sc_hd__fill_2 VGND VNB VPB VPWR
.ends

* Black-box entry subcircuit for sky130_fd_sc_hd__clkbuf_8 abstract view
.subckt sky130_fd_sc_hd__clkbuf_8 A VGND VNB VPB VPWR X
.ends

* Black-box entry subcircuit for sky130_fd_sc_hd__or2_1 abstract view
.subckt sky130_fd_sc_hd__or2_1 A B VGND VNB VPB VPWR X
.ends

* Black-box entry subcircuit for sky130_fd_sc_hd__fill_4 abstract view
.subckt sky130_fd_sc_hd__fill_4 VGND VNB VPB VPWR
.ends

* Black-box entry subcircuit for sky130_fd_sc_hd__o211ai_1 abstract view
.subckt sky130_fd_sc_hd__o211ai_1 A1 A2 B1 C1 VGND VNB VPB VPWR Y
.ends

* Black-box entry subcircuit for sky130_fd_sc_hd__a221o_1 abstract view
.subckt sky130_fd_sc_hd__a221o_1 A1 A2 B1 B2 C1 VGND VNB VPB VPWR X
.ends

* Black-box entry subcircuit for sky130_fd_sc_hd__xor2_1 abstract view
.subckt sky130_fd_sc_hd__xor2_1 A B VGND VNB VPB VPWR X
.ends

* Black-box entry subcircuit for sky130_fd_sc_hd__decap_3 abstract view
.subckt sky130_fd_sc_hd__decap_3 VGND VNB VPB VPWR
.ends

* Black-box entry subcircuit for sky130_fd_sc_hd__fill_8 abstract view
.subckt sky130_fd_sc_hd__fill_8 VGND VNB VPB VPWR
.ends

* Black-box entry subcircuit for sky130_fd_sc_hd__diode_2 abstract view
.subckt sky130_fd_sc_hd__diode_2 DIODE VGND VNB VPB VPWR
.ends

* Black-box entry subcircuit for sky130_fd_sc_hd__a22o_1 abstract view
.subckt sky130_fd_sc_hd__a22o_1 A1 A2 B1 B2 VGND VNB VPB VPWR X
.ends

* Black-box entry subcircuit for sky130_fd_sc_hd__nor2_1 abstract view
.subckt sky130_fd_sc_hd__nor2_1 A B VGND VNB VPB VPWR Y
.ends

* Black-box entry subcircuit for sky130_fd_sc_hd__o21a_1 abstract view
.subckt sky130_fd_sc_hd__o21a_1 A1 A2 B1 VGND VNB VPB VPWR X
.ends

* Black-box entry subcircuit for sky130_fd_sc_hd__dlygate4sd3_1 abstract view
.subckt sky130_fd_sc_hd__dlygate4sd3_1 A VGND VNB VPB VPWR X
.ends

* Black-box entry subcircuit for sky130_fd_sc_hd__inv_2 abstract view
.subckt sky130_fd_sc_hd__inv_2 A VGND VNB VPB VPWR Y
.ends

* Black-box entry subcircuit for sky130_fd_sc_hd__nand2_1 abstract view
.subckt sky130_fd_sc_hd__nand2_1 A B VGND VNB VPB VPWR Y
.ends

* Black-box entry subcircuit for sky130_fd_sc_hd__and2_1 abstract view
.subckt sky130_fd_sc_hd__and2_1 A B VGND VNB VPB VPWR X
.ends

* Black-box entry subcircuit for sky130_fd_sc_hd__conb_1 abstract view
.subckt sky130_fd_sc_hd__conb_1 VGND VNB VPB VPWR HI LO
.ends

* Black-box entry subcircuit for sky130_fd_sc_hd__a211o_1 abstract view
.subckt sky130_fd_sc_hd__a211o_1 A1 A2 B1 C1 VGND VNB VPB VPWR X
.ends

* Black-box entry subcircuit for sky130_fd_sc_hd__a31o_1 abstract view
.subckt sky130_fd_sc_hd__a31o_1 A1 A2 A3 B1 VGND VNB VPB VPWR X
.ends

* Black-box entry subcircuit for sky130_fd_sc_hd__o21ai_1 abstract view
.subckt sky130_fd_sc_hd__o21ai_1 A1 A2 B1 VGND VNB VPB VPWR Y
.ends

* Black-box entry subcircuit for sky130_fd_sc_hd__a221o_2 abstract view
.subckt sky130_fd_sc_hd__a221o_2 A1 A2 B1 B2 C1 VGND VNB VPB VPWR X
.ends

* Black-box entry subcircuit for sky130_fd_sc_hd__xnor2_1 abstract view
.subckt sky130_fd_sc_hd__xnor2_1 A B VGND VNB VPB VPWR Y
.ends

* Black-box entry subcircuit for sky130_fd_sc_hd__mux2_1 abstract view
.subckt sky130_fd_sc_hd__mux2_1 A0 A1 S VGND VNB VPB VPWR X
.ends

* Black-box entry subcircuit for sky130_fd_sc_hd__o2bb2ai_1 abstract view
.subckt sky130_fd_sc_hd__o2bb2ai_1 A1_N A2_N B1 B2 VGND VNB VPB VPWR Y
.ends

* Black-box entry subcircuit for sky130_fd_sc_hd__and3b_1 abstract view
.subckt sky130_fd_sc_hd__and3b_1 A_N B C VGND VNB VPB VPWR X
.ends

* Black-box entry subcircuit for sky130_fd_sc_hd__or4_1 abstract view
.subckt sky130_fd_sc_hd__or4_1 A B C D VGND VNB VPB VPWR X
.ends

* Black-box entry subcircuit for sky130_fd_sc_hd__nor2_2 abstract view
.subckt sky130_fd_sc_hd__nor2_2 A B VGND VNB VPB VPWR Y
.ends

* Black-box entry subcircuit for sky130_fd_sc_hd__a2111o_1 abstract view
.subckt sky130_fd_sc_hd__a2111o_1 A1 A2 B1 C1 D1 VGND VNB VPB VPWR X
.ends

* Black-box entry subcircuit for sky130_fd_sc_hd__o32a_1 abstract view
.subckt sky130_fd_sc_hd__o32a_1 A1 A2 A3 B1 B2 VGND VNB VPB VPWR X
.ends

* Black-box entry subcircuit for sky130_fd_sc_hd__o22a_1 abstract view
.subckt sky130_fd_sc_hd__o22a_1 A1 A2 B1 B2 VGND VNB VPB VPWR X
.ends

* Black-box entry subcircuit for sky130_fd_sc_hd__bufinv_16 abstract view
.subckt sky130_fd_sc_hd__bufinv_16 A VGND VNB VPB VPWR Y
.ends

* Black-box entry subcircuit for sky130_fd_sc_hd__and4bb_1 abstract view
.subckt sky130_fd_sc_hd__and4bb_1 A_N B_N C D VGND VNB VPB VPWR X
.ends

* Black-box entry subcircuit for sky130_fd_sc_hd__dfstp_1 abstract view
.subckt sky130_fd_sc_hd__dfstp_1 CLK D SET_B VGND VNB VPB VPWR Q
.ends

* Black-box entry subcircuit for sky130_fd_sc_hd__and3_1 abstract view
.subckt sky130_fd_sc_hd__and3_1 A B C VGND VNB VPB VPWR X
.ends

* Black-box entry subcircuit for sky130_fd_sc_hd__clkinv_2 abstract view
.subckt sky130_fd_sc_hd__clkinv_2 A VGND VNB VPB VPWR Y
.ends

* Black-box entry subcircuit for sky130_fd_sc_hd__or3_1 abstract view
.subckt sky130_fd_sc_hd__or3_1 A B C VGND VNB VPB VPWR X
.ends

* Black-box entry subcircuit for sky130_fd_sc_hd__o221a_1 abstract view
.subckt sky130_fd_sc_hd__o221a_1 A1 A2 B1 B2 C1 VGND VNB VPB VPWR X
.ends

* Black-box entry subcircuit for sky130_fd_sc_hd__a21oi_1 abstract view
.subckt sky130_fd_sc_hd__a21oi_1 A1 A2 B1 VGND VNB VPB VPWR Y
.ends

* Black-box entry subcircuit for sky130_fd_sc_hd__nor2_4 abstract view
.subckt sky130_fd_sc_hd__nor2_4 A B VGND VNB VPB VPWR Y
.ends

* Black-box entry subcircuit for sky130_fd_sc_hd__clkbuf_4 abstract view
.subckt sky130_fd_sc_hd__clkbuf_4 A VGND VNB VPB VPWR X
.ends

* Black-box entry subcircuit for sky130_fd_sc_hd__clkinvlp_4 abstract view
.subckt sky130_fd_sc_hd__clkinvlp_4 A VGND VNB VPB VPWR Y
.ends

* Black-box entry subcircuit for sky130_fd_sc_hd__or3b_2 abstract view
.subckt sky130_fd_sc_hd__or3b_2 A B C_N VGND VNB VPB VPWR X
.ends

* Black-box entry subcircuit for sky130_fd_sc_hd__clkbuf_2 abstract view
.subckt sky130_fd_sc_hd__clkbuf_2 A VGND VNB VPB VPWR X
.ends

* Black-box entry subcircuit for sky130_fd_sc_hd__clkinv_4 abstract view
.subckt sky130_fd_sc_hd__clkinv_4 A VGND VNB VPB VPWR Y
.ends

* Black-box entry subcircuit for sky130_fd_sc_hd__and4b_1 abstract view
.subckt sky130_fd_sc_hd__and4b_1 A_N B C D VGND VNB VPB VPWR X
.ends

* Black-box entry subcircuit for sky130_fd_sc_hd__clkbuf_16 abstract view
.subckt sky130_fd_sc_hd__clkbuf_16 A VGND VNB VPB VPWR X
.ends

* Black-box entry subcircuit for sky130_fd_sc_hd__a32o_1 abstract view
.subckt sky130_fd_sc_hd__a32o_1 A1 A2 A3 B1 B2 VGND VNB VPB VPWR X
.ends

* Black-box entry subcircuit for sky130_fd_sc_hd__buf_2 abstract view
.subckt sky130_fd_sc_hd__buf_2 A VGND VNB VPB VPWR X
.ends

* Black-box entry subcircuit for sky130_fd_sc_hd__or4_2 abstract view
.subckt sky130_fd_sc_hd__or4_2 A B C D VGND VNB VPB VPWR X
.ends

* Black-box entry subcircuit for sky130_fd_sc_hd__dfrtp_2 abstract view
.subckt sky130_fd_sc_hd__dfrtp_2 CLK D RESET_B VGND VNB VPB VPWR Q
.ends

* Black-box entry subcircuit for sky130_fd_sc_hd__nand3_1 abstract view
.subckt sky130_fd_sc_hd__nand3_1 A B C VGND VNB VPB VPWR Y
.ends

* Black-box entry subcircuit for sky130_fd_sc_hd__nand4_1 abstract view
.subckt sky130_fd_sc_hd__nand4_1 A B C D VGND VNB VPB VPWR Y
.ends

* Black-box entry subcircuit for sky130_fd_sc_hd__and4_1 abstract view
.subckt sky130_fd_sc_hd__and4_1 A B C D VGND VNB VPB VPWR X
.ends

* Black-box entry subcircuit for sky130_fd_sc_hd__nand3b_4 abstract view
.subckt sky130_fd_sc_hd__nand3b_4 A_N B C VGND VNB VPB VPWR Y
.ends

* Black-box entry subcircuit for sky130_fd_sc_hd__nand2b_1 abstract view
.subckt sky130_fd_sc_hd__nand2b_1 A_N B VGND VNB VPB VPWR Y
.ends

* Black-box entry subcircuit for sky130_fd_sc_hd__dlymetal6s2s_1 abstract view
.subckt sky130_fd_sc_hd__dlymetal6s2s_1 A VGND VNB VPB VPWR X
.ends

* Black-box entry subcircuit for sky130_fd_sc_hd__and2b_1 abstract view
.subckt sky130_fd_sc_hd__and2b_1 A_N B VGND VNB VPB VPWR X
.ends

* Black-box entry subcircuit for sky130_fd_sc_hd__a31o_2 abstract view
.subckt sky130_fd_sc_hd__a31o_2 A1 A2 A3 B1 VGND VNB VPB VPWR X
.ends

* Black-box entry subcircuit for sky130_fd_sc_hd__o211a_1 abstract view
.subckt sky130_fd_sc_hd__o211a_1 A1 A2 B1 C1 VGND VNB VPB VPWR X
.ends

* Black-box entry subcircuit for sky130_fd_sc_hd__o32ai_1 abstract view
.subckt sky130_fd_sc_hd__o32ai_1 A1 A2 A3 B1 B2 VGND VNB VPB VPWR Y
.ends

* Black-box entry subcircuit for sky130_fd_sc_hd__a2bb2o_1 abstract view
.subckt sky130_fd_sc_hd__a2bb2o_1 A1_N A2_N B1 B2 VGND VNB VPB VPWR X
.ends

* Black-box entry subcircuit for sky130_fd_sc_hd__clkbuf_1 abstract view
.subckt sky130_fd_sc_hd__clkbuf_1 A VGND VNB VPB VPWR X
.ends

* Black-box entry subcircuit for sky130_fd_sc_hd__o2bb2a_1 abstract view
.subckt sky130_fd_sc_hd__o2bb2a_1 A1_N A2_N B1 B2 VGND VNB VPB VPWR X
.ends

* Black-box entry subcircuit for sky130_fd_sc_hd__o31ai_2 abstract view
.subckt sky130_fd_sc_hd__o31ai_2 A1 A2 A3 B1 VGND VNB VPB VPWR Y
.ends

* Black-box entry subcircuit for sky130_fd_sc_hd__or4b_1 abstract view
.subckt sky130_fd_sc_hd__or4b_1 A B C D_N VGND VNB VPB VPWR X
.ends

* Black-box entry subcircuit for sky130_fd_sc_hd__o21ai_4 abstract view
.subckt sky130_fd_sc_hd__o21ai_4 A1 A2 B1 VGND VNB VPB VPWR Y
.ends

* Black-box entry subcircuit for sky130_fd_sc_hd__o21ai_2 abstract view
.subckt sky130_fd_sc_hd__o21ai_2 A1 A2 B1 VGND VNB VPB VPWR Y
.ends

* Black-box entry subcircuit for sky130_fd_sc_hd__and2_2 abstract view
.subckt sky130_fd_sc_hd__and2_2 A B VGND VNB VPB VPWR X
.ends

* Black-box entry subcircuit for sky130_fd_sc_hd__and3_2 abstract view
.subckt sky130_fd_sc_hd__and3_2 A B C VGND VNB VPB VPWR X
.ends

* Black-box entry subcircuit for sky130_fd_sc_hd__o21ba_1 abstract view
.subckt sky130_fd_sc_hd__o21ba_1 A1 A2 B1_N VGND VNB VPB VPWR X
.ends

* Black-box entry subcircuit for sky130_fd_sc_hd__or3b_1 abstract view
.subckt sky130_fd_sc_hd__or3b_1 A B C_N VGND VNB VPB VPWR X
.ends

* Black-box entry subcircuit for sky130_fd_sc_hd__o31a_1 abstract view
.subckt sky130_fd_sc_hd__o31a_1 A1 A2 A3 B1 VGND VNB VPB VPWR X
.ends

* Black-box entry subcircuit for sky130_fd_sc_hd__a21bo_2 abstract view
.subckt sky130_fd_sc_hd__a21bo_2 A1 A2 B1_N VGND VNB VPB VPWR X
.ends

* Black-box entry subcircuit for sky130_fd_sc_hd__or4bb_2 abstract view
.subckt sky130_fd_sc_hd__or4bb_2 A B C_N D_N VGND VNB VPB VPWR X
.ends

* Black-box entry subcircuit for sky130_fd_sc_hd__o21bai_1 abstract view
.subckt sky130_fd_sc_hd__o21bai_1 A1 A2 B1_N VGND VNB VPB VPWR Y
.ends

* Black-box entry subcircuit for sky130_fd_sc_hd__a311o_1 abstract view
.subckt sky130_fd_sc_hd__a311o_1 A1 A2 A3 B1 C1 VGND VNB VPB VPWR X
.ends

* Black-box entry subcircuit for sky130_fd_sc_hd__o32a_2 abstract view
.subckt sky130_fd_sc_hd__o32a_2 A1 A2 A3 B1 B2 VGND VNB VPB VPWR X
.ends

* Black-box entry subcircuit for sky130_fd_sc_hd__o211ai_2 abstract view
.subckt sky130_fd_sc_hd__o211ai_2 A1 A2 B1 C1 VGND VNB VPB VPWR Y
.ends

* Black-box entry subcircuit for sky130_fd_sc_hd__o311a_1 abstract view
.subckt sky130_fd_sc_hd__o311a_1 A1 A2 A3 B1 C1 VGND VNB VPB VPWR X
.ends

* Black-box entry subcircuit for sky130_fd_sc_hd__a211oi_1 abstract view
.subckt sky130_fd_sc_hd__a211oi_1 A1 A2 B1 C1 VGND VNB VPB VPWR Y
.ends

* Black-box entry subcircuit for sky130_fd_sc_hd__o21bai_2 abstract view
.subckt sky130_fd_sc_hd__o21bai_2 A1 A2 B1_N VGND VNB VPB VPWR Y
.ends

* Black-box entry subcircuit for sky130_fd_sc_hd__o22a_2 abstract view
.subckt sky130_fd_sc_hd__o22a_2 A1 A2 B1 B2 VGND VNB VPB VPWR X
.ends

* Black-box entry subcircuit for sky130_fd_sc_hd__or4bb_1 abstract view
.subckt sky130_fd_sc_hd__or4bb_1 A B C_N D_N VGND VNB VPB VPWR X
.ends

* Black-box entry subcircuit for sky130_fd_sc_hd__dfrtp_4 abstract view
.subckt sky130_fd_sc_hd__dfrtp_4 CLK D RESET_B VGND VNB VPB VPWR Q
.ends

.subckt team_05 clk en gpio_in[0] gpio_in[10] gpio_in[11] gpio_in[12] gpio_in[13]
+ gpio_in[14] gpio_in[15] gpio_in[16] gpio_in[17] gpio_in[18] gpio_in[19] gpio_in[1]
+ gpio_in[20] gpio_in[21] gpio_in[22] gpio_in[23] gpio_in[24] gpio_in[25] gpio_in[26]
+ gpio_in[27] gpio_in[28] gpio_in[29] gpio_in[2] gpio_in[30] gpio_in[31] gpio_in[32]
+ gpio_in[33] gpio_in[3] gpio_in[4] gpio_in[5] gpio_in[6] gpio_in[7] gpio_in[8] gpio_in[9]
+ gpio_oeb[0] gpio_oeb[10] gpio_oeb[11] gpio_oeb[12] gpio_oeb[13] gpio_oeb[14] gpio_oeb[15]
+ gpio_oeb[16] gpio_oeb[17] gpio_oeb[18] gpio_oeb[19] gpio_oeb[1] gpio_oeb[20] gpio_oeb[21]
+ gpio_oeb[22] gpio_oeb[23] gpio_oeb[24] gpio_oeb[25] gpio_oeb[26] gpio_oeb[27] gpio_oeb[28]
+ gpio_oeb[29] gpio_oeb[2] gpio_oeb[30] gpio_oeb[31] gpio_oeb[32] gpio_oeb[33] gpio_oeb[3]
+ gpio_oeb[4] gpio_oeb[5] gpio_oeb[6] gpio_oeb[7] gpio_oeb[8] gpio_oeb[9] gpio_out[0]
+ gpio_out[10] gpio_out[11] gpio_out[12] gpio_out[13] gpio_out[14] gpio_out[15] gpio_out[16]
+ gpio_out[17] gpio_out[18] gpio_out[19] gpio_out[1] gpio_out[20] gpio_out[21] gpio_out[22]
+ gpio_out[23] gpio_out[24] gpio_out[25] gpio_out[26] gpio_out[27] gpio_out[28] gpio_out[29]
+ gpio_out[2] gpio_out[30] gpio_out[31] gpio_out[32] gpio_out[33] gpio_out[3] gpio_out[4]
+ gpio_out[5] gpio_out[6] gpio_out[7] gpio_out[8] gpio_out[9] nrst vccd1 vssd1
XTAP_TAPCELL_ROW_9_126 vssd1 vccd1 sky130_fd_sc_hd__tapvpwrvgnd_1
XFILLER_13_111 vssd1 vssd1 vccd1 vccd1 sky130_fd_sc_hd__fill_1
X_0985_ clknet_4_7_0_clk _0023_ net53 vssd1 vssd1 vccd1 vccd1 SYNTH_INST.waveshape.scaled_count\[4\]
+ sky130_fd_sc_hd__dfrtp_1
XFILLER_6_107 vccd1 vssd1 vccd1 vssd1 sky130_ef_sc_hd__decap_40_12
XTAP_TAPCELL_ROW_20_175 vssd1 vccd1 sky130_fd_sc_hd__tapvpwrvgnd_1
X_0770_ SYNTH_INST.waveshape.scaled_count\[7\] net21 _0332_ vssd1 vssd1 vccd1 vccd1
+ _0026_ sky130_fd_sc_hd__a21o_1
XFILLER_32_250 vssd1 vssd1 vccd1 vccd1 sky130_fd_sc_hd__fill_2
X_0968_ clknet_4_1_0_clk _0006_ net48 vssd1 vssd1 vccd1 vccd1 SYNTH_INST.waveshape.seq_div.dividend\[10\]
+ sky130_fd_sc_hd__dfrtp_1
Xclkbuf_4_12_0_clk clknet_0_clk vssd1 vssd1 vccd1 vccd1 clknet_4_12_0_clk sky130_fd_sc_hd__clkbuf_8
X_0899_ SYNTH_INST.waveshape.seq_div.n\[0\] SYNTH_INST.waveshape.seq_div.state\[1\]
+ vssd1 vssd1 vccd1 vccd1 _0432_ sky130_fd_sc_hd__or2_1
XFILLER_23_97 vssd1 vssd1 vccd1 vccd1 sky130_fd_sc_hd__fill_4
XFILLER_2_121 vssd1 vssd1 vccd1 vccd1 sky130_fd_sc_hd__fill_2
XFILLER_0_57 vccd1 vssd1 vccd1 vssd1 sky130_ef_sc_hd__decap_40_12
X_0822_ _0151_ _0152_ _0154_ _0370_ vssd1 vssd1 vccd1 vccd1 _0374_ sky130_fd_sc_hd__o211ai_1
XFILLER_9_44 vssd1 vssd1 vccd1 vccd1 sky130_fd_sc_hd__fill_1
X_0753_ net46 SYNTH_INST.waveshape.seq_div.dividend\[21\] net31 SYNTH_INST.count\[14\]
+ net21 vssd1 vssd1 vccd1 vccd1 _0324_ sky130_fd_sc_hd__a221o_1
X_0684_ SYNTH_INST.waveshape.scaled_count\[7\] SYNTH_INST.waveshape.scaled_count\[1\]
+ vssd1 vssd1 vccd1 vccd1 _0288_ sky130_fd_sc_hd__xor2_1
XFILLER_20_253 vssd1 vssd1 vccd1 vccd1 sky130_fd_sc_hd__fill_2
XPHY_EDGE_ROW_8_Left_47 vssd1 vssd1 vccd1 vccd1 sky130_fd_sc_hd__decap_3
XFILLER_34_85 vssd1 vssd1 vccd1 vccd1 sky130_fd_sc_hd__fill_2
XFILLER_34_41 vssd1 vssd1 vccd1 vccd1 sky130_fd_sc_hd__fill_8
XFILLER_38_128 vccd1 vssd1 vccd1 vssd1 sky130_ef_sc_hd__decap_40_12
XANTENNA__0835__A2 net27 vssd1 vssd1 vccd1 vccd1 sky130_fd_sc_hd__diode_2
X_1021_ clknet_4_8_0_clk _0045_ net54 vssd1 vssd1 vccd1 vccd1 SYNTH_INST.waveshape.seq_div.dividend\[37\]
+ sky130_fd_sc_hd__dfrtp_1
X_0805_ net26 _0360_ _0361_ net174 vssd1 vssd1 vccd1 vccd1 _0032_ sky130_fd_sc_hd__a22o_1
X_0598_ SYNTH_INST.waveshape.seq_div.state\[1\] _0207_ _0226_ vssd1 vssd1 vccd1 vccd1
+ _0003_ sky130_fd_sc_hd__a21o_1
X_0667_ _0275_ _0276_ vssd1 vssd1 vccd1 vccd1 SYNTH_INST.oscill.n_count\[12\] sky130_fd_sc_hd__nor2_1
X_0736_ net158 net25 _0315_ vssd1 vssd1 vccd1 vccd1 _0009_ sky130_fd_sc_hd__o21a_1
XFILLER_29_128 vssd1 vssd1 vccd1 vccd1 sky130_fd_sc_hd__fill_4
Xhold63 SYNTH_INST.waveshape.seq_div.dividend\[30\] vssd1 vssd1 vccd1 vccd1 net194
+ sky130_fd_sc_hd__dlygate4sd3_1
Xhold52 SYNTH_INST.waveshape.seq_div.dividend\[27\] vssd1 vssd1 vccd1 vccd1 net183
+ sky130_fd_sc_hd__dlygate4sd3_1
Xhold30 SYNTH_INST.waveshape.seq_div.dividend\[23\] vssd1 vssd1 vccd1 vccd1 net161
+ sky130_fd_sc_hd__dlygate4sd3_1
Xhold41 SYNTH_INST.count\[7\] vssd1 vssd1 vccd1 vccd1 net172 sky130_fd_sc_hd__dlygate4sd3_1
XFILLER_29_74 vssd1 vssd1 vccd1 vccd1 sky130_fd_sc_hd__fill_1
XFILLER_35_109 vssd1 vssd1 vccd1 vccd1 sky130_fd_sc_hd__fill_2
X_0452_ SYNTH_INST.mode\[1\] vssd1 vssd1 vccd1 vccd1 _0085_ sky130_fd_sc_hd__inv_2
X_0521_ SYNTH_INST.waveshape.seq_div.dividend\[28\] _0153_ vssd1 vssd1 vccd1 vccd1
+ _0154_ sky130_fd_sc_hd__nand2_1
XFILLER_13_3 vssd1 vssd1 vccd1 vccd1 sky130_fd_sc_hd__fill_4
X_1004_ clknet_4_15_0_clk SYNTH_INST.pwm_counter.n_count\[4\] net61 vssd1 vssd1 vccd1
+ vccd1 SYNTH_INST.pwm_counter.count\[4\] sky130_fd_sc_hd__dfrtp_1
X_0719_ net16 net1 vssd1 vssd1 vccd1 vccd1 SYNTH_INST.keypad.n_rst sky130_fd_sc_hd__and2_1
Xteam_05_73 vssd1 vssd1 vccd1 vccd1 team_05_73/HI gpio_out[10] sky130_fd_sc_hd__conb_1
Xteam_05_62 vssd1 vssd1 vccd1 vccd1 team_05_62/HI gpio_oeb[14] sky130_fd_sc_hd__conb_1
Xteam_05_84 vssd1 vssd1 vccd1 vccd1 team_05_84/HI gpio_out[22] sky130_fd_sc_hd__conb_1
Xteam_05_95 vssd1 vssd1 vccd1 vccd1 team_05_95/HI gpio_out[33] sky130_fd_sc_hd__conb_1
XFILLER_0_241 vssd1 vssd1 vccd1 vccd1 sky130_fd_sc_hd__fill_2
X_0504_ _0135_ _0136_ vssd1 vssd1 vccd1 vccd1 _0137_ sky130_fd_sc_hd__and2_1
XPHY_EDGE_ROW_37_Left_76 vssd1 vssd1 vccd1 vccd1 sky130_fd_sc_hd__decap_3
XFILLER_3_35 vssd1 vssd1 vccd1 vccd1 sky130_fd_sc_hd__fill_2
X_0984_ clknet_4_13_0_clk _0022_ net58 vssd1 vssd1 vccd1 vccd1 SYNTH_INST.waveshape.scaled_count\[3\]
+ sky130_fd_sc_hd__dfrtp_1
XFILLER_6_119 vccd1 vssd1 vccd1 vssd1 sky130_ef_sc_hd__decap_40_12
XFILLER_12_33 vssd1 vssd1 vccd1 vccd1 sky130_fd_sc_hd__fill_2
XFILLER_12_88 vssd1 vssd1 vccd1 vccd1 sky130_fd_sc_hd__fill_1
XTAP_TAPCELL_ROW_20_176 vssd1 vccd1 sky130_fd_sc_hd__tapvpwrvgnd_1
XFILLER_37_30 vssd1 vssd1 vccd1 vccd1 sky130_fd_sc_hd__fill_2
XTAP_TAPCELL_ROW_28_210 vssd1 vccd1 sky130_fd_sc_hd__tapvpwrvgnd_1
XFILLER_33_229 vssd1 vssd1 vccd1 vccd1 sky130_fd_sc_hd__fill_1
XTAP_TAPCELL_ROW_11_132 vssd1 vccd1 sky130_fd_sc_hd__tapvpwrvgnd_1
XTAP_TAPCELL_ROW_34_235 vssd1 vccd1 sky130_fd_sc_hd__tapvpwrvgnd_1
X_0967_ clknet_4_1_0_clk _0005_ net47 vssd1 vssd1 vccd1 vccd1 SYNTH_INST.waveshape.seq_div.dividend\[9\]
+ sky130_fd_sc_hd__dfrtp_1
X_0898_ SYNTH_INST.waveshape.seq_div.dividend\[47\] net28 _0396_ _0431_ vssd1 vssd1
+ vccd1 vccd1 _0055_ sky130_fd_sc_hd__a22o_1
XPHY_EDGE_ROW_12_Right_12 vssd1 vssd1 vccd1 vccd1 sky130_fd_sc_hd__decap_3
XPHY_EDGE_ROW_21_Right_21 vssd1 vssd1 vccd1 vccd1 sky130_fd_sc_hd__decap_3
XFILLER_23_10 vssd1 vssd1 vccd1 vccd1 sky130_fd_sc_hd__fill_1
XPHY_EDGE_ROW_30_Right_30 vssd1 vssd1 vccd1 vccd1 sky130_fd_sc_hd__decap_3
XFILLER_0_69 vssd1 vssd1 vccd1 vccd1 sky130_fd_sc_hd__fill_8
X_0821_ _0154_ _0370_ _0151_ _0152_ vssd1 vssd1 vccd1 vccd1 _0373_ sky130_fd_sc_hd__a211o_1
XFILLER_9_67 vccd1 vssd1 vccd1 vssd1 sky130_ef_sc_hd__decap_40_12
X_0752_ net164 net24 _0323_ vssd1 vssd1 vccd1 vccd1 _0017_ sky130_fd_sc_hd__o21a_1
XPHY_EDGE_ROW_24_Left_63 vssd1 vssd1 vccd1 vccd1 sky130_fd_sc_hd__decap_3
X_0683_ SYNTH_INST.waveshape.scaled_count\[1\] _0285_ _0286_ _0287_ _0284_ vssd1 vssd1
+ vccd1 vccd1 SYNTH_INST.waveshape.shaper.n_sample\[1\] sky130_fd_sc_hd__a221o_1
XFILLER_20_221 vssd1 vssd1 vccd1 vccd1 sky130_fd_sc_hd__fill_1
XFILLER_18_21 vssd1 vssd1 vccd1 vccd1 sky130_fd_sc_hd__fill_1
XFILLER_7_214 vssd1 vssd1 vccd1 vccd1 sky130_fd_sc_hd__fill_1
XFILLER_7_225 vccd1 vssd1 vccd1 vssd1 sky130_ef_sc_hd__decap_40_12
XFILLER_11_221 vssd1 vssd1 vccd1 vccd1 sky130_fd_sc_hd__fill_2
X_1020_ clknet_4_2_0_clk _0044_ net54 vssd1 vssd1 vccd1 vccd1 SYNTH_INST.waveshape.seq_div.dividend\[36\]
+ sky130_fd_sc_hd__dfrtp_1
Xclkbuf_4_11_0_clk clknet_0_clk vssd1 vssd1 vccd1 vccd1 clknet_4_11_0_clk sky130_fd_sc_hd__clkbuf_8
X_0804_ net40 _0130_ _0132_ net29 vssd1 vssd1 vccd1 vccd1 _0361_ sky130_fd_sc_hd__a31o_1
X_0735_ net42 SYNTH_INST.waveshape.seq_div.dividend\[12\] net30 SYNTH_INST.count\[5\]
+ net22 vssd1 vssd1 vccd1 vccd1 _0315_ sky130_fd_sc_hd__a221o_1
X_0597_ SYNTH_INST.waveshape.seq_div.state\[0\] _0200_ vssd1 vssd1 vccd1 vccd1 _0226_
+ sky130_fd_sc_hd__and2_1
X_0666_ SYNTH_INST.count\[12\] _0273_ net19 vssd1 vssd1 vccd1 vccd1 _0276_ sky130_fd_sc_hd__o21ai_1
XANTENNA__0771__A2 net27 vssd1 vssd1 vccd1 vccd1 sky130_fd_sc_hd__diode_2
XFILLER_20_66 vssd1 vssd1 vccd1 vccd1 sky130_fd_sc_hd__fill_2
Xhold64 SYNTH_INST.waveshape.scaled_count\[6\] vssd1 vssd1 vccd1 vccd1 net195 sky130_fd_sc_hd__dlygate4sd3_1
Xhold53 SYNTH_INST.waveshape.seq_div.dividend\[38\] vssd1 vssd1 vccd1 vccd1 net184
+ sky130_fd_sc_hd__dlygate4sd3_1
Xhold20 SYNTH_INST.sample_rate.count\[4\] vssd1 vssd1 vccd1 vccd1 net151 sky130_fd_sc_hd__dlygate4sd3_1
Xhold31 SYNTH_INST.waveshape.seq_div.dividend\[12\] vssd1 vssd1 vccd1 vccd1 net162
+ sky130_fd_sc_hd__dlygate4sd3_1
Xhold42 SYNTH_INST.freq_div.keycode\[3\] vssd1 vssd1 vccd1 vccd1 net173 sky130_fd_sc_hd__dlygate4sd3_1
XFILLER_6_57 vssd1 vssd1 vccd1 vccd1 sky130_fd_sc_hd__fill_4
XFILLER_6_46 vssd1 vssd1 vccd1 vccd1 sky130_fd_sc_hd__fill_2
X_0520_ _0070_ _0094_ _0118_ net33 _0131_ vssd1 vssd1 vccd1 vccd1 _0153_ sky130_fd_sc_hd__a221o_2
X_0451_ SYNTH_INST.count\[5\] vssd1 vssd1 vccd1 vccd1 _0084_ sky130_fd_sc_hd__inv_2
X_1003_ clknet_4_15_0_clk SYNTH_INST.pwm_counter.n_count\[3\] net60 vssd1 vssd1 vccd1
+ vccd1 SYNTH_INST.pwm_counter.count\[3\] sky130_fd_sc_hd__dfrtp_1
XFILLER_34_187 vssd1 vssd1 vccd1 vccd1 sky130_fd_sc_hd__fill_1
X_0718_ _0076_ _0301_ vssd1 vssd1 vccd1 vccd1 SYNTH_INST.pwm_counter.n_count\[7\]
+ sky130_fd_sc_hd__xnor2_1
XPHY_EDGE_ROW_6_Right_6 vssd1 vssd1 vccd1 vccd1 sky130_fd_sc_hd__decap_3
Xteam_05_74 vssd1 vssd1 vccd1 vccd1 team_05_74/HI gpio_out[11] sky130_fd_sc_hd__conb_1
X_0649_ SYNTH_INST.count\[6\] _0263_ vssd1 vssd1 vccd1 vccd1 _0265_ sky130_fd_sc_hd__and2_1
Xteam_05_63 vssd1 vssd1 vccd1 vccd1 team_05_63/HI gpio_out[0] sky130_fd_sc_hd__conb_1
XPHY_EDGE_ROW_11_Left_50 vssd1 vssd1 vccd1 vccd1 sky130_fd_sc_hd__decap_3
Xteam_05_85 vssd1 vssd1 vccd1 vccd1 team_05_85/HI gpio_out[23] sky130_fd_sc_hd__conb_1
XFILLER_31_10 vssd1 vssd1 vccd1 vccd1 sky130_fd_sc_hd__fill_2
XFILLER_31_98 vssd1 vssd1 vccd1 vccd1 sky130_fd_sc_hd__fill_2
XFILLER_0_253 vssd1 vssd1 vccd1 vccd1 sky130_fd_sc_hd__fill_2
XFILLER_16_121 vssd1 vssd1 vccd1 vccd1 sky130_fd_sc_hd__fill_1
XFILLER_31_113 vssd1 vssd1 vccd1 vccd1 sky130_fd_sc_hd__fill_1
X_0503_ SYNTH_INST.waveshape.seq_div.dividend\[26\] _0124_ vssd1 vssd1 vccd1 vccd1
+ _0136_ sky130_fd_sc_hd__xor2_1
XTAP_TAPCELL_ROW_17_160 vssd1 vccd1 sky130_fd_sc_hd__tapvpwrvgnd_1
XFILLER_13_113 vssd1 vssd1 vccd1 vccd1 sky130_fd_sc_hd__fill_1
X_0983_ clknet_4_6_0_clk _0021_ net57 vssd1 vssd1 vccd1 vccd1 SYNTH_INST.waveshape.scaled_count\[2\]
+ sky130_fd_sc_hd__dfrtp_1
XTAP_TAPCELL_ROW_6_109 vssd1 vccd1 sky130_fd_sc_hd__tapvpwrvgnd_1
XFILLER_27_249 vssd1 vssd1 vccd1 vccd1 sky130_fd_sc_hd__fill_1
XFILLER_10_149 vssd1 vssd1 vccd1 vccd1 sky130_fd_sc_hd__fill_2
XFILLER_5_6 vccd1 vssd1 vccd1 vssd1 sky130_ef_sc_hd__decap_40_12
XTAP_TAPCELL_ROW_28_211 vssd1 vccd1 sky130_fd_sc_hd__tapvpwrvgnd_1
XTAP_TAPCELL_ROW_11_133 vssd1 vccd1 sky130_fd_sc_hd__tapvpwrvgnd_1
XTAP_TAPCELL_ROW_34_236 vssd1 vccd1 sky130_fd_sc_hd__tapvpwrvgnd_1
X_0897_ SYNTH_INST.waveshape.seq_div.dividend\[46\] net45 _0430_ SYNTH_INST.waveshape.seq_div.state\[4\]
+ vssd1 vssd1 vccd1 vccd1 _0431_ sky130_fd_sc_hd__a22o_1
X_0966_ clknet_4_1_0_clk _0004_ net47 vssd1 vssd1 vccd1 vccd1 SYNTH_INST.waveshape.seq_div.dividend\[8\]
+ sky130_fd_sc_hd__dfrtp_1
XFILLER_3_3 vssd1 vssd1 vccd1 vccd1 sky130_fd_sc_hd__fill_8
XFILLER_2_123 vssd1 vssd1 vccd1 vccd1 sky130_fd_sc_hd__fill_1
X_0820_ SYNTH_INST.waveshape.seq_div.dividend\[28\] _0372_ net27 vssd1 vssd1 vccd1
+ vccd1 _0036_ sky130_fd_sc_hd__mux2_1
XFILLER_9_57 vssd1 vssd1 vccd1 vccd1 sky130_fd_sc_hd__fill_2
XFILLER_9_79 vssd1 vssd1 vccd1 vccd1 sky130_fd_sc_hd__fill_2
X_0751_ net46 SYNTH_INST.waveshape.seq_div.dividend\[20\] net31 SYNTH_INST.count\[13\]
+ net21 vssd1 vssd1 vccd1 vccd1 _0323_ sky130_fd_sc_hd__a221o_1
XTAP_TAPCELL_ROW_0_80 vssd1 vccd1 sky130_fd_sc_hd__tapvpwrvgnd_1
X_0682_ SYNTH_INST.waveshape.scaled_count\[0\] SYNTH_INST.waveshape.scaled_count\[7\]
+ vssd1 vssd1 vccd1 vccd1 _0287_ sky130_fd_sc_hd__xor2_1
X_0949_ clknet_4_7_0_clk SYNTH_INST.state_machine.nextState\[1\] net58 vssd1 vssd1
+ vccd1 vccd1 SYNTH_INST.state_machine.fsmState\[1\] sky130_fd_sc_hd__dfrtp_1
XFILLER_34_87 vssd1 vssd1 vccd1 vccd1 sky130_fd_sc_hd__fill_1
XFILLER_7_237 vccd1 vssd1 vccd1 vssd1 sky130_ef_sc_hd__decap_40_12
XFILLER_11_233 vccd1 vssd1 vccd1 vssd1 sky130_ef_sc_hd__decap_40_12
X_0803_ net41 SYNTH_INST.waveshape.seq_div.dividend\[23\] _0133_ _0073_ vssd1 vssd1
+ vccd1 vccd1 _0360_ sky130_fd_sc_hd__o2bb2ai_1
X_0665_ SYNTH_INST.count\[12\] _0273_ vssd1 vssd1 vccd1 vccd1 _0275_ sky130_fd_sc_hd__and2_1
X_0734_ net162 net25 _0314_ vssd1 vssd1 vccd1 vccd1 _0008_ sky130_fd_sc_hd__o21a_1
X_0596_ net200 _0076_ _0224_ _0225_ vssd1 vssd1 vccd1 vccd1 SYNTH_INST.pwm_counter.n_pwm
+ sky130_fd_sc_hd__a22o_1
Xhold10 _0068_ vssd1 vssd1 vccd1 vccd1 net141 sky130_fd_sc_hd__dlygate4sd3_1
Xhold54 SYNTH_INST.waveshape.seq_div.dividend\[33\] vssd1 vssd1 vccd1 vccd1 net185
+ sky130_fd_sc_hd__dlygate4sd3_1
Xhold43 SYNTH_INST.waveshape.seq_div.dividend\[24\] vssd1 vssd1 vccd1 vccd1 net174
+ sky130_fd_sc_hd__dlygate4sd3_1
Xhold21 SYNTH_INST.sample_rate.n_count\[4\] vssd1 vssd1 vccd1 vccd1 net152 sky130_fd_sc_hd__dlygate4sd3_1
Xhold32 SYNTH_INST.waveshape.seq_div.dividend\[10\] vssd1 vssd1 vccd1 vccd1 net163
+ sky130_fd_sc_hd__dlygate4sd3_1
Xhold65 SYNTH_INST.waveshape.scaled_count\[1\] vssd1 vssd1 vccd1 vccd1 net196 sky130_fd_sc_hd__dlygate4sd3_1
XFILLER_28_141 vssd1 vssd1 vccd1 vccd1 sky130_fd_sc_hd__fill_4
XFILLER_6_25 vssd1 vssd1 vccd1 vccd1 sky130_fd_sc_hd__fill_1
X_0450_ SYNTH_INST.pwm_counter.count\[0\] vssd1 vssd1 vccd1 vccd1 _0083_ sky130_fd_sc_hd__inv_2
XFILLER_34_133 vssd1 vssd1 vccd1 vccd1 sky130_fd_sc_hd__fill_4
X_1002_ clknet_4_14_0_clk SYNTH_INST.pwm_counter.n_count\[2\] net60 vssd1 vssd1 vccd1
+ vccd1 SYNTH_INST.pwm_counter.count\[2\] sky130_fd_sc_hd__dfrtp_1
X_0717_ _0301_ _0305_ vssd1 vssd1 vccd1 vccd1 SYNTH_INST.pwm_counter.n_count\[6\]
+ sky130_fd_sc_hd__nor2_1
X_0648_ _0263_ _0264_ net18 vssd1 vssd1 vccd1 vccd1 SYNTH_INST.oscill.n_count\[5\]
+ sky130_fd_sc_hd__and3b_1
Xteam_05_75 vssd1 vssd1 vccd1 vccd1 team_05_75/HI gpio_out[12] sky130_fd_sc_hd__conb_1
X_0579_ SYNTH_INST.keypad.keypad_reg\[1\] SYNTH_INST.keypad.keypad_reg\[0\] SYNTH_INST.keypad.keypad_reg\[3\]
+ SYNTH_INST.keypad.keypad_reg\[2\] vssd1 vssd1 vccd1 vccd1 _0210_ sky130_fd_sc_hd__or4_1
Xteam_05_64 vssd1 vssd1 vccd1 vccd1 team_05_64/HI gpio_out[1] sky130_fd_sc_hd__conb_1
Xteam_05_86 vssd1 vssd1 vccd1 vccd1 team_05_86/HI gpio_out[24] sky130_fd_sc_hd__conb_1
XFILLER_25_111 vssd1 vssd1 vccd1 vccd1 sky130_fd_sc_hd__fill_1
XFILLER_25_177 vssd1 vssd1 vccd1 vccd1 sky130_fd_sc_hd__fill_4
Xclkbuf_4_10_0_clk clknet_0_clk vssd1 vssd1 vccd1 vccd1 clknet_4_10_0_clk sky130_fd_sc_hd__clkbuf_8
X_0502_ _0133_ _0134_ _0129_ vssd1 vssd1 vccd1 vccd1 _0135_ sky130_fd_sc_hd__a21o_1
XTAP_TAPCELL_ROW_17_161 vssd1 vccd1 sky130_fd_sc_hd__tapvpwrvgnd_1
XFILLER_22_147 vccd1 vssd1 vccd1 vssd1 sky130_ef_sc_hd__decap_40_12
XFILLER_26_33 vssd1 vssd1 vccd1 vccd1 sky130_fd_sc_hd__fill_2
XFILLER_9_129 vssd1 vssd1 vccd1 vccd1 sky130_fd_sc_hd__fill_2
XTAP_TAPCELL_ROW_23_186 vssd1 vccd1 sky130_fd_sc_hd__tapvpwrvgnd_1
X_0982_ clknet_4_12_0_clk _0020_ net57 vssd1 vssd1 vccd1 vccd1 SYNTH_INST.waveshape.scaled_count\[1\]
+ sky130_fd_sc_hd__dfrtp_1
XFILLER_10_128 vccd1 vssd1 vccd1 vssd1 sky130_ef_sc_hd__decap_40_12
XFILLER_37_32 vssd1 vssd1 vccd1 vccd1 sky130_fd_sc_hd__fill_1
XTAP_TAPCELL_ROW_28_212 vssd1 vccd1 sky130_fd_sc_hd__tapvpwrvgnd_1
XTAP_TAPCELL_ROW_11_134 vssd1 vccd1 sky130_fd_sc_hd__tapvpwrvgnd_1
XTAP_TAPCELL_ROW_34_237 vssd1 vccd1 sky130_fd_sc_hd__tapvpwrvgnd_1
XFILLER_32_253 vssd1 vssd1 vccd1 vccd1 sky130_fd_sc_hd__fill_2
X_0965_ clknet_4_7_0_clk SYNTH_INST.keypad.n_modekey net51 vssd1 vssd1 vccd1 vccd1
+ SYNTH_INST.keypad.modekey sky130_fd_sc_hd__dfrtp_1
X_0896_ SYNTH_INST.waveshape.seq_div.dividend\[47\] _0193_ vssd1 vssd1 vccd1 vccd1
+ _0430_ sky130_fd_sc_hd__xnor2_1
XFILLER_0_16 vssd1 vssd1 vccd1 vccd1 sky130_fd_sc_hd__fill_1
XFILLER_0_27 vssd1 vssd1 vccd1 vccd1 sky130_fd_sc_hd__fill_1
XFILLER_9_25 vssd1 vssd1 vccd1 vccd1 sky130_fd_sc_hd__fill_2
XFILLER_14_242 vssd1 vssd1 vccd1 vccd1 sky130_fd_sc_hd__fill_4
XFILLER_14_253 vssd1 vssd1 vccd1 vccd1 sky130_fd_sc_hd__fill_2
X_0681_ SYNTH_INST.state_machine.fsmState\[1\] _0085_ vssd1 vssd1 vccd1 vccd1 _0286_
+ sky130_fd_sc_hd__nor2_2
X_0750_ net156 net24 _0322_ vssd1 vssd1 vccd1 vccd1 _0016_ sky130_fd_sc_hd__o21a_1
XTAP_TAPCELL_ROW_0_81 vssd1 vccd1 sky130_fd_sc_hd__tapvpwrvgnd_1
XFILLER_29_3 vssd1 vssd1 vccd1 vccd1 sky130_fd_sc_hd__fill_2
X_0948_ clknet_4_13_0_clk SYNTH_INST.state_machine.nextState\[0\] net53 vssd1 vssd1
+ vccd1 vccd1 SYNTH_INST.state_machine.fsmState\[0\] sky130_fd_sc_hd__dfrtp_1
XFILLER_20_245 vssd1 vssd1 vccd1 vccd1 sky130_fd_sc_hd__fill_1
X_0879_ _0186_ _0187_ SYNTH_INST.waveshape.seq_div.dividend\[42\] SYNTH_INST.waveshape.seq_div.dividend\[41\]
+ SYNTH_INST.waveshape.seq_div.dividend\[40\] vssd1 vssd1 vccd1 vccd1 _0418_ sky130_fd_sc_hd__a2111o_1
XFILLER_18_67 vssd1 vssd1 vccd1 vccd1 sky130_fd_sc_hd__fill_2
XFILLER_11_223 vssd1 vssd1 vccd1 vccd1 sky130_fd_sc_hd__fill_1
XFILLER_7_249 vssd1 vssd1 vccd1 vccd1 sky130_fd_sc_hd__fill_2
XFILLER_11_245 vssd1 vssd1 vccd1 vccd1 sky130_fd_sc_hd__fill_4
XFILLER_38_109 vssd1 vssd1 vccd1 vccd1 sky130_fd_sc_hd__fill_2
X_0802_ _0356_ _0358_ _0359_ _0218_ net173 vssd1 vssd1 vccd1 vccd1 _0031_ sky130_fd_sc_hd__o32a_1
X_0664_ _0273_ _0274_ net18 vssd1 vssd1 vccd1 vccd1 SYNTH_INST.oscill.n_count\[11\]
+ sky130_fd_sc_hd__and3b_1
X_0733_ net42 SYNTH_INST.waveshape.seq_div.dividend\[11\] net30 SYNTH_INST.count\[4\]
+ net22 vssd1 vssd1 vccd1 vccd1 _0314_ sky130_fd_sc_hd__a221o_1
X_0595_ SYNTH_INST.pwm_counter.active_sample\[7\] _0076_ SYNTH_INST.pwm_counter.active_sample\[6\]
+ _0077_ vssd1 vssd1 vccd1 vccd1 _0225_ sky130_fd_sc_hd__o22a_1
XFILLER_20_46 vccd1 vssd1 vccd1 vssd1 sky130_ef_sc_hd__decap_40_12
Xhold22 SYNTH_INST.sample_rate.count\[1\] vssd1 vssd1 vccd1 vccd1 net153 sky130_fd_sc_hd__dlygate4sd3_1
Xhold11 SYNTH_INST.pwm_counter.sample\[0\] vssd1 vssd1 vccd1 vccd1 net142 sky130_fd_sc_hd__dlygate4sd3_1
Xhold66 SYNTH_INST.waveshape.seq_div.dividend\[29\] vssd1 vssd1 vccd1 vccd1 net197
+ sky130_fd_sc_hd__dlygate4sd3_1
Xhold33 SYNTH_INST.waveshape.seq_div.dividend\[21\] vssd1 vssd1 vccd1 vccd1 net164
+ sky130_fd_sc_hd__dlygate4sd3_1
Xhold44 SYNTH_INST.count\[4\] vssd1 vssd1 vccd1 vccd1 net175 sky130_fd_sc_hd__dlygate4sd3_1
XFILLER_28_186 vssd1 vssd1 vccd1 vccd1 sky130_fd_sc_hd__fill_1
XFILLER_29_99 vssd1 vssd1 vccd1 vccd1 sky130_fd_sc_hd__fill_1
Xhold55 SYNTH_INST.pwm_counter.count\[3\] vssd1 vssd1 vccd1 vccd1 net186 sky130_fd_sc_hd__dlygate4sd3_1
XFILLER_6_48 vssd1 vssd1 vccd1 vccd1 sky130_fd_sc_hd__fill_1
X_1001_ clknet_4_14_0_clk SYNTH_INST.pwm_counter.n_count\[1\] net59 vssd1 vssd1 vccd1
+ vccd1 SYNTH_INST.pwm_counter.count\[1\] sky130_fd_sc_hd__dfrtp_1
X_0716_ SYNTH_INST.pwm_counter.count\[6\] _0300_ vssd1 vssd1 vccd1 vccd1 _0305_ sky130_fd_sc_hd__nor2_1
X_0578_ SYNTH_INST.keypad.keypad_reg\[1\] SYNTH_INST.keypad.keypad_reg\[0\] vssd1
+ vssd1 vccd1 vccd1 _0209_ sky130_fd_sc_hd__nor2_1
X_0647_ SYNTH_INST.count\[3\] SYNTH_INST.count\[4\] _0258_ SYNTH_INST.count\[5\] vssd1
+ vssd1 vccd1 vccd1 _0264_ sky130_fd_sc_hd__a31o_1
Xteam_05_65 vssd1 vssd1 vccd1 vccd1 team_05_65/HI gpio_out[2] sky130_fd_sc_hd__conb_1
Xteam_05_87 vssd1 vssd1 vccd1 vccd1 team_05_87/HI gpio_out[25] sky130_fd_sc_hd__conb_1
Xteam_05_76 vssd1 vssd1 vccd1 vccd1 team_05_76/HI gpio_out[13] sky130_fd_sc_hd__conb_1
XFILLER_31_12 vssd1 vssd1 vccd1 vccd1 sky130_fd_sc_hd__fill_1
XFILLER_0_233 vssd1 vssd1 vccd1 vccd1 sky130_fd_sc_hd__fill_1
XANTENNA_input16_A nrst vssd1 vssd1 vccd1 vccd1 sky130_fd_sc_hd__diode_2
X_0501_ SYNTH_INST.waveshape.seq_div.dividend\[25\] _0128_ vssd1 vssd1 vccd1 vccd1
+ _0134_ sky130_fd_sc_hd__xor2_1
XTAP_TAPCELL_ROW_17_162 vssd1 vccd1 sky130_fd_sc_hd__tapvpwrvgnd_1
XFILLER_22_159 vssd1 vssd1 vccd1 vccd1 sky130_fd_sc_hd__fill_4
XANTENNA_input8_A gpio_in[2] vssd1 vssd1 vccd1 vccd1 sky130_fd_sc_hd__diode_2
XFILLER_26_23 vssd1 vssd1 vccd1 vccd1 sky130_fd_sc_hd__fill_4
XTAP_TAPCELL_ROW_23_187 vssd1 vccd1 sky130_fd_sc_hd__tapvpwrvgnd_1
X_0981_ clknet_4_9_0_clk _0019_ net48 vssd1 vssd1 vccd1 vccd1 SYNTH_INST.waveshape.seq_div.dividend\[23\]
+ sky130_fd_sc_hd__dfrtp_1
XFILLER_8_174 vccd1 vssd1 vccd1 vssd1 sky130_ef_sc_hd__decap_40_12
XFILLER_37_77 vssd1 vssd1 vccd1 vccd1 sky130_fd_sc_hd__fill_8
XFILLER_5_111 vssd1 vssd1 vccd1 vccd1 sky130_fd_sc_hd__fill_1
XTAP_TAPCELL_ROW_11_135 vssd1 vccd1 sky130_fd_sc_hd__tapvpwrvgnd_1
X_0964_ clknet_4_5_0_clk net6 net53 vssd1 vssd1 vccd1 vccd1 SYNTH_INST.keypad.keypad_reg\[13\]
+ sky130_fd_sc_hd__dfrtp_1
XTAP_TAPCELL_ROW_34_238 vssd1 vccd1 sky130_fd_sc_hd__tapvpwrvgnd_1
X_0895_ SYNTH_INST.waveshape.seq_div.dividend\[46\] net28 _0396_ _0429_ vssd1 vssd1
+ vccd1 vccd1 _0054_ sky130_fd_sc_hd__a22o_1
XFILLER_23_57 vssd1 vssd1 vccd1 vccd1 sky130_fd_sc_hd__fill_2
X_0680_ net192 _0285_ _0284_ vssd1 vssd1 vccd1 vccd1 SYNTH_INST.waveshape.shaper.n_sample\[0\]
+ sky130_fd_sc_hd__a21o_1
XTAP_TAPCELL_ROW_0_82 vssd1 vccd1 sky130_fd_sc_hd__tapvpwrvgnd_1
X_0947_ clknet_4_3_0_clk net96 net48 vssd1 vssd1 vccd1 vccd1 SYNTH_INST.count\[15\]
+ sky130_fd_sc_hd__dfrtp_1
XFILLER_20_213 vssd1 vssd1 vccd1 vccd1 sky130_fd_sc_hd__fill_8
X_0878_ SYNTH_INST.waveshape.seq_div.dividend\[41\] net26 _0417_ vssd1 vssd1 vccd1
+ vccd1 _0049_ sky130_fd_sc_hd__o21a_1
XFILLER_18_79 vssd1 vssd1 vccd1 vccd1 sky130_fd_sc_hd__fill_1
XFILLER_11_213 vssd1 vssd1 vccd1 vccd1 sky130_fd_sc_hd__fill_8
Xclkload0 clknet_4_0_0_clk vssd1 vssd1 vccd1 vccd1 clkload0/Y sky130_fd_sc_hd__bufinv_16
XPHY_EDGE_ROW_28_Left_67 vssd1 vssd1 vccd1 vccd1 sky130_fd_sc_hd__decap_3
X_0801_ SYNTH_INST.keypad.keypad_reg\[5\] SYNTH_INST.keypad.keypad_reg\[4\] SYNTH_INST.keypad.keypad_reg\[7\]
+ _0348_ vssd1 vssd1 vccd1 vccd1 _0359_ sky130_fd_sc_hd__and4bb_1
X_0594_ SYNTH_INST.pwm_counter.active_sample\[6\] _0077_ SYNTH_INST.pwm_counter.active_sample\[5\]
+ _0078_ _0223_ vssd1 vssd1 vccd1 vccd1 _0224_ sky130_fd_sc_hd__a221o_1
X_0732_ net165 net25 _0313_ vssd1 vssd1 vccd1 vccd1 _0007_ sky130_fd_sc_hd__o21a_1
X_0663_ SYNTH_INST.count\[10\] SYNTH_INST.count\[9\] _0268_ SYNTH_INST.count\[11\]
+ vssd1 vssd1 vccd1 vccd1 _0274_ sky130_fd_sc_hd__a31o_1
XFILLER_20_58 vssd1 vssd1 vccd1 vccd1 sky130_fd_sc_hd__fill_4
Xhold45 SYNTH_INST.waveshape.seq_div.dividend\[36\] vssd1 vssd1 vccd1 vccd1 net176
+ sky130_fd_sc_hd__dlygate4sd3_1
Xhold34 SYNTH_INST.waveshape.seq_div.dividend\[11\] vssd1 vssd1 vccd1 vccd1 net165
+ sky130_fd_sc_hd__dlygate4sd3_1
Xhold56 SYNTH_INST.waveshape.seq_div.n\[1\] vssd1 vssd1 vccd1 vccd1 net187 sky130_fd_sc_hd__dlygate4sd3_1
Xhold23 SYNTH_INST.sample_rate.n_count\[1\] vssd1 vssd1 vccd1 vccd1 net154 sky130_fd_sc_hd__dlygate4sd3_1
Xhold12 _0061_ vssd1 vssd1 vccd1 vccd1 net143 sky130_fd_sc_hd__dlygate4sd3_1
XFILLER_28_132 vssd1 vssd1 vccd1 vccd1 sky130_fd_sc_hd__fill_2
Xhold67 SYNTH_INST.waveshape.scaled_count\[4\] vssd1 vssd1 vccd1 vccd1 net198 sky130_fd_sc_hd__dlygate4sd3_1
XFILLER_3_253 vssd1 vssd1 vccd1 vccd1 sky130_fd_sc_hd__fill_2
X_1000_ clknet_4_15_0_clk SYNTH_INST.pwm_counter.n_count\[0\] net60 vssd1 vssd1 vccd1
+ vccd1 SYNTH_INST.pwm_counter.count\[0\] sky130_fd_sc_hd__dfstp_1
X_0715_ _0300_ net181 vssd1 vssd1 vccd1 vccd1 SYNTH_INST.pwm_counter.n_count\[5\]
+ sky130_fd_sc_hd__nor2_1
XANTENNA_clkbuf_0_clk_A clk vssd1 vssd1 vccd1 vccd1 sky130_fd_sc_hd__diode_2
XANTENNA_clkbuf_4_9_0_clk_A clknet_0_clk vssd1 vssd1 vccd1 vccd1 sky130_fd_sc_hd__diode_2
X_0577_ _0201_ _0208_ vssd1 vssd1 vccd1 vccd1 _0001_ sky130_fd_sc_hd__or2_1
X_0646_ SYNTH_INST.count\[5\] SYNTH_INST.count\[4\] _0260_ vssd1 vssd1 vccd1 vccd1
+ _0263_ sky130_fd_sc_hd__and3_1
Xteam_05_77 vssd1 vssd1 vccd1 vccd1 team_05_77/HI gpio_out[15] sky130_fd_sc_hd__conb_1
Xteam_05_99 vssd1 vssd1 vccd1 vccd1 gpio_oeb[0] team_05_99/LO sky130_fd_sc_hd__conb_1
Xteam_05_88 vssd1 vssd1 vccd1 vccd1 team_05_88/HI gpio_out[26] sky130_fd_sc_hd__conb_1
Xteam_05_66 vssd1 vssd1 vccd1 vccd1 team_05_66/HI gpio_out[3] sky130_fd_sc_hd__conb_1
XFILLER_25_113 vssd1 vssd1 vccd1 vccd1 sky130_fd_sc_hd__fill_1
XPHY_EDGE_ROW_19_Right_19 vssd1 vssd1 vccd1 vccd1 sky130_fd_sc_hd__decap_3
X_0500_ _0130_ _0132_ SYNTH_INST.waveshape.seq_div.dividend\[24\] vssd1 vssd1 vccd1
+ vccd1 _0133_ sky130_fd_sc_hd__a21o_1
XPHY_EDGE_ROW_28_Right_28 vssd1 vssd1 vccd1 vccd1 sky130_fd_sc_hd__decap_3
XPHY_EDGE_ROW_37_Right_37 vssd1 vssd1 vccd1 vccd1 sky130_fd_sc_hd__decap_3
XFILLER_22_138 vssd1 vssd1 vccd1 vccd1 sky130_fd_sc_hd__fill_2
XPHY_EDGE_ROW_15_Left_54 vssd1 vssd1 vccd1 vccd1 sky130_fd_sc_hd__decap_3
X_0629_ SYNTH_INST.count\[14\] _0091_ _0095_ SYNTH_INST.count\[13\] vssd1 vssd1 vccd1
+ vccd1 _0251_ sky130_fd_sc_hd__o22a_1
XTAP_TAPCELL_ROW_23_188 vssd1 vccd1 sky130_fd_sc_hd__tapvpwrvgnd_1
XTAP_TAPCELL_ROW_8_120 vssd1 vccd1 sky130_fd_sc_hd__tapvpwrvgnd_1
X_0980_ clknet_4_9_0_clk _0018_ net54 vssd1 vssd1 vccd1 vccd1 SYNTH_INST.waveshape.seq_div.dividend\[22\]
+ sky130_fd_sc_hd__dfrtp_1
XFILLER_16_90 vssd1 vssd1 vccd1 vccd1 sky130_fd_sc_hd__fill_1
XFILLER_8_186 vssd1 vssd1 vccd1 vccd1 sky130_fd_sc_hd__fill_2
XPHY_EDGE_ROW_0_Left_39 vssd1 vssd1 vccd1 vccd1 sky130_fd_sc_hd__decap_3
XFILLER_5_101 vssd1 vssd1 vccd1 vccd1 sky130_fd_sc_hd__fill_1
XFILLER_38_9 vssd1 vssd1 vccd1 vccd1 sky130_fd_sc_hd__fill_1
XTAP_TAPCELL_ROW_34_239 vssd1 vccd1 sky130_fd_sc_hd__tapvpwrvgnd_1
XFILLER_32_222 vssd1 vssd1 vccd1 vccd1 sky130_fd_sc_hd__fill_1
X_0963_ clknet_4_5_0_clk net5 net49 vssd1 vssd1 vccd1 vccd1 SYNTH_INST.keypad.keypad_reg\[12\]
+ sky130_fd_sc_hd__dfrtp_1
X_0894_ SYNTH_INST.waveshape.seq_div.dividend\[45\] net44 _0428_ SYNTH_INST.waveshape.seq_div.state\[4\]
+ vssd1 vssd1 vccd1 vccd1 _0429_ sky130_fd_sc_hd__a22o_1
XFILLER_4_82 vssd1 vssd1 vccd1 vccd1 sky130_fd_sc_hd__fill_2
XFILLER_23_36 vccd1 vssd1 vccd1 vssd1 sky130_ef_sc_hd__decap_40_12
XFILLER_0_29 vccd1 vssd1 vccd1 vssd1 sky130_ef_sc_hd__decap_40_12
XTAP_TAPCELL_ROW_0_83 vssd1 vccd1 sky130_fd_sc_hd__tapvpwrvgnd_1
X_0877_ SYNTH_INST.waveshape.seq_div.dividend\[40\] net44 _0416_ net39 net28 vssd1
+ vssd1 vccd1 vccd1 _0417_ sky130_fd_sc_hd__a221o_1
X_0946_ clknet_4_9_0_clk SYNTH_INST.oscill.n_count\[14\] net56 vssd1 vssd1 vccd1 vccd1
+ SYNTH_INST.count\[14\] sky130_fd_sc_hd__dfrtp_1
XTAP_TAPCELL_ROW_30_220 vssd1 vccd1 sky130_fd_sc_hd__tapvpwrvgnd_1
XFILLER_18_58 vssd1 vssd1 vccd1 vccd1 sky130_fd_sc_hd__fill_1
XFILLER_18_69 vssd1 vssd1 vccd1 vccd1 sky130_fd_sc_hd__fill_1
Xclkload1 clknet_4_1_0_clk vssd1 vssd1 vccd1 vccd1 clkload1/Y sky130_fd_sc_hd__clkinv_2
XPHY_EDGE_ROW_3_Left_42 vssd1 vssd1 vccd1 vccd1 sky130_fd_sc_hd__decap_3
X_0800_ SYNTH_INST.keypad.n_modekey _0343_ _0353_ vssd1 vssd1 vccd1 vccd1 _0358_ sky130_fd_sc_hd__or3_1
X_0731_ net42 SYNTH_INST.waveshape.seq_div.dividend\[10\] net30 SYNTH_INST.count\[3\]
+ net22 vssd1 vssd1 vccd1 vccd1 _0313_ sky130_fd_sc_hd__a221o_1
X_0593_ SYNTH_INST.pwm_counter.active_sample\[5\] _0078_ _0079_ SYNTH_INST.pwm_counter.active_sample\[4\]
+ _0222_ vssd1 vssd1 vccd1 vccd1 _0223_ sky130_fd_sc_hd__o221a_1
XFILLER_34_3 vssd1 vssd1 vccd1 vccd1 sky130_fd_sc_hd__fill_2
X_0662_ SYNTH_INST.count\[11\] SYNTH_INST.count\[10\] _0270_ vssd1 vssd1 vccd1 vccd1
+ _0273_ sky130_fd_sc_hd__and3_1
XANTENNA_clkbuf_4_5_0_clk_A clknet_0_clk vssd1 vssd1 vccd1 vccd1 sky130_fd_sc_hd__diode_2
X_0929_ clknet_4_11_0_clk SYNTH_INST.sample_rate.n_count\[5\] net55 vssd1 vssd1 vccd1
+ vccd1 SYNTH_INST.sample_rate.count\[5\] sky130_fd_sc_hd__dfrtp_1
Xhold13 SYNTH_INST.pwm_counter.sample\[5\] vssd1 vssd1 vccd1 vccd1 net144 sky130_fd_sc_hd__dlygate4sd3_1
Xhold68 SYNTH_INST.waveshape.scaled_count\[5\] vssd1 vssd1 vccd1 vccd1 net199 sky130_fd_sc_hd__dlygate4sd3_1
Xhold46 SYNTH_INST.freq_div.keycode\[2\] vssd1 vssd1 vccd1 vccd1 net177 sky130_fd_sc_hd__dlygate4sd3_1
Xhold57 SYNTH_INST.waveshape.seq_div.dividend\[32\] vssd1 vssd1 vccd1 vccd1 net188
+ sky130_fd_sc_hd__dlygate4sd3_1
Xhold24 SYNTH_INST.waveshape.seq_div.dividend\[14\] vssd1 vssd1 vccd1 vccd1 net155
+ sky130_fd_sc_hd__dlygate4sd3_1
Xhold35 SYNTH_INST.waveshape.seq_div.dividend\[17\] vssd1 vssd1 vccd1 vccd1 net166
+ sky130_fd_sc_hd__dlygate4sd3_1
XANTENNA_fanout41_A net43 vssd1 vssd1 vccd1 vccd1 sky130_fd_sc_hd__diode_2
XFILLER_3_221 vssd1 vssd1 vccd1 vccd1 sky130_fd_sc_hd__fill_2
XFILLER_20_9 vssd1 vssd1 vccd1 vccd1 sky130_fd_sc_hd__fill_1
X_0714_ SYNTH_INST.pwm_counter.count\[4\] _0299_ net180 vssd1 vssd1 vccd1 vccd1 _0304_
+ sky130_fd_sc_hd__a21oi_1
X_0645_ net175 _0260_ _0262_ vssd1 vssd1 vccd1 vccd1 SYNTH_INST.oscill.n_count\[4\]
+ sky130_fd_sc_hd__a21oi_1
X_0576_ SYNTH_INST.waveshape.seq_div.n\[3\] _0205_ vssd1 vssd1 vccd1 vccd1 _0208_
+ sky130_fd_sc_hd__nor2_4
Xteam_05_78 vssd1 vssd1 vccd1 vccd1 team_05_78/HI gpio_out[16] sky130_fd_sc_hd__conb_1
Xteam_05_67 vssd1 vssd1 vccd1 vccd1 team_05_67/HI gpio_out[4] sky130_fd_sc_hd__conb_1
Xteam_05_89 vssd1 vssd1 vccd1 vccd1 team_05_89/HI gpio_out[27] sky130_fd_sc_hd__conb_1
XFILLER_15_26 vssd1 vssd1 vccd1 vccd1 sky130_fd_sc_hd__fill_4
XFILLER_31_69 vssd1 vssd1 vccd1 vccd1 sky130_fd_sc_hd__fill_1
XFILLER_15_191 vssd1 vssd1 vccd1 vccd1 sky130_fd_sc_hd__fill_1
X_0628_ SYNTH_INST.count\[13\] _0095_ _0099_ SYNTH_INST.count\[12\] vssd1 vssd1 vccd1
+ vccd1 _0250_ sky130_fd_sc_hd__a22o_1
X_0559_ _0186_ _0187_ _0189_ _0191_ vssd1 vssd1 vccd1 vccd1 _0192_ sky130_fd_sc_hd__a211o_1
XFILLER_13_139 vccd1 vssd1 vccd1 vssd1 sky130_ef_sc_hd__decap_40_12
XTAP_TAPCELL_ROW_23_189 vssd1 vccd1 sky130_fd_sc_hd__tapvpwrvgnd_1
XTAP_TAPCELL_ROW_8_121 vssd1 vccd1 sky130_fd_sc_hd__tapvpwrvgnd_1
XANTENNA_clkbuf_4_13_0_clk_A clknet_0_clk vssd1 vssd1 vccd1 vccd1 sky130_fd_sc_hd__diode_2
XFILLER_29_250 vssd1 vssd1 vccd1 vccd1 sky130_fd_sc_hd__fill_4
XPHY_EDGE_ROW_32_Left_71 vssd1 vssd1 vccd1 vccd1 sky130_fd_sc_hd__decap_3
XTAP_TAPCELL_ROW_14_145 vssd1 vccd1 sky130_fd_sc_hd__tapvpwrvgnd_1
XFILLER_5_179 vccd1 vssd1 vccd1 vssd1 sky130_ef_sc_hd__decap_40_12
XFILLER_5_124 vssd1 vssd1 vccd1 vccd1 sky130_fd_sc_hd__fill_1
XFILLER_5_113 vssd1 vssd1 vccd1 vccd1 sky130_fd_sc_hd__fill_8
XFILLER_17_220 vssd1 vssd1 vccd1 vccd1 sky130_fd_sc_hd__fill_1
XFILLER_17_253 vssd1 vssd1 vccd1 vccd1 sky130_fd_sc_hd__fill_2
X_0962_ clknet_4_5_0_clk net4 net49 vssd1 vssd1 vccd1 vccd1 SYNTH_INST.keypad.keypad_reg\[11\]
+ sky130_fd_sc_hd__dfrtp_1
X_0893_ SYNTH_INST.waveshape.seq_div.dividend\[46\] _0192_ vssd1 vssd1 vccd1 vccd1
+ _0428_ sky130_fd_sc_hd__xnor2_1
XFILLER_4_190 vssd1 vssd1 vccd1 vccd1 sky130_fd_sc_hd__fill_4
XFILLER_23_15 vssd1 vssd1 vccd1 vccd1 sky130_fd_sc_hd__fill_4
XFILLER_23_48 vssd1 vssd1 vccd1 vccd1 sky130_fd_sc_hd__fill_8
XFILLER_2_149 vssd1 vssd1 vccd1 vccd1 sky130_fd_sc_hd__fill_4
Xfanout60 net61 vssd1 vssd1 vccd1 vccd1 net60 sky130_fd_sc_hd__clkbuf_4
XTAP_TAPCELL_ROW_0_84 vssd1 vccd1 sky130_fd_sc_hd__tapvpwrvgnd_1
XTAP_TAPCELL_ROW_30_221 vssd1 vccd1 sky130_fd_sc_hd__tapvpwrvgnd_1
X_0876_ SYNTH_INST.waveshape.seq_div.dividend\[41\] _0412_ vssd1 vssd1 vccd1 vccd1
+ _0416_ sky130_fd_sc_hd__xnor2_1
X_0945_ clknet_4_9_0_clk SYNTH_INST.oscill.n_count\[13\] net54 vssd1 vssd1 vccd1 vccd1
+ SYNTH_INST.count\[13\] sky130_fd_sc_hd__dfrtp_1
XANTENNA_clkbuf_4_1_0_clk_A clknet_0_clk vssd1 vssd1 vccd1 vccd1 sky130_fd_sc_hd__diode_2
XFILLER_18_15 vssd1 vssd1 vccd1 vccd1 sky130_fd_sc_hd__fill_4
XFILLER_34_25 vssd1 vssd1 vccd1 vccd1 sky130_fd_sc_hd__fill_2
Xclkload2 clknet_4_2_0_clk vssd1 vssd1 vccd1 vccd1 clkload2/Y sky130_fd_sc_hd__clkinvlp_4
X_0730_ net163 net25 _0312_ vssd1 vssd1 vccd1 vccd1 _0006_ sky130_fd_sc_hd__o21a_1
X_0661_ net171 _0270_ _0272_ vssd1 vssd1 vccd1 vccd1 SYNTH_INST.oscill.n_count\[10\]
+ sky130_fd_sc_hd__a21oi_1
X_0592_ _0079_ SYNTH_INST.pwm_counter.active_sample\[4\] SYNTH_INST.pwm_counter.active_sample\[3\]
+ _0080_ _0221_ vssd1 vssd1 vccd1 vccd1 _0222_ sky130_fd_sc_hd__a221o_1
X_0859_ _0100_ _0400_ _0109_ vssd1 vssd1 vccd1 vccd1 _0403_ sky130_fd_sc_hd__a21oi_1
X_0928_ clknet_4_11_0_clk net152 net55 vssd1 vssd1 vccd1 vccd1 SYNTH_INST.sample_rate.count\[4\]
+ sky130_fd_sc_hd__dfrtp_1
Xhold69 SYNTH_INST.pwm_counter.active_sample\[7\] vssd1 vssd1 vccd1 vccd1 net200 sky130_fd_sc_hd__dlygate4sd3_1
Xhold47 SYNTH_INST.pwm_counter.count\[7\] vssd1 vssd1 vccd1 vccd1 net178 sky130_fd_sc_hd__dlygate4sd3_1
Xhold14 _0066_ vssd1 vssd1 vccd1 vccd1 net145 sky130_fd_sc_hd__dlygate4sd3_1
Xhold36 SYNTH_INST.waveshape.seq_div.dividend\[9\] vssd1 vssd1 vccd1 vccd1 net167
+ sky130_fd_sc_hd__dlygate4sd3_1
Xhold25 SYNTH_INST.waveshape.seq_div.dividend\[20\] vssd1 vssd1 vccd1 vccd1 net156
+ sky130_fd_sc_hd__dlygate4sd3_1
Xhold58 SYNTH_INST.waveshape.scaled_count\[2\] vssd1 vssd1 vccd1 vccd1 net189 sky130_fd_sc_hd__dlygate4sd3_1
XFILLER_10_82 vssd1 vssd1 vccd1 vccd1 sky130_fd_sc_hd__fill_2
XFILLER_34_137 vssd1 vssd1 vccd1 vccd1 sky130_fd_sc_hd__fill_2
XFILLER_19_91 vssd1 vssd1 vccd1 vccd1 sky130_fd_sc_hd__fill_8
X_0713_ _0079_ _0299_ vssd1 vssd1 vccd1 vccd1 SYNTH_INST.pwm_counter.n_count\[4\]
+ sky130_fd_sc_hd__xnor2_1
X_0644_ SYNTH_INST.count\[4\] _0260_ net18 vssd1 vssd1 vccd1 vccd1 _0262_ sky130_fd_sc_hd__o21ai_1
Xteam_05_79 vssd1 vssd1 vccd1 vccd1 team_05_79/HI gpio_out[17] sky130_fd_sc_hd__conb_1
Xteam_05_68 vssd1 vssd1 vccd1 vccd1 team_05_68/HI gpio_out[5] sky130_fd_sc_hd__conb_1
X_0575_ SYNTH_INST.waveshape.seq_div.n\[4\] _0206_ vssd1 vssd1 vccd1 vccd1 _0207_
+ sky130_fd_sc_hd__nand2_1
XFILLER_33_181 vssd1 vssd1 vccd1 vccd1 sky130_fd_sc_hd__fill_4
XFILLER_0_225 vssd1 vssd1 vccd1 vccd1 sky130_fd_sc_hd__fill_8
XPHY_EDGE_ROW_1_Right_1 vssd1 vssd1 vccd1 vccd1 sky130_fd_sc_hd__decap_3
XFILLER_16_137 vssd1 vssd1 vccd1 vccd1 sky130_fd_sc_hd__fill_2
XFILLER_24_170 vssd1 vssd1 vccd1 vccd1 sky130_fd_sc_hd__fill_8
XANTENNA__0804__B1 net29 vssd1 vssd1 vccd1 vccd1 sky130_fd_sc_hd__diode_2
XFILLER_30_162 vccd1 vssd1 vccd1 vssd1 sky130_ef_sc_hd__decap_40_12
XFILLER_7_83 vccd1 vssd1 vccd1 vssd1 sky130_ef_sc_hd__decap_40_12
X_0558_ SYNTH_INST.waveshape.seq_div.dividend\[44\] SYNTH_INST.waveshape.seq_div.dividend\[45\]
+ vssd1 vssd1 vccd1 vccd1 _0191_ sky130_fd_sc_hd__or2_1
X_0627_ SYNTH_INST.count\[11\] _0162_ _0167_ SYNTH_INST.count\[10\] _0248_ vssd1 vssd1
+ vccd1 vccd1 _0249_ sky130_fd_sc_hd__a221o_1
X_0489_ _0069_ net37 _0120_ vssd1 vssd1 vccd1 vccd1 _0122_ sky130_fd_sc_hd__or3b_2
XTAP_TAPCELL_ROW_8_122 vssd1 vccd1 sky130_fd_sc_hd__tapvpwrvgnd_1
XANTENNA_input14_A gpio_in[8] vssd1 vssd1 vccd1 vccd1 sky130_fd_sc_hd__diode_2
XFILLER_32_91 vssd1 vssd1 vccd1 vccd1 sky130_fd_sc_hd__fill_1
XFILLER_8_188 vssd1 vssd1 vccd1 vccd1 sky130_fd_sc_hd__fill_1
XFILLER_12_195 vssd1 vssd1 vccd1 vccd1 sky130_fd_sc_hd__fill_1
XTAP_TAPCELL_ROW_14_146 vssd1 vccd1 sky130_fd_sc_hd__tapvpwrvgnd_1
XTAP_TAPCELL_ROW_37_249 vssd1 vccd1 sky130_fd_sc_hd__tapvpwrvgnd_1
XANTENNA_input6_A gpio_in[13] vssd1 vssd1 vccd1 vccd1 sky130_fd_sc_hd__diode_2
XFILLER_5_169 vssd1 vssd1 vccd1 vccd1 sky130_fd_sc_hd__fill_4
XFILLER_5_147 vccd1 vssd1 vccd1 vssd1 sky130_ef_sc_hd__decap_40_12
X_0961_ clknet_4_5_0_clk net3 net49 vssd1 vssd1 vccd1 vccd1 SYNTH_INST.keypad.keypad_reg\[10\]
+ sky130_fd_sc_hd__dfrtp_1
X_0892_ net202 net28 _0396_ _0427_ vssd1 vssd1 vccd1 vccd1 _0053_ sky130_fd_sc_hd__a22o_1
XFILLER_23_202 vssd1 vssd1 vccd1 vccd1 sky130_fd_sc_hd__fill_2
XFILLER_23_27 vssd1 vssd1 vccd1 vccd1 sky130_fd_sc_hd__fill_2
Xfanout50 net53 vssd1 vssd1 vccd1 vccd1 net50 sky130_fd_sc_hd__clkbuf_4
Xfanout61 SYNTH_INST.keypad.n_rst vssd1 vssd1 vccd1 vccd1 net61 sky130_fd_sc_hd__clkbuf_2
XFILLER_1_161 vssd1 vssd1 vccd1 vccd1 sky130_fd_sc_hd__fill_1
XTAP_TAPCELL_ROW_0_85 vssd1 vccd1 sky130_fd_sc_hd__tapvpwrvgnd_1
XFILLER_38_90 vssd1 vssd1 vccd1 vccd1 sky130_fd_sc_hd__fill_2
X_0944_ clknet_4_3_0_clk SYNTH_INST.oscill.n_count\[12\] net57 vssd1 vssd1 vccd1 vccd1
+ SYNTH_INST.count\[12\] sky130_fd_sc_hd__dfrtp_1
X_0875_ _0186_ _0187_ SYNTH_INST.waveshape.seq_div.dividend\[41\] SYNTH_INST.waveshape.seq_div.dividend\[40\]
+ vssd1 vssd1 vccd1 vccd1 _0415_ sky130_fd_sc_hd__a211o_1
XFILLER_11_205 vssd1 vssd1 vccd1 vccd1 sky130_fd_sc_hd__fill_1
XFILLER_11_249 vssd1 vssd1 vccd1 vccd1 sky130_fd_sc_hd__fill_2
Xclkload3 clknet_4_3_0_clk vssd1 vssd1 vccd1 vccd1 clkload3/Y sky130_fd_sc_hd__clkinv_4
XFILLER_24_70 vccd1 vssd1 vccd1 vssd1 sky130_ef_sc_hd__decap_40_12
XFILLER_6_253 vssd1 vssd1 vccd1 vccd1 sky130_fd_sc_hd__fill_2
X_0660_ SYNTH_INST.count\[10\] _0270_ net19 vssd1 vssd1 vccd1 vccd1 _0272_ sky130_fd_sc_hd__o21ai_1
X_0591_ SYNTH_INST.pwm_counter.active_sample\[3\] _0080_ SYNTH_INST.pwm_counter.active_sample\[2\]
+ _0081_ _0220_ vssd1 vssd1 vccd1 vccd1 _0221_ sky130_fd_sc_hd__o221a_1
XFILLER_37_113 vssd1 vssd1 vccd1 vccd1 sky130_fd_sc_hd__fill_4
XFILLER_37_146 vssd1 vssd1 vccd1 vccd1 sky130_fd_sc_hd__fill_2
XFILLER_1_52 vssd1 vssd1 vccd1 vccd1 sky130_fd_sc_hd__fill_4
X_0927_ clknet_4_11_0_clk SYNTH_INST.sample_rate.n_count\[3\] net55 vssd1 vssd1 vccd1
+ vccd1 SYNTH_INST.sample_rate.count\[3\] sky130_fd_sc_hd__dfrtp_1
X_0789_ _0344_ _0347_ _0349_ _0218_ net38 vssd1 vssd1 vccd1 vccd1 _0028_ sky130_fd_sc_hd__o32a_1
X_0858_ net176 _0402_ net26 vssd1 vssd1 vccd1 vccd1 _0044_ sky130_fd_sc_hd__mux2_1
XFILLER_20_17 vssd1 vssd1 vccd1 vccd1 sky130_fd_sc_hd__fill_4
Xhold15 SYNTH_INST.pwm_counter.sample\[4\] vssd1 vssd1 vccd1 vccd1 net146 sky130_fd_sc_hd__dlygate4sd3_1
Xhold59 SYNTH_INST.sample_rate.count\[3\] vssd1 vssd1 vccd1 vccd1 net190 sky130_fd_sc_hd__dlygate4sd3_1
Xhold26 SYNTH_INST.waveshape.seq_div.dividend\[19\] vssd1 vssd1 vccd1 vccd1 net157
+ sky130_fd_sc_hd__dlygate4sd3_1
Xhold37 SYNTH_INST.waveshape.seq_div.dividend\[15\] vssd1 vssd1 vccd1 vccd1 net168
+ sky130_fd_sc_hd__dlygate4sd3_1
Xhold48 SYNTH_INST.pwm_counter.count\[1\] vssd1 vssd1 vccd1 vccd1 net179 sky130_fd_sc_hd__dlygate4sd3_1
XFILLER_29_48 vssd1 vssd1 vccd1 vccd1 sky130_fd_sc_hd__fill_2
XFILLER_3_223 vssd1 vssd1 vccd1 vccd1 sky130_fd_sc_hd__fill_1
XFILLER_3_201 vssd1 vssd1 vccd1 vccd1 sky130_fd_sc_hd__fill_1
XFILLER_19_113 vssd1 vssd1 vccd1 vccd1 sky130_fd_sc_hd__fill_8
XFILLER_19_70 vssd1 vssd1 vccd1 vccd1 sky130_fd_sc_hd__fill_1
X_0643_ _0260_ _0261_ net18 vssd1 vssd1 vccd1 vccd1 SYNTH_INST.oscill.n_count\[3\]
+ sky130_fd_sc_hd__and3b_1
X_0574_ SYNTH_INST.waveshape.seq_div.n\[3\] SYNTH_INST.waveshape.seq_div.n\[2\] SYNTH_INST.waveshape.seq_div.n\[0\]
+ SYNTH_INST.waveshape.seq_div.n\[1\] vssd1 vssd1 vccd1 vccd1 _0206_ sky130_fd_sc_hd__and4b_1
X_0712_ _0299_ _0303_ vssd1 vssd1 vccd1 vccd1 SYNTH_INST.pwm_counter.n_count\[3\]
+ sky130_fd_sc_hd__nor2_1
Xteam_05_69 vssd1 vssd1 vccd1 vccd1 team_05_69/HI gpio_out[6] sky130_fd_sc_hd__conb_1
XFILLER_0_204 vccd1 vssd1 vccd1 vssd1 sky130_ef_sc_hd__decap_40_12
XFILLER_0_237 vssd1 vssd1 vccd1 vccd1 sky130_fd_sc_hd__fill_4
XFILLER_24_193 vssd1 vssd1 vccd1 vccd1 sky130_fd_sc_hd__fill_2
XTAP_TAPCELL_ROW_26_199 vssd1 vccd1 sky130_fd_sc_hd__tapvpwrvgnd_1
XFILLER_21_82 vssd1 vssd1 vccd1 vccd1 sky130_fd_sc_hd__fill_2
XANTENNA__0804__A1 net40 vssd1 vssd1 vccd1 vccd1 sky130_fd_sc_hd__diode_2
Xclkbuf_0_clk clk vssd1 vssd1 vccd1 vccd1 clknet_0_clk sky130_fd_sc_hd__clkbuf_16
XFILLER_22_108 vssd1 vssd1 vccd1 vccd1 sky130_fd_sc_hd__fill_2
XFILLER_30_130 vssd1 vssd1 vccd1 vccd1 sky130_fd_sc_hd__fill_1
XFILLER_7_95 vssd1 vssd1 vccd1 vccd1 sky130_fd_sc_hd__fill_4
XFILLER_30_141 vssd1 vssd1 vccd1 vccd1 sky130_fd_sc_hd__fill_4
XFILLER_30_152 vssd1 vssd1 vccd1 vccd1 sky130_fd_sc_hd__fill_2
XFILLER_30_174 vccd1 vssd1 vccd1 vssd1 sky130_ef_sc_hd__decap_40_12
X_0557_ _0186_ _0187_ _0189_ vssd1 vssd1 vccd1 vccd1 _0190_ sky130_fd_sc_hd__a21o_1
XPHY_EDGE_ROW_15_Right_15 vssd1 vssd1 vccd1 vccd1 sky130_fd_sc_hd__decap_3
X_0626_ SYNTH_INST.count\[9\] _0176_ _0245_ _0246_ _0247_ vssd1 vssd1 vccd1 vccd1
+ _0248_ sky130_fd_sc_hd__o221a_1
XFILLER_38_230 vssd1 vssd1 vccd1 vccd1 sky130_fd_sc_hd__fill_1
X_0488_ net32 _0120_ vssd1 vssd1 vccd1 vccd1 _0121_ sky130_fd_sc_hd__nand2_1
XPHY_EDGE_ROW_24_Right_24 vssd1 vssd1 vccd1 vccd1 sky130_fd_sc_hd__decap_3
XFILLER_26_27 vssd1 vssd1 vccd1 vccd1 sky130_fd_sc_hd__fill_1
XPHY_EDGE_ROW_33_Right_33 vssd1 vssd1 vccd1 vccd1 sky130_fd_sc_hd__decap_3
XANTENNA__1008__RESET_B net48 vssd1 vssd1 vccd1 vccd1 sky130_fd_sc_hd__diode_2
XFILLER_8_156 vssd1 vssd1 vccd1 vccd1 sky130_fd_sc_hd__fill_2
XTAP_TAPCELL_ROW_14_147 vssd1 vccd1 sky130_fd_sc_hd__tapvpwrvgnd_1
XTAP_TAPCELL_ROW_3_96 vssd1 vccd1 sky130_fd_sc_hd__tapvpwrvgnd_1
XPHY_EDGE_ROW_19_Left_58 vssd1 vssd1 vccd1 vccd1 sky130_fd_sc_hd__decap_3
XFILLER_12_29 vssd1 vssd1 vccd1 vccd1 sky130_fd_sc_hd__fill_4
XFILLER_37_26 vssd1 vssd1 vccd1 vccd1 sky130_fd_sc_hd__fill_4
X_0609_ SYNTH_INST.sample_rate.count\[3\] SYNTH_INST.sample_rate.count\[4\] _0195_
+ SYNTH_INST.sample_rate.count\[5\] vssd1 vssd1 vccd1 vccd1 _0232_ sky130_fd_sc_hd__a31o_1
XFILLER_5_159 vssd1 vssd1 vccd1 vccd1 sky130_fd_sc_hd__fill_4
X_0960_ clknet_4_5_0_clk net15 net49 vssd1 vssd1 vccd1 vccd1 SYNTH_INST.keypad.keypad_reg\[9\]
+ sky130_fd_sc_hd__dfrtp_1
X_0891_ SYNTH_INST.waveshape.seq_div.dividend\[44\] net44 _0426_ SYNTH_INST.waveshape.seq_div.state\[4\]
+ vssd1 vssd1 vccd1 vccd1 _0427_ sky130_fd_sc_hd__a22o_1
XFILLER_4_170 vssd1 vssd1 vccd1 vccd1 sky130_fd_sc_hd__fill_1
XFILLER_23_225 vssd1 vssd1 vccd1 vccd1 sky130_fd_sc_hd__fill_4
XTAP_TAPCELL_ROW_33_231 vssd1 vccd1 sky130_fd_sc_hd__tapvpwrvgnd_1
Xfanout40 SYNTH_INST.waveshape.seq_div.state\[4\] vssd1 vssd1 vccd1 vccd1 net40 sky130_fd_sc_hd__clkbuf_4
Xfanout51 net52 vssd1 vssd1 vccd1 vccd1 net51 sky130_fd_sc_hd__clkbuf_4
XFILLER_13_61 vssd1 vssd1 vccd1 vccd1 sky130_fd_sc_hd__fill_2
XTAP_TAPCELL_ROW_0_86 vssd1 vccd1 sky130_fd_sc_hd__tapvpwrvgnd_1
X_0874_ SYNTH_INST.waveshape.seq_div.dividend\[40\] net26 _0414_ vssd1 vssd1 vccd1
+ vccd1 _0048_ sky130_fd_sc_hd__o21a_1
XFILLER_9_251 vssd1 vssd1 vccd1 vccd1 sky130_fd_sc_hd__fill_1
Xclkload10 clknet_4_11_0_clk vssd1 vssd1 vccd1 vccd1 clkload10/Y sky130_fd_sc_hd__clkinv_2
X_0943_ clknet_4_6_0_clk SYNTH_INST.oscill.n_count\[11\] net52 vssd1 vssd1 vccd1 vccd1
+ SYNTH_INST.count\[11\] sky130_fd_sc_hd__dfrtp_1
XFILLER_18_39 vccd1 vssd1 vccd1 vssd1 sky130_ef_sc_hd__decap_40_12
XFILLER_34_49 vssd1 vssd1 vccd1 vccd1 sky130_fd_sc_hd__fill_1
XFILLER_34_27 vssd1 vssd1 vccd1 vccd1 sky130_fd_sc_hd__fill_1
Xclkload4 clknet_4_5_0_clk vssd1 vssd1 vccd1 vccd1 clkload4/Y sky130_fd_sc_hd__clkinv_2
XANTENNA__0843__C1 net29 vssd1 vssd1 vccd1 vccd1 sky130_fd_sc_hd__diode_2
XFILLER_24_82 vssd1 vssd1 vccd1 vccd1 sky130_fd_sc_hd__fill_2
XFILLER_6_232 vccd1 vssd1 vccd1 vssd1 sky130_ef_sc_hd__decap_40_12
X_0590_ SYNTH_INST.pwm_counter.active_sample\[2\] _0081_ SYNTH_INST.pwm_counter.active_sample\[1\]
+ _0082_ _0219_ vssd1 vssd1 vccd1 vccd1 _0220_ sky130_fd_sc_hd__a221o_1
X_0857_ net39 _0400_ _0401_ net45 SYNTH_INST.waveshape.seq_div.dividend\[35\] vssd1
+ vssd1 vccd1 vccd1 _0402_ sky130_fd_sc_hd__a32o_1
XFILLER_20_29 vssd1 vssd1 vccd1 vccd1 sky130_fd_sc_hd__fill_1
X_0926_ clknet_4_14_0_clk SYNTH_INST.sample_rate.n_count\[2\] net59 vssd1 vssd1 vccd1
+ vccd1 SYNTH_INST.sample_rate.count\[2\] sky130_fd_sc_hd__dfrtp_1
Xhold16 _0065_ vssd1 vssd1 vccd1 vccd1 net147 sky130_fd_sc_hd__dlygate4sd3_1
X_0788_ SYNTH_INST.keypad.keypad_reg\[5\] SYNTH_INST.keypad.keypad_reg\[7\] _0348_
+ SYNTH_INST.keypad.keypad_reg\[4\] vssd1 vssd1 vccd1 vccd1 _0349_ sky130_fd_sc_hd__and4bb_1
Xhold38 SYNTH_INST.count\[0\] vssd1 vssd1 vccd1 vccd1 net169 sky130_fd_sc_hd__dlygate4sd3_1
Xhold27 SYNTH_INST.waveshape.seq_div.dividend\[13\] vssd1 vssd1 vccd1 vccd1 net158
+ sky130_fd_sc_hd__dlygate4sd3_1
Xhold49 SYNTH_INST.pwm_counter.count\[5\] vssd1 vssd1 vccd1 vccd1 net180 sky130_fd_sc_hd__dlygate4sd3_1
XPHY_EDGE_ROW_7_Left_46 vssd1 vssd1 vccd1 vccd1 sky130_fd_sc_hd__decap_3
XFILLER_34_139 vssd1 vssd1 vccd1 vccd1 sky130_fd_sc_hd__fill_1
XFILLER_34_128 vssd1 vssd1 vccd1 vccd1 sky130_fd_sc_hd__fill_2
XFILLER_19_169 vccd1 vssd1 vccd1 vssd1 sky130_ef_sc_hd__decap_40_12
X_0711_ net186 _0298_ vssd1 vssd1 vccd1 vccd1 _0303_ sky130_fd_sc_hd__nor2_1
X_0573_ SYNTH_INST.waveshape.seq_div.n\[4\] _0203_ vssd1 vssd1 vccd1 vccd1 _0205_
+ sky130_fd_sc_hd__nand2_1
X_0642_ SYNTH_INST.count\[3\] _0258_ vssd1 vssd1 vccd1 vccd1 _0261_ sky130_fd_sc_hd__or2_1
XFILLER_33_161 vssd1 vssd1 vccd1 vccd1 sky130_fd_sc_hd__fill_4
Xoutput17 net17 vssd1 vssd1 vccd1 vccd1 gpio_out[14] sky130_fd_sc_hd__buf_2
X_0909_ SYNTH_INST.pwm_counter.active_sample\[1\] net136 _0208_ vssd1 vssd1 vccd1
+ vccd1 _0062_ sky130_fd_sc_hd__mux2_1
XFILLER_0_216 vssd1 vssd1 vccd1 vccd1 sky130_fd_sc_hd__fill_8
XFILLER_16_139 vssd1 vssd1 vccd1 vccd1 sky130_fd_sc_hd__fill_1
XFILLER_7_74 vssd1 vssd1 vccd1 vccd1 sky130_fd_sc_hd__fill_4
X_0625_ SYNTH_INST.count\[10\] _0167_ vssd1 vssd1 vccd1 vccd1 _0247_ sky130_fd_sc_hd__or2_1
XFILLER_30_186 vssd1 vssd1 vccd1 vccd1 sky130_fd_sc_hd__fill_2
X_0556_ SYNTH_INST.waveshape.seq_div.dividend\[43\] SYNTH_INST.waveshape.seq_div.dividend\[42\]
+ SYNTH_INST.waveshape.seq_div.dividend\[41\] SYNTH_INST.waveshape.seq_div.dividend\[40\]
+ vssd1 vssd1 vccd1 vccd1 _0189_ sky130_fd_sc_hd__or4_2
X_0487_ net34 net35 vssd1 vssd1 vccd1 vccd1 _0120_ sky130_fd_sc_hd__xor2_1
XFILLER_38_253 vssd1 vssd1 vccd1 vccd1 sky130_fd_sc_hd__fill_2
X_1039_ clknet_4_14_0_clk net133 net59 vssd1 vssd1 vccd1 vccd1 SYNTH_INST.pwm_counter.active_sample\[2\]
+ sky130_fd_sc_hd__dfrtp_1
XANTENNA__0830__S net27 vssd1 vssd1 vccd1 vccd1 sky130_fd_sc_hd__diode_2
XTAP_TAPCELL_ROW_14_148 vssd1 vccd1 sky130_fd_sc_hd__tapvpwrvgnd_1
XTAP_TAPCELL_ROW_3_97 vssd1 vccd1 sky130_fd_sc_hd__tapvpwrvgnd_1
XTAP_TAPCELL_ROW_22_181 vssd1 vccd1 sky130_fd_sc_hd__tapvpwrvgnd_1
X_0608_ net151 _0196_ _0231_ vssd1 vssd1 vccd1 vccd1 SYNTH_INST.sample_rate.n_count\[4\]
+ sky130_fd_sc_hd__a21oi_1
XTAP_TAPCELL_ROW_5_105 vssd1 vccd1 sky130_fd_sc_hd__tapvpwrvgnd_1
X_0539_ SYNTH_INST.waveshape.seq_div.dividend\[32\] _0171_ vssd1 vssd1 vccd1 vccd1
+ _0172_ sky130_fd_sc_hd__and2_1
XFILLER_26_245 vssd1 vssd1 vccd1 vccd1 sky130_fd_sc_hd__fill_4
XPHY_EDGE_ROW_36_Left_75 vssd1 vssd1 vccd1 vccd1 sky130_fd_sc_hd__decap_3
XPHY_EDGE_ROW_20_Left_59 vssd1 vssd1 vccd1 vccd1 sky130_fd_sc_hd__decap_3
X_0890_ SYNTH_INST.waveshape.seq_div.dividend\[45\] _0423_ vssd1 vssd1 vccd1 vccd1
+ _0426_ sky130_fd_sc_hd__xnor2_1
XTAP_TAPCELL_ROW_33_232 vssd1 vccd1 sky130_fd_sc_hd__tapvpwrvgnd_1
XFILLER_23_29 vssd1 vssd1 vccd1 vccd1 sky130_fd_sc_hd__fill_1
Xfanout41 net43 vssd1 vssd1 vccd1 vccd1 net41 sky130_fd_sc_hd__buf_2
Xfanout52 net53 vssd1 vssd1 vccd1 vccd1 net52 sky130_fd_sc_hd__clkbuf_4
Xfanout30 _0306_ vssd1 vssd1 vccd1 vccd1 net30 sky130_fd_sc_hd__buf_2
X_0873_ SYNTH_INST.waveshape.seq_div.dividend\[39\] net44 _0413_ net39 net28 vssd1
+ vssd1 vccd1 vccd1 _0414_ sky130_fd_sc_hd__a221o_1
X_0942_ clknet_4_3_0_clk SYNTH_INST.oscill.n_count\[10\] net52 vssd1 vssd1 vccd1 vccd1
+ SYNTH_INST.count\[10\] sky130_fd_sc_hd__dfrtp_2
Xclkload11 clknet_4_12_0_clk vssd1 vssd1 vccd1 vccd1 clkload11/X sky130_fd_sc_hd__clkbuf_8
XFILLER_18_29 vssd1 vssd1 vccd1 vccd1 sky130_fd_sc_hd__fill_2
Xclkload5 clknet_4_6_0_clk vssd1 vssd1 vccd1 vccd1 clkload5/X sky130_fd_sc_hd__clkbuf_8
XFILLER_6_211 vssd1 vssd1 vccd1 vccd1 sky130_fd_sc_hd__fill_1
XFILLER_6_244 vssd1 vssd1 vccd1 vccd1 sky130_fd_sc_hd__fill_4
XFILLER_1_21 vssd1 vssd1 vccd1 vccd1 sky130_fd_sc_hd__fill_8
XANTENNA__0834__B1 net29 vssd1 vssd1 vccd1 vccd1 sky130_fd_sc_hd__diode_2
XPHY_EDGE_ROW_23_Left_62 vssd1 vssd1 vccd1 vccd1 sky130_fd_sc_hd__decap_3
X_0787_ SYNTH_INST.keypad.keypad_reg\[6\] _0340_ vssd1 vssd1 vccd1 vccd1 _0348_ sky130_fd_sc_hd__nor2_1
X_0856_ _0107_ _0181_ _0185_ vssd1 vssd1 vccd1 vccd1 _0401_ sky130_fd_sc_hd__nand3_1
X_0925_ clknet_4_14_0_clk net154 net59 vssd1 vssd1 vccd1 vccd1 SYNTH_INST.sample_rate.count\[1\]
+ sky130_fd_sc_hd__dfrtp_1
Xhold39 SYNTH_INST.waveshape.seq_div.dividend\[22\] vssd1 vssd1 vccd1 vccd1 net170
+ sky130_fd_sc_hd__dlygate4sd3_1
Xhold28 SYNTH_INST.waveshape.seq_div.dividend\[18\] vssd1 vssd1 vccd1 vccd1 net159
+ sky130_fd_sc_hd__dlygate4sd3_1
Xhold17 SYNTH_INST.pwm_counter.sample\[3\] vssd1 vssd1 vccd1 vccd1 net148 sky130_fd_sc_hd__dlygate4sd3_1
XFILLER_36_181 vssd1 vssd1 vccd1 vccd1 sky130_fd_sc_hd__fill_4
XFILLER_3_225 vccd1 vssd1 vccd1 vssd1 sky130_ef_sc_hd__decap_40_12
XFILLER_10_63 vssd1 vssd1 vccd1 vccd1 sky130_fd_sc_hd__fill_1
XFILLER_10_85 vccd1 vssd1 vccd1 vssd1 sky130_ef_sc_hd__decap_40_12
XFILLER_19_104 vssd1 vssd1 vccd1 vccd1 sky130_fd_sc_hd__fill_8
XFILLER_19_126 vssd1 vssd1 vccd1 vccd1 sky130_fd_sc_hd__fill_1
X_0641_ SYNTH_INST.count\[3\] _0258_ vssd1 vssd1 vccd1 vccd1 _0260_ sky130_fd_sc_hd__and2_1
X_0710_ _0298_ _0302_ vssd1 vssd1 vccd1 vccd1 SYNTH_INST.pwm_counter.n_count\[2\]
+ sky130_fd_sc_hd__nor2_1
X_0572_ SYNTH_INST.waveshape.seq_div.n\[1\] SYNTH_INST.waveshape.seq_div.n\[0\] SYNTH_INST.waveshape.seq_div.n\[2\]
+ SYNTH_INST.waveshape.seq_div.state\[1\] vssd1 vssd1 vccd1 vccd1 _0204_ sky130_fd_sc_hd__nand4_1
XFILLER_33_151 vssd1 vssd1 vccd1 vccd1 sky130_fd_sc_hd__fill_2
X_0839_ SYNTH_INST.waveshape.seq_div.dividend\[31\] net41 _0385_ _0387_ vssd1 vssd1
+ vccd1 vccd1 _0388_ sky130_fd_sc_hd__a22o_1
X_0908_ SYNTH_INST.pwm_counter.active_sample\[0\] net142 _0208_ vssd1 vssd1 vccd1
+ vccd1 _0061_ sky130_fd_sc_hd__mux2_1
XFILLER_24_195 vssd1 vssd1 vccd1 vccd1 sky130_fd_sc_hd__fill_1
Xteam_05_130 vssd1 vssd1 vccd1 vccd1 gpio_oeb[32] team_05_130/LO sky130_fd_sc_hd__conb_1
XFILLER_30_121 vssd1 vssd1 vccd1 vccd1 sky130_fd_sc_hd__fill_2
XFILLER_7_53 vssd1 vssd1 vccd1 vccd1 sky130_fd_sc_hd__fill_2
X_0624_ SYNTH_INST.count\[8\] _0171_ _0176_ SYNTH_INST.count\[9\] vssd1 vssd1 vccd1
+ vccd1 _0246_ sky130_fd_sc_hd__a22o_1
X_0555_ _0186_ _0187_ vssd1 vssd1 vccd1 vccd1 _0188_ sky130_fd_sc_hd__and2_1
X_0486_ _0071_ net35 vssd1 vssd1 vccd1 vccd1 _0119_ sky130_fd_sc_hd__nor2_1
XPHY_EDGE_ROW_5_Right_5 vssd1 vssd1 vccd1 vccd1 sky130_fd_sc_hd__decap_3
XFILLER_26_29 vssd1 vssd1 vccd1 vccd1 sky130_fd_sc_hd__fill_4
X_1038_ clknet_4_14_0_clk net137 net59 vssd1 vssd1 vccd1 vccd1 SYNTH_INST.pwm_counter.active_sample\[1\]
+ sky130_fd_sc_hd__dfrtp_1
XFILLER_29_232 vssd1 vssd1 vccd1 vccd1 sky130_fd_sc_hd__fill_1
XFILLER_29_254 vssd1 vssd1 vccd1 vccd1 sky130_fd_sc_hd__fill_1
XANTENNA__1017__RESET_B net48 vssd1 vssd1 vccd1 vccd1 sky130_fd_sc_hd__diode_2
XTAP_TAPCELL_ROW_14_149 vssd1 vccd1 sky130_fd_sc_hd__tapvpwrvgnd_1
XTAP_TAPCELL_ROW_3_98 vssd1 vccd1 sky130_fd_sc_hd__tapvpwrvgnd_1
XTAP_TAPCELL_ROW_22_182 vssd1 vccd1 sky130_fd_sc_hd__tapvpwrvgnd_1
XTAP_TAPCELL_ROW_5_106 vssd1 vccd1 sky130_fd_sc_hd__tapvpwrvgnd_1
XFILLER_7_180 vccd1 vssd1 vccd1 vssd1 sky130_ef_sc_hd__decap_40_12
X_0538_ _0090_ _0119_ _0122_ vssd1 vssd1 vccd1 vccd1 _0171_ sky130_fd_sc_hd__o21a_1
X_0607_ SYNTH_INST.sample_rate.count\[4\] _0196_ _0199_ vssd1 vssd1 vccd1 vccd1 _0231_
+ sky130_fd_sc_hd__o21ai_1
X_0469_ SYNTH_INST.waveshape.seq_div.dividend\[37\] _0095_ vssd1 vssd1 vccd1 vccd1
+ _0102_ sky130_fd_sc_hd__or2_1
XFILLER_26_224 vssd1 vssd1 vccd1 vccd1 sky130_fd_sc_hd__fill_1
XTAP_TAPCELL_ROW_28_208 vssd1 vccd1 sky130_fd_sc_hd__tapvpwrvgnd_1
XANTENNA_input12_A gpio_in[6] vssd1 vssd1 vccd1 vccd1 sky130_fd_sc_hd__diode_2
XTAP_TAPCELL_ROW_10_130 vssd1 vccd1 sky130_fd_sc_hd__tapvpwrvgnd_1
XFILLER_4_194 vssd1 vssd1 vccd1 vccd1 sky130_fd_sc_hd__fill_2
XFILLER_4_161 vssd1 vssd1 vccd1 vccd1 sky130_fd_sc_hd__fill_2
XTAP_TAPCELL_ROW_33_233 vssd1 vccd1 sky130_fd_sc_hd__tapvpwrvgnd_1
XANTENNA_input4_A gpio_in[11] vssd1 vssd1 vccd1 vccd1 sky130_fd_sc_hd__diode_2
Xfanout31 _0306_ vssd1 vssd1 vccd1 vccd1 net31 sky130_fd_sc_hd__buf_2
Xfanout20 net21 vssd1 vssd1 vccd1 vccd1 net20 sky130_fd_sc_hd__buf_2
Xfanout42 net43 vssd1 vssd1 vccd1 vccd1 net42 sky130_fd_sc_hd__buf_2
Xfanout53 SYNTH_INST.keypad.n_rst vssd1 vssd1 vccd1 vccd1 net53 sky130_fd_sc_hd__buf_2
XFILLER_38_60 vccd1 vssd1 vccd1 vssd1 sky130_ef_sc_hd__decap_40_12
X_0941_ clknet_4_3_0_clk SYNTH_INST.oscill.n_count\[9\] net52 vssd1 vssd1 vccd1 vccd1
+ SYNTH_INST.count\[9\] sky130_fd_sc_hd__dfrtp_1
Xclkload12 clknet_4_13_0_clk vssd1 vssd1 vccd1 vccd1 clkload12/X sky130_fd_sc_hd__clkbuf_4
X_0872_ SYNTH_INST.waveshape.seq_div.dividend\[40\] _0188_ vssd1 vssd1 vccd1 vccd1
+ _0413_ sky130_fd_sc_hd__xnor2_1
XFILLER_18_19 vssd1 vssd1 vccd1 vccd1 sky130_fd_sc_hd__fill_2
XFILLER_34_29 vccd1 vssd1 vccd1 vssd1 sky130_ef_sc_hd__decap_40_12
Xclkload6 clknet_4_7_0_clk vssd1 vssd1 vccd1 vccd1 clkload6/X sky130_fd_sc_hd__clkbuf_4
XFILLER_24_95 vssd1 vssd1 vccd1 vccd1 sky130_fd_sc_hd__fill_4
X_0930__98 vssd1 vssd1 vccd1 vccd1 _0930__98/HI net98 sky130_fd_sc_hd__conb_1
X_0924_ clknet_4_14_0_clk SYNTH_INST.sample_rate.n_count\[0\] net59 vssd1 vssd1 vccd1
+ vccd1 SYNTH_INST.sample_rate.count\[0\] sky130_fd_sc_hd__dfrtp_1
X_0786_ SYNTH_INST.keypad.keypad_reg\[1\] SYNTH_INST.keypad.keypad_reg\[0\] _0346_
+ vssd1 vssd1 vccd1 vccd1 _0347_ sky130_fd_sc_hd__and3b_1
X_0855_ _0181_ _0185_ _0107_ vssd1 vssd1 vccd1 vccd1 _0400_ sky130_fd_sc_hd__a21o_1
Xhold18 _0064_ vssd1 vssd1 vccd1 vccd1 net149 sky130_fd_sc_hd__dlygate4sd3_1
Xhold29 SYNTH_INST.waveshape.seq_div.dividend\[16\] vssd1 vssd1 vccd1 vccd1 net160
+ sky130_fd_sc_hd__dlygate4sd3_1
XFILLER_3_237 vccd1 vssd1 vccd1 vssd1 sky130_ef_sc_hd__decap_40_12
XFILLER_10_97 vssd1 vssd1 vccd1 vccd1 sky130_fd_sc_hd__fill_4
X_0640_ _0258_ _0259_ net18 vssd1 vssd1 vccd1 vccd1 SYNTH_INST.oscill.n_count\[2\]
+ sky130_fd_sc_hd__and3b_1
X_0571_ SYNTH_INST.waveshape.seq_div.n\[1\] SYNTH_INST.waveshape.seq_div.n\[0\] SYNTH_INST.waveshape.seq_div.n\[2\]
+ SYNTH_INST.waveshape.seq_div.state\[1\] vssd1 vssd1 vccd1 vccd1 _0203_ sky130_fd_sc_hd__and4_1
XFILLER_18_3 vccd1 vssd1 vccd1 vssd1 sky130_ef_sc_hd__decap_40_12
XFILLER_33_141 vssd1 vssd1 vccd1 vccd1 sky130_fd_sc_hd__fill_2
XANTENNA__0807__B2 net40 vssd1 vssd1 vccd1 vccd1 sky130_fd_sc_hd__diode_2
XFILLER_18_182 vssd1 vssd1 vccd1 vccd1 sky130_fd_sc_hd__fill_2
XFILLER_33_185 vssd1 vssd1 vccd1 vccd1 sky130_fd_sc_hd__fill_1
X_0907_ _0205_ _0435_ vssd1 vssd1 vccd1 vccd1 _0060_ sky130_fd_sc_hd__and2_1
X_0838_ _0073_ _0386_ vssd1 vssd1 vccd1 vccd1 _0387_ sky130_fd_sc_hd__nor2_1
X_0769_ net42 SYNTH_INST.waveshape.scaled_count\[6\] net23 vssd1 vssd1 vccd1 vccd1
+ _0332_ sky130_fd_sc_hd__and3_1
XFILLER_24_141 vssd1 vssd1 vccd1 vccd1 sky130_fd_sc_hd__fill_2
XFILLER_24_185 vssd1 vssd1 vccd1 vccd1 sky130_fd_sc_hd__fill_8
Xteam_05_131 vssd1 vssd1 vccd1 vccd1 gpio_oeb[33] team_05_131/LO sky130_fd_sc_hd__conb_1
Xteam_05_120 vssd1 vssd1 vccd1 vccd1 gpio_oeb[22] team_05_120/LO sky130_fd_sc_hd__conb_1
X_0554_ _0105_ _0181_ _0185_ vssd1 vssd1 vccd1 vccd1 _0187_ sky130_fd_sc_hd__nand3b_4
X_0623_ SYNTH_INST.count\[7\] _0141_ _0171_ SYNTH_INST.count\[8\] _0244_ vssd1 vssd1
+ vccd1 vccd1 _0245_ sky130_fd_sc_hd__o221a_1
XFILLER_38_211 vssd1 vssd1 vccd1 vccd1 sky130_fd_sc_hd__fill_2
X_0485_ _0071_ net35 vssd1 vssd1 vccd1 vccd1 _0118_ sky130_fd_sc_hd__nand2_1
X_1037_ clknet_4_12_0_clk net143 net59 vssd1 vssd1 vccd1 vccd1 SYNTH_INST.pwm_counter.active_sample\[0\]
+ sky130_fd_sc_hd__dfrtp_1
XPHY_EDGE_ROW_11_Right_11 vssd1 vssd1 vccd1 vccd1 sky130_fd_sc_hd__decap_3
XTAP_TAPCELL_ROW_22_183 vssd1 vccd1 sky130_fd_sc_hd__tapvpwrvgnd_1
XTAP_TAPCELL_ROW_3_99 vssd1 vccd1 sky130_fd_sc_hd__tapvpwrvgnd_1
XPHY_EDGE_ROW_20_Right_20 vssd1 vssd1 vccd1 vccd1 sky130_fd_sc_hd__decap_3
XFILLER_7_192 vssd1 vssd1 vccd1 vccd1 sky130_fd_sc_hd__fill_1
XTAP_TAPCELL_ROW_5_107 vssd1 vccd1 sky130_fd_sc_hd__tapvpwrvgnd_1
X_0537_ _0164_ _0169_ vssd1 vssd1 vccd1 vccd1 _0170_ sky130_fd_sc_hd__nand2b_1
X_0606_ _0196_ net191 vssd1 vssd1 vccd1 vccd1 SYNTH_INST.sample_rate.n_count\[3\]
+ sky130_fd_sc_hd__nor2_1
X_0468_ SYNTH_INST.waveshape.seq_div.dividend\[37\] _0095_ vssd1 vssd1 vccd1 vccd1
+ _0101_ sky130_fd_sc_hd__nor2_1
XTAP_TAPCELL_ROW_28_209 vssd1 vccd1 sky130_fd_sc_hd__tapvpwrvgnd_1
XFILLER_32_217 vssd1 vssd1 vccd1 vccd1 sky130_fd_sc_hd__fill_2
XFILLER_32_206 vssd1 vssd1 vccd1 vccd1 sky130_fd_sc_hd__fill_2
XFILLER_17_214 vssd1 vssd1 vccd1 vccd1 sky130_fd_sc_hd__fill_1
XTAP_TAPCELL_ROW_10_131 vssd1 vccd1 sky130_fd_sc_hd__tapvpwrvgnd_1
XTAP_TAPCELL_ROW_33_234 vssd1 vccd1 sky130_fd_sc_hd__tapvpwrvgnd_1
Xfanout21 net22 vssd1 vssd1 vccd1 vccd1 net21 sky130_fd_sc_hd__clkbuf_2
XFILLER_14_217 vssd1 vssd1 vccd1 vccd1 sky130_fd_sc_hd__fill_2
Xfanout43 SYNTH_INST.waveshape.seq_div.state\[3\] vssd1 vssd1 vccd1 vccd1 net43 sky130_fd_sc_hd__dlymetal6s2s_1
Xfanout32 SYNTH_INST.freq_div.keycode\[3\] vssd1 vssd1 vccd1 vccd1 net32 sky130_fd_sc_hd__buf_2
Xfanout54 net56 vssd1 vssd1 vccd1 vccd1 net54 sky130_fd_sc_hd__clkbuf_4
XFILLER_22_250 vssd1 vssd1 vccd1 vccd1 sky130_fd_sc_hd__fill_2
XTAP_TAPCELL_ROW_0_78 vssd1 vccd1 sky130_fd_sc_hd__tapvpwrvgnd_1
XFILLER_38_72 vccd1 vssd1 vccd1 vssd1 sky130_ef_sc_hd__decap_40_12
X_0940_ clknet_4_3_0_clk SYNTH_INST.oscill.n_count\[8\] net52 vssd1 vssd1 vccd1 vccd1
+ SYNTH_INST.count\[8\] sky130_fd_sc_hd__dfrtp_1
X_0871_ _0186_ _0187_ SYNTH_INST.waveshape.seq_div.dividend\[40\] vssd1 vssd1 vccd1
+ vccd1 _0412_ sky130_fd_sc_hd__a21o_1
Xclkload13 clknet_4_14_0_clk vssd1 vssd1 vccd1 vccd1 clkload13/X sky130_fd_sc_hd__clkbuf_4
Xclkload7 clknet_4_8_0_clk vssd1 vssd1 vccd1 vccd1 clkload7/Y sky130_fd_sc_hd__clkinvlp_4
XFILLER_1_9 vccd1 vssd1 vccd1 vssd1 sky130_ef_sc_hd__decap_40_12
XANTENNA__0843__A2 net43 vssd1 vssd1 vccd1 vccd1 sky130_fd_sc_hd__diode_2
XFILLER_24_85 vssd1 vssd1 vccd1 vccd1 sky130_fd_sc_hd__fill_2
XFILLER_10_253 vssd1 vssd1 vccd1 vccd1 sky130_fd_sc_hd__fill_2
X_0923_ clknet_4_13_0_clk SYNTH_INST.waveshape.shaper.n_sample\[7\] net58 vssd1 vssd1
+ vccd1 vccd1 SYNTH_INST.pwm_counter.sample\[7\] sky130_fd_sc_hd__dfrtp_1
X_0854_ SYNTH_INST.waveshape.seq_div.dividend\[35\] net28 _0396_ _0399_ vssd1 vssd1
+ vccd1 vccd1 _0043_ sky130_fd_sc_hd__a22o_1
X_0785_ SYNTH_INST.keypad.keypad_reg\[3\] _0345_ vssd1 vssd1 vccd1 vccd1 _0346_ sky130_fd_sc_hd__and2b_1
Xhold19 SYNTH_INST.waveshape.seq_div.dividend\[8\] vssd1 vssd1 vccd1 vccd1 net150
+ sky130_fd_sc_hd__dlygate4sd3_1
XFILLER_36_194 vssd1 vssd1 vccd1 vccd1 sky130_fd_sc_hd__fill_2
XANTENNA__0825__A2 net27 vssd1 vssd1 vccd1 vccd1 sky130_fd_sc_hd__diode_2
XFILLER_3_249 vssd1 vssd1 vccd1 vccd1 sky130_fd_sc_hd__fill_4
X_0570_ SYNTH_INST.waveshape.seq_div.n\[0\] SYNTH_INST.waveshape.seq_div.state\[1\]
+ vssd1 vssd1 vccd1 vccd1 _0202_ sky130_fd_sc_hd__nand2_1
XFILLER_32_6 vccd1 vssd1 vccd1 vssd1 sky130_ef_sc_hd__decap_40_12
XFILLER_18_172 vssd1 vssd1 vccd1 vccd1 sky130_fd_sc_hd__fill_4
XFILLER_25_109 vssd1 vssd1 vccd1 vccd1 sky130_fd_sc_hd__fill_2
X_0837_ _0161_ _0174_ vssd1 vssd1 vccd1 vccd1 _0386_ sky130_fd_sc_hd__nor2_1
X_0906_ SYNTH_INST.waveshape.seq_div.n\[3\] _0203_ SYNTH_INST.waveshape.seq_div.n\[4\]
+ vssd1 vssd1 vccd1 vccd1 _0435_ sky130_fd_sc_hd__a21o_1
X_0699_ SYNTH_INST.state_machine.fsmState\[0\] _0087_ vssd1 vssd1 vccd1 vccd1 _0297_
+ sky130_fd_sc_hd__and2_1
X_0768_ net195 net20 _0331_ vssd1 vssd1 vccd1 vccd1 _0025_ sky130_fd_sc_hd__a21o_1
XFILLER_24_197 vssd1 vssd1 vccd1 vccd1 sky130_fd_sc_hd__fill_4
Xteam_05_121 vssd1 vssd1 vccd1 vccd1 gpio_oeb[23] team_05_121/LO sky130_fd_sc_hd__conb_1
Xteam_05_110 vssd1 vssd1 vccd1 vccd1 gpio_oeb[11] team_05_110/LO sky130_fd_sc_hd__conb_1
XFILLER_15_120 vssd1 vssd1 vccd1 vccd1 sky130_fd_sc_hd__fill_1
XTAP_TAPCELL_ROW_17_159 vssd1 vccd1 sky130_fd_sc_hd__tapvpwrvgnd_1
XFILLER_7_55 vssd1 vssd1 vccd1 vccd1 sky130_fd_sc_hd__fill_1
XFILLER_30_123 vssd1 vssd1 vccd1 vccd1 sky130_fd_sc_hd__fill_1
XFILLER_7_99 vssd1 vssd1 vccd1 vccd1 sky130_fd_sc_hd__fill_2
X_0553_ _0096_ _0102_ _0110_ _0105_ vssd1 vssd1 vccd1 vccd1 _0186_ sky130_fd_sc_hd__a31o_2
X_0484_ net34 net37 vssd1 vssd1 vccd1 vccd1 _0117_ sky130_fd_sc_hd__and2b_1
X_0622_ _0240_ _0242_ _0243_ vssd1 vssd1 vccd1 vccd1 _0244_ sky130_fd_sc_hd__a21o_1
XFILLER_38_223 vssd1 vssd1 vccd1 vccd1 sky130_fd_sc_hd__fill_1
X_1036_ clknet_4_12_0_clk _0060_ net57 vssd1 vssd1 vccd1 vccd1 SYNTH_INST.waveshape.seq_div.n\[4\]
+ sky130_fd_sc_hd__dfrtp_1
XFILLER_21_189 vssd1 vssd1 vccd1 vccd1 sky130_fd_sc_hd__fill_1
XFILLER_29_223 vssd1 vssd1 vccd1 vccd1 sky130_fd_sc_hd__fill_1
XFILLER_32_85 vssd1 vssd1 vccd1 vccd1 sky130_fd_sc_hd__fill_4
XFILLER_8_149 vssd1 vssd1 vccd1 vccd1 sky130_fd_sc_hd__fill_2
XFILLER_12_134 vssd1 vssd1 vccd1 vccd1 sky130_fd_sc_hd__fill_4
XTAP_TAPCELL_ROW_22_184 vssd1 vccd1 sky130_fd_sc_hd__tapvpwrvgnd_1
XFILLER_7_171 vssd1 vssd1 vccd1 vccd1 sky130_fd_sc_hd__fill_1
XTAP_TAPCELL_ROW_5_108 vssd1 vccd1 sky130_fd_sc_hd__tapvpwrvgnd_1
X_0536_ SYNTH_INST.waveshape.seq_div.dividend\[34\] _0167_ vssd1 vssd1 vccd1 vccd1
+ _0169_ sky130_fd_sc_hd__xor2_1
X_0467_ SYNTH_INST.waveshape.seq_div.dividend\[36\] _0099_ vssd1 vssd1 vccd1 vccd1
+ _0100_ sky130_fd_sc_hd__nand2_1
X_0605_ net190 _0195_ _0199_ vssd1 vssd1 vccd1 vccd1 _0230_ sky130_fd_sc_hd__o21ai_1
X_1019_ clknet_4_8_0_clk _0043_ net54 vssd1 vssd1 vccd1 vccd1 SYNTH_INST.waveshape.seq_div.dividend\[35\]
+ sky130_fd_sc_hd__dfrtp_1
XANTENNA_fanout40_X net40 vssd1 vssd1 vccd1 vccd1 sky130_fd_sc_hd__diode_2
XFILLER_27_74 vssd1 vssd1 vccd1 vccd1 sky130_fd_sc_hd__fill_1
XFILLER_4_163 vssd1 vssd1 vccd1 vccd1 sky130_fd_sc_hd__fill_1
XFILLER_4_89 vssd1 vssd1 vccd1 vccd1 sky130_fd_sc_hd__fill_1
XFILLER_4_45 vssd1 vssd1 vccd1 vccd1 sky130_fd_sc_hd__fill_1
X_0519_ net32 _0149_ _0121_ SYNTH_INST.waveshape.seq_div.dividend\[29\] vssd1 vssd1
+ vccd1 vccd1 _0152_ sky130_fd_sc_hd__o211a_1
Xfanout22 _0310_ vssd1 vssd1 vccd1 vccd1 net22 sky130_fd_sc_hd__buf_2
Xfanout44 net45 vssd1 vssd1 vccd1 vccd1 net44 sky130_fd_sc_hd__buf_2
Xfanout33 SYNTH_INST.freq_div.keycode\[3\] vssd1 vssd1 vccd1 vccd1 net33 sky130_fd_sc_hd__clkbuf_2
Xfanout55 net56 vssd1 vssd1 vccd1 vccd1 net55 sky130_fd_sc_hd__clkbuf_4
XFILLER_13_87 vssd1 vssd1 vccd1 vccd1 sky130_fd_sc_hd__fill_2
XTAP_TAPCELL_ROW_0_79 vssd1 vccd1 sky130_fd_sc_hd__tapvpwrvgnd_1
XFILLER_1_111 vssd1 vssd1 vccd1 vccd1 sky130_fd_sc_hd__fill_1
X_0870_ _0201_ net31 _0411_ net26 _0072_ vssd1 vssd1 vccd1 vccd1 _0047_ sky130_fd_sc_hd__o32ai_1
Xclkload14 clknet_4_15_0_clk vssd1 vssd1 vccd1 vccd1 clkload14/Y sky130_fd_sc_hd__clkinv_2
X_0999_ clknet_4_7_0_clk SYNTH_INST.pwm_counter.n_pwm net51 vssd1 vssd1 vccd1 vccd1
+ SYNTH_INST.pwm1 sky130_fd_sc_hd__dfrtp_1
Xclkload8 clknet_4_9_0_clk vssd1 vssd1 vccd1 vccd1 clkload8/Y sky130_fd_sc_hd__clkinv_2
XFILLER_10_210 vccd1 vssd1 vccd1 vssd1 sky130_ef_sc_hd__decap_40_12
XFILLER_1_57 vssd1 vssd1 vccd1 vccd1 sky130_fd_sc_hd__fill_2
X_0922_ clknet_4_13_0_clk SYNTH_INST.waveshape.shaper.n_sample\[6\] net58 vssd1 vssd1
+ vccd1 vccd1 SYNTH_INST.pwm_counter.sample\[6\] sky130_fd_sc_hd__dfrtp_1
X_0853_ _0397_ _0398_ SYNTH_INST.waveshape.seq_div.dividend\[34\] net45 vssd1 vssd1
+ vccd1 vccd1 _0399_ sky130_fd_sc_hd__a2bb2o_1
X_0784_ SYNTH_INST.keypad.keypad_reg\[2\] _0337_ vssd1 vssd1 vccd1 vccd1 _0345_ sky130_fd_sc_hd__nor2_1
Xinput1 en vssd1 vssd1 vccd1 vccd1 net1 sky130_fd_sc_hd__clkbuf_1
XFILLER_10_44 vssd1 vssd1 vccd1 vccd1 sky130_fd_sc_hd__fill_1
XFILLER_10_55 vssd1 vssd1 vccd1 vccd1 sky130_fd_sc_hd__fill_4
XFILLER_19_53 vssd1 vssd1 vccd1 vccd1 sky130_fd_sc_hd__fill_2
XFILLER_19_64 vssd1 vssd1 vccd1 vccd1 sky130_fd_sc_hd__fill_4
XPHY_EDGE_ROW_27_Left_66 vssd1 vssd1 vccd1 vccd1 sky130_fd_sc_hd__decap_3
XFILLER_33_165 vssd1 vssd1 vccd1 vccd1 sky130_fd_sc_hd__fill_2
XFILLER_33_143 vssd1 vssd1 vccd1 vccd1 sky130_fd_sc_hd__fill_1
XFILLER_18_184 vssd1 vssd1 vccd1 vccd1 sky130_fd_sc_hd__fill_1
X_0767_ net43 SYNTH_INST.waveshape.scaled_count\[5\] net23 vssd1 vssd1 vccd1 vccd1
+ _0331_ sky130_fd_sc_hd__and3_1
X_0836_ _0161_ _0174_ vssd1 vssd1 vccd1 vccd1 _0385_ sky130_fd_sc_hd__nand2_1
X_0905_ _0434_ _0204_ SYNTH_INST.waveshape.seq_div.n\[3\] vssd1 vssd1 vccd1 vccd1
+ _0059_ sky130_fd_sc_hd__mux2_1
X_0698_ SYNTH_INST.state_machine.fsmState\[0\] SYNTH_INST.keypad.modekey vssd1 vssd1
+ vccd1 vccd1 _0296_ sky130_fd_sc_hd__or2_1
XFILLER_24_110 vssd1 vssd1 vccd1 vccd1 sky130_fd_sc_hd__fill_1
XFILLER_24_132 vssd1 vssd1 vccd1 vccd1 sky130_fd_sc_hd__fill_2
XFILLER_24_143 vssd1 vssd1 vccd1 vccd1 sky130_fd_sc_hd__fill_1
Xteam_05_122 vssd1 vssd1 vccd1 vccd1 gpio_oeb[24] team_05_122/LO sky130_fd_sc_hd__conb_1
Xteam_05_100 vssd1 vssd1 vccd1 vccd1 gpio_oeb[1] team_05_100/LO sky130_fd_sc_hd__conb_1
Xteam_05_111 vssd1 vssd1 vccd1 vccd1 gpio_oeb[12] team_05_111/LO sky130_fd_sc_hd__conb_1
X_0621_ SYNTH_INST.count\[6\] _0098_ _0144_ _0141_ SYNTH_INST.count\[7\] vssd1 vssd1
+ vccd1 vccd1 _0243_ sky130_fd_sc_hd__a32o_1
X_0483_ SYNTH_INST.waveshape.seq_div.dividend\[27\] _0114_ vssd1 vssd1 vccd1 vccd1
+ _0116_ sky130_fd_sc_hd__and2_1
X_0552_ _0163_ _0184_ _0183_ _0170_ vssd1 vssd1 vccd1 vccd1 _0185_ sky130_fd_sc_hd__o2bb2a_1
X_1035_ clknet_4_12_0_clk _0059_ net57 vssd1 vssd1 vccd1 vccd1 SYNTH_INST.waveshape.seq_div.n\[3\]
+ sky130_fd_sc_hd__dfrtp_2
XFILLER_21_157 vssd1 vssd1 vccd1 vccd1 sky130_fd_sc_hd__fill_2
X_0819_ net40 _0370_ _0371_ net41 SYNTH_INST.waveshape.seq_div.dividend\[27\] vssd1
+ vssd1 vccd1 vccd1 _0372_ sky130_fd_sc_hd__a32o_1
XFILLER_8_117 vssd1 vssd1 vccd1 vccd1 sky130_fd_sc_hd__fill_2
XFILLER_8_139 vssd1 vssd1 vccd1 vccd1 sky130_fd_sc_hd__fill_1
XTAP_TAPCELL_ROW_22_185 vssd1 vccd1 sky130_fd_sc_hd__tapvpwrvgnd_1
XTAP_TAPCELL_ROW_13_141 vssd1 vccd1 sky130_fd_sc_hd__tapvpwrvgnd_1
XPHY_EDGE_ROW_9_Right_9 vssd1 vssd1 vccd1 vccd1 sky130_fd_sc_hd__decap_3
X_0604_ _0195_ _0199_ _0229_ vssd1 vssd1 vccd1 vccd1 SYNTH_INST.sample_rate.n_count\[2\]
+ sky130_fd_sc_hd__and3b_1
X_0535_ SYNTH_INST.waveshape.seq_div.dividend\[34\] _0167_ vssd1 vssd1 vccd1 vccd1
+ _0168_ sky130_fd_sc_hd__nand2_1
X_0466_ net33 net37 net35 _0097_ vssd1 vssd1 vccd1 vccd1 _0099_ sky130_fd_sc_hd__o31ai_2
XTAP_TAPCELL_ROW_36_244 vssd1 vccd1 sky130_fd_sc_hd__tapvpwrvgnd_1
X_1018_ clknet_4_2_0_clk _0042_ net54 vssd1 vssd1 vccd1 vccd1 SYNTH_INST.waveshape.seq_div.dividend\[34\]
+ sky130_fd_sc_hd__dfrtp_1
XPHY_EDGE_ROW_14_Left_53 vssd1 vssd1 vccd1 vccd1 sky130_fd_sc_hd__decap_3
XFILLER_32_208 vssd1 vssd1 vccd1 vccd1 sky130_fd_sc_hd__fill_1
X_0518_ SYNTH_INST.waveshape.seq_div.dividend\[29\] _0150_ vssd1 vssd1 vccd1 vccd1
+ _0151_ sky130_fd_sc_hd__and2b_1
X_0449_ SYNTH_INST.pwm_counter.count\[1\] vssd1 vssd1 vccd1 vccd1 _0082_ sky130_fd_sc_hd__inv_2
Xfanout45 net46 vssd1 vssd1 vccd1 vccd1 net45 sky130_fd_sc_hd__clkbuf_2
Xfanout56 net61 vssd1 vssd1 vccd1 vccd1 net56 sky130_fd_sc_hd__clkbuf_4
Xfanout34 SYNTH_INST.freq_div.keycode\[2\] vssd1 vssd1 vccd1 vccd1 net34 sky130_fd_sc_hd__clkbuf_4
Xfanout23 net24 vssd1 vssd1 vccd1 vccd1 net23 sky130_fd_sc_hd__clkbuf_2
XFILLER_13_77 vssd1 vssd1 vccd1 vccd1 sky130_fd_sc_hd__fill_2
XANTENNA_input10_A gpio_in[4] vssd1 vssd1 vccd1 vccd1 sky130_fd_sc_hd__diode_2
XTAP_TAPCELL_ROW_30_217 vssd1 vccd1 sky130_fd_sc_hd__tapvpwrvgnd_1
Xclkload9 clknet_4_10_0_clk vssd1 vssd1 vccd1 vccd1 clkload9/Y sky130_fd_sc_hd__clkinvlp_4
X_0998_ clknet_4_4_0_clk _0031_ net50 vssd1 vssd1 vccd1 vccd1 SYNTH_INST.freq_div.keycode\[3\]
+ sky130_fd_sc_hd__dfrtp_1
XANTENNA_input2_A gpio_in[0] vssd1 vssd1 vccd1 vccd1 sky130_fd_sc_hd__diode_2
XFILLER_10_222 vccd1 vssd1 vccd1 vssd1 sky130_ef_sc_hd__decap_40_12
XFILLER_6_248 vssd1 vssd1 vccd1 vccd1 sky130_fd_sc_hd__fill_1
XFILLER_37_108 vssd1 vssd1 vccd1 vccd1 sky130_fd_sc_hd__fill_4
XANTENNA__0819__A1 net40 vssd1 vssd1 vccd1 vccd1 sky130_fd_sc_hd__diode_2
X_0921_ clknet_4_13_0_clk SYNTH_INST.waveshape.shaper.n_sample\[5\] net58 vssd1 vssd1
+ vccd1 vccd1 SYNTH_INST.pwm_counter.sample\[5\] sky130_fd_sc_hd__dfrtp_1
X_0852_ _0164_ _0168_ _0393_ _0073_ vssd1 vssd1 vccd1 vccd1 _0398_ sky130_fd_sc_hd__a31o_1
X_0783_ _0336_ _0343_ _0339_ _0342_ vssd1 vssd1 vccd1 vccd1 _0344_ sky130_fd_sc_hd__or4b_1
XTAP_TAPCELL_ROW_1_90 vssd1 vccd1 sky130_fd_sc_hd__tapvpwrvgnd_1
Xinput2 gpio_in[0] vssd1 vssd1 vccd1 vccd1 net2 sky130_fd_sc_hd__clkbuf_1
XFILLER_10_67 vssd1 vssd1 vccd1 vccd1 sky130_fd_sc_hd__fill_2
XFILLER_19_43 vssd1 vssd1 vccd1 vccd1 sky130_fd_sc_hd__fill_2
XFILLER_27_163 vssd1 vssd1 vccd1 vccd1 sky130_fd_sc_hd__fill_4
XPHY_EDGE_ROW_2_Left_41 vssd1 vssd1 vccd1 vccd1 sky130_fd_sc_hd__decap_3
XFILLER_33_111 vssd1 vssd1 vccd1 vccd1 sky130_fd_sc_hd__fill_1
XFILLER_18_141 vssd1 vssd1 vccd1 vccd1 sky130_fd_sc_hd__fill_2
X_0904_ SYNTH_INST.waveshape.seq_div.n\[4\] _0204_ vssd1 vssd1 vccd1 vccd1 _0434_
+ sky130_fd_sc_hd__nor2_1
X_0697_ _0086_ _0293_ _0295_ vssd1 vssd1 vccd1 vccd1 SYNTH_INST.waveshape.shaper.n_sample\[7\]
+ sky130_fd_sc_hd__o21a_1
X_0766_ net199 net20 _0330_ vssd1 vssd1 vccd1 vccd1 _0024_ sky130_fd_sc_hd__a21o_1
X_0835_ SYNTH_INST.waveshape.seq_div.dividend\[31\] net27 _0383_ _0384_ vssd1 vssd1
+ vccd1 vccd1 _0039_ sky130_fd_sc_hd__o22a_1
Xteam_05_101 vssd1 vssd1 vccd1 vccd1 gpio_oeb[2] team_05_101/LO sky130_fd_sc_hd__conb_1
Xteam_05_123 vssd1 vssd1 vccd1 vccd1 gpio_oeb[25] team_05_123/LO sky130_fd_sc_hd__conb_1
Xteam_05_112 vssd1 vssd1 vccd1 vccd1 gpio_oeb[13] team_05_112/LO sky130_fd_sc_hd__conb_1
XFILLER_15_177 vssd1 vssd1 vccd1 vccd1 sky130_fd_sc_hd__fill_2
XFILLER_7_57 vssd1 vssd1 vccd1 vccd1 sky130_fd_sc_hd__fill_8
X_0551_ SYNTH_INST.waveshape.seq_div.dividend\[35\] _0162_ _0167_ SYNTH_INST.waveshape.seq_div.dividend\[34\]
+ vssd1 vssd1 vccd1 vccd1 _0184_ sky130_fd_sc_hd__a22o_1
X_0620_ _0084_ _0150_ _0241_ vssd1 vssd1 vccd1 vccd1 _0242_ sky130_fd_sc_hd__a21oi_1
XFILLER_38_225 vssd1 vssd1 vccd1 vccd1 sky130_fd_sc_hd__fill_2
X_0482_ SYNTH_INST.waveshape.seq_div.dividend\[27\] _0114_ vssd1 vssd1 vccd1 vccd1
+ _0115_ sky130_fd_sc_hd__nor2_1
X_1034_ clknet_4_14_0_clk _0058_ net59 vssd1 vssd1 vccd1 vccd1 SYNTH_INST.waveshape.seq_div.n\[2\]
+ sky130_fd_sc_hd__dfrtp_1
XANTENNA_clkbuf_4_8_0_clk_A clknet_0_clk vssd1 vssd1 vccd1 vccd1 sky130_fd_sc_hd__diode_2
X_0818_ _0116_ _0140_ _0155_ vssd1 vssd1 vccd1 vccd1 _0371_ sky130_fd_sc_hd__or3_1
XTAP_TAPCELL_ROW_8_118 vssd1 vccd1 sky130_fd_sc_hd__tapvpwrvgnd_1
X_0749_ net46 SYNTH_INST.waveshape.seq_div.dividend\[19\] net31 SYNTH_INST.count\[12\]
+ net21 vssd1 vssd1 vccd1 vccd1 _0322_ sky130_fd_sc_hd__a221o_1
XFILLER_11_191 vssd1 vssd1 vccd1 vccd1 sky130_fd_sc_hd__fill_1
XTAP_TAPCELL_ROW_13_142 vssd1 vccd1 sky130_fd_sc_hd__tapvpwrvgnd_1
X_0534_ net32 _0165_ _0166_ vssd1 vssd1 vccd1 vccd1 _0167_ sky130_fd_sc_hd__o21ai_4
X_0603_ SYNTH_INST.sample_rate.count\[1\] SYNTH_INST.sample_rate.count\[0\] SYNTH_INST.sample_rate.count\[2\]
+ vssd1 vssd1 vccd1 vccd1 _0229_ sky130_fd_sc_hd__a21o_1
X_0465_ net33 _0097_ vssd1 vssd1 vccd1 vccd1 _0098_ sky130_fd_sc_hd__nand2_1
XTAP_TAPCELL_ROW_36_245 vssd1 vccd1 sky130_fd_sc_hd__tapvpwrvgnd_1
XFILLER_34_250 vssd1 vssd1 vccd1 vccd1 sky130_fd_sc_hd__fill_2
X_1017_ clknet_4_2_0_clk _0041_ net48 vssd1 vssd1 vccd1 vccd1 SYNTH_INST.waveshape.seq_div.dividend\[33\]
+ sky130_fd_sc_hd__dfrtp_1
XPHY_EDGE_ROW_31_Left_70 vssd1 vssd1 vccd1 vccd1 sky130_fd_sc_hd__decap_3
X_0517_ net32 _0149_ _0121_ vssd1 vssd1 vccd1 vccd1 _0150_ sky130_fd_sc_hd__o21ai_1
X_0448_ SYNTH_INST.pwm_counter.count\[2\] vssd1 vssd1 vccd1 vccd1 _0081_ sky130_fd_sc_hd__inv_2
Xfanout24 net25 vssd1 vssd1 vccd1 vccd1 net24 sky130_fd_sc_hd__clkbuf_2
Xfanout35 net36 vssd1 vssd1 vccd1 vccd1 net35 sky130_fd_sc_hd__clkbuf_4
Xfanout46 SYNTH_INST.waveshape.seq_div.state\[3\] vssd1 vssd1 vccd1 vccd1 net46 sky130_fd_sc_hd__clkbuf_2
XFILLER_22_253 vssd1 vssd1 vccd1 vccd1 sky130_fd_sc_hd__fill_2
Xfanout57 net58 vssd1 vssd1 vccd1 vccd1 net57 sky130_fd_sc_hd__clkbuf_4
XFILLER_38_97 vssd1 vssd1 vccd1 vccd1 sky130_fd_sc_hd__fill_4
XFILLER_38_42 vssd1 vssd1 vccd1 vccd1 sky130_fd_sc_hd__fill_1
XFILLER_13_253 vssd1 vssd1 vccd1 vccd1 sky130_fd_sc_hd__fill_2
XTAP_TAPCELL_ROW_30_218 vssd1 vccd1 sky130_fd_sc_hd__tapvpwrvgnd_1
X_0997_ clknet_4_7_0_clk _0030_ net51 vssd1 vssd1 vccd1 vccd1 SYNTH_INST.freq_div.keycode\[2\]
+ sky130_fd_sc_hd__dfrtp_1
XFILLER_5_90 vssd1 vssd1 vccd1 vccd1 sky130_fd_sc_hd__fill_4
XFILLER_10_201 vssd1 vssd1 vccd1 vccd1 sky130_fd_sc_hd__fill_2
XFILLER_10_234 vccd1 vssd1 vccd1 vssd1 sky130_ef_sc_hd__decap_40_12
XFILLER_24_99 vssd1 vssd1 vccd1 vccd1 sky130_fd_sc_hd__fill_1
X_0920_ clknet_4_13_0_clk SYNTH_INST.waveshape.shaper.n_sample\[4\] net58 vssd1 vssd1
+ vccd1 vccd1 SYNTH_INST.pwm_counter.sample\[4\] sky130_fd_sc_hd__dfrtp_1
X_0782_ SYNTH_INST.keypad.keypad_reg\[8\] _0212_ _0215_ _0334_ vssd1 vssd1 vccd1 vccd1
+ _0343_ sky130_fd_sc_hd__and4_1
X_0851_ _0168_ _0393_ _0164_ vssd1 vssd1 vccd1 vccd1 _0397_ sky130_fd_sc_hd__a21oi_1
XPHY_EDGE_ROW_18_Right_18 vssd1 vssd1 vccd1 vccd1 sky130_fd_sc_hd__decap_3
Xinput3 gpio_in[10] vssd1 vssd1 vccd1 vccd1 net3 sky130_fd_sc_hd__clkbuf_1
XPHY_EDGE_ROW_27_Right_27 vssd1 vssd1 vccd1 vccd1 sky130_fd_sc_hd__decap_3
XPHY_EDGE_ROW_36_Right_36 vssd1 vssd1 vccd1 vccd1 sky130_fd_sc_hd__decap_3
XFILLER_19_55 vssd1 vssd1 vccd1 vccd1 sky130_fd_sc_hd__fill_1
XFILLER_19_99 vssd1 vssd1 vccd1 vccd1 sky130_fd_sc_hd__fill_1
XFILLER_2_241 vssd1 vssd1 vccd1 vccd1 sky130_fd_sc_hd__fill_8
XFILLER_33_167 vssd1 vssd1 vccd1 vccd1 sky130_fd_sc_hd__fill_1
X_0834_ SYNTH_INST.waveshape.seq_div.dividend\[30\] net41 net29 vssd1 vssd1 vccd1
+ vccd1 _0384_ sky130_fd_sc_hd__a21o_1
X_0903_ _0204_ _0433_ vssd1 vssd1 vccd1 vccd1 _0058_ sky130_fd_sc_hd__and2_1
X_0696_ _0086_ _0293_ _0294_ vssd1 vssd1 vccd1 vccd1 _0295_ sky130_fd_sc_hd__a21oi_1
X_0765_ net43 SYNTH_INST.waveshape.scaled_count\[4\] net23 vssd1 vssd1 vccd1 vccd1
+ _0330_ sky130_fd_sc_hd__and3_1
XANTENNA_clkbuf_4_4_0_clk_A clknet_0_clk vssd1 vssd1 vccd1 vccd1 sky130_fd_sc_hd__diode_2
XTAP_TAPCELL_ROW_19_170 vssd1 vccd1 sky130_fd_sc_hd__tapvpwrvgnd_1
XFILLER_24_178 vssd1 vssd1 vccd1 vccd1 sky130_fd_sc_hd__fill_1
XFILLER_21_78 vssd1 vssd1 vccd1 vccd1 sky130_fd_sc_hd__fill_4
Xteam_05_113 vssd1 vssd1 vccd1 vccd1 gpio_oeb[15] team_05_113/LO sky130_fd_sc_hd__conb_1
Xteam_05_102 vssd1 vssd1 vccd1 vccd1 gpio_oeb[3] team_05_102/LO sky130_fd_sc_hd__conb_1
Xteam_05_124 vssd1 vssd1 vccd1 vccd1 gpio_oeb[26] team_05_124/LO sky130_fd_sc_hd__conb_1
XFILLER_15_167 vssd1 vssd1 vccd1 vccd1 sky130_fd_sc_hd__fill_1
XFILLER_15_189 vssd1 vssd1 vccd1 vccd1 sky130_fd_sc_hd__fill_2
XTAP_TAPCELL_ROW_25_195 vssd1 vccd1 sky130_fd_sc_hd__tapvpwrvgnd_1
X_0550_ _0177_ _0182_ vssd1 vssd1 vccd1 vccd1 _0183_ sky130_fd_sc_hd__nand2_1
X_0481_ net33 _0071_ _0112_ _0111_ _0095_ vssd1 vssd1 vccd1 vccd1 _0114_ sky130_fd_sc_hd__o32a_1
X_1033_ clknet_4_14_0_clk _0057_ net59 vssd1 vssd1 vccd1 vccd1 SYNTH_INST.waveshape.seq_div.n\[1\]
+ sky130_fd_sc_hd__dfrtp_1
X_0817_ _0116_ _0140_ _0155_ vssd1 vssd1 vccd1 vccd1 _0370_ sky130_fd_sc_hd__o21ai_2
XFILLER_21_159 vssd1 vssd1 vccd1 vccd1 sky130_fd_sc_hd__fill_1
X_0679_ SYNTH_INST.state_machine.fsmState\[1\] SYNTH_INST.mode\[1\] vssd1 vssd1 vccd1
+ vccd1 _0285_ sky130_fd_sc_hd__and2_2
XTAP_TAPCELL_ROW_8_119 vssd1 vccd1 sky130_fd_sc_hd__tapvpwrvgnd_1
X_0748_ net157 net23 _0321_ vssd1 vssd1 vccd1 vccd1 _0015_ sky130_fd_sc_hd__o21a_1
XFILLER_16_23 vssd1 vssd1 vccd1 vccd1 sky130_fd_sc_hd__fill_4
XFILLER_29_204 vssd1 vssd1 vccd1 vccd1 sky130_fd_sc_hd__fill_2
XFILLER_32_22 vssd1 vssd1 vccd1 vccd1 sky130_fd_sc_hd__fill_2
XPHY_EDGE_ROW_0_Right_0 vssd1 vssd1 vccd1 vccd1 sky130_fd_sc_hd__decap_3
XFILLER_12_148 vssd1 vssd1 vccd1 vccd1 sky130_fd_sc_hd__fill_4
XTAP_TAPCELL_ROW_13_143 vssd1 vccd1 sky130_fd_sc_hd__tapvpwrvgnd_1
XANTENNA__0810__C net40 vssd1 vssd1 vccd1 vccd1 sky130_fd_sc_hd__diode_2
X_0533_ net37 _0120_ _0089_ _0069_ vssd1 vssd1 vccd1 vccd1 _0166_ sky130_fd_sc_hd__a211o_1
X_0464_ net37 net35 net34 vssd1 vssd1 vccd1 vccd1 _0097_ sky130_fd_sc_hd__o21ai_2
X_0602_ net153 SYNTH_INST.sample_rate.count\[0\] _0228_ vssd1 vssd1 vccd1 vccd1 SYNTH_INST.sample_rate.n_count\[1\]
+ sky130_fd_sc_hd__a21oi_1
XTAP_TAPCELL_ROW_36_246 vssd1 vccd1 sky130_fd_sc_hd__tapvpwrvgnd_1
X_1016_ clknet_4_2_0_clk _0040_ net48 vssd1 vssd1 vccd1 vccd1 SYNTH_INST.waveshape.seq_div.dividend\[32\]
+ sky130_fd_sc_hd__dfrtp_1
XTAP_TAPCELL_ROW_4_100 vssd1 vccd1 sky130_fd_sc_hd__tapvpwrvgnd_1
XFILLER_27_55 vssd1 vssd1 vccd1 vccd1 sky130_fd_sc_hd__fill_1
XFILLER_27_66 vssd1 vssd1 vccd1 vccd1 sky130_fd_sc_hd__fill_8
XFILLER_4_26 vssd1 vssd1 vccd1 vccd1 sky130_fd_sc_hd__fill_2
XANTENNA_clkbuf_4_12_0_clk_A clknet_0_clk vssd1 vssd1 vccd1 vccd1 sky130_fd_sc_hd__diode_2
X_0447_ SYNTH_INST.pwm_counter.count\[3\] vssd1 vssd1 vccd1 vccd1 _0080_ sky130_fd_sc_hd__inv_2
X_0516_ _0111_ _0126_ vssd1 vssd1 vccd1 vccd1 _0149_ sky130_fd_sc_hd__nor2_1
XFILLER_13_57 vssd1 vssd1 vccd1 vccd1 sky130_fd_sc_hd__fill_4
Xfanout25 _0309_ vssd1 vssd1 vccd1 vccd1 net25 sky130_fd_sc_hd__buf_2
Xfanout47 net48 vssd1 vssd1 vccd1 vccd1 net47 sky130_fd_sc_hd__clkbuf_4
Xfanout58 net61 vssd1 vssd1 vccd1 vccd1 net58 sky130_fd_sc_hd__clkbuf_4
Xfanout36 SYNTH_INST.freq_div.keycode\[1\] vssd1 vssd1 vccd1 vccd1 net36 sky130_fd_sc_hd__dlymetal6s2s_1
XFILLER_8_6 vccd1 vssd1 vccd1 vssd1 sky130_ef_sc_hd__decap_40_12
XFILLER_1_169 vssd1 vssd1 vccd1 vccd1 sky130_fd_sc_hd__fill_1
XFILLER_9_225 vccd1 vssd1 vccd1 vssd1 sky130_ef_sc_hd__decap_40_12
XTAP_TAPCELL_ROW_30_219 vssd1 vccd1 sky130_fd_sc_hd__tapvpwrvgnd_1
X_0996_ clknet_4_6_0_clk _0029_ net51 vssd1 vssd1 vccd1 vccd1 SYNTH_INST.freq_div.keycode\[1\]
+ sky130_fd_sc_hd__dfrtp_1
XFILLER_10_246 vssd1 vssd1 vccd1 vccd1 sky130_fd_sc_hd__fill_2
X_0850_ _0201_ net31 vssd1 vssd1 vccd1 vccd1 _0396_ sky130_fd_sc_hd__nor2_2
X_0781_ _0340_ _0341_ vssd1 vssd1 vccd1 vccd1 _0342_ sky130_fd_sc_hd__or2_1
Xinput4 gpio_in[11] vssd1 vssd1 vccd1 vccd1 net4 sky130_fd_sc_hd__clkbuf_1
XFILLER_3_209 vccd1 vssd1 vccd1 vssd1 sky130_ef_sc_hd__decap_40_12
XANTENNA_clkbuf_4_0_0_clk_A clknet_0_clk vssd1 vssd1 vccd1 vccd1 sky130_fd_sc_hd__diode_2
X_0979_ clknet_4_9_0_clk _0017_ net56 vssd1 vssd1 vccd1 vccd1 SYNTH_INST.waveshape.seq_div.dividend\[21\]
+ sky130_fd_sc_hd__dfrtp_1
XFILLER_10_69 vssd1 vssd1 vccd1 vccd1 sky130_fd_sc_hd__fill_1
XFILLER_19_45 vssd1 vssd1 vccd1 vccd1 sky130_fd_sc_hd__fill_1
XFILLER_2_253 vssd1 vssd1 vccd1 vccd1 sky130_fd_sc_hd__fill_2
XFILLER_25_9 vccd1 vssd1 vccd1 vssd1 sky130_ef_sc_hd__decap_40_12
XFILLER_18_110 vssd1 vssd1 vccd1 vccd1 sky130_fd_sc_hd__fill_8
XFILLER_18_143 vssd1 vssd1 vccd1 vccd1 sky130_fd_sc_hd__fill_1
X_0833_ net40 _0381_ _0382_ vssd1 vssd1 vccd1 vccd1 _0383_ sky130_fd_sc_hd__and3_1
X_0902_ SYNTH_INST.waveshape.seq_div.n\[1\] SYNTH_INST.waveshape.seq_div.n\[0\] SYNTH_INST.waveshape.seq_div.state\[1\]
+ SYNTH_INST.waveshape.seq_div.n\[2\] vssd1 vssd1 vccd1 vccd1 _0433_ sky130_fd_sc_hd__a31o_1
X_0695_ SYNTH_INST.state_machine.fsmState\[1\] SYNTH_INST.mode\[1\] vssd1 vssd1 vccd1
+ vccd1 _0294_ sky130_fd_sc_hd__nor2_1
X_0764_ net198 net20 _0329_ vssd1 vssd1 vccd1 vccd1 _0023_ sky130_fd_sc_hd__a21o_1
XTAP_TAPCELL_ROW_19_171 vssd1 vccd1 sky130_fd_sc_hd__tapvpwrvgnd_1
Xteam_05_125 vssd1 vssd1 vccd1 vccd1 gpio_oeb[27] team_05_125/LO sky130_fd_sc_hd__conb_1
Xteam_05_114 vssd1 vssd1 vccd1 vccd1 gpio_oeb[16] team_05_114/LO sky130_fd_sc_hd__conb_1
Xteam_05_103 vssd1 vssd1 vccd1 vccd1 gpio_oeb[4] team_05_103/LO sky130_fd_sc_hd__conb_1
XFILLER_15_113 vssd1 vssd1 vccd1 vccd1 sky130_fd_sc_hd__fill_1
XFILLER_15_146 vssd1 vssd1 vccd1 vccd1 sky130_fd_sc_hd__fill_1
XTAP_TAPCELL_ROW_25_196 vssd1 vccd1 sky130_fd_sc_hd__tapvpwrvgnd_1
XFILLER_11_90 vssd1 vssd1 vccd1 vccd1 sky130_fd_sc_hd__fill_2
X_0480_ net38 net35 vssd1 vssd1 vccd1 vccd1 _0113_ sky130_fd_sc_hd__xnor2_1
XFILLER_38_216 vssd1 vssd1 vccd1 vccd1 sky130_fd_sc_hd__fill_4
X_1032_ clknet_4_14_0_clk _0056_ net59 vssd1 vssd1 vccd1 vccd1 SYNTH_INST.waveshape.seq_div.n\[0\]
+ sky130_fd_sc_hd__dfrtp_1
XFILLER_23_6 vssd1 vssd1 vccd1 vccd1 sky130_fd_sc_hd__fill_4
X_0816_ net183 _0369_ net27 vssd1 vssd1 vccd1 vccd1 _0035_ sky130_fd_sc_hd__mux2_1
X_0747_ net46 SYNTH_INST.waveshape.seq_div.dividend\[18\] net31 SYNTH_INST.count\[11\]
+ net20 vssd1 vssd1 vccd1 vccd1 _0321_ sky130_fd_sc_hd__a221o_1
X_0678_ SYNTH_INST.state_machine.fsmState\[1\] _0085_ SYNTH_INST.waveshape.scaled_count\[7\]
+ vssd1 vssd1 vccd1 vccd1 _0284_ sky130_fd_sc_hd__and3_2
XFILLER_32_89 vssd1 vssd1 vccd1 vccd1 sky130_fd_sc_hd__fill_2
XFILLER_12_105 vssd1 vssd1 vccd1 vccd1 sky130_fd_sc_hd__fill_1
XFILLER_12_138 vssd1 vssd1 vccd1 vccd1 sky130_fd_sc_hd__fill_2
XTAP_TAPCELL_ROW_13_144 vssd1 vccd1 sky130_fd_sc_hd__tapvpwrvgnd_1
X_0601_ SYNTH_INST.sample_rate.count\[1\] SYNTH_INST.sample_rate.count\[0\] _0227_
+ vssd1 vssd1 vccd1 vccd1 _0228_ sky130_fd_sc_hd__o21ai_1
X_0463_ SYNTH_INST.waveshape.seq_div.dividend\[37\] _0095_ vssd1 vssd1 vccd1 vccd1
+ _0096_ sky130_fd_sc_hd__nand2_1
X_0532_ _0117_ _0126_ _0111_ vssd1 vssd1 vccd1 vccd1 _0165_ sky130_fd_sc_hd__o21ba_1
XFILLER_21_3 vssd1 vssd1 vccd1 vccd1 sky130_fd_sc_hd__fill_2
XTAP_TAPCELL_ROW_36_247 vssd1 vccd1 sky130_fd_sc_hd__tapvpwrvgnd_1
X_1015_ clknet_4_0_0_clk _0039_ net48 vssd1 vssd1 vccd1 vccd1 SYNTH_INST.waveshape.seq_div.dividend\[31\]
+ sky130_fd_sc_hd__dfrtp_1
XTAP_TAPCELL_ROW_4_101 vssd1 vccd1 sky130_fd_sc_hd__tapvpwrvgnd_1
XFILLER_27_23 vssd1 vssd1 vccd1 vccd1 sky130_fd_sc_hd__fill_4
XFILLER_4_178 vccd1 vssd1 vccd1 vssd1 sky130_ef_sc_hd__decap_40_12
XFILLER_4_145 vccd1 vssd1 vccd1 vssd1 sky130_ef_sc_hd__decap_40_12
XFILLER_31_222 vssd1 vssd1 vccd1 vccd1 sky130_fd_sc_hd__fill_2
XPHY_EDGE_ROW_18_Left_57 vssd1 vssd1 vccd1 vccd1 sky130_fd_sc_hd__decap_3
X_0446_ SYNTH_INST.pwm_counter.count\[4\] vssd1 vssd1 vccd1 vccd1 _0079_ sky130_fd_sc_hd__inv_2
X_0515_ _0145_ _0146_ _0143_ vssd1 vssd1 vccd1 vccd1 _0148_ sky130_fd_sc_hd__or3b_1
Xfanout26 net27 vssd1 vssd1 vccd1 vccd1 net26 sky130_fd_sc_hd__clkbuf_4
Xfanout37 net38 vssd1 vssd1 vccd1 vccd1 net37 sky130_fd_sc_hd__buf_2
Xfanout48 SYNTH_INST.keypad.n_rst vssd1 vssd1 vccd1 vccd1 net48 sky130_fd_sc_hd__clkbuf_4
Xfanout59 net60 vssd1 vssd1 vccd1 vccd1 net59 sky130_fd_sc_hd__clkbuf_4
XFILLER_1_115 vssd1 vssd1 vccd1 vccd1 sky130_fd_sc_hd__fill_4
XFILLER_38_55 vssd1 vssd1 vccd1 vccd1 sky130_fd_sc_hd__fill_1
XFILLER_9_237 vccd1 vssd1 vccd1 vssd1 sky130_ef_sc_hd__decap_40_12
XFILLER_13_222 vssd1 vssd1 vccd1 vccd1 sky130_fd_sc_hd__fill_2
XFILLER_0_181 vccd1 vssd1 vccd1 vssd1 sky130_ef_sc_hd__decap_40_12
X_0995_ clknet_4_7_0_clk _0028_ net51 vssd1 vssd1 vccd1 vccd1 SYNTH_INST.freq_div.keycode\[0\]
+ sky130_fd_sc_hd__dfrtp_1
XFILLER_24_46 vccd1 vssd1 vccd1 vssd1 sky130_ef_sc_hd__decap_40_12
X_0780_ SYNTH_INST.keypad.keypad_reg\[5\] SYNTH_INST.keypad.keypad_reg\[4\] SYNTH_INST.keypad.keypad_reg\[7\]
+ SYNTH_INST.keypad.keypad_reg\[6\] vssd1 vssd1 vccd1 vccd1 _0341_ sky130_fd_sc_hd__or4b_1
XFILLER_5_251 vssd1 vssd1 vccd1 vccd1 sky130_fd_sc_hd__fill_1
Xinput5 gpio_in[12] vssd1 vssd1 vccd1 vccd1 net5 sky130_fd_sc_hd__clkbuf_1
XFILLER_10_26 vssd1 vssd1 vccd1 vccd1 sky130_fd_sc_hd__fill_2
X_0978_ clknet_4_9_0_clk _0016_ net57 vssd1 vssd1 vccd1 vccd1 SYNTH_INST.waveshape.seq_div.dividend\[20\]
+ sky130_fd_sc_hd__dfrtp_1
XFILLER_19_57 vssd1 vssd1 vccd1 vccd1 sky130_fd_sc_hd__fill_2
XFILLER_19_68 vssd1 vssd1 vccd1 vccd1 sky130_fd_sc_hd__fill_2
XANTENNA_fanout39_A net40 vssd1 vssd1 vccd1 vccd1 sky130_fd_sc_hd__diode_2
XFILLER_33_169 vccd1 vssd1 vccd1 vssd1 sky130_ef_sc_hd__decap_40_12
X_0763_ net46 SYNTH_INST.waveshape.scaled_count\[3\] net24 vssd1 vssd1 vccd1 vccd1
+ _0329_ sky130_fd_sc_hd__and3_1
X_0832_ _0145_ _0378_ _0143_ vssd1 vssd1 vccd1 vccd1 _0382_ sky130_fd_sc_hd__o21ai_1
X_0901_ net187 _0202_ vssd1 vssd1 vccd1 vccd1 _0057_ sky130_fd_sc_hd__xnor2_1
X_0694_ SYNTH_INST.state_machine.fsmState\[1\] SYNTH_INST.waveshape.scaled_count\[6\]
+ vssd1 vssd1 vccd1 vccd1 _0293_ sky130_fd_sc_hd__nand2b_1
XFILLER_24_125 vssd1 vssd1 vccd1 vccd1 sky130_fd_sc_hd__fill_2
Xteam_05_104 vssd1 vssd1 vccd1 vccd1 gpio_oeb[5] team_05_104/LO sky130_fd_sc_hd__conb_1
Xteam_05_115 vssd1 vssd1 vccd1 vccd1 gpio_oeb[17] team_05_115/LO sky130_fd_sc_hd__conb_1
XFILLER_21_25 vssd1 vssd1 vccd1 vccd1 sky130_fd_sc_hd__fill_2
XPHY_EDGE_ROW_6_Left_45 vssd1 vssd1 vccd1 vccd1 sky130_fd_sc_hd__decap_3
Xteam_05_126 vssd1 vssd1 vccd1 vccd1 gpio_oeb[28] team_05_126/LO sky130_fd_sc_hd__conb_1
XFILLER_15_169 vssd1 vssd1 vccd1 vccd1 sky130_fd_sc_hd__fill_8
XFILLER_23_191 vssd1 vssd1 vccd1 vccd1 sky130_fd_sc_hd__fill_4
XTAP_TAPCELL_ROW_25_197 vssd1 vccd1 sky130_fd_sc_hd__tapvpwrvgnd_1
XFILLER_30_139 vssd1 vssd1 vccd1 vccd1 sky130_fd_sc_hd__fill_1
Xclkbuf_4_9_0_clk clknet_0_clk vssd1 vssd1 vccd1 vccd1 clknet_4_9_0_clk sky130_fd_sc_hd__clkbuf_8
X_1031_ clknet_4_10_0_clk _0055_ net56 vssd1 vssd1 vccd1 vccd1 SYNTH_INST.waveshape.seq_div.dividend\[47\]
+ sky130_fd_sc_hd__dfrtp_1
X_0815_ SYNTH_INST.waveshape.seq_div.dividend\[26\] net41 _0368_ net40 vssd1 vssd1
+ vccd1 vccd1 _0369_ sky130_fd_sc_hd__a22o_1
X_0746_ net159 net23 _0320_ vssd1 vssd1 vccd1 vccd1 _0014_ sky130_fd_sc_hd__o21a_1
X_0677_ net7 net2 _0283_ SYNTH_INST.pwm1 vssd1 vssd1 vccd1 vccd1 SYNTH_INST.pwm sky130_fd_sc_hd__o31a_1
XFILLER_32_24 vssd1 vssd1 vccd1 vccd1 sky130_fd_sc_hd__fill_1
XFILLER_28_250 vssd1 vssd1 vccd1 vccd1 sky130_fd_sc_hd__fill_2
XFILLER_11_150 vssd1 vssd1 vccd1 vccd1 sky130_fd_sc_hd__fill_2
X_0531_ SYNTH_INST.waveshape.seq_div.dividend\[35\] _0162_ vssd1 vssd1 vccd1 vccd1
+ _0164_ sky130_fd_sc_hd__xnor2_1
XFILLER_11_161 vssd1 vssd1 vccd1 vccd1 sky130_fd_sc_hd__fill_1
X_0600_ SYNTH_INST.sample_rate.count\[0\] _0227_ vssd1 vssd1 vccd1 vccd1 SYNTH_INST.sample_rate.n_count\[0\]
+ sky130_fd_sc_hd__and2b_1
X_0462_ SYNTH_INST.freq_div.keycode\[2\] net36 net33 vssd1 vssd1 vccd1 vccd1 _0095_
+ sky130_fd_sc_hd__a21bo_2
XTAP_TAPCELL_ROW_36_248 vssd1 vccd1 sky130_fd_sc_hd__tapvpwrvgnd_1
XFILLER_34_253 vssd1 vssd1 vccd1 vccd1 sky130_fd_sc_hd__fill_2
X_1014_ clknet_4_0_0_clk _0038_ net47 vssd1 vssd1 vccd1 vccd1 SYNTH_INST.waveshape.seq_div.dividend\[30\]
+ sky130_fd_sc_hd__dfrtp_1
XFILLER_8_92 vssd1 vssd1 vccd1 vccd1 sky130_fd_sc_hd__fill_2
X_0729_ net42 SYNTH_INST.waveshape.seq_div.dividend\[9\] net30 SYNTH_INST.count\[2\]
+ net22 vssd1 vssd1 vccd1 vccd1 _0312_ sky130_fd_sc_hd__a221o_1
XTAP_TAPCELL_ROW_4_102 vssd1 vccd1 sky130_fd_sc_hd__tapvpwrvgnd_1
XFILLER_27_57 vssd1 vssd1 vccd1 vccd1 sky130_fd_sc_hd__fill_1
XTAP_TAPCELL_ROW_27_204 vssd1 vccd1 sky130_fd_sc_hd__tapvpwrvgnd_1
XFILLER_4_157 vssd1 vssd1 vccd1 vccd1 sky130_fd_sc_hd__fill_4
XFILLER_16_231 vssd1 vssd1 vccd1 vccd1 sky130_fd_sc_hd__fill_1
XFILLER_16_253 vssd1 vssd1 vccd1 vccd1 sky130_fd_sc_hd__fill_2
X_0514_ _0145_ _0146_ vssd1 vssd1 vccd1 vccd1 _0147_ sky130_fd_sc_hd__or2_1
X_0445_ SYNTH_INST.pwm_counter.count\[5\] vssd1 vssd1 vccd1 vccd1 _0078_ sky130_fd_sc_hd__inv_2
Xfanout38 SYNTH_INST.freq_div.keycode\[0\] vssd1 vssd1 vccd1 vccd1 net38 sky130_fd_sc_hd__clkbuf_2
Xfanout27 _0308_ vssd1 vssd1 vccd1 vccd1 net27 sky130_fd_sc_hd__clkbuf_4
XFILLER_22_223 vssd1 vssd1 vccd1 vccd1 sky130_fd_sc_hd__fill_1
Xfanout49 net53 vssd1 vssd1 vccd1 vccd1 net49 sky130_fd_sc_hd__clkbuf_4
XFILLER_13_26 vssd1 vssd1 vccd1 vccd1 sky130_fd_sc_hd__fill_1
XPHY_EDGE_ROW_35_Left_74 vssd1 vssd1 vccd1 vccd1 sky130_fd_sc_hd__decap_3
XFILLER_9_249 vssd1 vssd1 vccd1 vccd1 sky130_fd_sc_hd__fill_2
XFILLER_13_245 vssd1 vssd1 vccd1 vccd1 sky130_fd_sc_hd__fill_8
XFILLER_0_193 vssd1 vssd1 vccd1 vccd1 sky130_fd_sc_hd__fill_2
X_0994_ clknet_4_11_0_clk net139 net56 vssd1 vssd1 vccd1 vccd1 SYNTH_INST.waveshape.seq_div.state\[4\]
+ sky130_fd_sc_hd__dfrtp_1
XFILLER_10_248 vssd1 vssd1 vccd1 vccd1 sky130_fd_sc_hd__fill_1
XFILLER_24_58 vccd1 vssd1 vccd1 vssd1 sky130_ef_sc_hd__decap_40_12
XFILLER_1_29 vssd1 vssd1 vccd1 vccd1 sky130_fd_sc_hd__fill_1
Xinput6 gpio_in[13] vssd1 vssd1 vccd1 vccd1 net6 sky130_fd_sc_hd__clkbuf_1
X_0977_ clknet_4_12_0_clk _0015_ net57 vssd1 vssd1 vccd1 vccd1 SYNTH_INST.waveshape.seq_div.dividend\[19\]
+ sky130_fd_sc_hd__dfrtp_1
XFILLER_19_14 vssd1 vssd1 vccd1 vccd1 sky130_fd_sc_hd__fill_1
XFILLER_35_79 vssd1 vssd1 vccd1 vccd1 sky130_fd_sc_hd__fill_2
XFILLER_35_57 vssd1 vssd1 vccd1 vccd1 sky130_fd_sc_hd__fill_2
XFILLER_35_46 vssd1 vssd1 vccd1 vccd1 sky130_fd_sc_hd__fill_2
XFILLER_27_167 vssd1 vssd1 vccd1 vccd1 sky130_fd_sc_hd__fill_1
XPHY_EDGE_ROW_14_Right_14 vssd1 vssd1 vccd1 vccd1 sky130_fd_sc_hd__decap_3
XPHY_EDGE_ROW_23_Right_23 vssd1 vssd1 vccd1 vccd1 sky130_fd_sc_hd__decap_3
XPHY_EDGE_ROW_32_Right_32 vssd1 vssd1 vccd1 vccd1 sky130_fd_sc_hd__decap_3
X_0900_ _0202_ _0432_ vssd1 vssd1 vccd1 vccd1 _0056_ sky130_fd_sc_hd__and2_1
X_0693_ SYNTH_INST.waveshape.scaled_count\[6\] _0285_ _0286_ _0292_ _0284_ vssd1 vssd1
+ vccd1 vccd1 SYNTH_INST.waveshape.shaper.n_sample\[6\] sky130_fd_sc_hd__a221o_1
X_0831_ _0143_ _0145_ _0378_ vssd1 vssd1 vccd1 vccd1 _0381_ sky130_fd_sc_hd__or3_1
X_0762_ net193 net20 _0328_ vssd1 vssd1 vccd1 vccd1 _0022_ sky130_fd_sc_hd__a21o_1
XPHY_EDGE_ROW_22_Left_61 vssd1 vssd1 vccd1 vccd1 sky130_fd_sc_hd__decap_3
XFILLER_2_83 vssd1 vssd1 vccd1 vccd1 sky130_fd_sc_hd__fill_1
Xteam_05_105 vssd1 vssd1 vccd1 vccd1 gpio_oeb[6] team_05_105/LO sky130_fd_sc_hd__conb_1
Xteam_05_116 vssd1 vssd1 vccd1 vccd1 gpio_oeb[18] team_05_116/LO sky130_fd_sc_hd__conb_1
Xteam_05_127 vssd1 vssd1 vccd1 vccd1 gpio_oeb[29] team_05_127/LO sky130_fd_sc_hd__conb_1
XFILLER_21_48 vssd1 vssd1 vccd1 vccd1 sky130_fd_sc_hd__fill_4
XTAP_TAPCELL_ROW_25_198 vssd1 vccd1 sky130_fd_sc_hd__tapvpwrvgnd_1
X_1030_ clknet_4_10_0_clk _0054_ net55 vssd1 vssd1 vccd1 vccd1 SYNTH_INST.waveshape.seq_div.dividend\[46\]
+ sky130_fd_sc_hd__dfrtp_1
X_0814_ _0138_ _0367_ vssd1 vssd1 vccd1 vccd1 _0368_ sky130_fd_sc_hd__xnor2_1
XTAP_TAPCELL_ROW_16_154 vssd1 vccd1 sky130_fd_sc_hd__tapvpwrvgnd_1
X_0676_ _0280_ _0281_ _0282_ vssd1 vssd1 vccd1 vccd1 _0283_ sky130_fd_sc_hd__or3_1
X_0745_ net42 SYNTH_INST.waveshape.seq_div.dividend\[17\] net31 SYNTH_INST.count\[10\]
+ net20 vssd1 vssd1 vccd1 vccd1 _0320_ sky130_fd_sc_hd__a221o_1
XFILLER_7_111 vssd1 vssd1 vccd1 vccd1 sky130_fd_sc_hd__fill_1
X_0530_ SYNTH_INST.waveshape.seq_div.dividend\[35\] _0162_ vssd1 vssd1 vccd1 vccd1
+ _0163_ sky130_fd_sc_hd__or2_1
X_0461_ _0093_ vssd1 vssd1 vccd1 vccd1 _0094_ sky130_fd_sc_hd__inv_2
X_1013_ clknet_4_0_0_clk _0037_ net47 vssd1 vssd1 vccd1 vccd1 SYNTH_INST.waveshape.seq_div.dividend\[29\]
+ sky130_fd_sc_hd__dfrtp_1
XFILLER_8_60 vccd1 vssd1 vccd1 vssd1 sky130_ef_sc_hd__decap_40_12
XPHY_EDGE_ROW_4_Right_4 vssd1 vssd1 vccd1 vccd1 sky130_fd_sc_hd__decap_3
XTAP_TAPCELL_ROW_4_103 vssd1 vccd1 sky130_fd_sc_hd__tapvpwrvgnd_1
X_0728_ net167 net25 _0311_ vssd1 vssd1 vccd1 vccd1 _0005_ sky130_fd_sc_hd__o21a_1
X_0659_ _0270_ _0271_ vssd1 vssd1 vccd1 vccd1 SYNTH_INST.oscill.n_count\[9\] sky130_fd_sc_hd__nor2_1
XTAP_TAPCELL_ROW_27_205 vssd1 vccd1 sky130_fd_sc_hd__tapvpwrvgnd_1
Xclkbuf_4_8_0_clk clknet_0_clk vssd1 vssd1 vccd1 vccd1 clknet_4_8_0_clk sky130_fd_sc_hd__clkbuf_8
XFILLER_25_254 vssd1 vssd1 vccd1 vccd1 sky130_fd_sc_hd__fill_1
XFILLER_4_18 vssd1 vssd1 vccd1 vccd1 sky130_fd_sc_hd__fill_8
XTAP_TAPCELL_ROW_10_127 vssd1 vccd1 sky130_fd_sc_hd__tapvpwrvgnd_1
X_0444_ SYNTH_INST.pwm_counter.count\[6\] vssd1 vssd1 vccd1 vccd1 _0077_ sky130_fd_sc_hd__inv_2
X_0513_ _0098_ _0144_ SYNTH_INST.waveshape.seq_div.dividend\[30\] vssd1 vssd1 vccd1
+ vccd1 _0146_ sky130_fd_sc_hd__a21oi_1
XTAP_TAPCELL_ROW_32_230 vssd1 vccd1 sky130_fd_sc_hd__tapvpwrvgnd_1
Xfanout28 net29 vssd1 vssd1 vccd1 vccd1 net28 sky130_fd_sc_hd__buf_2
Xfanout39 net40 vssd1 vssd1 vccd1 vccd1 net39 sky130_fd_sc_hd__buf_2
X_0993_ clknet_4_11_0_clk _0003_ net56 vssd1 vssd1 vccd1 vccd1 SYNTH_INST.waveshape.seq_div.state\[3\]
+ sky130_fd_sc_hd__dfrtp_1
XFILLER_6_209 vssd1 vssd1 vccd1 vccd1 sky130_fd_sc_hd__fill_2
XFILLER_24_26 vssd1 vssd1 vccd1 vccd1 sky130_fd_sc_hd__fill_2
XANTENNA__0767__A net43 vssd1 vssd1 vccd1 vccd1 sky130_fd_sc_hd__diode_2
Xinput7 gpio_in[1] vssd1 vssd1 vccd1 vccd1 net7 sky130_fd_sc_hd__clkbuf_1
X_0976_ clknet_4_6_0_clk _0014_ net52 vssd1 vssd1 vccd1 vccd1 SYNTH_INST.waveshape.seq_div.dividend\[18\]
+ sky130_fd_sc_hd__dfrtp_1
XFILLER_19_59 vssd1 vssd1 vccd1 vccd1 sky130_fd_sc_hd__fill_1
XFILLER_27_113 vssd1 vssd1 vccd1 vccd1 sky130_fd_sc_hd__fill_2
XFILLER_27_146 vssd1 vssd1 vccd1 vccd1 sky130_fd_sc_hd__fill_1
X_0830_ net194 _0380_ net27 vssd1 vssd1 vccd1 vccd1 _0038_ sky130_fd_sc_hd__mux2_1
X_0692_ SYNTH_INST.waveshape.scaled_count\[7\] SYNTH_INST.waveshape.scaled_count\[5\]
+ vssd1 vssd1 vccd1 vccd1 _0292_ sky130_fd_sc_hd__xor2_1
X_0761_ net46 SYNTH_INST.waveshape.scaled_count\[2\] net23 vssd1 vssd1 vccd1 vccd1
+ _0328_ sky130_fd_sc_hd__and3_1
XFILLER_37_3 vssd1 vssd1 vccd1 vccd1 sky130_fd_sc_hd__fill_1
XFILLER_24_127 vssd1 vssd1 vccd1 vccd1 sky130_fd_sc_hd__fill_1
X_0959_ clknet_4_5_0_clk net14 net49 vssd1 vssd1 vccd1 vccd1 SYNTH_INST.keypad.keypad_reg\[8\]
+ sky130_fd_sc_hd__dfrtp_1
XFILLER_21_27 vssd1 vssd1 vccd1 vccd1 sky130_fd_sc_hd__fill_1
Xteam_05_128 vssd1 vssd1 vccd1 vccd1 gpio_oeb[30] team_05_128/LO sky130_fd_sc_hd__conb_1
Xteam_05_117 vssd1 vssd1 vccd1 vccd1 gpio_oeb[19] team_05_117/LO sky130_fd_sc_hd__conb_1
Xteam_05_106 vssd1 vssd1 vccd1 vccd1 gpio_oeb[7] team_05_106/LO sky130_fd_sc_hd__conb_1
XFILLER_15_138 vssd1 vssd1 vccd1 vccd1 sky130_fd_sc_hd__fill_8
XFILLER_11_82 vssd1 vssd1 vccd1 vccd1 sky130_fd_sc_hd__fill_2
XTAP_TAPCELL_ROW_16_155 vssd1 vccd1 sky130_fd_sc_hd__tapvpwrvgnd_1
X_0813_ _0115_ _0116_ vssd1 vssd1 vccd1 vccd1 _0367_ sky130_fd_sc_hd__or2_1
Xinput10 gpio_in[4] vssd1 vssd1 vccd1 vccd1 net10 sky130_fd_sc_hd__clkbuf_1
X_0744_ net166 net23 _0319_ vssd1 vssd1 vccd1 vccd1 _0013_ sky130_fd_sc_hd__o21a_1
X_0675_ net9 net8 net11 net10 vssd1 vssd1 vccd1 vccd1 _0282_ sky130_fd_sc_hd__or4_1
XFILLER_16_27 vssd1 vssd1 vccd1 vccd1 sky130_fd_sc_hd__fill_1
XFILLER_7_101 vssd1 vssd1 vccd1 vccd1 sky130_fd_sc_hd__fill_1
XFILLER_11_152 vssd1 vssd1 vccd1 vccd1 sky130_fd_sc_hd__fill_1
XTAP_TAPCELL_ROW_21_180 vssd1 vccd1 sky130_fd_sc_hd__tapvpwrvgnd_1
XFILLER_7_167 vssd1 vssd1 vccd1 vccd1 sky130_fd_sc_hd__fill_1
X_0460_ net34 net36 vssd1 vssd1 vccd1 vccd1 _0093_ sky130_fd_sc_hd__nand2_1
X_1012_ clknet_4_0_0_clk _0036_ net47 vssd1 vssd1 vccd1 vccd1 SYNTH_INST.waveshape.seq_div.dividend\[28\]
+ sky130_fd_sc_hd__dfrtp_1
XFILLER_19_241 vssd1 vssd1 vccd1 vccd1 sky130_fd_sc_hd__fill_2
XFILLER_19_252 vssd1 vssd1 vccd1 vccd1 sky130_fd_sc_hd__fill_2
XFILLER_8_72 vccd1 vssd1 vccd1 vssd1 sky130_ef_sc_hd__decap_40_12
XFILLER_8_94 vssd1 vssd1 vccd1 vccd1 sky130_fd_sc_hd__fill_1
X_0727_ net41 SYNTH_INST.waveshape.seq_div.dividend\[8\] net30 SYNTH_INST.count\[1\]
+ net22 vssd1 vssd1 vccd1 vccd1 _0311_ sky130_fd_sc_hd__a221o_1
XTAP_TAPCELL_ROW_4_104 vssd1 vccd1 sky130_fd_sc_hd__tapvpwrvgnd_1
X_0658_ SYNTH_INST.count\[9\] _0268_ net18 vssd1 vssd1 vccd1 vccd1 _0271_ sky130_fd_sc_hd__o21ai_1
X_0589_ SYNTH_INST.pwm_counter.active_sample\[1\] _0082_ _0083_ SYNTH_INST.pwm_counter.active_sample\[0\]
+ vssd1 vssd1 vccd1 vccd1 _0219_ sky130_fd_sc_hd__o22a_1
XTAP_TAPCELL_ROW_27_206 vssd1 vccd1 sky130_fd_sc_hd__tapvpwrvgnd_1
XTAP_TAPCELL_ROW_10_128 vssd1 vccd1 sky130_fd_sc_hd__tapvpwrvgnd_1
XFILLER_31_225 vssd1 vssd1 vccd1 vccd1 sky130_fd_sc_hd__fill_2
X_0443_ SYNTH_INST.pwm_counter.count\[7\] vssd1 vssd1 vccd1 vccd1 _0076_ sky130_fd_sc_hd__inv_2
X_0512_ SYNTH_INST.waveshape.seq_div.dividend\[30\] _0098_ _0144_ vssd1 vssd1 vccd1
+ vccd1 _0145_ sky130_fd_sc_hd__and3_1
Xfanout29 _0307_ vssd1 vssd1 vccd1 vccd1 net29 sky130_fd_sc_hd__buf_2
Xfanout18 _0255_ vssd1 vssd1 vccd1 vccd1 net18 sky130_fd_sc_hd__clkbuf_2
XFILLER_38_25 vssd1 vssd1 vccd1 vccd1 sky130_fd_sc_hd__fill_1
XFILLER_0_195 vssd1 vssd1 vccd1 vccd1 sky130_fd_sc_hd__fill_1
X_0992_ clknet_4_11_0_clk net44 net55 vssd1 vssd1 vccd1 vccd1 SYNTH_INST.waveshape.seq_div.state\[2\]
+ sky130_fd_sc_hd__dfrtp_1
XFILLER_5_51 vssd1 vssd1 vccd1 vccd1 sky130_fd_sc_hd__fill_2
XFILLER_5_40 vssd1 vssd1 vccd1 vccd1 sky130_fd_sc_hd__fill_4
XFILLER_8_251 vssd1 vssd1 vccd1 vccd1 sky130_fd_sc_hd__fill_1
Xclkbuf_4_7_0_clk clknet_0_clk vssd1 vssd1 vccd1 vccd1 clknet_4_7_0_clk sky130_fd_sc_hd__clkbuf_8
Xinput8 gpio_in[2] vssd1 vssd1 vccd1 vccd1 net8 sky130_fd_sc_hd__clkbuf_1
X_0975_ clknet_4_6_0_clk _0013_ net52 vssd1 vssd1 vccd1 vccd1 SYNTH_INST.waveshape.seq_div.dividend\[17\]
+ sky130_fd_sc_hd__dfrtp_1
XFILLER_10_18 vssd1 vssd1 vccd1 vccd1 sky130_fd_sc_hd__fill_8
XFILLER_19_49 vssd1 vssd1 vccd1 vccd1 sky130_fd_sc_hd__fill_4
XFILLER_27_103 vssd1 vssd1 vccd1 vccd1 sky130_fd_sc_hd__fill_1
XFILLER_27_125 vssd1 vssd1 vccd1 vccd1 sky130_fd_sc_hd__fill_1
X_0760_ net189 net20 _0327_ vssd1 vssd1 vccd1 vccd1 _0021_ sky130_fd_sc_hd__a21o_1
X_0691_ SYNTH_INST.waveshape.scaled_count\[5\] _0285_ _0286_ _0291_ _0284_ vssd1 vssd1
+ vccd1 vccd1 SYNTH_INST.waveshape.shaper.n_sample\[5\] sky130_fd_sc_hd__a221o_1
XFILLER_2_96 vssd1 vssd1 vccd1 vccd1 sky130_fd_sc_hd__fill_1
X_0958_ clknet_4_5_0_clk net13 net49 vssd1 vssd1 vccd1 vccd1 SYNTH_INST.keypad.keypad_reg\[7\]
+ sky130_fd_sc_hd__dfrtp_1
X_0889_ SYNTH_INST.waveshape.seq_div.dividend\[44\] net28 _0396_ _0425_ vssd1 vssd1
+ vccd1 vccd1 _0052_ sky130_fd_sc_hd__a22o_1
Xteam_05_129 vssd1 vssd1 vccd1 vccd1 gpio_oeb[31] team_05_129/LO sky130_fd_sc_hd__conb_1
Xteam_05_107 vssd1 vssd1 vccd1 vccd1 gpio_oeb[8] team_05_107/LO sky130_fd_sc_hd__conb_1
Xteam_05_118 vssd1 vssd1 vccd1 vccd1 gpio_oeb[20] team_05_118/LO sky130_fd_sc_hd__conb_1
XANTENNA__0812__A2 net27 vssd1 vssd1 vccd1 vccd1 sky130_fd_sc_hd__diode_2
XTAP_TAPCELL_ROW_16_156 vssd1 vccd1 sky130_fd_sc_hd__tapvpwrvgnd_1
X_0812_ net201 net27 _0366_ vssd1 vssd1 vccd1 vccd1 _0034_ sky130_fd_sc_hd__o21a_1
X_0743_ net42 SYNTH_INST.waveshape.seq_div.dividend\[16\] net30 SYNTH_INST.count\[9\]
+ net20 vssd1 vssd1 vccd1 vccd1 _0319_ sky130_fd_sc_hd__a221o_1
Xinput11 gpio_in[5] vssd1 vssd1 vccd1 vccd1 net11 sky130_fd_sc_hd__clkbuf_1
X_0674_ net13 net12 net15 net14 vssd1 vssd1 vccd1 vccd1 _0281_ sky130_fd_sc_hd__or4_1
XFILLER_37_253 vssd1 vssd1 vccd1 vccd1 sky130_fd_sc_hd__fill_2
XANTENNA__0820__S net27 vssd1 vssd1 vccd1 vccd1 sky130_fd_sc_hd__diode_2
XFILLER_28_253 vssd1 vssd1 vccd1 vccd1 sky130_fd_sc_hd__fill_2
XFILLER_7_113 vccd1 vssd1 vccd1 vssd1 sky130_ef_sc_hd__decap_40_12
X_1011_ clknet_4_0_0_clk _0035_ net47 vssd1 vssd1 vccd1 vccd1 SYNTH_INST.waveshape.seq_div.dividend\[27\]
+ sky130_fd_sc_hd__dfrtp_1
XFILLER_14_6 vccd1 vssd1 vccd1 vssd1 sky130_ef_sc_hd__decap_40_12
XFILLER_19_231 vssd1 vssd1 vccd1 vccd1 sky130_fd_sc_hd__fill_2
X_0726_ SYNTH_INST.count\[0\] _0226_ net30 net22 net150 vssd1 vssd1 vccd1 vccd1 _0004_
+ sky130_fd_sc_hd__a32o_1
X_0588_ _0218_ vssd1 vssd1 vccd1 vccd1 SYNTH_INST.keypad.n_modekey sky130_fd_sc_hd__inv_2
X_0657_ SYNTH_INST.count\[9\] _0268_ vssd1 vssd1 vccd1 vccd1 _0270_ sky130_fd_sc_hd__and2_1
XTAP_TAPCELL_ROW_35_240 vssd1 vccd1 sky130_fd_sc_hd__tapvpwrvgnd_1
XFILLER_25_223 vssd1 vssd1 vccd1 vccd1 sky130_fd_sc_hd__fill_1
XTAP_TAPCELL_ROW_27_207 vssd1 vccd1 sky130_fd_sc_hd__tapvpwrvgnd_1
XTAP_TAPCELL_ROW_10_129 vssd1 vccd1 sky130_fd_sc_hd__tapvpwrvgnd_1
XFILLER_16_201 vccd1 vssd1 vccd1 vssd1 sky130_ef_sc_hd__decap_40_12
X_0511_ net37 _0120_ _0090_ vssd1 vssd1 vccd1 vccd1 _0144_ sky130_fd_sc_hd__a21o_1
X_0442_ SYNTH_INST.keypad.keypad_reg\[13\] vssd1 vssd1 vccd1 vccd1 _0075_ sky130_fd_sc_hd__inv_2
Xfanout19 _0255_ vssd1 vssd1 vccd1 vccd1 net19 sky130_fd_sc_hd__clkbuf_1
XFILLER_1_119 vssd1 vssd1 vccd1 vccd1 sky130_fd_sc_hd__fill_2
X_0709_ SYNTH_INST.pwm_counter.count\[1\] SYNTH_INST.pwm_counter.count\[0\] net182
+ vssd1 vssd1 vccd1 vccd1 _0302_ sky130_fd_sc_hd__a21oi_1
XANTENNA_input9_A gpio_in[3] vssd1 vssd1 vccd1 vccd1 sky130_fd_sc_hd__diode_2
XFILLER_0_130 vssd1 vssd1 vccd1 vccd1 sky130_fd_sc_hd__fill_8
XFILLER_0_141 vccd1 vssd1 vccd1 vssd1 sky130_ef_sc_hd__decap_40_12
XFILLER_28_70 vccd1 vssd1 vccd1 vssd1 sky130_ef_sc_hd__decap_40_12
X_0991_ clknet_4_11_0_clk _0002_ net56 vssd1 vssd1 vccd1 vccd1 SYNTH_INST.waveshape.seq_div.state\[1\]
+ sky130_fd_sc_hd__dfrtp_1
XFILLER_5_63 vssd1 vssd1 vccd1 vccd1 sky130_fd_sc_hd__fill_2
XANTENNA__0842__B1 net40 vssd1 vssd1 vccd1 vccd1 sky130_fd_sc_hd__diode_2
XFILLER_14_83 vssd1 vssd1 vccd1 vccd1 sky130_fd_sc_hd__fill_1
XFILLER_5_222 vssd1 vssd1 vccd1 vccd1 sky130_fd_sc_hd__fill_2
XFILLER_30_93 vssd1 vssd1 vccd1 vccd1 sky130_fd_sc_hd__fill_2
Xinput9 gpio_in[3] vssd1 vssd1 vccd1 vccd1 net9 sky130_fd_sc_hd__clkbuf_1
X_0974_ clknet_4_6_0_clk _0012_ net52 vssd1 vssd1 vccd1 vccd1 SYNTH_INST.waveshape.seq_div.dividend\[16\]
+ sky130_fd_sc_hd__dfrtp_1
XANTENNA__0824__B1 net29 vssd1 vssd1 vccd1 vccd1 sky130_fd_sc_hd__diode_2
XFILLER_33_129 vccd1 vssd1 vccd1 vssd1 sky130_ef_sc_hd__decap_40_12
X_0690_ SYNTH_INST.waveshape.scaled_count\[7\] SYNTH_INST.waveshape.scaled_count\[4\]
+ vssd1 vssd1 vccd1 vccd1 _0291_ sky130_fd_sc_hd__xor2_1
XANTENNA__0981__RESET_B net48 vssd1 vssd1 vccd1 vccd1 sky130_fd_sc_hd__diode_2
Xclkbuf_4_6_0_clk clknet_0_clk vssd1 vssd1 vccd1 vccd1 clknet_4_6_0_clk sky130_fd_sc_hd__clkbuf_8
XFILLER_2_64 vssd1 vssd1 vccd1 vccd1 sky130_fd_sc_hd__fill_2
XFILLER_2_31 vssd1 vssd1 vccd1 vccd1 sky130_fd_sc_hd__fill_1
XANTENNA__1016__RESET_B net48 vssd1 vssd1 vccd1 vccd1 sky130_fd_sc_hd__diode_2
XPHY_EDGE_ROW_10_Right_10 vssd1 vssd1 vccd1 vccd1 sky130_fd_sc_hd__decap_3
XFILLER_32_151 vssd1 vssd1 vccd1 vccd1 sky130_fd_sc_hd__fill_2
X_0957_ clknet_4_5_0_clk net12 net49 vssd1 vssd1 vccd1 vccd1 SYNTH_INST.keypad.keypad_reg\[6\]
+ sky130_fd_sc_hd__dfrtp_1
X_0888_ SYNTH_INST.waveshape.seq_div.dividend\[43\] net44 _0424_ SYNTH_INST.waveshape.seq_div.state\[4\]
+ vssd1 vssd1 vccd1 vccd1 _0425_ sky130_fd_sc_hd__a22o_1
Xteam_05_119 vssd1 vssd1 vccd1 vccd1 gpio_oeb[21] team_05_119/LO sky130_fd_sc_hd__conb_1
Xteam_05_108 vssd1 vssd1 vccd1 vccd1 gpio_oeb[9] team_05_108/LO sky130_fd_sc_hd__conb_1
XFILLER_14_151 vssd1 vssd1 vccd1 vccd1 sky130_fd_sc_hd__fill_1
XTAP_TAPCELL_ROW_16_157 vssd1 vccd1 sky130_fd_sc_hd__tapvpwrvgnd_1
XPHY_EDGE_ROW_26_Left_65 vssd1 vssd1 vccd1 vccd1 sky130_fd_sc_hd__decap_3
X_0673_ net4 net3 net6 net5 vssd1 vssd1 vccd1 vccd1 _0280_ sky130_fd_sc_hd__or4_1
Xinput12 gpio_in[6] vssd1 vssd1 vccd1 vccd1 net12 sky130_fd_sc_hd__clkbuf_1
X_0811_ SYNTH_INST.waveshape.seq_div.dividend\[25\] net41 net29 _0365_ vssd1 vssd1
+ vccd1 vccd1 _0366_ sky130_fd_sc_hd__a211o_1
XPHY_EDGE_ROW_10_Left_49 vssd1 vssd1 vccd1 vccd1 sky130_fd_sc_hd__decap_3
XTAP_TAPCELL_ROW_24_190 vssd1 vccd1 sky130_fd_sc_hd__tapvpwrvgnd_1
X_0742_ net160 net23 _0318_ vssd1 vssd1 vccd1 vccd1 _0012_ sky130_fd_sc_hd__o21a_1
XFILLER_20_143 vssd1 vssd1 vccd1 vccd1 sky130_fd_sc_hd__fill_4
XFILLER_20_187 vssd1 vssd1 vccd1 vccd1 sky130_fd_sc_hd__fill_1
XTAP_TAPCELL_ROW_7_114 vssd1 vccd1 sky130_fd_sc_hd__tapvpwrvgnd_1
XTAP_TAPCELL_ROW_38_260 vssd1 vccd1 sky130_fd_sc_hd__tapvpwrvgnd_1
XFILLER_7_169 vssd1 vssd1 vccd1 vccd1 sky130_fd_sc_hd__fill_2
XFILLER_7_125 vssd1 vssd1 vccd1 vccd1 sky130_fd_sc_hd__fill_4
X_1010_ clknet_4_0_0_clk _0034_ net47 vssd1 vssd1 vccd1 vccd1 SYNTH_INST.waveshape.seq_div.dividend\[26\]
+ sky130_fd_sc_hd__dfrtp_1
XFILLER_19_243 vssd1 vssd1 vccd1 vccd1 sky130_fd_sc_hd__fill_1
XFILLER_19_254 vssd1 vssd1 vccd1 vccd1 sky130_fd_sc_hd__fill_1
X_0725_ _0073_ net26 vssd1 vssd1 vccd1 vccd1 _0310_ sky130_fd_sc_hd__nand2_1
X_0656_ _0268_ _0269_ net19 vssd1 vssd1 vccd1 vccd1 SYNTH_INST.oscill.n_count\[8\]
+ sky130_fd_sc_hd__and3b_1
X_0587_ SYNTH_INST.keypad.keypad_reg\[12\] _0075_ _0212_ _0217_ vssd1 vssd1 vccd1
+ vccd1 _0218_ sky130_fd_sc_hd__or4bb_2
XTAP_TAPCELL_ROW_35_241 vssd1 vccd1 sky130_fd_sc_hd__tapvpwrvgnd_1
XFILLER_4_139 vssd1 vssd1 vccd1 vccd1 sky130_fd_sc_hd__fill_1
XFILLER_16_213 vccd1 vssd1 vccd1 vssd1 sky130_ef_sc_hd__decap_40_12
X_0510_ SYNTH_INST.waveshape.seq_div.dividend\[31\] _0141_ vssd1 vssd1 vccd1 vccd1
+ _0143_ sky130_fd_sc_hd__xor2_1
X_0441_ SYNTH_INST.keypad.keypad_reg\[0\] vssd1 vssd1 vccd1 vccd1 _0074_ sky130_fd_sc_hd__inv_2
Xhold1 SYNTH_INST.pwm_counter.sample\[2\] vssd1 vssd1 vccd1 vccd1 net132 sky130_fd_sc_hd__dlygate4sd3_1
XPHY_EDGE_ROW_8_Right_8 vssd1 vssd1 vccd1 vccd1 sky130_fd_sc_hd__decap_3
XPHY_EDGE_ROW_13_Left_52 vssd1 vssd1 vccd1 vccd1 sky130_fd_sc_hd__decap_3
X_0639_ SYNTH_INST.count\[0\] SYNTH_INST.count\[1\] SYNTH_INST.count\[2\] vssd1 vssd1
+ vccd1 vccd1 _0259_ sky130_fd_sc_hd__a21o_1
X_0708_ net179 SYNTH_INST.pwm_counter.count\[0\] vssd1 vssd1 vccd1 vccd1 SYNTH_INST.pwm_counter.n_count\[1\]
+ sky130_fd_sc_hd__xor2_1
XFILLER_0_153 vccd1 vssd1 vccd1 vssd1 sky130_ef_sc_hd__decap_40_12
XFILLER_28_82 vssd1 vssd1 vccd1 vccd1 sky130_fd_sc_hd__fill_2
XFILLER_28_93 vssd1 vssd1 vccd1 vccd1 sky130_fd_sc_hd__fill_1
XFILLER_8_253 vssd1 vssd1 vccd1 vccd1 sky130_fd_sc_hd__fill_2
X_0990_ clknet_4_9_0_clk _0001_ net54 vssd1 vssd1 vccd1 vccd1 SYNTH_INST.waveshape.seq_div.state\[0\]
+ sky130_fd_sc_hd__dfstp_1
XFILLER_5_97 vssd1 vssd1 vccd1 vccd1 sky130_fd_sc_hd__fill_1
XFILLER_5_86 vssd1 vssd1 vccd1 vccd1 sky130_fd_sc_hd__fill_1
XFILLER_24_29 vssd1 vssd1 vccd1 vccd1 sky130_fd_sc_hd__fill_1
XFILLER_6_9 vccd1 vssd1 vccd1 vssd1 sky130_ef_sc_hd__decap_40_12
XFILLER_38_190 vssd1 vssd1 vccd1 vccd1 sky130_fd_sc_hd__fill_2
XTAP_TAPCELL_ROW_1_87 vssd1 vccd1 sky130_fd_sc_hd__tapvpwrvgnd_1
XFILLER_30_83 vssd1 vssd1 vccd1 vccd1 sky130_fd_sc_hd__fill_1
XFILLER_36_105 vssd1 vssd1 vccd1 vccd1 sky130_fd_sc_hd__fill_1
X_0973_ clknet_4_6_0_clk _0011_ net52 vssd1 vssd1 vccd1 vccd1 SYNTH_INST.waveshape.seq_div.dividend\[15\]
+ sky130_fd_sc_hd__dfrtp_1
XANTENNA__0824__A1 net40 vssd1 vssd1 vccd1 vccd1 sky130_fd_sc_hd__diode_2
XFILLER_4_6 vccd1 vssd1 vccd1 vssd1 sky130_ef_sc_hd__decap_40_12
XANTENNA__0815__B2 net40 vssd1 vssd1 vccd1 vccd1 sky130_fd_sc_hd__diode_2
XFILLER_24_108 vssd1 vssd1 vccd1 vccd1 sky130_fd_sc_hd__fill_2
XFILLER_32_141 vssd1 vssd1 vccd1 vccd1 sky130_fd_sc_hd__fill_2
X_0956_ clknet_4_4_0_clk net11 net49 vssd1 vssd1 vccd1 vccd1 SYNTH_INST.keypad.keypad_reg\[5\]
+ sky130_fd_sc_hd__dfrtp_1
X_0887_ SYNTH_INST.waveshape.seq_div.dividend\[44\] _0190_ vssd1 vssd1 vccd1 vccd1
+ _0424_ sky130_fd_sc_hd__xnor2_1
Xteam_05_109 vssd1 vssd1 vccd1 vccd1 gpio_oeb[10] team_05_109/LO sky130_fd_sc_hd__conb_1
XPHY_EDGE_ROW_1_Left_40 vssd1 vssd1 vccd1 vccd1 sky130_fd_sc_hd__decap_3
Xinput13 gpio_in[7] vssd1 vssd1 vccd1 vccd1 net13 sky130_fd_sc_hd__clkbuf_1
X_0810_ _0137_ _0364_ net40 vssd1 vssd1 vccd1 vccd1 _0365_ sky130_fd_sc_hd__and3b_1
XFILLER_14_141 vssd1 vssd1 vccd1 vccd1 sky130_fd_sc_hd__fill_8
XTAP_TAPCELL_ROW_16_158 vssd1 vccd1 sky130_fd_sc_hd__tapvpwrvgnd_1
XTAP_TAPCELL_ROW_24_191 vssd1 vccd1 sky130_fd_sc_hd__tapvpwrvgnd_1
X_0672_ net19 _0279_ vssd1 vssd1 vccd1 vccd1 SYNTH_INST.oscill.n_count\[14\] sky130_fd_sc_hd__and2_1
X_0741_ net42 SYNTH_INST.waveshape.seq_div.dividend\[15\] net30 SYNTH_INST.count\[8\]
+ net22 vssd1 vssd1 vccd1 vccd1 _0318_ sky130_fd_sc_hd__a221o_1
XFILLER_32_29 vssd1 vssd1 vccd1 vccd1 sky130_fd_sc_hd__fill_2
XFILLER_32_18 vssd1 vssd1 vccd1 vccd1 sky130_fd_sc_hd__fill_4
XFILLER_20_111 vssd1 vssd1 vccd1 vccd1 sky130_fd_sc_hd__fill_2
X_0939_ clknet_4_1_0_clk SYNTH_INST.oscill.n_count\[7\] net50 vssd1 vssd1 vccd1 vccd1
+ SYNTH_INST.count\[7\] sky130_fd_sc_hd__dfrtp_2
XTAP_TAPCELL_ROW_7_115 vssd1 vccd1 sky130_fd_sc_hd__tapvpwrvgnd_1
XTAP_TAPCELL_ROW_38_261 vssd1 vccd1 sky130_fd_sc_hd__tapvpwrvgnd_1
Xclkbuf_4_5_0_clk clknet_0_clk vssd1 vssd1 vccd1 vccd1 clknet_4_5_0_clk sky130_fd_sc_hd__clkbuf_8
XANTENNA_fanout42_A net43 vssd1 vssd1 vccd1 vccd1 sky130_fd_sc_hd__diode_2
XFILLER_7_159 vssd1 vssd1 vccd1 vccd1 sky130_fd_sc_hd__fill_8
XFILLER_7_148 vssd1 vssd1 vccd1 vccd1 sky130_fd_sc_hd__fill_1
XFILLER_19_200 vccd1 vssd1 vccd1 vssd1 sky130_ef_sc_hd__decap_40_12
XFILLER_34_225 vssd1 vssd1 vccd1 vccd1 sky130_fd_sc_hd__fill_4
XFILLER_34_214 vssd1 vssd1 vccd1 vccd1 sky130_fd_sc_hd__fill_4
XFILLER_8_20 vssd1 vssd1 vccd1 vccd1 sky130_fd_sc_hd__fill_1
XFILLER_8_53 vssd1 vssd1 vccd1 vccd1 sky130_fd_sc_hd__fill_1
X_0586_ _0216_ vssd1 vssd1 vccd1 vccd1 _0217_ sky130_fd_sc_hd__inv_2
X_0724_ net39 net29 vssd1 vssd1 vccd1 vccd1 _0309_ sky130_fd_sc_hd__nor2_1
X_0655_ SYNTH_INST.count\[7\] SYNTH_INST.count\[6\] _0263_ SYNTH_INST.count\[8\] vssd1
+ vssd1 vccd1 vccd1 _0269_ sky130_fd_sc_hd__a31o_1
XFILLER_25_203 vssd1 vssd1 vccd1 vccd1 sky130_fd_sc_hd__fill_4
XTAP_TAPCELL_ROW_35_242 vssd1 vccd1 sky130_fd_sc_hd__tapvpwrvgnd_1
XANTENNA__0881__C1 net29 vssd1 vssd1 vccd1 vccd1 sky130_fd_sc_hd__diode_2
XFILLER_25_236 vssd1 vssd1 vccd1 vccd1 sky130_fd_sc_hd__fill_2
XFILLER_4_107 vssd1 vssd1 vccd1 vccd1 sky130_fd_sc_hd__fill_1
XFILLER_31_217 vssd1 vssd1 vccd1 vccd1 sky130_fd_sc_hd__fill_2
XFILLER_17_51 vssd1 vssd1 vccd1 vccd1 sky130_fd_sc_hd__fill_1
XFILLER_33_72 vssd1 vssd1 vccd1 vccd1 sky130_fd_sc_hd__fill_2
X_0440_ net40 vssd1 vssd1 vccd1 vccd1 _0073_ sky130_fd_sc_hd__inv_2
Xhold2 _0063_ vssd1 vssd1 vccd1 vccd1 net133 sky130_fd_sc_hd__dlygate4sd3_1
X_0707_ net178 SYNTH_INST.pwm_counter.count\[6\] _0300_ _0083_ vssd1 vssd1 vccd1 vccd1
+ SYNTH_INST.pwm_counter.n_count\[0\] sky130_fd_sc_hd__a31o_1
X_0638_ SYNTH_INST.count\[0\] SYNTH_INST.count\[1\] SYNTH_INST.count\[2\] vssd1 vssd1
+ vccd1 vccd1 _0258_ sky130_fd_sc_hd__and3_1
X_0569_ _0200_ SYNTH_INST.waveshape.seq_div.state\[0\] vssd1 vssd1 vccd1 vccd1 _0201_
+ sky130_fd_sc_hd__and2b_1
XFILLER_0_121 vssd1 vssd1 vccd1 vccd1 sky130_fd_sc_hd__fill_1
XFILLER_0_165 vssd1 vssd1 vccd1 vccd1 sky130_fd_sc_hd__fill_2
XFILLER_8_221 vccd1 vssd1 vccd1 vssd1 sky130_ef_sc_hd__decap_40_12
XFILLER_5_65 vssd1 vssd1 vccd1 vccd1 sky130_fd_sc_hd__fill_1
XFILLER_14_63 vssd1 vssd1 vccd1 vccd1 sky130_fd_sc_hd__fill_1
XTAP_TAPCELL_ROW_1_88 vssd1 vccd1 sky130_fd_sc_hd__tapvpwrvgnd_1
XFILLER_29_180 vssd1 vssd1 vccd1 vccd1 sky130_fd_sc_hd__fill_8
X_0972_ clknet_4_4_0_clk _0010_ net52 vssd1 vssd1 vccd1 vccd1 SYNTH_INST.waveshape.seq_div.dividend\[14\]
+ sky130_fd_sc_hd__dfrtp_1
XFILLER_18_139 vssd1 vssd1 vccd1 vccd1 sky130_fd_sc_hd__fill_1
XFILLER_26_161 vssd1 vssd1 vccd1 vccd1 sky130_fd_sc_hd__fill_2
XFILLER_32_186 vssd1 vssd1 vccd1 vccd1 sky130_fd_sc_hd__fill_2
X_0886_ _0186_ _0187_ _0189_ SYNTH_INST.waveshape.seq_div.dividend\[44\] vssd1 vssd1
+ vccd1 vccd1 _0423_ sky130_fd_sc_hd__a211o_1
X_0955_ clknet_4_4_0_clk net10 net50 vssd1 vssd1 vccd1 vccd1 SYNTH_INST.keypad.keypad_reg\[4\]
+ sky130_fd_sc_hd__dfrtp_1
XFILLER_11_31 vssd1 vssd1 vccd1 vccd1 sky130_fd_sc_hd__fill_2
Xinput14 gpio_in[8] vssd1 vssd1 vccd1 vccd1 net14 sky130_fd_sc_hd__clkbuf_1
XTAP_TAPCELL_ROW_24_192 vssd1 vccd1 sky130_fd_sc_hd__tapvpwrvgnd_1
X_0740_ net168 net25 _0317_ vssd1 vssd1 vccd1 vccd1 _0011_ sky130_fd_sc_hd__o21a_1
X_0671_ SYNTH_INST.count\[14\] _0277_ vssd1 vssd1 vccd1 vccd1 _0279_ sky130_fd_sc_hd__xnor2_1
X_0869_ SYNTH_INST.waveshape.seq_div.dividend\[38\] net44 _0409_ _0410_ vssd1 vssd1
+ vccd1 vccd1 _0411_ sky130_fd_sc_hd__o2bb2a_1
XFILLER_20_167 vccd1 vssd1 vccd1 vssd1 sky130_ef_sc_hd__decap_40_12
X_0938_ clknet_4_4_0_clk SYNTH_INST.oscill.n_count\[6\] net50 vssd1 vssd1 vccd1 vccd1
+ SYNTH_INST.count\[6\] sky130_fd_sc_hd__dfrtp_1
XTAP_TAPCELL_ROW_7_116 vssd1 vccd1 sky130_fd_sc_hd__tapvpwrvgnd_1
XFILLER_11_189 vssd1 vssd1 vccd1 vccd1 sky130_fd_sc_hd__fill_2
XFILLER_22_41 vssd1 vssd1 vccd1 vccd1 sky130_fd_sc_hd__fill_4
XFILLER_19_212 vssd1 vssd1 vccd1 vccd1 sky130_fd_sc_hd__fill_4
XTAP_TAPCELL_ROW_12_140 vssd1 vccd1 sky130_fd_sc_hd__tapvpwrvgnd_1
X_0723_ SYNTH_INST.waveshape.seq_div.state\[0\] net31 _0226_ vssd1 vssd1 vccd1 vccd1
+ _0308_ sky130_fd_sc_hd__o21bai_1
X_0585_ _0213_ _0214_ vssd1 vssd1 vccd1 vccd1 _0216_ sky130_fd_sc_hd__or2_1
XFILLER_6_193 vssd1 vssd1 vccd1 vccd1 sky130_fd_sc_hd__fill_2
X_0654_ SYNTH_INST.count\[7\] SYNTH_INST.count\[8\] _0265_ vssd1 vssd1 vccd1 vccd1
+ _0268_ sky130_fd_sc_hd__and3_1
XANTENNA_clkbuf_4_7_0_clk_A clknet_0_clk vssd1 vssd1 vccd1 vccd1 sky130_fd_sc_hd__diode_2
XFILLER_25_215 vssd1 vssd1 vccd1 vccd1 sky130_fd_sc_hd__fill_2
XTAP_TAPCELL_ROW_35_243 vssd1 vccd1 sky130_fd_sc_hd__tapvpwrvgnd_1
Xhold3 SYNTH_INST.pwm_counter.sample\[6\] vssd1 vssd1 vccd1 vccd1 net134 sky130_fd_sc_hd__dlygate4sd3_1
XFILLER_12_6 vssd1 vssd1 vccd1 vccd1 sky130_fd_sc_hd__fill_1
X_0706_ SYNTH_INST.pwm_counter.count\[6\] _0300_ vssd1 vssd1 vccd1 vccd1 _0301_ sky130_fd_sc_hd__and2_1
Xclkbuf_4_4_0_clk clknet_0_clk vssd1 vssd1 vccd1 vccd1 clknet_4_4_0_clk sky130_fd_sc_hd__clkbuf_8
XFILLER_38_29 vssd1 vssd1 vccd1 vccd1 sky130_fd_sc_hd__fill_1
X_0499_ _0071_ _0113_ _0095_ vssd1 vssd1 vccd1 vccd1 _0132_ sky130_fd_sc_hd__a21o_1
X_0637_ net18 _0256_ _0257_ vssd1 vssd1 vccd1 vccd1 SYNTH_INST.oscill.n_count\[1\]
+ sky130_fd_sc_hd__and3_1
X_0568_ _0197_ _0198_ _0199_ vssd1 vssd1 vccd1 vccd1 _0200_ sky130_fd_sc_hd__and3_1
XFILLER_0_111 vssd1 vssd1 vccd1 vccd1 sky130_fd_sc_hd__fill_1
XANTENNA_input15_A gpio_in[9] vssd1 vssd1 vccd1 vccd1 sky130_fd_sc_hd__diode_2
XFILLER_5_44 vssd1 vssd1 vccd1 vccd1 sky130_fd_sc_hd__fill_1
XFILLER_8_233 vccd1 vssd1 vccd1 vssd1 sky130_ef_sc_hd__decap_40_12
XANTENNA_input7_A gpio_in[1] vssd1 vssd1 vccd1 vccd1 sky130_fd_sc_hd__diode_2
XFILLER_14_20 vssd1 vssd1 vccd1 vccd1 sky130_fd_sc_hd__fill_1
XFILLER_5_225 vccd1 vssd1 vccd1 vssd1 sky130_ef_sc_hd__decap_40_12
XFILLER_5_214 vssd1 vssd1 vccd1 vccd1 sky130_fd_sc_hd__fill_8
XFILLER_5_203 vssd1 vssd1 vccd1 vccd1 sky130_fd_sc_hd__fill_4
XTAP_TAPCELL_ROW_1_89 vssd1 vccd1 sky130_fd_sc_hd__tapvpwrvgnd_1
XFILLER_30_85 vssd1 vssd1 vccd1 vccd1 sky130_fd_sc_hd__fill_8
XANTENNA_clkbuf_4_15_0_clk_A clknet_0_clk vssd1 vssd1 vccd1 vccd1 sky130_fd_sc_hd__diode_2
X_0971_ clknet_4_4_0_clk _0009_ net50 vssd1 vssd1 vccd1 vccd1 SYNTH_INST.waveshape.seq_div.dividend\[13\]
+ sky130_fd_sc_hd__dfrtp_1
XFILLER_2_217 vccd1 vssd1 vccd1 vssd1 sky130_ef_sc_hd__decap_40_12
XFILLER_26_184 vssd1 vssd1 vccd1 vccd1 sky130_fd_sc_hd__fill_4
XFILLER_32_143 vssd1 vssd1 vccd1 vccd1 sky130_fd_sc_hd__fill_1
XTAP_TAPCELL_ROW_19_168 vssd1 vccd1 sky130_fd_sc_hd__tapvpwrvgnd_1
X_0885_ SYNTH_INST.waveshape.seq_div.dividend\[43\] net28 _0396_ _0422_ vssd1 vssd1
+ vccd1 vccd1 _0051_ sky130_fd_sc_hd__a22o_1
X_0954_ clknet_4_4_0_clk net9 net49 vssd1 vssd1 vccd1 vccd1 SYNTH_INST.keypad.keypad_reg\[3\]
+ sky130_fd_sc_hd__dfrtp_1
XFILLER_23_121 vssd1 vssd1 vccd1 vccd1 sky130_fd_sc_hd__fill_2
XFILLER_36_51 vssd1 vssd1 vccd1 vccd1 sky130_fd_sc_hd__fill_1
Xinput15 gpio_in[9] vssd1 vssd1 vccd1 vccd1 net15 sky130_fd_sc_hd__clkbuf_1
X_0670_ net19 _0277_ _0278_ vssd1 vssd1 vccd1 vccd1 SYNTH_INST.oscill.n_count\[13\]
+ sky130_fd_sc_hd__and3_1
XTAP_TAPCELL_ROW_24_193 vssd1 vccd1 sky130_fd_sc_hd__tapvpwrvgnd_1
XFILLER_20_113 vssd1 vssd1 vccd1 vccd1 sky130_fd_sc_hd__fill_1
X_0799_ _0349_ _0351_ _0357_ _0218_ net177 vssd1 vssd1 vccd1 vccd1 _0030_ sky130_fd_sc_hd__o32a_1
X_0868_ SYNTH_INST.waveshape.seq_div.dividend\[39\] _0104_ _0407_ _0073_ vssd1 vssd1
+ vccd1 vccd1 _0410_ sky130_fd_sc_hd__a31o_1
XANTENNA_clkbuf_4_3_0_clk_A clknet_0_clk vssd1 vssd1 vccd1 vccd1 sky130_fd_sc_hd__diode_2
XFILLER_20_179 vssd1 vssd1 vccd1 vccd1 sky130_fd_sc_hd__fill_2
X_0937_ clknet_4_1_0_clk SYNTH_INST.oscill.n_count\[5\] net50 vssd1 vssd1 vccd1 vccd1
+ SYNTH_INST.count\[5\] sky130_fd_sc_hd__dfrtp_1
XTAP_TAPCELL_ROW_7_117 vssd1 vccd1 sky130_fd_sc_hd__tapvpwrvgnd_1
XFILLER_28_224 vssd1 vssd1 vccd1 vccd1 sky130_fd_sc_hd__fill_1
XFILLER_7_139 vssd1 vssd1 vccd1 vccd1 sky130_fd_sc_hd__fill_1
XANTENNA_fanout28_A net29 vssd1 vssd1 vccd1 vccd1 sky130_fd_sc_hd__diode_2
X_0722_ SYNTH_INST.waveshape.seq_div.state\[0\] net31 _0226_ vssd1 vssd1 vccd1 vccd1
+ _0307_ sky130_fd_sc_hd__o21ba_1
X_0653_ net172 _0265_ _0267_ vssd1 vssd1 vccd1 vccd1 SYNTH_INST.oscill.n_count\[7\]
+ sky130_fd_sc_hd__a21oi_1
X_0584_ SYNTH_INST.keypad.keypad_reg\[9\] _0214_ vssd1 vssd1 vccd1 vccd1 _0215_ sky130_fd_sc_hd__nor2_1
XFILLER_25_238 vssd1 vssd1 vccd1 vccd1 sky130_fd_sc_hd__fill_1
XFILLER_33_41 vssd1 vssd1 vccd1 vccd1 sky130_fd_sc_hd__fill_1
XFILLER_17_97 vssd1 vssd1 vccd1 vccd1 sky130_fd_sc_hd__fill_1
XTAP_TAPCELL_ROW_26_200 vssd1 vccd1 sky130_fd_sc_hd__tapvpwrvgnd_1
Xhold4 _0067_ vssd1 vssd1 vccd1 vccd1 net135 sky130_fd_sc_hd__dlygate4sd3_1
X_0705_ SYNTH_INST.pwm_counter.count\[5\] SYNTH_INST.pwm_counter.count\[4\] _0299_
+ vssd1 vssd1 vccd1 vccd1 _0300_ sky130_fd_sc_hd__and3_1
X_0636_ SYNTH_INST.count\[0\] SYNTH_INST.count\[1\] vssd1 vssd1 vccd1 vccd1 _0257_
+ sky130_fd_sc_hd__nand2_1
X_0567_ SYNTH_INST.sample_rate.count\[7\] SYNTH_INST.sample_rate.count\[6\] vssd1
+ vssd1 vccd1 vccd1 _0199_ sky130_fd_sc_hd__nor2_1
X_0498_ net34 _0112_ vssd1 vssd1 vccd1 vccd1 _0131_ sky130_fd_sc_hd__nor2_1
XPHY_EDGE_ROW_17_Right_17 vssd1 vssd1 vccd1 vccd1 sky130_fd_sc_hd__decap_3
XANTENNA__0440__A net40 vssd1 vssd1 vccd1 vccd1 sky130_fd_sc_hd__diode_2
XFILLER_0_101 vssd1 vssd1 vccd1 vccd1 sky130_fd_sc_hd__fill_2
XFILLER_0_167 vssd1 vssd1 vccd1 vccd1 sky130_fd_sc_hd__fill_1
XPHY_EDGE_ROW_26_Right_26 vssd1 vssd1 vccd1 vccd1 sky130_fd_sc_hd__decap_3
XFILLER_28_41 vssd1 vssd1 vccd1 vccd1 sky130_fd_sc_hd__fill_1
XFILLER_28_85 vssd1 vssd1 vccd1 vccd1 sky130_fd_sc_hd__fill_8
XPHY_EDGE_ROW_35_Right_35 vssd1 vssd1 vccd1 vccd1 sky130_fd_sc_hd__decap_3
XFILLER_8_245 vssd1 vssd1 vccd1 vccd1 sky130_fd_sc_hd__fill_4
XANTENNA_clkbuf_4_11_0_clk_A clknet_0_clk vssd1 vssd1 vccd1 vccd1 sky130_fd_sc_hd__diode_2
XFILLER_5_78 vssd1 vssd1 vccd1 vccd1 sky130_fd_sc_hd__fill_8
XPHY_EDGE_ROW_17_Left_56 vssd1 vssd1 vccd1 vccd1 sky130_fd_sc_hd__decap_3
X_0619_ _0098_ _0144_ SYNTH_INST.count\[6\] vssd1 vssd1 vccd1 vccd1 _0241_ sky130_fd_sc_hd__a21oi_1
XFILLER_5_237 vccd1 vssd1 vccd1 vssd1 sky130_ef_sc_hd__decap_40_12
Xclkbuf_4_3_0_clk clknet_0_clk vssd1 vssd1 vccd1 vccd1 clknet_4_3_0_clk sky130_fd_sc_hd__clkbuf_8
X_0970_ clknet_4_4_0_clk _0008_ net50 vssd1 vssd1 vccd1 vccd1 SYNTH_INST.waveshape.seq_div.dividend\[12\]
+ sky130_fd_sc_hd__dfrtp_1
XFILLER_2_229 vccd1 vssd1 vccd1 vssd1 sky130_ef_sc_hd__decap_40_12
XFILLER_26_163 vssd1 vssd1 vccd1 vccd1 sky130_fd_sc_hd__fill_1
XTAP_TAPCELL_ROW_19_169 vssd1 vccd1 sky130_fd_sc_hd__tapvpwrvgnd_1
X_0884_ SYNTH_INST.waveshape.seq_div.dividend\[42\] net44 _0421_ net39 vssd1 vssd1
+ vccd1 vccd1 _0422_ sky130_fd_sc_hd__a22o_1
X_0953_ clknet_4_4_0_clk net8 net49 vssd1 vssd1 vccd1 vccd1 SYNTH_INST.keypad.keypad_reg\[2\]
+ sky130_fd_sc_hd__dfrtp_1
XFILLER_23_111 vssd1 vssd1 vccd1 vccd1 sky130_fd_sc_hd__fill_1
XFILLER_2_6 vccd1 vssd1 vccd1 vssd1 sky130_ef_sc_hd__decap_40_12
XFILLER_11_33 vssd1 vssd1 vccd1 vccd1 sky130_fd_sc_hd__fill_1
XFILLER_11_66 vssd1 vssd1 vccd1 vccd1 sky130_fd_sc_hd__fill_2
XTAP_TAPCELL_ROW_24_194 vssd1 vccd1 sky130_fd_sc_hd__tapvpwrvgnd_1
Xinput16 nrst vssd1 vssd1 vccd1 vccd1 net16 sky130_fd_sc_hd__clkbuf_1
XTAP_TAPCELL_ROW_15_150 vssd1 vccd1 sky130_fd_sc_hd__tapvpwrvgnd_1
X_0936_ clknet_4_4_0_clk SYNTH_INST.oscill.n_count\[4\] net50 vssd1 vssd1 vccd1 vccd1
+ SYNTH_INST.count\[4\] sky130_fd_sc_hd__dfrtp_2
X_0798_ SYNTH_INST.keypad.keypad_reg\[3\] _0209_ _0345_ _0356_ SYNTH_INST.keypad.n_modekey
+ vssd1 vssd1 vccd1 vccd1 _0357_ sky130_fd_sc_hd__a311o_1
X_0867_ _0104_ _0407_ SYNTH_INST.waveshape.seq_div.dividend\[39\] vssd1 vssd1 vccd1
+ vccd1 _0409_ sky130_fd_sc_hd__a21oi_1
XTAP_TAPCELL_ROW_38_253 vssd1 vccd1 sky130_fd_sc_hd__tapvpwrvgnd_1
XFILLER_7_129 vssd1 vssd1 vccd1 vccd1 sky130_fd_sc_hd__fill_1
XPHY_EDGE_ROW_5_Left_44 vssd1 vssd1 vccd1 vccd1 sky130_fd_sc_hd__decap_3
X_0583_ SYNTH_INST.keypad.keypad_reg\[11\] SYNTH_INST.keypad.keypad_reg\[10\] vssd1
+ vssd1 vccd1 vccd1 _0214_ sky130_fd_sc_hd__or2_1
XFILLER_6_151 vssd1 vssd1 vccd1 vccd1 sky130_fd_sc_hd__fill_8
XFILLER_6_195 vssd1 vssd1 vccd1 vccd1 sky130_fd_sc_hd__fill_1
X_0721_ net39 net44 vssd1 vssd1 vccd1 vccd1 _0306_ sky130_fd_sc_hd__nor2_1
X_0652_ SYNTH_INST.count\[7\] _0265_ net18 vssd1 vssd1 vccd1 vccd1 _0267_ sky130_fd_sc_hd__o21ai_1
X_0919_ clknet_4_13_0_clk SYNTH_INST.waveshape.shaper.n_sample\[3\] net58 vssd1 vssd1
+ vccd1 vccd1 SYNTH_INST.pwm_counter.sample\[3\] sky130_fd_sc_hd__dfrtp_1
XTAP_TAPCELL_ROW_26_201 vssd1 vccd1 sky130_fd_sc_hd__tapvpwrvgnd_1
XFILLER_33_64 vssd1 vssd1 vccd1 vccd1 sky130_fd_sc_hd__fill_2
XFILLER_17_87 vssd1 vssd1 vccd1 vccd1 sky130_fd_sc_hd__fill_2
XFILLER_24_250 vssd1 vssd1 vccd1 vccd1 sky130_fd_sc_hd__fill_2
Xhold5 SYNTH_INST.pwm_counter.sample\[1\] vssd1 vssd1 vccd1 vccd1 net136 sky130_fd_sc_hd__dlygate4sd3_1
XTAP_TAPCELL_ROW_32_226 vssd1 vccd1 sky130_fd_sc_hd__tapvpwrvgnd_1
XFILLER_30_253 vssd1 vssd1 vccd1 vccd1 sky130_fd_sc_hd__fill_2
X_0704_ SYNTH_INST.pwm_counter.count\[3\] _0298_ vssd1 vssd1 vccd1 vccd1 _0299_ sky130_fd_sc_hd__and2_1
X_0635_ SYNTH_INST.count\[0\] SYNTH_INST.count\[1\] vssd1 vssd1 vccd1 vccd1 _0256_
+ sky130_fd_sc_hd__or2_1
X_0566_ _0091_ _0095_ vssd1 vssd1 vccd1 vccd1 _0198_ sky130_fd_sc_hd__nand2_1
X_0497_ net34 _0113_ _0090_ vssd1 vssd1 vccd1 vccd1 _0130_ sky130_fd_sc_hd__a21o_1
XFILLER_0_113 vssd1 vssd1 vccd1 vccd1 sky130_fd_sc_hd__fill_8
XANTENNA_fanout43_X net43 vssd1 vssd1 vccd1 vccd1 sky130_fd_sc_hd__diode_2
XFILLER_8_213 vssd1 vssd1 vccd1 vccd1 sky130_fd_sc_hd__fill_1
XFILLER_12_253 vssd1 vssd1 vccd1 vccd1 sky130_fd_sc_hd__fill_2
X_0549_ _0172_ _0178_ vssd1 vssd1 vccd1 vccd1 _0182_ sky130_fd_sc_hd__nand2b_1
X_0618_ _0237_ _0238_ _0239_ vssd1 vssd1 vccd1 vccd1 _0240_ sky130_fd_sc_hd__a21o_1
XFILLER_5_249 vssd1 vssd1 vccd1 vccd1 sky130_fd_sc_hd__fill_2
XPHY_EDGE_ROW_34_Left_73 vssd1 vssd1 vccd1 vccd1 sky130_fd_sc_hd__decap_3
XFILLER_29_150 vssd1 vssd1 vccd1 vccd1 sky130_fd_sc_hd__fill_2
XFILLER_25_87 vssd1 vssd1 vccd1 vccd1 sky130_fd_sc_hd__fill_2
X_0952_ clknet_4_7_0_clk net7 net51 vssd1 vssd1 vccd1 vccd1 SYNTH_INST.keypad.keypad_reg\[1\]
+ sky130_fd_sc_hd__dfrtp_1
X_0883_ SYNTH_INST.waveshape.seq_div.dividend\[43\] _0418_ vssd1 vssd1 vccd1 vccd1
+ _0421_ sky130_fd_sc_hd__xnor2_1
XFILLER_23_101 vssd1 vssd1 vccd1 vccd1 sky130_fd_sc_hd__fill_1
XFILLER_23_123 vssd1 vssd1 vccd1 vccd1 sky130_fd_sc_hd__fill_1
Xclkbuf_4_2_0_clk clknet_0_clk vssd1 vssd1 vccd1 vccd1 clknet_4_2_0_clk sky130_fd_sc_hd__clkbuf_8
X_0866_ net184 net28 _0396_ _0408_ vssd1 vssd1 vccd1 vccd1 _0046_ sky130_fd_sc_hd__a22o_1
XTAP_TAPCELL_ROW_15_151 vssd1 vccd1 sky130_fd_sc_hd__tapvpwrvgnd_1
XPHY_EDGE_ROW_21_Left_60 vssd1 vssd1 vccd1 vccd1 sky130_fd_sc_hd__decap_3
X_0935_ clknet_4_1_0_clk SYNTH_INST.oscill.n_count\[3\] net50 vssd1 vssd1 vccd1 vccd1
+ SYNTH_INST.count\[3\] sky130_fd_sc_hd__dfrtp_1
X_0797_ _0333_ _0355_ _0212_ vssd1 vssd1 vccd1 vccd1 _0356_ sky130_fd_sc_hd__o21a_1
XTAP_TAPCELL_ROW_38_254 vssd1 vccd1 sky130_fd_sc_hd__tapvpwrvgnd_1
XFILLER_34_229 vssd1 vssd1 vccd1 vccd1 sky130_fd_sc_hd__fill_1
XFILLER_34_218 vssd1 vssd1 vccd1 vccd1 sky130_fd_sc_hd__fill_1
X_0720_ SYNTH_INST.waveshape.seq_div.dividend\[47\] _0193_ net138 vssd1 vssd1 vccd1
+ vccd1 _0000_ sky130_fd_sc_hd__o21a_1
X_0582_ SYNTH_INST.keypad.keypad_reg\[9\] SYNTH_INST.keypad.keypad_reg\[8\] vssd1
+ vssd1 vccd1 vccd1 _0213_ sky130_fd_sc_hd__or2_1
X_0651_ _0265_ _0266_ vssd1 vssd1 vccd1 vccd1 SYNTH_INST.oscill.n_count\[6\] sky130_fd_sc_hd__nor2_1
X_0849_ SYNTH_INST.waveshape.seq_div.dividend\[34\] _0395_ net26 vssd1 vssd1 vccd1
+ vccd1 _0042_ sky130_fd_sc_hd__mux2_1
X_0918_ clknet_4_12_0_clk SYNTH_INST.waveshape.shaper.n_sample\[2\] net57 vssd1 vssd1
+ vccd1 vccd1 SYNTH_INST.pwm_counter.sample\[2\] sky130_fd_sc_hd__dfrtp_1
XTAP_TAPCELL_ROW_26_202 vssd1 vccd1 sky130_fd_sc_hd__tapvpwrvgnd_1
XFILLER_33_98 vssd1 vssd1 vccd1 vccd1 sky130_fd_sc_hd__fill_2
XFILLER_3_166 vssd1 vssd1 vccd1 vccd1 sky130_fd_sc_hd__fill_2
XFILLER_3_199 vssd1 vssd1 vccd1 vccd1 sky130_fd_sc_hd__fill_2
Xhold6 _0062_ vssd1 vssd1 vccd1 vccd1 net137 sky130_fd_sc_hd__dlygate4sd3_1
XTAP_TAPCELL_ROW_32_227 vssd1 vccd1 sky130_fd_sc_hd__tapvpwrvgnd_1
XFILLER_30_210 vssd1 vssd1 vccd1 vccd1 sky130_fd_sc_hd__fill_1
X_0703_ SYNTH_INST.pwm_counter.count\[2\] SYNTH_INST.pwm_counter.count\[1\] SYNTH_INST.pwm_counter.count\[0\]
+ vssd1 vssd1 vccd1 vccd1 _0298_ sky130_fd_sc_hd__and3_1
X_0496_ SYNTH_INST.waveshape.seq_div.dividend\[25\] _0128_ vssd1 vssd1 vccd1 vccd1
+ _0129_ sky130_fd_sc_hd__and2_1
X_0634_ net169 net18 vssd1 vssd1 vccd1 vccd1 SYNTH_INST.oscill.n_count\[0\] sky130_fd_sc_hd__nand2_1
X_0565_ SYNTH_INST.sample_rate.count\[5\] SYNTH_INST.sample_rate.count\[4\] _0196_
+ vssd1 vssd1 vccd1 vccd1 _0197_ sky130_fd_sc_hd__and3_1
XPHY_EDGE_ROW_3_Right_3 vssd1 vssd1 vccd1 vccd1 sky130_fd_sc_hd__decap_3
XFILLER_21_221 vssd1 vssd1 vccd1 vccd1 sky130_fd_sc_hd__fill_2
XFILLER_0_169 vccd1 vssd1 vccd1 vssd1 sky130_ef_sc_hd__decap_40_12
XFILLER_10_6 vccd1 vssd1 vccd1 vssd1 sky130_ef_sc_hd__decap_40_12
X_0548_ _0157_ _0160_ _0180_ vssd1 vssd1 vccd1 vccd1 _0181_ sky130_fd_sc_hd__a21o_1
X_0617_ _0084_ _0150_ _0153_ SYNTH_INST.count\[4\] vssd1 vssd1 vccd1 vccd1 _0239_
+ sky130_fd_sc_hd__a2bb2o_1
X_0479_ net38 net35 vssd1 vssd1 vccd1 vccd1 _0112_ sky130_fd_sc_hd__xor2_1
XFILLER_38_195 vssd1 vssd1 vccd1 vccd1 sky130_fd_sc_hd__fill_1
XFILLER_30_11 vssd1 vssd1 vccd1 vccd1 sky130_fd_sc_hd__fill_8
XFILLER_30_66 vssd1 vssd1 vccd1 vccd1 sky130_fd_sc_hd__fill_2
XANTENNA_input13_A gpio_in[7] vssd1 vssd1 vccd1 vccd1 sky130_fd_sc_hd__diode_2
XFILLER_29_140 vssd1 vssd1 vccd1 vccd1 sky130_fd_sc_hd__fill_2
XANTENNA_input5_A gpio_in[12] vssd1 vssd1 vccd1 vccd1 sky130_fd_sc_hd__diode_2
XFILLER_25_55 vssd1 vssd1 vccd1 vccd1 sky130_fd_sc_hd__fill_1
XFILLER_26_132 vssd1 vssd1 vccd1 vccd1 sky130_fd_sc_hd__fill_2
XFILLER_2_26 vssd1 vssd1 vccd1 vccd1 sky130_fd_sc_hd__fill_2
XFILLER_17_110 vssd1 vssd1 vccd1 vccd1 sky130_fd_sc_hd__fill_2
X_0951_ clknet_4_7_0_clk net2 net51 vssd1 vssd1 vccd1 vccd1 SYNTH_INST.keypad.keypad_reg\[0\]
+ sky130_fd_sc_hd__dfrtp_1
XFILLER_32_135 vssd1 vssd1 vccd1 vccd1 sky130_fd_sc_hd__fill_4
X_0882_ SYNTH_INST.waveshape.seq_div.dividend\[42\] net26 _0420_ vssd1 vssd1 vccd1
+ vccd1 _0050_ sky130_fd_sc_hd__o21a_1
XTAP_TAPCELL_ROW_2_91 vssd1 vccd1 sky130_fd_sc_hd__tapvpwrvgnd_1
XFILLER_11_57 vssd1 vssd1 vccd1 vccd1 sky130_fd_sc_hd__fill_2
XFILLER_36_21 vssd1 vssd1 vccd1 vccd1 sky130_fd_sc_hd__fill_1
XTAP_TAPCELL_ROW_15_152 vssd1 vccd1 sky130_fd_sc_hd__tapvpwrvgnd_1
XFILLER_20_105 vssd1 vssd1 vccd1 vccd1 sky130_fd_sc_hd__fill_1
XFILLER_9_183 vccd1 vssd1 vccd1 vssd1 sky130_ef_sc_hd__decap_40_12
X_0865_ net39 _0406_ _0407_ net45 SYNTH_INST.waveshape.seq_div.dividend\[37\] vssd1
+ vssd1 vccd1 vccd1 _0408_ sky130_fd_sc_hd__a32o_1
X_0934_ clknet_4_1_0_clk SYNTH_INST.oscill.n_count\[2\] net47 vssd1 vssd1 vccd1 vccd1
+ SYNTH_INST.count\[2\] sky130_fd_sc_hd__dfrtp_1
X_0796_ SYNTH_INST.keypad.keypad_reg\[10\] _0213_ _0334_ SYNTH_INST.keypad.keypad_reg\[11\]
+ vssd1 vssd1 vccd1 vccd1 _0355_ sky130_fd_sc_hd__and4bb_1
XTAP_TAPCELL_ROW_38_255 vssd1 vccd1 sky130_fd_sc_hd__tapvpwrvgnd_1
XANTENNA__0724__B net29 vssd1 vssd1 vccd1 vccd1 sky130_fd_sc_hd__diode_2
XTAP_TAPCELL_ROW_21_177 vssd1 vccd1 sky130_fd_sc_hd__tapvpwrvgnd_1
XFILLER_22_45 vssd1 vssd1 vccd1 vccd1 sky130_fd_sc_hd__fill_1
XFILLER_19_216 vssd1 vssd1 vccd1 vccd1 sky130_fd_sc_hd__fill_2
XFILLER_6_131 vssd1 vssd1 vccd1 vccd1 sky130_fd_sc_hd__fill_1
XANTENNA__0947__RESET_B net48 vssd1 vssd1 vccd1 vccd1 sky130_fd_sc_hd__diode_2
X_0581_ _0210_ _0211_ vssd1 vssd1 vccd1 vccd1 _0212_ sky130_fd_sc_hd__nor2_1
X_0650_ SYNTH_INST.count\[6\] _0263_ net18 vssd1 vssd1 vccd1 vccd1 _0266_ sky130_fd_sc_hd__o21ai_1
Xclkbuf_4_1_0_clk clknet_0_clk vssd1 vssd1 vccd1 vccd1 clknet_4_1_0_clk sky130_fd_sc_hd__clkbuf_8
X_0779_ _0210_ _0216_ _0334_ vssd1 vssd1 vccd1 vccd1 _0340_ sky130_fd_sc_hd__or3b_1
X_0848_ net39 _0393_ _0394_ net45 SYNTH_INST.waveshape.seq_div.dividend\[33\] vssd1
+ vssd1 vccd1 vccd1 _0395_ sky130_fd_sc_hd__a32o_1
X_0917_ clknet_4_12_0_clk SYNTH_INST.waveshape.shaper.n_sample\[1\] net58 vssd1 vssd1
+ vccd1 vccd1 SYNTH_INST.pwm_counter.sample\[1\] sky130_fd_sc_hd__dfrtp_1
XFILLER_24_241 vssd1 vssd1 vccd1 vccd1 sky130_fd_sc_hd__fill_1
XTAP_TAPCELL_ROW_26_203 vssd1 vccd1 sky130_fd_sc_hd__tapvpwrvgnd_1
XFILLER_33_77 vssd1 vssd1 vccd1 vccd1 sky130_fd_sc_hd__fill_1
XFILLER_33_44 vssd1 vssd1 vccd1 vccd1 sky130_fd_sc_hd__fill_2
XANTENNA_fanout26_A net27 vssd1 vssd1 vccd1 vccd1 sky130_fd_sc_hd__diode_2
Xhold7 SYNTH_INST.waveshape.seq_div.state\[2\] vssd1 vssd1 vccd1 vccd1 net138 sky130_fd_sc_hd__dlygate4sd3_1
XTAP_TAPCELL_ROW_32_228 vssd1 vccd1 sky130_fd_sc_hd__tapvpwrvgnd_1
X_0702_ SYNTH_INST.state_machine.fsmState\[1\] SYNTH_INST.mode\[1\] _0296_ vssd1 vssd1
+ vccd1 vccd1 SYNTH_INST.state_machine.nextState\[2\] sky130_fd_sc_hd__mux2_1
X_0633_ _0249_ _0253_ _0254_ vssd1 vssd1 vccd1 vccd1 _0255_ sky130_fd_sc_hd__a21oi_1
X_0495_ _0117_ _0126_ _0127_ _0088_ vssd1 vssd1 vccd1 vccd1 _0128_ sky130_fd_sc_hd__a2bb2o_1
X_0564_ SYNTH_INST.sample_rate.count\[3\] _0195_ vssd1 vssd1 vccd1 vccd1 _0196_ sky130_fd_sc_hd__and2_1
XFILLER_0_81 vssd1 vssd1 vccd1 vccd1 sky130_fd_sc_hd__fill_2
XANTENNA_fanout29_X net29 vssd1 vssd1 vccd1 vccd1 sky130_fd_sc_hd__diode_2
XFILLER_5_26 vssd1 vssd1 vccd1 vccd1 sky130_fd_sc_hd__fill_2
XPHY_EDGE_ROW_13_Right_13 vssd1 vssd1 vccd1 vccd1 sky130_fd_sc_hd__decap_3
XPHY_EDGE_ROW_22_Right_22 vssd1 vssd1 vccd1 vccd1 sky130_fd_sc_hd__decap_3
X_0616_ SYNTH_INST.count\[3\] _0114_ _0153_ SYNTH_INST.count\[4\] vssd1 vssd1 vccd1
+ vccd1 _0238_ sky130_fd_sc_hd__o22a_1
XFILLER_38_141 vccd1 vssd1 vccd1 vssd1 sky130_ef_sc_hd__decap_40_12
XPHY_EDGE_ROW_31_Right_31 vssd1 vssd1 vccd1 vccd1 sky130_fd_sc_hd__decap_3
X_0547_ _0170_ _0174_ _0179_ vssd1 vssd1 vccd1 vccd1 _0180_ sky130_fd_sc_hd__or3b_1
X_0478_ net37 net35 vssd1 vssd1 vccd1 vccd1 _0111_ sky130_fd_sc_hd__and2_1
XFILLER_35_177 vssd1 vssd1 vccd1 vccd1 sky130_fd_sc_hd__fill_1
XFILLER_35_111 vssd1 vssd1 vccd1 vccd1 sky130_fd_sc_hd__fill_1
XANTENNA__0833__A net40 vssd1 vssd1 vccd1 vccd1 sky130_fd_sc_hd__diode_2
XANTENNA_clkbuf_0_clk_X clknet_0_clk vssd1 vssd1 vccd1 vccd1 sky130_fd_sc_hd__diode_2
XFILLER_17_144 vssd1 vssd1 vccd1 vccd1 sky130_fd_sc_hd__fill_1
X_0950_ clknet_4_7_0_clk SYNTH_INST.state_machine.nextState\[2\] net53 vssd1 vssd1
+ vccd1 vccd1 SYNTH_INST.mode\[1\] sky130_fd_sc_hd__dfrtp_1
X_0881_ SYNTH_INST.waveshape.seq_div.dividend\[41\] net44 _0419_ net39 net29 vssd1
+ vssd1 vccd1 vccd1 _0420_ sky130_fd_sc_hd__a221o_1
XTAP_TAPCELL_ROW_2_92 vssd1 vccd1 sky130_fd_sc_hd__tapvpwrvgnd_1
XFILLER_23_169 vssd1 vssd1 vccd1 vccd1 sky130_fd_sc_hd__fill_2
XTAP_TAPCELL_ROW_15_153 vssd1 vccd1 sky130_fd_sc_hd__tapvpwrvgnd_1
XFILLER_9_195 vssd1 vssd1 vccd1 vccd1 sky130_fd_sc_hd__fill_2
X_0864_ _0096_ _0100_ _0400_ _0108_ _0101_ vssd1 vssd1 vccd1 vccd1 _0407_ sky130_fd_sc_hd__a311o_1
X_0933_ clknet_4_1_0_clk SYNTH_INST.oscill.n_count\[1\] net47 vssd1 vssd1 vccd1 vccd1
+ SYNTH_INST.count\[1\] sky130_fd_sc_hd__dfrtp_2
X_0795_ net36 _0218_ _0351_ _0354_ vssd1 vssd1 vccd1 vccd1 _0029_ sky130_fd_sc_hd__o22a_1
XTAP_TAPCELL_ROW_38_256 vssd1 vccd1 sky130_fd_sc_hd__tapvpwrvgnd_1
XFILLER_11_128 vssd1 vssd1 vccd1 vccd1 sky130_fd_sc_hd__fill_2
XTAP_TAPCELL_ROW_21_178 vssd1 vccd1 sky130_fd_sc_hd__tapvpwrvgnd_1
XTAP_TAPCELL_ROW_6_110 vssd1 vccd1 sky130_fd_sc_hd__tapvpwrvgnd_1
XFILLER_10_183 vccd1 vssd1 vccd1 vssd1 sky130_ef_sc_hd__decap_40_12
X_0580_ SYNTH_INST.keypad.keypad_reg\[5\] SYNTH_INST.keypad.keypad_reg\[4\] SYNTH_INST.keypad.keypad_reg\[7\]
+ SYNTH_INST.keypad.keypad_reg\[6\] vssd1 vssd1 vccd1 vccd1 _0211_ sky130_fd_sc_hd__or4_1
X_0947__96 vssd1 vssd1 vccd1 vccd1 _0947__96/HI net96 sky130_fd_sc_hd__conb_1
X_0916_ clknet_4_12_0_clk SYNTH_INST.waveshape.shaper.n_sample\[0\] net57 vssd1 vssd1
+ vccd1 vccd1 SYNTH_INST.pwm_counter.sample\[0\] sky130_fd_sc_hd__dfrtp_1
X_0778_ _0337_ _0338_ _0218_ vssd1 vssd1 vccd1 vccd1 _0339_ sky130_fd_sc_hd__o21ai_1
X_0847_ _0169_ _0392_ vssd1 vssd1 vccd1 vccd1 _0394_ sky130_fd_sc_hd__or2_1
XFILLER_33_23 vccd1 vssd1 vccd1 vssd1 sky130_ef_sc_hd__decap_40_12
XPHY_EDGE_ROW_9_Left_48 vssd1 vssd1 vccd1 vccd1 sky130_fd_sc_hd__decap_3
XFILLER_17_57 vssd1 vssd1 vccd1 vccd1 sky130_fd_sc_hd__fill_2
XFILLER_24_253 vssd1 vssd1 vccd1 vccd1 sky130_fd_sc_hd__fill_2
XFILLER_3_113 vssd1 vssd1 vccd1 vccd1 sky130_fd_sc_hd__fill_1
Xhold8 _0000_ vssd1 vssd1 vccd1 vccd1 net139 sky130_fd_sc_hd__dlygate4sd3_1
XTAP_TAPCELL_ROW_32_229 vssd1 vccd1 sky130_fd_sc_hd__tapvpwrvgnd_1
X_0701_ SYNTH_INST.state_machine.fsmState\[1\] _0085_ _0297_ vssd1 vssd1 vccd1 vccd1
+ SYNTH_INST.state_machine.nextState\[1\] sky130_fd_sc_hd__mux2_1
X_0632_ SYNTH_INST.count\[14\] _0091_ _0250_ _0251_ SYNTH_INST.count\[15\] vssd1 vssd1
+ vccd1 vccd1 _0254_ sky130_fd_sc_hd__a221o_1
X_0563_ SYNTH_INST.sample_rate.count\[1\] SYNTH_INST.sample_rate.count\[0\] SYNTH_INST.sample_rate.count\[2\]
+ vssd1 vssd1 vccd1 vccd1 _0195_ sky130_fd_sc_hd__and3_1
X_0494_ net36 net33 vssd1 vssd1 vccd1 vccd1 _0127_ sky130_fd_sc_hd__nand2b_1
X_1115_ SYNTH_INST.pwm vssd1 vssd1 vccd1 vccd1 net17 sky130_fd_sc_hd__clkbuf_1
XFILLER_21_223 vssd1 vssd1 vccd1 vccd1 sky130_fd_sc_hd__fill_1
XFILLER_0_138 vssd1 vssd1 vccd1 vccd1 sky130_fd_sc_hd__fill_2
XFILLER_28_45 vssd1 vssd1 vccd1 vccd1 sky130_fd_sc_hd__fill_4
XFILLER_8_249 vssd1 vssd1 vccd1 vccd1 sky130_fd_sc_hd__fill_2
Xclkbuf_4_0_0_clk clknet_0_clk vssd1 vssd1 vccd1 vccd1 clknet_4_0_0_clk sky130_fd_sc_hd__clkbuf_8
X_0546_ _0177_ _0178_ vssd1 vssd1 vccd1 vccd1 _0179_ sky130_fd_sc_hd__and2_1
X_0615_ _0234_ _0235_ _0236_ _0233_ vssd1 vssd1 vccd1 vccd1 _0237_ sky130_fd_sc_hd__a31o_1
XFILLER_38_153 vssd1 vssd1 vccd1 vccd1 sky130_fd_sc_hd__fill_4
X_0477_ _0107_ _0108_ vssd1 vssd1 vccd1 vccd1 _0110_ sky130_fd_sc_hd__nor2_1
X_1029_ clknet_4_10_0_clk _0053_ net55 vssd1 vssd1 vccd1 vccd1 SYNTH_INST.waveshape.seq_div.dividend\[45\]
+ sky130_fd_sc_hd__dfrtp_1
XFILLER_30_68 vssd1 vssd1 vccd1 vccd1 sky130_fd_sc_hd__fill_1
XFILLER_30_79 vssd1 vssd1 vccd1 vccd1 sky130_fd_sc_hd__fill_4
XFILLER_29_142 vssd1 vssd1 vccd1 vccd1 sky130_fd_sc_hd__fill_1
XFILLER_4_230 vccd1 vssd1 vccd1 vssd1 sky130_ef_sc_hd__decap_40_12
XFILLER_35_101 vssd1 vssd1 vccd1 vccd1 sky130_fd_sc_hd__fill_8
XFILLER_35_167 vssd1 vssd1 vccd1 vccd1 sky130_fd_sc_hd__fill_1
X_0529_ net33 _0094_ _0131_ _0127_ _0126_ vssd1 vssd1 vccd1 vccd1 _0162_ sky130_fd_sc_hd__o32a_2
XFILLER_26_134 vssd1 vssd1 vccd1 vccd1 sky130_fd_sc_hd__fill_1
XPHY_EDGE_ROW_38_Left_77 vssd1 vssd1 vccd1 vccd1 sky130_fd_sc_hd__decap_3
XFILLER_25_57 vssd1 vssd1 vccd1 vccd1 sky130_fd_sc_hd__fill_2
XFILLER_9_3 vssd1 vssd1 vccd1 vccd1 sky130_fd_sc_hd__fill_2
XFILLER_17_167 vssd1 vssd1 vccd1 vccd1 sky130_fd_sc_hd__fill_1
X_0880_ SYNTH_INST.waveshape.seq_div.dividend\[42\] _0415_ vssd1 vssd1 vccd1 vccd1
+ _0419_ sky130_fd_sc_hd__xnor2_1
XTAP_TAPCELL_ROW_2_93 vssd1 vccd1 sky130_fd_sc_hd__tapvpwrvgnd_1
XFILLER_14_115 vssd1 vssd1 vccd1 vccd1 sky130_fd_sc_hd__fill_1
XFILLER_14_137 vssd1 vssd1 vccd1 vccd1 sky130_fd_sc_hd__fill_2
XANTENNA__0811__B1 net29 vssd1 vssd1 vccd1 vccd1 sky130_fd_sc_hd__diode_2
X_0932_ clknet_4_0_0_clk SYNTH_INST.oscill.n_count\[0\] net47 vssd1 vssd1 vccd1 vccd1
+ SYNTH_INST.count\[0\] sky130_fd_sc_hd__dfrtp_2
X_0794_ SYNTH_INST.keypad.keypad_reg\[1\] _0074_ _0346_ _0353_ _0339_ vssd1 vssd1
+ vccd1 vccd1 _0354_ sky130_fd_sc_hd__a311o_1
X_0863_ _0101_ _0400_ _0108_ _0103_ vssd1 vssd1 vccd1 vccd1 _0406_ sky130_fd_sc_hd__o211ai_1
XTAP_TAPCELL_ROW_38_257 vssd1 vccd1 sky130_fd_sc_hd__tapvpwrvgnd_1
XTAP_TAPCELL_ROW_21_179 vssd1 vccd1 sky130_fd_sc_hd__tapvpwrvgnd_1
XTAP_TAPCELL_ROW_6_111 vssd1 vccd1 sky130_fd_sc_hd__tapvpwrvgnd_1
XFILLER_19_218 vssd1 vssd1 vccd1 vccd1 sky130_fd_sc_hd__fill_1
XTAP_TAPCELL_ROW_29_213 vssd1 vccd1 sky130_fd_sc_hd__tapvpwrvgnd_1
XFILLER_10_151 vssd1 vssd1 vccd1 vccd1 sky130_fd_sc_hd__fill_1
XFILLER_10_195 vssd1 vssd1 vccd1 vccd1 sky130_fd_sc_hd__fill_1
XPHY_EDGE_ROW_25_Left_64 vssd1 vssd1 vccd1 vccd1 sky130_fd_sc_hd__decap_3
X_0915_ SYNTH_INST.pwm_counter.active_sample\[7\] net140 _0208_ vssd1 vssd1 vccd1
+ vccd1 _0068_ sky130_fd_sc_hd__mux2_1
X_0846_ _0182_ _0386_ _0169_ _0177_ vssd1 vssd1 vccd1 vccd1 _0393_ sky130_fd_sc_hd__o211ai_2
X_0777_ SYNTH_INST.keypad.keypad_reg\[1\] SYNTH_INST.keypad.keypad_reg\[0\] SYNTH_INST.keypad.keypad_reg\[3\]
+ SYNTH_INST.keypad.keypad_reg\[2\] vssd1 vssd1 vccd1 vccd1 _0338_ sky130_fd_sc_hd__or4b_1
XFILLER_17_36 vssd1 vssd1 vccd1 vccd1 sky130_fd_sc_hd__fill_1
XFILLER_33_46 vssd1 vssd1 vccd1 vccd1 sky130_fd_sc_hd__fill_1
XFILLER_33_35 vssd1 vssd1 vccd1 vccd1 sky130_fd_sc_hd__fill_4
Xhold9 SYNTH_INST.pwm_counter.sample\[7\] vssd1 vssd1 vccd1 vccd1 net140 sky130_fd_sc_hd__dlygate4sd3_1
XFILLER_3_147 vccd1 vssd1 vccd1 vssd1 sky130_ef_sc_hd__decap_40_12
X_0700_ _0087_ _0285_ _0294_ _0296_ vssd1 vssd1 vccd1 vccd1 SYNTH_INST.state_machine.nextState\[0\]
+ sky130_fd_sc_hd__o31a_1
X_0562_ net138 _0194_ net39 vssd1 vssd1 vccd1 vccd1 _0002_ sky130_fd_sc_hd__a21o_1
X_0631_ _0250_ _0252_ vssd1 vssd1 vccd1 vccd1 _0253_ sky130_fd_sc_hd__and2b_1
X_0493_ net37 net34 vssd1 vssd1 vccd1 vccd1 _0126_ sky130_fd_sc_hd__and2b_1
XFILLER_24_3 vssd1 vssd1 vccd1 vccd1 sky130_fd_sc_hd__fill_2
XFILLER_0_83 vssd1 vssd1 vccd1 vccd1 sky130_fd_sc_hd__fill_1
X_0829_ _0378_ _0379_ SYNTH_INST.waveshape.seq_div.dividend\[29\] net41 vssd1 vssd1
+ vccd1 vccd1 _0380_ sky130_fd_sc_hd__a2bb2o_1
XFILLER_9_81 vssd1 vssd1 vccd1 vccd1 sky130_fd_sc_hd__fill_1
X_0476_ _0096_ _0102_ vssd1 vssd1 vccd1 vccd1 _0109_ sky130_fd_sc_hd__nand2_1
X_0545_ SYNTH_INST.waveshape.seq_div.dividend\[33\] _0176_ vssd1 vssd1 vccd1 vccd1
+ _0178_ sky130_fd_sc_hd__nand2_1
XPHY_EDGE_ROW_7_Right_7 vssd1 vssd1 vccd1 vccd1 sky130_fd_sc_hd__decap_3
X_0614_ _0122_ _0123_ SYNTH_INST.count\[2\] vssd1 vssd1 vccd1 vccd1 _0236_ sky130_fd_sc_hd__a21o_1
XFILLER_38_121 vssd1 vssd1 vccd1 vccd1 sky130_fd_sc_hd__fill_2
X_1028_ clknet_4_10_0_clk _0052_ net55 vssd1 vssd1 vccd1 vccd1 SYNTH_INST.waveshape.seq_div.dividend\[44\]
+ sky130_fd_sc_hd__dfrtp_1
XFILLER_14_26 vssd1 vssd1 vccd1 vccd1 sky130_fd_sc_hd__fill_2
XPHY_EDGE_ROW_12_Left_51 vssd1 vssd1 vccd1 vccd1 sky130_fd_sc_hd__decap_3
XFILLER_29_132 vssd1 vssd1 vccd1 vccd1 sky130_fd_sc_hd__fill_2
XFILLER_29_165 vssd1 vssd1 vccd1 vccd1 sky130_fd_sc_hd__fill_2
XFILLER_4_253 vssd1 vssd1 vccd1 vccd1 sky130_fd_sc_hd__fill_2
XFILLER_4_242 vssd1 vssd1 vccd1 vccd1 sky130_fd_sc_hd__fill_4
XFILLER_6_93 vssd1 vssd1 vccd1 vccd1 sky130_fd_sc_hd__fill_2
X_0528_ _0157_ _0160_ vssd1 vssd1 vccd1 vccd1 _0161_ sky130_fd_sc_hd__and2_1
X_0459_ SYNTH_INST.waveshape.seq_div.dividend\[38\] _0091_ vssd1 vssd1 vccd1 vccd1
+ _0092_ sky130_fd_sc_hd__nor2_1
XFILLER_2_29 vssd1 vssd1 vccd1 vccd1 sky130_fd_sc_hd__fill_2
XFILLER_2_18 vssd1 vssd1 vccd1 vccd1 sky130_fd_sc_hd__fill_8
XANTENNA_input11_A gpio_in[5] vssd1 vssd1 vccd1 vccd1 sky130_fd_sc_hd__diode_2
XTAP_TAPCELL_ROW_2_94 vssd1 vccd1 sky130_fd_sc_hd__tapvpwrvgnd_1
XTAP_TAPCELL_ROW_18_163 vssd1 vccd1 sky130_fd_sc_hd__tapvpwrvgnd_1
XFILLER_11_27 vssd1 vssd1 vccd1 vccd1 sky130_fd_sc_hd__fill_4
XFILLER_11_49 vssd1 vssd1 vccd1 vccd1 sky130_fd_sc_hd__fill_4
XANTENNA_input3_A gpio_in[10] vssd1 vssd1 vccd1 vccd1 sky130_fd_sc_hd__diode_2
XFILLER_14_149 vssd1 vssd1 vccd1 vccd1 sky130_fd_sc_hd__fill_2
XFILLER_9_131 vssd1 vssd1 vccd1 vccd1 sky130_fd_sc_hd__fill_1
X_0862_ SYNTH_INST.waveshape.seq_div.dividend\[37\] net28 _0396_ _0405_ vssd1 vssd1
+ vccd1 vccd1 _0045_ sky130_fd_sc_hd__a22o_1
X_0931_ clknet_4_11_0_clk net97 net55 vssd1 vssd1 vccd1 vccd1 SYNTH_INST.sample_rate.count\[7\]
+ sky130_fd_sc_hd__dfrtp_1
X_0793_ _0335_ _0352_ _0212_ vssd1 vssd1 vccd1 vccd1 _0353_ sky130_fd_sc_hd__o21a_1
XFILLER_3_83 vssd1 vssd1 vccd1 vccd1 sky130_fd_sc_hd__fill_4
XTAP_TAPCELL_ROW_38_258 vssd1 vccd1 sky130_fd_sc_hd__tapvpwrvgnd_1
XTAP_TAPCELL_ROW_6_112 vssd1 vccd1 sky130_fd_sc_hd__tapvpwrvgnd_1
XANTENNA__0765__A net43 vssd1 vssd1 vccd1 vccd1 sky130_fd_sc_hd__diode_2
XTAP_TAPCELL_ROW_29_214 vssd1 vccd1 sky130_fd_sc_hd__tapvpwrvgnd_1
XTAP_TAPCELL_ROW_12_136 vssd1 vccd1 sky130_fd_sc_hd__tapvpwrvgnd_1
XFILLER_6_145 vssd1 vssd1 vccd1 vccd1 sky130_fd_sc_hd__fill_2
XFILLER_6_189 vssd1 vssd1 vccd1 vccd1 sky130_fd_sc_hd__fill_4
XFILLER_19_6 vssd1 vssd1 vccd1 vccd1 sky130_fd_sc_hd__fill_8
XFILLER_33_233 vccd1 vssd1 vccd1 vssd1 sky130_ef_sc_hd__decap_40_12
X_0914_ SYNTH_INST.pwm_counter.active_sample\[6\] net134 _0208_ vssd1 vssd1 vccd1
+ vccd1 _0067_ sky130_fd_sc_hd__mux2_1
X_0845_ _0182_ _0386_ _0177_ vssd1 vssd1 vccd1 vccd1 _0392_ sky130_fd_sc_hd__o21a_1
X_0776_ _0211_ _0216_ _0334_ vssd1 vssd1 vccd1 vccd1 _0337_ sky130_fd_sc_hd__or3b_1
XFILLER_24_222 vssd1 vssd1 vccd1 vccd1 sky130_fd_sc_hd__fill_1
XFILLER_15_200 vssd1 vssd1 vccd1 vccd1 sky130_fd_sc_hd__fill_2
X_0492_ SYNTH_INST.waveshape.seq_div.dividend\[26\] _0122_ _0123_ vssd1 vssd1 vccd1
+ vccd1 _0125_ sky130_fd_sc_hd__and3_1
X_0561_ SYNTH_INST.waveshape.seq_div.dividend\[47\] _0193_ vssd1 vssd1 vccd1 vccd1
+ _0194_ sky130_fd_sc_hd__nor2_1
X_0630_ SYNTH_INST.count\[12\] _0099_ _0162_ SYNTH_INST.count\[11\] _0251_ vssd1 vssd1
+ vccd1 vccd1 _0252_ sky130_fd_sc_hd__o221a_1
X_1044_ clknet_4_13_0_clk net141 net58 vssd1 vssd1 vccd1 vccd1 SYNTH_INST.pwm_counter.active_sample\[7\]
+ sky130_fd_sc_hd__dfrtp_1
XFILLER_21_225 vssd1 vssd1 vccd1 vccd1 sky130_fd_sc_hd__fill_2
X_0828_ _0147_ _0377_ _0073_ vssd1 vssd1 vccd1 vccd1 _0379_ sky130_fd_sc_hd__a21o_1
X_0759_ net46 SYNTH_INST.waveshape.scaled_count\[1\] net23 vssd1 vssd1 vccd1 vccd1
+ _0327_ sky130_fd_sc_hd__and3_1
XFILLER_12_247 vssd1 vssd1 vccd1 vccd1 sky130_fd_sc_hd__fill_2
XFILLER_5_18 vssd1 vssd1 vccd1 vccd1 sky130_fd_sc_hd__fill_8
XFILLER_7_251 vssd1 vssd1 vccd1 vccd1 sky130_fd_sc_hd__fill_1
X_0613_ SYNTH_INST.count\[1\] _0128_ vssd1 vssd1 vccd1 vccd1 _0235_ sky130_fd_sc_hd__or2_1
XFILLER_38_111 vssd1 vssd1 vccd1 vccd1 sky130_fd_sc_hd__fill_1
X_0544_ SYNTH_INST.waveshape.seq_div.dividend\[33\] _0176_ vssd1 vssd1 vccd1 vccd1
+ _0177_ sky130_fd_sc_hd__or2_1
X_0475_ _0092_ _0104_ vssd1 vssd1 vccd1 vccd1 _0108_ sky130_fd_sc_hd__nand2b_1
X_1027_ clknet_4_10_0_clk _0051_ net55 vssd1 vssd1 vccd1 vccd1 SYNTH_INST.waveshape.seq_div.dividend\[43\]
+ sky130_fd_sc_hd__dfrtp_1
XFILLER_29_111 vssd1 vssd1 vccd1 vccd1 sky130_fd_sc_hd__fill_1
XANTENNA_fanout27_X net27 vssd1 vssd1 vccd1 vccd1 sky130_fd_sc_hd__diode_2
XFILLER_35_169 vssd1 vssd1 vccd1 vccd1 sky130_fd_sc_hd__fill_8
XFILLER_6_83 vssd1 vssd1 vccd1 vccd1 sky130_fd_sc_hd__fill_1
X_0527_ _0148_ _0151_ _0158_ _0159_ _0142_ vssd1 vssd1 vccd1 vccd1 _0160_ sky130_fd_sc_hd__o311a_1
X_0458_ _0088_ _0090_ vssd1 vssd1 vccd1 vccd1 _0091_ sky130_fd_sc_hd__and2_1
XFILLER_17_169 vssd1 vssd1 vccd1 vccd1 sky130_fd_sc_hd__fill_4
XFILLER_32_139 vssd1 vssd1 vccd1 vccd1 sky130_fd_sc_hd__fill_1
XFILLER_15_81 vssd1 vssd1 vccd1 vccd1 sky130_fd_sc_hd__fill_2
XTAP_TAPCELL_ROW_2_95 vssd1 vccd1 sky130_fd_sc_hd__tapvpwrvgnd_1
XTAP_TAPCELL_ROW_18_164 vssd1 vccd1 sky130_fd_sc_hd__tapvpwrvgnd_1
XFILLER_23_117 vssd1 vssd1 vccd1 vccd1 sky130_fd_sc_hd__fill_4
XFILLER_14_139 vssd1 vssd1 vccd1 vccd1 sky130_fd_sc_hd__fill_1
X_0792_ SYNTH_INST.keypad.keypad_reg\[8\] _0214_ _0334_ SYNTH_INST.keypad.keypad_reg\[9\]
+ vssd1 vssd1 vccd1 vccd1 _0352_ sky130_fd_sc_hd__and4bb_1
X_0861_ _0403_ _0404_ SYNTH_INST.waveshape.seq_div.dividend\[36\] net45 vssd1 vssd1
+ vccd1 vccd1 _0405_ sky130_fd_sc_hd__a2bb2o_1
X_0930_ clknet_4_10_0_clk net98 net55 vssd1 vssd1 vccd1 vccd1 SYNTH_INST.sample_rate.count\[6\]
+ sky130_fd_sc_hd__dfrtp_1
XTAP_TAPCELL_ROW_38_259 vssd1 vccd1 sky130_fd_sc_hd__tapvpwrvgnd_1
XFILLER_36_253 vssd1 vssd1 vccd1 vccd1 sky130_fd_sc_hd__fill_2
XFILLER_36_242 vssd1 vssd1 vccd1 vccd1 sky130_fd_sc_hd__fill_2
XFILLER_0_9 vssd1 vssd1 vccd1 vccd1 sky130_fd_sc_hd__fill_1
XTAP_TAPCELL_ROW_6_113 vssd1 vccd1 sky130_fd_sc_hd__tapvpwrvgnd_1
XTAP_TAPCELL_ROW_29_215 vssd1 vccd1 sky130_fd_sc_hd__tapvpwrvgnd_1
XPHY_EDGE_ROW_29_Right_29 vssd1 vssd1 vccd1 vccd1 sky130_fd_sc_hd__decap_3
XPHY_EDGE_ROW_38_Right_38 vssd1 vssd1 vccd1 vccd1 sky130_fd_sc_hd__decap_3
XFILLER_8_18 vssd1 vssd1 vccd1 vccd1 sky130_fd_sc_hd__fill_2
XTAP_TAPCELL_ROW_12_137 vssd1 vccd1 sky130_fd_sc_hd__tapvpwrvgnd_1
XFILLER_10_197 vssd1 vssd1 vccd1 vccd1 sky130_fd_sc_hd__fill_4
XFILLER_12_82 vssd1 vssd1 vccd1 vccd1 sky130_fd_sc_hd__fill_2
XFILLER_33_245 vssd1 vssd1 vccd1 vccd1 sky130_fd_sc_hd__fill_4
XFILLER_33_223 vssd1 vssd1 vccd1 vccd1 sky130_fd_sc_hd__fill_1
XFILLER_18_253 vssd1 vssd1 vccd1 vccd1 sky130_fd_sc_hd__fill_2
X_0913_ SYNTH_INST.pwm_counter.active_sample\[5\] net144 _0208_ vssd1 vssd1 vccd1
+ vccd1 _0066_ sky130_fd_sc_hd__mux2_1
X_0775_ _0333_ _0335_ _0212_ vssd1 vssd1 vccd1 vccd1 _0336_ sky130_fd_sc_hd__o21a_1
X_0844_ net185 net26 _0391_ vssd1 vssd1 vccd1 vccd1 _0041_ sky130_fd_sc_hd__o21a_1
XFILLER_24_201 vssd1 vssd1 vccd1 vccd1 sky130_fd_sc_hd__fill_1
XFILLER_30_248 vssd1 vssd1 vccd1 vccd1 sky130_fd_sc_hd__fill_4
XFILLER_31_6 vssd1 vssd1 vccd1 vccd1 sky130_fd_sc_hd__fill_4
XFILLER_2_193 vssd1 vssd1 vccd1 vccd1 sky130_fd_sc_hd__fill_2
X_0560_ _0186_ _0187_ _0189_ _0191_ SYNTH_INST.waveshape.seq_div.dividend\[46\] vssd1
+ vssd1 vccd1 vccd1 _0193_ sky130_fd_sc_hd__a2111o_1
X_0491_ _0122_ _0123_ vssd1 vssd1 vccd1 vccd1 _0124_ sky130_fd_sc_hd__and2_1
X_1043_ clknet_4_15_0_clk net135 net60 vssd1 vssd1 vccd1 vccd1 SYNTH_INST.pwm_counter.active_sample\[6\]
+ sky130_fd_sc_hd__dfrtp_1
XFILLER_0_41 vccd1 vssd1 vccd1 vssd1 sky130_ef_sc_hd__decap_40_12
XFILLER_0_85 vccd1 vssd1 vccd1 vssd1 sky130_ef_sc_hd__decap_40_12
X_0827_ _0158_ _0370_ _0147_ _0151_ vssd1 vssd1 vccd1 vccd1 _0378_ sky130_fd_sc_hd__a211oi_1
X_0758_ net196 net20 _0326_ vssd1 vssd1 vccd1 vccd1 _0020_ sky130_fd_sc_hd__a21o_1
X_0689_ SYNTH_INST.waveshape.scaled_count\[4\] _0285_ _0286_ _0290_ _0284_ vssd1 vssd1
+ vccd1 vccd1 SYNTH_INST.waveshape.shaper.n_sample\[4\] sky130_fd_sc_hd__a221o_1
XFILLER_28_37 vssd1 vssd1 vccd1 vccd1 sky130_fd_sc_hd__fill_4
XFILLER_34_80 vssd1 vssd1 vccd1 vccd1 sky130_fd_sc_hd__fill_4
X_0612_ SYNTH_INST.count\[1\] _0128_ _0130_ _0132_ SYNTH_INST.count\[0\] vssd1 vssd1
+ vccd1 vccd1 _0234_ sky130_fd_sc_hd__a221o_1
X_0474_ _0100_ _0106_ vssd1 vssd1 vccd1 vccd1 _0107_ sky130_fd_sc_hd__nand2_1
X_0543_ net32 _0094_ _0149_ _0175_ vssd1 vssd1 vccd1 vccd1 _0176_ sky130_fd_sc_hd__o31a_1
X_1026_ clknet_4_8_0_clk _0050_ net54 vssd1 vssd1 vccd1 vccd1 SYNTH_INST.waveshape.seq_div.dividend\[42\]
+ sky130_fd_sc_hd__dfrtp_1
XANTENNA__1015__RESET_B net48 vssd1 vssd1 vccd1 vccd1 sky130_fd_sc_hd__diode_2
XFILLER_29_167 vssd1 vssd1 vccd1 vccd1 sky130_fd_sc_hd__fill_1
XFILLER_35_159 vssd1 vssd1 vccd1 vccd1 sky130_fd_sc_hd__fill_8
XFILLER_6_95 vssd1 vssd1 vccd1 vccd1 sky130_fd_sc_hd__fill_1
X_0526_ SYNTH_INST.waveshape.seq_div.dividend\[31\] _0141_ _0145_ vssd1 vssd1 vccd1
+ vccd1 _0159_ sky130_fd_sc_hd__o21ai_1
X_0457_ net37 net34 net32 vssd1 vssd1 vccd1 vccd1 _0090_ sky130_fd_sc_hd__o21bai_2
X_1009_ clknet_4_2_0_clk _0033_ net48 vssd1 vssd1 vccd1 vccd1 SYNTH_INST.waveshape.seq_div.dividend\[25\]
+ sky130_fd_sc_hd__dfrtp_1
XFILLER_1_225 vccd1 vssd1 vccd1 vssd1 sky130_ef_sc_hd__decap_40_12
Xteam_05_90 vssd1 vssd1 vccd1 vccd1 team_05_90/HI gpio_out[28] sky130_fd_sc_hd__conb_1
XFILLER_17_104 vssd1 vssd1 vccd1 vccd1 sky130_fd_sc_hd__fill_1
XFILLER_17_159 vssd1 vssd1 vccd1 vccd1 sky130_fd_sc_hd__fill_8
XFILLER_25_181 vssd1 vssd1 vccd1 vccd1 sky130_fd_sc_hd__fill_2
XFILLER_16_192 vssd1 vssd1 vccd1 vccd1 sky130_fd_sc_hd__fill_4
XTAP_TAPCELL_ROW_18_165 vssd1 vccd1 sky130_fd_sc_hd__tapvpwrvgnd_1
X_0509_ SYNTH_INST.waveshape.seq_div.dividend\[31\] _0141_ vssd1 vssd1 vccd1 vccd1
+ _0142_ sky130_fd_sc_hd__nand2_1
XFILLER_22_195 vssd1 vssd1 vccd1 vccd1 sky130_fd_sc_hd__fill_1
XFILLER_9_100 vssd1 vssd1 vccd1 vccd1 sky130_fd_sc_hd__fill_2
XFILLER_13_151 vssd1 vssd1 vccd1 vccd1 sky130_fd_sc_hd__fill_2
XFILLER_26_81 vssd1 vssd1 vccd1 vccd1 sky130_fd_sc_hd__fill_2
XFILLER_9_111 vssd1 vssd1 vccd1 vccd1 sky130_fd_sc_hd__fill_1
X_0860_ _0100_ _0109_ _0400_ _0073_ vssd1 vssd1 vccd1 vccd1 _0404_ sky130_fd_sc_hd__a31o_1
X_0791_ _0342_ _0350_ vssd1 vssd1 vccd1 vccd1 _0351_ sky130_fd_sc_hd__nand2_1
X_0989_ clknet_4_12_0_clk _0027_ net57 vssd1 vssd1 vccd1 vccd1 SYNTH_INST.waveshape.scaled_count\[0\]
+ sky130_fd_sc_hd__dfrtp_1
XTAP_TAPCELL_ROW_29_216 vssd1 vccd1 sky130_fd_sc_hd__tapvpwrvgnd_1
XANTENNA_fanout47_A net48 vssd1 vssd1 vccd1 vccd1 sky130_fd_sc_hd__diode_2
XFILLER_6_147 vssd1 vssd1 vccd1 vccd1 sky130_fd_sc_hd__fill_1
XTAP_TAPCELL_ROW_12_138 vssd1 vccd1 sky130_fd_sc_hd__tapvpwrvgnd_1
X_0912_ SYNTH_INST.pwm_counter.active_sample\[4\] net146 _0208_ vssd1 vssd1 vccd1
+ vccd1 _0065_ sky130_fd_sc_hd__mux2_1
X_0774_ _0213_ SYNTH_INST.keypad.keypad_reg\[11\] SYNTH_INST.keypad.keypad_reg\[10\]
+ _0334_ vssd1 vssd1 vccd1 vccd1 _0335_ sky130_fd_sc_hd__and4bb_1
XFILLER_5_191 vccd1 vssd1 vccd1 vssd1 sky130_ef_sc_hd__decap_40_12
X_0843_ SYNTH_INST.waveshape.seq_div.dividend\[32\] net43 _0389_ _0390_ net29 vssd1
+ vssd1 vccd1 vccd1 _0391_ sky130_fd_sc_hd__a221o_1
XFILLER_3_106 vssd1 vssd1 vccd1 vccd1 sky130_fd_sc_hd__fill_1
XPHY_EDGE_ROW_29_Left_68 vssd1 vssd1 vccd1 vccd1 sky130_fd_sc_hd__decap_3
X_0490_ net32 _0117_ net35 vssd1 vssd1 vccd1 vccd1 _0123_ sky130_fd_sc_hd__or3b_1
X_1042_ clknet_4_13_0_clk net145 net60 vssd1 vssd1 vccd1 vccd1 SYNTH_INST.pwm_counter.active_sample\[5\]
+ sky130_fd_sc_hd__dfrtp_1
XFILLER_0_20 vssd1 vssd1 vccd1 vccd1 sky130_fd_sc_hd__fill_4
XFILLER_0_53 vssd1 vssd1 vccd1 vccd1 sky130_fd_sc_hd__fill_2
XFILLER_0_97 vssd1 vssd1 vccd1 vccd1 sky130_fd_sc_hd__fill_2
XTAP_TAPCELL_ROW_31_222 vssd1 vccd1 sky130_fd_sc_hd__tapvpwrvgnd_1
X_0688_ SYNTH_INST.waveshape.scaled_count\[7\] SYNTH_INST.waveshape.scaled_count\[3\]
+ vssd1 vssd1 vccd1 vccd1 _0290_ sky130_fd_sc_hd__xor2_1
X_0826_ _0158_ _0370_ _0151_ vssd1 vssd1 vccd1 vccd1 _0377_ sky130_fd_sc_hd__a21o_1
XFILLER_0_109 vssd1 vssd1 vccd1 vccd1 sky130_fd_sc_hd__fill_2
X_0757_ net46 SYNTH_INST.waveshape.scaled_count\[0\] net23 vssd1 vssd1 vccd1 vccd1
+ _0326_ sky130_fd_sc_hd__and3_1
XANTENNA_clkbuf_4_6_0_clk_A clknet_0_clk vssd1 vssd1 vccd1 vccd1 sky130_fd_sc_hd__diode_2
XFILLER_28_49 vssd1 vssd1 vccd1 vccd1 sky130_fd_sc_hd__fill_1
Xclkbuf_4_15_0_clk clknet_0_clk vssd1 vssd1 vccd1 vccd1 clknet_4_15_0_clk sky130_fd_sc_hd__clkbuf_8
XANTENNA__0816__S net27 vssd1 vssd1 vccd1 vccd1 sky130_fd_sc_hd__diode_2
X_0611_ SYNTH_INST.count\[2\] _0122_ _0123_ _0114_ SYNTH_INST.count\[3\] vssd1 vssd1
+ vccd1 vccd1 _0233_ sky130_fd_sc_hd__a32o_1
X_0542_ _0069_ _0097_ _0111_ _0126_ vssd1 vssd1 vccd1 vccd1 _0175_ sky130_fd_sc_hd__a211o_1
XFILLER_38_157 vssd1 vssd1 vccd1 vccd1 sky130_fd_sc_hd__fill_2
XFILLER_38_113 vssd1 vssd1 vccd1 vccd1 sky130_fd_sc_hd__fill_8
X_0473_ SYNTH_INST.waveshape.seq_div.dividend\[36\] _0099_ vssd1 vssd1 vccd1 vccd1
+ _0106_ sky130_fd_sc_hd__or2_1
X_1025_ clknet_4_8_0_clk _0049_ net54 vssd1 vssd1 vccd1 vccd1 SYNTH_INST.waveshape.seq_div.dividend\[41\]
+ sky130_fd_sc_hd__dfrtp_2
XFILLER_14_18 vssd1 vssd1 vccd1 vccd1 sky130_fd_sc_hd__fill_2
XFILLER_14_29 vssd1 vssd1 vccd1 vccd1 sky130_fd_sc_hd__fill_2
X_0809_ _0135_ _0136_ vssd1 vssd1 vccd1 vccd1 _0364_ sky130_fd_sc_hd__or2_1
XFILLER_29_157 vssd1 vssd1 vccd1 vccd1 sky130_fd_sc_hd__fill_8
XFILLER_20_83 vssd1 vssd1 vccd1 vccd1 sky130_fd_sc_hd__fill_1
Xhold70 SYNTH_INST.waveshape.seq_div.dividend\[26\] vssd1 vssd1 vccd1 vccd1 net201
+ sky130_fd_sc_hd__dlygate4sd3_1
XFILLER_6_85 vssd1 vssd1 vccd1 vccd1 sky130_fd_sc_hd__fill_8
X_0525_ SYNTH_INST.waveshape.seq_div.dividend\[28\] _0153_ _0152_ vssd1 vssd1 vccd1
+ vccd1 _0158_ sky130_fd_sc_hd__a21oi_1
X_0456_ net37 net34 vssd1 vssd1 vccd1 vccd1 _0089_ sky130_fd_sc_hd__nor2_1
XPHY_EDGE_ROW_16_Left_55 vssd1 vssd1 vccd1 vccd1 sky130_fd_sc_hd__decap_3
XFILLER_26_127 vssd1 vssd1 vccd1 vccd1 sky130_fd_sc_hd__fill_1
X_1008_ clknet_4_2_0_clk _0032_ net48 vssd1 vssd1 vccd1 vccd1 SYNTH_INST.waveshape.seq_div.dividend\[24\]
+ sky130_fd_sc_hd__dfrtp_1
XFILLER_1_204 vccd1 vssd1 vccd1 vssd1 sky130_ef_sc_hd__decap_40_12
XFILLER_1_237 vccd1 vssd1 vccd1 vssd1 sky130_ef_sc_hd__decap_40_12
Xteam_05_80 vssd1 vssd1 vccd1 vccd1 team_05_80/HI gpio_out[18] sky130_fd_sc_hd__conb_1
Xteam_05_91 vssd1 vssd1 vccd1 vccd1 team_05_91/HI gpio_out[29] sky130_fd_sc_hd__conb_1
XFILLER_15_83 vssd1 vssd1 vccd1 vccd1 sky130_fd_sc_hd__fill_1
XANTENNA_clkbuf_4_14_0_clk_A clknet_0_clk vssd1 vssd1 vccd1 vccd1 sky130_fd_sc_hd__diode_2
XTAP_TAPCELL_ROW_18_166 vssd1 vccd1 sky130_fd_sc_hd__tapvpwrvgnd_1
X_0439_ SYNTH_INST.waveshape.seq_div.dividend\[39\] vssd1 vssd1 vccd1 vccd1 _0072_
+ sky130_fd_sc_hd__inv_2
X_0508_ net32 _0093_ _0127_ _0070_ vssd1 vssd1 vccd1 vccd1 _0141_ sky130_fd_sc_hd__o22a_2
XFILLER_36_27 vssd1 vssd1 vccd1 vccd1 sky130_fd_sc_hd__fill_1
XFILLER_22_130 vssd1 vssd1 vccd1 vccd1 sky130_fd_sc_hd__fill_8
XFILLER_22_163 vssd1 vssd1 vccd1 vccd1 sky130_fd_sc_hd__fill_2
XTAP_TAPCELL_ROW_9_123 vssd1 vccd1 sky130_fd_sc_hd__tapvpwrvgnd_1
XFILLER_9_156 vssd1 vssd1 vccd1 vccd1 sky130_fd_sc_hd__fill_1
XFILLER_9_167 vssd1 vssd1 vccd1 vccd1 sky130_fd_sc_hd__fill_1
X_0790_ SYNTH_INST.keypad.keypad_reg\[4\] SYNTH_INST.keypad.keypad_reg\[7\] _0348_
+ SYNTH_INST.keypad.keypad_reg\[5\] vssd1 vssd1 vccd1 vccd1 _0350_ sky130_fd_sc_hd__or4bb_1
XFILLER_3_31 vssd1 vssd1 vccd1 vccd1 sky130_fd_sc_hd__fill_4
X_0988_ clknet_4_6_0_clk _0026_ net51 vssd1 vssd1 vccd1 vccd1 SYNTH_INST.waveshape.scaled_count\[7\]
+ sky130_fd_sc_hd__dfrtp_4
XANTENNA_input1_A en vssd1 vssd1 vccd1 vccd1 sky130_fd_sc_hd__diode_2
XTAP_TAPCELL_ROW_37_250 vssd1 vccd1 sky130_fd_sc_hd__tapvpwrvgnd_1
XFILLER_6_159 vssd1 vssd1 vccd1 vccd1 sky130_fd_sc_hd__fill_2
XFILLER_6_137 vssd1 vssd1 vccd1 vccd1 sky130_fd_sc_hd__fill_2
XTAP_TAPCELL_ROW_12_139 vssd1 vccd1 sky130_fd_sc_hd__tapvpwrvgnd_1
XTAP_TAPCELL_ROW_20_172 vssd1 vccd1 sky130_fd_sc_hd__tapvpwrvgnd_1
XFILLER_33_225 vssd1 vssd1 vccd1 vccd1 sky130_fd_sc_hd__fill_4
X_0842_ _0172_ _0179_ _0386_ net40 vssd1 vssd1 vccd1 vccd1 _0390_ sky130_fd_sc_hd__o31a_1
X_0911_ SYNTH_INST.pwm_counter.active_sample\[3\] net148 _0208_ vssd1 vssd1 vccd1
+ vccd1 _0064_ sky130_fd_sc_hd__mux2_1
X_0773_ SYNTH_INST.keypad.keypad_reg\[12\] SYNTH_INST.keypad.keypad_reg\[13\] vssd1
+ vssd1 vccd1 vccd1 _0334_ sky130_fd_sc_hd__nor2_1
XFILLER_33_39 vssd1 vssd1 vccd1 vccd1 sky130_fd_sc_hd__fill_2
XANTENNA_clkbuf_4_2_0_clk_A clknet_0_clk vssd1 vssd1 vccd1 vccd1 sky130_fd_sc_hd__diode_2
XFILLER_24_225 vssd1 vssd1 vccd1 vccd1 sky130_fd_sc_hd__fill_4
XANTENNA__1009__RESET_B net48 vssd1 vssd1 vccd1 vccd1 sky130_fd_sc_hd__diode_2
XPHY_EDGE_ROW_4_Left_43 vssd1 vssd1 vccd1 vccd1 sky130_fd_sc_hd__decap_3
XFILLER_30_206 vssd1 vssd1 vccd1 vccd1 sky130_fd_sc_hd__fill_4
XFILLER_2_195 vssd1 vssd1 vccd1 vccd1 sky130_fd_sc_hd__fill_1
X_1041_ clknet_4_13_0_clk net147 net60 vssd1 vssd1 vccd1 vccd1 SYNTH_INST.pwm_counter.active_sample\[4\]
+ sky130_fd_sc_hd__dfrtp_1
XFILLER_21_217 vssd1 vssd1 vccd1 vccd1 sky130_fd_sc_hd__fill_4
XTAP_TAPCELL_ROW_31_223 vssd1 vccd1 sky130_fd_sc_hd__tapvpwrvgnd_1
X_0825_ net197 net27 _0375_ _0376_ vssd1 vssd1 vccd1 vccd1 _0037_ sky130_fd_sc_hd__o22a_1
X_0756_ net161 net24 _0325_ vssd1 vssd1 vccd1 vccd1 _0019_ sky130_fd_sc_hd__o21a_1
X_0687_ SYNTH_INST.waveshape.scaled_count\[3\] _0285_ _0286_ _0289_ _0284_ vssd1 vssd1
+ vccd1 vccd1 SYNTH_INST.waveshape.shaper.n_sample\[3\] sky130_fd_sc_hd__a221o_1
XFILLER_12_239 vssd1 vssd1 vccd1 vccd1 sky130_fd_sc_hd__fill_8
XPHY_EDGE_ROW_30_Left_69 vssd1 vssd1 vccd1 vccd1 sky130_fd_sc_hd__decap_3
XFILLER_18_83 vssd1 vssd1 vccd1 vccd1 sky130_fd_sc_hd__fill_1
X_0541_ _0172_ _0173_ vssd1 vssd1 vccd1 vccd1 _0174_ sky130_fd_sc_hd__or2_1
X_0472_ _0092_ _0103_ _0104_ _0072_ vssd1 vssd1 vccd1 vccd1 _0105_ sky130_fd_sc_hd__o211ai_1
X_0610_ _0227_ _0232_ vssd1 vssd1 vccd1 vccd1 SYNTH_INST.sample_rate.n_count\[5\]
+ sky130_fd_sc_hd__and2_1
XFILLER_38_169 vssd1 vssd1 vccd1 vccd1 sky130_fd_sc_hd__fill_4
X_1024_ clknet_4_8_0_clk _0048_ net54 vssd1 vssd1 vccd1 vccd1 SYNTH_INST.waveshape.seq_div.dividend\[40\]
+ sky130_fd_sc_hd__dfrtp_2
X_0808_ SYNTH_INST.waveshape.seq_div.dividend\[25\] _0363_ net26 vssd1 vssd1 vccd1
+ vccd1 _0033_ sky130_fd_sc_hd__mux2_1
X_0739_ net42 SYNTH_INST.waveshape.seq_div.dividend\[14\] net30 SYNTH_INST.count\[7\]
+ net22 vssd1 vssd1 vccd1 vccd1 _0317_ sky130_fd_sc_hd__a221o_1
XFILLER_4_246 vssd1 vssd1 vccd1 vccd1 sky130_fd_sc_hd__fill_2
Xhold71 SYNTH_INST.waveshape.seq_div.dividend\[45\] vssd1 vssd1 vccd1 vccd1 net202
+ sky130_fd_sc_hd__dlygate4sd3_1
XANTENNA_clkbuf_4_10_0_clk_A clknet_0_clk vssd1 vssd1 vccd1 vccd1 sky130_fd_sc_hd__diode_2
Xhold60 _0230_ vssd1 vssd1 vccd1 vccd1 net191 sky130_fd_sc_hd__dlygate4sd3_1
Xclkbuf_4_14_0_clk clknet_0_clk vssd1 vssd1 vccd1 vccd1 clknet_4_14_0_clk sky130_fd_sc_hd__clkbuf_8
X_0524_ _0115_ _0156_ _0139_ vssd1 vssd1 vccd1 vccd1 _0157_ sky130_fd_sc_hd__or3b_1
X_0455_ net32 net35 vssd1 vssd1 vccd1 vccd1 _0088_ sky130_fd_sc_hd__nand2b_1
X_1007_ clknet_4_15_0_clk SYNTH_INST.pwm_counter.n_count\[7\] net60 vssd1 vssd1 vccd1
+ vccd1 SYNTH_INST.pwm_counter.count\[7\] sky130_fd_sc_hd__dfrtp_1
XFILLER_34_150 vssd1 vssd1 vccd1 vccd1 sky130_fd_sc_hd__fill_2
XFILLER_34_161 vssd1 vssd1 vccd1 vccd1 sky130_fd_sc_hd__fill_4
XFILLER_1_216 vssd1 vssd1 vccd1 vccd1 sky130_fd_sc_hd__fill_8
Xteam_05_70 vssd1 vssd1 vccd1 vccd1 team_05_70/HI gpio_out[7] sky130_fd_sc_hd__conb_1
Xteam_05_92 vssd1 vssd1 vccd1 vccd1 team_05_92/HI gpio_out[30] sky130_fd_sc_hd__conb_1
Xteam_05_81 vssd1 vssd1 vccd1 vccd1 team_05_81/HI gpio_out[19] sky130_fd_sc_hd__conb_1
XPHY_EDGE_ROW_33_Left_72 vssd1 vssd1 vccd1 vccd1 sky130_fd_sc_hd__decap_3
XTAP_TAPCELL_ROW_18_167 vssd1 vccd1 sky130_fd_sc_hd__tapvpwrvgnd_1
XFILLER_23_109 vssd1 vssd1 vccd1 vccd1 sky130_fd_sc_hd__fill_2
X_0507_ _0115_ _0138_ vssd1 vssd1 vccd1 vccd1 _0140_ sky130_fd_sc_hd__and2b_1
X_0438_ net34 vssd1 vssd1 vccd1 vccd1 _0071_ sky130_fd_sc_hd__inv_2
XANTENNA__0840__S net27 vssd1 vssd1 vccd1 vccd1 sky130_fd_sc_hd__diode_2
XTAP_TAPCELL_ROW_9_124 vssd1 vccd1 sky130_fd_sc_hd__tapvpwrvgnd_1
XFILLER_9_113 vccd1 vssd1 vccd1 vssd1 sky130_ef_sc_hd__decap_40_12
XFILLER_26_83 vssd1 vssd1 vccd1 vccd1 sky130_fd_sc_hd__fill_1
XFILLER_3_87 vssd1 vssd1 vccd1 vccd1 sky130_fd_sc_hd__fill_1
XFILLER_36_212 vssd1 vssd1 vccd1 vccd1 sky130_fd_sc_hd__fill_2
X_0987_ clknet_4_6_0_clk _0025_ net51 vssd1 vssd1 vccd1 vccd1 SYNTH_INST.waveshape.scaled_count\[6\]
+ sky130_fd_sc_hd__dfrtp_1
XFILLER_27_223 vssd1 vssd1 vccd1 vccd1 sky130_fd_sc_hd__fill_1
XFILLER_27_245 vssd1 vssd1 vccd1 vccd1 sky130_fd_sc_hd__fill_4
XTAP_TAPCELL_ROW_37_251 vssd1 vccd1 sky130_fd_sc_hd__tapvpwrvgnd_1
XFILLER_10_101 vssd1 vssd1 vccd1 vccd1 sky130_fd_sc_hd__fill_1
XTAP_TAPCELL_ROW_20_173 vssd1 vccd1 sky130_fd_sc_hd__tapvpwrvgnd_1
XFILLER_33_215 vssd1 vssd1 vccd1 vccd1 sky130_fd_sc_hd__fill_8
XPHY_EDGE_ROW_16_Right_16 vssd1 vssd1 vccd1 vccd1 sky130_fd_sc_hd__decap_3
X_0772_ SYNTH_INST.keypad.keypad_reg\[12\] _0075_ _0217_ vssd1 vssd1 vccd1 vccd1 _0333_
+ sky130_fd_sc_hd__and3_1
X_0841_ _0172_ _0386_ _0179_ vssd1 vssd1 vccd1 vccd1 _0389_ sky130_fd_sc_hd__o21ai_1
XPHY_EDGE_ROW_25_Right_25 vssd1 vssd1 vccd1 vccd1 sky130_fd_sc_hd__decap_3
X_0910_ SYNTH_INST.pwm_counter.active_sample\[2\] net132 _0208_ vssd1 vssd1 vccd1
+ vccd1 _0063_ sky130_fd_sc_hd__mux2_1
XPHY_EDGE_ROW_34_Right_34 vssd1 vssd1 vccd1 vccd1 sky130_fd_sc_hd__decap_3
XFILLER_23_73 vccd1 vssd1 vccd1 vssd1 sky130_ef_sc_hd__decap_40_12
X_1040_ clknet_4_15_0_clk net149 net60 vssd1 vssd1 vccd1 vccd1 SYNTH_INST.pwm_counter.active_sample\[3\]
+ sky130_fd_sc_hd__dfrtp_1
XTAP_TAPCELL_ROW_31_224 vssd1 vccd1 sky130_fd_sc_hd__tapvpwrvgnd_1
XFILLER_0_55 vssd1 vssd1 vccd1 vccd1 sky130_fd_sc_hd__fill_1
XFILLER_0_77 vssd1 vssd1 vccd1 vccd1 sky130_fd_sc_hd__fill_2
X_0824_ net40 _0373_ _0374_ net29 vssd1 vssd1 vccd1 vccd1 _0376_ sky130_fd_sc_hd__a31o_1
X_0755_ net45 SYNTH_INST.waveshape.seq_div.dividend\[22\] net31 SYNTH_INST.count\[15\]
+ net21 vssd1 vssd1 vccd1 vccd1 _0325_ sky130_fd_sc_hd__a221o_1
XFILLER_28_29 vssd1 vssd1 vccd1 vccd1 sky130_fd_sc_hd__fill_2
X_0686_ SYNTH_INST.waveshape.scaled_count\[7\] SYNTH_INST.waveshape.scaled_count\[2\]
+ vssd1 vssd1 vccd1 vccd1 _0289_ sky130_fd_sc_hd__xor2_1
XFILLER_18_51 vssd1 vssd1 vccd1 vccd1 sky130_fd_sc_hd__fill_1
XFILLER_11_251 vssd1 vssd1 vccd1 vccd1 sky130_fd_sc_hd__fill_1
X_0540_ SYNTH_INST.waveshape.seq_div.dividend\[32\] _0171_ vssd1 vssd1 vccd1 vccd1
+ _0173_ sky130_fd_sc_hd__nor2_1
X_0471_ SYNTH_INST.waveshape.seq_div.dividend\[38\] _0091_ vssd1 vssd1 vccd1 vccd1
+ _0104_ sky130_fd_sc_hd__nand2_1
XFILLER_38_159 vssd1 vssd1 vccd1 vccd1 sky130_fd_sc_hd__fill_1
X_1023_ clknet_4_8_0_clk _0047_ net56 vssd1 vssd1 vccd1 vccd1 SYNTH_INST.waveshape.seq_div.dividend\[39\]
+ sky130_fd_sc_hd__dfrtp_1
X_0931__97 vssd1 vssd1 vccd1 vccd1 _0931__97/HI net97 sky130_fd_sc_hd__conb_1
X_0807_ net41 SYNTH_INST.waveshape.seq_div.dividend\[24\] _0362_ net40 vssd1 vssd1
+ vccd1 vccd1 _0363_ sky130_fd_sc_hd__a22o_1
X_0738_ net155 net25 _0316_ vssd1 vssd1 vccd1 vccd1 _0010_ sky130_fd_sc_hd__o21a_1
XPHY_EDGE_ROW_2_Right_2 vssd1 vssd1 vccd1 vccd1 sky130_fd_sc_hd__decap_3
X_0669_ SYNTH_INST.count\[13\] _0275_ vssd1 vssd1 vccd1 vccd1 _0278_ sky130_fd_sc_hd__or2_1
XFILLER_29_115 vssd1 vssd1 vccd1 vccd1 sky130_fd_sc_hd__fill_1
Xhold50 _0304_ vssd1 vssd1 vccd1 vccd1 net181 sky130_fd_sc_hd__dlygate4sd3_1
Xhold61 SYNTH_INST.waveshape.scaled_count\[0\] vssd1 vssd1 vccd1 vccd1 net192 sky130_fd_sc_hd__dlygate4sd3_1
XFILLER_29_72 vssd1 vssd1 vccd1 vccd1 sky130_fd_sc_hd__fill_2
XFILLER_6_21 vssd1 vssd1 vccd1 vccd1 sky130_fd_sc_hd__fill_4
X_0454_ SYNTH_INST.keypad.modekey vssd1 vssd1 vccd1 vccd1 _0087_ sky130_fd_sc_hd__inv_2
X_0523_ _0148_ _0151_ _0152_ _0155_ vssd1 vssd1 vccd1 vccd1 _0156_ sky130_fd_sc_hd__or4b_1
X_1006_ clknet_4_15_0_clk SYNTH_INST.pwm_counter.n_count\[6\] net60 vssd1 vssd1 vccd1
+ vccd1 SYNTH_INST.pwm_counter.count\[6\] sky130_fd_sc_hd__dfrtp_1
XFILLER_19_181 vssd1 vssd1 vccd1 vccd1 sky130_fd_sc_hd__fill_8
Xteam_05_93 vssd1 vssd1 vccd1 vccd1 team_05_93/HI gpio_out[31] sky130_fd_sc_hd__conb_1
Xteam_05_71 vssd1 vssd1 vccd1 vccd1 team_05_71/HI gpio_out[8] sky130_fd_sc_hd__conb_1
Xteam_05_82 vssd1 vssd1 vccd1 vccd1 team_05_82/HI gpio_out[20] sky130_fd_sc_hd__conb_1
XFILLER_15_30 vssd1 vssd1 vccd1 vccd1 sky130_fd_sc_hd__fill_1
XANTENNA__0968__RESET_B net48 vssd1 vssd1 vccd1 vccd1 sky130_fd_sc_hd__diode_2
X_0506_ _0135_ _0136_ _0116_ _0125_ vssd1 vssd1 vccd1 vccd1 _0139_ sky130_fd_sc_hd__a211o_1
XFILLER_36_29 vssd1 vssd1 vccd1 vccd1 sky130_fd_sc_hd__fill_2
X_0437_ net38 vssd1 vssd1 vccd1 vccd1 _0070_ sky130_fd_sc_hd__inv_2
Xclkbuf_4_13_0_clk clknet_0_clk vssd1 vssd1 vccd1 vccd1 clknet_4_13_0_clk sky130_fd_sc_hd__clkbuf_8
XTAP_TAPCELL_ROW_9_125 vssd1 vccd1 sky130_fd_sc_hd__tapvpwrvgnd_1
XFILLER_9_125 vssd1 vssd1 vccd1 vccd1 sky130_fd_sc_hd__fill_4
X_0986_ clknet_4_7_0_clk _0024_ net51 vssd1 vssd1 vccd1 vccd1 SYNTH_INST.waveshape.scaled_count\[5\]
+ sky130_fd_sc_hd__dfrtp_1
XTAP_TAPCELL_ROW_37_252 vssd1 vccd1 sky130_fd_sc_hd__tapvpwrvgnd_1
XFILLER_6_139 vssd1 vssd1 vccd1 vccd1 sky130_fd_sc_hd__fill_1
XTAP_TAPCELL_ROW_20_174 vssd1 vccd1 sky130_fd_sc_hd__tapvpwrvgnd_1
X_0840_ net188 _0388_ net27 vssd1 vssd1 vccd1 vccd1 _0040_ sky130_fd_sc_hd__mux2_1
X_0771_ net192 net27 net20 vssd1 vssd1 vccd1 vccd1 _0027_ sky130_fd_sc_hd__o21a_1
X_0969_ clknet_4_4_0_clk _0007_ net50 vssd1 vssd1 vccd1 vccd1 SYNTH_INST.waveshape.seq_div.dividend\[11\]
+ sky130_fd_sc_hd__dfrtp_1
XFILLER_15_216 vssd1 vssd1 vccd1 vccd1 sky130_fd_sc_hd__fill_2
XFILLER_23_85 vccd1 vssd1 vccd1 vssd1 sky130_ef_sc_hd__decap_40_12
XFILLER_2_153 vssd1 vssd1 vccd1 vccd1 sky130_fd_sc_hd__fill_2
XTAP_TAPCELL_ROW_31_225 vssd1 vccd1 sky130_fd_sc_hd__tapvpwrvgnd_1
XFILLER_9_54 vssd1 vssd1 vccd1 vccd1 sky130_fd_sc_hd__fill_2
X_0823_ SYNTH_INST.waveshape.seq_div.dividend\[28\] net41 vssd1 vssd1 vccd1 vccd1
+ _0375_ sky130_fd_sc_hd__and2_1
X_0754_ net170 net24 _0324_ vssd1 vssd1 vccd1 vccd1 _0018_ sky130_fd_sc_hd__o21a_1
X_0685_ SYNTH_INST.waveshape.scaled_count\[2\] _0285_ _0286_ _0288_ _0284_ vssd1 vssd1
+ vccd1 vccd1 SYNTH_INST.waveshape.shaper.n_sample\[2\] sky130_fd_sc_hd__a221o_1
XFILLER_18_85 vssd1 vssd1 vccd1 vccd1 sky130_fd_sc_hd__fill_4
XFILLER_34_73 vssd1 vssd1 vccd1 vccd1 sky130_fd_sc_hd__fill_1
XANTENNA_fanout48_X net48 vssd1 vssd1 vccd1 vccd1 sky130_fd_sc_hd__diode_2
XFILLER_7_223 vssd1 vssd1 vccd1 vccd1 sky130_fd_sc_hd__fill_1
XFILLER_38_105 vssd1 vssd1 vccd1 vccd1 sky130_fd_sc_hd__fill_4
X_0470_ _0096_ _0100_ _0101_ vssd1 vssd1 vccd1 vccd1 _0103_ sky130_fd_sc_hd__a21o_1
XFILLER_22_6 vssd1 vssd1 vccd1 vccd1 sky130_fd_sc_hd__fill_8
X_1022_ clknet_4_9_0_clk _0046_ net56 vssd1 vssd1 vccd1 vccd1 SYNTH_INST.waveshape.seq_div.dividend\[38\]
+ sky130_fd_sc_hd__dfrtp_1
X_0806_ _0133_ _0134_ vssd1 vssd1 vccd1 vccd1 _0362_ sky130_fd_sc_hd__xor2_1
X_0668_ SYNTH_INST.count\[13\] _0275_ vssd1 vssd1 vccd1 vccd1 _0277_ sky130_fd_sc_hd__nand2_1
X_0737_ net42 SYNTH_INST.waveshape.seq_div.dividend\[13\] net30 SYNTH_INST.count\[6\]
+ net22 vssd1 vssd1 vccd1 vccd1 _0316_ sky130_fd_sc_hd__a221o_1
X_0599_ _0197_ _0199_ vssd1 vssd1 vccd1 vccd1 _0227_ sky130_fd_sc_hd__and2b_1
XFILLER_4_248 vssd1 vssd1 vccd1 vccd1 sky130_fd_sc_hd__fill_1
XFILLER_20_75 vssd1 vssd1 vccd1 vccd1 sky130_fd_sc_hd__fill_8
Xhold40 SYNTH_INST.count\[10\] vssd1 vssd1 vccd1 vccd1 net171 sky130_fd_sc_hd__dlygate4sd3_1
Xhold62 SYNTH_INST.waveshape.scaled_count\[3\] vssd1 vssd1 vccd1 vccd1 net193 sky130_fd_sc_hd__dlygate4sd3_1
Xhold51 SYNTH_INST.pwm_counter.count\[2\] vssd1 vssd1 vccd1 vccd1 net182 sky130_fd_sc_hd__dlygate4sd3_1
XFILLER_29_95 vssd1 vssd1 vccd1 vccd1 sky130_fd_sc_hd__fill_4
X_0522_ SYNTH_INST.waveshape.seq_div.dividend\[28\] _0153_ vssd1 vssd1 vccd1 vccd1
+ _0155_ sky130_fd_sc_hd__xor2_1
X_0453_ SYNTH_INST.waveshape.scaled_count\[7\] vssd1 vssd1 vccd1 vccd1 _0086_ sky130_fd_sc_hd__inv_2
X_1005_ clknet_4_15_0_clk SYNTH_INST.pwm_counter.n_count\[5\] net61 vssd1 vssd1 vccd1
+ vccd1 SYNTH_INST.pwm_counter.count\[5\] sky130_fd_sc_hd__dfrtp_1
XFILLER_34_185 vssd1 vssd1 vccd1 vccd1 sky130_fd_sc_hd__fill_2
XFILLER_34_152 vssd1 vssd1 vccd1 vccd1 sky130_fd_sc_hd__fill_1
XFILLER_34_141 vssd1 vssd1 vccd1 vccd1 sky130_fd_sc_hd__fill_2
XFILLER_19_160 vssd1 vssd1 vccd1 vccd1 sky130_fd_sc_hd__fill_8
Xteam_05_83 vssd1 vssd1 vccd1 vccd1 team_05_83/HI gpio_out[21] sky130_fd_sc_hd__conb_1
Xteam_05_72 vssd1 vssd1 vccd1 vccd1 team_05_72/HI gpio_out[9] sky130_fd_sc_hd__conb_1
Xteam_05_94 vssd1 vssd1 vccd1 vccd1 team_05_94/HI gpio_out[32] sky130_fd_sc_hd__conb_1
XFILLER_31_111 vssd1 vssd1 vccd1 vccd1 sky130_fd_sc_hd__fill_1
X_0505_ _0125_ _0137_ vssd1 vssd1 vccd1 vccd1 _0138_ sky130_fd_sc_hd__or2_1
X_0436_ net32 vssd1 vssd1 vccd1 vccd1 _0069_ sky130_fd_sc_hd__inv_2
.ends
