* NGSPICE file created from team_05.ext - technology: sky130A

* Black-box entry subcircuit for sky130_fd_sc_hd__tapvpwrvgnd_1 abstract view
.subckt sky130_fd_sc_hd__tapvpwrvgnd_1 VGND VPWR
.ends

* Black-box entry subcircuit for sky130_fd_sc_hd__fill_4 abstract view
.subckt sky130_fd_sc_hd__fill_4 VGND VNB VPB VPWR
.ends

* Black-box entry subcircuit for sky130_fd_sc_hd__fill_1 abstract view
.subckt sky130_fd_sc_hd__fill_1 VGND VNB VPB VPWR
.ends

* Black-box entry subcircuit for sky130_fd_sc_hd__dfrtp_2 abstract view
.subckt sky130_fd_sc_hd__dfrtp_2 CLK D RESET_B VGND VNB VPB VPWR Q
.ends

* Black-box entry subcircuit for sky130_fd_sc_hd__dlygate4sd3_1 abstract view
.subckt sky130_fd_sc_hd__dlygate4sd3_1 A VGND VNB VPB VPWR X
.ends

* Black-box entry subcircuit for sky130_fd_sc_hd__mux2_1 abstract view
.subckt sky130_fd_sc_hd__mux2_1 A0 A1 S VGND VNB VPB VPWR X
.ends

* Black-box entry subcircuit for sky130_fd_sc_hd__clkbuf_8 abstract view
.subckt sky130_fd_sc_hd__clkbuf_8 A VGND VNB VPB VPWR X
.ends

* Black-box entry subcircuit for sky130_fd_sc_hd__diode_2 abstract view
.subckt sky130_fd_sc_hd__diode_2 DIODE VGND VNB VPB VPWR
.ends

* Black-box entry subcircuit for sky130_fd_sc_hd__fill_2 abstract view
.subckt sky130_fd_sc_hd__fill_2 VGND VNB VPB VPWR
.ends

* Black-box entry subcircuit for sky130_ef_sc_hd__decap_40_12 abstract view
.subckt sky130_ef_sc_hd__decap_40_12 VNB VPB VGND VPWR
.ends

* Black-box entry subcircuit for sky130_fd_sc_hd__o21bai_2 abstract view
.subckt sky130_fd_sc_hd__o21bai_2 A1 A2 B1_N VGND VNB VPB VPWR Y
.ends

* Black-box entry subcircuit for sky130_fd_sc_hd__a32o_2 abstract view
.subckt sky130_fd_sc_hd__a32o_2 A1 A2 A3 B1 B2 VGND VNB VPB VPWR X
.ends

* Black-box entry subcircuit for sky130_fd_sc_hd__and2_2 abstract view
.subckt sky130_fd_sc_hd__and2_2 A B VGND VNB VPB VPWR X
.ends

* Black-box entry subcircuit for sky130_fd_sc_hd__decap_3 abstract view
.subckt sky130_fd_sc_hd__decap_3 VGND VNB VPB VPWR
.ends

* Black-box entry subcircuit for sky130_fd_sc_hd__a221o_2 abstract view
.subckt sky130_fd_sc_hd__a221o_2 A1 A2 B1 B2 C1 VGND VNB VPB VPWR X
.ends

* Black-box entry subcircuit for sky130_fd_sc_hd__or2_2 abstract view
.subckt sky130_fd_sc_hd__or2_2 A B VGND VNB VPB VPWR X
.ends

* Black-box entry subcircuit for sky130_fd_sc_hd__fill_8 abstract view
.subckt sky130_fd_sc_hd__fill_8 VGND VNB VPB VPWR
.ends

* Black-box entry subcircuit for sky130_fd_sc_hd__nor2_2 abstract view
.subckt sky130_fd_sc_hd__nor2_2 A B VGND VNB VPB VPWR Y
.ends

* Black-box entry subcircuit for sky130_fd_sc_hd__inv_2 abstract view
.subckt sky130_fd_sc_hd__inv_2 A VGND VNB VPB VPWR Y
.ends

* Black-box entry subcircuit for sky130_fd_sc_hd__conb_1 abstract view
.subckt sky130_fd_sc_hd__conb_1 VGND VNB VPB VPWR HI LO
.ends

* Black-box entry subcircuit for sky130_fd_sc_hd__or4b_2 abstract view
.subckt sky130_fd_sc_hd__or4b_2 A B C D_N VGND VNB VPB VPWR X
.ends

* Black-box entry subcircuit for sky130_fd_sc_hd__or3b_2 abstract view
.subckt sky130_fd_sc_hd__or3b_2 A B C_N VGND VNB VPB VPWR X
.ends

* Black-box entry subcircuit for sky130_fd_sc_hd__or3_2 abstract view
.subckt sky130_fd_sc_hd__or3_2 A B C VGND VNB VPB VPWR X
.ends

* Black-box entry subcircuit for sky130_fd_sc_hd__and3_2 abstract view
.subckt sky130_fd_sc_hd__and3_2 A B C VGND VNB VPB VPWR X
.ends

* Black-box entry subcircuit for sky130_fd_sc_hd__dfstp_2 abstract view
.subckt sky130_fd_sc_hd__dfstp_2 CLK D SET_B VGND VNB VPB VPWR Q
.ends

* Black-box entry subcircuit for sky130_fd_sc_hd__buf_2 abstract view
.subckt sky130_fd_sc_hd__buf_2 A VGND VNB VPB VPWR X
.ends

* Black-box entry subcircuit for sky130_fd_sc_hd__clkbuf_4 abstract view
.subckt sky130_fd_sc_hd__clkbuf_4 A VGND VNB VPB VPWR X
.ends

* Black-box entry subcircuit for sky130_fd_sc_hd__a21o_2 abstract view
.subckt sky130_fd_sc_hd__a21o_2 A1 A2 B1 VGND VNB VPB VPWR X
.ends

* Black-box entry subcircuit for sky130_fd_sc_hd__xor2_2 abstract view
.subckt sky130_fd_sc_hd__xor2_2 A B VGND VNB VPB VPWR X
.ends

* Black-box entry subcircuit for sky130_fd_sc_hd__a22o_2 abstract view
.subckt sky130_fd_sc_hd__a22o_2 A1 A2 B1 B2 VGND VNB VPB VPWR X
.ends

* Black-box entry subcircuit for sky130_fd_sc_hd__o21a_2 abstract view
.subckt sky130_fd_sc_hd__o21a_2 A1 A2 B1 VGND VNB VPB VPWR X
.ends

* Black-box entry subcircuit for sky130_fd_sc_hd__a21oi_2 abstract view
.subckt sky130_fd_sc_hd__a21oi_2 A1 A2 B1 VGND VNB VPB VPWR Y
.ends

* Black-box entry subcircuit for sky130_fd_sc_hd__xnor2_2 abstract view
.subckt sky130_fd_sc_hd__xnor2_2 A B VGND VNB VPB VPWR Y
.ends

* Black-box entry subcircuit for sky130_fd_sc_hd__nand3_2 abstract view
.subckt sky130_fd_sc_hd__nand3_2 A B C VGND VNB VPB VPWR Y
.ends

* Black-box entry subcircuit for sky130_fd_sc_hd__o221a_2 abstract view
.subckt sky130_fd_sc_hd__o221a_2 A1 A2 B1 B2 C1 VGND VNB VPB VPWR X
.ends

* Black-box entry subcircuit for sky130_fd_sc_hd__a211oi_2 abstract view
.subckt sky130_fd_sc_hd__a211oi_2 A1 A2 B1 C1 VGND VNB VPB VPWR Y
.ends

* Black-box entry subcircuit for sky130_fd_sc_hd__a211o_2 abstract view
.subckt sky130_fd_sc_hd__a211o_2 A1 A2 B1 C1 VGND VNB VPB VPWR X
.ends

* Black-box entry subcircuit for sky130_fd_sc_hd__o21ai_2 abstract view
.subckt sky130_fd_sc_hd__o21ai_2 A1 A2 B1 VGND VNB VPB VPWR Y
.ends

* Black-box entry subcircuit for sky130_fd_sc_hd__o211a_2 abstract view
.subckt sky130_fd_sc_hd__o211a_2 A1 A2 B1 C1 VGND VNB VPB VPWR X
.ends

* Black-box entry subcircuit for sky130_fd_sc_hd__nand2_2 abstract view
.subckt sky130_fd_sc_hd__nand2_2 A B VGND VNB VPB VPWR Y
.ends

* Black-box entry subcircuit for sky130_fd_sc_hd__o22a_2 abstract view
.subckt sky130_fd_sc_hd__o22a_2 A1 A2 B1 B2 VGND VNB VPB VPWR X
.ends

* Black-box entry subcircuit for sky130_fd_sc_hd__a2bb2o_2 abstract view
.subckt sky130_fd_sc_hd__a2bb2o_2 A1_N A2_N B1 B2 VGND VNB VPB VPWR X
.ends

* Black-box entry subcircuit for sky130_fd_sc_hd__o211ai_2 abstract view
.subckt sky130_fd_sc_hd__o211ai_2 A1 A2 B1 C1 VGND VNB VPB VPWR Y
.ends

* Black-box entry subcircuit for sky130_fd_sc_hd__and3b_2 abstract view
.subckt sky130_fd_sc_hd__and3b_2 A_N B C VGND VNB VPB VPWR X
.ends

* Black-box entry subcircuit for sky130_fd_sc_hd__clkdlybuf4s25_1 abstract view
.subckt sky130_fd_sc_hd__clkdlybuf4s25_1 A VGND VNB VPB VPWR X
.ends

* Black-box entry subcircuit for sky130_fd_sc_hd__o2bb2a_2 abstract view
.subckt sky130_fd_sc_hd__o2bb2a_2 A1_N A2_N B1 B2 VGND VNB VPB VPWR X
.ends

* Black-box entry subcircuit for sky130_fd_sc_hd__and4_2 abstract view
.subckt sky130_fd_sc_hd__and4_2 A B C D VGND VNB VPB VPWR X
.ends

* Black-box entry subcircuit for sky130_fd_sc_hd__clkbuf_16 abstract view
.subckt sky130_fd_sc_hd__clkbuf_16 A VGND VNB VPB VPWR X
.ends

* Black-box entry subcircuit for sky130_fd_sc_hd__a31oi_2 abstract view
.subckt sky130_fd_sc_hd__a31oi_2 A1 A2 A3 B1 VGND VNB VPB VPWR Y
.ends

* Black-box entry subcircuit for sky130_fd_sc_hd__a31o_2 abstract view
.subckt sky130_fd_sc_hd__a31o_2 A1 A2 A3 B1 VGND VNB VPB VPWR X
.ends

* Black-box entry subcircuit for sky130_fd_sc_hd__and2b_2 abstract view
.subckt sky130_fd_sc_hd__and2b_2 A_N B VGND VNB VPB VPWR X
.ends

* Black-box entry subcircuit for sky130_fd_sc_hd__nand3b_2 abstract view
.subckt sky130_fd_sc_hd__nand3b_2 A_N B C VGND VNB VPB VPWR Y
.ends

* Black-box entry subcircuit for sky130_fd_sc_hd__a41o_2 abstract view
.subckt sky130_fd_sc_hd__a41o_2 A1 A2 A3 A4 B1 VGND VNB VPB VPWR X
.ends

* Black-box entry subcircuit for sky130_fd_sc_hd__a2111oi_2 abstract view
.subckt sky130_fd_sc_hd__a2111oi_2 A1 A2 B1 C1 D1 VGND VNB VPB VPWR Y
.ends

* Black-box entry subcircuit for sky130_fd_sc_hd__nor3b_2 abstract view
.subckt sky130_fd_sc_hd__nor3b_2 A B C_N VGND VNB VPB VPWR Y
.ends

* Black-box entry subcircuit for sky130_fd_sc_hd__a21bo_2 abstract view
.subckt sky130_fd_sc_hd__a21bo_2 A1 A2 B1_N VGND VNB VPB VPWR X
.ends

* Black-box entry subcircuit for sky130_fd_sc_hd__nand2b_2 abstract view
.subckt sky130_fd_sc_hd__nand2b_2 A_N B VGND VNB VPB VPWR Y
.ends

* Black-box entry subcircuit for sky130_fd_sc_hd__or4_2 abstract view
.subckt sky130_fd_sc_hd__or4_2 A B C D VGND VNB VPB VPWR X
.ends

* Black-box entry subcircuit for sky130_fd_sc_hd__nor3_2 abstract view
.subckt sky130_fd_sc_hd__nor3_2 A B C VGND VNB VPB VPWR Y
.ends

* Black-box entry subcircuit for sky130_fd_sc_hd__o32a_2 abstract view
.subckt sky130_fd_sc_hd__o32a_2 A1 A2 A3 B1 B2 VGND VNB VPB VPWR X
.ends

* Black-box entry subcircuit for sky130_fd_sc_hd__o31ai_2 abstract view
.subckt sky130_fd_sc_hd__o31ai_2 A1 A2 A3 B1 VGND VNB VPB VPWR Y
.ends

* Black-box entry subcircuit for sky130_fd_sc_hd__o31a_2 abstract view
.subckt sky130_fd_sc_hd__o31a_2 A1 A2 A3 B1 VGND VNB VPB VPWR X
.ends

* Black-box entry subcircuit for sky130_fd_sc_hd__clkbuf_2 abstract view
.subckt sky130_fd_sc_hd__clkbuf_2 A VGND VNB VPB VPWR X
.ends

* Black-box entry subcircuit for sky130_fd_sc_hd__o2bb2ai_2 abstract view
.subckt sky130_fd_sc_hd__o2bb2ai_2 A1_N A2_N B1 B2 VGND VNB VPB VPWR Y
.ends

* Black-box entry subcircuit for sky130_fd_sc_hd__o21ba_2 abstract view
.subckt sky130_fd_sc_hd__o21ba_2 A1 A2 B1_N VGND VNB VPB VPWR X
.ends

* Black-box entry subcircuit for sky130_fd_sc_hd__a2111o_2 abstract view
.subckt sky130_fd_sc_hd__a2111o_2 A1 A2 B1 C1 D1 VGND VNB VPB VPWR X
.ends

* Black-box entry subcircuit for sky130_fd_sc_hd__a311o_2 abstract view
.subckt sky130_fd_sc_hd__a311o_2 A1 A2 A3 B1 C1 VGND VNB VPB VPWR X
.ends

* Black-box entry subcircuit for sky130_fd_sc_hd__and4bb_2 abstract view
.subckt sky130_fd_sc_hd__and4bb_2 A_N B_N C D VGND VNB VPB VPWR X
.ends

* Black-box entry subcircuit for sky130_fd_sc_hd__o22ai_2 abstract view
.subckt sky130_fd_sc_hd__o22ai_2 A1 A2 B1 B2 VGND VNB VPB VPWR Y
.ends

.subckt team_05 clk en gpio_in[0] gpio_in[10] gpio_in[11] gpio_in[12] gpio_in[13]
+ gpio_in[14] gpio_in[15] gpio_in[16] gpio_in[17] gpio_in[18] gpio_in[19] gpio_in[1]
+ gpio_in[20] gpio_in[21] gpio_in[22] gpio_in[23] gpio_in[24] gpio_in[25] gpio_in[26]
+ gpio_in[27] gpio_in[28] gpio_in[29] gpio_in[2] gpio_in[30] gpio_in[31] gpio_in[32]
+ gpio_in[33] gpio_in[3] gpio_in[4] gpio_in[5] gpio_in[6] gpio_in[7] gpio_in[8] gpio_in[9]
+ gpio_oeb[0] gpio_oeb[10] gpio_oeb[11] gpio_oeb[12] gpio_oeb[13] gpio_oeb[14] gpio_oeb[15]
+ gpio_oeb[16] gpio_oeb[17] gpio_oeb[18] gpio_oeb[19] gpio_oeb[1] gpio_oeb[20] gpio_oeb[21]
+ gpio_oeb[22] gpio_oeb[23] gpio_oeb[24] gpio_oeb[25] gpio_oeb[26] gpio_oeb[27] gpio_oeb[28]
+ gpio_oeb[29] gpio_oeb[2] gpio_oeb[30] gpio_oeb[31] gpio_oeb[32] gpio_oeb[33] gpio_oeb[3]
+ gpio_oeb[4] gpio_oeb[5] gpio_oeb[6] gpio_oeb[7] gpio_oeb[8] gpio_oeb[9] gpio_out[0]
+ gpio_out[10] gpio_out[11] gpio_out[12] gpio_out[13] gpio_out[14] gpio_out[15] gpio_out[16]
+ gpio_out[17] gpio_out[18] gpio_out[19] gpio_out[1] gpio_out[20] gpio_out[21] gpio_out[22]
+ gpio_out[23] gpio_out[24] gpio_out[25] gpio_out[26] gpio_out[27] gpio_out[28] gpio_out[29]
+ gpio_out[2] gpio_out[30] gpio_out[31] gpio_out[32] gpio_out[33] gpio_out[3] gpio_out[4]
+ gpio_out[5] gpio_out[6] gpio_out[7] gpio_out[8] gpio_out[9] nrst vccd1 vssd1
XTAP_TAPCELL_ROW_9_126 vssd1 vccd1 sky130_fd_sc_hd__tapvpwrvgnd_1
XFILLER_26_85 vssd1 vssd1 vccd1 vccd1 sky130_fd_sc_hd__fill_4
XFILLER_26_41 vssd1 vssd1 vccd1 vccd1 sky130_fd_sc_hd__fill_1
XFILLER_9_137 vssd1 vssd1 vccd1 vccd1 sky130_fd_sc_hd__fill_1
XFILLER_3_34 vssd1 vssd1 vccd1 vccd1 sky130_fd_sc_hd__fill_1
X_0985_ clkload8/A _0985_/D load_slew60/X vssd1 vssd1 vccd1 vccd1 _0985_/Q sky130_fd_sc_hd__dfrtp_2
XFILLER_10_136 vssd1 vssd1 vccd1 vccd1 sky130_fd_sc_hd__fill_4
XFILLER_12_87 vssd1 vssd1 vccd1 vccd1 sky130_fd_sc_hd__fill_1
Xhold170 _0993_/Q vssd1 vssd1 vccd1 vccd1 hold170/X sky130_fd_sc_hd__dlygate4sd3_1
Xhold181 _0907_/Q vssd1 vssd1 vccd1 vccd1 _0577_/A sky130_fd_sc_hd__dlygate4sd3_1
Xhold192 _0990_/Q vssd1 vssd1 vccd1 vccd1 hold192/X sky130_fd_sc_hd__dlygate4sd3_1
XTAP_TAPCELL_ROW_20_175 vssd1 vccd1 sky130_fd_sc_hd__tapvpwrvgnd_1
X_0770_ _0967_/Q _0769_/X _0788_/S vssd1 vssd1 vccd1 vccd1 _0967_/D sky130_fd_sc_hd__mux2_1
X_0968_ _0970_/CLK _0968_/D load_slew49/X vssd1 vssd1 vccd1 vccd1 _0968_/Q sky130_fd_sc_hd__dfrtp_2
Xclkbuf_4_12_0_clk clkbuf_0_clk/X vssd1 vssd1 vccd1 vccd1 _1011_/CLK sky130_fd_sc_hd__clkbuf_8
X_0899_ _1003_/CLK _0899_/D wire67/X vssd1 vssd1 vccd1 vccd1 _0899_/Q sky130_fd_sc_hd__dfrtp_2
XANTENNA__0871__A2 _0884_/B1 vssd1 vssd1 vccd1 vccd1 sky130_fd_sc_hd__diode_2
XANTENNA_fanout38_A _0765_/B2 vssd1 vssd1 vccd1 vccd1 sky130_fd_sc_hd__diode_2
XFILLER_0_46 vssd1 vssd1 vccd1 vccd1 sky130_fd_sc_hd__fill_2
XFILLER_0_57 vssd1 vssd1 vccd1 vccd1 sky130_fd_sc_hd__fill_2
XFILLER_0_68 vssd1 vccd1 vssd1 vccd1 sky130_ef_sc_hd__decap_40_12
X_0822_ _0979_/Q _0821_/A _0980_/Q vssd1 vssd1 vccd1 vccd1 _0822_/Y sky130_fd_sc_hd__o21bai_2
XFILLER_9_11 vssd1 vssd1 vccd1 vccd1 sky130_fd_sc_hd__fill_2
X_0753_ _0795_/B1 _0487_/B _0752_/X _0787_/B2 _0962_/Q vssd1 vssd1 vccd1 vccd1 _0753_/X
+ sky130_fd_sc_hd__a32o_2
X_0684_ _0897_/Q _0694_/B vssd1 vssd1 vccd1 vccd1 _0696_/B sky130_fd_sc_hd__and2_2
XANTENNA__0853__A2 _0884_/B1 vssd1 vssd1 vccd1 vccd1 sky130_fd_sc_hd__diode_2
XFILLER_20_253 vssd1 vssd1 vccd1 vccd1 sky130_fd_sc_hd__fill_2
XPHY_EDGE_ROW_8_Left_47 vssd1 vssd1 vccd1 vccd1 sky130_fd_sc_hd__decap_3
XFILLER_34_85 vssd1 vssd1 vccd1 vccd1 sky130_fd_sc_hd__fill_1
XFILLER_22_7 vssd1 vssd1 vccd1 vccd1 sky130_fd_sc_hd__fill_2
X_0805_ _0741_/A _0803_/Y _0808_/C _0823_/B1 _0974_/Q vssd1 vssd1 vccd1 vccd1 _0805_/X
+ sky130_fd_sc_hd__a32o_2
X_0736_ _0956_/Q hold160/X wire31/X vssd1 vssd1 vccd1 vccd1 _0736_/X sky130_fd_sc_hd__mux2_1
X_0667_ _1007_/Q _0657_/Y _0658_/Y _0666_/X _0664_/X vssd1 vssd1 vccd1 vccd1 _0900_/D
+ sky130_fd_sc_hd__a221o_2
X_0598_ _0923_/Q _0598_/B vssd1 vssd1 vccd1 vccd1 _0598_/X sky130_fd_sc_hd__or2_2
XFILLER_20_65 vssd1 vssd1 vccd1 vccd1 sky130_fd_sc_hd__fill_1
XFILLER_29_30 vssd1 vssd1 vccd1 vccd1 sky130_fd_sc_hd__fill_2
XFILLER_20_87 vssd1 vssd1 vccd1 vccd1 sky130_fd_sc_hd__fill_1
XFILLER_6_34 vssd1 vssd1 vccd1 vccd1 sky130_fd_sc_hd__fill_8
X_0521_ _0969_/Q _0598_/B vssd1 vssd1 vccd1 vccd1 _0780_/A sky130_fd_sc_hd__and2_2
X_0452_ _0975_/Q _0455_/B vssd1 vssd1 vccd1 vccd1 _0463_/A sky130_fd_sc_hd__nor2_2
XFILLER_13_3 vssd1 vccd1 vssd1 vccd1 sky130_ef_sc_hd__decap_40_12
X_1004_ clkload6/A _1004_/D fanout57/X vssd1 vssd1 vccd1 vccd1 _1004_/Q sky130_fd_sc_hd__dfrtp_2
XFILLER_34_197 vssd1 vssd1 vccd1 vccd1 sky130_fd_sc_hd__fill_1
X_0719_ _0728_/B vssd1 vssd1 vccd1 vccd1 _0719_/Y sky130_fd_sc_hd__inv_2
Xteam_05_95 vssd1 vssd1 vccd1 vccd1 team_05_95/HI gpio_out[21] sky130_fd_sc_hd__conb_1
Xteam_05_84 vssd1 vssd1 vccd1 vccd1 team_05_84/HI gpio_out[9] sky130_fd_sc_hd__conb_1
XFILLER_15_76 vssd1 vssd1 vccd1 vccd1 sky130_fd_sc_hd__fill_1
X_0504_ _0772_/A _0504_/B _0764_/A _0760_/B vssd1 vssd1 vccd1 vccd1 _0504_/X sky130_fd_sc_hd__or4b_2
X_0435_ _0897_/Q vssd1 vssd1 vccd1 vccd1 _0435_/Y sky130_fd_sc_hd__inv_2
XFILLER_22_167 vssd1 vssd1 vccd1 vccd1 sky130_fd_sc_hd__fill_8
XFILLER_22_156 vssd1 vssd1 vccd1 vccd1 sky130_fd_sc_hd__fill_2
XANTENNA_fanout68_A fanout74/X vssd1 vssd1 vccd1 vccd1 sky130_fd_sc_hd__diode_2
XPHY_EDGE_ROW_37_Left_76 vssd1 vssd1 vccd1 vccd1 sky130_fd_sc_hd__decap_3
X_0984_ clkload3/A _0984_/D load_slew53/X vssd1 vssd1 vccd1 vccd1 _0984_/Q sky130_fd_sc_hd__dfrtp_2
XFILLER_27_237 vssd1 vssd1 vccd1 vccd1 sky130_fd_sc_hd__fill_1
XTAP_TAPCELL_ROW_20_176 vssd1 vccd1 sky130_fd_sc_hd__tapvpwrvgnd_1
Xhold160 _0902_/Q vssd1 vssd1 vccd1 vccd1 hold160/X sky130_fd_sc_hd__dlygate4sd3_1
Xhold171 _0999_/Q vssd1 vssd1 vccd1 vccd1 hold171/X sky130_fd_sc_hd__dlygate4sd3_1
Xhold182 _0910_/Q vssd1 vssd1 vccd1 vccd1 hold182/X sky130_fd_sc_hd__dlygate4sd3_1
Xhold193 _0894_/Q vssd1 vssd1 vccd1 vccd1 _0689_/A sky130_fd_sc_hd__dlygate4sd3_1
XTAP_TAPCELL_ROW_28_210 vssd1 vccd1 sky130_fd_sc_hd__tapvpwrvgnd_1
XFILLER_37_96 vssd1 vssd1 vccd1 vccd1 sky130_fd_sc_hd__fill_4
XTAP_TAPCELL_ROW_11_132 vssd1 vccd1 sky130_fd_sc_hd__tapvpwrvgnd_1
XTAP_TAPCELL_ROW_34_235 vssd1 vccd1 sky130_fd_sc_hd__tapvpwrvgnd_1
XFILLER_24_229 vssd1 vssd1 vccd1 vccd1 sky130_fd_sc_hd__fill_2
X_0967_ _0970_/CLK _0967_/D load_slew49/X vssd1 vssd1 vccd1 vccd1 _0967_/Q sky130_fd_sc_hd__dfrtp_2
XFILLER_32_251 vssd1 vssd1 vccd1 vccd1 sky130_fd_sc_hd__fill_1
X_0898_ _1020_/CLK _0898_/D load_slew70/X vssd1 vssd1 vccd1 vccd1 _0898_/Q sky130_fd_sc_hd__dfrtp_2
XPHY_EDGE_ROW_12_Right_12 vssd1 vssd1 vccd1 vccd1 sky130_fd_sc_hd__decap_3
XPHY_EDGE_ROW_21_Right_21 vssd1 vssd1 vccd1 vccd1 sky130_fd_sc_hd__decap_3
XFILLER_23_54 vssd1 vssd1 vccd1 vccd1 sky130_fd_sc_hd__fill_2
XFILLER_23_32 vssd1 vssd1 vccd1 vccd1 sky130_fd_sc_hd__fill_1
XPHY_EDGE_ROW_30_Right_30 vssd1 vssd1 vccd1 vccd1 sky130_fd_sc_hd__decap_3
XFILLER_23_87 vssd1 vssd1 vccd1 vccd1 sky130_fd_sc_hd__fill_1
XFILLER_14_251 vssd1 vssd1 vccd1 vccd1 sky130_fd_sc_hd__fill_1
X_0821_ _0821_/A _0979_/Q _0980_/Q vssd1 vssd1 vccd1 vccd1 _0821_/X sky130_fd_sc_hd__or3b_2
X_0752_ _0752_/A _0752_/B _0752_/C vssd1 vssd1 vccd1 vccd1 _0752_/X sky130_fd_sc_hd__or3_2
X_0683_ _0896_/Q _0895_/Q _0691_/B vssd1 vssd1 vccd1 vccd1 _0694_/B sky130_fd_sc_hd__and3_2
XPHY_EDGE_ROW_24_Left_63 vssd1 vssd1 vccd1 vccd1 sky130_fd_sc_hd__decap_3
XANTENNA_fanout50_A fanout58/X vssd1 vssd1 vccd1 vccd1 sky130_fd_sc_hd__diode_2
XFILLER_18_98 vssd1 vssd1 vccd1 vccd1 sky130_fd_sc_hd__fill_4
XFILLER_11_232 vssd1 vssd1 vccd1 vccd1 sky130_fd_sc_hd__fill_4
X_1020_ _1020_/CLK _1020_/D fanout73/X vssd1 vssd1 vccd1 vccd1 _1020_/Q sky130_fd_sc_hd__dfstp_2
Xclkbuf_4_11_0_clk clkbuf_0_clk/X vssd1 vssd1 vccd1 vccd1 _1019_/CLK sky130_fd_sc_hd__clkbuf_8
Xload_slew64 fanout63/X vssd1 vssd1 vccd1 vccd1 load_slew64/X sky130_fd_sc_hd__buf_2
Xload_slew53 fanout52/X vssd1 vssd1 vccd1 vccd1 load_slew53/X sky130_fd_sc_hd__clkbuf_4
X_0804_ _0803_/A _0803_/C _0803_/B vssd1 vssd1 vccd1 vccd1 _0808_/C sky130_fd_sc_hd__a21o_2
X_0735_ _0955_/Q hold145/X wire31/X vssd1 vssd1 vccd1 vccd1 _0735_/X sky130_fd_sc_hd__mux2_1
X_0666_ _1006_/Q _1013_/Q vssd1 vssd1 vccd1 vccd1 _0666_/X sky130_fd_sc_hd__xor2_2
X_0597_ _0922_/Q _0490_/B _0595_/B _0921_/Q vssd1 vssd1 vccd1 vccd1 _0597_/X sky130_fd_sc_hd__a22o_2
XFILLER_20_44 vssd1 vssd1 vccd1 vccd1 sky130_fd_sc_hd__fill_1
XFILLER_29_75 vssd1 vssd1 vccd1 vccd1 sky130_fd_sc_hd__fill_2
XFILLER_29_53 vssd1 vssd1 vccd1 vccd1 sky130_fd_sc_hd__fill_2
XFILLER_28_195 vssd1 vssd1 vccd1 vccd1 sky130_fd_sc_hd__fill_1
XFILLER_6_24 vssd1 vssd1 vccd1 vccd1 sky130_fd_sc_hd__fill_4
X_0520_ _0952_/Q _0519_/Y _0473_/X vssd1 vssd1 vccd1 vccd1 _0598_/B sky130_fd_sc_hd__o21a_2
X_0451_ _0514_/A _0472_/A _0450_/X vssd1 vssd1 vccd1 vccd1 _0455_/B sky130_fd_sc_hd__a21oi_2
X_1003_ _1003_/CLK _1003_/D fanout68/X vssd1 vssd1 vccd1 vccd1 _1003_/Q sky130_fd_sc_hd__dfrtp_2
XANTENNA__0744__A2 _0749_/B vssd1 vssd1 vccd1 vccd1 sky130_fd_sc_hd__diode_2
X_0718_ _0703_/X _0717_/X _0702_/X vssd1 vssd1 vccd1 vccd1 _0728_/B sky130_fd_sc_hd__a21o_2
XPHY_EDGE_ROW_6_Right_6 vssd1 vssd1 vccd1 vccd1 sky130_fd_sc_hd__decap_3
X_0649_ _0929_/Q _0649_/B vssd1 vssd1 vccd1 vccd1 _0650_/B sky130_fd_sc_hd__xnor2_2
XFILLER_15_55 vssd1 vssd1 vccd1 vccd1 sky130_fd_sc_hd__fill_1
XFILLER_15_66 vssd1 vssd1 vccd1 vccd1 sky130_fd_sc_hd__fill_8
Xteam_05_96 vssd1 vssd1 vccd1 vccd1 team_05_96/HI gpio_out[22] sky130_fd_sc_hd__conb_1
Xteam_05_85 vssd1 vssd1 vccd1 vccd1 team_05_85/HI gpio_out[10] sky130_fd_sc_hd__conb_1
XPHY_EDGE_ROW_11_Left_50 vssd1 vssd1 vccd1 vccd1 sky130_fd_sc_hd__decap_3
XFILLER_25_154 vssd1 vssd1 vccd1 vccd1 sky130_fd_sc_hd__fill_4
XFILLER_31_43 vssd1 vssd1 vccd1 vccd1 sky130_fd_sc_hd__fill_2
X_0503_ _0965_/Q wire32/X vssd1 vssd1 vccd1 vccd1 _0760_/B sky130_fd_sc_hd__xnor2_2
X_0434_ _0898_/Q vssd1 vssd1 vccd1 vccd1 _0696_/A sky130_fd_sc_hd__inv_2
XTAP_TAPCELL_ROW_17_160 vssd1 vccd1 sky130_fd_sc_hd__tapvpwrvgnd_1
XFILLER_22_135 vssd1 vssd1 vccd1 vccd1 sky130_fd_sc_hd__fill_2
XFILLER_13_113 vssd1 vssd1 vccd1 vccd1 sky130_fd_sc_hd__fill_4
X_0983_ clkload3/A _0983_/D load_slew53/X vssd1 vssd1 vccd1 vccd1 _0983_/Q sky130_fd_sc_hd__dfrtp_2
XTAP_TAPCELL_ROW_6_109 vssd1 vccd1 sky130_fd_sc_hd__tapvpwrvgnd_1
XFILLER_10_149 vssd1 vssd1 vccd1 vccd1 sky130_fd_sc_hd__fill_2
Xhold150 _0904_/Q vssd1 vssd1 vccd1 vccd1 hold150/X sky130_fd_sc_hd__dlygate4sd3_1
Xhold161 _0736_/X vssd1 vssd1 vccd1 vccd1 _0956_/D sky130_fd_sc_hd__dlygate4sd3_1
Xhold172 _0994_/Q vssd1 vssd1 vccd1 vccd1 hold172/X sky130_fd_sc_hd__dlygate4sd3_1
Xhold183 _1000_/Q vssd1 vssd1 vccd1 vccd1 hold183/X sky130_fd_sc_hd__dlygate4sd3_1
Xhold194 _0898_/Q vssd1 vssd1 vccd1 vccd1 hold194/X sky130_fd_sc_hd__dlygate4sd3_1
XFILLER_5_6 vssd1 vssd1 vccd1 vccd1 sky130_fd_sc_hd__fill_4
XTAP_TAPCELL_ROW_28_211 vssd1 vccd1 sky130_fd_sc_hd__tapvpwrvgnd_1
XTAP_TAPCELL_ROW_11_133 vssd1 vccd1 sky130_fd_sc_hd__tapvpwrvgnd_1
XFILLER_5_142 vssd1 vssd1 vccd1 vccd1 sky130_fd_sc_hd__fill_2
XTAP_TAPCELL_ROW_34_236 vssd1 vccd1 sky130_fd_sc_hd__tapvpwrvgnd_1
X_0897_ _0960_/CLK _0897_/D load_slew70/X vssd1 vssd1 vccd1 vccd1 _0897_/Q sky130_fd_sc_hd__dfrtp_2
X_0966_ clkload1/A _0966_/D fanout50/X vssd1 vssd1 vccd1 vccd1 _0966_/Q sky130_fd_sc_hd__dfrtp_2
XANTENNA__0856__A1 _0856_/A1 vssd1 vssd1 vccd1 vccd1 sky130_fd_sc_hd__diode_2
XFILLER_0_48 vssd1 vssd1 vccd1 vccd1 sky130_fd_sc_hd__fill_1
XFILLER_0_59 vssd1 vssd1 vccd1 vccd1 sky130_fd_sc_hd__fill_1
XFILLER_9_13 vssd1 vssd1 vccd1 vccd1 sky130_fd_sc_hd__fill_1
X_0820_ _0979_/Q _0743_/Y _0747_/X _0978_/Q _0819_/Y vssd1 vssd1 vccd1 vccd1 _0979_/D
+ sky130_fd_sc_hd__a221o_2
X_0751_ _0962_/Q _0750_/X _0788_/S vssd1 vssd1 vccd1 vccd1 _0962_/D sky130_fd_sc_hd__mux2_1
XFILLER_9_57 vssd1 vssd1 vccd1 vccd1 sky130_fd_sc_hd__fill_2
X_0682_ _0894_/Q _0689_/B vssd1 vssd1 vccd1 vccd1 _0691_/B sky130_fd_sc_hd__and2_2
XTAP_TAPCELL_ROW_0_80 vssd1 vccd1 sky130_fd_sc_hd__tapvpwrvgnd_1
X_0949_ clkload7/A _0949_/D fanout59/X vssd1 vssd1 vccd1 vccd1 _0949_/Q sky130_fd_sc_hd__dfrtp_2
XFILLER_18_44 vssd1 vssd1 vccd1 vccd1 sky130_fd_sc_hd__fill_1
XFILLER_34_65 vssd1 vssd1 vccd1 vccd1 sky130_fd_sc_hd__fill_1
X_0803_ _0803_/A _0803_/B _0803_/C vssd1 vssd1 vccd1 vccd1 _0803_/Y sky130_fd_sc_hd__nand3_2
X_0734_ _0954_/Q hold152/X wire31/X vssd1 vssd1 vccd1 vccd1 _0734_/X sky130_fd_sc_hd__mux2_1
X_0665_ _1006_/Q _0657_/Y _0664_/X vssd1 vssd1 vccd1 vccd1 _0899_/D sky130_fd_sc_hd__a21o_2
X_0596_ _0920_/Q _0500_/B _0593_/X _0594_/X _0595_/X vssd1 vssd1 vccd1 vccd1 _0596_/X
+ sky130_fd_sc_hd__o221a_2
XFILLER_20_78 vssd1 vssd1 vccd1 vccd1 sky130_fd_sc_hd__fill_4
X_0450_ _0949_/Q _0951_/Q _0514_/A vssd1 vssd1 vccd1 vccd1 _0450_/X sky130_fd_sc_hd__o21a_2
X_1002_ clkload6/A _1002_/D fanout68/X vssd1 vssd1 vccd1 vccd1 _1002_/Q sky130_fd_sc_hd__dfrtp_2
X_0717_ _0938_/Q _0941_/Q _0940_/Q _0939_/Q vssd1 vssd1 vccd1 vccd1 _0717_/X sky130_fd_sc_hd__or4b_2
X_0648_ _0650_/A _0649_/B _0648_/C vssd1 vssd1 vccd1 vccd1 _0928_/D sky130_fd_sc_hd__and3_2
Xteam_05_97 vssd1 vssd1 vccd1 vccd1 team_05_97/HI gpio_out[23] sky130_fd_sc_hd__conb_1
Xteam_05_86 vssd1 vssd1 vccd1 vccd1 team_05_86/HI gpio_out[11] sky130_fd_sc_hd__conb_1
Xteam_05_75 vssd1 vssd1 vccd1 vccd1 team_05_75/HI gpio_out[0] sky130_fd_sc_hd__conb_1
X_0579_ _0907_/Q hold164/X _0578_/Y vssd1 vssd1 vccd1 vccd1 _0579_/Y sky130_fd_sc_hd__a21oi_2
XFILLER_25_111 vssd1 vssd1 vccd1 vccd1 sky130_fd_sc_hd__fill_1
XANTENNA__0452__B _0455_/B vssd1 vssd1 vccd1 vccd1 sky130_fd_sc_hd__diode_2
Xclkbuf_4_10_0_clk clkbuf_0_clk/X vssd1 vssd1 vccd1 vccd1 clkload9/A sky130_fd_sc_hd__clkbuf_8
XFILLER_16_155 vssd1 vssd1 vccd1 vccd1 sky130_fd_sc_hd__fill_1
XFILLER_31_169 vssd1 vssd1 vccd1 vccd1 sky130_fd_sc_hd__fill_1
X_0502_ _0472_/A _0497_/B _0480_/Y _0501_/Y vssd1 vssd1 vccd1 vccd1 wire32/A sky130_fd_sc_hd__a211oi_2
X_0433_ _0895_/Q vssd1 vssd1 vccd1 vccd1 _0691_/A sky130_fd_sc_hd__inv_2
XTAP_TAPCELL_ROW_17_161 vssd1 vccd1 sky130_fd_sc_hd__tapvpwrvgnd_1
XFILLER_22_158 vssd1 vssd1 vccd1 vccd1 sky130_fd_sc_hd__fill_1
XFILLER_26_11 vssd1 vssd1 vccd1 vccd1 sky130_fd_sc_hd__fill_1
XTAP_TAPCELL_ROW_23_186 vssd1 vccd1 sky130_fd_sc_hd__tapvpwrvgnd_1
XFILLER_9_107 vssd1 vssd1 vccd1 vccd1 sky130_fd_sc_hd__fill_4
XFILLER_12_191 vssd1 vssd1 vccd1 vccd1 sky130_fd_sc_hd__fill_1
X_0982_ clkload3/A _0982_/D fanout54/X vssd1 vssd1 vccd1 vccd1 _0982_/Q sky130_fd_sc_hd__dfrtp_2
XFILLER_12_46 vssd1 vssd1 vccd1 vccd1 sky130_fd_sc_hd__fill_2
Xhold151 _0738_/X vssd1 vssd1 vccd1 vccd1 _0958_/D sky130_fd_sc_hd__dlygate4sd3_1
Xhold162 _1003_/Q vssd1 vssd1 vccd1 vccd1 _0879_/A sky130_fd_sc_hd__dlygate4sd3_1
XANTENNA_fanout73_A fanout74/X vssd1 vssd1 vccd1 vccd1 sky130_fd_sc_hd__diode_2
Xhold173 _0995_/Q vssd1 vssd1 vccd1 vccd1 hold173/X sky130_fd_sc_hd__dlygate4sd3_1
Xhold184 _0896_/Q vssd1 vssd1 vccd1 vccd1 hold184/X sky130_fd_sc_hd__dlygate4sd3_1
Xhold195 _0970_/Q vssd1 vssd1 vccd1 vccd1 hold195/X sky130_fd_sc_hd__dlygate4sd3_1
XTAP_TAPCELL_ROW_28_212 vssd1 vccd1 sky130_fd_sc_hd__tapvpwrvgnd_1
XTAP_TAPCELL_ROW_11_134 vssd1 vccd1 sky130_fd_sc_hd__tapvpwrvgnd_1
XFILLER_5_110 vssd1 vssd1 vccd1 vccd1 sky130_fd_sc_hd__fill_2
XANTENNA__0865__A2 _0884_/B1 vssd1 vssd1 vccd1 vccd1 sky130_fd_sc_hd__diode_2
XTAP_TAPCELL_ROW_34_237 vssd1 vccd1 sky130_fd_sc_hd__tapvpwrvgnd_1
XFILLER_32_253 vssd1 vssd1 vccd1 vccd1 sky130_fd_sc_hd__fill_2
X_0896_ _1020_/CLK _0896_/D load_slew70/X vssd1 vssd1 vccd1 vccd1 _0896_/Q sky130_fd_sc_hd__dfrtp_2
X_0965_ _0970_/CLK _0965_/D fanout50/X vssd1 vssd1 vccd1 vccd1 _0965_/Q sky130_fd_sc_hd__dfrtp_2
XFILLER_2_146 vssd1 vssd1 vccd1 vccd1 sky130_fd_sc_hd__fill_1
XFILLER_14_253 vssd1 vssd1 vccd1 vccd1 sky130_fd_sc_hd__fill_2
XFILLER_9_36 vssd1 vccd1 vssd1 vccd1 sky130_ef_sc_hd__decap_40_12
X_0750_ _0795_/B1 _0484_/Y _0749_/X _0787_/B2 _0961_/Q vssd1 vssd1 vccd1 vccd1 _0750_/X
+ sky130_fd_sc_hd__a32o_2
X_0681_ _1020_/Q _0892_/Q _0893_/Q vssd1 vssd1 vccd1 vccd1 _0689_/B sky130_fd_sc_hd__and3_2
XTAP_TAPCELL_ROW_0_81 vssd1 vccd1 sky130_fd_sc_hd__tapvpwrvgnd_1
XFILLER_29_3 vssd1 vssd1 vccd1 vccd1 sky130_fd_sc_hd__fill_2
X_0948_ _1011_/CLK _0948_/D load_slew62/X vssd1 vssd1 vccd1 vccd1 _0948_/Q sky130_fd_sc_hd__dfrtp_2
X_0879_ _0879_/A _0879_/B vssd1 vssd1 vccd1 vccd1 _1003_/D sky130_fd_sc_hd__xor2_2
XANTENNA__0455__B _0455_/B vssd1 vssd1 vccd1 vccd1 sky130_fd_sc_hd__diode_2
XANTENNA_fanout36_A _0765_/B2 vssd1 vssd1 vccd1 vccd1 sky130_fd_sc_hd__diode_2
XFILLER_18_89 vssd1 vssd1 vccd1 vccd1 sky130_fd_sc_hd__fill_1
XANTENNA__0765__B2 _0765_/B2 vssd1 vssd1 vccd1 vccd1 sky130_fd_sc_hd__diode_2
X_0802_ _0538_/B _0538_/C _0460_/Y _0799_/A vssd1 vssd1 vccd1 vccd1 _0803_/C sky130_fd_sc_hd__a211o_2
X_0733_ _0953_/Q hold156/X wire31/X vssd1 vssd1 vccd1 vccd1 _0733_/X sky130_fd_sc_hd__mux2_1
X_0664_ _0932_/Q _0664_/B _1013_/Q vssd1 vssd1 vccd1 vccd1 _0664_/X sky130_fd_sc_hd__and3_2
X_0595_ _0921_/Q _0595_/B vssd1 vssd1 vccd1 vccd1 _0595_/X sky130_fd_sc_hd__or2_2
XFILLER_20_24 vssd1 vssd1 vccd1 vccd1 sky130_fd_sc_hd__fill_4
XFILLER_29_22 vssd1 vssd1 vccd1 vccd1 sky130_fd_sc_hd__fill_8
XFILLER_20_68 vssd1 vssd1 vccd1 vccd1 sky130_fd_sc_hd__fill_2
XFILLER_29_77 vssd1 vssd1 vccd1 vccd1 sky130_fd_sc_hd__fill_1
XFILLER_29_55 vssd1 vssd1 vccd1 vccd1 sky130_fd_sc_hd__fill_1
XANTENNA_fanout39_X _0765_/B2 vssd1 vssd1 vccd1 vccd1 sky130_fd_sc_hd__diode_2
X_1001_ clkload6/A _1001_/D fanout68/X vssd1 vssd1 vccd1 vccd1 _1001_/Q sky130_fd_sc_hd__dfrtp_2
XFILLER_34_101 vssd1 vssd1 vccd1 vccd1 sky130_fd_sc_hd__fill_2
X_0716_ _0700_/X _0715_/Y _0553_/A vssd1 vssd1 vccd1 vccd1 _0716_/X sky130_fd_sc_hd__o21a_2
X_0647_ _0928_/Q _0647_/B vssd1 vssd1 vccd1 vccd1 _0648_/C sky130_fd_sc_hd__or2_2
X_0578_ _0907_/Q hold164/X _0587_/A vssd1 vssd1 vccd1 vccd1 _0578_/Y sky130_fd_sc_hd__o21ai_2
Xteam_05_98 vssd1 vssd1 vccd1 vccd1 team_05_98/HI gpio_out[24] sky130_fd_sc_hd__conb_1
Xteam_05_87 vssd1 vssd1 vccd1 vccd1 team_05_87/HI gpio_out[12] sky130_fd_sc_hd__conb_1
Xteam_05_76 vssd1 vssd1 vccd1 vccd1 team_05_76/HI gpio_out[1] sky130_fd_sc_hd__conb_1
XANTENNA_input16_A nrst vssd1 vssd1 vccd1 vccd1 sky130_fd_sc_hd__diode_2
XFILLER_31_104 vssd1 vssd1 vccd1 vccd1 sky130_fd_sc_hd__fill_1
XFILLER_31_137 vssd1 vssd1 vccd1 vccd1 sky130_fd_sc_hd__fill_1
X_0501_ _0425_/Y _0472_/A _0514_/A vssd1 vssd1 vccd1 vccd1 _0501_/Y sky130_fd_sc_hd__a21oi_2
X_0432_ _0896_/Q vssd1 vssd1 vccd1 vccd1 _0432_/Y sky130_fd_sc_hd__inv_2
XTAP_TAPCELL_ROW_17_162 vssd1 vccd1 sky130_fd_sc_hd__tapvpwrvgnd_1
XFILLER_22_137 vssd1 vssd1 vccd1 vccd1 sky130_fd_sc_hd__fill_1
XANTENNA_input8_A gpio_in[2] vssd1 vssd1 vccd1 vccd1 sky130_fd_sc_hd__diode_2
XFILLER_26_89 vssd1 vssd1 vccd1 vccd1 sky130_fd_sc_hd__fill_2
XTAP_TAPCELL_ROW_23_187 vssd1 vccd1 sky130_fd_sc_hd__tapvpwrvgnd_1
X_0981_ clkload3/A _0981_/D fanout54/X vssd1 vssd1 vccd1 vccd1 _0981_/Q sky130_fd_sc_hd__dfrtp_2
XFILLER_8_141 vssd1 vssd1 vccd1 vccd1 sky130_fd_sc_hd__fill_1
XFILLER_8_130 vssd1 vssd1 vccd1 vccd1 sky130_fd_sc_hd__fill_1
Xhold152 _0900_/Q vssd1 vssd1 vccd1 vccd1 hold152/X sky130_fd_sc_hd__dlygate4sd3_1
Xhold163 _0985_/Q vssd1 vssd1 vccd1 vccd1 hold163/X sky130_fd_sc_hd__dlygate4sd3_1
Xhold174 _0987_/Q vssd1 vssd1 vccd1 vccd1 hold174/X sky130_fd_sc_hd__dlygate4sd3_1
Xhold185 _0692_/Y vssd1 vssd1 vccd1 vccd1 _0693_/B sky130_fd_sc_hd__dlygate4sd3_1
XANTENNA_fanout66_A fanout74/X vssd1 vssd1 vccd1 vccd1 sky130_fd_sc_hd__diode_2
Xhold196 _0980_/Q vssd1 vssd1 vccd1 vccd1 hold196/X sky130_fd_sc_hd__dlygate4sd3_1
XFILLER_18_218 vssd1 vssd1 vccd1 vccd1 sky130_fd_sc_hd__fill_4
XTAP_TAPCELL_ROW_11_135 vssd1 vccd1 sky130_fd_sc_hd__tapvpwrvgnd_1
XFILLER_5_144 vssd1 vssd1 vccd1 vccd1 sky130_fd_sc_hd__fill_1
X_0964_ _0970_/CLK _0964_/D fanout48/X vssd1 vssd1 vccd1 vccd1 _0964_/Q sky130_fd_sc_hd__dfrtp_2
XTAP_TAPCELL_ROW_34_238 vssd1 vccd1 sky130_fd_sc_hd__tapvpwrvgnd_1
X_0895_ _1020_/CLK _0895_/D fanout73/X vssd1 vssd1 vccd1 vccd1 _0895_/Q sky130_fd_sc_hd__dfrtp_2
XFILLER_23_57 vssd1 vccd1 vssd1 vccd1 sky130_ef_sc_hd__decap_40_12
XFILLER_9_59 vssd1 vssd1 vccd1 vccd1 sky130_fd_sc_hd__fill_1
XFILLER_9_48 vssd1 vssd1 vccd1 vccd1 sky130_fd_sc_hd__fill_8
X_0680_ _0932_/Q _0933_/Q _0678_/Y _0679_/X vssd1 vssd1 vccd1 vccd1 _0906_/D sky130_fd_sc_hd__o211a_2
XTAP_TAPCELL_ROW_0_82 vssd1 vccd1 sky130_fd_sc_hd__tapvpwrvgnd_1
X_0947_ clkload7/A input6/X load_slew64/X vssd1 vssd1 vccd1 vccd1 _0947_/Q sky130_fd_sc_hd__dfrtp_2
XFILLER_20_224 vssd1 vssd1 vccd1 vccd1 sky130_fd_sc_hd__fill_2
X_0878_ _1015_/Q _0880_/C vssd1 vssd1 vccd1 vccd1 _0878_/Y sky130_fd_sc_hd__nand2_2
Xclkload0 clkload0/A vssd1 vssd1 vccd1 vccd1 clkload0/X sky130_fd_sc_hd__clkbuf_4
Xload_slew56 fanout55/X vssd1 vssd1 vccd1 vccd1 load_slew56/X sky130_fd_sc_hd__buf_2
XPHY_EDGE_ROW_28_Left_67 vssd1 vssd1 vccd1 vccd1 sky130_fd_sc_hd__decap_3
X_0801_ hold204/X _0838_/A2 _0792_/X _0800_/X vssd1 vssd1 vccd1 vccd1 _0974_/D sky130_fd_sc_hd__a22o_2
X_0732_ _0952_/Q _0728_/A _0716_/X _0731_/Y vssd1 vssd1 vccd1 vccd1 _0952_/D sky130_fd_sc_hd__o22a_2
X_0663_ _0932_/Q hold210/X _0663_/S vssd1 vssd1 vccd1 vccd1 _0933_/D sky130_fd_sc_hd__mux2_1
X_0594_ _0436_/Y wire32/A _0500_/B _0920_/Q vssd1 vssd1 vccd1 vccd1 _0594_/X sky130_fd_sc_hd__a2bb2o_2
XFILLER_20_58 vssd1 vssd1 vccd1 vccd1 sky130_fd_sc_hd__fill_2
X_1000_ clkload5/A _1000_/D load_slew56/X vssd1 vssd1 vccd1 vccd1 _1000_/Q sky130_fd_sc_hd__dfrtp_2
XFILLER_19_165 vssd1 vssd1 vccd1 vccd1 sky130_fd_sc_hd__fill_2
XFILLER_19_198 vssd1 vssd1 vccd1 vccd1 sky130_fd_sc_hd__fill_4
XANTENNA_clkbuf_0_clk_A clk vssd1 vssd1 vccd1 vccd1 sky130_fd_sc_hd__diode_2
X_0715_ _0942_/Q _0715_/B vssd1 vssd1 vccd1 vccd1 _0715_/Y sky130_fd_sc_hd__nor2_2
XANTENNA_clkbuf_4_9_0_clk_A clkbuf_0_clk/X vssd1 vssd1 vccd1 vccd1 sky130_fd_sc_hd__diode_2
X_0646_ _0928_/Q _0647_/B vssd1 vssd1 vccd1 vccd1 _0649_/B sky130_fd_sc_hd__nand2_2
X_0577_ _0577_/A _0582_/B vssd1 vssd1 vccd1 vccd1 _0907_/D sky130_fd_sc_hd__nor2_2
Xteam_05_99 vssd1 vssd1 vccd1 vccd1 team_05_99/HI gpio_out[25] sky130_fd_sc_hd__conb_1
Xteam_05_88 vssd1 vssd1 vccd1 vccd1 team_05_88/HI gpio_out[13] sky130_fd_sc_hd__conb_1
Xteam_05_77 vssd1 vssd1 vccd1 vccd1 team_05_77/HI gpio_out[2] sky130_fd_sc_hd__conb_1
XFILLER_25_113 vssd1 vccd1 vssd1 vccd1 sky130_ef_sc_hd__decap_40_12
XPHY_EDGE_ROW_19_Right_19 vssd1 vssd1 vccd1 vccd1 sky130_fd_sc_hd__decap_3
X_0500_ _0966_/Q _0500_/B vssd1 vssd1 vccd1 vccd1 _0764_/A sky130_fd_sc_hd__xnor2_2
X_0431_ _0893_/Q vssd1 vssd1 vccd1 vccd1 _0431_/Y sky130_fd_sc_hd__inv_2
XPHY_EDGE_ROW_28_Right_28 vssd1 vssd1 vccd1 vccd1 sky130_fd_sc_hd__decap_3
XPHY_EDGE_ROW_37_Right_37 vssd1 vssd1 vccd1 vccd1 sky130_fd_sc_hd__decap_3
XPHY_EDGE_ROW_15_Left_54 vssd1 vssd1 vccd1 vccd1 sky130_fd_sc_hd__decap_3
XFILLER_7_81 vssd1 vssd1 vccd1 vccd1 sky130_fd_sc_hd__fill_8
X_0629_ _0922_/Q _0631_/C vssd1 vssd1 vccd1 vccd1 _0630_/C sky130_fd_sc_hd__or2_2
XFILLER_13_138 vssd1 vssd1 vccd1 vccd1 sky130_fd_sc_hd__fill_4
XTAP_TAPCELL_ROW_23_188 vssd1 vccd1 sky130_fd_sc_hd__tapvpwrvgnd_1
XTAP_TAPCELL_ROW_8_120 vssd1 vccd1 sky130_fd_sc_hd__tapvpwrvgnd_1
X_0980_ clkload3/A _0980_/D fanout52/X vssd1 vssd1 vccd1 vccd1 _0980_/Q sky130_fd_sc_hd__dfrtp_2
XFILLER_8_186 vssd1 vssd1 vccd1 vccd1 sky130_fd_sc_hd__fill_2
XFILLER_10_108 vssd1 vssd1 vccd1 vccd1 sky130_fd_sc_hd__fill_8
Xhold153 _0734_/X vssd1 vssd1 vccd1 vccd1 _0954_/D sky130_fd_sc_hd__dlygate4sd3_1
Xhold164 _0908_/Q vssd1 vssd1 vccd1 vccd1 hold164/X sky130_fd_sc_hd__dlygate4sd3_1
Xhold175 _0986_/Q vssd1 vssd1 vccd1 vccd1 hold175/X sky130_fd_sc_hd__dlygate4sd3_1
Xhold186 _0893_/Q vssd1 vssd1 vccd1 vccd1 hold186/X sky130_fd_sc_hd__dlygate4sd3_1
Xhold197 _0969_/Q vssd1 vssd1 vccd1 vccd1 hold197/X sky130_fd_sc_hd__dlygate4sd3_1
XPHY_EDGE_ROW_0_Left_39 vssd1 vssd1 vccd1 vccd1 sky130_fd_sc_hd__decap_3
XANTENNA_fanout59_A fanout65/X vssd1 vssd1 vccd1 vccd1 sky130_fd_sc_hd__diode_2
XTAP_TAPCELL_ROW_34_239 vssd1 vccd1 sky130_fd_sc_hd__tapvpwrvgnd_1
X_0894_ _1020_/CLK _0894_/D fanout73/X vssd1 vssd1 vccd1 vccd1 _0894_/Q sky130_fd_sc_hd__dfrtp_2
X_0963_ _0970_/CLK _0963_/D fanout48/X vssd1 vssd1 vccd1 vccd1 _0963_/Q sky130_fd_sc_hd__dfrtp_2
XFILLER_23_69 vssd1 vccd1 vssd1 vccd1 sky130_ef_sc_hd__decap_40_12
XTAP_TAPCELL_ROW_0_83 vssd1 vccd1 sky130_fd_sc_hd__tapvpwrvgnd_1
XFILLER_36_6 vssd1 vssd1 vccd1 vccd1 sky130_fd_sc_hd__fill_1
XFILLER_29_5 vssd1 vssd1 vccd1 vccd1 sky130_fd_sc_hd__fill_1
X_0946_ clkload7/A input5/X load_slew64/X vssd1 vssd1 vccd1 vccd1 _0946_/Q sky130_fd_sc_hd__dfrtp_2
X_0877_ _0879_/B _0877_/B vssd1 vssd1 vccd1 vccd1 _1002_/D sky130_fd_sc_hd__nor2_2
XTAP_TAPCELL_ROW_30_220 vssd1 vccd1 sky130_fd_sc_hd__tapvpwrvgnd_1
Xclkload1 clkload1/A vssd1 vssd1 vccd1 vccd1 clkload1/X sky130_fd_sc_hd__clkbuf_4
XPHY_EDGE_ROW_3_Left_42 vssd1 vssd1 vccd1 vccd1 sky130_fd_sc_hd__decap_3
X_0800_ _0973_/Q _0823_/B1 _0799_/Y _0741_/A vssd1 vssd1 vccd1 vccd1 _0800_/X sky130_fd_sc_hd__a22o_2
X_0731_ _0702_/X _0730_/X _0725_/Y _0712_/C vssd1 vssd1 vccd1 vccd1 _0731_/Y sky130_fd_sc_hd__o211ai_2
X_0662_ _0932_/Q _0664_/B _0662_/S vssd1 vssd1 vccd1 vccd1 _0932_/D sky130_fd_sc_hd__mux2_1
X_0593_ _0590_/X _0591_/X _0592_/X vssd1 vssd1 vccd1 vccd1 _0593_/X sky130_fd_sc_hd__o21a_2
XANTENNA_clkbuf_4_5_0_clk_A clkbuf_0_clk/X vssd1 vssd1 vccd1 vccd1 sky130_fd_sc_hd__diode_2
X_0929_ clkload2/A _0929_/D fanout55/X vssd1 vssd1 vccd1 vccd1 _0929_/Q sky130_fd_sc_hd__dfrtp_2
XFILLER_29_57 vssd1 vssd1 vccd1 vccd1 sky130_fd_sc_hd__fill_4
XFILLER_19_177 vssd1 vssd1 vccd1 vccd1 sky130_fd_sc_hd__fill_4
XFILLER_19_111 vssd1 vssd1 vccd1 vccd1 sky130_fd_sc_hd__fill_1
X_0714_ _0945_/Q _0944_/Q _0723_/B _0943_/Q vssd1 vssd1 vccd1 vccd1 _0715_/B sky130_fd_sc_hd__or4b_2
X_0645_ _0647_/B _0645_/B _0650_/A vssd1 vssd1 vccd1 vccd1 _0927_/D sky130_fd_sc_hd__and3b_2
X_0576_ _0576_/A _0582_/B vssd1 vssd1 vccd1 vccd1 _0587_/A sky130_fd_sc_hd__nor2_2
Xteam_05_89 vssd1 vssd1 vccd1 vccd1 team_05_89/HI gpio_out[15] sky130_fd_sc_hd__conb_1
Xteam_05_78 vssd1 vssd1 vccd1 vccd1 team_05_78/HI gpio_out[3] sky130_fd_sc_hd__conb_1
XFILLER_25_158 vssd1 vssd1 vccd1 vccd1 sky130_fd_sc_hd__fill_1
XFILLER_31_47 vssd1 vssd1 vccd1 vccd1 sky130_fd_sc_hd__fill_1
XFILLER_16_169 vssd1 vssd1 vccd1 vccd1 sky130_fd_sc_hd__fill_2
X_0430_ _0894_/Q vssd1 vssd1 vccd1 vccd1 _0430_/Y sky130_fd_sc_hd__inv_2
X_0628_ _0922_/Q _0631_/C vssd1 vssd1 vccd1 vccd1 _0630_/B sky130_fd_sc_hd__nand2_2
X_0559_ _0958_/Q _0432_/Y _0957_/Q _0691_/A _0558_/X vssd1 vssd1 vccd1 vccd1 _0559_/X
+ sky130_fd_sc_hd__o221a_2
XFILLER_26_25 vssd1 vssd1 vccd1 vccd1 sky130_fd_sc_hd__fill_2
XTAP_TAPCELL_ROW_23_189 vssd1 vccd1 sky130_fd_sc_hd__tapvpwrvgnd_1
XTAP_TAPCELL_ROW_8_121 vssd1 vccd1 sky130_fd_sc_hd__tapvpwrvgnd_1
XANTENNA_clkbuf_4_13_0_clk_A clkbuf_0_clk/X vssd1 vssd1 vccd1 vccd1 sky130_fd_sc_hd__diode_2
XTAP_TAPCELL_ROW_14_145 vssd1 vccd1 sky130_fd_sc_hd__tapvpwrvgnd_1
XPHY_EDGE_ROW_32_Left_71 vssd1 vssd1 vccd1 vccd1 sky130_fd_sc_hd__decap_3
Xhold154 _0903_/Q vssd1 vssd1 vccd1 vccd1 hold154/X sky130_fd_sc_hd__dlygate4sd3_1
Xhold165 _0579_/Y vssd1 vssd1 vccd1 vccd1 _0908_/D sky130_fd_sc_hd__dlygate4sd3_1
Xhold176 _0997_/Q vssd1 vssd1 vccd1 vccd1 hold176/X sky130_fd_sc_hd__dlygate4sd3_1
Xhold187 _1001_/Q vssd1 vssd1 vccd1 vccd1 _0874_/A sky130_fd_sc_hd__dlygate4sd3_1
Xhold198 _0973_/Q vssd1 vssd1 vccd1 vccd1 hold198/X sky130_fd_sc_hd__dlygate4sd3_1
XFILLER_37_57 vssd1 vssd1 vccd1 vccd1 sky130_fd_sc_hd__fill_4
XFILLER_5_179 vssd1 vssd1 vccd1 vccd1 sky130_fd_sc_hd__fill_2
XFILLER_5_113 vssd1 vssd1 vccd1 vccd1 sky130_fd_sc_hd__fill_2
XFILLER_5_102 vssd1 vssd1 vccd1 vccd1 sky130_fd_sc_hd__fill_8
X_0893_ _1020_/CLK _0893_/D load_slew72/X vssd1 vssd1 vccd1 vccd1 _0893_/Q sky130_fd_sc_hd__dfrtp_2
X_0962_ _0970_/CLK _0962_/D fanout48/X vssd1 vssd1 vccd1 vccd1 _0962_/Q sky130_fd_sc_hd__dfrtp_2
XFILLER_14_212 vssd1 vssd1 vccd1 vccd1 sky130_fd_sc_hd__fill_4
Xfanout71 fanout73/X vssd1 vssd1 vccd1 vccd1 fanout71/X sky130_fd_sc_hd__clkdlybuf4s25_1
XTAP_TAPCELL_ROW_0_84 vssd1 vccd1 sky130_fd_sc_hd__tapvpwrvgnd_1
XTAP_TAPCELL_ROW_30_221 vssd1 vccd1 sky130_fd_sc_hd__tapvpwrvgnd_1
X_0945_ clkload9/A input4/X load_slew64/X vssd1 vssd1 vccd1 vccd1 _0945_/Q sky130_fd_sc_hd__dfrtp_2
X_0876_ hold213/X _1015_/Q hold180/X vssd1 vssd1 vccd1 vccd1 _0877_/B sky130_fd_sc_hd__a21oi_2
XANTENNA_clkbuf_4_1_0_clk_A clkbuf_0_clk/X vssd1 vssd1 vccd1 vccd1 sky130_fd_sc_hd__diode_2
XFILLER_11_215 vssd1 vssd1 vccd1 vccd1 sky130_fd_sc_hd__fill_2
Xclkload2 clkload2/A vssd1 vssd1 vccd1 vccd1 clkload2/X sky130_fd_sc_hd__clkbuf_4
XFILLER_7_208 vssd1 vssd1 vccd1 vccd1 sky130_fd_sc_hd__fill_1
XANTENNA_fanout74_X fanout74/X vssd1 vssd1 vccd1 vccd1 sky130_fd_sc_hd__diode_2
X_0730_ _0939_/Q _0938_/Q _0940_/Q _0941_/Q vssd1 vssd1 vccd1 vccd1 _0730_/X sky130_fd_sc_hd__or4b_2
X_0661_ _0657_/Y _0660_/Y _0663_/S vssd1 vssd1 vccd1 vccd1 _0931_/D sky130_fd_sc_hd__o21a_2
X_0592_ _0436_/Y wire32/A _0470_/B _0918_/Q vssd1 vssd1 vccd1 vccd1 _0592_/X sky130_fd_sc_hd__o2bb2a_2
XFILLER_27_3 vssd1 vssd1 vccd1 vccd1 sky130_fd_sc_hd__fill_2
X_0928_ clkload2/A _0928_/D fanout55/X vssd1 vssd1 vccd1 vccd1 _0928_/Q sky130_fd_sc_hd__dfrtp_2
X_0859_ hold170/X _0842_/C _0858_/X vssd1 vssd1 vccd1 vccd1 _0993_/D sky130_fd_sc_hd__o21a_2
XFILLER_19_167 vssd1 vssd1 vccd1 vccd1 sky130_fd_sc_hd__fill_1
X_0713_ _0425_/Y _0948_/D _0712_/X vssd1 vssd1 vccd1 vccd1 _0949_/D sky130_fd_sc_hd__a21oi_2
X_0644_ _0927_/Q _0644_/B vssd1 vssd1 vccd1 vccd1 _0645_/B sky130_fd_sc_hd__or2_2
Xteam_05_79 vssd1 vssd1 vccd1 vccd1 team_05_79/HI gpio_out[4] sky130_fd_sc_hd__conb_1
X_0575_ _0574_/A _0574_/B _0839_/B vssd1 vssd1 vccd1 vccd1 _1014_/D sky130_fd_sc_hd__o21ai_2
XPHY_EDGE_ROW_1_Right_1 vssd1 vssd1 vccd1 vccd1 sky130_fd_sc_hd__decap_3
X_0627_ _0631_/C _0627_/B _0636_/C vssd1 vssd1 vccd1 vccd1 _0921_/D sky130_fd_sc_hd__and3b_2
X_0558_ _0956_/Q _0430_/Y _0957_/Q _0691_/A _0557_/X vssd1 vssd1 vccd1 vccd1 _0558_/X
+ sky130_fd_sc_hd__a221o_2
X_0489_ _0514_/A _0519_/A _0476_/Y _0425_/Y vssd1 vssd1 vccd1 vccd1 _0490_/B sky130_fd_sc_hd__o2bb2a_2
XFILLER_21_140 vssd1 vssd1 vccd1 vccd1 sky130_fd_sc_hd__fill_4
XTAP_TAPCELL_ROW_8_122 vssd1 vccd1 sky130_fd_sc_hd__tapvpwrvgnd_1
XANTENNA_input14_A gpio_in[8] vssd1 vssd1 vccd1 vccd1 sky130_fd_sc_hd__diode_2
XTAP_TAPCELL_ROW_14_146 vssd1 vccd1 sky130_fd_sc_hd__tapvpwrvgnd_1
XTAP_TAPCELL_ROW_37_249 vssd1 vccd1 sky130_fd_sc_hd__tapvpwrvgnd_1
XFILLER_35_254 vssd1 vssd1 vccd1 vccd1 sky130_fd_sc_hd__fill_1
Xhold144 _0950_/Q vssd1 vssd1 vccd1 vccd1 hold144/X sky130_fd_sc_hd__dlygate4sd3_1
XANTENNA_input6_A gpio_in[13] vssd1 vssd1 vccd1 vccd1 sky130_fd_sc_hd__diode_2
Xhold155 _0737_/X vssd1 vssd1 vccd1 vccd1 _0957_/D sky130_fd_sc_hd__dlygate4sd3_1
Xhold166 _0998_/Q vssd1 vssd1 vccd1 vccd1 hold166/X sky130_fd_sc_hd__dlygate4sd3_1
Xhold177 _0988_/Q vssd1 vssd1 vccd1 vccd1 hold177/X sky130_fd_sc_hd__dlygate4sd3_1
Xhold188 _0960_/Q vssd1 vssd1 vccd1 vccd1 hold188/X sky130_fd_sc_hd__dlygate4sd3_1
Xhold199 _0911_/Q vssd1 vssd1 vccd1 vccd1 hold199/X sky130_fd_sc_hd__dlygate4sd3_1
XFILLER_37_36 vssd1 vssd1 vccd1 vccd1 sky130_fd_sc_hd__fill_4
X_0961_ clkload2/A _0961_/D load_slew56/X vssd1 vssd1 vccd1 vccd1 _0961_/Q sky130_fd_sc_hd__dfrtp_2
XFILLER_17_254 vssd1 vssd1 vccd1 vccd1 sky130_fd_sc_hd__fill_1
X_0892_ _1020_/CLK _0892_/D load_slew72/X vssd1 vssd1 vccd1 vccd1 _0892_/Q sky130_fd_sc_hd__dfrtp_2
Xfanout50 fanout58/X vssd1 vssd1 vccd1 vccd1 fanout50/X sky130_fd_sc_hd__clkdlybuf4s25_1
Xfanout61 fanout63/X vssd1 vssd1 vccd1 vccd1 fanout61/X sky130_fd_sc_hd__clkdlybuf4s25_1
XTAP_TAPCELL_ROW_0_85 vssd1 vccd1 sky130_fd_sc_hd__tapvpwrvgnd_1
X_1091_ _1091_/A vssd1 vssd1 vccd1 vccd1 _1091_/X sky130_fd_sc_hd__buf_2
X_0944_ clkload7/A input3/X load_slew64/X vssd1 vssd1 vccd1 vccd1 _0944_/Q sky130_fd_sc_hd__dfrtp_2
X_0875_ _1001_/Q _1002_/Q _1015_/Q vssd1 vssd1 vccd1 vccd1 _0879_/B sky130_fd_sc_hd__and3_2
XFILLER_18_27 vssd1 vssd1 vccd1 vccd1 sky130_fd_sc_hd__fill_1
Xclkload3 clkload3/A vssd1 vssd1 vccd1 vccd1 clkload3/X sky130_fd_sc_hd__clkbuf_4
X_0660_ _0932_/Q _0933_/Q _0948_/Q vssd1 vssd1 vccd1 vccd1 _0660_/Y sky130_fd_sc_hd__o21ai_2
X_0591_ _0918_/Q _0470_/B _0485_/B _0917_/Q vssd1 vssd1 vccd1 vccd1 _0591_/X sky130_fd_sc_hd__a22o_2
X_0927_ clkload1/A _0927_/D fanout55/X vssd1 vssd1 vccd1 vccd1 _0927_/Q sky130_fd_sc_hd__dfrtp_2
X_0858_ _0860_/A1 _0992_/Q _0862_/B1 _0923_/Q _0864_/C1 vssd1 vssd1 vccd1 vccd1 _0858_/X
+ sky130_fd_sc_hd__a221o_2
X_0789_ _0790_/B _0790_/C _0790_/A vssd1 vssd1 vccd1 vccd1 _0789_/Y sky130_fd_sc_hd__o21ai_2
XFILLER_10_83 vssd1 vssd1 vccd1 vccd1 sky130_fd_sc_hd__fill_1
XFILLER_19_113 vssd1 vssd1 vccd1 vccd1 sky130_fd_sc_hd__fill_1
XFILLER_27_190 vssd1 vssd1 vccd1 vccd1 sky130_fd_sc_hd__fill_2
X_0712_ _0712_/A _0712_/B _0712_/C _0712_/D vssd1 vssd1 vccd1 vccd1 _0712_/X sky130_fd_sc_hd__and4_2
X_0643_ _0927_/Q _0644_/B vssd1 vssd1 vccd1 vccd1 _0647_/B sky130_fd_sc_hd__and2_2
X_0574_ _0574_/A _0574_/B vssd1 vssd1 vccd1 vccd1 wire31/A sky130_fd_sc_hd__nor2_2
XFILLER_33_182 vssd1 vssd1 vccd1 vccd1 sky130_fd_sc_hd__fill_1
XTAP_TAPCELL_ROW_26_199 vssd1 vccd1 sky130_fd_sc_hd__tapvpwrvgnd_1
Xclkbuf_0_clk clk vssd1 vssd1 vccd1 vccd1 clkbuf_0_clk/X sky130_fd_sc_hd__clkbuf_16
XFILLER_7_40 vssd1 vssd1 vccd1 vccd1 sky130_fd_sc_hd__fill_1
XFILLER_30_141 vssd1 vssd1 vccd1 vccd1 sky130_fd_sc_hd__fill_1
X_0626_ _0921_/Q _0626_/B vssd1 vssd1 vccd1 vccd1 _0627_/B sky130_fd_sc_hd__or2_2
X_0557_ _0956_/Q _0430_/Y _0955_/Q _0431_/Y _0556_/X vssd1 vssd1 vccd1 vccd1 _0557_/X
+ sky130_fd_sc_hd__o221a_2
XPHY_EDGE_ROW_15_Right_15 vssd1 vssd1 vccd1 vccd1 sky130_fd_sc_hd__decap_3
X_0488_ _0755_/A _0487_/A _0487_/B _0469_/Y vssd1 vssd1 vccd1 vccd1 _0760_/A sky130_fd_sc_hd__a31oi_2
XPHY_EDGE_ROW_24_Right_24 vssd1 vssd1 vccd1 vccd1 sky130_fd_sc_hd__decap_3
XFILLER_26_49 vssd1 vssd1 vccd1 vccd1 sky130_fd_sc_hd__fill_8
XFILLER_26_27 vssd1 vssd1 vccd1 vccd1 sky130_fd_sc_hd__fill_1
XFILLER_13_108 vssd1 vssd1 vccd1 vccd1 sky130_fd_sc_hd__fill_4
XPHY_EDGE_ROW_33_Right_33 vssd1 vssd1 vccd1 vccd1 sky130_fd_sc_hd__decap_3
XTAP_TAPCELL_ROW_14_147 vssd1 vccd1 sky130_fd_sc_hd__tapvpwrvgnd_1
XTAP_TAPCELL_ROW_3_96 vssd1 vccd1 sky130_fd_sc_hd__tapvpwrvgnd_1
XPHY_EDGE_ROW_19_Left_58 vssd1 vssd1 vccd1 vccd1 sky130_fd_sc_hd__decap_3
Xhold145 _0901_/Q vssd1 vssd1 vccd1 vccd1 hold145/X sky130_fd_sc_hd__dlygate4sd3_1
Xhold156 _0899_/Q vssd1 vssd1 vccd1 vccd1 hold156/X sky130_fd_sc_hd__dlygate4sd3_1
Xhold167 _0915_/Q vssd1 vssd1 vccd1 vccd1 _0609_/A sky130_fd_sc_hd__dlygate4sd3_1
Xhold178 _0991_/Q vssd1 vssd1 vccd1 vccd1 hold178/X sky130_fd_sc_hd__dlygate4sd3_1
Xhold189 _0909_/Q vssd1 vssd1 vccd1 vccd1 hold189/X sky130_fd_sc_hd__dlygate4sd3_1
X_0609_ _0609_/A _0636_/C vssd1 vssd1 vccd1 vccd1 _0915_/D sky130_fd_sc_hd__nand2_2
XFILLER_17_211 vssd1 vssd1 vccd1 vccd1 sky130_fd_sc_hd__fill_1
XFILLER_27_81 vssd1 vssd1 vccd1 vccd1 sky130_fd_sc_hd__fill_4
XFILLER_17_222 vssd1 vssd1 vccd1 vccd1 sky130_fd_sc_hd__fill_2
XANTENNA__0483__A2 _0749_/B vssd1 vssd1 vccd1 vccd1 sky130_fd_sc_hd__diode_2
X_0960_ _0960_/CLK _0960_/D fanout73/X vssd1 vssd1 vccd1 vccd1 _0960_/Q sky130_fd_sc_hd__dfrtp_2
X_0891_ _0741_/B _1012_/Q _0839_/X _0891_/B1 _1013_/Q vssd1 vssd1 vccd1 vccd1 _1013_/D
+ sky130_fd_sc_hd__a32o_2
XTAP_TAPCELL_ROW_33_231 vssd1 vccd1 sky130_fd_sc_hd__tapvpwrvgnd_1
XFILLER_23_28 vssd1 vssd1 vccd1 vccd1 sky130_fd_sc_hd__fill_4
XFILLER_3_9 vssd1 vssd1 vccd1 vccd1 sky130_fd_sc_hd__fill_2
XANTENNA_fanout57_A fanout58/X vssd1 vssd1 vccd1 vccd1 sky130_fd_sc_hd__diode_2
Xfanout40 _0856_/A1 vssd1 vssd1 vccd1 vccd1 _0787_/B2 sky130_fd_sc_hd__clkdlybuf4s25_1
Xfanout73 fanout74/X vssd1 vssd1 vccd1 vccd1 fanout73/X sky130_fd_sc_hd__clkdlybuf4s25_1
XTAP_TAPCELL_ROW_0_86 vssd1 vccd1 sky130_fd_sc_hd__tapvpwrvgnd_1
XFILLER_38_80 vssd1 vssd1 vccd1 vccd1 sky130_fd_sc_hd__fill_4
X_0943_ clkload9/A _0943_/D load_slew64/X vssd1 vssd1 vccd1 vccd1 _0943_/Q sky130_fd_sc_hd__dfrtp_2
Xclkload10 _1019_/CLK vssd1 vssd1 vccd1 vccd1 clkload10/X sky130_fd_sc_hd__clkbuf_4
X_0874_ _0874_/A _1015_/Q vssd1 vssd1 vccd1 vccd1 _1001_/D sky130_fd_sc_hd__xor2_2
Xclkload4 clkload4/A vssd1 vssd1 vccd1 vccd1 clkload4/X sky130_fd_sc_hd__clkbuf_4
Xload_slew49 fanout48/X vssd1 vssd1 vccd1 vccd1 load_slew49/X sky130_fd_sc_hd__buf_2
X_0590_ _0917_/Q _0485_/B _0482_/B _0916_/Q _0589_/X vssd1 vssd1 vccd1 vccd1 _0590_/X
+ sky130_fd_sc_hd__o221a_2
XFILLER_27_5 vssd1 vssd1 vccd1 vccd1 sky130_fd_sc_hd__fill_1
X_0926_ clkload1/A _0926_/D load_slew51/X vssd1 vssd1 vccd1 vccd1 _0926_/Q sky130_fd_sc_hd__dfrtp_2
X_0857_ hold179/X _0842_/C _0856_/X vssd1 vssd1 vccd1 vccd1 _0992_/D sky130_fd_sc_hd__o21a_2
X_0788_ hold211/X _0787_/X _0788_/S vssd1 vssd1 vccd1 vccd1 _0971_/D sky130_fd_sc_hd__mux2_1
XPHY_EDGE_ROW_7_Left_46 vssd1 vssd1 vccd1 vccd1 sky130_fd_sc_hd__decap_3
XFILLER_3_246 vssd1 vssd1 vccd1 vccd1 sky130_fd_sc_hd__fill_1
X_0711_ _0709_/X _0710_/X _0708_/X vssd1 vssd1 vccd1 vccd1 _0712_/D sky130_fd_sc_hd__a21o_2
X_0642_ _0644_/B _0642_/B _0650_/A vssd1 vssd1 vccd1 vccd1 _0926_/D sky130_fd_sc_hd__and3b_2
X_0573_ _0582_/B _0570_/B _1014_/Q vssd1 vssd1 vccd1 vccd1 _0839_/B sky130_fd_sc_hd__o21ai_2
XFILLER_32_3 vssd1 vssd1 vccd1 vccd1 sky130_fd_sc_hd__fill_1
X_0909_ clkload4/A _0909_/D load_slew53/X vssd1 vssd1 vccd1 vccd1 _0909_/Q sky130_fd_sc_hd__dfrtp_2
Xoutput17 _1091_/X vssd1 vssd1 vccd1 vccd1 gpio_out[14] sky130_fd_sc_hd__clkdlybuf4s25_1
XFILLER_24_194 vssd1 vssd1 vccd1 vccd1 sky130_fd_sc_hd__fill_2
Xteam_05_140 vssd1 vssd1 vccd1 vccd1 gpio_oeb[30] team_05_140/LO sky130_fd_sc_hd__conb_1
X_0625_ _0921_/Q _0626_/B vssd1 vssd1 vccd1 vccd1 _0631_/C sky130_fd_sc_hd__and2_2
X_0556_ _0954_/Q _0429_/Y _0955_/Q _0431_/Y _0555_/X vssd1 vssd1 vccd1 vccd1 _0556_/X
+ sky130_fd_sc_hd__a221o_2
X_0487_ _0487_/A _0487_/B vssd1 vssd1 vccd1 vccd1 _0755_/C sky130_fd_sc_hd__nand2_2
XFILLER_38_253 vssd1 vssd1 vccd1 vccd1 sky130_fd_sc_hd__fill_2
XFILLER_29_220 vssd1 vssd1 vccd1 vccd1 sky130_fd_sc_hd__fill_1
XFILLER_16_83 vssd1 vssd1 vccd1 vccd1 sky130_fd_sc_hd__fill_1
XTAP_TAPCELL_ROW_14_148 vssd1 vccd1 sky130_fd_sc_hd__tapvpwrvgnd_1
XTAP_TAPCELL_ROW_3_97 vssd1 vccd1 sky130_fd_sc_hd__tapvpwrvgnd_1
XTAP_TAPCELL_ROW_22_181 vssd1 vccd1 sky130_fd_sc_hd__tapvpwrvgnd_1
XFILLER_32_82 vssd1 vssd1 vccd1 vccd1 sky130_fd_sc_hd__fill_2
Xhold146 _0735_/X vssd1 vssd1 vccd1 vccd1 _0955_/D sky130_fd_sc_hd__dlygate4sd3_1
Xhold157 _0733_/X vssd1 vssd1 vccd1 vccd1 _0953_/D sky130_fd_sc_hd__dlygate4sd3_1
Xhold168 _0996_/Q vssd1 vssd1 vccd1 vccd1 hold168/X sky130_fd_sc_hd__dlygate4sd3_1
Xhold179 _0992_/Q vssd1 vssd1 vccd1 vccd1 hold179/X sky130_fd_sc_hd__dlygate4sd3_1
X_0608_ _0602_/X _0606_/X _0607_/X vssd1 vssd1 vccd1 vccd1 _0608_/Y sky130_fd_sc_hd__a21oi_2
X_0539_ _0977_/Q _0825_/B _0539_/C vssd1 vssd1 vccd1 vccd1 _0815_/B sky130_fd_sc_hd__or3_2
XTAP_TAPCELL_ROW_5_105 vssd1 vccd1 sky130_fd_sc_hd__tapvpwrvgnd_1
XFILLER_5_138 vssd1 vssd1 vccd1 vccd1 sky130_fd_sc_hd__fill_4
XPHY_EDGE_ROW_36_Left_75 vssd1 vssd1 vccd1 vccd1 sky130_fd_sc_hd__decap_3
XPHY_EDGE_ROW_20_Left_59 vssd1 vssd1 vccd1 vccd1 sky130_fd_sc_hd__decap_3
XFILLER_27_71 vssd1 vssd1 vccd1 vccd1 sky130_fd_sc_hd__fill_1
X_0890_ _0890_/A1 _1011_/Q _0839_/X _0890_/B1 hold203/X vssd1 vssd1 vccd1 vccd1 _1012_/D
+ sky130_fd_sc_hd__a32o_2
XTAP_TAPCELL_ROW_33_232 vssd1 vccd1 sky130_fd_sc_hd__tapvpwrvgnd_1
Xfanout30 _0797_/S vssd1 vssd1 vccd1 vccd1 _0788_/S sky130_fd_sc_hd__clkdlybuf4s25_1
Xfanout41 _0860_/A1 vssd1 vssd1 vccd1 vccd1 _0856_/A1 sky130_fd_sc_hd__clkdlybuf4s25_1
Xfanout52 fanout54/X vssd1 vssd1 vccd1 vccd1 fanout52/X sky130_fd_sc_hd__clkdlybuf4s25_1
Xfanout63 fanout65/X vssd1 vssd1 vccd1 vccd1 fanout63/X sky130_fd_sc_hd__clkdlybuf4s25_1
Xfanout74 _0546_/X vssd1 vssd1 vccd1 vccd1 fanout74/X sky130_fd_sc_hd__clkdlybuf4s25_1
XFILLER_1_163 vssd1 vssd1 vccd1 vccd1 sky130_fd_sc_hd__fill_4
X_0942_ clkload7/A _0942_/D fanout63/X vssd1 vssd1 vccd1 vccd1 _0942_/Q sky130_fd_sc_hd__dfrtp_2
Xclkload11 _1011_/CLK vssd1 vssd1 vccd1 vccd1 clkload11/X sky130_fd_sc_hd__clkbuf_4
X_0873_ hold183/X _0884_/B1 _0872_/X vssd1 vssd1 vccd1 vccd1 _1000_/D sky130_fd_sc_hd__o21a_2
XFILLER_18_29 vssd1 vssd1 vccd1 vccd1 sky130_fd_sc_hd__fill_4
Xclkload5 clkload5/A vssd1 vssd1 vccd1 vccd1 clkload5/X sky130_fd_sc_hd__clkbuf_4
XFILLER_34_17 vssd1 vssd1 vccd1 vccd1 sky130_fd_sc_hd__fill_2
XANTENNA__0604__B1 _0455_/B vssd1 vssd1 vccd1 vccd1 sky130_fd_sc_hd__diode_2
XFILLER_24_50 vssd1 vccd1 vssd1 vccd1 sky130_ef_sc_hd__decap_40_12
XPHY_EDGE_ROW_23_Left_62 vssd1 vssd1 vccd1 vccd1 sky130_fd_sc_hd__decap_3
X_0925_ clkload0/A _0925_/D load_slew51/X vssd1 vssd1 vccd1 vccd1 _0925_/Q sky130_fd_sc_hd__dfrtp_2
X_0856_ _0856_/A1 _0991_/Q _0862_/B1 _0922_/Q _0864_/C1 vssd1 vssd1 vccd1 vccd1 _0856_/X
+ sky130_fd_sc_hd__a221o_2
X_0787_ _0790_/C _0786_/Y _0970_/Q _0787_/B2 vssd1 vssd1 vccd1 vccd1 _0787_/X sky130_fd_sc_hd__a2bb2o_2
XFILLER_10_85 vssd1 vssd1 vccd1 vccd1 sky130_fd_sc_hd__fill_4
XFILLER_19_50 vssd1 vssd1 vccd1 vccd1 sky130_fd_sc_hd__fill_1
X_0710_ _0935_/Q _0937_/Q _0936_/Q _0934_/Q vssd1 vssd1 vccd1 vccd1 _0710_/X sky130_fd_sc_hd__or4b_2
X_0641_ _0925_/Q _0924_/Q _0635_/B _0926_/Q vssd1 vssd1 vccd1 vccd1 _0642_/B sky130_fd_sc_hd__a31o_2
X_0572_ hold147/X _0544_/Y _0741_/A vssd1 vssd1 vccd1 vccd1 _1015_/D sky130_fd_sc_hd__a21o_2
XFILLER_25_3 vssd1 vssd1 vccd1 vccd1 sky130_fd_sc_hd__fill_8
XFILLER_25_107 vssd1 vssd1 vccd1 vccd1 sky130_fd_sc_hd__fill_4
X_0908_ clkload4/A _0908_/D load_slew53/X vssd1 vssd1 vccd1 vccd1 _0908_/Q sky130_fd_sc_hd__dfrtp_2
X_0839_ _0745_/A _0839_/B vssd1 vssd1 vccd1 vccd1 _0839_/X sky130_fd_sc_hd__and2b_2
XFILLER_16_118 vssd1 vssd1 vccd1 vccd1 sky130_fd_sc_hd__fill_1
Xteam_05_141 vssd1 vssd1 vccd1 vccd1 gpio_oeb[31] team_05_141/LO sky130_fd_sc_hd__conb_1
Xteam_05_130 vssd1 vssd1 vccd1 vccd1 gpio_oeb[20] team_05_130/LO sky130_fd_sc_hd__conb_1
XFILLER_15_173 vssd1 vssd1 vccd1 vccd1 sky130_fd_sc_hd__fill_2
XFILLER_30_176 vssd1 vssd1 vccd1 vccd1 sky130_fd_sc_hd__fill_2
XFILLER_30_154 vssd1 vssd1 vccd1 vccd1 sky130_fd_sc_hd__fill_1
X_0624_ _0626_/B _0624_/B _0636_/C vssd1 vssd1 vccd1 vccd1 _0920_/D sky130_fd_sc_hd__and3b_2
X_0555_ _0953_/Q _0428_/Y _0954_/Q _0429_/Y vssd1 vssd1 vccd1 vccd1 _0555_/X sky130_fd_sc_hd__o22a_2
X_0486_ _0752_/A _0752_/B _0752_/C vssd1 vssd1 vccd1 vccd1 _0487_/B sky130_fd_sc_hd__o21ai_2
XPHY_EDGE_ROW_5_Right_5 vssd1 vssd1 vccd1 vccd1 sky130_fd_sc_hd__decap_3
XFILLER_26_29 vssd1 vssd1 vccd1 vccd1 sky130_fd_sc_hd__fill_2
XFILLER_29_254 vssd1 vssd1 vccd1 vccd1 sky130_fd_sc_hd__fill_1
XFILLER_12_143 vssd1 vssd1 vccd1 vccd1 sky130_fd_sc_hd__fill_2
XTAP_TAPCELL_ROW_14_149 vssd1 vccd1 sky130_fd_sc_hd__tapvpwrvgnd_1
XTAP_TAPCELL_ROW_3_98 vssd1 vccd1 sky130_fd_sc_hd__tapvpwrvgnd_1
XTAP_TAPCELL_ROW_22_182 vssd1 vccd1 sky130_fd_sc_hd__tapvpwrvgnd_1
Xhold147 _1016_/Q vssd1 vssd1 vccd1 vccd1 hold147/X sky130_fd_sc_hd__dlygate4sd3_1
Xhold158 _0906_/Q vssd1 vssd1 vccd1 vccd1 hold158/X sky130_fd_sc_hd__dlygate4sd3_1
Xhold169 _0989_/Q vssd1 vssd1 vccd1 vccd1 hold169/X sky130_fd_sc_hd__dlygate4sd3_1
X_0607_ _0929_/Q _0455_/B _0603_/X _0605_/B _0930_/Q vssd1 vssd1 vccd1 vccd1 _0607_/X
+ sky130_fd_sc_hd__a221o_2
X_0538_ _0825_/B _0538_/B _0538_/C vssd1 vssd1 vccd1 vccd1 _0538_/Y sky130_fd_sc_hd__nand3b_2
XTAP_TAPCELL_ROW_5_106 vssd1 vccd1 sky130_fd_sc_hd__tapvpwrvgnd_1
X_0469_ _0964_/Q _0470_/B vssd1 vssd1 vccd1 vccd1 _0469_/Y sky130_fd_sc_hd__nor2_2
XTAP_TAPCELL_ROW_28_208 vssd1 vccd1 sky130_fd_sc_hd__tapvpwrvgnd_1
XANTENNA_input12_A gpio_in[6] vssd1 vssd1 vccd1 vccd1 sky130_fd_sc_hd__diode_2
XFILLER_27_61 vssd1 vssd1 vccd1 vccd1 sky130_fd_sc_hd__fill_2
XTAP_TAPCELL_ROW_10_130 vssd1 vccd1 sky130_fd_sc_hd__tapvpwrvgnd_1
XFILLER_4_54 vssd1 vccd1 vssd1 vccd1 sky130_ef_sc_hd__decap_40_12
XFILLER_4_21 vssd1 vssd1 vccd1 vccd1 sky130_fd_sc_hd__fill_4
XFILLER_4_172 vssd1 vssd1 vccd1 vccd1 sky130_fd_sc_hd__fill_2
XTAP_TAPCELL_ROW_33_233 vssd1 vccd1 sky130_fd_sc_hd__tapvpwrvgnd_1
XANTENNA_input4_A gpio_in[11] vssd1 vssd1 vccd1 vccd1 sky130_fd_sc_hd__diode_2
XFILLER_14_216 vssd1 vssd1 vccd1 vccd1 sky130_fd_sc_hd__fill_1
XFILLER_14_249 vssd1 vssd1 vccd1 vccd1 sky130_fd_sc_hd__fill_2
Xfanout42 _0823_/B1 vssd1 vssd1 vccd1 vccd1 _1016_/D sky130_fd_sc_hd__clkdlybuf4s25_1
XFILLER_13_96 vssd1 vccd1 vssd1 vccd1 sky130_ef_sc_hd__decap_40_12
X_0941_ clkload9/A _0941_/D load_slew64/X vssd1 vssd1 vccd1 vccd1 _0941_/Q sky130_fd_sc_hd__dfrtp_2
Xclkload12 _1003_/CLK vssd1 vssd1 vccd1 vccd1 clkload12/X sky130_fd_sc_hd__clkbuf_4
X_0872_ _0741_/B _0999_/Q _0842_/B _0930_/Q _0890_/B1 vssd1 vssd1 vccd1 vccd1 _0872_/X
+ sky130_fd_sc_hd__a221o_2
XANTENNA__0852__A1 _0856_/A1 vssd1 vssd1 vccd1 vccd1 sky130_fd_sc_hd__diode_2
Xclkload6 clkload6/A vssd1 vssd1 vccd1 vccd1 clkload6/X sky130_fd_sc_hd__clkbuf_4
XFILLER_6_223 vssd1 vssd1 vccd1 vccd1 sky130_fd_sc_hd__fill_1
XFILLER_24_62 vssd1 vssd1 vccd1 vccd1 sky130_fd_sc_hd__fill_1
XFILLER_1_77 vssd1 vssd1 vccd1 vccd1 sky130_fd_sc_hd__fill_1
X_0924_ clkload0/A _0924_/D load_slew51/X vssd1 vssd1 vccd1 vccd1 _0924_/Q sky130_fd_sc_hd__dfrtp_2
X_0855_ hold178/X _0842_/C _0854_/X vssd1 vssd1 vccd1 vccd1 _0991_/D sky130_fd_sc_hd__o21a_2
X_0786_ _0518_/B _0784_/X _0795_/B1 vssd1 vssd1 vccd1 vccd1 _0786_/Y sky130_fd_sc_hd__o21ai_2
XANTENNA__0589__B1 _0749_/B vssd1 vssd1 vccd1 vccd1 sky130_fd_sc_hd__diode_2
XFILLER_10_42 vssd1 vssd1 vccd1 vccd1 sky130_fd_sc_hd__fill_2
XANTENNA_fanout65_X fanout65/X vssd1 vssd1 vccd1 vccd1 sky130_fd_sc_hd__diode_2
XFILLER_19_127 vssd1 vssd1 vccd1 vccd1 sky130_fd_sc_hd__fill_1
X_0640_ _0926_/Q _0925_/Q _0640_/C vssd1 vssd1 vccd1 vccd1 _0644_/B sky130_fd_sc_hd__and3_2
X_0571_ _1015_/Q _0574_/B _0570_/Y _1014_/Q vssd1 vssd1 vccd1 vccd1 _1017_/D sky130_fd_sc_hd__a22o_2
XFILLER_18_3 vssd1 vssd1 vccd1 vccd1 sky130_fd_sc_hd__fill_2
XFILLER_18_193 vssd1 vssd1 vccd1 vccd1 sky130_fd_sc_hd__fill_2
X_0907_ clkload3/A _0907_/D load_slew53/X vssd1 vssd1 vccd1 vccd1 _0907_/Q sky130_fd_sc_hd__dfrtp_2
X_0838_ _0984_/Q _0838_/A2 _0792_/X _0837_/X vssd1 vssd1 vccd1 vccd1 _0984_/D sky130_fd_sc_hd__a22o_2
X_0769_ _0966_/Q _0787_/B2 _0768_/Y _0795_/B1 vssd1 vssd1 vccd1 vccd1 _0769_/X sky130_fd_sc_hd__a22o_2
XFILLER_24_174 vssd1 vssd1 vccd1 vccd1 sky130_fd_sc_hd__fill_1
XFILLER_24_152 vssd1 vssd1 vccd1 vccd1 sky130_fd_sc_hd__fill_1
Xteam_05_142 vssd1 vssd1 vccd1 vccd1 gpio_oeb[32] team_05_142/LO sky130_fd_sc_hd__conb_1
Xteam_05_131 vssd1 vssd1 vccd1 vccd1 gpio_oeb[21] team_05_131/LO sky130_fd_sc_hd__conb_1
Xteam_05_120 vssd1 vssd1 vccd1 vccd1 gpio_oeb[9] team_05_120/LO sky130_fd_sc_hd__conb_1
XFILLER_7_54 vssd1 vssd1 vccd1 vccd1 sky130_fd_sc_hd__fill_2
XFILLER_7_32 vssd1 vssd1 vccd1 vccd1 sky130_fd_sc_hd__fill_8
X_0623_ _0919_/Q _0918_/Q _0617_/B _0920_/Q vssd1 vssd1 vccd1 vccd1 _0624_/B sky130_fd_sc_hd__a31o_2
X_0554_ _0728_/A vssd1 vssd1 vccd1 vccd1 _0948_/D sky130_fd_sc_hd__inv_2
X_0485_ _0963_/Q _0485_/B vssd1 vssd1 vccd1 vccd1 _0752_/C sky130_fd_sc_hd__xor2_2
XFILLER_21_144 vssd1 vssd1 vccd1 vccd1 sky130_fd_sc_hd__fill_1
XFILLER_21_166 vssd1 vssd1 vccd1 vccd1 sky130_fd_sc_hd__fill_2
XFILLER_12_111 vssd1 vssd1 vccd1 vccd1 sky130_fd_sc_hd__fill_1
XFILLER_12_155 vssd1 vssd1 vccd1 vccd1 sky130_fd_sc_hd__fill_4
XTAP_TAPCELL_ROW_22_183 vssd1 vccd1 sky130_fd_sc_hd__tapvpwrvgnd_1
XPHY_EDGE_ROW_11_Right_11 vssd1 vssd1 vccd1 vccd1 sky130_fd_sc_hd__decap_3
XTAP_TAPCELL_ROW_3_99 vssd1 vccd1 sky130_fd_sc_hd__tapvpwrvgnd_1
XPHY_EDGE_ROW_20_Right_20 vssd1 vssd1 vccd1 vccd1 sky130_fd_sc_hd__decap_3
XFILLER_35_225 vssd1 vssd1 vccd1 vccd1 sky130_fd_sc_hd__fill_2
Xhold148 _0905_/Q vssd1 vssd1 vccd1 vccd1 hold148/X sky130_fd_sc_hd__dlygate4sd3_1
Xhold159 _0740_/X vssd1 vssd1 vccd1 vccd1 _0960_/D sky130_fd_sc_hd__dlygate4sd3_1
X_0606_ _0927_/Q _0458_/B _0513_/B _0926_/Q _0605_/X vssd1 vssd1 vccd1 vccd1 _0606_/X
+ sky130_fd_sc_hd__o221a_2
X_0537_ _0453_/Y _0808_/B _0794_/A _0462_/Y _0825_/B vssd1 vssd1 vccd1 vccd1 _0537_/X
+ sky130_fd_sc_hd__a41o_2
XTAP_TAPCELL_ROW_5_107 vssd1 vccd1 sky130_fd_sc_hd__tapvpwrvgnd_1
X_0468_ _0964_/Q _0470_/B vssd1 vssd1 vccd1 vccd1 _0755_/A sky130_fd_sc_hd__nand2_2
XTAP_TAPCELL_ROW_28_209 vssd1 vccd1 sky130_fd_sc_hd__tapvpwrvgnd_1
XFILLER_17_225 vssd1 vssd1 vccd1 vccd1 sky130_fd_sc_hd__fill_2
XTAP_TAPCELL_ROW_10_131 vssd1 vccd1 sky130_fd_sc_hd__tapvpwrvgnd_1
XFILLER_4_66 vssd1 vccd1 vssd1 vccd1 sky130_ef_sc_hd__decap_40_12
XTAP_TAPCELL_ROW_33_234 vssd1 vccd1 sky130_fd_sc_hd__tapvpwrvgnd_1
XFILLER_13_42 vssd1 vssd1 vccd1 vccd1 sky130_fd_sc_hd__fill_2
Xfanout43 _0860_/A1 vssd1 vssd1 vccd1 vccd1 _0823_/B1 sky130_fd_sc_hd__clkdlybuf4s25_1
Xfanout54 fanout58/X vssd1 vssd1 vccd1 vccd1 fanout54/X sky130_fd_sc_hd__clkdlybuf4s25_1
Xfanout65 fanout74/X vssd1 vssd1 vccd1 vccd1 fanout65/X sky130_fd_sc_hd__clkdlybuf4s25_1
XTAP_TAPCELL_ROW_0_78 vssd1 vccd1 sky130_fd_sc_hd__tapvpwrvgnd_1
XFILLER_38_72 vssd1 vssd1 vccd1 vccd1 sky130_fd_sc_hd__fill_1
X_0940_ clkload9/A _0940_/D load_slew64/X vssd1 vssd1 vccd1 vccd1 _0940_/Q sky130_fd_sc_hd__dfrtp_2
Xclkload13 _0960_/CLK vssd1 vssd1 vccd1 vccd1 clkload13/X sky130_fd_sc_hd__clkbuf_4
X_0871_ hold171/X _0884_/B1 _0870_/X vssd1 vssd1 vccd1 vccd1 _0999_/D sky130_fd_sc_hd__o21a_2
XFILLER_34_19 vssd1 vssd1 vccd1 vccd1 sky130_fd_sc_hd__fill_1
XANTENNA__0604__A2 _0448_/B vssd1 vssd1 vccd1 vccd1 sky130_fd_sc_hd__diode_2
Xclkload7 clkload7/A vssd1 vssd1 vccd1 vccd1 clkload7/X sky130_fd_sc_hd__clkbuf_4
XANTENNA_fanout55_A fanout58/X vssd1 vssd1 vccd1 vccd1 sky130_fd_sc_hd__diode_2
XFILLER_24_85 vssd1 vssd1 vccd1 vccd1 sky130_fd_sc_hd__fill_4
XFILLER_24_41 vssd1 vssd1 vccd1 vccd1 sky130_fd_sc_hd__fill_4
XFILLER_34_9 vssd1 vssd1 vccd1 vccd1 sky130_fd_sc_hd__fill_8
X_0923_ _0970_/CLK _0923_/D load_slew51/X vssd1 vssd1 vccd1 vccd1 _0923_/Q sky130_fd_sc_hd__dfrtp_2
X_0854_ _0856_/A1 _0990_/Q _0862_/B1 _0921_/Q _0864_/C1 vssd1 vssd1 vccd1 vccd1 _0854_/X
+ sky130_fd_sc_hd__a221o_2
X_0785_ _0532_/C _0780_/C _0518_/B _0532_/B vssd1 vssd1 vccd1 vccd1 _0790_/C sky130_fd_sc_hd__o211a_2
XANTENNA__0761__A1 _0765_/B2 vssd1 vssd1 vccd1 vccd1 sky130_fd_sc_hd__diode_2
XFILLER_10_65 vssd1 vssd1 vccd1 vccd1 sky130_fd_sc_hd__fill_1
XANTENNA_fanout58_X fanout58/X vssd1 vssd1 vccd1 vccd1 sky130_fd_sc_hd__diode_2
XFILLER_35_95 vssd1 vssd1 vccd1 vccd1 sky130_fd_sc_hd__fill_4
XFILLER_35_73 vssd1 vssd1 vccd1 vccd1 sky130_fd_sc_hd__fill_1
X_0570_ _0582_/B _0570_/B vssd1 vssd1 vccd1 vccd1 _0570_/Y sky130_fd_sc_hd__nor2_2
XFILLER_18_183 vssd1 vssd1 vccd1 vccd1 sky130_fd_sc_hd__fill_2
X_0906_ _0960_/CLK _0906_/D load_slew70/X vssd1 vssd1 vccd1 vccd1 _0906_/Q sky130_fd_sc_hd__dfrtp_2
X_0837_ _0983_/Q _1016_/D _0836_/Y _0741_/A vssd1 vssd1 vccd1 vccd1 _0837_/X sky130_fd_sc_hd__a22o_2
X_0768_ _0768_/A _0768_/B vssd1 vssd1 vccd1 vccd1 _0768_/Y sky130_fd_sc_hd__xnor2_2
X_0699_ _0945_/Q _0723_/B vssd1 vssd1 vccd1 vccd1 _0699_/Y sky130_fd_sc_hd__nor2_2
XFILLER_24_120 vssd1 vssd1 vccd1 vccd1 sky130_fd_sc_hd__fill_2
XFILLER_24_197 vssd1 vssd1 vccd1 vccd1 sky130_fd_sc_hd__fill_4
Xteam_05_143 vssd1 vssd1 vccd1 vccd1 gpio_oeb[33] team_05_143/LO sky130_fd_sc_hd__conb_1
Xteam_05_132 vssd1 vssd1 vccd1 vccd1 gpio_oeb[22] team_05_132/LO sky130_fd_sc_hd__conb_1
Xteam_05_121 vssd1 vssd1 vccd1 vccd1 gpio_oeb[10] team_05_121/LO sky130_fd_sc_hd__conb_1
XTAP_TAPCELL_ROW_17_159 vssd1 vccd1 sky130_fd_sc_hd__tapvpwrvgnd_1
X_0622_ _0920_/Q _0919_/Q _0622_/C vssd1 vssd1 vccd1 vccd1 _0626_/B sky130_fd_sc_hd__and3_2
X_0553_ _0553_/A _0553_/B vssd1 vssd1 vccd1 vccd1 _0728_/A sky130_fd_sc_hd__nand2_2
X_0484_ _0752_/B vssd1 vssd1 vccd1 vccd1 _0484_/Y sky130_fd_sc_hd__inv_2
XFILLER_30_3 vssd1 vccd1 vssd1 vccd1 sky130_ef_sc_hd__decap_40_12
XFILLER_16_42 vssd1 vssd1 vccd1 vccd1 sky130_fd_sc_hd__fill_1
XFILLER_12_145 vssd1 vssd1 vccd1 vccd1 sky130_fd_sc_hd__fill_1
XFILLER_12_189 vssd1 vssd1 vccd1 vccd1 sky130_fd_sc_hd__fill_2
XTAP_TAPCELL_ROW_22_184 vssd1 vccd1 sky130_fd_sc_hd__tapvpwrvgnd_1
XFILLER_32_85 vssd1 vssd1 vccd1 vccd1 sky130_fd_sc_hd__fill_2
XANTENNA__0513__B _0513_/B vssd1 vssd1 vccd1 vccd1 sky130_fd_sc_hd__diode_2
Xhold149 _0739_/X vssd1 vssd1 vccd1 vccd1 _0959_/D sky130_fd_sc_hd__dlygate4sd3_1
XFILLER_7_171 vssd1 vssd1 vccd1 vccd1 sky130_fd_sc_hd__fill_1
X_0605_ _0603_/X _0605_/B vssd1 vssd1 vccd1 vccd1 _0605_/X sky130_fd_sc_hd__and2b_2
X_0536_ _0538_/B _0538_/C _0460_/Y _0799_/A _0803_/B vssd1 vssd1 vccd1 vccd1 _0825_/C
+ sky130_fd_sc_hd__a2111oi_2
X_0467_ _0448_/B _0497_/A _0466_/X _0952_/Q vssd1 vssd1 vccd1 vccd1 _0470_/B sky130_fd_sc_hd__o22a_2
XTAP_TAPCELL_ROW_5_108 vssd1 vccd1 sky130_fd_sc_hd__tapvpwrvgnd_1
X_1019_ _1019_/CLK _1019_/D fanout73/X vssd1 vssd1 vccd1 vccd1 _1019_/Q sky130_fd_sc_hd__dfrtp_2
XFILLER_27_63 vssd1 vssd1 vccd1 vccd1 sky130_fd_sc_hd__fill_1
XFILLER_27_85 vssd1 vssd1 vccd1 vccd1 sky130_fd_sc_hd__fill_1
XFILLER_4_78 vssd1 vssd1 vccd1 vccd1 sky130_fd_sc_hd__fill_1
XFILLER_4_174 vssd1 vssd1 vccd1 vccd1 sky130_fd_sc_hd__fill_1
XFILLER_23_218 vssd1 vssd1 vccd1 vccd1 sky130_fd_sc_hd__fill_1
XFILLER_31_251 vssd1 vssd1 vccd1 vccd1 sky130_fd_sc_hd__fill_1
X_0519_ _0519_/A _0519_/B vssd1 vssd1 vccd1 vccd1 _0519_/Y sky130_fd_sc_hd__nor2_2
Xfanout44 _0860_/A1 vssd1 vssd1 vccd1 vccd1 _0741_/B sky130_fd_sc_hd__clkdlybuf4s25_1
Xfanout55 fanout58/X vssd1 vssd1 vccd1 vccd1 fanout55/X sky130_fd_sc_hd__clkdlybuf4s25_1
Xfanout66 fanout74/X vssd1 vssd1 vccd1 vccd1 wire67/A sky130_fd_sc_hd__clkdlybuf4s25_1
XTAP_TAPCELL_ROW_0_79 vssd1 vccd1 sky130_fd_sc_hd__tapvpwrvgnd_1
XFILLER_8_3 vssd1 vssd1 vccd1 vccd1 sky130_fd_sc_hd__fill_8
X_0870_ _0741_/B _0998_/Q _0842_/B _0929_/Q _0890_/B1 vssd1 vssd1 vccd1 vccd1 _0870_/X
+ sky130_fd_sc_hd__a221o_2
Xclkload14 _1020_/CLK vssd1 vssd1 vccd1 vccd1 clkload14/X sky130_fd_sc_hd__clkbuf_4
X_0999_ clkload5/A _0999_/D wire67/X vssd1 vssd1 vccd1 vccd1 _0999_/Q sky130_fd_sc_hd__dfrtp_2
Xclkload8 clkload8/A vssd1 vssd1 vccd1 vccd1 clkload8/X sky130_fd_sc_hd__clkbuf_4
XANTENNA_fanout48_A fanout58/X vssd1 vssd1 vccd1 vccd1 sky130_fd_sc_hd__diode_2
X_0922_ clkload1/A _0922_/D load_slew51/X vssd1 vssd1 vccd1 vccd1 _0922_/Q sky130_fd_sc_hd__dfrtp_2
X_0853_ hold192/X _0884_/B1 _0852_/X vssd1 vssd1 vccd1 vccd1 _0990_/D sky130_fd_sc_hd__o21a_2
XANTENNA__0521__B _0598_/B vssd1 vssd1 vccd1 vccd1 sky130_fd_sc_hd__diode_2
X_0784_ _0532_/C _0780_/C _0532_/B vssd1 vssd1 vccd1 vccd1 _0784_/X sky130_fd_sc_hd__o21a_2
Xinput1 en vssd1 vssd1 vccd1 vccd1 input1/X sky130_fd_sc_hd__clkdlybuf4s25_1
XFILLER_36_162 vssd1 vssd1 vccd1 vccd1 sky130_fd_sc_hd__fill_2
XPHY_EDGE_ROW_27_Left_66 vssd1 vssd1 vccd1 vccd1 sky130_fd_sc_hd__decap_3
XFILLER_18_5 vssd1 vssd1 vccd1 vccd1 sky130_fd_sc_hd__fill_1
XFILLER_18_195 vssd1 vssd1 vccd1 vccd1 sky130_fd_sc_hd__fill_1
X_0905_ _0960_/CLK _0905_/D load_slew70/X vssd1 vssd1 vccd1 vccd1 _0905_/Q sky130_fd_sc_hd__dfrtp_2
X_0836_ _0984_/Q _0836_/B vssd1 vssd1 vccd1 vccd1 _0836_/Y sky130_fd_sc_hd__xnor2_2
X_0767_ _0507_/Y _0760_/Y _0499_/Y vssd1 vssd1 vccd1 vccd1 _0768_/B sky130_fd_sc_hd__a21o_2
X_0698_ _0946_/Q _0947_/Q vssd1 vssd1 vccd1 vccd1 _0723_/B sky130_fd_sc_hd__or2_2
Xteam_05_133 vssd1 vssd1 vccd1 vccd1 gpio_oeb[23] team_05_133/LO sky130_fd_sc_hd__conb_1
Xteam_05_122 vssd1 vssd1 vccd1 vccd1 gpio_oeb[11] team_05_122/LO sky130_fd_sc_hd__conb_1
Xteam_05_111 vssd1 vssd1 vccd1 vccd1 gpio_oeb[0] team_05_111/LO sky130_fd_sc_hd__conb_1
Xteam_05_100 vssd1 vssd1 vccd1 vccd1 team_05_100/HI gpio_out[26] sky130_fd_sc_hd__conb_1
X_0621_ _0636_/C _0621_/B _0621_/C vssd1 vssd1 vccd1 vccd1 _0919_/D sky130_fd_sc_hd__and3_2
XFILLER_7_89 vssd1 vssd1 vccd1 vccd1 sky130_fd_sc_hd__fill_2
X_0552_ _0708_/B _0946_/Q _0947_/Q vssd1 vssd1 vccd1 vccd1 _0553_/B sky130_fd_sc_hd__nor3b_2
X_0483_ _0961_/Q _0749_/B _0749_/C vssd1 vssd1 vccd1 vccd1 _0752_/B sky130_fd_sc_hd__o21a_2
XFILLER_23_3 vssd1 vssd1 vccd1 vccd1 sky130_fd_sc_hd__fill_8
XFILLER_21_113 vssd1 vssd1 vccd1 vccd1 sky130_fd_sc_hd__fill_1
X_0819_ _0819_/A _0819_/B vssd1 vssd1 vccd1 vccd1 _0819_/Y sky130_fd_sc_hd__nor2_2
XTAP_TAPCELL_ROW_22_185 vssd1 vccd1 sky130_fd_sc_hd__tapvpwrvgnd_1
XFILLER_32_31 vssd1 vssd1 vccd1 vccd1 sky130_fd_sc_hd__fill_1
XTAP_TAPCELL_ROW_13_141 vssd1 vccd1 sky130_fd_sc_hd__tapvpwrvgnd_1
X_0604_ _0928_/Q _0448_/B _0455_/B _0929_/Q vssd1 vssd1 vccd1 vccd1 _0605_/B sky130_fd_sc_hd__o22a_2
XPHY_EDGE_ROW_9_Right_9 vssd1 vssd1 vccd1 vccd1 sky130_fd_sc_hd__decap_3
X_0535_ _0538_/B _0535_/B vssd1 vssd1 vccd1 vccd1 _0794_/B sky130_fd_sc_hd__nand2_2
X_0466_ _0444_/B _0514_/B _0951_/Q vssd1 vssd1 vccd1 vccd1 _0466_/X sky130_fd_sc_hd__a21bo_2
X_0914__109 vssd1 vssd1 vccd1 vccd1 _0914__109/HI _0914_/D sky130_fd_sc_hd__conb_1
X_1018_ clkload3/A _1018_/D load_slew53/X vssd1 vssd1 vccd1 vccd1 _1018_/Q sky130_fd_sc_hd__dfrtp_2
XTAP_TAPCELL_ROW_36_244 vssd1 vccd1 sky130_fd_sc_hd__tapvpwrvgnd_1
XPHY_EDGE_ROW_14_Left_53 vssd1 vssd1 vccd1 vccd1 sky130_fd_sc_hd__decap_3
XFILLER_27_53 vssd1 vssd1 vccd1 vccd1 sky130_fd_sc_hd__fill_2
XFILLER_17_227 vssd1 vssd1 vccd1 vccd1 sky130_fd_sc_hd__fill_1
XFILLER_4_197 vssd1 vssd1 vccd1 vccd1 sky130_fd_sc_hd__fill_1
X_0518_ _0790_/A _0518_/B vssd1 vssd1 vccd1 vccd1 _0532_/A sky130_fd_sc_hd__and2_2
X_0449_ _0952_/Q _0472_/A vssd1 vssd1 vccd1 vccd1 _0449_/Y sky130_fd_sc_hd__nand2b_2
Xfanout23 _0891_/B1 vssd1 vssd1 vccd1 vccd1 _0864_/C1 sky130_fd_sc_hd__clkdlybuf4s25_1
Xfanout34 _0741_/Y vssd1 vssd1 vccd1 vccd1 _0862_/B1 sky130_fd_sc_hd__clkdlybuf4s25_1
Xfanout45 _0860_/A1 vssd1 vssd1 vccd1 vccd1 _0890_/A1 sky130_fd_sc_hd__clkdlybuf4s25_1
XFILLER_13_55 vssd1 vssd1 vccd1 vccd1 sky130_fd_sc_hd__fill_1
XANTENNA__0791__B1 _0856_/A1 vssd1 vssd1 vccd1 vccd1 sky130_fd_sc_hd__diode_2
XFILLER_1_167 vssd1 vssd1 vccd1 vccd1 sky130_fd_sc_hd__fill_1
XANTENNA__0846__A1 _0856_/A1 vssd1 vssd1 vccd1 vccd1 sky130_fd_sc_hd__diode_2
XANTENNA_input10_A gpio_in[4] vssd1 vssd1 vccd1 vccd1 sky130_fd_sc_hd__diode_2
XFILLER_38_85 vssd1 vssd1 vccd1 vccd1 sky130_fd_sc_hd__fill_2
XTAP_TAPCELL_ROW_30_217 vssd1 vccd1 sky130_fd_sc_hd__tapvpwrvgnd_1
X_0998_ clkload5/A _0998_/D wire67/X vssd1 vssd1 vccd1 vccd1 _0998_/Q sky130_fd_sc_hd__dfrtp_2
Xclkload9 clkload9/A vssd1 vssd1 vccd1 vccd1 clkload9/X sky130_fd_sc_hd__clkbuf_4
XANTENNA_input2_A gpio_in[0] vssd1 vssd1 vccd1 vccd1 sky130_fd_sc_hd__diode_2
XANTENNA__0451__Y _0455_/B vssd1 vssd1 vccd1 vccd1 sky130_fd_sc_hd__diode_2
X_0921_ clkload1/A _0921_/D load_slew51/X vssd1 vssd1 vccd1 vccd1 _0921_/Q sky130_fd_sc_hd__dfrtp_2
X_0852_ _0856_/A1 _0989_/Q _0862_/B1 _0920_/Q _0891_/B1 vssd1 vssd1 vccd1 vccd1 _0852_/X
+ sky130_fd_sc_hd__a221o_2
X_0783_ hold195/X _0782_/X _0788_/S vssd1 vssd1 vccd1 vccd1 _0970_/D sky130_fd_sc_hd__mux2_1
XTAP_TAPCELL_ROW_1_90 vssd1 vccd1 sky130_fd_sc_hd__tapvpwrvgnd_1
Xinput2 gpio_in[0] vssd1 vssd1 vccd1 vccd1 input2/X sky130_fd_sc_hd__clkdlybuf4s25_1
XFILLER_10_34 vssd1 vssd1 vccd1 vccd1 sky130_fd_sc_hd__fill_8
XFILLER_10_89 vssd1 vssd1 vccd1 vccd1 sky130_fd_sc_hd__fill_2
XFILLER_19_76 vssd1 vssd1 vccd1 vccd1 sky130_fd_sc_hd__fill_2
XFILLER_19_65 vssd1 vssd1 vccd1 vccd1 sky130_fd_sc_hd__fill_2
XFILLER_19_43 vssd1 vssd1 vccd1 vccd1 sky130_fd_sc_hd__fill_2
XPHY_EDGE_ROW_2_Left_41 vssd1 vssd1 vccd1 vccd1 sky130_fd_sc_hd__decap_3
XFILLER_33_111 vssd1 vssd1 vccd1 vccd1 sky130_fd_sc_hd__fill_1
XFILLER_18_141 vssd1 vssd1 vccd1 vccd1 sky130_fd_sc_hd__fill_2
X_0904_ _0960_/CLK _0904_/D load_slew70/X vssd1 vssd1 vccd1 vccd1 _0904_/Q sky130_fd_sc_hd__dfrtp_2
X_0835_ _0983_/Q _0838_/A2 _0792_/X _0834_/X vssd1 vssd1 vccd1 vccd1 _0983_/D sky130_fd_sc_hd__a22o_2
X_0766_ _0966_/Q _0765_/X _0788_/S vssd1 vssd1 vccd1 vccd1 _0966_/D sky130_fd_sc_hd__mux2_1
X_0697_ _0947_/Q _0708_/B _0946_/Q vssd1 vssd1 vccd1 vccd1 _0697_/Y sky130_fd_sc_hd__nor3b_2
XFILLER_24_122 vssd1 vssd1 vccd1 vccd1 sky130_fd_sc_hd__fill_1
XANTENNA__0442__B _0448_/B vssd1 vssd1 vccd1 vccd1 sky130_fd_sc_hd__diode_2
Xteam_05_134 vssd1 vssd1 vccd1 vccd1 gpio_oeb[24] team_05_134/LO sky130_fd_sc_hd__conb_1
Xteam_05_123 vssd1 vssd1 vccd1 vccd1 gpio_oeb[12] team_05_123/LO sky130_fd_sc_hd__conb_1
Xteam_05_112 vssd1 vssd1 vccd1 vccd1 gpio_oeb[1] team_05_112/LO sky130_fd_sc_hd__conb_1
Xteam_05_101 vssd1 vssd1 vccd1 vccd1 team_05_101/HI gpio_out[27] sky130_fd_sc_hd__conb_1
Xmax_cap20 _0814_/D vssd1 vssd1 vccd1 vccd1 _0539_/C sky130_fd_sc_hd__clkdlybuf4s25_1
XFILLER_15_144 vssd1 vssd1 vccd1 vccd1 sky130_fd_sc_hd__fill_4
XFILLER_15_166 vssd1 vssd1 vccd1 vccd1 sky130_fd_sc_hd__fill_2
X_0620_ _0919_/Q _0622_/C vssd1 vssd1 vccd1 vccd1 _0621_/C sky130_fd_sc_hd__or2_2
X_0551_ _0943_/Q _0942_/Q _0945_/Q _0944_/Q vssd1 vssd1 vccd1 vccd1 _0708_/B sky130_fd_sc_hd__or4_2
XFILLER_7_46 vssd1 vssd1 vccd1 vccd1 sky130_fd_sc_hd__fill_8
XFILLER_16_3 vssd1 vssd1 vccd1 vccd1 sky130_fd_sc_hd__fill_4
X_0482_ _0962_/Q _0482_/B vssd1 vssd1 vccd1 vccd1 _0749_/C sky130_fd_sc_hd__xor2_2
XANTENNA_clkbuf_4_8_0_clk_A clkbuf_0_clk/X vssd1 vssd1 vccd1 vccd1 sky130_fd_sc_hd__diode_2
XFILLER_21_169 vssd1 vssd1 vccd1 vccd1 sky130_fd_sc_hd__fill_1
X_0818_ _0979_/Q _0821_/A vssd1 vssd1 vccd1 vccd1 _0819_/B sky130_fd_sc_hd__xor2_2
X_0749_ _0961_/Q _0749_/B _0749_/C vssd1 vssd1 vccd1 vccd1 _0749_/X sky130_fd_sc_hd__or3_2
XTAP_TAPCELL_ROW_8_118 vssd1 vccd1 sky130_fd_sc_hd__tapvpwrvgnd_1
XTAP_TAPCELL_ROW_13_142 vssd1 vccd1 sky130_fd_sc_hd__tapvpwrvgnd_1
XFILLER_7_140 vssd1 vccd1 vssd1 vccd1 sky130_ef_sc_hd__decap_40_12
X_0603_ _0928_/Q _0448_/B _0458_/B _0927_/Q vssd1 vssd1 vccd1 vccd1 _0603_/X sky130_fd_sc_hd__a22o_2
X_0534_ _0972_/Q _0513_/B _0532_/X _0533_/X vssd1 vssd1 vccd1 vccd1 _0535_/B sky130_fd_sc_hd__a211oi_2
X_0465_ _0949_/Q _0472_/A vssd1 vssd1 vccd1 vccd1 _0514_/B sky130_fd_sc_hd__nand2_2
X_1017_ clkload6/A _1017_/D fanout57/X vssd1 vssd1 vccd1 vccd1 _1017_/Q sky130_fd_sc_hd__dfrtp_2
Xteam_05 vssd1 vssd1 vccd1 vccd1 team_05/HI gpio_oeb[14] sky130_fd_sc_hd__conb_1
XTAP_TAPCELL_ROW_36_245 vssd1 vccd1 sky130_fd_sc_hd__tapvpwrvgnd_1
XANTENNA__0873__A2 _0884_/B1 vssd1 vssd1 vccd1 vccd1 sky130_fd_sc_hd__diode_2
XFILLER_4_25 vssd1 vssd1 vccd1 vccd1 sky130_fd_sc_hd__fill_2
XPHY_EDGE_ROW_31_Left_70 vssd1 vssd1 vccd1 vccd1 sky130_fd_sc_hd__decap_3
X_0913__110 vssd1 vssd1 vccd1 vccd1 _0913__110/HI _0913_/D sky130_fd_sc_hd__conb_1
X_0517_ _0971_/Q _0517_/B vssd1 vssd1 vccd1 vccd1 _0518_/B sky130_fd_sc_hd__xor2_2
X_0448_ _0974_/Q _0448_/B vssd1 vssd1 vccd1 vccd1 _0461_/B sky130_fd_sc_hd__or2_2
XANTENNA__0607__A2 _0455_/B vssd1 vssd1 vccd1 vccd1 sky130_fd_sc_hd__diode_2
XANTENNA__0939__RESET_B fanout65/X vssd1 vssd1 vccd1 vccd1 sky130_fd_sc_hd__diode_2
Xfanout24 _0891_/B1 vssd1 vssd1 vccd1 vccd1 _0890_/B1 sky130_fd_sc_hd__clkdlybuf4s25_1
Xfanout35 _0741_/Y vssd1 vssd1 vccd1 vccd1 _0842_/B sky130_fd_sc_hd__clkdlybuf4s25_1
Xfanout46 _1017_/Q vssd1 vssd1 vccd1 vccd1 _0860_/A1 sky130_fd_sc_hd__clkdlybuf4s25_1
Xfanout57 fanout58/X vssd1 vssd1 vccd1 vccd1 fanout57/X sky130_fd_sc_hd__clkdlybuf4s25_1
Xfanout68 fanout74/X vssd1 vssd1 vccd1 vccd1 fanout68/X sky130_fd_sc_hd__clkdlybuf4s25_1
XFILLER_22_253 vssd1 vssd1 vccd1 vccd1 sky130_fd_sc_hd__fill_2
XFILLER_13_67 vssd1 vssd1 vccd1 vccd1 sky130_fd_sc_hd__fill_1
XFILLER_1_113 vssd1 vssd1 vccd1 vccd1 sky130_fd_sc_hd__fill_1
XTAP_TAPCELL_ROW_30_218 vssd1 vccd1 sky130_fd_sc_hd__tapvpwrvgnd_1
X_0997_ clkload2/A _0997_/D wire67/X vssd1 vssd1 vccd1 vccd1 _0997_/Q sky130_fd_sc_hd__dfrtp_2
XFILLER_1_15 vssd1 vssd1 vccd1 vccd1 sky130_fd_sc_hd__fill_4
X_0920_ clkload8/A _0920_/D load_slew60/X vssd1 vssd1 vccd1 vccd1 _0920_/Q sky130_fd_sc_hd__dfrtp_2
X_0851_ hold169/X _0842_/C _0850_/X vssd1 vssd1 vccd1 vccd1 _0989_/D sky130_fd_sc_hd__o21a_2
X_0782_ _0795_/B1 _0780_/X _0781_/Y _0787_/B2 _0969_/Q vssd1 vssd1 vccd1 vccd1 _0782_/X
+ sky130_fd_sc_hd__a32o_2
XPHY_EDGE_ROW_18_Right_18 vssd1 vssd1 vccd1 vccd1 sky130_fd_sc_hd__decap_3
Xinput3 gpio_in[10] vssd1 vssd1 vccd1 vccd1 input3/X sky130_fd_sc_hd__clkdlybuf4s25_1
XPHY_EDGE_ROW_27_Right_27 vssd1 vssd1 vccd1 vccd1 sky130_fd_sc_hd__decap_3
XFILLER_36_197 vssd1 vssd1 vccd1 vccd1 sky130_fd_sc_hd__fill_1
XFILLER_10_79 vssd1 vssd1 vccd1 vccd1 sky130_fd_sc_hd__fill_4
XPHY_EDGE_ROW_36_Right_36 vssd1 vssd1 vccd1 vccd1 sky130_fd_sc_hd__decap_3
XFILLER_18_153 vssd1 vssd1 vccd1 vccd1 sky130_fd_sc_hd__fill_2
X_0903_ _1011_/CLK _0903_/D load_slew72/X vssd1 vssd1 vccd1 vccd1 _0903_/Q sky130_fd_sc_hd__dfrtp_2
X_0834_ _0982_/Q _1016_/D _0833_/Y _0741_/A vssd1 vssd1 vccd1 vccd1 _0834_/X sky130_fd_sc_hd__a22o_2
XFILLER_33_167 vssd1 vssd1 vccd1 vccd1 sky130_fd_sc_hd__fill_1
X_0765_ _0965_/Q _0787_/B2 _0764_/Y _0765_/B2 vssd1 vssd1 vccd1 vccd1 _0765_/X sky130_fd_sc_hd__a22o_2
X_0696_ _0696_/A _0696_/B vssd1 vssd1 vccd1 vccd1 _0898_/D sky130_fd_sc_hd__xnor2_2
XANTENNA_clkbuf_4_4_0_clk_A clkbuf_0_clk/X vssd1 vssd1 vccd1 vccd1 sky130_fd_sc_hd__diode_2
XTAP_TAPCELL_ROW_19_170 vssd1 vccd1 sky130_fd_sc_hd__tapvpwrvgnd_1
XFILLER_24_101 vssd1 vssd1 vccd1 vccd1 sky130_fd_sc_hd__fill_4
Xteam_05_135 vssd1 vssd1 vccd1 vccd1 gpio_oeb[25] team_05_135/LO sky130_fd_sc_hd__conb_1
Xteam_05_124 vssd1 vssd1 vccd1 vccd1 gpio_oeb[13] team_05_124/LO sky130_fd_sc_hd__conb_1
Xteam_05_113 vssd1 vssd1 vccd1 vccd1 gpio_oeb[2] team_05_113/LO sky130_fd_sc_hd__conb_1
Xteam_05_102 vssd1 vssd1 vccd1 vccd1 team_05_102/HI gpio_out[28] sky130_fd_sc_hd__conb_1
XFILLER_15_123 vssd1 vssd1 vccd1 vccd1 sky130_fd_sc_hd__fill_1
Xmax_cap21 _0814_/D vssd1 vssd1 vccd1 vccd1 _0826_/A2 sky130_fd_sc_hd__clkdlybuf4s25_1
XTAP_TAPCELL_ROW_25_195 vssd1 vccd1 sky130_fd_sc_hd__tapvpwrvgnd_1
X_0550_ _0943_/Q _0942_/Q vssd1 vssd1 vccd1 vccd1 _0550_/Y sky130_fd_sc_hd__nor2_2
X_0481_ _0450_/X _0466_/X _0480_/Y _0448_/B vssd1 vssd1 vccd1 vccd1 _0749_/B sky130_fd_sc_hd__o2bb2a_2
X_0817_ _0978_/Q _0797_/S _0816_/X vssd1 vssd1 vccd1 vccd1 _0978_/D sky130_fd_sc_hd__o21a_2
X_0748_ _0961_/Q _0744_/X _0747_/X hold183/X _0746_/Y vssd1 vssd1 vccd1 vccd1 _0961_/D
+ sky130_fd_sc_hd__a221o_2
X_0679_ _0678_/A _1012_/Q _1013_/Q vssd1 vssd1 vccd1 vccd1 _0679_/X sky130_fd_sc_hd__a21o_2
XTAP_TAPCELL_ROW_8_119 vssd1 vccd1 sky130_fd_sc_hd__tapvpwrvgnd_1
XPHY_EDGE_ROW_0_Right_0 vssd1 vssd1 vccd1 vccd1 sky130_fd_sc_hd__decap_3
XTAP_TAPCELL_ROW_13_143 vssd1 vccd1 sky130_fd_sc_hd__tapvpwrvgnd_1
XFILLER_7_152 vssd1 vssd1 vccd1 vccd1 sky130_fd_sc_hd__fill_8
X_0602_ _0600_/X _0601_/X _0588_/X vssd1 vssd1 vccd1 vccd1 _0602_/X sky130_fd_sc_hd__a21o_2
X_0533_ _0972_/Q _0513_/B _0790_/B vssd1 vssd1 vccd1 vccd1 _0533_/X sky130_fd_sc_hd__o21a_2
X_0464_ _0949_/Q _0472_/A vssd1 vssd1 vccd1 vccd1 _0497_/A sky130_fd_sc_hd__and2_2
X_1016_ clkload3/A _1016_/D load_slew53/X vssd1 vssd1 vccd1 vccd1 _1016_/Q sky130_fd_sc_hd__dfrtp_2
XTAP_TAPCELL_ROW_36_246 vssd1 vccd1 sky130_fd_sc_hd__tapvpwrvgnd_1
XTAP_TAPCELL_ROW_4_100 vssd1 vccd1 sky130_fd_sc_hd__tapvpwrvgnd_1
XANTENNA__0448__B _0448_/B vssd1 vssd1 vccd1 vccd1 sky130_fd_sc_hd__diode_2
XFILLER_17_218 vssd1 vssd1 vccd1 vccd1 sky130_fd_sc_hd__fill_4
XFILLER_27_55 vssd1 vssd1 vccd1 vccd1 sky130_fd_sc_hd__fill_1
XANTENNA_clkbuf_4_12_0_clk_A clkbuf_0_clk/X vssd1 vssd1 vccd1 vccd1 sky130_fd_sc_hd__diode_2
XFILLER_4_100 vssd1 vssd1 vccd1 vccd1 sky130_fd_sc_hd__fill_8
X_0516_ _0971_/Q _0517_/B vssd1 vssd1 vccd1 vccd1 _0790_/B sky130_fd_sc_hd__and2_2
X_0447_ _0461_/A _0460_/A vssd1 vssd1 vccd1 vccd1 _0454_/A sky130_fd_sc_hd__nand2_2
XFILLER_13_57 vssd1 vssd1 vccd1 vccd1 sky130_fd_sc_hd__fill_1
Xfanout25 _0841_/Y vssd1 vssd1 vccd1 vccd1 _0891_/B1 sky130_fd_sc_hd__clkdlybuf4s25_1
Xfanout36 _0765_/B2 vssd1 vssd1 vccd1 vccd1 _0795_/B1 sky130_fd_sc_hd__clkdlybuf4s25_1
Xfanout47 _0950_/Q vssd1 vssd1 vccd1 vccd1 _0472_/A sky130_fd_sc_hd__clkdlybuf4s25_1
Xfanout58 fanout74/X vssd1 vssd1 vccd1 vccd1 fanout58/X sky130_fd_sc_hd__clkdlybuf4s25_1
Xfanout69 fanout73/X vssd1 vssd1 vccd1 vccd1 fanout69/X sky130_fd_sc_hd__clkdlybuf4s25_1
XFILLER_38_87 vssd1 vssd1 vccd1 vccd1 sky130_fd_sc_hd__fill_1
XANTENNA__0481__X _0749_/B vssd1 vssd1 vccd1 vccd1 sky130_fd_sc_hd__diode_2
XTAP_TAPCELL_ROW_30_219 vssd1 vccd1 sky130_fd_sc_hd__tapvpwrvgnd_1
XANTENNA__0534__A2 _0513_/B vssd1 vssd1 vccd1 vccd1 sky130_fd_sc_hd__diode_2
X_0996_ clkload2/A _0996_/D wire67/X vssd1 vssd1 vccd1 vccd1 _0996_/Q sky130_fd_sc_hd__dfrtp_2
XFILLER_24_45 vssd1 vssd1 vccd1 vccd1 sky130_fd_sc_hd__fill_2
XFILLER_24_89 vssd1 vssd1 vccd1 vccd1 sky130_fd_sc_hd__fill_2
X_0850_ _0856_/A1 _0988_/Q _0862_/B1 _0919_/Q _0891_/B1 vssd1 vssd1 vccd1 vccd1 _0850_/X
+ sky130_fd_sc_hd__a221o_2
X_0781_ _0780_/A _0780_/C _0780_/B vssd1 vssd1 vccd1 vccd1 _0781_/Y sky130_fd_sc_hd__o21ai_2
Xinput4 gpio_in[11] vssd1 vssd1 vccd1 vccd1 input4/X sky130_fd_sc_hd__clkdlybuf4s25_1
XANTENNA_clkbuf_4_0_0_clk_A clkbuf_0_clk/X vssd1 vssd1 vccd1 vccd1 sky130_fd_sc_hd__diode_2
X_0979_ clkload5/A _0979_/D fanout57/X vssd1 vssd1 vccd1 vccd1 _0979_/Q sky130_fd_sc_hd__dfrtp_2
XFILLER_19_67 vssd1 vssd1 vccd1 vccd1 sky130_fd_sc_hd__fill_1
XFILLER_19_45 vssd1 vssd1 vccd1 vccd1 sky130_fd_sc_hd__fill_1
XANTENNA__0994__RESET_B fanout65/X vssd1 vssd1 vccd1 vccd1 sky130_fd_sc_hd__diode_2
XFILLER_33_113 vssd1 vssd1 vccd1 vccd1 sky130_fd_sc_hd__fill_1
X_0902_ _1011_/CLK _0902_/D load_slew72/X vssd1 vssd1 vccd1 vccd1 _0902_/Q sky130_fd_sc_hd__dfrtp_2
X_0833_ _0983_/Q _0833_/B vssd1 vssd1 vccd1 vccd1 _0833_/Y sky130_fd_sc_hd__xnor2_2
X_0764_ _0764_/A _0764_/B vssd1 vssd1 vccd1 vccd1 _0764_/Y sky130_fd_sc_hd__xnor2_2
X_0695_ _0696_/B _0695_/B vssd1 vssd1 vccd1 vccd1 _0897_/D sky130_fd_sc_hd__nor2_2
XTAP_TAPCELL_ROW_19_171 vssd1 vccd1 sky130_fd_sc_hd__tapvpwrvgnd_1
XFILLER_21_57 vssd1 vssd1 vccd1 vccd1 sky130_fd_sc_hd__fill_4
XFILLER_21_35 vssd1 vssd1 vccd1 vccd1 sky130_fd_sc_hd__fill_2
Xteam_05_136 vssd1 vssd1 vccd1 vccd1 gpio_oeb[26] team_05_136/LO sky130_fd_sc_hd__conb_1
Xteam_05_125 vssd1 vssd1 vccd1 vccd1 gpio_oeb[15] team_05_125/LO sky130_fd_sc_hd__conb_1
Xteam_05_114 vssd1 vssd1 vccd1 vccd1 gpio_oeb[3] team_05_114/LO sky130_fd_sc_hd__conb_1
Xteam_05_103 vssd1 vssd1 vccd1 vccd1 team_05_103/HI gpio_out[29] sky130_fd_sc_hd__conb_1
XFILLER_15_135 vssd1 vssd1 vccd1 vccd1 sky130_fd_sc_hd__fill_1
Xmax_cap33 _0595_/B vssd1 vssd1 vccd1 vccd1 _0496_/B sky130_fd_sc_hd__buf_2
Xmax_cap22 _0825_/C vssd1 vssd1 vccd1 vccd1 _0814_/D sky130_fd_sc_hd__clkdlybuf4s25_1
XTAP_TAPCELL_ROW_25_196 vssd1 vccd1 sky130_fd_sc_hd__tapvpwrvgnd_1
X_0480_ _0444_/B _0514_/B _0951_/Q vssd1 vssd1 vccd1 vccd1 _0480_/Y sky130_fd_sc_hd__a21oi_2
X_0816_ _0977_/Q _1016_/D _0815_/Y _0745_/A _0743_/Y vssd1 vssd1 vccd1 vccd1 _0816_/X
+ sky130_fd_sc_hd__a221o_2
X_0747_ _1016_/D _0839_/B vssd1 vssd1 vccd1 vccd1 _0747_/X sky130_fd_sc_hd__and2_2
X_0678_ _0678_/A _1012_/Q _1013_/Q vssd1 vssd1 vccd1 vccd1 _0678_/Y sky130_fd_sc_hd__nand3_2
XFILLER_16_79 vssd1 vssd1 vccd1 vccd1 sky130_fd_sc_hd__fill_4
X_0601_ _0925_/Q _0517_/B _0527_/B _0924_/Q vssd1 vssd1 vccd1 vccd1 _0601_/X sky130_fd_sc_hd__o22a_2
XTAP_TAPCELL_ROW_13_144 vssd1 vccd1 sky130_fd_sc_hd__tapvpwrvgnd_1
X_0532_ _0532_/A _0532_/B _0532_/C vssd1 vssd1 vccd1 vccd1 _0532_/X sky130_fd_sc_hd__and3_2
X_0463_ _0463_/A _0463_/B vssd1 vssd1 vccd1 vccd1 _0803_/B sky130_fd_sc_hd__or2_2
XFILLER_21_3 vssd1 vccd1 vssd1 vccd1 sky130_ef_sc_hd__decap_40_12
X_1015_ clkload4/A _1015_/D fanout57/X vssd1 vssd1 vccd1 vccd1 _1015_/Q sky130_fd_sc_hd__dfrtp_2
XTAP_TAPCELL_ROW_36_247 vssd1 vccd1 sky130_fd_sc_hd__tapvpwrvgnd_1
XTAP_TAPCELL_ROW_4_101 vssd1 vccd1 sky130_fd_sc_hd__tapvpwrvgnd_1
XFILLER_4_27 vssd1 vssd1 vccd1 vccd1 sky130_fd_sc_hd__fill_1
XFILLER_31_211 vssd1 vssd1 vccd1 vccd1 sky130_fd_sc_hd__fill_1
XPHY_EDGE_ROW_18_Left_57 vssd1 vssd1 vccd1 vccd1 sky130_fd_sc_hd__decap_3
X_0515_ _0491_/X _0514_/Y _0492_/X vssd1 vssd1 vccd1 vccd1 _0517_/B sky130_fd_sc_hd__a21bo_2
X_0446_ _0973_/Q _0458_/B vssd1 vssd1 vccd1 vccd1 _0460_/A sky130_fd_sc_hd__nand2_2
Xfanout26 _0884_/B1 vssd1 vssd1 vccd1 vccd1 _0842_/C sky130_fd_sc_hd__clkdlybuf4s25_1
Xfanout37 _0765_/B2 vssd1 vssd1 vccd1 vccd1 _0741_/A sky130_fd_sc_hd__clkdlybuf4s25_1
Xfanout48 fanout58/X vssd1 vssd1 vccd1 vccd1 fanout48/X sky130_fd_sc_hd__clkdlybuf4s25_1
Xfanout59 fanout65/X vssd1 vssd1 vccd1 vccd1 fanout59/X sky130_fd_sc_hd__clkdlybuf4s25_1
XFILLER_13_233 vssd1 vssd1 vccd1 vccd1 sky130_fd_sc_hd__fill_1
X_0995_ _1011_/CLK _0995_/D wire67/X vssd1 vssd1 vccd1 vccd1 _0995_/Q sky130_fd_sc_hd__dfrtp_2
X_0429_ _0892_/Q vssd1 vssd1 vccd1 vccd1 _0429_/Y sky130_fd_sc_hd__inv_2
X_0780_ _0780_/A _0780_/B _0780_/C vssd1 vssd1 vccd1 vccd1 _0780_/X sky130_fd_sc_hd__or3_2
Xinput5 gpio_in[12] vssd1 vssd1 vccd1 vccd1 input5/X sky130_fd_sc_hd__clkdlybuf4s25_1
XFILLER_10_26 vssd1 vssd1 vccd1 vccd1 sky130_fd_sc_hd__fill_2
X_0978_ clkload2/A _0978_/D load_slew56/X vssd1 vssd1 vccd1 vccd1 _0978_/Q sky130_fd_sc_hd__dfrtp_2
XFILLER_19_57 vssd1 vssd1 vccd1 vccd1 sky130_fd_sc_hd__fill_2
X_0901_ _1003_/CLK _0901_/D load_slew72/X vssd1 vssd1 vccd1 vccd1 _0901_/Q sky130_fd_sc_hd__dfrtp_2
X_0832_ _0982_/Q _0838_/A2 _0792_/X _0831_/X vssd1 vssd1 vccd1 vccd1 _0982_/D sky130_fd_sc_hd__a22o_2
X_0763_ _0426_/Y wire32/X _0760_/Y vssd1 vssd1 vccd1 vccd1 _0764_/B sky130_fd_sc_hd__o21ai_2
X_0694_ _0694_/A _0694_/B vssd1 vssd1 vccd1 vccd1 _0695_/B sky130_fd_sc_hd__nor2_2
XFILLER_24_136 vssd1 vssd1 vccd1 vccd1 sky130_fd_sc_hd__fill_2
Xteam_05_115 vssd1 vssd1 vccd1 vccd1 gpio_oeb[4] team_05_115/LO sky130_fd_sc_hd__conb_1
Xteam_05_104 vssd1 vssd1 vccd1 vccd1 team_05_104/HI gpio_out[30] sky130_fd_sc_hd__conb_1
XFILLER_21_25 vssd1 vssd1 vccd1 vccd1 sky130_fd_sc_hd__fill_2
Xteam_05_137 vssd1 vssd1 vccd1 vccd1 gpio_oeb[27] team_05_137/LO sky130_fd_sc_hd__conb_1
Xteam_05_126 vssd1 vssd1 vccd1 vccd1 gpio_oeb[16] team_05_126/LO sky130_fd_sc_hd__conb_1
XPHY_EDGE_ROW_6_Left_45 vssd1 vssd1 vccd1 vccd1 sky130_fd_sc_hd__decap_3
XFILLER_15_169 vssd1 vssd1 vccd1 vccd1 sky130_fd_sc_hd__fill_4
XFILLER_30_106 vssd1 vssd1 vccd1 vccd1 sky130_fd_sc_hd__fill_2
XTAP_TAPCELL_ROW_25_197 vssd1 vccd1 sky130_fd_sc_hd__tapvpwrvgnd_1
XFILLER_11_80 vssd1 vssd1 vccd1 vccd1 sky130_fd_sc_hd__fill_8
Xclkbuf_4_9_0_clk clkbuf_0_clk/X vssd1 vssd1 vccd1 vccd1 clkload8/A sky130_fd_sc_hd__clkbuf_8
XFILLER_38_217 vssd1 vssd1 vccd1 vccd1 sky130_fd_sc_hd__fill_1
XFILLER_14_180 vssd1 vssd1 vccd1 vccd1 sky130_fd_sc_hd__fill_1
X_0815_ _0978_/Q _0815_/B vssd1 vssd1 vccd1 vccd1 _0815_/Y sky130_fd_sc_hd__xnor2_2
X_0746_ _0961_/Q _0749_/B _0819_/A vssd1 vssd1 vccd1 vccd1 _0746_/Y sky130_fd_sc_hd__nor3_2
X_0677_ hold215/X _0657_/Y _0658_/Y _0676_/X _0664_/X vssd1 vssd1 vccd1 vccd1 _0905_/D
+ sky130_fd_sc_hd__a221o_2
XFILLER_20_161 vssd1 vssd1 vccd1 vccd1 sky130_fd_sc_hd__fill_1
XFILLER_11_183 vssd1 vssd1 vccd1 vccd1 sky130_fd_sc_hd__fill_2
X_0600_ _0923_/Q _0598_/B _0527_/B _0924_/Q _0599_/X vssd1 vssd1 vccd1 vccd1 _0600_/X
+ sky130_fd_sc_hd__a221o_2
X_0531_ _0780_/A _0531_/B vssd1 vssd1 vccd1 vccd1 _0532_/C sky130_fd_sc_hd__nand2b_2
XFILLER_7_165 vssd1 vssd1 vccd1 vccd1 sky130_fd_sc_hd__fill_2
XFILLER_7_121 vssd1 vssd1 vccd1 vccd1 sky130_fd_sc_hd__fill_2
XANTENNA__0867__A2 _0884_/B1 vssd1 vssd1 vccd1 vccd1 sky130_fd_sc_hd__diode_2
XFILLER_14_3 vssd1 vssd1 vccd1 vccd1 sky130_fd_sc_hd__fill_2
X_0462_ _0799_/A vssd1 vssd1 vccd1 vccd1 _0462_/Y sky130_fd_sc_hd__inv_2
X_1014_ clkload6/A _1014_/D fanout57/X vssd1 vssd1 vccd1 vccd1 _1014_/Q sky130_fd_sc_hd__dfstp_2
XTAP_TAPCELL_ROW_36_248 vssd1 vccd1 sky130_fd_sc_hd__tapvpwrvgnd_1
XFILLER_34_253 vssd1 vssd1 vccd1 vccd1 sky130_fd_sc_hd__fill_2
X_0729_ _0728_/X _0725_/Y _0728_/A _0951_/Q vssd1 vssd1 vccd1 vccd1 _0951_/D sky130_fd_sc_hd__o2bb2a_2
XTAP_TAPCELL_ROW_4_102 vssd1 vccd1 sky130_fd_sc_hd__tapvpwrvgnd_1
XTAP_TAPCELL_ROW_27_204 vssd1 vccd1 sky130_fd_sc_hd__tapvpwrvgnd_1
XFILLER_27_57 vssd1 vssd1 vccd1 vccd1 sky130_fd_sc_hd__fill_4
X_0514_ _0514_/A _0514_/B vssd1 vssd1 vccd1 vccd1 _0514_/Y sky130_fd_sc_hd__nand2_2
X_0445_ _0952_/Q _0444_/B _0444_/Y vssd1 vssd1 vccd1 vccd1 _0458_/B sky130_fd_sc_hd__o21ai_2
XFILLER_13_15 vssd1 vssd1 vccd1 vccd1 sky130_fd_sc_hd__fill_1
Xfanout27 _0840_/X vssd1 vssd1 vccd1 vccd1 _0884_/B1 sky130_fd_sc_hd__clkdlybuf4s25_1
Xfanout38 _0765_/B2 vssd1 vssd1 vccd1 vccd1 _0745_/A sky130_fd_sc_hd__clkdlybuf4s25_1
XFILLER_1_149 vssd1 vssd1 vccd1 vccd1 sky130_fd_sc_hd__fill_1
XFILLER_1_138 vssd1 vssd1 vccd1 vccd1 sky130_fd_sc_hd__fill_2
XPHY_EDGE_ROW_35_Left_74 vssd1 vssd1 vccd1 vccd1 sky130_fd_sc_hd__decap_3
X_0994_ clkload1/A _0994_/D fanout65/X vssd1 vssd1 vccd1 vccd1 _0994_/Q sky130_fd_sc_hd__dfrtp_2
X_0428_ _1020_/Q vssd1 vssd1 vccd1 vccd1 _0428_/Y sky130_fd_sc_hd__inv_2
XFILLER_10_215 vssd1 vssd1 vccd1 vccd1 sky130_fd_sc_hd__fill_2
XFILLER_6_208 vssd1 vssd1 vccd1 vccd1 sky130_fd_sc_hd__fill_1
XFILLER_24_25 vssd1 vssd1 vccd1 vccd1 sky130_fd_sc_hd__fill_2
Xinput6 gpio_in[13] vssd1 vssd1 vccd1 vccd1 input6/X sky130_fd_sc_hd__clkdlybuf4s25_1
X_0977_ clkload0/A _0977_/D load_slew56/X vssd1 vssd1 vccd1 vccd1 _0977_/Q sky130_fd_sc_hd__dfrtp_2
XFILLER_35_57 vssd1 vssd1 vccd1 vccd1 sky130_fd_sc_hd__fill_1
XPHY_EDGE_ROW_14_Right_14 vssd1 vssd1 vccd1 vccd1 sky130_fd_sc_hd__decap_3
XPHY_EDGE_ROW_23_Right_23 vssd1 vssd1 vccd1 vccd1 sky130_fd_sc_hd__decap_3
X_0900_ _1003_/CLK _0900_/D load_slew72/X vssd1 vssd1 vccd1 vccd1 _0900_/Q sky130_fd_sc_hd__dfrtp_2
XPHY_EDGE_ROW_32_Right_32 vssd1 vssd1 vccd1 vccd1 sky130_fd_sc_hd__decap_3
XFILLER_33_148 vssd1 vssd1 vccd1 vccd1 sky130_fd_sc_hd__fill_2
X_0831_ _0981_/Q _1016_/D _0830_/Y _0741_/A vssd1 vssd1 vccd1 vccd1 _0831_/X sky130_fd_sc_hd__a22o_2
X_0762_ _0965_/Q _0761_/X _0788_/S vssd1 vssd1 vccd1 vccd1 _0965_/D sky130_fd_sc_hd__mux2_1
X_0693_ _0694_/B _0693_/B vssd1 vssd1 vccd1 vccd1 _0896_/D sky130_fd_sc_hd__nor2_2
XPHY_EDGE_ROW_22_Left_61 vssd1 vssd1 vccd1 vccd1 sky130_fd_sc_hd__decap_3
XFILLER_24_148 vssd1 vssd1 vccd1 vccd1 sky130_fd_sc_hd__fill_4
XFILLER_24_115 vssd1 vssd1 vccd1 vccd1 sky130_fd_sc_hd__fill_2
XFILLER_21_15 vssd1 vssd1 vccd1 vccd1 sky130_fd_sc_hd__fill_1
Xteam_05_138 vssd1 vssd1 vccd1 vccd1 gpio_oeb[28] team_05_138/LO sky130_fd_sc_hd__conb_1
Xteam_05_127 vssd1 vssd1 vccd1 vccd1 gpio_oeb[17] team_05_127/LO sky130_fd_sc_hd__conb_1
Xteam_05_116 vssd1 vssd1 vccd1 vccd1 gpio_oeb[5] team_05_116/LO sky130_fd_sc_hd__conb_1
Xteam_05_105 vssd1 vssd1 vccd1 vccd1 team_05_105/HI gpio_out[31] sky130_fd_sc_hd__conb_1
XTAP_TAPCELL_ROW_25_198 vssd1 vccd1 sky130_fd_sc_hd__tapvpwrvgnd_1
XFILLER_16_7 vssd1 vssd1 vccd1 vccd1 sky130_fd_sc_hd__fill_1
XFILLER_14_192 vssd1 vssd1 vccd1 vccd1 sky130_fd_sc_hd__fill_4
X_0814_ _0977_/Q _0978_/Q _0825_/B _0814_/D vssd1 vssd1 vccd1 vccd1 _0821_/A sky130_fd_sc_hd__or4_2
XTAP_TAPCELL_ROW_16_154 vssd1 vccd1 sky130_fd_sc_hd__tapvpwrvgnd_1
XFILLER_21_129 vssd1 vssd1 vccd1 vccd1 sky130_fd_sc_hd__fill_2
X_0745_ _0745_/A _0839_/B vssd1 vssd1 vccd1 vccd1 _0819_/A sky130_fd_sc_hd__nand2_2
X_0676_ _1013_/Q _1011_/Q vssd1 vssd1 vccd1 vccd1 _0676_/X sky130_fd_sc_hd__xor2_2
X_0930__108 vssd1 vssd1 vccd1 vccd1 _0930__108/HI _0930_/D sky130_fd_sc_hd__conb_1
XFILLER_32_25 vssd1 vssd1 vccd1 vccd1 sky130_fd_sc_hd__fill_2
XFILLER_11_140 vssd1 vccd1 vssd1 vccd1 sky130_ef_sc_hd__decap_40_12
X_0530_ _0511_/A _0511_/B _0529_/X vssd1 vssd1 vccd1 vccd1 _0538_/B sky130_fd_sc_hd__a21bo_2
X_0461_ _0461_/A _0461_/B vssd1 vssd1 vccd1 vccd1 _0799_/A sky130_fd_sc_hd__nand2_2
X_1013_ clkload5/A _1013_/D wire67/X vssd1 vssd1 vccd1 vccd1 _1013_/Q sky130_fd_sc_hd__dfrtp_2
X_0728_ _0728_/A _0728_/B _0728_/C vssd1 vssd1 vccd1 vccd1 _0728_/X sky130_fd_sc_hd__and3_2
X_0659_ _0931_/Q _0948_/Q vssd1 vssd1 vccd1 vccd1 _0663_/S sky130_fd_sc_hd__or2_2
XTAP_TAPCELL_ROW_4_103 vssd1 vccd1 sky130_fd_sc_hd__tapvpwrvgnd_1
XPHY_EDGE_ROW_4_Right_4 vssd1 vssd1 vccd1 vccd1 sky130_fd_sc_hd__decap_3
XTAP_TAPCELL_ROW_27_205 vssd1 vccd1 sky130_fd_sc_hd__tapvpwrvgnd_1
Xclkbuf_4_8_0_clk clkbuf_0_clk/X vssd1 vssd1 vccd1 vccd1 clkload7/A sky130_fd_sc_hd__clkbuf_8
XTAP_TAPCELL_ROW_10_127 vssd1 vccd1 sky130_fd_sc_hd__tapvpwrvgnd_1
XFILLER_4_29 vssd1 vssd1 vccd1 vccd1 sky130_fd_sc_hd__fill_4
XFILLER_4_125 vssd1 vssd1 vccd1 vccd1 sky130_fd_sc_hd__fill_1
X_0513_ _0972_/Q _0513_/B vssd1 vssd1 vccd1 vccd1 _0790_/A sky130_fd_sc_hd__xor2_2
X_0444_ _0951_/Q _0444_/B vssd1 vssd1 vccd1 vccd1 _0444_/Y sky130_fd_sc_hd__nand2_2
XFILLER_13_38 vssd1 vssd1 vccd1 vccd1 sky130_fd_sc_hd__fill_4
Xfanout39 _1018_/Q vssd1 vssd1 vccd1 vccd1 _0765_/B2 sky130_fd_sc_hd__clkdlybuf4s25_1
XTAP_TAPCELL_ROW_32_230 vssd1 vccd1 sky130_fd_sc_hd__tapvpwrvgnd_1
X_0993_ clkload1/A _0993_/D fanout65/X vssd1 vssd1 vccd1 vccd1 _0993_/Q sky130_fd_sc_hd__dfrtp_2
X_0427_ _1015_/Q vssd1 vssd1 vccd1 vccd1 _0574_/A sky130_fd_sc_hd__inv_2
XFILLER_10_205 vssd1 vssd1 vccd1 vccd1 sky130_fd_sc_hd__fill_4
XFILLER_10_227 vssd1 vssd1 vccd1 vccd1 sky130_fd_sc_hd__fill_1
Xinput7 gpio_in[1] vssd1 vssd1 vccd1 vccd1 input7/X sky130_fd_sc_hd__clkdlybuf4s25_1
X_0976_ clkload0/A _0976_/D fanout54/X vssd1 vssd1 vccd1 vccd1 _0976_/Q sky130_fd_sc_hd__dfrtp_2
XFILLER_27_113 vssd1 vssd1 vccd1 vccd1 sky130_fd_sc_hd__fill_2
XFILLER_19_59 vssd1 vssd1 vccd1 vccd1 sky130_fd_sc_hd__fill_1
XFILLER_27_146 vssd1 vssd1 vccd1 vccd1 sky130_fd_sc_hd__fill_1
X_0830_ _0982_/Q _0830_/B vssd1 vssd1 vccd1 vccd1 _0830_/Y sky130_fd_sc_hd__xnor2_2
XFILLER_33_138 vssd1 vssd1 vccd1 vccd1 sky130_fd_sc_hd__fill_2
X_0761_ _0765_/B2 _0759_/X _0760_/Y _0787_/B2 _0964_/Q vssd1 vssd1 vccd1 vccd1 _0761_/X
+ sky130_fd_sc_hd__a32o_2
X_0692_ _0895_/Q _0691_/B hold184/X vssd1 vssd1 vccd1 vccd1 _0692_/Y sky130_fd_sc_hd__a21oi_2
XFILLER_24_105 vssd1 vssd1 vccd1 vccd1 sky130_fd_sc_hd__fill_2
X_0959_ _0960_/CLK _0959_/D load_slew70/X vssd1 vssd1 vccd1 vccd1 _0959_/Q sky130_fd_sc_hd__dfrtp_2
Xteam_05_139 vssd1 vssd1 vccd1 vccd1 gpio_oeb[29] team_05_139/LO sky130_fd_sc_hd__conb_1
Xteam_05_128 vssd1 vssd1 vccd1 vccd1 gpio_oeb[18] team_05_128/LO sky130_fd_sc_hd__conb_1
Xteam_05_117 vssd1 vssd1 vccd1 vccd1 gpio_oeb[6] team_05_117/LO sky130_fd_sc_hd__conb_1
Xteam_05_106 vssd1 vssd1 vccd1 vccd1 team_05_106/HI gpio_out[32] sky130_fd_sc_hd__conb_1
XFILLER_30_108 vssd1 vssd1 vccd1 vccd1 sky130_fd_sc_hd__fill_1
XTAP_TAPCELL_ROW_16_155 vssd1 vccd1 sky130_fd_sc_hd__tapvpwrvgnd_1
Xinput10 gpio_in[4] vssd1 vssd1 vccd1 vccd1 _0938_/D sky130_fd_sc_hd__clkdlybuf4s25_1
X_0813_ _0977_/Q _0838_/A2 _0747_/X _0976_/Q _0812_/Y vssd1 vssd1 vccd1 vccd1 _0977_/D
+ sky130_fd_sc_hd__a221o_2
X_0744_ _0745_/A _0749_/B _0838_/A2 vssd1 vssd1 vccd1 vccd1 _0744_/X sky130_fd_sc_hd__a21o_2
X_0675_ _1011_/Q _0657_/Y _0658_/Y _0674_/X _0664_/X vssd1 vssd1 vccd1 vccd1 _0904_/D
+ sky130_fd_sc_hd__a221o_2
XFILLER_16_27 vssd1 vssd1 vccd1 vccd1 sky130_fd_sc_hd__fill_1
XFILLER_11_152 vssd1 vssd1 vccd1 vccd1 sky130_fd_sc_hd__fill_1
XFILLER_11_185 vssd1 vssd1 vccd1 vccd1 sky130_fd_sc_hd__fill_1
XTAP_TAPCELL_ROW_21_180 vssd1 vccd1 sky130_fd_sc_hd__tapvpwrvgnd_1
XFILLER_7_123 vssd1 vssd1 vccd1 vccd1 sky130_fd_sc_hd__fill_1
X_0460_ _0460_/A _0460_/B vssd1 vssd1 vccd1 vccd1 _0460_/Y sky130_fd_sc_hd__nand2_2
XFILLER_7_178 vssd1 vssd1 vccd1 vccd1 sky130_fd_sc_hd__fill_1
XFILLER_7_167 vssd1 vssd1 vccd1 vccd1 sky130_fd_sc_hd__fill_1
XFILLER_14_5 vssd1 vssd1 vccd1 vccd1 sky130_fd_sc_hd__fill_1
X_1012_ clkload5/A _1012_/D wire67/X vssd1 vssd1 vccd1 vccd1 _1012_/Q sky130_fd_sc_hd__dfrtp_2
X_0727_ _0702_/X _0704_/X _0708_/X _0726_/X vssd1 vssd1 vccd1 vccd1 _0728_/C sky130_fd_sc_hd__o22a_2
XFILLER_8_83 vssd1 vssd1 vccd1 vccd1 sky130_fd_sc_hd__fill_1
X_0658_ _0932_/Q _0664_/B vssd1 vssd1 vccd1 vccd1 _0658_/Y sky130_fd_sc_hd__nor2_2
X_0589_ _0916_/Q _0482_/B _0749_/B _0915_/Q vssd1 vssd1 vccd1 vccd1 _0589_/X sky130_fd_sc_hd__a211o_2
XTAP_TAPCELL_ROW_4_104 vssd1 vccd1 sky130_fd_sc_hd__tapvpwrvgnd_1
XTAP_TAPCELL_ROW_27_206 vssd1 vccd1 sky130_fd_sc_hd__tapvpwrvgnd_1
XTAP_TAPCELL_ROW_10_128 vssd1 vccd1 sky130_fd_sc_hd__tapvpwrvgnd_1
X_0512_ _0952_/Q _0519_/A _0480_/Y _0497_/B _0476_/Y vssd1 vssd1 vccd1 vccd1 _0513_/B
+ sky130_fd_sc_hd__o32a_2
X_0443_ _0949_/Q _0472_/A vssd1 vssd1 vccd1 vccd1 _0444_/B sky130_fd_sc_hd__or2_2
Xfanout18 _0608_/Y vssd1 vssd1 vccd1 vccd1 _0636_/C sky130_fd_sc_hd__clkdlybuf4s25_1
Xfanout29 _0743_/Y vssd1 vssd1 vccd1 vccd1 _0838_/A2 sky130_fd_sc_hd__clkdlybuf4s25_1
X_0992_ clkload1/A _0992_/D load_slew51/X vssd1 vssd1 vccd1 vccd1 _0992_/Q sky130_fd_sc_hd__dfrtp_2
XFILLER_5_40 vssd1 vssd1 vccd1 vccd1 sky130_fd_sc_hd__fill_2
Xclkbuf_4_7_0_clk clkbuf_0_clk/X vssd1 vssd1 vccd1 vccd1 clkload6/A sky130_fd_sc_hd__clkbuf_8
X_0426_ _0965_/Q vssd1 vssd1 vccd1 vccd1 _0426_/Y sky130_fd_sc_hd__inv_2
XFILLER_24_27 vssd1 vssd1 vccd1 vccd1 sky130_fd_sc_hd__fill_1
XFILLER_10_239 vssd1 vssd1 vccd1 vccd1 sky130_fd_sc_hd__fill_2
XFILLER_30_81 vssd1 vssd1 vccd1 vccd1 sky130_fd_sc_hd__fill_2
Xinput8 gpio_in[2] vssd1 vssd1 vccd1 vccd1 input8/X sky130_fd_sc_hd__clkdlybuf4s25_1
X_0975_ clkload0/A _0975_/D fanout54/X vssd1 vssd1 vccd1 vccd1 _0975_/Q sky130_fd_sc_hd__dfrtp_2
XANTENNA__0600__A2 _0598_/B vssd1 vssd1 vccd1 vccd1 sky130_fd_sc_hd__diode_2
XFILLER_19_27 vssd1 vccd1 vssd1 vccd1 sky130_ef_sc_hd__decap_40_12
XFILLER_27_169 vssd1 vssd1 vccd1 vccd1 sky130_fd_sc_hd__fill_1
XFILLER_26_191 vssd1 vssd1 vccd1 vccd1 sky130_fd_sc_hd__fill_2
X_0760_ _0760_/A _0760_/B vssd1 vssd1 vccd1 vccd1 _0760_/Y sky130_fd_sc_hd__nand2_2
X_0691_ _0691_/A _0691_/B vssd1 vssd1 vccd1 vccd1 _0895_/D sky130_fd_sc_hd__xnor2_2
XFILLER_24_117 vssd1 vssd1 vccd1 vccd1 sky130_fd_sc_hd__fill_1
X_0889_ _0890_/A1 _1010_/Q _0839_/X _0890_/B1 hold207/X vssd1 vssd1 vccd1 vccd1 _1011_/D
+ sky130_fd_sc_hd__a32o_2
X_0958_ _0960_/CLK _0958_/D load_slew70/X vssd1 vssd1 vccd1 vccd1 _0958_/Q sky130_fd_sc_hd__dfrtp_2
Xteam_05_129 vssd1 vssd1 vccd1 vccd1 gpio_oeb[19] team_05_129/LO sky130_fd_sc_hd__conb_1
Xteam_05_118 vssd1 vssd1 vccd1 vccd1 gpio_oeb[7] team_05_118/LO sky130_fd_sc_hd__conb_1
Xteam_05_107 vssd1 vssd1 vccd1 vccd1 team_05_107/HI gpio_out[33] sky130_fd_sc_hd__conb_1
XANTENNA_fanout37_A _0765_/B2 vssd1 vssd1 vccd1 vccd1 sky130_fd_sc_hd__diode_2
XTAP_TAPCELL_ROW_16_156 vssd1 vccd1 sky130_fd_sc_hd__tapvpwrvgnd_1
Xinput11 gpio_in[5] vssd1 vssd1 vccd1 vccd1 _0939_/D sky130_fd_sc_hd__clkdlybuf4s25_1
X_0812_ _0815_/B _0811_/Y _0819_/A vssd1 vssd1 vccd1 vccd1 _0812_/Y sky130_fd_sc_hd__a21oi_2
X_0743_ _0745_/A _1016_/D _1014_/Q _0839_/B vssd1 vssd1 vccd1 vccd1 _0743_/Y sky130_fd_sc_hd__o31ai_2
X_0674_ _1013_/Q _1010_/Q vssd1 vssd1 vccd1 vccd1 _0674_/X sky130_fd_sc_hd__xor2_2
XFILLER_32_27 vssd1 vssd1 vccd1 vccd1 sky130_fd_sc_hd__fill_1
XFILLER_20_197 vssd1 vssd1 vccd1 vccd1 sky130_fd_sc_hd__fill_1
XFILLER_28_253 vssd1 vssd1 vccd1 vccd1 sky130_fd_sc_hd__fill_2
XFILLER_7_113 vssd1 vssd1 vccd1 vccd1 sky130_fd_sc_hd__fill_8
XFILLER_22_82 vssd1 vssd1 vccd1 vccd1 sky130_fd_sc_hd__fill_2
X_1011_ _1011_/CLK _1011_/D wire67/X vssd1 vssd1 vccd1 vccd1 _1011_/Q sky130_fd_sc_hd__dfrtp_2
XFILLER_19_220 vssd1 vssd1 vccd1 vccd1 sky130_fd_sc_hd__fill_4
X_0726_ _0934_/Q _0935_/Q _0936_/Q _0937_/Q vssd1 vssd1 vccd1 vccd1 _0726_/X sky130_fd_sc_hd__or4b_2
X_0657_ _0678_/A _0664_/B vssd1 vssd1 vccd1 vccd1 _0657_/Y sky130_fd_sc_hd__nor2_2
X_0588_ _0926_/Q _0513_/B _0517_/B _0925_/Q vssd1 vssd1 vccd1 vccd1 _0588_/X sky130_fd_sc_hd__a22o_2
XFILLER_27_27 vssd1 vssd1 vccd1 vccd1 sky130_fd_sc_hd__fill_2
XTAP_TAPCELL_ROW_35_240 vssd1 vccd1 sky130_fd_sc_hd__tapvpwrvgnd_1
XTAP_TAPCELL_ROW_27_207 vssd1 vccd1 sky130_fd_sc_hd__tapvpwrvgnd_1
XFILLER_25_223 vssd1 vssd1 vccd1 vccd1 sky130_fd_sc_hd__fill_1
XTAP_TAPCELL_ROW_10_129 vssd1 vccd1 sky130_fd_sc_hd__tapvpwrvgnd_1
XFILLER_4_138 vssd1 vssd1 vccd1 vccd1 sky130_fd_sc_hd__fill_2
X_0511_ _0511_/A _0511_/B vssd1 vssd1 vccd1 vccd1 _0777_/A sky130_fd_sc_hd__nand2_2
XFILLER_12_3 vssd1 vccd1 vssd1 vccd1 sky130_ef_sc_hd__decap_40_12
X_0442_ _0974_/Q _0448_/B vssd1 vssd1 vccd1 vccd1 _0461_/A sky130_fd_sc_hd__nand2_2
XFILLER_3_171 vssd1 vssd1 vccd1 vccd1 sky130_fd_sc_hd__fill_1
XFILLER_3_160 vssd1 vssd1 vccd1 vccd1 sky130_fd_sc_hd__fill_1
Xfanout19 _0608_/Y vssd1 vssd1 vccd1 vccd1 _0650_/A sky130_fd_sc_hd__clkdlybuf4s25_1
X_0709_ _0934_/Q _0935_/Q _0937_/Q _0936_/Q vssd1 vssd1 vccd1 vccd1 _0709_/X sky130_fd_sc_hd__or4b_2
XANTENNA_input9_A gpio_in[3] vssd1 vssd1 vccd1 vccd1 sky130_fd_sc_hd__diode_2
XFILLER_0_141 vssd1 vccd1 vssd1 vccd1 sky130_ef_sc_hd__decap_40_12
XFILLER_28_92 vssd1 vssd1 vccd1 vccd1 sky130_fd_sc_hd__fill_1
XFILLER_28_81 vssd1 vssd1 vccd1 vccd1 sky130_fd_sc_hd__fill_2
X_0991_ clkload8/A _0991_/D load_slew51/X vssd1 vssd1 vccd1 vccd1 _0991_/Q sky130_fd_sc_hd__dfrtp_2
X_0425_ _0949_/Q vssd1 vssd1 vccd1 vccd1 _0425_/Y sky130_fd_sc_hd__inv_2
XFILLER_14_83 vssd1 vssd1 vccd1 vccd1 sky130_fd_sc_hd__fill_1
Xinput9 gpio_in[3] vssd1 vssd1 vccd1 vccd1 input9/X sky130_fd_sc_hd__clkdlybuf4s25_1
X_0974_ clkload2/A _0974_/D fanout55/X vssd1 vssd1 vccd1 vccd1 _0974_/Q sky130_fd_sc_hd__dfrtp_2
XFILLER_19_39 vssd1 vssd1 vccd1 vccd1 sky130_fd_sc_hd__fill_4
Xclkbuf_4_6_0_clk clkbuf_0_clk/X vssd1 vssd1 vccd1 vccd1 clkload5/A sky130_fd_sc_hd__clkbuf_8
X_0690_ _0691_/B _0690_/B vssd1 vssd1 vccd1 vccd1 _0894_/D sky130_fd_sc_hd__nor2_2
XPHY_EDGE_ROW_10_Right_10 vssd1 vssd1 vccd1 vccd1 sky130_fd_sc_hd__decap_3
X_0888_ _0890_/A1 _1009_/Q _0839_/X _0890_/B1 hold206/X vssd1 vssd1 vccd1 vccd1 _1010_/D
+ sky130_fd_sc_hd__a32o_2
X_0957_ _1020_/CLK _0957_/D fanout71/X vssd1 vssd1 vccd1 vccd1 _0957_/Q sky130_fd_sc_hd__dfrtp_2
XANTENNA__0598__B _0598_/B vssd1 vssd1 vccd1 vccd1 sky130_fd_sc_hd__diode_2
Xteam_05_119 vssd1 vssd1 vccd1 vccd1 gpio_oeb[8] team_05_119/LO sky130_fd_sc_hd__conb_1
XTAP_TAPCELL_ROW_16_157 vssd1 vccd1 sky130_fd_sc_hd__tapvpwrvgnd_1
XPHY_EDGE_ROW_26_Left_65 vssd1 vssd1 vccd1 vccd1 sky130_fd_sc_hd__decap_3
Xinput12 gpio_in[6] vssd1 vssd1 vccd1 vccd1 _0940_/D sky130_fd_sc_hd__clkdlybuf4s25_1
X_0811_ _0825_/B _0539_/C _0977_/Q vssd1 vssd1 vccd1 vccd1 _0811_/Y sky130_fd_sc_hd__o21ai_2
X_0742_ _0745_/A _1016_/D _1014_/Q _0839_/B vssd1 vssd1 vccd1 vccd1 _0797_/S sky130_fd_sc_hd__o31a_2
X_0673_ _1010_/Q _0657_/Y _0658_/Y _0672_/X _0664_/X vssd1 vssd1 vccd1 vccd1 _0903_/D
+ sky130_fd_sc_hd__a221o_2
XTAP_TAPCELL_ROW_24_190 vssd1 vccd1 sky130_fd_sc_hd__tapvpwrvgnd_1
XPHY_EDGE_ROW_10_Left_49 vssd1 vssd1 vccd1 vccd1 sky130_fd_sc_hd__decap_3
XFILLER_20_176 vssd1 vssd1 vccd1 vccd1 sky130_fd_sc_hd__fill_2
XTAP_TAPCELL_ROW_7_114 vssd1 vccd1 sky130_fd_sc_hd__tapvpwrvgnd_1
XTAP_TAPCELL_ROW_38_260 vssd1 vccd1 sky130_fd_sc_hd__tapvpwrvgnd_1
XFILLER_7_169 vssd1 vssd1 vccd1 vccd1 sky130_fd_sc_hd__fill_2
X_1010_ clkload5/A _1010_/D fanout68/X vssd1 vssd1 vccd1 vccd1 _1010_/Q sky130_fd_sc_hd__dfrtp_2
XFILLER_19_254 vssd1 vssd1 vccd1 vccd1 sky130_fd_sc_hd__fill_1
XFILLER_8_85 vssd1 vssd1 vccd1 vccd1 sky130_fd_sc_hd__fill_4
X_0725_ _0697_/Y _0724_/Y _0553_/A vssd1 vssd1 vccd1 vccd1 _0725_/Y sky130_fd_sc_hd__o21ai_2
X_0656_ _0948_/Q _0931_/Q vssd1 vssd1 vccd1 vccd1 _0662_/S sky130_fd_sc_hd__and2b_2
X_0587_ _0587_/A _0587_/B vssd1 vssd1 vccd1 vccd1 _0912_/D sky130_fd_sc_hd__and2_2
XTAP_TAPCELL_ROW_35_241 vssd1 vccd1 sky130_fd_sc_hd__tapvpwrvgnd_1
XANTENNA__0467__A1 _0448_/B vssd1 vssd1 vccd1 vccd1 sky130_fd_sc_hd__diode_2
X_0510_ _0968_/Q _0490_/B _0508_/X _0509_/X vssd1 vssd1 vccd1 vccd1 _0511_/B sky130_fd_sc_hd__a211oi_2
X_0441_ _0514_/A _0519_/A vssd1 vssd1 vccd1 vccd1 _0448_/B sky130_fd_sc_hd__or2_2
XPHY_EDGE_ROW_8_Right_8 vssd1 vssd1 vccd1 vccd1 sky130_fd_sc_hd__decap_3
X_0708_ _0708_/A _0708_/B _0723_/B vssd1 vssd1 vccd1 vccd1 _0708_/X sky130_fd_sc_hd__or3_2
X_0639_ _0650_/A _0639_/B _0639_/C vssd1 vssd1 vccd1 vccd1 _0925_/D sky130_fd_sc_hd__and3_2
XPHY_EDGE_ROW_13_Left_52 vssd1 vssd1 vccd1 vccd1 sky130_fd_sc_hd__decap_3
XFILLER_38_27 vssd1 vssd1 vccd1 vccd1 sky130_fd_sc_hd__fill_1
XFILLER_0_153 vssd1 vssd1 vccd1 vccd1 sky130_fd_sc_hd__fill_4
XFILLER_0_197 vssd1 vssd1 vccd1 vccd1 sky130_fd_sc_hd__fill_1
X_0990_ clkload9/A _0990_/D fanout61/X vssd1 vssd1 vccd1 vccd1 _0990_/Q sky130_fd_sc_hd__dfrtp_2
X_0424_ _0952_/Q vssd1 vssd1 vccd1 vccd1 _0514_/A sky130_fd_sc_hd__inv_2
XFILLER_5_53 vssd1 vssd1 vccd1 vccd1 sky130_fd_sc_hd__fill_2
XFILLER_5_42 vssd1 vssd1 vccd1 vccd1 sky130_fd_sc_hd__fill_1
XFILLER_24_29 vssd1 vccd1 vssd1 vccd1 sky130_ef_sc_hd__decap_40_12
XTAP_TAPCELL_ROW_1_87 vssd1 vccd1 sky130_fd_sc_hd__tapvpwrvgnd_1
XFILLER_5_223 vssd1 vssd1 vccd1 vccd1 sky130_fd_sc_hd__fill_1
XFILLER_30_83 vssd1 vssd1 vccd1 vccd1 sky130_fd_sc_hd__fill_1
X_0973_ clkload0/A _0973_/D fanout48/X vssd1 vssd1 vccd1 vccd1 _0973_/Q sky130_fd_sc_hd__dfrtp_2
XFILLER_35_28 vssd1 vssd1 vccd1 vccd1 sky130_fd_sc_hd__fill_1
X_0956_ _1003_/CLK _0956_/D fanout71/X vssd1 vssd1 vccd1 vccd1 _0956_/Q sky130_fd_sc_hd__dfrtp_2
XANTENNA__0512__X _0513_/B vssd1 vssd1 vccd1 vccd1 sky130_fd_sc_hd__diode_2
X_0887_ _0890_/A1 _1008_/Q _0839_/X _0890_/B1 hold212/X vssd1 vssd1 vccd1 vccd1 _1009_/D
+ sky130_fd_sc_hd__a32o_2
Xmax_cap28 _0535_/B vssd1 vssd1 vccd1 vccd1 _0538_/C sky130_fd_sc_hd__clkbuf_2
XFILLER_23_163 vssd1 vssd1 vccd1 vccd1 sky130_fd_sc_hd__fill_4
XFILLER_23_141 vssd1 vssd1 vccd1 vccd1 sky130_fd_sc_hd__fill_1
XPHY_EDGE_ROW_1_Left_40 vssd1 vssd1 vccd1 vccd1 sky130_fd_sc_hd__decap_3
XFILLER_14_141 vssd1 vssd1 vccd1 vccd1 sky130_fd_sc_hd__fill_8
Xinput13 gpio_in[7] vssd1 vssd1 vccd1 vccd1 _0941_/D sky130_fd_sc_hd__clkdlybuf4s25_1
X_0810_ _0976_/Q _0838_/A2 _0792_/X _0809_/X vssd1 vssd1 vccd1 vccd1 _0976_/D sky130_fd_sc_hd__a22o_2
XTAP_TAPCELL_ROW_24_191 vssd1 vccd1 sky130_fd_sc_hd__tapvpwrvgnd_1
XTAP_TAPCELL_ROW_16_158 vssd1 vccd1 sky130_fd_sc_hd__tapvpwrvgnd_1
X_0741_ _0741_/A _0741_/B vssd1 vssd1 vccd1 vccd1 _0741_/Y sky130_fd_sc_hd__nor2_2
X_0672_ _1013_/Q _1009_/Q vssd1 vssd1 vccd1 vccd1 _0672_/X sky130_fd_sc_hd__xor2_2
XFILLER_37_222 vssd1 vssd1 vccd1 vccd1 sky130_fd_sc_hd__fill_2
X_0939_ _1019_/CLK _0939_/D fanout65/X vssd1 vssd1 vccd1 vccd1 _0939_/Q sky130_fd_sc_hd__dfrtp_2
XFILLER_32_29 vssd1 vssd1 vccd1 vccd1 sky130_fd_sc_hd__fill_2
XFILLER_20_188 vssd1 vssd1 vccd1 vccd1 sky130_fd_sc_hd__fill_1
XTAP_TAPCELL_ROW_7_115 vssd1 vccd1 sky130_fd_sc_hd__tapvpwrvgnd_1
Xclkbuf_4_5_0_clk clkbuf_0_clk/X vssd1 vssd1 vccd1 vccd1 clkload4/A sky130_fd_sc_hd__clkbuf_8
XTAP_TAPCELL_ROW_38_261 vssd1 vccd1 sky130_fd_sc_hd__tapvpwrvgnd_1
XFILLER_11_111 vssd1 vssd1 vccd1 vccd1 sky130_fd_sc_hd__fill_1
XFILLER_11_166 vssd1 vssd1 vccd1 vccd1 sky130_fd_sc_hd__fill_2
X_0724_ _0944_/Q _0724_/B vssd1 vssd1 vccd1 vccd1 _0724_/Y sky130_fd_sc_hd__nor2_2
X_0655_ input7/X input2/X _0654_/X _1019_/Q vssd1 vssd1 vccd1 vccd1 _1091_/A sky130_fd_sc_hd__o31a_2
X_0586_ _0911_/Q _0910_/Q _0581_/A _0912_/Q vssd1 vssd1 vccd1 vccd1 _0587_/B sky130_fd_sc_hd__a31o_2
XFILLER_27_29 vssd1 vssd1 vccd1 vccd1 sky130_fd_sc_hd__fill_1
XTAP_TAPCELL_ROW_35_242 vssd1 vccd1 sky130_fd_sc_hd__tapvpwrvgnd_1
XFILLER_33_83 vssd1 vssd1 vccd1 vccd1 sky130_fd_sc_hd__fill_2
X_0440_ _0472_/A _0951_/Q vssd1 vssd1 vccd1 vccd1 _0519_/A sky130_fd_sc_hd__and2_2
X_0707_ _0707_/A _0708_/A _0723_/B _0707_/D vssd1 vssd1 vccd1 vccd1 _0712_/C sky130_fd_sc_hd__or4_2
XFILLER_30_250 vssd1 vssd1 vccd1 vccd1 sky130_fd_sc_hd__fill_2
XANTENNA__0520__X _0598_/B vssd1 vssd1 vccd1 vccd1 sky130_fd_sc_hd__diode_2
X_0638_ _0925_/Q _0640_/C vssd1 vssd1 vccd1 vccd1 _0639_/C sky130_fd_sc_hd__or2_2
X_0569_ _0448_/B _0455_/B _0576_/A vssd1 vssd1 vccd1 vccd1 _0570_/B sky130_fd_sc_hd__a21bo_2
XFILLER_28_83 vssd1 vssd1 vccd1 vccd1 sky130_fd_sc_hd__fill_1
XANTENNA__0603__A2 _0448_/B vssd1 vssd1 vccd1 vccd1 sky130_fd_sc_hd__diode_2
XFILLER_10_209 vssd1 vssd1 vccd1 vccd1 sky130_fd_sc_hd__fill_1
Xhold210 _0933_/Q vssd1 vssd1 vccd1 vccd1 hold210/X sky130_fd_sc_hd__dlygate4sd3_1
XTAP_TAPCELL_ROW_1_88 vssd1 vccd1 sky130_fd_sc_hd__tapvpwrvgnd_1
XFILLER_36_106 vssd1 vssd1 vccd1 vccd1 sky130_fd_sc_hd__fill_2
X_0972_ clkload0/A _0972_/D load_slew49/X vssd1 vssd1 vccd1 vccd1 _0972_/Q sky130_fd_sc_hd__dfrtp_2
XFILLER_25_95 vssd1 vssd1 vccd1 vccd1 sky130_fd_sc_hd__fill_4
XFILLER_17_161 vssd1 vssd1 vccd1 vccd1 sky130_fd_sc_hd__fill_4
X_0955_ _1003_/CLK _0955_/D load_slew72/X vssd1 vssd1 vccd1 vccd1 _0955_/Q sky130_fd_sc_hd__dfrtp_2
X_0886_ _0890_/A1 _1007_/Q _0839_/X _0890_/B1 hold208/X vssd1 vssd1 vccd1 vccd1 _1008_/D
+ sky130_fd_sc_hd__a32o_2
XFILLER_32_197 vssd1 vssd1 vccd1 vccd1 sky130_fd_sc_hd__fill_2
Xinput14 gpio_in[8] vssd1 vssd1 vccd1 vccd1 _0942_/D sky130_fd_sc_hd__clkdlybuf4s25_1
X_0740_ _0960_/Q hold158/X wire31/X vssd1 vssd1 vccd1 vccd1 _0740_/X sky130_fd_sc_hd__mux2_1
XTAP_TAPCELL_ROW_24_192 vssd1 vccd1 sky130_fd_sc_hd__tapvpwrvgnd_1
X_0671_ _1009_/Q _0657_/Y _0658_/Y _0670_/X _0664_/X vssd1 vssd1 vccd1 vccd1 _0902_/D
+ sky130_fd_sc_hd__a221o_2
XFILLER_28_3 vssd1 vssd1 vccd1 vccd1 sky130_fd_sc_hd__fill_2
X_0938_ _1019_/CLK _0938_/D fanout65/X vssd1 vssd1 vccd1 vccd1 _0938_/Q sky130_fd_sc_hd__dfrtp_2
X_0869_ hold166/X _0884_/B1 _0868_/X vssd1 vssd1 vccd1 vccd1 _0998_/D sky130_fd_sc_hd__o21a_2
XFILLER_20_178 vssd1 vssd1 vccd1 vccd1 sky130_fd_sc_hd__fill_1
XTAP_TAPCELL_ROW_7_116 vssd1 vccd1 sky130_fd_sc_hd__tapvpwrvgnd_1
XFILLER_22_85 vssd1 vssd1 vccd1 vccd1 sky130_fd_sc_hd__fill_1
XFILLER_22_74 vssd1 vssd1 vccd1 vccd1 sky130_fd_sc_hd__fill_8
X_0723_ _0943_/Q _0723_/B _0942_/Q _0945_/Q vssd1 vssd1 vccd1 vccd1 _0724_/B sky130_fd_sc_hd__or4b_2
XTAP_TAPCELL_ROW_12_140 vssd1 vccd1 sky130_fd_sc_hd__tapvpwrvgnd_1
X_0654_ _0654_/A _0654_/B _0654_/C vssd1 vssd1 vccd1 vccd1 _0654_/X sky130_fd_sc_hd__or3_2
X_0585_ hold199/X _0582_/A _0584_/Y vssd1 vssd1 vccd1 vccd1 _0911_/D sky130_fd_sc_hd__o21a_2
XANTENNA_clkbuf_4_7_0_clk_A clkbuf_0_clk/X vssd1 vssd1 vccd1 vccd1 sky130_fd_sc_hd__diode_2
XTAP_TAPCELL_ROW_35_243 vssd1 vccd1 sky130_fd_sc_hd__tapvpwrvgnd_1
XFILLER_4_108 vssd1 vssd1 vccd1 vccd1 sky130_fd_sc_hd__fill_2
XFILLER_16_204 vssd1 vccd1 vssd1 vccd1 sky130_ef_sc_hd__decap_40_12
Xclkbuf_4_4_0_clk clkbuf_0_clk/X vssd1 vssd1 vccd1 vccd1 clkload3/A sky130_fd_sc_hd__clkbuf_8
X_0706_ _0943_/Q _0945_/Q _0944_/Q _0942_/Q vssd1 vssd1 vccd1 vccd1 _0707_/D sky130_fd_sc_hd__or4b_2
X_0637_ _0925_/Q _0640_/C vssd1 vssd1 vccd1 vccd1 _0639_/B sky130_fd_sc_hd__nand2_2
X_0568_ _0913_/Q _0914_/Q vssd1 vssd1 vccd1 vccd1 _0582_/B sky130_fd_sc_hd__or2_2
X_0499_ _0966_/Q _0500_/B vssd1 vssd1 vccd1 vccd1 _0499_/Y sky130_fd_sc_hd__nor2_2
XFILLER_38_29 vssd1 vccd1 vssd1 vccd1 sky130_ef_sc_hd__decap_40_12
XANTENNA__0606__B1 _0513_/B vssd1 vssd1 vccd1 vccd1 sky130_fd_sc_hd__diode_2
XFILLER_0_111 vssd1 vssd1 vccd1 vccd1 sky130_fd_sc_hd__fill_1
XANTENNA_input15_A gpio_in[9] vssd1 vssd1 vccd1 vccd1 sky130_fd_sc_hd__diode_2
XFILLER_8_211 vssd1 vssd1 vccd1 vccd1 sky130_fd_sc_hd__fill_1
XFILLER_5_55 vssd1 vssd1 vccd1 vccd1 sky130_fd_sc_hd__fill_1
XFILLER_10_3 vssd1 vssd1 vccd1 vccd1 sky130_fd_sc_hd__fill_4
Xhold200 _0897_/Q vssd1 vssd1 vccd1 vccd1 _0694_/A sky130_fd_sc_hd__dlygate4sd3_1
Xhold211 _0971_/Q vssd1 vssd1 vccd1 vccd1 hold211/X sky130_fd_sc_hd__dlygate4sd3_1
XANTENNA_input7_A gpio_in[1] vssd1 vssd1 vccd1 vccd1 sky130_fd_sc_hd__diode_2
XFILLER_14_53 vssd1 vssd1 vccd1 vccd1 sky130_fd_sc_hd__fill_2
XANTENNA__0441__X _0448_/B vssd1 vssd1 vccd1 vccd1 sky130_fd_sc_hd__diode_2
XANTENNA_clkbuf_4_15_0_clk_A clkbuf_0_clk/X vssd1 vssd1 vccd1 vccd1 sky130_fd_sc_hd__diode_2
XTAP_TAPCELL_ROW_1_89 vssd1 vccd1 sky130_fd_sc_hd__tapvpwrvgnd_1
XFILLER_30_85 vssd1 vssd1 vccd1 vccd1 sky130_fd_sc_hd__fill_4
X_0971_ clkload0/A _0971_/D load_slew49/X vssd1 vssd1 vccd1 vccd1 _0971_/Q sky130_fd_sc_hd__dfrtp_2
XANTENNA__0588__A2 _0513_/B vssd1 vssd1 vccd1 vccd1 sky130_fd_sc_hd__diode_2
XFILLER_2_239 vssd1 vssd1 vccd1 vccd1 sky130_fd_sc_hd__fill_1
XANTENNA_fanout65_A fanout74/X vssd1 vssd1 vccd1 vccd1 sky130_fd_sc_hd__diode_2
XFILLER_2_67 vssd1 vssd1 vccd1 vccd1 sky130_fd_sc_hd__fill_4
XTAP_TAPCELL_ROW_19_168 vssd1 vccd1 sky130_fd_sc_hd__tapvpwrvgnd_1
XFILLER_32_165 vssd1 vssd1 vccd1 vccd1 sky130_fd_sc_hd__fill_2
XFILLER_32_143 vssd1 vssd1 vccd1 vccd1 sky130_fd_sc_hd__fill_1
X_0954_ _1003_/CLK _0954_/D load_slew72/X vssd1 vssd1 vccd1 vccd1 _0954_/Q sky130_fd_sc_hd__dfrtp_2
X_0885_ _0890_/A1 _1006_/Q _0839_/X _0890_/B1 hold205/X vssd1 vssd1 vccd1 vccd1 _1007_/D
+ sky130_fd_sc_hd__a32o_2
XFILLER_14_176 vssd1 vssd1 vccd1 vccd1 sky130_fd_sc_hd__fill_4
Xinput15 gpio_in[9] vssd1 vssd1 vccd1 vccd1 _0943_/D sky130_fd_sc_hd__clkdlybuf4s25_1
X_0670_ _1013_/Q _1008_/Q vssd1 vssd1 vccd1 vccd1 _0670_/X sky130_fd_sc_hd__xor2_2
XTAP_TAPCELL_ROW_24_193 vssd1 vccd1 sky130_fd_sc_hd__tapvpwrvgnd_1
XFILLER_37_246 vssd1 vssd1 vccd1 vccd1 sky130_fd_sc_hd__fill_1
XFILLER_20_102 vssd1 vssd1 vccd1 vccd1 sky130_fd_sc_hd__fill_2
XANTENNA_clkbuf_4_3_0_clk_A clkbuf_0_clk/X vssd1 vssd1 vccd1 vccd1 sky130_fd_sc_hd__diode_2
X_0937_ clkload9/A input9/X load_slew62/X vssd1 vssd1 vccd1 vccd1 _0937_/Q sky130_fd_sc_hd__dfrtp_2
X_0868_ _0741_/B _0997_/Q _0842_/B _0928_/Q _0890_/B1 vssd1 vssd1 vccd1 vccd1 _0868_/X
+ sky130_fd_sc_hd__a221o_2
X_0799_ _0799_/A _0799_/B vssd1 vssd1 vccd1 vccd1 _0799_/Y sky130_fd_sc_hd__xnor2_2
XTAP_TAPCELL_ROW_7_117 vssd1 vccd1 sky130_fd_sc_hd__tapvpwrvgnd_1
XFILLER_28_213 vssd1 vssd1 vccd1 vccd1 sky130_fd_sc_hd__fill_1
XFILLER_11_113 vssd1 vssd1 vccd1 vccd1 sky130_fd_sc_hd__fill_4
XFILLER_8_11 vssd1 vssd1 vccd1 vccd1 sky130_fd_sc_hd__fill_2
X_0722_ _0716_/X _0719_/Y _0721_/Y _0728_/A hold144/X vssd1 vssd1 vccd1 vccd1 _0950_/D
+ sky130_fd_sc_hd__o32a_2
X_0653_ input9/X input8/X _0939_/D _0938_/D vssd1 vssd1 vccd1 vccd1 _0654_/C sky130_fd_sc_hd__or4_2
X_0584_ _0911_/Q _0582_/A _0582_/B vssd1 vssd1 vccd1 vccd1 _0584_/Y sky130_fd_sc_hd__a21oi_2
XFILLER_16_216 vssd1 vssd1 vccd1 vccd1 sky130_fd_sc_hd__fill_1
XTAP_TAPCELL_ROW_26_200 vssd1 vccd1 sky130_fd_sc_hd__tapvpwrvgnd_1
X_0705_ _0703_/X _0704_/X _0702_/X vssd1 vssd1 vccd1 vccd1 _0712_/B sky130_fd_sc_hd__a21o_2
X_0636_ _0640_/C _0636_/B _0636_/C vssd1 vssd1 vccd1 vccd1 _0924_/D sky130_fd_sc_hd__and3b_2
X_0567_ _0911_/Q _0912_/Q _0582_/A vssd1 vssd1 vccd1 vccd1 _0576_/A sky130_fd_sc_hd__and3_2
X_0498_ _0473_/C _0497_/Y _0514_/A vssd1 vssd1 vccd1 vccd1 _0500_/B sky130_fd_sc_hd__mux2_1
XANTENNA__0854__A1 _0856_/A1 vssd1 vssd1 vccd1 vccd1 sky130_fd_sc_hd__diode_2
XPHY_EDGE_ROW_17_Right_17 vssd1 vssd1 vccd1 vccd1 sky130_fd_sc_hd__decap_3
XFILLER_0_167 vssd1 vssd1 vccd1 vccd1 sky130_fd_sc_hd__fill_1
XPHY_EDGE_ROW_26_Right_26 vssd1 vssd1 vccd1 vccd1 sky130_fd_sc_hd__decap_3
XFILLER_28_41 vssd1 vssd1 vccd1 vccd1 sky130_fd_sc_hd__fill_2
XANTENNA_clkbuf_4_11_0_clk_A clkbuf_0_clk/X vssd1 vssd1 vccd1 vccd1 sky130_fd_sc_hd__diode_2
XPHY_EDGE_ROW_35_Right_35 vssd1 vssd1 vccd1 vccd1 sky130_fd_sc_hd__decap_3
Xhold201 _1005_/Q vssd1 vssd1 vccd1 vccd1 _0883_/S sky130_fd_sc_hd__dlygate4sd3_1
XPHY_EDGE_ROW_17_Left_56 vssd1 vssd1 vccd1 vccd1 sky130_fd_sc_hd__decap_3
Xhold212 _1009_/Q vssd1 vssd1 vccd1 vccd1 hold212/X sky130_fd_sc_hd__dlygate4sd3_1
X_0619_ _0919_/Q _0622_/C vssd1 vssd1 vccd1 vccd1 _0621_/B sky130_fd_sc_hd__nand2_2
XFILLER_30_53 vssd1 vssd1 vccd1 vccd1 sky130_fd_sc_hd__fill_2
Xclkbuf_4_3_0_clk clkbuf_0_clk/X vssd1 vssd1 vccd1 vccd1 clkload2/A sky130_fd_sc_hd__clkbuf_8
XFILLER_36_108 vssd1 vssd1 vccd1 vccd1 sky130_fd_sc_hd__fill_1
X_0970_ _0970_/CLK _0970_/D load_slew49/X vssd1 vssd1 vccd1 vccd1 _0970_/Q sky130_fd_sc_hd__dfrtp_2
XFILLER_4_9 vssd1 vccd1 vssd1 vccd1 sky130_ef_sc_hd__decap_40_12
XANTENNA_fanout58_A fanout74/X vssd1 vssd1 vccd1 vccd1 sky130_fd_sc_hd__diode_2
XFILLER_25_53 vssd1 vssd1 vccd1 vccd1 sky130_fd_sc_hd__fill_2
XFILLER_17_152 vssd1 vssd1 vccd1 vccd1 sky130_fd_sc_hd__fill_4
XTAP_TAPCELL_ROW_19_169 vssd1 vccd1 sky130_fd_sc_hd__tapvpwrvgnd_1
XANTENNA__0522__B _0598_/B vssd1 vssd1 vccd1 vccd1 sky130_fd_sc_hd__diode_2
X_0953_ _1003_/CLK _0953_/D fanout68/X vssd1 vssd1 vccd1 vccd1 _0953_/Q sky130_fd_sc_hd__dfrtp_2
X_0884_ _0439_/Y _0819_/A _0884_/B1 vssd1 vssd1 vccd1 vccd1 _1006_/D sky130_fd_sc_hd__a21oi_2
XFILLER_11_88 vssd1 vssd1 vccd1 vccd1 sky130_fd_sc_hd__fill_2
Xinput16 nrst vssd1 vssd1 vccd1 vccd1 _0546_/A sky130_fd_sc_hd__clkdlybuf4s25_1
XTAP_TAPCELL_ROW_24_194 vssd1 vccd1 sky130_fd_sc_hd__tapvpwrvgnd_1
XFILLER_28_5 vssd1 vssd1 vccd1 vccd1 sky130_fd_sc_hd__fill_1
X_0936_ _1019_/CLK input8/X load_slew62/X vssd1 vssd1 vccd1 vccd1 _0936_/Q sky130_fd_sc_hd__dfrtp_2
XTAP_TAPCELL_ROW_15_150 vssd1 vccd1 sky130_fd_sc_hd__tapvpwrvgnd_1
X_0867_ hold176/X _0884_/B1 _0866_/X vssd1 vssd1 vccd1 vccd1 _0997_/D sky130_fd_sc_hd__o21a_2
X_0798_ _0794_/A _0794_/B _0460_/A vssd1 vssd1 vccd1 vccd1 _0799_/B sky130_fd_sc_hd__a21bo_2
XTAP_TAPCELL_ROW_38_253 vssd1 vccd1 sky130_fd_sc_hd__tapvpwrvgnd_1
XFILLER_11_169 vssd1 vssd1 vccd1 vccd1 sky130_fd_sc_hd__fill_1
XPHY_EDGE_ROW_5_Left_44 vssd1 vssd1 vccd1 vccd1 sky130_fd_sc_hd__decap_3
XFILLER_22_65 vssd1 vssd1 vccd1 vccd1 sky130_fd_sc_hd__fill_2
XANTENNA__0938__RESET_B fanout65/X vssd1 vssd1 vccd1 vccd1 sky130_fd_sc_hd__diode_2
X_0721_ _0709_/X _0720_/X _0708_/X vssd1 vssd1 vccd1 vccd1 _0721_/Y sky130_fd_sc_hd__a21oi_2
X_0652_ _0941_/D _0940_/D _0943_/D _0942_/D vssd1 vssd1 vccd1 vccd1 _0654_/B sky130_fd_sc_hd__or4_2
X_0583_ hold182/X _0581_/A _0582_/Y vssd1 vssd1 vccd1 vccd1 _0910_/D sky130_fd_sc_hd__o21a_2
XFILLER_8_89 vssd1 vssd1 vccd1 vccd1 sky130_fd_sc_hd__fill_2
X_0919_ clkload8/A _0919_/D load_slew60/X vssd1 vssd1 vccd1 vccd1 _0919_/Q sky130_fd_sc_hd__dfrtp_2
XTAP_TAPCELL_ROW_26_201 vssd1 vccd1 sky130_fd_sc_hd__tapvpwrvgnd_1
XANTENNA_fanout40_A _0856_/A1 vssd1 vssd1 vccd1 vccd1 sky130_fd_sc_hd__diode_2
XFILLER_17_98 vssd1 vssd1 vccd1 vccd1 sky130_fd_sc_hd__fill_1
XFILLER_17_76 vssd1 vssd1 vccd1 vccd1 sky130_fd_sc_hd__fill_1
XTAP_TAPCELL_ROW_32_226 vssd1 vccd1 sky130_fd_sc_hd__tapvpwrvgnd_1
XFILLER_30_253 vssd1 vssd1 vccd1 vccd1 sky130_fd_sc_hd__fill_2
X_0704_ _0939_/Q _0941_/Q _0940_/Q _0938_/Q vssd1 vssd1 vccd1 vccd1 _0704_/X sky130_fd_sc_hd__or4b_2
X_0635_ _0924_/Q _0635_/B vssd1 vssd1 vccd1 vccd1 _0636_/B sky130_fd_sc_hd__or2_2
X_0566_ _0910_/Q _0581_/A vssd1 vssd1 vccd1 vccd1 _0582_/A sky130_fd_sc_hd__and2_2
X_0497_ _0497_/A _0497_/B vssd1 vssd1 vccd1 vccd1 _0497_/Y sky130_fd_sc_hd__nor2_2
XFILLER_0_113 vssd1 vssd1 vccd1 vccd1 sky130_fd_sc_hd__fill_2
XFILLER_0_157 vssd1 vssd1 vccd1 vccd1 sky130_fd_sc_hd__fill_2
XFILLER_5_57 vssd1 vccd1 vssd1 vccd1 sky130_ef_sc_hd__decap_40_12
Xhold202 _0975_/Q vssd1 vssd1 vccd1 vccd1 hold202/X sky130_fd_sc_hd__dlygate4sd3_1
Xhold213 _1001_/Q vssd1 vssd1 vccd1 vccd1 hold213/X sky130_fd_sc_hd__dlygate4sd3_1
X_0618_ _0622_/C _0618_/B _0636_/C vssd1 vssd1 vccd1 vccd1 _0918_/D sky130_fd_sc_hd__and3b_2
X_0549_ _0707_/A _0708_/A vssd1 vssd1 vccd1 vccd1 _0553_/A sky130_fd_sc_hd__nor2_2
XPHY_EDGE_ROW_34_Left_73 vssd1 vssd1 vccd1 vccd1 sky130_fd_sc_hd__decap_3
XFILLER_25_21 vssd1 vccd1 vssd1 vccd1 sky130_ef_sc_hd__decap_40_12
X_0952_ clkload7/A _0952_/D load_slew60/X vssd1 vssd1 vccd1 vccd1 _0952_/Q sky130_fd_sc_hd__dfrtp_2
X_0883_ _0882_/A _0878_/Y _0883_/S vssd1 vssd1 vccd1 vccd1 _1005_/D sky130_fd_sc_hd__mux2_1
Xclkbuf_4_2_0_clk clkbuf_0_clk/X vssd1 vssd1 vccd1 vccd1 clkload1/A sky130_fd_sc_hd__clkbuf_8
XFILLER_23_167 vssd1 vssd1 vccd1 vccd1 sky130_fd_sc_hd__fill_1
XFILLER_36_31 vssd1 vssd1 vccd1 vccd1 sky130_fd_sc_hd__fill_1
X_0935_ _1019_/CLK input7/X load_slew62/X vssd1 vssd1 vccd1 vccd1 _0935_/Q sky130_fd_sc_hd__dfrtp_2
X_0866_ _0741_/B _0996_/Q _0842_/B _0927_/Q _0890_/B1 vssd1 vssd1 vccd1 vccd1 _0866_/X
+ sky130_fd_sc_hd__a221o_2
XTAP_TAPCELL_ROW_15_151 vssd1 vccd1 sky130_fd_sc_hd__tapvpwrvgnd_1
XPHY_EDGE_ROW_21_Left_60 vssd1 vssd1 vccd1 vccd1 sky130_fd_sc_hd__decap_3
X_0797_ hold198/X _0796_/X _0797_/S vssd1 vssd1 vccd1 vccd1 _0973_/D sky130_fd_sc_hd__mux2_1
XANTENNA__0884__B1 _0884_/B1 vssd1 vssd1 vccd1 vccd1 sky130_fd_sc_hd__diode_2
XTAP_TAPCELL_ROW_38_254 vssd1 vccd1 sky130_fd_sc_hd__tapvpwrvgnd_1
XFILLER_22_33 vssd1 vssd1 vccd1 vccd1 sky130_fd_sc_hd__fill_2
X_0720_ _0934_/Q _0937_/Q _0936_/Q _0935_/Q vssd1 vssd1 vccd1 vccd1 _0720_/X sky130_fd_sc_hd__or4b_2
XFILLER_8_79 vssd1 vssd1 vccd1 vccd1 sky130_fd_sc_hd__fill_4
XFILLER_8_46 vssd1 vssd1 vccd1 vccd1 sky130_fd_sc_hd__fill_2
XFILLER_8_35 vssd1 vssd1 vccd1 vccd1 sky130_fd_sc_hd__fill_2
XFILLER_8_13 vssd1 vssd1 vccd1 vccd1 sky130_fd_sc_hd__fill_1
X_0651_ input4/X input3/X input6/X input5/X vssd1 vssd1 vccd1 vccd1 _0654_/A sky130_fd_sc_hd__or4_2
X_0582_ _0582_/A _0582_/B vssd1 vssd1 vccd1 vccd1 _0582_/Y sky130_fd_sc_hd__nor2_2
XFILLER_6_174 vssd1 vssd1 vccd1 vccd1 sky130_fd_sc_hd__fill_1
XFILLER_6_141 vssd1 vccd1 vssd1 vccd1 sky130_ef_sc_hd__decap_40_12
XFILLER_26_3 vssd1 vssd1 vccd1 vccd1 sky130_fd_sc_hd__fill_8
X_0918_ clkload8/A _0918_/D load_slew60/X vssd1 vssd1 vccd1 vccd1 _0918_/Q sky130_fd_sc_hd__dfrtp_2
X_0849_ hold177/X _0842_/C _0848_/X vssd1 vssd1 vccd1 vccd1 _0988_/D sky130_fd_sc_hd__o21a_2
XTAP_TAPCELL_ROW_26_202 vssd1 vccd1 sky130_fd_sc_hd__tapvpwrvgnd_1
XTAP_TAPCELL_ROW_32_227 vssd1 vccd1 sky130_fd_sc_hd__tapvpwrvgnd_1
X_0703_ _0939_/Q _0938_/Q _0941_/Q _0940_/Q vssd1 vssd1 vccd1 vccd1 _0703_/X sky130_fd_sc_hd__or4b_2
X_0634_ _0924_/Q _0635_/B vssd1 vssd1 vccd1 vccd1 _0640_/C sky130_fd_sc_hd__and2_2
X_0565_ _0909_/Q _0907_/Q _0908_/Q vssd1 vssd1 vccd1 vccd1 _0581_/A sky130_fd_sc_hd__and3_2
X_0496_ _0967_/Q _0496_/B vssd1 vssd1 vccd1 vccd1 _0504_/B sky130_fd_sc_hd__xnor2_2
XFILLER_0_80 vssd1 vssd1 vccd1 vccd1 sky130_fd_sc_hd__fill_2
XPHY_EDGE_ROW_3_Right_3 vssd1 vssd1 vccd1 vccd1 sky130_fd_sc_hd__decap_3
XFILLER_0_125 vssd1 vccd1 vssd1 vccd1 sky130_ef_sc_hd__decap_40_12
XFILLER_0_169 vssd1 vssd1 vccd1 vccd1 sky130_fd_sc_hd__fill_1
XFILLER_28_43 vssd1 vssd1 vccd1 vccd1 sky130_fd_sc_hd__fill_1
XFILLER_5_69 vssd1 vssd1 vccd1 vccd1 sky130_fd_sc_hd__fill_1
XFILLER_5_36 vssd1 vssd1 vccd1 vccd1 sky130_fd_sc_hd__fill_4
XANTENNA__0533__A2 _0513_/B vssd1 vssd1 vccd1 vccd1 sky130_fd_sc_hd__diode_2
XANTENNA__0993__RESET_B fanout65/X vssd1 vssd1 vccd1 vccd1 sky130_fd_sc_hd__diode_2
Xhold203 _1012_/Q vssd1 vssd1 vccd1 vccd1 hold203/X sky130_fd_sc_hd__dlygate4sd3_1
Xhold214 _0892_/Q vssd1 vssd1 vccd1 vccd1 hold214/X sky130_fd_sc_hd__dlygate4sd3_1
X_0617_ _0918_/Q _0617_/B vssd1 vssd1 vccd1 vccd1 _0618_/B sky130_fd_sc_hd__or2_2
X_0548_ _0939_/Q _0938_/Q _0941_/Q _0940_/Q vssd1 vssd1 vccd1 vccd1 _0708_/A sky130_fd_sc_hd__or4_2
X_0479_ _0962_/Q _0482_/B vssd1 vssd1 vccd1 vccd1 _0752_/A sky130_fd_sc_hd__and2_2
XFILLER_30_55 vssd1 vssd1 vccd1 vccd1 sky130_fd_sc_hd__fill_1
XANTENNA_input13_A gpio_in[7] vssd1 vssd1 vccd1 vccd1 sky130_fd_sc_hd__diode_2
XANTENNA_input5_A gpio_in[12] vssd1 vssd1 vccd1 vccd1 sky130_fd_sc_hd__diode_2
XFILLER_25_55 vssd1 vssd1 vccd1 vccd1 sky130_fd_sc_hd__fill_1
XFILLER_25_33 vssd1 vssd1 vccd1 vccd1 sky130_fd_sc_hd__fill_4
XFILLER_25_11 vssd1 vssd1 vccd1 vccd1 sky130_fd_sc_hd__fill_2
XFILLER_17_165 vssd1 vssd1 vccd1 vccd1 sky130_fd_sc_hd__fill_2
X_0951_ clkload7/A _0951_/D load_slew60/X vssd1 vssd1 vccd1 vccd1 _0951_/Q sky130_fd_sc_hd__dfrtp_2
X_0882_ _0882_/A _0882_/B vssd1 vssd1 vccd1 vccd1 _1004_/D sky130_fd_sc_hd__nor2_2
XTAP_TAPCELL_ROW_2_91 vssd1 vccd1 sky130_fd_sc_hd__tapvpwrvgnd_1
XFILLER_11_24 vssd1 vssd1 vccd1 vccd1 sky130_fd_sc_hd__fill_1
XFILLER_11_46 vssd1 vssd1 vccd1 vccd1 sky130_fd_sc_hd__fill_1
XFILLER_11_57 vssd1 vssd1 vccd1 vccd1 sky130_fd_sc_hd__fill_4
XANTENNA_fanout63_A fanout65/X vssd1 vssd1 vccd1 vccd1 sky130_fd_sc_hd__diode_2
XTAP_TAPCELL_ROW_15_152 vssd1 vccd1 sky130_fd_sc_hd__tapvpwrvgnd_1
X_0934_ _1019_/CLK input2/X load_slew62/X vssd1 vssd1 vccd1 vccd1 _0934_/Q sky130_fd_sc_hd__dfrtp_2
X_0865_ hold168/X _0884_/B1 _0864_/X vssd1 vssd1 vccd1 vccd1 _0996_/D sky130_fd_sc_hd__o21a_2
X_0796_ _0972_/Q _0856_/A1 _0794_/Y _0795_/X vssd1 vssd1 vccd1 vccd1 _0796_/X sky130_fd_sc_hd__a22o_2
Xwire31 wire31/A vssd1 vssd1 vccd1 vccd1 wire31/X sky130_fd_sc_hd__clkbuf_4
XTAP_TAPCELL_ROW_38_255 vssd1 vccd1 sky130_fd_sc_hd__tapvpwrvgnd_1
XFILLER_3_80 vssd1 vssd1 vccd1 vccd1 sky130_fd_sc_hd__fill_1
XFILLER_11_105 vssd1 vssd1 vccd1 vccd1 sky130_fd_sc_hd__fill_4
XTAP_TAPCELL_ROW_21_177 vssd1 vccd1 sky130_fd_sc_hd__tapvpwrvgnd_1
XFILLER_6_153 vssd1 vssd1 vccd1 vccd1 sky130_fd_sc_hd__fill_1
X_0650_ _0650_/A _0650_/B vssd1 vssd1 vccd1 vccd1 _0929_/D sky130_fd_sc_hd__and2_2
X_0581_ _0581_/A _0582_/B _0581_/C vssd1 vssd1 vccd1 vccd1 _0909_/D sky130_fd_sc_hd__nor3_2
Xclkbuf_4_1_0_clk clkbuf_0_clk/X vssd1 vssd1 vccd1 vccd1 clkload0/A sky130_fd_sc_hd__clkbuf_8
XFILLER_19_3 vssd1 vssd1 vccd1 vccd1 sky130_fd_sc_hd__fill_4
X_0917_ clkload8/A _0917_/D load_slew60/X vssd1 vssd1 vccd1 vccd1 _0917_/Q sky130_fd_sc_hd__dfrtp_2
X_0848_ _0856_/A1 _0987_/Q _0862_/B1 _0918_/Q _0864_/C1 vssd1 vssd1 vccd1 vccd1 _0848_/X
+ sky130_fd_sc_hd__a221o_2
X_0779_ hold197/X _0778_/X _0788_/S vssd1 vssd1 vccd1 vccd1 _0969_/D sky130_fd_sc_hd__mux2_1
XTAP_TAPCELL_ROW_26_203 vssd1 vccd1 sky130_fd_sc_hd__tapvpwrvgnd_1
XANTENNA_fanout26_A _0884_/B1 vssd1 vssd1 vccd1 vccd1 sky130_fd_sc_hd__diode_2
XFILLER_3_123 vssd1 vssd1 vccd1 vccd1 sky130_fd_sc_hd__fill_1
XANTENNA__0848__A1 _0856_/A1 vssd1 vssd1 vccd1 vccd1 sky130_fd_sc_hd__diode_2
XTAP_TAPCELL_ROW_32_228 vssd1 vccd1 sky130_fd_sc_hd__tapvpwrvgnd_1
X_0702_ _0707_/A _0708_/B _0723_/B vssd1 vssd1 vccd1 vccd1 _0702_/X sky130_fd_sc_hd__or3_2
X_0633_ _0635_/B _0633_/B _0636_/C vssd1 vssd1 vccd1 vccd1 _0923_/D sky130_fd_sc_hd__and3b_2
X_0564_ _1004_/Q _0880_/C _1005_/Q vssd1 vssd1 vccd1 vccd1 _0574_/B sky130_fd_sc_hd__nand3b_2
X_0495_ _0967_/Q _0496_/B vssd1 vssd1 vccd1 vccd1 _0768_/A sky130_fd_sc_hd__xor2_2
XFILLER_0_137 vssd1 vssd1 vccd1 vccd1 sky130_fd_sc_hd__fill_2
XFILLER_0_159 vssd1 vssd1 vccd1 vccd1 sky130_fd_sc_hd__fill_1
XFILLER_12_222 vssd1 vssd1 vccd1 vccd1 sky130_fd_sc_hd__fill_2
XFILLER_10_7 vssd1 vssd1 vccd1 vccd1 sky130_fd_sc_hd__fill_2
XPHY_EDGE_ROW_13_Right_13 vssd1 vssd1 vccd1 vccd1 sky130_fd_sc_hd__decap_3
XPHY_EDGE_ROW_22_Right_22 vssd1 vssd1 vccd1 vccd1 sky130_fd_sc_hd__decap_3
Xhold204 _0974_/Q vssd1 vssd1 vccd1 vccd1 hold204/X sky130_fd_sc_hd__dlygate4sd3_1
Xhold215 _1012_/Q vssd1 vssd1 vccd1 vccd1 hold215/X sky130_fd_sc_hd__dlygate4sd3_1
X_0616_ _0918_/Q _0617_/B vssd1 vssd1 vccd1 vccd1 _0622_/C sky130_fd_sc_hd__and2_2
X_0547_ _0934_/Q _0935_/Q _0937_/Q _0936_/Q vssd1 vssd1 vccd1 vccd1 _0707_/A sky130_fd_sc_hd__or4_2
X_0478_ _0449_/Y _0476_/Y _0497_/B _0519_/B vssd1 vssd1 vccd1 vccd1 _0482_/B sky130_fd_sc_hd__o2bb2ai_2
XPHY_EDGE_ROW_31_Right_31 vssd1 vssd1 vccd1 vccd1 sky130_fd_sc_hd__decap_3
XFILLER_14_57 vssd1 vssd1 vccd1 vccd1 sky130_fd_sc_hd__fill_2
XANTENNA_clkbuf_0_clk_X clkbuf_0_clk/X vssd1 vssd1 vccd1 vccd1 sky130_fd_sc_hd__diode_2
XFILLER_25_45 vssd1 vssd1 vccd1 vccd1 sky130_fd_sc_hd__fill_8
XFILLER_2_38 vssd1 vssd1 vccd1 vccd1 sky130_fd_sc_hd__fill_1
X_0950_ clkload7/A _0950_/D fanout63/X vssd1 vssd1 vccd1 vccd1 _0950_/Q sky130_fd_sc_hd__dfrtp_2
X_0881_ _1005_/Q _0878_/Y _1004_/Q vssd1 vssd1 vccd1 vccd1 _0882_/B sky130_fd_sc_hd__o21ba_2
XTAP_TAPCELL_ROW_2_92 vssd1 vccd1 sky130_fd_sc_hd__tapvpwrvgnd_1
XFILLER_23_169 vssd1 vssd1 vccd1 vccd1 sky130_fd_sc_hd__fill_2
XFILLER_2_9 vssd1 vssd1 vccd1 vccd1 sky130_fd_sc_hd__fill_8
XFILLER_35_9 vssd1 vccd1 vssd1 vccd1 sky130_ef_sc_hd__decap_40_12
XTAP_TAPCELL_ROW_15_153 vssd1 vccd1 sky130_fd_sc_hd__tapvpwrvgnd_1
X_0933_ _1011_/CLK _0933_/D fanout69/X vssd1 vssd1 vccd1 vccd1 _0933_/Q sky130_fd_sc_hd__dfrtp_2
X_0864_ _0741_/B _0995_/Q _0842_/B _0926_/Q _0864_/C1 vssd1 vssd1 vccd1 vccd1 _0864_/X
+ sky130_fd_sc_hd__a221o_2
X_0795_ _0794_/A _0794_/B _0795_/B1 vssd1 vssd1 vccd1 vccd1 _0795_/X sky130_fd_sc_hd__o21a_2
Xwire32 wire32/A vssd1 vssd1 vccd1 vccd1 wire32/X sky130_fd_sc_hd__clkbuf_2
XTAP_TAPCELL_ROW_38_256 vssd1 vccd1 sky130_fd_sc_hd__tapvpwrvgnd_1
XFILLER_11_117 vssd1 vssd1 vccd1 vccd1 sky130_fd_sc_hd__fill_2
XTAP_TAPCELL_ROW_21_178 vssd1 vccd1 sky130_fd_sc_hd__tapvpwrvgnd_1
XFILLER_22_24 vssd1 vssd1 vccd1 vccd1 sky130_fd_sc_hd__fill_4
XTAP_TAPCELL_ROW_6_110 vssd1 vccd1 sky130_fd_sc_hd__tapvpwrvgnd_1
XFILLER_8_37 vssd1 vssd1 vccd1 vccd1 sky130_fd_sc_hd__fill_1
X_0580_ _0907_/Q _0908_/Q hold189/X vssd1 vssd1 vccd1 vccd1 _0580_/Y sky130_fd_sc_hd__a21oi_2
XFILLER_33_6 vssd1 vssd1 vccd1 vccd1 sky130_fd_sc_hd__fill_4
X_0916_ clkload8/A _0916_/D load_slew60/X vssd1 vssd1 vccd1 vccd1 _0916_/Q sky130_fd_sc_hd__dfrtp_2
X_0847_ hold174/X _0842_/C _0846_/X vssd1 vssd1 vccd1 vccd1 _0987_/D sky130_fd_sc_hd__o21a_2
X_0778_ _0795_/B1 _0775_/X _0777_/Y _0787_/B2 _0968_/Q vssd1 vssd1 vccd1 vccd1 _0778_/X
+ sky130_fd_sc_hd__a32o_2
XPHY_EDGE_ROW_9_Left_48 vssd1 vssd1 vccd1 vccd1 sky130_fd_sc_hd__decap_3
XFILLER_24_253 vssd1 vssd1 vccd1 vccd1 sky130_fd_sc_hd__fill_2
XFILLER_17_68 vssd1 vssd1 vccd1 vccd1 sky130_fd_sc_hd__fill_8
XFILLER_17_24 vssd1 vssd1 vccd1 vccd1 sky130_fd_sc_hd__fill_2
XFILLER_3_113 vssd1 vssd1 vccd1 vccd1 sky130_fd_sc_hd__fill_2
XTAP_TAPCELL_ROW_32_229 vssd1 vccd1 sky130_fd_sc_hd__tapvpwrvgnd_1
X_0701_ _0697_/Y _0700_/X _0553_/A vssd1 vssd1 vccd1 vccd1 _0712_/A sky130_fd_sc_hd__o21ai_2
X_0632_ _0922_/Q _0921_/Q _0626_/B _0923_/Q vssd1 vssd1 vccd1 vccd1 _0633_/B sky130_fd_sc_hd__a31o_2
X_0563_ _1001_/Q _1002_/Q _1003_/Q vssd1 vssd1 vccd1 vccd1 _0880_/C sky130_fd_sc_hd__and3_2
X_0494_ _0967_/Q _0496_/B vssd1 vssd1 vccd1 vccd1 _0494_/Y sky130_fd_sc_hd__nand2_2
XFILLER_31_3 vssd1 vssd1 vccd1 vccd1 sky130_fd_sc_hd__fill_2
XFILLER_12_234 vssd1 vssd1 vccd1 vccd1 sky130_fd_sc_hd__fill_1
XFILLER_8_227 vssd1 vssd1 vccd1 vccd1 sky130_fd_sc_hd__fill_4
Xclkbuf_4_0_0_clk clkbuf_0_clk/X vssd1 vssd1 vccd1 vccd1 _0970_/CLK sky130_fd_sc_hd__clkbuf_8
Xhold205 _1007_/Q vssd1 vssd1 vccd1 vccd1 hold205/X sky130_fd_sc_hd__dlygate4sd3_1
Xhold216 _0897_/Q vssd1 vssd1 vccd1 vccd1 hold216/X sky130_fd_sc_hd__dlygate4sd3_1
X_0615_ _0617_/B _0615_/B _0636_/C vssd1 vssd1 vccd1 vccd1 _0917_/D sky130_fd_sc_hd__and3b_2
X_0546_ _0546_/A input1/X vssd1 vssd1 vccd1 vccd1 _0546_/X sky130_fd_sc_hd__and2_2
X_0477_ _0949_/Q _0951_/Q vssd1 vssd1 vccd1 vccd1 _0497_/B sky130_fd_sc_hd__and2b_2
XFILLER_14_36 vssd1 vssd1 vccd1 vccd1 sky130_fd_sc_hd__fill_4
XANTENNA_fanout41_X _0856_/A1 vssd1 vssd1 vccd1 vccd1 sky130_fd_sc_hd__diode_2
X_0529_ _0532_/A _0777_/B _0780_/B vssd1 vssd1 vccd1 vccd1 _0529_/X sky130_fd_sc_hd__and3_2
XPHY_EDGE_ROW_38_Left_77 vssd1 vssd1 vccd1 vccd1 sky130_fd_sc_hd__decap_3
XFILLER_25_57 vssd1 vssd1 vccd1 vccd1 sky130_fd_sc_hd__fill_2
XFILLER_9_3 vssd1 vssd1 vccd1 vccd1 sky130_fd_sc_hd__fill_8
XFILLER_2_17 vssd1 vssd1 vccd1 vccd1 sky130_fd_sc_hd__fill_2
XFILLER_17_167 vssd1 vssd1 vccd1 vccd1 sky130_fd_sc_hd__fill_1
X_0880_ _1004_/Q _1015_/Q _0880_/C vssd1 vssd1 vccd1 vccd1 _0882_/A sky130_fd_sc_hd__and3_2
XTAP_TAPCELL_ROW_2_93 vssd1 vccd1 sky130_fd_sc_hd__tapvpwrvgnd_1
XFILLER_23_137 vssd1 vssd1 vccd1 vccd1 sky130_fd_sc_hd__fill_4
X_0932_ _1011_/CLK _0932_/D wire67/A vssd1 vssd1 vccd1 vccd1 _0932_/Q sky130_fd_sc_hd__dfrtp_2
X_0863_ hold173/X _0842_/C _0862_/X vssd1 vssd1 vccd1 vccd1 _0995_/D sky130_fd_sc_hd__o21a_2
X_0794_ _0794_/A _0794_/B vssd1 vssd1 vccd1 vccd1 _0794_/Y sky130_fd_sc_hd__nand2_2
XTAP_TAPCELL_ROW_38_257 vssd1 vccd1 sky130_fd_sc_hd__tapvpwrvgnd_1
XTAP_TAPCELL_ROW_21_179 vssd1 vccd1 sky130_fd_sc_hd__tapvpwrvgnd_1
XTAP_TAPCELL_ROW_6_111 vssd1 vccd1 sky130_fd_sc_hd__tapvpwrvgnd_1
XTAP_TAPCELL_ROW_29_213 vssd1 vccd1 sky130_fd_sc_hd__tapvpwrvgnd_1
XFILLER_10_151 vssd1 vssd1 vccd1 vccd1 sky130_fd_sc_hd__fill_1
XFILLER_6_166 vssd1 vssd1 vccd1 vccd1 sky130_fd_sc_hd__fill_8
XPHY_EDGE_ROW_25_Left_64 vssd1 vssd1 vccd1 vccd1 sky130_fd_sc_hd__decap_3
XFILLER_33_254 vssd1 vssd1 vccd1 vccd1 sky130_fd_sc_hd__fill_1
X_0915_ clkload8/A _0915_/D load_slew60/X vssd1 vssd1 vccd1 vccd1 _0915_/Q sky130_fd_sc_hd__dfrtp_2
X_0846_ _0856_/A1 _0986_/Q _0862_/B1 _0917_/Q _0864_/C1 vssd1 vssd1 vccd1 vccd1 _0846_/X
+ sky130_fd_sc_hd__a221o_2
X_0777_ _0777_/A _0777_/B vssd1 vssd1 vccd1 vccd1 _0777_/Y sky130_fd_sc_hd__nand2_2
XFILLER_3_169 vssd1 vssd1 vccd1 vccd1 sky130_fd_sc_hd__fill_2
XFILLER_3_136 vssd1 vssd1 vccd1 vccd1 sky130_fd_sc_hd__fill_8
XANTENNA__0481__B2 _0448_/B vssd1 vssd1 vccd1 vccd1 sky130_fd_sc_hd__diode_2
X_0700_ _0944_/Q _0550_/Y _0699_/Y _0553_/B vssd1 vssd1 vccd1 vccd1 _0700_/X sky130_fd_sc_hd__a31o_2
X_0631_ _0923_/Q _0922_/Q _0631_/C vssd1 vssd1 vccd1 vccd1 _0635_/B sky130_fd_sc_hd__and3_2
X_0562_ hold188/X _0696_/A _0560_/X _0561_/X vssd1 vssd1 vccd1 vccd1 _1019_/D sky130_fd_sc_hd__a22o_2
X_0493_ _0514_/A _0444_/Y _0492_/X vssd1 vssd1 vccd1 vccd1 _0595_/B sky130_fd_sc_hd__o21ai_2
XFILLER_24_3 vssd1 vssd1 vccd1 vccd1 sky130_fd_sc_hd__fill_1
X_0829_ hold209/X _0838_/A2 _0792_/X _0828_/X vssd1 vssd1 vccd1 vccd1 _0981_/D sky130_fd_sc_hd__a22o_2
XFILLER_0_139 vssd1 vssd1 vccd1 vccd1 sky130_fd_sc_hd__fill_1
XANTENNA__0746__B _0749_/B vssd1 vssd1 vccd1 vccd1 sky130_fd_sc_hd__diode_2
XFILLER_28_68 vssd1 vssd1 vccd1 vccd1 sky130_fd_sc_hd__fill_8
XFILLER_28_57 vssd1 vssd1 vccd1 vccd1 sky130_fd_sc_hd__fill_2
Xhold206 _1010_/Q vssd1 vssd1 vccd1 vccd1 hold206/X sky130_fd_sc_hd__dlygate4sd3_1
X_0614_ _0916_/Q _0915_/Q _0917_/Q vssd1 vssd1 vccd1 vccd1 _0615_/B sky130_fd_sc_hd__a21o_2
X_0545_ _0984_/Q _0836_/B hold147/X vssd1 vssd1 vccd1 vccd1 _1018_/D sky130_fd_sc_hd__o21a_2
X_0476_ _0472_/A _0952_/Q vssd1 vssd1 vccd1 vccd1 _0476_/Y sky130_fd_sc_hd__nand2b_2
XPHY_EDGE_ROW_7_Right_7 vssd1 vssd1 vccd1 vccd1 sky130_fd_sc_hd__decap_3
XPHY_EDGE_ROW_12_Left_51 vssd1 vssd1 vccd1 vccd1 sky130_fd_sc_hd__decap_3
XFILLER_30_58 vssd1 vssd1 vccd1 vccd1 sky130_fd_sc_hd__fill_1
XFILLER_30_36 vssd1 vssd1 vccd1 vccd1 sky130_fd_sc_hd__fill_1
XFILLER_35_113 vssd1 vssd1 vccd1 vccd1 sky130_fd_sc_hd__fill_1
XFILLER_6_82 vssd1 vssd1 vccd1 vccd1 sky130_fd_sc_hd__fill_2
XFILLER_6_71 vssd1 vssd1 vccd1 vccd1 sky130_fd_sc_hd__fill_1
X_0528_ _0532_/B _0531_/B vssd1 vssd1 vccd1 vccd1 _0780_/B sky130_fd_sc_hd__and2_2
X_0459_ _0460_/A _0460_/B vssd1 vssd1 vccd1 vccd1 _0794_/A sky130_fd_sc_hd__and2_2
XANTENNA_input11_A gpio_in[5] vssd1 vssd1 vccd1 vccd1 sky130_fd_sc_hd__diode_2
XFILLER_17_113 vssd1 vssd1 vccd1 vccd1 sky130_fd_sc_hd__fill_1
XTAP_TAPCELL_ROW_2_94 vssd1 vccd1 sky130_fd_sc_hd__tapvpwrvgnd_1
XTAP_TAPCELL_ROW_18_163 vssd1 vccd1 sky130_fd_sc_hd__tapvpwrvgnd_1
XFILLER_11_38 vssd1 vssd1 vccd1 vccd1 sky130_fd_sc_hd__fill_8
XANTENNA_input3_A gpio_in[10] vssd1 vssd1 vccd1 vccd1 sky130_fd_sc_hd__diode_2
X_0931_ _0960_/CLK _0931_/D fanout69/X vssd1 vssd1 vccd1 vccd1 _0931_/Q sky130_fd_sc_hd__dfrtp_2
X_0862_ _0741_/B _0994_/Q _0862_/B1 _0925_/Q _0864_/C1 vssd1 vssd1 vccd1 vccd1 _0862_/X
+ sky130_fd_sc_hd__a221o_2
XFILLER_9_164 vssd1 vssd1 vccd1 vccd1 sky130_fd_sc_hd__fill_4
XFILLER_9_153 vssd1 vssd1 vccd1 vccd1 sky130_fd_sc_hd__fill_2
X_0793_ _0972_/Q _0838_/A2 _0791_/X _0792_/X vssd1 vssd1 vccd1 vccd1 _0972_/D sky130_fd_sc_hd__a22o_2
Xwire67 wire67/A vssd1 vssd1 vccd1 vccd1 wire67/X sky130_fd_sc_hd__clkbuf_4
XTAP_TAPCELL_ROW_38_258 vssd1 vccd1 sky130_fd_sc_hd__tapvpwrvgnd_1
XANTENNA__0749__B _0749_/B vssd1 vssd1 vccd1 vccd1 sky130_fd_sc_hd__diode_2
XTAP_TAPCELL_ROW_6_112 vssd1 vccd1 sky130_fd_sc_hd__tapvpwrvgnd_1
XTAP_TAPCELL_ROW_29_214 vssd1 vccd1 sky130_fd_sc_hd__tapvpwrvgnd_1
XFILLER_10_141 vssd1 vssd1 vccd1 vccd1 sky130_fd_sc_hd__fill_8
XTAP_TAPCELL_ROW_12_136 vssd1 vccd1 sky130_fd_sc_hd__tapvpwrvgnd_1
X_0914_ clkload4/A _0914_/D load_slew53/X vssd1 vssd1 vccd1 vccd1 _0914_/Q sky130_fd_sc_hd__dfrtp_2
X_0845_ hold175/X _0842_/C _0844_/X vssd1 vssd1 vccd1 vccd1 _0986_/D sky130_fd_sc_hd__o21a_2
X_0776_ _0777_/A _0777_/B vssd1 vssd1 vccd1 vccd1 _0780_/C sky130_fd_sc_hd__and2_2
XFILLER_15_233 vssd1 vssd1 vccd1 vccd1 sky130_fd_sc_hd__fill_1
X_0630_ _0636_/C _0630_/B _0630_/C vssd1 vssd1 vccd1 vccd1 _0922_/D sky130_fd_sc_hd__and3_2
X_0561_ _0960_/Q _0696_/A _0959_/Q _0435_/Y vssd1 vssd1 vccd1 vccd1 _0561_/X sky130_fd_sc_hd__o22a_2
X_0492_ _0949_/Q _0473_/C _0497_/B _0952_/Q vssd1 vssd1 vccd1 vccd1 _0492_/X sky130_fd_sc_hd__a211o_2
XFILLER_31_5 vssd1 vssd1 vccd1 vccd1 sky130_fd_sc_hd__fill_1
XFILLER_2_170 vssd1 vssd1 vccd1 vccd1 sky130_fd_sc_hd__fill_1
XFILLER_0_40 vssd1 vssd1 vccd1 vccd1 sky130_fd_sc_hd__fill_2
XFILLER_17_3 vssd1 vssd1 vccd1 vccd1 sky130_fd_sc_hd__fill_4
X_0828_ _0980_/Q _1016_/D _0827_/Y _0741_/A vssd1 vssd1 vccd1 vccd1 _0828_/X sky130_fd_sc_hd__a22o_2
X_0759_ _0760_/A _0760_/B vssd1 vssd1 vccd1 vccd1 _0759_/X sky130_fd_sc_hd__or2_2
Xhold207 _1011_/Q vssd1 vssd1 vccd1 vccd1 hold207/X sky130_fd_sc_hd__dlygate4sd3_1
X_0613_ _0917_/Q _0916_/Q _0915_/Q vssd1 vssd1 vccd1 vccd1 _0617_/B sky130_fd_sc_hd__and3_2
X_0544_ _0984_/Q _0836_/B vssd1 vssd1 vccd1 vccd1 _0544_/Y sky130_fd_sc_hd__nor2_2
X_0475_ _0963_/Q _0485_/B vssd1 vssd1 vccd1 vccd1 _0487_/A sky130_fd_sc_hd__nand2_2
XFILLER_38_100 vssd1 vssd1 vccd1 vccd1 sky130_fd_sc_hd__fill_4
XFILLER_29_188 vssd1 vssd1 vccd1 vccd1 sky130_fd_sc_hd__fill_2
XANTENNA_fanout27_X _0884_/B1 vssd1 vssd1 vccd1 vccd1 sky130_fd_sc_hd__diode_2
XFILLER_6_94 vssd1 vccd1 vssd1 vccd1 sky130_ef_sc_hd__decap_40_12
X_0527_ _0970_/Q _0527_/B vssd1 vssd1 vccd1 vccd1 _0531_/B sky130_fd_sc_hd__nand2_2
X_0458_ _0973_/Q _0458_/B vssd1 vssd1 vccd1 vccd1 _0460_/B sky130_fd_sc_hd__or2_2
XFILLER_25_37 vssd1 vssd1 vccd1 vccd1 sky130_fd_sc_hd__fill_1
XTAP_TAPCELL_ROW_2_95 vssd1 vccd1 sky130_fd_sc_hd__tapvpwrvgnd_1
XTAP_TAPCELL_ROW_18_164 vssd1 vccd1 sky130_fd_sc_hd__tapvpwrvgnd_1
XFILLER_14_139 vssd1 vssd1 vccd1 vccd1 sky130_fd_sc_hd__fill_1
X_0930_ clkload2/A _0930_/D load_slew56/X vssd1 vssd1 vccd1 vccd1 _0930_/Q sky130_fd_sc_hd__dfrtp_2
X_0861_ hold172/X _0842_/C _0860_/X vssd1 vssd1 vccd1 vccd1 _0994_/D sky130_fd_sc_hd__o21a_2
X_0792_ _0745_/A _1016_/D _0839_/B vssd1 vssd1 vccd1 vccd1 _0792_/X sky130_fd_sc_hd__o21a_2
XANTENNA__0869__A2 _0884_/B1 vssd1 vssd1 vccd1 vccd1 sky130_fd_sc_hd__diode_2
XTAP_TAPCELL_ROW_38_259 vssd1 vccd1 sky130_fd_sc_hd__tapvpwrvgnd_1
XFILLER_3_62 vssd1 vssd1 vccd1 vccd1 sky130_fd_sc_hd__fill_1
XFILLER_36_253 vssd1 vssd1 vccd1 vccd1 sky130_fd_sc_hd__fill_2
XFILLER_11_109 vssd1 vssd1 vccd1 vccd1 sky130_fd_sc_hd__fill_2
XFILLER_0_9 vssd1 vssd1 vccd1 vccd1 sky130_fd_sc_hd__fill_1
XTAP_TAPCELL_ROW_6_113 vssd1 vccd1 sky130_fd_sc_hd__tapvpwrvgnd_1
XANTENNA_fanout54_A fanout58/X vssd1 vssd1 vccd1 vccd1 sky130_fd_sc_hd__diode_2
XTAP_TAPCELL_ROW_29_215 vssd1 vccd1 sky130_fd_sc_hd__tapvpwrvgnd_1
XPHY_EDGE_ROW_29_Right_29 vssd1 vssd1 vccd1 vccd1 sky130_fd_sc_hd__decap_3
XTAP_TAPCELL_ROW_12_137 vssd1 vccd1 sky130_fd_sc_hd__tapvpwrvgnd_1
XPHY_EDGE_ROW_38_Right_38 vssd1 vssd1 vccd1 vccd1 sky130_fd_sc_hd__decap_3
XFILLER_19_7 vssd1 vssd1 vccd1 vccd1 sky130_fd_sc_hd__fill_2
XFILLER_18_253 vssd1 vssd1 vccd1 vccd1 sky130_fd_sc_hd__fill_2
X_0913_ clkload4/A _0913_/D load_slew53/X vssd1 vssd1 vccd1 vccd1 _0913_/Q sky130_fd_sc_hd__dfrtp_2
X_0844_ _0856_/A1 _0985_/Q _0862_/B1 _0916_/Q _0864_/C1 vssd1 vssd1 vccd1 vccd1 _0844_/X
+ sky130_fd_sc_hd__a221o_2
X_0775_ _0777_/A _0777_/B vssd1 vssd1 vccd1 vccd1 _0775_/X sky130_fd_sc_hd__or2_2
XFILLER_23_81 vssd1 vssd1 vccd1 vccd1 sky130_fd_sc_hd__fill_4
X_0560_ _0958_/Q _0432_/Y _0959_/Q _0435_/Y _0559_/X vssd1 vssd1 vccd1 vccd1 _0560_/X
+ sky130_fd_sc_hd__a221o_2
X_0491_ _0949_/Q _0473_/C _0497_/B vssd1 vssd1 vccd1 vccd1 _0491_/X sky130_fd_sc_hd__a21o_2
XFILLER_0_85 vssd1 vssd1 vccd1 vccd1 sky130_fd_sc_hd__fill_1
XFILLER_9_72 vssd1 vccd1 vssd1 vccd1 sky130_ef_sc_hd__decap_40_12
X_0827_ _0830_/B _0827_/B vssd1 vssd1 vccd1 vccd1 _0827_/Y sky130_fd_sc_hd__nand2_2
X_0758_ _0964_/Q _0757_/X _0788_/S vssd1 vssd1 vccd1 vccd1 _0964_/D sky130_fd_sc_hd__mux2_1
X_0689_ _0689_/A _0689_/B vssd1 vssd1 vccd1 vccd1 _0690_/B sky130_fd_sc_hd__nor2_2
XFILLER_28_59 vssd1 vssd1 vccd1 vccd1 sky130_fd_sc_hd__fill_1
Xhold208 _1008_/Q vssd1 vssd1 vccd1 vccd1 hold208/X sky130_fd_sc_hd__dlygate4sd3_1
X_0612_ _0636_/C _0612_/B _0612_/C vssd1 vssd1 vccd1 vccd1 _0916_/D sky130_fd_sc_hd__and3_2
X_0543_ _0537_/X _0538_/Y _0825_/D _0542_/D _0983_/Q vssd1 vssd1 vccd1 vccd1 _0836_/B
+ sky130_fd_sc_hd__a2111o_2
X_0474_ _0449_/Y _0473_/X _0519_/B vssd1 vssd1 vccd1 vccd1 _0485_/B sky130_fd_sc_hd__a21o_2
XFILLER_20_82 vssd1 vssd1 vccd1 vccd1 sky130_fd_sc_hd__fill_2
X_0526_ _0970_/Q _0527_/B vssd1 vssd1 vccd1 vccd1 _0532_/B sky130_fd_sc_hd__or2_2
X_0457_ _0454_/A _0461_/B _0453_/Y _0463_/B _0976_/Q vssd1 vssd1 vccd1 vccd1 _0825_/B
+ sky130_fd_sc_hd__a311o_2
X_1009_ _1011_/CLK _1009_/D fanout68/X vssd1 vssd1 vccd1 vccd1 _1009_/Q sky130_fd_sc_hd__dfrtp_2
XFILLER_34_170 vssd1 vssd1 vccd1 vccd1 sky130_fd_sc_hd__fill_1
Xteam_05_90 vssd1 vssd1 vccd1 vccd1 team_05_90/HI gpio_out[16] sky130_fd_sc_hd__conb_1
XTAP_TAPCELL_ROW_18_165 vssd1 vccd1 sky130_fd_sc_hd__tapvpwrvgnd_1
X_0509_ _0968_/Q _0490_/B _0496_/B _0967_/Q vssd1 vssd1 vccd1 vccd1 _0509_/X sky130_fd_sc_hd__o211a_2
XFILLER_14_107 vssd1 vssd1 vccd1 vccd1 sky130_fd_sc_hd__fill_8
XFILLER_7_3 vssd1 vssd1 vccd1 vccd1 sky130_fd_sc_hd__fill_4
X_0860_ _0860_/A1 _0993_/Q _0862_/B1 _0924_/Q _0864_/C1 vssd1 vssd1 vccd1 vccd1 _0860_/X
+ sky130_fd_sc_hd__a221o_2
X_0791_ _0795_/B1 _0789_/Y _0790_/X _0856_/A1 _0971_/Q vssd1 vssd1 vccd1 vccd1 _0791_/X
+ sky130_fd_sc_hd__a32o_2
XFILLER_9_155 vssd1 vssd1 vccd1 vccd1 sky130_fd_sc_hd__fill_1
XFILLER_9_111 vssd1 vssd1 vccd1 vccd1 sky130_fd_sc_hd__fill_1
X_0989_ clkload9/A _0989_/D fanout61/X vssd1 vssd1 vccd1 vccd1 _0989_/Q sky130_fd_sc_hd__dfrtp_2
XTAP_TAPCELL_ROW_29_216 vssd1 vccd1 sky130_fd_sc_hd__tapvpwrvgnd_1
XANTENNA__0796__A2 _0856_/A1 vssd1 vssd1 vccd1 vccd1 sky130_fd_sc_hd__diode_2
XTAP_TAPCELL_ROW_12_138 vssd1 vccd1 sky130_fd_sc_hd__tapvpwrvgnd_1
XFILLER_6_114 vssd1 vssd1 vccd1 vccd1 sky130_fd_sc_hd__fill_1
X_0912_ clkload4/A _0912_/D fanout57/X vssd1 vssd1 vccd1 vccd1 _0912_/Q sky130_fd_sc_hd__dfrtp_2
X_0843_ hold163/X _0864_/C1 _0842_/X vssd1 vssd1 vccd1 vccd1 _0985_/D sky130_fd_sc_hd__a21o_2
X_0774_ _0968_/Q _0773_/X _0788_/S vssd1 vssd1 vccd1 vccd1 _0968_/D sky130_fd_sc_hd__mux2_1
XFILLER_17_39 vssd1 vssd1 vccd1 vccd1 sky130_fd_sc_hd__fill_1
XPHY_EDGE_ROW_29_Left_68 vssd1 vssd1 vccd1 vccd1 sky130_fd_sc_hd__decap_3
X_0490_ _0968_/Q _0490_/B vssd1 vssd1 vccd1 vccd1 _0772_/A sky130_fd_sc_hd__xnor2_2
XFILLER_0_97 vssd1 vccd1 vssd1 vccd1 sky130_ef_sc_hd__decap_40_12
XTAP_TAPCELL_ROW_31_222 vssd1 vccd1 sky130_fd_sc_hd__tapvpwrvgnd_1
XFILLER_9_84 vssd1 vssd1 vccd1 vccd1 sky130_fd_sc_hd__fill_4
XANTENNA_clkbuf_4_6_0_clk_A clkbuf_0_clk/X vssd1 vssd1 vccd1 vccd1 sky130_fd_sc_hd__diode_2
XFILLER_0_109 vssd1 vssd1 vccd1 vccd1 sky130_fd_sc_hd__fill_2
X_0826_ _0825_/B _0826_/A2 _0825_/D _0981_/Q vssd1 vssd1 vccd1 vccd1 _0827_/B sky130_fd_sc_hd__o31ai_2
X_0757_ _0795_/B1 _0755_/Y _0756_/X _0787_/B2 _0963_/Q vssd1 vssd1 vccd1 vccd1 _0757_/X
+ sky130_fd_sc_hd__a32o_2
X_0688_ _0689_/B _0688_/B vssd1 vssd1 vccd1 vccd1 _0893_/D sky130_fd_sc_hd__nor2_2
Xclkbuf_4_15_0_clk clkbuf_0_clk/X vssd1 vssd1 vccd1 vccd1 _1020_/CLK sky130_fd_sc_hd__clkbuf_8
XFILLER_28_27 vssd1 vssd1 vccd1 vccd1 sky130_fd_sc_hd__fill_1
XFILLER_18_82 vssd1 vssd1 vccd1 vccd1 sky130_fd_sc_hd__fill_2
Xhold209 _0981_/Q vssd1 vssd1 vccd1 vccd1 hold209/X sky130_fd_sc_hd__dlygate4sd3_1
X_0611_ _0916_/Q _0915_/Q vssd1 vssd1 vccd1 vccd1 _0612_/C sky130_fd_sc_hd__nand2_2
X_0542_ _0825_/B _0825_/C _0825_/D _0542_/D vssd1 vssd1 vccd1 vccd1 _0833_/B sky130_fd_sc_hd__or4_2
X_0473_ _0514_/A _0949_/Q _0473_/C vssd1 vssd1 vccd1 vccd1 _0473_/X sky130_fd_sc_hd__or3_2
XFILLER_22_3 vssd1 vssd1 vccd1 vccd1 sky130_fd_sc_hd__fill_4
XANTENNA__0850__A1 _0856_/A1 vssd1 vssd1 vccd1 vccd1 sky130_fd_sc_hd__diode_2
Xload_slew70 fanout69/X vssd1 vssd1 vccd1 vccd1 load_slew70/X sky130_fd_sc_hd__clkbuf_4
X_0809_ _0741_/A _0807_/X _0808_/Y _0823_/B1 _0975_/Q vssd1 vssd1 vccd1 vccd1 _0809_/X
+ sky130_fd_sc_hd__a32o_2
XFILLER_29_146 vssd1 vssd1 vccd1 vccd1 sky130_fd_sc_hd__fill_1
XFILLER_29_113 vssd1 vssd1 vccd1 vccd1 sky130_fd_sc_hd__fill_4
XFILLER_20_50 vssd1 vssd1 vccd1 vccd1 sky130_fd_sc_hd__fill_8
X_0525_ _0951_/Q _0514_/Y _0524_/Y vssd1 vssd1 vccd1 vccd1 _0527_/B sky130_fd_sc_hd__o21ai_2
X_0456_ _0463_/B vssd1 vssd1 vccd1 vccd1 _0808_/B sky130_fd_sc_hd__inv_2
XPHY_EDGE_ROW_16_Left_55 vssd1 vssd1 vccd1 vccd1 sky130_fd_sc_hd__decap_3
X_1008_ clkload6/A _1008_/D fanout68/X vssd1 vssd1 vccd1 vccd1 _1008_/Q sky130_fd_sc_hd__dfrtp_2
Xteam_05_91 vssd1 vssd1 vccd1 vccd1 team_05_91/HI gpio_out[17] sky130_fd_sc_hd__conb_1
Xteam_05_80 vssd1 vssd1 vccd1 vccd1 team_05_80/HI gpio_out[5] sky130_fd_sc_hd__conb_1
XFILLER_25_182 vssd1 vssd1 vccd1 vccd1 sky130_fd_sc_hd__fill_2
XANTENNA_clkbuf_4_14_0_clk_A clkbuf_0_clk/X vssd1 vssd1 vccd1 vccd1 sky130_fd_sc_hd__diode_2
XFILLER_16_193 vssd1 vssd1 vccd1 vccd1 sky130_fd_sc_hd__fill_2
XTAP_TAPCELL_ROW_18_166 vssd1 vccd1 sky130_fd_sc_hd__tapvpwrvgnd_1
XFILLER_23_119 vssd1 vssd1 vccd1 vccd1 sky130_fd_sc_hd__fill_1
X_0508_ _0772_/A _0499_/Y _0508_/C _0768_/A vssd1 vssd1 vccd1 vccd1 _0508_/X sky130_fd_sc_hd__and4bb_2
X_0439_ _1006_/Q vssd1 vssd1 vccd1 vccd1 _0439_/Y sky130_fd_sc_hd__inv_2
XTAP_TAPCELL_ROW_9_123 vssd1 vccd1 sky130_fd_sc_hd__tapvpwrvgnd_1
XFILLER_13_174 vssd1 vssd1 vccd1 vccd1 sky130_fd_sc_hd__fill_1
X_0790_ _0790_/A _0790_/B _0790_/C vssd1 vssd1 vccd1 vccd1 _0790_/X sky130_fd_sc_hd__or3_2
X_0988_ clkload9/A _0988_/D load_slew62/X vssd1 vssd1 vccd1 vccd1 _0988_/Q sky130_fd_sc_hd__dfrtp_2
XFILLER_22_29 vssd1 vssd1 vccd1 vccd1 sky130_fd_sc_hd__fill_4
XANTENNA_input1_A en vssd1 vssd1 vccd1 vccd1 sky130_fd_sc_hd__diode_2
XTAP_TAPCELL_ROW_37_250 vssd1 vccd1 sky130_fd_sc_hd__tapvpwrvgnd_1
XTAP_TAPCELL_ROW_20_172 vssd1 vccd1 sky130_fd_sc_hd__tapvpwrvgnd_1
XTAP_TAPCELL_ROW_12_139 vssd1 vccd1 sky130_fd_sc_hd__tapvpwrvgnd_1
XFILLER_6_126 vssd1 vccd1 vssd1 vccd1 sky130_ef_sc_hd__decap_40_12
XFILLER_37_70 vssd1 vssd1 vccd1 vccd1 sky130_fd_sc_hd__fill_4
XFILLER_18_222 vssd1 vssd1 vccd1 vccd1 sky130_fd_sc_hd__fill_1
X_0911_ clkload4/A _0911_/D fanout57/X vssd1 vssd1 vccd1 vccd1 _0911_/Q sky130_fd_sc_hd__dfrtp_2
X_0842_ _0915_/Q _0842_/B _0842_/C vssd1 vssd1 vccd1 vccd1 _0842_/X sky130_fd_sc_hd__and3_2
X_0773_ _0967_/Q _0787_/B2 _0772_/Y _0795_/B1 vssd1 vssd1 vccd1 vccd1 _0773_/X sky130_fd_sc_hd__a22o_2
XFILLER_5_181 vssd1 vssd1 vccd1 vccd1 sky130_fd_sc_hd__fill_1
XANTENNA_clkbuf_4_2_0_clk_A clkbuf_0_clk/X vssd1 vssd1 vccd1 vccd1 sky130_fd_sc_hd__diode_2
XFILLER_3_107 vssd1 vssd1 vccd1 vccd1 sky130_fd_sc_hd__fill_1
XPHY_EDGE_ROW_4_Left_43 vssd1 vssd1 vccd1 vccd1 sky130_fd_sc_hd__decap_3
XFILLER_0_32 vssd1 vssd1 vccd1 vccd1 sky130_fd_sc_hd__fill_8
X_0825_ _0981_/Q _0825_/B _0825_/C _0825_/D vssd1 vssd1 vccd1 vccd1 _0830_/B sky130_fd_sc_hd__or4_2
XTAP_TAPCELL_ROW_31_223 vssd1 vccd1 sky130_fd_sc_hd__tapvpwrvgnd_1
X_0756_ _0755_/A _0755_/B _0755_/C vssd1 vssd1 vccd1 vccd1 _0756_/X sky130_fd_sc_hd__a21o_2
X_0687_ _1020_/Q hold214/X hold186/X vssd1 vssd1 vccd1 vccd1 _0688_/B sky130_fd_sc_hd__a21oi_2
XPHY_EDGE_ROW_30_Left_69 vssd1 vssd1 vccd1 vccd1 sky130_fd_sc_hd__decap_3
XFILLER_34_93 vssd1 vssd1 vccd1 vccd1 sky130_fd_sc_hd__fill_1
X_0610_ _0916_/Q _0915_/Q vssd1 vssd1 vccd1 vccd1 _0612_/B sky130_fd_sc_hd__or2_2
X_0541_ _0981_/Q _0982_/Q vssd1 vssd1 vccd1 vccd1 _0542_/D sky130_fd_sc_hd__or2_2
X_0472_ _0472_/A _0951_/Q vssd1 vssd1 vccd1 vccd1 _0473_/C sky130_fd_sc_hd__xnor2_2
Xload_slew60 fanout59/X vssd1 vssd1 vccd1 vccd1 load_slew60/X sky130_fd_sc_hd__clkbuf_4
X_0808_ _0976_/Q _0808_/B _0808_/C vssd1 vssd1 vccd1 vccd1 _0808_/Y sky130_fd_sc_hd__nand3_2
X_0739_ _0959_/Q hold148/X wire31/X vssd1 vssd1 vccd1 vccd1 _0739_/X sky130_fd_sc_hd__mux2_1
XANTENNA_clkbuf_4_10_0_clk_A clkbuf_0_clk/X vssd1 vssd1 vccd1 vccd1 sky130_fd_sc_hd__diode_2
Xclkbuf_4_14_0_clk clkbuf_0_clk/X vssd1 vssd1 vccd1 vccd1 _0960_/CLK sky130_fd_sc_hd__clkbuf_8
XFILLER_6_42 vssd1 vssd1 vccd1 vccd1 sky130_fd_sc_hd__fill_2
X_0524_ _0952_/Q _0519_/A _0497_/A _0497_/B vssd1 vssd1 vccd1 vccd1 _0524_/Y sky130_fd_sc_hd__o22ai_2
X_0455_ _0975_/Q _0455_/B vssd1 vssd1 vccd1 vccd1 _0463_/B sky130_fd_sc_hd__and2_2
X_1007_ clkload6/A _1007_/D fanout68/X vssd1 vssd1 vccd1 vccd1 _1007_/Q sky130_fd_sc_hd__dfrtp_2
Xteam_05_92 vssd1 vssd1 vccd1 vccd1 team_05_92/HI gpio_out[18] sky130_fd_sc_hd__conb_1
Xteam_05_81 vssd1 vssd1 vccd1 vccd1 team_05_81/HI gpio_out[6] sky130_fd_sc_hd__conb_1
XPHY_EDGE_ROW_33_Left_72 vssd1 vssd1 vccd1 vccd1 sky130_fd_sc_hd__decap_3
XTAP_TAPCELL_ROW_18_167 vssd1 vccd1 sky130_fd_sc_hd__tapvpwrvgnd_1
XFILLER_16_161 vssd1 vssd1 vccd1 vccd1 sky130_fd_sc_hd__fill_8
XFILLER_31_186 vssd1 vssd1 vccd1 vccd1 sky130_fd_sc_hd__fill_1
XANTENNA__0569__A1 _0448_/B vssd1 vssd1 vccd1 vccd1 sky130_fd_sc_hd__diode_2
X_0507_ _0508_/C vssd1 vssd1 vccd1 vccd1 _0507_/Y sky130_fd_sc_hd__inv_2
X_0438_ _0933_/Q vssd1 vssd1 vccd1 vccd1 _0664_/B sky130_fd_sc_hd__inv_2
XFILLER_22_175 vssd1 vssd1 vccd1 vccd1 sky130_fd_sc_hd__fill_2
XTAP_TAPCELL_ROW_9_124 vssd1 vccd1 sky130_fd_sc_hd__tapvpwrvgnd_1
XFILLER_13_142 vssd1 vssd1 vccd1 vccd1 sky130_fd_sc_hd__fill_2
XFILLER_13_164 vssd1 vssd1 vccd1 vccd1 sky130_fd_sc_hd__fill_4
XFILLER_9_135 vssd1 vssd1 vccd1 vccd1 sky130_fd_sc_hd__fill_2
XFILLER_3_76 vssd1 vssd1 vccd1 vccd1 sky130_fd_sc_hd__fill_4
XFILLER_3_32 vssd1 vssd1 vccd1 vccd1 sky130_fd_sc_hd__fill_2
X_0987_ _1019_/CLK _0987_/D load_slew62/X vssd1 vssd1 vccd1 vccd1 _0987_/Q sky130_fd_sc_hd__dfrtp_2
XTAP_TAPCELL_ROW_37_251 vssd1 vccd1 sky130_fd_sc_hd__tapvpwrvgnd_1
XFILLER_12_85 vssd1 vssd1 vccd1 vccd1 sky130_fd_sc_hd__fill_2
XTAP_TAPCELL_ROW_20_173 vssd1 vccd1 sky130_fd_sc_hd__tapvpwrvgnd_1
XFILLER_6_138 vssd1 vssd1 vccd1 vccd1 sky130_fd_sc_hd__fill_2
Xhold190 _0580_/Y vssd1 vssd1 vccd1 vccd1 _0581_/C sky130_fd_sc_hd__dlygate4sd3_1
XPHY_EDGE_ROW_16_Right_16 vssd1 vssd1 vccd1 vccd1 sky130_fd_sc_hd__decap_3
X_0910_ clkload4/A _0910_/D load_slew56/X vssd1 vssd1 vccd1 vccd1 _0910_/Q sky130_fd_sc_hd__dfrtp_2
X_0841_ _0741_/B _1014_/Q _0839_/X vssd1 vssd1 vccd1 vccd1 _0841_/Y sky130_fd_sc_hd__o21ai_2
X_0772_ _0772_/A _0772_/B vssd1 vssd1 vccd1 vccd1 _0772_/Y sky130_fd_sc_hd__xnor2_2
XPHY_EDGE_ROW_25_Right_25 vssd1 vssd1 vccd1 vccd1 sky130_fd_sc_hd__decap_3
XFILLER_5_171 vssd1 vssd1 vccd1 vccd1 sky130_fd_sc_hd__fill_8
XPHY_EDGE_ROW_34_Right_34 vssd1 vssd1 vccd1 vccd1 sky130_fd_sc_hd__decap_3
XFILLER_17_7 vssd1 vssd1 vccd1 vccd1 sky130_fd_sc_hd__fill_1
XTAP_TAPCELL_ROW_31_224 vssd1 vccd1 sky130_fd_sc_hd__tapvpwrvgnd_1
X_0824_ hold196/X _0743_/Y _0792_/X _0823_/X vssd1 vssd1 vccd1 vccd1 _0980_/D sky130_fd_sc_hd__a22o_2
X_0755_ _0755_/A _0755_/B _0755_/C vssd1 vssd1 vccd1 vccd1 _0755_/Y sky130_fd_sc_hd__nand3_2
X_0686_ _1020_/Q _0686_/B vssd1 vssd1 vccd1 vccd1 _0892_/D sky130_fd_sc_hd__xor2_2
XFILLER_28_29 vssd1 vssd1 vccd1 vccd1 sky130_fd_sc_hd__fill_4
XFILLER_12_218 vssd1 vssd1 vccd1 vccd1 sky130_fd_sc_hd__fill_4
X_0540_ _0979_/Q _0980_/Q _0977_/Q _0978_/Q vssd1 vssd1 vccd1 vccd1 _0825_/D sky130_fd_sc_hd__or4_2
X_0471_ _0951_/Q _0949_/Q vssd1 vssd1 vccd1 vccd1 _0519_/B sky130_fd_sc_hd__and2b_2
Xload_slew72 fanout71/X vssd1 vssd1 vccd1 vccd1 load_slew72/X sky130_fd_sc_hd__clkbuf_4
X_0807_ _0808_/B _0808_/C _0976_/Q vssd1 vssd1 vccd1 vccd1 _0807_/X sky130_fd_sc_hd__a21o_2
X_0738_ _0958_/Q hold150/X wire31/X vssd1 vssd1 vccd1 vccd1 _0738_/X sky130_fd_sc_hd__mux2_1
X_0669_ _1008_/Q _0657_/Y _0658_/Y _0668_/X _0664_/X vssd1 vssd1 vccd1 vccd1 _0901_/D
+ sky130_fd_sc_hd__a221o_2
XPHY_EDGE_ROW_2_Right_2 vssd1 vssd1 vccd1 vccd1 sky130_fd_sc_hd__decap_3
XFILLER_20_85 vssd1 vssd1 vccd1 vccd1 sky130_fd_sc_hd__fill_2
XFILLER_35_129 vssd1 vssd1 vccd1 vccd1 sky130_fd_sc_hd__fill_1
XFILLER_6_65 vssd1 vssd1 vccd1 vccd1 sky130_fd_sc_hd__fill_1
X_0523_ _0780_/A _0523_/B vssd1 vssd1 vccd1 vccd1 _0777_/B sky130_fd_sc_hd__nor2_2
X_0454_ _0454_/A _0461_/B vssd1 vssd1 vccd1 vccd1 _0803_/A sky130_fd_sc_hd__nand2_2
X_1006_ clkload5/A _1006_/D fanout68/X vssd1 vssd1 vccd1 vccd1 _1006_/Q sky130_fd_sc_hd__dfrtp_2
XFILLER_19_181 vssd1 vssd1 vccd1 vccd1 sky130_fd_sc_hd__fill_2
Xteam_05_93 vssd1 vssd1 vccd1 vccd1 team_05_93/HI gpio_out[19] sky130_fd_sc_hd__conb_1
Xteam_05_82 vssd1 vssd1 vccd1 vccd1 team_05_82/HI gpio_out[7] sky130_fd_sc_hd__conb_1
XFILLER_15_74 vssd1 vssd1 vccd1 vccd1 sky130_fd_sc_hd__fill_2
XFILLER_31_73 vssd1 vssd1 vccd1 vccd1 sky130_fd_sc_hd__fill_4
XFILLER_16_151 vssd1 vssd1 vccd1 vccd1 sky130_fd_sc_hd__fill_4
XANTENNA__0569__A2 _0455_/B vssd1 vssd1 vccd1 vccd1 sky130_fd_sc_hd__diode_2
XFILLER_16_195 vssd1 vssd1 vccd1 vccd1 sky130_fd_sc_hd__fill_1
X_0506_ _0426_/Y wire32/X _0500_/B _0966_/Q vssd1 vssd1 vccd1 vccd1 _0508_/C sky130_fd_sc_hd__a2bb2o_2
X_0437_ _0932_/Q vssd1 vssd1 vccd1 vccd1 _0678_/A sky130_fd_sc_hd__inv_2
XFILLER_36_29 vssd1 vssd1 vccd1 vccd1 sky130_fd_sc_hd__fill_2
Xclkbuf_4_13_0_clk clkbuf_0_clk/X vssd1 vssd1 vccd1 vccd1 _1003_/CLK sky130_fd_sc_hd__clkbuf_8
XTAP_TAPCELL_ROW_9_125 vssd1 vccd1 sky130_fd_sc_hd__tapvpwrvgnd_1
XFILLER_13_154 vssd1 vssd1 vccd1 vccd1 sky130_fd_sc_hd__fill_2
X_0986_ _1019_/CLK _0986_/D load_slew62/X vssd1 vssd1 vccd1 vccd1 _0986_/Q sky130_fd_sc_hd__dfrtp_2
XTAP_TAPCELL_ROW_37_252 vssd1 vccd1 sky130_fd_sc_hd__tapvpwrvgnd_1
XFILLER_6_106 vssd1 vssd1 vccd1 vccd1 sky130_fd_sc_hd__fill_8
XFILLER_12_42 vssd1 vssd1 vccd1 vccd1 sky130_fd_sc_hd__fill_4
Xhold180 _1002_/Q vssd1 vssd1 vccd1 vccd1 hold180/X sky130_fd_sc_hd__dlygate4sd3_1
XTAP_TAPCELL_ROW_20_174 vssd1 vccd1 sky130_fd_sc_hd__tapvpwrvgnd_1
Xhold191 _0892_/Q vssd1 vssd1 vccd1 vccd1 _0686_/B sky130_fd_sc_hd__dlygate4sd3_1
XFILLER_37_61 vssd1 vssd1 vccd1 vccd1 sky130_fd_sc_hd__fill_1
X_0840_ _0741_/B _1014_/Q _0839_/X vssd1 vssd1 vccd1 vccd1 _0840_/X sky130_fd_sc_hd__o21a_2
X_0771_ _0504_/B _0768_/B _0494_/Y vssd1 vssd1 vccd1 vccd1 _0772_/B sky130_fd_sc_hd__o21ai_2
X_0969_ _0970_/CLK _0969_/D load_slew49/X vssd1 vssd1 vccd1 vccd1 _0969_/Q sky130_fd_sc_hd__dfrtp_2
XFILLER_23_85 vssd1 vssd1 vccd1 vccd1 sky130_fd_sc_hd__fill_2
XTAP_TAPCELL_ROW_31_225 vssd1 vccd1 sky130_fd_sc_hd__tapvpwrvgnd_1
X_0823_ _0741_/A _0821_/X _0822_/Y _0823_/B1 _0979_/Q vssd1 vssd1 vccd1 vccd1 _0823_/X
+ sky130_fd_sc_hd__a32o_2
X_0754_ _0963_/Q _0753_/X _0788_/S vssd1 vssd1 vccd1 vccd1 _0963_/D sky130_fd_sc_hd__mux2_1
X_0685_ hold194/X hold216/X _0694_/B _0428_/Y vssd1 vssd1 vccd1 vccd1 _1020_/D sky130_fd_sc_hd__a31o_2
XFILLER_18_85 vssd1 vssd1 vccd1 vccd1 sky130_fd_sc_hd__fill_4
XFILLER_18_74 vssd1 vssd1 vccd1 vccd1 sky130_fd_sc_hd__fill_8
XANTENNA__0844__A1 _0856_/A1 vssd1 vssd1 vccd1 vccd1 sky130_fd_sc_hd__diode_2
X_0470_ _0964_/Q _0470_/B vssd1 vssd1 vccd1 vccd1 _0755_/B sky130_fd_sc_hd__or2_2
Xload_slew62 fanout61/X vssd1 vssd1 vccd1 vccd1 load_slew62/X sky130_fd_sc_hd__buf_2
Xload_slew51 fanout50/X vssd1 vssd1 vccd1 vccd1 load_slew51/X sky130_fd_sc_hd__clkbuf_4
X_0806_ hold202/X _0838_/A2 _0792_/X _0805_/X vssd1 vssd1 vccd1 vccd1 _0975_/D sky130_fd_sc_hd__a22o_2
X_0737_ _0957_/Q hold154/X wire31/X vssd1 vssd1 vccd1 vccd1 _0737_/X sky130_fd_sc_hd__mux2_1
X_0668_ _1013_/Q _1007_/Q vssd1 vssd1 vccd1 vccd1 _0668_/X sky130_fd_sc_hd__xor2_2
X_0599_ _0922_/Q _0490_/B _0596_/X _0597_/X _0598_/X vssd1 vssd1 vccd1 vccd1 _0599_/X
+ sky130_fd_sc_hd__o221a_2
X_0522_ _0969_/Q _0598_/B vssd1 vssd1 vccd1 vccd1 _0523_/B sky130_fd_sc_hd__nor2_2
X_0453_ _0463_/A vssd1 vssd1 vccd1 vccd1 _0453_/Y sky130_fd_sc_hd__inv_2
X_1005_ clkload6/A _1005_/D fanout57/X vssd1 vssd1 vccd1 vccd1 _1005_/Q sky130_fd_sc_hd__dfrtp_2
XFILLER_1_218 vssd1 vssd1 vccd1 vccd1 sky130_fd_sc_hd__fill_1
Xteam_05_94 vssd1 vssd1 vccd1 vccd1 team_05_94/HI gpio_out[20] sky130_fd_sc_hd__conb_1
Xteam_05_83 vssd1 vssd1 vccd1 vccd1 team_05_83/HI gpio_out[8] sky130_fd_sc_hd__conb_1
X_0505_ _0755_/A _0487_/A _0487_/B _0504_/X _0469_/Y vssd1 vssd1 vccd1 vccd1 _0511_/A
+ sky130_fd_sc_hd__a311o_2
X_0436_ _0919_/Q vssd1 vssd1 vccd1 vccd1 _0436_/Y sky130_fd_sc_hd__inv_2
.ends
