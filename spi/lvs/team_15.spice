* NGSPICE file created from team_15.ext - technology: sky130A

* Black-box entry subcircuit for sky130_fd_sc_hd__fill_1 abstract view
.subckt sky130_fd_sc_hd__fill_1 VGND VNB VPB VPWR
.ends

* Black-box entry subcircuit for sky130_fd_sc_hd__nor3_1 abstract view
.subckt sky130_fd_sc_hd__nor3_1 A B C VGND VNB VPB VPWR Y
.ends

* Black-box entry subcircuit for sky130_fd_sc_hd__mux2_1 abstract view
.subckt sky130_fd_sc_hd__mux2_1 A0 A1 S VGND VNB VPB VPWR X
.ends

* Black-box entry subcircuit for sky130_fd_sc_hd__nand2_4 abstract view
.subckt sky130_fd_sc_hd__nand2_4 A B VGND VNB VPB VPWR Y
.ends

* Black-box entry subcircuit for sky130_fd_sc_hd__a21oi_1 abstract view
.subckt sky130_fd_sc_hd__a21oi_1 A1 A2 B1 VGND VNB VPB VPWR Y
.ends

* Black-box entry subcircuit for sky130_fd_sc_hd__or4b_1 abstract view
.subckt sky130_fd_sc_hd__or4b_1 A B C D_N VGND VNB VPB VPWR X
.ends

* Black-box entry subcircuit for sky130_fd_sc_hd__fill_4 abstract view
.subckt sky130_fd_sc_hd__fill_4 VGND VNB VPB VPWR
.ends

* Black-box entry subcircuit for sky130_fd_sc_hd__and2b_1 abstract view
.subckt sky130_fd_sc_hd__and2b_1 A_N B VGND VNB VPB VPWR X
.ends

* Black-box entry subcircuit for sky130_fd_sc_hd__mux4_1 abstract view
.subckt sky130_fd_sc_hd__mux4_1 A0 A1 A2 A3 S0 S1 VGND VNB VPB VPWR X
.ends

* Black-box entry subcircuit for sky130_fd_sc_hd__diode_2 abstract view
.subckt sky130_fd_sc_hd__diode_2 DIODE VGND VNB VPB VPWR
.ends

* Black-box entry subcircuit for sky130_fd_sc_hd__a311o_1 abstract view
.subckt sky130_fd_sc_hd__a311o_1 A1 A2 A3 B1 C1 VGND VNB VPB VPWR X
.ends

* Black-box entry subcircuit for sky130_fd_sc_hd__tapvpwrvgnd_1 abstract view
.subckt sky130_fd_sc_hd__tapvpwrvgnd_1 VGND VPWR
.ends

* Black-box entry subcircuit for sky130_fd_sc_hd__o21a_1 abstract view
.subckt sky130_fd_sc_hd__o21a_1 A1 A2 B1 VGND VNB VPB VPWR X
.ends

* Black-box entry subcircuit for sky130_fd_sc_hd__o32a_1 abstract view
.subckt sky130_fd_sc_hd__o32a_1 A1 A2 A3 B1 B2 VGND VNB VPB VPWR X
.ends

* Black-box entry subcircuit for sky130_fd_sc_hd__fill_8 abstract view
.subckt sky130_fd_sc_hd__fill_8 VGND VNB VPB VPWR
.ends

* Black-box entry subcircuit for sky130_fd_sc_hd__fill_2 abstract view
.subckt sky130_fd_sc_hd__fill_2 VGND VNB VPB VPWR
.ends

* Black-box entry subcircuit for sky130_fd_sc_hd__nor2_4 abstract view
.subckt sky130_fd_sc_hd__nor2_4 A B VGND VNB VPB VPWR Y
.ends

* Black-box entry subcircuit for sky130_fd_sc_hd__a21o_1 abstract view
.subckt sky130_fd_sc_hd__a21o_1 A1 A2 B1 VGND VNB VPB VPWR X
.ends

* Black-box entry subcircuit for sky130_fd_sc_hd__and2b_4 abstract view
.subckt sky130_fd_sc_hd__and2b_4 A_N B VGND VNB VPB VPWR X
.ends

* Black-box entry subcircuit for sky130_ef_sc_hd__decap_40_12 abstract view
.subckt sky130_ef_sc_hd__decap_40_12 VPWR VGND VPB VNB
.ends

* Black-box entry subcircuit for sky130_fd_sc_hd__o21bai_1 abstract view
.subckt sky130_fd_sc_hd__o21bai_1 A1 A2 B1_N VGND VNB VPB VPWR Y
.ends

* Black-box entry subcircuit for sky130_fd_sc_hd__buf_2 abstract view
.subckt sky130_fd_sc_hd__buf_2 A VGND VNB VPB VPWR X
.ends

* Black-box entry subcircuit for sky130_fd_sc_hd__clkbuf_2 abstract view
.subckt sky130_fd_sc_hd__clkbuf_2 A VGND VNB VPB VPWR X
.ends

* Black-box entry subcircuit for sky130_fd_sc_hd__a21bo_1 abstract view
.subckt sky130_fd_sc_hd__a21bo_1 A1 A2 B1_N VGND VNB VPB VPWR X
.ends

* Black-box entry subcircuit for sky130_fd_sc_hd__buf_1 abstract view
.subckt sky130_fd_sc_hd__buf_1 A VGND VNB VPB VPWR X
.ends

* Black-box entry subcircuit for sky130_fd_sc_hd__clkbuf_1 abstract view
.subckt sky130_fd_sc_hd__clkbuf_1 A VGND VNB VPB VPWR X
.ends

* Black-box entry subcircuit for sky130_fd_sc_hd__dfrtp_1 abstract view
.subckt sky130_fd_sc_hd__dfrtp_1 CLK D RESET_B VGND VNB VPB VPWR Q
.ends

* Black-box entry subcircuit for sky130_fd_sc_hd__dfstp_1 abstract view
.subckt sky130_fd_sc_hd__dfstp_1 CLK D SET_B VGND VNB VPB VPWR Q
.ends

* Black-box entry subcircuit for sky130_fd_sc_hd__inv_2 abstract view
.subckt sky130_fd_sc_hd__inv_2 A VGND VNB VPB VPWR Y
.ends

* Black-box entry subcircuit for sky130_fd_sc_hd__nor3b_2 abstract view
.subckt sky130_fd_sc_hd__nor3b_2 A B C_N VGND VNB VPB VPWR Y
.ends

* Black-box entry subcircuit for sky130_fd_sc_hd__o2111ai_4 abstract view
.subckt sky130_fd_sc_hd__o2111ai_4 A1 A2 B1 C1 D1 VGND VNB VPB VPWR Y
.ends

* Black-box entry subcircuit for sky130_fd_sc_hd__nand2_1 abstract view
.subckt sky130_fd_sc_hd__nand2_1 A B VGND VNB VPB VPWR Y
.ends

* Black-box entry subcircuit for sky130_fd_sc_hd__o31a_1 abstract view
.subckt sky130_fd_sc_hd__o31a_1 A1 A2 A3 B1 VGND VNB VPB VPWR X
.ends

* Black-box entry subcircuit for sky130_fd_sc_hd__o211a_1 abstract view
.subckt sky130_fd_sc_hd__o211a_1 A1 A2 B1 C1 VGND VNB VPB VPWR X
.ends

* Black-box entry subcircuit for sky130_fd_sc_hd__a221oi_1 abstract view
.subckt sky130_fd_sc_hd__a221oi_1 A1 A2 B1 B2 C1 VGND VNB VPB VPWR Y
.ends

* Black-box entry subcircuit for sky130_fd_sc_hd__a2111o_1 abstract view
.subckt sky130_fd_sc_hd__a2111o_1 A1 A2 B1 C1 D1 VGND VNB VPB VPWR X
.ends

* Black-box entry subcircuit for sky130_fd_sc_hd__o32ai_4 abstract view
.subckt sky130_fd_sc_hd__o32ai_4 A1 A2 A3 B1 B2 VGND VNB VPB VPWR Y
.ends

* Black-box entry subcircuit for sky130_fd_sc_hd__a221o_1 abstract view
.subckt sky130_fd_sc_hd__a221o_1 A1 A2 B1 B2 C1 VGND VNB VPB VPWR X
.ends

* Black-box entry subcircuit for sky130_fd_sc_hd__nor2_1 abstract view
.subckt sky130_fd_sc_hd__nor2_1 A B VGND VNB VPB VPWR Y
.ends

* Black-box entry subcircuit for sky130_fd_sc_hd__or3_1 abstract view
.subckt sky130_fd_sc_hd__or3_1 A B C VGND VNB VPB VPWR X
.ends

* Black-box entry subcircuit for sky130_fd_sc_hd__o311ai_2 abstract view
.subckt sky130_fd_sc_hd__o311ai_2 A1 A2 A3 B1 C1 VGND VNB VPB VPWR Y
.ends

* Black-box entry subcircuit for sky130_fd_sc_hd__clkbuf_4 abstract view
.subckt sky130_fd_sc_hd__clkbuf_4 A VGND VNB VPB VPWR X
.ends

* Black-box entry subcircuit for sky130_fd_sc_hd__a211o_1 abstract view
.subckt sky130_fd_sc_hd__a211o_1 A1 A2 B1 C1 VGND VNB VPB VPWR X
.ends

* Black-box entry subcircuit for sky130_fd_sc_hd__nand2b_1 abstract view
.subckt sky130_fd_sc_hd__nand2b_1 A_N B VGND VNB VPB VPWR Y
.ends

* Black-box entry subcircuit for sky130_fd_sc_hd__nor3_2 abstract view
.subckt sky130_fd_sc_hd__nor3_2 A B C VGND VNB VPB VPWR Y
.ends

* Black-box entry subcircuit for sky130_fd_sc_hd__o32ai_2 abstract view
.subckt sky130_fd_sc_hd__o32ai_2 A1 A2 A3 B1 B2 VGND VNB VPB VPWR Y
.ends

* Black-box entry subcircuit for sky130_fd_sc_hd__decap_3 abstract view
.subckt sky130_fd_sc_hd__decap_3 VGND VNB VPB VPWR
.ends

* Black-box entry subcircuit for sky130_fd_sc_hd__a31o_1 abstract view
.subckt sky130_fd_sc_hd__a31o_1 A1 A2 A3 B1 VGND VNB VPB VPWR X
.ends

* Black-box entry subcircuit for sky130_fd_sc_hd__nand4_4 abstract view
.subckt sky130_fd_sc_hd__nand4_4 A B C D VGND VNB VPB VPWR Y
.ends

* Black-box entry subcircuit for sky130_fd_sc_hd__o221a_1 abstract view
.subckt sky130_fd_sc_hd__o221a_1 A1 A2 B1 B2 C1 VGND VNB VPB VPWR X
.ends

* Black-box entry subcircuit for sky130_fd_sc_hd__o21ai_1 abstract view
.subckt sky130_fd_sc_hd__o21ai_1 A1 A2 B1 VGND VNB VPB VPWR Y
.ends

* Black-box entry subcircuit for sky130_fd_sc_hd__and2_2 abstract view
.subckt sky130_fd_sc_hd__and2_2 A B VGND VNB VPB VPWR X
.ends

* Black-box entry subcircuit for sky130_fd_sc_hd__or4bb_1 abstract view
.subckt sky130_fd_sc_hd__or4bb_1 A B C_N D_N VGND VNB VPB VPWR X
.ends

* Black-box entry subcircuit for sky130_fd_sc_hd__a211oi_1 abstract view
.subckt sky130_fd_sc_hd__a211oi_1 A1 A2 B1 C1 VGND VNB VPB VPWR Y
.ends

* Black-box entry subcircuit for sky130_fd_sc_hd__or2_1 abstract view
.subckt sky130_fd_sc_hd__or2_1 A B VGND VNB VPB VPWR X
.ends

* Black-box entry subcircuit for sky130_fd_sc_hd__o311a_1 abstract view
.subckt sky130_fd_sc_hd__o311a_1 A1 A2 A3 B1 C1 VGND VNB VPB VPWR X
.ends

* Black-box entry subcircuit for sky130_fd_sc_hd__xor2_2 abstract view
.subckt sky130_fd_sc_hd__xor2_2 A B VGND VNB VPB VPWR X
.ends

* Black-box entry subcircuit for sky130_fd_sc_hd__o211ai_1 abstract view
.subckt sky130_fd_sc_hd__o211ai_1 A1 A2 B1 C1 VGND VNB VPB VPWR Y
.ends

* Black-box entry subcircuit for sky130_fd_sc_hd__o21ba_1 abstract view
.subckt sky130_fd_sc_hd__o21ba_1 A1 A2 B1_N VGND VNB VPB VPWR X
.ends

* Black-box entry subcircuit for sky130_fd_sc_hd__or4_1 abstract view
.subckt sky130_fd_sc_hd__or4_1 A B C D VGND VNB VPB VPWR X
.ends

* Black-box entry subcircuit for sky130_fd_sc_hd__a31o_2 abstract view
.subckt sky130_fd_sc_hd__a31o_2 A1 A2 A3 B1 VGND VNB VPB VPWR X
.ends

* Black-box entry subcircuit for sky130_fd_sc_hd__or3b_4 abstract view
.subckt sky130_fd_sc_hd__or3b_4 A B C_N VGND VNB VPB VPWR X
.ends

* Black-box entry subcircuit for sky130_fd_sc_hd__o22a_1 abstract view
.subckt sky130_fd_sc_hd__o22a_1 A1 A2 B1 B2 VGND VNB VPB VPWR X
.ends

* Black-box entry subcircuit for sky130_fd_sc_hd__o21bai_2 abstract view
.subckt sky130_fd_sc_hd__o21bai_2 A1 A2 B1_N VGND VNB VPB VPWR Y
.ends

* Black-box entry subcircuit for sky130_fd_sc_hd__nand2_2 abstract view
.subckt sky130_fd_sc_hd__nand2_2 A B VGND VNB VPB VPWR Y
.ends

* Black-box entry subcircuit for sky130_fd_sc_hd__a22o_1 abstract view
.subckt sky130_fd_sc_hd__a22o_1 A1 A2 B1 B2 VGND VNB VPB VPWR X
.ends

* Black-box entry subcircuit for sky130_fd_sc_hd__and2b_2 abstract view
.subckt sky130_fd_sc_hd__and2b_2 A_N B VGND VNB VPB VPWR X
.ends

* Black-box entry subcircuit for sky130_fd_sc_hd__dfstp_2 abstract view
.subckt sky130_fd_sc_hd__dfstp_2 CLK D SET_B VGND VNB VPB VPWR Q
.ends

* Black-box entry subcircuit for sky130_fd_sc_hd__a31o_4 abstract view
.subckt sky130_fd_sc_hd__a31o_4 A1 A2 A3 B1 VGND VNB VPB VPWR X
.ends

* Black-box entry subcircuit for sky130_fd_sc_hd__o311a_4 abstract view
.subckt sky130_fd_sc_hd__o311a_4 A1 A2 A3 B1 C1 VGND VNB VPB VPWR X
.ends

* Black-box entry subcircuit for sky130_fd_sc_hd__or3b_1 abstract view
.subckt sky130_fd_sc_hd__or3b_1 A B C_N VGND VNB VPB VPWR X
.ends

* Black-box entry subcircuit for sky130_fd_sc_hd__and4_2 abstract view
.subckt sky130_fd_sc_hd__and4_2 A B C D VGND VNB VPB VPWR X
.ends

* Black-box entry subcircuit for sky130_fd_sc_hd__a41o_1 abstract view
.subckt sky130_fd_sc_hd__a41o_1 A1 A2 A3 A4 B1 VGND VNB VPB VPWR X
.ends

* Black-box entry subcircuit for sky130_fd_sc_hd__xnor2_1 abstract view
.subckt sky130_fd_sc_hd__xnor2_1 A B VGND VNB VPB VPWR Y
.ends

* Black-box entry subcircuit for sky130_fd_sc_hd__and2_1 abstract view
.subckt sky130_fd_sc_hd__and2_1 A B VGND VNB VPB VPWR X
.ends

* Black-box entry subcircuit for sky130_fd_sc_hd__a32o_1 abstract view
.subckt sky130_fd_sc_hd__a32o_1 A1 A2 A3 B1 B2 VGND VNB VPB VPWR X
.ends

* Black-box entry subcircuit for sky130_fd_sc_hd__nand2b_2 abstract view
.subckt sky130_fd_sc_hd__nand2b_2 A_N B VGND VNB VPB VPWR Y
.ends

* Black-box entry subcircuit for sky130_fd_sc_hd__o21bai_4 abstract view
.subckt sky130_fd_sc_hd__o21bai_4 A1 A2 B1_N VGND VNB VPB VPWR Y
.ends

* Black-box entry subcircuit for sky130_fd_sc_hd__o41a_1 abstract view
.subckt sky130_fd_sc_hd__o41a_1 A1 A2 A3 A4 B1 VGND VNB VPB VPWR X
.ends

* Black-box entry subcircuit for sky130_fd_sc_hd__dfrtp_2 abstract view
.subckt sky130_fd_sc_hd__dfrtp_2 CLK D RESET_B VGND VNB VPB VPWR Q
.ends

* Black-box entry subcircuit for sky130_fd_sc_hd__buf_4 abstract view
.subckt sky130_fd_sc_hd__buf_4 A VGND VNB VPB VPWR X
.ends

* Black-box entry subcircuit for sky130_fd_sc_hd__and3_1 abstract view
.subckt sky130_fd_sc_hd__and3_1 A B C VGND VNB VPB VPWR X
.ends

* Black-box entry subcircuit for sky130_fd_sc_hd__a311oi_1 abstract view
.subckt sky130_fd_sc_hd__a311oi_1 A1 A2 A3 B1 C1 VGND VNB VPB VPWR Y
.ends

* Black-box entry subcircuit for sky130_fd_sc_hd__nand2b_4 abstract view
.subckt sky130_fd_sc_hd__nand2b_4 A_N B VGND VNB VPB VPWR Y
.ends

* Black-box entry subcircuit for sky130_fd_sc_hd__a211oi_2 abstract view
.subckt sky130_fd_sc_hd__a211oi_2 A1 A2 B1 C1 VGND VNB VPB VPWR Y
.ends

* Black-box entry subcircuit for sky130_fd_sc_hd__o21ai_2 abstract view
.subckt sky130_fd_sc_hd__o21ai_2 A1 A2 B1 VGND VNB VPB VPWR Y
.ends

* Black-box entry subcircuit for sky130_fd_sc_hd__a211o_4 abstract view
.subckt sky130_fd_sc_hd__a211o_4 A1 A2 B1 C1 VGND VNB VPB VPWR X
.ends

* Black-box entry subcircuit for sky130_fd_sc_hd__a221oi_2 abstract view
.subckt sky130_fd_sc_hd__a221oi_2 A1 A2 B1 B2 C1 VGND VNB VPB VPWR Y
.ends

* Black-box entry subcircuit for sky130_fd_sc_hd__or3_2 abstract view
.subckt sky130_fd_sc_hd__or3_2 A B C VGND VNB VPB VPWR X
.ends

* Black-box entry subcircuit for sky130_fd_sc_hd__and3b_1 abstract view
.subckt sky130_fd_sc_hd__and3b_1 A_N B C VGND VNB VPB VPWR X
.ends

* Black-box entry subcircuit for sky130_fd_sc_hd__nor2_2 abstract view
.subckt sky130_fd_sc_hd__nor2_2 A B VGND VNB VPB VPWR Y
.ends

* Black-box entry subcircuit for sky130_fd_sc_hd__or2_2 abstract view
.subckt sky130_fd_sc_hd__or2_2 A B VGND VNB VPB VPWR X
.ends

* Black-box entry subcircuit for sky130_fd_sc_hd__a22oi_1 abstract view
.subckt sky130_fd_sc_hd__a22oi_1 A1 A2 B1 B2 VGND VNB VPB VPWR Y
.ends

* Black-box entry subcircuit for sky130_fd_sc_hd__or4b_4 abstract view
.subckt sky130_fd_sc_hd__or4b_4 A B C D_N VGND VNB VPB VPWR X
.ends

* Black-box entry subcircuit for sky130_fd_sc_hd__or3b_2 abstract view
.subckt sky130_fd_sc_hd__or3b_2 A B C_N VGND VNB VPB VPWR X
.ends

* Black-box entry subcircuit for sky130_fd_sc_hd__a211o_2 abstract view
.subckt sky130_fd_sc_hd__a211o_2 A1 A2 B1 C1 VGND VNB VPB VPWR X
.ends

* Black-box entry subcircuit for sky130_fd_sc_hd__and3_2 abstract view
.subckt sky130_fd_sc_hd__and3_2 A B C VGND VNB VPB VPWR X
.ends

* Black-box entry subcircuit for sky130_fd_sc_hd__dlymetal6s2s_1 abstract view
.subckt sky130_fd_sc_hd__dlymetal6s2s_1 A VGND VNB VPB VPWR X
.ends

* Black-box entry subcircuit for sky130_fd_sc_hd__o211a_4 abstract view
.subckt sky130_fd_sc_hd__o211a_4 A1 A2 B1 C1 VGND VNB VPB VPWR X
.ends

* Black-box entry subcircuit for sky130_fd_sc_hd__and4b_1 abstract view
.subckt sky130_fd_sc_hd__and4b_1 A_N B C D VGND VNB VPB VPWR X
.ends

* Black-box entry subcircuit for sky130_fd_sc_hd__a2bb2o_1 abstract view
.subckt sky130_fd_sc_hd__a2bb2o_1 A1_N A2_N B1 B2 VGND VNB VPB VPWR X
.ends

* Black-box entry subcircuit for sky130_fd_sc_hd__nand3_1 abstract view
.subckt sky130_fd_sc_hd__nand3_1 A B C VGND VNB VPB VPWR Y
.ends

* Black-box entry subcircuit for sky130_fd_sc_hd__o2bb2a_1 abstract view
.subckt sky130_fd_sc_hd__o2bb2a_1 A1_N A2_N B1 B2 VGND VNB VPB VPWR X
.ends

* Black-box entry subcircuit for sky130_fd_sc_hd__o211ai_4 abstract view
.subckt sky130_fd_sc_hd__o211ai_4 A1 A2 B1 C1 VGND VNB VPB VPWR Y
.ends

* Black-box entry subcircuit for sky130_fd_sc_hd__or3_4 abstract view
.subckt sky130_fd_sc_hd__or3_4 A B C VGND VNB VPB VPWR X
.ends

* Black-box entry subcircuit for sky130_fd_sc_hd__and4_1 abstract view
.subckt sky130_fd_sc_hd__and4_1 A B C D VGND VNB VPB VPWR X
.ends

* Black-box entry subcircuit for sky130_fd_sc_hd__or4b_2 abstract view
.subckt sky130_fd_sc_hd__or4b_2 A B C D_N VGND VNB VPB VPWR X
.ends

* Black-box entry subcircuit for sky130_fd_sc_hd__a31oi_1 abstract view
.subckt sky130_fd_sc_hd__a31oi_1 A1 A2 A3 B1 VGND VNB VPB VPWR Y
.ends

* Black-box entry subcircuit for sky130_fd_sc_hd__a21boi_1 abstract view
.subckt sky130_fd_sc_hd__a21boi_1 A1 A2 B1_N VGND VNB VPB VPWR Y
.ends

* Black-box entry subcircuit for sky130_fd_sc_hd__o32a_2 abstract view
.subckt sky130_fd_sc_hd__o32a_2 A1 A2 A3 B1 B2 VGND VNB VPB VPWR X
.ends

* Black-box entry subcircuit for sky130_fd_sc_hd__dfstp_4 abstract view
.subckt sky130_fd_sc_hd__dfstp_4 CLK D SET_B VGND VNB VPB VPWR Q
.ends

* Black-box entry subcircuit for sky130_fd_sc_hd__a311oi_2 abstract view
.subckt sky130_fd_sc_hd__a311oi_2 A1 A2 A3 B1 C1 VGND VNB VPB VPWR Y
.ends

* Black-box entry subcircuit for sky130_fd_sc_hd__a21o_2 abstract view
.subckt sky130_fd_sc_hd__a21o_2 A1 A2 B1 VGND VNB VPB VPWR X
.ends

* Black-box entry subcircuit for sky130_fd_sc_hd__and3_4 abstract view
.subckt sky130_fd_sc_hd__and3_4 A B C VGND VNB VPB VPWR X
.ends

* Black-box entry subcircuit for sky130_fd_sc_hd__a311oi_4 abstract view
.subckt sky130_fd_sc_hd__a311oi_4 A1 A2 A3 B1 C1 VGND VNB VPB VPWR Y
.ends

* Black-box entry subcircuit for sky130_fd_sc_hd__a311o_2 abstract view
.subckt sky130_fd_sc_hd__a311o_2 A1 A2 A3 B1 C1 VGND VNB VPB VPWR X
.ends

* Black-box entry subcircuit for sky130_fd_sc_hd__nand3b_4 abstract view
.subckt sky130_fd_sc_hd__nand3b_4 A_N B C VGND VNB VPB VPWR Y
.ends

* Black-box entry subcircuit for sky130_fd_sc_hd__o2111a_1 abstract view
.subckt sky130_fd_sc_hd__o2111a_1 A1 A2 B1 C1 D1 VGND VNB VPB VPWR X
.ends

* Black-box entry subcircuit for sky130_fd_sc_hd__and4_4 abstract view
.subckt sky130_fd_sc_hd__and4_4 A B C D VGND VNB VPB VPWR X
.ends

* Black-box entry subcircuit for sky130_fd_sc_hd__o31a_4 abstract view
.subckt sky130_fd_sc_hd__o31a_4 A1 A2 A3 B1 VGND VNB VPB VPWR X
.ends

* Black-box entry subcircuit for sky130_fd_sc_hd__and2_4 abstract view
.subckt sky130_fd_sc_hd__and2_4 A B VGND VNB VPB VPWR X
.ends

* Black-box entry subcircuit for sky130_fd_sc_hd__a21boi_4 abstract view
.subckt sky130_fd_sc_hd__a21boi_4 A1 A2 B1_N VGND VNB VPB VPWR Y
.ends

* Black-box entry subcircuit for sky130_fd_sc_hd__o211a_2 abstract view
.subckt sky130_fd_sc_hd__o211a_2 A1 A2 B1 C1 VGND VNB VPB VPWR X
.ends

* Black-box entry subcircuit for sky130_fd_sc_hd__nand3b_2 abstract view
.subckt sky130_fd_sc_hd__nand3b_2 A_N B C VGND VNB VPB VPWR Y
.ends

* Black-box entry subcircuit for sky130_fd_sc_hd__a31oi_2 abstract view
.subckt sky130_fd_sc_hd__a31oi_2 A1 A2 A3 B1 VGND VNB VPB VPWR Y
.ends

* Black-box entry subcircuit for sky130_fd_sc_hd__a21oi_4 abstract view
.subckt sky130_fd_sc_hd__a21oi_4 A1 A2 B1 VGND VNB VPB VPWR Y
.ends

* Black-box entry subcircuit for sky130_fd_sc_hd__a221oi_4 abstract view
.subckt sky130_fd_sc_hd__a221oi_4 A1 A2 B1 B2 C1 VGND VNB VPB VPWR Y
.ends

* Black-box entry subcircuit for sky130_fd_sc_hd__and3b_2 abstract view
.subckt sky130_fd_sc_hd__and3b_2 A_N B C VGND VNB VPB VPWR X
.ends

* Black-box entry subcircuit for sky130_fd_sc_hd__a21oi_2 abstract view
.subckt sky130_fd_sc_hd__a21oi_2 A1 A2 B1 VGND VNB VPB VPWR Y
.ends

* Black-box entry subcircuit for sky130_fd_sc_hd__o31ai_1 abstract view
.subckt sky130_fd_sc_hd__o31ai_1 A1 A2 A3 B1 VGND VNB VPB VPWR Y
.ends

* Black-box entry subcircuit for sky130_fd_sc_hd__conb_1 abstract view
.subckt sky130_fd_sc_hd__conb_1 VGND VNB VPB VPWR HI LO
.ends

* Black-box entry subcircuit for sky130_fd_sc_hd__or2_4 abstract view
.subckt sky130_fd_sc_hd__or2_4 A B VGND VNB VPB VPWR X
.ends

* Black-box entry subcircuit for sky130_fd_sc_hd__and4bb_1 abstract view
.subckt sky130_fd_sc_hd__and4bb_1 A_N B_N C D VGND VNB VPB VPWR X
.ends

* Black-box entry subcircuit for sky130_fd_sc_hd__a41o_2 abstract view
.subckt sky130_fd_sc_hd__a41o_2 A1 A2 A3 A4 B1 VGND VNB VPB VPWR X
.ends

* Black-box entry subcircuit for sky130_fd_sc_hd__o221a_2 abstract view
.subckt sky130_fd_sc_hd__o221a_2 A1 A2 B1 B2 C1 VGND VNB VPB VPWR X
.ends

* Black-box entry subcircuit for sky130_fd_sc_hd__nor3b_1 abstract view
.subckt sky130_fd_sc_hd__nor3b_1 A B C_N VGND VNB VPB VPWR Y
.ends

* Black-box entry subcircuit for sky130_fd_sc_hd__clkbuf_8 abstract view
.subckt sky130_fd_sc_hd__clkbuf_8 A VGND VNB VPB VPWR X
.ends

* Black-box entry subcircuit for sky130_fd_sc_hd__a311o_4 abstract view
.subckt sky130_fd_sc_hd__a311o_4 A1 A2 A3 B1 C1 VGND VNB VPB VPWR X
.ends

* Black-box entry subcircuit for sky130_fd_sc_hd__o21ai_4 abstract view
.subckt sky130_fd_sc_hd__o21ai_4 A1 A2 B1 VGND VNB VPB VPWR Y
.ends

* Black-box entry subcircuit for sky130_fd_sc_hd__a32o_2 abstract view
.subckt sky130_fd_sc_hd__a32o_2 A1 A2 A3 B1 B2 VGND VNB VPB VPWR X
.ends

* Black-box entry subcircuit for sky130_fd_sc_hd__buf_6 abstract view
.subckt sky130_fd_sc_hd__buf_6 A VGND VNB VPB VPWR X
.ends

* Black-box entry subcircuit for sky130_fd_sc_hd__nand3b_1 abstract view
.subckt sky130_fd_sc_hd__nand3b_1 A_N B C VGND VNB VPB VPWR Y
.ends

* Black-box entry subcircuit for sky130_fd_sc_hd__or4bb_2 abstract view
.subckt sky130_fd_sc_hd__or4bb_2 A B C_N D_N VGND VNB VPB VPWR X
.ends

* Black-box entry subcircuit for sky130_fd_sc_hd__o2111ai_2 abstract view
.subckt sky130_fd_sc_hd__o2111ai_2 A1 A2 B1 C1 D1 VGND VNB VPB VPWR Y
.ends

* Black-box entry subcircuit for sky130_fd_sc_hd__o211ai_2 abstract view
.subckt sky130_fd_sc_hd__o211ai_2 A1 A2 B1 C1 VGND VNB VPB VPWR Y
.ends

* Black-box entry subcircuit for sky130_fd_sc_hd__o311a_2 abstract view
.subckt sky130_fd_sc_hd__o311a_2 A1 A2 A3 B1 C1 VGND VNB VPB VPWR X
.ends

* Black-box entry subcircuit for sky130_fd_sc_hd__a221o_2 abstract view
.subckt sky130_fd_sc_hd__a221o_2 A1 A2 B1 B2 C1 VGND VNB VPB VPWR X
.ends

* Black-box entry subcircuit for sky130_fd_sc_hd__o32ai_1 abstract view
.subckt sky130_fd_sc_hd__o32ai_1 A1 A2 A3 B1 B2 VGND VNB VPB VPWR Y
.ends

* Black-box entry subcircuit for sky130_fd_sc_hd__a211oi_4 abstract view
.subckt sky130_fd_sc_hd__a211oi_4 A1 A2 B1 C1 VGND VNB VPB VPWR Y
.ends

* Black-box entry subcircuit for sky130_fd_sc_hd__nor3b_4 abstract view
.subckt sky130_fd_sc_hd__nor3b_4 A B C_N VGND VNB VPB VPWR Y
.ends

.subckt team_15 clk en gpio_in[0] gpio_in[10] gpio_in[11] gpio_in[12] gpio_in[13]
+ gpio_in[14] gpio_in[15] gpio_in[16] gpio_in[17] gpio_in[18] gpio_in[19] gpio_in[1]
+ gpio_in[20] gpio_in[21] gpio_in[22] gpio_in[23] gpio_in[24] gpio_in[25] gpio_in[26]
+ gpio_in[27] gpio_in[28] gpio_in[29] gpio_in[2] gpio_in[30] gpio_in[31] gpio_in[32]
+ gpio_in[33] gpio_in[3] gpio_in[4] gpio_in[5] gpio_in[6] gpio_in[7] gpio_in[8] gpio_in[9]
+ gpio_oeb[0] gpio_oeb[10] gpio_oeb[11] gpio_oeb[12] gpio_oeb[13] gpio_oeb[14] gpio_oeb[15]
+ gpio_oeb[16] gpio_oeb[17] gpio_oeb[18] gpio_oeb[19] gpio_oeb[1] gpio_oeb[20] gpio_oeb[21]
+ gpio_oeb[22] gpio_oeb[23] gpio_oeb[24] gpio_oeb[25] gpio_oeb[26] gpio_oeb[27] gpio_oeb[28]
+ gpio_oeb[29] gpio_oeb[2] gpio_oeb[30] gpio_oeb[31] gpio_oeb[32] gpio_oeb[33] gpio_oeb[3]
+ gpio_oeb[4] gpio_oeb[5] gpio_oeb[6] gpio_oeb[7] gpio_oeb[8] gpio_oeb[9] gpio_out[0]
+ gpio_out[10] gpio_out[11] gpio_out[12] gpio_out[13] gpio_out[14] gpio_out[15] gpio_out[16]
+ gpio_out[17] gpio_out[18] gpio_out[19] gpio_out[1] gpio_out[20] gpio_out[21] gpio_out[22]
+ gpio_out[23] gpio_out[24] gpio_out[25] gpio_out[26] gpio_out[27] gpio_out[28] gpio_out[29]
+ gpio_out[2] gpio_out[30] gpio_out[31] gpio_out[32] gpio_out[33] gpio_out[3] gpio_out[4]
+ gpio_out[5] gpio_out[6] gpio_out[7] gpio_out[8] gpio_out[9] nrst vccd1 vssd1
XFILLER_79_391 vssd1 vssd1 vccd1 vccd1 sky130_fd_sc_hd__fill_1
X_05903_ net113 _01879_ _02181_ vssd1 vssd1 vccd1 vccd1 _02183_ sky130_fd_sc_hd__nor3_1
X_09671_ FPGA_INST.cell0.SB0.route_sel\[74\] FPGA_INST.cell0.SB0.route_sel\[75\] net182
+ vssd1 vssd1 vccd1 vccd1 _00580_ sky130_fd_sc_hd__mux2_1
X_06883_ FPGA_INST.bus2_0\[2\] FPGA_INST.bus2_0\[3\] net425 vssd1 vssd1 vccd1 vccd1
+ _03151_ sky130_fd_sc_hd__mux2_1
X_08622_ _03492_ _04830_ vssd1 vssd1 vccd1 vccd1 _04831_ sky130_fd_sc_hd__nand2_4
XFILLER_54_225 vssd1 vssd1 vccd1 vccd1 sky130_fd_sc_hd__fill_1
X_05834_ FPGA_INST.cell2.SB0.route_sel\[76\] FPGA_INST.cell2.SB0.route_sel\[77\] _02113_
+ vssd1 vssd1 vccd1 vccd1 _02114_ sky130_fd_sc_hd__a21oi_1
X_08553_ FPGA_INST.cell3.CB_1.config_dataB\[18\] FPGA_INST.cell3.CB_1.config_dataB\[17\]
+ FPGA_INST.cell3.CB_1.config_dataB\[16\] FPGA_INST.cell3.CB_1.config_dataB\[15\]
+ vssd1 vssd1 vccd1 vccd1 _04764_ sky130_fd_sc_hd__or4b_1
XFILLER_54_247 vssd1 vssd1 vccd1 vccd1 sky130_fd_sc_hd__fill_4
X_05765_ FPGA_INST.cell2.CB_0.config_dataB\[22\] FPGA_INST.cell2.CB_0.config_dataB\[23\]
+ vssd1 vssd1 vccd1 vccd1 _02045_ sky130_fd_sc_hd__and2b_1
X_08484_ net151 net144 net149 net142 FPGA_INST.cell1.LEI0.config_data\[45\] FPGA_INST.cell1.LEI0.config_data\[46\]
+ vssd1 vssd1 vccd1 vccd1 _04700_ sky130_fd_sc_hd__mux4_1
XFILLER_82_589 vssd1 vssd1 vccd1 vccd1 sky130_fd_sc_hd__fill_4
XANTENNA__07591__B1_N net141 vssd1 vssd1 vccd1 vccd1 sky130_fd_sc_hd__diode_2
X_07504_ _03756_ _03757_ _03758_ _02142_ _02134_ vssd1 vssd1 vccd1 vccd1 _03760_ sky130_fd_sc_hd__a311o_1
XTAP_TAPCELL_ROW_25_629 vssd1 vccd1 sky130_fd_sc_hd__tapvpwrvgnd_1
X_07435_ _02239_ _02793_ _02241_ vssd1 vssd1 vccd1 vccd1 _03693_ sky130_fd_sc_hd__o21a_1
X_05696_ net97 net382 net165 _01975_ _01826_ vssd1 vssd1 vccd1 vccd1 _01976_ sky130_fd_sc_hd__o32a_1
XFILLER_35_494 vssd1 vssd1 vccd1 vccd1 sky130_fd_sc_hd__fill_8
X_07366_ _03625_ net91 _03623_ vssd1 vssd1 vccd1 vccd1 _03626_ sky130_fd_sc_hd__mux2_1
XANTENNA_wire75_A FPGA_INST.bus1_0\[4\] vssd1 vssd1 vccd1 vccd1 sky130_fd_sc_hd__diode_2
XFILLER_50_486 vssd1 vssd1 vccd1 vccd1 sky130_fd_sc_hd__fill_2
XFILLER_10_339 vssd1 vssd1 vccd1 vccd1 sky130_fd_sc_hd__fill_1
XFILLER_22_188 vssd1 vssd1 vccd1 vccd1 sky130_fd_sc_hd__fill_8
XANTENNA__08262__A2 _03504_ vssd1 vssd1 vccd1 vccd1 sky130_fd_sc_hd__diode_2
X_07297_ _02347_ _03557_ vssd1 vssd1 vccd1 vccd1 _03558_ sky130_fd_sc_hd__nor2_4
X_09105_ FPGA_INST.cell2.LEI0.config_data\[19\] FPGA_INST.cell2.LEI0.config_data\[20\]
+ net259 vssd1 vssd1 vccd1 vccd1 _00021_ sky130_fd_sc_hd__mux2_1
X_06317_ net499 _02594_ _02596_ vssd1 vssd1 vccd1 vccd1 _02597_ sky130_fd_sc_hd__a21o_1
XANTENNA__08163__B _03875_ vssd1 vssd1 vccd1 vccd1 sky130_fd_sc_hd__diode_2
XANTENNA__06273__A1 _02450_ vssd1 vssd1 vccd1 vccd1 sky130_fd_sc_hd__diode_2
XANTENNA__06273__B2 _02487_ vssd1 vssd1 vccd1 vccd1 sky130_fd_sc_hd__diode_2
X_06248_ net9 net10 net11 net13 net509 net508 vssd1 vssd1 vccd1 vccd1 _02528_ sky130_fd_sc_hd__mux4_1
X_09036_ _05197_ _02484_ vssd1 vssd1 vccd1 vccd1 FPGA_INST.bus2_0\[0\] sky130_fd_sc_hd__and2b_4
XANTENNA_fanout796_A net803 vssd1 vssd1 vccd1 vccd1 sky130_fd_sc_hd__diode_2
XFILLER_89_122 vccd1 vssd1 vccd1 vssd1 sky130_ef_sc_hd__decap_40_12
X_06179_ _01920_ net158 FPGA_INST.bus2_0\[0\] vssd1 vssd1 vccd1 vccd1 _02459_ sky130_fd_sc_hd__o21bai_1
XFILLER_104_444 vssd1 vssd1 vccd1 vccd1 sky130_fd_sc_hd__fill_2
XFILLER_77_15 vccd1 vssd1 vccd1 vssd1 sky130_ef_sc_hd__decap_40_12
Xfanout842 net843 vssd1 vssd1 vccd1 vccd1 net842 sky130_fd_sc_hd__buf_2
Xfanout820 net843 vssd1 vssd1 vccd1 vccd1 net820 sky130_fd_sc_hd__clkbuf_2
Xfanout831 net843 vssd1 vssd1 vccd1 vccd1 net831 sky130_fd_sc_hd__clkbuf_2
XANTENNA__06576__A2 FPGA_INST.bus3_2\[14\] vssd1 vssd1 vccd1 vccd1 sky130_fd_sc_hd__diode_2
X_09938_ FPGA_INST.cell0.LE_1B.dff0_out net522 _05220_ vssd1 vssd1 vccd1 vccd1 _00843_
+ sky130_fd_sc_hd__a21bo_1
Xfanout853 net854 vssd1 vssd1 vccd1 vccd1 net853 sky130_fd_sc_hd__clkbuf_2
XTAP_TAPCELL_ROW_5_354 vssd1 vccd1 sky130_fd_sc_hd__tapvpwrvgnd_1
Xfanout864 net865 vssd1 vssd1 vccd1 vccd1 net864 sky130_fd_sc_hd__buf_1
Xfanout875 net877 vssd1 vssd1 vccd1 vccd1 net875 sky130_fd_sc_hd__buf_2
XANTENNA__08722__A0 net20 vssd1 vssd1 vccd1 vccd1 sky130_fd_sc_hd__diode_2
Xfanout897 net898 vssd1 vssd1 vccd1 vccd1 net897 sky130_fd_sc_hd__clkbuf_2
Xfanout886 net891 vssd1 vssd1 vccd1 vccd1 net886 sky130_fd_sc_hd__clkbuf_1
X_09869_ FPGA_INST.cell0.LE_0A.dff0_out net522 _05217_ vssd1 vssd1 vccd1 vccd1 _00777_
+ sky130_fd_sc_hd__a21bo_1
XANTENNA_fanout849_X net849 vssd1 vssd1 vccd1 vccd1 sky130_fd_sc_hd__diode_2
X_11900_ net929 _01246_ net713 vssd1 vssd1 vccd1 vccd1 FPGA_INST.cell3.LE_0B.config_data\[8\]
+ sky130_fd_sc_hd__dfrtp_1
XFILLER_45_225 vssd1 vssd1 vccd1 vccd1 sky130_fd_sc_hd__fill_1
X_11831_ net915 _01177_ net699 vssd1 vssd1 vccd1 vccd1 FPGA_INST.cell3.LEI0.config_data\[11\]
+ sky130_fd_sc_hd__dfrtp_1
XANTENNA__09278__A1 FPGA_INST.cell1.SB0.route_sel\[49\] vssd1 vssd1 vccd1 vccd1 sky130_fd_sc_hd__diode_2
XTAP_TAPCELL_ROW_44_905 vssd1 vccd1 sky130_fd_sc_hd__tapvpwrvgnd_1
XTAP_TAPCELL_ROW_103_1727 vssd1 vccd1 sky130_fd_sc_hd__tapvpwrvgnd_1
XFILLER_60_228 vssd1 vssd1 vccd1 vccd1 sky130_fd_sc_hd__fill_8
XANTENNA__10925__SET_B net636 vssd1 vssd1 vccd1 vccd1 sky130_fd_sc_hd__diode_2
XFILLER_26_461 vssd1 vssd1 vccd1 vccd1 sky130_fd_sc_hd__fill_1
X_11762_ net924 _01108_ net708 vssd1 vssd1 vccd1 vccd1 FPGA_INST.io_west_oeb\[8\]
+ sky130_fd_sc_hd__dfrtp_1
XFILLER_26_96 vssd1 vssd1 vccd1 vccd1 sky130_fd_sc_hd__fill_1
X_11693_ net897 _01039_ net681 vssd1 vssd1 vccd1 vccd1 FPGA_INST.cell3.SB0.route_sel\[63\]
+ sky130_fd_sc_hd__dfstp_1
X_10713_ net869 _00063_ net654 vssd1 vssd1 vccd1 vccd1 FPGA_INST.cell2.LE_0A.config_data\[12\]
+ sky130_fd_sc_hd__dfrtp_1
X_10644_ FPGA_INST.cell3.LE_1B.config_data\[13\] FPGA_INST.cell3.LE_1B.config_data\[14\]
+ net280 vssd1 vssd1 vccd1 vccd1 _01523_ sky130_fd_sc_hd__mux2_1
XFILLER_42_62 vssd1 vssd1 vccd1 vccd1 sky130_fd_sc_hd__fill_1
X_10575_ FPGA_INST.cell3.CB_0.config_dataA\[20\] FPGA_INST.cell3.CB_0.config_dataA\[19\]
+ net371 vssd1 vssd1 vccd1 vccd1 _01454_ sky130_fd_sc_hd__mux2_1
X_12176_ net909 _01522_ net693 vssd1 vssd1 vccd1 vccd1 FPGA_INST.cell3.LE_1B.config_data\[13\]
+ sky130_fd_sc_hd__dfrtp_1
XFILLER_122_241 vssd1 vssd1 vccd1 vccd1 sky130_fd_sc_hd__fill_8
XTAP_TAPCELL_ROW_114_1878 vssd1 vccd1 sky130_fd_sc_hd__tapvpwrvgnd_1
XANTENNA__07257__X _03519_ vssd1 vssd1 vccd1 vccd1 sky130_fd_sc_hd__diode_2
XANTENNA__06016__A1 net122 vssd1 vssd1 vccd1 vccd1 sky130_fd_sc_hd__diode_2
X_11127_ net794 _00477_ net579 vssd1 vssd1 vccd1 vccd1 FPGA_INST.cell1.LE_1A.reset_val
+ sky130_fd_sc_hd__dfrtp_1
XFILLER_3_45 vssd1 vssd1 vccd1 vccd1 sky130_fd_sc_hd__fill_2
XFILLER_3_23 vssd1 vssd1 vccd1 vccd1 sky130_fd_sc_hd__fill_2
XFILLER_122_296 vccd1 vssd1 vccd1 vssd1 sky130_ef_sc_hd__decap_40_12
X_11058_ net796 _00408_ net580 vssd1 vssd1 vccd1 vccd1 FPGA_INST.cell1.LEI0.config_data\[43\]
+ sky130_fd_sc_hd__dfrtp_1
XFILLER_37_715 vssd1 vssd1 vccd1 vccd1 sky130_fd_sc_hd__fill_1
X_10009_ FPGA_INST.cell0.CB_0.config_dataA\[8\] FPGA_INST.cell0.CB_0.config_dataA\[9\]
+ net193 vssd1 vssd1 vccd1 vccd1 _00890_ sky130_fd_sc_hd__mux2_1
XFILLER_52_707 vssd1 vssd1 vccd1 vccd1 sky130_fd_sc_hd__fill_1
XFILLER_36_236 vssd1 vssd1 vccd1 vccd1 sky130_fd_sc_hd__fill_4
X_05550_ FPGA_INST.cfg_done net740 vssd1 vssd1 vccd1 vccd1 _01830_ sky130_fd_sc_hd__and2b_1
XFILLER_91_375 vssd1 vssd1 vccd1 vccd1 sky130_fd_sc_hd__fill_2
XFILLER_45_781 vssd1 vssd1 vccd1 vccd1 sky130_fd_sc_hd__fill_2
XFILLER_60_751 vssd1 vssd1 vccd1 vccd1 sky130_fd_sc_hd__fill_4
XFILLER_44_291 vssd1 vssd1 vccd1 vccd1 sky130_fd_sc_hd__fill_1
X_05481_ FPGA_INST.cell3.CB_0.config_dataA\[2\] vssd1 vssd1 vccd1 vccd1 _01763_ sky130_fd_sc_hd__inv_2
X_07220_ FPGA_INST.cell3.CB_0.config_dataB\[21\] FPGA_INST.cell3.CB_0.config_dataB\[24\]
+ FPGA_INST.cell3.CB_0.config_dataB\[20\] vssd1 vssd1 vccd1 vccd1 _03483_ sky130_fd_sc_hd__nor3b_2
X_07151_ _03404_ _03410_ _03414_ FPGA_INST.cell1.SB0.route_sel\[1\] FPGA_INST.cell1.SB0.route_sel\[0\]
+ vssd1 vssd1 vccd1 vccd1 _03415_ sky130_fd_sc_hd__o2111ai_4
XFILLER_9_671 vssd1 vssd1 vccd1 vccd1 sky130_fd_sc_hd__fill_1
XFILLER_9_660 vssd1 vssd1 vccd1 vccd1 sky130_fd_sc_hd__fill_2
XANTENNA__09794__S net327 vssd1 vssd1 vccd1 vccd1 sky130_fd_sc_hd__diode_2
X_06102_ net97 net383 net157 _02340_ _01825_ vssd1 vssd1 vccd1 vccd1 _02382_ sky130_fd_sc_hd__o32a_1
XTAP_TAPCELL_ROW_30_698 vssd1 vccd1 sky130_fd_sc_hd__tapvpwrvgnd_1
XFILLER_106_709 vssd1 vssd1 vccd1 vccd1 sky130_fd_sc_hd__fill_2
X_07082_ FPGA_INST.cell0.LE_0A.config_data\[7\] FPGA_INST.cell0.LE_0A.config_data\[6\]
+ _03313_ vssd1 vssd1 vccd1 vccd1 _03348_ sky130_fd_sc_hd__mux2_1
X_06033_ FPGA_INST.cell2.SB0.route_sel\[42\] FPGA_INST.cell2.SB0.route_sel\[43\] vssd1
+ vssd1 vccd1 vccd1 _02313_ sky130_fd_sc_hd__nand2_1
XFILLER_87_604 vssd1 vssd1 vccd1 vccd1 sky130_fd_sc_hd__fill_1
XFILLER_114_797 vssd1 vssd1 vccd1 vccd1 sky130_fd_sc_hd__fill_2
XFILLER_113_274 vssd1 vssd1 vccd1 vccd1 sky130_fd_sc_hd__fill_1
XFILLER_101_403 vssd1 vssd1 vccd1 vccd1 sky130_fd_sc_hd__fill_4
XFILLER_87_615 vssd1 vssd1 vccd1 vccd1 sky130_fd_sc_hd__fill_1
Xfanout138 net139 vssd1 vssd1 vccd1 vccd1 net138 sky130_fd_sc_hd__clkbuf_2
Xfanout127 net128 vssd1 vssd1 vccd1 vccd1 net127 sky130_fd_sc_hd__clkbuf_2
Xfanout116 net117 vssd1 vssd1 vccd1 vccd1 net116 sky130_fd_sc_hd__buf_2
Xfanout149 net150 vssd1 vssd1 vccd1 vccd1 net149 sky130_fd_sc_hd__clkbuf_2
X_07984_ FPGA_INST.cell1.CB_0.config_dataA\[17\] _04201_ _04203_ _04211_ vssd1 vssd1
+ vccd1 vccd1 _04212_ sky130_fd_sc_hd__o31a_1
XFILLER_101_458 vccd1 vssd1 vccd1 vssd1 sky130_ef_sc_hd__decap_40_12
XFILLER_74_309 vccd1 vssd1 vccd1 vssd1 sky130_ef_sc_hd__decap_40_12
X_09723_ FPGA_INST.cell0.SB0.route_sel\[126\] FPGA_INST.cell0.SB0.config_data_out
+ net200 vssd1 vssd1 vccd1 vccd1 _00632_ sky130_fd_sc_hd__mux2_1
XTAP_TAPCELL_ROW_2_313 vssd1 vccd1 sky130_fd_sc_hd__tapvpwrvgnd_1
X_06935_ net415 _01839_ _03202_ net414 vssd1 vssd1 vccd1 vccd1 _03203_ sky130_fd_sc_hd__o211a_1
XANTENNA_fanout377_A net378 vssd1 vssd1 vccd1 vccd1 sky130_fd_sc_hd__diode_2
X_06866_ _01937_ _03127_ _03129_ _01984_ _01741_ vssd1 vssd1 vccd1 vccd1 _03134_ sky130_fd_sc_hd__a221oi_1
X_09654_ FPGA_INST.cell0.SB0.route_sel\[57\] FPGA_INST.cell0.SB0.route_sel\[58\] net180
+ vssd1 vssd1 vccd1 vccd1 _00563_ sky130_fd_sc_hd__mux2_1
XFILLER_103_57 vssd1 vssd1 vccd1 vccd1 sky130_fd_sc_hd__fill_4
X_08605_ _04790_ _04813_ _04806_ _01763_ _04810_ vssd1 vssd1 vccd1 vccd1 _04814_ sky130_fd_sc_hd__a2111o_1
XANTENNA__08180__B2 _03408_ vssd1 vssd1 vccd1 vccd1 sky130_fd_sc_hd__diode_2
XANTENNA__08180__A1 _03465_ vssd1 vssd1 vccd1 vccd1 sky130_fd_sc_hd__diode_2
X_05817_ net120 net166 net162 _02013_ _01968_ vssd1 vssd1 vccd1 vccd1 _02097_ sky130_fd_sc_hd__o32ai_4
X_09585_ FPGA_INST.cell1.CB_1.config_dataB\[13\] FPGA_INST.cell1.CB_1.config_dataB\[14\]
+ net213 vssd1 vssd1 vccd1 vccd1 _00494_ sky130_fd_sc_hd__mux2_1
X_06797_ _02784_ _03051_ _03052_ _02780_ FPGA_INST.cell2.CB_1.config_dataB\[17\] vssd1
+ vssd1 vccd1 vccd1 _03071_ sky130_fd_sc_hd__a221o_1
XANTENNA_fanout165_X net165 vssd1 vssd1 vccd1 vccd1 sky130_fd_sc_hd__diode_2
XFILLER_36_781 vssd1 vssd1 vccd1 vccd1 sky130_fd_sc_hd__fill_4
X_08536_ _04747_ FPGA_INST.cell3.LE_1A.dff_out FPGA_INST.cell3.LE_1A.config_data\[16\]
+ vssd1 vssd1 vccd1 vccd1 _04748_ sky130_fd_sc_hd__mux2_1
X_05748_ FPGA_INST.cell0.SB0.route_sel\[82\] FPGA_INST.cell0.SB0.route_sel\[83\] vssd1
+ vssd1 vccd1 vccd1 _02028_ sky130_fd_sc_hd__nor2_1
XFILLER_35_291 vssd1 vssd1 vccd1 vccd1 sky130_fd_sc_hd__fill_2
XANTENNA_fanout332_X net332 vssd1 vssd1 vccd1 vccd1 sky130_fd_sc_hd__diode_2
X_08467_ _04683_ FPGA_INST.cell1.LE_1A.dff_out FPGA_INST.cell1.LE_1A.config_data\[16\]
+ vssd1 vssd1 vccd1 vccd1 _04684_ sky130_fd_sc_hd__mux2_1
XFILLER_11_615 vssd1 vssd1 vccd1 vccd1 sky130_fd_sc_hd__fill_1
X_05679_ net125 _01857_ _01955_ vssd1 vssd1 vccd1 vccd1 _01959_ sky130_fd_sc_hd__or3_1
XANTENNA_fanout809_A net811 vssd1 vssd1 vccd1 vccd1 sky130_fd_sc_hd__diode_2
X_07418_ FPGA_INST.cell1.SB0.route_sel\[48\] FPGA_INST.cell1.SB0.route_sel\[49\] vssd1
+ vssd1 vccd1 vccd1 _03676_ sky130_fd_sc_hd__nand2_1
X_08398_ net439 _03558_ vssd1 vssd1 vccd1 vccd1 _04620_ sky130_fd_sc_hd__nand2_1
XFILLER_109_503 vssd1 vssd1 vccd1 vccd1 sky130_fd_sc_hd__fill_1
X_07349_ net148 _03411_ _03607_ _03608_ _03600_ vssd1 vssd1 vccd1 vccd1 _03609_ sky130_fd_sc_hd__o311ai_2
XANTENNA__09432__A1 FPGA_INST.cell2.LE_1B.config_data\[0\] vssd1 vssd1 vccd1 vccd1
+ sky130_fd_sc_hd__diode_2
XANTENNA__06246__A1 _02010_ vssd1 vssd1 vccd1 vccd1 sky130_fd_sc_hd__diode_2
X_10360_ FPGA_INST.cell3.LE_0B.config_data\[1\] FPGA_INST.cell3.LE_0B.config_data\[2\]
+ net301 vssd1 vssd1 vccd1 vccd1 _01240_ sky130_fd_sc_hd__mux2_1
XANTENNA__06246__B2 _01966_ vssd1 vssd1 vccd1 vccd1 sky130_fd_sc_hd__diode_2
XFILLER_124_539 vssd1 vssd1 vccd1 vccd1 sky130_fd_sc_hd__fill_1
X_10291_ FPGA_INST.cell3.LEI0.config_data\[5\] FPGA_INST.cell3.LEI0.config_data\[6\]
+ net303 vssd1 vssd1 vccd1 vccd1 _01172_ sky130_fd_sc_hd__mux2_1
X_09019_ _01703_ FPGA_INST.cell3.SB0.route_sel\[19\] vssd1 vssd1 vccd1 vccd1 _05186_
+ sky130_fd_sc_hd__nand2_1
XANTENNA__08538__A3 _01792_ vssd1 vssd1 vccd1 vccd1 sky130_fd_sc_hd__diode_2
XFILLER_117_591 vssd1 vssd1 vccd1 vccd1 sky130_fd_sc_hd__fill_1
XANTENNA__09209__S net374 vssd1 vssd1 vccd1 vccd1 sky130_fd_sc_hd__diode_2
X_12030_ net879 _01376_ net643 vssd1 vssd1 vccd1 vccd1 FPGA_INST.cell2.SB0.route_sel\[70\]
+ sky130_fd_sc_hd__dfstp_1
XANTENNA__06549__A2 _02819_ vssd1 vssd1 vccd1 vccd1 sky130_fd_sc_hd__diode_2
XFILLER_2_379 vssd1 vssd1 vccd1 vccd1 sky130_fd_sc_hd__fill_2
XANTENNA_fanout78_X net78 vssd1 vssd1 vccd1 vccd1 sky130_fd_sc_hd__diode_2
Xfanout650 net662 vssd1 vssd1 vccd1 vccd1 net650 sky130_fd_sc_hd__buf_2
Xfanout694 net695 vssd1 vssd1 vccd1 vccd1 net694 sky130_fd_sc_hd__clkbuf_4
Xfanout683 net702 vssd1 vssd1 vccd1 vccd1 net683 sky130_fd_sc_hd__clkbuf_2
Xfanout672 net675 vssd1 vssd1 vccd1 vccd1 net672 sky130_fd_sc_hd__clkbuf_2
Xfanout661 net662 vssd1 vssd1 vccd1 vccd1 net661 sky130_fd_sc_hd__clkbuf_2
XTAP_TAPCELL_ROW_129_2085 vssd1 vccd1 sky130_fd_sc_hd__tapvpwrvgnd_1
XFILLER_92_139 vssd1 vssd1 vccd1 vccd1 sky130_fd_sc_hd__fill_1
XFILLER_46_523 vssd1 vssd1 vccd1 vccd1 sky130_fd_sc_hd__fill_2
XFILLER_46_567 vssd1 vssd1 vccd1 vccd1 sky130_fd_sc_hd__fill_8
XFILLER_73_386 vssd1 vssd1 vccd1 vccd1 sky130_fd_sc_hd__fill_2
X_11814_ net872 _01160_ net656 vssd1 vssd1 vccd1 vccd1 net39 sky130_fd_sc_hd__dfrtp_1
X_11745_ net895 _01091_ net679 vssd1 vssd1 vccd1 vccd1 FPGA_INST.cell3.SB0.route_sel\[115\]
+ sky130_fd_sc_hd__dfstp_1
XTAP_TAPCELL_ROW_60_1129 vssd1 vccd1 sky130_fd_sc_hd__tapvpwrvgnd_1
XTAP_TAPCELL_ROW_60_1118 vssd1 vccd1 sky130_fd_sc_hd__tapvpwrvgnd_1
X_11676_ net906 _01022_ net690 vssd1 vssd1 vccd1 vccd1 FPGA_INST.cell3.SB0.route_sel\[46\]
+ sky130_fd_sc_hd__dfstp_1
XANTENNA__05501__A net99 vssd1 vssd1 vccd1 vccd1 sky130_fd_sc_hd__diode_2
XTAP_TAPCELL_ROW_116_1907 vssd1 vccd1 sky130_fd_sc_hd__tapvpwrvgnd_1
X_10627_ FPGA_INST.cell3.CB_1.config_dataA\[21\] FPGA_INST.cell3.CB_1.config_dataA\[22\]
+ net278 vssd1 vssd1 vccd1 vccd1 _01506_ sky130_fd_sc_hd__mux2_1
XANTENNA__06237__A1 net8 vssd1 vssd1 vccd1 vccd1 sky130_fd_sc_hd__diode_2
XFILLER_10_670 vssd1 vssd1 vccd1 vccd1 sky130_fd_sc_hd__fill_2
X_10558_ FPGA_INST.cell3.CB_0.config_dataA\[3\] FPGA_INST.cell3.CB_0.config_dataA\[2\]
+ net373 vssd1 vssd1 vccd1 vccd1 _01437_ sky130_fd_sc_hd__mux2_1
X_10489_ FPGA_INST.cell2.SB0.route_sel\[61\] FPGA_INST.cell2.SB0.route_sel\[62\] net238
+ vssd1 vssd1 vccd1 vccd1 _01368_ sky130_fd_sc_hd__mux2_1
XFILLER_111_701 vssd1 vssd1 vccd1 vccd1 sky130_fd_sc_hd__fill_1
XFILLER_111_756 vssd1 vssd1 vccd1 vccd1 sky130_fd_sc_hd__fill_2
X_12159_ net912 _01505_ net696 vssd1 vssd1 vccd1 vccd1 FPGA_INST.cell3.CB_1.config_dataA\[21\]
+ sky130_fd_sc_hd__dfstp_1
XFILLER_83_139 vssd1 vssd1 vccd1 vccd1 sky130_fd_sc_hd__fill_1
XFILLER_77_670 vssd1 vssd1 vccd1 vccd1 sky130_fd_sc_hd__fill_2
X_06720_ net516 net517 vssd1 vssd1 vccd1 vccd1 _02994_ sky130_fd_sc_hd__and2b_1
X_06651_ _02819_ _02918_ _02925_ _02926_ vssd1 vssd1 vccd1 vccd1 _02927_ sky130_fd_sc_hd__a211o_1
X_05602_ FPGA_INST.cell0.SB0.route_sel\[122\] FPGA_INST.cell0.SB0.route_sel\[123\]
+ _01878_ _01880_ _01881_ vssd1 vssd1 vccd1 vccd1 _01882_ sky130_fd_sc_hd__a221o_1
XFILLER_24_206 vssd1 vssd1 vccd1 vccd1 sky130_fd_sc_hd__fill_1
XTAP_TAPCELL_ROW_86_1490 vssd1 vccd1 sky130_fd_sc_hd__tapvpwrvgnd_1
XFILLER_52_559 vssd1 vssd1 vccd1 vccd1 sky130_fd_sc_hd__fill_8
X_06582_ net484 _02836_ _02857_ net482 vssd1 vssd1 vccd1 vccd1 _02858_ sky130_fd_sc_hd__o211a_1
X_09370_ FPGA_INST.cell2.CB_0.config_dataA\[13\] FPGA_INST.cell2.CB_0.config_dataA\[14\]
+ net237 vssd1 vssd1 vccd1 vccd1 _00283_ sky130_fd_sc_hd__mux2_1
X_05533_ FPGA_INST.cell2.CB_0.config_dataA\[7\] _01812_ FPGA_INST.cell2.CB_0.config_dataA\[8\]
+ vssd1 vssd1 vccd1 vccd1 _01813_ sky130_fd_sc_hd__a21bo_1
X_08321_ FPGA_INST.cell0.LEI0.config_data\[23\] _04542_ vssd1 vssd1 vccd1 vccd1 _04543_
+ sky130_fd_sc_hd__nand2b_1
XTAP_TAPCELL_ROW_35_768 vssd1 vccd1 sky130_fd_sc_hd__tapvpwrvgnd_1
XTAP_TAPCELL_ROW_35_779 vssd1 vccd1 sky130_fd_sc_hd__tapvpwrvgnd_1
X_08252_ FPGA_INST.bus1_0\[10\] FPGA_INST.bus1_0\[11\] net404 vssd1 vssd1 vccd1 vccd1
+ _04476_ sky130_fd_sc_hd__mux2_1
X_05464_ FPGA_INST.cell0.CB_0.config_dataB\[12\] vssd1 vssd1 vccd1 vccd1 _01746_ sky130_fd_sc_hd__inv_2
X_07203_ _03462_ _03463_ _03464_ _02426_ _02417_ vssd1 vssd1 vccd1 vccd1 _03466_ sky130_fd_sc_hd__a311o_1
XTAP_TAPCELL_ROW_15_492 vssd1 vccd1 sky130_fd_sc_hd__tapvpwrvgnd_1
XFILLER_118_300 vssd1 vssd1 vccd1 vccd1 sky130_fd_sc_hd__fill_2
X_05395_ FPGA_INST.cell0.SB0.route_sel\[53\] vssd1 vssd1 vccd1 vccd1 _01677_ sky130_fd_sc_hd__inv_2
X_08183_ net115 net119 net112 net99 FPGA_INST.cell0.LEI0.config_data\[6\] FPGA_INST.cell0.LEI0.config_data\[7\]
+ vssd1 vssd1 vccd1 vccd1 _04407_ sky130_fd_sc_hd__mux4_1
X_07134_ FPGA_INST.cell1.CB_0.config_dataB\[24\] FPGA_INST.cell1.CB_0.config_dataB\[20\]
+ FPGA_INST.cell1.CB_0.config_dataB\[21\] vssd1 vssd1 vccd1 vccd1 _03398_ sky130_fd_sc_hd__nor3_2
XFILLER_106_539 vssd1 vssd1 vccd1 vccd1 sky130_fd_sc_hd__fill_2
XANTENNA__07976__A1 FPGA_INST.bus3_1\[13\] vssd1 vssd1 vccd1 vccd1 sky130_fd_sc_hd__diode_2
XANTENNA__10463__S net352 vssd1 vssd1 vccd1 vccd1 sky130_fd_sc_hd__diode_2
X_07065_ FPGA_INST.bus2_0\[4\] _03317_ _03330_ _01734_ FPGA_INST.cell0.CB_0.config_dataA\[13\]
+ vssd1 vssd1 vccd1 vccd1 _03331_ sky130_fd_sc_hd__a2111o_1
X_06016_ net122 net166 net160 _02174_ _01968_ vssd1 vssd1 vccd1 vccd1 _02296_ sky130_fd_sc_hd__o32ai_2
XFILLER_114_572 vssd1 vssd1 vccd1 vccd1 sky130_fd_sc_hd__fill_2
XFILLER_102_701 vssd1 vssd1 vccd1 vccd1 sky130_fd_sc_hd__fill_4
XANTENNA__07728__A1 net89 vssd1 vssd1 vccd1 vccd1 sky130_fd_sc_hd__diode_2
XFILLER_87_445 vssd1 vssd1 vccd1 vccd1 sky130_fd_sc_hd__fill_2
X_07967_ net463 _03728_ vssd1 vssd1 vccd1 vccd1 _04195_ sky130_fd_sc_hd__nand2_1
XFILLER_59_169 vssd1 vssd1 vccd1 vccd1 sky130_fd_sc_hd__fill_1
XANTENNA_fanout661_A net662 vssd1 vssd1 vccd1 vccd1 sky130_fd_sc_hd__diode_2
X_06918_ FPGA_INST.cell0.CB_0.config_dataB\[13\] _03184_ _03185_ FPGA_INST.cell0.CB_0.config_dataB\[12\]
+ vssd1 vssd1 vccd1 vccd1 _03186_ sky130_fd_sc_hd__or4b_1
X_09706_ FPGA_INST.cell0.SB0.route_sel\[109\] FPGA_INST.cell0.SB0.route_sel\[110\]
+ net197 vssd1 vssd1 vccd1 vccd1 _00615_ sky130_fd_sc_hd__mux2_1
X_07898_ net472 _03568_ vssd1 vssd1 vccd1 vccd1 _04126_ sky130_fd_sc_hd__nand2_1
XFILLER_74_27 vssd1 vssd1 vccd1 vccd1 sky130_fd_sc_hd__fill_1
XANTENNA__07900__A1 _03421_ vssd1 vssd1 vccd1 vccd1 sky130_fd_sc_hd__diode_2
XANTENNA_fanout926_A net931 vssd1 vssd1 vccd1 vccd1 sky130_fd_sc_hd__diode_2
X_06849_ _03115_ _03116_ _03113_ vssd1 vssd1 vccd1 vccd1 _03117_ sky130_fd_sc_hd__o21a_1
XFILLER_15_206 vssd1 vssd1 vccd1 vccd1 sky130_fd_sc_hd__fill_1
XFILLER_28_578 vssd1 vssd1 vccd1 vccd1 sky130_fd_sc_hd__fill_1
XFILLER_28_589 vssd1 vssd1 vccd1 vccd1 sky130_fd_sc_hd__fill_4
X_09637_ FPGA_INST.cell0.SB0.route_sel\[40\] FPGA_INST.cell0.SB0.route_sel\[41\] net185
+ vssd1 vssd1 vccd1 vccd1 _00546_ sky130_fd_sc_hd__mux2_1
XANTENNA__07900__B2 _03475_ vssd1 vssd1 vccd1 vccd1 sky130_fd_sc_hd__diode_2
X_09568_ FPGA_INST.cell1.LE_1A.reset_val FPGA_INST.cell1.LE_1A.edge_mode net326 vssd1
+ vssd1 vccd1 vccd1 _00477_ sky130_fd_sc_hd__mux2_1
XFILLER_70_323 vssd1 vssd1 vccd1 vccd1 sky130_fd_sc_hd__fill_1
X_08519_ net93 net88 FPGA_INST.cell3.CB_1.le_outA net79 FPGA_INST.cell3.LEI0.config_data\[42\]
+ FPGA_INST.cell3.LEI0.config_data\[43\] vssd1 vssd1 vccd1 vccd1 _04732_ sky130_fd_sc_hd__mux4_1
XANTENNA__05799__Y _02079_ vssd1 vssd1 vccd1 vccd1 sky130_fd_sc_hd__diode_2
X_11530_ net810 _00880_ net596 vssd1 vssd1 vccd1 vccd1 FPGA_INST.config_bits\[11\]
+ sky130_fd_sc_hd__dfstp_1
X_09499_ FPGA_INST.cell1.LEI0.config_data\[45\] FPGA_INST.cell1.LEI0.config_data\[46\]
+ net211 vssd1 vssd1 vccd1 vccd1 _00411_ sky130_fd_sc_hd__mux2_1
XANTENNA__07520__B _03775_ vssd1 vssd1 vccd1 vccd1 sky130_fd_sc_hd__diode_2
XFILLER_11_412 vssd1 vssd1 vccd1 vccd1 sky130_fd_sc_hd__fill_8
XANTENNA__06467__A1 _02131_ vssd1 vssd1 vccd1 vccd1 sky130_fd_sc_hd__diode_2
XANTENNA__06467__B2 _02168_ vssd1 vssd1 vccd1 vccd1 sky130_fd_sc_hd__diode_2
XFILLER_23_283 vssd1 vssd1 vccd1 vccd1 sky130_fd_sc_hd__fill_4
XFILLER_23_53 vssd1 vssd1 vccd1 vccd1 sky130_fd_sc_hd__fill_2
X_11461_ net771 _00811_ net556 vssd1 vssd1 vccd1 vccd1 FPGA_INST.cell0.LE_0B.config_data\[10\]
+ sky130_fd_sc_hd__dfrtp_1
X_10412_ FPGA_INST.cell3.CB_1.config_dataB\[9\] FPGA_INST.cell3.CB_1.config_dataB\[10\]
+ net283 vssd1 vssd1 vccd1 vccd1 _01291_ sky130_fd_sc_hd__mux2_1
XANTENNA__07416__B1 FPGA_INST.bus3_1\[6\] vssd1 vssd1 vccd1 vccd1 sky130_fd_sc_hd__diode_2
X_11392_ net747 _00742_ net532 vssd1 vssd1 vccd1 vccd1 FPGA_INST.cell0.LEI0.config_data\[13\]
+ sky130_fd_sc_hd__dfrtp_1
XANTENNA__10373__S net305 vssd1 vssd1 vccd1 vccd1 sky130_fd_sc_hd__diode_2
XANTENNA__07519__Y _03775_ vssd1 vssd1 vccd1 vccd1 sky130_fd_sc_hd__diode_2
X_10343_ FPGA_INST.cell3.LE_0A.config_data\[7\] FPGA_INST.cell3.LE_0A.config_data\[8\]
+ net292 vssd1 vssd1 vccd1 vccd1 _01224_ sky130_fd_sc_hd__mux2_1
XFILLER_124_369 vssd1 vssd1 vccd1 vccd1 sky130_fd_sc_hd__fill_1
XTAP_TAPCELL_ROW_111_1837 vssd1 vccd1 sky130_fd_sc_hd__tapvpwrvgnd_1
XFILLER_105_561 vssd1 vssd1 vccd1 vccd1 sky130_fd_sc_hd__fill_1
XFILLER_78_412 vssd1 vssd1 vccd1 vccd1 sky130_fd_sc_hd__fill_1
XTAP_TAPCELL_ROW_57_1080 vssd1 vccd1 sky130_fd_sc_hd__tapvpwrvgnd_1
X_10274_ net33 net34 net253 vssd1 vssd1 vccd1 vccd1 _01155_ sky130_fd_sc_hd__mux2_1
XFILLER_120_531 vssd1 vssd1 vccd1 vccd1 sky130_fd_sc_hd__fill_1
X_12013_ net777 _01359_ net563 vssd1 vssd1 vccd1 vccd1 FPGA_INST.cell2.SB0.route_sel\[53\]
+ sky130_fd_sc_hd__dfstp_1
XFILLER_38_309 vssd1 vssd1 vccd1 vccd1 sky130_fd_sc_hd__fill_1
XFILLER_120_597 vssd1 vssd1 vccd1 vccd1 sky130_fd_sc_hd__fill_1
Xfanout480 FPGA_INST.cell2.CB_1.config_dataA\[6\] vssd1 vssd1 vccd1 vccd1 net480 sky130_fd_sc_hd__buf_2
Xfanout491 net492 vssd1 vssd1 vccd1 vccd1 net491 sky130_fd_sc_hd__buf_2
XFILLER_0_68 vccd1 vssd1 vccd1 vssd1 sky130_ef_sc_hd__decap_40_12
XFILLER_74_695 vssd1 vssd1 vccd1 vccd1 sky130_fd_sc_hd__fill_2
XFILLER_61_378 vssd1 vssd1 vccd1 vccd1 sky130_fd_sc_hd__fill_2
XFILLER_61_356 vssd1 vssd1 vccd1 vccd1 sky130_fd_sc_hd__fill_1
XANTENNA__09402__S net355 vssd1 vssd1 vccd1 vccd1 sky130_fd_sc_hd__diode_2
XTAP_TAPCELL_ROW_122_1988 vssd1 vccd1 sky130_fd_sc_hd__tapvpwrvgnd_1
XANTENNA__10548__S net241 vssd1 vssd1 vccd1 vccd1 sky130_fd_sc_hd__diode_2
XTAP_TAPCELL_ROW_32_727 vssd1 vccd1 sky130_fd_sc_hd__tapvpwrvgnd_1
X_11728_ net903 _01074_ net687 vssd1 vssd1 vccd1 vccd1 FPGA_INST.cell3.SB0.route_sel\[98\]
+ sky130_fd_sc_hd__dfstp_1
XFILLER_30_754 vssd1 vssd1 vccd1 vccd1 sky130_fd_sc_hd__fill_2
XPHY_EDGE_ROW_104_Right_104 vssd1 vssd1 vccd1 vccd1 sky130_fd_sc_hd__decap_3
X_11659_ net894 _01005_ net678 vssd1 vssd1 vccd1 vccd1 FPGA_INST.cell3.SB0.route_sel\[29\]
+ sky130_fd_sc_hd__dfstp_1
XTAP_TAPCELL_ROW_12_451 vssd1 vccd1 sky130_fd_sc_hd__tapvpwrvgnd_1
XFILLER_127_174 vssd1 vssd1 vccd1 vccd1 sky130_fd_sc_hd__fill_1
XTAP_TAPCELL_ROW_73_1309 vssd1 vccd1 sky130_fd_sc_hd__tapvpwrvgnd_1
XANTENNA__08261__B _03558_ vssd1 vssd1 vccd1 vccd1 sky130_fd_sc_hd__diode_2
X_08870_ net22 _05072_ _05076_ FPGA_INST.cell3.CB_0.config_dataB\[16\] _01779_ vssd1
+ vssd1 vccd1 vccd1 _05077_ sky130_fd_sc_hd__a221o_1
XFILLER_97_721 vssd1 vssd1 vccd1 vccd1 sky130_fd_sc_hd__fill_2
XFILLER_69_423 vssd1 vssd1 vccd1 vccd1 sky130_fd_sc_hd__fill_1
X_07821_ _01861_ _01862_ _04063_ _01863_ vssd1 vssd1 vccd1 vccd1 net58 sky130_fd_sc_hd__a31o_1
XFILLER_97_798 vssd1 vssd1 vccd1 vccd1 sky130_fd_sc_hd__fill_1
XANTENNA__06933__A2 FPGA_INST.bus2_0\[13\] vssd1 vssd1 vccd1 vccd1 sky130_fd_sc_hd__diode_2
XFILLER_84_448 vssd1 vssd1 vccd1 vccd1 sky130_fd_sc_hd__fill_2
X_07752_ _03507_ _03926_ vssd1 vssd1 vccd1 vccd1 _04002_ sky130_fd_sc_hd__nor2_1
XFILLER_56_139 vssd1 vssd1 vccd1 vccd1 sky130_fd_sc_hd__fill_1
X_06703_ net519 _02975_ _02976_ vssd1 vssd1 vccd1 vccd1 _02977_ sky130_fd_sc_hd__a21o_1
X_07683_ _01944_ _02819_ _01949_ _01947_ vssd1 vssd1 vccd1 vccd1 _03935_ sky130_fd_sc_hd__o211a_1
XANTENNA__07894__A0 FPGA_INST.bus3_1\[0\] vssd1 vssd1 vccd1 vccd1 sky130_fd_sc_hd__diode_2
XFILLER_80_643 vssd1 vssd1 vccd1 vccd1 sky130_fd_sc_hd__fill_1
X_09422_ net476 net474 net249 vssd1 vssd1 vccd1 vccd1 _00335_ sky130_fd_sc_hd__mux2_1
X_06634_ FPGA_INST.cell2.CB_1.config_dataA\[13\] _02881_ FPGA_INST.cell2.CB_1.config_dataA\[12\]
+ FPGA_INST.cell2.CB_1.config_dataA\[14\] vssd1 vssd1 vccd1 vccd1 _02910_ sky130_fd_sc_hd__or4b_1
X_09353_ FPGA_INST.cell1.SB0.route_sel\[124\] FPGA_INST.cell1.SB0.route_sel\[125\]
+ net199 vssd1 vssd1 vccd1 vccd1 _00266_ sky130_fd_sc_hd__mux2_1
X_08304_ FPGA_INST.bus1_0\[8\] _04518_ _04525_ net444 FPGA_INST.cell0.CB_1.config_dataB\[7\]
+ vssd1 vssd1 vccd1 vccd1 _04526_ sky130_fd_sc_hd__a221o_1
XANTENNA_fanout242_A net244 vssd1 vssd1 vccd1 vccd1 sky130_fd_sc_hd__diode_2
XFILLER_33_570 vssd1 vssd1 vccd1 vccd1 sky130_fd_sc_hd__fill_4
XANTENNA__06508__Y _02784_ vssd1 vssd1 vccd1 vccd1 sky130_fd_sc_hd__diode_2
X_06565_ FPGA_INST.cell2.SB0.route_sel\[76\] FPGA_INST.cell2.SB0.route_sel\[77\] vssd1
+ vssd1 vccd1 vccd1 _02841_ sky130_fd_sc_hd__nor2_1
X_09284_ FPGA_INST.cell1.SB0.route_sel\[56\] FPGA_INST.cell1.SB0.route_sel\[55\] net328
+ vssd1 vssd1 vccd1 vccd1 _00197_ sky130_fd_sc_hd__mux2_1
X_05516_ FPGA_INST.bus3_2\[14\] vssd1 vssd1 vccd1 vccd1 _01798_ sky130_fd_sc_hd__inv_2
X_06496_ net237 _02404_ _02409_ _02771_ vssd1 vssd1 vccd1 vccd1 _02772_ sky130_fd_sc_hd__nand4_4
X_05447_ FPGA_INST.cell1.LE_0B.config_data\[16\] vssd1 vssd1 vccd1 vccd1 _01729_ sky130_fd_sc_hd__inv_2
X_08235_ _04458_ vssd1 vssd1 vccd1 vccd1 _04459_ sky130_fd_sc_hd__inv_2
XFILLER_60_29 vssd1 vssd1 vccd1 vccd1 sky130_fd_sc_hd__fill_2
XFILLER_21_776 vssd1 vssd1 vccd1 vccd1 sky130_fd_sc_hd__fill_8
XFILLER_118_141 vssd1 vssd1 vccd1 vccd1 sky130_fd_sc_hd__fill_1
XFILLER_118_130 vssd1 vssd1 vccd1 vccd1 sky130_fd_sc_hd__fill_8
XANTENNA__09548__A net736 vssd1 vssd1 vccd1 vccd1 sky130_fd_sc_hd__diode_2
XTAP_TAPCELL_ROW_99_1670 vssd1 vccd1 sky130_fd_sc_hd__tapvpwrvgnd_1
X_05378_ FPGA_INST.cell1.SB0.route_sel\[70\] vssd1 vssd1 vccd1 vccd1 _01660_ sky130_fd_sc_hd__inv_2
X_08166_ FPGA_INST.bus1_0\[10\] FPGA_INST.bus1_0\[11\] net412 vssd1 vssd1 vccd1 vccd1
+ _04390_ sky130_fd_sc_hd__mux2_1
XANTENNA__09938__A2 net522 vssd1 vssd1 vccd1 vccd1 sky130_fd_sc_hd__diode_2
XFILLER_4_419 vssd1 vssd1 vccd1 vccd1 sky130_fd_sc_hd__fill_1
X_07117_ _03381_ _03382_ _03279_ vssd1 vssd1 vccd1 vccd1 _03383_ sky130_fd_sc_hd__mux2_1
X_08097_ net455 _04013_ _04322_ FPGA_INST.cell1.CB_0.config_dataB\[11\] vssd1 vssd1
+ vccd1 vccd1 _04323_ sky130_fd_sc_hd__o211a_1
XFILLER_106_336 vssd1 vssd1 vccd1 vccd1 sky130_fd_sc_hd__fill_1
XANTENNA__10193__S net285 vssd1 vssd1 vccd1 vccd1 sky130_fd_sc_hd__diode_2
XANTENNA__06621__A1 FPGA_INST.bus3_2\[13\] vssd1 vssd1 vccd1 vccd1 sky130_fd_sc_hd__diode_2
X_07048_ FPGA_INST.cell0.LE_0A.config_data\[5\] FPGA_INST.cell0.LE_0A.config_data\[4\]
+ _03313_ vssd1 vssd1 vccd1 vccd1 _03314_ sky130_fd_sc_hd__mux2_1
XFILLER_85_15 vssd1 vssd1 vccd1 vccd1 sky130_fd_sc_hd__fill_1
XANTENNA__06385__A0 net7 vssd1 vssd1 vccd1 vccd1 sky130_fd_sc_hd__diode_2
XANTENNA_input2_X net2 vssd1 vssd1 vccd1 vccd1 sky130_fd_sc_hd__diode_2
XANTENNA__11553__CLK net772 vssd1 vssd1 vccd1 vccd1 sky130_fd_sc_hd__diode_2
XFILLER_85_37 vssd1 vssd1 vccd1 vccd1 sky130_fd_sc_hd__fill_8
X_08999_ _01556_ FPGA_INST.cell2.SB0.route_sel\[33\] FPGA_INST.cell2.SB0.route_sel\[38\]
+ FPGA_INST.cell2.SB0.route_sel\[39\] _05172_ vssd1 vssd1 vccd1 vccd1 _05173_ sky130_fd_sc_hd__o221a_1
XTAP_TAPCELL_ROW_126_2044 vssd1 vccd1 sky130_fd_sc_hd__tapvpwrvgnd_1
XFILLER_18_42 vssd1 vssd1 vccd1 vccd1 sky130_fd_sc_hd__fill_2
XANTENNA_fanout831_X net831 vssd1 vssd1 vccd1 vccd1 sky130_fd_sc_hd__diode_2
X_10961_ net866 _00311_ net653 vssd1 vssd1 vccd1 vccd1 FPGA_INST.cell2.CB_0.config_dataB\[17\]
+ sky130_fd_sc_hd__dfstp_1
X_10892_ net825 _00242_ net609 vssd1 vssd1 vccd1 vccd1 FPGA_INST.cell1.SB0.route_sel\[101\]
+ sky130_fd_sc_hd__dfstp_1
XFILLER_34_41 vssd1 vssd1 vccd1 vccd1 sky130_fd_sc_hd__fill_2
XANTENNA__07637__B1 _03889_ vssd1 vssd1 vccd1 vccd1 sky130_fd_sc_hd__diode_2
XFILLER_12_743 vssd1 vssd1 vccd1 vccd1 sky130_fd_sc_hd__fill_1
XFILLER_12_754 vssd1 vssd1 vccd1 vccd1 sky130_fd_sc_hd__fill_2
XFILLER_34_85 vssd1 vssd1 vccd1 vccd1 sky130_fd_sc_hd__fill_1
X_11513_ net768 _00863_ net553 vssd1 vssd1 vccd1 vccd1 FPGA_INST.cell0.CB_1.config_dataB\[19\]
+ sky130_fd_sc_hd__dfstp_1
X_11444_ net775 _00794_ net561 vssd1 vssd1 vccd1 vccd1 FPGA_INST.cell0.LE_0A.config_data\[15\]
+ sky130_fd_sc_hd__dfrtp_1
XFILLER_109_163 vssd1 vssd1 vccd1 vccd1 sky130_fd_sc_hd__fill_4
X_11375_ net816 _00725_ net601 vssd1 vssd1 vccd1 vccd1 FPGA_INST.cell1.LE_1B.edge_mode
+ sky130_fd_sc_hd__dfstp_1
XANTENNA__08081__B _03728_ vssd1 vssd1 vccd1 vccd1 sky130_fd_sc_hd__diode_2
X_10326_ FPGA_INST.cell3.LEI0.config_data\[40\] FPGA_INST.cell3.LEI0.config_data\[41\]
+ net300 vssd1 vssd1 vccd1 vccd1 _01207_ sky130_fd_sc_hd__mux2_1
X_10257_ FPGA_INST.io_east_oeb\[2\] FPGA_INST.io_east_oeb\[4\] net264 vssd1 vssd1
+ vccd1 vccd1 _01138_ sky130_fd_sc_hd__mux2_1
XFILLER_79_798 vssd1 vssd1 vccd1 vccd1 sky130_fd_sc_hd__fill_1
X_10188_ FPGA_INST.cell3.SB0.route_sel\[93\] FPGA_INST.cell3.SB0.route_sel\[92\] net364
+ vssd1 vssd1 vccd1 vccd1 _01069_ sky130_fd_sc_hd__mux2_1
XFILLER_94_757 vssd1 vssd1 vccd1 vccd1 sky130_fd_sc_hd__fill_4
XFILLER_93_223 vssd1 vssd1 vccd1 vccd1 sky130_fd_sc_hd__fill_1
XFILLER_66_448 vssd1 vssd1 vccd1 vccd1 sky130_fd_sc_hd__fill_8
XFILLER_46_150 vssd1 vssd1 vccd1 vccd1 sky130_fd_sc_hd__fill_1
XFILLER_62_643 vssd1 vssd1 vccd1 vccd1 sky130_fd_sc_hd__fill_1
XTAP_TAPCELL_ROW_17_521 vssd1 vccd1 sky130_fd_sc_hd__tapvpwrvgnd_1
XANTENNA__08537__A net156 vssd1 vssd1 vccd1 vccd1 sky130_fd_sc_hd__diode_2
XANTENNA__07441__A net84 vssd1 vssd1 vccd1 vccd1 sky130_fd_sc_hd__diode_2
XFILLER_34_367 vccd1 vssd1 vccd1 vssd1 sky130_ef_sc_hd__decap_40_12
XFILLER_98_3 vssd1 vssd1 vccd1 vccd1 sky130_fd_sc_hd__fill_4
X_06350_ net494 _02255_ net493 vssd1 vssd1 vccd1 vccd1 _02628_ sky130_fd_sc_hd__o21a_1
X_06281_ net2 _02540_ _02558_ net502 _02560_ vssd1 vssd1 vccd1 vccd1 _02561_ sky130_fd_sc_hd__a221o_1
X_05301_ FPGA_INST.cell2.SB0.route_sel\[119\] vssd1 vssd1 vccd1 vccd1 _01583_ sky130_fd_sc_hd__inv_2
X_08020_ net458 _03854_ net456 vssd1 vssd1 vccd1 vccd1 _04246_ sky130_fd_sc_hd__o21ai_1
XANTENNA__06851__A1 FPGA_INST.bus2_0\[9\] vssd1 vssd1 vccd1 vccd1 sky130_fd_sc_hd__diode_2
XFILLER_128_472 vssd1 vssd1 vccd1 vccd1 sky130_fd_sc_hd__fill_2
XFILLER_115_111 vssd1 vssd1 vccd1 vccd1 sky130_fd_sc_hd__fill_1
X_09971_ net740 FPGA_INST.config_bits\[1\] FPGA_INST.config_bits\[0\] FPGA_INST.config_bits\[2\]
+ vssd1 vssd1 vccd1 vccd1 _05226_ sky130_fd_sc_hd__a31o_1
XFILLER_103_328 vssd1 vssd1 vccd1 vccd1 sky130_fd_sc_hd__fill_1
X_08922_ _03980_ _05121_ vssd1 vssd1 vccd1 vccd1 FPGA_INST.bus3_1\[13\] sky130_fd_sc_hd__and2_2
XFILLER_69_220 vssd1 vssd1 vccd1 vccd1 sky130_fd_sc_hd__fill_4
XFILLER_69_231 vssd1 vssd1 vccd1 vccd1 sky130_fd_sc_hd__fill_1
XANTENNA__08356__A1 _03797_ vssd1 vssd1 vccd1 vccd1 sky130_fd_sc_hd__diode_2
X_08853_ FPGA_INST.cell3.CB_0.config_dataB\[13\] FPGA_INST.cell3.CB_0.config_dataB\[12\]
+ FPGA_INST.cell3.CB_0.config_dataB\[14\] _05038_ vssd1 vssd1 vccd1 vccd1 _05060_
+ sky130_fd_sc_hd__or4bb_1
XANTENNA__10163__A1 FPGA_INST.cell3.SB0.route_sel\[68\] vssd1 vssd1 vccd1 vccd1 sky130_fd_sc_hd__diode_2
X_08784_ net390 _04801_ vssd1 vssd1 vccd1 vccd1 _04991_ sky130_fd_sc_hd__nand2_1
X_07804_ _01894_ _02814_ _01898_ _01897_ vssd1 vssd1 vccd1 vccd1 _04053_ sky130_fd_sc_hd__a211oi_1
X_05996_ FPGA_INST.cell2.SB0.route_sel\[32\] FPGA_INST.cell2.SB0.route_sel\[33\] vssd1
+ vssd1 vccd1 vccd1 _02276_ sky130_fd_sc_hd__nand2_1
XFILLER_84_267 vssd1 vssd1 vccd1 vccd1 sky130_fd_sc_hd__fill_2
X_07735_ FPGA_INST.cell3.SB0.route_sel\[114\] FPGA_INST.cell3.SB0.route_sel\[115\]
+ vssd1 vssd1 vccd1 vccd1 _03985_ sky130_fd_sc_hd__nand2_1
XFILLER_72_418 vssd1 vssd1 vccd1 vccd1 sky130_fd_sc_hd__fill_2
XANTENNA__08659__A2 net20 vssd1 vssd1 vccd1 vccd1 sky130_fd_sc_hd__diode_2
XANTENNA__07622__Y _03875_ vssd1 vssd1 vccd1 vccd1 sky130_fd_sc_hd__diode_2
X_07666_ FPGA_INST.cell1.SB0.route_sel\[97\] FPGA_INST.cell1.SB0.route_sel\[96\] _03914_
+ _03915_ _03916_ vssd1 vssd1 vccd1 vccd1 _03918_ sky130_fd_sc_hd__a221o_1
X_09405_ FPGA_INST.cell2.CB_0.config_dataB\[24\] FPGA_INST.cell2.CB_0.config_dataB\[23\]
+ net355 vssd1 vssd1 vccd1 vccd1 _00318_ sky130_fd_sc_hd__mux2_1
XANTENNA_fanout624_A net626 vssd1 vssd1 vccd1 vccd1 sky130_fd_sc_hd__diode_2
X_07597_ _03843_ _03846_ _03850_ vssd1 vssd1 vccd1 vccd1 _03851_ sky130_fd_sc_hd__o21a_1
XANTENNA__10188__S net364 vssd1 vssd1 vccd1 vccd1 sky130_fd_sc_hd__diode_2
X_06617_ net479 _02836_ vssd1 vssd1 vccd1 vccd1 _02893_ sky130_fd_sc_hd__or2_1
XFILLER_13_529 vssd1 vssd1 vccd1 vccd1 sky130_fd_sc_hd__fill_1
XFILLER_40_304 vssd1 vssd1 vccd1 vccd1 sky130_fd_sc_hd__fill_4
X_09336_ FPGA_INST.cell1.SB0.route_sel\[107\] FPGA_INST.cell1.SB0.route_sel\[108\]
+ net223 vssd1 vssd1 vccd1 vccd1 _00249_ sky130_fd_sc_hd__mux2_1
X_06548_ _02823_ vssd1 vssd1 vccd1 vccd1 _02824_ sky130_fd_sc_hd__inv_2
XFILLER_52_197 vssd1 vssd1 vccd1 vccd1 sky130_fd_sc_hd__fill_1
XANTENNA__09084__A2 net524 vssd1 vssd1 vccd1 vccd1 sky130_fd_sc_hd__diode_2
XANTENNA__11493__RESET_B net732 vssd1 vssd1 vccd1 vccd1 sky130_fd_sc_hd__diode_2
XANTENNA__07070__B _01888_ vssd1 vssd1 vccd1 vccd1 sky130_fd_sc_hd__diode_2
X_09267_ FPGA_INST.cell1.SB0.route_sel\[39\] FPGA_INST.cell1.SB0.route_sel\[38\] net329
+ vssd1 vssd1 vccd1 vccd1 _00180_ sky130_fd_sc_hd__mux2_1
XANTENNA__07095__A1 FPGA_INST.bus2_0\[1\] vssd1 vssd1 vccd1 vccd1 sky130_fd_sc_hd__diode_2
X_08218_ net407 _03682_ _04441_ FPGA_INST.cell0.CB_1.config_dataA\[11\] vssd1 vssd1
+ vccd1 vccd1 _04442_ sky130_fd_sc_hd__o211a_1
X_06479_ FPGA_INST.cell2.LE_0B.config_data\[3\] FPGA_INST.cell2.LE_0B.config_data\[2\]
+ _02688_ vssd1 vssd1 vccd1 vccd1 _02757_ sky130_fd_sc_hd__mux2_1
XANTENNA__08044__A0 FPGA_INST.bus3_1\[4\] vssd1 vssd1 vccd1 vccd1 sky130_fd_sc_hd__diode_2
X_09198_ FPGA_INST.cell2.LE_1A.config_data\[15\] FPGA_INST.cell2.LE_1A.config_data\[16\]
+ net263 vssd1 vssd1 vccd1 vccd1 _00111_ sky130_fd_sc_hd__mux2_1
X_08149_ FPGA_INST.cell1.LE_0B.config_data\[11\] FPGA_INST.cell1.LE_0B.config_data\[10\]
+ _04296_ vssd1 vssd1 vccd1 vccd1 _04375_ sky130_fd_sc_hd__mux2_1
X_11160_ net821 _00510_ net605 vssd1 vssd1 vccd1 vccd1 FPGA_INST.cell0.SB0.route_sel\[5\]
+ sky130_fd_sc_hd__dfstp_1
X_11091_ net839 _00441_ net623 vssd1 vssd1 vccd1 vccd1 FPGA_INST.cell1.LE_0B.config_data\[4\]
+ sky130_fd_sc_hd__dfrtp_1
X_10111_ FPGA_INST.cell3.SB0.route_sel\[16\] FPGA_INST.cell3.SB0.route_sel\[15\] net364
+ vssd1 vssd1 vccd1 vccd1 _00992_ sky130_fd_sc_hd__mux2_1
XFILLER_20_87 vssd1 vssd1 vccd1 vccd1 sky130_fd_sc_hd__fill_1
X_10042_ FPGA_INST.cell0.CB_0.config_dataB\[17\] net414 net309 vssd1 vssd1 vccd1 vccd1
+ _00923_ sky130_fd_sc_hd__mux2_1
XFILLER_121_169 vssd1 vssd1 vccd1 vccd1 sky130_fd_sc_hd__fill_4
XFILLER_0_477 vssd1 vssd1 vccd1 vccd1 sky130_fd_sc_hd__fill_1
XFILLER_76_757 vssd1 vssd1 vccd1 vccd1 sky130_fd_sc_hd__fill_4
XANTENNA_input18_A gpio_in[25] vssd1 vssd1 vccd1 vccd1 sky130_fd_sc_hd__diode_2
XFILLER_29_662 vssd1 vssd1 vccd1 vccd1 sky130_fd_sc_hd__fill_2
XANTENNA__07858__A0 FPGA_INST.bus3_1\[0\] vssd1 vssd1 vccd1 vccd1 sky130_fd_sc_hd__diode_2
XFILLER_56_481 vssd1 vssd1 vccd1 vccd1 sky130_fd_sc_hd__fill_2
XFILLER_44_610 vssd1 vssd1 vccd1 vccd1 sky130_fd_sc_hd__fill_2
X_11993_ net852 _01339_ net637 vssd1 vssd1 vccd1 vccd1 FPGA_INST.cell2.SB0.route_sel\[33\]
+ sky130_fd_sc_hd__dfstp_1
XTAP_TAPCELL_ROW_106_1769 vssd1 vccd1 sky130_fd_sc_hd__tapvpwrvgnd_1
XFILLER_44_643 vssd1 vssd1 vccd1 vccd1 sky130_fd_sc_hd__fill_1
X_10944_ net849 _00294_ net634 vssd1 vssd1 vccd1 vccd1 FPGA_INST.cell2.CB_0.config_dataB\[0\]
+ sky130_fd_sc_hd__dfstp_1
XANTENNA__07873__A3 FPGA_INST.bus3_1\[15\] vssd1 vssd1 vccd1 vccd1 sky130_fd_sc_hd__diode_2
X_10875_ net791 _00225_ net576 vssd1 vssd1 vccd1 vccd1 FPGA_INST.cell1.SB0.route_sel\[84\]
+ sky130_fd_sc_hd__dfstp_1
XFILLER_71_473 vssd1 vssd1 vccd1 vccd1 sky130_fd_sc_hd__fill_1
XFILLER_44_698 vssd1 vssd1 vccd1 vccd1 sky130_fd_sc_hd__fill_2
XTAP_TAPCELL_ROW_65_1190 vssd1 vccd1 sky130_fd_sc_hd__tapvpwrvgnd_1
XFILLER_31_337 vssd1 vssd1 vccd1 vccd1 sky130_fd_sc_hd__fill_2
XFILLER_31_348 vssd1 vssd1 vccd1 vccd1 sky130_fd_sc_hd__fill_1
XTAP_TAPCELL_ROW_42_877 vssd1 vccd1 sky130_fd_sc_hd__tapvpwrvgnd_1
XTAP_TAPCELL_ROW_42_866 vssd1 vccd1 sky130_fd_sc_hd__tapvpwrvgnd_1
XFILLER_129_247 vssd1 vssd1 vccd1 vccd1 sky130_fd_sc_hd__fill_1
XANTENNA__08822__A2 FPGA_INST.cell3.CB_1.le_outA vssd1 vssd1 vccd1 vccd1 sky130_fd_sc_hd__diode_2
XANTENNA__05636__A2 _01869_ vssd1 vssd1 vccd1 vccd1 sky130_fd_sc_hd__diode_2
XFILLER_8_533 vssd1 vssd1 vccd1 vccd1 sky130_fd_sc_hd__fill_2
XANTENNA__06833__A1 FPGA_INST.bus2_0\[7\] vssd1 vssd1 vccd1 vccd1 sky130_fd_sc_hd__diode_2
XTAP_TAPCELL_ROW_22_590 vssd1 vccd1 sky130_fd_sc_hd__tapvpwrvgnd_1
XFILLER_125_431 vssd1 vssd1 vccd1 vccd1 sky130_fd_sc_hd__fill_1
X_11427_ FPGA_INST.cell0.LE_0A.sel_clk _00777_ net732 vssd1 vssd1 vccd1 vccd1 FPGA_INST.cell0.LE_0A.dff0_out
+ sky130_fd_sc_hd__dfrtp_1
X_11358_ net835 _00708_ net619 vssd1 vssd1 vccd1 vccd1 FPGA_INST.cell1.LE_1B.config_data\[0\]
+ sky130_fd_sc_hd__dfrtp_1
XFILLER_113_604 vssd1 vssd1 vccd1 vccd1 sky130_fd_sc_hd__fill_8
XANTENNA__09916__A net736 vssd1 vssd1 vccd1 vccd1 sky130_fd_sc_hd__diode_2
XFILLER_6_78 vssd1 vssd1 vccd1 vccd1 sky130_fd_sc_hd__fill_4
X_10309_ FPGA_INST.cell3.LEI0.config_data\[24\] FPGA_INST.cell3.LEI0.config_data\[23\]
+ net378 vssd1 vssd1 vccd1 vccd1 _01190_ sky130_fd_sc_hd__mux2_1
XFILLER_112_114 vssd1 vssd1 vccd1 vccd1 sky130_fd_sc_hd__fill_1
XANTENNA__06061__A2 net170 vssd1 vssd1 vccd1 vccd1 sky130_fd_sc_hd__diode_2
X_11289_ net833 _00639_ net617 vssd1 vssd1 vccd1 vccd1 FPGA_INST.cell1.CB_0.config_dataA\[6\]
+ sky130_fd_sc_hd__dfstp_1
XFILLER_100_309 vssd1 vssd1 vccd1 vccd1 sky130_fd_sc_hd__fill_1
XFILLER_39_426 vssd1 vssd1 vccd1 vccd1 sky130_fd_sc_hd__fill_8
XFILLER_120_180 vssd1 vssd1 vccd1 vccd1 sky130_fd_sc_hd__fill_1
XFILLER_94_543 vssd1 vssd1 vccd1 vccd1 sky130_fd_sc_hd__fill_4
XFILLER_13_3 vccd1 vssd1 vccd1 vssd1 sky130_ef_sc_hd__decap_40_12
X_05850_ FPGA_INST.cell2.SB0.route_sel\[78\] _01570_ FPGA_INST.cell2.SB0.route_sel\[74\]
+ FPGA_INST.cell2.SB0.route_sel\[75\] _02129_ vssd1 vssd1 vccd1 vccd1 _02130_ sky130_fd_sc_hd__o221a_1
XFILLER_82_727 vssd1 vssd1 vccd1 vccd1 sky130_fd_sc_hd__fill_1
X_07520_ _03428_ _03775_ vssd1 vssd1 vccd1 vccd1 _03776_ sky130_fd_sc_hd__nor2_1
X_05781_ net96 net170 _02016_ _02019_ _01879_ vssd1 vssd1 vccd1 vccd1 _02061_ sky130_fd_sc_hd__o32a_1
XFILLER_35_621 vssd1 vssd1 vccd1 vccd1 sky130_fd_sc_hd__fill_2
XFILLER_62_451 vssd1 vssd1 vccd1 vccd1 sky130_fd_sc_hd__fill_1
XANTENNA__06339__X _02619_ vssd1 vssd1 vccd1 vccd1 sky130_fd_sc_hd__diode_2
XFILLER_35_665 vssd1 vssd1 vccd1 vccd1 sky130_fd_sc_hd__fill_2
X_07451_ net81 _03542_ _03587_ _03706_ _03707_ vssd1 vssd1 vccd1 vccd1 _03708_ sky130_fd_sc_hd__o311a_1
XTAP_TAPCELL_ROW_81_1419 vssd1 vccd1 sky130_fd_sc_hd__tapvpwrvgnd_1
X_07382_ FPGA_INST.cell1.SB0.route_sel\[47\] FPGA_INST.cell1.SB0.route_sel\[46\] _02301_
+ _03640_ _02302_ vssd1 vssd1 vccd1 vccd1 _03641_ sky130_fd_sc_hd__a221o_1
X_06402_ net9 net10 net11 net13 net497 net496 vssd1 vssd1 vccd1 vccd1 _02680_ sky130_fd_sc_hd__mux4_1
XFILLER_22_348 vssd1 vssd1 vccd1 vccd1 sky130_fd_sc_hd__fill_1
XFILLER_34_197 vssd1 vssd1 vccd1 vccd1 sky130_fd_sc_hd__fill_1
X_06333_ _02612_ _02611_ _02502_ vssd1 vssd1 vccd1 vccd1 _02613_ sky130_fd_sc_hd__mux2_1
X_09121_ FPGA_INST.cell2.LEI0.config_data\[36\] FPGA_INST.cell2.LEI0.config_data\[35\]
+ net357 vssd1 vssd1 vccd1 vccd1 _00037_ sky130_fd_sc_hd__mux2_1
XANTENNA__08274__B1 _04495_ vssd1 vssd1 vccd1 vccd1 sky130_fd_sc_hd__diode_2
XFILLER_129_781 vssd1 vssd1 vccd1 vccd1 sky130_fd_sc_hd__fill_2
X_06264_ net504 _01914_ vssd1 vssd1 vccd1 vccd1 _02544_ sky130_fd_sc_hd__nand2_1
X_09052_ net530 FPGA_INST.cell0.LE_1A.reset_mode vssd1 vssd1 vccd1 vccd1 _09052_/X
+ sky130_fd_sc_hd__xor2_2
X_08003_ _01727_ _04230_ vssd1 vssd1 vccd1 vccd1 _04231_ sky130_fd_sc_hd__nand2_1
X_06195_ _01797_ _02471_ _02472_ _02474_ vssd1 vssd1 vccd1 vccd1 _02475_ sky130_fd_sc_hd__o211ai_1
XANTENNA__09774__A0 FPGA_INST.cell1.CB_0.config_dataB\[24\] vssd1 vssd1 vccd1 vccd1
+ sky130_fd_sc_hd__diode_2
XFILLER_106_24 vssd1 vssd1 vccd1 vccd1 sky130_fd_sc_hd__fill_4
XFILLER_89_359 vssd1 vssd1 vccd1 vccd1 sky130_fd_sc_hd__fill_4
XANTENNA__08329__A1 FPGA_INST.bus1_0\[13\] vssd1 vssd1 vccd1 vccd1 sky130_fd_sc_hd__diode_2
XANTENNA__08329__B2 net77 vssd1 vssd1 vccd1 vccd1 sky130_fd_sc_hd__diode_2
X_09954_ FPGA_INST.cell0.CB_1.config_dataB\[14\] net439 net184 vssd1 vssd1 vccd1 vccd1
+ _00859_ sky130_fd_sc_hd__mux2_1
XFILLER_103_169 vssd1 vssd1 vccd1 vccd1 sky130_fd_sc_hd__fill_4
XANTENNA__08800__A1_N _04828_ vssd1 vssd1 vccd1 vccd1 sky130_fd_sc_hd__diode_2
X_08905_ FPGA_INST.cell1.SB0.route_sel\[116\] FPGA_INST.cell1.SB0.route_sel\[117\]
+ vssd1 vssd1 vccd1 vccd1 _05110_ sky130_fd_sc_hd__nand2b_1
X_09885_ FPGA_INST.cell0.LE_0A.config_data\[13\] FPGA_INST.cell0.LE_0A.config_data\[12\]
+ net318 vssd1 vssd1 vccd1 vccd1 _00792_ sky130_fd_sc_hd__mux2_1
XANTENNA_fanout574_A net575 vssd1 vssd1 vccd1 vccd1 sky130_fd_sc_hd__diode_2
X_08836_ _05041_ _05042_ FPGA_INST.cell3.CB_0.config_dataB\[12\] vssd1 vssd1 vccd1
+ vccd1 _05043_ sky130_fd_sc_hd__mux2_1
XFILLER_58_757 vssd1 vssd1 vccd1 vccd1 sky130_fd_sc_hd__fill_1
XFILLER_57_223 vssd1 vssd1 vccd1 vccd1 sky130_fd_sc_hd__fill_1
XTAP_TAPCELL_ROW_123_2003 vssd1 vccd1 sky130_fd_sc_hd__tapvpwrvgnd_1
XFILLER_85_576 vccd1 vssd1 vccd1 vssd1 sky130_ef_sc_hd__decap_40_12
XANTENNA__07552__A2 _03806_ vssd1 vssd1 vccd1 vccd1 sky130_fd_sc_hd__diode_2
XFILLER_17_109 vssd1 vssd1 vccd1 vccd1 sky130_fd_sc_hd__fill_2
XANTENNA_fanout839_A net842 vssd1 vssd1 vccd1 vccd1 sky130_fd_sc_hd__diode_2
XFILLER_122_34 vssd1 vssd1 vccd1 vccd1 sky130_fd_sc_hd__fill_2
X_08767_ net390 net389 vssd1 vssd1 vccd1 vccd1 _04974_ sky130_fd_sc_hd__nor2_1
XFILLER_73_738 vssd1 vssd1 vccd1 vccd1 sky130_fd_sc_hd__fill_1
XANTENNA__06760__A0 FPGA_INST.bus3_2\[0\] vssd1 vssd1 vccd1 vccd1 sky130_fd_sc_hd__diode_2
XANTENNA_fanout362_X net362 vssd1 vssd1 vccd1 vccd1 sky130_fd_sc_hd__diode_2
X_05979_ net167 _02178_ vssd1 vssd1 vccd1 vccd1 _02259_ sky130_fd_sc_hd__nor2_1
XFILLER_26_610 vssd1 vssd1 vccd1 vccd1 sky130_fd_sc_hd__fill_2
XFILLER_122_89 vssd1 vssd1 vccd1 vccd1 sky130_fd_sc_hd__fill_2
X_08698_ net397 _04781_ net396 vssd1 vssd1 vccd1 vccd1 _04907_ sky130_fd_sc_hd__o21a_1
X_07718_ _03953_ _03955_ _03968_ _03967_ vssd1 vssd1 vccd1 vccd1 _03969_ sky130_fd_sc_hd__a31o_1
XFILLER_82_27 vssd1 vssd1 vccd1 vccd1 sky130_fd_sc_hd__fill_1
XTAP_TAPCELL_ROW_0_263 vssd1 vccd1 sky130_fd_sc_hd__tapvpwrvgnd_1
XFILLER_26_643 vssd1 vssd1 vccd1 vccd1 sky130_fd_sc_hd__fill_1
XFILLER_26_654 vssd1 vssd1 vccd1 vccd1 sky130_fd_sc_hd__fill_8
X_07649_ net89 _03899_ _03901_ vssd1 vssd1 vccd1 vccd1 _03902_ sky130_fd_sc_hd__o21ba_1
XANTENNA__06512__A0 FPGA_INST.bus3_2\[0\] vssd1 vssd1 vccd1 vccd1 sky130_fd_sc_hd__diode_2
XTAP_TAPCELL_ROW_0_274 vssd1 vccd1 sky130_fd_sc_hd__tapvpwrvgnd_1
XTAP_TAPCELL_ROW_0_285 vssd1 vccd1 sky130_fd_sc_hd__tapvpwrvgnd_1
XFILLER_26_687 vssd1 vssd1 vccd1 vccd1 sky130_fd_sc_hd__fill_2
XANTENNA_fanout627_X net627 vssd1 vssd1 vccd1 vccd1 sky130_fd_sc_hd__diode_2
X_10660_ net884 _00010_ net668 vssd1 vssd1 vccd1 vccd1 FPGA_INST.cell2.LEI0.config_data\[9\]
+ sky130_fd_sc_hd__dfrtp_1
XFILLER_25_197 vssd1 vssd1 vccd1 vccd1 sky130_fd_sc_hd__fill_4
X_09319_ FPGA_INST.cell1.SB0.route_sel\[90\] FPGA_INST.cell1.SB0.route_sel\[91\] net208
+ vssd1 vssd1 vccd1 vccd1 _00232_ sky130_fd_sc_hd__mux2_1
XFILLER_41_668 vssd1 vssd1 vccd1 vccd1 sky130_fd_sc_hd__fill_4
X_10591_ FPGA_INST.cell3.CB_0.config_dataB\[10\] FPGA_INST.cell3.CB_0.config_dataB\[11\]
+ net302 vssd1 vssd1 vccd1 vccd1 _01470_ sky130_fd_sc_hd__mux2_1
XTAP_TAPCELL_ROW_101_1699 vssd1 vccd1 sky130_fd_sc_hd__tapvpwrvgnd_1
X_11212_ net756 _00562_ net541 vssd1 vssd1 vccd1 vccd1 FPGA_INST.cell0.SB0.route_sel\[57\]
+ sky130_fd_sc_hd__dfstp_1
Xoutput42 net42 vssd1 vssd1 vccd1 vccd1 gpio_oeb[31] sky130_fd_sc_hd__buf_2
Xoutput64 net64 vssd1 vssd1 vccd1 vccd1 gpio_out[29] sky130_fd_sc_hd__buf_2
XFILLER_122_456 vccd1 vssd1 vccd1 vssd1 sky130_ef_sc_hd__decap_40_12
X_11143_ net809 _00493_ net595 vssd1 vssd1 vccd1 vccd1 FPGA_INST.cell1.CB_1.config_dataB\[13\]
+ sky130_fd_sc_hd__dfstp_1
XTAP_TAPCELL_ROW_52_1009 vssd1 vccd1 sky130_fd_sc_hd__tapvpwrvgnd_1
Xoutput53 net53 vssd1 vssd1 vccd1 vccd1 gpio_out[18] sky130_fd_sc_hd__buf_2
X_11074_ net837 _00424_ net621 vssd1 vssd1 vccd1 vccd1 FPGA_INST.cell1.LE_0A.config_data\[9\]
+ sky130_fd_sc_hd__dfrtp_1
XANTENNA__10127__A1 FPGA_INST.cell3.SB0.route_sel\[31\] vssd1 vssd1 vccd1 vccd1 sky130_fd_sc_hd__diode_2
XTAP_TAPCELL_ROW_8_396 vssd1 vccd1 sky130_fd_sc_hd__tapvpwrvgnd_1
X_10025_ FPGA_INST.cell0.CB_0.config_dataA\[24\] net425 net191 vssd1 vssd1 vccd1 vccd1
+ _00906_ sky130_fd_sc_hd__mux2_1
XFILLER_36_418 vssd1 vssd1 vccd1 vccd1 sky130_fd_sc_hd__fill_2
XTAP_TAPCELL_ROW_47_947 vssd1 vccd1 sky130_fd_sc_hd__tapvpwrvgnd_1
XTAP_TAPCELL_ROW_47_936 vssd1 vccd1 sky130_fd_sc_hd__tapvpwrvgnd_1
XFILLER_91_557 vssd1 vssd1 vccd1 vccd1 sky130_fd_sc_hd__fill_2
X_11976_ net845 _01322_ net630 vssd1 vssd1 vccd1 vccd1 FPGA_INST.cell2.SB0.route_sel\[16\]
+ sky130_fd_sc_hd__dfstp_1
XFILLER_44_462 vssd1 vssd1 vccd1 vccd1 sky130_fd_sc_hd__fill_2
X_10927_ net851 _00277_ net636 vssd1 vssd1 vccd1 vccd1 FPGA_INST.cell2.CB_0.config_dataA\[8\]
+ sky130_fd_sc_hd__dfstp_1
XTAP_TAPCELL_ROW_27_660 vssd1 vccd1 sky130_fd_sc_hd__tapvpwrvgnd_1
XFILLER_71_270 vssd1 vssd1 vccd1 vccd1 sky130_fd_sc_hd__fill_8
X_10858_ net801 _00208_ net586 vssd1 vssd1 vccd1 vccd1 FPGA_INST.cell1.SB0.route_sel\[67\]
+ sky130_fd_sc_hd__dfstp_1
XANTENNA__08256__A0 net77 vssd1 vssd1 vccd1 vccd1 sky130_fd_sc_hd__diode_2
X_10789_ net859 _00139_ net645 vssd1 vssd1 vccd1 vccd1 FPGA_INST.cell2.CB_1.config_dataB\[23\]
+ sky130_fd_sc_hd__dfstp_1
XANTENNA__05510__Y _01792_ vssd1 vssd1 vccd1 vccd1 sky130_fd_sc_hd__diode_2
XTAP_TAPCELL_ROW_119_1949 vssd1 vccd1 sky130_fd_sc_hd__tapvpwrvgnd_1
XANTENNA__05609__A2 _01873_ vssd1 vssd1 vccd1 vccd1 sky130_fd_sc_hd__diode_2
XTAP_TAPCELL_ROW_78_1381 vssd1 vccd1 sky130_fd_sc_hd__tapvpwrvgnd_1
XTAP_TAPCELL_ROW_78_1370 vssd1 vccd1 sky130_fd_sc_hd__tapvpwrvgnd_1
XFILLER_113_401 vssd1 vssd1 vccd1 vccd1 sky130_fd_sc_hd__fill_4
Xfanout309 net315 vssd1 vssd1 vccd1 vccd1 net309 sky130_fd_sc_hd__clkbuf_4
XFILLER_4_580 vssd1 vssd1 vccd1 vccd1 sky130_fd_sc_hd__fill_1
XFILLER_101_629 vssd1 vssd1 vccd1 vccd1 sky130_fd_sc_hd__fill_2
X_06951_ FPGA_INST.bus2_0\[5\] _03199_ FPGA_INST.cell0.CB_0.config_dataB\[18\] _01749_
+ vssd1 vssd1 vccd1 vccd1 _03219_ sky130_fd_sc_hd__a211o_1
XFILLER_100_139 vssd1 vssd1 vccd1 vccd1 sky130_fd_sc_hd__fill_1
X_05902_ net96 net170 net159 _02181_ _01879_ vssd1 vssd1 vccd1 vccd1 _02182_ sky130_fd_sc_hd__o32a_1
X_09670_ FPGA_INST.cell0.SB0.route_sel\[73\] FPGA_INST.cell0.SB0.route_sel\[74\] net185
+ vssd1 vssd1 vccd1 vccd1 _00579_ sky130_fd_sc_hd__mux2_1
XFILLER_39_212 vssd1 vssd1 vccd1 vccd1 sky130_fd_sc_hd__fill_1
XANTENNA__08731__A1 _04843_ vssd1 vssd1 vccd1 vccd1 sky130_fd_sc_hd__diode_2
XANTENNA__08731__B2 _04846_ vssd1 vssd1 vccd1 vccd1 sky130_fd_sc_hd__diode_2
XANTENNA__11819__SET_B net734 vssd1 vssd1 vccd1 vccd1 sky130_fd_sc_hd__diode_2
X_08621_ _01712_ FPGA_INST.cell3.SB0.route_sel\[12\] _01713_ FPGA_INST.cell3.SB0.route_sel\[15\]
+ _04829_ vssd1 vssd1 vccd1 vccd1 _04830_ sky130_fd_sc_hd__a221o_1
XFILLER_67_554 vssd1 vssd1 vccd1 vccd1 sky130_fd_sc_hd__fill_4
X_06882_ FPGA_INST.cell0.CB_0.config_dataB\[3\] _01741_ _03148_ _03149_ vssd1 vssd1
+ vccd1 vccd1 _03150_ sky130_fd_sc_hd__or4_1
X_05833_ FPGA_INST.cell2.SB0.route_sel\[74\] FPGA_INST.cell2.SB0.route_sel\[75\] vssd1
+ vssd1 vccd1 vccd1 _02113_ sky130_fd_sc_hd__nand2_1
XFILLER_39_278 vssd1 vssd1 vccd1 vccd1 sky130_fd_sc_hd__fill_2
XANTENNA__08709__B net79 vssd1 vssd1 vccd1 vccd1 sky130_fd_sc_hd__diode_2
X_08552_ _04762_ vssd1 vssd1 vccd1 vccd1 _04763_ sky130_fd_sc_hd__inv_2
X_05764_ _02032_ _02034_ _02035_ _02043_ vssd1 vssd1 vccd1 vccd1 _02044_ sky130_fd_sc_hd__a211o_1
X_08483_ _04698_ _04693_ _04688_ vssd1 vssd1 vccd1 vccd1 _04699_ sky130_fd_sc_hd__mux2_1
XANTENNA__11085__RESET_B net733 vssd1 vssd1 vccd1 vccd1 sky130_fd_sc_hd__diode_2
X_07503_ _03756_ _03757_ _03758_ _02142_ vssd1 vssd1 vccd1 vccd1 _03759_ sky130_fd_sc_hd__a31o_2
XFILLER_35_484 vssd1 vssd1 vccd1 vccd1 sky130_fd_sc_hd__fill_2
X_07434_ FPGA_INST.cell3.SB0.route_sel\[53\] FPGA_INST.cell3.SB0.route_sel\[52\] _03673_
+ _03691_ _03675_ vssd1 vssd1 vccd1 vccd1 _03692_ sky130_fd_sc_hd__a221o_1
X_05695_ FPGA_INST.cell0.CB_1.config_dataA\[24\] FPGA_INST.cell0.CB_1.config_dataA\[21\]
+ FPGA_INST.cell0.CB_1.config_dataA\[20\] vssd1 vssd1 vccd1 vccd1 _01975_ sky130_fd_sc_hd__or3b_4
XANTENNA__06229__B _02217_ vssd1 vssd1 vccd1 vccd1 sky130_fd_sc_hd__diode_2
XANTENNA_fanout155_A _02619_ vssd1 vssd1 vccd1 vccd1 sky130_fd_sc_hd__diode_2
X_07365_ net22 net85 _03621_ vssd1 vssd1 vccd1 vccd1 _03625_ sky130_fd_sc_hd__mux2_1
XANTENNA_fanout322_A net324 vssd1 vssd1 vccd1 vccd1 sky130_fd_sc_hd__diode_2
XFILLER_109_707 vssd1 vssd1 vccd1 vccd1 sky130_fd_sc_hd__fill_2
X_07296_ FPGA_INST.cell0.SB0.route_sel\[29\] FPGA_INST.cell0.SB0.route_sel\[28\] _01700_
+ FPGA_INST.cell0.SB0.route_sel\[31\] _03556_ vssd1 vssd1 vccd1 vccd1 _03557_ sky130_fd_sc_hd__o221a_1
X_09104_ FPGA_INST.cell2.LEI0.config_data\[18\] FPGA_INST.cell2.LEI0.config_data\[19\]
+ net259 vssd1 vssd1 vccd1 vccd1 _00020_ sky130_fd_sc_hd__mux2_1
X_06316_ net30 _02574_ _02575_ net2 _02595_ vssd1 vssd1 vccd1 vccd1 _02596_ sky130_fd_sc_hd__a221o_1
X_06247_ _02522_ _02523_ _02525_ _02526_ vssd1 vssd1 vccd1 vccd1 _02527_ sky130_fd_sc_hd__o22a_1
X_09035_ _01548_ FPGA_INST.cell2.SB0.route_sel\[1\] FPGA_INST.cell2.SB0.route_sel\[6\]
+ FPGA_INST.cell2.SB0.route_sel\[7\] _05196_ vssd1 vssd1 vccd1 vccd1 _05197_ sky130_fd_sc_hd__o221a_1
XANTENNA_fanout691_A net695 vssd1 vssd1 vccd1 vccd1 sky130_fd_sc_hd__diode_2
XFILLER_89_101 vssd1 vssd1 vccd1 vccd1 sky130_fd_sc_hd__fill_1
X_06178_ FPGA_INST.cell0.SB0.route_sel\[3\] FPGA_INST.cell0.SB0.route_sel\[2\] _02455_
+ _02456_ _02457_ vssd1 vssd1 vccd1 vccd1 _02458_ sky130_fd_sc_hd__a221o_1
XFILLER_89_134 vssd1 vssd1 vccd1 vccd1 sky130_fd_sc_hd__fill_4
XFILLER_77_27 vccd1 vssd1 vccd1 vssd1 sky130_ef_sc_hd__decap_40_12
XANTENNA_fanout789_A net790 vssd1 vssd1 vccd1 vccd1 sky130_fd_sc_hd__diode_2
Xfanout843 net1 vssd1 vssd1 vccd1 vccd1 net843 sky130_fd_sc_hd__clkbuf_4
Xfanout810 net811 vssd1 vssd1 vccd1 vccd1 net810 sky130_fd_sc_hd__clkbuf_2
Xfanout832 net833 vssd1 vssd1 vccd1 vccd1 net832 sky130_fd_sc_hd__clkbuf_2
XFILLER_104_467 vssd1 vssd1 vccd1 vccd1 sky130_fd_sc_hd__fill_1
XANTENNA__08970__A1 _03716_ vssd1 vssd1 vccd1 vccd1 sky130_fd_sc_hd__diode_2
Xfanout821 net823 vssd1 vssd1 vccd1 vccd1 net821 sky130_fd_sc_hd__clkbuf_2
XANTENNA__06576__A3 FPGA_INST.bus3_2\[15\] vssd1 vssd1 vccd1 vccd1 sky130_fd_sc_hd__diode_2
X_09937_ FPGA_INST.cell0.LE_1A.reset_val FPGA_INST.cell0.LE_1A.reset_mode net175 vssd1
+ vssd1 vccd1 vccd1 _00842_ sky130_fd_sc_hd__mux2_1
XANTENNA__05784__A1 net171 vssd1 vssd1 vccd1 vccd1 sky130_fd_sc_hd__diode_2
XANTENNA_fanout577_X net577 vssd1 vssd1 vccd1 vccd1 sky130_fd_sc_hd__diode_2
Xfanout854 net862 vssd1 vssd1 vccd1 vccd1 net854 sky130_fd_sc_hd__buf_1
XTAP_TAPCELL_ROW_5_355 vssd1 vccd1 sky130_fd_sc_hd__tapvpwrvgnd_1
Xfanout865 net892 vssd1 vssd1 vccd1 vccd1 net865 sky130_fd_sc_hd__clkbuf_2
Xfanout876 net877 vssd1 vssd1 vccd1 vccd1 net876 sky130_fd_sc_hd__buf_1
XANTENNA__08722__A1 net21 vssd1 vssd1 vccd1 vccd1 sky130_fd_sc_hd__diode_2
Xfanout898 net899 vssd1 vssd1 vccd1 vccd1 net898 sky130_fd_sc_hd__clkbuf_2
Xfanout887 net891 vssd1 vssd1 vccd1 vccd1 net887 sky130_fd_sc_hd__clkbuf_2
XFILLER_58_554 vssd1 vssd1 vccd1 vccd1 sky130_fd_sc_hd__fill_1
X_09868_ FPGA_INST.cell0.LEI0.config_data\[46\] FPGA_INST.cell0.CB_0.config_data_inA
+ net179 vssd1 vssd1 vccd1 vccd1 _00776_ sky130_fd_sc_hd__mux2_1
X_09799_ FPGA_INST.cell1.LE_0A.reset_mode FPGA_INST.cell1.LE_1B.config_data\[0\] net228
+ vssd1 vssd1 vccd1 vccd1 _00708_ sky130_fd_sc_hd__mux2_1
X_08819_ _05018_ _05019_ _05025_ vssd1 vssd1 vccd1 vccd1 _05026_ sky130_fd_sc_hd__o21a_1
XFILLER_85_395 vssd1 vssd1 vccd1 vccd1 sky130_fd_sc_hd__fill_1
XFILLER_73_524 vssd1 vssd1 vccd1 vccd1 sky130_fd_sc_hd__fill_4
XANTENNA__06733__A0 FPGA_INST.bus3_2\[4\] vssd1 vssd1 vccd1 vccd1 sky130_fd_sc_hd__diode_2
XFILLER_46_749 vssd1 vssd1 vccd1 vccd1 sky130_fd_sc_hd__fill_4
X_11830_ net915 _01176_ net699 vssd1 vssd1 vccd1 vccd1 FPGA_INST.cell3.LEI0.config_data\[10\]
+ sky130_fd_sc_hd__dfrtp_1
X_11761_ net923 _01107_ net707 vssd1 vssd1 vccd1 vccd1 FPGA_INST.io_west_oeb\[6\]
+ sky130_fd_sc_hd__dfrtp_1
XFILLER_26_473 vssd1 vssd1 vccd1 vccd1 sky130_fd_sc_hd__fill_2
XTAP_TAPCELL_ROW_103_1728 vssd1 vccd1 sky130_fd_sc_hd__tapvpwrvgnd_1
XFILLER_53_281 vssd1 vssd1 vccd1 vccd1 sky130_fd_sc_hd__fill_2
X_10712_ net863 _00062_ net648 vssd1 vssd1 vccd1 vccd1 FPGA_INST.cell2.LE_0A.config_data\[11\]
+ sky130_fd_sc_hd__dfrtp_1
X_11692_ net897 _01038_ net681 vssd1 vssd1 vccd1 vccd1 FPGA_INST.cell3.SB0.route_sel\[62\]
+ sky130_fd_sc_hd__dfstp_1
XFILLER_13_167 vssd1 vssd1 vccd1 vccd1 sky130_fd_sc_hd__fill_1
X_10643_ FPGA_INST.cell3.LE_1B.config_data\[13\] FPGA_INST.cell3.LE_1B.config_data\[12\]
+ net368 vssd1 vssd1 vccd1 vccd1 _01522_ sky130_fd_sc_hd__mux2_1
XANTENNA__10376__S net377 vssd1 vssd1 vccd1 vccd1 sky130_fd_sc_hd__diode_2
X_10574_ FPGA_INST.cell3.CB_0.config_dataA\[18\] FPGA_INST.cell3.CB_0.config_dataA\[19\]
+ net284 vssd1 vssd1 vccd1 vccd1 _01453_ sky130_fd_sc_hd__mux2_1
XANTENNA__08922__X FPGA_INST.bus3_1\[13\] vssd1 vssd1 vccd1 vccd1 sky130_fd_sc_hd__diode_2
XFILLER_42_74 vssd1 vssd1 vccd1 vccd1 sky130_fd_sc_hd__fill_4
XANTENNA__09202__A2 net524 vssd1 vssd1 vccd1 vccd1 sky130_fd_sc_hd__diode_2
X_12175_ net909 _01521_ net693 vssd1 vssd1 vccd1 vccd1 FPGA_INST.cell3.LE_1B.config_data\[12\]
+ sky130_fd_sc_hd__dfrtp_1
XTAP_TAPCELL_ROW_114_1879 vssd1 vccd1 sky130_fd_sc_hd__tapvpwrvgnd_1
XFILLER_123_798 vssd1 vssd1 vccd1 vccd1 sky130_fd_sc_hd__fill_1
XFILLER_122_275 vssd1 vssd1 vccd1 vccd1 sky130_fd_sc_hd__fill_2
XFILLER_122_253 vssd1 vssd1 vccd1 vccd1 sky130_fd_sc_hd__fill_1
X_11126_ net794 _00476_ net579 vssd1 vssd1 vccd1 vccd1 FPGA_INST.cell1.LE_1A.edge_mode
+ sky130_fd_sc_hd__dfstp_1
XFILLER_96_649 vssd1 vssd1 vccd1 vccd1 sky130_fd_sc_hd__fill_4
X_11057_ net812 _00407_ net597 vssd1 vssd1 vccd1 vccd1 FPGA_INST.cell1.LEI0.config_data\[42\]
+ sky130_fd_sc_hd__dfrtp_1
XANTENNA__07516__A2 _02840_ vssd1 vssd1 vccd1 vccd1 sky130_fd_sc_hd__diode_2
XANTENNA__09405__S net355 vssd1 vssd1 vccd1 vccd1 sky130_fd_sc_hd__diode_2
X_10008_ FPGA_INST.cell0.CB_0.config_dataA\[8\] FPGA_INST.cell0.CB_0.config_dataA\[7\]
+ net318 vssd1 vssd1 vccd1 vccd1 _00889_ sky130_fd_sc_hd__mux2_1
XFILLER_37_727 vssd1 vssd1 vccd1 vccd1 sky130_fd_sc_hd__fill_1
X_11959_ net908 _01305_ net692 vssd1 vssd1 vccd1 vccd1 FPGA_INST.cell3.CB_1.config_dataB\[24\]
+ sky130_fd_sc_hd__dfstp_1
XFILLER_44_281 vssd1 vssd1 vccd1 vccd1 sky130_fd_sc_hd__fill_1
XFILLER_17_484 vssd1 vssd1 vccd1 vccd1 sky130_fd_sc_hd__fill_1
X_05480_ FPGA_INST.cell3.CB_0.config_dataA\[3\] vssd1 vssd1 vccd1 vccd1 _01762_ sky130_fd_sc_hd__inv_2
XFILLER_80_3 vccd1 vssd1 vccd1 vssd1 sky130_ef_sc_hd__decap_40_12
X_07150_ _03413_ _03404_ vssd1 vssd1 vccd1 vccd1 _03414_ sky130_fd_sc_hd__nand2b_1
XANTENNA__07213__A_N _03475_ vssd1 vssd1 vccd1 vccd1 sky130_fd_sc_hd__diode_2
X_06101_ _01821_ _02337_ FPGA_INST.bus1_0\[2\] vssd1 vssd1 vccd1 vccd1 _02381_ sky130_fd_sc_hd__o21ai_1
X_07081_ FPGA_INST.cell0.CB_0.config_dataA\[14\] _03318_ _03325_ _03344_ _03346_ vssd1
+ vssd1 vccd1 vccd1 _03347_ sky130_fd_sc_hd__a311o_1
XTAP_TAPCELL_ROW_30_699 vssd1 vccd1 sky130_fd_sc_hd__tapvpwrvgnd_1
XANTENNA__07448__X FPGA_INST.bus3_2\[6\] vssd1 vssd1 vccd1 vccd1 sky130_fd_sc_hd__diode_2
X_06032_ _02296_ _02311_ _02294_ vssd1 vssd1 vccd1 vccd1 _02312_ sky130_fd_sc_hd__o21bai_2
XANTENNA__08401__A0 net73 vssd1 vssd1 vccd1 vccd1 sky130_fd_sc_hd__diode_2
Xfanout128 FPGA_INST.cell2.CB_0.le_outB vssd1 vssd1 vccd1 vccd1 net128 sky130_fd_sc_hd__clkbuf_2
Xfanout117 FPGA_INST.cell0.CB_0.le_outA vssd1 vssd1 vccd1 vccd1 net117 sky130_fd_sc_hd__buf_2
X_07983_ _03932_ _04188_ _04209_ _04210_ vssd1 vssd1 vccd1 vccd1 _04211_ sky130_fd_sc_hd__a211o_1
XFILLER_86_137 vssd1 vssd1 vccd1 vccd1 sky130_fd_sc_hd__fill_2
X_09722_ FPGA_INST.cell0.SB0.route_sel\[125\] FPGA_INST.cell0.SB0.route_sel\[126\]
+ net199 vssd1 vssd1 vccd1 vccd1 _00631_ sky130_fd_sc_hd__mux2_1
Xfanout139 FPGA_INST.cell2.CB_0.le_outA vssd1 vssd1 vccd1 vccd1 net139 sky130_fd_sc_hd__clkbuf_2
XTAP_TAPCELL_ROW_2_314 vssd1 vccd1 sky130_fd_sc_hd__tapvpwrvgnd_1
X_06934_ net415 _01888_ vssd1 vssd1 vccd1 vccd1 _03202_ sky130_fd_sc_hd__nand2_1
XANTENNA_fanout272_A net273 vssd1 vssd1 vccd1 vccd1 sky130_fd_sc_hd__diode_2
XFILLER_95_671 vssd1 vssd1 vccd1 vccd1 sky130_fd_sc_hd__fill_1
XANTENNA__09315__S net327 vssd1 vssd1 vccd1 vccd1 sky130_fd_sc_hd__diode_2
X_06865_ net424 _01888_ _03132_ vssd1 vssd1 vccd1 vccd1 _03133_ sky130_fd_sc_hd__a21o_1
X_09653_ FPGA_INST.cell0.SB0.route_sel\[56\] FPGA_INST.cell0.SB0.route_sel\[57\] net180
+ vssd1 vssd1 vccd1 vccd1 _00562_ sky130_fd_sc_hd__mux2_1
X_09584_ FPGA_INST.cell1.CB_1.config_dataB\[13\] FPGA_INST.cell1.CB_1.config_dataB\[12\]
+ net334 vssd1 vssd1 vccd1 vccd1 _00493_ sky130_fd_sc_hd__mux2_1
X_08604_ _03980_ _04812_ vssd1 vssd1 vccd1 vccd1 _04813_ sky130_fd_sc_hd__nand2_2
X_05816_ _01782_ _01968_ _02013_ vssd1 vssd1 vccd1 vccd1 _02096_ sky130_fd_sc_hd__or3_1
XPHY_EDGE_ROW_118_Right_118 vssd1 vssd1 vccd1 vccd1 sky130_fd_sc_hd__decap_3
X_08535_ FPGA_INST.cell3.LE_1A.dff0_out FPGA_INST.cell3.LE_1A.dff1_out FPGA_INST.cell3.LE_1A.reset_val
+ vssd1 vssd1 vccd1 vccd1 FPGA_INST.cell3.LE_1A.dff_out sky130_fd_sc_hd__mux2_1
XFILLER_82_387 vssd1 vssd1 vccd1 vccd1 sky130_fd_sc_hd__fill_1
X_06796_ _02772_ _02776_ net512 vssd1 vssd1 vccd1 vccd1 _03070_ sky130_fd_sc_hd__mux2_1
X_05747_ FPGA_INST.cell0.SB0.route_sel\[80\] FPGA_INST.cell0.SB0.route_sel\[81\] _02022_
+ _02025_ net313 vssd1 vssd1 vccd1 vccd1 _02027_ sky130_fd_sc_hd__a311o_1
X_08466_ FPGA_INST.cell1.LE_1A.dff0_out FPGA_INST.cell1.LE_1A.dff1_out FPGA_INST.cell1.LE_1A.reset_val
+ vssd1 vssd1 vccd1 vccd1 FPGA_INST.cell1.LE_1A.dff_out sky130_fd_sc_hd__mux2_1
X_05678_ _01860_ _01957_ vssd1 vssd1 vccd1 vccd1 _01958_ sky130_fd_sc_hd__or2_1
X_07417_ net154 _03496_ _03591_ vssd1 vssd1 vccd1 vccd1 _03675_ sky130_fd_sc_hd__nor3_1
X_08397_ _04610_ _04613_ _04616_ _04618_ vssd1 vssd1 vccd1 vccd1 _04619_ sky130_fd_sc_hd__a22o_1
XFILLER_51_785 vssd1 vssd1 vccd1 vccd1 sky130_fd_sc_hd__fill_2
X_07348_ _03411_ _03607_ net141 vssd1 vssd1 vccd1 vccd1 _03608_ sky130_fd_sc_hd__o21ai_1
XANTENNA_fanout325_X net325 vssd1 vssd1 vccd1 vccd1 sky130_fd_sc_hd__diode_2
X_07279_ _03538_ _03540_ vssd1 vssd1 vccd1 vccd1 FPGA_INST.bus3_2\[2\] sky130_fd_sc_hd__nor2_4
X_10290_ FPGA_INST.cell3.LEI0.config_data\[4\] FPGA_INST.cell3.LEI0.config_data\[5\]
+ net298 vssd1 vssd1 vccd1 vccd1 _01171_ sky130_fd_sc_hd__mux2_1
X_09018_ _05185_ _02410_ vssd1 vssd1 vccd1 vccd1 FPGA_INST.bus2_0\[2\] sky130_fd_sc_hd__and2b_2
XFILLER_104_242 vssd1 vssd1 vccd1 vccd1 sky130_fd_sc_hd__fill_8
XFILLER_78_605 vssd1 vssd1 vccd1 vccd1 sky130_fd_sc_hd__fill_8
XFILLER_77_104 vssd1 vssd1 vccd1 vccd1 sky130_fd_sc_hd__fill_1
XFILLER_120_757 vssd1 vssd1 vccd1 vccd1 sky130_fd_sc_hd__fill_4
XFILLER_78_649 vssd1 vssd1 vccd1 vccd1 sky130_fd_sc_hd__fill_2
Xfanout640 net647 vssd1 vssd1 vccd1 vccd1 net640 sky130_fd_sc_hd__clkbuf_4
Xfanout651 net662 vssd1 vssd1 vccd1 vccd1 net651 sky130_fd_sc_hd__clkbuf_4
Xfanout684 net686 vssd1 vssd1 vccd1 vccd1 net684 sky130_fd_sc_hd__clkbuf_4
Xfanout673 net674 vssd1 vssd1 vccd1 vccd1 net673 sky130_fd_sc_hd__clkbuf_4
Xfanout662 net676 vssd1 vssd1 vccd1 vccd1 net662 sky130_fd_sc_hd__clkbuf_2
XTAP_TAPCELL_ROW_129_2086 vssd1 vccd1 sky130_fd_sc_hd__tapvpwrvgnd_1
Xfanout695 net702 vssd1 vssd1 vccd1 vccd1 net695 sky130_fd_sc_hd__clkbuf_2
XFILLER_86_682 vssd1 vssd1 vccd1 vccd1 sky130_fd_sc_hd__fill_2
XANTENNA__09225__S net244 vssd1 vssd1 vccd1 vccd1 sky130_fd_sc_hd__diode_2
XFILLER_19_727 vssd1 vssd1 vccd1 vccd1 sky130_fd_sc_hd__fill_1
XANTENNA__08171__A2 _03682_ vssd1 vssd1 vccd1 vccd1 sky130_fd_sc_hd__diode_2
XFILLER_61_516 vssd1 vssd1 vccd1 vccd1 sky130_fd_sc_hd__fill_4
XFILLER_61_505 vssd1 vssd1 vccd1 vccd1 sky130_fd_sc_hd__fill_8
X_11813_ net871 _01159_ net655 vssd1 vssd1 vccd1 vccd1 net38 sky130_fd_sc_hd__dfrtp_1
XFILLER_27_760 vssd1 vssd1 vccd1 vccd1 sky130_fd_sc_hd__fill_4
X_11744_ net899 _01090_ net683 vssd1 vssd1 vccd1 vccd1 FPGA_INST.cell3.SB0.route_sel\[114\]
+ sky130_fd_sc_hd__dfstp_1
XFILLER_42_752 vssd1 vssd1 vccd1 vccd1 sky130_fd_sc_hd__fill_4
XFILLER_41_240 vssd1 vssd1 vccd1 vccd1 sky130_fd_sc_hd__fill_1
X_11675_ net842 _01021_ net626 vssd1 vssd1 vccd1 vccd1 FPGA_INST.cell3.SB0.route_sel\[45\]
+ sky130_fd_sc_hd__dfstp_1
XTAP_TAPCELL_ROW_60_1119 vssd1 vccd1 sky130_fd_sc_hd__tapvpwrvgnd_1
X_10626_ FPGA_INST.cell3.CB_1.config_dataA\[21\] FPGA_INST.cell3.CB_1.config_dataA\[20\]
+ net371 vssd1 vssd1 vccd1 vccd1 _01505_ sky130_fd_sc_hd__mux2_1
XTAP_TAPCELL_ROW_116_1908 vssd1 vccd1 sky130_fd_sc_hd__tapvpwrvgnd_1
X_10557_ FPGA_INST.cell3.CB_0.config_dataA\[2\] net400 net374 vssd1 vssd1 vccd1 vccd1
+ _01436_ sky130_fd_sc_hd__mux2_1
XFILLER_127_378 vssd1 vssd1 vccd1 vccd1 sky130_fd_sc_hd__fill_4
X_10488_ FPGA_INST.cell2.SB0.route_sel\[60\] FPGA_INST.cell2.SB0.route_sel\[61\] net239
+ vssd1 vssd1 vccd1 vccd1 _01367_ sky130_fd_sc_hd__mux2_1
X_12158_ net912 _01504_ net696 vssd1 vssd1 vccd1 vccd1 FPGA_INST.cell3.CB_1.config_dataA\[20\]
+ sky130_fd_sc_hd__dfstp_2
XFILLER_96_446 vssd1 vssd1 vccd1 vccd1 sky130_fd_sc_hd__fill_4
X_11109_ net810 _00459_ net593 vssd1 vssd1 vccd1 vccd1 FPGA_INST.cell1.LE_1A.config_data\[0\]
+ sky130_fd_sc_hd__dfrtp_1
X_12089_ net921 _01435_ net705 vssd1 vssd1 vccd1 vccd1 FPGA_INST.cell3.CB_0.config_dataA\[1\]
+ sky130_fd_sc_hd__dfstp_1
XFILLER_77_682 vssd1 vssd1 vccd1 vccd1 sky130_fd_sc_hd__fill_8
XFILLER_49_373 vssd1 vssd1 vccd1 vccd1 sky130_fd_sc_hd__fill_2
XFILLER_64_343 vssd1 vssd1 vccd1 vccd1 sky130_fd_sc_hd__fill_1
XANTENNA__08259__B _03720_ vssd1 vssd1 vccd1 vccd1 sky130_fd_sc_hd__diode_2
X_06650_ _02823_ _02917_ FPGA_INST.cell2.CB_1.config_dataA\[17\] vssd1 vssd1 vccd1
+ vccd1 _02926_ sky130_fd_sc_hd__o21ai_1
XFILLER_64_365 vssd1 vssd1 vccd1 vccd1 sky130_fd_sc_hd__fill_2
X_05601_ net113 _01826_ _01879_ vssd1 vssd1 vccd1 vccd1 _01881_ sky130_fd_sc_hd__nor3_1
XFILLER_91_173 vssd1 vssd1 vccd1 vccd1 sky130_fd_sc_hd__fill_2
XTAP_TAPCELL_ROW_86_1491 vssd1 vccd1 sky130_fd_sc_hd__tapvpwrvgnd_1
XTAP_TAPCELL_ROW_86_1480 vssd1 vccd1 sky130_fd_sc_hd__tapvpwrvgnd_1
XFILLER_52_549 vssd1 vssd1 vccd1 vccd1 sky130_fd_sc_hd__fill_1
X_06581_ net483 _02832_ vssd1 vssd1 vccd1 vccd1 _02857_ sky130_fd_sc_hd__nand2_1
XANTENNA__05899__A net170 vssd1 vssd1 vccd1 vccd1 sky130_fd_sc_hd__diode_2
X_05532_ net14 net15 net16 net17 net506 net505 vssd1 vssd1 vccd1 vccd1 _01812_ sky130_fd_sc_hd__mux4_1
X_08320_ net115 net119 net111 net99 FPGA_INST.cell0.LEI0.config_data\[21\] FPGA_INST.cell0.LEI0.config_data\[22\]
+ vssd1 vssd1 vccd1 vccd1 _04542_ sky130_fd_sc_hd__mux4_1
XTAP_TAPCELL_ROW_35_769 vssd1 vccd1 sky130_fd_sc_hd__tapvpwrvgnd_1
XANTENNA__08706__C net27 vssd1 vssd1 vccd1 vccd1 sky130_fd_sc_hd__diode_2
X_08251_ _03759_ _04473_ _04474_ _03797_ _04472_ vssd1 vssd1 vccd1 vccd1 _04475_ sky130_fd_sc_hd__a221o_1
X_05463_ FPGA_INST.cell0.CB_0.config_dataB\[9\] vssd1 vssd1 vccd1 vccd1 _01745_ sky130_fd_sc_hd__inv_2
XFILLER_33_796 vssd1 vssd1 vccd1 vccd1 sky130_fd_sc_hd__fill_2
X_07202_ _03462_ _03463_ _03464_ _02426_ vssd1 vssd1 vccd1 vccd1 _03465_ sky130_fd_sc_hd__a31o_4
XTAP_TAPCELL_ROW_15_493 vssd1 vccd1 sky130_fd_sc_hd__tapvpwrvgnd_1
X_05394_ FPGA_INST.cell1.SB0.route_sel\[55\] vssd1 vssd1 vccd1 vccd1 _01676_ sky130_fd_sc_hd__inv_2
X_08182_ FPGA_INST.cell0.CB_1.config_dataA\[3\] _04393_ _04401_ _04405_ FPGA_INST.cell0.CB_1.config_dataA\[4\]
+ vssd1 vssd1 vccd1 vccd1 _04406_ sky130_fd_sc_hd__a221o_1
X_07133_ _03395_ _03396_ vssd1 vssd1 vccd1 vccd1 _03397_ sky130_fd_sc_hd__nor2_1
XANTENNA__07976__A2 FPGA_INST.bus3_1\[14\] vssd1 vssd1 vccd1 vccd1 sky130_fd_sc_hd__diode_2
XPHY_EDGE_ROW_12_Right_12 vssd1 vssd1 vccd1 vccd1 sky130_fd_sc_hd__decap_3
XANTENNA_fanout118_A net119 vssd1 vssd1 vccd1 vccd1 sky130_fd_sc_hd__diode_2
X_07064_ FPGA_INST.bus2_0\[5\] _03318_ _03329_ net429 vssd1 vssd1 vccd1 vccd1 _03330_
+ sky130_fd_sc_hd__a22o_1
X_06015_ _01782_ _01968_ _02174_ vssd1 vssd1 vccd1 vccd1 _02295_ sky130_fd_sc_hd__or3_1
XFILLER_59_104 vssd1 vssd1 vccd1 vccd1 sky130_fd_sc_hd__fill_1
XANTENNA__11447__RESET_B net561 vssd1 vssd1 vccd1 vccd1 sky130_fd_sc_hd__diode_2
XFILLER_102_757 vssd1 vssd1 vccd1 vccd1 sky130_fd_sc_hd__fill_4
X_07966_ _04192_ _04193_ FPGA_INST.cell1.CB_0.config_dataA\[17\] vssd1 vssd1 vccd1
+ vccd1 _04194_ sky130_fd_sc_hd__mux2_1
X_06917_ FPGA_INST.bus2_0\[5\] _03163_ _03165_ FPGA_INST.bus2_0\[4\] vssd1 vssd1 vccd1
+ vccd1 _03185_ sky130_fd_sc_hd__a22o_1
XFILLER_28_513 vssd1 vssd1 vccd1 vccd1 sky130_fd_sc_hd__fill_1
X_09705_ FPGA_INST.cell0.SB0.route_sel\[108\] FPGA_INST.cell0.SB0.route_sel\[109\]
+ net197 vssd1 vssd1 vccd1 vccd1 _00614_ sky130_fd_sc_hd__mux2_1
X_07897_ FPGA_INST.cell1.CB_0.config_dataA\[3\] _04124_ vssd1 vssd1 vccd1 vccd1 _04125_
+ sky130_fd_sc_hd__nor2_1
XFILLER_74_17 vssd1 vssd1 vccd1 vccd1 sky130_fd_sc_hd__fill_8
X_09636_ FPGA_INST.cell0.SB0.route_sel\[40\] FPGA_INST.cell0.SB0.route_sel\[39\] net314
+ vssd1 vssd1 vccd1 vccd1 _00545_ sky130_fd_sc_hd__mux2_1
X_06848_ _02146_ _03094_ _03095_ _02110_ FPGA_INST.cell0.CB_0.config_dataB\[7\] vssd1
+ vssd1 vccd1 vccd1 _03116_ sky130_fd_sc_hd__a221o_1
XANTENNA__06164__A1 net2 vssd1 vssd1 vccd1 vccd1 sky130_fd_sc_hd__diode_2
XPHY_EDGE_ROW_21_Right_21 vssd1 vssd1 vccd1 vccd1 sky130_fd_sc_hd__decap_3
X_09567_ FPGA_INST.cell1.LE_1A.config_data\[16\] FPGA_INST.cell1.LE_1A.edge_mode net204
+ vssd1 vssd1 vccd1 vccd1 _00476_ sky130_fd_sc_hd__mux2_1
X_06779_ _02840_ _03051_ _03052_ _02843_ FPGA_INST.cell2.CB_1.config_dataB\[17\] vssd1
+ vssd1 vccd1 vccd1 _03053_ sky130_fd_sc_hd__a221o_1
X_08518_ _04730_ _04726_ _04721_ vssd1 vssd1 vccd1 vccd1 _04731_ sky130_fd_sc_hd__mux2_1
X_09498_ FPGA_INST.cell1.LEI0.config_data\[44\] FPGA_INST.cell1.LEI0.config_data\[45\]
+ net210 vssd1 vssd1 vccd1 vccd1 _00410_ sky130_fd_sc_hd__mux2_1
XFILLER_90_27 vssd1 vssd1 vccd1 vccd1 sky130_fd_sc_hd__fill_1
XFILLER_24_752 vssd1 vssd1 vccd1 vccd1 sky130_fd_sc_hd__fill_4
X_08449_ _04666_ _04661_ _04656_ vssd1 vssd1 vccd1 vccd1 _04667_ sky130_fd_sc_hd__mux2_1
XFILLER_90_38 vssd1 vssd1 vccd1 vccd1 sky130_fd_sc_hd__fill_8
XFILLER_23_32 vssd1 vssd1 vccd1 vccd1 sky130_fd_sc_hd__fill_1
X_11460_ net771 _00810_ net556 vssd1 vssd1 vccd1 vccd1 FPGA_INST.cell0.LE_0B.config_data\[9\]
+ sky130_fd_sc_hd__dfrtp_1
X_10411_ FPGA_INST.cell3.CB_1.config_dataB\[8\] FPGA_INST.cell3.CB_1.config_dataB\[9\]
+ net281 vssd1 vssd1 vccd1 vccd1 _01290_ sky130_fd_sc_hd__mux2_1
XFILLER_99_25 vssd1 vssd1 vccd1 vccd1 sky130_fd_sc_hd__fill_2
X_11391_ net747 _00741_ net532 vssd1 vssd1 vccd1 vccd1 FPGA_INST.cell0.LEI0.config_data\[12\]
+ sky130_fd_sc_hd__dfrtp_1
XPHY_EDGE_ROW_30_Right_30 vssd1 vssd1 vccd1 vccd1 sky130_fd_sc_hd__decap_3
X_10342_ FPGA_INST.cell3.LE_0A.config_data\[6\] FPGA_INST.cell3.LE_0A.config_data\[7\]
+ net294 vssd1 vssd1 vccd1 vccd1 _01223_ sky130_fd_sc_hd__mux2_1
XTAP_TAPCELL_ROW_111_1838 vssd1 vccd1 sky130_fd_sc_hd__tapvpwrvgnd_1
XTAP_TAPCELL_ROW_57_1081 vssd1 vccd1 sky130_fd_sc_hd__tapvpwrvgnd_1
X_10273_ net32 net33 net255 vssd1 vssd1 vccd1 vccd1 _01154_ sky130_fd_sc_hd__mux2_1
X_12012_ net777 _01358_ net563 vssd1 vssd1 vccd1 vccd1 FPGA_INST.cell2.SB0.route_sel\[52\]
+ sky130_fd_sc_hd__dfstp_1
XFILLER_2_199 vssd1 vssd1 vccd1 vccd1 sky130_fd_sc_hd__fill_1
XFILLER_78_468 vssd1 vssd1 vccd1 vccd1 sky130_fd_sc_hd__fill_8
Xfanout470 FPGA_INST.cell1.CB_0.config_dataA\[5\] vssd1 vssd1 vccd1 vccd1 net470 sky130_fd_sc_hd__clkbuf_2
XFILLER_93_438 vssd1 vssd1 vccd1 vccd1 sky130_fd_sc_hd__fill_1
XFILLER_59_671 vssd1 vssd1 vccd1 vccd1 sky130_fd_sc_hd__fill_1
Xfanout481 FPGA_INST.cell2.CB_1.config_dataA\[5\] vssd1 vssd1 vccd1 vccd1 net481 sky130_fd_sc_hd__buf_2
Xfanout492 FPGA_INST.cell2.CB_0.config_dataB\[10\] vssd1 vssd1 vccd1 vccd1 net492
+ sky130_fd_sc_hd__clkbuf_2
XFILLER_93_449 vssd1 vssd1 vccd1 vccd1 sky130_fd_sc_hd__fill_2
XFILLER_74_674 vssd1 vssd1 vccd1 vccd1 sky130_fd_sc_hd__fill_1
XANTENNA__09892__A2 net522 vssd1 vssd1 vccd1 vccd1 sky130_fd_sc_hd__diode_2
XFILLER_61_335 vssd1 vssd1 vccd1 vccd1 sky130_fd_sc_hd__fill_1
XPHY_EDGE_ROW_14_Left_145 vssd1 vssd1 vccd1 vccd1 sky130_fd_sc_hd__decap_3
XTAP_TAPCELL_ROW_122_1989 vssd1 vccd1 sky130_fd_sc_hd__tapvpwrvgnd_1
X_11727_ net903 _01073_ net687 vssd1 vssd1 vccd1 vccd1 FPGA_INST.cell3.SB0.route_sel\[97\]
+ sky130_fd_sc_hd__dfstp_2
XANTENNA__05512__A FPGA_INST.bus3_2\[4\] vssd1 vssd1 vccd1 vccd1 sky130_fd_sc_hd__diode_2
XTAP_TAPCELL_ROW_32_728 vssd1 vccd1 sky130_fd_sc_hd__tapvpwrvgnd_1
X_11658_ net894 _01004_ net678 vssd1 vssd1 vccd1 vccd1 FPGA_INST.cell3.SB0.route_sel\[28\]
+ sky130_fd_sc_hd__dfstp_1
XTAP_TAPCELL_ROW_12_452 vssd1 vccd1 sky130_fd_sc_hd__tapvpwrvgnd_1
XFILLER_127_142 vssd1 vssd1 vccd1 vccd1 sky130_fd_sc_hd__fill_1
X_10609_ FPGA_INST.cell3.CB_1.config_dataA\[3\] FPGA_INST.cell3.CB_1.config_dataA\[4\]
+ net303 vssd1 vssd1 vccd1 vccd1 _01488_ sky130_fd_sc_hd__mux2_1
X_11589_ net791 _00939_ net576 vssd1 vssd1 vccd1 vccd1 FPGA_INST.cell0.CB_1.config_dataA\[8\]
+ sky130_fd_sc_hd__dfstp_1
XFILLER_115_348 vssd1 vssd1 vccd1 vccd1 sky130_fd_sc_hd__fill_1
XFILLER_115_337 vssd1 vssd1 vccd1 vccd1 sky130_fd_sc_hd__fill_2
XPHY_EDGE_ROW_23_Left_154 vssd1 vssd1 vccd1 vccd1 sky130_fd_sc_hd__decap_3
XFILLER_43_3 vssd1 vssd1 vccd1 vccd1 sky130_fd_sc_hd__fill_4
XFILLER_111_521 vssd1 vssd1 vccd1 vccd1 sky130_fd_sc_hd__fill_2
XFILLER_111_565 vssd1 vssd1 vccd1 vccd1 sky130_fd_sc_hd__fill_1
XFILLER_111_532 vssd1 vssd1 vccd1 vccd1 sky130_fd_sc_hd__fill_2
XFILLER_69_446 vssd1 vssd1 vccd1 vccd1 sky130_fd_sc_hd__fill_2
XFILLER_57_619 vssd1 vssd1 vccd1 vccd1 sky130_fd_sc_hd__fill_1
X_07820_ net485 net486 _01856_ _01869_ vssd1 vssd1 vccd1 vccd1 _04063_ sky130_fd_sc_hd__a31o_1
X_07751_ _01827_ _03998_ _04000_ vssd1 vssd1 vccd1 vccd1 _04001_ sky130_fd_sc_hd__a21o_1
XANTENNA__06933__A3 FPGA_INST.bus2_0\[15\] vssd1 vssd1 vccd1 vccd1 sky130_fd_sc_hd__diode_2
XTAP_TAPCELL_ROW_88_1520 vssd1 vccd1 sky130_fd_sc_hd__tapvpwrvgnd_1
X_06702_ _02784_ _02963_ _02964_ _02780_ FPGA_INST.cell2.CB_1.config_dataB\[2\] vssd1
+ vssd1 vccd1 vccd1 _02976_ sky130_fd_sc_hd__a221o_1
X_07682_ FPGA_INST.cell3.SB0.route_sel\[101\] FPGA_INST.cell3.SB0.route_sel\[100\]
+ _03914_ _03933_ _03916_ vssd1 vssd1 vccd1 vccd1 _03934_ sky130_fd_sc_hd__a221o_1
XFILLER_80_600 vssd1 vssd1 vccd1 vccd1 sky130_fd_sc_hd__fill_1
XANTENNA__07894__A1 FPGA_INST.bus3_1\[1\] vssd1 vssd1 vccd1 vccd1 sky130_fd_sc_hd__diode_2
XFILLER_64_195 vssd1 vssd1 vccd1 vccd1 sky130_fd_sc_hd__fill_1
X_09421_ FPGA_INST.cell2.CB_1.config_dataA\[14\] FPGA_INST.cell2.CB_1.config_dataA\[15\]
+ net265 vssd1 vssd1 vccd1 vccd1 _00334_ sky130_fd_sc_hd__mux2_1
XFILLER_25_549 vssd1 vssd1 vccd1 vccd1 sky130_fd_sc_hd__fill_4
XPHY_EDGE_ROW_32_Left_163 vssd1 vssd1 vccd1 vccd1 sky130_fd_sc_hd__decap_3
X_06633_ FPGA_INST.cell2.LEI0.config_data\[32\] _02906_ _02908_ vssd1 vssd1 vccd1
+ vccd1 _02909_ sky130_fd_sc_hd__or3_1
X_09352_ FPGA_INST.cell1.SB0.route_sel\[123\] FPGA_INST.cell1.SB0.route_sel\[124\]
+ net199 vssd1 vssd1 vccd1 vccd1 _00265_ sky130_fd_sc_hd__mux2_1
XFILLER_52_357 vssd1 vssd1 vccd1 vccd1 sky130_fd_sc_hd__fill_4
XFILLER_52_346 vssd1 vssd1 vccd1 vccd1 sky130_fd_sc_hd__fill_2
X_06564_ net249 _02157_ _02163_ _02839_ vssd1 vssd1 vccd1 vccd1 _02840_ sky130_fd_sc_hd__nand4_4
X_05515_ FPGA_INST.bus3_2\[0\] vssd1 vssd1 vccd1 vccd1 _01797_ sky130_fd_sc_hd__inv_2
X_08303_ FPGA_INST.bus1_0\[10\] FPGA_INST.bus1_0\[11\] net445 vssd1 vssd1 vccd1 vccd1
+ _04525_ sky130_fd_sc_hd__mux2_1
XANTENNA__06449__A2 _02413_ vssd1 vssd1 vccd1 vccd1 sky130_fd_sc_hd__diode_2
X_09283_ FPGA_INST.cell1.SB0.route_sel\[55\] FPGA_INST.cell1.SB0.route_sel\[54\] net328
+ vssd1 vssd1 vccd1 vccd1 _00196_ sky130_fd_sc_hd__mux2_1
X_06495_ _01552_ FPGA_INST.cell2.SB0.route_sel\[17\] FPGA_INST.cell2.SB0.route_sel\[22\]
+ _01553_ _02770_ vssd1 vssd1 vccd1 vccd1 _02771_ sky130_fd_sc_hd__a221o_1
X_05446_ FPGA_INST.cell1.CB_0.config_dataB\[7\] vssd1 vssd1 vccd1 vccd1 _01728_ sky130_fd_sc_hd__inv_2
X_08234_ net76 FPGA_INST.bus1_0\[13\] FPGA_INST.bus1_0\[14\] FPGA_INST.bus1_0\[15\]
+ net406 net405 vssd1 vssd1 vccd1 vccd1 _04458_ sky130_fd_sc_hd__mux4_1
XANTENNA__08292__X FPGA_INST.cell0.CB_1.le_outA vssd1 vssd1 vccd1 vccd1 sky130_fd_sc_hd__diode_2
XFILLER_109_13 vssd1 vssd1 vccd1 vccd1 sky130_fd_sc_hd__fill_1
XTAP_TAPCELL_ROW_99_1671 vssd1 vccd1 sky130_fd_sc_hd__tapvpwrvgnd_1
X_05377_ FPGA_INST.cell1.SB0.route_sel\[69\] vssd1 vssd1 vccd1 vccd1 _01659_ sky130_fd_sc_hd__inv_2
X_08165_ _03797_ _04382_ _04383_ _03759_ _04388_ vssd1 vssd1 vccd1 vccd1 _04389_ sky130_fd_sc_hd__a221o_1
XFILLER_119_687 vssd1 vssd1 vccd1 vccd1 sky130_fd_sc_hd__fill_1
XFILLER_109_35 vssd1 vssd1 vccd1 vccd1 sky130_fd_sc_hd__fill_4
X_07116_ FPGA_INST.cell0.LE_0A.config_data\[1\] FPGA_INST.cell0.LE_0A.config_data\[0\]
+ _03313_ vssd1 vssd1 vccd1 vccd1 _03382_ sky130_fd_sc_hd__mux2_1
XPHY_EDGE_ROW_41_Left_172 vssd1 vssd1 vccd1 vccd1 sky130_fd_sc_hd__decap_3
X_08096_ net454 _04049_ vssd1 vssd1 vccd1 vccd1 _04322_ sky130_fd_sc_hd__nand2_1
XFILLER_109_57 vssd1 vssd1 vccd1 vccd1 sky130_fd_sc_hd__fill_8
XANTENNA__06621__A2 FPGA_INST.bus3_2\[14\] vssd1 vssd1 vccd1 vccd1 sky130_fd_sc_hd__diode_2
X_07047_ _01731_ _03283_ _03306_ _03310_ _03312_ vssd1 vssd1 vccd1 vccd1 _03313_ sky130_fd_sc_hd__o311a_4
XFILLER_102_521 vssd1 vssd1 vccd1 vccd1 sky130_fd_sc_hd__fill_2
XANTENNA__07636__X _03889_ vssd1 vssd1 vccd1 vccd1 sky130_fd_sc_hd__diode_2
XANTENNA_fanout771_A net772 vssd1 vssd1 vccd1 vccd1 sky130_fd_sc_hd__diode_2
XFILLER_0_615 vssd1 vssd1 vccd1 vccd1 sky130_fd_sc_hd__fill_1
XFILLER_88_755 vssd1 vssd1 vccd1 vccd1 sky130_fd_sc_hd__fill_1
XANTENNA__08374__A2 _03682_ vssd1 vssd1 vccd1 vccd1 sky130_fd_sc_hd__diode_2
XFILLER_125_78 vccd1 vssd1 vccd1 vssd1 sky130_ef_sc_hd__decap_40_12
XFILLER_102_587 vssd1 vssd1 vccd1 vccd1 sky130_fd_sc_hd__fill_1
XANTENNA__06385__A1 net8 vssd1 vssd1 vccd1 vccd1 sky130_fd_sc_hd__diode_2
X_08998_ FPGA_INST.cell2.SB0.route_sel\[34\] FPGA_INST.cell2.SB0.route_sel\[35\] vssd1
+ vssd1 vccd1 vccd1 _05172_ sky130_fd_sc_hd__nand2b_1
XTAP_TAPCELL_ROW_126_2045 vssd1 vccd1 sky130_fd_sc_hd__tapvpwrvgnd_1
X_07949_ _04163_ _04164_ _04176_ _01726_ vssd1 vssd1 vccd1 vccd1 _04177_ sky130_fd_sc_hd__o211a_1
XFILLER_75_449 vssd1 vssd1 vccd1 vccd1 sky130_fd_sc_hd__fill_1
XFILLER_90_408 vccd1 vssd1 vccd1 vssd1 sky130_ef_sc_hd__decap_40_12
XPHY_EDGE_ROW_50_Left_181 vssd1 vssd1 vccd1 vccd1 sky130_fd_sc_hd__decap_3
X_10960_ net866 _00310_ net653 vssd1 vssd1 vccd1 vccd1 FPGA_INST.cell2.CB_0.config_dataB\[16\]
+ sky130_fd_sc_hd__dfstp_1
XFILLER_28_365 vssd1 vssd1 vccd1 vccd1 sky130_fd_sc_hd__fill_4
XANTENNA__07371__X FPGA_INST.bus3_2\[4\] vssd1 vssd1 vccd1 vccd1 sky130_fd_sc_hd__diode_2
X_10891_ net825 _00241_ net609 vssd1 vssd1 vccd1 vccd1 FPGA_INST.cell1.SB0.route_sel\[100\]
+ sky130_fd_sc_hd__dfstp_1
XFILLER_56_696 vssd1 vssd1 vccd1 vccd1 sky130_fd_sc_hd__fill_4
X_09619_ FPGA_INST.cell0.SB0.route_sel\[22\] FPGA_INST.cell0.SB0.route_sel\[23\] net201
+ vssd1 vssd1 vccd1 vccd1 _00528_ sky130_fd_sc_hd__mux2_1
XFILLER_16_549 vssd1 vssd1 vccd1 vccd1 sky130_fd_sc_hd__fill_1
XFILLER_34_31 vssd1 vssd1 vccd1 vccd1 sky130_fd_sc_hd__fill_1
XANTENNA__08834__A0 net18 vssd1 vssd1 vccd1 vccd1 sky130_fd_sc_hd__diode_2
X_11512_ net768 _00862_ net553 vssd1 vssd1 vccd1 vccd1 FPGA_INST.cell0.CB_1.config_dataB\[18\]
+ sky130_fd_sc_hd__dfstp_1
XFILLER_7_247 vccd1 vssd1 vccd1 vssd1 sky130_ef_sc_hd__decap_40_12
XFILLER_7_225 vssd1 vssd1 vccd1 vccd1 sky130_fd_sc_hd__fill_4
X_11443_ net773 _00793_ net559 vssd1 vssd1 vccd1 vccd1 FPGA_INST.cell0.LE_0A.config_data\[14\]
+ sky130_fd_sc_hd__dfrtp_1
XTAP_TAPCELL_ROW_59_1110 vssd1 vccd1 sky130_fd_sc_hd__tapvpwrvgnd_1
X_11374_ net816 _00724_ net601 vssd1 vssd1 vccd1 vccd1 FPGA_INST.cell1.LE_1B.config_data\[16\]
+ sky130_fd_sc_hd__dfrtp_1
X_10325_ FPGA_INST.cell3.LEI0.config_data\[39\] FPGA_INST.cell3.LEI0.config_data\[40\]
+ net300 vssd1 vssd1 vccd1 vccd1 _01206_ sky130_fd_sc_hd__mux2_1
X_10256_ FPGA_INST.io_east_oeb\[0\] FPGA_INST.io_east_oeb\[2\] net264 vssd1 vssd1
+ vccd1 vccd1 _01137_ sky130_fd_sc_hd__mux2_1
XANTENNA__05820__B1 FPGA_INST.bus1_0\[9\] vssd1 vssd1 vccd1 vccd1 sky130_fd_sc_hd__diode_2
XFILLER_59_72 vssd1 vssd1 vccd1 vccd1 sky130_fd_sc_hd__fill_1
XANTENNA__05507__A net150 vssd1 vssd1 vccd1 vccd1 sky130_fd_sc_hd__diode_2
XFILLER_93_202 vssd1 vssd1 vccd1 vccd1 sky130_fd_sc_hd__fill_1
X_10187_ FPGA_INST.cell3.SB0.route_sel\[91\] FPGA_INST.cell3.SB0.route_sel\[92\] net274
+ vssd1 vssd1 vccd1 vccd1 _01068_ sky130_fd_sc_hd__mux2_1
XANTENNA__06128__A1 net135 vssd1 vssd1 vccd1 vccd1 sky130_fd_sc_hd__diode_2
XANTENNA__08522__C1 FPGA_INST.cell3.CB_1.config_dataA\[19\] vssd1 vssd1 vccd1 vccd1
+ sky130_fd_sc_hd__diode_2
XANTENNA__09413__S net362 vssd1 vssd1 vccd1 vccd1 sky130_fd_sc_hd__diode_2
XFILLER_46_195 vssd1 vssd1 vccd1 vccd1 sky130_fd_sc_hd__fill_1
XTAP_TAPCELL_ROW_17_522 vssd1 vccd1 sky130_fd_sc_hd__tapvpwrvgnd_1
XTAP_TAPCELL_ROW_83_1450 vssd1 vccd1 sky130_fd_sc_hd__tapvpwrvgnd_1
XFILLER_62_699 vssd1 vssd1 vccd1 vccd1 sky130_fd_sc_hd__fill_1
XFILLER_34_379 vccd1 vssd1 vccd1 vssd1 sky130_ef_sc_hd__decap_40_12
X_06280_ FPGA_INST.cell2.CB_0.config_dataA\[13\] FPGA_INST.cell2.CB_0.config_dataA\[12\]
+ vssd1 vssd1 vccd1 vccd1 _02560_ sky130_fd_sc_hd__or2_1
X_05300_ FPGA_INST.cell2.SB0.route_sel\[112\] vssd1 vssd1 vccd1 vccd1 _01582_ sky130_fd_sc_hd__inv_2
XANTENNA__12153__CLK net946 vssd1 vssd1 vccd1 vccd1 sky130_fd_sc_hd__diode_2
XANTENNA__06851__A2 FPGA_INST.bus2_0\[10\] vssd1 vssd1 vccd1 vccd1 sky130_fd_sc_hd__diode_2
X_09970_ _01529_ _05224_ net738 vssd1 vssd1 vccd1 vccd1 _05225_ sky130_fd_sc_hd__o21ai_1
X_08921_ FPGA_INST.cell3.SB0.route_sel\[104\] _01615_ _01616_ FPGA_INST.cell3.SB0.route_sel\[107\]
+ _05120_ vssd1 vssd1 vccd1 vccd1 _05121_ sky130_fd_sc_hd__a221o_1
X_08852_ _05057_ _05058_ FPGA_INST.cell3.CB_0.config_dataB\[14\] vssd1 vssd1 vccd1
+ vccd1 _05059_ sky130_fd_sc_hd__a21o_1
XANTENNA__08356__A2 _03840_ vssd1 vssd1 vccd1 vccd1 sky130_fd_sc_hd__diode_2
XANTENNA__07013__C1 _03278_ vssd1 vssd1 vccd1 vccd1 sky130_fd_sc_hd__diode_2
X_07803_ FPGA_INST.cell3.SB0.route_sel\[125\] FPGA_INST.cell3.SB0.route_sel\[124\]
+ _04031_ _04050_ _04033_ vssd1 vssd1 vccd1 vccd1 _04052_ sky130_fd_sc_hd__a221o_1
X_08783_ _01662_ FPGA_INST.cell3.CB_0.config_dataB\[7\] _04974_ vssd1 vssd1 vccd1
+ vccd1 _04990_ sky130_fd_sc_hd__or3b_1
X_05995_ FPGA_INST.cell2.SB0.route_sel\[36\] FPGA_INST.cell2.SB0.route_sel\[37\] _02274_
+ vssd1 vssd1 vccd1 vccd1 _02275_ sky130_fd_sc_hd__a21o_1
XFILLER_38_641 vssd1 vssd1 vccd1 vccd1 sky130_fd_sc_hd__fill_2
XFILLER_84_279 vssd1 vssd1 vccd1 vccd1 sky130_fd_sc_hd__fill_8
X_07734_ _03526_ _03907_ net78 vssd1 vssd1 vccd1 vccd1 _03984_ sky130_fd_sc_hd__o21ai_1
XFILLER_72_408 vssd1 vssd1 vccd1 vccd1 sky130_fd_sc_hd__fill_1
XANTENNA__08659__A3 net21 vssd1 vssd1 vccd1 vccd1 sky130_fd_sc_hd__diode_2
X_07665_ FPGA_INST.cell1.SB0.route_sel\[97\] FPGA_INST.cell1.SB0.route_sel\[96\] vssd1
+ vssd1 vccd1 vccd1 _03917_ sky130_fd_sc_hd__nand2_1
XANTENNA__05704__X _01984_ vssd1 vssd1 vccd1 vccd1 sky130_fd_sc_hd__diode_2
XANTENNA__07351__B FPGA_INST.cell1.SB0.route_sel\[39\] vssd1 vssd1 vccd1 vccd1 sky130_fd_sc_hd__diode_2
XFILLER_80_430 vssd1 vssd1 vccd1 vccd1 sky130_fd_sc_hd__fill_4
XANTENNA_fanout352_A net355 vssd1 vssd1 vccd1 vccd1 sky130_fd_sc_hd__diode_2
X_06616_ net479 _02832_ vssd1 vssd1 vccd1 vccd1 _02892_ sky130_fd_sc_hd__nand2_1
X_09404_ FPGA_INST.cell2.CB_0.config_dataB\[23\] FPGA_INST.cell2.CB_0.config_dataB\[22\]
+ net355 vssd1 vssd1 vccd1 vccd1 _00317_ sky130_fd_sc_hd__mux2_1
XFILLER_80_474 vssd1 vssd1 vccd1 vccd1 sky130_fd_sc_hd__fill_2
X_07596_ _03835_ _03849_ net328 vssd1 vssd1 vccd1 vccd1 _03850_ sky130_fd_sc_hd__a21oi_1
XFILLER_53_688 vssd1 vssd1 vccd1 vccd1 sky130_fd_sc_hd__fill_8
XANTENNA_fanout617_A net627 vssd1 vssd1 vccd1 vccd1 sky130_fd_sc_hd__diode_2
X_09335_ FPGA_INST.cell1.SB0.route_sel\[106\] FPGA_INST.cell1.SB0.route_sel\[107\]
+ net223 vssd1 vssd1 vccd1 vccd1 _00248_ sky130_fd_sc_hd__mux2_1
XFILLER_80_496 vssd1 vssd1 vccd1 vccd1 sky130_fd_sc_hd__fill_4
X_06547_ net242 _01998_ _02006_ _02822_ vssd1 vssd1 vccd1 vccd1 _02823_ sky130_fd_sc_hd__and4_2
X_09266_ FPGA_INST.cell1.SB0.route_sel\[37\] FPGA_INST.cell1.SB0.route_sel\[38\] net209
+ vssd1 vssd1 vccd1 vccd1 _00179_ sky130_fd_sc_hd__mux2_1
X_06478_ _01543_ _01544_ FPGA_INST.cell2.CB_0.config_dataB\[19\] _02728_ _02755_ vssd1
+ vssd1 vccd1 vccd1 _02756_ sky130_fd_sc_hd__a41o_1
X_05429_ FPGA_INST.cell3.SB0.route_sel\[10\] vssd1 vssd1 vccd1 vccd1 _01711_ sky130_fd_sc_hd__inv_2
X_08217_ net407 _03720_ vssd1 vssd1 vccd1 vccd1 _04441_ sky130_fd_sc_hd__nand2_1
X_09197_ FPGA_INST.cell2.LE_1A.config_data\[15\] FPGA_INST.cell2.LE_1A.config_data\[14\]
+ net361 vssd1 vssd1 vccd1 vccd1 _00110_ sky130_fd_sc_hd__mux2_1
XFILLER_5_729 vssd1 vssd1 vccd1 vccd1 sky130_fd_sc_hd__fill_4
XFILLER_5_707 vssd1 vssd1 vccd1 vccd1 sky130_fd_sc_hd__fill_4
X_08148_ FPGA_INST.cell1.LE_0B.config_data\[9\] FPGA_INST.cell1.LE_0B.config_data\[8\]
+ _04296_ vssd1 vssd1 vccd1 vccd1 _04374_ sky130_fd_sc_hd__mux2_1
XANTENNA__08044__A1 FPGA_INST.bus3_1\[5\] vssd1 vssd1 vccd1 vccd1 sky130_fd_sc_hd__diode_2
XFILLER_20_33 vssd1 vssd1 vccd1 vccd1 sky130_fd_sc_hd__fill_2
XFILLER_107_679 vssd1 vssd1 vccd1 vccd1 sky130_fd_sc_hd__fill_1
XFILLER_107_668 vssd1 vssd1 vccd1 vccd1 sky130_fd_sc_hd__fill_4
X_08079_ FPGA_INST.bus3_1\[4\] FPGA_INST.bus3_1\[5\] FPGA_INST.bus3_1\[6\] FPGA_INST.bus3_1\[7\]
+ net454 net453 vssd1 vssd1 vccd1 vccd1 _04305_ sky130_fd_sc_hd__mux4_1
X_11090_ net839 _00440_ net623 vssd1 vssd1 vccd1 vccd1 FPGA_INST.cell1.LE_0B.config_data\[3\]
+ sky130_fd_sc_hd__dfrtp_1
XFILLER_121_115 vssd1 vssd1 vccd1 vccd1 sky130_fd_sc_hd__fill_1
X_10110_ FPGA_INST.cell3.SB0.route_sel\[14\] FPGA_INST.cell3.SB0.route_sel\[15\] net244
+ vssd1 vssd1 vccd1 vccd1 _00991_ sky130_fd_sc_hd__mux2_1
XANTENNA_fanout98_A net99 vssd1 vssd1 vccd1 vccd1 sky130_fd_sc_hd__diode_2
XFILLER_96_59 vssd1 vssd1 vccd1 vccd1 sky130_fd_sc_hd__fill_4
XTAP_TAPCELL_ROW_54_1040 vssd1 vccd1 sky130_fd_sc_hd__tapvpwrvgnd_1
XFILLER_0_445 vssd1 vssd1 vccd1 vccd1 sky130_fd_sc_hd__fill_2
X_10041_ net414 net415 net309 vssd1 vssd1 vccd1 vccd1 _00922_ sky130_fd_sc_hd__mux2_1
XFILLER_102_340 vssd1 vssd1 vccd1 vccd1 sky130_fd_sc_hd__fill_1
XFILLER_76_714 vssd1 vssd1 vccd1 vccd1 sky130_fd_sc_hd__fill_2
XANTENNA__06358__A1 net5 vssd1 vssd1 vccd1 vccd1 sky130_fd_sc_hd__diode_2
XFILLER_75_246 vssd1 vssd1 vccd1 vccd1 sky130_fd_sc_hd__fill_2
XANTENNA__07813__Y FPGA_INST.bus3_2\[15\] vssd1 vssd1 vccd1 vccd1 sky130_fd_sc_hd__diode_2
X_11992_ net774 _01338_ net560 vssd1 vssd1 vccd1 vccd1 FPGA_INST.cell2.SB0.route_sel\[32\]
+ sky130_fd_sc_hd__dfstp_1
XANTENNA__07858__A1 FPGA_INST.bus3_1\[1\] vssd1 vssd1 vccd1 vccd1 sky130_fd_sc_hd__diode_2
XFILLER_56_471 vssd1 vssd1 vccd1 vccd1 sky130_fd_sc_hd__fill_4
X_10943_ net848 _00293_ net633 vssd1 vssd1 vccd1 vccd1 FPGA_INST.cell2.CB_0.config_dataA\[24\]
+ sky130_fd_sc_hd__dfstp_1
XFILLER_28_195 vssd1 vssd1 vccd1 vccd1 sky130_fd_sc_hd__fill_1
X_10874_ net793 _00224_ net578 vssd1 vssd1 vccd1 vccd1 FPGA_INST.cell1.SB0.route_sel\[83\]
+ sky130_fd_sc_hd__dfstp_1
XFILLER_45_96 vssd1 vssd1 vccd1 vccd1 sky130_fd_sc_hd__fill_1
XFILLER_16_368 vssd1 vssd1 vccd1 vccd1 sky130_fd_sc_hd__fill_1
XFILLER_31_316 vssd1 vssd1 vccd1 vccd1 sky130_fd_sc_hd__fill_1
XTAP_TAPCELL_ROW_65_1191 vssd1 vccd1 sky130_fd_sc_hd__tapvpwrvgnd_1
XFILLER_12_530 vssd1 vssd1 vccd1 vccd1 sky130_fd_sc_hd__fill_2
XTAP_TAPCELL_ROW_42_867 vssd1 vccd1 sky130_fd_sc_hd__tapvpwrvgnd_1
XANTENNA__08822__A3 net80 vssd1 vssd1 vccd1 vccd1 sky130_fd_sc_hd__diode_2
XFILLER_8_545 vssd1 vssd1 vccd1 vccd1 sky130_fd_sc_hd__fill_1
XFILLER_12_574 vssd1 vssd1 vccd1 vccd1 sky130_fd_sc_hd__fill_1
XTAP_TAPCELL_ROW_22_591 vssd1 vccd1 sky130_fd_sc_hd__tapvpwrvgnd_1
XFILLER_125_410 vssd1 vssd1 vccd1 vccd1 sky130_fd_sc_hd__fill_1
X_11426_ net754 _00776_ net539 vssd1 vssd1 vccd1 vccd1 FPGA_INST.cell0.CB_0.config_data_inA
+ sky130_fd_sc_hd__dfrtp_1
X_11357_ net802 _00707_ net587 vssd1 vssd1 vccd1 vccd1 FPGA_INST.cell1.CB_1.config_dataA\[24\]
+ sky130_fd_sc_hd__dfstp_1
XFILLER_6_68 vssd1 vssd1 vccd1 vccd1 sky130_fd_sc_hd__fill_1
X_10308_ FPGA_INST.cell3.LEI0.config_data\[22\] FPGA_INST.cell3.LEI0.config_data\[23\]
+ net283 vssd1 vssd1 vccd1 vccd1 _01189_ sky130_fd_sc_hd__mux2_1
XFILLER_113_638 vssd1 vssd1 vccd1 vccd1 sky130_fd_sc_hd__fill_4
XANTENNA__07717__A FPGA_INST.bus3_1\[13\] vssd1 vssd1 vccd1 vccd1 sky130_fd_sc_hd__diode_2
XANTENNA__09408__S net362 vssd1 vssd1 vccd1 vccd1 sky130_fd_sc_hd__diode_2
X_11288_ net833 _00638_ net617 vssd1 vssd1 vccd1 vccd1 FPGA_INST.cell1.CB_0.config_dataA\[5\]
+ sky130_fd_sc_hd__dfstp_1
XANTENNA__08338__A2 _03504_ vssd1 vssd1 vccd1 vccd1 sky130_fd_sc_hd__diode_2
XFILLER_3_294 vssd1 vssd1 vccd1 vccd1 sky130_fd_sc_hd__fill_2
X_10239_ FPGA_INST.io_west_oeb\[30\] FPGA_INST.io_south_oeb\[0\] net292 vssd1 vssd1
+ vccd1 vccd1 _01120_ sky130_fd_sc_hd__mux2_1
XFILLER_120_170 vssd1 vssd1 vccd1 vccd1 sky130_fd_sc_hd__fill_8
X_05780_ net170 net161 FPGA_INST.bus1_0\[11\] vssd1 vssd1 vccd1 vccd1 _02060_ sky130_fd_sc_hd__o21ai_1
XFILLER_75_780 vssd1 vssd1 vccd1 vccd1 sky130_fd_sc_hd__fill_4
XANTENNA__09143__S net351 vssd1 vssd1 vccd1 vccd1 sky130_fd_sc_hd__diode_2
XFILLER_19_173 vssd1 vssd1 vccd1 vccd1 sky130_fd_sc_hd__fill_2
XFILLER_35_611 vssd1 vssd1 vccd1 vccd1 sky130_fd_sc_hd__fill_4
XFILLER_81_249 vssd1 vssd1 vccd1 vccd1 sky130_fd_sc_hd__fill_1
X_07450_ FPGA_INST.cell3.SB0.route_sel\[58\] FPGA_INST.cell3.SB0.route_sel\[59\] vssd1
+ vssd1 vccd1 vccd1 _03707_ sky130_fd_sc_hd__nand2_1
XFILLER_90_761 vssd1 vssd1 vccd1 vccd1 sky130_fd_sc_hd__fill_1
XFILLER_22_305 vssd1 vssd1 vccd1 vccd1 sky130_fd_sc_hd__fill_1
XFILLER_50_658 vssd1 vssd1 vccd1 vccd1 sky130_fd_sc_hd__fill_1
XFILLER_50_647 vssd1 vssd1 vccd1 vccd1 sky130_fd_sc_hd__fill_4
X_06401_ _02673_ _02674_ _02678_ vssd1 vssd1 vccd1 vccd1 _02679_ sky130_fd_sc_hd__o21ai_1
X_07381_ _03636_ _03637_ _03638_ _02306_ _02299_ vssd1 vssd1 vccd1 vccd1 _03640_ sky130_fd_sc_hd__a311o_1
X_06332_ FPGA_INST.cell2.LE_0A.config_data\[15\] FPGA_INST.cell2.LE_0A.config_data\[14\]
+ _02536_ vssd1 vssd1 vccd1 vccd1 _02612_ sky130_fd_sc_hd__mux2_1
X_09120_ FPGA_INST.cell2.LEI0.config_data\[34\] FPGA_INST.cell2.LEI0.config_data\[35\]
+ net259 vssd1 vssd1 vccd1 vccd1 _00036_ sky130_fd_sc_hd__mux2_1
X_09051_ net750 FPGA_INST.cell0.LE_0B.edge_mode vssd1 vssd1 vccd1 vccd1 FPGA_INST.cell0.LE_0B.sel_clk
+ sky130_fd_sc_hd__xnor2_1
X_08002_ _04217_ _04221_ _04229_ vssd1 vssd1 vccd1 vccd1 _04230_ sky130_fd_sc_hd__a21oi_1
XPHY_EDGE_ROW_6_Right_6 vssd1 vssd1 vccd1 vccd1 sky130_fd_sc_hd__decap_3
X_06263_ FPGA_INST.cell2.CB_0.config_dataA\[11\] _02538_ _02539_ _02542_ vssd1 vssd1
+ vccd1 vccd1 _02543_ sky130_fd_sc_hd__a31o_1
XFILLER_129_793 vssd1 vssd1 vccd1 vccd1 sky130_fd_sc_hd__fill_2
XFILLER_116_432 vssd1 vssd1 vccd1 vccd1 sky130_fd_sc_hd__fill_1
XTAP_TAPCELL_ROW_96_1630 vssd1 vccd1 sky130_fd_sc_hd__tapvpwrvgnd_1
X_06194_ _02473_ vssd1 vssd1 vccd1 vccd1 _02474_ sky130_fd_sc_hd__inv_2
XFILLER_89_305 vssd1 vssd1 vccd1 vccd1 sky130_fd_sc_hd__fill_4
X_09953_ FPGA_INST.cell0.CB_1.config_dataB\[13\] FPGA_INST.cell0.CB_1.config_dataB\[14\]
+ net182 vssd1 vssd1 vccd1 vccd1 _00858_ sky130_fd_sc_hd__mux2_1
X_08904_ FPGA_INST.cell3.LE_0B.config_data\[16\] _05108_ _05109_ net156 vssd1 vssd1
+ vccd1 vccd1 FPGA_INST.cell3.CB_0.le_outB sky130_fd_sc_hd__o211a_1
X_09884_ FPGA_INST.cell0.LE_0A.config_data\[11\] FPGA_INST.cell0.LE_0A.config_data\[12\]
+ net192 vssd1 vssd1 vccd1 vccd1 _00791_ sky130_fd_sc_hd__mux2_1
X_08835_ net22 net24 net25 net26 net388 FPGA_INST.cell3.CB_0.config_dataB\[11\] vssd1
+ vssd1 vccd1 vccd1 _05042_ sky130_fd_sc_hd__mux4_1
XFILLER_58_747 vssd1 vssd1 vccd1 vccd1 sky130_fd_sc_hd__fill_1
XTAP_TAPCELL_ROW_123_2004 vssd1 vccd1 sky130_fd_sc_hd__tapvpwrvgnd_1
X_08766_ _04819_ _04823_ net390 vssd1 vssd1 vccd1 vccd1 _04973_ sky130_fd_sc_hd__mux2_1
XFILLER_58_769 vssd1 vssd1 vccd1 vccd1 sky130_fd_sc_hd__fill_1
XFILLER_57_246 vssd1 vssd1 vccd1 vccd1 sky130_fd_sc_hd__fill_1
XANTENNA_fanout567_A net575 vssd1 vssd1 vccd1 vccd1 sky130_fd_sc_hd__diode_2
XFILLER_85_588 vssd1 vssd1 vccd1 vccd1 sky130_fd_sc_hd__fill_2
X_07717_ FPGA_INST.bus3_1\[13\] _03954_ vssd1 vssd1 vccd1 vccd1 _03968_ sky130_fd_sc_hd__nand2_1
XFILLER_72_227 vssd1 vssd1 vccd1 vccd1 sky130_fd_sc_hd__fill_1
XANTENNA__06760__A1 FPGA_INST.bus3_2\[1\] vssd1 vssd1 vccd1 vccd1 sky130_fd_sc_hd__diode_2
XFILLER_57_279 vssd1 vssd1 vccd1 vccd1 sky130_fd_sc_hd__fill_1
XANTENNA__06677__S _02878_ vssd1 vssd1 vccd1 vccd1 sky130_fd_sc_hd__diode_2
X_05978_ FPGA_INST.cell0.SB0.route_sel\[32\] FPGA_INST.cell0.SB0.route_sel\[33\] vssd1
+ vssd1 vccd1 vccd1 _02258_ sky130_fd_sc_hd__and2_1
X_08697_ net397 _04785_ vssd1 vssd1 vccd1 vccd1 _04906_ sky130_fd_sc_hd__nand2_1
XANTENNA_fanout734_A net29 vssd1 vssd1 vccd1 vccd1 sky130_fd_sc_hd__diode_2
XANTENNA_fanout355_X net355 vssd1 vssd1 vccd1 vccd1 sky130_fd_sc_hd__diode_2
X_07648_ _03576_ _03822_ _03899_ FPGA_INST.cell3.SB0.route_sel\[89\] FPGA_INST.cell3.SB0.route_sel\[88\]
+ vssd1 vssd1 vccd1 vccd1 _03901_ sky130_fd_sc_hd__a32o_1
XFILLER_81_783 vssd1 vssd1 vccd1 vccd1 sky130_fd_sc_hd__fill_1
XANTENNA__06512__A1 FPGA_INST.bus3_2\[1\] vssd1 vssd1 vccd1 vccd1 sky130_fd_sc_hd__diode_2
XTAP_TAPCELL_ROW_0_264 vssd1 vccd1 sky130_fd_sc_hd__tapvpwrvgnd_1
XTAP_TAPCELL_ROW_0_275 vssd1 vccd1 sky130_fd_sc_hd__tapvpwrvgnd_1
XTAP_TAPCELL_ROW_0_286 vssd1 vccd1 sky130_fd_sc_hd__tapvpwrvgnd_1
XFILLER_25_165 vssd1 vssd1 vccd1 vccd1 sky130_fd_sc_hd__fill_2
XFILLER_26_699 vssd1 vssd1 vccd1 vccd1 sky130_fd_sc_hd__fill_1
XANTENNA_fanout522_X net522 vssd1 vssd1 vccd1 vccd1 sky130_fd_sc_hd__diode_2
X_07579_ _03499_ _03748_ vssd1 vssd1 vccd1 vccd1 _03833_ sky130_fd_sc_hd__nor2_1
XFILLER_25_187 vssd1 vssd1 vccd1 vccd1 sky130_fd_sc_hd__fill_1
X_09318_ FPGA_INST.cell1.SB0.route_sel\[90\] FPGA_INST.cell1.SB0.route_sel\[89\] net329
+ vssd1 vssd1 vccd1 vccd1 _00231_ sky130_fd_sc_hd__mux2_1
XANTENNA__08265__A1 _03604_ vssd1 vssd1 vccd1 vccd1 sky130_fd_sc_hd__diode_2
XANTENNA__07068__A2 _02030_ vssd1 vssd1 vccd1 vccd1 sky130_fd_sc_hd__diode_2
X_10590_ FPGA_INST.cell3.CB_0.config_dataB\[9\] net388 net302 vssd1 vssd1 vccd1 vccd1
+ _01469_ sky130_fd_sc_hd__mux2_1
XANTENNA__08265__B2 _03639_ vssd1 vssd1 vccd1 vccd1 sky130_fd_sc_hd__diode_2
X_09249_ FPGA_INST.cell1.SB0.route_sel\[20\] FPGA_INST.cell1.SB0.route_sel\[21\] net224
+ vssd1 vssd1 vccd1 vccd1 _00162_ sky130_fd_sc_hd__mux2_1
XANTENNA__06425__B _02376_ vssd1 vssd1 vccd1 vccd1 sky130_fd_sc_hd__diode_2
XFILLER_119_281 vssd1 vssd1 vccd1 vccd1 sky130_fd_sc_hd__fill_4
XANTENNA__08017__B2 _03421_ vssd1 vssd1 vccd1 vccd1 sky130_fd_sc_hd__diode_2
XANTENNA__08017__A1 _03475_ vssd1 vssd1 vccd1 vccd1 sky130_fd_sc_hd__diode_2
XFILLER_110_3 vccd1 vssd1 vccd1 vssd1 sky130_ef_sc_hd__decap_40_12
X_11211_ net755 _00561_ net540 vssd1 vssd1 vccd1 vccd1 FPGA_INST.cell0.SB0.route_sel\[56\]
+ sky130_fd_sc_hd__dfstp_1
X_11142_ net808 _00492_ net594 vssd1 vssd1 vccd1 vccd1 FPGA_INST.cell1.CB_1.config_dataB\[12\]
+ sky130_fd_sc_hd__dfstp_1
XANTENNA__09228__S net336 vssd1 vssd1 vccd1 vccd1 sky130_fd_sc_hd__diode_2
XANTENNA__06579__B2 _02819_ vssd1 vssd1 vccd1 vccd1 sky130_fd_sc_hd__diode_2
Xoutput32 net32 vssd1 vssd1 vccd1 vccd1 gpio_oeb[11] sky130_fd_sc_hd__buf_2
Xoutput43 net43 vssd1 vssd1 vccd1 vccd1 gpio_oeb[33] sky130_fd_sc_hd__buf_2
Xoutput65 net65 vssd1 vssd1 vccd1 vccd1 gpio_out[30] sky130_fd_sc_hd__buf_2
XANTENNA__05787__C1 net314 vssd1 vssd1 vccd1 vccd1 sky130_fd_sc_hd__diode_2
Xoutput54 net54 vssd1 vssd1 vccd1 vccd1 gpio_out[19] sky130_fd_sc_hd__buf_2
X_11073_ net837 _00423_ net621 vssd1 vssd1 vccd1 vccd1 FPGA_INST.cell1.LE_0A.config_data\[8\]
+ sky130_fd_sc_hd__dfrtp_1
XFILLER_122_468 vssd1 vssd1 vccd1 vccd1 sky130_fd_sc_hd__fill_8
XFILLER_49_703 vssd1 vssd1 vccd1 vccd1 sky130_fd_sc_hd__fill_4
XTAP_TAPCELL_ROW_8_397 vssd1 vccd1 sky130_fd_sc_hd__tapvpwrvgnd_1
XFILLER_0_297 vssd1 vssd1 vccd1 vccd1 sky130_fd_sc_hd__fill_2
XANTENNA_input30_A gpio_in[9] vssd1 vssd1 vccd1 vccd1 sky130_fd_sc_hd__diode_2
X_10024_ FPGA_INST.cell0.CB_0.config_dataA\[24\] FPGA_INST.cell0.CB_0.config_dataA\[23\]
+ net317 vssd1 vssd1 vccd1 vccd1 _00905_ sky130_fd_sc_hd__mux2_1
XTAP_TAPCELL_ROW_47_937 vssd1 vccd1 sky130_fd_sc_hd__tapvpwrvgnd_1
XTAP_TAPCELL_ROW_67_1220 vssd1 vccd1 sky130_fd_sc_hd__tapvpwrvgnd_1
XANTENNA__06159__Y _02439_ vssd1 vssd1 vccd1 vccd1 sky130_fd_sc_hd__diode_2
X_11975_ net845 _01321_ net630 vssd1 vssd1 vccd1 vccd1 FPGA_INST.cell2.SB0.route_sel\[15\]
+ sky130_fd_sc_hd__dfstp_1
XFILLER_17_655 vssd1 vssd1 vccd1 vccd1 sky130_fd_sc_hd__fill_1
XFILLER_72_783 vccd1 vssd1 vccd1 vssd1 sky130_ef_sc_hd__decap_40_12
XFILLER_72_772 vssd1 vssd1 vccd1 vccd1 sky130_fd_sc_hd__fill_2
X_10926_ net851 _00276_ net636 vssd1 vssd1 vccd1 vccd1 FPGA_INST.cell2.CB_0.config_dataA\[7\]
+ sky130_fd_sc_hd__dfstp_1
XTAP_TAPCELL_ROW_27_661 vssd1 vccd1 sky130_fd_sc_hd__tapvpwrvgnd_1
X_10857_ net801 _00207_ net586 vssd1 vssd1 vccd1 vccd1 FPGA_INST.cell1.SB0.route_sel\[66\]
+ sky130_fd_sc_hd__dfstp_1
XFILLER_72_50 vssd1 vssd1 vccd1 vccd1 sky130_fd_sc_hd__fill_2
XANTENNA__07251__B1_N FPGA_INST.bus3_1\[2\] vssd1 vssd1 vccd1 vccd1 sky130_fd_sc_hd__diode_2
XANTENNA__08256__A1 FPGA_INST.bus1_0\[13\] vssd1 vssd1 vccd1 vccd1 sky130_fd_sc_hd__diode_2
XPHY_EDGE_ROW_59_Right_59 vssd1 vssd1 vccd1 vccd1 sky130_fd_sc_hd__decap_3
X_10788_ net856 _00138_ net641 vssd1 vssd1 vccd1 vccd1 FPGA_INST.cell2.CB_1.config_dataB\[22\]
+ sky130_fd_sc_hd__dfstp_1
XFILLER_12_393 vssd1 vssd1 vccd1 vccd1 sky130_fd_sc_hd__fill_1
XFILLER_40_691 vssd1 vssd1 vccd1 vccd1 sky130_fd_sc_hd__fill_1
XANTENNA__10572__S net378 vssd1 vssd1 vccd1 vccd1 sky130_fd_sc_hd__diode_2
XTAP_TAPCELL_ROW_78_1371 vssd1 vccd1 sky130_fd_sc_hd__tapvpwrvgnd_1
X_11409_ net744 _00759_ net529 vssd1 vssd1 vccd1 vccd1 FPGA_INST.cell0.LEI0.config_data\[30\]
+ sky130_fd_sc_hd__dfrtp_1
XFILLER_101_608 vssd1 vssd1 vccd1 vccd1 sky130_fd_sc_hd__fill_8
XTAP_TAPCELL_ROW_91_1560 vssd1 vccd1 sky130_fd_sc_hd__tapvpwrvgnd_1
X_06950_ FPGA_INST.bus2_0\[6\] FPGA_INST.bus2_0\[7\] net416 vssd1 vssd1 vccd1 vccd1
+ _03218_ sky130_fd_sc_hd__mux2_1
XFILLER_79_393 vssd1 vssd1 vccd1 vccd1 sky130_fd_sc_hd__fill_1
XFILLER_79_371 vssd1 vssd1 vccd1 vccd1 sky130_fd_sc_hd__fill_4
XPHY_EDGE_ROW_68_Right_68 vssd1 vssd1 vccd1 vccd1 sky130_fd_sc_hd__decap_3
X_05901_ FPGA_INST.cell0.CB_1.config_dataA\[23\] FPGA_INST.cell0.CB_1.config_dataA\[22\]
+ vssd1 vssd1 vccd1 vccd1 _02181_ sky130_fd_sc_hd__nand2b_2
XANTENNA__06990__A1 FPGA_INST.bus2_0\[5\] vssd1 vssd1 vccd1 vccd1 sky130_fd_sc_hd__diode_2
X_06881_ FPGA_INST.bus2_0\[4\] _03127_ _03129_ FPGA_INST.bus2_0\[5\] vssd1 vssd1 vccd1
+ vccd1 _03149_ sky130_fd_sc_hd__a22o_1
X_08620_ FPGA_INST.cell3.SB0.route_sel\[10\] FPGA_INST.cell3.SB0.route_sel\[11\] vssd1
+ vssd1 vccd1 vccd1 _04829_ sky130_fd_sc_hd__nor2_1
X_05832_ _02097_ _02111_ _02095_ vssd1 vssd1 vccd1 vccd1 _02112_ sky130_fd_sc_hd__o21bai_4
XFILLER_67_588 vssd1 vssd1 vccd1 vccd1 sky130_fd_sc_hd__fill_1
XPHY_EDGE_ROW_6_Left_137 vssd1 vssd1 vccd1 vccd1 sky130_fd_sc_hd__decap_3
X_08551_ net92 net87 FPGA_INST.cell3.CB_1.le_outA net79 FPGA_INST.cell3.LEI0.config_data\[45\]
+ FPGA_INST.cell3.LEI0.config_data\[46\] vssd1 vssd1 vccd1 vccd1 _04762_ sky130_fd_sc_hd__mux4_1
X_05763_ net134 _01849_ _02039_ _02042_ _02033_ vssd1 vssd1 vccd1 vccd1 _02043_ sky130_fd_sc_hd__o311a_1
XANTENNA__05950__C1 net317 vssd1 vssd1 vccd1 vccd1 sky130_fd_sc_hd__diode_2
X_08482_ FPGA_INST.cell1.LE_1B.config_data\[6\] FPGA_INST.cell1.LE_1B.config_data\[7\]
+ _04692_ vssd1 vssd1 vccd1 vccd1 _04698_ sky130_fd_sc_hd__mux2_1
X_05694_ net382 net165 FPGA_INST.bus1_0\[13\] vssd1 vssd1 vccd1 vccd1 _01974_ sky130_fd_sc_hd__o21ai_1
X_07502_ FPGA_INST.cell0.SB0.route_sel\[70\] _01661_ vssd1 vssd1 vccd1 vccd1 _03758_
+ sky130_fd_sc_hd__nand2_1
X_07433_ _03498_ _03593_ _03690_ vssd1 vssd1 vccd1 vccd1 _03691_ sky130_fd_sc_hd__a21o_1
XFILLER_63_794 vssd1 vssd1 vccd1 vccd1 sky130_fd_sc_hd__fill_4
XPHY_EDGE_ROW_77_Right_77 vssd1 vssd1 vccd1 vccd1 sky130_fd_sc_hd__decap_3
XFILLER_23_669 vssd1 vssd1 vccd1 vccd1 sky130_fd_sc_hd__fill_2
X_07364_ net84 _03621_ _03623_ vssd1 vssd1 vccd1 vccd1 _03624_ sky130_fd_sc_hd__a21oi_1
XFILLER_50_488 vssd1 vssd1 vccd1 vccd1 sky130_fd_sc_hd__fill_1
X_09103_ FPGA_INST.cell2.LEI0.config_data\[17\] FPGA_INST.cell2.LEI0.config_data\[18\]
+ net251 vssd1 vssd1 vccd1 vccd1 _00019_ sky130_fd_sc_hd__mux2_1
XANTENNA_fanout315_A net381 vssd1 vssd1 vccd1 vccd1 sky130_fd_sc_hd__diode_2
X_07295_ FPGA_INST.cell0.SB0.route_sel\[24\] FPGA_INST.cell0.SB0.route_sel\[25\] vssd1
+ vssd1 vccd1 vccd1 _03556_ sky130_fd_sc_hd__nand2b_1
X_06315_ FPGA_INST.cell2.CB_0.config_dataA\[18\] FPGA_INST.cell2.CB_0.config_dataA\[17\]
+ vssd1 vssd1 vccd1 vccd1 _02595_ sky130_fd_sc_hd__or2_1
X_06246_ _02010_ _02505_ _02506_ _01966_ _01530_ vssd1 vssd1 vccd1 vccd1 _02526_ sky130_fd_sc_hd__a221o_1
X_09034_ FPGA_INST.cell2.SB0.route_sel\[2\] FPGA_INST.cell2.SB0.route_sel\[3\] vssd1
+ vssd1 vccd1 vccd1 _05196_ sky130_fd_sc_hd__nand2b_1
XFILLER_117_763 vccd1 vssd1 vccd1 vssd1 sky130_ef_sc_hd__decap_40_12
XFILLER_117_785 vccd1 vssd1 vccd1 vssd1 sky130_ef_sc_hd__decap_40_12
XFILLER_117_35 vssd1 vssd1 vccd1 vccd1 sky130_fd_sc_hd__fill_1
XANTENNA__10357__A2 net525 vssd1 vssd1 vccd1 vccd1 sky130_fd_sc_hd__diode_2
X_06177_ net112 _01927_ _02340_ vssd1 vssd1 vccd1 vccd1 _02457_ sky130_fd_sc_hd__nor3_1
XANTENNA_fanout103_X net103 vssd1 vssd1 vccd1 vccd1 sky130_fd_sc_hd__diode_2
XFILLER_117_68 vssd1 vssd1 vccd1 vccd1 sky130_fd_sc_hd__fill_4
Xfanout800 net802 vssd1 vssd1 vccd1 vccd1 net800 sky130_fd_sc_hd__clkbuf_2
Xfanout811 net843 vssd1 vssd1 vccd1 vccd1 net811 sky130_fd_sc_hd__clkbuf_2
Xfanout833 net843 vssd1 vssd1 vccd1 vccd1 net833 sky130_fd_sc_hd__buf_1
XPHY_EDGE_ROW_86_Right_86 vssd1 vssd1 vccd1 vccd1 sky130_fd_sc_hd__decap_3
XFILLER_77_39 vssd1 vssd1 vccd1 vccd1 sky130_fd_sc_hd__fill_4
Xfanout822 net823 vssd1 vssd1 vccd1 vccd1 net822 sky130_fd_sc_hd__clkbuf_2
X_09936_ FPGA_INST.cell0.LE_1A.reset_val FPGA_INST.cell0.LE_1A.edge_mode net308 vssd1
+ vssd1 vccd1 vccd1 _00841_ sky130_fd_sc_hd__mux2_1
Xfanout855 net856 vssd1 vssd1 vccd1 vccd1 net855 sky130_fd_sc_hd__clkbuf_2
XFILLER_58_533 vssd1 vssd1 vccd1 vccd1 sky130_fd_sc_hd__fill_1
Xfanout844 net849 vssd1 vssd1 vccd1 vccd1 net844 sky130_fd_sc_hd__clkbuf_2
Xfanout866 net868 vssd1 vssd1 vccd1 vccd1 net866 sky130_fd_sc_hd__clkbuf_2
Xfanout899 net918 vssd1 vssd1 vccd1 vccd1 net899 sky130_fd_sc_hd__clkbuf_2
Xfanout888 net891 vssd1 vssd1 vccd1 vccd1 net888 sky130_fd_sc_hd__buf_1
XTAP_TAPCELL_ROW_5_356 vssd1 vccd1 sky130_fd_sc_hd__tapvpwrvgnd_1
X_09867_ FPGA_INST.cell0.LEI0.config_data\[45\] FPGA_INST.cell0.LEI0.config_data\[46\]
+ net180 vssd1 vssd1 vccd1 vccd1 _00775_ sky130_fd_sc_hd__mux2_1
XANTENNA_fanout851_A net862 vssd1 vssd1 vccd1 vccd1 sky130_fd_sc_hd__diode_2
Xfanout877 net892 vssd1 vssd1 vccd1 vccd1 net877 sky130_fd_sc_hd__clkbuf_2
XANTENNA__08183__A0 net115 vssd1 vssd1 vccd1 vccd1 sky130_fd_sc_hd__diode_2
XANTENNA__07930__A0 FPGA_INST.bus3_1\[4\] vssd1 vssd1 vccd1 vccd1 sky130_fd_sc_hd__diode_2
X_08818_ _01773_ _05021_ _05022_ _05023_ _05024_ vssd1 vssd1 vccd1 vccd1 _05025_ sky130_fd_sc_hd__o41a_1
X_09798_ FPGA_INST.cell1.CB_1.config_dataA\[24\] FPGA_INST.cell1.CB_1.config_dataA\[23\]
+ net331 vssd1 vssd1 vccd1 vccd1 _00707_ sky130_fd_sc_hd__mux2_1
XFILLER_85_363 vssd1 vssd1 vccd1 vccd1 sky130_fd_sc_hd__fill_2
XFILLER_73_514 vssd1 vssd1 vccd1 vccd1 sky130_fd_sc_hd__fill_1
XANTENNA__06733__A1 FPGA_INST.bus3_2\[5\] vssd1 vssd1 vccd1 vccd1 sky130_fd_sc_hd__diode_2
XFILLER_39_780 vssd1 vssd1 vccd1 vccd1 sky130_fd_sc_hd__fill_2
XANTENNA_fanout737_X net737 vssd1 vssd1 vccd1 vccd1 sky130_fd_sc_hd__diode_2
X_08749_ FPGA_INST.cell3.LEI0.config_data\[38\] _04954_ _04956_ _04957_ vssd1 vssd1
+ vccd1 vccd1 _04958_ sky130_fd_sc_hd__o31a_1
XTAP_TAPCELL_ROW_103_1718 vssd1 vccd1 sky130_fd_sc_hd__tapvpwrvgnd_1
X_11760_ net923 _01106_ net707 vssd1 vssd1 vccd1 vccd1 FPGA_INST.io_west_oeb\[4\]
+ sky130_fd_sc_hd__dfrtp_1
XTAP_TAPCELL_ROW_103_1729 vssd1 vccd1 sky130_fd_sc_hd__tapvpwrvgnd_1
XPHY_EDGE_ROW_95_Right_95 vssd1 vssd1 vccd1 vccd1 sky130_fd_sc_hd__decap_3
X_10711_ net863 _00061_ net648 vssd1 vssd1 vccd1 vccd1 FPGA_INST.cell2.LE_0A.config_data\[10\]
+ sky130_fd_sc_hd__dfrtp_1
XFILLER_13_102 vssd1 vssd1 vccd1 vccd1 sky130_fd_sc_hd__fill_1
XTAP_TAPCELL_ROW_24_620 vssd1 vccd1 sky130_fd_sc_hd__tapvpwrvgnd_1
X_11691_ net898 _01037_ net682 vssd1 vssd1 vccd1 vccd1 FPGA_INST.cell3.SB0.route_sel\[61\]
+ sky130_fd_sc_hd__dfstp_1
XFILLER_14_669 vssd1 vssd1 vccd1 vccd1 sky130_fd_sc_hd__fill_1
X_10642_ FPGA_INST.cell3.LE_1B.config_data\[11\] FPGA_INST.cell3.LE_1B.config_data\[12\]
+ net280 vssd1 vssd1 vccd1 vccd1 _01521_ sky130_fd_sc_hd__mux2_1
XANTENNA__08238__A1 FPGA_INST.bus1_0\[8\] vssd1 vssd1 vccd1 vccd1 sky130_fd_sc_hd__diode_2
XTAP_TAPCELL_ROW_62_1150 vssd1 vccd1 sky130_fd_sc_hd__tapvpwrvgnd_1
XANTENNA__06249__A0 net14 vssd1 vssd1 vccd1 vccd1 sky130_fd_sc_hd__diode_2
X_10573_ FPGA_INST.cell3.CB_0.config_dataA\[18\] FPGA_INST.cell3.CB_0.config_dataA\[17\]
+ net371 vssd1 vssd1 vccd1 vccd1 _01452_ sky130_fd_sc_hd__mux2_1
XANTENNA__05699__B1_N FPGA_INST.bus2_0\[13\] vssd1 vssd1 vccd1 vccd1 sky130_fd_sc_hd__diode_2
X_12174_ net909 _01520_ net693 vssd1 vssd1 vccd1 vccd1 FPGA_INST.cell3.LE_1B.config_data\[11\]
+ sky130_fd_sc_hd__dfrtp_1
XFILLER_123_755 vssd1 vssd1 vccd1 vccd1 sky130_fd_sc_hd__fill_8
X_11125_ net796 _00475_ net581 vssd1 vssd1 vccd1 vccd1 FPGA_INST.cell1.LE_1A.config_data\[16\]
+ sky130_fd_sc_hd__dfrtp_1
X_11056_ net814 _00406_ net599 vssd1 vssd1 vccd1 vccd1 FPGA_INST.cell1.LEI0.config_data\[41\]
+ sky130_fd_sc_hd__dfrtp_1
XFILLER_76_330 vssd1 vssd1 vccd1 vccd1 sky130_fd_sc_hd__fill_1
XFILLER_67_72 vssd1 vssd1 vccd1 vccd1 sky130_fd_sc_hd__fill_1
X_10007_ FPGA_INST.cell0.CB_0.config_dataA\[7\] FPGA_INST.cell0.CB_0.config_dataA\[6\]
+ net319 vssd1 vssd1 vccd1 vccd1 _00888_ sky130_fd_sc_hd__mux2_1
XFILLER_76_363 vssd1 vssd1 vccd1 vccd1 sky130_fd_sc_hd__fill_1
XFILLER_91_333 vssd1 vssd1 vccd1 vccd1 sky130_fd_sc_hd__fill_2
XFILLER_76_396 vssd1 vssd1 vccd1 vccd1 sky130_fd_sc_hd__fill_1
XANTENNA__05515__A FPGA_INST.bus3_2\[0\] vssd1 vssd1 vccd1 vccd1 sky130_fd_sc_hd__diode_2
XFILLER_36_249 vssd1 vssd1 vccd1 vccd1 sky130_fd_sc_hd__fill_2
XFILLER_45_783 vssd1 vssd1 vccd1 vccd1 sky130_fd_sc_hd__fill_1
X_11958_ net908 _01304_ net692 vssd1 vssd1 vccd1 vccd1 FPGA_INST.cell3.CB_1.config_dataB\[23\]
+ sky130_fd_sc_hd__dfstp_1
X_11889_ net937 _01235_ net722 vssd1 vssd1 vccd1 vccd1 FPGA_INST.cell3.LE_0A.reset_mode
+ sky130_fd_sc_hd__dfrtp_2
XANTENNA__10567__S net374 vssd1 vssd1 vccd1 vccd1 sky130_fd_sc_hd__diode_2
X_10909_ net785 _00259_ net570 vssd1 vssd1 vccd1 vccd1 FPGA_INST.cell1.SB0.route_sel\[118\]
+ sky130_fd_sc_hd__dfstp_1
XFILLER_12_190 vssd1 vssd1 vccd1 vccd1 sky130_fd_sc_hd__fill_2
XFILLER_73_3 vccd1 vssd1 vccd1 vssd1 sky130_ef_sc_hd__decap_40_12
X_06100_ _01821_ net157 vssd1 vssd1 vccd1 vccd1 _02380_ sky130_fd_sc_hd__nor2_1
XFILLER_9_673 vssd1 vssd1 vccd1 vccd1 sky130_fd_sc_hd__fill_2
XFILLER_8_161 vssd1 vssd1 vccd1 vccd1 sky130_fd_sc_hd__fill_1
X_07080_ FPGA_INST.cell0.LEI0.config_data\[26\] _03345_ vssd1 vssd1 vccd1 vccd1 _03346_
+ sky130_fd_sc_hd__and2b_1
X_06031_ net166 net160 _02306_ _02308_ vssd1 vssd1 vccd1 vccd1 _02311_ sky130_fd_sc_hd__o22a_1
XANTENNA__08401__A1 net95 vssd1 vssd1 vccd1 vccd1 sky130_fd_sc_hd__diode_2
X_07982_ _03973_ _04189_ FPGA_INST.cell1.CB_0.config_dataA\[17\] vssd1 vssd1 vccd1
+ vccd1 _04210_ sky130_fd_sc_hd__o21ai_1
XFILLER_87_628 vssd1 vssd1 vccd1 vccd1 sky130_fd_sc_hd__fill_2
Xfanout118 net119 vssd1 vssd1 vccd1 vccd1 net118 sky130_fd_sc_hd__clkbuf_2
Xfanout129 net130 vssd1 vssd1 vccd1 vccd1 net129 sky130_fd_sc_hd__buf_4
X_09721_ FPGA_INST.cell0.SB0.route_sel\[124\] FPGA_INST.cell0.SB0.route_sel\[125\]
+ net199 vssd1 vssd1 vccd1 vccd1 _00630_ sky130_fd_sc_hd__mux2_1
X_06933_ FPGA_INST.bus2_0\[12\] FPGA_INST.bus2_0\[14\] FPGA_INST.bus2_0\[13\] FPGA_INST.bus2_0\[15\]
+ net414 net416 vssd1 vssd1 vccd1 vccd1 _03201_ sky130_fd_sc_hd__mux4_1
XTAP_TAPCELL_ROW_2_304 vssd1 vccd1 sky130_fd_sc_hd__tapvpwrvgnd_1
XFILLER_67_385 vssd1 vssd1 vccd1 vccd1 sky130_fd_sc_hd__fill_4
XFILLER_55_503 vssd1 vssd1 vccd1 vccd1 sky130_fd_sc_hd__fill_1
XTAP_TAPCELL_ROW_2_315 vssd1 vccd1 sky130_fd_sc_hd__tapvpwrvgnd_1
X_09652_ FPGA_INST.cell0.SB0.route_sel\[56\] FPGA_INST.cell0.SB0.route_sel\[55\] net310
+ vssd1 vssd1 vccd1 vccd1 _00561_ sky130_fd_sc_hd__mux2_1
X_06864_ net424 _01839_ net423 vssd1 vssd1 vccd1 vccd1 _03132_ sky130_fd_sc_hd__o21ai_1
X_09583_ FPGA_INST.cell1.CB_1.config_dataB\[12\] FPGA_INST.cell1.CB_1.config_dataB\[11\]
+ net334 vssd1 vssd1 vccd1 vccd1 _00492_ sky130_fd_sc_hd__mux2_1
X_08603_ _01617_ FPGA_INST.cell3.SB0.route_sel\[108\] _01618_ FPGA_INST.cell3.SB0.route_sel\[111\]
+ _04811_ vssd1 vssd1 vccd1 vccd1 _04812_ sky130_fd_sc_hd__a221o_1
XFILLER_82_344 vssd1 vssd1 vccd1 vccd1 sky130_fd_sc_hd__fill_1
X_06795_ _03067_ _03068_ FPGA_INST.cell2.CB_1.config_dataB\[17\] vssd1 vssd1 vccd1
+ vccd1 _03069_ sky130_fd_sc_hd__mux2_1
XANTENNA__07116__S _03313_ vssd1 vssd1 vccd1 vccd1 sky130_fd_sc_hd__diode_2
X_05815_ net116 _01967_ _02012_ vssd1 vssd1 vccd1 vccd1 _02095_ sky130_fd_sc_hd__and3_1
X_08534_ _04746_ _04739_ _04735_ vssd1 vssd1 vccd1 vccd1 _04747_ sky130_fd_sc_hd__mux2_1
XANTENNA_fanout265_A net266 vssd1 vssd1 vccd1 vccd1 sky130_fd_sc_hd__diode_2
X_05746_ FPGA_INST.cell0.SB0.route_sel\[80\] FPGA_INST.cell0.SB0.route_sel\[81\] _02022_
+ _02025_ net314 vssd1 vssd1 vccd1 vccd1 _02026_ sky130_fd_sc_hd__a311oi_1
XFILLER_35_271 vssd1 vssd1 vccd1 vccd1 sky130_fd_sc_hd__fill_1
XFILLER_36_794 vssd1 vssd1 vccd1 vccd1 sky130_fd_sc_hd__fill_2
X_08465_ _04682_ _04675_ _04671_ vssd1 vssd1 vccd1 vccd1 _04683_ sky130_fd_sc_hd__mux2_1
X_05677_ FPGA_INST.cell2.CB_0.config_dataA\[24\] FPGA_INST.cell2.CB_0.config_dataA\[21\]
+ FPGA_INST.cell2.CB_0.config_dataA\[20\] vssd1 vssd1 vccd1 vccd1 _01957_ sky130_fd_sc_hd__or3_1
XFILLER_23_444 vssd1 vssd1 vccd1 vccd1 sky130_fd_sc_hd__fill_4
X_07416_ _03499_ _03594_ FPGA_INST.bus3_1\[6\] vssd1 vssd1 vccd1 vccd1 _03674_ sky130_fd_sc_hd__o21ai_1
X_08396_ FPGA_INST.cell0.CB_1.config_dataB\[17\] _04617_ vssd1 vssd1 vccd1 vccd1 _04618_
+ sky130_fd_sc_hd__nor2_1
XFILLER_51_797 vssd1 vssd1 vccd1 vccd1 sky130_fd_sc_hd__fill_2
X_07347_ FPGA_INST.cell1.CB_1.config_dataA\[23\] FPGA_INST.cell1.CB_1.config_dataA\[22\]
+ vssd1 vssd1 vccd1 vccd1 _03607_ sky130_fd_sc_hd__nand2b_4
XANTENNA_fanout899_A net918 vssd1 vssd1 vccd1 vccd1 sky130_fd_sc_hd__diode_2
XANTENNA__08640__A1 net26 vssd1 vssd1 vccd1 vccd1 sky130_fd_sc_hd__diode_2
X_07278_ FPGA_INST.cell3.SB0.route_sel\[16\] FPGA_INST.cell3.SB0.route_sel\[17\] _01703_
+ FPGA_INST.cell3.SB0.route_sel\[19\] _03539_ vssd1 vssd1 vccd1 vccd1 _03540_ sky130_fd_sc_hd__o221a_1
X_09017_ _01552_ FPGA_INST.cell2.SB0.route_sel\[17\] FPGA_INST.cell2.SB0.route_sel\[22\]
+ FPGA_INST.cell2.SB0.route_sel\[23\] _05184_ vssd1 vssd1 vccd1 vccd1 _05185_ sky130_fd_sc_hd__o221a_1
X_06229_ net509 _02217_ vssd1 vssd1 vccd1 vccd1 _02509_ sky130_fd_sc_hd__nand2_1
XANTENNA__06403__A0 net14 vssd1 vssd1 vccd1 vccd1 sky130_fd_sc_hd__diode_2
Xfanout641 net647 vssd1 vssd1 vccd1 vccd1 net641 sky130_fd_sc_hd__clkbuf_4
Xfanout630 net634 vssd1 vssd1 vccd1 vccd1 net630 sky130_fd_sc_hd__clkbuf_2
Xfanout685 net686 vssd1 vssd1 vccd1 vccd1 net685 sky130_fd_sc_hd__clkbuf_4
Xfanout674 net675 vssd1 vssd1 vccd1 vccd1 net674 sky130_fd_sc_hd__buf_2
X_09919_ FPGA_INST.cell0.LE_1A.config_data\[1\] FPGA_INST.cell0.LE_1A.config_data\[0\]
+ net308 vssd1 vssd1 vccd1 vccd1 _00824_ sky130_fd_sc_hd__mux2_1
Xfanout652 net662 vssd1 vssd1 vccd1 vccd1 net652 sky130_fd_sc_hd__clkbuf_2
Xfanout663 net666 vssd1 vssd1 vccd1 vccd1 net663 sky130_fd_sc_hd__clkbuf_4
XTAP_TAPCELL_ROW_129_2087 vssd1 vccd1 sky130_fd_sc_hd__tapvpwrvgnd_1
Xfanout696 net701 vssd1 vssd1 vccd1 vccd1 net696 sky130_fd_sc_hd__clkbuf_4
XFILLER_86_694 vssd1 vssd1 vccd1 vccd1 sky130_fd_sc_hd__fill_4
XFILLER_58_385 vssd1 vssd1 vccd1 vccd1 sky130_fd_sc_hd__fill_4
XFILLER_37_42 vccd1 vssd1 vccd1 vssd1 sky130_ef_sc_hd__decap_40_12
X_11812_ net871 _01158_ net655 vssd1 vssd1 vccd1 vccd1 net37 sky130_fd_sc_hd__dfrtp_1
XFILLER_61_528 vssd1 vssd1 vccd1 vccd1 sky130_fd_sc_hd__fill_4
X_11743_ net895 _01089_ net679 vssd1 vssd1 vccd1 vccd1 FPGA_INST.cell3.SB0.route_sel\[113\]
+ sky130_fd_sc_hd__dfstp_1
XFILLER_53_30 vssd1 vssd1 vccd1 vccd1 sky130_fd_sc_hd__fill_2
X_11674_ net906 _01020_ net690 vssd1 vssd1 vccd1 vccd1 FPGA_INST.cell3.SB0.route_sel\[44\]
+ sky130_fd_sc_hd__dfstp_2
XPHY_EDGE_ROW_78_Left_209 vssd1 vssd1 vccd1 vccd1 sky130_fd_sc_hd__decap_3
X_10625_ FPGA_INST.cell3.CB_1.config_dataA\[20\] FPGA_INST.cell3.CB_1.config_dataA\[19\]
+ net370 vssd1 vssd1 vccd1 vccd1 _01504_ sky130_fd_sc_hd__mux2_1
XTAP_TAPCELL_ROW_116_1909 vssd1 vccd1 sky130_fd_sc_hd__tapvpwrvgnd_1
X_10556_ net401 net400 net288 vssd1 vssd1 vccd1 vccd1 _01435_ sky130_fd_sc_hd__mux2_1
X_10487_ FPGA_INST.cell2.SB0.route_sel\[60\] FPGA_INST.cell2.SB0.route_sel\[59\] net351
+ vssd1 vssd1 vccd1 vccd1 _01366_ sky130_fd_sc_hd__mux2_1
XTAP_TAPCELL_ROW_75_1330 vssd1 vccd1 sky130_fd_sc_hd__tapvpwrvgnd_1
X_12157_ net934 _01503_ net718 vssd1 vssd1 vccd1 vccd1 FPGA_INST.cell3.CB_1.config_dataA\[19\]
+ sky130_fd_sc_hd__dfstp_1
XFILLER_69_617 vssd1 vssd1 vccd1 vccd1 sky130_fd_sc_hd__fill_1
XANTENNA__08395__A0 FPGA_INST.bus1_0\[8\] vssd1 vssd1 vccd1 vccd1 sky130_fd_sc_hd__diode_2
X_11108_ FPGA_INST.cell1.LE_1B.sel_clk _00458_ net733 vssd1 vssd1 vccd1 vccd1 FPGA_INST.cell1.LE_1B.dff1_out
+ sky130_fd_sc_hd__dfstp_1
XFILLER_111_725 vssd1 vssd1 vccd1 vccd1 sky130_fd_sc_hd__fill_2
XFILLER_96_414 vssd1 vssd1 vccd1 vccd1 sky130_fd_sc_hd__fill_4
XPHY_EDGE_ROW_87_Left_218 vssd1 vssd1 vccd1 vccd1 sky130_fd_sc_hd__decap_3
XANTENNA__06945__B2 _02309_ vssd1 vssd1 vccd1 vccd1 sky130_fd_sc_hd__diode_2
X_12088_ net915 _01434_ net699 vssd1 vssd1 vccd1 vccd1 FPGA_INST.cell3.CB_0.config_dataA\[0\]
+ sky130_fd_sc_hd__dfstp_1
XFILLER_111_758 vssd1 vssd1 vccd1 vccd1 sky130_fd_sc_hd__fill_1
X_11039_ net814 _00389_ net599 vssd1 vssd1 vccd1 vccd1 FPGA_INST.cell1.LEI0.config_data\[24\]
+ sky130_fd_sc_hd__dfrtp_1
XFILLER_37_514 vssd1 vssd1 vccd1 vccd1 sky130_fd_sc_hd__fill_4
XFILLER_64_322 vccd1 vssd1 vccd1 vssd1 sky130_ef_sc_hd__decap_40_12
XFILLER_64_377 vccd1 vssd1 vccd1 vssd1 sky130_ef_sc_hd__decap_40_12
X_05600_ net96 net382 _01876_ _01879_ _01826_ vssd1 vssd1 vccd1 vccd1 _01880_ sky130_fd_sc_hd__o32a_1
XFILLER_52_517 vssd1 vssd1 vccd1 vccd1 sky130_fd_sc_hd__fill_2
XTAP_TAPCELL_ROW_86_1492 vssd1 vccd1 sky130_fd_sc_hd__tapvpwrvgnd_1
XTAP_TAPCELL_ROW_86_1481 vssd1 vccd1 sky130_fd_sc_hd__tapvpwrvgnd_1
X_06580_ _02852_ _02855_ FPGA_INST.cell2.CB_1.config_dataA\[2\] vssd1 vssd1 vccd1
+ vccd1 _02856_ sky130_fd_sc_hd__o21ai_1
XFILLER_18_794 vssd1 vssd1 vccd1 vccd1 sky130_fd_sc_hd__fill_1
XPHY_EDGE_ROW_96_Left_227 vssd1 vssd1 vccd1 vccd1 sky130_fd_sc_hd__decap_3
X_05531_ net506 net505 vssd1 vssd1 vccd1 vccd1 _01811_ sky130_fd_sc_hd__nor2_1
XANTENNA__08870__A1 net22 vssd1 vssd1 vccd1 vccd1 sky130_fd_sc_hd__diode_2
X_08250_ net402 net403 vssd1 vssd1 vccd1 vccd1 _04474_ sky130_fd_sc_hd__and2b_1
X_05462_ FPGA_INST.cell0.CB_0.config_dataB\[7\] vssd1 vssd1 vccd1 vccd1 _01744_ sky130_fd_sc_hd__inv_2
X_07201_ _01717_ FPGA_INST.cell0.SB0.route_sel\[15\] vssd1 vssd1 vccd1 vccd1 _03464_
+ sky130_fd_sc_hd__or2_1
X_08181_ _04395_ _04396_ _04403_ _04404_ vssd1 vssd1 vccd1 vccd1 _04405_ sky130_fd_sc_hd__o22a_1
XTAP_TAPCELL_ROW_15_494 vssd1 vccd1 sky130_fd_sc_hd__tapvpwrvgnd_1
XFILLER_32_296 vssd1 vssd1 vccd1 vccd1 sky130_fd_sc_hd__fill_1
XFILLER_118_302 vssd1 vssd1 vccd1 vccd1 sky130_fd_sc_hd__fill_1
XANTENNA__07459__X _03716_ vssd1 vssd1 vccd1 vccd1 sky130_fd_sc_hd__diode_2
X_05393_ FPGA_INST.cell1.SB0.route_sel\[50\] vssd1 vssd1 vccd1 vccd1 _01675_ sky130_fd_sc_hd__inv_2
X_07132_ FPGA_INST.cell1.CB_0.config_dataA\[23\] FPGA_INST.cell1.CB_0.config_dataA\[22\]
+ vssd1 vssd1 vccd1 vccd1 _03396_ sky130_fd_sc_hd__or2_1
XANTENNA__10699__RESET_B net734 vssd1 vssd1 vccd1 vccd1 sky130_fd_sc_hd__diode_2
XFILLER_118_346 vccd1 vssd1 vccd1 vssd1 sky130_ef_sc_hd__decap_40_12
XFILLER_9_481 vssd1 vssd1 vccd1 vccd1 sky130_fd_sc_hd__fill_1
XANTENNA__07976__A3 FPGA_INST.bus3_1\[15\] vssd1 vssd1 vccd1 vccd1 sky130_fd_sc_hd__diode_2
X_07063_ FPGA_INST.bus2_0\[6\] FPGA_INST.bus2_0\[7\] net430 vssd1 vssd1 vccd1 vccd1
+ _03329_ sky130_fd_sc_hd__mux2_1
X_06014_ net116 _01967_ _02173_ vssd1 vssd1 vccd1 vccd1 _02294_ sky130_fd_sc_hd__and3_1
XANTENNA__10722__SET_B net734 vssd1 vssd1 vccd1 vccd1 sky130_fd_sc_hd__diode_2
XANTENNA__06936__A1 _01937_ vssd1 vssd1 vccd1 vccd1 sky130_fd_sc_hd__diode_2
XANTENNA__06936__B2 _01984_ vssd1 vssd1 vccd1 vccd1 sky130_fd_sc_hd__diode_2
XANTENNA__08138__A0 net152 vssd1 vssd1 vccd1 vccd1 sky130_fd_sc_hd__diode_2
X_07965_ FPGA_INST.bus3_1\[4\] FPGA_INST.bus3_1\[5\] FPGA_INST.bus3_1\[6\] FPGA_INST.bus3_1\[7\]
+ net463 FPGA_INST.cell1.CB_0.config_dataA\[16\] vssd1 vssd1 vccd1 vccd1 _04193_ sky130_fd_sc_hd__mux4_1
XFILLER_87_447 vssd1 vssd1 vccd1 vccd1 sky130_fd_sc_hd__fill_1
X_06916_ net417 _03183_ vssd1 vssd1 vccd1 vccd1 _03184_ sky130_fd_sc_hd__and2_1
X_09704_ FPGA_INST.cell0.SB0.route_sel\[108\] FPGA_INST.cell0.SB0.route_sel\[107\]
+ net324 vssd1 vssd1 vccd1 vccd1 _00613_ sky130_fd_sc_hd__mux2_1
X_07896_ _04122_ _04123_ FPGA_INST.cell1.CB_0.config_dataA\[2\] vssd1 vssd1 vccd1
+ vccd1 _04124_ sky130_fd_sc_hd__mux2_1
X_09635_ FPGA_INST.cell0.SB0.route_sel\[38\] FPGA_INST.cell0.SB0.route_sel\[39\] net186
+ vssd1 vssd1 vccd1 vccd1 _00544_ sky130_fd_sc_hd__mux2_1
XFILLER_28_558 vssd1 vssd1 vccd1 vccd1 sky130_fd_sc_hd__fill_1
XANTENNA_fanout268_X net268 vssd1 vssd1 vccd1 vccd1 sky130_fd_sc_hd__diode_2
XANTENNA_fanout170_X net170 vssd1 vssd1 vccd1 vccd1 sky130_fd_sc_hd__diode_2
X_06847_ net421 _02030_ _03114_ net420 vssd1 vssd1 vccd1 vccd1 _03115_ sky130_fd_sc_hd__o211a_1
XANTENNA_fanout647_A net676 vssd1 vssd1 vccd1 vccd1 sky130_fd_sc_hd__diode_2
X_09566_ FPGA_INST.cell1.LE_1A.config_data\[15\] FPGA_INST.cell1.LE_1A.config_data\[16\]
+ net205 vssd1 vssd1 vccd1 vccd1 _00475_ sky130_fd_sc_hd__mux2_1
X_06778_ net511 net512 vssd1 vssd1 vccd1 vccd1 _03052_ sky130_fd_sc_hd__and2b_1
XANTENNA__06538__X _02814_ vssd1 vssd1 vccd1 vccd1 sky130_fd_sc_hd__diode_2
XFILLER_130_68 vssd1 vssd1 vccd1 vccd1 sky130_fd_sc_hd__fill_2
XFILLER_130_57 vssd1 vssd1 vccd1 vccd1 sky130_fd_sc_hd__fill_1
X_08517_ FPGA_INST.cell3.LE_1A.config_data\[6\] FPGA_INST.cell3.LE_1A.config_data\[7\]
+ _04725_ vssd1 vssd1 vccd1 vccd1 _04730_ sky130_fd_sc_hd__mux2_1
XANTENNA_fanout814_A net820 vssd1 vssd1 vccd1 vccd1 sky130_fd_sc_hd__diode_2
X_09497_ FPGA_INST.cell1.LEI0.config_data\[43\] FPGA_INST.cell1.LEI0.config_data\[44\]
+ net205 vssd1 vssd1 vccd1 vccd1 _00409_ sky130_fd_sc_hd__mux2_1
XANTENNA__08310__A0 net73 vssd1 vssd1 vccd1 vccd1 sky130_fd_sc_hd__diode_2
X_05729_ FPGA_INST.cell2.SB0.route_sel\[110\] _01581_ FPGA_INST.cell2.SB0.route_sel\[106\]
+ FPGA_INST.cell2.SB0.route_sel\[107\] _02008_ vssd1 vssd1 vccd1 vccd1 _02009_ sky130_fd_sc_hd__o221a_1
X_08448_ FPGA_INST.cell1.LE_1A.config_data\[2\] FPGA_INST.cell1.LE_1A.config_data\[3\]
+ _04660_ vssd1 vssd1 vccd1 vccd1 _04666_ sky130_fd_sc_hd__mux2_1
XFILLER_51_561 vssd1 vssd1 vccd1 vccd1 sky130_fd_sc_hd__fill_2
XFILLER_24_797 vssd1 vssd1 vccd1 vccd1 sky130_fd_sc_hd__fill_2
XFILLER_11_447 vssd1 vssd1 vccd1 vccd1 sky130_fd_sc_hd__fill_1
XFILLER_23_55 vssd1 vssd1 vccd1 vccd1 sky130_fd_sc_hd__fill_1
X_10410_ FPGA_INST.cell3.CB_1.config_dataB\[8\] FPGA_INST.cell3.CB_1.config_dataB\[7\]
+ net370 vssd1 vssd1 vccd1 vccd1 _01289_ sky130_fd_sc_hd__mux2_1
XFILLER_11_458 vssd1 vssd1 vccd1 vccd1 sky130_fd_sc_hd__fill_2
X_08379_ net114 net118 net110 net98 FPGA_INST.cell0.LEI0.config_data\[33\] FPGA_INST.cell0.LEI0.config_data\[34\]
+ vssd1 vssd1 vccd1 vccd1 _04601_ sky130_fd_sc_hd__mux4_1
X_11390_ net761 _00740_ net546 vssd1 vssd1 vccd1 vccd1 FPGA_INST.cell0.LEI0.config_data\[11\]
+ sky130_fd_sc_hd__dfrtp_1
X_10341_ FPGA_INST.cell3.LE_0A.config_data\[5\] FPGA_INST.cell3.LE_0A.config_data\[6\]
+ net294 vssd1 vssd1 vccd1 vccd1 _01222_ sky130_fd_sc_hd__mux2_1
X_10272_ net44 net32 net255 vssd1 vssd1 vccd1 vccd1 _01153_ sky130_fd_sc_hd__mux2_1
XFILLER_3_3 vccd1 vssd1 vccd1 vssd1 sky130_ef_sc_hd__decap_40_12
XFILLER_2_145 vssd1 vssd1 vccd1 vccd1 sky130_fd_sc_hd__fill_2
X_12011_ net776 _01357_ net562 vssd1 vssd1 vccd1 vccd1 FPGA_INST.cell2.SB0.route_sel\[51\]
+ sky130_fd_sc_hd__dfstp_1
XANTENNA_fanout83_X net83 vssd1 vssd1 vccd1 vccd1 sky130_fd_sc_hd__diode_2
XTAP_TAPCELL_ROW_111_1839 vssd1 vccd1 sky130_fd_sc_hd__tapvpwrvgnd_1
XTAP_TAPCELL_ROW_57_1082 vssd1 vccd1 sky130_fd_sc_hd__tapvpwrvgnd_1
Xfanout471 FPGA_INST.cell1.CB_0.config_dataA\[1\] vssd1 vssd1 vccd1 vccd1 net471 sky130_fd_sc_hd__clkbuf_2
Xfanout460 FPGA_INST.cell1.CB_0.config_dataB\[0\] vssd1 vssd1 vccd1 vccd1 net460 sky130_fd_sc_hd__buf_2
XTAP_TAPCELL_ROW_70_1260 vssd1 vccd1 sky130_fd_sc_hd__tapvpwrvgnd_1
Xfanout482 FPGA_INST.cell2.CB_1.config_dataA\[1\] vssd1 vssd1 vccd1 vccd1 net482 sky130_fd_sc_hd__buf_2
Xfanout493 FPGA_INST.cell2.CB_0.config_dataB\[6\] vssd1 vssd1 vccd1 vccd1 net493 sky130_fd_sc_hd__buf_2
XFILLER_19_503 vssd1 vssd1 vccd1 vccd1 sky130_fd_sc_hd__fill_1
XFILLER_74_620 vssd1 vssd1 vccd1 vccd1 sky130_fd_sc_hd__fill_2
XFILLER_0_26 vssd1 vssd1 vccd1 vccd1 sky130_fd_sc_hd__fill_2
XFILLER_19_547 vssd1 vssd1 vccd1 vccd1 sky130_fd_sc_hd__fill_1
XANTENNA__08928__X FPGA_INST.bus2_0\[12\] vssd1 vssd1 vccd1 vccd1 sky130_fd_sc_hd__diode_2
XANTENNA__07551__Y _03806_ vssd1 vssd1 vccd1 vccd1 sky130_fd_sc_hd__diode_2
XANTENNA__05902__A2 net170 vssd1 vssd1 vccd1 vccd1 sky130_fd_sc_hd__diode_2
XFILLER_14_230 vssd1 vssd1 vccd1 vccd1 sky130_fd_sc_hd__fill_1
X_11726_ net903 _01072_ net687 vssd1 vssd1 vccd1 vccd1 FPGA_INST.cell3.SB0.route_sel\[96\]
+ sky130_fd_sc_hd__dfstp_1
XFILLER_9_24 vssd1 vssd1 vccd1 vccd1 sky130_fd_sc_hd__fill_8
XFILLER_14_263 vssd1 vssd1 vccd1 vccd1 sky130_fd_sc_hd__fill_4
XTAP_TAPCELL_ROW_32_729 vssd1 vccd1 sky130_fd_sc_hd__tapvpwrvgnd_1
X_11657_ net893 _01003_ net677 vssd1 vssd1 vccd1 vccd1 FPGA_INST.cell3.SB0.route_sel\[27\]
+ sky130_fd_sc_hd__dfstp_1
XTAP_TAPCELL_ROW_12_453 vssd1 vccd1 sky130_fd_sc_hd__tapvpwrvgnd_1
X_10608_ FPGA_INST.cell3.CB_1.config_dataA\[3\] FPGA_INST.cell3.CB_1.config_dataA\[2\]
+ net375 vssd1 vssd1 vccd1 vccd1 _01487_ sky130_fd_sc_hd__mux2_1
X_11588_ net763 _00938_ net548 vssd1 vssd1 vccd1 vccd1 FPGA_INST.cell0.CB_1.config_dataA\[7\]
+ sky130_fd_sc_hd__dfstp_1
XANTENNA__10721__RESET_B net734 vssd1 vssd1 vccd1 vccd1 sky130_fd_sc_hd__diode_2
X_10539_ FPGA_INST.cell2.SB0.route_sel\[111\] FPGA_INST.cell2.SB0.route_sel\[112\]
+ net242 vssd1 vssd1 vccd1 vccd1 _01418_ sky130_fd_sc_hd__mux2_1
XANTENNA__06343__B _02413_ vssd1 vssd1 vccd1 vccd1 sky130_fd_sc_hd__diode_2
XFILLER_84_417 vssd1 vssd1 vccd1 vccd1 sky130_fd_sc_hd__fill_2
X_07750_ FPGA_INST.cell1.SB0.route_sel\[119\] FPGA_INST.cell1.SB0.route_sel\[118\]
+ _01828_ _03999_ vssd1 vssd1 vccd1 vccd1 _04000_ sky130_fd_sc_hd__a211o_1
XTAP_TAPCELL_ROW_88_1521 vssd1 vccd1 sky130_fd_sc_hd__tapvpwrvgnd_1
XTAP_TAPCELL_ROW_88_1510 vssd1 vccd1 sky130_fd_sc_hd__tapvpwrvgnd_1
X_06701_ _02772_ _02776_ net520 vssd1 vssd1 vccd1 vccd1 _02975_ sky130_fd_sc_hd__mux2_1
X_07681_ _03398_ _03912_ _03932_ vssd1 vssd1 vccd1 vccd1 _03933_ sky130_fd_sc_hd__a21o_1
XANTENNA__07894__A2 FPGA_INST.bus3_1\[2\] vssd1 vssd1 vccd1 vccd1 sky130_fd_sc_hd__diode_2
XANTENNA__07902__B _03889_ vssd1 vssd1 vccd1 vccd1 sky130_fd_sc_hd__diode_2
X_09420_ FPGA_INST.cell2.CB_1.config_dataA\[13\] FPGA_INST.cell2.CB_1.config_dataA\[14\]
+ net265 vssd1 vssd1 vccd1 vccd1 _00333_ sky130_fd_sc_hd__mux2_1
XFILLER_37_377 vssd1 vssd1 vccd1 vccd1 sky130_fd_sc_hd__fill_8
X_06632_ FPGA_INST.cell2.LEI0.config_data\[30\] net129 _02907_ FPGA_INST.cell2.LEI0.config_data\[31\]
+ vssd1 vssd1 vccd1 vccd1 _02908_ sky130_fd_sc_hd__o211a_1
XANTENNA__07190__A FPGA_INST.cell1.CB_0.config_dataB\[24\] vssd1 vssd1 vccd1 vccd1
+ sky130_fd_sc_hd__diode_2
X_09351_ FPGA_INST.cell1.SB0.route_sel\[122\] FPGA_INST.cell1.SB0.route_sel\[123\]
+ net199 vssd1 vssd1 vccd1 vccd1 _00264_ sky130_fd_sc_hd__mux2_1
X_06563_ _01564_ FPGA_INST.cell2.SB0.route_sel\[65\] FPGA_INST.cell2.SB0.route_sel\[70\]
+ _01568_ _02838_ vssd1 vssd1 vccd1 vccd1 _02839_ sky130_fd_sc_hd__a221o_1
XFILLER_100_27 vssd1 vssd1 vccd1 vccd1 sky130_fd_sc_hd__fill_1
X_09282_ FPGA_INST.cell1.SB0.route_sel\[53\] FPGA_INST.cell1.SB0.route_sel\[54\] net207
+ vssd1 vssd1 vccd1 vccd1 _00195_ sky130_fd_sc_hd__mux2_1
X_05514_ FPGA_INST.bus3_2\[8\] vssd1 vssd1 vccd1 vccd1 _01796_ sky130_fd_sc_hd__inv_2
X_08302_ _03797_ _04517_ _04518_ _03759_ _04523_ vssd1 vssd1 vccd1 vccd1 _04524_ sky130_fd_sc_hd__a221o_1
XFILLER_100_38 vssd1 vssd1 vccd1 vccd1 sky130_fd_sc_hd__fill_4
X_08233_ _03959_ _04443_ _04444_ _03923_ _04456_ vssd1 vssd1 vccd1 vccd1 _04457_ sky130_fd_sc_hd__a221o_1
X_06494_ FPGA_INST.cell2.SB0.route_sel\[20\] FPGA_INST.cell2.SB0.route_sel\[21\] vssd1
+ vssd1 vccd1 vccd1 _02770_ sky130_fd_sc_hd__nor2_1
X_05445_ FPGA_INST.cell1.LE_0A.config_data\[16\] vssd1 vssd1 vccd1 vccd1 _01727_ sky130_fd_sc_hd__inv_2
XTAP_TAPCELL_ROW_99_1672 vssd1 vccd1 sky130_fd_sc_hd__tapvpwrvgnd_1
X_05376_ FPGA_INST.cell1.SB0.route_sel\[66\] vssd1 vssd1 vccd1 vccd1 _01658_ sky130_fd_sc_hd__inv_2
X_08164_ net413 _03840_ _04387_ net411 vssd1 vssd1 vccd1 vccd1 _04388_ sky130_fd_sc_hd__o211a_1
XFILLER_119_666 vssd1 vssd1 vccd1 vccd1 sky130_fd_sc_hd__fill_4
X_08095_ FPGA_INST.cell1.CB_0.config_dataB\[12\] _04318_ _04320_ FPGA_INST.cell1.CB_0.config_dataB\[13\]
+ vssd1 vssd1 vccd1 vccd1 _04321_ sky130_fd_sc_hd__o211a_1
X_07115_ FPGA_INST.cell0.LE_0A.config_data\[3\] FPGA_INST.cell0.LE_0A.config_data\[2\]
+ _03313_ vssd1 vssd1 vccd1 vccd1 _03381_ sky130_fd_sc_hd__mux2_1
XFILLER_69_29 vssd1 vssd1 vccd1 vccd1 sky130_fd_sc_hd__fill_2
XANTENNA__06082__A1 FPGA_INST.bus3_2\[3\] vssd1 vssd1 vccd1 vccd1 sky130_fd_sc_hd__diode_2
X_07046_ FPGA_INST.cell0.LEI0.config_data\[2\] _03311_ vssd1 vssd1 vccd1 vccd1 _03312_
+ sky130_fd_sc_hd__nand2b_1
XANTENNA_fanout597_A net604 vssd1 vssd1 vccd1 vccd1 sky130_fd_sc_hd__diode_2
XFILLER_88_701 vssd1 vssd1 vccd1 vccd1 sky130_fd_sc_hd__fill_2
XANTENNA__06621__A3 FPGA_INST.bus3_2\[15\] vssd1 vssd1 vccd1 vccd1 sky130_fd_sc_hd__diode_2
XFILLER_125_57 vssd1 vssd1 vccd1 vccd1 sky130_fd_sc_hd__fill_2
XFILLER_102_544 vccd1 vssd1 vccd1 vssd1 sky130_ef_sc_hd__decap_40_12
X_08997_ _03599_ _03610_ _05171_ net339 vssd1 vssd1 vccd1 vccd1 FPGA_INST.bus1_0\[4\]
+ sky130_fd_sc_hd__a211oi_2
XFILLER_87_266 vssd1 vssd1 vccd1 vccd1 sky130_fd_sc_hd__fill_2
XFILLER_75_417 vssd1 vssd1 vccd1 vccd1 sky130_fd_sc_hd__fill_8
XANTENNA__07084__B _02350_ vssd1 vssd1 vccd1 vccd1 sky130_fd_sc_hd__diode_2
XTAP_TAPCELL_ROW_126_2046 vssd1 vccd1 sky130_fd_sc_hd__tapvpwrvgnd_1
XANTENNA__08895__S _05032_ vssd1 vssd1 vccd1 vccd1 sky130_fd_sc_hd__diode_2
X_07948_ _04168_ _04171_ _04175_ FPGA_INST.cell1.CB_0.config_dataA\[13\] vssd1 vssd1
+ vccd1 vccd1 _04176_ sky130_fd_sc_hd__or4b_1
XFILLER_18_44 vssd1 vssd1 vccd1 vccd1 sky130_fd_sc_hd__fill_1
X_07879_ _03932_ _04082_ _04105_ _04106_ vssd1 vssd1 vccd1 vccd1 _04107_ sky130_fd_sc_hd__a211o_1
XANTENNA_fanout931_A net947 vssd1 vssd1 vccd1 vccd1 sky130_fd_sc_hd__diode_2
X_10890_ net825 _00240_ net609 vssd1 vssd1 vccd1 vccd1 FPGA_INST.cell1.SB0.route_sel\[99\]
+ sky130_fd_sc_hd__dfstp_1
X_09618_ FPGA_INST.cell0.SB0.route_sel\[21\] FPGA_INST.cell0.SB0.route_sel\[22\] net200
+ vssd1 vssd1 vccd1 vccd1 _00527_ sky130_fd_sc_hd__mux2_1
XFILLER_43_325 vssd1 vssd1 vccd1 vccd1 sky130_fd_sc_hd__fill_2
X_09549_ FPGA_INST.cell1.LE_1B.dff1_out net523 _05216_ vssd1 vssd1 vccd1 vccd1 _00458_
+ sky130_fd_sc_hd__a21bo_1
XTAP_TAPCELL_ROW_108_1790 vssd1 vccd1 sky130_fd_sc_hd__tapvpwrvgnd_1
XANTENNA__06428__B _02217_ vssd1 vssd1 vccd1 vccd1 sky130_fd_sc_hd__diode_2
XFILLER_129_408 vssd1 vssd1 vccd1 vccd1 sky130_fd_sc_hd__fill_1
XANTENNA__08834__A1 net19 vssd1 vssd1 vccd1 vccd1 sky130_fd_sc_hd__diode_2
X_11511_ net769 _00861_ net554 vssd1 vssd1 vccd1 vccd1 FPGA_INST.cell0.CB_1.config_dataB\[17\]
+ sky130_fd_sc_hd__dfstp_1
XFILLER_8_705 vssd1 vssd1 vccd1 vccd1 sky130_fd_sc_hd__fill_2
XFILLER_12_778 vssd1 vssd1 vccd1 vccd1 sky130_fd_sc_hd__fill_1
XFILLER_7_215 vssd1 vssd1 vccd1 vccd1 sky130_fd_sc_hd__fill_8
X_11442_ net773 _00792_ net559 vssd1 vssd1 vccd1 vccd1 FPGA_INST.cell0.LE_0A.config_data\[13\]
+ sky130_fd_sc_hd__dfrtp_1
X_11373_ net816 _00723_ net601 vssd1 vssd1 vccd1 vccd1 FPGA_INST.cell1.LE_1B.config_data\[15\]
+ sky130_fd_sc_hd__dfrtp_1
XTAP_TAPCELL_ROW_59_1111 vssd1 vccd1 sky130_fd_sc_hd__tapvpwrvgnd_1
X_10324_ FPGA_INST.cell3.LEI0.config_data\[38\] FPGA_INST.cell3.LEI0.config_data\[39\]
+ net298 vssd1 vssd1 vccd1 vccd1 _01205_ sky130_fd_sc_hd__mux2_1
XANTENNA__07827__X net55 vssd1 vssd1 vccd1 vccd1 sky130_fd_sc_hd__diode_2
XFILLER_98_509 vssd1 vssd1 vccd1 vccd1 sky130_fd_sc_hd__fill_2
XANTENNA__09011__B2 FPGA_INST.cell3.SB0.route_sel\[31\] vssd1 vssd1 vccd1 vccd1 sky130_fd_sc_hd__diode_2
XFILLER_59_62 vssd1 vssd1 vccd1 vccd1 sky130_fd_sc_hd__fill_1
XFILLER_59_40 vssd1 vssd1 vccd1 vccd1 sky130_fd_sc_hd__fill_1
X_10255_ FPGA_INST.io_south_oeb\[30\] FPGA_INST.io_east_oeb\[0\] net264 vssd1 vssd1
+ vccd1 vccd1 _01136_ sky130_fd_sc_hd__mux2_1
XANTENNA__05820__A1 net165 vssd1 vssd1 vccd1 vccd1 sky130_fd_sc_hd__diode_2
X_10186_ FPGA_INST.cell3.SB0.route_sel\[90\] FPGA_INST.cell3.SB0.route_sel\[91\] net275
+ vssd1 vssd1 vccd1 vccd1 _01067_ sky130_fd_sc_hd__mux2_1
XFILLER_120_374 vccd1 vssd1 vccd1 vssd1 sky130_ef_sc_hd__decap_40_12
Xfanout290 net291 vssd1 vssd1 vccd1 vccd1 net290 sky130_fd_sc_hd__clkbuf_4
XANTENNA__07281__Y _03542_ vssd1 vssd1 vccd1 vccd1 sky130_fd_sc_hd__diode_2
XTAP_TAPCELL_ROW_83_1440 vssd1 vccd1 sky130_fd_sc_hd__tapvpwrvgnd_1
XTAP_TAPCELL_ROW_17_523 vssd1 vccd1 sky130_fd_sc_hd__tapvpwrvgnd_1
XTAP_TAPCELL_ROW_83_1451 vssd1 vccd1 sky130_fd_sc_hd__tapvpwrvgnd_1
XANTENNA__06836__A0 FPGA_INST.bus2_0\[2\] vssd1 vssd1 vccd1 vccd1 sky130_fd_sc_hd__diode_2
XFILLER_30_531 vssd1 vssd1 vccd1 vccd1 sky130_fd_sc_hd__fill_1
X_11709_ net919 _01055_ net703 vssd1 vssd1 vccd1 vccd1 FPGA_INST.cell3.SB0.route_sel\[79\]
+ sky130_fd_sc_hd__dfstp_1
XANTENNA__06851__A3 FPGA_INST.bus2_0\[11\] vssd1 vssd1 vccd1 vccd1 sky130_fd_sc_hd__diode_2
XFILLER_115_113 vssd1 vssd1 vccd1 vccd1 sky130_fd_sc_hd__fill_1
XANTENNA__08053__A2 _03854_ vssd1 vssd1 vccd1 vccd1 sky130_fd_sc_hd__diode_2
XANTENNA__06064__A1 net171 vssd1 vssd1 vccd1 vccd1 sky130_fd_sc_hd__diode_2
X_08920_ FPGA_INST.cell3.SB0.route_sel\[110\] FPGA_INST.cell3.SB0.route_sel\[111\]
+ vssd1 vssd1 vccd1 vccd1 _05120_ sky130_fd_sc_hd__nor2_1
X_08851_ _01662_ FPGA_INST.cell3.CB_0.config_dataB\[12\] _05037_ FPGA_INST.cell3.CB_0.config_dataB\[13\]
+ vssd1 vssd1 vccd1 vccd1 _05058_ sky130_fd_sc_hd__or4b_1
XFILLER_97_553 vssd1 vssd1 vccd1 vccd1 sky130_fd_sc_hd__fill_1
XANTENNA__07564__A1 net83 vssd1 vssd1 vccd1 vccd1 sky130_fd_sc_hd__diode_2
X_07802_ FPGA_INST.cell3.SB0.route_sel\[125\] FPGA_INST.cell3.SB0.route_sel\[124\]
+ vssd1 vssd1 vccd1 vccd1 _04051_ sky130_fd_sc_hd__nand2_1
X_08782_ net389 _04986_ _04987_ _04988_ vssd1 vssd1 vccd1 vccd1 _04989_ sky130_fd_sc_hd__a31o_1
X_05994_ FPGA_INST.cell2.SB0.route_sel\[34\] FPGA_INST.cell2.SB0.route_sel\[35\] vssd1
+ vssd1 vccd1 vccd1 _02274_ sky130_fd_sc_hd__nand2_1
XFILLER_84_269 vssd1 vssd1 vccd1 vccd1 sky130_fd_sc_hd__fill_1
X_07733_ FPGA_INST.cell3.SB0.route_sel\[112\] FPGA_INST.cell3.SB0.route_sel\[113\]
+ vssd1 vssd1 vccd1 vccd1 _03983_ sky130_fd_sc_hd__nand2_1
XANTENNA__07867__A2 _03854_ vssd1 vssd1 vccd1 vccd1 sky130_fd_sc_hd__diode_2
X_07664_ net153 _03395_ _03911_ vssd1 vssd1 vccd1 vccd1 _03916_ sky130_fd_sc_hd__nor3_1
XFILLER_111_15 vccd1 vssd1 vccd1 vssd1 sky130_ef_sc_hd__decap_40_12
X_06615_ FPGA_INST.cell2.CB_1.config_dataA\[12\] _02885_ _02888_ _02890_ vssd1 vssd1
+ vccd1 vccd1 _02891_ sky130_fd_sc_hd__o211a_1
X_09403_ FPGA_INST.cell2.CB_0.config_dataB\[21\] net486 net240 vssd1 vssd1 vccd1 vccd1
+ _00316_ sky130_fd_sc_hd__mux2_1
XFILLER_37_185 vssd1 vssd1 vccd1 vccd1 sky130_fd_sc_hd__fill_2
XANTENNA_fanout345_A net349 vssd1 vssd1 vccd1 vccd1 sky130_fd_sc_hd__diode_2
X_07595_ _03834_ _03848_ _03847_ vssd1 vssd1 vccd1 vccd1 _03849_ sky130_fd_sc_hd__o21ai_2
XFILLER_80_486 vssd1 vssd1 vccd1 vccd1 sky130_fd_sc_hd__fill_2
X_09334_ FPGA_INST.cell1.SB0.route_sel\[106\] FPGA_INST.cell1.SB0.route_sel\[105\]
+ net338 vssd1 vssd1 vccd1 vccd1 _00247_ sky130_fd_sc_hd__mux2_1
X_06546_ _01580_ FPGA_INST.cell2.SB0.route_sel\[105\] FPGA_INST.cell2.SB0.route_sel\[110\]
+ _01581_ _02821_ vssd1 vssd1 vccd1 vccd1 _02822_ sky130_fd_sc_hd__a221o_1
XFILLER_33_391 vssd1 vssd1 vccd1 vccd1 sky130_fd_sc_hd__fill_1
X_09265_ FPGA_INST.cell1.SB0.route_sel\[36\] FPGA_INST.cell1.SB0.route_sel\[37\] net209
+ vssd1 vssd1 vccd1 vccd1 _00178_ sky130_fd_sc_hd__mux2_1
XANTENNA_fanout133_X net133 vssd1 vssd1 vccd1 vccd1 sky130_fd_sc_hd__diode_2
X_06477_ _01545_ _02753_ _02754_ _01542_ vssd1 vssd1 vccd1 vccd1 _02755_ sky130_fd_sc_hd__a22o_1
X_05428_ FPGA_INST.cell3.SB0.route_sel\[9\] vssd1 vssd1 vccd1 vccd1 _01710_ sky130_fd_sc_hd__inv_2
X_09196_ FPGA_INST.cell2.LE_1A.config_data\[13\] FPGA_INST.cell2.LE_1A.config_data\[14\]
+ net264 vssd1 vssd1 vccd1 vccd1 _00109_ sky130_fd_sc_hd__mux2_1
X_08216_ _01753_ _04439_ _04438_ _04437_ vssd1 vssd1 vccd1 vccd1 _04440_ sky130_fd_sc_hd__a211o_1
XANTENNA_fanout300_X net300 vssd1 vssd1 vccd1 vccd1 sky130_fd_sc_hd__diode_2
X_08147_ _04372_ _04371_ _04262_ vssd1 vssd1 vccd1 vccd1 _04373_ sky130_fd_sc_hd__mux2_1
XANTENNA__08750__Y _04959_ vssd1 vssd1 vccd1 vccd1 sky130_fd_sc_hd__diode_2
XANTENNA__08044__A2 FPGA_INST.bus3_1\[6\] vssd1 vssd1 vccd1 vccd1 sky130_fd_sc_hd__diode_2
X_05359_ FPGA_INST.cell3.SB0.route_sel\[84\] vssd1 vssd1 vccd1 vccd1 _01641_ sky130_fd_sc_hd__inv_2
X_08078_ FPGA_INST.bus3_1\[0\] FPGA_INST.bus3_1\[1\] FPGA_INST.bus3_1\[2\] FPGA_INST.bus3_1\[3\]
+ net454 net453 vssd1 vssd1 vccd1 vccd1 _04304_ sky130_fd_sc_hd__mux4_1
XFILLER_0_413 vssd1 vssd1 vccd1 vccd1 sky130_fd_sc_hd__fill_4
X_07029_ net436 _02233_ net435 vssd1 vssd1 vccd1 vccd1 _03295_ sky130_fd_sc_hd__o21ai_1
XFILLER_96_27 vssd1 vssd1 vccd1 vccd1 sky130_fd_sc_hd__fill_1
XFILLER_88_531 vssd1 vssd1 vccd1 vccd1 sky130_fd_sc_hd__fill_1
XTAP_TAPCELL_ROW_54_1041 vssd1 vccd1 sky130_fd_sc_hd__tapvpwrvgnd_1
X_10040_ FPGA_INST.cell0.CB_0.config_dataB\[14\] net416 net190 vssd1 vssd1 vccd1 vccd1
+ _00921_ sky130_fd_sc_hd__mux2_1
XFILLER_102_363 vssd1 vssd1 vccd1 vccd1 sky130_fd_sc_hd__fill_1
XFILLER_88_564 vssd1 vssd1 vccd1 vccd1 sky130_fd_sc_hd__fill_1
XFILLER_48_417 vssd1 vssd1 vccd1 vccd1 sky130_fd_sc_hd__fill_2
XFILLER_75_225 vssd1 vssd1 vccd1 vccd1 sky130_fd_sc_hd__fill_2
XFILLER_29_631 vssd1 vssd1 vccd1 vccd1 sky130_fd_sc_hd__fill_2
XANTENNA__09514__S net233 vssd1 vssd1 vccd1 vccd1 sky130_fd_sc_hd__diode_2
X_11991_ net774 _01337_ net560 vssd1 vssd1 vccd1 vccd1 FPGA_INST.cell2.SB0.route_sel\[31\]
+ sky130_fd_sc_hd__dfstp_1
XFILLER_91_729 vssd1 vssd1 vccd1 vccd1 sky130_fd_sc_hd__fill_4
X_10942_ net848 _00292_ net633 vssd1 vssd1 vccd1 vccd1 FPGA_INST.cell2.CB_0.config_dataA\[23\]
+ sky130_fd_sc_hd__dfstp_1
XANTENNA__07858__A2 FPGA_INST.bus3_1\[2\] vssd1 vssd1 vccd1 vccd1 sky130_fd_sc_hd__diode_2
XFILLER_71_420 vssd1 vssd1 vccd1 vccd1 sky130_fd_sc_hd__fill_4
XFILLER_43_111 vssd1 vssd1 vccd1 vccd1 sky130_fd_sc_hd__fill_1
X_10873_ net793 _00223_ net578 vssd1 vssd1 vccd1 vccd1 FPGA_INST.cell1.SB0.route_sel\[82\]
+ sky130_fd_sc_hd__dfstp_1
XFILLER_43_166 vssd1 vssd1 vccd1 vccd1 sky130_fd_sc_hd__fill_2
XTAP_TAPCELL_ROW_65_1192 vssd1 vccd1 sky130_fd_sc_hd__tapvpwrvgnd_1
XTAP_TAPCELL_ROW_42_868 vssd1 vccd1 sky130_fd_sc_hd__tapvpwrvgnd_1
XANTENNA__08373__B _03720_ vssd1 vssd1 vccd1 vccd1 sky130_fd_sc_hd__diode_2
XFILLER_8_535 vssd1 vssd1 vccd1 vccd1 sky130_fd_sc_hd__fill_1
XFILLER_12_586 vssd1 vssd1 vccd1 vccd1 sky130_fd_sc_hd__fill_2
XTAP_TAPCELL_ROW_22_592 vssd1 vccd1 sky130_fd_sc_hd__tapvpwrvgnd_1
X_11425_ net755 _00775_ net540 vssd1 vssd1 vccd1 vccd1 FPGA_INST.cell0.LEI0.config_data\[46\]
+ sky130_fd_sc_hd__dfrtp_1
X_11356_ net825 _00706_ net609 vssd1 vssd1 vccd1 vccd1 FPGA_INST.cell1.CB_1.config_dataA\[23\]
+ sky130_fd_sc_hd__dfstp_2
X_10307_ FPGA_INST.cell3.LEI0.config_data\[21\] FPGA_INST.cell3.LEI0.config_data\[22\]
+ net283 vssd1 vssd1 vccd1 vccd1 _01188_ sky130_fd_sc_hd__mux2_1
X_11287_ net833 _00637_ net617 vssd1 vssd1 vccd1 vccd1 FPGA_INST.cell1.CB_0.config_dataA\[4\]
+ sky130_fd_sc_hd__dfstp_1
XFILLER_79_542 vssd1 vssd1 vccd1 vccd1 sky130_fd_sc_hd__fill_1
X_10238_ FPGA_INST.io_west_oeb\[28\] FPGA_INST.io_west_oeb\[30\] net292 vssd1 vssd1
+ vccd1 vccd1 _01119_ sky130_fd_sc_hd__mux2_1
XANTENNA__07546__A1 net148 vssd1 vssd1 vccd1 vccd1 sky130_fd_sc_hd__diode_2
XFILLER_79_553 vssd1 vssd1 vccd1 vccd1 sky130_fd_sc_hd__fill_2
XFILLER_94_523 vssd1 vssd1 vccd1 vccd1 sky130_fd_sc_hd__fill_2
XFILLER_86_82 vssd1 vssd1 vccd1 vccd1 sky130_fd_sc_hd__fill_2
X_10169_ FPGA_INST.cell3.SB0.route_sel\[73\] FPGA_INST.cell3.SB0.route_sel\[74\] net275
+ vssd1 vssd1 vccd1 vccd1 _01050_ sky130_fd_sc_hd__mux2_1
XFILLER_54_409 vssd1 vssd1 vccd1 vccd1 sky130_fd_sc_hd__fill_2
XANTENNA__09424__S net354 vssd1 vssd1 vccd1 vccd1 sky130_fd_sc_hd__diode_2
XFILLER_94_589 vssd1 vssd1 vccd1 vccd1 sky130_fd_sc_hd__fill_1
XFILLER_81_239 vssd1 vssd1 vccd1 vccd1 sky130_fd_sc_hd__fill_1
XFILLER_19_185 vssd1 vssd1 vccd1 vccd1 sky130_fd_sc_hd__fill_2
X_06400_ _02676_ _02677_ FPGA_INST.cell2.CB_0.config_dataB\[2\] vssd1 vssd1 vccd1
+ vccd1 _02678_ sky130_fd_sc_hd__or3b_1
X_07380_ _03636_ _03637_ _03638_ _02306_ vssd1 vssd1 vccd1 vccd1 _03639_ sky130_fd_sc_hd__a31o_4
X_06331_ FPGA_INST.cell2.LE_0A.config_data\[13\] FPGA_INST.cell2.LE_0A.config_data\[12\]
+ _02536_ vssd1 vssd1 vccd1 vccd1 _02611_ sky130_fd_sc_hd__mux2_1
XANTENNA__07482__A0 net94 vssd1 vssd1 vccd1 vccd1 sky130_fd_sc_hd__diode_2
X_06262_ _02131_ _02540_ _02541_ _02168_ FPGA_INST.cell2.CB_0.config_dataA\[12\] vssd1
+ vssd1 vccd1 vccd1 _02542_ sky130_fd_sc_hd__a221o_1
XANTENNA__06285__A1 net6 vssd1 vssd1 vccd1 vccd1 sky130_fd_sc_hd__diode_2
XANTENNA__06285__B2 net5 vssd1 vssd1 vccd1 vccd1 sky130_fd_sc_hd__diode_2
X_09050_ net526 FPGA_INST.cell0.LE_0B.reset_mode vssd1 vssd1 vccd1 vccd1 _09050_/X
+ sky130_fd_sc_hd__xor2_2
XFILLER_30_361 vssd1 vssd1 vccd1 vccd1 sky130_fd_sc_hd__fill_1
X_08001_ _04217_ _04228_ vssd1 vssd1 vccd1 vccd1 _04229_ sky130_fd_sc_hd__and2b_1
XTAP_TAPCELL_ROW_96_1620 vssd1 vccd1 sky130_fd_sc_hd__tapvpwrvgnd_1
XANTENNA__11698__Q FPGA_INST.cell3.SB0.route_sel\[68\] vssd1 vssd1 vccd1 vccd1 sky130_fd_sc_hd__diode_2
XFILLER_129_783 vssd1 vssd1 vccd1 vccd1 sky130_fd_sc_hd__fill_1
XTAP_TAPCELL_ROW_96_1631 vssd1 vccd1 sky130_fd_sc_hd__tapvpwrvgnd_1
X_06193_ net100 _01942_ _02356_ vssd1 vssd1 vccd1 vccd1 _02473_ sky130_fd_sc_hd__and3_1
XFILLER_116_444 vssd1 vssd1 vccd1 vccd1 sky130_fd_sc_hd__fill_1
XANTENNA__06588__A2 _02772_ vssd1 vssd1 vccd1 vccd1 sky130_fd_sc_hd__diode_2
X_09952_ FPGA_INST.cell0.CB_1.config_dataB\[13\] FPGA_INST.cell0.CB_1.config_dataB\[12\]
+ net311 vssd1 vssd1 vccd1 vccd1 _00857_ sky130_fd_sc_hd__mux2_1
X_08903_ _01780_ FPGA_INST.cell3.LE_0B.dff_out vssd1 vssd1 vccd1 vccd1 _05109_ sky130_fd_sc_hd__or2_1
XANTENNA__09526__A2 net523 vssd1 vssd1 vccd1 vccd1 sky130_fd_sc_hd__diode_2
XFILLER_89_339 vssd1 vssd1 vccd1 vccd1 sky130_fd_sc_hd__fill_8
XANTENNA__07119__S _03313_ vssd1 vssd1 vccd1 vccd1 sky130_fd_sc_hd__diode_2
XFILLER_106_37 vssd1 vssd1 vccd1 vccd1 sky130_fd_sc_hd__fill_1
XANTENNA_fanout295_A net306 vssd1 vssd1 vccd1 vccd1 sky130_fd_sc_hd__diode_2
XFILLER_97_350 vssd1 vssd1 vccd1 vccd1 sky130_fd_sc_hd__fill_4
X_09883_ FPGA_INST.cell0.LE_0A.config_data\[11\] FPGA_INST.cell0.LE_0A.config_data\[10\]
+ net318 vssd1 vssd1 vccd1 vccd1 _00790_ sky130_fd_sc_hd__mux2_1
XFILLER_111_182 vssd1 vssd1 vccd1 vccd1 sky130_fd_sc_hd__fill_2
XFILLER_111_171 vssd1 vssd1 vccd1 vccd1 sky130_fd_sc_hd__fill_2
X_08834_ net18 net19 net20 net21 net388 FPGA_INST.cell3.CB_0.config_dataB\[11\] vssd1
+ vssd1 vccd1 vccd1 _05041_ sky130_fd_sc_hd__mux4_1
X_08765_ FPGA_INST.cell3.LE_0A.config_data\[16\] _04971_ _04972_ net156 vssd1 vssd1
+ vccd1 vccd1 FPGA_INST.cell3.CB_0.le_outA sky130_fd_sc_hd__o211a_1
XTAP_TAPCELL_ROW_123_2005 vssd1 vccd1 sky130_fd_sc_hd__tapvpwrvgnd_1
X_07716_ net153 _03953_ vssd1 vssd1 vccd1 vccd1 _03967_ sky130_fd_sc_hd__nor2_1
XANTENNA__06760__A2 FPGA_INST.bus3_2\[2\] vssd1 vssd1 vccd1 vccd1 sky130_fd_sc_hd__diode_2
XFILLER_26_612 vssd1 vssd1 vccd1 vccd1 sky130_fd_sc_hd__fill_1
X_05977_ net120 net168 net160 _02174_ _01918_ vssd1 vssd1 vccd1 vccd1 _02257_ sky130_fd_sc_hd__o32ai_2
XFILLER_122_58 vssd1 vssd1 vccd1 vccd1 sky130_fd_sc_hd__fill_4
X_08696_ FPGA_INST.cell3.CB_0.config_dataA\[12\] _04903_ _04904_ _04894_ _04898_ vssd1
+ vssd1 vccd1 vccd1 _04905_ sky130_fd_sc_hd__a32o_1
XFILLER_82_29 vccd1 vssd1 vccd1 vssd1 sky130_ef_sc_hd__decap_40_12
XFILLER_53_431 vssd1 vssd1 vccd1 vccd1 sky130_fd_sc_hd__fill_8
XFILLER_25_111 vssd1 vssd1 vccd1 vccd1 sky130_fd_sc_hd__fill_1
XANTENNA_fanout348_X net348 vssd1 vssd1 vccd1 vccd1 sky130_fd_sc_hd__diode_2
XANTENNA_fanout727_A net729 vssd1 vssd1 vccd1 vccd1 sky130_fd_sc_hd__diode_2
X_07647_ FPGA_INST.cell3.SB0.route_sel\[90\] FPGA_INST.cell3.SB0.route_sel\[91\] _03891_
+ _03896_ _03898_ vssd1 vssd1 vccd1 vccd1 _03900_ sky130_fd_sc_hd__a41o_1
XANTENNA__06512__A2 FPGA_INST.bus3_2\[2\] vssd1 vssd1 vccd1 vccd1 sky130_fd_sc_hd__diode_2
XTAP_TAPCELL_ROW_0_265 vssd1 vccd1 sky130_fd_sc_hd__tapvpwrvgnd_1
XTAP_TAPCELL_ROW_0_276 vssd1 vccd1 sky130_fd_sc_hd__tapvpwrvgnd_1
XTAP_TAPCELL_ROW_0_287 vssd1 vccd1 sky130_fd_sc_hd__tapvpwrvgnd_1
XFILLER_26_689 vssd1 vssd1 vccd1 vccd1 sky130_fd_sc_hd__fill_1
X_07578_ _03496_ _03745_ vssd1 vssd1 vccd1 vccd1 _03832_ sky130_fd_sc_hd__or2_1
XFILLER_81_795 vssd1 vssd1 vccd1 vccd1 sky130_fd_sc_hd__fill_4
X_09317_ FPGA_INST.cell1.SB0.route_sel\[88\] FPGA_INST.cell1.SB0.route_sel\[89\] net208
+ vssd1 vssd1 vccd1 vccd1 _00230_ sky130_fd_sc_hd__mux2_1
X_06529_ _02785_ _02801_ _02804_ _02781_ _01590_ vssd1 vssd1 vccd1 vccd1 _02805_ sky130_fd_sc_hd__a221o_1
XANTENNA__06276__A1 _02330_ vssd1 vssd1 vccd1 vccd1 sky130_fd_sc_hd__diode_2
X_09248_ FPGA_INST.cell1.SB0.route_sel\[19\] FPGA_INST.cell1.SB0.route_sel\[20\] net224
+ vssd1 vssd1 vccd1 vccd1 _00161_ sky130_fd_sc_hd__mux2_1
XANTENNA__06276__B2 _02293_ vssd1 vssd1 vccd1 vccd1 sky130_fd_sc_hd__diode_2
XFILLER_126_219 vssd1 vssd1 vccd1 vccd1 sky130_fd_sc_hd__fill_4
X_09179_ FPGA_INST.cell2.LE_1A.dff0_out net524 _05211_ vssd1 vssd1 vccd1 vccd1 _00093_
+ sky130_fd_sc_hd__a21bo_1
XFILLER_31_55 vssd1 vssd1 vccd1 vccd1 sky130_fd_sc_hd__fill_1
X_11210_ net755 _00560_ net540 vssd1 vssd1 vccd1 vccd1 FPGA_INST.cell0.SB0.route_sel\[55\]
+ sky130_fd_sc_hd__dfstp_1
X_11141_ net808 _00491_ net594 vssd1 vssd1 vccd1 vccd1 FPGA_INST.cell1.CB_1.config_dataB\[11\]
+ sky130_fd_sc_hd__dfstp_1
XFILLER_103_3 vssd1 vssd1 vccd1 vccd1 sky130_fd_sc_hd__fill_4
Xoutput33 net33 vssd1 vssd1 vccd1 vccd1 gpio_oeb[13] sky130_fd_sc_hd__buf_2
Xoutput66 net66 vssd1 vssd1 vccd1 vccd1 gpio_out[31] sky130_fd_sc_hd__buf_2
XFILLER_122_436 vssd1 vssd1 vccd1 vccd1 sky130_fd_sc_hd__fill_8
XFILLER_122_425 vssd1 vssd1 vccd1 vccd1 sky130_fd_sc_hd__fill_2
XFILLER_0_221 vssd1 vssd1 vccd1 vccd1 sky130_fd_sc_hd__fill_2
Xoutput55 net55 vssd1 vssd1 vccd1 vccd1 gpio_out[20] sky130_fd_sc_hd__buf_2
Xoutput44 net44 vssd1 vssd1 vccd1 vccd1 gpio_oeb[9] sky130_fd_sc_hd__buf_2
X_11072_ net839 _00422_ net623 vssd1 vssd1 vccd1 vccd1 FPGA_INST.cell1.LE_0A.config_data\[7\]
+ sky130_fd_sc_hd__dfrtp_1
XANTENNA__08725__A0 net25 vssd1 vssd1 vccd1 vccd1 sky130_fd_sc_hd__diode_2
XTAP_TAPCELL_ROW_8_398 vssd1 vccd1 sky130_fd_sc_hd__tapvpwrvgnd_1
X_10023_ FPGA_INST.cell0.CB_0.config_dataA\[23\] FPGA_INST.cell0.CB_0.config_dataA\[22\]
+ net317 vssd1 vssd1 vccd1 vccd1 _00904_ sky130_fd_sc_hd__mux2_1
XFILLER_48_247 vssd1 vssd1 vccd1 vccd1 sky130_fd_sc_hd__fill_2
XANTENNA_input23_A gpio_in[2] vssd1 vssd1 vccd1 vccd1 sky130_fd_sc_hd__diode_2
XFILLER_76_589 vssd1 vssd1 vccd1 vccd1 sky130_fd_sc_hd__fill_1
XFILLER_63_217 vssd1 vssd1 vccd1 vccd1 sky130_fd_sc_hd__fill_1
XTAP_TAPCELL_ROW_47_938 vssd1 vccd1 sky130_fd_sc_hd__tapvpwrvgnd_1
XFILLER_91_559 vssd1 vssd1 vccd1 vccd1 sky130_fd_sc_hd__fill_1
XTAP_TAPCELL_ROW_67_1221 vssd1 vccd1 sky130_fd_sc_hd__tapvpwrvgnd_1
X_11974_ net845 _01320_ net630 vssd1 vssd1 vccd1 vccd1 FPGA_INST.cell2.SB0.route_sel\[14\]
+ sky130_fd_sc_hd__dfstp_1
XANTENNA__07700__A1 net133 vssd1 vssd1 vccd1 vccd1 sky130_fd_sc_hd__diode_2
XANTENNA__07161__C1 _02472_ vssd1 vssd1 vccd1 vccd1 sky130_fd_sc_hd__diode_2
XFILLER_44_475 vssd1 vssd1 vccd1 vccd1 sky130_fd_sc_hd__fill_1
XFILLER_44_464 vssd1 vssd1 vccd1 vccd1 sky130_fd_sc_hd__fill_1
XFILLER_44_442 vssd1 vssd1 vccd1 vccd1 sky130_fd_sc_hd__fill_4
X_10925_ net851 _00275_ net636 vssd1 vssd1 vccd1 vccd1 FPGA_INST.cell2.CB_0.config_dataA\[6\]
+ sky130_fd_sc_hd__dfstp_1
XTAP_TAPCELL_ROW_27_662 vssd1 vccd1 sky130_fd_sc_hd__tapvpwrvgnd_1
X_10856_ net824 _00206_ net608 vssd1 vssd1 vccd1 vccd1 FPGA_INST.cell1.SB0.route_sel\[65\]
+ sky130_fd_sc_hd__dfstp_1
XFILLER_72_795 vssd1 vssd1 vccd1 vccd1 sky130_fd_sc_hd__fill_4
XANTENNA__08256__A2 FPGA_INST.bus1_0\[14\] vssd1 vssd1 vccd1 vccd1 sky130_fd_sc_hd__diode_2
X_10787_ net856 _00137_ net641 vssd1 vssd1 vccd1 vccd1 FPGA_INST.cell2.CB_1.config_dataB\[21\]
+ sky130_fd_sc_hd__dfstp_1
XANTENNA__06616__B _02832_ vssd1 vssd1 vccd1 vccd1 sky130_fd_sc_hd__diode_2
XFILLER_8_321 vssd1 vssd1 vccd1 vccd1 sky130_fd_sc_hd__fill_1
XFILLER_12_350 vssd1 vssd1 vccd1 vccd1 sky130_fd_sc_hd__fill_2
XFILLER_8_354 vssd1 vssd1 vccd1 vccd1 sky130_fd_sc_hd__fill_1
XTAP_TAPCELL_ROW_78_1372 vssd1 vccd1 sky130_fd_sc_hd__tapvpwrvgnd_1
X_11408_ net750 _00758_ net535 vssd1 vssd1 vccd1 vccd1 FPGA_INST.cell0.LEI0.config_data\[29\]
+ sky130_fd_sc_hd__dfrtp_1
XANTENNA__08413__C1 _04631_ vssd1 vssd1 vccd1 vccd1 sky130_fd_sc_hd__diode_2
XFILLER_99_615 vssd1 vssd1 vccd1 vccd1 sky130_fd_sc_hd__fill_1
XFILLER_113_447 vssd1 vssd1 vccd1 vccd1 sky130_fd_sc_hd__fill_1
XFILLER_113_436 vssd1 vssd1 vccd1 vccd1 sky130_fd_sc_hd__fill_2
X_11339_ net805 _00689_ net590 vssd1 vssd1 vccd1 vccd1 FPGA_INST.cell1.CB_1.config_dataA\[6\]
+ sky130_fd_sc_hd__dfstp_1
XTAP_TAPCELL_ROW_91_1550 vssd1 vccd1 sky130_fd_sc_hd__tapvpwrvgnd_1
XTAP_TAPCELL_ROW_91_1561 vssd1 vccd1 sky130_fd_sc_hd__tapvpwrvgnd_1
XFILLER_79_361 vssd1 vssd1 vccd1 vccd1 sky130_fd_sc_hd__fill_4
XFILLER_67_501 vssd1 vssd1 vccd1 vccd1 sky130_fd_sc_hd__fill_1
X_05900_ net170 _02178_ FPGA_INST.bus1_0\[7\] vssd1 vssd1 vccd1 vccd1 _02180_ sky130_fd_sc_hd__o21ai_1
X_06880_ FPGA_INST.cell0.CB_0.config_dataB\[1\] _03147_ vssd1 vssd1 vccd1 vccd1 _03148_
+ sky130_fd_sc_hd__and2_1
XFILLER_94_331 vccd1 vssd1 vccd1 vssd1 sky130_ef_sc_hd__decap_40_12
X_05831_ net166 net162 _02106_ _02108_ vssd1 vssd1 vccd1 vccd1 _02111_ sky130_fd_sc_hd__o22a_1
XANTENNA__09154__S net358 vssd1 vssd1 vccd1 vccd1 sky130_fd_sc_hd__diode_2
XFILLER_55_729 vssd1 vssd1 vccd1 vccd1 sky130_fd_sc_hd__fill_4
XFILLER_55_718 vssd1 vssd1 vccd1 vccd1 sky130_fd_sc_hd__fill_1
XFILLER_27_409 vssd1 vssd1 vccd1 vccd1 sky130_fd_sc_hd__fill_1
X_08550_ _04760_ _04756_ _04751_ vssd1 vssd1 vccd1 vccd1 _04761_ sky130_fd_sc_hd__mux2_1
X_05762_ _01800_ _02038_ _02041_ vssd1 vssd1 vccd1 vccd1 _02042_ sky130_fd_sc_hd__o21ai_1
X_08481_ FPGA_INST.cell1.CB_1.config_dataB\[14\] _04695_ _04696_ vssd1 vssd1 vccd1
+ vccd1 _04697_ sky130_fd_sc_hd__and3_1
XFILLER_63_773 vssd1 vssd1 vccd1 vccd1 sky130_fd_sc_hd__fill_2
X_05693_ net382 net165 vssd1 vssd1 vccd1 vccd1 _01973_ sky130_fd_sc_hd__nor2_1
X_07501_ FPGA_INST.cell0.SB0.route_sel\[64\] FPGA_INST.cell0.SB0.route_sel\[65\] vssd1
+ vssd1 vccd1 vccd1 _03757_ sky130_fd_sc_hd__nand2b_1
X_07432_ _03677_ _03687_ _03689_ net331 vssd1 vssd1 vccd1 vccd1 _03690_ sky130_fd_sc_hd__a211o_4
XFILLER_23_626 vssd1 vssd1 vccd1 vccd1 sky130_fd_sc_hd__fill_2
XFILLER_35_486 vssd1 vssd1 vccd1 vccd1 sky130_fd_sc_hd__fill_1
X_07363_ _03437_ _03622_ vssd1 vssd1 vccd1 vccd1 _03623_ sky130_fd_sc_hd__nor2_1
X_09102_ FPGA_INST.cell2.LEI0.config_data\[16\] FPGA_INST.cell2.LEI0.config_data\[17\]
+ net250 vssd1 vssd1 vccd1 vccd1 _00018_ sky130_fd_sc_hd__mux2_1
XANTENNA__07455__B1 FPGA_INST.bus3_1\[7\] vssd1 vssd1 vccd1 vccd1 sky130_fd_sc_hd__diode_2
X_07294_ _03551_ _03552_ _03553_ _03554_ vssd1 vssd1 vccd1 vccd1 _03555_ sky130_fd_sc_hd__o211a_1
X_06314_ net3 net4 net500 vssd1 vssd1 vccd1 vccd1 _02594_ sky130_fd_sc_hd__mux2_1
X_09033_ _03415_ _03418_ _05195_ net339 vssd1 vssd1 vccd1 vccd1 FPGA_INST.bus1_0\[0\]
+ sky130_fd_sc_hd__a211oi_2
X_06245_ net509 _01869_ _02524_ FPGA_INST.cell2.CB_0.config_dataA\[1\] vssd1 vssd1
+ vccd1 vccd1 _02525_ sky130_fd_sc_hd__o211a_1
XPHY_EDGE_ROW_107_Left_238 vssd1 vssd1 vccd1 vccd1 sky130_fd_sc_hd__decap_3
XANTENNA__07207__A0 net150 vssd1 vssd1 vccd1 vccd1 sky130_fd_sc_hd__diode_2
X_06176_ net97 _01924_ net157 _02340_ _01927_ vssd1 vssd1 vccd1 vccd1 _02456_ sky130_fd_sc_hd__o32a_1
XANTENNA_fanout308_A net315 vssd1 vssd1 vccd1 vccd1 sky130_fd_sc_hd__diode_2
XFILLER_117_797 vssd1 vssd1 vccd1 vccd1 sky130_fd_sc_hd__fill_2
Xfanout834 net837 vssd1 vssd1 vccd1 vccd1 net834 sky130_fd_sc_hd__clkbuf_2
Xfanout812 net820 vssd1 vssd1 vccd1 vccd1 net812 sky130_fd_sc_hd__clkbuf_2
Xfanout801 net802 vssd1 vssd1 vccd1 vccd1 net801 sky130_fd_sc_hd__clkbuf_2
Xfanout823 net826 vssd1 vssd1 vccd1 vccd1 net823 sky130_fd_sc_hd__clkbuf_2
XTAP_TAPCELL_ROW_51_1000 vssd1 vccd1 sky130_fd_sc_hd__tapvpwrvgnd_1
XANTENNA__06430__A1 _02330_ vssd1 vssd1 vccd1 vccd1 sky130_fd_sc_hd__diode_2
XANTENNA__06430__B2 _02293_ vssd1 vssd1 vccd1 vccd1 sky130_fd_sc_hd__diode_2
X_09935_ FPGA_INST.cell0.LE_1A.config_data\[16\] FPGA_INST.cell0.LE_1A.edge_mode net175
+ vssd1 vssd1 vccd1 vccd1 _00840_ sky130_fd_sc_hd__mux2_1
XANTENNA_fanout677_A net683 vssd1 vssd1 vccd1 vccd1 sky130_fd_sc_hd__diode_2
Xfanout856 net862 vssd1 vssd1 vccd1 vccd1 net856 sky130_fd_sc_hd__buf_2
XTAP_TAPCELL_ROW_5_346 vssd1 vccd1 sky130_fd_sc_hd__tapvpwrvgnd_1
Xfanout845 net849 vssd1 vssd1 vccd1 vccd1 net845 sky130_fd_sc_hd__buf_1
Xfanout867 net868 vssd1 vssd1 vccd1 vccd1 net867 sky130_fd_sc_hd__clkbuf_2
X_09866_ FPGA_INST.cell0.LEI0.config_data\[44\] FPGA_INST.cell0.LEI0.config_data\[45\]
+ net180 vssd1 vssd1 vccd1 vccd1 _00774_ sky130_fd_sc_hd__mux2_1
X_08817_ _01662_ FPGA_INST.cell3.CB_0.config_dataB\[2\] _05004_ _05015_ vssd1 vssd1
+ vccd1 vccd1 _05024_ sky130_fd_sc_hd__o31a_1
Xfanout889 net890 vssd1 vssd1 vccd1 vccd1 net889 sky130_fd_sc_hd__clkbuf_2
XFILLER_46_707 vssd1 vssd1 vccd1 vccd1 sky130_fd_sc_hd__fill_1
Xfanout878 net882 vssd1 vssd1 vccd1 vccd1 net878 sky130_fd_sc_hd__clkbuf_2
XTAP_TAPCELL_ROW_5_357 vssd1 vccd1 sky130_fd_sc_hd__tapvpwrvgnd_1
XANTENNA__08183__A1 net119 vssd1 vssd1 vccd1 vccd1 sky130_fd_sc_hd__diode_2
XPHY_EDGE_ROW_116_Left_247 vssd1 vssd1 vccd1 vccd1 sky130_fd_sc_hd__decap_3
XANTENNA__07930__A1 FPGA_INST.bus3_1\[5\] vssd1 vssd1 vccd1 vccd1 sky130_fd_sc_hd__diode_2
X_09797_ FPGA_INST.cell1.CB_1.config_dataA\[23\] FPGA_INST.cell1.CB_1.config_dataA\[22\]
+ net339 vssd1 vssd1 vccd1 vccd1 _00706_ sky130_fd_sc_hd__mux2_1
XANTENNA__06733__A2 FPGA_INST.bus3_2\[6\] vssd1 vssd1 vccd1 vccd1 sky130_fd_sc_hd__diode_2
XANTENNA_fanout844_A net849 vssd1 vssd1 vccd1 vccd1 sky130_fd_sc_hd__diode_2
X_08748_ FPGA_INST.cell3.CB_0.config_dataA\[18\] FPGA_INST.cell3.CB_0.config_dataA\[17\]
+ FPGA_INST.cell3.CB_0.config_dataA\[19\] _04929_ vssd1 vssd1 vccd1 vccd1 _04957_
+ sky130_fd_sc_hd__or4bb_1
XFILLER_73_559 vssd1 vssd1 vccd1 vccd1 sky130_fd_sc_hd__fill_1
X_08679_ FPGA_INST.cell3.LEI0.config_data\[12\] net82 _04887_ FPGA_INST.cell3.LEI0.config_data\[13\]
+ vssd1 vssd1 vccd1 vccd1 _04888_ sky130_fd_sc_hd__o211a_1
XFILLER_54_751 vssd1 vssd1 vccd1 vccd1 sky130_fd_sc_hd__fill_2
XTAP_TAPCELL_ROW_103_1719 vssd1 vccd1 sky130_fd_sc_hd__tapvpwrvgnd_1
XFILLER_54_795 vssd1 vssd1 vccd1 vccd1 sky130_fd_sc_hd__fill_4
XFILLER_53_283 vssd1 vssd1 vccd1 vccd1 sky130_fd_sc_hd__fill_1
X_10710_ net863 _00060_ net648 vssd1 vssd1 vccd1 vccd1 FPGA_INST.cell2.LE_0A.config_data\[9\]
+ sky130_fd_sc_hd__dfrtp_1
XTAP_TAPCELL_ROW_24_621 vssd1 vccd1 sky130_fd_sc_hd__tapvpwrvgnd_1
XFILLER_26_77 vssd1 vssd1 vccd1 vccd1 sky130_fd_sc_hd__fill_4
XFILLER_26_475 vssd1 vssd1 vccd1 vccd1 sky130_fd_sc_hd__fill_1
XFILLER_26_497 vssd1 vssd1 vccd1 vccd1 sky130_fd_sc_hd__fill_1
X_11690_ net898 _01036_ net682 vssd1 vssd1 vccd1 vccd1 FPGA_INST.cell3.SB0.route_sel\[60\]
+ sky130_fd_sc_hd__dfstp_1
XFILLER_14_659 vssd1 vssd1 vccd1 vccd1 sky130_fd_sc_hd__fill_1
X_10641_ FPGA_INST.cell3.LE_1B.config_data\[11\] FPGA_INST.cell3.LE_1B.config_data\[10\]
+ net368 vssd1 vssd1 vccd1 vccd1 _01520_ sky130_fd_sc_hd__mux2_1
XTAP_TAPCELL_ROW_62_1151 vssd1 vccd1 sky130_fd_sc_hd__tapvpwrvgnd_1
X_10572_ FPGA_INST.cell3.CB_0.config_dataA\[17\] net393 net378 vssd1 vssd1 vccd1 vccd1
+ _01451_ sky130_fd_sc_hd__mux2_1
XFILLER_42_54 vssd1 vssd1 vccd1 vccd1 sky130_fd_sc_hd__fill_1
XPHY_EDGE_ROW_125_Left_256 vssd1 vssd1 vccd1 vccd1 sky130_fd_sc_hd__decap_3
XTAP_TAPCELL_ROW_118_1940 vssd1 vccd1 sky130_fd_sc_hd__tapvpwrvgnd_1
XFILLER_108_731 vssd1 vssd1 vccd1 vccd1 sky130_fd_sc_hd__fill_1
XFILLER_5_335 vssd1 vssd1 vccd1 vccd1 sky130_fd_sc_hd__fill_1
X_12173_ net909 _01519_ net693 vssd1 vssd1 vccd1 vccd1 FPGA_INST.cell3.LE_1B.config_data\[10\]
+ sky130_fd_sc_hd__dfrtp_1
X_11124_ net796 _00474_ net581 vssd1 vssd1 vccd1 vccd1 FPGA_INST.cell1.LE_1A.config_data\[15\]
+ sky130_fd_sc_hd__dfrtp_1
XFILLER_3_15 vssd1 vssd1 vccd1 vccd1 sky130_fd_sc_hd__fill_8
XFILLER_122_277 vssd1 vssd1 vccd1 vccd1 sky130_fd_sc_hd__fill_1
X_11055_ net814 _00405_ net599 vssd1 vssd1 vccd1 vccd1 FPGA_INST.cell1.LEI0.config_data\[40\]
+ sky130_fd_sc_hd__dfrtp_1
XANTENNA_input26_X net26 vssd1 vssd1 vccd1 vccd1 sky130_fd_sc_hd__diode_2
XFILLER_49_556 vssd1 vssd1 vccd1 vccd1 sky130_fd_sc_hd__fill_2
X_10006_ FPGA_INST.cell0.CB_0.config_dataA\[6\] net434 net319 vssd1 vssd1 vccd1 vccd1
+ _00887_ sky130_fd_sc_hd__mux2_1
XANTENNA__06724__A2 _02836_ vssd1 vssd1 vccd1 vccd1 sky130_fd_sc_hd__diode_2
XFILLER_37_729 vssd1 vssd1 vccd1 vccd1 sky130_fd_sc_hd__fill_4
X_11957_ net908 _01303_ net692 vssd1 vssd1 vccd1 vccd1 FPGA_INST.cell3.CB_1.config_dataB\[22\]
+ sky130_fd_sc_hd__dfstp_1
XFILLER_91_367 vssd1 vssd1 vccd1 vccd1 sky130_fd_sc_hd__fill_4
XFILLER_72_581 vssd1 vssd1 vccd1 vccd1 sky130_fd_sc_hd__fill_4
X_10908_ net827 _00258_ net611 vssd1 vssd1 vccd1 vccd1 FPGA_INST.cell1.SB0.route_sel\[117\]
+ sky130_fd_sc_hd__dfstp_1
X_11888_ net927 _01234_ net711 vssd1 vssd1 vccd1 vccd1 FPGA_INST.cell3.LE_0A.reset_val
+ sky130_fd_sc_hd__dfrtp_1
X_10839_ net802 _00189_ net587 vssd1 vssd1 vccd1 vccd1 FPGA_INST.cell1.SB0.route_sel\[48\]
+ sky130_fd_sc_hd__dfstp_1
XFILLER_60_798 vssd1 vssd1 vccd1 vccd1 sky130_fd_sc_hd__fill_1
XFILLER_9_652 vssd1 vssd1 vccd1 vccd1 sky130_fd_sc_hd__fill_8
XANTENNA__11543__SET_B net563 vssd1 vssd1 vccd1 vccd1 sky130_fd_sc_hd__diode_2
XANTENNA__10583__S net378 vssd1 vssd1 vccd1 vccd1 sky130_fd_sc_hd__diode_2
XANTENNA__09149__S net358 vssd1 vssd1 vccd1 vccd1 sky130_fd_sc_hd__diode_2
X_06030_ _02306_ _02308_ vssd1 vssd1 vccd1 vccd1 _02310_ sky130_fd_sc_hd__or2_1
XANTENNA__08401__A2 FPGA_INST.bus1_0\[2\] vssd1 vssd1 vccd1 vccd1 sky130_fd_sc_hd__diode_2
XFILLER_114_789 vssd1 vssd1 vccd1 vccd1 sky130_fd_sc_hd__fill_8
X_07981_ net464 _04013_ _04208_ net462 vssd1 vssd1 vccd1 vccd1 _04209_ sky130_fd_sc_hd__o211a_1
Xfanout119 net122 vssd1 vssd1 vccd1 vccd1 net119 sky130_fd_sc_hd__clkbuf_2
X_09720_ FPGA_INST.cell0.SB0.route_sel\[124\] FPGA_INST.cell0.SB0.route_sel\[123\]
+ net323 vssd1 vssd1 vccd1 vccd1 _00629_ sky130_fd_sc_hd__mux2_1
X_06932_ net414 net415 vssd1 vssd1 vccd1 vccd1 _03200_ sky130_fd_sc_hd__nand2b_1
XFILLER_86_139 vssd1 vssd1 vccd1 vccd1 sky130_fd_sc_hd__fill_1
XANTENNA__08165__A1 _03797_ vssd1 vssd1 vccd1 vccd1 sky130_fd_sc_hd__diode_2
XANTENNA__08165__B2 _03759_ vssd1 vssd1 vccd1 vccd1 sky130_fd_sc_hd__diode_2
XTAP_TAPCELL_ROW_2_305 vssd1 vccd1 sky130_fd_sc_hd__tapvpwrvgnd_1
XFILLER_67_375 vssd1 vssd1 vccd1 vccd1 sky130_fd_sc_hd__fill_1
XTAP_TAPCELL_ROW_2_316 vssd1 vccd1 sky130_fd_sc_hd__tapvpwrvgnd_1
X_06863_ _02145_ _03128_ _03130_ _02109_ _01741_ vssd1 vssd1 vccd1 vccd1 _03131_ sky130_fd_sc_hd__o221a_1
X_09651_ FPGA_INST.cell0.SB0.route_sel\[54\] FPGA_INST.cell0.SB0.route_sel\[55\] net179
+ vssd1 vssd1 vccd1 vccd1 _00560_ sky130_fd_sc_hd__mux2_1
X_09582_ FPGA_INST.cell1.CB_1.config_dataB\[11\] FPGA_INST.cell1.CB_1.config_dataB\[10\]
+ net333 vssd1 vssd1 vccd1 vccd1 _00491_ sky130_fd_sc_hd__mux2_1
X_08602_ FPGA_INST.cell3.SB0.route_sel\[106\] FPGA_INST.cell3.SB0.route_sel\[107\]
+ vssd1 vssd1 vccd1 vccd1 _04811_ sky130_fd_sc_hd__nor2_1
X_06794_ FPGA_INST.bus3_2\[4\] FPGA_INST.bus3_2\[5\] FPGA_INST.bus3_2\[6\] FPGA_INST.bus3_2\[7\]
+ net512 net511 vssd1 vssd1 vccd1 vccd1 _03068_ sky130_fd_sc_hd__mux4_1
XFILLER_55_559 vssd1 vssd1 vccd1 vccd1 sky130_fd_sc_hd__fill_1
XFILLER_55_548 vssd1 vssd1 vccd1 vccd1 sky130_fd_sc_hd__fill_1
X_05814_ net507 _02056_ _02093_ net505 vssd1 vssd1 vccd1 vccd1 _02094_ sky130_fd_sc_hd__o211a_1
X_08533_ _04745_ _04742_ _04729_ vssd1 vssd1 vccd1 vccd1 _04746_ sky130_fd_sc_hd__mux2_1
X_05745_ _02015_ _02023_ _02024_ vssd1 vssd1 vccd1 vccd1 _02025_ sky130_fd_sc_hd__a21oi_1
XFILLER_63_570 vssd1 vssd1 vccd1 vccd1 sky130_fd_sc_hd__fill_1
XANTENNA_fanout258_A net267 vssd1 vssd1 vccd1 vccd1 sky130_fd_sc_hd__diode_2
X_08464_ _04678_ _04681_ _04665_ vssd1 vssd1 vccd1 vccd1 _04682_ sky130_fd_sc_hd__mux2_1
X_05676_ net485 net486 _01954_ net14 vssd1 vssd1 vccd1 vccd1 _01956_ sky130_fd_sc_hd__a31o_1
X_07415_ _01788_ _03499_ _03594_ _03591_ _03496_ vssd1 vssd1 vccd1 vccd1 _03673_ sky130_fd_sc_hd__o32a_1
X_08395_ FPGA_INST.bus1_0\[8\] FPGA_INST.bus1_0\[10\] FPGA_INST.bus1_0\[9\] FPGA_INST.bus1_0\[11\]
+ net438 net440 vssd1 vssd1 vccd1 vccd1 _04617_ sky130_fd_sc_hd__mux4_1
XFILLER_51_787 vssd1 vssd1 vccd1 vccd1 sky130_fd_sc_hd__fill_1
X_07346_ FPGA_INST.cell1.SB0.route_sel\[39\] FPGA_INST.cell1.SB0.route_sel\[38\] _02261_
+ _03605_ _02262_ vssd1 vssd1 vccd1 vccd1 _03606_ sky130_fd_sc_hd__a221oi_2
XANTENNA_wire73_A FPGA_INST.bus1_0\[0\] vssd1 vssd1 vccd1 vccd1 sky130_fd_sc_hd__diode_2
XFILLER_10_117 vssd1 vssd1 vccd1 vccd1 sky130_fd_sc_hd__fill_2
X_07277_ FPGA_INST.cell3.SB0.route_sel\[21\] _01705_ vssd1 vssd1 vccd1 vccd1 _03539_
+ sky130_fd_sc_hd__nand2_1
XANTENNA__06651__A1 _02819_ vssd1 vssd1 vccd1 vccd1 sky130_fd_sc_hd__diode_2
XANTENNA__06543__Y _02819_ vssd1 vssd1 vccd1 vccd1 sky130_fd_sc_hd__diode_2
X_09016_ FPGA_INST.cell2.SB0.route_sel\[18\] FPGA_INST.cell2.SB0.route_sel\[19\] vssd1
+ vssd1 vccd1 vccd1 _05184_ sky130_fd_sc_hd__nand2b_1
XFILLER_12_57 vssd1 vssd1 vccd1 vccd1 sky130_fd_sc_hd__fill_2
XFILLER_117_561 vssd1 vssd1 vccd1 vccd1 sky130_fd_sc_hd__fill_1
XANTENNA__11328__SET_B net626 vssd1 vssd1 vccd1 vccd1 sky130_fd_sc_hd__diode_2
X_06228_ net508 _02503_ _02504_ _02507_ vssd1 vssd1 vccd1 vccd1 _02508_ sky130_fd_sc_hd__a31o_1
XFILLER_117_583 vssd1 vssd1 vccd1 vccd1 sky130_fd_sc_hd__fill_8
XANTENNA__08898__S _05032_ vssd1 vssd1 vccd1 vccd1 sky130_fd_sc_hd__diode_2
X_06159_ net129 _02437_ _02438_ _02436_ _02432_ vssd1 vssd1 vccd1 vccd1 _02439_ sky130_fd_sc_hd__a221oi_2
XTAP_TAPCELL_ROW_113_1870 vssd1 vccd1 sky130_fd_sc_hd__tapvpwrvgnd_1
XANTENNA__11556__CLK net778 vssd1 vssd1 vccd1 vccd1 sky130_fd_sc_hd__diode_2
Xfanout620 net621 vssd1 vssd1 vccd1 vccd1 net620 sky130_fd_sc_hd__clkbuf_4
XFILLER_77_128 vssd1 vssd1 vccd1 vccd1 sky130_fd_sc_hd__fill_2
Xfanout631 net634 vssd1 vssd1 vccd1 vccd1 net631 sky130_fd_sc_hd__clkbuf_4
X_09918_ FPGA_INST.cell0.LE_0B.reset_mode FPGA_INST.cell0.LE_1A.config_data\[0\] net175
+ vssd1 vssd1 vccd1 vccd1 _00823_ sky130_fd_sc_hd__mux2_1
Xfanout642 net644 vssd1 vssd1 vccd1 vccd1 net642 sky130_fd_sc_hd__clkbuf_4
Xfanout664 net666 vssd1 vssd1 vccd1 vccd1 net664 sky130_fd_sc_hd__clkbuf_2
Xfanout653 net662 vssd1 vssd1 vccd1 vccd1 net653 sky130_fd_sc_hd__clkbuf_4
Xfanout675 net676 vssd1 vssd1 vccd1 vccd1 net675 sky130_fd_sc_hd__clkbuf_2
XTAP_TAPCELL_ROW_129_2088 vssd1 vccd1 sky130_fd_sc_hd__tapvpwrvgnd_1
Xfanout697 net698 vssd1 vssd1 vccd1 vccd1 net697 sky130_fd_sc_hd__clkbuf_4
XFILLER_86_684 vssd1 vssd1 vccd1 vccd1 sky130_fd_sc_hd__fill_1
Xfanout686 net702 vssd1 vssd1 vccd1 vccd1 net686 sky130_fd_sc_hd__clkbuf_2
X_09849_ FPGA_INST.cell0.LEI0.config_data\[27\] FPGA_INST.cell0.LEI0.config_data\[28\]
+ net177 vssd1 vssd1 vccd1 vccd1 _00757_ sky130_fd_sc_hd__mux2_1
XFILLER_19_729 vssd1 vssd1 vccd1 vccd1 sky130_fd_sc_hd__fill_2
XFILLER_85_183 vssd1 vssd1 vccd1 vccd1 sky130_fd_sc_hd__fill_1
XFILLER_37_54 vssd1 vssd1 vccd1 vccd1 sky130_fd_sc_hd__fill_2
X_11811_ net871 _01157_ net655 vssd1 vssd1 vccd1 vccd1 net36 sky130_fd_sc_hd__dfrtp_1
XFILLER_27_795 vssd1 vssd1 vccd1 vccd1 sky130_fd_sc_hd__fill_4
X_11742_ net895 _01088_ net679 vssd1 vssd1 vccd1 vccd1 FPGA_INST.cell3.SB0.route_sel\[112\]
+ sky130_fd_sc_hd__dfstp_1
X_11673_ net906 _01019_ net690 vssd1 vssd1 vccd1 vccd1 FPGA_INST.cell3.SB0.route_sel\[43\]
+ sky130_fd_sc_hd__dfstp_1
X_10624_ FPGA_INST.cell3.CB_1.config_dataA\[18\] FPGA_INST.cell3.CB_1.config_dataA\[19\]
+ net299 vssd1 vssd1 vccd1 vccd1 _01503_ sky130_fd_sc_hd__mux2_1
XFILLER_10_662 vssd1 vssd1 vccd1 vccd1 sky130_fd_sc_hd__fill_8
X_10555_ FPGA_INST.cell3.CB_0.config_dataA\[0\] FPGA_INST.cell3.CB_0.config_data_inA
+ net370 vssd1 vssd1 vccd1 vccd1 _01434_ sky130_fd_sc_hd__mux2_1
X_10486_ FPGA_INST.cell2.SB0.route_sel\[58\] FPGA_INST.cell2.SB0.route_sel\[59\] net238
+ vssd1 vssd1 vccd1 vccd1 _01365_ sky130_fd_sc_hd__mux2_1
XTAP_TAPCELL_ROW_75_1331 vssd1 vccd1 sky130_fd_sc_hd__tapvpwrvgnd_1
XFILLER_6_699 vssd1 vssd1 vccd1 vccd1 sky130_fd_sc_hd__fill_1
X_12156_ net934 _01502_ net718 vssd1 vssd1 vccd1 vccd1 FPGA_INST.cell3.CB_1.config_dataA\[18\]
+ sky130_fd_sc_hd__dfstp_1
XANTENNA__08395__A1 FPGA_INST.bus1_0\[10\] vssd1 vssd1 vccd1 vccd1 sky130_fd_sc_hd__diode_2
XFILLER_110_214 vccd1 vssd1 vccd1 vssd1 sky130_ef_sc_hd__decap_40_12
X_11107_ FPGA_INST.cell1.LE_1A.sel_clk _00457_ net733 vssd1 vssd1 vccd1 vccd1 FPGA_INST.cell1.LE_1A.dff0_out
+ sky130_fd_sc_hd__dfrtp_1
XFILLER_78_83 vssd1 vssd1 vccd1 vccd1 sky130_fd_sc_hd__fill_1
XFILLER_68_139 vssd1 vssd1 vccd1 vccd1 sky130_fd_sc_hd__fill_1
X_12087_ net861 _01433_ net644 vssd1 vssd1 vccd1 vccd1 FPGA_INST.cell2.SB0.config_data_out
+ sky130_fd_sc_hd__dfstp_2
XFILLER_1_393 vssd1 vssd1 vccd1 vccd1 sky130_fd_sc_hd__fill_1
X_11038_ net818 _00388_ net603 vssd1 vssd1 vccd1 vccd1 FPGA_INST.cell1.LEI0.config_data\[23\]
+ sky130_fd_sc_hd__dfrtp_1
XANTENNA__08698__A2 _04781_ vssd1 vssd1 vccd1 vccd1 sky130_fd_sc_hd__diode_2
XFILLER_76_150 vccd1 vssd1 vccd1 vssd1 sky130_ef_sc_hd__decap_40_12
XANTENNA_output54_A net54 vssd1 vssd1 vccd1 vccd1 sky130_fd_sc_hd__diode_2
XFILLER_92_643 vssd1 vssd1 vccd1 vccd1 sky130_fd_sc_hd__fill_1
XFILLER_64_334 vssd1 vssd1 vccd1 vccd1 sky130_fd_sc_hd__fill_2
XFILLER_49_397 vssd1 vssd1 vccd1 vccd1 sky130_fd_sc_hd__fill_2
XFILLER_64_367 vssd1 vssd1 vccd1 vccd1 sky130_fd_sc_hd__fill_1
XFILLER_91_186 vccd1 vssd1 vccd1 vssd1 sky130_ef_sc_hd__decap_40_12
XTAP_TAPCELL_ROW_86_1482 vssd1 vccd1 sky130_fd_sc_hd__tapvpwrvgnd_1
XFILLER_52_529 vssd1 vssd1 vccd1 vccd1 sky130_fd_sc_hd__fill_2
XTAP_TAPCELL_ROW_86_1493 vssd1 vccd1 sky130_fd_sc_hd__tapvpwrvgnd_1
X_05530_ net505 net506 vssd1 vssd1 vccd1 vccd1 _01810_ sky130_fd_sc_hd__and2b_1
XFILLER_60_573 vssd1 vssd1 vccd1 vccd1 sky130_fd_sc_hd__fill_4
X_05461_ FPGA_INST.cell0.CB_0.config_dataB\[8\] vssd1 vssd1 vccd1 vccd1 _01743_ sky130_fd_sc_hd__inv_2
XFILLER_32_253 vssd1 vssd1 vccd1 vccd1 sky130_fd_sc_hd__fill_1
XFILLER_33_798 vssd1 vssd1 vccd1 vccd1 sky130_fd_sc_hd__fill_1
X_05392_ FPGA_INST.cell3.SB0.route_sel\[54\] vssd1 vssd1 vccd1 vccd1 _01674_ sky130_fd_sc_hd__inv_2
X_07200_ FPGA_INST.cell0.SB0.route_sel\[8\] FPGA_INST.cell0.SB0.route_sel\[9\] vssd1
+ vssd1 vccd1 vccd1 _03463_ sky130_fd_sc_hd__nand2b_1
X_08180_ _03465_ _04382_ _04383_ _03408_ FPGA_INST.cell0.CB_1.config_dataA\[2\] vssd1
+ vssd1 vccd1 vccd1 _04404_ sky130_fd_sc_hd__a221o_1
XTAP_TAPCELL_ROW_15_495 vssd1 vccd1 sky130_fd_sc_hd__tapvpwrvgnd_1
XANTENNA__06881__A1 FPGA_INST.bus2_0\[4\] vssd1 vssd1 vccd1 vccd1 sky130_fd_sc_hd__diode_2
X_07131_ FPGA_INST.cell1.CB_0.config_dataA\[24\] FPGA_INST.cell1.CB_0.config_dataA\[21\]
+ FPGA_INST.cell1.CB_0.config_dataA\[20\] vssd1 vssd1 vccd1 vccd1 _03395_ sky130_fd_sc_hd__or3_2
XANTENNA__06881__B2 FPGA_INST.bus2_0\[5\] vssd1 vssd1 vccd1 vccd1 sky130_fd_sc_hd__diode_2
XANTENNA__11579__CLK net778 vssd1 vssd1 vccd1 vccd1 sky130_fd_sc_hd__diode_2
XFILLER_118_358 vssd1 vssd1 vccd1 vccd1 sky130_fd_sc_hd__fill_4
XFILLER_106_509 vssd1 vssd1 vccd1 vccd1 sky130_fd_sc_hd__fill_1
X_07062_ net429 _03324_ _03327_ vssd1 vssd1 vccd1 vccd1 _03328_ sky130_fd_sc_hd__a21o_1
X_06013_ _02292_ vssd1 vssd1 vccd1 vccd1 _02293_ sky130_fd_sc_hd__inv_2
XFILLER_114_531 vssd1 vssd1 vccd1 vccd1 sky130_fd_sc_hd__fill_1
XFILLER_87_437 vssd1 vssd1 vccd1 vccd1 sky130_fd_sc_hd__fill_8
XFILLER_114_15 vccd1 vssd1 vccd1 vssd1 sky130_ef_sc_hd__decap_40_12
X_07964_ FPGA_INST.bus3_1\[0\] FPGA_INST.bus3_1\[1\] FPGA_INST.bus3_1\[2\] FPGA_INST.bus3_1\[3\]
+ net463 FPGA_INST.cell1.CB_0.config_dataA\[16\] vssd1 vssd1 vccd1 vccd1 _04192_ sky130_fd_sc_hd__mux4_1
X_07895_ FPGA_INST.bus3_1\[4\] FPGA_INST.bus3_1\[5\] FPGA_INST.bus3_1\[6\] FPGA_INST.bus3_1\[7\]
+ net472 FPGA_INST.cell1.CB_0.config_dataA\[1\] vssd1 vssd1 vccd1 vccd1 _04123_ sky130_fd_sc_hd__mux4_1
XFILLER_68_684 vssd1 vssd1 vccd1 vccd1 sky130_fd_sc_hd__fill_8
XANTENNA__07127__S FPGA_INST.cell0.LE_0A.reset_val vssd1 vssd1 vccd1 vccd1 sky130_fd_sc_hd__diode_2
X_06915_ FPGA_INST.bus2_0\[6\] FPGA_INST.bus2_0\[7\] net418 vssd1 vssd1 vccd1 vccd1
+ _03183_ sky130_fd_sc_hd__mux2_1
X_09703_ FPGA_INST.cell0.SB0.route_sel\[106\] FPGA_INST.cell0.SB0.route_sel\[107\]
+ net198 vssd1 vssd1 vccd1 vccd1 _00612_ sky130_fd_sc_hd__mux2_1
XANTENNA_fanout375_A net377 vssd1 vssd1 vccd1 vccd1 sky130_fd_sc_hd__diode_2
XFILLER_55_334 vssd1 vssd1 vccd1 vccd1 sky130_fd_sc_hd__fill_2
X_09634_ FPGA_INST.cell0.SB0.route_sel\[37\] FPGA_INST.cell0.SB0.route_sel\[38\] net185
+ vssd1 vssd1 vccd1 vccd1 _00543_ sky130_fd_sc_hd__mux2_1
X_06846_ net421 _02070_ vssd1 vssd1 vccd1 vccd1 _03114_ sky130_fd_sc_hd__nand2_1
XFILLER_28_548 vssd1 vssd1 vccd1 vccd1 sky130_fd_sc_hd__fill_1
X_09565_ FPGA_INST.cell1.LE_1A.config_data\[15\] FPGA_INST.cell1.LE_1A.config_data\[14\]
+ net326 vssd1 vssd1 vccd1 vccd1 _00474_ sky130_fd_sc_hd__mux2_1
XFILLER_82_186 vssd1 vssd1 vccd1 vccd1 sky130_fd_sc_hd__fill_2
X_06777_ net511 net512 vssd1 vssd1 vccd1 vccd1 _03051_ sky130_fd_sc_hd__nor2_1
XFILLER_55_389 vssd1 vssd1 vccd1 vccd1 sky130_fd_sc_hd__fill_2
X_08516_ FPGA_INST.cell3.LEI0.config_data\[32\] _04727_ _04728_ FPGA_INST.cell3.CB_1.config_dataA\[14\]
+ vssd1 vssd1 vccd1 vccd1 _04729_ sky130_fd_sc_hd__o211a_1
X_09496_ FPGA_INST.cell1.LEI0.config_data\[42\] FPGA_INST.cell1.LEI0.config_data\[43\]
+ net205 vssd1 vssd1 vccd1 vccd1 _00408_ sky130_fd_sc_hd__mux2_1
XANTENNA__08310__A1 net95 vssd1 vssd1 vccd1 vccd1 sky130_fd_sc_hd__diode_2
X_05728_ FPGA_INST.cell2.SB0.route_sel\[109\] FPGA_INST.cell2.SB0.route_sel\[108\]
+ vssd1 vssd1 vccd1 vccd1 _02008_ sky130_fd_sc_hd__nand2b_1
X_08447_ FPGA_INST.cell1.CB_1.config_dataA\[14\] _04663_ _04664_ vssd1 vssd1 vccd1
+ vccd1 _04665_ sky130_fd_sc_hd__and3_1
X_05659_ _01922_ _01938_ _01919_ vssd1 vssd1 vccd1 vccd1 _01939_ sky130_fd_sc_hd__o21ba_1
XTAP_TAPCELL_ROW_34_760 vssd1 vccd1 sky130_fd_sc_hd__tapvpwrvgnd_1
XANTENNA_fanout807_A net811 vssd1 vssd1 vccd1 vccd1 sky130_fd_sc_hd__diode_2
X_08378_ FPGA_INST.cell0.CB_1.config_dataB\[13\] FPGA_INST.cell0.CB_1.config_dataB\[12\]
+ FPGA_INST.cell0.CB_1.config_dataB\[14\] _04577_ vssd1 vssd1 vccd1 vccd1 _04600_
+ sky130_fd_sc_hd__or4bb_1
XFILLER_128_5 vccd1 vssd1 vccd1 vssd1 sky130_ef_sc_hd__decap_40_12
X_07329_ FPGA_INST.cell3.SB0.route_sel\[34\] FPGA_INST.cell3.SB0.route_sel\[35\] vssd1
+ vssd1 vccd1 vccd1 _03589_ sky130_fd_sc_hd__nand2_1
X_10340_ FPGA_INST.cell3.LE_0A.config_data\[4\] FPGA_INST.cell3.LE_0A.config_data\[5\]
+ net294 vssd1 vssd1 vccd1 vccd1 _01221_ sky130_fd_sc_hd__mux2_1
X_10271_ FPGA_INST.io_east_oeb\[30\] net44 net255 vssd1 vssd1 vccd1 vccd1 _01152_
+ sky130_fd_sc_hd__mux2_1
XFILLER_117_391 vssd1 vssd1 vccd1 vccd1 sky130_fd_sc_hd__fill_1
X_12010_ net776 _01356_ net562 vssd1 vssd1 vccd1 vccd1 FPGA_INST.cell2.SB0.route_sel\[50\]
+ sky130_fd_sc_hd__dfstp_1
XTAP_TAPCELL_ROW_57_1083 vssd1 vccd1 sky130_fd_sc_hd__tapvpwrvgnd_1
XANTENNA__06388__A0 net3 vssd1 vssd1 vccd1 vccd1 sky130_fd_sc_hd__diode_2
XANTENNA__08421__S _04574_ vssd1 vssd1 vccd1 vccd1 sky130_fd_sc_hd__diode_2
Xfanout450 FPGA_INST.cell1.CB_0.config_dataB\[16\] vssd1 vssd1 vccd1 vccd1 net450
+ sky130_fd_sc_hd__buf_2
XFILLER_120_589 vssd1 vssd1 vccd1 vccd1 sky130_fd_sc_hd__fill_4
Xfanout472 net473 vssd1 vssd1 vccd1 vccd1 net472 sky130_fd_sc_hd__buf_2
Xfanout461 FPGA_INST.cell1.CB_0.config_dataB\[0\] vssd1 vssd1 vccd1 vccd1 net461 sky130_fd_sc_hd__clkbuf_2
XANTENNA__11086__SET_B net733 vssd1 vssd1 vccd1 vccd1 sky130_fd_sc_hd__diode_2
XTAP_TAPCELL_ROW_70_1261 vssd1 vccd1 sky130_fd_sc_hd__tapvpwrvgnd_1
Xfanout483 net484 vssd1 vssd1 vccd1 vccd1 net483 sky130_fd_sc_hd__clkbuf_2
XFILLER_101_781 vssd1 vssd1 vccd1 vccd1 sky130_fd_sc_hd__fill_1
XFILLER_74_643 vssd1 vssd1 vccd1 vccd1 sky130_fd_sc_hd__fill_1
Xfanout494 FPGA_INST.cell2.CB_0.config_dataB\[5\] vssd1 vssd1 vccd1 vccd1 net494 sky130_fd_sc_hd__buf_2
XFILLER_74_654 vccd1 vssd1 vccd1 vssd1 sky130_ef_sc_hd__decap_40_12
XANTENNA__09252__S net341 vssd1 vssd1 vccd1 vccd1 sky130_fd_sc_hd__diode_2
XFILLER_19_559 vssd1 vssd1 vccd1 vccd1 sky130_fd_sc_hd__fill_1
XFILLER_64_96 vssd1 vssd1 vccd1 vccd1 sky130_fd_sc_hd__fill_1
XFILLER_64_85 vssd1 vssd1 vccd1 vccd1 sky130_fd_sc_hd__fill_1
XFILLER_61_337 vssd1 vssd1 vccd1 vccd1 sky130_fd_sc_hd__fill_2
XANTENNA__06177__A net112 vssd1 vssd1 vccd1 vccd1 sky130_fd_sc_hd__diode_2
X_11725_ net902 _01071_ net686 vssd1 vssd1 vccd1 vccd1 FPGA_INST.cell3.SB0.route_sel\[95\]
+ sky130_fd_sc_hd__dfstp_1
XFILLER_128_623 vssd1 vssd1 vccd1 vccd1 sky130_fd_sc_hd__fill_1
Xfanout90 _01785_ vssd1 vssd1 vccd1 vccd1 net90 sky130_fd_sc_hd__buf_1
X_11656_ net893 _01002_ net677 vssd1 vssd1 vccd1 vccd1 FPGA_INST.cell3.SB0.route_sel\[26\]
+ sky130_fd_sc_hd__dfstp_1
XTAP_TAPCELL_ROW_12_454 vssd1 vccd1 sky130_fd_sc_hd__tapvpwrvgnd_1
X_10607_ FPGA_INST.cell3.CB_1.config_dataA\[2\] FPGA_INST.cell3.CB_1.config_dataA\[1\]
+ net375 vssd1 vssd1 vccd1 vccd1 _01486_ sky130_fd_sc_hd__mux2_1
XANTENNA__07279__Y FPGA_INST.bus3_2\[2\] vssd1 vssd1 vccd1 vccd1 sky130_fd_sc_hd__diode_2
X_11587_ net763 _00937_ net548 vssd1 vssd1 vccd1 vccd1 FPGA_INST.cell0.CB_1.config_dataA\[6\]
+ sky130_fd_sc_hd__dfstp_1
XANTENNA__06624__B _02810_ vssd1 vssd1 vccd1 vccd1 sky130_fd_sc_hd__diode_2
X_10538_ FPGA_INST.cell2.SB0.route_sel\[110\] FPGA_INST.cell2.SB0.route_sel\[111\]
+ net244 vssd1 vssd1 vccd1 vccd1 _01417_ sky130_fd_sc_hd__mux2_1
XFILLER_6_463 vssd1 vssd1 vccd1 vccd1 sky130_fd_sc_hd__fill_1
XFILLER_6_430 vssd1 vssd1 vccd1 vccd1 sky130_fd_sc_hd__fill_1
XANTENNA__11311__SET_B net626 vssd1 vssd1 vccd1 vccd1 sky130_fd_sc_hd__diode_2
XANTENNA__09427__S net354 vssd1 vssd1 vccd1 vccd1 sky130_fd_sc_hd__diode_2
X_10469_ FPGA_INST.cell2.SB0.route_sel\[41\] FPGA_INST.cell2.SB0.route_sel\[42\] net245
+ vssd1 vssd1 vccd1 vccd1 _01348_ sky130_fd_sc_hd__mux2_1
XANTENNA__08368__B2 _03465_ vssd1 vssd1 vccd1 vccd1 sky130_fd_sc_hd__diode_2
XANTENNA__08368__A1 _03408_ vssd1 vssd1 vccd1 vccd1 sky130_fd_sc_hd__diode_2
X_12139_ net941 _01485_ net725 vssd1 vssd1 vccd1 vccd1 FPGA_INST.cell3.CB_1.config_dataA\[1\]
+ sky130_fd_sc_hd__dfstp_1
XFILLER_97_779 vssd1 vssd1 vccd1 vccd1 sky130_fd_sc_hd__fill_1
XFILLER_29_3 vssd1 vssd1 vccd1 vccd1 sky130_fd_sc_hd__fill_8
XTAP_TAPCELL_ROW_88_1511 vssd1 vccd1 sky130_fd_sc_hd__tapvpwrvgnd_1
X_06700_ _02972_ _02973_ _02966_ _02970_ vssd1 vssd1 vccd1 vccd1 _02974_ sky130_fd_sc_hd__o211a_1
X_07680_ _03918_ _03929_ _03931_ net340 vssd1 vssd1 vccd1 vccd1 _03932_ sky130_fd_sc_hd__a211o_4
XANTENNA__09015__X FPGA_INST.bus1_0\[2\] vssd1 vssd1 vccd1 vccd1 sky130_fd_sc_hd__diode_2
XANTENNA__09162__S net358 vssd1 vssd1 vccd1 vccd1 sky130_fd_sc_hd__diode_2
XFILLER_37_334 vssd1 vssd1 vccd1 vccd1 sky130_fd_sc_hd__fill_2
XFILLER_37_345 vssd1 vssd1 vccd1 vccd1 sky130_fd_sc_hd__fill_4
XANTENNA__07894__A3 FPGA_INST.bus3_1\[3\] vssd1 vssd1 vccd1 vccd1 sky130_fd_sc_hd__diode_2
XFILLER_52_315 vssd1 vssd1 vccd1 vccd1 sky130_fd_sc_hd__fill_1
XANTENNA__06551__A0 FPGA_INST.bus3_2\[12\] vssd1 vssd1 vccd1 vccd1 sky130_fd_sc_hd__diode_2
X_06631_ FPGA_INST.cell2.LEI0.config_data\[30\] net102 vssd1 vssd1 vccd1 vccd1 _02907_
+ sky130_fd_sc_hd__nand2_1
X_09350_ FPGA_INST.cell1.SB0.route_sel\[122\] FPGA_INST.cell1.SB0.route_sel\[121\]
+ net342 vssd1 vssd1 vccd1 vccd1 _00263_ sky130_fd_sc_hd__mux2_1
X_06562_ FPGA_INST.cell2.SB0.route_sel\[68\] FPGA_INST.cell2.SB0.route_sel\[69\] vssd1
+ vssd1 vccd1 vccd1 _02838_ sky130_fd_sc_hd__nor2_1
X_09281_ FPGA_INST.cell1.SB0.route_sel\[52\] FPGA_INST.cell1.SB0.route_sel\[53\] net207
+ vssd1 vssd1 vccd1 vccd1 _00194_ sky130_fd_sc_hd__mux2_1
XFILLER_80_679 vssd1 vssd1 vccd1 vccd1 sky130_fd_sc_hd__fill_1
X_05513_ FPGA_INST.bus3_2\[2\] vssd1 vssd1 vccd1 vccd1 _01795_ sky130_fd_sc_hd__inv_2
X_08301_ net445 _03840_ _04522_ net444 vssd1 vssd1 vccd1 vccd1 _04523_ sky130_fd_sc_hd__o211a_1
X_08232_ net406 _03997_ _04455_ net405 vssd1 vssd1 vccd1 vccd1 _04456_ sky130_fd_sc_hd__o211a_1
XFILLER_20_223 vssd1 vssd1 vccd1 vccd1 sky130_fd_sc_hd__fill_1
X_06493_ FPGA_INST.cell2.LE_0B.config_data\[16\] _02768_ _02769_ net155 vssd1 vssd1
+ vccd1 vccd1 FPGA_INST.cell2.CB_0.le_outB sky130_fd_sc_hd__o211a_1
X_05444_ FPGA_INST.cell1.CB_0.config_dataA\[14\] vssd1 vssd1 vccd1 vccd1 _01726_ sky130_fd_sc_hd__inv_2
XTAP_TAPCELL_ROW_99_1662 vssd1 vccd1 sky130_fd_sc_hd__tapvpwrvgnd_1
X_05375_ FPGA_INST.cell3.SB0.route_sel\[69\] vssd1 vssd1 vccd1 vccd1 _01657_ sky130_fd_sc_hd__inv_2
X_08163_ net412 _03875_ vssd1 vssd1 vccd1 vccd1 _04387_ sky130_fd_sc_hd__nand2_1
X_08094_ FPGA_INST.cell1.CB_0.config_dataB\[12\] _04319_ vssd1 vssd1 vccd1 vccd1 _04320_
+ sky130_fd_sc_hd__nand2_1
XTAP_TAPCELL_ROW_99_1673 vssd1 vccd1 sky130_fd_sc_hd__tapvpwrvgnd_1
X_07114_ _01737_ _01738_ FPGA_INST.cell0.CB_0.config_dataA\[19\] _03352_ _03379_ vssd1
+ vssd1 vccd1 vccd1 _03380_ sky130_fd_sc_hd__a41o_1
XANTENNA__06067__C1 net320 vssd1 vssd1 vccd1 vccd1 sky130_fd_sc_hd__diode_2
XFILLER_109_48 vssd1 vssd1 vccd1 vccd1 sky130_fd_sc_hd__fill_8
X_07045_ net114 net118 net110 net98 FPGA_INST.cell0.LEI0.config_data\[0\] FPGA_INST.cell0.LEI0.config_data\[1\]
+ vssd1 vssd1 vccd1 vccd1 _03311_ sky130_fd_sc_hd__mux4_1
XFILLER_102_501 vssd1 vssd1 vccd1 vccd1 sky130_fd_sc_hd__fill_1
X_08996_ _01691_ FPGA_INST.cell1.SB0.route_sel\[35\] FPGA_INST.cell1.SB0.route_sel\[32\]
+ FPGA_INST.cell1.SB0.route_sel\[33\] _05170_ vssd1 vssd1 vccd1 vccd1 _05171_ sky130_fd_sc_hd__o221a_1
XFILLER_88_757 vssd1 vssd1 vccd1 vccd1 sky130_fd_sc_hd__fill_4
XFILLER_87_234 vssd1 vssd1 vccd1 vccd1 sky130_fd_sc_hd__fill_2
XFILLER_87_223 vssd1 vssd1 vccd1 vccd1 sky130_fd_sc_hd__fill_1
XFILLER_102_589 vssd1 vssd1 vccd1 vccd1 sky130_fd_sc_hd__fill_2
X_07947_ _03973_ _04154_ _04174_ vssd1 vssd1 vccd1 vccd1 _04175_ sky130_fd_sc_hd__o21ba_1
XANTENNA_fanout378_X net378 vssd1 vssd1 vccd1 vccd1 sky130_fd_sc_hd__diode_2
XTAP_TAPCELL_ROW_126_2047 vssd1 vccd1 sky130_fd_sc_hd__tapvpwrvgnd_1
X_07878_ _03973_ _04083_ FPGA_INST.cell1.CB_0.config_dataA\[7\] vssd1 vssd1 vccd1
+ vccd1 _04106_ sky130_fd_sc_hd__o21ai_1
XFILLER_56_643 vssd1 vssd1 vccd1 vccd1 sky130_fd_sc_hd__fill_1
XTAP_TAPCELL_ROW_39_830 vssd1 vccd1 sky130_fd_sc_hd__tapvpwrvgnd_1
XANTENNA_fanout924_A net931 vssd1 vssd1 vccd1 vccd1 sky130_fd_sc_hd__diode_2
XFILLER_70_101 vssd1 vssd1 vccd1 vccd1 sky130_fd_sc_hd__fill_2
X_09617_ FPGA_INST.cell0.SB0.route_sel\[20\] FPGA_INST.cell0.SB0.route_sel\[21\] net200
+ vssd1 vssd1 vccd1 vccd1 _00526_ sky130_fd_sc_hd__mux2_1
X_06829_ net422 _02350_ vssd1 vssd1 vccd1 vccd1 _03097_ sky130_fd_sc_hd__nand2_1
XFILLER_28_389 vssd1 vssd1 vccd1 vccd1 sky130_fd_sc_hd__fill_2
X_09548_ net736 _04715_ vssd1 vssd1 vccd1 vccd1 _05216_ sky130_fd_sc_hd__nand2_1
XTAP_TAPCELL_ROW_108_1791 vssd1 vccd1 sky130_fd_sc_hd__tapvpwrvgnd_1
XFILLER_70_134 vssd1 vssd1 vccd1 vccd1 sky130_fd_sc_hd__fill_1
XANTENNA__05896__A2 net171 vssd1 vssd1 vccd1 vccd1 sky130_fd_sc_hd__diode_2
XANTENNA__09800__S net336 vssd1 vssd1 vccd1 vccd1 sky130_fd_sc_hd__diode_2
XANTENNA__11744__CLK net899 vssd1 vssd1 vccd1 vccd1 sky130_fd_sc_hd__diode_2
XFILLER_70_156 vccd1 vssd1 vccd1 vssd1 sky130_ef_sc_hd__decap_40_12
XANTENNA__07098__A1 FPGA_INST.bus2_0\[5\] vssd1 vssd1 vccd1 vccd1 sky130_fd_sc_hd__diode_2
XTAP_TAPCELL_ROW_121_1980 vssd1 vccd1 sky130_fd_sc_hd__tapvpwrvgnd_1
X_09479_ FPGA_INST.cell1.LEI0.config_data\[25\] FPGA_INST.cell1.LEI0.config_data\[26\]
+ net216 vssd1 vssd1 vccd1 vccd1 _00391_ sky130_fd_sc_hd__mux2_1
XANTENNA__08834__A2 net20 vssd1 vssd1 vccd1 vccd1 sky130_fd_sc_hd__diode_2
X_11510_ net763 _00860_ net548 vssd1 vssd1 vccd1 vccd1 FPGA_INST.cell0.CB_1.config_dataB\[16\]
+ sky130_fd_sc_hd__dfstp_1
XFILLER_7_205 vssd1 vssd1 vccd1 vccd1 sky130_fd_sc_hd__fill_1
XANTENNA__08416__S _04544_ vssd1 vssd1 vccd1 vccd1 sky130_fd_sc_hd__diode_2
XFILLER_12_757 vssd1 vssd1 vccd1 vccd1 sky130_fd_sc_hd__fill_1
X_11441_ net773 _00791_ net629 vssd1 vssd1 vccd1 vccd1 FPGA_INST.cell0.LE_0A.config_data\[12\]
+ sky130_fd_sc_hd__dfrtp_1
X_11372_ net817 _00722_ net602 vssd1 vssd1 vccd1 vccd1 FPGA_INST.cell1.LE_1B.config_data\[14\]
+ sky130_fd_sc_hd__dfrtp_1
XTAP_TAPCELL_ROW_59_1112 vssd1 vccd1 sky130_fd_sc_hd__tapvpwrvgnd_1
XFILLER_50_76 vssd1 vssd1 vccd1 vccd1 sky130_fd_sc_hd__fill_1
X_10323_ FPGA_INST.cell3.LEI0.config_data\[37\] FPGA_INST.cell3.LEI0.config_data\[38\]
+ net282 vssd1 vssd1 vccd1 vccd1 _01204_ sky130_fd_sc_hd__mux2_1
X_10254_ FPGA_INST.io_south_oeb\[28\] FPGA_INST.io_south_oeb\[30\] net264 vssd1 vssd1
+ vccd1 vccd1 _01135_ sky130_fd_sc_hd__mux2_1
X_10185_ FPGA_INST.cell3.SB0.route_sel\[89\] FPGA_INST.cell3.SB0.route_sel\[90\] net275
+ vssd1 vssd1 vccd1 vccd1 _01066_ sky130_fd_sc_hd__mux2_1
XANTENNA__07275__B _03536_ vssd1 vssd1 vccd1 vccd1 sky130_fd_sc_hd__diode_2
XFILLER_66_418 vssd1 vssd1 vccd1 vccd1 sky130_fd_sc_hd__fill_2
Xfanout280 net285 vssd1 vssd1 vccd1 vccd1 net280 sky130_fd_sc_hd__buf_2
XFILLER_120_386 vssd1 vssd1 vccd1 vccd1 sky130_fd_sc_hd__fill_8
Xfanout291 net295 vssd1 vssd1 vccd1 vccd1 net291 sky130_fd_sc_hd__clkbuf_4
XANTENNA__11274__CLK net789 vssd1 vssd1 vccd1 vccd1 sky130_fd_sc_hd__diode_2
XANTENNA__07291__A FPGA_INST.bus3_1\[3\] vssd1 vssd1 vccd1 vccd1 sky130_fd_sc_hd__diode_2
XFILLER_74_473 vssd1 vssd1 vccd1 vccd1 sky130_fd_sc_hd__fill_1
XFILLER_19_389 vssd1 vssd1 vccd1 vccd1 sky130_fd_sc_hd__fill_1
XTAP_TAPCELL_ROW_17_524 vssd1 vccd1 sky130_fd_sc_hd__tapvpwrvgnd_1
XTAP_TAPCELL_ROW_83_1441 vssd1 vccd1 sky130_fd_sc_hd__tapvpwrvgnd_1
X_11708_ net920 _01054_ net704 vssd1 vssd1 vccd1 vccd1 FPGA_INST.cell3.SB0.route_sel\[78\]
+ sky130_fd_sc_hd__dfstp_1
XANTENNA__06836__A1 FPGA_INST.bus2_0\[3\] vssd1 vssd1 vccd1 vccd1 sky130_fd_sc_hd__diode_2
X_11639_ net893 _00985_ net677 vssd1 vssd1 vccd1 vccd1 FPGA_INST.cell3.SB0.route_sel\[9\]
+ sky130_fd_sc_hd__dfstp_1
XFILLER_128_486 vssd1 vssd1 vccd1 vccd1 sky130_fd_sc_hd__fill_4
XFILLER_7_794 vssd1 vssd1 vccd1 vccd1 sky130_fd_sc_hd__fill_1
XFILLER_6_282 vssd1 vssd1 vccd1 vccd1 sky130_fd_sc_hd__fill_4
XFILLER_124_670 vssd1 vssd1 vccd1 vccd1 sky130_fd_sc_hd__fill_1
XTAP_TAPCELL_ROW_94_1592 vssd1 vccd1 sky130_fd_sc_hd__tapvpwrvgnd_1
X_08850_ FPGA_INST.cell3.CB_0.config_dataB\[13\] _05052_ _05056_ _05048_ vssd1 vssd1
+ vccd1 vccd1 _05057_ sky130_fd_sc_hd__a31o_1
XFILLER_85_716 vccd1 vssd1 vccd1 vssd1 sky130_ef_sc_hd__decap_40_12
XANTENNA__07564__A2 _03447_ vssd1 vssd1 vccd1 vccd1 sky130_fd_sc_hd__diode_2
X_07801_ _03549_ _03913_ _04049_ vssd1 vssd1 vccd1 vccd1 _04050_ sky130_fd_sc_hd__o21ai_1
XFILLER_57_418 vssd1 vssd1 vccd1 vccd1 sky130_fd_sc_hd__fill_1
X_08781_ _04794_ _04974_ _04975_ _04789_ FPGA_INST.cell3.CB_0.config_dataB\[7\] vssd1
+ vssd1 vccd1 vccd1 _04988_ sky130_fd_sc_hd__a221o_1
XANTENNA__06772__B1 _03045_ vssd1 vssd1 vccd1 vccd1 sky130_fd_sc_hd__diode_2
X_05993_ _01782_ _01918_ _02174_ _02257_ _02272_ vssd1 vssd1 vccd1 vccd1 _02273_ sky130_fd_sc_hd__o32a_1
X_07732_ _03982_ _03980_ vssd1 vssd1 vccd1 vccd1 FPGA_INST.bus3_2\[13\] sky130_fd_sc_hd__and2b_2
XFILLER_38_643 vssd1 vssd1 vccd1 vccd1 sky130_fd_sc_hd__fill_1
XFILLER_38_654 vssd1 vssd1 vccd1 vccd1 sky130_fd_sc_hd__fill_4
X_07663_ _03399_ _03913_ FPGA_INST.bus3_1\[12\] vssd1 vssd1 vccd1 vccd1 _03915_ sky130_fd_sc_hd__o21ai_1
XFILLER_25_304 vssd1 vssd1 vccd1 vccd1 sky130_fd_sc_hd__fill_1
XFILLER_37_164 vssd1 vssd1 vccd1 vccd1 sky130_fd_sc_hd__fill_4
XFILLER_111_27 vssd1 vssd1 vccd1 vccd1 sky130_fd_sc_hd__fill_8
X_06614_ FPGA_INST.cell2.CB_1.config_dataA\[12\] _02889_ FPGA_INST.cell2.CB_1.config_dataA\[13\]
+ vssd1 vssd1 vccd1 vccd1 _02890_ sky130_fd_sc_hd__a21oi_1
XFILLER_25_326 vssd1 vssd1 vccd1 vccd1 sky130_fd_sc_hd__fill_1
X_09402_ FPGA_INST.cell2.CB_0.config_dataB\[21\] FPGA_INST.cell2.CB_0.config_dataB\[20\]
+ net355 vssd1 vssd1 vccd1 vccd1 _00315_ sky130_fd_sc_hd__mux2_1
X_07594_ _03499_ _03748_ FPGA_INST.bus3_1\[10\] vssd1 vssd1 vccd1 vccd1 _03848_ sky130_fd_sc_hd__o21a_1
X_09333_ FPGA_INST.cell1.SB0.route_sel\[104\] FPGA_INST.cell1.SB0.route_sel\[105\]
+ net221 vssd1 vssd1 vccd1 vccd1 _00246_ sky130_fd_sc_hd__mux2_1
XFILLER_53_668 vssd1 vssd1 vccd1 vccd1 sky130_fd_sc_hd__fill_1
XANTENNA__08744__B net79 vssd1 vssd1 vccd1 vccd1 sky130_fd_sc_hd__diode_2
XANTENNA_fanout338_A net341 vssd1 vssd1 vccd1 vccd1 sky130_fd_sc_hd__diode_2
X_06545_ FPGA_INST.cell2.SB0.route_sel\[108\] FPGA_INST.cell2.SB0.route_sel\[109\]
+ vssd1 vssd1 vccd1 vccd1 _02821_ sky130_fd_sc_hd__nor2_1
XANTENNA_fanout240_A net241 vssd1 vssd1 vccd1 vccd1 sky130_fd_sc_hd__diode_2
X_09264_ FPGA_INST.cell1.SB0.route_sel\[35\] FPGA_INST.cell1.SB0.route_sel\[36\] net215
+ vssd1 vssd1 vccd1 vccd1 _00177_ sky130_fd_sc_hd__mux2_1
X_06476_ net139 net128 net131 net102 FPGA_INST.cell2.LEI0.config_data\[39\] FPGA_INST.cell2.LEI0.config_data\[40\]
+ vssd1 vssd1 vccd1 vccd1 _02754_ sky130_fd_sc_hd__mux4_1
X_09195_ FPGA_INST.cell2.LE_1A.config_data\[13\] FPGA_INST.cell2.LE_1A.config_data\[12\]
+ net360 vssd1 vssd1 vccd1 vccd1 _00108_ sky130_fd_sc_hd__mux2_1
X_05427_ FPGA_INST.cell0.SB0.route_sel\[22\] vssd1 vssd1 vccd1 vccd1 _01709_ sky130_fd_sc_hd__inv_2
X_08215_ net115 net119 net111 net99 FPGA_INST.cell0.LEI0.config_data\[18\] FPGA_INST.cell0.LEI0.config_data\[19\]
+ vssd1 vssd1 vccd1 vccd1 _04439_ sky130_fd_sc_hd__mux4_1
X_08146_ FPGA_INST.cell1.LE_0B.config_data\[15\] FPGA_INST.cell1.LE_0B.config_data\[14\]
+ _04296_ vssd1 vssd1 vccd1 vccd1 _04372_ sky130_fd_sc_hd__mux2_1
XFILLER_107_615 vssd1 vssd1 vccd1 vccd1 sky130_fd_sc_hd__fill_1
XANTENNA__08044__A3 FPGA_INST.bus3_1\[7\] vssd1 vssd1 vccd1 vccd1 sky130_fd_sc_hd__diode_2
X_05358_ FPGA_INST.cell3.SB0.route_sel\[82\] vssd1 vssd1 vccd1 vccd1 _01640_ sky130_fd_sc_hd__inv_2
X_08077_ _03421_ _04300_ _04302_ _03475_ FPGA_INST.cell1.CB_0.config_dataB\[12\] vssd1
+ vssd1 vccd1 vccd1 _04303_ sky130_fd_sc_hd__a221o_1
XFILLER_20_35 vssd1 vssd1 vccd1 vccd1 sky130_fd_sc_hd__fill_1
X_05289_ FPGA_INST.cell2.SB0.route_sel\[80\] vssd1 vssd1 vccd1 vccd1 _01571_ sky130_fd_sc_hd__inv_2
XANTENNA__06055__A2 net171 vssd1 vssd1 vccd1 vccd1 sky130_fd_sc_hd__diode_2
XFILLER_122_618 vssd1 vssd1 vccd1 vccd1 sky130_fd_sc_hd__fill_1
XANTENNA__10139__A1 FPGA_INST.cell3.SB0.route_sel\[44\] vssd1 vssd1 vccd1 vccd1 sky130_fd_sc_hd__diode_2
X_07028_ _03293_ FPGA_INST.cell0.CB_0.config_dataA\[3\] _03288_ vssd1 vssd1 vccd1
+ vccd1 _03294_ sky130_fd_sc_hd__and3b_1
XTAP_TAPCELL_ROW_54_1042 vssd1 vccd1 sky130_fd_sc_hd__tapvpwrvgnd_1
XANTENNA__10006__S net319 vssd1 vssd1 vccd1 vccd1 sky130_fd_sc_hd__diode_2
XFILLER_0_447 vssd1 vssd1 vccd1 vccd1 sky130_fd_sc_hd__fill_1
XFILLER_29_33 vssd1 vssd1 vccd1 vccd1 sky130_fd_sc_hd__fill_2
XFILLER_102_386 vssd1 vssd1 vccd1 vccd1 sky130_fd_sc_hd__fill_1
X_08979_ _03677_ _03687_ _05159_ net330 vssd1 vssd1 vccd1 vccd1 FPGA_INST.bus1_0\[6\]
+ sky130_fd_sc_hd__a211oi_2
XFILLER_88_587 vssd1 vssd1 vccd1 vccd1 sky130_fd_sc_hd__fill_1
XANTENNA_fanout662_X net662 vssd1 vssd1 vccd1 vccd1 sky130_fd_sc_hd__diode_2
X_11990_ net774 _01336_ net560 vssd1 vssd1 vccd1 vccd1 FPGA_INST.cell2.SB0.route_sel\[30\]
+ sky130_fd_sc_hd__dfstp_1
XANTENNA__11471__RESET_B net732 vssd1 vssd1 vccd1 vccd1 sky130_fd_sc_hd__diode_2
XFILLER_29_654 vssd1 vssd1 vccd1 vccd1 sky130_fd_sc_hd__fill_8
XFILLER_90_218 vssd1 vssd1 vccd1 vccd1 sky130_fd_sc_hd__fill_2
XFILLER_44_624 vccd1 vssd1 vccd1 vssd1 sky130_ef_sc_hd__decap_40_12
X_10941_ net848 _00291_ net633 vssd1 vssd1 vccd1 vccd1 FPGA_INST.cell2.CB_0.config_dataA\[22\]
+ sky130_fd_sc_hd__dfstp_1
XANTENNA__07858__A3 FPGA_INST.bus3_1\[3\] vssd1 vssd1 vccd1 vccd1 sky130_fd_sc_hd__diode_2
XFILLER_83_281 vssd1 vssd1 vccd1 vccd1 sky130_fd_sc_hd__fill_8
XFILLER_45_32 vssd1 vssd1 vccd1 vccd1 sky130_fd_sc_hd__fill_4
XFILLER_43_134 vssd1 vssd1 vccd1 vccd1 sky130_fd_sc_hd__fill_2
X_10872_ net795 _00222_ net580 vssd1 vssd1 vccd1 vccd1 FPGA_INST.cell1.SB0.route_sel\[81\]
+ sky130_fd_sc_hd__dfstp_1
XANTENNA__05911__X _02191_ vssd1 vssd1 vccd1 vccd1 sky130_fd_sc_hd__diode_2
XTAP_TAPCELL_ROW_65_1193 vssd1 vccd1 sky130_fd_sc_hd__tapvpwrvgnd_1
XTAP_TAPCELL_ROW_42_869 vssd1 vccd1 sky130_fd_sc_hd__tapvpwrvgnd_1
XFILLER_6_15 vssd1 vssd1 vccd1 vccd1 sky130_fd_sc_hd__fill_2
XTAP_TAPCELL_ROW_22_593 vssd1 vccd1 sky130_fd_sc_hd__tapvpwrvgnd_1
X_11424_ net755 _00774_ net540 vssd1 vssd1 vccd1 vccd1 FPGA_INST.cell0.LEI0.config_data\[45\]
+ sky130_fd_sc_hd__dfrtp_1
XFILLER_125_445 vssd1 vssd1 vccd1 vccd1 sky130_fd_sc_hd__fill_2
X_11355_ net801 _00705_ net586 vssd1 vssd1 vccd1 vccd1 FPGA_INST.cell1.CB_1.config_dataA\[22\]
+ sky130_fd_sc_hd__dfstp_2
XANTENNA__07557__Y _03812_ vssd1 vssd1 vccd1 vccd1 sky130_fd_sc_hd__diode_2
X_10306_ FPGA_INST.cell3.LEI0.config_data\[20\] FPGA_INST.cell3.LEI0.config_data\[21\]
+ net297 vssd1 vssd1 vccd1 vccd1 _01187_ sky130_fd_sc_hd__mux2_1
X_11286_ net833 _00636_ net617 vssd1 vssd1 vccd1 vccd1 FPGA_INST.cell1.CB_0.config_dataA\[3\]
+ sky130_fd_sc_hd__dfstp_1
XFILLER_3_241 vssd1 vssd1 vccd1 vccd1 sky130_fd_sc_hd__fill_4
XFILLER_112_139 vssd1 vssd1 vccd1 vccd1 sky130_fd_sc_hd__fill_1
X_10237_ FPGA_INST.io_west_oeb\[26\] FPGA_INST.io_west_oeb\[28\] net292 vssd1 vssd1
+ vccd1 vccd1 _01118_ sky130_fd_sc_hd__mux2_1
X_10168_ FPGA_INST.cell3.SB0.route_sel\[72\] FPGA_INST.cell3.SB0.route_sel\[73\] net275
+ vssd1 vssd1 vccd1 vccd1 _01049_ sky130_fd_sc_hd__mux2_1
XFILLER_120_194 vssd1 vssd1 vccd1 vccd1 sky130_fd_sc_hd__fill_2
X_10099_ FPGA_INST.cell3.SB0.route_sel\[3\] FPGA_INST.cell3.SB0.route_sel\[4\] net272
+ vssd1 vssd1 vccd1 vccd1 _00980_ sky130_fd_sc_hd__mux2_1
XANTENNA__06349__B _02217_ vssd1 vssd1 vccd1 vccd1 sky130_fd_sc_hd__diode_2
XFILLER_19_175 vssd1 vssd1 vccd1 vccd1 sky130_fd_sc_hd__fill_1
XFILLER_90_752 vssd1 vssd1 vccd1 vccd1 sky130_fd_sc_hd__fill_4
XANTENNA__09440__S net374 vssd1 vssd1 vccd1 vccd1 sky130_fd_sc_hd__diode_2
XANTENNA__09012__Y FPGA_INST.bus3_1\[3\] vssd1 vssd1 vccd1 vccd1 sky130_fd_sc_hd__diode_2
X_06330_ _02609_ _02573_ _02571_ vssd1 vssd1 vccd1 vccd1 _02610_ sky130_fd_sc_hd__mux2_1
X_06261_ net503 FPGA_INST.cell2.CB_0.config_dataA\[11\] vssd1 vssd1 vccd1 vccd1 _02541_
+ sky130_fd_sc_hd__nor2_2
X_08000_ _04227_ _04224_ _04183_ vssd1 vssd1 vccd1 vccd1 _04228_ sky130_fd_sc_hd__mux2_1
XFILLER_129_795 vssd1 vssd1 vccd1 vccd1 sky130_fd_sc_hd__fill_1
XTAP_TAPCELL_ROW_96_1632 vssd1 vccd1 sky130_fd_sc_hd__tapvpwrvgnd_1
XTAP_TAPCELL_ROW_96_1621 vssd1 vccd1 sky130_fd_sc_hd__tapvpwrvgnd_1
X_06192_ _01946_ _02358_ vssd1 vssd1 vccd1 vccd1 _02472_ sky130_fd_sc_hd__or2_2
X_09951_ FPGA_INST.cell0.CB_1.config_dataB\[12\] net441 net311 vssd1 vssd1 vccd1 vccd1
+ _00856_ sky130_fd_sc_hd__mux2_1
X_08902_ FPGA_INST.cell3.LE_0B.dff0_out FPGA_INST.cell3.LE_0B.dff1_out FPGA_INST.cell3.LE_0B.reset_val
+ vssd1 vssd1 vccd1 vccd1 FPGA_INST.cell3.LE_0B.dff_out sky130_fd_sc_hd__mux2_1
XFILLER_103_139 vssd1 vssd1 vccd1 vccd1 sky130_fd_sc_hd__fill_2
X_09882_ FPGA_INST.cell0.LE_0A.config_data\[9\] FPGA_INST.cell0.LE_0A.config_data\[10\]
+ net192 vssd1 vssd1 vccd1 vccd1 _00789_ sky130_fd_sc_hd__mux2_1
X_08833_ FPGA_INST.cell3.CB_0.config_dataB\[11\] _05035_ _05039_ FPGA_INST.cell3.CB_0.config_dataB\[12\]
+ vssd1 vssd1 vccd1 vccd1 _05040_ sky130_fd_sc_hd__a211o_1
XANTENNA_fanout190_A net202 vssd1 vssd1 vccd1 vccd1 sky130_fd_sc_hd__diode_2
XPHY_EDGE_ROW_29_Left_160 vssd1 vssd1 vccd1 vccd1 sky130_fd_sc_hd__decap_3
XANTENNA__08739__B _04804_ vssd1 vssd1 vccd1 vccd1 sky130_fd_sc_hd__diode_2
XANTENNA_fanout288_A net295 vssd1 vssd1 vccd1 vccd1 sky130_fd_sc_hd__diode_2
X_08764_ _01772_ FPGA_INST.cell3.LE_0A.dff_out vssd1 vssd1 vccd1 vccd1 _04972_ sky130_fd_sc_hd__or2_1
X_05976_ net507 _02255_ _02218_ net505 vssd1 vssd1 vccd1 vccd1 _02256_ sky130_fd_sc_hd__o211a_1
XTAP_TAPCELL_ROW_123_2006 vssd1 vccd1 sky130_fd_sc_hd__tapvpwrvgnd_1
XFILLER_122_26 vssd1 vssd1 vccd1 vccd1 sky130_fd_sc_hd__fill_2
X_07715_ _03960_ _03962_ _03963_ _03965_ vssd1 vssd1 vccd1 vccd1 _03966_ sky130_fd_sc_hd__a211o_1
XANTENNA__06760__A3 FPGA_INST.bus3_2\[3\] vssd1 vssd1 vccd1 vccd1 sky130_fd_sc_hd__diode_2
X_08695_ _04843_ _04895_ _04896_ _04846_ vssd1 vssd1 vccd1 vccd1 _04904_ sky130_fd_sc_hd__a22oi_1
XTAP_TAPCELL_ROW_105_1750 vssd1 vccd1 sky130_fd_sc_hd__tapvpwrvgnd_1
X_07646_ _03578_ _03781_ vssd1 vssd1 vccd1 vccd1 _03899_ sky130_fd_sc_hd__or2_1
XFILLER_81_785 vssd1 vssd1 vccd1 vccd1 sky130_fd_sc_hd__fill_1
XTAP_TAPCELL_ROW_0_266 vssd1 vccd1 sky130_fd_sc_hd__tapvpwrvgnd_1
XTAP_TAPCELL_ROW_0_277 vssd1 vccd1 sky130_fd_sc_hd__tapvpwrvgnd_1
XTAP_TAPCELL_ROW_0_288 vssd1 vccd1 sky130_fd_sc_hd__tapvpwrvgnd_1
XFILLER_25_167 vssd1 vssd1 vccd1 vccd1 sky130_fd_sc_hd__fill_1
XANTENNA_fanout622_A net626 vssd1 vssd1 vccd1 vccd1 sky130_fd_sc_hd__diode_2
X_07577_ net83 _03526_ _03775_ _03829_ _03830_ vssd1 vssd1 vccd1 vccd1 _03831_ sky130_fd_sc_hd__o311a_1
XANTENNA__06512__A3 FPGA_INST.bus3_2\[3\] vssd1 vssd1 vccd1 vccd1 sky130_fd_sc_hd__diode_2
XFILLER_41_649 vssd1 vssd1 vccd1 vccd1 sky130_fd_sc_hd__fill_1
XANTENNA__12013__SET_B net563 vssd1 vssd1 vccd1 vccd1 sky130_fd_sc_hd__diode_2
X_09316_ FPGA_INST.cell1.SB0.route_sel\[88\] FPGA_INST.cell1.SB0.route_sel\[87\] net328
+ vssd1 vssd1 vccd1 vccd1 _00229_ sky130_fd_sc_hd__mux2_1
X_06528_ net352 _02321_ _02326_ _02803_ vssd1 vssd1 vccd1 vccd1 _02804_ sky130_fd_sc_hd__or4b_4
XANTENNA__11889__Q FPGA_INST.cell3.LE_0A.reset_mode vssd1 vssd1 vccd1 vccd1 sky130_fd_sc_hd__diode_2
X_09247_ FPGA_INST.cell1.SB0.route_sel\[18\] FPGA_INST.cell1.SB0.route_sel\[19\] net224
+ vssd1 vssd1 vccd1 vccd1 _00160_ sky130_fd_sc_hd__mux2_1
XFILLER_21_340 vssd1 vssd1 vccd1 vccd1 sky130_fd_sc_hd__fill_1
X_06459_ net30 _02729_ _02735_ net487 _02736_ vssd1 vssd1 vccd1 vccd1 _02737_ sky130_fd_sc_hd__a221o_1
XFILLER_21_395 vssd1 vssd1 vccd1 vccd1 sky130_fd_sc_hd__fill_1
XFILLER_5_528 vssd1 vssd1 vccd1 vccd1 sky130_fd_sc_hd__fill_1
X_09178_ FPGA_INST.cell2.LE_0B.reset_val FPGA_INST.cell2.LE_0B.reset_mode net258 vssd1
+ vssd1 vccd1 vccd1 _00092_ sky130_fd_sc_hd__mux2_1
X_08129_ _04353_ _04354_ FPGA_INST.cell1.CB_0.config_dataB\[17\] vssd1 vssd1 vccd1
+ vccd1 _04355_ sky130_fd_sc_hd__mux2_1
X_11140_ net817 _00490_ net602 vssd1 vssd1 vccd1 vccd1 FPGA_INST.cell1.CB_1.config_dataB\[10\]
+ sky130_fd_sc_hd__dfstp_1
XANTENNA__05619__A net129 vssd1 vssd1 vccd1 vccd1 sky130_fd_sc_hd__diode_2
Xoutput34 net34 vssd1 vssd1 vccd1 vccd1 gpio_oeb[15] sky130_fd_sc_hd__buf_2
Xoutput67 net67 vssd1 vssd1 vccd1 vccd1 gpio_out[32] sky130_fd_sc_hd__buf_2
Xoutput45 net45 vssd1 vssd1 vccd1 vccd1 gpio_out[10] sky130_fd_sc_hd__buf_2
Xoutput56 net56 vssd1 vssd1 vccd1 vccd1 gpio_out[21] sky130_fd_sc_hd__buf_2
X_11071_ net838 _00421_ net622 vssd1 vssd1 vccd1 vccd1 FPGA_INST.cell1.LE_0A.config_data\[6\]
+ sky130_fd_sc_hd__dfrtp_1
XANTENNA__08725__A1 net26 vssd1 vssd1 vccd1 vccd1 sky130_fd_sc_hd__diode_2
XANTENNA__07393__X _03652_ vssd1 vssd1 vccd1 vccd1 sky130_fd_sc_hd__diode_2
XTAP_TAPCELL_ROW_8_388 vssd1 vccd1 sky130_fd_sc_hd__tapvpwrvgnd_1
XANTENNA__06736__A0 _02784_ vssd1 vssd1 vccd1 vccd1 sky130_fd_sc_hd__diode_2
XTAP_TAPCELL_ROW_8_399 vssd1 vccd1 sky130_fd_sc_hd__tapvpwrvgnd_1
XFILLER_0_277 vssd1 vssd1 vccd1 vccd1 sky130_fd_sc_hd__fill_2
X_10022_ FPGA_INST.cell0.CB_0.config_dataA\[21\] FPGA_INST.cell0.CB_0.config_dataA\[22\]
+ net191 vssd1 vssd1 vccd1 vccd1 _00903_ sky130_fd_sc_hd__mux2_1
XFILLER_56_20 vssd1 vssd1 vccd1 vccd1 sky130_fd_sc_hd__fill_4
XTAP_TAPCELL_ROW_47_939 vssd1 vccd1 sky130_fd_sc_hd__tapvpwrvgnd_1
XANTENNA_input16_A gpio_in[23] vssd1 vssd1 vccd1 vccd1 sky130_fd_sc_hd__diode_2
XTAP_TAPCELL_ROW_67_1222 vssd1 vccd1 sky130_fd_sc_hd__tapvpwrvgnd_1
X_11973_ net844 _01319_ net630 vssd1 vssd1 vccd1 vccd1 FPGA_INST.cell2.SB0.route_sel\[13\]
+ sky130_fd_sc_hd__dfstp_1
XFILLER_29_495 vssd1 vssd1 vccd1 vccd1 sky130_fd_sc_hd__fill_8
XPHY_EDGE_ROW_113_Right_113 vssd1 vssd1 vccd1 vccd1 sky130_fd_sc_hd__decap_3
X_10924_ net851 _00274_ net636 vssd1 vssd1 vccd1 vccd1 FPGA_INST.cell2.CB_0.config_dataA\[5\]
+ sky130_fd_sc_hd__dfstp_1
X_10855_ net824 _00205_ net608 vssd1 vssd1 vccd1 vccd1 FPGA_INST.cell1.SB0.route_sel\[64\]
+ sky130_fd_sc_hd__dfstp_1
XTAP_TAPCELL_ROW_80_1400 vssd1 vccd1 sky130_fd_sc_hd__tapvpwrvgnd_1
XTAP_TAPCELL_ROW_27_663 vssd1 vccd1 sky130_fd_sc_hd__tapvpwrvgnd_1
XANTENNA__08384__B _04040_ vssd1 vssd1 vccd1 vccd1 sky130_fd_sc_hd__diode_2
XANTENNA__08952__X FPGA_INST.bus1_0\[9\] vssd1 vssd1 vccd1 vccd1 sky130_fd_sc_hd__diode_2
XANTENNA__08256__A3 FPGA_INST.bus1_0\[15\] vssd1 vssd1 vccd1 vccd1 sky130_fd_sc_hd__diode_2
X_10786_ net900 _00136_ net684 vssd1 vssd1 vccd1 vccd1 FPGA_INST.cell2.CB_1.config_dataB\[20\]
+ sky130_fd_sc_hd__dfstp_1
XFILLER_12_362 vssd1 vssd1 vccd1 vccd1 sky130_fd_sc_hd__fill_2
XFILLER_12_373 vssd1 vssd1 vccd1 vccd1 sky130_fd_sc_hd__fill_2
XFILLER_126_710 vssd1 vssd1 vccd1 vccd1 sky130_fd_sc_hd__fill_1
XANTENNA__07216__A1 net133 vssd1 vssd1 vccd1 vccd1 sky130_fd_sc_hd__diode_2
X_11407_ net750 _00757_ net535 vssd1 vssd1 vccd1 vccd1 FPGA_INST.cell0.LEI0.config_data\[28\]
+ sky130_fd_sc_hd__dfrtp_1
XFILLER_126_776 vssd1 vssd1 vccd1 vccd1 sky130_fd_sc_hd__fill_2
X_11338_ net805 _00688_ net590 vssd1 vssd1 vccd1 vccd1 FPGA_INST.cell1.CB_1.config_dataA\[5\]
+ sky130_fd_sc_hd__dfstp_1
XTAP_TAPCELL_ROW_78_1373 vssd1 vccd1 sky130_fd_sc_hd__tapvpwrvgnd_1
XANTENNA__10220__A0 FPGA_INST.cell3.SB0.route_sel\[125\] vssd1 vssd1 vccd1 vccd1 sky130_fd_sc_hd__diode_2
XTAP_TAPCELL_ROW_91_1562 vssd1 vccd1 sky130_fd_sc_hd__tapvpwrvgnd_1
XTAP_TAPCELL_ROW_91_1551 vssd1 vccd1 sky130_fd_sc_hd__tapvpwrvgnd_1
X_11269_ net784 _00619_ net569 vssd1 vssd1 vccd1 vccd1 FPGA_INST.cell0.SB0.route_sel\[114\]
+ sky130_fd_sc_hd__dfstp_1
XFILLER_39_215 vssd1 vssd1 vccd1 vccd1 sky130_fd_sc_hd__fill_2
XFILLER_94_343 vssd1 vssd1 vccd1 vccd1 sky130_fd_sc_hd__fill_1
XANTENNA__08192__A2 _03504_ vssd1 vssd1 vccd1 vccd1 sky130_fd_sc_hd__diode_2
XFILLER_11_3 vssd1 vssd1 vccd1 vccd1 sky130_fd_sc_hd__fill_4
X_05830_ _02109_ vssd1 vssd1 vccd1 vccd1 _02110_ sky130_fd_sc_hd__inv_2
XFILLER_82_549 vssd1 vssd1 vccd1 vccd1 sky130_fd_sc_hd__fill_8
X_05761_ net103 _02038_ _02040_ vssd1 vssd1 vccd1 vccd1 _02041_ sky130_fd_sc_hd__a21oi_1
X_07500_ FPGA_INST.cell0.SB0.route_sel\[69\] FPGA_INST.cell0.SB0.route_sel\[68\] vssd1
+ vssd1 vccd1 vccd1 _03756_ sky130_fd_sc_hd__or2_1
XFILLER_35_410 vssd1 vssd1 vccd1 vccd1 sky130_fd_sc_hd__fill_1
X_08480_ FPGA_INST.cell1.CB_1.config_dataB\[13\] FPGA_INST.cell1.CB_1.config_dataB\[12\]
+ FPGA_INST.cell1.CB_1.config_dataB\[11\] FPGA_INST.cell1.CB_1.config_dataB\[10\]
+ vssd1 vssd1 vccd1 vccd1 _04696_ sky130_fd_sc_hd__or4b_1
X_05692_ FPGA_INST.cell0.CB_1.config_dataB\[24\] FPGA_INST.cell0.CB_1.config_dataB\[21\]
+ FPGA_INST.cell0.CB_1.config_dataB\[20\] vssd1 vssd1 vccd1 vccd1 _01972_ sky130_fd_sc_hd__or3b_2
X_07431_ FPGA_INST.cell1.SB0.route_sel\[50\] FPGA_INST.cell1.SB0.route_sel\[51\] _01676_
+ FPGA_INST.cell1.SB0.route_sel\[54\] _03688_ vssd1 vssd1 vccd1 vccd1 _03689_ sky130_fd_sc_hd__o221a_1
XANTENNA__09170__S net358 vssd1 vssd1 vccd1 vccd1 sky130_fd_sc_hd__diode_2
X_07362_ FPGA_INST.cell3.CB_0.config_dataA\[23\] FPGA_INST.cell3.CB_0.config_dataA\[22\]
+ vssd1 vssd1 vccd1 vccd1 _03622_ sky130_fd_sc_hd__nand2b_1
X_06313_ _01535_ _02588_ _02589_ _02591_ _02592_ vssd1 vssd1 vccd1 vccd1 _02593_ sky130_fd_sc_hd__o32a_1
X_09101_ FPGA_INST.cell2.LEI0.config_data\[15\] FPGA_INST.cell2.LEI0.config_data\[16\]
+ net267 vssd1 vssd1 vccd1 vccd1 _00017_ sky130_fd_sc_hd__mux2_1
XTAP_TAPCELL_ROW_100_1680 vssd1 vccd1 sky130_fd_sc_hd__tapvpwrvgnd_1
X_07293_ FPGA_INST.cell1.SB0.route_sel\[24\] FPGA_INST.cell1.SB0.route_sel\[25\] vssd1
+ vssd1 vccd1 vccd1 _03554_ sky130_fd_sc_hd__nand2_1
X_09032_ FPGA_INST.cell1.SB0.route_sel\[3\] _01721_ FPGA_INST.cell1.SB0.route_sel\[0\]
+ FPGA_INST.cell1.SB0.route_sel\[1\] _05194_ vssd1 vssd1 vccd1 vccd1 _05195_ sky130_fd_sc_hd__o221a_1
X_06244_ net509 _01914_ vssd1 vssd1 vccd1 vccd1 _02524_ sky130_fd_sc_hd__nand2_1
X_06175_ net167 net157 FPGA_INST.bus1_0\[0\] vssd1 vssd1 vccd1 vccd1 _02455_ sky130_fd_sc_hd__o21ai_1
XFILLER_117_15 vccd1 vssd1 vccd1 vssd1 sky130_ef_sc_hd__decap_40_12
Xfanout813 net820 vssd1 vssd1 vccd1 vccd1 net813 sky130_fd_sc_hd__clkbuf_2
Xfanout802 net803 vssd1 vssd1 vccd1 vccd1 net802 sky130_fd_sc_hd__clkbuf_2
Xfanout824 net825 vssd1 vssd1 vccd1 vccd1 net824 sky130_fd_sc_hd__clkbuf_2
XTAP_TAPCELL_ROW_51_1001 vssd1 vccd1 sky130_fd_sc_hd__tapvpwrvgnd_1
X_09934_ FPGA_INST.cell0.LE_1A.config_data\[15\] FPGA_INST.cell0.LE_1A.config_data\[16\]
+ net175 vssd1 vssd1 vccd1 vccd1 _00839_ sky130_fd_sc_hd__mux2_1
Xfanout835 net837 vssd1 vssd1 vccd1 vccd1 net835 sky130_fd_sc_hd__buf_1
XANTENNA__11063__RESET_B net732 vssd1 vssd1 vccd1 vccd1 sky130_fd_sc_hd__diode_2
Xfanout857 net861 vssd1 vssd1 vccd1 vccd1 net857 sky130_fd_sc_hd__clkbuf_2
Xfanout846 net849 vssd1 vssd1 vccd1 vccd1 net846 sky130_fd_sc_hd__clkbuf_2
XANTENNA_input8_A gpio_in[16] vssd1 vssd1 vccd1 vccd1 sky130_fd_sc_hd__diode_2
X_09865_ FPGA_INST.cell0.LEI0.config_data\[43\] FPGA_INST.cell0.LEI0.config_data\[44\]
+ net179 vssd1 vssd1 vccd1 vccd1 _00773_ sky130_fd_sc_hd__mux2_1
XFILLER_100_643 vssd1 vssd1 vccd1 vccd1 sky130_fd_sc_hd__fill_1
X_08816_ _03980_ _04812_ _05006_ vssd1 vssd1 vccd1 vccd1 _05023_ sky130_fd_sc_hd__a21oi_1
Xfanout879 net882 vssd1 vssd1 vccd1 vccd1 net879 sky130_fd_sc_hd__buf_1
XANTENNA__08183__A2 net112 vssd1 vssd1 vccd1 vccd1 sky130_fd_sc_hd__diode_2
XTAP_TAPCELL_ROW_5_358 vssd1 vccd1 sky130_fd_sc_hd__tapvpwrvgnd_1
XTAP_TAPCELL_ROW_5_347 vssd1 vccd1 sky130_fd_sc_hd__tapvpwrvgnd_1
Xfanout868 net892 vssd1 vssd1 vccd1 vccd1 net868 sky130_fd_sc_hd__clkbuf_2
XANTENNA__07930__A2 FPGA_INST.bus3_1\[6\] vssd1 vssd1 vccd1 vccd1 sky130_fd_sc_hd__diode_2
XFILLER_93_29 vssd1 vssd1 vccd1 vccd1 sky130_fd_sc_hd__fill_8
X_09796_ FPGA_INST.cell1.CB_1.config_dataA\[21\] FPGA_INST.cell1.CB_1.config_dataA\[22\]
+ net207 vssd1 vssd1 vccd1 vccd1 _00705_ sky130_fd_sc_hd__mux2_1
XANTENNA__06733__A3 FPGA_INST.bus3_2\[7\] vssd1 vssd1 vccd1 vccd1 sky130_fd_sc_hd__diode_2
XFILLER_39_760 vssd1 vssd1 vccd1 vccd1 sky130_fd_sc_hd__fill_8
XANTENNA_fanout837_A net843 vssd1 vssd1 vccd1 vccd1 sky130_fd_sc_hd__diode_2
X_08747_ FPGA_INST.cell3.LEI0.config_data\[37\] _04955_ vssd1 vssd1 vccd1 vccd1 _04956_
+ sky130_fd_sc_hd__nor2_1
XFILLER_85_387 vssd1 vssd1 vccd1 vccd1 sky130_fd_sc_hd__fill_4
X_05959_ _01845_ _02198_ vssd1 vssd1 vccd1 vccd1 _02239_ sky130_fd_sc_hd__nor2_1
XANTENNA__09132__A1 FPGA_INST.cell2.CB_0.config_data_inA vssd1 vssd1 vccd1 vccd1 sky130_fd_sc_hd__diode_2
X_08678_ FPGA_INST.cell3.LEI0.config_data\[12\] net80 vssd1 vssd1 vccd1 vccd1 _04887_
+ sky130_fd_sc_hd__nand2_1
XFILLER_54_774 vssd1 vssd1 vccd1 vccd1 sky130_fd_sc_hd__fill_1
XFILLER_26_465 vssd1 vssd1 vccd1 vccd1 sky130_fd_sc_hd__fill_8
X_07629_ _03549_ _03748_ FPGA_INST.bus3_1\[11\] vssd1 vssd1 vccd1 vccd1 _03882_ sky130_fd_sc_hd__o21ai_1
X_10640_ FPGA_INST.cell3.LE_1B.config_data\[9\] FPGA_INST.cell3.LE_1B.config_data\[10\]
+ net279 vssd1 vssd1 vccd1 vccd1 _01519_ sky130_fd_sc_hd__mux2_1
XTAP_TAPCELL_ROW_24_622 vssd1 vccd1 sky130_fd_sc_hd__tapvpwrvgnd_1
XTAP_TAPCELL_ROW_62_1152 vssd1 vccd1 sky130_fd_sc_hd__tapvpwrvgnd_1
X_10571_ net395 net393 net284 vssd1 vssd1 vccd1 vccd1 _01450_ sky130_fd_sc_hd__mux2_1
XANTENNA__06249__A2 net16 vssd1 vssd1 vccd1 vccd1 sky130_fd_sc_hd__diode_2
XTAP_TAPCELL_ROW_118_1930 vssd1 vccd1 sky130_fd_sc_hd__tapvpwrvgnd_1
XTAP_TAPCELL_ROW_118_1941 vssd1 vccd1 sky130_fd_sc_hd__tapvpwrvgnd_1
X_12172_ net909 _01518_ net693 vssd1 vssd1 vccd1 vccd1 FPGA_INST.cell3.LE_1B.config_data\[9\]
+ sky130_fd_sc_hd__dfrtp_1
X_11123_ net794 _00473_ net579 vssd1 vssd1 vccd1 vccd1 FPGA_INST.cell1.LE_1A.config_data\[14\]
+ sky130_fd_sc_hd__dfrtp_1
XANTENNA__06421__A2 net11 vssd1 vssd1 vccd1 vccd1 sky130_fd_sc_hd__diode_2
XFILLER_122_267 vssd1 vssd1 vccd1 vccd1 sky130_fd_sc_hd__fill_8
XFILLER_107_81 vssd1 vssd1 vccd1 vccd1 sky130_fd_sc_hd__fill_4
X_11054_ net814 _00404_ net599 vssd1 vssd1 vccd1 vccd1 FPGA_INST.cell1.LEI0.config_data\[39\]
+ sky130_fd_sc_hd__dfrtp_1
XFILLER_67_30 vssd1 vssd1 vccd1 vccd1 sky130_fd_sc_hd__fill_1
XFILLER_1_586 vssd1 vssd1 vccd1 vccd1 sky130_fd_sc_hd__fill_1
XFILLER_76_343 vssd1 vssd1 vccd1 vccd1 sky130_fd_sc_hd__fill_1
X_10005_ FPGA_INST.cell0.CB_0.config_dataA\[4\] net433 net191 vssd1 vssd1 vccd1 vccd1
+ _00886_ sky130_fd_sc_hd__mux2_1
XANTENNA__10698__Q FPGA_INST.cell2.CB_0.config_data_inA vssd1 vssd1 vccd1 vccd1 sky130_fd_sc_hd__diode_2
XANTENNA_input19_X net19 vssd1 vssd1 vccd1 vccd1 sky130_fd_sc_hd__diode_2
XFILLER_91_335 vssd1 vssd1 vccd1 vccd1 sky130_fd_sc_hd__fill_1
XFILLER_29_281 vssd1 vssd1 vccd1 vccd1 sky130_fd_sc_hd__fill_1
X_11956_ net908 _01302_ net692 vssd1 vssd1 vccd1 vccd1 FPGA_INST.cell3.CB_1.config_dataB\[21\]
+ sky130_fd_sc_hd__dfstp_1
XFILLER_91_346 vssd1 vssd1 vccd1 vccd1 sky130_fd_sc_hd__fill_2
X_10907_ net827 _00257_ net611 vssd1 vssd1 vccd1 vccd1 FPGA_INST.cell1.SB0.route_sel\[116\]
+ sky130_fd_sc_hd__dfstp_1
XFILLER_45_796 vssd1 vssd1 vccd1 vccd1 sky130_fd_sc_hd__fill_2
XFILLER_45_785 vssd1 vssd1 vccd1 vccd1 sky130_fd_sc_hd__fill_2
XFILLER_44_251 vssd1 vssd1 vccd1 vccd1 sky130_fd_sc_hd__fill_1
X_11887_ net927 _01233_ net711 vssd1 vssd1 vccd1 vccd1 FPGA_INST.cell3.LE_0A.edge_mode
+ sky130_fd_sc_hd__dfstp_1
XFILLER_60_755 vssd1 vssd1 vccd1 vccd1 sky130_fd_sc_hd__fill_1
X_10838_ net800 _00188_ net585 vssd1 vssd1 vccd1 vccd1 FPGA_INST.cell1.SB0.route_sel\[47\]
+ sky130_fd_sc_hd__dfstp_1
X_10769_ net887 _00119_ net671 vssd1 vssd1 vccd1 vccd1 FPGA_INST.cell2.CB_1.config_dataB\[3\]
+ sky130_fd_sc_hd__dfstp_1
XANTENNA__08842__B _04785_ vssd1 vssd1 vccd1 vccd1 sky130_fd_sc_hd__diode_2
XFILLER_59_3 vssd1 vssd1 vccd1 vccd1 sky130_fd_sc_hd__fill_2
XANTENNA__06660__A2 _02796_ vssd1 vssd1 vccd1 vccd1 sky130_fd_sc_hd__diode_2
XANTENNA__08401__A3 FPGA_INST.bus1_0\[3\] vssd1 vssd1 vccd1 vccd1 sky130_fd_sc_hd__diode_2
XFILLER_114_757 vssd1 vssd1 vccd1 vccd1 sky130_fd_sc_hd__fill_4
X_07980_ net463 _04049_ vssd1 vssd1 vccd1 vccd1 _04208_ sky130_fd_sc_hd__nand2_1
XFILLER_101_407 vssd1 vssd1 vccd1 vccd1 sky130_fd_sc_hd__fill_2
XANTENNA__09018__X FPGA_INST.bus2_0\[2\] vssd1 vssd1 vccd1 vccd1 sky130_fd_sc_hd__diode_2
X_06931_ net414 net415 vssd1 vssd1 vccd1 vccd1 _03199_ sky130_fd_sc_hd__and2b_1
XANTENNA__11992__Q FPGA_INST.cell2.SB0.route_sel\[32\] vssd1 vssd1 vccd1 vccd1 sky130_fd_sc_hd__diode_2
XFILLER_67_343 vssd1 vssd1 vccd1 vccd1 sky130_fd_sc_hd__fill_1
X_09650_ FPGA_INST.cell0.SB0.route_sel\[53\] FPGA_INST.cell0.SB0.route_sel\[54\] net179
+ vssd1 vssd1 vccd1 vccd1 _00559_ sky130_fd_sc_hd__mux2_1
X_08601_ _03943_ _04808_ _04796_ vssd1 vssd1 vccd1 vccd1 _04810_ sky130_fd_sc_hd__a21oi_1
XFILLER_67_365 vssd1 vssd1 vccd1 vccd1 sky130_fd_sc_hd__fill_2
XTAP_TAPCELL_ROW_2_317 vssd1 vccd1 sky130_fd_sc_hd__tapvpwrvgnd_1
XTAP_TAPCELL_ROW_2_306 vssd1 vccd1 sky130_fd_sc_hd__tapvpwrvgnd_1
X_06862_ net423 net424 vssd1 vssd1 vccd1 vccd1 _03130_ sky130_fd_sc_hd__nand2b_1
X_09581_ FPGA_INST.cell1.CB_1.config_dataB\[9\] FPGA_INST.cell1.CB_1.config_dataB\[10\]
+ net218 vssd1 vssd1 vccd1 vccd1 _00490_ sky130_fd_sc_hd__mux2_1
XFILLER_103_28 vssd1 vssd1 vccd1 vccd1 sky130_fd_sc_hd__fill_4
XANTENNA__08576__Y _04785_ vssd1 vssd1 vccd1 vccd1 sky130_fd_sc_hd__diode_2
X_06793_ FPGA_INST.bus3_2\[0\] FPGA_INST.bus3_2\[1\] FPGA_INST.bus3_2\[2\] FPGA_INST.bus3_2\[3\]
+ FPGA_INST.cell2.CB_1.config_dataB\[15\] net511 vssd1 vssd1 vccd1 vccd1 _03067_ sky130_fd_sc_hd__mux4_1
XANTENNA__05923__A1 FPGA_INST.bus3_2\[7\] vssd1 vssd1 vccd1 vccd1 sky130_fd_sc_hd__diode_2
X_05813_ net507 _02092_ vssd1 vssd1 vccd1 vccd1 _02093_ sky130_fd_sc_hd__nand2_1
X_08532_ _04744_ _04743_ _04721_ vssd1 vssd1 vccd1 vccd1 _04745_ sky130_fd_sc_hd__mux2_1
X_05744_ net116 _01814_ _02012_ FPGA_INST.cell0.SB0.route_sel\[81\] FPGA_INST.cell0.SB0.route_sel\[80\]
+ vssd1 vssd1 vccd1 vccd1 _02024_ sky130_fd_sc_hd__a32o_1
X_08463_ _04680_ _04679_ _04656_ vssd1 vssd1 vccd1 vccd1 _04681_ sky130_fd_sc_hd__mux2_1
XANTENNA__07676__A1 net148 vssd1 vssd1 vccd1 vccd1 sky130_fd_sc_hd__diode_2
XFILLER_36_796 vssd1 vssd1 vccd1 vccd1 sky130_fd_sc_hd__fill_1
X_07414_ net81 _03526_ _03587_ _03670_ _03671_ vssd1 vssd1 vccd1 vccd1 _03672_ sky130_fd_sc_hd__o311a_1
XANTENNA_fanout153_A net154 vssd1 vssd1 vccd1 vccd1 sky130_fd_sc_hd__diode_2
XANTENNA__06096__Y _02376_ vssd1 vssd1 vccd1 vccd1 sky130_fd_sc_hd__diode_2
X_05675_ FPGA_INST.cell2.CB_0.config_dataB\[24\] FPGA_INST.cell2.CB_0.config_dataB\[21\]
+ FPGA_INST.cell2.CB_0.config_dataB\[20\] vssd1 vssd1 vccd1 vccd1 _01955_ sky130_fd_sc_hd__or3_1
X_08394_ _03797_ _04608_ _04609_ _03759_ _04615_ vssd1 vssd1 vccd1 vccd1 _04616_ sky130_fd_sc_hd__a221o_1
XANTENNA__07428__A1 net148 vssd1 vssd1 vccd1 vccd1 sky130_fd_sc_hd__diode_2
XANTENNA_fanout320_A net325 vssd1 vssd1 vccd1 vccd1 sky130_fd_sc_hd__diode_2
X_07345_ _03601_ _03602_ _03603_ _02267_ _02259_ vssd1 vssd1 vccd1 vccd1 _03605_ sky130_fd_sc_hd__a311o_1
X_07276_ _03495_ _03529_ _03537_ net364 vssd1 vssd1 vccd1 vccd1 _03538_ sky130_fd_sc_hd__a211o_2
XANTENNA__12133__CLK net917 vssd1 vssd1 vccd1 vccd1 sky130_fd_sc_hd__diode_2
X_09015_ net224 _03516_ _05183_ vssd1 vssd1 vccd1 vccd1 FPGA_INST.bus1_0\[2\] sky130_fd_sc_hd__and3_2
X_06227_ _02450_ _02505_ _02506_ _02487_ FPGA_INST.cell2.CB_0.config_dataA\[2\] vssd1
+ vssd1 vccd1 vccd1 _02507_ sky130_fd_sc_hd__a221o_1
XFILLER_12_69 vccd1 vssd1 vccd1 vssd1 sky130_ef_sc_hd__decap_40_12
XFILLER_105_735 vssd1 vssd1 vccd1 vccd1 sky130_fd_sc_hd__fill_4
XFILLER_88_29 vssd1 vssd1 vccd1 vccd1 sky130_fd_sc_hd__fill_2
X_06158_ net100 _02435_ _02437_ vssd1 vssd1 vccd1 vccd1 _02438_ sky130_fd_sc_hd__a21oi_1
XANTENNA__06939__A0 FPGA_INST.bus2_0\[8\] vssd1 vssd1 vccd1 vccd1 sky130_fd_sc_hd__diode_2
XTAP_TAPCELL_ROW_113_1860 vssd1 vccd1 sky130_fd_sc_hd__tapvpwrvgnd_1
XFILLER_78_619 vssd1 vssd1 vccd1 vccd1 sky130_fd_sc_hd__fill_1
XANTENNA__06403__A2 net16 vssd1 vssd1 vccd1 vccd1 sky130_fd_sc_hd__diode_2
X_06089_ _01905_ _02368_ vssd1 vssd1 vccd1 vccd1 _02369_ sky130_fd_sc_hd__or2_1
Xfanout621 net627 vssd1 vssd1 vccd1 vccd1 net621 sky130_fd_sc_hd__buf_2
XTAP_TAPCELL_ROW_113_1871 vssd1 vccd1 sky130_fd_sc_hd__tapvpwrvgnd_1
Xfanout610 net615 vssd1 vssd1 vccd1 vccd1 net610 sky130_fd_sc_hd__clkbuf_2
X_09917_ FPGA_INST.cell0.LE_1B.dff1_out net522 _05220_ vssd1 vssd1 vccd1 vccd1 _00822_
+ sky130_fd_sc_hd__a21bo_1
Xfanout632 net634 vssd1 vssd1 vccd1 vccd1 net632 sky130_fd_sc_hd__clkbuf_4
Xfanout654 net657 vssd1 vssd1 vccd1 vccd1 net654 sky130_fd_sc_hd__clkbuf_4
XANTENNA_fanout575_X net575 vssd1 vssd1 vccd1 vccd1 sky130_fd_sc_hd__diode_2
Xfanout676 net731 vssd1 vssd1 vccd1 vccd1 net676 sky130_fd_sc_hd__clkbuf_4
Xfanout665 net666 vssd1 vssd1 vccd1 vccd1 net665 sky130_fd_sc_hd__clkbuf_4
Xfanout643 net644 vssd1 vssd1 vccd1 vccd1 net643 sky130_fd_sc_hd__clkbuf_4
XTAP_TAPCELL_ROW_129_2089 vssd1 vccd1 sky130_fd_sc_hd__tapvpwrvgnd_1
Xfanout698 net701 vssd1 vssd1 vccd1 vccd1 net698 sky130_fd_sc_hd__clkbuf_4
Xfanout687 net702 vssd1 vssd1 vccd1 vccd1 net687 sky130_fd_sc_hd__clkbuf_4
XFILLER_73_302 vssd1 vssd1 vccd1 vccd1 sky130_fd_sc_hd__fill_1
XFILLER_58_365 vssd1 vssd1 vccd1 vccd1 sky130_fd_sc_hd__fill_1
XANTENNA__07671__X _03923_ vssd1 vssd1 vccd1 vccd1 sky130_fd_sc_hd__diode_2
X_09848_ FPGA_INST.cell0.LEI0.config_data\[26\] FPGA_INST.cell0.LEI0.config_data\[27\]
+ net179 vssd1 vssd1 vccd1 vccd1 _00756_ sky130_fd_sc_hd__mux2_1
X_09779_ FPGA_INST.cell1.CB_1.config_dataA\[4\] FPGA_INST.cell1.CB_1.config_dataA\[5\]
+ net212 vssd1 vssd1 vccd1 vccd1 _00688_ sky130_fd_sc_hd__mux2_1
XANTENNA__07903__A2 _03854_ vssd1 vssd1 vccd1 vccd1 sky130_fd_sc_hd__diode_2
XFILLER_85_173 vssd1 vssd1 vccd1 vccd1 sky130_fd_sc_hd__fill_1
XFILLER_73_324 vccd1 vssd1 vccd1 vssd1 sky130_ef_sc_hd__decap_40_12
XFILLER_73_368 vssd1 vssd1 vccd1 vccd1 sky130_fd_sc_hd__fill_2
X_11810_ net871 _01156_ net655 vssd1 vssd1 vccd1 vccd1 net35 sky130_fd_sc_hd__dfrtp_1
X_11741_ net895 _01087_ net679 vssd1 vssd1 vccd1 vccd1 FPGA_INST.cell3.SB0.route_sel\[111\]
+ sky130_fd_sc_hd__dfstp_1
XANTENNA__08419__S _04574_ vssd1 vssd1 vccd1 vccd1 sky130_fd_sc_hd__diode_2
XFILLER_26_251 vssd1 vssd1 vccd1 vccd1 sky130_fd_sc_hd__fill_1
XFILLER_27_785 vssd1 vssd1 vccd1 vccd1 sky130_fd_sc_hd__fill_1
XFILLER_53_21 vssd1 vssd1 vccd1 vccd1 sky130_fd_sc_hd__fill_4
X_11672_ net908 _01018_ net692 vssd1 vssd1 vccd1 vccd1 FPGA_INST.cell3.SB0.route_sel\[42\]
+ sky130_fd_sc_hd__dfstp_1
X_10623_ FPGA_INST.cell3.CB_1.config_dataA\[18\] FPGA_INST.cell3.CB_1.config_dataA\[17\]
+ net378 vssd1 vssd1 vccd1 vccd1 _01502_ sky130_fd_sc_hd__mux2_1
XANTENNA__07419__A1 FPGA_INST.cell1.SB0.route_sel\[48\] vssd1 vssd1 vccd1 vccd1 sky130_fd_sc_hd__diode_2
X_10554_ FPGA_INST.cell2.SB0.route_sel\[126\] FPGA_INST.cell2.SB0.config_data_out
+ net248 vssd1 vssd1 vccd1 vccd1 _01433_ sky130_fd_sc_hd__mux2_1
XFILLER_127_337 vssd1 vssd1 vccd1 vccd1 sky130_fd_sc_hd__fill_1
XFILLER_127_326 vssd1 vssd1 vccd1 vccd1 sky130_fd_sc_hd__fill_1
XFILLER_108_551 vssd1 vssd1 vccd1 vccd1 sky130_fd_sc_hd__fill_2
X_10485_ FPGA_INST.cell2.SB0.route_sel\[57\] FPGA_INST.cell2.SB0.route_sel\[58\] net194
+ vssd1 vssd1 vccd1 vccd1 _01364_ sky130_fd_sc_hd__mux2_1
XFILLER_108_573 vssd1 vssd1 vccd1 vccd1 sky130_fd_sc_hd__fill_2
XTAP_TAPCELL_ROW_75_1332 vssd1 vccd1 sky130_fd_sc_hd__tapvpwrvgnd_1
X_12155_ net935 _01501_ net719 vssd1 vssd1 vccd1 vccd1 FPGA_INST.cell3.CB_1.config_dataA\[17\]
+ sky130_fd_sc_hd__dfstp_1
XFILLER_118_91 vssd1 vssd1 vccd1 vccd1 sky130_fd_sc_hd__fill_1
XANTENNA__08395__A2 FPGA_INST.bus1_0\[9\] vssd1 vssd1 vccd1 vccd1 sky130_fd_sc_hd__diode_2
X_11106_ net836 _00456_ net620 vssd1 vssd1 vccd1 vccd1 FPGA_INST.cell1.LE_0B.reset_mode
+ sky130_fd_sc_hd__dfrtp_2
XFILLER_111_727 vssd1 vssd1 vccd1 vccd1 sky130_fd_sc_hd__fill_1
XFILLER_110_226 vssd1 vssd1 vccd1 vccd1 sky130_fd_sc_hd__fill_4
X_12086_ net858 _01432_ net644 vssd1 vssd1 vccd1 vccd1 FPGA_INST.cell2.SB0.route_sel\[126\]
+ sky130_fd_sc_hd__dfstp_1
X_11037_ net818 _00387_ net603 vssd1 vssd1 vccd1 vccd1 FPGA_INST.cell1.LEI0.config_data\[22\]
+ sky130_fd_sc_hd__dfrtp_1
XFILLER_77_696 vssd1 vssd1 vccd1 vccd1 sky130_fd_sc_hd__fill_4
XFILLER_76_184 vssd1 vssd1 vccd1 vccd1 sky130_fd_sc_hd__fill_2
XFILLER_76_162 vssd1 vssd1 vccd1 vccd1 sky130_fd_sc_hd__fill_4
XFILLER_49_387 vssd1 vssd1 vccd1 vccd1 sky130_fd_sc_hd__fill_4
XANTENNA__05905__A1 net171 vssd1 vssd1 vccd1 vccd1 sky130_fd_sc_hd__diode_2
XFILLER_76_195 vssd1 vssd1 vccd1 vccd1 sky130_fd_sc_hd__fill_1
XFILLER_92_699 vssd1 vssd1 vccd1 vccd1 sky130_fd_sc_hd__fill_1
XFILLER_91_165 vssd1 vssd1 vccd1 vccd1 sky130_fd_sc_hd__fill_2
XTAP_TAPCELL_ROW_86_1483 vssd1 vccd1 sky130_fd_sc_hd__tapvpwrvgnd_1
XFILLER_52_519 vssd1 vssd1 vccd1 vccd1 sky130_fd_sc_hd__fill_1
XFILLER_17_240 vssd1 vssd1 vccd1 vccd1 sky130_fd_sc_hd__fill_1
XFILLER_17_251 vssd1 vssd1 vccd1 vccd1 sky130_fd_sc_hd__fill_1
X_11939_ net913 _01285_ net697 vssd1 vssd1 vccd1 vccd1 FPGA_INST.cell3.CB_1.config_dataB\[4\]
+ sky130_fd_sc_hd__dfstp_1
XANTENNA__07658__A1 net83 vssd1 vssd1 vccd1 vccd1 sky130_fd_sc_hd__diode_2
X_05460_ FPGA_INST.cell0.CB_0.config_dataB\[4\] vssd1 vssd1 vccd1 vccd1 _01742_ sky130_fd_sc_hd__inv_2
XFILLER_33_777 vssd1 vssd1 vccd1 vccd1 sky130_fd_sc_hd__fill_1
X_05391_ FPGA_INST.cell3.SB0.route_sel\[53\] vssd1 vssd1 vccd1 vccd1 _01673_ sky130_fd_sc_hd__inv_2
XANTENNA__08607__A0 net18 vssd1 vssd1 vccd1 vccd1 sky130_fd_sc_hd__diode_2
XTAP_TAPCELL_ROW_15_496 vssd1 vccd1 sky130_fd_sc_hd__tapvpwrvgnd_1
X_07130_ FPGA_INST.cell3.SB0.route_sel\[0\] FPGA_INST.cell3.SB0.route_sel\[1\] vssd1
+ vssd1 vccd1 vccd1 _03394_ sky130_fd_sc_hd__and2_1
XANTENNA__08083__B2 _03652_ vssd1 vssd1 vccd1 vccd1 sky130_fd_sc_hd__diode_2
XANTENNA__07830__A1 _02131_ vssd1 vssd1 vccd1 vccd1 sky130_fd_sc_hd__diode_2
X_07061_ FPGA_INST.bus2_0\[0\] _03317_ _03318_ FPGA_INST.bus2_0\[1\] _03326_ vssd1
+ vssd1 vccd1 vccd1 _03327_ sky130_fd_sc_hd__a221o_1
X_06012_ net352 _02283_ _02288_ _02291_ vssd1 vssd1 vccd1 vccd1 _02292_ sky130_fd_sc_hd__or4_1
XFILLER_102_705 vssd1 vssd1 vccd1 vccd1 sky130_fd_sc_hd__fill_2
XANTENNA__07594__B1 FPGA_INST.bus3_1\[10\] vssd1 vssd1 vccd1 vccd1 sky130_fd_sc_hd__diode_2
XANTENNA__08138__A2 FPGA_INST.cell1.CB_1.le_outA vssd1 vssd1 vccd1 vccd1 sky130_fd_sc_hd__diode_2
X_07963_ _03421_ _04188_ _04190_ _03475_ FPGA_INST.cell1.CB_0.config_dataA\[17\] vssd1
+ vssd1 vccd1 vccd1 _04191_ sky130_fd_sc_hd__a221o_1
XFILLER_114_27 vssd1 vssd1 vccd1 vccd1 sky130_fd_sc_hd__fill_1
X_07894_ FPGA_INST.bus3_1\[0\] FPGA_INST.bus3_1\[1\] FPGA_INST.bus3_1\[2\] FPGA_INST.bus3_1\[3\]
+ net472 net471 vssd1 vssd1 vccd1 vccd1 _04122_ sky130_fd_sc_hd__mux4_1
X_09702_ FPGA_INST.cell0.SB0.route_sel\[105\] FPGA_INST.cell0.SB0.route_sel\[106\]
+ net198 vssd1 vssd1 vccd1 vccd1 _00611_ sky130_fd_sc_hd__mux2_1
X_06914_ _03177_ _03178_ _03180_ _03181_ vssd1 vssd1 vccd1 vccd1 _03182_ sky130_fd_sc_hd__o22a_1
XANTENNA__08689__A3 _04828_ vssd1 vssd1 vccd1 vccd1 sky130_fd_sc_hd__diode_2
XANTENNA__09623__S net320 vssd1 vssd1 vccd1 vccd1 sky130_fd_sc_hd__diode_2
X_09633_ FPGA_INST.cell0.SB0.route_sel\[36\] FPGA_INST.cell0.SB0.route_sel\[37\] net196
+ vssd1 vssd1 vccd1 vccd1 _00542_ sky130_fd_sc_hd__mux2_1
X_06845_ _01744_ _03111_ _03112_ vssd1 vssd1 vccd1 vccd1 _03113_ sky130_fd_sc_hd__or3_1
XANTENNA_fanout368_A net369 vssd1 vssd1 vccd1 vccd1 sky130_fd_sc_hd__diode_2
X_09564_ FPGA_INST.cell1.LE_1A.config_data\[13\] FPGA_INST.cell1.LE_1A.config_data\[14\]
+ net204 vssd1 vssd1 vccd1 vccd1 _00473_ sky130_fd_sc_hd__mux2_1
XANTENNA_fanout270_A net273 vssd1 vssd1 vccd1 vccd1 sky130_fd_sc_hd__diode_2
X_08515_ FPGA_INST.cell3.CB_1.config_dataA\[13\] FPGA_INST.cell3.CB_1.config_dataA\[12\]
+ FPGA_INST.cell3.CB_1.config_dataA\[11\] FPGA_INST.cell3.CB_1.config_dataA\[10\]
+ vssd1 vssd1 vccd1 vccd1 _04728_ sky130_fd_sc_hd__or4b_1
XFILLER_130_15 vssd1 vssd1 vccd1 vccd1 sky130_fd_sc_hd__fill_1
X_06776_ net512 _02836_ _03049_ net511 vssd1 vssd1 vccd1 vccd1 _03050_ sky130_fd_sc_hd__o211a_1
XANTENNA__06548__A _02823_ vssd1 vssd1 vccd1 vccd1 sky130_fd_sc_hd__diode_2
X_09495_ FPGA_INST.cell1.LEI0.config_data\[41\] FPGA_INST.cell1.LEI0.config_data\[42\]
+ net210 vssd1 vssd1 vccd1 vccd1 _00407_ sky130_fd_sc_hd__mux2_1
XANTENNA__07649__A1 net89 vssd1 vssd1 vccd1 vccd1 sky130_fd_sc_hd__diode_2
XANTENNA_fanout156_X net156 vssd1 vssd1 vccd1 vccd1 sky130_fd_sc_hd__diode_2
X_05727_ net242 _01998_ _02006_ vssd1 vssd1 vccd1 vccd1 _02007_ sky130_fd_sc_hd__and3_1
X_08446_ FPGA_INST.cell1.CB_1.config_dataA\[13\] FPGA_INST.cell1.CB_1.config_dataA\[12\]
+ FPGA_INST.cell1.CB_1.config_dataA\[11\] FPGA_INST.cell1.CB_1.config_dataA\[10\]
+ vssd1 vssd1 vccd1 vccd1 _04664_ sky130_fd_sc_hd__or4b_1
XANTENNA__08310__A2 FPGA_INST.bus1_0\[2\] vssd1 vssd1 vccd1 vccd1 sky130_fd_sc_hd__diode_2
X_05658_ net384 net168 _01933_ _01935_ vssd1 vssd1 vccd1 vccd1 _01938_ sky130_fd_sc_hd__o22a_1
XTAP_TAPCELL_ROW_34_761 vssd1 vccd1 sky130_fd_sc_hd__tapvpwrvgnd_1
X_08377_ FPGA_INST.cell0.CB_1.config_dataB\[13\] _04587_ _04594_ _04598_ FPGA_INST.cell0.CB_1.config_dataB\[14\]
+ vssd1 vssd1 vccd1 vccd1 _04599_ sky130_fd_sc_hd__a221o_1
X_07328_ _03428_ _03587_ net79 vssd1 vssd1 vccd1 vccd1 _03588_ sky130_fd_sc_hd__o21ai_1
XANTENNA_fanout702_A net731 vssd1 vssd1 vccd1 vccd1 sky130_fd_sc_hd__diode_2
XFILLER_23_57 vccd1 vssd1 vccd1 vssd1 sky130_ef_sc_hd__decap_40_12
X_05589_ _01868_ _01866_ vssd1 vssd1 vccd1 vccd1 _01869_ sky130_fd_sc_hd__and2b_2
X_07259_ FPGA_INST.cell3.SB0.route_sel\[21\] FPGA_INST.cell3.SB0.route_sel\[20\] _03500_
+ _03520_ _03514_ vssd1 vssd1 vccd1 vccd1 _03521_ sky130_fd_sc_hd__a221o_1
X_10270_ FPGA_INST.io_east_oeb\[28\] FPGA_INST.io_east_oeb\[30\] net253 vssd1 vssd1
+ vccd1 vccd1 _01151_ sky130_fd_sc_hd__mux2_1
XFILLER_2_125 vssd1 vssd1 vccd1 vccd1 sky130_fd_sc_hd__fill_2
XTAP_TAPCELL_ROW_57_1084 vssd1 vccd1 sky130_fd_sc_hd__tapvpwrvgnd_1
XANTENNA__06388__A1 net4 vssd1 vssd1 vccd1 vccd1 sky130_fd_sc_hd__diode_2
XANTENNA__07826__B _02092_ vssd1 vssd1 vccd1 vccd1 sky130_fd_sc_hd__diode_2
Xfanout440 FPGA_INST.cell0.CB_1.config_dataB\[15\] vssd1 vssd1 vccd1 vccd1 net440
+ sky130_fd_sc_hd__clkbuf_2
Xfanout451 FPGA_INST.cell1.CB_0.config_dataB\[15\] vssd1 vssd1 vccd1 vccd1 net451
+ sky130_fd_sc_hd__buf_2
Xfanout473 FPGA_INST.cell1.CB_0.config_dataA\[0\] vssd1 vssd1 vccd1 vccd1 net473 sky130_fd_sc_hd__clkbuf_2
XANTENNA__07337__B1 FPGA_INST.bus3_1\[4\] vssd1 vssd1 vccd1 vccd1 sky130_fd_sc_hd__diode_2
Xfanout462 FPGA_INST.cell1.CB_0.config_dataA\[16\] vssd1 vssd1 vccd1 vccd1 net462
+ sky130_fd_sc_hd__clkbuf_2
XTAP_TAPCELL_ROW_70_1262 vssd1 vccd1 sky130_fd_sc_hd__tapvpwrvgnd_1
Xfanout484 FPGA_INST.cell2.CB_1.config_dataA\[0\] vssd1 vssd1 vccd1 vccd1 net484 sky130_fd_sc_hd__clkbuf_2
XFILLER_86_471 vssd1 vssd1 vccd1 vccd1 sky130_fd_sc_hd__fill_4
XFILLER_59_685 vssd1 vssd1 vccd1 vccd1 sky130_fd_sc_hd__fill_1
Xfanout495 FPGA_INST.cell2.CB_0.config_dataB\[5\] vssd1 vssd1 vccd1 vccd1 net495 sky130_fd_sc_hd__dlymetal6s2s_1
XFILLER_19_516 vccd1 vssd1 vccd1 vssd1 sky130_ef_sc_hd__decap_40_12
XFILLER_74_666 vssd1 vssd1 vccd1 vccd1 sky130_fd_sc_hd__fill_8
XFILLER_104_82 vssd1 vssd1 vccd1 vccd1 sky130_fd_sc_hd__fill_2
XFILLER_74_699 vssd1 vssd1 vccd1 vccd1 sky130_fd_sc_hd__fill_1
XFILLER_15_733 vssd1 vssd1 vccd1 vccd1 sky130_fd_sc_hd__fill_1
X_11724_ net900 _01070_ net684 vssd1 vssd1 vccd1 vccd1 FPGA_INST.cell3.SB0.route_sel\[94\]
+ sky130_fd_sc_hd__dfstp_1
XANTENNA__08301__A2 _03840_ vssd1 vssd1 vccd1 vccd1 sky130_fd_sc_hd__diode_2
XANTENNA__06312__A1 _02487_ vssd1 vssd1 vccd1 vccd1 sky130_fd_sc_hd__diode_2
X_11655_ net893 _01001_ net677 vssd1 vssd1 vccd1 vccd1 FPGA_INST.cell3.SB0.route_sel\[25\]
+ sky130_fd_sc_hd__dfstp_1
XANTENNA__06312__B2 _02450_ vssd1 vssd1 vccd1 vccd1 sky130_fd_sc_hd__diode_2
Xfanout80 FPGA_INST.cell3.CB_1.le_outB vssd1 vssd1 vccd1 vccd1 net80 sky130_fd_sc_hd__clkbuf_4
Xfanout91 net92 vssd1 vssd1 vccd1 vccd1 net91 sky130_fd_sc_hd__clkbuf_2
XANTENNA__08392__B _03875_ vssd1 vssd1 vccd1 vccd1 sky130_fd_sc_hd__diode_2
XTAP_TAPCELL_ROW_12_444 vssd1 vccd1 sky130_fd_sc_hd__tapvpwrvgnd_1
X_10606_ FPGA_INST.cell3.CB_1.config_dataA\[0\] FPGA_INST.cell3.CB_1.config_dataA\[1\]
+ net303 vssd1 vssd1 vccd1 vccd1 _01485_ sky130_fd_sc_hd__mux2_1
XANTENNA__08065__A1 _03932_ vssd1 vssd1 vccd1 vccd1 sky130_fd_sc_hd__diode_2
X_11586_ net763 _00936_ net548 vssd1 vssd1 vccd1 vccd1 FPGA_INST.cell0.CB_1.config_dataA\[5\]
+ sky130_fd_sc_hd__dfstp_1
XTAP_TAPCELL_ROW_12_455 vssd1 vccd1 sky130_fd_sc_hd__tapvpwrvgnd_1
XANTENNA__05743__B1_N FPGA_INST.bus2_0\[10\] vssd1 vssd1 vccd1 vccd1 sky130_fd_sc_hd__diode_2
X_10537_ FPGA_INST.cell2.SB0.route_sel\[109\] FPGA_INST.cell2.SB0.route_sel\[110\]
+ net242 vssd1 vssd1 vccd1 vccd1 _01416_ sky130_fd_sc_hd__mux2_1
XFILLER_127_167 vssd1 vssd1 vccd1 vccd1 sky130_fd_sc_hd__fill_1
X_10468_ FPGA_INST.cell2.SB0.route_sel\[40\] FPGA_INST.cell2.SB0.route_sel\[41\] net243
+ vssd1 vssd1 vccd1 vccd1 _01347_ sky130_fd_sc_hd__mux2_1
XFILLER_6_475 vssd1 vssd1 vccd1 vccd1 sky130_fd_sc_hd__fill_1
XANTENNA__09708__S net324 vssd1 vssd1 vccd1 vccd1 sky130_fd_sc_hd__diode_2
X_10399_ FPGA_INST.cell3.LE_1A.reset_val FPGA_INST.cell3.LE_1A.edge_mode net375 vssd1
+ vssd1 vccd1 vccd1 _01278_ sky130_fd_sc_hd__mux2_1
XFILLER_111_502 vssd1 vssd1 vccd1 vccd1 sky130_fd_sc_hd__fill_2
XANTENNA__06379__A1 _02450_ vssd1 vssd1 vccd1 vccd1 sky130_fd_sc_hd__diode_2
XANTENNA__06379__B2 _02487_ vssd1 vssd1 vccd1 vccd1 sky130_fd_sc_hd__diode_2
X_12138_ net915 _01484_ net699 vssd1 vssd1 vccd1 vccd1 FPGA_INST.cell3.CB_1.config_dataA\[0\]
+ sky130_fd_sc_hd__dfstp_1
XFILLER_69_449 vssd1 vssd1 vccd1 vccd1 sky130_fd_sc_hd__fill_4
XFILLER_69_438 vssd1 vssd1 vccd1 vccd1 sky130_fd_sc_hd__fill_8
XFILLER_111_557 vssd1 vssd1 vccd1 vccd1 sky130_fd_sc_hd__fill_2
XFILLER_84_419 vssd1 vssd1 vccd1 vccd1 sky130_fd_sc_hd__fill_1
X_12069_ net854 _01415_ net639 vssd1 vssd1 vccd1 vccd1 FPGA_INST.cell2.SB0.route_sel\[109\]
+ sky130_fd_sc_hd__dfstp_1
XANTENNA__07879__A1 _03932_ vssd1 vssd1 vccd1 vccd1 sky130_fd_sc_hd__diode_2
XANTENNA__07328__B1 net79 vssd1 vssd1 vccd1 vccd1 sky130_fd_sc_hd__diode_2
XTAP_TAPCELL_ROW_88_1512 vssd1 vccd1 sky130_fd_sc_hd__tapvpwrvgnd_1
X_06630_ FPGA_INST.cell2.LEI0.config_data\[31\] _02905_ vssd1 vssd1 vccd1 vccd1 _02906_
+ sky130_fd_sc_hd__nor2_1
XFILLER_92_463 vssd1 vssd1 vccd1 vccd1 sky130_fd_sc_hd__fill_1
XANTENNA__06551__A1 FPGA_INST.bus3_2\[13\] vssd1 vssd1 vccd1 vccd1 sky130_fd_sc_hd__diode_2
XANTENNA__08828__A0 _04819_ vssd1 vssd1 vccd1 vccd1 sky130_fd_sc_hd__diode_2
X_06561_ net481 _02836_ vssd1 vssd1 vccd1 vccd1 _02837_ sky130_fd_sc_hd__or2_1
X_09280_ FPGA_INST.cell1.SB0.route_sel\[51\] FPGA_INST.cell1.SB0.route_sel\[52\] net207
+ vssd1 vssd1 vccd1 vccd1 _00193_ sky130_fd_sc_hd__mux2_1
X_05512_ FPGA_INST.bus3_2\[4\] vssd1 vssd1 vccd1 vccd1 _01794_ sky130_fd_sc_hd__inv_2
X_08300_ net445 _03875_ vssd1 vssd1 vccd1 vccd1 _04522_ sky130_fd_sc_hd__nand2_1
XANTENNA__06303__A1 _01966_ vssd1 vssd1 vccd1 vccd1 sky130_fd_sc_hd__diode_2
X_06492_ _01546_ FPGA_INST.cell2.LE_0B.dff_out vssd1 vssd1 vccd1 vccd1 _02769_ sky130_fd_sc_hd__or2_1
XANTENNA__11546__CLK net772 vssd1 vssd1 vccd1 vccd1 sky130_fd_sc_hd__diode_2
X_05443_ FPGA_INST.cell1.CB_0.config_dataA\[12\] vssd1 vssd1 vccd1 vccd1 _01725_ sky130_fd_sc_hd__inv_2
X_08231_ net406 _04040_ vssd1 vssd1 vccd1 vccd1 _04455_ sky130_fd_sc_hd__nand2_1
XANTENNA__06303__B2 _02010_ vssd1 vssd1 vccd1 vccd1 sky130_fd_sc_hd__diode_2
XFILLER_21_747 vssd1 vssd1 vccd1 vccd1 sky130_fd_sc_hd__fill_1
XTAP_TAPCELL_ROW_31_720 vssd1 vccd1 sky130_fd_sc_hd__tapvpwrvgnd_1
XFILLER_33_574 vssd1 vssd1 vccd1 vccd1 sky130_fd_sc_hd__fill_2
XFILLER_33_596 vssd1 vssd1 vccd1 vccd1 sky130_fd_sc_hd__fill_1
XFILLER_118_101 vssd1 vssd1 vccd1 vccd1 sky130_fd_sc_hd__fill_8
XTAP_TAPCELL_ROW_99_1663 vssd1 vccd1 sky130_fd_sc_hd__tapvpwrvgnd_1
X_05374_ FPGA_INST.cell3.SB0.route_sel\[67\] vssd1 vssd1 vccd1 vccd1 _01656_ sky130_fd_sc_hd__inv_2
X_08162_ _01752_ _04385_ vssd1 vssd1 vccd1 vccd1 _04386_ sky130_fd_sc_hd__nor2_1
X_08093_ FPGA_INST.bus3_1\[12\] FPGA_INST.bus3_1\[13\] FPGA_INST.bus3_1\[14\] FPGA_INST.bus3_1\[15\]
+ net454 net453 vssd1 vssd1 vccd1 vccd1 _04319_ sky130_fd_sc_hd__mux4_1
XTAP_TAPCELL_ROW_99_1674 vssd1 vccd1 sky130_fd_sc_hd__tapvpwrvgnd_1
XANTENNA__07803__A1 FPGA_INST.cell3.SB0.route_sel\[125\] vssd1 vssd1 vccd1 vccd1 sky130_fd_sc_hd__diode_2
X_07113_ _01736_ _03378_ _03377_ vssd1 vssd1 vccd1 vccd1 _03379_ sky130_fd_sc_hd__a21o_1
X_07044_ FPGA_INST.cell0.CB_0.config_dataA\[4\] _03294_ _03309_ vssd1 vssd1 vccd1
+ vccd1 _03310_ sky130_fd_sc_hd__or3_1
XFILLER_88_703 vssd1 vssd1 vccd1 vccd1 sky130_fd_sc_hd__fill_1
XFILLER_114_395 vssd1 vssd1 vccd1 vccd1 sky130_fd_sc_hd__fill_4
X_08995_ _01692_ FPGA_INST.cell1.SB0.route_sel\[37\] vssd1 vssd1 vccd1 vccd1 _05170_
+ sky130_fd_sc_hd__nand2_1
XPHY_EDGE_ROW_10_Left_141 vssd1 vssd1 vccd1 vccd1 sky130_fd_sc_hd__decap_3
X_07946_ _03932_ _04152_ _04173_ _01725_ vssd1 vssd1 vccd1 vccd1 _04174_ sky130_fd_sc_hd__a211o_1
XFILLER_87_268 vssd1 vssd1 vccd1 vccd1 sky130_fd_sc_hd__fill_1
XTAP_TAPCELL_ROW_126_2048 vssd1 vccd1 sky130_fd_sc_hd__tapvpwrvgnd_1
XANTENNA__06790__A1 _02801_ vssd1 vssd1 vccd1 vccd1 sky130_fd_sc_hd__diode_2
XANTENNA__06790__B2 _02804_ vssd1 vssd1 vccd1 vccd1 sky130_fd_sc_hd__diode_2
X_07877_ net469 _04013_ _04104_ net468 vssd1 vssd1 vccd1 vccd1 _04105_ sky130_fd_sc_hd__o211a_1
XANTENNA_fanout273_X net273 vssd1 vssd1 vccd1 vccd1 sky130_fd_sc_hd__diode_2
XFILLER_55_121 vssd1 vssd1 vccd1 vccd1 sky130_fd_sc_hd__fill_1
XANTENNA_fanout652_A net662 vssd1 vssd1 vccd1 vccd1 sky130_fd_sc_hd__diode_2
XTAP_TAPCELL_ROW_39_831 vssd1 vccd1 sky130_fd_sc_hd__tapvpwrvgnd_1
X_09616_ FPGA_INST.cell0.SB0.route_sel\[20\] FPGA_INST.cell0.SB0.route_sel\[19\] net323
+ vssd1 vssd1 vccd1 vccd1 _00525_ sky130_fd_sc_hd__mux2_1
XFILLER_43_305 vccd1 vssd1 vccd1 vssd1 sky130_ef_sc_hd__decap_40_12
X_06828_ _02270_ _03094_ _03095_ _02309_ _01744_ vssd1 vssd1 vccd1 vccd1 _03096_ sky130_fd_sc_hd__a221oi_1
XTAP_TAPCELL_ROW_108_1792 vssd1 vccd1 sky130_fd_sc_hd__tapvpwrvgnd_1
X_09547_ FPGA_INST.cell1.LE_1A.dff0_out net523 _05215_ vssd1 vssd1 vccd1 vccd1 _00457_
+ sky130_fd_sc_hd__a21bo_1
X_06759_ net513 _03031_ _03032_ vssd1 vssd1 vccd1 vccd1 _03033_ sky130_fd_sc_hd__a21o_1
XFILLER_55_198 vssd1 vssd1 vccd1 vccd1 sky130_fd_sc_hd__fill_8
XFILLER_43_349 vssd1 vssd1 vccd1 vccd1 sky130_fd_sc_hd__fill_1
XANTENNA_fanout917_A net918 vssd1 vssd1 vccd1 vccd1 sky130_fd_sc_hd__diode_2
XFILLER_70_168 vssd1 vssd1 vccd1 vccd1 sky130_fd_sc_hd__fill_4
XTAP_TAPCELL_ROW_121_1970 vssd1 vccd1 sky130_fd_sc_hd__tapvpwrvgnd_1
X_09478_ FPGA_INST.cell1.LEI0.config_data\[24\] FPGA_INST.cell1.LEI0.config_data\[25\]
+ net216 vssd1 vssd1 vccd1 vccd1 _00390_ sky130_fd_sc_hd__mux2_1
XANTENNA__08834__A3 net21 vssd1 vssd1 vccd1 vccd1 sky130_fd_sc_hd__diode_2
XTAP_TAPCELL_ROW_121_1981 vssd1 vccd1 sky130_fd_sc_hd__tapvpwrvgnd_1
XANTENNA__06725__B _02814_ vssd1 vssd1 vccd1 vccd1 sky130_fd_sc_hd__diode_2
X_08429_ _01603_ FPGA_INST.cell1.SB0.route_sel\[123\] FPGA_INST.cell1.SB0.route_sel\[120\]
+ FPGA_INST.cell1.SB0.route_sel\[121\] vssd1 vssd1 vccd1 vccd1 _04649_ sky130_fd_sc_hd__o22a_1
XFILLER_8_707 vssd1 vssd1 vccd1 vccd1 sky130_fd_sc_hd__fill_1
X_11440_ net773 _00790_ net559 vssd1 vssd1 vccd1 vccd1 FPGA_INST.cell0.LE_0A.config_data\[11\]
+ sky130_fd_sc_hd__dfrtp_1
X_11371_ net817 _00721_ net602 vssd1 vssd1 vccd1 vccd1 FPGA_INST.cell1.LE_1B.config_data\[13\]
+ sky130_fd_sc_hd__dfrtp_1
XTAP_TAPCELL_ROW_59_1113 vssd1 vccd1 sky130_fd_sc_hd__tapvpwrvgnd_1
XTAP_TAPCELL_ROW_59_1102 vssd1 vccd1 sky130_fd_sc_hd__tapvpwrvgnd_1
XFILLER_50_66 vssd1 vssd1 vccd1 vccd1 sky130_fd_sc_hd__fill_1
X_10322_ FPGA_INST.cell3.LEI0.config_data\[36\] FPGA_INST.cell3.LEI0.config_data\[37\]
+ net282 vssd1 vssd1 vccd1 vccd1 _01203_ sky130_fd_sc_hd__mux2_1
XFILLER_109_178 vssd1 vssd1 vccd1 vccd1 sky130_fd_sc_hd__fill_4
XFILLER_109_167 vssd1 vssd1 vccd1 vccd1 sky130_fd_sc_hd__fill_1
X_10253_ FPGA_INST.io_south_oeb\[26\] FPGA_INST.io_south_oeb\[28\] net266 vssd1 vssd1
+ vccd1 vccd1 _01134_ sky130_fd_sc_hd__mux2_1
XFILLER_120_321 vssd1 vssd1 vccd1 vccd1 sky130_fd_sc_hd__fill_2
XFILLER_105_395 vssd1 vssd1 vccd1 vccd1 sky130_fd_sc_hd__fill_1
X_10184_ FPGA_INST.cell3.SB0.route_sel\[88\] FPGA_INST.cell3.SB0.route_sel\[89\] net275
+ vssd1 vssd1 vccd1 vccd1 _01065_ sky130_fd_sc_hd__mux2_1
XANTENNA__07048__S _03313_ vssd1 vssd1 vccd1 vccd1 sky130_fd_sc_hd__diode_2
XFILLER_79_769 vccd1 vssd1 vccd1 vssd1 sky130_ef_sc_hd__decap_40_12
Xfanout281 net283 vssd1 vssd1 vccd1 vccd1 net281 sky130_fd_sc_hd__clkbuf_4
Xfanout292 net295 vssd1 vssd1 vccd1 vccd1 net292 sky130_fd_sc_hd__clkbuf_4
XFILLER_93_227 vccd1 vssd1 vccd1 vssd1 sky130_ef_sc_hd__decap_40_12
Xfanout270 net273 vssd1 vssd1 vccd1 vccd1 net270 sky130_fd_sc_hd__clkbuf_4
XFILLER_59_482 vssd1 vssd1 vccd1 vccd1 sky130_fd_sc_hd__fill_1
XFILLER_75_52 vssd1 vssd1 vccd1 vccd1 sky130_fd_sc_hd__fill_4
XANTENNA__08955__X FPGA_INST.bus2_0\[9\] vssd1 vssd1 vccd1 vccd1 sky130_fd_sc_hd__diode_2
XTAP_TAPCELL_ROW_17_514 vssd1 vccd1 sky130_fd_sc_hd__tapvpwrvgnd_1
XTAP_TAPCELL_ROW_17_525 vssd1 vccd1 sky130_fd_sc_hd__tapvpwrvgnd_1
XFILLER_91_51 vssd1 vssd1 vccd1 vccd1 sky130_fd_sc_hd__fill_1
XTAP_TAPCELL_ROW_83_1442 vssd1 vccd1 sky130_fd_sc_hd__tapvpwrvgnd_1
XFILLER_98_7 vssd1 vssd1 vccd1 vccd1 sky130_fd_sc_hd__fill_1
XFILLER_91_95 vssd1 vssd1 vccd1 vccd1 sky130_fd_sc_hd__fill_4
X_11707_ net920 _01053_ net704 vssd1 vssd1 vccd1 vccd1 FPGA_INST.cell3.SB0.route_sel\[77\]
+ sky130_fd_sc_hd__dfstp_1
XFILLER_30_533 vssd1 vssd1 vccd1 vccd1 sky130_fd_sc_hd__fill_1
XFILLER_30_555 vssd1 vssd1 vccd1 vccd1 sky130_fd_sc_hd__fill_2
X_11638_ net893 _00984_ net677 vssd1 vssd1 vccd1 vccd1 FPGA_INST.cell3.SB0.route_sel\[8\]
+ sky130_fd_sc_hd__dfstp_1
XANTENNA__09438__S net374 vssd1 vssd1 vccd1 vccd1 sky130_fd_sc_hd__diode_2
XFILLER_7_762 vssd1 vssd1 vccd1 vccd1 sky130_fd_sc_hd__fill_2
X_11569_ net775 _00919_ net561 vssd1 vssd1 vccd1 vccd1 FPGA_INST.cell0.CB_0.config_dataB\[13\]
+ sky130_fd_sc_hd__dfstp_1
XANTENNA__07261__A2 _02772_ vssd1 vssd1 vccd1 vccd1 sky130_fd_sc_hd__diode_2
XTAP_TAPCELL_ROW_94_1593 vssd1 vccd1 sky130_fd_sc_hd__tapvpwrvgnd_1
XFILLER_41_3 vssd1 vssd1 vccd1 vccd1 sky130_fd_sc_hd__fill_2
XANTENNA__08210__A1 net76 vssd1 vssd1 vccd1 vccd1 sky130_fd_sc_hd__diode_2
X_08780_ FPGA_INST.cell3.CB_0.config_dataB\[5\] _04785_ vssd1 vssd1 vccd1 vccd1 _04987_
+ sky130_fd_sc_hd__nand2_1
XANTENNA__07564__A3 _03775_ vssd1 vssd1 vccd1 vccd1 sky130_fd_sc_hd__diode_2
X_07800_ _04036_ _04046_ _04048_ net225 vssd1 vssd1 vccd1 vccd1 _04049_ sky130_fd_sc_hd__o211a_4
XPHY_EDGE_ROW_127_Right_127 vssd1 vssd1 vccd1 vccd1 sky130_fd_sc_hd__decap_3
XFILLER_111_398 vssd1 vssd1 vccd1 vccd1 sky130_fd_sc_hd__fill_1
XFILLER_111_365 vssd1 vssd1 vccd1 vccd1 sky130_fd_sc_hd__fill_2
X_07731_ _01616_ FPGA_INST.cell3.SB0.route_sel\[107\] _01617_ FPGA_INST.cell3.SB0.route_sel\[108\]
+ _03981_ vssd1 vssd1 vccd1 vccd1 _03982_ sky130_fd_sc_hd__o221a_1
X_05992_ net168 net160 _02267_ _02269_ vssd1 vssd1 vccd1 vccd1 _02272_ sky130_fd_sc_hd__o22a_1
XFILLER_93_783 vssd1 vssd1 vccd1 vccd1 sky130_fd_sc_hd__fill_1
X_07662_ _01788_ _03399_ _03913_ _03911_ _03395_ vssd1 vssd1 vccd1 vccd1 _03914_ sky130_fd_sc_hd__o32a_1
XFILLER_38_699 vssd1 vssd1 vccd1 vccd1 sky130_fd_sc_hd__fill_1
XFILLER_93_794 vssd1 vssd1 vccd1 vccd1 sky130_fd_sc_hd__fill_4
X_07593_ net153 _03832_ vssd1 vssd1 vccd1 vccd1 _03847_ sky130_fd_sc_hd__or2_1
X_06613_ FPGA_INST.bus3_2\[4\] FPGA_INST.bus3_2\[5\] FPGA_INST.bus3_2\[6\] FPGA_INST.bus3_2\[7\]
+ net478 net477 vssd1 vssd1 vccd1 vccd1 _02889_ sky130_fd_sc_hd__mux4_1
XFILLER_1_93 vccd1 vssd1 vccd1 vssd1 sky130_ef_sc_hd__decap_40_12
X_09401_ FPGA_INST.cell2.CB_0.config_dataB\[19\] FPGA_INST.cell2.CB_0.config_dataB\[20\]
+ net251 vssd1 vssd1 vccd1 vccd1 _00314_ sky130_fd_sc_hd__mux2_1
X_09332_ FPGA_INST.cell1.SB0.route_sel\[104\] FPGA_INST.cell1.SB0.route_sel\[103\]
+ net338 vssd1 vssd1 vccd1 vccd1 _00245_ sky130_fd_sc_hd__mux2_1
X_06544_ _02819_ vssd1 vssd1 vccd1 vccd1 _02820_ sky130_fd_sc_hd__inv_2
XANTENNA__10936__CLK net851 vssd1 vssd1 vccd1 vccd1 sky130_fd_sc_hd__diode_2
XANTENNA_fanout233_A net234 vssd1 vssd1 vccd1 vccd1 sky130_fd_sc_hd__diode_2
X_09263_ FPGA_INST.cell1.SB0.route_sel\[34\] FPGA_INST.cell1.SB0.route_sel\[35\] net215
+ vssd1 vssd1 vccd1 vccd1 _00176_ sky130_fd_sc_hd__mux2_1
X_06475_ _01543_ _02749_ _02752_ _02734_ _02742_ vssd1 vssd1 vccd1 vccd1 _02753_ sky130_fd_sc_hd__o32a_1
XFILLER_33_393 vssd1 vssd1 vccd1 vccd1 sky130_fd_sc_hd__fill_4
XANTENNA__08029__A1 _03932_ vssd1 vssd1 vccd1 vccd1 sky130_fd_sc_hd__diode_2
X_08214_ FPGA_INST.cell0.CB_1.config_dataA\[8\] _01754_ FPGA_INST.cell0.CB_1.config_dataA\[9\]
+ _04413_ vssd1 vssd1 vccd1 vccd1 _04438_ sky130_fd_sc_hd__and4b_1
X_09194_ FPGA_INST.cell2.LE_1A.config_data\[11\] FPGA_INST.cell2.LE_1A.config_data\[12\]
+ net264 vssd1 vssd1 vccd1 vccd1 _00107_ sky130_fd_sc_hd__mux2_1
X_05426_ FPGA_INST.cell0.SB0.route_sel\[21\] vssd1 vssd1 vccd1 vccd1 _01708_ sky130_fd_sc_hd__inv_2
X_08145_ FPGA_INST.cell1.LE_0B.config_data\[13\] FPGA_INST.cell1.LE_0B.config_data\[12\]
+ _04296_ vssd1 vssd1 vccd1 vccd1 _04371_ sky130_fd_sc_hd__mux2_1
X_05357_ FPGA_INST.cell3.SB0.route_sel\[81\] vssd1 vssd1 vccd1 vccd1 _01639_ sky130_fd_sc_hd__inv_2
XFILLER_4_209 vssd1 vssd1 vccd1 vccd1 sky130_fd_sc_hd__fill_2
XANTENNA_fanout119_X net119 vssd1 vssd1 vccd1 vccd1 sky130_fd_sc_hd__diode_2
X_08076_ _04301_ vssd1 vssd1 vccd1 vccd1 _04302_ sky130_fd_sc_hd__inv_2
X_05288_ FPGA_INST.cell2.SB0.route_sel\[79\] vssd1 vssd1 vccd1 vccd1 _01570_ sky130_fd_sc_hd__inv_2
X_07027_ _03290_ _03292_ _01730_ vssd1 vssd1 vccd1 vccd1 _03293_ sky130_fd_sc_hd__o21a_1
XFILLER_96_29 vssd1 vssd1 vccd1 vccd1 sky130_fd_sc_hd__fill_1
XTAP_TAPCELL_ROW_54_1043 vssd1 vccd1 sky130_fd_sc_hd__tapvpwrvgnd_1
XTAP_TAPCELL_ROW_54_1032 vssd1 vccd1 sky130_fd_sc_hd__tapvpwrvgnd_1
XFILLER_130_663 vssd1 vssd1 vccd1 vccd1 sky130_fd_sc_hd__fill_1
X_08978_ _01675_ FPGA_INST.cell1.SB0.route_sel\[51\] FPGA_INST.cell1.SB0.route_sel\[48\]
+ FPGA_INST.cell1.SB0.route_sel\[49\] _05158_ vssd1 vssd1 vccd1 vccd1 _05159_ sky130_fd_sc_hd__o221a_1
XFILLER_75_227 vssd1 vssd1 vccd1 vccd1 sky130_fd_sc_hd__fill_1
XFILLER_48_419 vssd1 vssd1 vccd1 vccd1 sky130_fd_sc_hd__fill_1
XFILLER_102_398 vssd1 vssd1 vccd1 vccd1 sky130_fd_sc_hd__fill_1
X_07929_ FPGA_INST.bus3_1\[0\] FPGA_INST.bus3_1\[1\] FPGA_INST.bus3_1\[2\] FPGA_INST.bus3_1\[3\]
+ net466 net465 vssd1 vssd1 vccd1 vccd1 _04157_ sky130_fd_sc_hd__mux4_1
XFILLER_29_633 vssd1 vssd1 vccd1 vccd1 sky130_fd_sc_hd__fill_1
XFILLER_45_11 vssd1 vssd1 vccd1 vccd1 sky130_fd_sc_hd__fill_2
XFILLER_16_305 vssd1 vssd1 vccd1 vccd1 sky130_fd_sc_hd__fill_1
X_10940_ net848 _00290_ net633 vssd1 vssd1 vccd1 vccd1 FPGA_INST.cell2.CB_0.config_dataA\[21\]
+ sky130_fd_sc_hd__dfstp_1
XFILLER_29_688 vssd1 vssd1 vccd1 vccd1 sky130_fd_sc_hd__fill_2
XFILLER_45_55 vssd1 vssd1 vccd1 vccd1 sky130_fd_sc_hd__fill_1
XFILLER_44_636 vssd1 vssd1 vccd1 vccd1 sky130_fd_sc_hd__fill_2
XFILLER_28_187 vssd1 vssd1 vccd1 vccd1 sky130_fd_sc_hd__fill_8
X_10871_ net792 _00221_ net577 vssd1 vssd1 vccd1 vccd1 FPGA_INST.cell1.SB0.route_sel\[80\]
+ sky130_fd_sc_hd__dfstp_1
XANTENNA__05640__A FPGA_INST.cell0.CB_0.config_dataB\[24\] vssd1 vssd1 vccd1 vccd1
+ sky130_fd_sc_hd__diode_2
XTAP_TAPCELL_ROW_65_1194 vssd1 vccd1 sky130_fd_sc_hd__tapvpwrvgnd_1
XFILLER_12_533 vssd1 vssd1 vccd1 vccd1 sky130_fd_sc_hd__fill_8
XTAP_TAPCELL_ROW_22_594 vssd1 vccd1 sky130_fd_sc_hd__tapvpwrvgnd_1
X_11423_ net754 _00773_ net539 vssd1 vssd1 vccd1 vccd1 FPGA_INST.cell0.LEI0.config_data\[44\]
+ sky130_fd_sc_hd__dfrtp_1
XANTENNA__10378__A2 net525 vssd1 vssd1 vccd1 vccd1 sky130_fd_sc_hd__diode_2
XFILLER_6_27 vssd1 vssd1 vccd1 vccd1 sky130_fd_sc_hd__fill_1
X_11354_ net801 _00704_ net586 vssd1 vssd1 vccd1 vccd1 FPGA_INST.cell1.CB_1.config_dataA\[21\]
+ sky130_fd_sc_hd__dfstp_1
X_10305_ FPGA_INST.cell3.LEI0.config_data\[19\] FPGA_INST.cell3.LEI0.config_data\[20\]
+ net297 vssd1 vssd1 vccd1 vccd1 _01186_ sky130_fd_sc_hd__mux2_1
XFILLER_106_660 vssd1 vssd1 vccd1 vccd1 sky130_fd_sc_hd__fill_8
X_11285_ net832 _00635_ net616 vssd1 vssd1 vccd1 vccd1 FPGA_INST.cell1.CB_0.config_dataA\[2\]
+ sky130_fd_sc_hd__dfstp_2
XFILLER_4_754 vssd1 vssd1 vccd1 vccd1 sky130_fd_sc_hd__fill_2
XFILLER_3_231 vssd1 vssd1 vccd1 vccd1 sky130_fd_sc_hd__fill_1
X_10236_ FPGA_INST.io_west_oeb\[24\] FPGA_INST.io_west_oeb\[26\] net289 vssd1 vssd1
+ vccd1 vccd1 _01117_ sky130_fd_sc_hd__mux2_1
XFILLER_4_798 vssd1 vssd1 vccd1 vccd1 sky130_fd_sc_hd__fill_1
XFILLER_94_525 vssd1 vssd1 vccd1 vccd1 sky130_fd_sc_hd__fill_1
X_10167_ FPGA_INST.cell3.SB0.route_sel\[72\] FPGA_INST.cell3.SB0.route_sel\[71\] net366
+ vssd1 vssd1 vccd1 vccd1 _01048_ sky130_fd_sc_hd__mux2_1
XANTENNA__06754__A1 _02843_ vssd1 vssd1 vccd1 vccd1 sky130_fd_sc_hd__diode_2
XANTENNA__06754__B2 _02840_ vssd1 vssd1 vccd1 vccd1 sky130_fd_sc_hd__diode_2
XFILLER_66_205 vssd1 vssd1 vccd1 vccd1 sky130_fd_sc_hd__fill_1
XFILLER_94_569 vccd1 vssd1 vccd1 vssd1 sky130_ef_sc_hd__decap_40_12
XFILLER_94_547 vssd1 vssd1 vccd1 vccd1 sky130_fd_sc_hd__fill_1
X_10098_ FPGA_INST.cell3.SB0.route_sel\[2\] FPGA_INST.cell3.SB0.route_sel\[3\] net272
+ vssd1 vssd1 vccd1 vccd1 _00979_ sky130_fd_sc_hd__mux2_1
XFILLER_47_441 vssd1 vssd1 vccd1 vccd1 sky130_fd_sc_hd__fill_4
XFILLER_81_208 vssd1 vssd1 vccd1 vccd1 sky130_fd_sc_hd__fill_4
XFILLER_47_463 vccd1 vssd1 vccd1 vssd1 sky130_ef_sc_hd__decap_40_12
XFILLER_75_794 vssd1 vssd1 vccd1 vccd1 sky130_fd_sc_hd__fill_4
XFILLER_74_271 vccd1 vssd1 vccd1 vssd1 sky130_ef_sc_hd__decap_40_12
XFILLER_19_187 vssd1 vssd1 vccd1 vccd1 sky130_fd_sc_hd__fill_1
XFILLER_89_3 vssd1 vssd1 vccd1 vccd1 sky130_fd_sc_hd__fill_8
X_06260_ net502 net503 vssd1 vssd1 vccd1 vccd1 _02540_ sky130_fd_sc_hd__and2b_2
XFILLER_30_374 vssd1 vssd1 vccd1 vccd1 sky130_fd_sc_hd__fill_4
XFILLER_129_785 vssd1 vssd1 vccd1 vccd1 sky130_fd_sc_hd__fill_8
XFILLER_128_251 vssd1 vssd1 vccd1 vccd1 sky130_fd_sc_hd__fill_1
XTAP_TAPCELL_ROW_96_1633 vssd1 vccd1 sky130_fd_sc_hd__tapvpwrvgnd_1
XTAP_TAPCELL_ROW_96_1622 vssd1 vccd1 sky130_fd_sc_hd__tapvpwrvgnd_1
X_06191_ _01942_ _02356_ vssd1 vssd1 vccd1 vccd1 _02471_ sky130_fd_sc_hd__and2_1
XANTENNA__09168__S net358 vssd1 vssd1 vccd1 vccd1 sky130_fd_sc_hd__diode_2
XFILLER_104_619 vssd1 vssd1 vccd1 vccd1 sky130_fd_sc_hd__fill_2
X_09950_ net441 net443 net311 vssd1 vssd1 vccd1 vccd1 _00855_ sky130_fd_sc_hd__mux2_1
X_08901_ _05069_ _05100_ _05107_ _05099_ vssd1 vssd1 vccd1 vccd1 _05108_ sky130_fd_sc_hd__a22o_1
XFILLER_124_490 vssd1 vssd1 vccd1 vccd1 sky130_fd_sc_hd__fill_1
XFILLER_112_641 vssd1 vssd1 vccd1 vccd1 sky130_fd_sc_hd__fill_2
XFILLER_97_341 vssd1 vssd1 vccd1 vccd1 sky130_fd_sc_hd__fill_1
X_09881_ FPGA_INST.cell0.LE_0A.config_data\[9\] FPGA_INST.cell0.LE_0A.config_data\[8\]
+ net318 vssd1 vssd1 vccd1 vccd1 _00788_ sky130_fd_sc_hd__mux2_1
X_08832_ _04828_ _05037_ _05038_ _04831_ vssd1 vssd1 vccd1 vccd1 _05039_ sky130_fd_sc_hd__a2bb2o_1
XANTENNA__07942__A0 FPGA_INST.bus3_1\[12\] vssd1 vssd1 vccd1 vccd1 sky130_fd_sc_hd__diode_2
X_08763_ FPGA_INST.cell3.LE_0A.dff0_out FPGA_INST.cell3.LE_0A.dff1_out FPGA_INST.cell3.LE_0A.reset_val
+ vssd1 vssd1 vccd1 vccd1 FPGA_INST.cell3.LE_0A.dff_out sky130_fd_sc_hd__mux2_1
X_05975_ _02254_ _02252_ vssd1 vssd1 vccd1 vccd1 _02255_ sky130_fd_sc_hd__and2b_4
XTAP_TAPCELL_ROW_123_2007 vssd1 vccd1 sky130_fd_sc_hd__tapvpwrvgnd_1
X_07714_ net150 _03468_ _03926_ _03961_ _03964_ vssd1 vssd1 vccd1 vccd1 _03965_ sky130_fd_sc_hd__o311a_1
XTAP_TAPCELL_ROW_49_970 vssd1 vccd1 sky130_fd_sc_hd__tapvpwrvgnd_1
XANTENNA_fanout183_A net184 vssd1 vssd1 vccd1 vccd1 sky130_fd_sc_hd__diode_2
X_08694_ net397 _04835_ _04902_ vssd1 vssd1 vccd1 vccd1 _04903_ sky130_fd_sc_hd__a21o_1
XANTENNA__08595__X _04804_ vssd1 vssd1 vccd1 vccd1 sky130_fd_sc_hd__diode_2
X_07645_ net81 _03542_ _03775_ _03892_ _03897_ vssd1 vssd1 vccd1 vccd1 _03898_ sky130_fd_sc_hd__o311a_1
XTAP_TAPCELL_ROW_0_267 vssd1 vccd1 sky130_fd_sc_hd__tapvpwrvgnd_1
XTAP_TAPCELL_ROW_0_278 vssd1 vccd1 sky130_fd_sc_hd__tapvpwrvgnd_1
XANTENNA_fanout350_A net351 vssd1 vssd1 vccd1 vccd1 sky130_fd_sc_hd__diode_2
XTAP_TAPCELL_ROW_105_1751 vssd1 vccd1 sky130_fd_sc_hd__tapvpwrvgnd_1
X_07576_ FPGA_INST.cell3.SB0.route_sel\[82\] FPGA_INST.cell3.SB0.route_sel\[83\] vssd1
+ vssd1 vccd1 vccd1 _03830_ sky130_fd_sc_hd__nand2_1
XFILLER_41_617 vssd1 vssd1 vccd1 vccd1 sky130_fd_sc_hd__fill_4
XTAP_TAPCELL_ROW_0_289 vssd1 vccd1 sky130_fd_sc_hd__tapvpwrvgnd_1
X_09315_ FPGA_INST.cell1.SB0.route_sel\[87\] FPGA_INST.cell1.SB0.route_sel\[86\] net327
+ vssd1 vssd1 vccd1 vccd1 _00228_ sky130_fd_sc_hd__mux2_1
X_06527_ _01558_ FPGA_INST.cell2.SB0.route_sel\[41\] FPGA_INST.cell2.SB0.route_sel\[46\]
+ _01559_ _02802_ vssd1 vssd1 vccd1 vccd1 _02803_ sky130_fd_sc_hd__a221o_1
X_09246_ FPGA_INST.cell1.SB0.route_sel\[18\] FPGA_INST.cell1.SB0.route_sel\[17\] net342
+ vssd1 vssd1 vccd1 vccd1 _00159_ sky130_fd_sc_hd__mux2_1
XANTENNA_fanout615_A net627 vssd1 vssd1 vccd1 vccd1 sky130_fd_sc_hd__diode_2
X_06458_ FPGA_INST.cell2.CB_0.config_dataB\[18\] FPGA_INST.cell2.CB_0.config_dataB\[17\]
+ vssd1 vssd1 vccd1 vccd1 _02736_ sky130_fd_sc_hd__or2_1
X_05409_ FPGA_INST.cell1.SB0.route_sel\[34\] vssd1 vssd1 vccd1 vccd1 _01691_ sky130_fd_sc_hd__inv_2
X_06389_ FPGA_INST.cell2.CB_0.config_dataB\[3\] FPGA_INST.cell2.CB_0.config_dataB\[2\]
+ vssd1 vssd1 vccd1 vccd1 _02667_ sky130_fd_sc_hd__or2_1
X_09177_ FPGA_INST.cell2.LE_0B.reset_val FPGA_INST.cell2.LE_0B.edge_mode net359 vssd1
+ vssd1 vccd1 vccd1 _00091_ sky130_fd_sc_hd__mux2_1
X_08128_ FPGA_INST.bus3_1\[12\] FPGA_INST.bus3_1\[13\] FPGA_INST.bus3_1\[14\] FPGA_INST.bus3_1\[15\]
+ net451 net450 vssd1 vssd1 vccd1 vccd1 _04354_ sky130_fd_sc_hd__mux4_1
XANTENNA__07387__A net154 vssd1 vssd1 vccd1 vccd1 sky130_fd_sc_hd__diode_2
X_08059_ FPGA_INST.bus3_1\[12\] FPGA_INST.bus3_1\[13\] FPGA_INST.bus3_1\[14\] FPGA_INST.bus3_1\[15\]
+ net461 net459 vssd1 vssd1 vccd1 vccd1 _04285_ sky130_fd_sc_hd__mux4_1
XANTENNA__09806__S net337 vssd1 vssd1 vccd1 vccd1 sky130_fd_sc_hd__diode_2
X_11070_ net838 _00420_ net622 vssd1 vssd1 vccd1 vccd1 FPGA_INST.cell1.LE_0A.config_data\[5\]
+ sky130_fd_sc_hd__dfrtp_1
Xoutput46 net46 vssd1 vssd1 vccd1 vccd1 gpio_out[11] sky130_fd_sc_hd__buf_2
Xoutput57 net57 vssd1 vssd1 vccd1 vccd1 gpio_out[22] sky130_fd_sc_hd__buf_2
Xoutput35 net35 vssd1 vssd1 vccd1 vccd1 gpio_oeb[17] sky130_fd_sc_hd__buf_2
Xoutput68 net68 vssd1 vssd1 vccd1 vccd1 gpio_out[33] sky130_fd_sc_hd__buf_2
XFILLER_0_223 vssd1 vssd1 vccd1 vccd1 sky130_fd_sc_hd__fill_1
X_10021_ FPGA_INST.cell0.CB_0.config_dataA\[21\] FPGA_INST.cell0.CB_0.config_dataA\[20\]
+ net317 vssd1 vssd1 vccd1 vccd1 _00902_ sky130_fd_sc_hd__mux2_1
XANTENNA_fanout772_X net772 vssd1 vssd1 vccd1 vccd1 sky130_fd_sc_hd__diode_2
XANTENNA__06736__A1 _02780_ vssd1 vssd1 vccd1 vccd1 sky130_fd_sc_hd__diode_2
XFILLER_49_717 vssd1 vssd1 vccd1 vccd1 sky130_fd_sc_hd__fill_2
XTAP_TAPCELL_ROW_8_389 vssd1 vccd1 sky130_fd_sc_hd__tapvpwrvgnd_1
XANTENNA__07834__B _02217_ vssd1 vssd1 vccd1 vccd1 sky130_fd_sc_hd__diode_2
XFILLER_48_249 vssd1 vssd1 vccd1 vccd1 sky130_fd_sc_hd__fill_1
XFILLER_57_772 vccd1 vssd1 vccd1 vssd1 sky130_ef_sc_hd__decap_40_12
XANTENNA__09541__S net232 vssd1 vssd1 vccd1 vccd1 sky130_fd_sc_hd__diode_2
XTAP_TAPCELL_ROW_67_1223 vssd1 vccd1 sky130_fd_sc_hd__tapvpwrvgnd_1
X_11972_ net776 _01318_ net562 vssd1 vssd1 vccd1 vccd1 FPGA_INST.cell2.SB0.route_sel\[12\]
+ sky130_fd_sc_hd__dfstp_1
XFILLER_72_742 vssd1 vssd1 vccd1 vccd1 sky130_fd_sc_hd__fill_4
X_10923_ net865 _00273_ net650 vssd1 vssd1 vccd1 vccd1 FPGA_INST.cell2.CB_0.config_dataA\[4\]
+ sky130_fd_sc_hd__dfstp_1
XPHY_EDGE_ROW_19_Right_19 vssd1 vssd1 vccd1 vccd1 sky130_fd_sc_hd__decap_3
XTAP_TAPCELL_ROW_80_1401 vssd1 vccd1 sky130_fd_sc_hd__tapvpwrvgnd_1
X_10854_ net821 _00204_ net605 vssd1 vssd1 vccd1 vccd1 FPGA_INST.cell1.SB0.route_sel\[63\]
+ sky130_fd_sc_hd__dfstp_1
XTAP_TAPCELL_ROW_27_664 vssd1 vccd1 sky130_fd_sc_hd__tapvpwrvgnd_1
X_10785_ net919 _00135_ net703 vssd1 vssd1 vccd1 vccd1 FPGA_INST.cell2.CB_1.config_dataB\[19\]
+ sky130_fd_sc_hd__dfstp_1
XFILLER_12_352 vssd1 vssd1 vccd1 vccd1 sky130_fd_sc_hd__fill_1
X_11406_ net754 _00756_ net539 vssd1 vssd1 vccd1 vccd1 FPGA_INST.cell0.LEI0.config_data\[27\]
+ sky130_fd_sc_hd__dfrtp_1
XFILLER_125_265 vssd1 vssd1 vccd1 vccd1 sky130_fd_sc_hd__fill_2
XFILLER_113_405 vssd1 vssd1 vccd1 vccd1 sky130_fd_sc_hd__fill_2
X_11337_ net805 _00687_ net590 vssd1 vssd1 vccd1 vccd1 FPGA_INST.cell1.CB_1.config_dataA\[4\]
+ sky130_fd_sc_hd__dfstp_1
XTAP_TAPCELL_ROW_78_1374 vssd1 vccd1 sky130_fd_sc_hd__tapvpwrvgnd_1
XANTENNA__10220__A1 FPGA_INST.cell3.SB0.route_sel\[124\] vssd1 vssd1 vccd1 vccd1 sky130_fd_sc_hd__diode_2
XPHY_EDGE_ROW_28_Right_28 vssd1 vssd1 vccd1 vccd1 sky130_fd_sc_hd__decap_3
XFILLER_98_138 vssd1 vssd1 vccd1 vccd1 sky130_fd_sc_hd__fill_2
XFILLER_98_105 vssd1 vssd1 vccd1 vccd1 sky130_fd_sc_hd__fill_1
XANTENNA__09716__S net324 vssd1 vssd1 vccd1 vccd1 sky130_fd_sc_hd__diode_2
XFILLER_113_449 vssd1 vssd1 vccd1 vccd1 sky130_fd_sc_hd__fill_1
XTAP_TAPCELL_ROW_91_1563 vssd1 vccd1 sky130_fd_sc_hd__tapvpwrvgnd_1
XTAP_TAPCELL_ROW_91_1552 vssd1 vccd1 sky130_fd_sc_hd__tapvpwrvgnd_1
X_11268_ net783 _00618_ net568 vssd1 vssd1 vccd1 vccd1 FPGA_INST.cell0.SB0.route_sel\[113\]
+ sky130_fd_sc_hd__dfstp_1
X_10219_ FPGA_INST.cell3.SB0.route_sel\[123\] FPGA_INST.cell3.SB0.route_sel\[124\]
+ net274 vssd1 vssd1 vccd1 vccd1 _01100_ sky130_fd_sc_hd__mux2_1
XANTENNA__06727__A1 _02819_ vssd1 vssd1 vccd1 vccd1 sky130_fd_sc_hd__diode_2
X_11199_ net764 _00549_ net549 vssd1 vssd1 vccd1 vccd1 FPGA_INST.cell0.SB0.route_sel\[44\]
+ sky130_fd_sc_hd__dfstp_1
XFILLER_67_547 vssd1 vssd1 vccd1 vccd1 sky130_fd_sc_hd__fill_1
X_05760_ _01849_ _02039_ vssd1 vssd1 vccd1 vccd1 _02040_ sky130_fd_sc_hd__nor2_1
XPHY_EDGE_ROW_37_Right_37 vssd1 vssd1 vccd1 vccd1 sky130_fd_sc_hd__decap_3
XANTENNA__10597__S net378 vssd1 vssd1 vccd1 vccd1 sky130_fd_sc_hd__diode_2
XANTENNA__07152__A1 FPGA_INST.bus3_1\[0\] vssd1 vssd1 vccd1 vccd1 sky130_fd_sc_hd__diode_2
X_05691_ net121 net384 net166 _01968_ _01817_ vssd1 vssd1 vccd1 vccd1 _01971_ sky130_fd_sc_hd__o32a_1
XANTENNA__05551__Y _01831_ vssd1 vssd1 vccd1 vccd1 sky130_fd_sc_hd__diode_2
X_07430_ FPGA_INST.cell1.SB0.route_sel\[53\] FPGA_INST.cell1.SB0.route_sel\[52\] vssd1
+ vssd1 vccd1 vccd1 _03688_ sky130_fd_sc_hd__nand2b_1
XFILLER_23_617 vssd1 vssd1 vccd1 vccd1 sky130_fd_sc_hd__fill_4
X_07361_ _03434_ _03620_ vssd1 vssd1 vccd1 vccd1 _03621_ sky130_fd_sc_hd__nor2_1
XFILLER_50_458 vccd1 vssd1 vccd1 vssd1 sky130_ef_sc_hd__decap_40_12
XFILLER_22_138 vssd1 vssd1 vccd1 vccd1 sky130_fd_sc_hd__fill_2
X_06312_ _02487_ _02574_ _02575_ _02450_ FPGA_INST.cell2.CB_0.config_dataA\[17\] vssd1
+ vssd1 vccd1 vccd1 _02592_ sky130_fd_sc_hd__a221o_1
X_09100_ FPGA_INST.cell2.LEI0.config_data\[14\] FPGA_INST.cell2.LEI0.config_data\[15\]
+ net250 vssd1 vssd1 vccd1 vccd1 _00016_ sky130_fd_sc_hd__mux2_1
X_09031_ _01722_ FPGA_INST.cell1.SB0.route_sel\[5\] vssd1 vssd1 vccd1 vccd1 _05194_
+ sky130_fd_sc_hd__nand2_1
X_07292_ _01787_ _03547_ vssd1 vssd1 vccd1 vccd1 _03553_ sky130_fd_sc_hd__nand2_1
XTAP_TAPCELL_ROW_100_1681 vssd1 vccd1 sky130_fd_sc_hd__tapvpwrvgnd_1
XPHY_EDGE_ROW_46_Right_46 vssd1 vssd1 vccd1 vccd1 sky130_fd_sc_hd__decap_3
X_06243_ _02131_ _02505_ _02506_ _02168_ FPGA_INST.cell2.CB_0.config_dataA\[2\] vssd1
+ vssd1 vccd1 vccd1 _02523_ sky130_fd_sc_hd__a221o_1
XFILLER_30_193 vssd1 vssd1 vccd1 vccd1 sky130_fd_sc_hd__fill_2
XFILLER_117_733 vssd1 vssd1 vccd1 vccd1 sky130_fd_sc_hd__fill_1
X_06174_ _01924_ net157 vssd1 vssd1 vccd1 vccd1 _02454_ sky130_fd_sc_hd__nor2_1
XFILLER_117_27 vssd1 vssd1 vccd1 vccd1 sky130_fd_sc_hd__fill_8
Xfanout814 net820 vssd1 vssd1 vccd1 vccd1 net814 sky130_fd_sc_hd__clkbuf_2
Xfanout825 net826 vssd1 vssd1 vccd1 vccd1 net825 sky130_fd_sc_hd__buf_2
Xfanout803 net843 vssd1 vssd1 vccd1 vccd1 net803 sky130_fd_sc_hd__buf_2
XFILLER_89_138 vssd1 vssd1 vccd1 vccd1 sky130_fd_sc_hd__fill_2
X_09933_ FPGA_INST.cell0.LE_1A.config_data\[15\] FPGA_INST.cell0.LE_1A.config_data\[14\]
+ net308 vssd1 vssd1 vccd1 vccd1 _00838_ sky130_fd_sc_hd__mux2_1
Xfanout836 net837 vssd1 vssd1 vccd1 vccd1 net836 sky130_fd_sc_hd__clkbuf_2
XFILLER_97_160 vssd1 vssd1 vccd1 vccd1 sky130_fd_sc_hd__fill_8
XTAP_TAPCELL_ROW_51_1002 vssd1 vccd1 sky130_fd_sc_hd__tapvpwrvgnd_1
Xfanout858 net861 vssd1 vssd1 vccd1 vccd1 net858 sky130_fd_sc_hd__clkbuf_2
X_09864_ FPGA_INST.cell0.LEI0.config_data\[42\] FPGA_INST.cell0.LEI0.config_data\[43\]
+ net179 vssd1 vssd1 vccd1 vccd1 _00772_ sky130_fd_sc_hd__mux2_1
Xfanout847 net849 vssd1 vssd1 vccd1 vccd1 net847 sky130_fd_sc_hd__clkbuf_2
XFILLER_97_171 vssd1 vssd1 vccd1 vccd1 sky130_fd_sc_hd__fill_4
X_08815_ _03943_ _04808_ _05004_ vssd1 vssd1 vccd1 vccd1 _05022_ sky130_fd_sc_hd__a21oi_1
XFILLER_85_333 vssd1 vssd1 vccd1 vccd1 sky130_fd_sc_hd__fill_2
XANTENNA__08183__A3 net99 vssd1 vssd1 vccd1 vccd1 sky130_fd_sc_hd__diode_2
XTAP_TAPCELL_ROW_5_359 vssd1 vccd1 sky130_fd_sc_hd__tapvpwrvgnd_1
XTAP_TAPCELL_ROW_5_348 vssd1 vccd1 sky130_fd_sc_hd__tapvpwrvgnd_1
Xfanout869 net873 vssd1 vssd1 vccd1 vccd1 net869 sky130_fd_sc_hd__buf_2
X_09795_ FPGA_INST.cell1.CB_1.config_dataA\[21\] FPGA_INST.cell1.CB_1.config_dataA\[20\]
+ net331 vssd1 vssd1 vccd1 vccd1 _00704_ sky130_fd_sc_hd__mux2_1
XFILLER_85_355 vssd1 vssd1 vccd1 vccd1 sky130_fd_sc_hd__fill_8
XPHY_EDGE_ROW_55_Right_55 vssd1 vssd1 vccd1 vccd1 sky130_fd_sc_hd__decap_3
X_08746_ net92 net87 FPGA_INST.cell3.LEI0.config_data\[36\] vssd1 vssd1 vccd1 vccd1
+ _04955_ sky130_fd_sc_hd__mux2_1
XANTENNA__07930__A3 FPGA_INST.bus3_1\[7\] vssd1 vssd1 vccd1 vccd1 sky130_fd_sc_hd__diode_2
XANTENNA__09361__S net240 vssd1 vssd1 vccd1 vccd1 sky130_fd_sc_hd__diode_2
X_05958_ FPGA_INST.cell2.SB0.route_sel\[48\] FPGA_INST.cell2.SB0.route_sel\[49\] vssd1
+ vssd1 vccd1 vccd1 _02238_ sky130_fd_sc_hd__nand2_1
XFILLER_39_794 vssd1 vssd1 vccd1 vccd1 sky130_fd_sc_hd__fill_1
X_08677_ FPGA_INST.cell3.LEI0.config_data\[13\] _04885_ vssd1 vssd1 vccd1 vccd1 _04886_
+ sky130_fd_sc_hd__nor2_1
XFILLER_54_753 vssd1 vssd1 vccd1 vccd1 sky130_fd_sc_hd__fill_1
X_05889_ net9 net10 net11 net13 net506 net505 vssd1 vssd1 vccd1 vccd1 _02169_ sky130_fd_sc_hd__mux4_1
XANTENNA_fanout732_A net29 vssd1 vssd1 vccd1 vccd1 sky130_fd_sc_hd__diode_2
XFILLER_38_293 vssd1 vssd1 vccd1 vccd1 sky130_fd_sc_hd__fill_4
X_07628_ FPGA_INST.cell1.SB0.route_sel\[88\] FPGA_INST.cell1.SB0.route_sel\[89\] vssd1
+ vssd1 vccd1 vccd1 _03881_ sky130_fd_sc_hd__nand2_1
XFILLER_41_414 vssd1 vssd1 vccd1 vccd1 sky130_fd_sc_hd__fill_4
XTAP_TAPCELL_ROW_24_612 vssd1 vccd1 sky130_fd_sc_hd__tapvpwrvgnd_1
XFILLER_26_477 vccd1 vssd1 vccd1 vssd1 sky130_ef_sc_hd__decap_40_12
XFILLER_41_447 vssd1 vssd1 vccd1 vccd1 sky130_fd_sc_hd__fill_1
XTAP_TAPCELL_ROW_24_623 vssd1 vccd1 sky130_fd_sc_hd__tapvpwrvgnd_1
X_07559_ FPGA_INST.cell3.SB0.route_sel\[74\] FPGA_INST.cell3.SB0.route_sel\[75\] vssd1
+ vssd1 vccd1 vccd1 _03814_ sky130_fd_sc_hd__nand2_1
XTAP_TAPCELL_ROW_62_1153 vssd1 vccd1 sky130_fd_sc_hd__tapvpwrvgnd_1
X_10570_ FPGA_INST.cell3.CB_0.config_dataA\[14\] FPGA_INST.cell3.CB_0.config_dataA\[15\]
+ net302 vssd1 vssd1 vccd1 vccd1 _01449_ sky130_fd_sc_hd__mux2_1
XANTENNA__08643__A1 net19 vssd1 vssd1 vccd1 vccd1 sky130_fd_sc_hd__diode_2
XPHY_EDGE_ROW_64_Right_64 vssd1 vssd1 vccd1 vccd1 sky130_fd_sc_hd__decap_3
XFILLER_42_78 vssd1 vssd1 vccd1 vccd1 sky130_fd_sc_hd__fill_2
XANTENNA__06249__A3 net17 vssd1 vssd1 vccd1 vccd1 sky130_fd_sc_hd__diode_2
XFILLER_21_171 vssd1 vssd1 vccd1 vccd1 sky130_fd_sc_hd__fill_4
XTAP_TAPCELL_ROW_118_1931 vssd1 vccd1 sky130_fd_sc_hd__tapvpwrvgnd_1
X_09229_ FPGA_INST.cell1.SB0.route_sel\[0\] FPGA_INST.cell1.SB0.route_sel\[1\] net222
+ vssd1 vssd1 vccd1 vccd1 _00142_ sky130_fd_sc_hd__mux2_1
X_12171_ net909 _01517_ net693 vssd1 vssd1 vccd1 vccd1 FPGA_INST.cell3.LE_1B.config_data\[8\]
+ sky130_fd_sc_hd__dfrtp_1
XFILLER_108_755 vssd1 vssd1 vccd1 vccd1 sky130_fd_sc_hd__fill_1
XPHY_EDGE_ROW_2_Left_133 vssd1 vssd1 vccd1 vccd1 sky130_fd_sc_hd__decap_3
XANTENNA_fanout99_X net99 vssd1 vssd1 vccd1 vccd1 sky130_fd_sc_hd__diode_2
XFILLER_122_257 vssd1 vssd1 vccd1 vccd1 sky130_fd_sc_hd__fill_1
X_11122_ net794 _00472_ net579 vssd1 vssd1 vccd1 vccd1 FPGA_INST.cell1.LE_1A.config_data\[13\]
+ sky130_fd_sc_hd__dfrtp_1
XANTENNA__06421__A3 net13 vssd1 vssd1 vccd1 vccd1 sky130_fd_sc_hd__diode_2
X_11053_ net814 _00403_ net599 vssd1 vssd1 vccd1 vccd1 FPGA_INST.cell1.LEI0.config_data\[38\]
+ sky130_fd_sc_hd__dfrtp_1
XANTENNA__06709__A1 _02801_ vssd1 vssd1 vccd1 vccd1 sky130_fd_sc_hd__diode_2
XFILLER_1_565 vssd1 vssd1 vccd1 vccd1 sky130_fd_sc_hd__fill_1
XPHY_EDGE_ROW_73_Right_73 vssd1 vssd1 vccd1 vccd1 sky130_fd_sc_hd__decap_3
XANTENNA__06709__B2 _02804_ vssd1 vssd1 vccd1 vccd1 sky130_fd_sc_hd__diode_2
X_10004_ FPGA_INST.cell0.CB_0.config_dataA\[3\] FPGA_INST.cell0.CB_0.config_dataA\[4\]
+ net180 vssd1 vssd1 vccd1 vccd1 _00885_ sky130_fd_sc_hd__mux2_1
XANTENNA__07382__B2 _03640_ vssd1 vssd1 vccd1 vccd1 sky130_fd_sc_hd__diode_2
XFILLER_123_70 vssd1 vssd1 vccd1 vccd1 sky130_fd_sc_hd__fill_2
X_11955_ net908 _01301_ net692 vssd1 vssd1 vccd1 vccd1 FPGA_INST.cell3.CB_1.config_dataB\[20\]
+ sky130_fd_sc_hd__dfstp_1
XPHY_EDGE_ROW_48_Left_179 vssd1 vssd1 vccd1 vccd1 sky130_fd_sc_hd__decap_3
XFILLER_45_753 vssd1 vssd1 vccd1 vccd1 sky130_fd_sc_hd__fill_4
XANTENNA__08882__A1 _04794_ vssd1 vssd1 vccd1 vccd1 sky130_fd_sc_hd__diode_2
XFILLER_83_85 vssd1 vssd1 vccd1 vccd1 sky130_fd_sc_hd__fill_4
X_10906_ net827 _00256_ net611 vssd1 vssd1 vccd1 vccd1 FPGA_INST.cell1.SB0.route_sel\[115\]
+ sky130_fd_sc_hd__dfstp_1
XFILLER_72_572 vssd1 vssd1 vccd1 vccd1 sky130_fd_sc_hd__fill_4
XFILLER_60_701 vssd1 vssd1 vccd1 vccd1 sky130_fd_sc_hd__fill_2
XANTENNA__06908__B _02350_ vssd1 vssd1 vccd1 vccd1 sky130_fd_sc_hd__diode_2
XANTENNA__08882__B2 _04789_ vssd1 vssd1 vccd1 vccd1 sky130_fd_sc_hd__diode_2
X_11886_ net929 _01232_ net713 vssd1 vssd1 vccd1 vccd1 FPGA_INST.cell3.LE_0A.config_data\[16\]
+ sky130_fd_sc_hd__dfrtp_1
X_10837_ net802 _00187_ net587 vssd1 vssd1 vccd1 vccd1 FPGA_INST.cell1.SB0.route_sel\[46\]
+ sky130_fd_sc_hd__dfstp_1
XPHY_EDGE_ROW_82_Right_82 vssd1 vssd1 vccd1 vccd1 sky130_fd_sc_hd__decap_3
X_10768_ net887 _00118_ net671 vssd1 vssd1 vccd1 vccd1 FPGA_INST.cell2.CB_1.config_dataB\[2\]
+ sky130_fd_sc_hd__dfstp_2
XPHY_EDGE_ROW_57_Left_188 vssd1 vssd1 vccd1 vccd1 sky130_fd_sc_hd__decap_3
X_10699_ FPGA_INST.cell2.LE_0A.sel_clk _00049_ net734 vssd1 vssd1 vccd1 vccd1 FPGA_INST.cell2.LE_0A.dff0_out
+ sky130_fd_sc_hd__dfrtp_1
XANTENNA__06948__B2 _02429_ vssd1 vssd1 vccd1 vccd1 sky130_fd_sc_hd__diode_2
XANTENNA__06948__A1 _02465_ vssd1 vssd1 vccd1 vccd1 sky130_fd_sc_hd__diode_2
XANTENNA__09446__S net361 vssd1 vssd1 vccd1 vccd1 sky130_fd_sc_hd__diode_2
XPHY_EDGE_ROW_91_Right_91 vssd1 vssd1 vccd1 vccd1 sky130_fd_sc_hd__decap_3
X_06930_ FPGA_INST.cell0.CB_0.config_dataB\[16\] net416 vssd1 vssd1 vccd1 vccd1 _03198_
+ sky130_fd_sc_hd__nor2_1
XFILLER_121_290 vssd1 vssd1 vccd1 vccd1 sky130_fd_sc_hd__fill_8
X_08600_ _03943_ _04808_ vssd1 vssd1 vccd1 vccd1 _04809_ sky130_fd_sc_hd__nand2_2
XTAP_TAPCELL_ROW_2_307 vssd1 vccd1 sky130_fd_sc_hd__tapvpwrvgnd_1
X_06861_ FPGA_INST.cell0.CB_0.config_dataB\[1\] net425 vssd1 vssd1 vccd1 vccd1 _03129_
+ sky130_fd_sc_hd__and2b_1
X_09580_ FPGA_INST.cell1.CB_1.config_dataB\[8\] FPGA_INST.cell1.CB_1.config_dataB\[9\]
+ net217 vssd1 vssd1 vccd1 vccd1 _00489_ sky130_fd_sc_hd__mux2_1
XFILLER_95_697 vssd1 vssd1 vccd1 vccd1 sky130_fd_sc_hd__fill_1
X_06792_ FPGA_INST.cell2.CB_1.config_dataB\[18\] FPGA_INST.cell2.CB_1.config_dataB\[17\]
+ vssd1 vssd1 vccd1 vccd1 _03066_ sky130_fd_sc_hd__nor2_1
XPHY_EDGE_ROW_66_Left_197 vssd1 vssd1 vccd1 vccd1 sky130_fd_sc_hd__decap_3
XFILLER_55_528 vssd1 vssd1 vccd1 vccd1 sky130_fd_sc_hd__fill_1
X_05812_ _02089_ _02091_ vssd1 vssd1 vccd1 vccd1 _02092_ sky130_fd_sc_hd__nand2_4
X_08531_ FPGA_INST.cell3.LE_1A.config_data\[14\] FPGA_INST.cell3.LE_1A.config_data\[15\]
+ _04725_ vssd1 vssd1 vccd1 vccd1 _04744_ sky130_fd_sc_hd__mux2_1
XFILLER_70_509 vssd1 vssd1 vccd1 vccd1 sky130_fd_sc_hd__fill_2
X_05743_ net385 net162 FPGA_INST.bus2_0\[10\] vssd1 vssd1 vccd1 vccd1 _02023_ sky130_fd_sc_hd__o21bai_1
X_08462_ FPGA_INST.cell1.LE_1A.config_data\[10\] FPGA_INST.cell1.LE_1A.config_data\[11\]
+ _04660_ vssd1 vssd1 vccd1 vccd1 _04680_ sky130_fd_sc_hd__mux2_1
X_05674_ FPGA_INST.cell2.CB_0.config_dataB\[24\] FPGA_INST.cell2.CB_0.config_dataB\[21\]
+ FPGA_INST.cell2.CB_0.config_dataB\[20\] vssd1 vssd1 vccd1 vccd1 _01954_ sky130_fd_sc_hd__nor3_2
XFILLER_35_241 vssd1 vssd1 vccd1 vccd1 sky130_fd_sc_hd__fill_1
XFILLER_35_274 vssd1 vssd1 vccd1 vccd1 sky130_fd_sc_hd__fill_1
XANTENNA__08873__A1 net18 vssd1 vssd1 vccd1 vccd1 sky130_fd_sc_hd__diode_2
XANTENNA__08873__B2 net19 vssd1 vssd1 vccd1 vccd1 sky130_fd_sc_hd__diode_2
XTAP_TAPCELL_ROW_102_1710 vssd1 vccd1 sky130_fd_sc_hd__tapvpwrvgnd_1
X_07413_ FPGA_INST.cell3.SB0.route_sel\[50\] FPGA_INST.cell3.SB0.route_sel\[51\] vssd1
+ vssd1 vccd1 vccd1 _03671_ sky130_fd_sc_hd__nand2_1
XFILLER_51_756 vssd1 vssd1 vccd1 vccd1 sky130_fd_sc_hd__fill_4
XANTENNA_fanout146_A net147 vssd1 vssd1 vccd1 vccd1 sky130_fd_sc_hd__diode_2
XANTENNA__08592__Y _04801_ vssd1 vssd1 vccd1 vccd1 sky130_fd_sc_hd__diode_2
X_08393_ net439 _03840_ _04614_ net438 vssd1 vssd1 vccd1 vccd1 _04615_ sky130_fd_sc_hd__o211a_1
XFILLER_50_288 vssd1 vssd1 vccd1 vccd1 sky130_fd_sc_hd__fill_4
X_07344_ _03601_ _03602_ _03603_ _02267_ vssd1 vssd1 vccd1 vccd1 _03604_ sky130_fd_sc_hd__a31o_4
XFILLER_10_119 vssd1 vssd1 vccd1 vccd1 sky130_fd_sc_hd__fill_1
XANTENNA__10356__A net737 vssd1 vssd1 vccd1 vccd1 sky130_fd_sc_hd__diode_2
X_07275_ _03495_ _03536_ vssd1 vssd1 vccd1 vccd1 _03537_ sky130_fd_sc_hd__nor2_1
XFILLER_12_15 vssd1 vssd1 vccd1 vccd1 sky130_fd_sc_hd__fill_4
XFILLER_128_26 vssd1 vssd1 vccd1 vccd1 sky130_fd_sc_hd__fill_2
X_09014_ FPGA_INST.cell1.SB0.route_sel\[18\] _01706_ _01707_ FPGA_INST.cell1.SB0.route_sel\[21\]
+ _05182_ vssd1 vssd1 vccd1 vccd1 _05183_ sky130_fd_sc_hd__a221o_1
X_06226_ net508 net509 vssd1 vssd1 vccd1 vccd1 _02506_ sky130_fd_sc_hd__nor2_1
XFILLER_12_59 vssd1 vssd1 vccd1 vccd1 sky130_fd_sc_hd__fill_1
XANTENNA_fanout313_A net314 vssd1 vssd1 vccd1 vccd1 sky130_fd_sc_hd__diode_2
XANTENNA__08389__A0 FPGA_INST.bus1_0\[14\] vssd1 vssd1 vccd1 vccd1 sky130_fd_sc_hd__diode_2
X_06157_ _01993_ _02358_ vssd1 vssd1 vccd1 vccd1 _02437_ sky130_fd_sc_hd__nor2_1
XANTENNA__06939__A1 FPGA_INST.bus2_0\[9\] vssd1 vssd1 vccd1 vccd1 sky130_fd_sc_hd__diode_2
XTAP_TAPCELL_ROW_113_1861 vssd1 vccd1 sky130_fd_sc_hd__tapvpwrvgnd_1
XANTENNA_fanout682_A net683 vssd1 vssd1 vccd1 vccd1 sky130_fd_sc_hd__diode_2
XANTENNA__09356__S net357 vssd1 vssd1 vccd1 vccd1 sky130_fd_sc_hd__diode_2
XANTENNA__06403__A3 net17 vssd1 vssd1 vccd1 vccd1 sky130_fd_sc_hd__diode_2
X_06088_ FPGA_INST.cell2.CB_0.config_dataA\[23\] FPGA_INST.cell2.CB_0.config_dataA\[22\]
+ vssd1 vssd1 vccd1 vccd1 _02368_ sky130_fd_sc_hd__or2_1
Xfanout622 net626 vssd1 vssd1 vccd1 vccd1 net622 sky130_fd_sc_hd__clkbuf_4
Xfanout600 net604 vssd1 vssd1 vccd1 vccd1 net600 sky130_fd_sc_hd__clkbuf_2
Xfanout611 net615 vssd1 vssd1 vccd1 vccd1 net611 sky130_fd_sc_hd__clkbuf_4
XFILLER_58_300 vssd1 vssd1 vccd1 vccd1 sky130_fd_sc_hd__fill_1
X_09916_ net736 _04647_ vssd1 vssd1 vccd1 vccd1 _05220_ sky130_fd_sc_hd__nand2_1
Xfanout633 net634 vssd1 vssd1 vccd1 vccd1 net633 sky130_fd_sc_hd__buf_2
Xfanout655 net656 vssd1 vssd1 vccd1 vccd1 net655 sky130_fd_sc_hd__clkbuf_4
Xfanout666 net676 vssd1 vssd1 vccd1 vccd1 net666 sky130_fd_sc_hd__buf_2
Xfanout644 net647 vssd1 vssd1 vccd1 vccd1 net644 sky130_fd_sc_hd__clkbuf_2
XANTENNA_fanout947_A net1 vssd1 vssd1 vccd1 vccd1 sky130_fd_sc_hd__diode_2
Xfanout699 net701 vssd1 vssd1 vccd1 vccd1 net699 sky130_fd_sc_hd__clkbuf_4
XANTENNA__07364__A1 net84 vssd1 vssd1 vccd1 vccd1 sky130_fd_sc_hd__diode_2
Xfanout688 net702 vssd1 vssd1 vccd1 vccd1 net688 sky130_fd_sc_hd__buf_2
Xfanout677 net683 vssd1 vssd1 vccd1 vccd1 net677 sky130_fd_sc_hd__clkbuf_4
X_09847_ FPGA_INST.cell0.LEI0.config_data\[25\] FPGA_INST.cell0.LEI0.config_data\[26\]
+ net179 vssd1 vssd1 vccd1 vccd1 _00755_ sky130_fd_sc_hd__mux2_1
X_09778_ FPGA_INST.cell1.CB_1.config_dataA\[3\] FPGA_INST.cell1.CB_1.config_dataA\[4\]
+ net212 vssd1 vssd1 vccd1 vccd1 _00687_ sky130_fd_sc_hd__mux2_1
XFILLER_85_163 vssd1 vssd1 vccd1 vccd1 sky130_fd_sc_hd__fill_4
XFILLER_37_67 vssd1 vssd1 vccd1 vccd1 sky130_fd_sc_hd__fill_2
X_08729_ net394 _04839_ vssd1 vssd1 vccd1 vccd1 _04938_ sky130_fd_sc_hd__or2_1
XFILLER_37_89 vssd1 vssd1 vccd1 vccd1 sky130_fd_sc_hd__fill_2
XANTENNA_fanout735_X net735 vssd1 vssd1 vccd1 vccd1 sky130_fd_sc_hd__diode_2
X_11740_ net895 _01086_ net679 vssd1 vssd1 vccd1 vccd1 FPGA_INST.cell3.SB0.route_sel\[110\]
+ sky130_fd_sc_hd__dfstp_1
XFILLER_53_11 vssd1 vssd1 vccd1 vccd1 sky130_fd_sc_hd__fill_1
XFILLER_42_712 vssd1 vssd1 vccd1 vccd1 sky130_fd_sc_hd__fill_1
XFILLER_27_764 vssd1 vssd1 vccd1 vccd1 sky130_fd_sc_hd__fill_2
XFILLER_81_391 vssd1 vssd1 vccd1 vccd1 sky130_fd_sc_hd__fill_1
XFILLER_41_211 vssd1 vssd1 vccd1 vccd1 sky130_fd_sc_hd__fill_2
X_11671_ net908 _01017_ net692 vssd1 vssd1 vccd1 vccd1 FPGA_INST.cell3.SB0.route_sel\[41\]
+ sky130_fd_sc_hd__dfstp_2
X_10622_ FPGA_INST.cell3.CB_1.config_dataA\[17\] FPGA_INST.cell3.CB_1.config_dataA\[16\]
+ net375 vssd1 vssd1 vccd1 vccd1 _01501_ sky130_fd_sc_hd__mux2_1
XANTENNA__07419__A2 FPGA_INST.cell1.SB0.route_sel\[49\] vssd1 vssd1 vccd1 vccd1 sky130_fd_sc_hd__diode_2
X_10553_ FPGA_INST.cell2.SB0.route_sel\[125\] FPGA_INST.cell2.SB0.route_sel\[126\]
+ net248 vssd1 vssd1 vccd1 vccd1 _01432_ sky130_fd_sc_hd__mux2_1
X_10484_ FPGA_INST.cell2.SB0.route_sel\[56\] FPGA_INST.cell2.SB0.route_sel\[57\] net194
+ vssd1 vssd1 vccd1 vccd1 _01363_ sky130_fd_sc_hd__mux2_1
XTAP_TAPCELL_ROW_75_1333 vssd1 vccd1 sky130_fd_sc_hd__tapvpwrvgnd_1
XFILLER_5_178 vssd1 vssd1 vccd1 vccd1 sky130_fd_sc_hd__fill_2
X_12154_ net935 _01500_ net719 vssd1 vssd1 vccd1 vccd1 FPGA_INST.cell3.CB_1.config_dataA\[16\]
+ sky130_fd_sc_hd__dfstp_1
XANTENNA__08395__A3 FPGA_INST.bus1_0\[11\] vssd1 vssd1 vccd1 vccd1 sky130_fd_sc_hd__diode_2
X_11105_ net838 _00455_ net622 vssd1 vssd1 vccd1 vccd1 FPGA_INST.cell1.LE_0B.reset_val
+ sky130_fd_sc_hd__dfrtp_1
XANTENNA__08958__X FPGA_INST.bus3_1\[9\] vssd1 vssd1 vccd1 vccd1 sky130_fd_sc_hd__diode_2
XFILLER_78_96 vssd1 vssd1 vccd1 vccd1 sky130_fd_sc_hd__fill_1
X_12085_ net859 _01431_ net645 vssd1 vssd1 vccd1 vccd1 FPGA_INST.cell2.SB0.route_sel\[125\]
+ sky130_fd_sc_hd__dfstp_1
XANTENNA_input31_X net31 vssd1 vssd1 vccd1 vccd1 sky130_fd_sc_hd__diode_2
X_11036_ net814 _00386_ net599 vssd1 vssd1 vccd1 vccd1 FPGA_INST.cell1.LEI0.config_data\[21\]
+ sky130_fd_sc_hd__dfrtp_1
XFILLER_92_612 vssd1 vssd1 vccd1 vccd1 sky130_fd_sc_hd__fill_1
XANTENNA__06638__B _02832_ vssd1 vssd1 vccd1 vccd1 sky130_fd_sc_hd__diode_2
XFILLER_45_561 vssd1 vssd1 vccd1 vccd1 sky130_fd_sc_hd__fill_2
X_11938_ net914 _01284_ net698 vssd1 vssd1 vccd1 vccd1 FPGA_INST.cell3.CB_1.config_dataB\[3\]
+ sky130_fd_sc_hd__dfstp_1
XTAP_TAPCELL_ROW_86_1484 vssd1 vccd1 sky130_fd_sc_hd__tapvpwrvgnd_1
XFILLER_60_531 vssd1 vssd1 vccd1 vccd1 sky130_fd_sc_hd__fill_1
XFILLER_33_734 vssd1 vssd1 vccd1 vccd1 sky130_fd_sc_hd__fill_1
X_11869_ FPGA_INST.cell3.LE_0B.sel_clk _01215_ net735 vssd1 vssd1 vccd1 vccd1 FPGA_INST.cell3.LE_0B.dff1_out
+ sky130_fd_sc_hd__dfstp_1
X_05390_ FPGA_INST.cell3.SB0.route_sel\[50\] vssd1 vssd1 vccd1 vccd1 _01672_ sky130_fd_sc_hd__inv_2
XANTENNA__08607__A1 net27 vssd1 vssd1 vccd1 vccd1 sky130_fd_sc_hd__diode_2
XTAP_TAPCELL_ROW_15_486 vssd1 vccd1 sky130_fd_sc_hd__tapvpwrvgnd_1
XTAP_TAPCELL_ROW_15_497 vssd1 vccd1 sky130_fd_sc_hd__tapvpwrvgnd_1
XFILLER_71_3 vssd1 vssd1 vccd1 vccd1 sky130_fd_sc_hd__fill_2
X_07060_ FPGA_INST.cell0.CB_0.config_dataA\[13\] FPGA_INST.cell0.CB_0.config_dataA\[12\]
+ vssd1 vssd1 vccd1 vccd1 _03326_ sky130_fd_sc_hd__or2_1
X_06011_ FPGA_INST.cell2.SB0.route_sel\[38\] _01557_ FPGA_INST.cell2.SB0.route_sel\[34\]
+ FPGA_INST.cell2.SB0.route_sel\[35\] _02290_ vssd1 vssd1 vccd1 vccd1 _02291_ sky130_fd_sc_hd__o221a_1
XANTENNA__05841__A1 _02112_ vssd1 vssd1 vccd1 vccd1 sky130_fd_sc_hd__diode_2
XFILLER_114_533 vssd1 vssd1 vccd1 vccd1 sky130_fd_sc_hd__fill_2
XFILLER_101_238 vssd1 vssd1 vccd1 vccd1 sky130_fd_sc_hd__fill_1
XFILLER_99_288 vssd1 vssd1 vccd1 vccd1 sky130_fd_sc_hd__fill_1
X_07962_ _04189_ vssd1 vssd1 vccd1 vccd1 _04190_ sky130_fd_sc_hd__inv_2
X_09701_ FPGA_INST.cell0.SB0.route_sel\[104\] FPGA_INST.cell0.SB0.route_sel\[105\]
+ net198 vssd1 vssd1 vccd1 vccd1 _00610_ sky130_fd_sc_hd__mux2_1
XFILLER_4_82 vssd1 vssd1 vccd1 vccd1 sky130_fd_sc_hd__fill_2
XFILLER_110_761 vssd1 vssd1 vccd1 vccd1 sky130_fd_sc_hd__fill_2
XFILLER_110_750 vssd1 vssd1 vccd1 vccd1 sky130_fd_sc_hd__fill_4
X_07893_ _03613_ _04117_ _04120_ _04116_ vssd1 vssd1 vccd1 vccd1 _04121_ sky130_fd_sc_hd__a211o_1
XPHY_EDGE_ROW_74_Left_205 vssd1 vssd1 vccd1 vccd1 sky130_fd_sc_hd__decap_3
XANTENNA__07346__A1 FPGA_INST.cell1.SB0.route_sel\[39\] vssd1 vssd1 vccd1 vccd1 sky130_fd_sc_hd__diode_2
X_06913_ _02309_ _03163_ _03165_ _02270_ _01746_ vssd1 vssd1 vccd1 vccd1 _03181_ sky130_fd_sc_hd__a221o_1
XANTENNA__07932__B _03568_ vssd1 vssd1 vccd1 vccd1 sky130_fd_sc_hd__diode_2
XFILLER_55_303 vssd1 vssd1 vccd1 vccd1 sky130_fd_sc_hd__fill_2
X_09632_ FPGA_INST.cell0.SB0.route_sel\[36\] FPGA_INST.cell0.SB0.route_sel\[35\] net321
+ vssd1 vssd1 vccd1 vccd1 _00541_ sky130_fd_sc_hd__mux2_1
X_06844_ _01937_ _03094_ _03095_ _01984_ vssd1 vssd1 vccd1 vccd1 _03112_ sky130_fd_sc_hd__a22o_1
X_09563_ FPGA_INST.cell1.LE_1A.config_data\[13\] FPGA_INST.cell1.LE_1A.config_data\[12\]
+ net326 vssd1 vssd1 vccd1 vccd1 _00472_ sky130_fd_sc_hd__mux2_1
X_08514_ net90 net84 net82 _01792_ FPGA_INST.cell3.LEI0.config_data\[30\] FPGA_INST.cell3.LEI0.config_data\[31\]
+ vssd1 vssd1 vccd1 vccd1 _04727_ sky130_fd_sc_hd__mux4_1
XFILLER_70_306 vssd1 vssd1 vccd1 vccd1 sky130_fd_sc_hd__fill_2
X_06775_ net512 _02832_ vssd1 vssd1 vccd1 vccd1 _03049_ sky130_fd_sc_hd__nand2_1
XANTENNA_fanout263_A net266 vssd1 vssd1 vccd1 vccd1 sky130_fd_sc_hd__diode_2
XFILLER_24_701 vssd1 vssd1 vccd1 vccd1 sky130_fd_sc_hd__fill_2
X_09494_ FPGA_INST.cell1.LEI0.config_data\[40\] FPGA_INST.cell1.LEI0.config_data\[41\]
+ net215 vssd1 vssd1 vccd1 vccd1 _00406_ sky130_fd_sc_hd__mux2_1
XFILLER_82_188 vssd1 vssd1 vccd1 vccd1 sky130_fd_sc_hd__fill_1
X_05726_ _02005_ vssd1 vssd1 vccd1 vccd1 _02006_ sky130_fd_sc_hd__inv_2
XFILLER_36_583 vssd1 vssd1 vccd1 vccd1 sky130_fd_sc_hd__fill_2
X_08445_ FPGA_INST.cell1.LEI0.config_data\[32\] _04662_ vssd1 vssd1 vccd1 vccd1 _04663_
+ sky130_fd_sc_hd__nand2b_1
XANTENNA__08310__A3 FPGA_INST.bus1_0\[3\] vssd1 vssd1 vccd1 vccd1 sky130_fd_sc_hd__diode_2
XFILLER_23_233 vssd1 vssd1 vccd1 vccd1 sky130_fd_sc_hd__fill_1
X_05657_ _01936_ vssd1 vssd1 vccd1 vccd1 _01937_ sky130_fd_sc_hd__inv_2
XTAP_TAPCELL_ROW_34_762 vssd1 vccd1 sky130_fd_sc_hd__tapvpwrvgnd_1
XPHY_EDGE_ROW_83_Left_214 vssd1 vssd1 vccd1 vccd1 sky130_fd_sc_hd__decap_3
X_08376_ _04589_ _04590_ _04596_ _04597_ vssd1 vssd1 vccd1 vccd1 _04598_ sky130_fd_sc_hd__o22a_1
X_05588_ FPGA_INST.cell2.SB0.route_sel\[118\] _01583_ FPGA_INST.cell2.SB0.route_sel\[114\]
+ FPGA_INST.cell2.SB0.route_sel\[115\] _01867_ vssd1 vssd1 vccd1 vccd1 _01868_ sky130_fd_sc_hd__o221a_1
X_07327_ FPGA_INST.cell3.CB_1.config_dataA\[23\] FPGA_INST.cell3.CB_1.config_dataA\[22\]
+ vssd1 vssd1 vccd1 vccd1 _03587_ sky130_fd_sc_hd__nand2b_2
XFILLER_23_69 vccd1 vssd1 vccd1 vssd1 sky130_ef_sc_hd__decap_40_12
XANTENNA__06085__A1 _02352_ vssd1 vssd1 vccd1 vccd1 sky130_fd_sc_hd__diode_2
X_07258_ _03400_ _03498_ _03519_ vssd1 vssd1 vccd1 vccd1 _03520_ sky130_fd_sc_hd__a21o_1
X_07189_ _03396_ _03451_ vssd1 vssd1 vccd1 vccd1 _03452_ sky130_fd_sc_hd__nor2_1
X_06209_ _02256_ _02331_ _02414_ _02488_ vssd1 vssd1 vccd1 vccd1 _02489_ sky130_fd_sc_hd__o22a_1
XTAP_TAPCELL_ROW_57_1085 vssd1 vccd1 sky130_fd_sc_hd__tapvpwrvgnd_1
XTAP_TAPCELL_ROW_57_1074 vssd1 vccd1 sky130_fd_sc_hd__tapvpwrvgnd_1
XPHY_EDGE_ROW_92_Left_223 vssd1 vssd1 vccd1 vccd1 sky130_fd_sc_hd__decap_3
Xfanout441 FPGA_INST.cell0.CB_1.config_dataB\[11\] vssd1 vssd1 vccd1 vccd1 net441
+ sky130_fd_sc_hd__buf_2
Xfanout430 FPGA_INST.cell0.CB_0.config_dataA\[10\] vssd1 vssd1 vccd1 vccd1 net430
+ sky130_fd_sc_hd__buf_2
Xfanout452 FPGA_INST.cell1.CB_0.config_dataB\[15\] vssd1 vssd1 vccd1 vccd1 net452
+ sky130_fd_sc_hd__clkbuf_2
Xfanout463 net464 vssd1 vssd1 vccd1 vccd1 net463 sky130_fd_sc_hd__buf_2
XTAP_TAPCELL_ROW_70_1263 vssd1 vccd1 sky130_fd_sc_hd__tapvpwrvgnd_1
XFILLER_58_141 vssd1 vssd1 vccd1 vccd1 sky130_fd_sc_hd__fill_1
Xfanout474 FPGA_INST.cell2.CB_1.config_dataA\[16\] vssd1 vssd1 vccd1 vccd1 net474
+ sky130_fd_sc_hd__clkbuf_2
XANTENNA__07888__A2 _03690_ vssd1 vssd1 vccd1 vccd1 sky130_fd_sc_hd__diode_2
XFILLER_101_794 vssd1 vssd1 vccd1 vccd1 sky130_fd_sc_hd__fill_1
XFILLER_59_675 vssd1 vssd1 vccd1 vccd1 sky130_fd_sc_hd__fill_1
Xfanout496 FPGA_INST.cell2.CB_0.config_dataB\[1\] vssd1 vssd1 vccd1 vccd1 net496 sky130_fd_sc_hd__buf_2
XFILLER_19_539 vssd1 vssd1 vccd1 vccd1 sky130_fd_sc_hd__fill_8
Xfanout485 FPGA_INST.cell2.CB_0.config_dataB\[23\] vssd1 vssd1 vccd1 vccd1 net485
+ sky130_fd_sc_hd__buf_2
XFILLER_0_29 vssd1 vssd1 vccd1 vccd1 sky130_fd_sc_hd__fill_4
XFILLER_0_18 vssd1 vssd1 vccd1 vccd1 sky130_fd_sc_hd__fill_8
XFILLER_42_531 vssd1 vssd1 vccd1 vccd1 sky130_fd_sc_hd__fill_1
X_11723_ net894 _01069_ net678 vssd1 vssd1 vccd1 vccd1 FPGA_INST.cell3.SB0.route_sel\[93\]
+ sky130_fd_sc_hd__dfstp_1
XFILLER_14_244 vssd1 vssd1 vccd1 vccd1 sky130_fd_sc_hd__fill_1
XFILLER_120_82 vssd1 vssd1 vccd1 vccd1 sky130_fd_sc_hd__fill_2
X_11654_ net895 _01000_ net679 vssd1 vssd1 vccd1 vccd1 FPGA_INST.cell3.SB0.route_sel\[24\]
+ sky130_fd_sc_hd__dfstp_1
XFILLER_42_597 vssd1 vssd1 vccd1 vccd1 sky130_fd_sc_hd__fill_2
X_10605_ FPGA_INST.cell3.CB_0.config_dataB\[24\] FPGA_INST.cell3.CB_1.config_dataA\[0\]
+ net282 vssd1 vssd1 vccd1 vccd1 _01484_ sky130_fd_sc_hd__mux2_1
Xfanout92 net93 vssd1 vssd1 vccd1 vccd1 net92 sky130_fd_sc_hd__clkbuf_2
Xfanout81 net83 vssd1 vssd1 vccd1 vccd1 net81 sky130_fd_sc_hd__buf_2
XTAP_TAPCELL_ROW_12_445 vssd1 vccd1 sky130_fd_sc_hd__tapvpwrvgnd_1
XANTENNA__09262__A1 FPGA_INST.cell1.SB0.route_sel\[33\] vssd1 vssd1 vccd1 vccd1 sky130_fd_sc_hd__diode_2
X_11585_ net760 _00935_ net545 vssd1 vssd1 vccd1 vccd1 FPGA_INST.cell0.CB_1.config_dataA\[4\]
+ sky130_fd_sc_hd__dfstp_1
XTAP_TAPCELL_ROW_12_456 vssd1 vccd1 sky130_fd_sc_hd__tapvpwrvgnd_1
X_10536_ FPGA_INST.cell2.SB0.route_sel\[108\] FPGA_INST.cell2.SB0.route_sel\[109\]
+ net244 vssd1 vssd1 vccd1 vccd1 _01415_ sky130_fd_sc_hd__mux2_1
XPHY_EDGE_ROW_108_Right_108 vssd1 vssd1 vccd1 vccd1 sky130_fd_sc_hd__decap_3
X_10467_ FPGA_INST.cell2.SB0.route_sel\[39\] FPGA_INST.cell2.SB0.route_sel\[40\] net243
+ vssd1 vssd1 vccd1 vccd1 _01346_ sky130_fd_sc_hd__mux2_1
XANTENNA__07025__A0 FPGA_INST.bus2_0\[8\] vssd1 vssd1 vccd1 vccd1 sky130_fd_sc_hd__diode_2
XFILLER_123_352 vssd1 vssd1 vccd1 vccd1 sky130_fd_sc_hd__fill_2
XFILLER_123_341 vssd1 vssd1 vccd1 vccd1 sky130_fd_sc_hd__fill_2
X_10398_ FPGA_INST.cell3.LE_1A.config_data\[16\] FPGA_INST.cell3.LE_1A.edge_mode net303
+ vssd1 vssd1 vccd1 vccd1 _01277_ sky130_fd_sc_hd__mux2_1
XFILLER_69_417 vssd1 vssd1 vccd1 vccd1 sky130_fd_sc_hd__fill_4
XFILLER_43_7 vssd1 vssd1 vccd1 vccd1 sky130_fd_sc_hd__fill_1
X_12137_ net915 _01483_ net699 vssd1 vssd1 vccd1 vccd1 FPGA_INST.cell3.CB_0.config_dataB\[24\]
+ sky130_fd_sc_hd__dfstp_1
XFILLER_96_225 vssd1 vssd1 vccd1 vccd1 sky130_fd_sc_hd__fill_1
XANTENNA__09724__S net336 vssd1 vssd1 vccd1 vccd1 sky130_fd_sc_hd__diode_2
XFILLER_84_409 vssd1 vssd1 vccd1 vccd1 sky130_fd_sc_hd__fill_8
X_12068_ net853 _01414_ net638 vssd1 vssd1 vccd1 vccd1 FPGA_INST.cell2.SB0.route_sel\[108\]
+ sky130_fd_sc_hd__dfstp_1
X_11019_ net812 _00369_ net597 vssd1 vssd1 vccd1 vccd1 FPGA_INST.cell1.LEI0.config_data\[4\]
+ sky130_fd_sc_hd__dfrtp_1
XTAP_TAPCELL_ROW_88_1513 vssd1 vccd1 sky130_fd_sc_hd__tapvpwrvgnd_1
XFILLER_92_486 vssd1 vssd1 vccd1 vccd1 sky130_fd_sc_hd__fill_1
XFILLER_64_155 vssd1 vssd1 vccd1 vccd1 sky130_fd_sc_hd__fill_4
XANTENNA__06551__A2 FPGA_INST.bus3_2\[14\] vssd1 vssd1 vccd1 vccd1 sky130_fd_sc_hd__diode_2
XFILLER_33_520 vccd1 vssd1 vccd1 vssd1 sky130_ef_sc_hd__decap_40_12
X_06560_ net241 _02044_ _02052_ _02835_ vssd1 vssd1 vccd1 vccd1 _02836_ sky130_fd_sc_hd__nand4_4
X_05511_ FPGA_INST.bus3_2\[6\] vssd1 vssd1 vccd1 vccd1 _01793_ sky130_fd_sc_hd__inv_2
X_06491_ FPGA_INST.cell2.LE_0B.dff0_out FPGA_INST.cell2.LE_0B.dff1_out FPGA_INST.cell2.LE_0B.reset_val
+ vssd1 vssd1 vccd1 vccd1 FPGA_INST.cell2.LE_0B.dff_out sky130_fd_sc_hd__mux2_1
X_08230_ _04447_ _04448_ _04450_ _04453_ vssd1 vssd1 vccd1 vccd1 _04454_ sky130_fd_sc_hd__o211a_1
X_05442_ FPGA_INST.cell0.SB0.route_sel\[6\] vssd1 vssd1 vccd1 vccd1 _01724_ sky130_fd_sc_hd__inv_2
XFILLER_20_214 vssd1 vssd1 vccd1 vccd1 sky130_fd_sc_hd__fill_2
XTAP_TAPCELL_ROW_31_710 vssd1 vccd1 sky130_fd_sc_hd__tapvpwrvgnd_1
XTAP_TAPCELL_ROW_31_721 vssd1 vccd1 sky130_fd_sc_hd__tapvpwrvgnd_1
XFILLER_119_614 vssd1 vssd1 vccd1 vccd1 sky130_fd_sc_hd__fill_2
XFILLER_118_113 vssd1 vssd1 vccd1 vccd1 sky130_fd_sc_hd__fill_8
X_05373_ FPGA_INST.cell3.SB0.route_sel\[66\] vssd1 vssd1 vccd1 vccd1 _01655_ sky130_fd_sc_hd__inv_2
X_08161_ net76 FPGA_INST.bus1_0\[13\] FPGA_INST.bus1_0\[14\] FPGA_INST.bus1_0\[15\]
+ net412 net411 vssd1 vssd1 vccd1 vccd1 _04385_ sky130_fd_sc_hd__mux4_1
X_08092_ _04317_ vssd1 vssd1 vccd1 vccd1 _04318_ sky130_fd_sc_hd__inv_2
XTAP_TAPCELL_ROW_99_1675 vssd1 vccd1 sky130_fd_sc_hd__tapvpwrvgnd_1
XTAP_TAPCELL_ROW_99_1664 vssd1 vccd1 sky130_fd_sc_hd__tapvpwrvgnd_1
XANTENNA__07803__A2 FPGA_INST.cell3.SB0.route_sel\[124\] vssd1 vssd1 vccd1 vccd1 sky130_fd_sc_hd__diode_2
X_07112_ net115 net118 net110 net98 FPGA_INST.cell0.LEI0.config_data\[36\] FPGA_INST.cell0.LEI0.config_data\[37\]
+ vssd1 vssd1 vccd1 vccd1 _03378_ sky130_fd_sc_hd__mux4_1
X_07043_ _03304_ _03308_ _03301_ vssd1 vssd1 vccd1 vccd1 _03309_ sky130_fd_sc_hd__a21oi_1
XFILLER_114_363 vssd1 vssd1 vccd1 vccd1 sky130_fd_sc_hd__fill_1
XTAP_TAPCELL_ROW_110_1820 vssd1 vccd1 sky130_fd_sc_hd__tapvpwrvgnd_1
X_08994_ _03666_ _05169_ vssd1 vssd1 vccd1 vccd1 FPGA_INST.bus3_1\[5\] sky130_fd_sc_hd__and2_2
XFILLER_102_525 vssd1 vssd1 vccd1 vccd1 sky130_fd_sc_hd__fill_2
XANTENNA__05578__B1 net16 vssd1 vssd1 vccd1 vccd1 sky130_fd_sc_hd__diode_2
XANTENNA_fanout380_A net381 vssd1 vssd1 vccd1 vccd1 sky130_fd_sc_hd__diode_2
XANTENNA__07319__A1 net21 vssd1 vssd1 vccd1 vccd1 sky130_fd_sc_hd__diode_2
X_07945_ net467 _04013_ _04172_ net465 vssd1 vssd1 vccd1 vccd1 _04173_ sky130_fd_sc_hd__o211a_1
XFILLER_28_303 vssd1 vssd1 vccd1 vccd1 sky130_fd_sc_hd__fill_2
XTAP_TAPCELL_ROW_126_2049 vssd1 vccd1 sky130_fd_sc_hd__tapvpwrvgnd_1
X_07876_ net469 _04049_ vssd1 vssd1 vccd1 vccd1 _04104_ sky130_fd_sc_hd__nand2_1
X_09615_ FPGA_INST.cell0.SB0.route_sel\[19\] FPGA_INST.cell0.SB0.route_sel\[18\] net323
+ vssd1 vssd1 vccd1 vccd1 _00524_ sky130_fd_sc_hd__mux2_1
XFILLER_28_336 vssd1 vssd1 vccd1 vccd1 sky130_fd_sc_hd__fill_1
XTAP_TAPCELL_ROW_39_832 vssd1 vccd1 sky130_fd_sc_hd__tapvpwrvgnd_1
XANTENNA_fanout266_X net266 vssd1 vssd1 vccd1 vccd1 sky130_fd_sc_hd__diode_2
XFILLER_55_166 vssd1 vssd1 vccd1 vccd1 sky130_fd_sc_hd__fill_2
XANTENNA_fanout645_A net647 vssd1 vssd1 vccd1 vccd1 sky130_fd_sc_hd__diode_2
XFILLER_43_317 vssd1 vssd1 vccd1 vccd1 sky130_fd_sc_hd__fill_8
X_06827_ net420 net421 vssd1 vssd1 vccd1 vccd1 _03095_ sky130_fd_sc_hd__and2b_2
XFILLER_28_369 vssd1 vssd1 vccd1 vccd1 sky130_fd_sc_hd__fill_2
X_09546_ FPGA_INST.cell1.LE_0B.reset_val FPGA_INST.cell1.LE_0B.reset_mode net229 vssd1
+ vssd1 vccd1 vccd1 _00456_ sky130_fd_sc_hd__mux2_1
XTAP_TAPCELL_ROW_108_1793 vssd1 vccd1 sky130_fd_sc_hd__tapvpwrvgnd_1
XFILLER_70_103 vssd1 vssd1 vccd1 vccd1 sky130_fd_sc_hd__fill_1
X_06758_ _02780_ _03021_ _03022_ _02784_ FPGA_INST.cell2.CB_1.config_dataB\[12\] vssd1
+ vssd1 vccd1 vccd1 _03032_ sky130_fd_sc_hd__a221o_1
XFILLER_43_339 vssd1 vssd1 vccd1 vccd1 sky130_fd_sc_hd__fill_1
X_09477_ FPGA_INST.cell1.LEI0.config_data\[24\] FPGA_INST.cell1.LEI0.config_data\[23\]
+ net336 vssd1 vssd1 vccd1 vccd1 _00389_ sky130_fd_sc_hd__mux2_1
XANTENNA_fanout812_A net820 vssd1 vssd1 vccd1 vccd1 sky130_fd_sc_hd__diode_2
X_05709_ FPGA_INST.cell2.SB0.route_sel\[104\] FPGA_INST.cell2.SB0.route_sel\[105\]
+ vssd1 vssd1 vccd1 vccd1 _01989_ sky130_fd_sc_hd__nand2_1
XANTENNA__05750__X _02030_ vssd1 vssd1 vccd1 vccd1 sky130_fd_sc_hd__diode_2
XTAP_TAPCELL_ROW_121_1971 vssd1 vccd1 sky130_fd_sc_hd__tapvpwrvgnd_1
X_06689_ net519 net520 vssd1 vssd1 vccd1 vccd1 _02963_ sky130_fd_sc_hd__nor2_1
X_08428_ FPGA_INST.cell0.LE_1B.config_data\[16\] _04647_ _04648_ net155 vssd1 vssd1
+ vccd1 vccd1 FPGA_INST.cell0.CB_1.le_outB sky130_fd_sc_hd__o211a_1
XTAP_TAPCELL_ROW_121_1982 vssd1 vccd1 sky130_fd_sc_hd__tapvpwrvgnd_1
XFILLER_109_113 vssd1 vssd1 vccd1 vccd1 sky130_fd_sc_hd__fill_4
X_08359_ net442 _04040_ vssd1 vssd1 vccd1 vccd1 _04581_ sky130_fd_sc_hd__nand2_1
X_11370_ net817 _00720_ net602 vssd1 vssd1 vccd1 vccd1 FPGA_INST.cell1.LE_1B.config_data\[12\]
+ sky130_fd_sc_hd__dfrtp_1
XTAP_TAPCELL_ROW_59_1114 vssd1 vccd1 sky130_fd_sc_hd__tapvpwrvgnd_1
XTAP_TAPCELL_ROW_59_1103 vssd1 vccd1 sky130_fd_sc_hd__tapvpwrvgnd_1
X_10321_ FPGA_INST.cell3.LEI0.config_data\[36\] FPGA_INST.cell3.LEI0.config_data\[35\]
+ net370 vssd1 vssd1 vccd1 vccd1 _01202_ sky130_fd_sc_hd__mux2_1
XFILLER_3_402 vssd1 vssd1 vccd1 vccd1 sky130_fd_sc_hd__fill_4
XANTENNA__09547__A2 net523 vssd1 vssd1 vccd1 vccd1 sky130_fd_sc_hd__diode_2
XANTENNA__07007__A0 FPGA_INST.bus2_0\[8\] vssd1 vssd1 vccd1 vccd1 sky130_fd_sc_hd__diode_2
X_10252_ FPGA_INST.io_south_oeb\[24\] FPGA_INST.io_south_oeb\[26\] net264 vssd1 vssd1
+ vccd1 vccd1 _01133_ sky130_fd_sc_hd__mux2_1
XFILLER_120_311 vssd1 vssd1 vccd1 vccd1 sky130_fd_sc_hd__fill_1
XFILLER_105_385 vssd1 vssd1 vccd1 vccd1 sky130_fd_sc_hd__fill_1
XANTENNA_fanout81_X net81 vssd1 vssd1 vccd1 vccd1 sky130_fd_sc_hd__diode_2
X_10183_ FPGA_INST.cell3.SB0.route_sel\[88\] FPGA_INST.cell3.SB0.route_sel\[87\] net373
+ vssd1 vssd1 vccd1 vccd1 _01064_ sky130_fd_sc_hd__mux2_1
XFILLER_78_236 vssd1 vssd1 vccd1 vccd1 sky130_fd_sc_hd__fill_2
XFILLER_59_65 vssd1 vssd1 vccd1 vccd1 sky130_fd_sc_hd__fill_1
XANTENNA__08770__A3 _04828_ vssd1 vssd1 vccd1 vccd1 sky130_fd_sc_hd__diode_2
Xfanout282 net283 vssd1 vssd1 vccd1 vccd1 net282 sky130_fd_sc_hd__clkbuf_4
Xfanout271 net273 vssd1 vssd1 vccd1 vccd1 net271 sky130_fd_sc_hd__clkbuf_4
XFILLER_59_461 vssd1 vssd1 vccd1 vccd1 sky130_fd_sc_hd__fill_4
Xfanout260 net261 vssd1 vssd1 vccd1 vccd1 net260 sky130_fd_sc_hd__clkbuf_4
Xfanout293 net295 vssd1 vssd1 vccd1 vccd1 net293 sky130_fd_sc_hd__buf_2
XFILLER_93_239 vssd1 vssd1 vccd1 vccd1 sky130_fd_sc_hd__fill_2
XFILLER_74_453 vccd1 vssd1 vccd1 vssd1 sky130_ef_sc_hd__decap_40_12
XTAP_TAPCELL_ROW_17_515 vssd1 vccd1 sky130_fd_sc_hd__tapvpwrvgnd_1
XTAP_TAPCELL_ROW_17_526 vssd1 vccd1 sky130_fd_sc_hd__tapvpwrvgnd_1
XTAP_TAPCELL_ROW_83_1443 vssd1 vccd1 sky130_fd_sc_hd__tapvpwrvgnd_1
XFILLER_27_391 vssd1 vssd1 vccd1 vccd1 sky130_fd_sc_hd__fill_1
X_11706_ net920 _01052_ net704 vssd1 vssd1 vccd1 vccd1 FPGA_INST.cell3.SB0.route_sel\[76\]
+ sky130_fd_sc_hd__dfstp_1
XFILLER_70_692 vssd1 vssd1 vccd1 vccd1 sky130_fd_sc_hd__fill_4
XANTENNA__08038__A2 _03519_ vssd1 vssd1 vccd1 vccd1 sky130_fd_sc_hd__diode_2
X_11637_ net896 _00983_ net680 vssd1 vssd1 vccd1 vccd1 FPGA_INST.cell3.SB0.route_sel\[7\]
+ sky130_fd_sc_hd__dfstp_1
X_11568_ net772 _00918_ net558 vssd1 vssd1 vccd1 vccd1 FPGA_INST.cell0.CB_0.config_dataB\[12\]
+ sky130_fd_sc_hd__dfstp_2
XFILLER_7_774 vssd1 vssd1 vccd1 vccd1 sky130_fd_sc_hd__fill_2
X_10519_ FPGA_INST.cell2.SB0.route_sel\[92\] FPGA_INST.cell2.SB0.route_sel\[91\] net354
+ vssd1 vssd1 vccd1 vccd1 _01398_ sky130_fd_sc_hd__mux2_1
X_11499_ net791 _00849_ net576 vssd1 vssd1 vccd1 vccd1 FPGA_INST.cell0.CB_1.config_dataB\[5\]
+ sky130_fd_sc_hd__dfstp_1
XFILLER_111_311 vssd1 vssd1 vccd1 vccd1 sky130_fd_sc_hd__fill_1
XTAP_TAPCELL_ROW_94_1594 vssd1 vccd1 sky130_fd_sc_hd__tapvpwrvgnd_1
XFILLER_69_225 vssd1 vssd1 vccd1 vccd1 sky130_fd_sc_hd__fill_4
XFILLER_34_3 vssd1 vssd1 vccd1 vccd1 sky130_fd_sc_hd__fill_4
XFILLER_85_729 vssd1 vssd1 vccd1 vccd1 sky130_fd_sc_hd__fill_4
X_07730_ FPGA_INST.cell3.SB0.route_sel\[104\] FPGA_INST.cell3.SB0.route_sel\[105\]
+ vssd1 vssd1 vccd1 vccd1 _03981_ sky130_fd_sc_hd__or2_1
X_05991_ _02267_ _02269_ vssd1 vssd1 vccd1 vccd1 _02271_ sky130_fd_sc_hd__or2_1
XANTENNA__05980__B1 FPGA_INST.bus1_0\[4\] vssd1 vssd1 vccd1 vccd1 sky130_fd_sc_hd__diode_2
X_07661_ FPGA_INST.cell1.CB_0.config_dataB\[23\] FPGA_INST.cell1.CB_0.config_dataB\[22\]
+ vssd1 vssd1 vccd1 vccd1 _03913_ sky130_fd_sc_hd__nand2_2
XFILLER_53_604 vssd1 vssd1 vccd1 vccd1 sky130_fd_sc_hd__fill_1
XFILLER_1_72 vssd1 vssd1 vccd1 vccd1 sky130_fd_sc_hd__fill_1
XFILLER_1_61 vssd1 vssd1 vccd1 vccd1 sky130_fd_sc_hd__fill_2
XFILLER_92_294 vssd1 vssd1 vccd1 vccd1 sky130_fd_sc_hd__fill_1
XFILLER_92_272 vssd1 vssd1 vccd1 vccd1 sky130_fd_sc_hd__fill_1
X_07592_ _03836_ _03844_ _03845_ _03835_ vssd1 vssd1 vccd1 vccd1 _03846_ sky130_fd_sc_hd__a31o_1
X_06612_ net477 _02886_ _02887_ vssd1 vssd1 vccd1 vccd1 _02888_ sky130_fd_sc_hd__a21o_1
X_09400_ FPGA_INST.cell2.CB_0.config_dataB\[18\] FPGA_INST.cell2.CB_0.config_dataB\[19\]
+ net251 vssd1 vssd1 vccd1 vccd1 _00313_ sky130_fd_sc_hd__mux2_1
X_09331_ FPGA_INST.cell1.SB0.route_sel\[103\] FPGA_INST.cell1.SB0.route_sel\[102\]
+ net338 vssd1 vssd1 vccd1 vccd1 _00244_ sky130_fd_sc_hd__mux2_1
X_06543_ net247 _01953_ _01962_ _02818_ vssd1 vssd1 vccd1 vccd1 _02819_ sky130_fd_sc_hd__nand4_4
XFILLER_40_309 vssd1 vssd1 vccd1 vccd1 sky130_fd_sc_hd__fill_2
X_09262_ FPGA_INST.cell1.SB0.route_sel\[34\] FPGA_INST.cell1.SB0.route_sel\[33\] net336
+ vssd1 vssd1 vccd1 vccd1 _00175_ sky130_fd_sc_hd__mux2_1
XFILLER_21_523 vssd1 vssd1 vccd1 vccd1 sky130_fd_sc_hd__fill_1
XFILLER_21_545 vssd1 vssd1 vccd1 vccd1 sky130_fd_sc_hd__fill_4
X_06474_ _02750_ _02751_ FPGA_INST.cell2.CB_0.config_dataB\[17\] vssd1 vssd1 vccd1
+ vccd1 _02752_ sky130_fd_sc_hd__mux2_1
X_05425_ FPGA_INST.cell1.SB0.route_sel\[20\] vssd1 vssd1 vccd1 vccd1 _01707_ sky130_fd_sc_hd__inv_2
X_08213_ _04422_ _04423_ _04436_ vssd1 vssd1 vccd1 vccd1 _04437_ sky130_fd_sc_hd__a21oi_1
X_09193_ FPGA_INST.cell2.LE_1A.config_data\[11\] FPGA_INST.cell2.LE_1A.config_data\[10\]
+ net362 vssd1 vssd1 vccd1 vccd1 _00106_ sky130_fd_sc_hd__mux2_1
X_08144_ _04332_ _04369_ _04330_ vssd1 vssd1 vccd1 vccd1 _04370_ sky130_fd_sc_hd__mux2_1
XANTENNA_fanout226_A net227 vssd1 vssd1 vccd1 vccd1 sky130_fd_sc_hd__diode_2
X_05356_ FPGA_INST.cell0.SB0.route_sel\[95\] vssd1 vssd1 vccd1 vccd1 _01638_ sky130_fd_sc_hd__inv_2
XANTENNA__09629__S net196 vssd1 vssd1 vccd1 vccd1 sky130_fd_sc_hd__diode_2
XFILLER_107_628 vssd1 vssd1 vccd1 vccd1 sky130_fd_sc_hd__fill_1
XFILLER_106_105 vssd1 vssd1 vccd1 vccd1 sky130_fd_sc_hd__fill_1
XFILLER_20_15 vssd1 vssd1 vccd1 vccd1 sky130_fd_sc_hd__fill_4
X_08075_ FPGA_INST.cell1.CB_0.config_dataB\[11\] net455 vssd1 vssd1 vccd1 vccd1 _04301_
+ sky130_fd_sc_hd__nand2b_1
XFILLER_106_127 vssd1 vssd1 vccd1 vccd1 sky130_fd_sc_hd__fill_4
XANTENNA__06561__B _02836_ vssd1 vssd1 vccd1 vccd1 sky130_fd_sc_hd__diode_2
X_05287_ FPGA_INST.cell2.SB0.route_sel\[72\] vssd1 vssd1 vccd1 vccd1 _01569_ sky130_fd_sc_hd__inv_2
XANTENNA__06460__A1 net2 vssd1 vssd1 vccd1 vccd1 sky130_fd_sc_hd__diode_2
X_07026_ _02110_ _03282_ _03284_ _02146_ _03291_ vssd1 vssd1 vccd1 vccd1 _03292_ sky130_fd_sc_hd__a221o_1
XANTENNA_fanout595_A net596 vssd1 vssd1 vccd1 vccd1 sky130_fd_sc_hd__diode_2
XFILLER_88_523 vssd1 vssd1 vccd1 vccd1 sky130_fd_sc_hd__fill_8
XANTENNA__08201__A2 _03840_ vssd1 vssd1 vccd1 vccd1 sky130_fd_sc_hd__diode_2
XTAP_TAPCELL_ROW_54_1044 vssd1 vccd1 sky130_fd_sc_hd__tapvpwrvgnd_1
XTAP_TAPCELL_ROW_54_1033 vssd1 vccd1 sky130_fd_sc_hd__tapvpwrvgnd_1
XFILLER_114_193 vssd1 vssd1 vccd1 vccd1 sky130_fd_sc_hd__fill_1
XFILLER_88_556 vssd1 vssd1 vccd1 vccd1 sky130_fd_sc_hd__fill_8
XANTENNA__06212__A1 net2 vssd1 vssd1 vccd1 vccd1 sky130_fd_sc_hd__diode_2
XANTENNA__06212__B2 net30 vssd1 vssd1 vccd1 vccd1 sky130_fd_sc_hd__diode_2
XANTENNA__09364__S net351 vssd1 vssd1 vccd1 vccd1 sky130_fd_sc_hd__diode_2
XFILLER_29_35 vssd1 vssd1 vccd1 vccd1 sky130_fd_sc_hd__fill_1
X_08977_ FPGA_INST.cell1.SB0.route_sel\[52\] FPGA_INST.cell1.SB0.route_sel\[53\] vssd1
+ vssd1 vccd1 vccd1 _05158_ sky130_fd_sc_hd__nand2b_1
XANTENNA_fanout383_X net383 vssd1 vssd1 vccd1 vccd1 sky130_fd_sc_hd__diode_2
XANTENNA_fanout762_A net769 vssd1 vssd1 vccd1 vccd1 sky130_fd_sc_hd__diode_2
XFILLER_29_57 vssd1 vssd1 vccd1 vccd1 sky130_fd_sc_hd__fill_2
X_07928_ FPGA_INST.cell1.CB_0.config_dataA\[13\] FPGA_INST.cell1.CB_0.config_dataA\[12\]
+ vssd1 vssd1 vccd1 vccd1 _04156_ sky130_fd_sc_hd__nor2_1
XANTENNA__05971__B1 net350 vssd1 vssd1 vccd1 vccd1 sky130_fd_sc_hd__diode_2
X_07859_ FPGA_INST.bus3_1\[4\] FPGA_INST.bus3_1\[5\] FPGA_INST.bus3_1\[6\] FPGA_INST.bus3_1\[7\]
+ net470 net468 vssd1 vssd1 vccd1 vccd1 _04087_ sky130_fd_sc_hd__mux4_1
XFILLER_56_475 vssd1 vssd1 vccd1 vccd1 sky130_fd_sc_hd__fill_1
XFILLER_56_453 vssd1 vssd1 vccd1 vccd1 sky130_fd_sc_hd__fill_1
XFILLER_29_667 vssd1 vssd1 vccd1 vccd1 sky130_fd_sc_hd__fill_4
X_10870_ net799 _00220_ net584 vssd1 vssd1 vccd1 vccd1 FPGA_INST.cell1.SB0.route_sel\[79\]
+ sky130_fd_sc_hd__dfstp_1
X_09529_ FPGA_INST.cell1.LE_0B.config_data\[1\] FPGA_INST.cell1.LE_0B.config_data\[2\]
+ net231 vssd1 vssd1 vccd1 vccd1 _00439_ sky130_fd_sc_hd__mux2_1
XFILLER_71_489 vssd1 vssd1 vccd1 vccd1 sky130_fd_sc_hd__fill_4
XFILLER_43_169 vccd1 vssd1 vccd1 vssd1 sky130_ef_sc_hd__decap_40_12
XFILLER_101_73 vssd1 vssd1 vccd1 vccd1 sky130_fd_sc_hd__fill_1
XTAP_TAPCELL_ROW_65_1195 vssd1 vccd1 sky130_fd_sc_hd__tapvpwrvgnd_1
XFILLER_61_55 vssd1 vssd1 vccd1 vccd1 sky130_fd_sc_hd__fill_1
XFILLER_8_527 vssd1 vssd1 vccd1 vccd1 sky130_fd_sc_hd__fill_4
XANTENNA__09539__S net232 vssd1 vssd1 vccd1 vccd1 sky130_fd_sc_hd__diode_2
XTAP_TAPCELL_ROW_22_584 vssd1 vccd1 sky130_fd_sc_hd__tapvpwrvgnd_1
X_11422_ net754 _00772_ net539 vssd1 vssd1 vccd1 vccd1 FPGA_INST.cell0.LEI0.config_data\[43\]
+ sky130_fd_sc_hd__dfrtp_1
XTAP_TAPCELL_ROW_22_595 vssd1 vccd1 sky130_fd_sc_hd__tapvpwrvgnd_1
XANTENNA__07779__A1 net81 vssd1 vssd1 vccd1 vccd1 sky130_fd_sc_hd__diode_2
XFILLER_6_17 vssd1 vssd1 vccd1 vccd1 sky130_fd_sc_hd__fill_1
XFILLER_125_447 vssd1 vssd1 vccd1 vccd1 sky130_fd_sc_hd__fill_1
X_11353_ net795 _00703_ net580 vssd1 vssd1 vccd1 vccd1 FPGA_INST.cell1.CB_1.config_dataA\[20\]
+ sky130_fd_sc_hd__dfstp_2
X_10304_ FPGA_INST.cell3.LEI0.config_data\[18\] FPGA_INST.cell3.LEI0.config_data\[19\]
+ net296 vssd1 vssd1 vccd1 vccd1 _01185_ sky130_fd_sc_hd__mux2_1
X_11284_ net832 _00634_ net616 vssd1 vssd1 vccd1 vccd1 FPGA_INST.cell1.CB_0.config_dataA\[1\]
+ sky130_fd_sc_hd__dfstp_1
X_10235_ FPGA_INST.io_west_oeb\[22\] FPGA_INST.io_west_oeb\[24\] net289 vssd1 vssd1
+ vccd1 vccd1 _01116_ sky130_fd_sc_hd__mux2_1
X_10166_ FPGA_INST.cell3.SB0.route_sel\[70\] FPGA_INST.cell3.SB0.route_sel\[71\] net276
+ vssd1 vssd1 vccd1 vccd1 _01047_ sky130_fd_sc_hd__mux2_1
XFILLER_79_578 vssd1 vssd1 vccd1 vccd1 sky130_fd_sc_hd__fill_1
XANTENNA__08398__B _03558_ vssd1 vssd1 vccd1 vccd1 sky130_fd_sc_hd__diode_2
X_10097_ FPGA_INST.cell3.SB0.route_sel\[1\] FPGA_INST.cell3.SB0.route_sel\[2\] net272
+ vssd1 vssd1 vccd1 vccd1 _00978_ sky130_fd_sc_hd__mux2_1
XFILLER_86_85 vssd1 vssd1 vccd1 vccd1 sky130_fd_sc_hd__fill_1
XFILLER_74_250 vssd1 vssd1 vccd1 vccd1 sky130_fd_sc_hd__fill_2
XFILLER_47_453 vssd1 vssd1 vccd1 vccd1 sky130_fd_sc_hd__fill_1
XFILLER_47_475 vssd1 vssd1 vccd1 vccd1 sky130_fd_sc_hd__fill_4
XFILLER_34_103 vssd1 vssd1 vccd1 vccd1 sky130_fd_sc_hd__fill_2
XFILLER_35_615 vssd1 vssd1 vccd1 vccd1 sky130_fd_sc_hd__fill_1
XFILLER_50_607 vssd1 vssd1 vccd1 vccd1 sky130_fd_sc_hd__fill_1
X_10999_ net926 _00349_ net710 vssd1 vssd1 vccd1 vccd1 FPGA_INST.cell2.LE_1B.config_data\[5\]
+ sky130_fd_sc_hd__dfrtp_1
XTAP_TAPCELL_ROW_41_860 vssd1 vccd1 sky130_fd_sc_hd__tapvpwrvgnd_1
XANTENNA__09449__S net363 vssd1 vssd1 vccd1 vccd1 sky130_fd_sc_hd__diode_2
XFILLER_30_386 vssd1 vssd1 vccd1 vccd1 sky130_fd_sc_hd__fill_2
X_06190_ FPGA_INST.cell2.SB0.route_sel\[0\] FPGA_INST.cell2.SB0.route_sel\[1\] vssd1
+ vssd1 vccd1 vccd1 _02470_ sky130_fd_sc_hd__nand2_1
XTAP_TAPCELL_ROW_96_1623 vssd1 vccd1 sky130_fd_sc_hd__tapvpwrvgnd_1
XANTENNA__08353__S _04574_ vssd1 vssd1 vccd1 vccd1 sky130_fd_sc_hd__diode_2
XANTENNA__06381__B _02217_ vssd1 vssd1 vccd1 vccd1 sky130_fd_sc_hd__diode_2
XFILLER_89_309 vssd1 vssd1 vccd1 vccd1 sky130_fd_sc_hd__fill_1
X_08900_ _05103_ _05106_ _05063_ vssd1 vssd1 vccd1 vccd1 _05107_ sky130_fd_sc_hd__mux2_1
X_09880_ FPGA_INST.cell0.LE_0A.config_data\[7\] FPGA_INST.cell0.LE_0A.config_data\[8\]
+ net192 vssd1 vssd1 vccd1 vccd1 _00787_ sky130_fd_sc_hd__mux2_1
X_08831_ FPGA_INST.cell3.CB_0.config_dataB\[11\] net388 vssd1 vssd1 vccd1 vccd1 _05038_
+ sky130_fd_sc_hd__and2b_1
XANTENNA__08195__A1 _03639_ vssd1 vssd1 vccd1 vccd1 sky130_fd_sc_hd__diode_2
XANTENNA__08195__B2 _03604_ vssd1 vssd1 vccd1 vccd1 sky130_fd_sc_hd__diode_2
XANTENNA__07942__A1 FPGA_INST.bus3_1\[13\] vssd1 vssd1 vccd1 vccd1 sky130_fd_sc_hd__diode_2
X_08762_ _04963_ _04970_ _04959_ vssd1 vssd1 vccd1 vccd1 _04971_ sky130_fd_sc_hd__mux2_1
XFILLER_85_559 vssd1 vssd1 vccd1 vccd1 sky130_fd_sc_hd__fill_1
X_05974_ FPGA_INST.cell2.SB0.route_sel\[54\] _01561_ FPGA_INST.cell2.SB0.route_sel\[51\]
+ FPGA_INST.cell2.SB0.route_sel\[50\] _02253_ vssd1 vssd1 vccd1 vccd1 _02254_ sky130_fd_sc_hd__o221a_1
XFILLER_38_431 vssd1 vssd1 vccd1 vccd1 sky130_fd_sc_hd__fill_2
XTAP_TAPCELL_ROW_123_2008 vssd1 vccd1 sky130_fd_sc_hd__tapvpwrvgnd_1
X_08693_ net397 _04839_ net396 vssd1 vssd1 vccd1 vccd1 _04902_ sky130_fd_sc_hd__o21ai_1
X_07713_ _03468_ _03926_ net140 vssd1 vssd1 vccd1 vccd1 _03964_ sky130_fd_sc_hd__o21bai_1
X_07644_ _03542_ _03775_ net78 vssd1 vssd1 vccd1 vccd1 _03897_ sky130_fd_sc_hd__o21ai_1
XTAP_TAPCELL_ROW_49_971 vssd1 vccd1 sky130_fd_sc_hd__tapvpwrvgnd_1
XANTENNA_fanout176_A net234 vssd1 vssd1 vccd1 vccd1 sky130_fd_sc_hd__diode_2
XFILLER_38_475 vssd1 vssd1 vccd1 vccd1 sky130_fd_sc_hd__fill_1
XFILLER_38_486 vssd1 vssd1 vccd1 vccd1 sky130_fd_sc_hd__fill_4
XANTENNA__05741__A net112 vssd1 vssd1 vccd1 vccd1 sky130_fd_sc_hd__diode_2
XTAP_TAPCELL_ROW_0_268 vssd1 vccd1 sky130_fd_sc_hd__tapvpwrvgnd_1
XTAP_TAPCELL_ROW_0_279 vssd1 vccd1 sky130_fd_sc_hd__tapvpwrvgnd_1
XTAP_TAPCELL_ROW_105_1752 vssd1 vccd1 sky130_fd_sc_hd__tapvpwrvgnd_1
XANTENNA_fanout343_A net349 vssd1 vssd1 vccd1 vccd1 sky130_fd_sc_hd__diode_2
X_07575_ _03526_ _03775_ net80 vssd1 vssd1 vccd1 vccd1 _03829_ sky130_fd_sc_hd__o21ai_1
XFILLER_25_169 vccd1 vssd1 vccd1 vssd1 sky130_ef_sc_hd__decap_40_12
X_09314_ FPGA_INST.cell1.SB0.route_sel\[85\] FPGA_INST.cell1.SB0.route_sel\[86\] net203
+ vssd1 vssd1 vccd1 vccd1 _00227_ sky130_fd_sc_hd__mux2_1
X_06526_ FPGA_INST.cell2.SB0.route_sel\[44\] FPGA_INST.cell2.SB0.route_sel\[45\] vssd1
+ vssd1 vccd1 vccd1 _02802_ sky130_fd_sc_hd__nor2_1
X_09245_ FPGA_INST.cell1.SB0.route_sel\[17\] FPGA_INST.cell1.SB0.route_sel\[16\] net342
+ vssd1 vssd1 vccd1 vccd1 _00158_ sky130_fd_sc_hd__mux2_1
X_06457_ net3 net4 net489 vssd1 vssd1 vccd1 vccd1 _02735_ sky130_fd_sc_hd__mux2_1
X_05408_ FPGA_INST.cell3.SB0.route_sel\[38\] vssd1 vssd1 vccd1 vccd1 _01690_ sky130_fd_sc_hd__inv_2
XANTENNA__08670__A2 _04804_ vssd1 vssd1 vccd1 vccd1 sky130_fd_sc_hd__diode_2
X_06388_ net3 net4 net498 vssd1 vssd1 vccd1 vccd1 _02666_ sky130_fd_sc_hd__mux2_1
X_09176_ FPGA_INST.cell2.LE_0B.config_data\[16\] FPGA_INST.cell2.LE_0B.edge_mode net256
+ vssd1 vssd1 vccd1 vccd1 _00090_ sky130_fd_sc_hd__mux2_1
XFILLER_119_285 vssd1 vssd1 vccd1 vccd1 sky130_fd_sc_hd__fill_2
XFILLER_107_436 vssd1 vssd1 vccd1 vccd1 sky130_fd_sc_hd__fill_1
X_08127_ FPGA_INST.bus3_1\[8\] FPGA_INST.bus3_1\[9\] FPGA_INST.bus3_1\[10\] FPGA_INST.bus3_1\[11\]
+ net451 net450 vssd1 vssd1 vccd1 vccd1 _04353_ sky130_fd_sc_hd__mux4_1
X_05339_ FPGA_INST.cell1.SB0.route_sel\[110\] vssd1 vssd1 vccd1 vccd1 _01621_ sky130_fd_sc_hd__inv_2
X_08058_ _04283_ vssd1 vssd1 vccd1 vccd1 _04284_ sky130_fd_sc_hd__inv_2
Xoutput36 net36 vssd1 vssd1 vccd1 vccd1 gpio_oeb[19] sky130_fd_sc_hd__buf_2
Xoutput47 net47 vssd1 vssd1 vccd1 vccd1 gpio_out[12] sky130_fd_sc_hd__buf_2
Xoutput58 net58 vssd1 vssd1 vccd1 vccd1 gpio_out[23] sky130_fd_sc_hd__buf_2
X_07009_ _03271_ _03274_ FPGA_INST.cell0.CB_0.config_dataA\[8\] vssd1 vssd1 vccd1
+ vccd1 _03275_ sky130_fd_sc_hd__or3b_1
Xoutput69 net69 vssd1 vssd1 vccd1 vccd1 gpio_out[4] sky130_fd_sc_hd__buf_2
XFILLER_49_707 vssd1 vssd1 vccd1 vccd1 sky130_fd_sc_hd__fill_1
X_10020_ FPGA_INST.cell0.CB_0.config_dataA\[20\] FPGA_INST.cell0.CB_0.config_dataA\[19\]
+ net317 vssd1 vssd1 vccd1 vccd1 _00901_ sky130_fd_sc_hd__mux2_1
XFILLER_130_472 vssd1 vssd1 vccd1 vccd1 sky130_fd_sc_hd__fill_2
XFILLER_103_675 vssd1 vssd1 vccd1 vccd1 sky130_fd_sc_hd__fill_2
XFILLER_102_141 vssd1 vssd1 vccd1 vccd1 sky130_fd_sc_hd__fill_2
XANTENNA__06736__A2 _02772_ vssd1 vssd1 vccd1 vccd1 sky130_fd_sc_hd__diode_2
XFILLER_0_279 vssd1 vssd1 vccd1 vccd1 sky130_fd_sc_hd__fill_1
XFILLER_48_239 vssd1 vssd1 vccd1 vccd1 sky130_fd_sc_hd__fill_8
X_11971_ net776 _01317_ net562 vssd1 vssd1 vccd1 vccd1 FPGA_INST.cell2.SB0.route_sel\[11\]
+ sky130_fd_sc_hd__dfstp_1
XFILLER_84_570 vssd1 vssd1 vccd1 vccd1 sky130_fd_sc_hd__fill_1
XTAP_TAPCELL_ROW_67_1224 vssd1 vccd1 sky130_fd_sc_hd__tapvpwrvgnd_1
X_10922_ net865 _00272_ net650 vssd1 vssd1 vccd1 vccd1 FPGA_INST.cell2.CB_0.config_dataA\[3\]
+ sky130_fd_sc_hd__dfstp_1
XANTENNA__07161__A2 _02784_ vssd1 vssd1 vccd1 vccd1 sky130_fd_sc_hd__diode_2
XFILLER_16_136 vssd1 vssd1 vccd1 vccd1 sky130_fd_sc_hd__fill_4
XFILLER_16_147 vssd1 vssd1 vccd1 vccd1 sky130_fd_sc_hd__fill_2
XTAP_TAPCELL_ROW_80_1402 vssd1 vccd1 sky130_fd_sc_hd__tapvpwrvgnd_1
X_10853_ net823 _00203_ net583 vssd1 vssd1 vccd1 vccd1 FPGA_INST.cell1.SB0.route_sel\[62\]
+ sky130_fd_sc_hd__dfstp_1
XFILLER_25_670 vssd1 vssd1 vccd1 vccd1 sky130_fd_sc_hd__fill_2
XTAP_TAPCELL_ROW_27_654 vssd1 vccd1 sky130_fd_sc_hd__tapvpwrvgnd_1
XTAP_TAPCELL_ROW_27_665 vssd1 vccd1 sky130_fd_sc_hd__tapvpwrvgnd_1
XANTENNA__07449__B1 net78 vssd1 vssd1 vccd1 vccd1 sky130_fd_sc_hd__diode_2
X_10784_ net919 _00134_ net703 vssd1 vssd1 vccd1 vccd1 FPGA_INST.cell2.CB_1.config_dataB\[18\]
+ sky130_fd_sc_hd__dfstp_1
XFILLER_25_681 vssd1 vssd1 vccd1 vccd1 sky130_fd_sc_hd__fill_1
XFILLER_31_139 vssd1 vssd1 vccd1 vccd1 sky130_fd_sc_hd__fill_1
XFILLER_40_651 vssd1 vssd1 vccd1 vccd1 sky130_fd_sc_hd__fill_1
XANTENNA__10208__S net273 vssd1 vssd1 vccd1 vccd1 sky130_fd_sc_hd__diode_2
X_11405_ net754 _00755_ net539 vssd1 vssd1 vccd1 vccd1 FPGA_INST.cell0.LEI0.config_data\[26\]
+ sky130_fd_sc_hd__dfrtp_1
XFILLER_126_778 vssd1 vssd1 vccd1 vccd1 sky130_fd_sc_hd__fill_1
X_11336_ net804 _00686_ net589 vssd1 vssd1 vccd1 vccd1 FPGA_INST.cell1.CB_1.config_dataA\[3\]
+ sky130_fd_sc_hd__dfstp_1
XTAP_TAPCELL_ROW_78_1375 vssd1 vccd1 sky130_fd_sc_hd__tapvpwrvgnd_1
XFILLER_113_428 vssd1 vssd1 vccd1 vccd1 sky130_fd_sc_hd__fill_8
XANTENNA__10926__CLK net851 vssd1 vssd1 vccd1 vccd1 sky130_fd_sc_hd__diode_2
XTAP_TAPCELL_ROW_91_1553 vssd1 vccd1 sky130_fd_sc_hd__tapvpwrvgnd_1
X_11267_ net783 _00617_ net568 vssd1 vssd1 vccd1 vccd1 FPGA_INST.cell0.SB0.route_sel\[112\]
+ sky130_fd_sc_hd__dfstp_1
X_10218_ FPGA_INST.cell3.SB0.route_sel\[122\] FPGA_INST.cell3.SB0.route_sel\[123\]
+ net274 vssd1 vssd1 vccd1 vccd1 _01099_ sky130_fd_sc_hd__mux2_1
X_11198_ net764 _00548_ net549 vssd1 vssd1 vccd1 vccd1 FPGA_INST.cell0.SB0.route_sel\[43\]
+ sky130_fd_sc_hd__dfstp_1
X_10149_ FPGA_INST.cell3.SB0.route_sel\[53\] FPGA_INST.cell3.SB0.route_sel\[54\] net272
+ vssd1 vssd1 vccd1 vccd1 _01030_ sky130_fd_sc_hd__mux2_1
XFILLER_79_386 vssd1 vssd1 vccd1 vccd1 sky130_fd_sc_hd__fill_1
XANTENNA__09732__S net344 vssd1 vssd1 vccd1 vccd1 sky130_fd_sc_hd__diode_2
XANTENNA__05832__Y _02112_ vssd1 vssd1 vccd1 vccd1 sky130_fd_sc_hd__diode_2
XTAP_TAPCELL_ROW_46_930 vssd1 vccd1 sky130_fd_sc_hd__tapvpwrvgnd_1
X_05690_ FPGA_INST.cell0.CB_0.config_dataB\[24\] FPGA_INST.cell0.CB_0.config_dataB\[21\]
+ FPGA_INST.cell0.CB_0.config_dataB\[20\] vssd1 vssd1 vccd1 vccd1 _01970_ sky130_fd_sc_hd__or3b_1
XFILLER_63_798 vssd1 vssd1 vccd1 vccd1 sky130_fd_sc_hd__fill_1
XANTENNA__06376__B _02376_ vssd1 vssd1 vccd1 vccd1 sky130_fd_sc_hd__diode_2
X_07360_ FPGA_INST.cell3.CB_0.config_dataB\[23\] FPGA_INST.cell3.CB_0.config_dataB\[22\]
+ vssd1 vssd1 vccd1 vccd1 _03620_ sky130_fd_sc_hd__nand2b_1
X_06311_ net501 _02413_ _02590_ net499 vssd1 vssd1 vccd1 vccd1 _02591_ sky130_fd_sc_hd__o211a_1
X_07291_ FPGA_INST.bus3_1\[3\] _03550_ vssd1 vssd1 vccd1 vccd1 _03552_ sky130_fd_sc_hd__and2_1
X_09030_ _03492_ _05193_ vssd1 vssd1 vccd1 vccd1 FPGA_INST.bus3_1\[1\] sky130_fd_sc_hd__and2_2
XTAP_TAPCELL_ROW_100_1682 vssd1 vccd1 sky130_fd_sc_hd__tapvpwrvgnd_1
X_06242_ net509 _02056_ _02521_ FPGA_INST.cell2.CB_0.config_dataA\[1\] vssd1 vssd1
+ vccd1 vccd1 _02522_ sky130_fd_sc_hd__o211a_1
XANTENNA__10118__S net244 vssd1 vssd1 vccd1 vccd1 sky130_fd_sc_hd__diode_2
X_06173_ FPGA_INST.cell0.SB0.route_sel\[0\] FPGA_INST.cell0.SB0.route_sel\[1\] vssd1
+ vssd1 vccd1 vccd1 _02453_ sky130_fd_sc_hd__and2_1
XFILLER_7_390 vssd1 vssd1 vccd1 vccd1 sky130_fd_sc_hd__fill_2
XFILLER_104_417 vssd1 vssd1 vccd1 vccd1 sky130_fd_sc_hd__fill_2
X_09932_ FPGA_INST.cell0.LE_1A.config_data\[13\] FPGA_INST.cell0.LE_1A.config_data\[14\]
+ net175 vssd1 vssd1 vccd1 vccd1 _00837_ sky130_fd_sc_hd__mux2_1
Xfanout804 net811 vssd1 vssd1 vccd1 vccd1 net804 sky130_fd_sc_hd__clkbuf_2
Xfanout815 net820 vssd1 vssd1 vccd1 vccd1 net815 sky130_fd_sc_hd__buf_1
Xfanout837 net843 vssd1 vssd1 vccd1 vccd1 net837 sky130_fd_sc_hd__clkbuf_2
XANTENNA__07915__A1 _03932_ vssd1 vssd1 vccd1 vccd1 sky130_fd_sc_hd__diode_2
XANTENNA_fanout293_A net295 vssd1 vssd1 vccd1 vccd1 sky130_fd_sc_hd__diode_2
XFILLER_98_673 vssd1 vssd1 vccd1 vccd1 sky130_fd_sc_hd__fill_1
Xfanout826 net831 vssd1 vssd1 vccd1 vccd1 net826 sky130_fd_sc_hd__clkbuf_2
XTAP_TAPCELL_ROW_51_1003 vssd1 vccd1 sky130_fd_sc_hd__tapvpwrvgnd_1
XANTENNA__06331__S _02536_ vssd1 vssd1 vccd1 vccd1 sky130_fd_sc_hd__diode_2
X_09863_ FPGA_INST.cell0.LEI0.config_data\[41\] FPGA_INST.cell0.LEI0.config_data\[42\]
+ net179 vssd1 vssd1 vccd1 vccd1 _00771_ sky130_fd_sc_hd__mux2_1
Xfanout848 net849 vssd1 vssd1 vccd1 vccd1 net848 sky130_fd_sc_hd__clkbuf_2
X_09794_ FPGA_INST.cell1.CB_1.config_dataA\[20\] FPGA_INST.cell1.CB_1.config_dataA\[19\]
+ net327 vssd1 vssd1 vccd1 vccd1 _00703_ sky130_fd_sc_hd__mux2_1
X_08814_ _01774_ _04059_ _04800_ _05020_ net391 vssd1 vssd1 vccd1 vccd1 _05021_ sky130_fd_sc_hd__o311a_1
Xfanout859 net861 vssd1 vssd1 vccd1 vccd1 net859 sky130_fd_sc_hd__clkbuf_2
XTAP_TAPCELL_ROW_5_349 vssd1 vccd1 sky130_fd_sc_hd__tapvpwrvgnd_1
X_08745_ FPGA_INST.cell3.LEI0.config_data\[36\] net82 _04953_ FPGA_INST.cell3.LEI0.config_data\[37\]
+ vssd1 vssd1 vccd1 vccd1 _04954_ sky130_fd_sc_hd__o211a_1
XANTENNA_fanout558_A net575 vssd1 vssd1 vccd1 vccd1 sky130_fd_sc_hd__diode_2
X_05957_ FPGA_INST.cell2.SB0.route_sel\[53\] FPGA_INST.cell2.SB0.route_sel\[52\] _02236_
+ vssd1 vssd1 vccd1 vccd1 _02237_ sky130_fd_sc_hd__a21oi_1
X_08676_ net92 net87 FPGA_INST.cell3.LEI0.config_data\[12\] vssd1 vssd1 vccd1 vccd1
+ _04885_ sky130_fd_sc_hd__mux2_1
XFILLER_54_743 vssd1 vssd1 vccd1 vccd1 sky130_fd_sc_hd__fill_8
X_05888_ _02167_ vssd1 vssd1 vccd1 vccd1 _02168_ sky130_fd_sc_hd__inv_2
XANTENNA_fanout725_A net729 vssd1 vssd1 vccd1 vccd1 sky130_fd_sc_hd__diode_2
X_07627_ net148 _03561_ _03762_ _03872_ _03879_ vssd1 vssd1 vccd1 vccd1 _03880_ sky130_fd_sc_hd__o311a_1
XFILLER_26_489 vssd1 vssd1 vccd1 vccd1 sky130_fd_sc_hd__fill_8
XANTENNA__07158__A_N _03421_ vssd1 vssd1 vccd1 vccd1 sky130_fd_sc_hd__diode_2
X_07558_ _03804_ _03811_ _03812_ vssd1 vssd1 vccd1 vccd1 _03813_ sky130_fd_sc_hd__nand3_1
XTAP_TAPCELL_ROW_24_613 vssd1 vccd1 sky130_fd_sc_hd__tapvpwrvgnd_1
XTAP_TAPCELL_ROW_24_624 vssd1 vccd1 sky130_fd_sc_hd__tapvpwrvgnd_1
XTAP_TAPCELL_ROW_62_1154 vssd1 vccd1 sky130_fd_sc_hd__tapvpwrvgnd_1
X_06509_ net480 net481 vssd1 vssd1 vccd1 vccd1 _02785_ sky130_fd_sc_hd__nor2_1
X_07489_ FPGA_INST.cell1.CB_0.config_dataA\[22\] FPGA_INST.cell1.CB_0.config_dataA\[23\]
+ vssd1 vssd1 vccd1 vccd1 _03745_ sky130_fd_sc_hd__nand2b_1
X_09228_ FPGA_INST.cell1.SB0.route_sel\[0\] FPGA_INST.cell1.CB_1.config_dataB\[24\]
+ net336 vssd1 vssd1 vccd1 vccd1 _00141_ sky130_fd_sc_hd__mux2_1
XTAP_TAPCELL_ROW_118_1932 vssd1 vccd1 sky130_fd_sc_hd__tapvpwrvgnd_1
XANTENNA__05862__C1 net314 vssd1 vssd1 vccd1 vccd1 sky130_fd_sc_hd__diode_2
X_09159_ FPGA_INST.cell2.LE_0B.config_data\[0\] FPGA_INST.cell2.LE_1B.reset_mode net359
+ vssd1 vssd1 vccd1 vccd1 _00073_ sky130_fd_sc_hd__mux2_1
X_12170_ net910 _01516_ net695 vssd1 vssd1 vccd1 vccd1 FPGA_INST.cell3.LE_1B.config_data\[7\]
+ sky130_fd_sc_hd__dfrtp_1
XANTENNA__09817__S net336 vssd1 vssd1 vccd1 vccd1 sky130_fd_sc_hd__diode_2
XFILLER_108_778 vssd1 vssd1 vccd1 vccd1 sky130_fd_sc_hd__fill_1
XANTENNA__08006__B _03728_ vssd1 vssd1 vccd1 vccd1 sky130_fd_sc_hd__diode_2
XANTENNA__07603__B1 _03856_ vssd1 vssd1 vccd1 vccd1 sky130_fd_sc_hd__diode_2
XFILLER_101_3 vssd1 vssd1 vccd1 vccd1 sky130_fd_sc_hd__fill_4
X_11121_ net794 _00471_ net579 vssd1 vssd1 vccd1 vccd1 FPGA_INST.cell1.LE_1A.config_data\[12\]
+ sky130_fd_sc_hd__dfrtp_1
XFILLER_107_50 vssd1 vssd1 vccd1 vccd1 sky130_fd_sc_hd__fill_1
XFILLER_103_461 vssd1 vssd1 vccd1 vccd1 sky130_fd_sc_hd__fill_1
X_11052_ net812 _00402_ net597 vssd1 vssd1 vccd1 vccd1 FPGA_INST.cell1.LEI0.config_data\[37\]
+ sky130_fd_sc_hd__dfrtp_1
XFILLER_49_548 vssd1 vssd1 vccd1 vccd1 sky130_fd_sc_hd__fill_8
X_10003_ FPGA_INST.cell0.CB_0.config_dataA\[3\] FPGA_INST.cell0.CB_0.config_dataA\[2\]
+ net310 vssd1 vssd1 vccd1 vccd1 _00884_ sky130_fd_sc_hd__mux2_1
XANTENNA_input21_A gpio_in[28] vssd1 vssd1 vccd1 vccd1 sky130_fd_sc_hd__diode_2
XANTENNA__06590__A0 FPGA_INST.bus3_2\[0\] vssd1 vssd1 vccd1 vccd1 sky130_fd_sc_hd__diode_2
XFILLER_123_93 vssd1 vssd1 vccd1 vccd1 sky130_fd_sc_hd__fill_4
X_11954_ net914 _01300_ net698 vssd1 vssd1 vccd1 vccd1 FPGA_INST.cell3.CB_1.config_dataB\[19\]
+ sky130_fd_sc_hd__dfstp_1
XFILLER_91_348 vssd1 vssd1 vccd1 vccd1 sky130_fd_sc_hd__fill_1
XPHY_EDGE_ROW_103_Left_234 vssd1 vssd1 vccd1 vccd1 sky130_fd_sc_hd__decap_3
X_11885_ net929 _01231_ net713 vssd1 vssd1 vccd1 vccd1 FPGA_INST.cell3.LE_0A.config_data\[15\]
+ sky130_fd_sc_hd__dfrtp_1
X_10905_ net827 _00255_ net611 vssd1 vssd1 vccd1 vccd1 FPGA_INST.cell1.SB0.route_sel\[114\]
+ sky130_fd_sc_hd__dfstp_1
XFILLER_45_798 vssd1 vssd1 vccd1 vccd1 sky130_fd_sc_hd__fill_1
XANTENNA__06342__B1 net155 vssd1 vssd1 vccd1 vccd1 sky130_fd_sc_hd__diode_2
X_10836_ net802 _00186_ net587 vssd1 vssd1 vccd1 vccd1 FPGA_INST.cell1.SB0.route_sel\[45\]
+ sky130_fd_sc_hd__dfstp_1
XFILLER_60_768 vssd1 vssd1 vccd1 vccd1 sky130_fd_sc_hd__fill_4
X_10767_ net882 _00117_ net676 vssd1 vssd1 vccd1 vccd1 FPGA_INST.cell2.CB_1.config_dataB\[1\]
+ sky130_fd_sc_hd__dfstp_1
XFILLER_8_121 vssd1 vssd1 vccd1 vccd1 sky130_fd_sc_hd__fill_2
X_10698_ net880 _00048_ net665 vssd1 vssd1 vccd1 vccd1 FPGA_INST.cell2.CB_0.config_data_inA
+ sky130_fd_sc_hd__dfrtp_1
XFILLER_9_688 vssd1 vssd1 vccd1 vccd1 sky130_fd_sc_hd__fill_2
XFILLER_8_165 vssd1 vssd1 vccd1 vccd1 sky130_fd_sc_hd__fill_2
XPHY_EDGE_ROW_112_Left_243 vssd1 vssd1 vccd1 vccd1 sky130_fd_sc_hd__decap_3
XANTENNA__09727__S net344 vssd1 vssd1 vccd1 vccd1 sky130_fd_sc_hd__diode_2
XFILLER_59_5 vssd1 vssd1 vccd1 vccd1 sky130_fd_sc_hd__fill_1
XFILLER_4_360 vssd1 vssd1 vccd1 vccd1 sky130_fd_sc_hd__fill_4
X_11319_ net840 _00669_ net624 vssd1 vssd1 vccd1 vccd1 FPGA_INST.cell1.CB_0.config_dataB\[11\]
+ sky130_fd_sc_hd__dfstp_1
XFILLER_79_183 vssd1 vssd1 vccd1 vccd1 sky130_fd_sc_hd__fill_1
XFILLER_67_334 vssd1 vssd1 vccd1 vccd1 sky130_fd_sc_hd__fill_2
XFILLER_67_312 vssd1 vssd1 vccd1 vccd1 sky130_fd_sc_hd__fill_1
X_06860_ net423 net424 vssd1 vssd1 vccd1 vccd1 _03128_ sky130_fd_sc_hd__or2_1
XFILLER_67_367 vssd1 vssd1 vccd1 vccd1 sky130_fd_sc_hd__fill_1
XTAP_TAPCELL_ROW_2_308 vssd1 vccd1 sky130_fd_sc_hd__tapvpwrvgnd_1
X_05811_ FPGA_INST.cell2.SB0.route_sel\[92\] _01575_ _01576_ FPGA_INST.cell2.SB0.route_sel\[95\]
+ _02090_ vssd1 vssd1 vccd1 vccd1 _02091_ sky130_fd_sc_hd__a221o_1
X_06791_ FPGA_INST.cell2.CB_1.config_dataB\[16\] _03063_ _03064_ vssd1 vssd1 vccd1
+ vccd1 _03065_ sky130_fd_sc_hd__a21o_1
XFILLER_67_389 vssd1 vssd1 vccd1 vccd1 sky130_fd_sc_hd__fill_1
X_08530_ FPGA_INST.cell3.LE_1A.config_data\[12\] FPGA_INST.cell3.LE_1A.config_data\[13\]
+ _04725_ vssd1 vssd1 vccd1 vccd1 _04743_ sky130_fd_sc_hd__mux2_1
XPHY_EDGE_ROW_121_Left_252 vssd1 vssd1 vccd1 vccd1 sky130_fd_sc_hd__decap_3
X_05742_ FPGA_INST.cell0.SB0.route_sel\[82\] FPGA_INST.cell0.SB0.route_sel\[83\] _02018_
+ _02020_ _02021_ vssd1 vssd1 vccd1 vccd1 _02022_ sky130_fd_sc_hd__a221o_1
XFILLER_36_754 vssd1 vssd1 vccd1 vccd1 sky130_fd_sc_hd__fill_2
X_08461_ FPGA_INST.cell1.LE_1A.config_data\[8\] FPGA_INST.cell1.LE_1A.config_data\[9\]
+ _04660_ vssd1 vssd1 vccd1 vccd1 _04679_ sky130_fd_sc_hd__mux2_1
X_05673_ _01939_ _01941_ _01952_ vssd1 vssd1 vccd1 vccd1 _01953_ sky130_fd_sc_hd__o21ai_2
XTAP_TAPCELL_ROW_102_1711 vssd1 vccd1 sky130_fd_sc_hd__tapvpwrvgnd_1
X_07412_ _03526_ _03587_ net79 vssd1 vssd1 vccd1 vccd1 _03670_ sky130_fd_sc_hd__o21ai_1
XFILLER_51_735 vssd1 vssd1 vccd1 vccd1 sky130_fd_sc_hd__fill_1
X_08392_ net439 _03875_ vssd1 vssd1 vccd1 vccd1 _04614_ sky130_fd_sc_hd__nand2_1
X_07343_ FPGA_INST.cell0.SB0.route_sel\[38\] _01693_ vssd1 vssd1 vccd1 vccd1 _03603_
+ sky130_fd_sc_hd__nand2_1
X_07274_ net94 _03535_ _03533_ vssd1 vssd1 vccd1 vccd1 _03536_ sky130_fd_sc_hd__mux2_1
XANTENNA_fanout139_A FPGA_INST.cell2.CB_0.le_outA vssd1 vssd1 vccd1 vccd1 sky130_fd_sc_hd__diode_2
XPHY_EDGE_ROW_130_Left_261 vssd1 vssd1 vccd1 vccd1 sky130_fd_sc_hd__decap_3
X_09013_ FPGA_INST.cell1.SB0.route_sel\[17\] FPGA_INST.cell1.SB0.route_sel\[16\] vssd1
+ vssd1 vccd1 vccd1 _05182_ sky130_fd_sc_hd__nor2_1
X_06225_ net508 net509 vssd1 vssd1 vccd1 vccd1 _02505_ sky130_fd_sc_hd__and2b_2
XFILLER_12_49 vssd1 vssd1 vccd1 vccd1 sky130_fd_sc_hd__fill_8
XANTENNA_fanout306_A _01831_ vssd1 vssd1 vccd1 vccd1 sky130_fd_sc_hd__diode_2
XANTENNA__08389__A1 FPGA_INST.bus1_0\[15\] vssd1 vssd1 vccd1 vccd1 sky130_fd_sc_hd__diode_2
X_06156_ _02435_ FPGA_INST.bus3_2\[1\] vssd1 vssd1 vccd1 vccd1 _02436_ sky130_fd_sc_hd__nand2b_1
XANTENNA__06939__A2 FPGA_INST.bus2_0\[10\] vssd1 vssd1 vccd1 vccd1 sky130_fd_sc_hd__diode_2
XANTENNA__07665__B FPGA_INST.cell1.SB0.route_sel\[96\] vssd1 vssd1 vccd1 vccd1 sky130_fd_sc_hd__diode_2
X_06087_ _01903_ _02366_ vssd1 vssd1 vccd1 vccd1 _02367_ sky130_fd_sc_hd__nand2_1
XANTENNA__07061__B2 FPGA_INST.bus2_0\[1\] vssd1 vssd1 vccd1 vccd1 sky130_fd_sc_hd__diode_2
XANTENNA__07061__A1 FPGA_INST.bus2_0\[0\] vssd1 vssd1 vccd1 vccd1 sky130_fd_sc_hd__diode_2
Xfanout623 net626 vssd1 vssd1 vccd1 vccd1 net623 sky130_fd_sc_hd__clkbuf_2
XTAP_TAPCELL_ROW_113_1862 vssd1 vccd1 sky130_fd_sc_hd__tapvpwrvgnd_1
Xfanout601 net604 vssd1 vssd1 vccd1 vccd1 net601 sky130_fd_sc_hd__clkbuf_4
Xfanout612 net615 vssd1 vssd1 vccd1 vccd1 net612 sky130_fd_sc_hd__buf_2
X_09915_ FPGA_INST.cell0.LE_1A.dff0_out net522 _05219_ vssd1 vssd1 vccd1 vccd1 _00821_
+ sky130_fd_sc_hd__a21o_1
Xfanout645 net647 vssd1 vssd1 vccd1 vccd1 net645 sky130_fd_sc_hd__clkbuf_4
Xfanout634 net676 vssd1 vssd1 vccd1 vccd1 net634 sky130_fd_sc_hd__clkbuf_2
Xfanout656 net657 vssd1 vssd1 vccd1 vccd1 net656 sky130_fd_sc_hd__clkbuf_4
X_09846_ FPGA_INST.cell0.LEI0.config_data\[24\] FPGA_INST.cell0.LEI0.config_data\[25\]
+ net174 vssd1 vssd1 vccd1 vccd1 _00754_ sky130_fd_sc_hd__mux2_1
Xfanout667 net675 vssd1 vssd1 vccd1 vccd1 net667 sky130_fd_sc_hd__clkbuf_4
XANTENNA_fanout675_A net676 vssd1 vssd1 vccd1 vccd1 sky130_fd_sc_hd__diode_2
Xfanout689 net690 vssd1 vssd1 vccd1 vccd1 net689 sky130_fd_sc_hd__clkbuf_4
XFILLER_100_453 vssd1 vssd1 vccd1 vccd1 sky130_fd_sc_hd__fill_2
Xfanout678 net683 vssd1 vssd1 vccd1 vccd1 net678 sky130_fd_sc_hd__clkbuf_2
XFILLER_58_356 vssd1 vssd1 vccd1 vccd1 sky130_fd_sc_hd__fill_8
XFILLER_58_334 vssd1 vssd1 vccd1 vccd1 sky130_fd_sc_hd__fill_1
XANTENNA__09372__S net351 vssd1 vssd1 vccd1 vccd1 sky130_fd_sc_hd__diode_2
XANTENNA_fanout842_A net843 vssd1 vssd1 vccd1 vccd1 sky130_fd_sc_hd__diode_2
X_09777_ FPGA_INST.cell1.CB_1.config_dataA\[3\] FPGA_INST.cell1.CB_1.config_dataA\[2\]
+ net333 vssd1 vssd1 vccd1 vccd1 _00686_ sky130_fd_sc_hd__mux2_1
XFILLER_86_698 vssd1 vssd1 vccd1 vccd1 sky130_fd_sc_hd__fill_2
XFILLER_58_389 vssd1 vssd1 vccd1 vccd1 sky130_fd_sc_hd__fill_2
X_06989_ FPGA_INST.bus2_0\[6\] FPGA_INST.bus2_0\[7\] net434 vssd1 vssd1 vccd1 vccd1
+ _03255_ sky130_fd_sc_hd__mux2_1
X_08728_ _04933_ _04936_ FPGA_INST.cell3.CB_0.config_dataA\[18\] vssd1 vssd1 vccd1
+ vccd1 _04937_ sky130_fd_sc_hd__a21oi_1
XFILLER_73_337 vssd1 vssd1 vccd1 vccd1 sky130_fd_sc_hd__fill_2
X_08659_ net18 net19 net20 net21 net399 net398 vssd1 vssd1 vccd1 vccd1 _04868_ sky130_fd_sc_hd__mux4_1
XANTENNA__08864__A2 _04819_ vssd1 vssd1 vccd1 vccd1 sky130_fd_sc_hd__diode_2
X_11670_ net907 _01016_ net691 vssd1 vssd1 vccd1 vccd1 FPGA_INST.cell3.SB0.route_sel\[40\]
+ sky130_fd_sc_hd__dfstp_1
XFILLER_53_78 vssd1 vssd1 vccd1 vccd1 sky130_fd_sc_hd__fill_1
XFILLER_42_757 vssd1 vssd1 vccd1 vccd1 sky130_fd_sc_hd__fill_4
X_10621_ FPGA_INST.cell3.CB_1.config_dataA\[15\] FPGA_INST.cell3.CB_1.config_dataA\[16\]
+ net299 vssd1 vssd1 vccd1 vccd1 _01500_ sky130_fd_sc_hd__mux2_1
XANTENNA__08616__A2 _04819_ vssd1 vssd1 vccd1 vccd1 sky130_fd_sc_hd__diode_2
X_10552_ FPGA_INST.cell2.SB0.route_sel\[124\] FPGA_INST.cell2.SB0.route_sel\[125\]
+ net249 vssd1 vssd1 vccd1 vccd1 _01431_ sky130_fd_sc_hd__mux2_1
XFILLER_10_632 vssd1 vssd1 vccd1 vccd1 sky130_fd_sc_hd__fill_1
XANTENNA__07824__B1 _01966_ vssd1 vssd1 vccd1 vccd1 sky130_fd_sc_hd__diode_2
XFILLER_5_146 vssd1 vssd1 vccd1 vccd1 sky130_fd_sc_hd__fill_2
X_10483_ FPGA_INST.cell2.SB0.route_sel\[55\] FPGA_INST.cell2.SB0.route_sel\[56\] net194
+ vssd1 vssd1 vccd1 vccd1 _01362_ sky130_fd_sc_hd__mux2_1
XTAP_TAPCELL_ROW_75_1334 vssd1 vccd1 sky130_fd_sc_hd__tapvpwrvgnd_1
X_12153_ net946 _01499_ net730 vssd1 vssd1 vccd1 vccd1 FPGA_INST.cell3.CB_1.config_dataA\[15\]
+ sky130_fd_sc_hd__dfstp_1
XFILLER_123_589 vssd1 vssd1 vccd1 vccd1 sky130_fd_sc_hd__fill_2
X_11104_ net838 _00454_ net622 vssd1 vssd1 vccd1 vccd1 FPGA_INST.cell1.LE_0B.edge_mode
+ sky130_fd_sc_hd__dfstp_1
XFILLER_96_418 vssd1 vssd1 vccd1 vccd1 sky130_fd_sc_hd__fill_2
X_12084_ net859 _01430_ net645 vssd1 vssd1 vccd1 vccd1 FPGA_INST.cell2.SB0.route_sel\[124\]
+ sky130_fd_sc_hd__dfstp_1
X_11035_ net813 _00385_ net598 vssd1 vssd1 vccd1 vccd1 FPGA_INST.cell1.LEI0.config_data\[20\]
+ sky130_fd_sc_hd__dfrtp_1
XFILLER_77_621 vccd1 vssd1 vccd1 vssd1 sky130_ef_sc_hd__decap_40_12
XFILLER_49_323 vssd1 vssd1 vccd1 vccd1 sky130_fd_sc_hd__fill_4
XANTENNA_input24_X net24 vssd1 vssd1 vccd1 vccd1 sky130_fd_sc_hd__diode_2
XANTENNA__07927__A1_N _03613_ vssd1 vssd1 vccd1 vccd1 sky130_fd_sc_hd__diode_2
XFILLER_91_101 vssd1 vssd1 vccd1 vccd1 sky130_fd_sc_hd__fill_1
XFILLER_94_85 vssd1 vssd1 vccd1 vccd1 sky130_fd_sc_hd__fill_1
XFILLER_91_167 vssd1 vssd1 vccd1 vccd1 sky130_fd_sc_hd__fill_1
XANTENNA__08304__A1 FPGA_INST.bus1_0\[8\] vssd1 vssd1 vccd1 vccd1 sky130_fd_sc_hd__diode_2
X_11937_ net914 _01283_ net698 vssd1 vssd1 vccd1 vccd1 FPGA_INST.cell3.CB_1.config_dataB\[2\]
+ sky130_fd_sc_hd__dfstp_1
XTAP_TAPCELL_ROW_86_1485 vssd1 vccd1 sky130_fd_sc_hd__tapvpwrvgnd_1
XFILLER_72_381 vssd1 vssd1 vccd1 vccd1 sky130_fd_sc_hd__fill_1
XFILLER_45_584 vssd1 vssd1 vccd1 vccd1 sky130_fd_sc_hd__fill_2
XFILLER_17_275 vssd1 vssd1 vccd1 vccd1 sky130_fd_sc_hd__fill_1
XFILLER_32_201 vssd1 vssd1 vccd1 vccd1 sky130_fd_sc_hd__fill_2
X_11868_ FPGA_INST.cell3.LE_0A.sel_clk _01214_ net734 vssd1 vssd1 vccd1 vccd1 FPGA_INST.cell3.LE_0A.dff0_out
+ sky130_fd_sc_hd__dfrtp_1
XANTENNA__06866__B2 _01984_ vssd1 vssd1 vccd1 vccd1 sky130_fd_sc_hd__diode_2
XANTENNA__06866__A1 _01937_ vssd1 vssd1 vccd1 vccd1 sky130_fd_sc_hd__diode_2
X_10819_ net821 _00169_ net605 vssd1 vssd1 vccd1 vccd1 FPGA_INST.cell1.SB0.route_sel\[28\]
+ sky130_fd_sc_hd__dfstp_1
XFILLER_60_587 vssd1 vssd1 vccd1 vccd1 sky130_fd_sc_hd__fill_1
XTAP_TAPCELL_ROW_15_487 vssd1 vccd1 sky130_fd_sc_hd__tapvpwrvgnd_1
X_11799_ net875 _01145_ net660 vssd1 vssd1 vccd1 vccd1 FPGA_INST.io_east_oeb\[18\]
+ sky130_fd_sc_hd__dfrtp_1
XANTENNA__06618__A1 _02843_ vssd1 vssd1 vccd1 vccd1 sky130_fd_sc_hd__diode_2
XANTENNA__06618__B2 _02840_ vssd1 vssd1 vccd1 vccd1 sky130_fd_sc_hd__diode_2
XTAP_TAPCELL_ROW_15_498 vssd1 vccd1 sky130_fd_sc_hd__tapvpwrvgnd_1
XFILLER_64_3 vssd1 vssd1 vccd1 vccd1 sky130_fd_sc_hd__fill_1
X_06010_ FPGA_INST.cell2.SB0.route_sel\[37\] FPGA_INST.cell2.SB0.route_sel\[36\] vssd1
+ vssd1 vccd1 vccd1 _02290_ sky130_fd_sc_hd__nand2b_1
XFILLER_114_523 vssd1 vssd1 vccd1 vccd1 sky130_fd_sc_hd__fill_2
XANTENNA__08791__A1 net84 vssd1 vssd1 vccd1 vccd1 sky130_fd_sc_hd__diode_2
X_07961_ net462 net464 vssd1 vssd1 vccd1 vccd1 _04189_ sky130_fd_sc_hd__nand2b_1
XFILLER_87_418 vssd1 vssd1 vccd1 vccd1 sky130_fd_sc_hd__fill_1
X_09700_ FPGA_INST.cell0.SB0.route_sel\[104\] FPGA_INST.cell0.SB0.route_sel\[103\]
+ net322 vssd1 vssd1 vccd1 vccd1 _00609_ sky130_fd_sc_hd__mux2_1
X_06912_ net418 _02233_ _03179_ FPGA_INST.cell0.CB_0.config_dataB\[11\] vssd1 vssd1
+ vccd1 vccd1 _03180_ sky130_fd_sc_hd__o211a_1
XFILLER_114_29 vccd1 vssd1 vccd1 vssd1 sky130_ef_sc_hd__decap_40_12
X_07892_ _03652_ _04118_ FPGA_INST.cell1.CB_0.config_dataA\[2\] vssd1 vssd1 vccd1
+ vccd1 _04120_ sky130_fd_sc_hd__o21ai_1
XFILLER_68_643 vssd1 vssd1 vccd1 vccd1 sky130_fd_sc_hd__fill_1
XTAP_TAPCELL_ROW_128_2080 vssd1 vccd1 sky130_fd_sc_hd__tapvpwrvgnd_1
X_09631_ FPGA_INST.cell0.SB0.route_sel\[34\] FPGA_INST.cell0.SB0.route_sel\[35\] net195
+ vssd1 vssd1 vccd1 vccd1 _00540_ sky130_fd_sc_hd__mux2_1
X_06843_ net421 _01839_ _03110_ net420 vssd1 vssd1 vccd1 vccd1 _03111_ sky130_fd_sc_hd__o211a_1
X_09562_ FPGA_INST.cell1.LE_1A.config_data\[11\] FPGA_INST.cell1.LE_1A.config_data\[12\]
+ net204 vssd1 vssd1 vccd1 vccd1 _00471_ sky130_fd_sc_hd__mux2_1
X_06774_ _03020_ _03047_ _03019_ vssd1 vssd1 vccd1 vccd1 _03048_ sky130_fd_sc_hd__mux2_1
XFILLER_55_348 vssd1 vssd1 vccd1 vccd1 sky130_fd_sc_hd__fill_1
XFILLER_55_337 vssd1 vssd1 vccd1 vccd1 sky130_fd_sc_hd__fill_2
XANTENNA__06829__B _02350_ vssd1 vssd1 vccd1 vccd1 sky130_fd_sc_hd__diode_2
X_08513_ FPGA_INST.cell3.LE_1A.config_data\[4\] FPGA_INST.cell3.LE_1A.config_data\[5\]
+ _04725_ vssd1 vssd1 vccd1 vccd1 _04726_ sky130_fd_sc_hd__mux2_1
XFILLER_82_178 vssd1 vssd1 vccd1 vccd1 sky130_fd_sc_hd__fill_8
X_05725_ _02004_ _01989_ vssd1 vssd1 vccd1 vccd1 _02005_ sky130_fd_sc_hd__and2b_1
X_09493_ FPGA_INST.cell1.LEI0.config_data\[39\] FPGA_INST.cell1.LEI0.config_data\[40\]
+ net215 vssd1 vssd1 vccd1 vccd1 _00405_ sky130_fd_sc_hd__mux2_1
X_08444_ net151 net144 net149 net142 FPGA_INST.cell1.LEI0.config_data\[30\] FPGA_INST.cell1.LEI0.config_data\[31\]
+ vssd1 vssd1 vccd1 vccd1 _04662_ sky130_fd_sc_hd__mux4_1
X_05656_ _01933_ _01935_ vssd1 vssd1 vccd1 vccd1 _01936_ sky130_fd_sc_hd__or2_1
XTAP_TAPCELL_ROW_34_752 vssd1 vccd1 sky130_fd_sc_hd__tapvpwrvgnd_1
XANTENNA__08059__A0 FPGA_INST.bus3_1\[12\] vssd1 vssd1 vccd1 vccd1 sky130_fd_sc_hd__diode_2
X_08375_ _03604_ _04576_ _04577_ _03639_ _01759_ vssd1 vssd1 vccd1 vccd1 _04597_ sky130_fd_sc_hd__a221o_1
XFILLER_23_278 vssd1 vssd1 vccd1 vccd1 sky130_fd_sc_hd__fill_2
X_05587_ FPGA_INST.cell2.SB0.route_sel\[117\] FPGA_INST.cell2.SB0.route_sel\[116\]
+ vssd1 vssd1 vccd1 vccd1 _01867_ sky130_fd_sc_hd__nand2b_1
XTAP_TAPCELL_ROW_34_763 vssd1 vccd1 sky130_fd_sc_hd__tapvpwrvgnd_1
X_07326_ FPGA_INST.cell3.SB0.route_sel\[32\] FPGA_INST.cell3.SB0.route_sel\[33\] vssd1
+ vssd1 vccd1 vccd1 _03586_ sky130_fd_sc_hd__and2_1
XANTENNA__07012__Y _03278_ vssd1 vssd1 vccd1 vccd1 sky130_fd_sc_hd__diode_2
X_07257_ _03512_ _03515_ _03518_ net342 vssd1 vssd1 vccd1 vccd1 _03519_ sky130_fd_sc_hd__a211o_4
XFILLER_124_309 vssd1 vssd1 vccd1 vccd1 sky130_fd_sc_hd__fill_2
X_07188_ FPGA_INST.cell1.CB_0.config_dataA\[24\] FPGA_INST.cell1.CB_0.config_dataA\[21\]
+ FPGA_INST.cell1.CB_0.config_dataA\[20\] vssd1 vssd1 vccd1 vccd1 _03451_ sky130_fd_sc_hd__or3b_2
XANTENNA_fanout792_A net803 vssd1 vssd1 vccd1 vccd1 sky130_fd_sc_hd__diode_2
X_06208_ _01810_ _02450_ _02487_ _01811_ FPGA_INST.cell2.CB_0.config_dataA\[7\] vssd1
+ vssd1 vccd1 vccd1 _02488_ sky130_fd_sc_hd__a221o_1
X_06139_ net97 _01972_ net157 _02340_ _01975_ vssd1 vssd1 vccd1 vccd1 _02419_ sky130_fd_sc_hd__o32a_1
XFILLER_2_127 vssd1 vssd1 vccd1 vccd1 sky130_fd_sc_hd__fill_1
XANTENNA__07034__B2 _02465_ vssd1 vssd1 vccd1 vccd1 sky130_fd_sc_hd__diode_2
XANTENNA__07034__A1 _02429_ vssd1 vssd1 vccd1 vccd1 sky130_fd_sc_hd__diode_2
XTAP_TAPCELL_ROW_57_1086 vssd1 vccd1 sky130_fd_sc_hd__tapvpwrvgnd_1
XTAP_TAPCELL_ROW_57_1075 vssd1 vccd1 sky130_fd_sc_hd__tapvpwrvgnd_1
XANTENNA__06793__A0 FPGA_INST.bus3_2\[0\] vssd1 vssd1 vccd1 vccd1 sky130_fd_sc_hd__diode_2
Xfanout420 FPGA_INST.cell0.CB_0.config_dataB\[6\] vssd1 vssd1 vccd1 vccd1 net420 sky130_fd_sc_hd__buf_2
Xfanout431 FPGA_INST.cell0.CB_0.config_dataA\[10\] vssd1 vssd1 vccd1 vccd1 net431
+ sky130_fd_sc_hd__dlymetal6s2s_1
Xfanout453 FPGA_INST.cell1.CB_0.config_dataB\[11\] vssd1 vssd1 vccd1 vccd1 net453
+ sky130_fd_sc_hd__buf_2
Xfanout464 FPGA_INST.cell1.CB_0.config_dataA\[15\] vssd1 vssd1 vccd1 vccd1 net464
+ sky130_fd_sc_hd__clkbuf_2
XTAP_TAPCELL_ROW_70_1264 vssd1 vccd1 sky130_fd_sc_hd__tapvpwrvgnd_1
XFILLER_58_131 vssd1 vssd1 vccd1 vccd1 sky130_fd_sc_hd__fill_1
Xfanout475 net476 vssd1 vssd1 vccd1 vccd1 net475 sky130_fd_sc_hd__buf_2
Xfanout442 net443 vssd1 vssd1 vccd1 vccd1 net442 sky130_fd_sc_hd__buf_2
XANTENNA__11434__RESET_B net561 vssd1 vssd1 vccd1 vccd1 sky130_fd_sc_hd__diode_2
XANTENNA__07496__A_N net154 vssd1 vssd1 vccd1 vccd1 sky130_fd_sc_hd__diode_2
Xfanout497 FPGA_INST.cell2.CB_0.config_dataB\[0\] vssd1 vssd1 vccd1 vccd1 net497 sky130_fd_sc_hd__buf_2
Xfanout486 FPGA_INST.cell2.CB_0.config_dataB\[22\] vssd1 vssd1 vccd1 vccd1 net486
+ sky130_fd_sc_hd__buf_2
X_09829_ FPGA_INST.cell0.LEI0.config_data\[7\] FPGA_INST.cell0.LEI0.config_data\[8\]
+ net183 vssd1 vssd1 vccd1 vccd1 _00737_ sky130_fd_sc_hd__mux2_1
XFILLER_104_51 vssd1 vssd1 vccd1 vccd1 sky130_fd_sc_hd__fill_4
XANTENNA__08298__A0 net76 vssd1 vssd1 vccd1 vccd1 sky130_fd_sc_hd__diode_2
XFILLER_82_690 vssd1 vssd1 vccd1 vccd1 sky130_fd_sc_hd__fill_1
XFILLER_73_178 vssd1 vssd1 vccd1 vccd1 sky130_fd_sc_hd__fill_2
XFILLER_64_88 vssd1 vssd1 vccd1 vccd1 sky130_fd_sc_hd__fill_1
XFILLER_14_201 vssd1 vssd1 vccd1 vccd1 sky130_fd_sc_hd__fill_1
X_11722_ net900 _01068_ net684 vssd1 vssd1 vccd1 vccd1 FPGA_INST.cell3.SB0.route_sel\[92\]
+ sky130_fd_sc_hd__dfstp_1
XFILLER_42_554 vssd1 vssd1 vccd1 vccd1 sky130_fd_sc_hd__fill_1
X_11653_ net856 _00999_ net641 vssd1 vssd1 vccd1 vccd1 FPGA_INST.cell3.SB0.route_sel\[23\]
+ sky130_fd_sc_hd__dfstp_1
XFILLER_14_267 vssd1 vssd1 vccd1 vccd1 sky130_fd_sc_hd__fill_2
Xfanout82 net83 vssd1 vssd1 vccd1 vccd1 net82 sky130_fd_sc_hd__buf_2
X_10604_ FPGA_INST.cell3.CB_0.config_dataB\[23\] FPGA_INST.cell3.CB_0.config_dataB\[24\]
+ net284 vssd1 vssd1 vccd1 vccd1 _01483_ sky130_fd_sc_hd__mux2_1
Xfanout93 net94 vssd1 vssd1 vccd1 vccd1 net93 sky130_fd_sc_hd__dlymetal6s2s_1
XFILLER_80_98 vssd1 vssd1 vccd1 vccd1 sky130_fd_sc_hd__fill_2
X_11584_ net760 _00934_ net545 vssd1 vssd1 vccd1 vccd1 FPGA_INST.cell0.CB_1.config_dataA\[3\]
+ sky130_fd_sc_hd__dfstp_1
XTAP_TAPCELL_ROW_12_446 vssd1 vccd1 sky130_fd_sc_hd__tapvpwrvgnd_1
XTAP_TAPCELL_ROW_12_457 vssd1 vccd1 sky130_fd_sc_hd__tapvpwrvgnd_1
XANTENNA__07273__A1 net20 vssd1 vssd1 vccd1 vccd1 sky130_fd_sc_hd__diode_2
X_10535_ FPGA_INST.cell2.SB0.route_sel\[108\] FPGA_INST.cell2.SB0.route_sel\[107\]
+ net352 vssd1 vssd1 vccd1 vccd1 _01414_ sky130_fd_sc_hd__mux2_1
XFILLER_127_169 vssd1 vssd1 vccd1 vccd1 sky130_fd_sc_hd__fill_1
XFILLER_89_41 vccd1 vssd1 vccd1 vssd1 sky130_ef_sc_hd__decap_40_12
X_10466_ FPGA_INST.cell2.SB0.route_sel\[38\] FPGA_INST.cell2.SB0.route_sel\[39\] net243
+ vssd1 vssd1 vccd1 vccd1 _01345_ sky130_fd_sc_hd__mux2_1
XFILLER_6_455 vssd1 vssd1 vccd1 vccd1 sky130_fd_sc_hd__fill_8
XANTENNA__07025__A1 FPGA_INST.bus2_0\[9\] vssd1 vssd1 vccd1 vccd1 sky130_fd_sc_hd__diode_2
X_10397_ FPGA_INST.cell3.LE_1A.config_data\[15\] FPGA_INST.cell3.LE_1A.config_data\[16\]
+ net304 vssd1 vssd1 vccd1 vccd1 _01276_ sky130_fd_sc_hd__mux2_1
X_12136_ net912 _01482_ net696 vssd1 vssd1 vccd1 vccd1 FPGA_INST.cell3.CB_0.config_dataB\[23\]
+ sky130_fd_sc_hd__dfstp_1
XFILLER_97_727 vssd1 vssd1 vccd1 vccd1 sky130_fd_sc_hd__fill_1
XFILLER_97_716 vssd1 vssd1 vccd1 vccd1 sky130_fd_sc_hd__fill_2
XFILLER_111_559 vssd1 vssd1 vccd1 vccd1 sky130_fd_sc_hd__fill_1
X_12067_ net862 _01413_ net641 vssd1 vssd1 vccd1 vccd1 FPGA_INST.cell2.SB0.route_sel\[107\]
+ sky130_fd_sc_hd__dfstp_1
XFILLER_1_182 vssd1 vssd1 vccd1 vccd1 sky130_fd_sc_hd__fill_2
XFILLER_1_171 vssd1 vssd1 vccd1 vccd1 sky130_fd_sc_hd__fill_2
X_11018_ net812 _00368_ net597 vssd1 vssd1 vccd1 vccd1 FPGA_INST.cell1.LEI0.config_data\[3\]
+ sky130_fd_sc_hd__dfrtp_1
XTAP_TAPCELL_ROW_88_1514 vssd1 vccd1 sky130_fd_sc_hd__tapvpwrvgnd_1
XFILLER_77_451 vssd1 vssd1 vccd1 vccd1 sky130_fd_sc_hd__fill_1
XFILLER_64_101 vssd1 vssd1 vccd1 vccd1 sky130_fd_sc_hd__fill_1
XANTENNA_output52_A net52 vssd1 vssd1 vccd1 vccd1 sky130_fd_sc_hd__diode_2
XANTENNA__06001__Y _02281_ vssd1 vssd1 vccd1 vccd1 sky130_fd_sc_hd__diode_2
XANTENNA__06551__A3 FPGA_INST.bus3_2\[15\] vssd1 vssd1 vccd1 vccd1 sky130_fd_sc_hd__diode_2
XANTENNA__10926__SET_B net636 vssd1 vssd1 vccd1 vccd1 sky130_fd_sc_hd__diode_2
X_05510_ net79 vssd1 vssd1 vccd1 vccd1 _01792_ sky130_fd_sc_hd__inv_2
XANTENNA__06839__B2 FPGA_INST.bus2_0\[1\] vssd1 vssd1 vccd1 vccd1 sky130_fd_sc_hd__diode_2
XANTENNA__06839__A1 FPGA_INST.bus2_0\[0\] vssd1 vssd1 vccd1 vccd1 sky130_fd_sc_hd__diode_2
X_06490_ _02760_ _02767_ _02756_ vssd1 vssd1 vccd1 vccd1 _02768_ sky130_fd_sc_hd__mux2_1
XFILLER_33_532 vssd1 vssd1 vccd1 vccd1 sky130_fd_sc_hd__fill_1
X_05441_ FPGA_INST.cell0.SB0.route_sel\[5\] vssd1 vssd1 vccd1 vccd1 _01723_ sky130_fd_sc_hd__inv_2
XTAP_TAPCELL_ROW_31_711 vssd1 vccd1 sky130_fd_sc_hd__tapvpwrvgnd_1
XFILLER_33_576 vssd1 vssd1 vccd1 vccd1 sky130_fd_sc_hd__fill_1
X_08160_ _03959_ _04382_ _04383_ _03923_ _04381_ vssd1 vssd1 vccd1 vccd1 _04384_ sky130_fd_sc_hd__a221o_1
XFILLER_20_226 vssd1 vssd1 vccd1 vccd1 sky130_fd_sc_hd__fill_1
XTAP_TAPCELL_ROW_31_722 vssd1 vccd1 sky130_fd_sc_hd__tapvpwrvgnd_1
X_05372_ FPGA_INST.cell3.SB0.route_sel\[65\] vssd1 vssd1 vccd1 vccd1 _01654_ sky130_fd_sc_hd__inv_2
X_07111_ _01737_ _03373_ _03376_ _01739_ _03366_ vssd1 vssd1 vccd1 vccd1 _03377_ sky130_fd_sc_hd__o311a_1
X_08091_ FPGA_INST.bus3_1\[8\] FPGA_INST.bus3_1\[9\] FPGA_INST.bus3_1\[10\] FPGA_INST.bus3_1\[11\]
+ net454 net453 vssd1 vssd1 vccd1 vccd1 _04317_ sky130_fd_sc_hd__mux4_1
XTAP_TAPCELL_ROW_99_1665 vssd1 vccd1 sky130_fd_sc_hd__tapvpwrvgnd_1
XANTENNA__09187__S net361 vssd1 vssd1 vccd1 vccd1 sky130_fd_sc_hd__diode_2
X_07042_ FPGA_INST.bus2_0\[0\] _03284_ _03307_ vssd1 vssd1 vccd1 vccd1 _03308_ sky130_fd_sc_hd__a21o_1
XTAP_TAPCELL_ROW_110_1821 vssd1 vccd1 sky130_fd_sc_hd__tapvpwrvgnd_1
X_08993_ FPGA_INST.cell3.SB0.route_sel\[40\] _01679_ _01680_ FPGA_INST.cell3.SB0.route_sel\[43\]
+ _05168_ vssd1 vssd1 vccd1 vccd1 _05169_ sky130_fd_sc_hd__a221o_1
XFILLER_87_215 vssd1 vssd1 vccd1 vccd1 sky130_fd_sc_hd__fill_8
X_07944_ net467 _04049_ vssd1 vssd1 vccd1 vccd1 _04172_ sky130_fd_sc_hd__nand2_1
X_07875_ FPGA_INST.cell1.CB_0.config_dataA\[7\] _04100_ _04102_ FPGA_INST.cell1.CB_0.config_dataA\[8\]
+ vssd1 vssd1 vccd1 vccd1 _04103_ sky130_fd_sc_hd__o211a_1
XFILLER_68_451 vssd1 vssd1 vccd1 vccd1 sky130_fd_sc_hd__fill_4
XFILLER_18_15 vccd1 vssd1 vccd1 vssd1 sky130_ef_sc_hd__decap_40_12
XANTENNA_fanout373_A net374 vssd1 vssd1 vccd1 vccd1 sky130_fd_sc_hd__diode_2
X_09614_ FPGA_INST.cell0.SB0.route_sel\[17\] FPGA_INST.cell0.SB0.route_sel\[18\] net200
+ vssd1 vssd1 vccd1 vccd1 _00523_ sky130_fd_sc_hd__mux2_1
X_06826_ net422 net420 vssd1 vssd1 vccd1 vccd1 _03094_ sky130_fd_sc_hd__nor2_1
XTAP_TAPCELL_ROW_39_822 vssd1 vccd1 sky130_fd_sc_hd__tapvpwrvgnd_1
XTAP_TAPCELL_ROW_39_833 vssd1 vccd1 sky130_fd_sc_hd__tapvpwrvgnd_1
X_09545_ FPGA_INST.cell1.LE_0B.reset_val FPGA_INST.cell1.LE_0B.edge_mode net346 vssd1
+ vssd1 vccd1 vccd1 _00455_ sky130_fd_sc_hd__mux2_1
X_06757_ _02772_ _02776_ net515 vssd1 vssd1 vccd1 vccd1 _03031_ sky130_fd_sc_hd__mux2_1
XFILLER_55_178 vssd1 vssd1 vccd1 vccd1 sky130_fd_sc_hd__fill_1
X_09476_ FPGA_INST.cell1.LEI0.config_data\[22\] FPGA_INST.cell1.LEI0.config_data\[23\]
+ net218 vssd1 vssd1 vccd1 vccd1 _00388_ sky130_fd_sc_hd__mux2_1
XTAP_TAPCELL_ROW_108_1794 vssd1 vccd1 sky130_fd_sc_hd__tapvpwrvgnd_1
X_06688_ net520 _02836_ vssd1 vssd1 vccd1 vccd1 _02962_ sky130_fd_sc_hd__or2_1
X_05708_ FPGA_INST.cell2.SB0.route_sel\[108\] FPGA_INST.cell2.SB0.route_sel\[109\]
+ _01987_ vssd1 vssd1 vccd1 vccd1 _01988_ sky130_fd_sc_hd__a21oi_1
X_08427_ _01761_ FPGA_INST.cell0.LE_1B.dff_out vssd1 vssd1 vccd1 vccd1 _04648_ sky130_fd_sc_hd__or2_1
X_05639_ FPGA_INST.cell0.CB_0.le_outA _01816_ _01917_ vssd1 vssd1 vccd1 vccd1 _01919_
+ sky130_fd_sc_hd__and3_1
XTAP_TAPCELL_ROW_121_1983 vssd1 vccd1 sky130_fd_sc_hd__tapvpwrvgnd_1
XTAP_TAPCELL_ROW_121_1972 vssd1 vccd1 sky130_fd_sc_hd__tapvpwrvgnd_1
XANTENNA_fanout805_A net811 vssd1 vssd1 vccd1 vccd1 sky130_fd_sc_hd__diode_2
XFILLER_11_215 vssd1 vssd1 vccd1 vccd1 sky130_fd_sc_hd__fill_1
X_08358_ FPGA_INST.cell0.CB_1.config_dataB\[12\] _04579_ vssd1 vssd1 vccd1 vccd1 _04580_
+ sky130_fd_sc_hd__nor2_1
X_07309_ FPGA_INST.cell3.SB0.route_sel\[29\] FPGA_INST.cell3.SB0.route_sel\[28\] _01787_
+ _03547_ _03569_ vssd1 vssd1 vccd1 vccd1 _03570_ sky130_fd_sc_hd__a221o_1
XTAP_TAPCELL_ROW_59_1115 vssd1 vccd1 sky130_fd_sc_hd__tapvpwrvgnd_1
XTAP_TAPCELL_ROW_59_1104 vssd1 vccd1 sky130_fd_sc_hd__tapvpwrvgnd_1
XFILLER_20_793 vssd1 vssd1 vccd1 vccd1 sky130_fd_sc_hd__fill_2
X_08289_ _04512_ _04505_ _04498_ vssd1 vssd1 vccd1 vccd1 _04513_ sky130_fd_sc_hd__mux2_1
X_10320_ FPGA_INST.cell3.LEI0.config_data\[34\] FPGA_INST.cell3.LEI0.config_data\[35\]
+ net282 vssd1 vssd1 vccd1 vccd1 _01201_ sky130_fd_sc_hd__mux2_1
XANTENNA__09097__S net361 vssd1 vssd1 vccd1 vccd1 sky130_fd_sc_hd__diode_2
X_10251_ FPGA_INST.io_south_oeb\[22\] FPGA_INST.io_south_oeb\[24\] net264 vssd1 vssd1
+ vccd1 vccd1 _01132_ sky130_fd_sc_hd__mux2_1
XANTENNA__07007__A1 FPGA_INST.bus2_0\[9\] vssd1 vssd1 vccd1 vccd1 sky130_fd_sc_hd__diode_2
XANTENNA__10036__S net317 vssd1 vssd1 vccd1 vccd1 sky130_fd_sc_hd__diode_2
XFILLER_105_364 vssd1 vssd1 vccd1 vccd1 sky130_fd_sc_hd__fill_1
XFILLER_79_727 vssd1 vssd1 vccd1 vccd1 sky130_fd_sc_hd__fill_1
X_10182_ FPGA_INST.cell3.SB0.route_sel\[86\] FPGA_INST.cell3.SB0.route_sel\[87\] net286
+ vssd1 vssd1 vccd1 vccd1 _01063_ sky130_fd_sc_hd__mux2_1
XFILLER_120_323 vssd1 vssd1 vccd1 vccd1 sky130_fd_sc_hd__fill_1
XANTENNA__06230__A2 _02255_ vssd1 vssd1 vccd1 vccd1 sky130_fd_sc_hd__diode_2
Xfanout250 net251 vssd1 vssd1 vccd1 vccd1 net250 sky130_fd_sc_hd__clkbuf_4
Xfanout283 net284 vssd1 vssd1 vccd1 vccd1 net283 sky130_fd_sc_hd__buf_2
Xfanout272 net273 vssd1 vssd1 vccd1 vccd1 net272 sky130_fd_sc_hd__clkbuf_4
XFILLER_59_451 vssd1 vssd1 vccd1 vccd1 sky130_fd_sc_hd__fill_4
Xfanout261 net267 vssd1 vssd1 vccd1 vccd1 net261 sky130_fd_sc_hd__clkbuf_2
Xfanout294 net295 vssd1 vssd1 vccd1 vccd1 net294 sky130_fd_sc_hd__clkbuf_4
XFILLER_74_432 vssd1 vssd1 vccd1 vccd1 sky130_fd_sc_hd__fill_2
XFILLER_74_465 vssd1 vssd1 vccd1 vccd1 sky130_fd_sc_hd__fill_8
XFILLER_74_443 vssd1 vssd1 vccd1 vccd1 sky130_fd_sc_hd__fill_1
XTAP_TAPCELL_ROW_17_516 vssd1 vccd1 sky130_fd_sc_hd__tapvpwrvgnd_1
XTAP_TAPCELL_ROW_17_527 vssd1 vccd1 sky130_fd_sc_hd__tapvpwrvgnd_1
XTAP_TAPCELL_ROW_83_1444 vssd1 vccd1 sky130_fd_sc_hd__tapvpwrvgnd_1
XANTENNA__08691__A0 net22 vssd1 vssd1 vccd1 vccd1 sky130_fd_sc_hd__diode_2
X_11705_ net901 _01051_ net685 vssd1 vssd1 vccd1 vccd1 FPGA_INST.cell3.SB0.route_sel\[75\]
+ sky130_fd_sc_hd__dfstp_1
X_11636_ net896 _00982_ net680 vssd1 vssd1 vccd1 vccd1 FPGA_INST.cell3.SB0.route_sel\[6\]
+ sky130_fd_sc_hd__dfstp_1
XFILLER_24_80 vssd1 vssd1 vccd1 vccd1 sky130_fd_sc_hd__fill_4
XFILLER_128_423 vssd1 vssd1 vccd1 vccd1 sky130_fd_sc_hd__fill_4
X_11567_ net770 _00917_ net555 vssd1 vssd1 vccd1 vccd1 FPGA_INST.cell0.CB_0.config_dataB\[11\]
+ sky130_fd_sc_hd__dfstp_1
XFILLER_116_629 vssd1 vssd1 vccd1 vccd1 sky130_fd_sc_hd__fill_2
XFILLER_7_764 vssd1 vssd1 vccd1 vccd1 sky130_fd_sc_hd__fill_1
XFILLER_6_230 vssd1 vssd1 vccd1 vccd1 sky130_fd_sc_hd__fill_1
X_10518_ FPGA_INST.cell2.SB0.route_sel\[90\] FPGA_INST.cell2.SB0.route_sel\[91\] net248
+ vssd1 vssd1 vccd1 vccd1 _01397_ sky130_fd_sc_hd__mux2_1
X_11498_ net791 _00848_ net576 vssd1 vssd1 vccd1 vccd1 FPGA_INST.cell0.CB_1.config_dataB\[4\]
+ sky130_fd_sc_hd__dfstp_1
XANTENNA__05548__B _01825_ vssd1 vssd1 vccd1 vccd1 sky130_fd_sc_hd__diode_2
X_10449_ FPGA_INST.cell2.SB0.route_sel\[21\] FPGA_INST.cell2.SB0.route_sel\[22\] net235
+ vssd1 vssd1 vccd1 vccd1 _01328_ sky130_fd_sc_hd__mux2_1
XANTENNA__09735__S net230 vssd1 vssd1 vccd1 vccd1 sky130_fd_sc_hd__diode_2
XTAP_TAPCELL_ROW_94_1595 vssd1 vccd1 sky130_fd_sc_hd__tapvpwrvgnd_1
XANTENNA__06757__A0 _02772_ vssd1 vssd1 vccd1 vccd1 sky130_fd_sc_hd__diode_2
XFILLER_123_183 vssd1 vssd1 vccd1 vccd1 sky130_fd_sc_hd__fill_4
X_12119_ net937 _01465_ net721 vssd1 vssd1 vccd1 vccd1 FPGA_INST.cell3.CB_0.config_dataB\[6\]
+ sky130_fd_sc_hd__dfstp_1
X_05990_ _02267_ _02269_ vssd1 vssd1 vccd1 vccd1 _02270_ sky130_fd_sc_hd__nor2_2
XFILLER_111_367 vssd1 vssd1 vccd1 vccd1 sky130_fd_sc_hd__fill_1
XANTENNA__09470__S net230 vssd1 vssd1 vccd1 vccd1 sky130_fd_sc_hd__diode_2
X_07660_ FPGA_INST.cell1.CB_0.config_dataB\[23\] FPGA_INST.cell1.CB_0.config_dataB\[22\]
+ vssd1 vssd1 vccd1 vccd1 _03912_ sky130_fd_sc_hd__and2_1
XANTENNA__05851__X _02131_ vssd1 vssd1 vccd1 vccd1 sky130_fd_sc_hd__diode_2
X_07591_ _03507_ _03762_ net141 vssd1 vssd1 vccd1 vccd1 _03845_ sky130_fd_sc_hd__o21bai_1
X_06611_ _02804_ _02880_ _02882_ _02801_ _01592_ vssd1 vssd1 vccd1 vccd1 _02887_ sky130_fd_sc_hd__a221o_1
X_09330_ FPGA_INST.cell1.SB0.route_sel\[101\] FPGA_INST.cell1.SB0.route_sel\[102\]
+ net223 vssd1 vssd1 vccd1 vccd1 _00243_ sky130_fd_sc_hd__mux2_1
X_06542_ _01578_ FPGA_INST.cell2.SB0.route_sel\[97\] FPGA_INST.cell2.SB0.route_sel\[102\]
+ _01579_ _02817_ vssd1 vssd1 vccd1 vccd1 _02818_ sky130_fd_sc_hd__a221o_1
X_09261_ FPGA_INST.cell1.SB0.route_sel\[32\] FPGA_INST.cell1.SB0.route_sel\[33\] net230
+ vssd1 vssd1 vccd1 vccd1 _00174_ sky130_fd_sc_hd__mux2_1
XFILLER_33_362 vssd1 vssd1 vccd1 vccd1 sky130_fd_sc_hd__fill_4
XANTENNA__08682__B1 _04889_ vssd1 vssd1 vccd1 vccd1 sky130_fd_sc_hd__diode_2
X_08212_ FPGA_INST.cell0.CB_1.config_dataA\[8\] _04435_ FPGA_INST.cell0.CB_1.config_dataA\[9\]
+ vssd1 vssd1 vccd1 vccd1 _04436_ sky130_fd_sc_hd__a21o_1
X_06473_ net14 net15 net16 net17 net488 FPGA_INST.cell2.CB_0.config_dataB\[16\] vssd1
+ vssd1 vccd1 vccd1 _02751_ sky130_fd_sc_hd__mux4_1
X_05424_ FPGA_INST.cell1.SB0.route_sel\[19\] vssd1 vssd1 vccd1 vccd1 _01706_ sky130_fd_sc_hd__inv_2
X_09192_ FPGA_INST.cell2.LE_1A.config_data\[9\] FPGA_INST.cell2.LE_1A.config_data\[10\]
+ net263 vssd1 vssd1 vccd1 vccd1 _00105_ sky130_fd_sc_hd__mux2_1
X_08143_ _04367_ _04368_ _04262_ vssd1 vssd1 vccd1 vccd1 _04369_ sky130_fd_sc_hd__mux2_1
X_05355_ FPGA_INST.cell0.SB0.route_sel\[89\] vssd1 vssd1 vccd1 vccd1 _01637_ sky130_fd_sc_hd__inv_2
XANTENNA_fanout121_A net122 vssd1 vssd1 vccd1 vccd1 sky130_fd_sc_hd__diode_2
XANTENNA_fanout219_A net233 vssd1 vssd1 vccd1 vccd1 sky130_fd_sc_hd__diode_2
X_08074_ net453 net454 vssd1 vssd1 vccd1 vccd1 _04300_ sky130_fd_sc_hd__nor2_1
XANTENNA__06842__B _01888_ vssd1 vssd1 vccd1 vccd1 sky130_fd_sc_hd__diode_2
XANTENNA__06334__S _02536_ vssd1 vssd1 vccd1 vccd1 sky130_fd_sc_hd__diode_2
X_07025_ FPGA_INST.bus2_0\[8\] FPGA_INST.bus2_0\[9\] FPGA_INST.bus2_0\[10\] FPGA_INST.bus2_0\[11\]
+ net437 net435 vssd1 vssd1 vccd1 vccd1 _03291_ sky130_fd_sc_hd__mux4_1
X_05286_ FPGA_INST.cell2.SB0.route_sel\[71\] vssd1 vssd1 vccd1 vccd1 _01568_ sky130_fd_sc_hd__inv_2
XFILLER_115_695 vssd1 vssd1 vccd1 vccd1 sky130_fd_sc_hd__fill_1
XFILLER_115_673 vssd1 vssd1 vccd1 vccd1 sky130_fd_sc_hd__fill_2
XFILLER_114_161 vssd1 vssd1 vccd1 vccd1 sky130_fd_sc_hd__fill_2
XTAP_TAPCELL_ROW_54_1045 vssd1 vccd1 sky130_fd_sc_hd__tapvpwrvgnd_1
XTAP_TAPCELL_ROW_54_1034 vssd1 vccd1 sky130_fd_sc_hd__tapvpwrvgnd_1
XFILLER_0_417 vssd1 vssd1 vccd1 vccd1 sky130_fd_sc_hd__fill_2
XFILLER_130_643 vssd1 vssd1 vccd1 vccd1 sky130_fd_sc_hd__fill_1
XFILLER_102_334 vssd1 vssd1 vccd1 vccd1 sky130_fd_sc_hd__fill_1
XANTENNA_fanout588_A net627 vssd1 vssd1 vccd1 vccd1 sky130_fd_sc_hd__diode_2
XFILLER_102_367 vssd1 vssd1 vccd1 vccd1 sky130_fd_sc_hd__fill_4
X_08976_ _03741_ _05157_ vssd1 vssd1 vccd1 vccd1 FPGA_INST.bus3_1\[7\] sky130_fd_sc_hd__nor2_2
XFILLER_69_771 vccd1 vssd1 vccd1 vssd1 sky130_ef_sc_hd__decap_40_12
XFILLER_29_69 vssd1 vssd1 vccd1 vccd1 sky130_fd_sc_hd__fill_2
X_07927_ _03613_ _04152_ _04154_ _03652_ vssd1 vssd1 vccd1 vccd1 _04155_ sky130_fd_sc_hd__o2bb2a_1
XFILLER_68_270 vssd1 vssd1 vccd1 vccd1 sky130_fd_sc_hd__fill_4
XFILLER_56_421 vccd1 vssd1 vccd1 vssd1 sky130_ef_sc_hd__decap_40_12
X_07858_ FPGA_INST.bus3_1\[0\] FPGA_INST.bus3_1\[1\] FPGA_INST.bus3_1\[2\] FPGA_INST.bus3_1\[3\]
+ net470 net468 vssd1 vssd1 vccd1 vccd1 _04086_ sky130_fd_sc_hd__mux4_1
XFILLER_83_251 vssd1 vssd1 vccd1 vccd1 sky130_fd_sc_hd__fill_4
XFILLER_56_443 vssd1 vssd1 vccd1 vccd1 sky130_fd_sc_hd__fill_1
XFILLER_45_13 vssd1 vssd1 vccd1 vccd1 sky130_fd_sc_hd__fill_1
XANTENNA_fanout922_A net947 vssd1 vssd1 vccd1 vccd1 sky130_fd_sc_hd__diode_2
XFILLER_71_424 vssd1 vssd1 vccd1 vccd1 sky130_fd_sc_hd__fill_1
X_06809_ FPGA_INST.cell2.LE_1B.config_data\[15\] FPGA_INST.cell2.LE_1B.config_data\[14\]
+ _02992_ vssd1 vssd1 vccd1 vccd1 _03083_ sky130_fd_sc_hd__mux2_1
X_07789_ FPGA_INST.cell0.SB0.route_sel\[126\] _01608_ vssd1 vssd1 vccd1 vccd1 _04038_
+ sky130_fd_sc_hd__nand2_1
XFILLER_44_638 vssd1 vssd1 vccd1 vccd1 sky130_fd_sc_hd__fill_1
XANTENNA__09380__S net351 vssd1 vssd1 vccd1 vccd1 sky130_fd_sc_hd__diode_2
X_09528_ FPGA_INST.cell1.LE_0B.config_data\[1\] FPGA_INST.cell1.LE_0B.config_data\[0\]
+ net346 vssd1 vssd1 vccd1 vccd1 _00438_ sky130_fd_sc_hd__mux2_1
XFILLER_71_435 vssd1 vssd1 vccd1 vccd1 sky130_fd_sc_hd__fill_1
X_09459_ FPGA_INST.cell1.LEI0.config_data\[5\] FPGA_INST.cell1.LEI0.config_data\[6\]
+ net216 vssd1 vssd1 vccd1 vccd1 _00371_ sky130_fd_sc_hd__mux2_1
XANTENNA__07476__A1 net134 vssd1 vssd1 vccd1 vccd1 sky130_fd_sc_hd__diode_2
XTAP_TAPCELL_ROW_65_1196 vssd1 vccd1 sky130_fd_sc_hd__tapvpwrvgnd_1
XFILLER_12_524 vssd1 vssd1 vccd1 vccd1 sky130_fd_sc_hd__fill_2
XFILLER_12_579 vssd1 vssd1 vccd1 vccd1 sky130_fd_sc_hd__fill_2
X_11421_ net754 _00771_ net539 vssd1 vssd1 vccd1 vccd1 FPGA_INST.cell0.LEI0.config_data\[42\]
+ sky130_fd_sc_hd__dfrtp_1
XTAP_TAPCELL_ROW_22_585 vssd1 vccd1 sky130_fd_sc_hd__tapvpwrvgnd_1
X_11352_ net795 _00702_ net580 vssd1 vssd1 vccd1 vccd1 FPGA_INST.cell1.CB_1.config_dataA\[19\]
+ sky130_fd_sc_hd__dfstp_1
XANTENNA__07779__A2 _03542_ vssd1 vssd1 vccd1 vccd1 sky130_fd_sc_hd__diode_2
XANTENNA__06752__B _02832_ vssd1 vssd1 vccd1 vccd1 sky130_fd_sc_hd__diode_2
XTAP_TAPCELL_ROW_22_596 vssd1 vccd1 sky130_fd_sc_hd__tapvpwrvgnd_1
X_10303_ FPGA_INST.cell3.LEI0.config_data\[17\] FPGA_INST.cell3.LEI0.config_data\[18\]
+ net299 vssd1 vssd1 vccd1 vccd1 _01184_ sky130_fd_sc_hd__mux2_1
XFILLER_4_712 vccd1 vssd1 vccd1 vssd1 sky130_ef_sc_hd__decap_40_12
XFILLER_125_459 vssd1 vssd1 vccd1 vccd1 sky130_fd_sc_hd__fill_4
X_11283_ net813 _00633_ net598 vssd1 vssd1 vccd1 vccd1 FPGA_INST.cell1.CB_0.config_dataA\[0\]
+ sky130_fd_sc_hd__dfstp_1
XFILLER_106_684 vssd1 vssd1 vccd1 vccd1 sky130_fd_sc_hd__fill_1
XFILLER_106_673 vssd1 vssd1 vccd1 vccd1 sky130_fd_sc_hd__fill_2
XANTENNA__09555__S net333 vssd1 vssd1 vccd1 vccd1 sky130_fd_sc_hd__diode_2
X_10234_ FPGA_INST.io_west_oeb\[20\] FPGA_INST.io_west_oeb\[22\] net289 vssd1 vssd1
+ vccd1 vccd1 _01115_ sky130_fd_sc_hd__mux2_1
XFILLER_3_266 vccd1 vssd1 vccd1 vssd1 sky130_ef_sc_hd__decap_40_12
X_10165_ FPGA_INST.cell3.SB0.route_sel\[69\] FPGA_INST.cell3.SB0.route_sel\[70\] net276
+ vssd1 vssd1 vccd1 vccd1 _01046_ sky130_fd_sc_hd__mux2_1
XFILLER_120_197 vssd1 vssd1 vccd1 vccd1 sky130_fd_sc_hd__fill_4
X_10096_ FPGA_INST.cell3.SB0.route_sel\[0\] FPGA_INST.cell3.SB0.route_sel\[1\] net272
+ vssd1 vssd1 vccd1 vccd1 _00977_ sky130_fd_sc_hd__mux2_1
XFILLER_47_410 vssd1 vssd1 vccd1 vccd1 sky130_fd_sc_hd__fill_1
XFILLER_62_457 vssd1 vssd1 vccd1 vccd1 sky130_fd_sc_hd__fill_2
XFILLER_28_690 vssd1 vssd1 vccd1 vccd1 sky130_fd_sc_hd__fill_1
X_10998_ net926 _00348_ net710 vssd1 vssd1 vccd1 vccd1 FPGA_INST.cell2.LE_1B.config_data\[4\]
+ sky130_fd_sc_hd__dfrtp_1
XFILLER_62_468 vssd1 vssd1 vccd1 vccd1 sky130_fd_sc_hd__fill_2
XFILLER_43_671 vssd1 vssd1 vccd1 vccd1 sky130_fd_sc_hd__fill_1
XANTENNA__08982__X FPGA_INST.bus2_0\[6\] vssd1 vssd1 vccd1 vccd1 sky130_fd_sc_hd__diode_2
XANTENNA__07467__A1 net148 vssd1 vssd1 vccd1 vccd1 sky130_fd_sc_hd__diode_2
XFILLER_42_170 vssd1 vssd1 vccd1 vccd1 sky130_fd_sc_hd__fill_1
XFILLER_42_192 vssd1 vssd1 vccd1 vccd1 sky130_fd_sc_hd__fill_4
XTAP_TAPCELL_ROW_41_861 vssd1 vccd1 sky130_fd_sc_hd__tapvpwrvgnd_1
XTAP_TAPCELL_ROW_41_850 vssd1 vccd1 sky130_fd_sc_hd__tapvpwrvgnd_1
X_11619_ net742 _00969_ net527 vssd1 vssd1 vccd1 vccd1 FPGA_INST.cell0.LE_1B.config_data\[13\]
+ sky130_fd_sc_hd__dfrtp_1
XFILLER_128_253 vssd1 vssd1 vccd1 vccd1 sky130_fd_sc_hd__fill_4
XFILLER_116_404 vccd1 vssd1 vccd1 vssd1 sky130_ef_sc_hd__decap_40_12
XTAP_TAPCELL_ROW_96_1624 vssd1 vccd1 sky130_fd_sc_hd__tapvpwrvgnd_1
XFILLER_112_643 vssd1 vssd1 vccd1 vccd1 sky130_fd_sc_hd__fill_1
X_08830_ _05036_ vssd1 vssd1 vccd1 vccd1 _05037_ sky130_fd_sc_hd__inv_2
XANTENNA__07942__A2 FPGA_INST.bus3_1\[14\] vssd1 vssd1 vccd1 vccd1 sky130_fd_sc_hd__diode_2
XFILLER_97_354 vssd1 vssd1 vccd1 vccd1 sky130_fd_sc_hd__fill_2
XFILLER_85_505 vssd1 vssd1 vccd1 vccd1 sky130_fd_sc_hd__fill_1
X_08761_ _04966_ _04969_ _04922_ vssd1 vssd1 vccd1 vccd1 _04970_ sky130_fd_sc_hd__mux2_1
X_05973_ FPGA_INST.cell2.SB0.route_sel\[53\] FPGA_INST.cell2.SB0.route_sel\[52\] vssd1
+ vssd1 vccd1 vccd1 _02253_ sky130_fd_sc_hd__nand2b_1
XFILLER_38_421 vssd1 vssd1 vccd1 vccd1 sky130_fd_sc_hd__fill_2
XTAP_TAPCELL_ROW_123_2009 vssd1 vccd1 sky130_fd_sc_hd__tapvpwrvgnd_1
XFILLER_122_18 vssd1 vssd1 vccd1 vccd1 sky130_fd_sc_hd__fill_8
X_08692_ _04899_ _04900_ FPGA_INST.cell3.CB_0.config_dataA\[12\] vssd1 vssd1 vccd1
+ vccd1 _04901_ sky130_fd_sc_hd__mux2_1
X_07712_ FPGA_INST.cell1.SB0.route_sel\[104\] FPGA_INST.cell1.SB0.route_sel\[105\]
+ vssd1 vssd1 vccd1 vccd1 _03963_ sky130_fd_sc_hd__nand2_1
XANTENNA__10701__Q FPGA_INST.cell2.LE_0A.config_data\[0\] vssd1 vssd1 vccd1 vccd1
+ sky130_fd_sc_hd__diode_2
X_07643_ _03893_ _03895_ vssd1 vssd1 vccd1 vccd1 _03896_ sky130_fd_sc_hd__nand2_1
XFILLER_65_251 vssd1 vssd1 vccd1 vccd1 sky130_fd_sc_hd__fill_1
XTAP_TAPCELL_ROW_49_972 vssd1 vccd1 sky130_fd_sc_hd__tapvpwrvgnd_1
XANTENNA__05741__B _01825_ vssd1 vssd1 vccd1 vccd1 sky130_fd_sc_hd__diode_2
XTAP_TAPCELL_ROW_0_269 vssd1 vccd1 sky130_fd_sc_hd__tapvpwrvgnd_1
XTAP_TAPCELL_ROW_105_1753 vssd1 vccd1 sky130_fd_sc_hd__tapvpwrvgnd_1
X_07574_ FPGA_INST.cell3.SB0.route_sel\[80\] FPGA_INST.cell3.SB0.route_sel\[81\] vssd1
+ vssd1 vccd1 vccd1 _03828_ sky130_fd_sc_hd__nand2_1
X_09313_ FPGA_INST.cell1.SB0.route_sel\[84\] FPGA_INST.cell1.SB0.route_sel\[85\] net203
+ vssd1 vssd1 vccd1 vccd1 _00226_ sky130_fd_sc_hd__mux2_1
XANTENNA__11780__CLK net931 vssd1 vssd1 vccd1 vccd1 sky130_fd_sc_hd__diode_2
XANTENNA_fanout336_A net337 vssd1 vssd1 vccd1 vccd1 sky130_fd_sc_hd__diode_2
X_06525_ net352 _02283_ _02288_ _02800_ vssd1 vssd1 vccd1 vccd1 _02801_ sky130_fd_sc_hd__or4b_4
X_09244_ FPGA_INST.cell1.SB0.route_sel\[16\] FPGA_INST.cell1.SB0.route_sel\[15\] net342
+ vssd1 vssd1 vccd1 vccd1 _00157_ sky130_fd_sc_hd__mux2_1
X_06456_ _02727_ _02730_ _02732_ _02733_ vssd1 vssd1 vccd1 vccd1 _02734_ sky130_fd_sc_hd__o22a_1
X_05407_ FPGA_INST.cell3.SB0.route_sel\[37\] vssd1 vssd1 vccd1 vccd1 _01689_ sky130_fd_sc_hd__inv_2
XFILLER_21_387 vssd1 vssd1 vccd1 vccd1 sky130_fd_sc_hd__fill_1
X_09175_ FPGA_INST.cell2.LE_0B.config_data\[15\] FPGA_INST.cell2.LE_0B.config_data\[16\]
+ net256 vssd1 vssd1 vccd1 vccd1 _00089_ sky130_fd_sc_hd__mux2_1
X_08126_ FPGA_INST.cell1.CB_0.config_dataB\[17\] _04349_ _04351_ vssd1 vssd1 vccd1
+ vccd1 _04352_ sky130_fd_sc_hd__or3_1
X_06387_ net6 _02655_ _02663_ net496 vssd1 vssd1 vccd1 vccd1 _02665_ sky130_fd_sc_hd__a22o_1
X_05338_ FPGA_INST.cell1.SB0.route_sel\[109\] vssd1 vssd1 vccd1 vccd1 _01620_ sky130_fd_sc_hd__inv_2
X_08057_ FPGA_INST.bus3_1\[8\] FPGA_INST.bus3_1\[9\] FPGA_INST.bus3_1\[10\] FPGA_INST.bus3_1\[11\]
+ net461 net459 vssd1 vssd1 vccd1 vccd1 _04283_ sky130_fd_sc_hd__mux4_1
XPHY_EDGE_ROW_1_Right_1 vssd1 vssd1 vccd1 vccd1 sky130_fd_sc_hd__decap_3
X_05269_ FPGA_INST.cell2.SB0.route_sel\[15\] vssd1 vssd1 vccd1 vccd1 _01551_ sky130_fd_sc_hd__inv_2
Xoutput37 net37 vssd1 vssd1 vccd1 vccd1 gpio_oeb[21] sky130_fd_sc_hd__buf_2
Xoutput48 net48 vssd1 vssd1 vccd1 vccd1 gpio_out[13] sky130_fd_sc_hd__buf_2
XFILLER_1_726 vssd1 vssd1 vccd1 vccd1 sky130_fd_sc_hd__fill_2
X_07008_ _03273_ _03272_ FPGA_INST.cell0.CB_0.config_dataA\[7\] vssd1 vssd1 vccd1
+ vccd1 _03274_ sky130_fd_sc_hd__mux2_1
XANTENNA__09375__S net240 vssd1 vssd1 vccd1 vccd1 sky130_fd_sc_hd__diode_2
XFILLER_0_225 vccd1 vssd1 vccd1 vssd1 sky130_ef_sc_hd__decap_40_12
Xoutput59 net59 vssd1 vssd1 vccd1 vccd1 gpio_out[24] sky130_fd_sc_hd__buf_2
XANTENNA__07933__A2 _03519_ vssd1 vssd1 vccd1 vccd1 sky130_fd_sc_hd__diode_2
XANTENNA__07394__B1 _03652_ vssd1 vssd1 vccd1 vccd1 sky130_fd_sc_hd__diode_2
XFILLER_88_365 vssd1 vssd1 vccd1 vccd1 sky130_fd_sc_hd__fill_2
XFILLER_76_505 vssd1 vssd1 vccd1 vccd1 sky130_fd_sc_hd__fill_1
XFILLER_102_197 vssd1 vssd1 vccd1 vccd1 sky130_fd_sc_hd__fill_2
XFILLER_102_186 vssd1 vssd1 vccd1 vccd1 sky130_fd_sc_hd__fill_1
X_08959_ FPGA_INST.cell1.SB0.route_sel\[67\] _01658_ FPGA_INST.cell1.SB0.route_sel\[64\]
+ FPGA_INST.cell1.SB0.route_sel\[65\] vssd1 vssd1 vccd1 vccd1 _05146_ sky130_fd_sc_hd__o22a_1
XFILLER_56_45 vssd1 vssd1 vccd1 vccd1 sky130_fd_sc_hd__fill_1
X_11970_ net847 _01316_ net632 vssd1 vssd1 vccd1 vccd1 FPGA_INST.cell2.SB0.route_sel\[10\]
+ sky130_fd_sc_hd__dfstp_1
XFILLER_84_560 vssd1 vssd1 vccd1 vccd1 sky130_fd_sc_hd__fill_2
XANTENNA__07697__A1 net81 vssd1 vssd1 vccd1 vccd1 sky130_fd_sc_hd__diode_2
XTAP_TAPCELL_ROW_67_1225 vssd1 vccd1 sky130_fd_sc_hd__tapvpwrvgnd_1
XTAP_TAPCELL_ROW_67_1214 vssd1 vccd1 sky130_fd_sc_hd__tapvpwrvgnd_1
XFILLER_57_785 vccd1 vssd1 vccd1 vssd1 sky130_ef_sc_hd__decap_40_12
X_10921_ net865 _00271_ net650 vssd1 vssd1 vccd1 vccd1 FPGA_INST.cell2.CB_0.config_dataA\[2\]
+ sky130_fd_sc_hd__dfstp_1
XFILLER_44_446 vssd1 vssd1 vccd1 vccd1 sky130_fd_sc_hd__fill_2
XTAP_TAPCELL_ROW_80_1403 vssd1 vccd1 sky130_fd_sc_hd__tapvpwrvgnd_1
X_10852_ net823 _00202_ net607 vssd1 vssd1 vccd1 vccd1 FPGA_INST.cell1.SB0.route_sel\[61\]
+ sky130_fd_sc_hd__dfstp_1
XTAP_TAPCELL_ROW_27_655 vssd1 vccd1 sky130_fd_sc_hd__tapvpwrvgnd_1
XTAP_TAPCELL_ROW_27_666 vssd1 vccd1 sky130_fd_sc_hd__tapvpwrvgnd_1
XANTENNA__07449__A1 _03542_ vssd1 vssd1 vccd1 vccd1 sky130_fd_sc_hd__diode_2
X_10783_ net919 _00133_ net703 vssd1 vssd1 vccd1 vccd1 FPGA_INST.cell2.CB_1.config_dataB\[17\]
+ sky130_fd_sc_hd__dfstp_2
XFILLER_12_365 vssd1 vssd1 vccd1 vccd1 sky130_fd_sc_hd__fill_8
X_11404_ net754 _00754_ net539 vssd1 vssd1 vccd1 vccd1 FPGA_INST.cell0.LEI0.config_data\[25\]
+ sky130_fd_sc_hd__dfrtp_1
XFILLER_126_757 vssd1 vssd1 vccd1 vccd1 sky130_fd_sc_hd__fill_1
XFILLER_125_223 vssd1 vssd1 vccd1 vccd1 sky130_fd_sc_hd__fill_1
X_11335_ net807 _00685_ net592 vssd1 vssd1 vccd1 vccd1 FPGA_INST.cell1.CB_1.config_dataA\[2\]
+ sky130_fd_sc_hd__dfstp_1
XTAP_TAPCELL_ROW_78_1376 vssd1 vccd1 sky130_fd_sc_hd__tapvpwrvgnd_1
X_11266_ net783 _00616_ net568 vssd1 vssd1 vccd1 vccd1 FPGA_INST.cell0.SB0.route_sel\[111\]
+ sky130_fd_sc_hd__dfstp_1
XFILLER_106_492 vssd1 vssd1 vccd1 vccd1 sky130_fd_sc_hd__fill_4
XTAP_TAPCELL_ROW_91_1554 vssd1 vccd1 sky130_fd_sc_hd__tapvpwrvgnd_1
X_10217_ FPGA_INST.cell3.SB0.route_sel\[121\] FPGA_INST.cell3.SB0.route_sel\[122\]
+ net274 vssd1 vssd1 vccd1 vccd1 _01098_ sky130_fd_sc_hd__mux2_1
XFILLER_79_365 vssd1 vssd1 vccd1 vccd1 sky130_fd_sc_hd__fill_2
XFILLER_67_516 vssd1 vssd1 vccd1 vccd1 sky130_fd_sc_hd__fill_1
X_11197_ net764 _00547_ net549 vssd1 vssd1 vccd1 vccd1 FPGA_INST.cell0.SB0.route_sel\[42\]
+ sky130_fd_sc_hd__dfstp_1
X_10148_ FPGA_INST.cell3.SB0.route_sel\[53\] FPGA_INST.cell3.SB0.route_sel\[52\] net365
+ vssd1 vssd1 vccd1 vccd1 _01029_ sky130_fd_sc_hd__mux2_1
XTAP_TAPCELL_ROW_7_380 vssd1 vccd1 sky130_fd_sc_hd__tapvpwrvgnd_1
XFILLER_48_752 vssd1 vssd1 vccd1 vccd1 sky130_fd_sc_hd__fill_2
X_10079_ FPGA_INST.cell0.LE_1B.config_data\[3\] FPGA_INST.cell0.LE_1B.config_data\[4\]
+ net173 vssd1 vssd1 vccd1 vccd1 _00960_ sky130_fd_sc_hd__mux2_1
XFILLER_75_582 vssd1 vssd1 vccd1 vccd1 sky130_fd_sc_hd__fill_2
XFILLER_35_402 vssd1 vssd1 vccd1 vccd1 sky130_fd_sc_hd__fill_8
XTAP_TAPCELL_ROW_46_931 vssd1 vccd1 sky130_fd_sc_hd__tapvpwrvgnd_1
XTAP_TAPCELL_ROW_46_920 vssd1 vccd1 sky130_fd_sc_hd__tapvpwrvgnd_1
XFILLER_35_446 vssd1 vssd1 vccd1 vccd1 sky130_fd_sc_hd__fill_2
XFILLER_94_3 vssd1 vssd1 vccd1 vccd1 sky130_fd_sc_hd__fill_4
X_07290_ net146 _03400_ _03548_ _03547_ vssd1 vssd1 vccd1 vccd1 _03551_ sky130_fd_sc_hd__a31o_1
XFILLER_43_490 vssd1 vssd1 vccd1 vccd1 sky130_fd_sc_hd__fill_4
X_06310_ net500 _02376_ vssd1 vssd1 vccd1 vccd1 _02590_ sky130_fd_sc_hd__nand2_1
XFILLER_31_630 vssd1 vssd1 vccd1 vccd1 sky130_fd_sc_hd__fill_2
XFILLER_31_641 vssd1 vssd1 vccd1 vccd1 sky130_fd_sc_hd__fill_4
X_06241_ net509 _02092_ vssd1 vssd1 vccd1 vccd1 _02521_ sky130_fd_sc_hd__nand2_1
XTAP_TAPCELL_ROW_100_1683 vssd1 vccd1 sky130_fd_sc_hd__tapvpwrvgnd_1
XFILLER_30_195 vssd1 vssd1 vccd1 vccd1 sky130_fd_sc_hd__fill_1
XFILLER_116_201 vssd1 vssd1 vccd1 vccd1 sky130_fd_sc_hd__fill_2
X_06172_ net120 _01920_ net158 _02333_ _01918_ vssd1 vssd1 vccd1 vccd1 _02452_ sky130_fd_sc_hd__o32a_1
X_09931_ FPGA_INST.cell0.LE_1A.config_data\[13\] FPGA_INST.cell0.LE_1A.config_data\[12\]
+ net311 vssd1 vssd1 vccd1 vccd1 _00836_ sky130_fd_sc_hd__mux2_1
Xfanout816 net819 vssd1 vssd1 vccd1 vccd1 net816 sky130_fd_sc_hd__clkbuf_2
Xfanout805 net811 vssd1 vssd1 vccd1 vccd1 net805 sky130_fd_sc_hd__buf_1
Xfanout838 net842 vssd1 vssd1 vccd1 vccd1 net838 sky130_fd_sc_hd__clkbuf_2
Xfanout827 net831 vssd1 vssd1 vccd1 vccd1 net827 sky130_fd_sc_hd__clkbuf_2
X_09862_ FPGA_INST.cell0.LEI0.config_data\[40\] FPGA_INST.cell0.LEI0.config_data\[41\]
+ net179 vssd1 vssd1 vccd1 vccd1 _00770_ sky130_fd_sc_hd__mux2_1
Xfanout849 net862 vssd1 vssd1 vccd1 vccd1 net849 sky130_fd_sc_hd__clkbuf_2
XFILLER_85_335 vssd1 vssd1 vccd1 vccd1 sky130_fd_sc_hd__fill_1
X_09793_ FPGA_INST.cell1.CB_1.config_dataA\[18\] FPGA_INST.cell1.CB_1.config_dataA\[19\]
+ net205 vssd1 vssd1 vccd1 vccd1 _00702_ sky130_fd_sc_hd__mux2_1
X_08813_ FPGA_INST.cell3.CB_0.config_dataB\[0\] _04018_ _04022_ _04803_ vssd1 vssd1
+ vccd1 vccd1 _05020_ sky130_fd_sc_hd__or4_1
XANTENNA__05926__A1 _02193_ vssd1 vssd1 vccd1 vccd1 sky130_fd_sc_hd__diode_2
X_08744_ FPGA_INST.cell3.LEI0.config_data\[36\] net79 vssd1 vssd1 vccd1 vccd1 _04953_
+ sky130_fd_sc_hd__nand2_1
XFILLER_85_346 vssd1 vssd1 vccd1 vccd1 sky130_fd_sc_hd__fill_4
X_05956_ FPGA_INST.cell2.SB0.route_sel\[51\] FPGA_INST.cell2.SB0.route_sel\[50\] vssd1
+ vssd1 vccd1 vccd1 _02236_ sky130_fd_sc_hd__nand2_1
X_08675_ _04867_ _04871_ _04874_ _04883_ vssd1 vssd1 vccd1 vccd1 _04884_ sky130_fd_sc_hd__a31o_1
X_05887_ _02164_ _02166_ vssd1 vssd1 vccd1 vccd1 _02167_ sky130_fd_sc_hd__nand2_1
X_07626_ _03561_ _03762_ net140 vssd1 vssd1 vccd1 vccd1 _03879_ sky130_fd_sc_hd__o21ai_1
XANTENNA__08340__A2 _03682_ vssd1 vssd1 vccd1 vccd1 sky130_fd_sc_hd__diode_2
XFILLER_54_766 vssd1 vssd1 vccd1 vccd1 sky130_fd_sc_hd__fill_8
XANTENNA__06351__A1 _02330_ vssd1 vssd1 vccd1 vccd1 sky130_fd_sc_hd__diode_2
X_07557_ FPGA_INST.cell3.SB0.route_sel\[77\] FPGA_INST.cell3.SB0.route_sel\[76\] vssd1
+ vssd1 vccd1 vccd1 _03812_ sky130_fd_sc_hd__nand2_1
XTAP_TAPCELL_ROW_24_614 vssd1 vccd1 sky130_fd_sc_hd__tapvpwrvgnd_1
XTAP_TAPCELL_ROW_24_625 vssd1 vccd1 sky130_fd_sc_hd__tapvpwrvgnd_1
XANTENNA_fanout241_X net241 vssd1 vssd1 vccd1 vccd1 sky130_fd_sc_hd__diode_2
XTAP_TAPCELL_ROW_62_1155 vssd1 vccd1 sky130_fd_sc_hd__tapvpwrvgnd_1
XTAP_TAPCELL_ROW_62_1144 vssd1 vccd1 sky130_fd_sc_hd__tapvpwrvgnd_1
X_06508_ net242 _02477_ _02483_ _02783_ vssd1 vssd1 vccd1 vccd1 _02784_ sky130_fd_sc_hd__nand4_4
X_07488_ FPGA_INST.cell3.SB0.route_sel\[64\] FPGA_INST.cell3.SB0.route_sel\[65\] vssd1
+ vssd1 vccd1 vccd1 _03744_ sky130_fd_sc_hd__and2_1
XFILLER_42_58 vssd1 vssd1 vccd1 vccd1 sky130_fd_sc_hd__fill_4
XANTENNA__10309__S net378 vssd1 vssd1 vccd1 vccd1 sky130_fd_sc_hd__diode_2
XANTENNA__06654__A2 _02772_ vssd1 vssd1 vccd1 vccd1 sky130_fd_sc_hd__diode_2
X_09227_ FPGA_INST.cell2.CB_1.config_dataB\[24\] FPGA_INST.cell2.CB_1.config_dataB\[23\]
+ net352 vssd1 vssd1 vccd1 vccd1 _00140_ sky130_fd_sc_hd__mux2_1
X_06439_ _02711_ _02713_ _02715_ _02716_ vssd1 vssd1 vccd1 vccd1 _02717_ sky130_fd_sc_hd__o22a_1
XTAP_TAPCELL_ROW_118_1933 vssd1 vccd1 sky130_fd_sc_hd__tapvpwrvgnd_1
XFILLER_107_212 vssd1 vssd1 vccd1 vccd1 sky130_fd_sc_hd__fill_8
X_09158_ FPGA_INST.cell2.LE_1A.dff1_out net524 _05211_ vssd1 vssd1 vccd1 vccd1 _00072_
+ sky130_fd_sc_hd__a21bo_1
X_08109_ net450 net451 vssd1 vssd1 vccd1 vccd1 _04335_ sky130_fd_sc_hd__nand2b_2
XFILLER_107_234 vssd1 vssd1 vccd1 vccd1 sky130_fd_sc_hd__fill_1
X_09089_ FPGA_INST.cell2.LEI0.config_data\[3\] FPGA_INST.cell2.LEI0.config_data\[4\]
+ net262 vssd1 vssd1 vccd1 vccd1 _00005_ sky130_fd_sc_hd__mux2_1
X_11120_ net794 _00470_ net579 vssd1 vssd1 vccd1 vccd1 FPGA_INST.cell1.LE_1A.config_data\[11\]
+ sky130_fd_sc_hd__dfrtp_1
XANTENNA__09356__A1 FPGA_INST.cell2.CB_0.config_data_inA vssd1 vssd1 vccd1 vccd1 sky130_fd_sc_hd__diode_2
X_11051_ net812 _00401_ net597 vssd1 vssd1 vccd1 vccd1 FPGA_INST.cell1.LEI0.config_data\[36\]
+ sky130_fd_sc_hd__dfrtp_1
XFILLER_49_505 vssd1 vssd1 vccd1 vccd1 sky130_fd_sc_hd__fill_1
XFILLER_49_527 vssd1 vssd1 vccd1 vccd1 sky130_fd_sc_hd__fill_1
X_10002_ FPGA_INST.cell0.CB_0.config_dataA\[2\] FPGA_INST.cell0.CB_0.config_dataA\[1\]
+ net310 vssd1 vssd1 vccd1 vccd1 _00883_ sky130_fd_sc_hd__mux2_1
XANTENNA__09108__A1 FPGA_INST.cell2.LEI0.config_data\[23\] vssd1 vssd1 vccd1 vccd1
+ sky130_fd_sc_hd__diode_2
XANTENNA__06590__A1 FPGA_INST.bus3_2\[1\] vssd1 vssd1 vccd1 vccd1 sky130_fd_sc_hd__diode_2
XANTENNA__09134__A net736 vssd1 vssd1 vccd1 vccd1 sky130_fd_sc_hd__diode_2
X_11953_ net914 _01299_ net698 vssd1 vssd1 vccd1 vccd1 FPGA_INST.cell3.CB_1.config_dataB\[18\]
+ sky130_fd_sc_hd__dfstp_1
XANTENNA_input14_A gpio_in[21] vssd1 vssd1 vccd1 vccd1 sky130_fd_sc_hd__diode_2
XFILLER_17_446 vssd1 vssd1 vccd1 vccd1 sky130_fd_sc_hd__fill_2
XFILLER_29_295 vssd1 vssd1 vccd1 vccd1 sky130_fd_sc_hd__fill_2
X_11884_ net929 _01230_ net713 vssd1 vssd1 vccd1 vccd1 FPGA_INST.cell3.LE_0A.config_data\[14\]
+ sky130_fd_sc_hd__dfrtp_1
X_10904_ net827 _00254_ net611 vssd1 vssd1 vccd1 vccd1 FPGA_INST.cell1.SB0.route_sel\[113\]
+ sky130_fd_sc_hd__dfstp_1
XFILLER_60_703 vssd1 vssd1 vccd1 vccd1 sky130_fd_sc_hd__fill_1
XFILLER_45_777 vssd1 vssd1 vccd1 vccd1 sky130_fd_sc_hd__fill_4
XFILLER_17_457 vssd1 vssd1 vccd1 vccd1 sky130_fd_sc_hd__fill_2
X_10835_ net800 _00185_ net585 vssd1 vssd1 vccd1 vccd1 FPGA_INST.cell1.SB0.route_sel\[44\]
+ sky130_fd_sc_hd__dfstp_1
XFILLER_72_585 vssd1 vssd1 vccd1 vccd1 sky130_fd_sc_hd__fill_2
XANTENNA__05696__A3 net165 vssd1 vssd1 vccd1 vccd1 sky130_fd_sc_hd__diode_2
XFILLER_32_438 vccd1 vssd1 vccd1 vssd1 sky130_ef_sc_hd__decap_40_12
XANTENNA__11129__RESET_B net733 vssd1 vssd1 vccd1 vccd1 sky130_fd_sc_hd__diode_2
X_10766_ net860 _00116_ net646 vssd1 vssd1 vccd1 vccd1 FPGA_INST.cell2.CB_1.config_dataB\[0\]
+ sky130_fd_sc_hd__dfstp_1
X_10697_ net880 _00047_ net665 vssd1 vssd1 vccd1 vccd1 FPGA_INST.cell2.LEI0.config_data\[46\]
+ sky130_fd_sc_hd__dfrtp_1
XANTENNA__07101__B _02070_ vssd1 vssd1 vccd1 vccd1 sky130_fd_sc_hd__diode_2
XANTENNA__07595__Y _03849_ vssd1 vssd1 vccd1 vccd1 sky130_fd_sc_hd__diode_2
X_11318_ net840 _00668_ net624 vssd1 vssd1 vccd1 vccd1 FPGA_INST.cell1.CB_0.config_dataB\[10\]
+ sky130_fd_sc_hd__dfstp_1
X_11249_ net767 _00599_ net552 vssd1 vssd1 vccd1 vccd1 FPGA_INST.cell0.SB0.route_sel\[94\]
+ sky130_fd_sc_hd__dfstp_1
XFILLER_95_633 vssd1 vssd1 vccd1 vccd1 sky130_fd_sc_hd__fill_2
XFILLER_79_173 vssd1 vssd1 vccd1 vccd1 sky130_fd_sc_hd__fill_1
XTAP_TAPCELL_ROW_2_309 vssd1 vccd1 sky130_fd_sc_hd__tapvpwrvgnd_1
X_05810_ FPGA_INST.cell2.SB0.route_sel\[90\] FPGA_INST.cell2.SB0.route_sel\[91\] vssd1
+ vssd1 vccd1 vccd1 _02090_ sky130_fd_sc_hd__nor2_1
X_06790_ _02801_ _03051_ _03052_ _02804_ _01598_ vssd1 vssd1 vccd1 vccd1 _03064_ sky130_fd_sc_hd__a221o_1
X_05741_ net112 _01825_ _02019_ vssd1 vssd1 vccd1 vccd1 _02021_ sky130_fd_sc_hd__nor3_1
XFILLER_48_582 vssd1 vssd1 vccd1 vccd1 sky130_fd_sc_hd__fill_4
XANTENNA__11108__SET_B net733 vssd1 vssd1 vccd1 vccd1 sky130_fd_sc_hd__diode_2
X_08460_ _04677_ _04676_ _04656_ vssd1 vssd1 vccd1 vccd1 _04678_ sky130_fd_sc_hd__mux2_1
X_05672_ _01950_ _01951_ FPGA_INST.cell2.SB0.route_sel\[96\] FPGA_INST.cell2.SB0.route_sel\[97\]
+ vssd1 vssd1 vccd1 vccd1 _01952_ sky130_fd_sc_hd__o211a_1
X_07411_ FPGA_INST.cell3.SB0.route_sel\[48\] FPGA_INST.cell3.SB0.route_sel\[49\] vssd1
+ vssd1 vccd1 vccd1 _03669_ sky130_fd_sc_hd__and2_1
XTAP_TAPCELL_ROW_102_1712 vssd1 vccd1 sky130_fd_sc_hd__tapvpwrvgnd_1
X_08391_ net438 _04611_ _04612_ vssd1 vssd1 vccd1 vccd1 _04613_ sky130_fd_sc_hd__a21oi_1
X_07342_ FPGA_INST.cell0.SB0.route_sel\[32\] FPGA_INST.cell0.SB0.route_sel\[33\] vssd1
+ vssd1 vccd1 vccd1 _03602_ sky130_fd_sc_hd__nand2b_1
XFILLER_23_449 vssd1 vssd1 vccd1 vccd1 sky130_fd_sc_hd__fill_2
X_07273_ net85 net20 _03531_ vssd1 vssd1 vccd1 vccd1 _03535_ sky130_fd_sc_hd__mux2_1
XFILLER_128_17 vssd1 vssd1 vccd1 vccd1 sky130_fd_sc_hd__fill_2
XANTENNA__08107__B _03519_ vssd1 vssd1 vccd1 vccd1 sky130_fd_sc_hd__diode_2
X_09012_ _03583_ _05181_ vssd1 vssd1 vccd1 vccd1 FPGA_INST.bus3_1\[3\] sky130_fd_sc_hd__nor2_2
X_06224_ net510 _02413_ vssd1 vssd1 vccd1 vccd1 _02504_ sky130_fd_sc_hd__or2_1
X_06155_ _01990_ _02356_ vssd1 vssd1 vccd1 vccd1 _02435_ sky130_fd_sc_hd__and2_1
XANTENNA_fanout201_A net202 vssd1 vssd1 vccd1 vccd1 sky130_fd_sc_hd__diode_2
XANTENNA__06939__A3 FPGA_INST.bus2_0\[11\] vssd1 vssd1 vccd1 vccd1 sky130_fd_sc_hd__diode_2
XFILLER_104_226 vssd1 vssd1 vccd1 vccd1 sky130_fd_sc_hd__fill_8
X_06086_ net485 net486 vssd1 vssd1 vccd1 vccd1 _02366_ sky130_fd_sc_hd__nor2_1
Xfanout602 net604 vssd1 vssd1 vccd1 vccd1 net602 sky130_fd_sc_hd__buf_2
Xfanout624 net626 vssd1 vssd1 vccd1 vccd1 net624 sky130_fd_sc_hd__clkbuf_4
XTAP_TAPCELL_ROW_113_1863 vssd1 vccd1 sky130_fd_sc_hd__tapvpwrvgnd_1
Xfanout613 net615 vssd1 vssd1 vccd1 vccd1 net613 sky130_fd_sc_hd__clkbuf_4
X_09914_ FPGA_INST.cell0.LE_0B.reset_val FPGA_INST.cell0.LE_0B.reset_mode net173 vssd1
+ vssd1 vccd1 vccd1 _00820_ sky130_fd_sc_hd__mux2_1
Xfanout646 net647 vssd1 vssd1 vccd1 vccd1 net646 sky130_fd_sc_hd__clkbuf_2
XANTENNA_input6_A gpio_in[14] vssd1 vssd1 vccd1 vccd1 sky130_fd_sc_hd__diode_2
Xfanout657 net662 vssd1 vssd1 vccd1 vccd1 net657 sky130_fd_sc_hd__buf_2
Xfanout635 net636 vssd1 vssd1 vccd1 vccd1 net635 sky130_fd_sc_hd__clkbuf_4
X_09845_ FPGA_INST.cell0.LEI0.config_data\[24\] FPGA_INST.cell0.LEI0.config_data\[23\]
+ net308 vssd1 vssd1 vccd1 vccd1 _00753_ sky130_fd_sc_hd__mux2_1
XFILLER_100_421 vssd1 vssd1 vccd1 vccd1 sky130_fd_sc_hd__fill_2
XFILLER_86_666 vssd1 vssd1 vccd1 vccd1 sky130_fd_sc_hd__fill_2
Xfanout679 net683 vssd1 vssd1 vccd1 vccd1 net679 sky130_fd_sc_hd__clkbuf_4
XANTENNA_fanout668_A net675 vssd1 vssd1 vccd1 vccd1 sky130_fd_sc_hd__diode_2
Xfanout668 net675 vssd1 vssd1 vccd1 vccd1 net668 sky130_fd_sc_hd__clkbuf_2
X_09776_ FPGA_INST.cell1.CB_1.config_dataA\[2\] FPGA_INST.cell1.CB_1.config_dataA\[1\]
+ net333 vssd1 vssd1 vccd1 vccd1 _00685_ sky130_fd_sc_hd__mux2_1
X_06988_ _03249_ _03250_ _03252_ _03253_ vssd1 vssd1 vccd1 vccd1 _03254_ sky130_fd_sc_hd__o2bb2a_1
X_08727_ net393 _04934_ _04935_ vssd1 vssd1 vccd1 vccd1 _04936_ sky130_fd_sc_hd__a21o_1
XANTENNA__06297__B _02092_ vssd1 vssd1 vccd1 vccd1 sky130_fd_sc_hd__diode_2
X_05939_ net122 net385 net160 _02174_ _01815_ vssd1 vssd1 vccd1 vccd1 _02219_ sky130_fd_sc_hd__o32a_1
X_08658_ net398 _04861_ _04862_ _04866_ vssd1 vssd1 vccd1 vccd1 _04867_ sky130_fd_sc_hd__a31o_1
XFILLER_27_766 vssd1 vssd1 vccd1 vccd1 sky130_fd_sc_hd__fill_1
XANTENNA__12088__Q FPGA_INST.cell3.CB_0.config_dataA\[0\] vssd1 vssd1 vccd1 vccd1
+ sky130_fd_sc_hd__diode_2
X_07609_ net94 _03862_ vssd1 vssd1 vccd1 vccd1 _03863_ sky130_fd_sc_hd__nand2_1
XFILLER_41_213 vssd1 vssd1 vccd1 vccd1 sky130_fd_sc_hd__fill_1
XTAP_TAPCELL_ROW_37_794 vssd1 vccd1 sky130_fd_sc_hd__tapvpwrvgnd_1
X_08589_ FPGA_INST.cell3.CB_0.config_dataA\[2\] _04786_ _04791_ _04797_ vssd1 vssd1
+ vccd1 vccd1 _04798_ sky130_fd_sc_hd__or4_1
X_10620_ FPGA_INST.cell3.CB_1.config_dataA\[14\] FPGA_INST.cell3.CB_1.config_dataA\[15\]
+ net298 vssd1 vssd1 vccd1 vccd1 _01499_ sky130_fd_sc_hd__mux2_1
XANTENNA__08077__B2 _03475_ vssd1 vssd1 vccd1 vccd1 sky130_fd_sc_hd__diode_2
XANTENNA__08077__A1 _03421_ vssd1 vssd1 vccd1 vccd1 sky130_fd_sc_hd__diode_2
X_10551_ FPGA_INST.cell2.SB0.route_sel\[124\] FPGA_INST.cell2.SB0.route_sel\[123\]
+ net354 vssd1 vssd1 vccd1 vccd1 _01430_ sky130_fd_sc_hd__mux2_1
XFILLER_127_318 vssd1 vssd1 vccd1 vccd1 sky130_fd_sc_hd__fill_8
XANTENNA__09828__S net184 vssd1 vssd1 vccd1 vccd1 sky130_fd_sc_hd__diode_2
X_10482_ FPGA_INST.cell2.SB0.route_sel\[54\] FPGA_INST.cell2.SB0.route_sel\[55\] net194
+ vssd1 vssd1 vccd1 vccd1 _01361_ sky130_fd_sc_hd__mux2_1
XFILLER_10_699 vssd1 vssd1 vccd1 vccd1 sky130_fd_sc_hd__fill_1
XTAP_TAPCELL_ROW_75_1335 vssd1 vccd1 sky130_fd_sc_hd__tapvpwrvgnd_1
X_12152_ net934 _01498_ net718 vssd1 vssd1 vccd1 vccd1 FPGA_INST.cell3.CB_1.config_dataA\[14\]
+ sky130_fd_sc_hd__dfstp_1
XFILLER_123_535 vssd1 vssd1 vccd1 vccd1 sky130_fd_sc_hd__fill_2
XFILLER_118_83 vssd1 vssd1 vccd1 vccd1 sky130_fd_sc_hd__fill_1
X_11103_ net840 _00453_ net624 vssd1 vssd1 vccd1 vccd1 FPGA_INST.cell1.LE_0B.config_data\[16\]
+ sky130_fd_sc_hd__dfrtp_1
X_12083_ net859 _01429_ net645 vssd1 vssd1 vccd1 vccd1 FPGA_INST.cell2.SB0.route_sel\[123\]
+ sky130_fd_sc_hd__dfstp_1
X_11034_ net813 _00384_ net598 vssd1 vssd1 vccd1 vccd1 FPGA_INST.cell1.LEI0.config_data\[19\]
+ sky130_fd_sc_hd__dfrtp_1
XFILLER_77_633 vccd1 vssd1 vccd1 vssd1 sky130_ef_sc_hd__decap_40_12
XFILLER_77_666 vssd1 vssd1 vccd1 vccd1 sky130_fd_sc_hd__fill_4
XFILLER_77_655 vssd1 vssd1 vccd1 vccd1 sky130_fd_sc_hd__fill_2
XFILLER_76_132 vssd1 vssd1 vccd1 vccd1 sky130_fd_sc_hd__fill_1
XFILLER_49_357 vccd1 vssd1 vccd1 vssd1 sky130_ef_sc_hd__decap_40_12
XFILLER_49_335 vssd1 vssd1 vccd1 vccd1 sky130_fd_sc_hd__fill_1
XFILLER_92_603 vssd1 vssd1 vccd1 vccd1 sky130_fd_sc_hd__fill_1
XFILLER_76_176 vssd1 vssd1 vccd1 vccd1 sky130_fd_sc_hd__fill_8
XFILLER_91_113 vssd1 vssd1 vccd1 vccd1 sky130_fd_sc_hd__fill_1
XANTENNA_input17_X net17 vssd1 vssd1 vccd1 vccd1 sky130_fd_sc_hd__diode_2
X_11936_ net914 _01282_ net698 vssd1 vssd1 vccd1 vccd1 FPGA_INST.cell3.CB_1.config_dataB\[1\]
+ sky130_fd_sc_hd__dfstp_1
XFILLER_18_766 vssd1 vssd1 vccd1 vccd1 sky130_fd_sc_hd__fill_2
XTAP_TAPCELL_ROW_86_1486 vssd1 vccd1 sky130_fd_sc_hd__tapvpwrvgnd_1
X_11867_ net914 _01213_ net698 vssd1 vssd1 vccd1 vccd1 FPGA_INST.cell3.CB_0.config_data_inA
+ sky130_fd_sc_hd__dfrtp_1
XFILLER_60_533 vssd1 vssd1 vccd1 vccd1 sky130_fd_sc_hd__fill_2
XFILLER_17_298 vssd1 vssd1 vccd1 vccd1 sky130_fd_sc_hd__fill_1
X_10818_ net823 _00168_ net607 vssd1 vssd1 vccd1 vccd1 FPGA_INST.cell1.SB0.route_sel\[27\]
+ sky130_fd_sc_hd__dfstp_1
XFILLER_20_408 vssd1 vssd1 vccd1 vccd1 sky130_fd_sc_hd__fill_1
X_11798_ net876 _01144_ net660 vssd1 vssd1 vccd1 vccd1 FPGA_INST.io_east_oeb\[16\]
+ sky130_fd_sc_hd__dfrtp_1
XANTENNA__07276__C1 net364 vssd1 vssd1 vccd1 vccd1 sky130_fd_sc_hd__diode_2
XTAP_TAPCELL_ROW_15_488 vssd1 vccd1 sky130_fd_sc_hd__tapvpwrvgnd_1
XTAP_TAPCELL_ROW_15_499 vssd1 vccd1 sky130_fd_sc_hd__tapvpwrvgnd_1
X_10749_ net885 _00099_ net669 vssd1 vssd1 vccd1 vccd1 FPGA_INST.cell2.LE_1A.config_data\[4\]
+ sky130_fd_sc_hd__dfrtp_1
XFILLER_118_307 vssd1 vssd1 vccd1 vccd1 sky130_fd_sc_hd__fill_1
XANTENNA__09738__S net230 vssd1 vssd1 vccd1 vccd1 sky130_fd_sc_hd__diode_2
XFILLER_126_362 vssd1 vssd1 vccd1 vccd1 sky130_fd_sc_hd__fill_2
XFILLER_57_3 vssd1 vssd1 vccd1 vccd1 sky130_fd_sc_hd__fill_8
XANTENNA__08791__A2 net83 vssd1 vssd1 vccd1 vccd1 sky130_fd_sc_hd__diode_2
X_07960_ net463 net462 vssd1 vssd1 vccd1 vccd1 _04188_ sky130_fd_sc_hd__nor2_1
X_06911_ net418 _02191_ vssd1 vssd1 vccd1 vccd1 _03179_ sky130_fd_sc_hd__nand2_1
X_07891_ _04118_ vssd1 vssd1 vccd1 vccd1 _04119_ sky130_fd_sc_hd__inv_2
XTAP_TAPCELL_ROW_128_2070 vssd1 vccd1 sky130_fd_sc_hd__tapvpwrvgnd_1
XFILLER_110_763 vssd1 vssd1 vccd1 vccd1 sky130_fd_sc_hd__fill_1
XFILLER_68_677 vssd1 vssd1 vccd1 vccd1 sky130_fd_sc_hd__fill_2
X_09630_ FPGA_INST.cell0.SB0.route_sel\[33\] FPGA_INST.cell0.SB0.route_sel\[34\] net196
+ vssd1 vssd1 vccd1 vccd1 _00539_ sky130_fd_sc_hd__mux2_1
X_06842_ net421 _01888_ vssd1 vssd1 vccd1 vccd1 _03110_ sky130_fd_sc_hd__nand2_1
XTAP_TAPCELL_ROW_128_2081 vssd1 vccd1 sky130_fd_sc_hd__tapvpwrvgnd_1
X_09561_ FPGA_INST.cell1.LE_1A.config_data\[11\] FPGA_INST.cell1.LE_1A.config_data\[10\]
+ net326 vssd1 vssd1 vccd1 vccd1 _00470_ sky130_fd_sc_hd__mux2_1
X_06773_ FPGA_INST.cell2.LE_1B.config_data\[5\] FPGA_INST.cell2.LE_1B.config_data\[4\]
+ _02992_ vssd1 vssd1 vccd1 vccd1 _03047_ sky130_fd_sc_hd__mux2_1
XFILLER_36_530 vssd1 vssd1 vccd1 vccd1 sky130_fd_sc_hd__fill_2
X_08512_ FPGA_INST.cell3.LEI0.config_data\[8\] _04723_ _04724_ FPGA_INST.cell3.CB_1.config_dataA\[4\]
+ vssd1 vssd1 vccd1 vccd1 _04725_ sky130_fd_sc_hd__o211ai_4
X_05724_ _02003_ net137 _02002_ vssd1 vssd1 vccd1 vccd1 _02004_ sky130_fd_sc_hd__mux2_1
XANTENNA__09502__A net736 vssd1 vssd1 vccd1 vccd1 sky130_fd_sc_hd__diode_2
X_09492_ FPGA_INST.cell1.LEI0.config_data\[38\] FPGA_INST.cell1.LEI0.config_data\[39\]
+ net215 vssd1 vssd1 vccd1 vccd1 _00404_ sky130_fd_sc_hd__mux2_1
XFILLER_36_585 vssd1 vssd1 vccd1 vccd1 sky130_fd_sc_hd__fill_1
XANTENNA_fanout151_A net152 vssd1 vssd1 vccd1 vccd1 sky130_fd_sc_hd__diode_2
X_08443_ FPGA_INST.cell1.LE_1A.config_data\[0\] FPGA_INST.cell1.LE_1A.config_data\[1\]
+ _04660_ vssd1 vssd1 vccd1 vccd1 _04661_ sky130_fd_sc_hd__mux2_1
XFILLER_63_393 vssd1 vssd1 vccd1 vccd1 sky130_fd_sc_hd__fill_1
XANTENNA_fanout249_A net268 vssd1 vssd1 vccd1 vccd1 sky130_fd_sc_hd__diode_2
X_05655_ FPGA_INST.cell0.SB0.route_sel\[102\] _01631_ FPGA_INST.cell0.SB0.route_sel\[98\]
+ FPGA_INST.cell0.SB0.route_sel\[99\] _01934_ vssd1 vssd1 vccd1 vccd1 _01935_ sky130_fd_sc_hd__o221a_1
XANTENNA__06857__A2 _02030_ vssd1 vssd1 vccd1 vccd1 sky130_fd_sc_hd__diode_2
XTAP_TAPCELL_ROW_34_753 vssd1 vccd1 sky130_fd_sc_hd__tapvpwrvgnd_1
XANTENNA__08059__A1 FPGA_INST.bus3_1\[13\] vssd1 vssd1 vccd1 vccd1 sky130_fd_sc_hd__diode_2
X_08374_ net443 _03682_ _04595_ FPGA_INST.cell0.CB_1.config_dataB\[11\] vssd1 vssd1
+ vccd1 vccd1 _04596_ sky130_fd_sc_hd__o211a_1
X_05586_ net239 _01855_ _01865_ vssd1 vssd1 vccd1 vccd1 _01866_ sky130_fd_sc_hd__and3_1
XTAP_TAPCELL_ROW_34_764 vssd1 vccd1 sky130_fd_sc_hd__tapvpwrvgnd_1
X_07325_ _03583_ _03585_ vssd1 vssd1 vccd1 vccd1 FPGA_INST.bus3_2\[3\] sky130_fd_sc_hd__nor2_4
X_07256_ FPGA_INST.cell1.SB0.route_sel\[18\] FPGA_INST.cell1.SB0.route_sel\[19\] _01707_
+ FPGA_INST.cell1.SB0.route_sel\[21\] _03517_ vssd1 vssd1 vccd1 vccd1 _03518_ sky130_fd_sc_hd__o221a_1
X_06207_ _02486_ _02484_ vssd1 vssd1 vccd1 vccd1 _02487_ sky130_fd_sc_hd__and2b_4
XFILLER_105_502 vssd1 vssd1 vccd1 vccd1 sky130_fd_sc_hd__fill_2
X_07187_ net81 _03429_ _03447_ _03448_ _03449_ vssd1 vssd1 vccd1 vccd1 _03450_ sky130_fd_sc_hd__o311a_1
XFILLER_117_384 vssd1 vssd1 vccd1 vccd1 sky130_fd_sc_hd__fill_2
X_06138_ _01972_ _02337_ FPGA_INST.bus1_0\[1\] vssd1 vssd1 vccd1 vccd1 _02418_ sky130_fd_sc_hd__o21ai_1
XTAP_TAPCELL_ROW_57_1087 vssd1 vccd1 sky130_fd_sc_hd__tapvpwrvgnd_1
XTAP_TAPCELL_ROW_57_1076 vssd1 vccd1 sky130_fd_sc_hd__tapvpwrvgnd_1
X_06069_ FPGA_INST.cell0.SB0.route_sel\[30\] _01701_ FPGA_INST.cell0.SB0.route_sel\[27\]
+ FPGA_INST.cell0.SB0.route_sel\[26\] _02348_ vssd1 vssd1 vccd1 vccd1 _02349_ sky130_fd_sc_hd__o221a_1
XFILLER_2_139 vssd1 vssd1 vccd1 vccd1 sky130_fd_sc_hd__fill_1
XFILLER_78_419 vssd1 vssd1 vccd1 vccd1 sky130_fd_sc_hd__fill_1
XANTENNA__06793__A1 FPGA_INST.bus3_2\[1\] vssd1 vssd1 vccd1 vccd1 sky130_fd_sc_hd__diode_2
Xfanout410 FPGA_INST.cell0.CB_1.config_dataA\[5\] vssd1 vssd1 vccd1 vccd1 net410 sky130_fd_sc_hd__clkbuf_2
Xfanout421 FPGA_INST.cell0.CB_0.config_dataB\[5\] vssd1 vssd1 vccd1 vccd1 net421 sky130_fd_sc_hd__buf_2
Xfanout432 FPGA_INST.cell0.CB_0.config_dataA\[6\] vssd1 vssd1 vccd1 vccd1 net432 sky130_fd_sc_hd__buf_2
XFILLER_113_590 vssd1 vssd1 vccd1 vccd1 sky130_fd_sc_hd__fill_1
Xfanout454 FPGA_INST.cell1.CB_0.config_dataB\[10\] vssd1 vssd1 vccd1 vccd1 net454
+ sky130_fd_sc_hd__buf_2
Xfanout465 FPGA_INST.cell1.CB_0.config_dataA\[11\] vssd1 vssd1 vccd1 vccd1 net465
+ sky130_fd_sc_hd__clkbuf_2
XTAP_TAPCELL_ROW_70_1265 vssd1 vccd1 sky130_fd_sc_hd__tapvpwrvgnd_1
Xfanout443 FPGA_INST.cell0.CB_1.config_dataB\[10\] vssd1 vssd1 vccd1 vccd1 net443
+ sky130_fd_sc_hd__clkbuf_2
XPHY_EDGE_ROW_122_Right_122 vssd1 vssd1 vccd1 vccd1 sky130_fd_sc_hd__decap_3
XFILLER_58_154 vssd1 vssd1 vccd1 vccd1 sky130_fd_sc_hd__fill_1
XANTENNA__08300__B _03875_ vssd1 vssd1 vccd1 vccd1 sky130_fd_sc_hd__diode_2
Xfanout476 FPGA_INST.cell2.CB_1.config_dataA\[15\] vssd1 vssd1 vccd1 vccd1 net476
+ sky130_fd_sc_hd__clkbuf_2
X_09828_ FPGA_INST.cell0.LEI0.config_data\[6\] FPGA_INST.cell0.LEI0.config_data\[7\]
+ net184 vssd1 vssd1 vccd1 vccd1 _00736_ sky130_fd_sc_hd__mux2_1
Xfanout498 FPGA_INST.cell2.CB_0.config_dataB\[0\] vssd1 vssd1 vccd1 vccd1 net498 sky130_fd_sc_hd__buf_1
Xfanout487 FPGA_INST.cell2.CB_0.config_dataB\[16\] vssd1 vssd1 vccd1 vccd1 net487
+ sky130_fd_sc_hd__buf_2
X_09759_ FPGA_INST.cell1.CB_0.config_dataB\[9\] net455 net231 vssd1 vssd1 vccd1 vccd1
+ _00668_ sky130_fd_sc_hd__mux2_1
XFILLER_104_85 vssd1 vssd1 vccd1 vccd1 sky130_fd_sc_hd__fill_4
XANTENNA__08298__A1 FPGA_INST.bus1_0\[13\] vssd1 vssd1 vccd1 vccd1 sky130_fd_sc_hd__diode_2
XFILLER_15_714 vssd1 vssd1 vccd1 vccd1 sky130_fd_sc_hd__fill_2
XFILLER_27_596 vssd1 vssd1 vccd1 vccd1 sky130_fd_sc_hd__fill_2
XFILLER_81_190 vssd1 vssd1 vccd1 vccd1 sky130_fd_sc_hd__fill_8
X_11721_ net902 _01067_ net686 vssd1 vssd1 vccd1 vccd1 FPGA_INST.cell3.SB0.route_sel\[91\]
+ sky130_fd_sc_hd__dfstp_1
XFILLER_80_33 vssd1 vssd1 vccd1 vccd1 sky130_fd_sc_hd__fill_1
X_11652_ net856 _00998_ net640 vssd1 vssd1 vccd1 vccd1 FPGA_INST.cell3.SB0.route_sel\[22\]
+ sky130_fd_sc_hd__dfstp_1
Xfanout83 _01791_ vssd1 vssd1 vccd1 vccd1 net83 sky130_fd_sc_hd__buf_2
X_10603_ FPGA_INST.cell3.CB_0.config_dataB\[23\] FPGA_INST.cell3.CB_0.config_dataB\[22\]
+ net371 vssd1 vssd1 vccd1 vccd1 _01482_ sky130_fd_sc_hd__mux2_1
Xfanout94 FPGA_INST.cell3.CB_0.le_outA vssd1 vssd1 vccd1 vccd1 net94 sky130_fd_sc_hd__buf_2
X_11583_ net760 _00933_ net545 vssd1 vssd1 vccd1 vccd1 FPGA_INST.cell0.CB_1.config_dataA\[2\]
+ sky130_fd_sc_hd__dfstp_2
XFILLER_10_452 vssd1 vssd1 vccd1 vccd1 sky130_fd_sc_hd__fill_1
XTAP_TAPCELL_ROW_12_447 vssd1 vccd1 sky130_fd_sc_hd__tapvpwrvgnd_1
X_10534_ FPGA_INST.cell2.SB0.route_sel\[106\] FPGA_INST.cell2.SB0.route_sel\[107\]
+ net245 vssd1 vssd1 vccd1 vccd1 _01413_ sky130_fd_sc_hd__mux2_1
XFILLER_10_474 vssd1 vssd1 vccd1 vccd1 sky130_fd_sc_hd__fill_2
X_10465_ FPGA_INST.cell2.SB0.route_sel\[37\] FPGA_INST.cell2.SB0.route_sel\[38\] net243
+ vssd1 vssd1 vccd1 vccd1 _01344_ sky130_fd_sc_hd__mux2_1
XFILLER_123_310 vccd1 vssd1 vccd1 vssd1 sky130_ef_sc_hd__decap_40_12
X_10396_ FPGA_INST.cell3.LE_1A.config_data\[15\] FPGA_INST.cell3.LE_1A.config_data\[14\]
+ net376 vssd1 vssd1 vccd1 vccd1 _01275_ sky130_fd_sc_hd__mux2_1
XFILLER_89_53 vssd1 vssd1 vccd1 vccd1 sky130_fd_sc_hd__fill_2
XANTENNA__07025__A2 FPGA_INST.bus2_0\[10\] vssd1 vssd1 vccd1 vccd1 sky130_fd_sc_hd__diode_2
X_12135_ net912 _01481_ net696 vssd1 vssd1 vccd1 vccd1 FPGA_INST.cell3.CB_0.config_dataB\[22\]
+ sky130_fd_sc_hd__dfstp_2
XANTENNA__06233__A0 net3 vssd1 vssd1 vccd1 vccd1 sky130_fd_sc_hd__diode_2
XFILLER_111_505 vccd1 vssd1 vccd1 vssd1 sky130_ef_sc_hd__decap_40_12
XFILLER_96_249 vssd1 vssd1 vccd1 vccd1 sky130_fd_sc_hd__fill_1
XFILLER_89_290 vssd1 vssd1 vccd1 vccd1 sky130_fd_sc_hd__fill_4
X_12066_ net856 _01412_ net641 vssd1 vssd1 vccd1 vccd1 FPGA_INST.cell2.SB0.route_sel\[106\]
+ sky130_fd_sc_hd__dfstp_1
X_11017_ net812 _00367_ net597 vssd1 vssd1 vccd1 vccd1 FPGA_INST.cell1.LEI0.config_data\[2\]
+ sky130_fd_sc_hd__dfrtp_1
XANTENNA__08985__X FPGA_INST.bus3_1\[6\] vssd1 vssd1 vccd1 vccd1 sky130_fd_sc_hd__diode_2
XTAP_TAPCELL_ROW_88_1515 vssd1 vccd1 sky130_fd_sc_hd__tapvpwrvgnd_1
X_11919_ net941 _01265_ net725 vssd1 vssd1 vccd1 vccd1 FPGA_INST.cell3.LE_1A.config_data\[5\]
+ sky130_fd_sc_hd__dfrtp_1
XFILLER_33_544 vssd1 vssd1 vccd1 vccd1 sky130_fd_sc_hd__fill_1
X_05440_ FPGA_INST.cell1.SB0.route_sel\[4\] vssd1 vssd1 vccd1 vccd1 _01722_ sky130_fd_sc_hd__inv_2
XFILLER_21_706 vssd1 vssd1 vccd1 vccd1 sky130_fd_sc_hd__fill_2
X_05371_ FPGA_INST.cell0.SB0.route_sel\[79\] vssd1 vssd1 vccd1 vccd1 _01653_ sky130_fd_sc_hd__inv_2
XTAP_TAPCELL_ROW_31_712 vssd1 vccd1 sky130_fd_sc_hd__tapvpwrvgnd_1
XTAP_TAPCELL_ROW_31_723 vssd1 vccd1 sky130_fd_sc_hd__tapvpwrvgnd_1
XANTENNA__08880__B _04785_ vssd1 vssd1 vccd1 vccd1 sky130_fd_sc_hd__diode_2
X_07110_ _03374_ _03375_ _01738_ vssd1 vssd1 vccd1 vccd1 _03376_ sky130_fd_sc_hd__mux2_1
X_08090_ FPGA_INST.cell1.CB_0.config_dataB\[12\] _04313_ _04315_ vssd1 vssd1 vccd1
+ vccd1 _04316_ sky130_fd_sc_hd__or3_1
XTAP_TAPCELL_ROW_99_1666 vssd1 vccd1 sky130_fd_sc_hd__tapvpwrvgnd_1
X_07041_ FPGA_INST.bus2_0\[1\] _03282_ _03305_ net435 _03306_ vssd1 vssd1 vccd1 vccd1
+ _03307_ sky130_fd_sc_hd__a221o_1
XFILLER_127_682 vssd1 vssd1 vccd1 vccd1 sky130_fd_sc_hd__fill_1
XANTENNA__08104__C _04329_ vssd1 vssd1 vccd1 vccd1 sky130_fd_sc_hd__diode_2
XFILLER_125_18 vccd1 vssd1 vccd1 vssd1 sky130_ef_sc_hd__decap_40_12
XTAP_TAPCELL_ROW_110_1822 vssd1 vccd1 sky130_fd_sc_hd__tapvpwrvgnd_1
X_08992_ FPGA_INST.cell3.SB0.route_sel\[46\] FPGA_INST.cell3.SB0.route_sel\[47\] vssd1
+ vssd1 vccd1 vccd1 _05168_ sky130_fd_sc_hd__nor2_1
X_07943_ _04169_ _04170_ FPGA_INST.cell1.CB_0.config_dataA\[12\] vssd1 vssd1 vccd1
+ vccd1 _04171_ sky130_fd_sc_hd__mux2_1
X_07874_ FPGA_INST.cell1.CB_0.config_dataA\[7\] _04101_ vssd1 vssd1 vccd1 vccd1 _04102_
+ sky130_fd_sc_hd__nand2_1
XFILLER_28_305 vssd1 vssd1 vccd1 vccd1 sky130_fd_sc_hd__fill_1
XFILLER_68_485 vccd1 vssd1 vccd1 vssd1 sky130_ef_sc_hd__decap_40_12
XFILLER_55_124 vssd1 vssd1 vccd1 vccd1 sky130_fd_sc_hd__fill_1
X_09613_ FPGA_INST.cell0.SB0.route_sel\[16\] FPGA_INST.cell0.SB0.route_sel\[17\] net199
+ vssd1 vssd1 vccd1 vccd1 _00522_ sky130_fd_sc_hd__mux2_1
X_06825_ net422 _02191_ _03092_ vssd1 vssd1 vccd1 vccd1 _03093_ sky130_fd_sc_hd__a21o_1
XFILLER_18_27 vssd1 vssd1 vccd1 vccd1 sky130_fd_sc_hd__fill_1
XTAP_TAPCELL_ROW_39_823 vssd1 vccd1 sky130_fd_sc_hd__tapvpwrvgnd_1
XTAP_TAPCELL_ROW_39_834 vssd1 vccd1 sky130_fd_sc_hd__tapvpwrvgnd_1
XANTENNA_fanout366_A net367 vssd1 vssd1 vccd1 vccd1 sky130_fd_sc_hd__diode_2
X_09544_ FPGA_INST.cell1.LE_0B.config_data\[16\] FPGA_INST.cell1.LE_0B.edge_mode net231
+ vssd1 vssd1 vccd1 vccd1 _00454_ sky130_fd_sc_hd__mux2_1
X_06756_ _03027_ _03028_ _03029_ FPGA_INST.cell2.CB_1.config_dataB\[12\] FPGA_INST.cell2.CB_1.config_dataB\[13\]
+ vssd1 vssd1 vccd1 vccd1 _03030_ sky130_fd_sc_hd__o221a_1
XANTENNA_fanout154_X net154 vssd1 vssd1 vccd1 vccd1 sky130_fd_sc_hd__diode_2
X_09475_ FPGA_INST.cell1.LEI0.config_data\[21\] FPGA_INST.cell1.LEI0.config_data\[22\]
+ net218 vssd1 vssd1 vccd1 vccd1 _00387_ sky130_fd_sc_hd__mux2_1
XTAP_TAPCELL_ROW_108_1795 vssd1 vccd1 sky130_fd_sc_hd__tapvpwrvgnd_1
X_06687_ net520 _02832_ vssd1 vssd1 vccd1 vccd1 _02961_ sky130_fd_sc_hd__nand2_1
X_05707_ FPGA_INST.cell2.SB0.route_sel\[106\] FPGA_INST.cell2.SB0.route_sel\[107\]
+ vssd1 vssd1 vccd1 vccd1 _01987_ sky130_fd_sc_hd__nand2_1
XFILLER_34_26 vssd1 vssd1 vccd1 vccd1 sky130_fd_sc_hd__fill_2
X_08426_ FPGA_INST.cell0.LE_1B.dff0_out FPGA_INST.cell0.LE_1B.dff1_out FPGA_INST.cell0.LE_1B.reset_val
+ vssd1 vssd1 vccd1 vccd1 FPGA_INST.cell0.LE_1B.dff_out sky130_fd_sc_hd__mux2_1
X_05638_ FPGA_INST.cell0.CB_0.config_dataA\[24\] FPGA_INST.cell0.CB_0.config_dataA\[21\]
+ FPGA_INST.cell0.CB_0.config_dataA\[20\] vssd1 vssd1 vccd1 vccd1 _01918_ sky130_fd_sc_hd__or3_4
XTAP_TAPCELL_ROW_121_1973 vssd1 vccd1 sky130_fd_sc_hd__tapvpwrvgnd_1
XANTENNA__06160__C1 _02439_ vssd1 vssd1 vccd1 vccd1 sky130_fd_sc_hd__diode_2
XANTENNA_fanout700_A net701 vssd1 vssd1 vccd1 vccd1 sky130_fd_sc_hd__diode_2
X_05569_ FPGA_INST.cell2.CB_1.config_dataA\[24\] FPGA_INST.cell2.CB_1.config_dataA\[20\]
+ FPGA_INST.cell2.CB_1.config_dataA\[21\] vssd1 vssd1 vccd1 vccd1 _01849_ sky130_fd_sc_hd__or3b_4
X_08357_ FPGA_INST.bus1_0\[8\] FPGA_INST.bus1_0\[10\] FPGA_INST.bus1_0\[9\] FPGA_INST.bus1_0\[11\]
+ net441 net442 vssd1 vssd1 vccd1 vccd1 _04579_ sky130_fd_sc_hd__mux4_1
XFILLER_126_6 vccd1 vssd1 vccd1 vssd1 sky130_ef_sc_hd__decap_40_12
X_07308_ _03550_ _03568_ _03551_ vssd1 vssd1 vccd1 vccd1 _03569_ sky130_fd_sc_hd__a21oi_1
XTAP_TAPCELL_ROW_59_1105 vssd1 vccd1 sky130_fd_sc_hd__tapvpwrvgnd_1
XFILLER_20_772 vssd1 vssd1 vccd1 vccd1 sky130_fd_sc_hd__fill_1
X_08288_ _04508_ _04511_ _04470_ vssd1 vssd1 vccd1 vccd1 _04512_ sky130_fd_sc_hd__mux2_1
X_07239_ FPGA_INST.cell0.SB0.route_sel\[20\] FPGA_INST.cell0.SB0.route_sel\[21\] vssd1
+ vssd1 vccd1 vccd1 _03501_ sky130_fd_sc_hd__or2_1
X_10250_ FPGA_INST.io_south_oeb\[20\] FPGA_INST.io_south_oeb\[22\] net264 vssd1 vssd1
+ vccd1 vccd1 _01131_ sky130_fd_sc_hd__mux2_1
XANTENNA__07007__A2 FPGA_INST.bus2_0\[10\] vssd1 vssd1 vccd1 vccd1 sky130_fd_sc_hd__diode_2
X_10181_ FPGA_INST.cell3.SB0.route_sel\[85\] FPGA_INST.cell3.SB0.route_sel\[86\] net286
+ vssd1 vssd1 vccd1 vccd1 _01062_ sky130_fd_sc_hd__mux2_1
XFILLER_78_249 vssd1 vssd1 vccd1 vccd1 sky130_fd_sc_hd__fill_1
Xfanout240 net241 vssd1 vssd1 vccd1 vccd1 net240 sky130_fd_sc_hd__clkbuf_4
XFILLER_115_51 vssd1 vssd1 vccd1 vccd1 sky130_fd_sc_hd__fill_4
Xfanout273 net285 vssd1 vssd1 vccd1 vccd1 net273 sky130_fd_sc_hd__buf_2
XFILLER_75_11 vccd1 vssd1 vccd1 vssd1 sky130_ef_sc_hd__decap_40_12
Xfanout262 net263 vssd1 vssd1 vccd1 vccd1 net262 sky130_fd_sc_hd__clkbuf_4
Xfanout251 net267 vssd1 vssd1 vccd1 vccd1 net251 sky130_fd_sc_hd__clkbuf_4
Xfanout284 net285 vssd1 vssd1 vccd1 vccd1 net284 sky130_fd_sc_hd__clkbuf_4
Xfanout295 net306 vssd1 vssd1 vccd1 vccd1 net295 sky130_fd_sc_hd__clkbuf_2
XFILLER_86_260 vssd1 vssd1 vccd1 vccd1 sky130_fd_sc_hd__fill_4
XFILLER_19_316 vssd1 vssd1 vccd1 vccd1 sky130_fd_sc_hd__fill_1
XFILLER_74_477 vssd1 vssd1 vccd1 vccd1 sky130_fd_sc_hd__fill_1
XTAP_TAPCELL_ROW_17_517 vssd1 vccd1 sky130_fd_sc_hd__tapvpwrvgnd_1
XTAP_TAPCELL_ROW_83_1445 vssd1 vccd1 sky130_fd_sc_hd__tapvpwrvgnd_1
XANTENNA__05670__A net132 vssd1 vssd1 vccd1 vccd1 sky130_fd_sc_hd__diode_2
XFILLER_27_393 vccd1 vssd1 vccd1 vssd1 sky130_ef_sc_hd__decap_40_12
XFILLER_91_43 vssd1 vssd1 vccd1 vccd1 sky130_fd_sc_hd__fill_8
X_11704_ net901 _01050_ net685 vssd1 vssd1 vccd1 vccd1 FPGA_INST.cell3.SB0.route_sel\[74\]
+ sky130_fd_sc_hd__dfstp_1
XANTENNA__08691__A1 net24 vssd1 vssd1 vccd1 vccd1 sky130_fd_sc_hd__diode_2
X_11635_ net896 _00981_ net680 vssd1 vssd1 vccd1 vccd1 FPGA_INST.cell3.SB0.route_sel\[5\]
+ sky130_fd_sc_hd__dfstp_1
X_11566_ net770 _00916_ net555 vssd1 vssd1 vccd1 vccd1 FPGA_INST.cell0.CB_0.config_dataB\[10\]
+ sky130_fd_sc_hd__dfstp_1
XFILLER_128_468 vssd1 vssd1 vccd1 vccd1 sky130_fd_sc_hd__fill_4
XFILLER_7_776 vssd1 vssd1 vccd1 vccd1 sky130_fd_sc_hd__fill_1
X_10517_ FPGA_INST.cell2.SB0.route_sel\[89\] FPGA_INST.cell2.SB0.route_sel\[90\] net248
+ vssd1 vssd1 vccd1 vccd1 _01396_ sky130_fd_sc_hd__mux2_1
X_11497_ net792 _00847_ net577 vssd1 vssd1 vccd1 vccd1 FPGA_INST.cell0.CB_1.config_dataB\[3\]
+ sky130_fd_sc_hd__dfstp_1
XANTENNA__08205__B _04040_ vssd1 vssd1 vccd1 vccd1 sky130_fd_sc_hd__diode_2
XFILLER_6_286 vssd1 vssd1 vccd1 vccd1 sky130_fd_sc_hd__fill_2
X_10448_ FPGA_INST.cell2.SB0.route_sel\[20\] FPGA_INST.cell2.SB0.route_sel\[21\] net235
+ vssd1 vssd1 vccd1 vccd1 _01327_ sky130_fd_sc_hd__mux2_1
X_10379_ net737 _04777_ vssd1 vssd1 vccd1 vccd1 _05246_ sky130_fd_sc_hd__nand2_1
XFILLER_97_514 vssd1 vssd1 vccd1 vccd1 sky130_fd_sc_hd__fill_2
XFILLER_97_503 vssd1 vssd1 vccd1 vccd1 sky130_fd_sc_hd__fill_1
XTAP_TAPCELL_ROW_94_1596 vssd1 vccd1 sky130_fd_sc_hd__tapvpwrvgnd_1
XFILLER_123_173 vssd1 vssd1 vccd1 vccd1 sky130_fd_sc_hd__fill_1
X_12118_ net936 _01464_ net720 vssd1 vssd1 vccd1 vccd1 FPGA_INST.cell3.CB_0.config_dataB\[5\]
+ sky130_fd_sc_hd__dfstp_1
X_12049_ net850 _01395_ net635 vssd1 vssd1 vccd1 vccd1 FPGA_INST.cell2.SB0.route_sel\[89\]
+ sky130_fd_sc_hd__dfstp_1
XANTENNA__09751__S net348 vssd1 vssd1 vccd1 vccd1 sky130_fd_sc_hd__diode_2
XFILLER_78_794 vssd1 vssd1 vccd1 vccd1 sky130_fd_sc_hd__fill_4
XFILLER_1_30 vssd1 vssd1 vccd1 vccd1 sky130_fd_sc_hd__fill_4
XFILLER_38_658 vssd1 vssd1 vccd1 vccd1 sky130_fd_sc_hd__fill_2
X_07590_ net150 _03507_ _03762_ vssd1 vssd1 vccd1 vccd1 _03844_ sky130_fd_sc_hd__or3_1
X_06610_ _02793_ _02797_ net478 vssd1 vssd1 vccd1 vccd1 _02886_ sky130_fd_sc_hd__mux2_1
X_06541_ FPGA_INST.cell2.SB0.route_sel\[100\] FPGA_INST.cell2.SB0.route_sel\[101\]
+ vssd1 vssd1 vccd1 vccd1 _02817_ sky130_fd_sc_hd__nor2_1
XANTENNA__08011__A1_N _03652_ vssd1 vssd1 vccd1 vccd1 sky130_fd_sc_hd__diode_2
X_09260_ FPGA_INST.cell1.SB0.route_sel\[32\] FPGA_INST.cell1.SB0.route_sel\[31\] net339
+ vssd1 vssd1 vccd1 vccd1 _00173_ sky130_fd_sc_hd__mux2_1
XFILLER_21_503 vssd1 vssd1 vccd1 vccd1 sky130_fd_sc_hd__fill_1
X_06472_ net9 net10 net11 net13 net489 net487 vssd1 vssd1 vccd1 vccd1 _02750_ sky130_fd_sc_hd__mux4_1
X_05423_ FPGA_INST.cell3.SB0.route_sel\[20\] vssd1 vssd1 vccd1 vccd1 _01705_ sky130_fd_sc_hd__inv_2
X_08211_ _04426_ _04428_ _04431_ _04434_ vssd1 vssd1 vccd1 vccd1 _04435_ sky130_fd_sc_hd__a22o_1
XANTENNA__06693__A0 FPGA_INST.bus3_2\[12\] vssd1 vssd1 vccd1 vccd1 sky130_fd_sc_hd__diode_2
XTAP_TAPCELL_ROW_44_892 vssd1 vccd1 sky130_fd_sc_hd__tapvpwrvgnd_1
X_09191_ FPGA_INST.cell2.LE_1A.config_data\[9\] FPGA_INST.cell2.LE_1A.config_data\[8\]
+ net361 vssd1 vssd1 vccd1 vccd1 _00104_ sky130_fd_sc_hd__mux2_1
XFILLER_21_569 vssd1 vssd1 vccd1 vccd1 sky130_fd_sc_hd__fill_1
X_08142_ FPGA_INST.cell1.LE_0B.config_data\[1\] FPGA_INST.cell1.LE_0B.config_data\[0\]
+ _04296_ vssd1 vssd1 vccd1 vccd1 _04368_ sky130_fd_sc_hd__mux2_1
XFILLER_119_446 vssd1 vssd1 vccd1 vccd1 sky130_fd_sc_hd__fill_2
XFILLER_119_424 vssd1 vssd1 vccd1 vccd1 sky130_fd_sc_hd__fill_1
X_05354_ FPGA_INST.cell1.SB0.route_sel\[94\] vssd1 vssd1 vccd1 vccd1 _01636_ sky130_fd_sc_hd__inv_2
X_08073_ net454 _03519_ _04298_ net453 vssd1 vssd1 vccd1 vccd1 _04299_ sky130_fd_sc_hd__o211a_1
X_05285_ FPGA_INST.cell2.SB0.route_sel\[70\] vssd1 vssd1 vccd1 vccd1 _01567_ sky130_fd_sc_hd__inv_2
XANTENNA_fanout114_A net115 vssd1 vssd1 vccd1 vccd1 sky130_fd_sc_hd__diode_2
X_07024_ net437 _02030_ _03289_ net435 vssd1 vssd1 vccd1 vccd1 _03290_ sky130_fd_sc_hd__o211a_1
XTAP_TAPCELL_ROW_54_1035 vssd1 vccd1 sky130_fd_sc_hd__tapvpwrvgnd_1
X_08975_ _01663_ FPGA_INST.cell3.SB0.route_sel\[57\] FPGA_INST.cell3.SB0.route_sel\[62\]
+ FPGA_INST.cell3.SB0.route_sel\[63\] _05156_ vssd1 vssd1 vccd1 vccd1 _05157_ sky130_fd_sc_hd__o221a_1
X_07926_ net465 net466 vssd1 vssd1 vccd1 vccd1 _04154_ sky130_fd_sc_hd__nand2b_1
XFILLER_84_731 vssd1 vssd1 vccd1 vccd1 sky130_fd_sc_hd__fill_2
XFILLER_69_794 vssd1 vssd1 vccd1 vccd1 sky130_fd_sc_hd__fill_4
XFILLER_69_783 vssd1 vssd1 vccd1 vccd1 sky130_fd_sc_hd__fill_1
XANTENNA_fanout369_X net369 vssd1 vssd1 vccd1 vccd1 sky130_fd_sc_hd__diode_2
X_07857_ _03421_ _04082_ _04084_ _03475_ FPGA_INST.cell1.CB_0.config_dataA\[7\] vssd1
+ vssd1 vccd1 vccd1 _04085_ sky130_fd_sc_hd__a221o_1
XANTENNA__08785__B _04804_ vssd1 vssd1 vccd1 vccd1 sky130_fd_sc_hd__diode_2
XFILLER_84_753 vssd1 vssd1 vccd1 vccd1 sky130_fd_sc_hd__fill_2
XFILLER_56_433 vssd1 vssd1 vccd1 vccd1 sky130_fd_sc_hd__fill_2
XANTENNA__08370__A0 net75 vssd1 vssd1 vccd1 vccd1 sky130_fd_sc_hd__diode_2
XANTENNA_fanout650_A net662 vssd1 vssd1 vccd1 vccd1 sky130_fd_sc_hd__diode_2
XFILLER_84_797 vssd1 vssd1 vccd1 vccd1 sky130_fd_sc_hd__fill_2
X_06808_ _03077_ _03081_ vssd1 vssd1 vccd1 vccd1 _03082_ sky130_fd_sc_hd__and2b_1
X_07788_ FPGA_INST.cell1.SB0.route_sel\[122\] FPGA_INST.cell1.SB0.route_sel\[123\]
+ vssd1 vssd1 vccd1 vccd1 _04037_ sky130_fd_sc_hd__nand2_1
XFILLER_56_477 vssd1 vssd1 vccd1 vccd1 sky130_fd_sc_hd__fill_4
XFILLER_45_36 vssd1 vssd1 vccd1 vccd1 sky130_fd_sc_hd__fill_1
X_09527_ FPGA_INST.cell1.LE_0B.config_data\[0\] FPGA_INST.cell1.LE_1B.reset_mode net346
+ vssd1 vssd1 vccd1 vccd1 _00437_ sky130_fd_sc_hd__mux2_1
X_06739_ net516 _03011_ _03012_ vssd1 vssd1 vccd1 vccd1 _03013_ sky130_fd_sc_hd__a21oi_1
XANTENNA_fanout915_A net917 vssd1 vssd1 vccd1 vccd1 sky130_fd_sc_hd__diode_2
XFILLER_101_42 vssd1 vssd1 vccd1 vccd1 sky130_fd_sc_hd__fill_2
X_09458_ FPGA_INST.cell1.LEI0.config_data\[4\] FPGA_INST.cell1.LEI0.config_data\[5\]
+ net214 vssd1 vssd1 vccd1 vccd1 _00370_ sky130_fd_sc_hd__mux2_1
XFILLER_101_53 vssd1 vssd1 vccd1 vccd1 sky130_fd_sc_hd__fill_2
XTAP_TAPCELL_ROW_65_1197 vssd1 vccd1 sky130_fd_sc_hd__tapvpwrvgnd_1
XTAP_TAPCELL_ROW_65_1186 vssd1 vccd1 sky130_fd_sc_hd__tapvpwrvgnd_1
X_08409_ FPGA_INST.cell0.CB_1.config_dataB\[18\] _04619_ _04626_ _04630_ FPGA_INST.cell0.CB_1.config_dataB\[19\]
+ vssd1 vssd1 vccd1 vccd1 _04631_ sky130_fd_sc_hd__a221o_1
XFILLER_51_193 vssd1 vssd1 vccd1 vccd1 sky130_fd_sc_hd__fill_2
X_09389_ FPGA_INST.cell2.CB_0.config_dataB\[8\] FPGA_INST.cell2.CB_0.config_dataB\[7\]
+ net356 vssd1 vssd1 vccd1 vccd1 _00302_ sky130_fd_sc_hd__mux2_1
X_11420_ net754 _00770_ net539 vssd1 vssd1 vccd1 vccd1 FPGA_INST.cell0.LEI0.config_data\[41\]
+ sky130_fd_sc_hd__dfrtp_1
XTAP_TAPCELL_ROW_22_586 vssd1 vccd1 sky130_fd_sc_hd__tapvpwrvgnd_1
XPHY_EDGE_ROW_89_Left_220 vssd1 vssd1 vccd1 vccd1 sky130_fd_sc_hd__decap_3
X_11351_ net795 _00701_ net580 vssd1 vssd1 vccd1 vccd1 FPGA_INST.cell1.CB_1.config_dataA\[18\]
+ sky130_fd_sc_hd__dfstp_1
XANTENNA__06436__A0 net7 vssd1 vssd1 vccd1 vccd1 sky130_fd_sc_hd__diode_2
XFILLER_20_591 vssd1 vssd1 vccd1 vccd1 sky130_fd_sc_hd__fill_2
XTAP_TAPCELL_ROW_22_597 vssd1 vccd1 sky130_fd_sc_hd__tapvpwrvgnd_1
X_10302_ FPGA_INST.cell3.LEI0.config_data\[16\] FPGA_INST.cell3.LEI0.config_data\[17\]
+ net298 vssd1 vssd1 vccd1 vccd1 _01183_ sky130_fd_sc_hd__mux2_1
XFILLER_4_724 vssd1 vssd1 vccd1 vccd1 sky130_fd_sc_hd__fill_1
XANTENNA__06987__A1 _02465_ vssd1 vssd1 vccd1 vccd1 sky130_fd_sc_hd__diode_2
XANTENNA__06987__B2 _02429_ vssd1 vssd1 vccd1 vccd1 sky130_fd_sc_hd__diode_2
XFILLER_125_449 vssd1 vssd1 vccd1 vccd1 sky130_fd_sc_hd__fill_1
X_11282_ net787 _00632_ net572 vssd1 vssd1 vccd1 vccd1 FPGA_INST.cell0.SB0.config_data_out
+ sky130_fd_sc_hd__dfstp_2
XFILLER_4_757 vssd1 vssd1 vccd1 vccd1 sky130_fd_sc_hd__fill_4
XFILLER_3_223 vssd1 vssd1 vccd1 vccd1 sky130_fd_sc_hd__fill_1
XFILLER_3_212 vssd1 vssd1 vccd1 vccd1 sky130_fd_sc_hd__fill_2
XFILLER_79_503 vssd1 vssd1 vccd1 vccd1 sky130_fd_sc_hd__fill_1
X_10233_ FPGA_INST.io_west_oeb\[18\] FPGA_INST.io_west_oeb\[20\] net289 vssd1 vssd1
+ vccd1 vccd1 _01114_ sky130_fd_sc_hd__mux2_1
XFILLER_126_72 vccd1 vssd1 vccd1 vssd1 sky130_ef_sc_hd__decap_40_12
X_10164_ FPGA_INST.cell3.SB0.route_sel\[69\] FPGA_INST.cell3.SB0.route_sel\[68\] net365
+ vssd1 vssd1 vccd1 vccd1 _01045_ sky130_fd_sc_hd__mux2_1
XFILLER_10_94 vssd1 vssd1 vccd1 vccd1 sky130_fd_sc_hd__fill_2
XFILLER_10_83 vssd1 vssd1 vccd1 vccd1 sky130_fd_sc_hd__fill_1
XFILLER_120_132 vssd1 vssd1 vccd1 vccd1 sky130_fd_sc_hd__fill_8
X_10095_ FPGA_INST.cell3.SB0.route_sel\[0\] FPGA_INST.cell3.CB_1.config_dataB\[24\]
+ net368 vssd1 vssd1 vccd1 vccd1 _00976_ sky130_fd_sc_hd__mux2_1
XFILLER_90_701 vssd1 vssd1 vccd1 vccd1 sky130_fd_sc_hd__fill_8
XFILLER_35_606 vssd1 vssd1 vccd1 vccd1 sky130_fd_sc_hd__fill_2
XFILLER_35_617 vssd1 vssd1 vccd1 vccd1 sky130_fd_sc_hd__fill_4
X_10997_ net890 _00347_ net674 vssd1 vssd1 vccd1 vccd1 FPGA_INST.cell2.LE_1B.config_data\[3\]
+ sky130_fd_sc_hd__dfrtp_1
XFILLER_27_190 vssd1 vssd1 vccd1 vccd1 sky130_fd_sc_hd__fill_1
XANTENNA__08664__A1 _04831_ vssd1 vssd1 vccd1 vccd1 sky130_fd_sc_hd__diode_2
XFILLER_43_694 vssd1 vssd1 vccd1 vccd1 sky130_fd_sc_hd__fill_1
XANTENNA__07104__B _01888_ vssd1 vssd1 vccd1 vccd1 sky130_fd_sc_hd__diode_2
XTAP_TAPCELL_ROW_41_851 vssd1 vccd1 sky130_fd_sc_hd__tapvpwrvgnd_1
XFILLER_128_221 vssd1 vssd1 vccd1 vccd1 sky130_fd_sc_hd__fill_1
XTAP_TAPCELL_ROW_41_862 vssd1 vccd1 sky130_fd_sc_hd__tapvpwrvgnd_1
X_11618_ net742 _00968_ net527 vssd1 vssd1 vccd1 vccd1 FPGA_INST.cell0.LE_1B.config_data\[12\]
+ sky130_fd_sc_hd__dfrtp_1
XFILLER_129_777 vssd1 vssd1 vccd1 vccd1 sky130_fd_sc_hd__fill_4
XTAP_TAPCELL_ROW_96_1625 vssd1 vccd1 sky130_fd_sc_hd__tapvpwrvgnd_1
XFILLER_116_416 vssd1 vssd1 vccd1 vccd1 sky130_fd_sc_hd__fill_4
X_11549_ net770 _00899_ net555 vssd1 vssd1 vccd1 vccd1 FPGA_INST.cell0.CB_0.config_dataA\[18\]
+ sky130_fd_sc_hd__dfstp_1
XANTENNA__07942__A3 FPGA_INST.bus3_1\[15\] vssd1 vssd1 vccd1 vccd1 sky130_fd_sc_hd__diode_2
X_08760_ _04967_ _04968_ _04891_ vssd1 vssd1 vccd1 vccd1 _04969_ sky130_fd_sc_hd__mux2_1
X_05972_ _02251_ _02245_ vssd1 vssd1 vccd1 vccd1 _02252_ sky130_fd_sc_hd__and2b_1
X_08691_ net22 net24 net25 net26 net397 net396 vssd1 vssd1 vccd1 vccd1 _04900_ sky130_fd_sc_hd__mux4_1
XFILLER_93_550 vssd1 vssd1 vccd1 vccd1 sky130_fd_sc_hd__fill_1
X_07711_ FPGA_INST.cell1.SB0.route_sel\[111\] FPGA_INST.cell1.SB0.route_sel\[110\]
+ net109 _03961_ vssd1 vssd1 vccd1 vccd1 _03962_ sky130_fd_sc_hd__a211oi_1
XFILLER_93_561 vssd1 vssd1 vccd1 vccd1 sky130_fd_sc_hd__fill_4
X_07642_ FPGA_INST.cell3.SB0.route_sel\[93\] FPGA_INST.cell3.SB0.route_sel\[92\] _02079_
+ _03894_ vssd1 vssd1 vccd1 vccd1 _03895_ sky130_fd_sc_hd__and4_1
XTAP_TAPCELL_ROW_49_973 vssd1 vccd1 sky130_fd_sc_hd__tapvpwrvgnd_1
XTAP_TAPCELL_ROW_49_962 vssd1 vccd1 sky130_fd_sc_hd__tapvpwrvgnd_1
XTAP_TAPCELL_ROW_105_1754 vssd1 vccd1 sky130_fd_sc_hd__tapvpwrvgnd_1
X_09312_ FPGA_INST.cell1.SB0.route_sel\[83\] FPGA_INST.cell1.SB0.route_sel\[84\] net203
+ vssd1 vssd1 vccd1 vccd1 _00225_ sky130_fd_sc_hd__mux2_1
X_07573_ _03827_ _03825_ vssd1 vssd1 vccd1 vccd1 FPGA_INST.bus3_2\[9\] sky130_fd_sc_hd__and2b_1
XFILLER_53_469 vssd1 vssd1 vccd1 vccd1 sky130_fd_sc_hd__fill_2
XFILLER_80_288 vssd1 vssd1 vccd1 vccd1 sky130_fd_sc_hd__fill_2
XANTENNA__07014__B _01888_ vssd1 vssd1 vccd1 vccd1 sky130_fd_sc_hd__diode_2
X_06524_ _01556_ FPGA_INST.cell2.SB0.route_sel\[33\] FPGA_INST.cell2.SB0.route_sel\[38\]
+ _01557_ _02799_ vssd1 vssd1 vccd1 vccd1 _02800_ sky130_fd_sc_hd__a221o_1
XANTENNA_fanout231_A net232 vssd1 vssd1 vccd1 vccd1 sky130_fd_sc_hd__diode_2
X_09243_ FPGA_INST.cell1.SB0.route_sel\[15\] FPGA_INST.cell1.SB0.route_sel\[14\] net323
+ vssd1 vssd1 vccd1 vccd1 _00156_ sky130_fd_sc_hd__mux2_1
X_06455_ _02330_ _02728_ _02729_ _02293_ _01544_ vssd1 vssd1 vccd1 vccd1 _02733_ sky130_fd_sc_hd__a221o_1
X_05406_ FPGA_INST.cell3.SB0.route_sel\[34\] vssd1 vssd1 vccd1 vccd1 _01688_ sky130_fd_sc_hd__inv_2
XANTENNA_fanout329_A net332 vssd1 vssd1 vccd1 vccd1 sky130_fd_sc_hd__diode_2
XANTENNA__08407__A1 _03639_ vssd1 vssd1 vccd1 vccd1 sky130_fd_sc_hd__diode_2
X_06386_ net5 _02656_ FPGA_INST.cell2.CB_0.config_dataB\[2\] vssd1 vssd1 vccd1 vccd1
+ _02664_ sky130_fd_sc_hd__a21bo_1
X_09174_ FPGA_INST.cell2.LE_0B.config_data\[15\] FPGA_INST.cell2.LE_0B.config_data\[14\]
+ net359 vssd1 vssd1 vccd1 vccd1 _00088_ sky130_fd_sc_hd__mux2_1
X_08125_ _03810_ _04335_ _04350_ vssd1 vssd1 vccd1 vccd1 _04351_ sky130_fd_sc_hd__o21ai_1
X_05337_ FPGA_INST.cell1.SB0.route_sel\[106\] vssd1 vssd1 vccd1 vccd1 _01619_ sky130_fd_sc_hd__inv_2
XANTENNA__08407__B2 _03604_ vssd1 vssd1 vccd1 vccd1 sky130_fd_sc_hd__diode_2
XFILLER_119_287 vssd1 vssd1 vccd1 vccd1 sky130_fd_sc_hd__fill_1
X_08056_ FPGA_INST.cell1.CB_0.config_dataB\[2\] _04279_ _04281_ vssd1 vssd1 vccd1
+ vccd1 _04282_ sky130_fd_sc_hd__or3_1
X_05268_ FPGA_INST.cell2.SB0.route_sel\[8\] vssd1 vssd1 vccd1 vccd1 _01550_ sky130_fd_sc_hd__inv_2
XFILLER_122_408 vccd1 vssd1 vccd1 vssd1 sky130_ef_sc_hd__decap_40_12
XANTENNA_fanout698_A net701 vssd1 vssd1 vccd1 vccd1 sky130_fd_sc_hd__diode_2
Xoutput38 net38 vssd1 vssd1 vccd1 vccd1 gpio_oeb[23] sky130_fd_sc_hd__buf_2
Xoutput49 net49 vssd1 vssd1 vccd1 vccd1 gpio_out[14] sky130_fd_sc_hd__buf_2
X_07007_ FPGA_INST.bus2_0\[8\] FPGA_INST.bus2_0\[9\] FPGA_INST.bus2_0\[10\] FPGA_INST.bus2_0\[11\]
+ net434 FPGA_INST.cell0.CB_0.config_dataA\[6\] vssd1 vssd1 vccd1 vccd1 _03273_ sky130_fd_sc_hd__mux4_1
XFILLER_88_322 vssd1 vssd1 vccd1 vccd1 sky130_fd_sc_hd__fill_4
XFILLER_0_237 vssd1 vssd1 vccd1 vccd1 sky130_fd_sc_hd__fill_2
XFILLER_102_154 vssd1 vssd1 vccd1 vccd1 sky130_fd_sc_hd__fill_2
XANTENNA__08591__B1 FPGA_INST.cell3.SB0.route_sel\[125\] vssd1 vssd1 vccd1 vccd1 sky130_fd_sc_hd__diode_2
XANTENNA_fanout865_A net892 vssd1 vssd1 vccd1 vccd1 sky130_fd_sc_hd__diode_2
X_08958_ _03825_ _05145_ vssd1 vssd1 vccd1 vccd1 FPGA_INST.bus3_1\[9\] sky130_fd_sc_hd__and2_2
X_08889_ _05085_ _05086_ _05095_ vssd1 vssd1 vccd1 vccd1 _05096_ sky130_fd_sc_hd__a21oi_1
X_07909_ FPGA_INST.bus3_1\[8\] FPGA_INST.bus3_1\[9\] FPGA_INST.bus3_1\[10\] FPGA_INST.bus3_1\[11\]
+ net473 net471 vssd1 vssd1 vccd1 vccd1 _04137_ sky130_fd_sc_hd__mux4_1
XANTENNA__08343__A0 net75 vssd1 vssd1 vccd1 vccd1 sky130_fd_sc_hd__diode_2
XFILLER_56_24 vssd1 vssd1 vccd1 vccd1 sky130_fd_sc_hd__fill_2
XANTENNA__09135__A2 net524 vssd1 vssd1 vccd1 vccd1 sky130_fd_sc_hd__diode_2
XTAP_TAPCELL_ROW_67_1215 vssd1 vccd1 sky130_fd_sc_hd__tapvpwrvgnd_1
XFILLER_57_797 vssd1 vssd1 vccd1 vccd1 sky130_fd_sc_hd__fill_2
X_10920_ net865 _00270_ net650 vssd1 vssd1 vccd1 vccd1 FPGA_INST.cell2.CB_0.config_dataA\[1\]
+ sky130_fd_sc_hd__dfstp_1
XANTENNA__10700__SET_B net734 vssd1 vssd1 vccd1 vccd1 sky130_fd_sc_hd__diode_2
XANTENNA__07697__A2 _03447_ vssd1 vssd1 vccd1 vccd1 sky130_fd_sc_hd__diode_2
XFILLER_71_222 vssd1 vssd1 vccd1 vccd1 sky130_fd_sc_hd__fill_2
XTAP_TAPCELL_ROW_67_1226 vssd1 vccd1 sky130_fd_sc_hd__tapvpwrvgnd_1
XANTENNA_fanout918_X net918 vssd1 vssd1 vccd1 vccd1 sky130_fd_sc_hd__diode_2
XANTENNA_fanout820_X net820 vssd1 vssd1 vccd1 vccd1 sky130_fd_sc_hd__diode_2
XFILLER_112_85 vssd1 vssd1 vccd1 vccd1 sky130_fd_sc_hd__fill_2
X_10851_ net823 _00201_ net607 vssd1 vssd1 vccd1 vccd1 FPGA_INST.cell1.SB0.route_sel\[60\]
+ sky130_fd_sc_hd__dfstp_1
XFILLER_44_458 vssd1 vssd1 vccd1 vccd1 sky130_fd_sc_hd__fill_4
XTAP_TAPCELL_ROW_27_656 vssd1 vccd1 sky130_fd_sc_hd__tapvpwrvgnd_1
XTAP_TAPCELL_ROW_27_667 vssd1 vccd1 sky130_fd_sc_hd__tapvpwrvgnd_1
XTAP_TAPCELL_ROW_80_1404 vssd1 vccd1 sky130_fd_sc_hd__tapvpwrvgnd_1
X_10782_ net920 _00132_ net704 vssd1 vssd1 vccd1 vccd1 FPGA_INST.cell2.CB_1.config_dataB\[16\]
+ sky130_fd_sc_hd__dfstp_1
XFILLER_40_620 vssd1 vssd1 vccd1 vccd1 sky130_fd_sc_hd__fill_8
XANTENNA__06657__A0 FPGA_INST.bus3_2\[4\] vssd1 vssd1 vccd1 vccd1 sky130_fd_sc_hd__diode_2
XFILLER_40_642 vssd1 vssd1 vccd1 vccd1 sky130_fd_sc_hd__fill_2
XANTENNA__06763__B _02796_ vssd1 vssd1 vccd1 vccd1 sky130_fd_sc_hd__diode_2
X_11403_ net748 _00753_ net533 vssd1 vssd1 vccd1 vccd1 FPGA_INST.cell0.LEI0.config_data\[24\]
+ sky130_fd_sc_hd__dfrtp_1
XANTENNA__07606__C1 _03857_ vssd1 vssd1 vccd1 vccd1 sky130_fd_sc_hd__diode_2
X_11334_ net806 _00684_ net591 vssd1 vssd1 vccd1 vccd1 FPGA_INST.cell1.CB_1.config_dataA\[1\]
+ sky130_fd_sc_hd__dfstp_1
XTAP_TAPCELL_ROW_78_1377 vssd1 vccd1 sky130_fd_sc_hd__tapvpwrvgnd_1
X_11265_ net783 _00615_ net568 vssd1 vssd1 vccd1 vccd1 FPGA_INST.cell0.SB0.route_sel\[110\]
+ sky130_fd_sc_hd__dfstp_1
XFILLER_106_471 vssd1 vssd1 vccd1 vccd1 sky130_fd_sc_hd__fill_4
XANTENNA__07909__A0 FPGA_INST.bus3_1\[8\] vssd1 vssd1 vccd1 vccd1 sky130_fd_sc_hd__diode_2
XTAP_TAPCELL_ROW_91_1555 vssd1 vccd1 sky130_fd_sc_hd__tapvpwrvgnd_1
X_10216_ FPGA_INST.cell3.SB0.route_sel\[120\] FPGA_INST.cell3.SB0.route_sel\[121\]
+ net274 vssd1 vssd1 vccd1 vccd1 _01097_ sky130_fd_sc_hd__mux2_1
XANTENNA__07385__A1 net148 vssd1 vssd1 vccd1 vccd1 sky130_fd_sc_hd__diode_2
X_11196_ net765 _00546_ net550 vssd1 vssd1 vccd1 vccd1 FPGA_INST.cell0.SB0.route_sel\[41\]
+ sky130_fd_sc_hd__dfstp_1
XFILLER_121_496 vssd1 vssd1 vccd1 vccd1 sky130_fd_sc_hd__fill_8
X_10147_ FPGA_INST.cell3.SB0.route_sel\[51\] FPGA_INST.cell3.SB0.route_sel\[52\] net277
+ vssd1 vssd1 vccd1 vccd1 _01028_ sky130_fd_sc_hd__mux2_1
XANTENNA_max_cap76_A net77 vssd1 vssd1 vccd1 vccd1 sky130_fd_sc_hd__diode_2
XTAP_TAPCELL_ROW_7_381 vssd1 vccd1 sky130_fd_sc_hd__tapvpwrvgnd_1
XFILLER_0_782 vssd1 vssd1 vccd1 vccd1 sky130_fd_sc_hd__fill_2
XFILLER_39_208 vssd1 vssd1 vccd1 vccd1 sky130_fd_sc_hd__fill_4
XFILLER_39_219 vssd1 vssd1 vccd1 vccd1 sky130_fd_sc_hd__fill_1
XANTENNA__08334__A0 FPGA_INST.bus1_0\[8\] vssd1 vssd1 vccd1 vccd1 sky130_fd_sc_hd__diode_2
X_10078_ FPGA_INST.cell0.LE_1B.config_data\[3\] FPGA_INST.cell0.LE_1B.config_data\[2\]
+ net307 vssd1 vssd1 vccd1 vccd1 _00959_ sky130_fd_sc_hd__mux2_1
XFILLER_48_786 vssd1 vssd1 vccd1 vccd1 sky130_fd_sc_hd__fill_2
XTAP_TAPCELL_ROW_46_932 vssd1 vccd1 sky130_fd_sc_hd__tapvpwrvgnd_1
XTAP_TAPCELL_ROW_46_921 vssd1 vccd1 sky130_fd_sc_hd__tapvpwrvgnd_1
XANTENNA__11328__CLK net842 vssd1 vssd1 vccd1 vccd1 sky130_fd_sc_hd__diode_2
XFILLER_87_3 vssd1 vssd1 vccd1 vccd1 sky130_fd_sc_hd__fill_4
X_06240_ _02516_ _02519_ _02512_ vssd1 vssd1 vccd1 vccd1 _02520_ sky130_fd_sc_hd__a21oi_1
XTAP_TAPCELL_ROW_100_1684 vssd1 vccd1 sky130_fd_sc_hd__tapvpwrvgnd_1
XFILLER_30_185 vssd1 vssd1 vccd1 vccd1 sky130_fd_sc_hd__fill_8
X_06171_ net117 net169 _02332_ vssd1 vssd1 vccd1 vccd1 _02451_ sky130_fd_sc_hd__and3_1
XANTENNA__10415__S net372 vssd1 vssd1 vccd1 vccd1 sky130_fd_sc_hd__diode_2
XFILLER_104_419 vssd1 vssd1 vccd1 vccd1 sky130_fd_sc_hd__fill_1
X_09930_ FPGA_INST.cell0.LE_1A.config_data\[11\] FPGA_INST.cell0.LE_1A.config_data\[12\]
+ net183 vssd1 vssd1 vccd1 vccd1 _00835_ sky130_fd_sc_hd__mux2_1
XFILLER_125_780 vssd1 vssd1 vccd1 vccd1 sky130_fd_sc_hd__fill_4
Xfanout806 net811 vssd1 vssd1 vccd1 vccd1 net806 sky130_fd_sc_hd__clkbuf_2
XPHY_EDGE_ROW_15_Right_15 vssd1 vssd1 vccd1 vccd1 sky130_fd_sc_hd__decap_3
Xfanout839 net842 vssd1 vssd1 vccd1 vccd1 net839 sky130_fd_sc_hd__buf_1
Xfanout817 net819 vssd1 vssd1 vccd1 vccd1 net817 sky130_fd_sc_hd__clkbuf_2
Xfanout828 net831 vssd1 vssd1 vccd1 vccd1 net828 sky130_fd_sc_hd__dlymetal6s2s_1
X_09861_ FPGA_INST.cell0.LEI0.config_data\[39\] FPGA_INST.cell0.LEI0.config_data\[40\]
+ net177 vssd1 vssd1 vccd1 vccd1 _00769_ sky130_fd_sc_hd__mux2_1
XANTENNA__06024__B1_N FPGA_INST.bus2_0\[5\] vssd1 vssd1 vccd1 vccd1 sky130_fd_sc_hd__diode_2
X_08812_ _04794_ _05003_ _05005_ _04789_ FPGA_INST.cell3.CB_0.config_dataB\[2\] vssd1
+ vssd1 vccd1 vccd1 _05019_ sky130_fd_sc_hd__a221o_1
X_09792_ FPGA_INST.cell1.CB_1.config_dataA\[18\] FPGA_INST.cell1.CB_1.config_dataA\[17\]
+ net327 vssd1 vssd1 vccd1 vccd1 _00701_ sky130_fd_sc_hd__mux2_1
XANTENNA__07791__Y _04040_ vssd1 vssd1 vccd1 vccd1 sky130_fd_sc_hd__diode_2
X_08743_ _04946_ _04950_ _04951_ _04942_ FPGA_INST.cell3.CB_0.config_dataA\[19\] vssd1
+ vssd1 vccd1 vccd1 _04952_ sky130_fd_sc_hd__a311o_1
X_05955_ net116 _01814_ _02173_ _02219_ _02234_ vssd1 vssd1 vccd1 vccd1 _02235_ sky130_fd_sc_hd__a32o_1
XANTENNA_fanout181_A net234 vssd1 vssd1 vccd1 vccd1 sky130_fd_sc_hd__diode_2
XFILLER_93_391 vssd1 vssd1 vccd1 vccd1 sky130_fd_sc_hd__fill_1
X_08674_ FPGA_INST.cell3.CB_0.config_dataA\[8\] _04878_ _04882_ FPGA_INST.cell3.CB_0.config_dataA\[9\]
+ vssd1 vssd1 vccd1 vccd1 _04883_ sky130_fd_sc_hd__a31o_1
XFILLER_81_531 vssd1 vssd1 vccd1 vccd1 sky130_fd_sc_hd__fill_1
XFILLER_53_222 vssd1 vssd1 vccd1 vccd1 sky130_fd_sc_hd__fill_2
X_05886_ FPGA_INST.cell2.SB0.route_sel\[68\] _01566_ _01567_ FPGA_INST.cell2.SB0.route_sel\[71\]
+ _02165_ vssd1 vssd1 vccd1 vccd1 _02166_ sky130_fd_sc_hd__a221o_1
XFILLER_26_38 vssd1 vssd1 vccd1 vccd1 sky130_fd_sc_hd__fill_2
X_07625_ FPGA_INST.cell1.SB0.route_sel\[95\] FPGA_INST.cell1.SB0.route_sel\[94\] _02061_
+ _03877_ _02062_ vssd1 vssd1 vccd1 vccd1 _03878_ sky130_fd_sc_hd__a221o_1
XPHY_EDGE_ROW_24_Right_24 vssd1 vssd1 vccd1 vccd1 sky130_fd_sc_hd__decap_3
X_07556_ _03791_ _03810_ _03792_ _03790_ vssd1 vssd1 vccd1 vccd1 _03811_ sky130_fd_sc_hd__a211o_1
XFILLER_13_119 vssd1 vssd1 vccd1 vccd1 sky130_fd_sc_hd__fill_2
XTAP_TAPCELL_ROW_24_615 vssd1 vccd1 sky130_fd_sc_hd__tapvpwrvgnd_1
XTAP_TAPCELL_ROW_62_1145 vssd1 vccd1 sky130_fd_sc_hd__tapvpwrvgnd_1
X_06507_ _01548_ FPGA_INST.cell2.SB0.route_sel\[1\] FPGA_INST.cell2.SB0.route_sel\[6\]
+ _01549_ _02782_ vssd1 vssd1 vccd1 vccd1 _02783_ sky130_fd_sc_hd__a221o_1
XFILLER_34_480 vssd1 vssd1 vccd1 vccd1 sky130_fd_sc_hd__fill_4
XANTENNA_fanout234_X net234 vssd1 vssd1 vccd1 vccd1 sky130_fd_sc_hd__diode_2
X_07487_ _03741_ _03743_ vssd1 vssd1 vccd1 vccd1 FPGA_INST.bus3_2\[7\] sky130_fd_sc_hd__nor2_4
XANTENNA_fanout613_A net615 vssd1 vssd1 vccd1 vccd1 sky130_fd_sc_hd__diode_2
XTAP_TAPCELL_ROW_62_1156 vssd1 vccd1 sky130_fd_sc_hd__tapvpwrvgnd_1
X_09226_ FPGA_INST.cell2.CB_1.config_dataB\[23\] FPGA_INST.cell2.CB_1.config_dataB\[22\]
+ net354 vssd1 vssd1 vccd1 vccd1 _00139_ sky130_fd_sc_hd__mux2_1
X_06438_ net6 _02692_ _02714_ net490 vssd1 vssd1 vccd1 vccd1 _02716_ sky130_fd_sc_hd__a22o_1
XTAP_TAPCELL_ROW_118_1934 vssd1 vccd1 sky130_fd_sc_hd__tapvpwrvgnd_1
X_09157_ net737 _02959_ vssd1 vssd1 vccd1 vccd1 _05211_ sky130_fd_sc_hd__nand2_1
X_06369_ net9 net10 net11 net13 net494 net493 vssd1 vssd1 vccd1 vccd1 _02647_ sky130_fd_sc_hd__mux4_1
X_08108_ net451 _03568_ vssd1 vssd1 vccd1 vccd1 _04334_ sky130_fd_sc_hd__nand2_1
X_09088_ FPGA_INST.cell2.LEI0.config_data\[2\] FPGA_INST.cell2.LEI0.config_data\[3\]
+ net262 vssd1 vssd1 vccd1 vccd1 _00004_ sky130_fd_sc_hd__mux2_1
XFILLER_107_279 vssd1 vssd1 vccd1 vccd1 sky130_fd_sc_hd__fill_1
X_08039_ net461 net459 vssd1 vssd1 vccd1 vccd1 _04265_ sky130_fd_sc_hd__nor2_1
XANTENNA__08800__B2 _04831_ vssd1 vssd1 vccd1 vccd1 sky130_fd_sc_hd__diode_2
XPHY_EDGE_ROW_33_Right_33 vssd1 vssd1 vccd1 vccd1 sky130_fd_sc_hd__decap_3
XFILLER_122_216 vssd1 vssd1 vccd1 vccd1 sky130_fd_sc_hd__fill_4
XANTENNA__10325__S net300 vssd1 vssd1 vccd1 vccd1 sky130_fd_sc_hd__diode_2
XFILLER_122_249 vssd1 vssd1 vccd1 vccd1 sky130_fd_sc_hd__fill_1
XFILLER_107_63 vssd1 vssd1 vccd1 vccd1 sky130_fd_sc_hd__fill_1
X_11050_ net813 _00400_ net598 vssd1 vssd1 vccd1 vccd1 FPGA_INST.cell1.LEI0.config_data\[35\]
+ sky130_fd_sc_hd__dfrtp_1
XFILLER_89_664 vssd1 vssd1 vccd1 vccd1 sky130_fd_sc_hd__fill_1
XFILLER_89_653 vssd1 vssd1 vccd1 vccd1 sky130_fd_sc_hd__fill_2
XFILLER_88_141 vssd1 vssd1 vccd1 vccd1 sky130_fd_sc_hd__fill_4
XFILLER_107_85 vssd1 vssd1 vccd1 vccd1 sky130_fd_sc_hd__fill_2
XFILLER_89_686 vssd1 vssd1 vccd1 vccd1 sky130_fd_sc_hd__fill_1
X_10001_ net437 FPGA_INST.cell0.CB_0.config_dataA\[1\] net181 vssd1 vssd1 vccd1 vccd1
+ _00882_ sky130_fd_sc_hd__mux2_1
XTAP_TAPCELL_ROW_4_340 vssd1 vccd1 sky130_fd_sc_hd__tapvpwrvgnd_1
XANTENNA__06590__A2 FPGA_INST.bus3_2\[2\] vssd1 vssd1 vccd1 vccd1 sky130_fd_sc_hd__diode_2
XFILLER_45_712 vssd1 vssd1 vccd1 vccd1 sky130_fd_sc_hd__fill_4
X_11952_ net913 _01298_ net697 vssd1 vssd1 vccd1 vccd1 FPGA_INST.cell3.CB_1.config_dataB\[17\]
+ sky130_fd_sc_hd__dfstp_1
XFILLER_72_531 vssd1 vssd1 vccd1 vccd1 sky130_fd_sc_hd__fill_1
XPHY_EDGE_ROW_42_Right_42 vssd1 vssd1 vccd1 vccd1 sky130_fd_sc_hd__decap_3
X_11883_ net928 _01229_ net712 vssd1 vssd1 vccd1 vccd1 FPGA_INST.cell3.LE_0A.config_data\[13\]
+ sky130_fd_sc_hd__dfrtp_1
X_10903_ net827 _00253_ net611 vssd1 vssd1 vccd1 vccd1 FPGA_INST.cell1.SB0.route_sel\[112\]
+ sky130_fd_sc_hd__dfstp_1
XFILLER_44_255 vssd1 vssd1 vccd1 vccd1 sky130_fd_sc_hd__fill_1
X_10834_ net800 _00184_ net585 vssd1 vssd1 vccd1 vccd1 FPGA_INST.cell1.SB0.route_sel\[43\]
+ sky130_fd_sc_hd__dfstp_1
XFILLER_44_277 vssd1 vssd1 vccd1 vccd1 sky130_fd_sc_hd__fill_4
XFILLER_16_71 vssd1 vssd1 vccd1 vccd1 sky130_fd_sc_hd__fill_2
XPHY_EDGE_ROW_17_Left_148 vssd1 vssd1 vccd1 vccd1 sky130_fd_sc_hd__decap_3
X_10765_ FPGA_INST.cell2.LE_1B.sel_clk _00115_ net734 vssd1 vssd1 vccd1 vccd1 FPGA_INST.cell2.LE_1B.dff0_out
+ sky130_fd_sc_hd__dfrtp_1
XTAP_TAPCELL_ROW_51_990 vssd1 vccd1 sky130_fd_sc_hd__tapvpwrvgnd_1
XFILLER_8_123 vssd1 vssd1 vccd1 vccd1 sky130_fd_sc_hd__fill_1
X_10696_ net880 _00046_ net665 vssd1 vssd1 vccd1 vccd1 FPGA_INST.cell2.LEI0.config_data\[45\]
+ sky130_fd_sc_hd__dfrtp_1
XPHY_EDGE_ROW_51_Right_51 vssd1 vssd1 vccd1 vccd1 sky130_fd_sc_hd__decap_3
XFILLER_126_544 vssd1 vssd1 vccd1 vccd1 sky130_fd_sc_hd__fill_1
X_11317_ net840 _00667_ net624 vssd1 vssd1 vccd1 vccd1 FPGA_INST.cell1.CB_0.config_dataB\[9\]
+ sky130_fd_sc_hd__dfstp_1
XANTENNA__08988__X FPGA_INST.bus1_0\[5\] vssd1 vssd1 vccd1 vccd1 sky130_fd_sc_hd__diode_2
X_11248_ net767 _00598_ net552 vssd1 vssd1 vccd1 vccd1 FPGA_INST.cell0.SB0.route_sel\[93\]
+ sky130_fd_sc_hd__dfstp_1
XPHY_EDGE_ROW_26_Left_157 vssd1 vssd1 vccd1 vccd1 sky130_fd_sc_hd__decap_3
X_11179_ net780 _00529_ net565 vssd1 vssd1 vccd1 vccd1 FPGA_INST.cell0.SB0.route_sel\[24\]
+ sky130_fd_sc_hd__dfstp_1
XPHY_EDGE_ROW_60_Right_60 vssd1 vssd1 vccd1 vccd1 sky130_fd_sc_hd__decap_3
XFILLER_94_188 vssd1 vssd1 vccd1 vccd1 sky130_fd_sc_hd__fill_1
X_05740_ net96 net383 net161 _02019_ _01825_ vssd1 vssd1 vccd1 vccd1 _02020_ sky130_fd_sc_hd__o32a_1
XANTENNA__06869__A0 FPGA_INST.bus2_0\[8\] vssd1 vssd1 vccd1 vccd1 sky130_fd_sc_hd__diode_2
XFILLER_35_211 vssd1 vssd1 vccd1 vccd1 sky130_fd_sc_hd__fill_1
X_05671_ _01945_ _01947_ _01949_ FPGA_INST.cell2.SB0.route_sel\[99\] FPGA_INST.cell2.SB0.route_sel\[98\]
+ vssd1 vssd1 vccd1 vccd1 _01951_ sky130_fd_sc_hd__a32o_1
X_07410_ _03668_ _03666_ vssd1 vssd1 vccd1 vccd1 FPGA_INST.bus3_2\[5\] sky130_fd_sc_hd__and2b_2
XTAP_TAPCELL_ROW_102_1713 vssd1 vccd1 sky130_fd_sc_hd__tapvpwrvgnd_1
XFILLER_63_586 vssd1 vssd1 vccd1 vccd1 sky130_fd_sc_hd__fill_1
X_08390_ FPGA_INST.bus1_0\[13\] _04608_ _04609_ net77 _01760_ vssd1 vssd1 vccd1 vccd1
+ _04612_ sky130_fd_sc_hd__a221o_1
XFILLER_23_406 vssd1 vssd1 vccd1 vccd1 sky130_fd_sc_hd__fill_1
XPHY_EDGE_ROW_35_Left_166 vssd1 vssd1 vccd1 vccd1 sky130_fd_sc_hd__decap_3
X_07341_ FPGA_INST.cell0.SB0.route_sel\[36\] FPGA_INST.cell0.SB0.route_sel\[37\] vssd1
+ vssd1 vccd1 vccd1 _03601_ sky130_fd_sc_hd__or2_1
X_07272_ net85 _03531_ _03533_ vssd1 vssd1 vccd1 vccd1 _03534_ sky130_fd_sc_hd__o21a_1
X_09011_ _01694_ FPGA_INST.cell3.SB0.route_sel\[25\] FPGA_INST.cell3.SB0.route_sel\[30\]
+ FPGA_INST.cell3.SB0.route_sel\[31\] _05180_ vssd1 vssd1 vccd1 vccd1 _05181_ sky130_fd_sc_hd__o221a_1
X_06223_ net510 _02376_ vssd1 vssd1 vccd1 vccd1 _02503_ sky130_fd_sc_hd__nand2_1
XFILLER_128_29 vssd1 vssd1 vccd1 vccd1 sky130_fd_sc_hd__fill_2
XFILLER_8_690 vssd1 vssd1 vccd1 vccd1 sky130_fd_sc_hd__fill_2
X_06154_ FPGA_INST.cell2.SB0.route_sel\[8\] FPGA_INST.cell2.SB0.route_sel\[9\] vssd1
+ vssd1 vccd1 vccd1 _02434_ sky130_fd_sc_hd__nand2_1
XFILLER_105_706 vssd1 vssd1 vccd1 vccd1 sky130_fd_sc_hd__fill_1
XPHY_EDGE_ROW_103_Right_103 vssd1 vssd1 vccd1 vccd1 sky130_fd_sc_hd__decap_3
XFILLER_104_238 vssd1 vssd1 vccd1 vccd1 sky130_fd_sc_hd__fill_2
XPHY_EDGE_ROW_44_Left_175 vssd1 vssd1 vccd1 vccd1 sky130_fd_sc_hd__decap_3
X_06085_ _02352_ _02354_ _02364_ vssd1 vssd1 vccd1 vccd1 _02365_ sky130_fd_sc_hd__o21ai_1
Xfanout603 net604 vssd1 vssd1 vccd1 vccd1 net603 sky130_fd_sc_hd__clkbuf_4
XTAP_TAPCELL_ROW_113_1864 vssd1 vccd1 sky130_fd_sc_hd__tapvpwrvgnd_1
XANTENNA__07349__A1 net148 vssd1 vssd1 vccd1 vccd1 sky130_fd_sc_hd__diode_2
Xfanout614 net615 vssd1 vssd1 vccd1 vccd1 net614 sky130_fd_sc_hd__clkbuf_2
X_09913_ FPGA_INST.cell0.LE_0B.reset_val FPGA_INST.cell0.LE_0B.edge_mode net309 vssd1
+ vssd1 vccd1 vccd1 _00819_ sky130_fd_sc_hd__mux2_1
Xfanout625 net626 vssd1 vssd1 vccd1 vccd1 net625 sky130_fd_sc_hd__clkbuf_2
XFILLER_113_794 vssd1 vssd1 vccd1 vccd1 sky130_fd_sc_hd__fill_4
XFILLER_58_303 vssd1 vssd1 vccd1 vccd1 sky130_fd_sc_hd__fill_4
Xfanout658 net661 vssd1 vssd1 vccd1 vccd1 net658 sky130_fd_sc_hd__clkbuf_4
Xfanout636 net676 vssd1 vssd1 vccd1 vccd1 net636 sky130_fd_sc_hd__clkbuf_4
X_09844_ FPGA_INST.cell0.LEI0.config_data\[22\] FPGA_INST.cell0.LEI0.config_data\[23\]
+ net174 vssd1 vssd1 vccd1 vccd1 _00752_ sky130_fd_sc_hd__mux2_1
Xfanout647 net676 vssd1 vssd1 vccd1 vccd1 net647 sky130_fd_sc_hd__buf_2
XFILLER_85_111 vssd1 vssd1 vccd1 vccd1 sky130_fd_sc_hd__fill_1
XANTENNA__07307__X _03568_ vssd1 vssd1 vccd1 vccd1 sky130_fd_sc_hd__diode_2
Xfanout669 net675 vssd1 vssd1 vccd1 vccd1 net669 sky130_fd_sc_hd__clkbuf_4
X_09775_ FPGA_INST.cell1.CB_1.config_dataA\[0\] FPGA_INST.cell1.CB_1.config_dataA\[1\]
+ net210 vssd1 vssd1 vccd1 vccd1 _00684_ sky130_fd_sc_hd__mux2_1
XANTENNA_fanout184_X net184 vssd1 vssd1 vccd1 vccd1 sky130_fd_sc_hd__diode_2
XANTENNA_fanout563_A net575 vssd1 vssd1 vccd1 vccd1 sky130_fd_sc_hd__diode_2
X_06987_ _02465_ _03246_ _03247_ _02429_ FPGA_INST.cell0.CB_0.config_dataA\[7\] vssd1
+ vssd1 vccd1 vccd1 _03253_ sky130_fd_sc_hd__a221o_1
XFILLER_39_561 vssd1 vssd1 vccd1 vccd1 sky130_fd_sc_hd__fill_4
X_08726_ net22 _04927_ _04929_ net24 _01771_ vssd1 vssd1 vccd1 vccd1 _04935_ sky130_fd_sc_hd__a221o_1
XANTENNA__05780__B1 FPGA_INST.bus1_0\[11\] vssd1 vssd1 vccd1 vccd1 sky130_fd_sc_hd__diode_2
XFILLER_54_531 vssd1 vssd1 vccd1 vccd1 sky130_fd_sc_hd__fill_1
X_05938_ net507 _02217_ vssd1 vssd1 vccd1 vccd1 _02218_ sky130_fd_sc_hd__nand2_1
XANTENNA_fanout730_A net731 vssd1 vssd1 vccd1 vccd1 sky130_fd_sc_hd__diode_2
X_08657_ _04843_ _04863_ _04865_ _04846_ _01766_ vssd1 vssd1 vccd1 vccd1 _04866_ sky130_fd_sc_hd__a221o_1
XPHY_EDGE_ROW_53_Left_184 vssd1 vssd1 vccd1 vccd1 sky130_fd_sc_hd__decap_3
X_05869_ FPGA_INST.cell2.SB0.route_sel\[66\] FPGA_INST.cell2.SB0.route_sel\[67\] vssd1
+ vssd1 vccd1 vccd1 _02149_ sky130_fd_sc_hd__nand2_1
XANTENNA_fanout351_X net351 vssd1 vssd1 vccd1 vccd1 sky130_fd_sc_hd__diode_2
X_07608_ _03532_ _03781_ vssd1 vssd1 vccd1 vccd1 _03862_ sky130_fd_sc_hd__nor2_1
XANTENNA_fanout828_A net831 vssd1 vssd1 vccd1 vccd1 sky130_fd_sc_hd__diode_2
XFILLER_53_36 vssd1 vssd1 vccd1 vccd1 sky130_fd_sc_hd__fill_1
XFILLER_53_25 vssd1 vssd1 vccd1 vccd1 sky130_fd_sc_hd__fill_2
XANTENNA__05532__A0 net14 vssd1 vssd1 vccd1 vccd1 sky130_fd_sc_hd__diode_2
X_08588_ _03787_ _04793_ _04796_ vssd1 vssd1 vccd1 vccd1 _04797_ sky130_fd_sc_hd__a21oi_1
XTAP_TAPCELL_ROW_37_795 vssd1 vccd1 sky130_fd_sc_hd__tapvpwrvgnd_1
X_07539_ FPGA_INST.cell0.SB0.route_sel\[76\] FPGA_INST.cell0.SB0.route_sel\[77\] vssd1
+ vssd1 vccd1 vccd1 _03794_ sky130_fd_sc_hd__or2_1
X_10550_ FPGA_INST.cell2.SB0.route_sel\[122\] FPGA_INST.cell2.SB0.route_sel\[123\]
+ net249 vssd1 vssd1 vccd1 vccd1 _01429_ sky130_fd_sc_hd__mux2_1
X_09209_ FPGA_INST.cell2.CB_1.config_dataB\[6\] net517 net374 vssd1 vssd1 vccd1 vccd1
+ _00122_ sky130_fd_sc_hd__mux2_1
X_10481_ FPGA_INST.cell2.SB0.route_sel\[53\] FPGA_INST.cell2.SB0.route_sel\[54\] net194
+ vssd1 vssd1 vccd1 vccd1 _01360_ sky130_fd_sc_hd__mux2_1
XPHY_EDGE_ROW_62_Left_193 vssd1 vssd1 vccd1 vccd1 sky130_fd_sc_hd__decap_3
XFILLER_123_503 vssd1 vssd1 vccd1 vccd1 sky130_fd_sc_hd__fill_1
XTAP_TAPCELL_ROW_75_1336 vssd1 vccd1 sky130_fd_sc_hd__tapvpwrvgnd_1
XTAP_TAPCELL_ROW_9_410 vssd1 vccd1 sky130_fd_sc_hd__tapvpwrvgnd_1
X_12151_ net934 _01497_ net718 vssd1 vssd1 vccd1 vccd1 FPGA_INST.cell3.CB_1.config_dataA\[13\]
+ sky130_fd_sc_hd__dfstp_1
XANTENNA__10055__S net184 vssd1 vssd1 vccd1 vccd1 sky130_fd_sc_hd__diode_2
X_11102_ net840 _00452_ net624 vssd1 vssd1 vccd1 vccd1 FPGA_INST.cell1.LE_0B.config_data\[15\]
+ sky130_fd_sc_hd__dfrtp_1
X_12082_ net861 _01428_ net644 vssd1 vssd1 vccd1 vccd1 FPGA_INST.cell2.SB0.route_sel\[122\]
+ sky130_fd_sc_hd__dfstp_1
X_11033_ net814 _00383_ net599 vssd1 vssd1 vccd1 vccd1 FPGA_INST.cell1.LEI0.config_data\[18\]
+ sky130_fd_sc_hd__dfrtp_1
XFILLER_89_483 vccd1 vssd1 vccd1 vssd1 sky130_ef_sc_hd__decap_40_12
XFILLER_89_461 vssd1 vssd1 vccd1 vccd1 sky130_fd_sc_hd__fill_1
XFILLER_77_612 vssd1 vssd1 vccd1 vccd1 sky130_fd_sc_hd__fill_4
XFILLER_77_645 vssd1 vssd1 vccd1 vccd1 sky130_fd_sc_hd__fill_1
XFILLER_76_166 vssd1 vssd1 vccd1 vccd1 sky130_fd_sc_hd__fill_1
XFILLER_49_369 vssd1 vssd1 vccd1 vccd1 sky130_fd_sc_hd__fill_4
XANTENNA__09501__A2 net523 vssd1 vssd1 vccd1 vccd1 sky130_fd_sc_hd__diode_2
X_11935_ net914 _01281_ net698 vssd1 vssd1 vccd1 vccd1 FPGA_INST.cell3.CB_1.config_dataB\[0\]
+ sky130_fd_sc_hd__dfstp_1
XFILLER_91_169 vssd1 vssd1 vccd1 vccd1 sky130_fd_sc_hd__fill_4
XFILLER_57_391 vssd1 vssd1 vccd1 vccd1 sky130_fd_sc_hd__fill_1
XFILLER_45_542 vssd1 vssd1 vccd1 vccd1 sky130_fd_sc_hd__fill_2
XTAP_TAPCELL_ROW_86_1487 vssd1 vccd1 sky130_fd_sc_hd__tapvpwrvgnd_1
XFILLER_60_501 vssd1 vssd1 vccd1 vccd1 sky130_fd_sc_hd__fill_4
XFILLER_32_203 vssd1 vssd1 vccd1 vccd1 sky130_fd_sc_hd__fill_1
X_11866_ net914 _01212_ net698 vssd1 vssd1 vccd1 vccd1 FPGA_INST.cell3.LEI0.config_data\[46\]
+ sky130_fd_sc_hd__dfrtp_1
X_10817_ net821 _00167_ net605 vssd1 vssd1 vccd1 vccd1 FPGA_INST.cell1.SB0.route_sel\[26\]
+ sky130_fd_sc_hd__dfstp_1
X_11797_ net876 _01143_ net659 vssd1 vssd1 vccd1 vccd1 FPGA_INST.io_east_oeb\[14\]
+ sky130_fd_sc_hd__dfrtp_1
XANTENNA__06009__A net352 vssd1 vssd1 vccd1 vccd1 sky130_fd_sc_hd__diode_2
XFILLER_13_483 vssd1 vssd1 vccd1 vccd1 sky130_fd_sc_hd__fill_2
XTAP_TAPCELL_ROW_15_489 vssd1 vccd1 sky130_fd_sc_hd__tapvpwrvgnd_1
X_10748_ net885 _00098_ net669 vssd1 vssd1 vccd1 vccd1 FPGA_INST.cell2.LE_1A.config_data\[3\]
+ sky130_fd_sc_hd__dfrtp_1
X_10679_ net874 _00029_ net658 vssd1 vssd1 vccd1 vccd1 FPGA_INST.cell2.LEI0.config_data\[28\]
+ sky130_fd_sc_hd__dfrtp_1
XTAP_TAPCELL_ROW_130_2120 vssd1 vccd1 sky130_fd_sc_hd__tapvpwrvgnd_1
XFILLER_5_671 vssd1 vssd1 vccd1 vccd1 sky130_fd_sc_hd__fill_1
XANTENNA__08791__A3 _01792_ vssd1 vssd1 vccd1 vccd1 sky130_fd_sc_hd__diode_2
XFILLER_4_181 vssd1 vssd1 vccd1 vccd1 sky130_fd_sc_hd__fill_2
XANTENNA__10335__A0 FPGA_INST.cell2.SB0.config_data_out vssd1 vssd1 vccd1 vccd1 sky130_fd_sc_hd__diode_2
XFILLER_4_85 vssd1 vssd1 vccd1 vccd1 sky130_fd_sc_hd__fill_8
X_06910_ _02429_ _03163_ _03165_ _02465_ FPGA_INST.cell0.CB_0.config_dataB\[12\] vssd1
+ vssd1 vccd1 vccd1 _03178_ sky130_fd_sc_hd__a221o_1
X_07890_ net471 net473 vssd1 vssd1 vccd1 vccd1 _04118_ sky130_fd_sc_hd__nand2b_2
XFILLER_95_431 vssd1 vssd1 vccd1 vccd1 sky130_fd_sc_hd__fill_8
XANTENNA__06003__A1 _02273_ vssd1 vssd1 vccd1 vccd1 sky130_fd_sc_hd__diode_2
XANTENNA__05583__A net135 vssd1 vssd1 vccd1 vccd1 sky130_fd_sc_hd__diode_2
XTAP_TAPCELL_ROW_128_2071 vssd1 vccd1 sky130_fd_sc_hd__tapvpwrvgnd_1
XFILLER_110_775 vssd1 vssd1 vccd1 vccd1 sky130_fd_sc_hd__fill_2
XFILLER_67_155 vssd1 vssd1 vccd1 vccd1 sky130_fd_sc_hd__fill_4
X_06841_ _03103_ _03108_ _03100_ vssd1 vssd1 vccd1 vccd1 _03109_ sky130_fd_sc_hd__a21o_1
X_09560_ FPGA_INST.cell1.LE_1A.config_data\[9\] FPGA_INST.cell1.LE_1A.config_data\[10\]
+ net204 vssd1 vssd1 vccd1 vccd1 _00469_ sky130_fd_sc_hd__mux2_1
X_06772_ _01597_ _03043_ _03045_ _03042_ vssd1 vssd1 vccd1 vccd1 _03046_ sky130_fd_sc_hd__o211a_1
X_08511_ FPGA_INST.cell3.CB_1.config_dataA\[3\] FPGA_INST.cell3.CB_1.config_dataA\[2\]
+ FPGA_INST.cell3.CB_1.config_dataA\[1\] FPGA_INST.cell3.CB_1.config_dataA\[0\] vssd1
+ vssd1 vccd1 vccd1 _04724_ sky130_fd_sc_hd__or4b_2
X_09491_ FPGA_INST.cell1.LEI0.config_data\[37\] FPGA_INST.cell1.LEI0.config_data\[38\]
+ net215 vssd1 vssd1 vccd1 vccd1 _00403_ sky130_fd_sc_hd__mux2_1
X_05723_ net15 net125 _02000_ vssd1 vssd1 vccd1 vccd1 _02003_ sky130_fd_sc_hd__mux2_1
X_08442_ FPGA_INST.cell1.LEI0.config_data\[8\] _04658_ _04659_ FPGA_INST.cell1.CB_1.config_dataA\[4\]
+ vssd1 vssd1 vccd1 vccd1 _04660_ sky130_fd_sc_hd__o211ai_4
X_05654_ FPGA_INST.cell0.SB0.route_sel\[101\] FPGA_INST.cell0.SB0.route_sel\[100\]
+ vssd1 vssd1 vccd1 vccd1 _01934_ sky130_fd_sc_hd__nand2b_1
XFILLER_23_225 vssd1 vssd1 vccd1 vccd1 sky130_fd_sc_hd__fill_1
XANTENNA__08059__A2 FPGA_INST.bus3_1\[14\] vssd1 vssd1 vccd1 vccd1 sky130_fd_sc_hd__diode_2
XANTENNA_fanout144_A net145 vssd1 vssd1 vccd1 vccd1 sky130_fd_sc_hd__diode_2
X_08373_ net443 _03720_ vssd1 vssd1 vccd1 vccd1 _04595_ sky130_fd_sc_hd__nand2_1
XFILLER_23_28 vssd1 vssd1 vccd1 vccd1 sky130_fd_sc_hd__fill_4
X_05585_ _01863_ _01864_ vssd1 vssd1 vccd1 vccd1 _01865_ sky130_fd_sc_hd__or2_1
XTAP_TAPCELL_ROW_34_754 vssd1 vccd1 sky130_fd_sc_hd__tapvpwrvgnd_1
XTAP_TAPCELL_ROW_34_765 vssd1 vccd1 sky130_fd_sc_hd__tapvpwrvgnd_1
XANTENNA__08118__B _03728_ vssd1 vssd1 vccd1 vccd1 sky130_fd_sc_hd__diode_2
X_07324_ FPGA_INST.cell3.SB0.route_sel\[24\] FPGA_INST.cell3.SB0.route_sel\[25\] _01695_
+ FPGA_INST.cell3.SB0.route_sel\[27\] _03584_ vssd1 vssd1 vccd1 vccd1 _03585_ sky130_fd_sc_hd__o221a_1
X_07255_ FPGA_INST.cell1.SB0.route_sel\[22\] FPGA_INST.cell1.SB0.route_sel\[23\] vssd1
+ vssd1 vccd1 vccd1 _03517_ sky130_fd_sc_hd__nand2b_1
XANTENNA_fanout311_A net315 vssd1 vssd1 vccd1 vccd1 sky130_fd_sc_hd__diode_2
X_06206_ FPGA_INST.cell2.SB0.route_sel\[6\] _01549_ FPGA_INST.cell2.SB0.route_sel\[2\]
+ FPGA_INST.cell2.SB0.route_sel\[3\] _02485_ vssd1 vssd1 vccd1 vccd1 _02486_ sky130_fd_sc_hd__o221a_1
XFILLER_117_341 vssd1 vssd1 vccd1 vccd1 sky130_fd_sc_hd__fill_1
X_07186_ FPGA_INST.cell3.SB0.route_sel\[10\] FPGA_INST.cell3.SB0.route_sel\[11\] vssd1
+ vssd1 vccd1 vccd1 _03449_ sky130_fd_sc_hd__nand2_1
X_06137_ net165 net157 vssd1 vssd1 vccd1 vccd1 _02417_ sky130_fd_sc_hd__nor2_1
XFILLER_78_409 vssd1 vssd1 vccd1 vccd1 sky130_fd_sc_hd__fill_1
XTAP_TAPCELL_ROW_57_1077 vssd1 vccd1 sky130_fd_sc_hd__tapvpwrvgnd_1
X_06068_ FPGA_INST.cell0.SB0.route_sel\[29\] FPGA_INST.cell0.SB0.route_sel\[28\] vssd1
+ vssd1 vccd1 vccd1 _02348_ sky130_fd_sc_hd__nand2b_1
Xfanout400 FPGA_INST.cell3.CB_0.config_dataA\[1\] vssd1 vssd1 vccd1 vccd1 net400 sky130_fd_sc_hd__buf_2
XANTENNA__06793__A2 FPGA_INST.bus3_2\[2\] vssd1 vssd1 vccd1 vccd1 sky130_fd_sc_hd__diode_2
Xfanout411 FPGA_INST.cell0.CB_1.config_dataA\[1\] vssd1 vssd1 vccd1 vccd1 net411 sky130_fd_sc_hd__buf_2
Xfanout422 FPGA_INST.cell0.CB_0.config_dataB\[5\] vssd1 vssd1 vccd1 vccd1 net422 sky130_fd_sc_hd__clkbuf_2
XANTENNA_fanout778_A net790 vssd1 vssd1 vccd1 vccd1 sky130_fd_sc_hd__diode_2
Xfanout455 FPGA_INST.cell1.CB_0.config_dataB\[10\] vssd1 vssd1 vccd1 vccd1 net455
+ sky130_fd_sc_hd__clkbuf_2
XFILLER_101_742 vssd1 vssd1 vccd1 vccd1 sky130_fd_sc_hd__fill_1
Xfanout466 FPGA_INST.cell1.CB_0.config_dataA\[10\] vssd1 vssd1 vccd1 vccd1 net466
+ sky130_fd_sc_hd__buf_2
XFILLER_86_442 vccd1 vssd1 vccd1 vssd1 sky130_ef_sc_hd__decap_40_12
XTAP_TAPCELL_ROW_70_1266 vssd1 vccd1 sky130_fd_sc_hd__tapvpwrvgnd_1
Xfanout444 FPGA_INST.cell0.CB_1.config_dataB\[6\] vssd1 vssd1 vccd1 vccd1 net444 sky130_fd_sc_hd__buf_2
Xfanout433 FPGA_INST.cell0.CB_0.config_dataA\[5\] vssd1 vssd1 vccd1 vccd1 net433 sky130_fd_sc_hd__clkbuf_2
XANTENNA_fanout945_A net946 vssd1 vssd1 vccd1 vccd1 sky130_fd_sc_hd__diode_2
XFILLER_86_475 vssd1 vssd1 vccd1 vccd1 sky130_fd_sc_hd__fill_1
Xfanout477 FPGA_INST.cell2.CB_1.config_dataA\[11\] vssd1 vssd1 vccd1 vccd1 net477
+ sky130_fd_sc_hd__buf_2
XFILLER_48_69 vssd1 vssd1 vccd1 vccd1 sky130_fd_sc_hd__fill_1
Xfanout499 FPGA_INST.cell2.CB_0.config_dataA\[16\] vssd1 vssd1 vccd1 vccd1 net499
+ sky130_fd_sc_hd__buf_2
Xfanout488 net489 vssd1 vssd1 vccd1 vccd1 net488 sky130_fd_sc_hd__buf_2
X_09827_ FPGA_INST.cell0.LEI0.config_data\[5\] FPGA_INST.cell0.LEI0.config_data\[6\]
+ net174 vssd1 vssd1 vccd1 vccd1 _00735_ sky130_fd_sc_hd__mux2_1
X_09758_ FPGA_INST.cell1.CB_0.config_dataB\[8\] FPGA_INST.cell1.CB_0.config_dataB\[9\]
+ net231 vssd1 vssd1 vccd1 vccd1 _00667_ sky130_fd_sc_hd__mux2_1
X_08709_ FPGA_INST.cell3.LEI0.config_data\[24\] net79 vssd1 vssd1 vccd1 vccd1 _04918_
+ sky130_fd_sc_hd__nand2_1
XANTENNA_fanout733_X net733 vssd1 vssd1 vccd1 vccd1 sky130_fd_sc_hd__diode_2
X_11720_ net902 _01066_ net686 vssd1 vssd1 vccd1 vccd1 FPGA_INST.cell3.SB0.route_sel\[90\]
+ sky130_fd_sc_hd__dfstp_1
XANTENNA__08298__A2 FPGA_INST.bus1_0\[14\] vssd1 vssd1 vccd1 vccd1 sky130_fd_sc_hd__diode_2
X_09689_ FPGA_INST.cell0.SB0.route_sel\[92\] FPGA_INST.cell0.SB0.route_sel\[93\] net187
+ vssd1 vssd1 vccd1 vccd1 _00598_ sky130_fd_sc_hd__mux2_1
X_11651_ net828 _00997_ net612 vssd1 vssd1 vccd1 vccd1 FPGA_INST.cell3.SB0.route_sel\[21\]
+ sky130_fd_sc_hd__dfstp_1
XFILLER_42_589 vssd1 vssd1 vccd1 vccd1 sky130_fd_sc_hd__fill_8
XFILLER_30_729 vssd1 vssd1 vccd1 vccd1 sky130_fd_sc_hd__fill_2
X_10602_ FPGA_INST.cell3.CB_0.config_dataB\[21\] FPGA_INST.cell3.CB_0.config_dataB\[22\]
+ net284 vssd1 vssd1 vccd1 vccd1 _01481_ sky130_fd_sc_hd__mux2_1
XANTENNA__07258__B1 _03519_ vssd1 vssd1 vccd1 vccd1 sky130_fd_sc_hd__diode_2
X_11582_ net760 _00932_ net545 vssd1 vssd1 vccd1 vccd1 FPGA_INST.cell0.CB_1.config_dataA\[1\]
+ sky130_fd_sc_hd__dfstp_1
Xfanout84 _01786_ vssd1 vssd1 vccd1 vccd1 net84 sky130_fd_sc_hd__buf_2
XPHY_EDGE_ROW_70_Left_201 vssd1 vssd1 vccd1 vccd1 sky130_fd_sc_hd__decap_3
X_10533_ FPGA_INST.cell2.SB0.route_sel\[105\] FPGA_INST.cell2.SB0.route_sel\[106\]
+ net244 vssd1 vssd1 vccd1 vccd1 _01412_ sky130_fd_sc_hd__mux2_1
XTAP_TAPCELL_ROW_12_448 vssd1 vccd1 sky130_fd_sc_hd__tapvpwrvgnd_1
XFILLER_89_32 vssd1 vssd1 vccd1 vccd1 sky130_fd_sc_hd__fill_4
X_10464_ FPGA_INST.cell2.SB0.route_sel\[36\] FPGA_INST.cell2.SB0.route_sel\[37\] net243
+ vssd1 vssd1 vccd1 vccd1 _01343_ sky130_fd_sc_hd__mux2_1
X_10395_ FPGA_INST.cell3.LE_1A.config_data\[13\] FPGA_INST.cell3.LE_1A.config_data\[14\]
+ net304 vssd1 vssd1 vccd1 vccd1 _01274_ sky130_fd_sc_hd__mux2_1
XFILLER_108_363 vssd1 vssd1 vccd1 vccd1 sky130_fd_sc_hd__fill_1
XANTENNA__07025__A3 FPGA_INST.bus2_0\[11\] vssd1 vssd1 vccd1 vccd1 sky130_fd_sc_hd__diode_2
XFILLER_123_322 vccd1 vssd1 vccd1 vssd1 sky130_ef_sc_hd__decap_40_12
X_12134_ net912 _01480_ net696 vssd1 vssd1 vccd1 vccd1 FPGA_INST.cell3.CB_0.config_dataB\[21\]
+ sky130_fd_sc_hd__dfstp_1
XFILLER_97_718 vssd1 vssd1 vccd1 vccd1 sky130_fd_sc_hd__fill_1
XANTENNA__06233__A1 net4 vssd1 vssd1 vccd1 vccd1 sky130_fd_sc_hd__diode_2
XFILLER_111_517 vssd1 vssd1 vccd1 vccd1 sky130_fd_sc_hd__fill_4
XFILLER_77_431 vssd1 vssd1 vccd1 vccd1 sky130_fd_sc_hd__fill_4
X_12065_ net853 _01411_ net638 vssd1 vssd1 vccd1 vccd1 FPGA_INST.cell2.SB0.route_sel\[105\]
+ sky130_fd_sc_hd__dfstp_1
X_11016_ net812 _00366_ net597 vssd1 vssd1 vccd1 vccd1 FPGA_INST.cell1.LEI0.config_data\[1\]
+ sky130_fd_sc_hd__dfrtp_1
XTAP_TAPCELL_ROW_88_1516 vssd1 vccd1 sky130_fd_sc_hd__tapvpwrvgnd_1
XFILLER_37_328 vssd1 vssd1 vccd1 vccd1 sky130_fd_sc_hd__fill_2
XANTENNA__06946__B _02350_ vssd1 vssd1 vccd1 vccd1 sky130_fd_sc_hd__diode_2
XFILLER_18_564 vssd1 vssd1 vccd1 vccd1 sky130_fd_sc_hd__fill_1
X_11918_ net943 _01264_ net727 vssd1 vssd1 vccd1 vccd1 FPGA_INST.cell3.LE_1A.config_data\[4\]
+ sky130_fd_sc_hd__dfrtp_1
XFILLER_60_320 vssd1 vssd1 vccd1 vccd1 sky130_fd_sc_hd__fill_1
XFILLER_18_597 vssd1 vssd1 vccd1 vccd1 sky130_fd_sc_hd__fill_1
X_11849_ net934 _01195_ net718 vssd1 vssd1 vccd1 vccd1 FPGA_INST.cell3.LEI0.config_data\[29\]
+ sky130_fd_sc_hd__dfrtp_1
XFILLER_60_342 vssd1 vssd1 vccd1 vccd1 sky130_fd_sc_hd__fill_1
XFILLER_33_556 vssd1 vssd1 vccd1 vccd1 sky130_fd_sc_hd__fill_4
XPHY_EDGE_ROW_109_Left_240 vssd1 vssd1 vccd1 vccd1 sky130_fd_sc_hd__decap_3
X_05370_ FPGA_INST.cell1.SB0.route_sel\[78\] vssd1 vssd1 vccd1 vccd1 _01652_ sky130_fd_sc_hd__inv_2
XFILLER_20_206 vssd1 vssd1 vccd1 vccd1 sky130_fd_sc_hd__fill_8
XTAP_TAPCELL_ROW_31_713 vssd1 vccd1 sky130_fd_sc_hd__tapvpwrvgnd_1
XFILLER_119_617 vssd1 vssd1 vccd1 vccd1 sky130_fd_sc_hd__fill_2
XANTENNA__07410__X FPGA_INST.bus3_2\[5\] vssd1 vssd1 vccd1 vccd1 sky130_fd_sc_hd__diode_2
XFILLER_118_138 vssd1 vssd1 vccd1 vccd1 sky130_fd_sc_hd__fill_2
XTAP_TAPCELL_ROW_99_1667 vssd1 vccd1 sky130_fd_sc_hd__tapvpwrvgnd_1
X_07040_ FPGA_INST.cell0.CB_0.config_dataA\[3\] FPGA_INST.cell0.CB_0.config_dataA\[2\]
+ vssd1 vssd1 vccd1 vccd1 _03306_ sky130_fd_sc_hd__or2_1
XTAP_TAPCELL_ROW_110_1823 vssd1 vccd1 sky130_fd_sc_hd__tapvpwrvgnd_1
X_08991_ _05167_ _02327_ vssd1 vssd1 vccd1 vccd1 FPGA_INST.bus2_0\[5\] sky130_fd_sc_hd__and2b_4
XFILLER_114_399 vssd1 vssd1 vccd1 vccd1 sky130_fd_sc_hd__fill_1
X_07942_ FPGA_INST.bus3_1\[12\] FPGA_INST.bus3_1\[13\] FPGA_INST.bus3_1\[14\] FPGA_INST.bus3_1\[15\]
+ net467 FPGA_INST.cell1.CB_0.config_dataA\[11\] vssd1 vssd1 vccd1 vccd1 _04170_ sky130_fd_sc_hd__mux4_1
X_07873_ FPGA_INST.bus3_1\[12\] FPGA_INST.bus3_1\[13\] FPGA_INST.bus3_1\[14\] FPGA_INST.bus3_1\[15\]
+ net470 FPGA_INST.cell1.CB_0.config_dataA\[6\] vssd1 vssd1 vccd1 vccd1 _04101_ sky130_fd_sc_hd__mux4_1
XFILLER_96_751 vssd1 vssd1 vccd1 vccd1 sky130_fd_sc_hd__fill_4
XANTENNA__06202__A net135 vssd1 vssd1 vccd1 vccd1 sky130_fd_sc_hd__diode_2
XFILLER_95_261 vssd1 vssd1 vccd1 vccd1 sky130_fd_sc_hd__fill_1
XFILLER_68_497 vssd1 vssd1 vccd1 vccd1 sky130_fd_sc_hd__fill_4
X_09612_ FPGA_INST.cell0.SB0.route_sel\[16\] FPGA_INST.cell0.SB0.route_sel\[15\] net323
+ vssd1 vssd1 vccd1 vccd1 _00521_ sky130_fd_sc_hd__mux2_1
XFILLER_55_103 vssd1 vssd1 vccd1 vccd1 sky130_fd_sc_hd__fill_1
X_06824_ net421 _02233_ FPGA_INST.cell0.CB_0.config_dataB\[6\] vssd1 vssd1 vccd1 vccd1
+ _03092_ sky130_fd_sc_hd__o21ai_1
XFILLER_28_328 vssd1 vssd1 vccd1 vccd1 sky130_fd_sc_hd__fill_1
XTAP_TAPCELL_ROW_39_824 vssd1 vccd1 sky130_fd_sc_hd__tapvpwrvgnd_1
XTAP_TAPCELL_ROW_39_835 vssd1 vccd1 sky130_fd_sc_hd__tapvpwrvgnd_1
X_09543_ FPGA_INST.cell1.LE_0B.config_data\[15\] FPGA_INST.cell1.LE_0B.config_data\[16\]
+ net232 vssd1 vssd1 vccd1 vccd1 _00453_ sky130_fd_sc_hd__mux2_1
XFILLER_55_136 vssd1 vssd1 vccd1 vccd1 sky130_fd_sc_hd__fill_4
X_06755_ _01796_ _01800_ _01801_ _01799_ net513 net514 vssd1 vssd1 vccd1 vccd1 _03029_
+ sky130_fd_sc_hd__mux4_1
XANTENNA_fanout261_A net267 vssd1 vssd1 vccd1 vccd1 sky130_fd_sc_hd__diode_2
XANTENNA_fanout359_A net363 vssd1 vssd1 vccd1 vccd1 sky130_fd_sc_hd__diode_2
X_09474_ FPGA_INST.cell1.LEI0.config_data\[20\] FPGA_INST.cell1.LEI0.config_data\[21\]
+ net215 vssd1 vssd1 vccd1 vccd1 _00386_ sky130_fd_sc_hd__mux2_1
XTAP_TAPCELL_ROW_108_1796 vssd1 vccd1 sky130_fd_sc_hd__tapvpwrvgnd_1
X_06686_ FPGA_INST.cell2.LE_1A.config_data\[16\] _02959_ _02960_ net156 vssd1 vssd1
+ vccd1 vccd1 FPGA_INST.cell2.CB_1.le_outA sky130_fd_sc_hd__o211a_1
X_05706_ _01971_ _01985_ _01969_ vssd1 vssd1 vccd1 vccd1 _01986_ sky130_fd_sc_hd__a21o_1
X_08425_ _04646_ _04639_ _04635_ vssd1 vssd1 vccd1 vccd1 _04647_ sky130_fd_sc_hd__mux2_1
X_05637_ FPGA_INST.cell0.CB_0.config_dataA\[24\] FPGA_INST.cell0.CB_0.config_dataA\[21\]
+ FPGA_INST.cell0.CB_0.config_dataA\[20\] vssd1 vssd1 vccd1 vccd1 _01917_ sky130_fd_sc_hd__nor3_1
XTAP_TAPCELL_ROW_121_1974 vssd1 vccd1 sky130_fd_sc_hd__tapvpwrvgnd_1
XANTENNA_fanout147_X net147 vssd1 vssd1 vccd1 vccd1 sky130_fd_sc_hd__diode_2
X_08356_ _03759_ _03797_ _03840_ _03876_ net443 net441 vssd1 vssd1 vccd1 vccd1 _04578_
+ sky130_fd_sc_hd__mux4_1
XFILLER_11_206 vssd1 vssd1 vccd1 vccd1 sky130_fd_sc_hd__fill_1
XFILLER_24_589 vssd1 vssd1 vccd1 vccd1 sky130_fd_sc_hd__fill_4
XANTENNA__07320__X _03581_ vssd1 vssd1 vccd1 vccd1 sky130_fd_sc_hd__diode_2
X_07307_ _03555_ _03565_ _03567_ net221 vssd1 vssd1 vccd1 vccd1 _03568_ sky130_fd_sc_hd__o211a_4
X_05568_ _01845_ _01847_ vssd1 vssd1 vccd1 vccd1 _01848_ sky130_fd_sc_hd__nor2_1
X_05499_ net736 vssd1 vssd1 vccd1 vccd1 _01781_ sky130_fd_sc_hd__inv_2
XANTENNA_fanout314_X net314 vssd1 vssd1 vccd1 vccd1 sky130_fd_sc_hd__diode_2
XTAP_TAPCELL_ROW_59_1106 vssd1 vccd1 sky130_fd_sc_hd__tapvpwrvgnd_1
XFILLER_50_48 vssd1 vssd1 vccd1 vccd1 sky130_fd_sc_hd__fill_1
XFILLER_50_37 vssd1 vssd1 vccd1 vccd1 sky130_fd_sc_hd__fill_1
XFILLER_20_795 vssd1 vssd1 vccd1 vccd1 sky130_fd_sc_hd__fill_1
X_08287_ _04510_ _04509_ _04440_ vssd1 vssd1 vccd1 vccd1 _04511_ sky130_fd_sc_hd__mux2_1
XFILLER_119_6 vccd1 vssd1 vccd1 vssd1 sky130_ef_sc_hd__decap_40_12
X_07238_ net146 _03400_ _03498_ _03497_ vssd1 vssd1 vccd1 vccd1 _03500_ sky130_fd_sc_hd__a31oi_1
XANTENNA__06463__A1 net6 vssd1 vssd1 vccd1 vccd1 sky130_fd_sc_hd__diode_2
X_07169_ FPGA_INST.cell3.CB_0.config_dataB\[21\] FPGA_INST.cell3.CB_0.config_dataB\[20\]
+ FPGA_INST.cell3.CB_0.config_dataB\[24\] vssd1 vssd1 vccd1 vccd1 _03433_ sky130_fd_sc_hd__nor3_1
XANTENNA_fanout895_A net899 vssd1 vssd1 vccd1 vccd1 sky130_fd_sc_hd__diode_2
XANTENNA__07007__A3 FPGA_INST.bus2_0\[11\] vssd1 vssd1 vccd1 vccd1 sky130_fd_sc_hd__diode_2
XANTENNA__07412__B1 net79 vssd1 vssd1 vccd1 vccd1 sky130_fd_sc_hd__diode_2
XANTENNA__06215__A1 net6 vssd1 vssd1 vccd1 vccd1 sky130_fd_sc_hd__diode_2
XFILLER_1_6 vccd1 vssd1 vccd1 vssd1 sky130_ef_sc_hd__decap_40_12
XANTENNA__09394__S net357 vssd1 vssd1 vccd1 vccd1 sky130_fd_sc_hd__diode_2
XANTENNA__07963__A1 _03421_ vssd1 vssd1 vccd1 vccd1 sky130_fd_sc_hd__diode_2
X_10180_ FPGA_INST.cell3.SB0.route_sel\[85\] FPGA_INST.cell3.SB0.route_sel\[84\] net373
+ vssd1 vssd1 vccd1 vccd1 _01061_ sky130_fd_sc_hd__mux2_1
XANTENNA_fanout683_X net683 vssd1 vssd1 vccd1 vccd1 sky130_fd_sc_hd__diode_2
Xfanout230 net233 vssd1 vssd1 vccd1 vccd1 net230 sky130_fd_sc_hd__clkbuf_4
XANTENNA__07963__B2 _03475_ vssd1 vssd1 vccd1 vccd1 sky130_fd_sc_hd__diode_2
XANTENNA__10333__S net737 vssd1 vssd1 vccd1 vccd1 sky130_fd_sc_hd__diode_2
XFILLER_87_740 vssd1 vssd1 vccd1 vccd1 sky130_fd_sc_hd__fill_8
XFILLER_59_431 vssd1 vssd1 vccd1 vccd1 sky130_fd_sc_hd__fill_1
Xfanout241 net268 vssd1 vssd1 vccd1 vccd1 net241 sky130_fd_sc_hd__buf_2
XFILLER_87_762 vssd1 vssd1 vccd1 vccd1 sky130_fd_sc_hd__fill_2
Xfanout274 net276 vssd1 vssd1 vccd1 vccd1 net274 sky130_fd_sc_hd__clkbuf_4
Xfanout263 net266 vssd1 vssd1 vccd1 vccd1 net263 sky130_fd_sc_hd__clkbuf_4
Xfanout252 net267 vssd1 vssd1 vccd1 vccd1 net252 sky130_fd_sc_hd__clkbuf_4
Xfanout296 net300 vssd1 vssd1 vccd1 vccd1 net296 sky130_fd_sc_hd__clkbuf_4
Xfanout285 net306 vssd1 vssd1 vccd1 vccd1 net285 sky130_fd_sc_hd__clkbuf_4
XFILLER_101_594 vssd1 vssd1 vccd1 vccd1 sky130_fd_sc_hd__fill_2
XFILLER_101_561 vssd1 vssd1 vccd1 vccd1 sky130_fd_sc_hd__fill_1
XFILLER_75_23 vssd1 vssd1 vccd1 vccd1 sky130_fd_sc_hd__fill_4
XTAP_TAPCELL_ROW_17_518 vssd1 vccd1 sky130_fd_sc_hd__tapvpwrvgnd_1
XFILLER_34_309 vssd1 vssd1 vccd1 vccd1 sky130_fd_sc_hd__fill_2
XTAP_TAPCELL_ROW_83_1446 vssd1 vccd1 sky130_fd_sc_hd__tapvpwrvgnd_1
XANTENNA__05670__B _01947_ vssd1 vssd1 vccd1 vccd1 sky130_fd_sc_hd__diode_2
X_11703_ net901 _01049_ net685 vssd1 vssd1 vccd1 vccd1 FPGA_INST.cell3.SB0.route_sel\[73\]
+ sky130_fd_sc_hd__dfstp_2
XFILLER_30_504 vssd1 vssd1 vccd1 vccd1 sky130_fd_sc_hd__fill_2
XANTENNA__08691__A2 net25 vssd1 vssd1 vccd1 vccd1 sky130_fd_sc_hd__diode_2
XFILLER_91_99 vssd1 vssd1 vccd1 vccd1 sky130_fd_sc_hd__fill_2
X_11634_ net896 _00980_ net680 vssd1 vssd1 vccd1 vccd1 FPGA_INST.cell3.SB0.route_sel\[4\]
+ sky130_fd_sc_hd__dfstp_1
XANTENNA__08428__C1 net155 vssd1 vssd1 vccd1 vccd1 sky130_fd_sc_hd__diode_2
X_11565_ net771 _00915_ net556 vssd1 vssd1 vccd1 vccd1 FPGA_INST.cell0.CB_0.config_dataB\[9\]
+ sky130_fd_sc_hd__dfstp_1
XFILLER_116_609 vccd1 vssd1 vccd1 vssd1 sky130_ef_sc_hd__decap_40_12
XANTENNA__07288__A_N FPGA_INST.cell1.CB_0.config_dataB\[24\] vssd1 vssd1 vccd1 vccd1
+ sky130_fd_sc_hd__diode_2
X_11496_ net792 _00846_ net577 vssd1 vssd1 vccd1 vccd1 FPGA_INST.cell0.CB_1.config_dataB\[2\]
+ sky130_fd_sc_hd__dfstp_1
XANTENNA__10650__SET_B net734 vssd1 vssd1 vccd1 vccd1 sky130_fd_sc_hd__diode_2
X_10516_ FPGA_INST.cell2.SB0.route_sel\[88\] FPGA_INST.cell2.SB0.route_sel\[89\] net241
+ vssd1 vssd1 vccd1 vccd1 _01395_ sky130_fd_sc_hd__mux2_1
XFILLER_6_265 vssd1 vssd1 vccd1 vccd1 sky130_fd_sc_hd__fill_4
X_10447_ FPGA_INST.cell2.SB0.route_sel\[20\] FPGA_INST.cell2.SB0.route_sel\[19\] net350
+ vssd1 vssd1 vccd1 vccd1 _01326_ sky130_fd_sc_hd__mux2_1
XFILLER_124_686 vssd1 vssd1 vccd1 vccd1 sky130_fd_sc_hd__fill_2
X_10378_ FPGA_INST.cell3.LE_1A.dff0_out net525 _05245_ vssd1 vssd1 vccd1 vccd1 _01258_
+ sky130_fd_sc_hd__a21bo_1
XANTENNA__08502__A net155 vssd1 vssd1 vccd1 vccd1 sky130_fd_sc_hd__diode_2
XTAP_TAPCELL_ROW_94_1597 vssd1 vccd1 sky130_fd_sc_hd__tapvpwrvgnd_1
XFILLER_124_697 vssd1 vssd1 vccd1 vccd1 sky130_fd_sc_hd__fill_2
XFILLER_111_325 vssd1 vssd1 vccd1 vccd1 sky130_fd_sc_hd__fill_1
XFILLER_97_537 vssd1 vssd1 vccd1 vccd1 sky130_fd_sc_hd__fill_1
X_12117_ net921 _01463_ net705 vssd1 vssd1 vccd1 vccd1 FPGA_INST.cell3.CB_0.config_dataB\[4\]
+ sky130_fd_sc_hd__dfstp_1
XFILLER_77_250 vssd1 vssd1 vccd1 vccd1 sky130_fd_sc_hd__fill_1
XANTENNA__06022__A net112 vssd1 vssd1 vccd1 vccd1 sky130_fd_sc_hd__diode_2
X_12048_ net868 _01394_ net653 vssd1 vssd1 vccd1 vccd1 FPGA_INST.cell2.SB0.route_sel\[88\]
+ sky130_fd_sc_hd__dfstp_1
XTAP_TAPCELL_ROW_125_2030 vssd1 vccd1 sky130_fd_sc_hd__tapvpwrvgnd_1
XFILLER_65_445 vssd1 vssd1 vccd1 vccd1 sky130_fd_sc_hd__fill_1
XFILLER_93_798 vssd1 vssd1 vccd1 vccd1 sky130_fd_sc_hd__fill_1
XFILLER_92_264 vssd1 vssd1 vccd1 vccd1 sky130_fd_sc_hd__fill_8
XFILLER_65_489 vccd1 vssd1 vccd1 vssd1 sky130_ef_sc_hd__decap_40_12
XFILLER_37_169 vccd1 vssd1 vccd1 vssd1 sky130_ef_sc_hd__decap_40_12
XFILLER_80_448 vssd1 vssd1 vccd1 vccd1 sky130_fd_sc_hd__fill_1
X_06540_ net481 _02810_ _02815_ net480 vssd1 vssd1 vccd1 vccd1 _02816_ sky130_fd_sc_hd__o211a_1
XFILLER_33_320 vssd1 vssd1 vccd1 vccd1 sky130_fd_sc_hd__fill_1
XFILLER_61_673 vssd1 vssd1 vccd1 vccd1 sky130_fd_sc_hd__fill_1
X_06471_ _02744_ _02745_ _02747_ _02748_ vssd1 vssd1 vccd1 vccd1 _02749_ sky130_fd_sc_hd__o22a_1
X_05422_ FPGA_INST.cell3.SB0.route_sel\[21\] vssd1 vssd1 vccd1 vccd1 _01704_ sky130_fd_sc_hd__inv_2
X_08210_ net76 _04414_ _04433_ vssd1 vssd1 vccd1 vccd1 _04434_ sky130_fd_sc_hd__a21oi_1
XANTENNA__06693__A1 FPGA_INST.bus3_2\[13\] vssd1 vssd1 vccd1 vccd1 sky130_fd_sc_hd__diode_2
XTAP_TAPCELL_ROW_44_893 vssd1 vccd1 sky130_fd_sc_hd__tapvpwrvgnd_1
XFILLER_33_397 vssd1 vssd1 vccd1 vccd1 sky130_fd_sc_hd__fill_2
XANTENNA__08623__A2_N _04828_ vssd1 vssd1 vccd1 vccd1 sky130_fd_sc_hd__diode_2
X_09190_ FPGA_INST.cell2.LE_1A.config_data\[7\] FPGA_INST.cell2.LE_1A.config_data\[8\]
+ net266 vssd1 vssd1 vccd1 vccd1 _00103_ sky130_fd_sc_hd__mux2_1
XANTENNA__08383__S _04544_ vssd1 vssd1 vccd1 vccd1 sky130_fd_sc_hd__diode_2
X_08141_ FPGA_INST.cell1.LE_0B.config_data\[3\] FPGA_INST.cell1.LE_0B.config_data\[2\]
+ _04296_ vssd1 vssd1 vccd1 vccd1 _04367_ sky130_fd_sc_hd__mux2_1
X_05353_ FPGA_INST.cell1.SB0.route_sel\[93\] vssd1 vssd1 vccd1 vccd1 _01635_ sky130_fd_sc_hd__inv_2
X_08072_ net454 _03568_ vssd1 vssd1 vccd1 vccd1 _04298_ sky130_fd_sc_hd__nand2_1
X_05284_ FPGA_INST.cell2.SB0.route_sel\[69\] vssd1 vssd1 vccd1 vccd1 _01566_ sky130_fd_sc_hd__inv_2
XANTENNA__05653__C1 net320 vssd1 vssd1 vccd1 vccd1 sky130_fd_sc_hd__diode_2
XFILLER_20_29 vssd1 vssd1 vccd1 vccd1 sky130_fd_sc_hd__fill_4
X_07023_ net437 _02070_ vssd1 vssd1 vccd1 vccd1 _03289_ sky130_fd_sc_hd__nand2_1
XTAP_TAPCELL_ROW_54_1036 vssd1 vccd1 sky130_fd_sc_hd__tapvpwrvgnd_1
XFILLER_0_419 vssd1 vssd1 vccd1 vccd1 sky130_fd_sc_hd__fill_1
XANTENNA__10153__S net273 vssd1 vssd1 vccd1 vccd1 sky130_fd_sc_hd__diode_2
X_08974_ _01664_ FPGA_INST.cell3.SB0.route_sel\[59\] vssd1 vssd1 vccd1 vccd1 _05156_
+ sky130_fd_sc_hd__nand2_1
XANTENNA__08131__B _04049_ vssd1 vssd1 vccd1 vccd1 sky130_fd_sc_hd__diode_2
X_07925_ net465 net466 vssd1 vssd1 vccd1 vccd1 _04153_ sky130_fd_sc_hd__and2b_1
XPHY_EDGE_ROW_89_Right_89 vssd1 vssd1 vccd1 vccd1 sky130_fd_sc_hd__decap_3
XANTENNA__09942__S net327 vssd1 vssd1 vccd1 vccd1 sky130_fd_sc_hd__diode_2
XFILLER_84_710 vssd1 vssd1 vccd1 vccd1 sky130_fd_sc_hd__fill_1
XFILLER_29_615 vssd1 vssd1 vccd1 vccd1 sky130_fd_sc_hd__fill_1
X_07856_ _04083_ vssd1 vssd1 vccd1 vccd1 _04084_ sky130_fd_sc_hd__inv_2
XANTENNA__08370__A1 FPGA_INST.bus1_0\[5\] vssd1 vssd1 vccd1 vccd1 sky130_fd_sc_hd__diode_2
XFILLER_28_136 vssd1 vssd1 vccd1 vccd1 sky130_fd_sc_hd__fill_4
X_07787_ _04035_ vssd1 vssd1 vccd1 vccd1 _04036_ sky130_fd_sc_hd__inv_2
X_06807_ _03048_ _03080_ _03046_ vssd1 vssd1 vccd1 vccd1 _03081_ sky130_fd_sc_hd__mux2_1
XFILLER_16_309 vssd1 vssd1 vccd1 vccd1 sky130_fd_sc_hd__fill_1
X_09526_ FPGA_INST.cell1.LE_1A.dff1_out net523 _05215_ vssd1 vssd1 vccd1 vccd1 _00436_
+ sky130_fd_sc_hd__a21bo_1
X_06738_ FPGA_INST.bus3_2\[0\] _02993_ _02994_ FPGA_INST.bus3_2\[1\] FPGA_INST.cell2.CB_1.config_dataB\[7\]
+ vssd1 vssd1 vccd1 vccd1 _03012_ sky130_fd_sc_hd__a221o_1
XFILLER_45_59 vssd1 vssd1 vccd1 vccd1 sky130_fd_sc_hd__fill_1
X_09457_ FPGA_INST.cell1.LEI0.config_data\[3\] FPGA_INST.cell1.LEI0.config_data\[4\]
+ net214 vssd1 vssd1 vccd1 vccd1 _00369_ sky130_fd_sc_hd__mux2_1
XANTENNA_fanout810_A net811 vssd1 vssd1 vccd1 vccd1 sky130_fd_sc_hd__diode_2
XPHY_EDGE_ROW_98_Right_98 vssd1 vssd1 vccd1 vccd1 sky130_fd_sc_hd__decap_3
XTAP_TAPCELL_ROW_65_1198 vssd1 vccd1 sky130_fd_sc_hd__tapvpwrvgnd_1
XTAP_TAPCELL_ROW_65_1187 vssd1 vccd1 sky130_fd_sc_hd__tapvpwrvgnd_1
X_08408_ _04621_ _04622_ _04628_ _04629_ vssd1 vssd1 vccd1 vccd1 _04630_ sky130_fd_sc_hd__o22a_1
X_06669_ FPGA_INST.cell2.LEI0.config_data\[44\] _02942_ _02944_ vssd1 vssd1 vccd1
+ vccd1 _02945_ sky130_fd_sc_hd__or3_1
XFILLER_12_504 vssd1 vssd1 vccd1 vccd1 sky130_fd_sc_hd__fill_1
XANTENNA__07881__A0 net154 vssd1 vssd1 vccd1 vccd1 sky130_fd_sc_hd__diode_2
X_09388_ FPGA_INST.cell2.CB_0.config_dataB\[7\] FPGA_INST.cell2.CB_0.config_dataB\[6\]
+ net357 vssd1 vssd1 vccd1 vccd1 _00301_ sky130_fd_sc_hd__mux2_1
X_08339_ net448 _03720_ vssd1 vssd1 vccd1 vccd1 _04561_ sky130_fd_sc_hd__nand2_1
X_11350_ net795 _00700_ net580 vssd1 vssd1 vccd1 vccd1 FPGA_INST.cell1.CB_1.config_dataA\[17\]
+ sky130_fd_sc_hd__dfstp_1
XANTENNA__06436__A1 net8 vssd1 vssd1 vccd1 vccd1 sky130_fd_sc_hd__diode_2
XTAP_TAPCELL_ROW_22_587 vssd1 vccd1 sky130_fd_sc_hd__tapvpwrvgnd_1
XFILLER_125_406 vssd1 vssd1 vccd1 vccd1 sky130_fd_sc_hd__fill_4
X_10301_ FPGA_INST.cell3.LEI0.config_data\[15\] FPGA_INST.cell3.LEI0.config_data\[16\]
+ net296 vssd1 vssd1 vccd1 vccd1 _01182_ sky130_fd_sc_hd__mux2_1
XFILLER_117_3 vccd1 vssd1 vccd1 vssd1 sky130_ef_sc_hd__decap_40_12
XFILLER_118_491 vssd1 vssd1 vccd1 vccd1 sky130_fd_sc_hd__fill_1
X_11281_ net786 _00631_ net571 vssd1 vssd1 vccd1 vccd1 FPGA_INST.cell0.SB0.route_sel\[126\]
+ sky130_fd_sc_hd__dfstp_1
XFILLER_106_675 vssd1 vssd1 vccd1 vccd1 sky130_fd_sc_hd__fill_1
X_10232_ FPGA_INST.io_west_oeb\[16\] FPGA_INST.io_west_oeb\[18\] net289 vssd1 vssd1
+ vccd1 vccd1 _01113_ sky130_fd_sc_hd__mux2_1
X_10163_ FPGA_INST.cell3.SB0.route_sel\[67\] FPGA_INST.cell3.SB0.route_sel\[68\] net276
+ vssd1 vssd1 vccd1 vccd1 _01044_ sky130_fd_sc_hd__mux2_1
XANTENNA__10063__S net327 vssd1 vssd1 vccd1 vccd1 sky130_fd_sc_hd__diode_2
XFILLER_87_581 vccd1 vssd1 vccd1 vssd1 sky130_ef_sc_hd__decap_40_12
XFILLER_59_272 vssd1 vssd1 vccd1 vccd1 sky130_fd_sc_hd__fill_4
X_10094_ FPGA_INST.cell0.LE_1B.reset_val FPGA_INST.cell0.LE_1B.reset_mode net177 vssd1
+ vssd1 vccd1 vccd1 _00975_ sky130_fd_sc_hd__mux2_1
XFILLER_47_445 vssd1 vssd1 vccd1 vccd1 sky130_fd_sc_hd__fill_1
XANTENNA__08361__A1 _03923_ vssd1 vssd1 vccd1 vccd1 sky130_fd_sc_hd__diode_2
XFILLER_19_136 vssd1 vssd1 vccd1 vccd1 sky130_fd_sc_hd__fill_2
XFILLER_75_798 vssd1 vssd1 vccd1 vccd1 sky130_fd_sc_hd__fill_1
XANTENNA__08361__B2 _03959_ vssd1 vssd1 vccd1 vccd1 sky130_fd_sc_hd__diode_2
XFILLER_19_169 vssd1 vssd1 vccd1 vccd1 sky130_fd_sc_hd__fill_4
XFILLER_90_757 vssd1 vssd1 vccd1 vccd1 sky130_fd_sc_hd__fill_4
XFILLER_90_735 vssd1 vssd1 vccd1 vccd1 sky130_fd_sc_hd__fill_8
X_10996_ net890 _00346_ net674 vssd1 vssd1 vccd1 vccd1 FPGA_INST.cell2.LE_1B.config_data\[2\]
+ sky130_fd_sc_hd__dfrtp_1
XFILLER_43_640 vssd1 vssd1 vccd1 vccd1 sky130_fd_sc_hd__fill_1
XTAP_TAPCELL_ROW_41_852 vssd1 vccd1 sky130_fd_sc_hd__tapvpwrvgnd_1
XFILLER_129_745 vssd1 vssd1 vccd1 vccd1 sky130_fd_sc_hd__fill_2
XTAP_TAPCELL_ROW_41_863 vssd1 vccd1 sky130_fd_sc_hd__tapvpwrvgnd_1
X_11617_ net741 _00967_ net526 vssd1 vssd1 vccd1 vccd1 FPGA_INST.cell0.LE_1B.config_data\[11\]
+ sky130_fd_sc_hd__dfrtp_1
XTAP_TAPCELL_ROW_96_1626 vssd1 vccd1 sky130_fd_sc_hd__tapvpwrvgnd_1
X_11548_ net770 _00898_ net555 vssd1 vssd1 vccd1 vccd1 FPGA_INST.cell0.CB_0.config_dataA\[17\]
+ sky130_fd_sc_hd__dfstp_1
XANTENNA__06427__A1 _02450_ vssd1 vssd1 vccd1 vccd1 sky130_fd_sc_hd__diode_2
XANTENNA__06427__B2 _02487_ vssd1 vssd1 vccd1 vccd1 sky130_fd_sc_hd__diode_2
X_11479_ net746 _00829_ net531 vssd1 vssd1 vccd1 vccd1 FPGA_INST.cell0.LE_1A.config_data\[6\]
+ sky130_fd_sc_hd__dfrtp_1
XFILLER_124_461 vssd1 vssd1 vccd1 vccd1 sky130_fd_sc_hd__fill_4
XFILLER_112_623 vssd1 vssd1 vccd1 vccd1 sky130_fd_sc_hd__fill_2
XANTENNA__07927__B2 _03652_ vssd1 vssd1 vccd1 vccd1 sky130_fd_sc_hd__diode_2
XFILLER_32_3 vssd1 vssd1 vccd1 vccd1 sky130_fd_sc_hd__fill_1
XFILLER_112_645 vssd1 vssd1 vccd1 vccd1 sky130_fd_sc_hd__fill_2
X_07710_ FPGA_INST.cell1.SB0.route_sel\[106\] FPGA_INST.cell1.SB0.route_sel\[107\]
+ vssd1 vssd1 vccd1 vccd1 _03961_ sky130_fd_sc_hd__nand2_1
X_05971_ _02238_ _02249_ _02250_ net350 vssd1 vssd1 vccd1 vccd1 _02251_ sky130_fd_sc_hd__a31o_1
X_08690_ net18 net19 net20 net21 net397 net396 vssd1 vssd1 vccd1 vccd1 _04899_ sky130_fd_sc_hd__mux4_1
XFILLER_93_540 vssd1 vssd1 vccd1 vccd1 sky130_fd_sc_hd__fill_8
XFILLER_38_423 vssd1 vssd1 vccd1 vccd1 sky130_fd_sc_hd__fill_1
XFILLER_38_445 vssd1 vssd1 vccd1 vccd1 sky130_fd_sc_hd__fill_1
X_07641_ FPGA_INST.cell3.SB0.route_sel\[94\] FPGA_INST.cell3.SB0.route_sel\[95\] vssd1
+ vssd1 vccd1 vccd1 _03894_ sky130_fd_sc_hd__nand2_1
XFILLER_65_275 vssd1 vssd1 vccd1 vccd1 sky130_fd_sc_hd__fill_2
XTAP_TAPCELL_ROW_49_974 vssd1 vccd1 sky130_fd_sc_hd__tapvpwrvgnd_1
XTAP_TAPCELL_ROW_49_963 vssd1 vccd1 sky130_fd_sc_hd__tapvpwrvgnd_1
XFILLER_38_467 vssd1 vssd1 vccd1 vccd1 sky130_fd_sc_hd__fill_8
X_07572_ _01647_ FPGA_INST.cell3.SB0.route_sel\[75\] _01648_ FPGA_INST.cell3.SB0.route_sel\[76\]
+ _03826_ vssd1 vssd1 vccd1 vccd1 _03827_ sky130_fd_sc_hd__o221a_1
XTAP_TAPCELL_ROW_105_1755 vssd1 vccd1 sky130_fd_sc_hd__tapvpwrvgnd_1
XFILLER_81_779 vssd1 vssd1 vccd1 vccd1 sky130_fd_sc_hd__fill_4
X_09311_ FPGA_INST.cell1.SB0.route_sel\[82\] FPGA_INST.cell1.SB0.route_sel\[83\] net204
+ vssd1 vssd1 vccd1 vccd1 _00224_ sky130_fd_sc_hd__mux2_1
X_06523_ FPGA_INST.cell2.SB0.route_sel\[36\] FPGA_INST.cell2.SB0.route_sel\[37\] vssd1
+ vssd1 vccd1 vccd1 _02799_ sky130_fd_sc_hd__nor2_1
XFILLER_34_651 vssd1 vssd1 vccd1 vccd1 sky130_fd_sc_hd__fill_8
XFILLER_61_481 vssd1 vssd1 vccd1 vccd1 sky130_fd_sc_hd__fill_1
XFILLER_34_684 vssd1 vssd1 vccd1 vccd1 sky130_fd_sc_hd__fill_2
XFILLER_34_695 vssd1 vssd1 vccd1 vccd1 sky130_fd_sc_hd__fill_2
X_09242_ FPGA_INST.cell1.SB0.route_sel\[13\] FPGA_INST.cell1.SB0.route_sel\[14\] net221
+ vssd1 vssd1 vccd1 vccd1 _00155_ sky130_fd_sc_hd__mux2_1
X_06454_ net488 _02255_ _02731_ FPGA_INST.cell2.CB_0.config_dataB\[16\] vssd1 vssd1
+ vccd1 vccd1 _02732_ sky130_fd_sc_hd__o211a_1
X_05405_ FPGA_INST.cell3.SB0.route_sel\[33\] vssd1 vssd1 vccd1 vccd1 _01687_ sky130_fd_sc_hd__inv_2
X_06385_ net7 net8 net497 vssd1 vssd1 vccd1 vccd1 _02663_ sky130_fd_sc_hd__mux2_1
X_09173_ FPGA_INST.cell2.LE_0B.config_data\[13\] FPGA_INST.cell2.LE_0B.config_data\[14\]
+ net256 vssd1 vssd1 vccd1 vccd1 _00087_ sky130_fd_sc_hd__mux2_1
X_08124_ FPGA_INST.cell1.CB_0.config_dataB\[16\] net452 _03769_ vssd1 vssd1 vccd1
+ vccd1 _04350_ sky130_fd_sc_hd__or3_1
X_05336_ FPGA_INST.cell3.SB0.route_sel\[110\] vssd1 vssd1 vccd1 vccd1 _01618_ sky130_fd_sc_hd__inv_2
XFILLER_31_28 vssd1 vssd1 vccd1 vccd1 sky130_fd_sc_hd__fill_4
XFILLER_119_266 vccd1 vssd1 vccd1 vssd1 sky130_ef_sc_hd__decap_40_12
X_08055_ _03810_ _04266_ _04280_ vssd1 vssd1 vccd1 vccd1 _04281_ sky130_fd_sc_hd__o21ai_1
XANTENNA__07091__A1 _02309_ vssd1 vssd1 vccd1 vccd1 sky130_fd_sc_hd__diode_2
X_05267_ FPGA_INST.cell2.SB0.route_sel\[7\] vssd1 vssd1 vccd1 vccd1 _01549_ sky130_fd_sc_hd__inv_2
Xoutput39 net39 vssd1 vssd1 vccd1 vccd1 gpio_oeb[25] sky130_fd_sc_hd__buf_2
XFILLER_1_706 vccd1 vssd1 vccd1 vssd1 sky130_ef_sc_hd__decap_40_12
X_07006_ FPGA_INST.bus2_0\[12\] FPGA_INST.bus2_0\[14\] FPGA_INST.bus2_0\[13\] FPGA_INST.bus2_0\[15\]
+ net432 net434 vssd1 vssd1 vccd1 vccd1 _03272_ sky130_fd_sc_hd__mux4_1
XANTENNA_fanout593_A net596 vssd1 vssd1 vccd1 vccd1 sky130_fd_sc_hd__diode_2
XFILLER_0_205 vssd1 vssd1 vccd1 vccd1 sky130_fd_sc_hd__fill_2
XFILLER_0_249 vssd1 vssd1 vccd1 vccd1 sky130_fd_sc_hd__fill_2
XANTENNA_fanout381_X net381 vssd1 vssd1 vccd1 vccd1 sky130_fd_sc_hd__diode_2
X_08957_ FPGA_INST.cell3.SB0.route_sel\[72\] _01646_ _01647_ FPGA_INST.cell3.SB0.route_sel\[75\]
+ _05144_ vssd1 vssd1 vccd1 vccd1 _05145_ sky130_fd_sc_hd__a221o_1
X_08888_ FPGA_INST.cell3.CB_0.config_dataB\[18\] _05090_ _05094_ FPGA_INST.cell3.CB_0.config_dataB\[19\]
+ vssd1 vssd1 vccd1 vccd1 _05095_ sky130_fd_sc_hd__a31o_1
X_07908_ FPGA_INST.cell1.CB_0.config_dataA\[2\] _04135_ vssd1 vssd1 vccd1 vccd1 _04136_
+ sky130_fd_sc_hd__nand2_1
XFILLER_102_199 vssd1 vssd1 vccd1 vccd1 sky130_fd_sc_hd__fill_1
XANTENNA__08343__A1 FPGA_INST.bus1_0\[5\] vssd1 vssd1 vccd1 vccd1 sky130_fd_sc_hd__diode_2
XTAP_TAPCELL_ROW_67_1216 vssd1 vccd1 sky130_fd_sc_hd__tapvpwrvgnd_1
XFILLER_56_253 vssd1 vssd1 vccd1 vccd1 sky130_fd_sc_hd__fill_1
X_07839_ net123 _02330_ _02322_ vssd1 vssd1 vccd1 vccd1 _04073_ sky130_fd_sc_hd__mux2_1
XFILLER_29_456 vssd1 vssd1 vccd1 vccd1 sky130_fd_sc_hd__fill_2
XFILLER_29_489 vssd1 vssd1 vccd1 vccd1 sky130_fd_sc_hd__fill_1
X_10850_ net798 _00200_ net583 vssd1 vssd1 vccd1 vccd1 FPGA_INST.cell1.SB0.route_sel\[59\]
+ sky130_fd_sc_hd__dfstp_1
XFILLER_72_746 vssd1 vssd1 vccd1 vccd1 sky130_fd_sc_hd__fill_1
XTAP_TAPCELL_ROW_67_1227 vssd1 vccd1 sky130_fd_sc_hd__tapvpwrvgnd_1
XFILLER_56_286 vssd1 vssd1 vccd1 vccd1 sky130_fd_sc_hd__fill_1
XFILLER_44_448 vssd1 vssd1 vccd1 vccd1 sky130_fd_sc_hd__fill_1
XFILLER_72_768 vssd1 vssd1 vccd1 vccd1 sky130_fd_sc_hd__fill_4
XFILLER_25_640 vssd1 vssd1 vccd1 vccd1 sky130_fd_sc_hd__fill_1
XFILLER_25_662 vssd1 vssd1 vccd1 vccd1 sky130_fd_sc_hd__fill_8
XTAP_TAPCELL_ROW_27_657 vssd1 vccd1 sky130_fd_sc_hd__tapvpwrvgnd_1
X_09509_ FPGA_INST.cell1.LE_0A.config_data\[5\] FPGA_INST.cell1.LE_0A.config_data\[4\]
+ net346 vssd1 vssd1 vccd1 vccd1 _00420_ sky130_fd_sc_hd__mux2_1
XTAP_TAPCELL_ROW_80_1405 vssd1 vccd1 sky130_fd_sc_hd__tapvpwrvgnd_1
XFILLER_71_278 vssd1 vssd1 vccd1 vccd1 sky130_fd_sc_hd__fill_2
X_10781_ net920 _00131_ net704 vssd1 vssd1 vccd1 vccd1 FPGA_INST.cell2.CB_1.config_dataB\[15\]
+ sky130_fd_sc_hd__dfstp_1
XFILLER_25_673 vssd1 vssd1 vccd1 vccd1 sky130_fd_sc_hd__fill_8
XANTENNA__06657__A1 FPGA_INST.bus3_2\[5\] vssd1 vssd1 vccd1 vccd1 sky130_fd_sc_hd__diode_2
XFILLER_52_492 vssd1 vssd1 vccd1 vccd1 sky130_fd_sc_hd__fill_2
XFILLER_12_334 vccd1 vssd1 vccd1 vssd1 sky130_ef_sc_hd__decap_40_12
XPHY_EDGE_ROW_117_Right_117 vssd1 vssd1 vccd1 vccd1 sky130_fd_sc_hd__decap_3
X_11402_ net748 _00752_ net533 vssd1 vssd1 vccd1 vccd1 FPGA_INST.cell0.LEI0.config_data\[23\]
+ sky130_fd_sc_hd__dfrtp_1
XANTENNA__08751__S _04860_ vssd1 vssd1 vccd1 vccd1 sky130_fd_sc_hd__diode_2
XFILLER_125_225 vssd1 vssd1 vccd1 vccd1 sky130_fd_sc_hd__fill_2
X_11333_ net806 _00683_ net591 vssd1 vssd1 vccd1 vccd1 FPGA_INST.cell1.CB_1.config_dataA\[0\]
+ sky130_fd_sc_hd__dfstp_1
XTAP_TAPCELL_ROW_78_1378 vssd1 vccd1 sky130_fd_sc_hd__tapvpwrvgnd_1
XFILLER_4_533 vssd1 vssd1 vccd1 vccd1 sky130_fd_sc_hd__fill_1
XFILLER_106_461 vssd1 vssd1 vccd1 vccd1 sky130_fd_sc_hd__fill_1
X_11264_ net783 _00614_ net568 vssd1 vssd1 vccd1 vccd1 FPGA_INST.cell0.SB0.route_sel\[109\]
+ sky130_fd_sc_hd__dfstp_1
XANTENNA__07909__A1 FPGA_INST.bus3_1\[9\] vssd1 vssd1 vccd1 vccd1 sky130_fd_sc_hd__diode_2
XFILLER_97_54 vssd1 vssd1 vccd1 vccd1 sky130_fd_sc_hd__fill_2
XTAP_TAPCELL_ROW_91_1556 vssd1 vccd1 sky130_fd_sc_hd__tapvpwrvgnd_1
X_10215_ FPGA_INST.cell3.SB0.route_sel\[120\] FPGA_INST.cell3.SB0.route_sel\[119\]
+ net367 vssd1 vssd1 vccd1 vccd1 _01096_ sky130_fd_sc_hd__mux2_1
XANTENNA__09582__S net333 vssd1 vssd1 vccd1 vccd1 sky130_fd_sc_hd__diode_2
XFILLER_97_98 vssd1 vssd1 vccd1 vccd1 sky130_fd_sc_hd__fill_1
XFILLER_97_87 vssd1 vssd1 vccd1 vccd1 sky130_fd_sc_hd__fill_2
XFILLER_79_367 vssd1 vssd1 vccd1 vccd1 sky130_fd_sc_hd__fill_1
X_11195_ net765 _00545_ net550 vssd1 vssd1 vccd1 vccd1 FPGA_INST.cell0.SB0.route_sel\[40\]
+ sky130_fd_sc_hd__dfstp_1
X_10146_ FPGA_INST.cell3.SB0.route_sel\[50\] FPGA_INST.cell3.SB0.route_sel\[51\] net277
+ vssd1 vssd1 vccd1 vccd1 _01027_ sky130_fd_sc_hd__mux2_1
XFILLER_79_389 vssd1 vssd1 vccd1 vccd1 sky130_fd_sc_hd__fill_2
XFILLER_79_378 vssd1 vssd1 vccd1 vccd1 sky130_fd_sc_hd__fill_2
XTAP_TAPCELL_ROW_7_382 vssd1 vccd1 sky130_fd_sc_hd__tapvpwrvgnd_1
XFILLER_0_761 vssd1 vssd1 vccd1 vccd1 sky130_fd_sc_hd__fill_1
XFILLER_48_732 vssd1 vssd1 vccd1 vccd1 sky130_fd_sc_hd__fill_2
X_10077_ FPGA_INST.cell0.LE_1B.config_data\[1\] FPGA_INST.cell0.LE_1B.config_data\[2\]
+ net172 vssd1 vssd1 vccd1 vccd1 _00958_ sky130_fd_sc_hd__mux2_1
XANTENNA__08334__A1 FPGA_INST.bus1_0\[10\] vssd1 vssd1 vccd1 vccd1 sky130_fd_sc_hd__diode_2
XANTENNA__08885__A2 _04804_ vssd1 vssd1 vccd1 vccd1 sky130_fd_sc_hd__diode_2
XFILLER_75_584 vssd1 vssd1 vccd1 vccd1 sky130_fd_sc_hd__fill_1
XFILLER_63_746 vssd1 vssd1 vccd1 vccd1 sky130_fd_sc_hd__fill_2
XFILLER_63_724 vssd1 vssd1 vccd1 vccd1 sky130_fd_sc_hd__fill_4
XTAP_TAPCELL_ROW_46_933 vssd1 vccd1 sky130_fd_sc_hd__tapvpwrvgnd_1
XTAP_TAPCELL_ROW_46_922 vssd1 vccd1 sky130_fd_sc_hd__tapvpwrvgnd_1
X_10979_ net887 _00329_ net671 vssd1 vssd1 vccd1 vccd1 FPGA_INST.cell2.CB_1.config_dataA\[10\]
+ sky130_fd_sc_hd__dfstp_1
XANTENNA__11064__SET_B net733 vssd1 vssd1 vccd1 vccd1 sky130_fd_sc_hd__diode_2
XFILLER_30_153 vssd1 vssd1 vccd1 vccd1 sky130_fd_sc_hd__fill_1
XTAP_TAPCELL_ROW_100_1685 vssd1 vccd1 sky130_fd_sc_hd__tapvpwrvgnd_1
XFILLER_30_197 vssd1 vssd1 vccd1 vccd1 sky130_fd_sc_hd__fill_2
XFILLER_116_203 vssd1 vssd1 vccd1 vccd1 sky130_fd_sc_hd__fill_1
X_06170_ _02447_ _02449_ vssd1 vssd1 vccd1 vccd1 _02450_ sky130_fd_sc_hd__nor2_4
Xfanout807 net811 vssd1 vssd1 vccd1 vccd1 net807 sky130_fd_sc_hd__dlymetal6s2s_1
X_09860_ FPGA_INST.cell0.LEI0.config_data\[38\] FPGA_INST.cell0.LEI0.config_data\[39\]
+ net178 vssd1 vssd1 vccd1 vccd1 _00768_ sky130_fd_sc_hd__mux2_1
Xfanout818 net819 vssd1 vssd1 vccd1 vccd1 net818 sky130_fd_sc_hd__buf_2
XFILLER_98_654 vssd1 vssd1 vccd1 vccd1 sky130_fd_sc_hd__fill_1
Xfanout829 net831 vssd1 vssd1 vccd1 vccd1 net829 sky130_fd_sc_hd__clkbuf_2
XFILLER_97_175 vssd1 vssd1 vccd1 vccd1 sky130_fd_sc_hd__fill_2
X_08811_ net392 _04785_ _05017_ vssd1 vssd1 vccd1 vccd1 _05018_ sky130_fd_sc_hd__a21oi_1
X_09791_ FPGA_INST.cell1.CB_1.config_dataA\[17\] FPGA_INST.cell1.CB_1.config_dataA\[16\]
+ net332 vssd1 vssd1 vccd1 vccd1 _00700_ sky130_fd_sc_hd__mux2_1
X_08742_ _01662_ FPGA_INST.cell3.CB_0.config_dataA\[17\] _04928_ FPGA_INST.cell3.CB_0.config_dataA\[18\]
+ vssd1 vssd1 vccd1 vccd1 _04951_ sky130_fd_sc_hd__o31a_1
X_05954_ net385 net160 _02229_ _02232_ vssd1 vssd1 vccd1 vccd1 _02234_ sky130_fd_sc_hd__a2bb2o_1
X_08673_ _04876_ _04877_ _04880_ _04881_ vssd1 vssd1 vccd1 vccd1 _04882_ sky130_fd_sc_hd__o22a_1
XFILLER_81_521 vssd1 vssd1 vccd1 vccd1 sky130_fd_sc_hd__fill_1
X_07624_ _02059_ _02067_ _03874_ vssd1 vssd1 vccd1 vccd1 _03877_ sky130_fd_sc_hd__or3_1
X_05885_ FPGA_INST.cell2.SB0.route_sel\[66\] FPGA_INST.cell2.SB0.route_sel\[67\] vssd1
+ vssd1 vccd1 vccd1 _02165_ sky130_fd_sc_hd__nor2_1
XFILLER_38_297 vssd1 vssd1 vccd1 vccd1 sky130_fd_sc_hd__fill_2
XFILLER_26_459 vssd1 vssd1 vccd1 vccd1 sky130_fd_sc_hd__fill_2
XANTENNA_fanout341_A net349 vssd1 vssd1 vccd1 vccd1 sky130_fd_sc_hd__diode_2
X_07555_ _03802_ _03805_ _03807_ _03809_ vssd1 vssd1 vccd1 vccd1 _03810_ sky130_fd_sc_hd__o211a_4
XFILLER_53_267 vssd1 vssd1 vccd1 vccd1 sky130_fd_sc_hd__fill_4
XFILLER_41_418 vssd1 vssd1 vccd1 vccd1 sky130_fd_sc_hd__fill_2
XTAP_TAPCELL_ROW_24_616 vssd1 vccd1 sky130_fd_sc_hd__tapvpwrvgnd_1
X_07486_ FPGA_INST.cell3.SB0.route_sel\[56\] FPGA_INST.cell3.SB0.route_sel\[57\] _01664_
+ FPGA_INST.cell3.SB0.route_sel\[59\] _03742_ vssd1 vssd1 vccd1 vccd1 _03743_ sky130_fd_sc_hd__o221a_1
XTAP_TAPCELL_ROW_62_1146 vssd1 vccd1 sky130_fd_sc_hd__tapvpwrvgnd_1
X_06506_ FPGA_INST.cell2.SB0.route_sel\[4\] FPGA_INST.cell2.SB0.route_sel\[5\] vssd1
+ vssd1 vccd1 vccd1 _02782_ sky130_fd_sc_hd__nor2_1
XTAP_TAPCELL_ROW_62_1157 vssd1 vccd1 sky130_fd_sc_hd__tapvpwrvgnd_1
X_09225_ FPGA_INST.cell2.CB_1.config_dataB\[21\] FPGA_INST.cell2.CB_1.config_dataB\[22\]
+ net244 vssd1 vssd1 vccd1 vccd1 _00138_ sky130_fd_sc_hd__mux2_1
XFILLER_42_27 vssd1 vssd1 vccd1 vccd1 sky130_fd_sc_hd__fill_1
X_06437_ net5 _02693_ _01541_ FPGA_INST.cell2.CB_0.config_dataB\[13\] vssd1 vssd1
+ vccd1 vccd1 _02715_ sky130_fd_sc_hd__a211o_1
XANTENNA_fanout227_X net227 vssd1 vssd1 vccd1 vccd1 sky130_fd_sc_hd__diode_2
XFILLER_21_175 vssd1 vssd1 vccd1 vccd1 sky130_fd_sc_hd__fill_1
XTAP_TAPCELL_ROW_118_1935 vssd1 vccd1 sky130_fd_sc_hd__tapvpwrvgnd_1
X_06368_ net14 net15 net16 net17 net494 net493 vssd1 vssd1 vccd1 vccd1 _02646_ sky130_fd_sc_hd__mux4_1
X_09156_ FPGA_INST.cell2.LE_0B.dff0_out net524 _05210_ vssd1 vssd1 vccd1 vccd1 _00071_
+ sky130_fd_sc_hd__a21bo_1
X_08107_ net451 _03519_ vssd1 vssd1 vccd1 vccd1 _04333_ sky130_fd_sc_hd__or2_1
X_05319_ FPGA_INST.cell3.SB0.route_sel\[122\] vssd1 vssd1 vccd1 vccd1 _01601_ sky130_fd_sc_hd__inv_2
X_06299_ _02168_ _02574_ _02575_ _02131_ FPGA_INST.cell2.CB_0.config_dataA\[17\] vssd1
+ vssd1 vccd1 vccd1 _02579_ sky130_fd_sc_hd__a221o_1
XANTENNA__07064__A1 FPGA_INST.bus2_0\[5\] vssd1 vssd1 vccd1 vccd1 sky130_fd_sc_hd__diode_2
X_09087_ FPGA_INST.cell2.LEI0.config_data\[1\] FPGA_INST.cell2.LEI0.config_data\[2\]
+ net256 vssd1 vssd1 vccd1 vccd1 _00003_ sky130_fd_sc_hd__mux2_1
X_08038_ net460 _03519_ _04263_ net459 vssd1 vssd1 vccd1 vccd1 _04264_ sky130_fd_sc_hd__o211a_1
XFILLER_122_206 vssd1 vssd1 vccd1 vccd1 sky130_fd_sc_hd__fill_1
XANTENNA__08013__A0 FPGA_INST.bus3_1\[4\] vssd1 vssd1 vccd1 vccd1 sky130_fd_sc_hd__diode_2
XANTENNA_fanout596_X net596 vssd1 vssd1 vccd1 vccd1 sky130_fd_sc_hd__diode_2
XFILLER_1_503 vssd1 vssd1 vccd1 vccd1 sky130_fd_sc_hd__fill_1
X_10000_ net437 FPGA_INST.cell0.CB_0.config_data_inA net310 vssd1 vssd1 vccd1 vccd1
+ _00881_ sky130_fd_sc_hd__mux2_1
X_09989_ _01529_ _05237_ net738 vssd1 vssd1 vccd1 vccd1 _05238_ sky130_fd_sc_hd__o21ai_1
XFILLER_88_153 vssd1 vssd1 vccd1 vccd1 sky130_fd_sc_hd__fill_1
XFILLER_67_24 vssd1 vssd1 vccd1 vccd1 sky130_fd_sc_hd__fill_4
XTAP_TAPCELL_ROW_4_341 vssd1 vccd1 sky130_fd_sc_hd__tapvpwrvgnd_1
XFILLER_91_318 vssd1 vssd1 vccd1 vccd1 sky130_fd_sc_hd__fill_4
XANTENNA__08316__A1 _03639_ vssd1 vssd1 vccd1 vccd1 sky130_fd_sc_hd__diode_2
XANTENNA__08316__B2 _03604_ vssd1 vssd1 vccd1 vccd1 sky130_fd_sc_hd__diode_2
XANTENNA__06590__A3 FPGA_INST.bus3_2\[3\] vssd1 vssd1 vccd1 vccd1 sky130_fd_sc_hd__diode_2
X_11951_ net913 _01297_ net697 vssd1 vssd1 vccd1 vccd1 FPGA_INST.cell3.CB_1.config_dataB\[16\]
+ sky130_fd_sc_hd__dfstp_1
XFILLER_44_223 vssd1 vssd1 vccd1 vccd1 sky130_fd_sc_hd__fill_4
X_11882_ net928 _01228_ net712 vssd1 vssd1 vccd1 vccd1 FPGA_INST.cell3.LE_0A.config_data\[12\]
+ sky130_fd_sc_hd__dfrtp_1
X_10902_ net829 _00252_ net613 vssd1 vssd1 vccd1 vccd1 FPGA_INST.cell1.SB0.route_sel\[111\]
+ sky130_fd_sc_hd__dfstp_1
X_10833_ net800 _00183_ net585 vssd1 vssd1 vccd1 vccd1 FPGA_INST.cell1.SB0.route_sel\[42\]
+ sky130_fd_sc_hd__dfstp_1
XFILLER_83_89 vssd1 vssd1 vccd1 vccd1 sky130_fd_sc_hd__fill_2
XFILLER_72_587 vssd1 vssd1 vccd1 vccd1 sky130_fd_sc_hd__fill_1
XFILLER_72_576 vssd1 vssd1 vccd1 vccd1 sky130_fd_sc_hd__fill_1
XANTENNA__07503__X _03759_ vssd1 vssd1 vccd1 vccd1 sky130_fd_sc_hd__diode_2
XFILLER_16_83 vssd1 vssd1 vccd1 vccd1 sky130_fd_sc_hd__fill_1
X_10764_ net885 _00114_ net669 vssd1 vssd1 vccd1 vccd1 FPGA_INST.cell2.LE_1A.reset_mode
+ sky130_fd_sc_hd__dfrtp_1
XTAP_TAPCELL_ROW_51_991 vssd1 vccd1 sky130_fd_sc_hd__tapvpwrvgnd_1
X_10695_ net881 _00045_ net665 vssd1 vssd1 vccd1 vccd1 FPGA_INST.cell2.LEI0.config_data\[44\]
+ sky130_fd_sc_hd__dfrtp_1
XFILLER_9_636 vssd1 vssd1 vccd1 vccd1 sky130_fd_sc_hd__fill_1
XANTENNA__08252__A0 FPGA_INST.bus1_0\[10\] vssd1 vssd1 vccd1 vccd1 sky130_fd_sc_hd__diode_2
XANTENNA__10516__S net241 vssd1 vssd1 vccd1 vccd1 sky130_fd_sc_hd__diode_2
XFILLER_126_556 vssd1 vssd1 vccd1 vccd1 sky130_fd_sc_hd__fill_1
X_11316_ net908 _00666_ net692 vssd1 vssd1 vccd1 vccd1 FPGA_INST.cell1.CB_0.config_dataB\[8\]
+ sky130_fd_sc_hd__dfstp_1
XFILLER_4_330 vssd1 vssd1 vccd1 vccd1 sky130_fd_sc_hd__fill_4
XFILLER_126_589 vssd1 vssd1 vccd1 vccd1 sky130_fd_sc_hd__fill_1
XFILLER_113_239 vssd1 vssd1 vccd1 vccd1 sky130_fd_sc_hd__fill_1
XFILLER_106_280 vssd1 vssd1 vccd1 vccd1 sky130_fd_sc_hd__fill_1
X_11247_ net767 _00597_ net552 vssd1 vssd1 vccd1 vccd1 FPGA_INST.cell0.SB0.route_sel\[92\]
+ sky130_fd_sc_hd__dfstp_1
XFILLER_95_624 vssd1 vssd1 vccd1 vccd1 sky130_fd_sc_hd__fill_1
X_11178_ net780 _00528_ net565 vssd1 vssd1 vccd1 vccd1 FPGA_INST.cell0.SB0.route_sel\[23\]
+ sky130_fd_sc_hd__dfstp_1
X_10129_ FPGA_INST.cell3.SB0.route_sel\[33\] FPGA_INST.cell3.SB0.route_sel\[34\] net278
+ vssd1 vssd1 vccd1 vccd1 _01010_ sky130_fd_sc_hd__mux2_1
XFILLER_0_591 vssd1 vssd1 vccd1 vccd1 sky130_fd_sc_hd__fill_1
XANTENNA__09504__A0 FPGA_INST.cell0.SB0.config_data_out vssd1 vssd1 vccd1 vccd1 sky130_fd_sc_hd__diode_2
XFILLER_82_318 vssd1 vssd1 vccd1 vccd1 sky130_fd_sc_hd__fill_1
XANTENNA__06318__A0 net7 vssd1 vssd1 vccd1 vccd1 sky130_fd_sc_hd__diode_2
XFILLER_36_746 vssd1 vssd1 vccd1 vccd1 sky130_fd_sc_hd__fill_8
X_05670_ net132 _01947_ vssd1 vssd1 vccd1 vccd1 _01950_ sky130_fd_sc_hd__nor2_1
XANTENNA__06869__A1 FPGA_INST.bus2_0\[9\] vssd1 vssd1 vccd1 vccd1 sky130_fd_sc_hd__diode_2
XFILLER_36_757 vssd1 vssd1 vccd1 vccd1 sky130_fd_sc_hd__fill_4
XTAP_TAPCELL_ROW_102_1714 vssd1 vccd1 sky130_fd_sc_hd__tapvpwrvgnd_1
XFILLER_51_727 vssd1 vssd1 vccd1 vccd1 sky130_fd_sc_hd__fill_1
X_07340_ FPGA_INST.cell1.SB0.route_sel\[34\] FPGA_INST.cell1.SB0.route_sel\[35\] vssd1
+ vssd1 vccd1 vccd1 _03600_ sky130_fd_sc_hd__nand2_1
XFILLER_16_470 vssd1 vssd1 vccd1 vccd1 sky130_fd_sc_hd__fill_1
XFILLER_31_451 vssd1 vssd1 vccd1 vccd1 sky130_fd_sc_hd__fill_2
X_07271_ _03438_ _03532_ vssd1 vssd1 vccd1 vccd1 _03533_ sky130_fd_sc_hd__or2_1
X_09010_ _01695_ FPGA_INST.cell3.SB0.route_sel\[27\] vssd1 vssd1 vccd1 vccd1 _05180_
+ sky130_fd_sc_hd__nand2_1
XFILLER_128_19 vssd1 vssd1 vccd1 vccd1 sky130_fd_sc_hd__fill_1
XANTENNA__05868__X _02148_ vssd1 vssd1 vccd1 vccd1 sky130_fd_sc_hd__diode_2
X_06222_ _02491_ _02499_ _02501_ _02498_ vssd1 vssd1 vccd1 vccd1 _02502_ sky130_fd_sc_hd__o211a_1
X_06153_ FPGA_INST.cell2.SB0.route_sel\[12\] FPGA_INST.cell2.SB0.route_sel\[13\] _02432_
+ vssd1 vssd1 vccd1 vccd1 _02433_ sky130_fd_sc_hd__a21boi_1
XANTENNA__10050__A0 FPGA_INST.cell0.CB_0.config_dataB\[24\] vssd1 vssd1 vccd1 vccd1
+ sky130_fd_sc_hd__diode_2
X_06084_ _02353_ _02363_ _02355_ vssd1 vssd1 vccd1 vccd1 _02364_ sky130_fd_sc_hd__a21oi_1
XANTENNA__08546__A1 net84 vssd1 vssd1 vccd1 vccd1 sky130_fd_sc_hd__diode_2
XTAP_TAPCELL_ROW_113_1865 vssd1 vccd1 sky130_fd_sc_hd__tapvpwrvgnd_1
Xfanout604 net627 vssd1 vssd1 vccd1 vccd1 net604 sky130_fd_sc_hd__buf_2
Xfanout615 net627 vssd1 vssd1 vccd1 vccd1 net615 sky130_fd_sc_hd__clkbuf_2
X_09912_ FPGA_INST.cell0.LE_0B.config_data\[16\] FPGA_INST.cell0.LE_0B.edge_mode net177
+ vssd1 vssd1 vccd1 vccd1 _00818_ sky130_fd_sc_hd__mux2_1
Xfanout626 net627 vssd1 vssd1 vccd1 vccd1 net626 sky130_fd_sc_hd__clkbuf_4
Xfanout648 net650 vssd1 vssd1 vccd1 vccd1 net648 sky130_fd_sc_hd__clkbuf_4
X_09843_ FPGA_INST.cell0.LEI0.config_data\[21\] FPGA_INST.cell0.LEI0.config_data\[22\]
+ net174 vssd1 vssd1 vccd1 vccd1 _00751_ sky130_fd_sc_hd__mux2_1
Xfanout637 net639 vssd1 vssd1 vccd1 vccd1 net637 sky130_fd_sc_hd__clkbuf_4
XFILLER_100_423 vssd1 vssd1 vccd1 vccd1 sky130_fd_sc_hd__fill_1
XANTENNA_fanout291_A net295 vssd1 vssd1 vccd1 vccd1 sky130_fd_sc_hd__diode_2
XANTENNA__06021__A2 net165 vssd1 vssd1 vccd1 vccd1 sky130_fd_sc_hd__diode_2
Xfanout659 net660 vssd1 vssd1 vccd1 vccd1 net659 sky130_fd_sc_hd__buf_4
X_09774_ FPGA_INST.cell1.CB_0.config_dataB\[24\] FPGA_INST.cell1.CB_1.config_dataA\[0\]
+ net210 vssd1 vssd1 vccd1 vccd1 _00683_ sky130_fd_sc_hd__mux2_1
XFILLER_85_167 vssd1 vssd1 vccd1 vccd1 sky130_fd_sc_hd__fill_1
XTAP_TAPCELL_ROW_1_300 vssd1 vccd1 sky130_fd_sc_hd__tapvpwrvgnd_1
X_06986_ net433 _02392_ _03251_ net432 vssd1 vssd1 vccd1 vccd1 _03252_ sky130_fd_sc_hd__o211a_1
X_08725_ net25 net26 net395 vssd1 vssd1 vccd1 vccd1 _04934_ sky130_fd_sc_hd__mux2_1
XANTENNA__05780__A1 net170 vssd1 vssd1 vccd1 vccd1 sky130_fd_sc_hd__diode_2
XFILLER_54_510 vssd1 vssd1 vccd1 vccd1 sky130_fd_sc_hd__fill_2
XANTENNA_fanout556_A net558 vssd1 vssd1 vccd1 vccd1 sky130_fd_sc_hd__diode_2
X_05937_ _02216_ _02214_ vssd1 vssd1 vccd1 vccd1 _02217_ sky130_fd_sc_hd__nand2b_4
XFILLER_27_713 vssd1 vssd1 vccd1 vccd1 sky130_fd_sc_hd__fill_2
XFILLER_27_735 vssd1 vssd1 vccd1 vccd1 sky130_fd_sc_hd__fill_2
XFILLER_39_595 vssd1 vssd1 vccd1 vccd1 sky130_fd_sc_hd__fill_1
X_08656_ _01767_ net398 vssd1 vssd1 vccd1 vccd1 _04865_ sky130_fd_sc_hd__nor2_1
X_05868_ _01782_ _01918_ _02013_ _02132_ _02147_ vssd1 vssd1 vccd1 vccd1 _02148_ sky130_fd_sc_hd__o32a_2
X_08587_ net401 net400 vssd1 vssd1 vccd1 vccd1 _04796_ sky130_fd_sc_hd__or2_1
X_07607_ _03831_ _03860_ _03828_ vssd1 vssd1 vccd1 vccd1 _03861_ sky130_fd_sc_hd__o21ba_1
XFILLER_54_587 vssd1 vssd1 vccd1 vccd1 sky130_fd_sc_hd__fill_1
XFILLER_42_738 vssd1 vssd1 vccd1 vccd1 sky130_fd_sc_hd__fill_1
XANTENNA_fanout344_X net344 vssd1 vssd1 vccd1 vccd1 sky130_fd_sc_hd__diode_2
XANTENNA_fanout723_A net729 vssd1 vssd1 vccd1 vccd1 sky130_fd_sc_hd__diode_2
X_07538_ FPGA_INST.cell1.SB0.route_sel\[74\] FPGA_INST.cell1.SB0.route_sel\[75\] vssd1
+ vssd1 vccd1 vccd1 _03793_ sky130_fd_sc_hd__nand2_1
X_05799_ net129 _02076_ vssd1 vssd1 vccd1 vccd1 _02079_ sky130_fd_sc_hd__nand2_1
XTAP_TAPCELL_ROW_37_796 vssd1 vccd1 sky130_fd_sc_hd__tapvpwrvgnd_1
X_07469_ FPGA_INST.cell1.SB0.route_sel\[58\] FPGA_INST.cell1.SB0.route_sel\[59\] vssd1
+ vssd1 vccd1 vccd1 _03726_ sky130_fd_sc_hd__nor2_1
X_09208_ FPGA_INST.cell2.CB_1.config_dataB\[4\] net518 net265 vssd1 vssd1 vccd1 vccd1
+ _00121_ sky130_fd_sc_hd__mux2_1
XFILLER_10_657 vssd1 vssd1 vccd1 vccd1 sky130_fd_sc_hd__fill_1
XANTENNA__06493__C1 net155 vssd1 vssd1 vccd1 vccd1 sky130_fd_sc_hd__diode_2
XANTENNA__09397__S net357 vssd1 vssd1 vccd1 vccd1 sky130_fd_sc_hd__diode_2
X_10480_ FPGA_INST.cell2.SB0.route_sel\[53\] FPGA_INST.cell2.SB0.route_sel\[52\] net319
+ vssd1 vssd1 vccd1 vccd1 _01359_ sky130_fd_sc_hd__mux2_1
XANTENNA__08234__A0 net76 vssd1 vssd1 vccd1 vccd1 sky130_fd_sc_hd__diode_2
X_09139_ FPGA_INST.cell2.LE_0A.config_data\[3\] FPGA_INST.cell2.LE_0A.config_data\[2\]
+ net350 vssd1 vssd1 vccd1 vccd1 _00054_ sky130_fd_sc_hd__mux2_1
XANTENNA__05938__B _02217_ vssd1 vssd1 vccd1 vccd1 sky130_fd_sc_hd__diode_2
XANTENNA__07037__A1 FPGA_INST.bus2_0\[5\] vssd1 vssd1 vccd1 vccd1 sky130_fd_sc_hd__diode_2
X_12150_ net934 _01496_ net718 vssd1 vssd1 vccd1 vccd1 FPGA_INST.cell3.CB_1.config_dataA\[12\]
+ sky130_fd_sc_hd__dfstp_1
XFILLER_118_41 vccd1 vssd1 vccd1 vssd1 sky130_ef_sc_hd__decap_40_12
XTAP_TAPCELL_ROW_75_1326 vssd1 vccd1 sky130_fd_sc_hd__tapvpwrvgnd_1
XANTENNA__08314__B _03720_ vssd1 vssd1 vccd1 vccd1 sky130_fd_sc_hd__diode_2
XFILLER_123_537 vssd1 vssd1 vccd1 vccd1 sky130_fd_sc_hd__fill_1
X_11101_ net841 _00451_ net625 vssd1 vssd1 vccd1 vccd1 FPGA_INST.cell1.LE_0B.config_data\[14\]
+ sky130_fd_sc_hd__dfrtp_1
XTAP_TAPCELL_ROW_75_1337 vssd1 vccd1 sky130_fd_sc_hd__tapvpwrvgnd_1
XANTENNA__06796__A0 _02772_ vssd1 vssd1 vccd1 vccd1 sky130_fd_sc_hd__diode_2
XTAP_TAPCELL_ROW_9_411 vssd1 vccd1 sky130_fd_sc_hd__tapvpwrvgnd_1
XFILLER_123_559 vssd1 vssd1 vccd1 vccd1 sky130_fd_sc_hd__fill_1
XFILLER_118_85 vssd1 vssd1 vccd1 vccd1 sky130_fd_sc_hd__fill_4
X_12081_ net850 _01427_ net635 vssd1 vssd1 vccd1 vccd1 FPGA_INST.cell2.SB0.route_sel\[121\]
+ sky130_fd_sc_hd__dfstp_1
X_11032_ net832 _00382_ net616 vssd1 vssd1 vccd1 vccd1 FPGA_INST.cell1.LEI0.config_data\[17\]
+ sky130_fd_sc_hd__dfrtp_1
XFILLER_89_451 vssd1 vssd1 vccd1 vccd1 sky130_fd_sc_hd__fill_8
XFILLER_89_495 vssd1 vssd1 vccd1 vccd1 sky130_fd_sc_hd__fill_8
XFILLER_49_337 vssd1 vssd1 vccd1 vccd1 sky130_fd_sc_hd__fill_4
XFILLER_91_104 vssd1 vssd1 vccd1 vccd1 sky130_fd_sc_hd__fill_8
XFILLER_17_201 vssd1 vssd1 vccd1 vccd1 sky130_fd_sc_hd__fill_2
XANTENNA__05771__A1 net135 vssd1 vssd1 vccd1 vccd1 sky130_fd_sc_hd__diode_2
X_11934_ FPGA_INST.cell3.LE_1B.sel_clk _01280_ net735 vssd1 vssd1 vccd1 vccd1 FPGA_INST.cell3.LE_1B.dff0_out
+ sky130_fd_sc_hd__dfrtp_1
XANTENNA__05960__Y _02240_ vssd1 vssd1 vccd1 vccd1 sky130_fd_sc_hd__diode_2
XTAP_TAPCELL_ROW_86_1488 vssd1 vccd1 sky130_fd_sc_hd__tapvpwrvgnd_1
XFILLER_72_362 vssd1 vssd1 vccd1 vccd1 sky130_fd_sc_hd__fill_2
X_11865_ net914 _01211_ net698 vssd1 vssd1 vccd1 vccd1 FPGA_INST.cell3.LEI0.config_data\[45\]
+ sky130_fd_sc_hd__dfrtp_1
XFILLER_60_535 vssd1 vssd1 vccd1 vccd1 sky130_fd_sc_hd__fill_1
X_10816_ net822 _00166_ net606 vssd1 vssd1 vccd1 vccd1 FPGA_INST.cell1.SB0.route_sel\[25\]
+ sky130_fd_sc_hd__dfstp_1
X_11796_ net876 _01142_ net659 vssd1 vssd1 vccd1 vccd1 FPGA_INST.io_east_oeb\[12\]
+ sky130_fd_sc_hd__dfrtp_1
XFILLER_43_81 vssd1 vssd1 vccd1 vccd1 sky130_fd_sc_hd__fill_2
X_10747_ net885 _00097_ net669 vssd1 vssd1 vccd1 vccd1 FPGA_INST.cell2.LE_1A.config_data\[2\]
+ sky130_fd_sc_hd__dfrtp_1
XFILLER_9_455 vssd1 vssd1 vccd1 vccd1 sky130_fd_sc_hd__fill_2
X_10678_ net874 _00028_ net658 vssd1 vssd1 vccd1 vccd1 FPGA_INST.cell2.LEI0.config_data\[27\]
+ sky130_fd_sc_hd__dfrtp_1
XFILLER_126_320 vssd1 vssd1 vccd1 vccd1 sky130_fd_sc_hd__fill_1
XANTENNA__08225__A0 net75 vssd1 vssd1 vccd1 vccd1 sky130_fd_sc_hd__diode_2
XTAP_TAPCELL_ROW_130_2110 vssd1 vccd1 sky130_fd_sc_hd__tapvpwrvgnd_1
XTAP_TAPCELL_ROW_130_2121 vssd1 vccd1 sky130_fd_sc_hd__tapvpwrvgnd_1
XFILLER_4_193 vssd1 vssd1 vccd1 vccd1 sky130_fd_sc_hd__fill_2
X_06840_ net420 _03104_ _03107_ vssd1 vssd1 vccd1 vccd1 _03108_ sky130_fd_sc_hd__a21o_1
XFILLER_110_754 vssd1 vssd1 vccd1 vccd1 sky130_fd_sc_hd__fill_2
XFILLER_68_679 vssd1 vssd1 vccd1 vccd1 sky130_fd_sc_hd__fill_1
XTAP_TAPCELL_ROW_128_2072 vssd1 vccd1 sky130_fd_sc_hd__tapvpwrvgnd_1
XFILLER_110_798 vssd1 vssd1 vccd1 vccd1 sky130_fd_sc_hd__fill_1
XFILLER_95_487 vssd1 vssd1 vccd1 vccd1 sky130_fd_sc_hd__fill_1
XFILLER_83_649 vssd1 vssd1 vccd1 vccd1 sky130_fd_sc_hd__fill_2
X_06771_ FPGA_INST.cell2.LEI0.config_data\[35\] _03044_ vssd1 vssd1 vccd1 vccd1 _03045_
+ sky130_fd_sc_hd__nand2b_1
XANTENNA__12178__RESET_B net695 vssd1 vssd1 vccd1 vccd1 sky130_fd_sc_hd__diode_2
X_08510_ _04722_ vssd1 vssd1 vccd1 vccd1 _04723_ sky130_fd_sc_hd__inv_2
X_09490_ FPGA_INST.cell1.LEI0.config_data\[36\] FPGA_INST.cell1.LEI0.config_data\[37\]
+ net214 vssd1 vssd1 vccd1 vccd1 _00402_ sky130_fd_sc_hd__mux2_1
X_05722_ _01860_ _02001_ vssd1 vssd1 vccd1 vccd1 _02002_ sky130_fd_sc_hd__nor2_1
X_08441_ FPGA_INST.cell1.CB_1.config_dataA\[3\] FPGA_INST.cell1.CB_1.config_dataA\[2\]
+ FPGA_INST.cell1.CB_1.config_dataA\[1\] FPGA_INST.cell1.CB_1.config_dataA\[0\] vssd1
+ vssd1 vccd1 vccd1 _04659_ sky130_fd_sc_hd__or4b_2
XFILLER_91_671 vssd1 vssd1 vccd1 vccd1 sky130_fd_sc_hd__fill_1
X_05653_ _01923_ _01930_ _01932_ net320 vssd1 vssd1 vccd1 vccd1 _01933_ sky130_fd_sc_hd__a211o_1
XANTENNA__08059__A3 FPGA_INST.bus3_1\[15\] vssd1 vssd1 vccd1 vccd1 sky130_fd_sc_hd__diode_2
X_08372_ FPGA_INST.cell0.CB_1.config_dataB\[13\] _04593_ vssd1 vssd1 vccd1 vccd1 _04594_
+ sky130_fd_sc_hd__nor2_1
X_05584_ _01858_ _01861_ _01862_ FPGA_INST.cell2.SB0.route_sel\[113\] FPGA_INST.cell2.SB0.route_sel\[112\]
+ vssd1 vssd1 vccd1 vccd1 _01864_ sky130_fd_sc_hd__a32o_1
XTAP_TAPCELL_ROW_34_755 vssd1 vccd1 sky130_fd_sc_hd__tapvpwrvgnd_1
X_07323_ FPGA_INST.cell3.SB0.route_sel\[29\] _01696_ vssd1 vssd1 vccd1 vccd1 _03584_
+ sky130_fd_sc_hd__nand2_1
X_07254_ _03512_ _03515_ vssd1 vssd1 vccd1 vccd1 _03516_ sky130_fd_sc_hd__nand2_1
XANTENNA_fanout137_A FPGA_INST.cell2.CB_0.le_outA vssd1 vssd1 vccd1 vccd1 sky130_fd_sc_hd__diode_2
XFILLER_31_281 vssd1 vssd1 vccd1 vccd1 sky130_fd_sc_hd__fill_1
X_06205_ FPGA_INST.cell2.SB0.route_sel\[5\] FPGA_INST.cell2.SB0.route_sel\[4\] vssd1
+ vssd1 vccd1 vccd1 _02485_ sky130_fd_sc_hd__nand2b_1
XANTENNA_fanout304_A net305 vssd1 vssd1 vccd1 vccd1 sky130_fd_sc_hd__diode_2
X_07185_ _03429_ _03447_ net78 vssd1 vssd1 vccd1 vccd1 _03448_ sky130_fd_sc_hd__o21ai_1
XFILLER_117_386 vssd1 vssd1 vccd1 vccd1 sky130_fd_sc_hd__fill_1
XFILLER_105_526 vssd1 vssd1 vccd1 vccd1 sky130_fd_sc_hd__fill_1
X_06136_ FPGA_INST.cell0.SB0.route_sel\[8\] FPGA_INST.cell0.SB0.route_sel\[9\] vssd1
+ vssd1 vccd1 vccd1 _02416_ sky130_fd_sc_hd__and2_1
XANTENNA__09945__S net184 vssd1 vssd1 vccd1 vccd1 sky130_fd_sc_hd__diode_2
XFILLER_105_537 vssd1 vssd1 vccd1 vccd1 sky130_fd_sc_hd__fill_1
XTAP_TAPCELL_ROW_57_1078 vssd1 vccd1 sky130_fd_sc_hd__tapvpwrvgnd_1
X_06067_ _02336_ _02343_ _02346_ net320 vssd1 vssd1 vccd1 vccd1 _02347_ sky130_fd_sc_hd__a211o_2
XFILLER_120_529 vssd1 vssd1 vccd1 vccd1 sky130_fd_sc_hd__fill_2
Xfanout401 FPGA_INST.cell3.CB_0.config_dataA\[0\] vssd1 vssd1 vccd1 vccd1 net401 sky130_fd_sc_hd__buf_2
XANTENNA__06793__A3 FPGA_INST.bus3_2\[3\] vssd1 vssd1 vccd1 vccd1 sky130_fd_sc_hd__diode_2
XFILLER_59_613 vssd1 vssd1 vccd1 vccd1 sky130_fd_sc_hd__fill_2
Xfanout412 net413 vssd1 vssd1 vccd1 vccd1 net412 sky130_fd_sc_hd__buf_2
Xfanout423 FPGA_INST.cell0.CB_0.config_dataB\[1\] vssd1 vssd1 vccd1 vccd1 net423 sky130_fd_sc_hd__clkbuf_2
Xfanout456 FPGA_INST.cell1.CB_0.config_dataB\[6\] vssd1 vssd1 vccd1 vccd1 net456 sky130_fd_sc_hd__clkbuf_2
XFILLER_113_570 vccd1 vssd1 vccd1 vssd1 sky130_ef_sc_hd__decap_40_12
XFILLER_101_721 vssd1 vssd1 vccd1 vccd1 sky130_fd_sc_hd__fill_4
XFILLER_98_281 vssd1 vssd1 vccd1 vccd1 sky130_fd_sc_hd__fill_2
XTAP_TAPCELL_ROW_70_1256 vssd1 vccd1 sky130_fd_sc_hd__tapvpwrvgnd_1
Xfanout445 FPGA_INST.cell0.CB_1.config_dataB\[5\] vssd1 vssd1 vccd1 vccd1 net445 sky130_fd_sc_hd__buf_2
Xfanout434 FPGA_INST.cell0.CB_0.config_dataA\[5\] vssd1 vssd1 vccd1 vccd1 net434 sky130_fd_sc_hd__clkbuf_2
Xfanout467 FPGA_INST.cell1.CB_0.config_dataA\[10\] vssd1 vssd1 vccd1 vccd1 net467
+ sky130_fd_sc_hd__clkbuf_2
XFILLER_86_454 vssd1 vssd1 vccd1 vccd1 sky130_fd_sc_hd__fill_4
XTAP_TAPCELL_ROW_70_1267 vssd1 vccd1 sky130_fd_sc_hd__tapvpwrvgnd_1
Xfanout478 FPGA_INST.cell2.CB_1.config_dataA\[10\] vssd1 vssd1 vccd1 vccd1 net478
+ sky130_fd_sc_hd__clkbuf_4
XANTENNA__09680__S net314 vssd1 vssd1 vccd1 vccd1 sky130_fd_sc_hd__diode_2
XFILLER_46_307 vssd1 vssd1 vccd1 vccd1 sky130_fd_sc_hd__fill_1
Xfanout489 FPGA_INST.cell2.CB_0.config_dataB\[15\] vssd1 vssd1 vccd1 vccd1 net489
+ sky130_fd_sc_hd__buf_2
X_09826_ FPGA_INST.cell0.LEI0.config_data\[4\] FPGA_INST.cell0.LEI0.config_data\[5\]
+ net174 vssd1 vssd1 vccd1 vccd1 _00734_ sky130_fd_sc_hd__mux2_1
XANTENNA_fanout840_A net842 vssd1 vssd1 vccd1 vccd1 sky130_fd_sc_hd__diode_2
X_09757_ FPGA_INST.cell1.CB_0.config_dataB\[8\] FPGA_INST.cell1.CB_0.config_dataB\[7\]
+ net368 vssd1 vssd1 vccd1 vccd1 _00666_ sky130_fd_sc_hd__mux2_1
X_06969_ _03236_ _03235_ _03124_ vssd1 vssd1 vccd1 vccd1 _03237_ sky130_fd_sc_hd__mux2_1
XANTENNA__06950__A0 FPGA_INST.bus2_0\[6\] vssd1 vssd1 vccd1 vccd1 sky130_fd_sc_hd__diode_2
X_08708_ net90 net84 FPGA_INST.cell3.LEI0.config_data\[24\] vssd1 vssd1 vccd1 vccd1
+ _04917_ sky130_fd_sc_hd__mux2_1
XANTENNA_fanout938_A net945 vssd1 vssd1 vccd1 vccd1 sky130_fd_sc_hd__diode_2
XFILLER_67_690 vssd1 vssd1 vccd1 vccd1 sky130_fd_sc_hd__fill_1
XANTENNA__08298__A3 FPGA_INST.bus1_0\[15\] vssd1 vssd1 vccd1 vccd1 sky130_fd_sc_hd__diode_2
XFILLER_54_340 vccd1 vssd1 vccd1 vssd1 sky130_ef_sc_hd__decap_40_12
X_09688_ FPGA_INST.cell0.SB0.route_sel\[92\] FPGA_INST.cell0.SB0.route_sel\[91\] net314
+ vssd1 vssd1 vccd1 vccd1 _00597_ sky130_fd_sc_hd__mux2_1
XFILLER_15_727 vssd1 vssd1 vccd1 vccd1 sky130_fd_sc_hd__fill_1
X_08639_ net25 net401 vssd1 vssd1 vccd1 vccd1 _04848_ sky130_fd_sc_hd__or2_1
XFILLER_14_226 vssd1 vssd1 vccd1 vccd1 sky130_fd_sc_hd__fill_2
X_11650_ net893 _00996_ net677 vssd1 vssd1 vccd1 vccd1 FPGA_INST.cell3.SB0.route_sel\[20\]
+ sky130_fd_sc_hd__dfstp_1
X_10601_ FPGA_INST.cell3.CB_0.config_dataB\[21\] FPGA_INST.cell3.CB_0.config_dataB\[20\]
+ net371 vssd1 vssd1 vccd1 vccd1 _01480_ sky130_fd_sc_hd__mux2_1
X_11581_ net759 _00931_ net544 vssd1 vssd1 vccd1 vccd1 FPGA_INST.cell0.CB_1.config_dataA\[0\]
+ sky130_fd_sc_hd__dfstp_1
Xfanout85 net87 vssd1 vssd1 vccd1 vccd1 net85 sky130_fd_sc_hd__clkbuf_2
Xfanout96 _01783_ vssd1 vssd1 vccd1 vccd1 net96 sky130_fd_sc_hd__buf_2
X_10532_ FPGA_INST.cell2.SB0.route_sel\[104\] FPGA_INST.cell2.SB0.route_sel\[105\]
+ net242 vssd1 vssd1 vccd1 vccd1 _01411_ sky130_fd_sc_hd__mux2_1
XFILLER_10_421 vssd1 vssd1 vccd1 vccd1 sky130_fd_sc_hd__fill_2
XTAP_TAPCELL_ROW_12_449 vssd1 vccd1 sky130_fd_sc_hd__tapvpwrvgnd_1
XFILLER_89_22 vssd1 vssd1 vccd1 vccd1 sky130_fd_sc_hd__fill_2
XFILLER_89_11 vssd1 vssd1 vccd1 vccd1 sky130_fd_sc_hd__fill_2
X_10463_ FPGA_INST.cell2.SB0.route_sel\[36\] FPGA_INST.cell2.SB0.route_sel\[35\] net352
+ vssd1 vssd1 vccd1 vccd1 _01342_ sky130_fd_sc_hd__mux2_1
X_10394_ FPGA_INST.cell3.LE_1A.config_data\[13\] FPGA_INST.cell3.LE_1A.config_data\[12\]
+ net376 vssd1 vssd1 vccd1 vccd1 _01273_ sky130_fd_sc_hd__mux2_1
XFILLER_89_66 vssd1 vssd1 vccd1 vccd1 sky130_fd_sc_hd__fill_4
XFILLER_89_55 vssd1 vssd1 vccd1 vccd1 sky130_fd_sc_hd__fill_1
XANTENNA__08612__X _04821_ vssd1 vssd1 vccd1 vccd1 sky130_fd_sc_hd__diode_2
XFILLER_123_334 vssd1 vssd1 vccd1 vccd1 sky130_fd_sc_hd__fill_2
X_12133_ net917 _01479_ net701 vssd1 vssd1 vccd1 vccd1 FPGA_INST.cell3.CB_0.config_dataB\[20\]
+ sky130_fd_sc_hd__dfstp_1
XFILLER_97_708 vssd1 vssd1 vccd1 vccd1 sky130_fd_sc_hd__fill_8
XANTENNA__07981__A2 _04013_ vssd1 vssd1 vccd1 vccd1 sky130_fd_sc_hd__diode_2
X_12064_ net857 _01410_ net642 vssd1 vssd1 vccd1 vccd1 FPGA_INST.cell2.SB0.route_sel\[104\]
+ sky130_fd_sc_hd__dfstp_1
XFILLER_104_581 vssd1 vssd1 vccd1 vccd1 sky130_fd_sc_hd__fill_4
X_11015_ net806 _00365_ net591 vssd1 vssd1 vccd1 vccd1 FPGA_INST.cell1.LEI0.config_data\[0\]
+ sky130_fd_sc_hd__dfrtp_1
XANTENNA__10708__CLK net851 vssd1 vssd1 vccd1 vccd1 sky130_fd_sc_hd__diode_2
XANTENNA_input22_X net22 vssd1 vssd1 vccd1 vccd1 sky130_fd_sc_hd__diode_2
XTAP_TAPCELL_ROW_88_1517 vssd1 vccd1 sky130_fd_sc_hd__tapvpwrvgnd_1
XFILLER_65_638 vssd1 vssd1 vccd1 vccd1 sky130_fd_sc_hd__fill_1
XFILLER_49_167 vssd1 vssd1 vccd1 vccd1 sky130_fd_sc_hd__fill_1
XFILLER_92_446 vssd1 vssd1 vccd1 vccd1 sky130_fd_sc_hd__fill_2
X_11917_ net943 _01263_ net727 vssd1 vssd1 vccd1 vccd1 FPGA_INST.cell3.LE_1A.config_data\[3\]
+ sky130_fd_sc_hd__dfrtp_1
X_11848_ net933 _01194_ net717 vssd1 vssd1 vccd1 vccd1 FPGA_INST.cell3.LEI0.config_data\[28\]
+ sky130_fd_sc_hd__dfrtp_1
XFILLER_60_365 vssd1 vssd1 vccd1 vccd1 sky130_fd_sc_hd__fill_4
XFILLER_13_270 vssd1 vssd1 vccd1 vccd1 sky130_fd_sc_hd__fill_2
XFILLER_20_218 vssd1 vssd1 vccd1 vccd1 sky130_fd_sc_hd__fill_1
XFILLER_20_229 vssd1 vssd1 vccd1 vccd1 sky130_fd_sc_hd__fill_1
XTAP_TAPCELL_ROW_31_714 vssd1 vccd1 sky130_fd_sc_hd__tapvpwrvgnd_1
X_11779_ net925 _01125_ net709 vssd1 vssd1 vccd1 vccd1 FPGA_INST.io_south_oeb\[10\]
+ sky130_fd_sc_hd__dfrtp_1
XTAP_TAPCELL_ROW_99_1668 vssd1 vccd1 sky130_fd_sc_hd__tapvpwrvgnd_1
XFILLER_9_285 vssd1 vssd1 vccd1 vccd1 sky130_fd_sc_hd__fill_2
XFILLER_62_3 vssd1 vssd1 vccd1 vccd1 sky130_fd_sc_hd__fill_4
XANTENNA__06472__A2 net11 vssd1 vssd1 vccd1 vccd1 sky130_fd_sc_hd__diode_2
XFILLER_126_183 vccd1 vssd1 vccd1 vssd1 sky130_ef_sc_hd__decap_40_12
XFILLER_114_367 vssd1 vssd1 vccd1 vccd1 sky130_fd_sc_hd__fill_4
XTAP_TAPCELL_ROW_110_1824 vssd1 vccd1 sky130_fd_sc_hd__tapvpwrvgnd_1
X_08990_ _01558_ FPGA_INST.cell2.SB0.route_sel\[41\] FPGA_INST.cell2.SB0.route_sel\[46\]
+ FPGA_INST.cell2.SB0.route_sel\[47\] _05166_ vssd1 vssd1 vccd1 vccd1 _05167_ sky130_fd_sc_hd__o221a_1
X_07941_ FPGA_INST.bus3_1\[8\] FPGA_INST.bus3_1\[9\] FPGA_INST.bus3_1\[10\] FPGA_INST.bus3_1\[11\]
+ net467 FPGA_INST.cell1.CB_0.config_dataA\[11\] vssd1 vssd1 vccd1 vccd1 _04169_ sky130_fd_sc_hd__mux4_1
X_07872_ _04099_ vssd1 vssd1 vccd1 vccd1 _04100_ sky130_fd_sc_hd__inv_2
XANTENNA__07185__B1 net78 vssd1 vssd1 vccd1 vccd1 sky130_fd_sc_hd__diode_2
X_09611_ FPGA_INST.cell0.SB0.route_sel\[14\] FPGA_INST.cell0.SB0.route_sel\[15\] net200
+ vssd1 vssd1 vccd1 vccd1 _00520_ sky130_fd_sc_hd__mux2_1
X_06823_ net875 FPGA_INST.cell2.LE_0B.edge_mode vssd1 vssd1 vccd1 vccd1 FPGA_INST.cell2.LE_0B.sel_clk
+ sky130_fd_sc_hd__xnor2_1
XANTENNA__05735__A1 net122 vssd1 vssd1 vccd1 vccd1 sky130_fd_sc_hd__diode_2
XTAP_TAPCELL_ROW_39_825 vssd1 vccd1 sky130_fd_sc_hd__tapvpwrvgnd_1
X_09542_ FPGA_INST.cell1.LE_0B.config_data\[15\] FPGA_INST.cell1.LE_0B.config_data\[14\]
+ net347 vssd1 vssd1 vccd1 vccd1 _00452_ sky130_fd_sc_hd__mux2_1
X_06754_ _02843_ _03021_ _03022_ _02840_ FPGA_INST.cell2.CB_1.config_dataB\[12\] vssd1
+ vssd1 vccd1 vccd1 _03028_ sky130_fd_sc_hd__a221o_1
XFILLER_36_351 vssd1 vssd1 vccd1 vccd1 sky130_fd_sc_hd__fill_2
X_05705_ net384 net166 _01981_ _01983_ vssd1 vssd1 vccd1 vccd1 _01985_ sky130_fd_sc_hd__a2bb2o_1
X_09473_ FPGA_INST.cell1.LEI0.config_data\[19\] FPGA_INST.cell1.LEI0.config_data\[20\]
+ net214 vssd1 vssd1 vccd1 vccd1 _00385_ sky130_fd_sc_hd__mux2_1
XTAP_TAPCELL_ROW_108_1797 vssd1 vccd1 sky130_fd_sc_hd__tapvpwrvgnd_1
XFILLER_64_682 vssd1 vssd1 vccd1 vccd1 sky130_fd_sc_hd__fill_4
X_06685_ _01593_ FPGA_INST.cell2.LE_1A.dff_out vssd1 vssd1 vccd1 vccd1 _02960_ sky130_fd_sc_hd__or2_1
X_05636_ net506 _01869_ _01915_ net505 vssd1 vssd1 vccd1 vccd1 _01916_ sky130_fd_sc_hd__o211a_1
X_08424_ _04642_ _04645_ _04603_ vssd1 vssd1 vccd1 vccd1 _04646_ sky130_fd_sc_hd__mux2_1
XANTENNA__06160__A1 _02431_ vssd1 vssd1 vccd1 vccd1 sky130_fd_sc_hd__diode_2
XANTENNA__10492__A0 FPGA_INST.cell2.SB0.route_sel\[64\] vssd1 vssd1 vccd1 vccd1 sky130_fd_sc_hd__diode_2
XTAP_TAPCELL_ROW_121_1975 vssd1 vccd1 sky130_fd_sc_hd__tapvpwrvgnd_1
X_05567_ FPGA_INST.cell2.CB_1.config_dataB\[23\] FPGA_INST.cell2.CB_1.config_dataB\[22\]
+ vssd1 vssd1 vccd1 vccd1 _01847_ sky130_fd_sc_hd__nand2_1
X_08355_ FPGA_INST.cell0.CB_1.config_dataB\[11\] net442 vssd1 vssd1 vccd1 vccd1 _04577_
+ sky130_fd_sc_hd__and2b_1
X_07306_ FPGA_INST.cell1.SB0.route_sel\[28\] _01698_ FPGA_INST.cell1.SB0.route_sel\[31\]
+ _01699_ _03566_ vssd1 vssd1 vccd1 vccd1 _03567_ sky130_fd_sc_hd__a221o_1
XFILLER_20_752 vssd1 vssd1 vccd1 vccd1 sky130_fd_sc_hd__fill_2
X_05498_ FPGA_INST.cell3.LE_0B.config_data\[16\] vssd1 vssd1 vccd1 vccd1 _01780_ sky130_fd_sc_hd__inv_2
X_08286_ FPGA_INST.cell0.LE_1A.config_data\[8\] FPGA_INST.cell0.LE_1A.config_data\[9\]
+ _04410_ vssd1 vssd1 vccd1 vccd1 _04510_ sky130_fd_sc_hd__mux2_1
X_07237_ FPGA_INST.cell1.CB_0.config_dataB\[24\] FPGA_INST.cell1.CB_0.config_dataB\[20\]
+ FPGA_INST.cell1.CB_0.config_dataB\[21\] vssd1 vssd1 vccd1 vccd1 _03499_ sky130_fd_sc_hd__or3b_2
XTAP_TAPCELL_ROW_59_1107 vssd1 vccd1 sky130_fd_sc_hd__tapvpwrvgnd_1
X_07168_ FPGA_INST.cell3.SB0.route_sel\[2\] FPGA_INST.cell3.SB0.route_sel\[3\] _03423_
+ _03427_ _03431_ vssd1 vssd1 vccd1 vccd1 _03432_ sky130_fd_sc_hd__a41o_1
XANTENNA_fanout790_A net1 vssd1 vssd1 vccd1 vccd1 sky130_fd_sc_hd__diode_2
XANTENNA__09675__S net184 vssd1 vssd1 vccd1 vccd1 sky130_fd_sc_hd__diode_2
XFILLER_117_172 vssd1 vssd1 vccd1 vccd1 sky130_fd_sc_hd__fill_1
XFILLER_105_312 vssd1 vssd1 vccd1 vccd1 sky130_fd_sc_hd__fill_1
XANTENNA__07412__A1 _03526_ vssd1 vssd1 vccd1 vccd1 sky130_fd_sc_hd__diode_2
X_06119_ _01849_ _02358_ vssd1 vssd1 vccd1 vccd1 _02399_ sky130_fd_sc_hd__nor2_1
X_07099_ FPGA_INST.bus2_0\[4\] _03353_ _03364_ _01738_ FPGA_INST.cell0.CB_0.config_dataA\[18\]
+ vssd1 vssd1 vccd1 vccd1 _03365_ sky130_fd_sc_hd__a2111o_1
Xfanout231 net232 vssd1 vssd1 vccd1 vccd1 net231 sky130_fd_sc_hd__clkbuf_4
Xfanout220 net221 vssd1 vssd1 vccd1 vccd1 net220 sky130_fd_sc_hd__clkbuf_4
XANTENNA_fanout676_X net676 vssd1 vssd1 vccd1 vccd1 sky130_fd_sc_hd__diode_2
XFILLER_101_551 vssd1 vssd1 vccd1 vccd1 sky130_fd_sc_hd__fill_2
Xfanout264 net265 vssd1 vssd1 vccd1 vccd1 net264 sky130_fd_sc_hd__clkbuf_4
XFILLER_59_465 vssd1 vssd1 vccd1 vccd1 sky130_fd_sc_hd__fill_1
Xfanout242 net244 vssd1 vssd1 vccd1 vccd1 net242 sky130_fd_sc_hd__clkbuf_4
Xfanout253 net254 vssd1 vssd1 vccd1 vccd1 net253 sky130_fd_sc_hd__clkbuf_4
X_09809_ FPGA_INST.cell1.LE_1B.config_data\[9\] FPGA_INST.cell1.LE_1B.config_data\[10\]
+ net217 vssd1 vssd1 vccd1 vccd1 _00718_ sky130_fd_sc_hd__mux2_1
Xfanout297 net300 vssd1 vssd1 vccd1 vccd1 net297 sky130_fd_sc_hd__clkbuf_2
XFILLER_87_796 vssd1 vssd1 vccd1 vccd1 sky130_fd_sc_hd__fill_2
Xfanout286 net288 vssd1 vssd1 vccd1 vccd1 net286 sky130_fd_sc_hd__clkbuf_4
Xfanout275 net276 vssd1 vssd1 vccd1 vccd1 net275 sky130_fd_sc_hd__buf_2
XANTENNA_fanout843_X net843 vssd1 vssd1 vccd1 vccd1 sky130_fd_sc_hd__diode_2
XFILLER_75_79 vssd1 vssd1 vccd1 vccd1 sky130_fd_sc_hd__fill_1
XFILLER_75_57 vssd1 vssd1 vccd1 vccd1 sky130_fd_sc_hd__fill_1
XFILLER_46_137 vssd1 vssd1 vccd1 vccd1 sky130_fd_sc_hd__fill_2
XFILLER_15_502 vssd1 vssd1 vccd1 vccd1 sky130_fd_sc_hd__fill_2
XTAP_TAPCELL_ROW_17_519 vssd1 vccd1 sky130_fd_sc_hd__tapvpwrvgnd_1
X_11702_ net904 _01048_ net688 vssd1 vssd1 vccd1 vccd1 FPGA_INST.cell3.SB0.route_sel\[72\]
+ sky130_fd_sc_hd__dfstp_1
XTAP_TAPCELL_ROW_83_1447 vssd1 vccd1 sky130_fd_sc_hd__tapvpwrvgnd_1
XFILLER_42_354 vssd1 vssd1 vccd1 vccd1 sky130_fd_sc_hd__fill_1
XFILLER_42_343 vssd1 vssd1 vccd1 vccd1 sky130_fd_sc_hd__fill_2
XANTENNA__08691__A3 net26 vssd1 vssd1 vccd1 vccd1 sky130_fd_sc_hd__diode_2
X_11633_ net896 _00979_ net680 vssd1 vssd1 vccd1 vccd1 FPGA_INST.cell3.SB0.route_sel\[3\]
+ sky130_fd_sc_hd__dfstp_1
XFILLER_70_696 vssd1 vssd1 vccd1 vccd1 sky130_fd_sc_hd__fill_2
XFILLER_70_685 vssd1 vssd1 vccd1 vccd1 sky130_fd_sc_hd__fill_1
XFILLER_24_50 vssd1 vssd1 vccd1 vccd1 sky130_fd_sc_hd__fill_1
XANTENNA__08979__A1 _03677_ vssd1 vssd1 vccd1 vccd1 sky130_fd_sc_hd__diode_2
XFILLER_10_251 vssd1 vssd1 vccd1 vccd1 sky130_fd_sc_hd__fill_1
X_11564_ net771 _00914_ net556 vssd1 vssd1 vccd1 vccd1 FPGA_INST.cell0.CB_0.config_dataB\[8\]
+ sky130_fd_sc_hd__dfstp_1
XFILLER_11_785 vssd1 vssd1 vccd1 vccd1 sky130_fd_sc_hd__fill_2
XFILLER_109_651 vssd1 vssd1 vccd1 vccd1 sky130_fd_sc_hd__fill_1
X_11495_ net792 _00845_ net577 vssd1 vssd1 vccd1 vccd1 FPGA_INST.cell0.CB_1.config_dataB\[1\]
+ sky130_fd_sc_hd__dfstp_1
XFILLER_6_222 vssd1 vssd1 vccd1 vccd1 sky130_fd_sc_hd__fill_8
XFILLER_11_796 vssd1 vssd1 vccd1 vccd1 sky130_fd_sc_hd__fill_1
XANTENNA__06454__A2 _02255_ vssd1 vssd1 vccd1 vccd1 sky130_fd_sc_hd__diode_2
X_10515_ FPGA_INST.cell2.SB0.route_sel\[87\] FPGA_INST.cell2.SB0.route_sel\[88\] net251
+ vssd1 vssd1 vccd1 vccd1 _01394_ sky130_fd_sc_hd__mux2_1
XFILLER_108_150 vssd1 vssd1 vccd1 vccd1 sky130_fd_sc_hd__fill_8
X_10446_ FPGA_INST.cell2.SB0.route_sel\[18\] FPGA_INST.cell2.SB0.route_sel\[19\] net235
+ vssd1 vssd1 vccd1 vccd1 _01325_ sky130_fd_sc_hd__mux2_1
XFILLER_124_643 vssd1 vssd1 vccd1 vccd1 sky130_fd_sc_hd__fill_1
XFILLER_108_183 vssd1 vssd1 vccd1 vccd1 sky130_fd_sc_hd__fill_2
XFILLER_6_288 vssd1 vssd1 vccd1 vccd1 sky130_fd_sc_hd__fill_1
X_10377_ FPGA_INST.cell3.LE_0B.reset_val FPGA_INST.cell3.LE_0B.reset_mode net305 vssd1
+ vssd1 vccd1 vccd1 _01257_ sky130_fd_sc_hd__mux2_1
XTAP_TAPCELL_ROW_94_1598 vssd1 vccd1 sky130_fd_sc_hd__tapvpwrvgnd_1
X_12116_ net936 _01462_ net720 vssd1 vssd1 vccd1 vccd1 FPGA_INST.cell3.CB_0.config_dataB\[3\]
+ sky130_fd_sc_hd__dfstp_1
XFILLER_69_229 vssd1 vssd1 vccd1 vccd1 sky130_fd_sc_hd__fill_2
XFILLER_34_7 vssd1 vssd1 vccd1 vccd1 sky130_fd_sc_hd__fill_1
X_12047_ net866 _01393_ net653 vssd1 vssd1 vccd1 vccd1 FPGA_INST.cell2.SB0.route_sel\[87\]
+ sky130_fd_sc_hd__dfstp_1
XTAP_TAPCELL_ROW_125_2031 vssd1 vccd1 sky130_fd_sc_hd__tapvpwrvgnd_1
XANTENNA__05717__A1 net133 vssd1 vssd1 vccd1 vccd1 sky130_fd_sc_hd__diode_2
XFILLER_37_137 vssd1 vssd1 vccd1 vccd1 sky130_fd_sc_hd__fill_1
XANTENNA__06390__A1 net2 vssd1 vssd1 vccd1 vccd1 sky130_fd_sc_hd__diode_2
XANTENNA__06390__B2 net30 vssd1 vssd1 vccd1 vccd1 sky130_fd_sc_hd__diode_2
XANTENNA__07134__A FPGA_INST.cell1.CB_0.config_dataB\[24\] vssd1 vssd1 vccd1 vccd1
+ sky130_fd_sc_hd__diode_2
X_06470_ _02010_ _02728_ _02729_ _01966_ _01544_ vssd1 vssd1 vccd1 vccd1 _02748_ sky130_fd_sc_hd__a221o_1
X_05421_ FPGA_INST.cell3.SB0.route_sel\[18\] vssd1 vssd1 vccd1 vccd1 _01703_ sky130_fd_sc_hd__inv_2
X_08140_ _04362_ _04363_ _04365_ vssd1 vssd1 vccd1 vccd1 _04366_ sky130_fd_sc_hd__and3_1
XANTENNA__06693__A2 FPGA_INST.bus3_2\[14\] vssd1 vssd1 vccd1 vccd1 sky130_fd_sc_hd__diode_2
XTAP_TAPCELL_ROW_44_894 vssd1 vccd1 sky130_fd_sc_hd__tapvpwrvgnd_1
X_05352_ FPGA_INST.cell1.SB0.route_sel\[90\] vssd1 vssd1 vccd1 vccd1 _01634_ sky130_fd_sc_hd__inv_2
X_08071_ FPGA_INST.cell1.LE_0B.config_data\[5\] FPGA_INST.cell1.LE_0B.config_data\[4\]
+ _04296_ vssd1 vssd1 vccd1 vccd1 _04297_ sky130_fd_sc_hd__mux2_1
X_05283_ FPGA_INST.cell2.SB0.route_sel\[65\] vssd1 vssd1 vccd1 vccd1 _01565_ sky130_fd_sc_hd__inv_2
X_07022_ _03281_ _03287_ FPGA_INST.cell0.CB_0.config_dataA\[2\] vssd1 vssd1 vccd1
+ vccd1 _03288_ sky130_fd_sc_hd__o21ai_1
XANTENNA__07945__A2 _04013_ vssd1 vssd1 vccd1 vccd1 sky130_fd_sc_hd__diode_2
XTAP_TAPCELL_ROW_54_1037 vssd1 vccd1 sky130_fd_sc_hd__tapvpwrvgnd_1
X_08973_ _05155_ _02214_ vssd1 vssd1 vccd1 vccd1 FPGA_INST.bus2_0\[7\] sky130_fd_sc_hd__and2b_2
X_07924_ net466 net465 vssd1 vssd1 vccd1 vccd1 _04152_ sky130_fd_sc_hd__nor2_1
XFILLER_56_402 vccd1 vssd1 vccd1 vssd1 sky130_ef_sc_hd__decap_40_12
XFILLER_29_627 vssd1 vssd1 vccd1 vccd1 sky130_fd_sc_hd__fill_4
XANTENNA_fanout371_A net372 vssd1 vssd1 vccd1 vccd1 sky130_fd_sc_hd__diode_2
X_07855_ net468 net469 vssd1 vssd1 vccd1 vccd1 _04083_ sky130_fd_sc_hd__nand2b_1
XFILLER_84_755 vssd1 vssd1 vccd1 vccd1 sky130_fd_sc_hd__fill_1
XFILLER_56_435 vssd1 vssd1 vccd1 vccd1 sky130_fd_sc_hd__fill_1
XANTENNA__08370__A2 net74 vssd1 vssd1 vccd1 vccd1 sky130_fd_sc_hd__diode_2
XANTENNA__06905__A0 FPGA_INST.bus2_0\[8\] vssd1 vssd1 vccd1 vccd1 sky130_fd_sc_hd__diode_2
XFILLER_28_126 vssd1 vssd1 vccd1 vccd1 sky130_fd_sc_hd__fill_1
X_07786_ FPGA_INST.cell1.SB0.route_sel\[120\] FPGA_INST.cell1.SB0.route_sel\[121\]
+ _04031_ _04032_ _04033_ vssd1 vssd1 vccd1 vccd1 _04035_ sky130_fd_sc_hd__a221o_1
X_06806_ _03078_ _03079_ _03019_ vssd1 vssd1 vccd1 vccd1 _03080_ sky130_fd_sc_hd__mux2_1
X_09525_ net736 _04683_ vssd1 vssd1 vccd1 vccd1 _05215_ sky130_fd_sc_hd__nand2_1
X_06737_ FPGA_INST.bus3_2\[2\] FPGA_INST.bus3_2\[3\] net517 vssd1 vssd1 vccd1 vccd1
+ _03011_ sky130_fd_sc_hd__mux2_1
XFILLER_37_671 vssd1 vssd1 vccd1 vccd1 sky130_fd_sc_hd__fill_1
X_09456_ FPGA_INST.cell1.LEI0.config_data\[2\] FPGA_INST.cell1.LEI0.config_data\[3\]
+ net214 vssd1 vssd1 vccd1 vccd1 _00368_ sky130_fd_sc_hd__mux2_1
XFILLER_64_490 vssd1 vssd1 vccd1 vccd1 sky130_fd_sc_hd__fill_1
X_06668_ FPGA_INST.cell2.LEI0.config_data\[42\] net130 _02943_ FPGA_INST.cell2.LEI0.config_data\[43\]
+ vssd1 vssd1 vccd1 vccd1 _02944_ sky130_fd_sc_hd__o211a_1
XANTENNA_fanout636_A net676 vssd1 vssd1 vccd1 vccd1 sky130_fd_sc_hd__diode_2
XFILLER_101_55 vssd1 vssd1 vccd1 vccd1 sky130_fd_sc_hd__fill_1
XTAP_TAPCELL_ROW_65_1188 vssd1 vccd1 sky130_fd_sc_hd__tapvpwrvgnd_1
X_05619_ net129 _01897_ vssd1 vssd1 vccd1 vccd1 _01899_ sky130_fd_sc_hd__and2_1
X_08407_ _03639_ _04608_ _04609_ _03604_ _01760_ vssd1 vssd1 vccd1 vccd1 _04629_ sky130_fd_sc_hd__a221o_1
XFILLER_52_696 vssd1 vssd1 vccd1 vccd1 sky130_fd_sc_hd__fill_4
XFILLER_12_516 vssd1 vssd1 vccd1 vccd1 sky130_fd_sc_hd__fill_8
XANTENNA__07881__A1 net147 vssd1 vssd1 vccd1 vccd1 sky130_fd_sc_hd__diode_2
XFILLER_101_99 vssd1 vssd1 vccd1 vccd1 sky130_fd_sc_hd__fill_4
XANTENNA_fanout803_A net843 vssd1 vssd1 vccd1 vccd1 sky130_fd_sc_hd__diode_2
XTAP_TAPCELL_ROW_65_1199 vssd1 vccd1 sky130_fd_sc_hd__tapvpwrvgnd_1
X_06599_ FPGA_INST.cell2.CB_1.config_dataA\[3\] FPGA_INST.cell2.CB_1.config_dataA\[2\]
+ _02850_ vssd1 vssd1 vccd1 vccd1 _02875_ sky130_fd_sc_hd__or3b_1
X_09387_ net495 net493 net252 vssd1 vssd1 vccd1 vccd1 _00300_ sky130_fd_sc_hd__mux2_1
XANTENNA__05499__A net736 vssd1 vssd1 vccd1 vccd1 sky130_fd_sc_hd__diode_2
X_08338_ net448 _03504_ _04559_ net447 vssd1 vssd1 vccd1 vccd1 _04560_ sky130_fd_sc_hd__o211a_1
X_08269_ _04486_ _04487_ _04489_ _04484_ vssd1 vssd1 vccd1 vccd1 _04493_ sky130_fd_sc_hd__o22a_1
XTAP_TAPCELL_ROW_22_588 vssd1 vccd1 sky130_fd_sc_hd__tapvpwrvgnd_1
XPHY_EDGE_ROW_128_Left_259 vssd1 vssd1 vccd1 vccd1 sky130_fd_sc_hd__decap_3
X_10300_ FPGA_INST.cell3.LEI0.config_data\[14\] FPGA_INST.cell3.LEI0.config_data\[15\]
+ net296 vssd1 vssd1 vccd1 vccd1 _01181_ sky130_fd_sc_hd__mux2_1
X_11280_ net786 _00630_ net571 vssd1 vssd1 vccd1 vccd1 FPGA_INST.cell0.SB0.route_sel\[125\]
+ sky130_fd_sc_hd__dfstp_1
X_10231_ FPGA_INST.io_west_oeb\[14\] FPGA_INST.io_west_oeb\[16\] net291 vssd1 vssd1
+ vccd1 vccd1 _01112_ sky130_fd_sc_hd__mux2_1
XFILLER_3_225 vssd1 vssd1 vccd1 vccd1 sky130_fd_sc_hd__fill_4
XFILLER_79_505 vssd1 vssd1 vccd1 vccd1 sky130_fd_sc_hd__fill_1
X_10162_ FPGA_INST.cell3.SB0.route_sel\[66\] FPGA_INST.cell3.SB0.route_sel\[67\] net276
+ vssd1 vssd1 vccd1 vccd1 _01043_ sky130_fd_sc_hd__mux2_1
XFILLER_10_96 vssd1 vssd1 vccd1 vccd1 sky130_fd_sc_hd__fill_1
XFILLER_126_96 vssd1 vssd1 vccd1 vccd1 sky130_fd_sc_hd__fill_1
XANTENNA__07149__A0 net150 vssd1 vssd1 vccd1 vccd1 sky130_fd_sc_hd__diode_2
X_10093_ FPGA_INST.cell0.LE_1B.reset_val FPGA_INST.cell0.LE_1B.edge_mode net307 vssd1
+ vssd1 vccd1 vccd1 _00974_ sky130_fd_sc_hd__mux2_1
XFILLER_120_178 vssd1 vssd1 vccd1 vccd1 sky130_fd_sc_hd__fill_2
XFILLER_59_251 vssd1 vssd1 vccd1 vccd1 sky130_fd_sc_hd__fill_1
XFILLER_19_148 vccd1 vssd1 vccd1 vssd1 sky130_ef_sc_hd__decap_40_12
XFILLER_28_660 vssd1 vssd1 vccd1 vccd1 sky130_fd_sc_hd__fill_1
XFILLER_35_608 vssd1 vssd1 vccd1 vccd1 sky130_fd_sc_hd__fill_1
XFILLER_62_449 vssd1 vssd1 vccd1 vccd1 sky130_fd_sc_hd__fill_2
XFILLER_15_310 vssd1 vssd1 vccd1 vccd1 sky130_fd_sc_hd__fill_2
X_10995_ net890 _00345_ net674 vssd1 vssd1 vccd1 vccd1 FPGA_INST.cell2.LE_1B.config_data\[1\]
+ sky130_fd_sc_hd__dfrtp_1
XFILLER_30_302 vssd1 vssd1 vccd1 vccd1 sky130_fd_sc_hd__fill_4
XANTENNA__10519__S net354 vssd1 vssd1 vccd1 vccd1 sky130_fd_sc_hd__diode_2
XTAP_TAPCELL_ROW_41_853 vssd1 vccd1 sky130_fd_sc_hd__tapvpwrvgnd_1
X_11616_ net741 _00966_ net526 vssd1 vssd1 vccd1 vccd1 FPGA_INST.cell0.LE_1B.config_data\[10\]
+ sky130_fd_sc_hd__dfrtp_1
XFILLER_30_357 vssd1 vssd1 vccd1 vccd1 sky130_fd_sc_hd__fill_4
X_11547_ net770 _00897_ net555 vssd1 vssd1 vccd1 vccd1 FPGA_INST.cell0.CB_0.config_dataA\[16\]
+ sky130_fd_sc_hd__dfstp_1
XFILLER_128_289 vssd1 vssd1 vccd1 vccd1 sky130_fd_sc_hd__fill_1
XTAP_TAPCELL_ROW_96_1627 vssd1 vccd1 sky130_fd_sc_hd__tapvpwrvgnd_1
X_11478_ net745 _00828_ net530 vssd1 vssd1 vccd1 vccd1 FPGA_INST.cell0.LE_1A.config_data\[5\]
+ sky130_fd_sc_hd__dfrtp_1
XFILLER_112_602 vssd1 vssd1 vccd1 vccd1 sky130_fd_sc_hd__fill_1
X_10429_ FPGA_INST.cell2.SB0.route_sel\[1\] FPGA_INST.cell2.SB0.route_sel\[2\] net243
+ vssd1 vssd1 vccd1 vccd1 _01308_ sky130_fd_sc_hd__mux2_1
XFILLER_3_781 vssd1 vssd1 vccd1 vccd1 sky130_fd_sc_hd__fill_2
X_05970_ net137 _02247_ vssd1 vssd1 vccd1 vccd1 _02250_ sky130_fd_sc_hd__nand2_1
XFILLER_66_755 vssd1 vssd1 vccd1 vccd1 sky130_fd_sc_hd__fill_1
XANTENNA__06687__B _02832_ vssd1 vssd1 vccd1 vccd1 sky130_fd_sc_hd__diode_2
X_07640_ _02075_ _02832_ _02077_ _02076_ vssd1 vssd1 vccd1 vccd1 _03893_ sky130_fd_sc_hd__a211o_1
XTAP_TAPCELL_ROW_49_975 vssd1 vccd1 sky130_fd_sc_hd__tapvpwrvgnd_1
XTAP_TAPCELL_ROW_49_964 vssd1 vccd1 sky130_fd_sc_hd__tapvpwrvgnd_1
XANTENNA__06363__A1 _02010_ vssd1 vssd1 vccd1 vccd1 sky130_fd_sc_hd__diode_2
X_07571_ FPGA_INST.cell3.SB0.route_sel\[72\] FPGA_INST.cell3.SB0.route_sel\[73\] vssd1
+ vssd1 vccd1 vccd1 _03826_ sky130_fd_sc_hd__or2_1
XANTENNA__07560__B1 _02843_ vssd1 vssd1 vccd1 vccd1 sky130_fd_sc_hd__diode_2
XFILLER_53_427 vssd1 vssd1 vccd1 vccd1 sky130_fd_sc_hd__fill_1
XANTENNA__06363__B2 _01966_ vssd1 vssd1 vccd1 vccd1 sky130_fd_sc_hd__diode_2
XTAP_TAPCELL_ROW_105_1756 vssd1 vccd1 sky130_fd_sc_hd__tapvpwrvgnd_1
X_09310_ FPGA_INST.cell1.SB0.route_sel\[82\] FPGA_INST.cell1.SB0.route_sel\[81\] net326
+ vssd1 vssd1 vccd1 vccd1 _00223_ sky130_fd_sc_hd__mux2_1
X_06522_ _02793_ _02797_ FPGA_INST.cell2.CB_1.config_dataA\[5\] vssd1 vssd1 vccd1
+ vccd1 _02798_ sky130_fd_sc_hd__mux2_1
XFILLER_80_268 vssd1 vssd1 vccd1 vccd1 sky130_fd_sc_hd__fill_1
XFILLER_33_162 vssd1 vssd1 vccd1 vccd1 sky130_fd_sc_hd__fill_2
XANTENNA__07863__B2 _03652_ vssd1 vssd1 vccd1 vccd1 sky130_fd_sc_hd__diode_2
X_09241_ FPGA_INST.cell1.SB0.route_sel\[12\] FPGA_INST.cell1.SB0.route_sel\[13\] net221
+ vssd1 vssd1 vccd1 vccd1 _00154_ sky130_fd_sc_hd__mux2_1
X_06453_ net488 _02217_ vssd1 vssd1 vccd1 vccd1 _02731_ sky130_fd_sc_hd__nand2_1
XANTENNA__09065__A0 net84 vssd1 vssd1 vccd1 vccd1 sky130_fd_sc_hd__diode_2
XANTENNA__07311__B FPGA_INST.cell3.SB0.route_sel\[31\] vssd1 vssd1 vccd1 vccd1 sky130_fd_sc_hd__diode_2
X_06384_ _02660_ _02661_ FPGA_INST.cell2.CB_0.config_dataB\[2\] vssd1 vssd1 vccd1
+ vccd1 _02662_ sky130_fd_sc_hd__or3b_1
X_09172_ FPGA_INST.cell2.LE_0B.config_data\[13\] FPGA_INST.cell2.LE_0B.config_data\[12\]
+ net358 vssd1 vssd1 vccd1 vccd1 _00086_ sky130_fd_sc_hd__mux2_1
X_05404_ FPGA_INST.cell0.SB0.route_sel\[47\] vssd1 vssd1 vccd1 vccd1 _01686_ sky130_fd_sc_hd__inv_2
XFILLER_119_245 vssd1 vssd1 vccd1 vccd1 sky130_fd_sc_hd__fill_1
XFILLER_119_223 vssd1 vssd1 vccd1 vccd1 sky130_fd_sc_hd__fill_1
X_08123_ net452 _03854_ _04348_ FPGA_INST.cell1.CB_0.config_dataB\[16\] vssd1 vssd1
+ vccd1 vccd1 _04349_ sky130_fd_sc_hd__o211a_1
X_05335_ FPGA_INST.cell3.SB0.route_sel\[109\] vssd1 vssd1 vccd1 vccd1 _01617_ sky130_fd_sc_hd__inv_2
XANTENNA__06418__A2 _01869_ vssd1 vssd1 vccd1 vccd1 sky130_fd_sc_hd__diode_2
XFILLER_119_278 vssd1 vssd1 vccd1 vccd1 sky130_fd_sc_hd__fill_2
X_08054_ net460 net459 _03769_ vssd1 vssd1 vccd1 vccd1 _04280_ sky130_fd_sc_hd__or3_1
X_07005_ _03269_ _03270_ _03267_ vssd1 vssd1 vccd1 vccd1 _03271_ sky130_fd_sc_hd__o21a_1
X_05266_ FPGA_INST.cell2.SB0.route_sel\[0\] vssd1 vssd1 vccd1 vccd1 _01548_ sky130_fd_sc_hd__inv_2
XFILLER_1_718 vssd1 vssd1 vccd1 vccd1 sky130_fd_sc_hd__fill_8
XFILLER_0_217 vssd1 vssd1 vccd1 vccd1 sky130_fd_sc_hd__fill_4
XANTENNA__06051__B1 _02330_ vssd1 vssd1 vccd1 vccd1 sky130_fd_sc_hd__diode_2
XFILLER_0_239 vssd1 vssd1 vccd1 vccd1 sky130_fd_sc_hd__fill_1
XFILLER_102_156 vssd1 vssd1 vccd1 vccd1 sky130_fd_sc_hd__fill_1
X_08956_ FPGA_INST.cell3.SB0.route_sel\[78\] FPGA_INST.cell3.SB0.route_sel\[79\] vssd1
+ vssd1 vccd1 vccd1 _05144_ sky130_fd_sc_hd__nor2_1
XANTENNA__05782__A net112 vssd1 vssd1 vccd1 vccd1 sky130_fd_sc_hd__diode_2
X_08887_ _05088_ _05089_ _05092_ _05093_ vssd1 vssd1 vccd1 vccd1 _05094_ sky130_fd_sc_hd__o22a_1
X_07907_ FPGA_INST.bus3_1\[12\] FPGA_INST.bus3_1\[13\] FPGA_INST.bus3_1\[14\] FPGA_INST.bus3_1\[15\]
+ net472 net471 vssd1 vssd1 vccd1 vccd1 _04135_ sky130_fd_sc_hd__mux4_1
XANTENNA_fanout374_X net374 vssd1 vssd1 vccd1 vccd1 sky130_fd_sc_hd__diode_2
X_07838_ _04072_ net136 _02247_ vssd1 vssd1 vccd1 vccd1 net50 sky130_fd_sc_hd__mux2_1
XTAP_TAPCELL_ROW_67_1217 vssd1 vccd1 sky130_fd_sc_hd__tapvpwrvgnd_1
X_09508_ FPGA_INST.cell1.LE_0A.config_data\[3\] FPGA_INST.cell1.LE_0A.config_data\[4\]
+ net229 vssd1 vssd1 vccd1 vccd1 _00419_ sky130_fd_sc_hd__mux2_1
X_07769_ _03532_ _03939_ vssd1 vssd1 vccd1 vccd1 _04019_ sky130_fd_sc_hd__nor2_1
XTAP_TAPCELL_ROW_27_658 vssd1 vccd1 sky130_fd_sc_hd__tapvpwrvgnd_1
XTAP_TAPCELL_ROW_80_1406 vssd1 vccd1 sky130_fd_sc_hd__tapvpwrvgnd_1
X_10780_ net901 _00130_ net685 vssd1 vssd1 vccd1 vccd1 FPGA_INST.cell2.CB_1.config_dataB\[14\]
+ sky130_fd_sc_hd__dfstp_1
X_09439_ FPGA_INST.cell2.LE_1B.config_data\[7\] FPGA_INST.cell2.LE_1B.config_data\[8\]
+ net290 vssd1 vssd1 vccd1 vccd1 _00352_ sky130_fd_sc_hd__mux2_1
XANTENNA__06657__A2 FPGA_INST.bus3_2\[6\] vssd1 vssd1 vccd1 vccd1 sky130_fd_sc_hd__diode_2
XFILLER_12_346 vssd1 vssd1 vccd1 vccd1 sky130_fd_sc_hd__fill_4
X_11401_ net748 _00751_ net533 vssd1 vssd1 vccd1 vccd1 FPGA_INST.cell0.LEI0.config_data\[22\]
+ sky130_fd_sc_hd__dfrtp_1
X_11332_ net830 _00682_ net614 vssd1 vssd1 vccd1 vccd1 FPGA_INST.cell1.CB_0.config_dataB\[24\]
+ sky130_fd_sc_hd__dfstp_4
XTAP_TAPCELL_ROW_78_1379 vssd1 vccd1 sky130_fd_sc_hd__tapvpwrvgnd_1
XTAP_TAPCELL_ROW_78_1368 vssd1 vccd1 sky130_fd_sc_hd__tapvpwrvgnd_1
XFILLER_21_51 vssd1 vssd1 vccd1 vccd1 sky130_fd_sc_hd__fill_4
X_11263_ net784 _00613_ net569 vssd1 vssd1 vccd1 vccd1 FPGA_INST.cell0.SB0.route_sel\[108\]
+ sky130_fd_sc_hd__dfstp_1
XANTENNA__07909__A2 FPGA_INST.bus3_1\[10\] vssd1 vssd1 vccd1 vccd1 sky130_fd_sc_hd__diode_2
XANTENNA__08052__B _03889_ vssd1 vssd1 vccd1 vccd1 sky130_fd_sc_hd__diode_2
XFILLER_79_302 vccd1 vssd1 vccd1 vssd1 sky130_ef_sc_hd__decap_40_12
X_10214_ FPGA_INST.cell3.SB0.route_sel\[118\] FPGA_INST.cell3.SB0.route_sel\[119\]
+ net274 vssd1 vssd1 vccd1 vccd1 _01095_ sky130_fd_sc_hd__mux2_1
X_11194_ net765 _00544_ net550 vssd1 vssd1 vccd1 vccd1 FPGA_INST.cell0.SB0.route_sel\[39\]
+ sky130_fd_sc_hd__dfstp_1
X_10145_ FPGA_INST.cell3.SB0.route_sel\[49\] FPGA_INST.cell3.SB0.route_sel\[50\] net277
+ vssd1 vssd1 vccd1 vccd1 _01026_ sky130_fd_sc_hd__mux2_1
XTAP_TAPCELL_ROW_91_1557 vssd1 vccd1 sky130_fd_sc_hd__tapvpwrvgnd_1
XFILLER_48_711 vssd1 vssd1 vccd1 vccd1 sky130_fd_sc_hd__fill_1
XTAP_TAPCELL_ROW_7_383 vssd1 vccd1 sky130_fd_sc_hd__tapvpwrvgnd_1
X_10076_ FPGA_INST.cell0.LE_1B.config_data\[1\] FPGA_INST.cell0.LE_1B.config_data\[0\]
+ net307 vssd1 vssd1 vccd1 vccd1 _00957_ sky130_fd_sc_hd__mux2_1
XANTENNA__08334__A2 FPGA_INST.bus1_0\[9\] vssd1 vssd1 vccd1 vccd1 sky130_fd_sc_hd__diode_2
XFILLER_47_243 vssd1 vssd1 vccd1 vccd1 sky130_fd_sc_hd__fill_2
XTAP_TAPCELL_ROW_46_923 vssd1 vccd1 sky130_fd_sc_hd__tapvpwrvgnd_1
XFILLER_63_769 vssd1 vssd1 vccd1 vccd1 sky130_fd_sc_hd__fill_4
XFILLER_46_81 vssd1 vssd1 vccd1 vccd1 sky130_fd_sc_hd__fill_1
XANTENNA__08098__A1 _03973_ vssd1 vssd1 vccd1 vccd1 sky130_fd_sc_hd__diode_2
X_10978_ net887 _00328_ net671 vssd1 vssd1 vccd1 vccd1 FPGA_INST.cell2.CB_1.config_dataA\[9\]
+ sky130_fd_sc_hd__dfstp_1
XTAP_TAPCELL_ROW_100_1686 vssd1 vccd1 sky130_fd_sc_hd__tapvpwrvgnd_1
XFILLER_7_350 vssd1 vssd1 vccd1 vccd1 sky130_fd_sc_hd__fill_4
Xfanout819 net820 vssd1 vssd1 vccd1 vccd1 net819 sky130_fd_sc_hd__buf_1
Xfanout808 net811 vssd1 vssd1 vccd1 vccd1 net808 sky130_fd_sc_hd__clkbuf_2
XFILLER_112_432 vssd1 vssd1 vccd1 vccd1 sky130_fd_sc_hd__fill_2
X_08810_ net392 _04781_ net391 vssd1 vssd1 vccd1 vccd1 _05017_ sky130_fd_sc_hd__o21ai_1
XANTENNA__10380__A2 net524 vssd1 vssd1 vccd1 vccd1 sky130_fd_sc_hd__diode_2
XFILLER_112_454 vssd1 vssd1 vccd1 vccd1 sky130_fd_sc_hd__fill_2
XFILLER_100_616 vssd1 vssd1 vccd1 vccd1 sky130_fd_sc_hd__fill_4
XFILLER_98_699 vssd1 vssd1 vccd1 vccd1 sky130_fd_sc_hd__fill_1
X_09790_ FPGA_INST.cell1.CB_1.config_dataA\[16\] FPGA_INST.cell1.CB_1.config_dataA\[15\]
+ net326 vssd1 vssd1 vccd1 vccd1 _00699_ sky130_fd_sc_hd__mux2_1
X_08741_ net393 _04947_ _04948_ _04949_ vssd1 vssd1 vccd1 vccd1 _04950_ sky130_fd_sc_hd__a31o_1
XFILLER_100_649 vssd1 vssd1 vccd1 vccd1 sky130_fd_sc_hd__fill_1
XANTENNA__06050__X _02330_ vssd1 vssd1 vccd1 vccd1 sky130_fd_sc_hd__diode_2
X_05953_ _02229_ _02232_ vssd1 vssd1 vccd1 vccd1 _02233_ sky130_fd_sc_hd__and2_2
X_08672_ _04809_ _04863_ _04865_ _04813_ _01766_ vssd1 vssd1 vccd1 vccd1 _04881_ sky130_fd_sc_hd__a221o_1
X_05884_ net248 _02157_ _02163_ vssd1 vssd1 vccd1 vccd1 _02164_ sky130_fd_sc_hd__and3_1
X_07623_ _03875_ vssd1 vssd1 vccd1 vccd1 _03876_ sky130_fd_sc_hd__inv_2
XFILLER_26_405 vccd1 vssd1 vccd1 vssd1 sky130_ef_sc_hd__decap_40_12
XFILLER_93_393 vssd1 vssd1 vccd1 vccd1 sky130_fd_sc_hd__fill_8
XPHY_EDGE_ROW_5_Right_5 vssd1 vssd1 vccd1 vccd1 sky130_fd_sc_hd__decap_3
XANTENNA__08089__A1 _03810_ vssd1 vssd1 vccd1 vccd1 sky130_fd_sc_hd__diode_2
XFILLER_81_577 vssd1 vssd1 vccd1 vccd1 sky130_fd_sc_hd__fill_1
X_07554_ FPGA_INST.cell1.SB0.route_sel\[76\] _01651_ FPGA_INST.cell1.SB0.route_sel\[79\]
+ _01652_ _03808_ vssd1 vssd1 vccd1 vccd1 _03809_ sky130_fd_sc_hd__a221o_1
XTAP_TAPCELL_ROW_24_617 vssd1 vccd1 sky130_fd_sc_hd__tapvpwrvgnd_1
X_07485_ FPGA_INST.cell3.SB0.route_sel\[61\] _01665_ vssd1 vssd1 vccd1 vccd1 _03742_
+ sky130_fd_sc_hd__nand2_1
XANTENNA__06639__A2 _02836_ vssd1 vssd1 vccd1 vccd1 sky130_fd_sc_hd__diode_2
X_06505_ net480 net481 vssd1 vssd1 vccd1 vccd1 _02781_ sky130_fd_sc_hd__and2b_1
XANTENNA_fanout334_A net337 vssd1 vssd1 vccd1 vccd1 sky130_fd_sc_hd__diode_2
XTAP_TAPCELL_ROW_62_1147 vssd1 vccd1 sky130_fd_sc_hd__tapvpwrvgnd_1
X_09224_ FPGA_INST.cell2.CB_1.config_dataB\[21\] FPGA_INST.cell2.CB_1.config_dataB\[20\]
+ net352 vssd1 vssd1 vccd1 vccd1 _00137_ sky130_fd_sc_hd__mux2_1
XANTENNA__09948__S net184 vssd1 vssd1 vccd1 vccd1 sky130_fd_sc_hd__diode_2
X_06436_ net7 net8 net492 vssd1 vssd1 vccd1 vccd1 _02714_ sky130_fd_sc_hd__mux2_1
XANTENNA__05847__B1 net355 vssd1 vssd1 vccd1 vccd1 sky130_fd_sc_hd__diode_2
XTAP_TAPCELL_ROW_118_1936 vssd1 vccd1 sky130_fd_sc_hd__tapvpwrvgnd_1
X_09155_ FPGA_INST.cell2.LE_0A.reset_val FPGA_INST.cell2.LE_0A.reset_mode net253 vssd1
+ vssd1 vccd1 vccd1 _00070_ sky130_fd_sc_hd__mux2_1
XANTENNA_fanout122_X net122 vssd1 vssd1 vccd1 vccd1 sky130_fd_sc_hd__diode_2
X_06367_ _02640_ _02641_ _02643_ _02644_ vssd1 vssd1 vccd1 vccd1 _02645_ sky130_fd_sc_hd__o22a_1
X_08106_ _04331_ _04297_ _04262_ vssd1 vssd1 vccd1 vccd1 _04332_ sky130_fd_sc_hd__mux2_1
X_05318_ FPGA_INST.cell3.SB0.route_sel\[120\] vssd1 vssd1 vccd1 vccd1 _01600_ sky130_fd_sc_hd__inv_2
X_06298_ net500 _02056_ _02577_ net499 vssd1 vssd1 vccd1 vccd1 _02578_ sky130_fd_sc_hd__o211a_1
X_09086_ FPGA_INST.cell2.LEI0.config_data\[0\] FPGA_INST.cell2.LEI0.config_data\[1\]
+ net256 vssd1 vssd1 vccd1 vccd1 _00002_ sky130_fd_sc_hd__mux2_1
XFILLER_101_7 vssd1 vssd1 vccd1 vccd1 sky130_fd_sc_hd__fill_2
X_08037_ net460 _03568_ vssd1 vssd1 vccd1 vccd1 _04263_ sky130_fd_sc_hd__nand2_1
X_05249_ FPGA_INST.cell2.CB_0.config_dataA\[7\] vssd1 vssd1 vccd1 vccd1 _01531_ sky130_fd_sc_hd__inv_2
XANTENNA__08013__A1 FPGA_INST.bus3_1\[5\] vssd1 vssd1 vccd1 vccd1 sky130_fd_sc_hd__diode_2
XFILLER_89_655 vssd1 vssd1 vccd1 vccd1 sky130_fd_sc_hd__fill_1
X_09988_ FPGA_INST.config_bits\[8\] FPGA_INST.config_bits\[7\] _05232_ vssd1 vssd1
+ vccd1 vccd1 _05237_ sky130_fd_sc_hd__and3_1
XFILLER_103_454 vssd1 vssd1 vccd1 vccd1 sky130_fd_sc_hd__fill_1
XFILLER_76_305 vssd1 vssd1 vccd1 vccd1 sky130_fd_sc_hd__fill_2
XTAP_TAPCELL_ROW_73_1298 vssd1 vccd1 sky130_fd_sc_hd__tapvpwrvgnd_1
X_08939_ FPGA_INST.cell3.SB0.route_sel\[90\] _01632_ FPGA_INST.cell3.SB0.route_sel\[94\]
+ FPGA_INST.cell3.SB0.route_sel\[95\] _05132_ vssd1 vssd1 vccd1 vccd1 _05133_ sky130_fd_sc_hd__o221a_1
XFILLER_57_530 vssd1 vssd1 vccd1 vccd1 sky130_fd_sc_hd__fill_1
XTAP_TAPCELL_ROW_4_342 vssd1 vccd1 sky130_fd_sc_hd__tapvpwrvgnd_1
X_11950_ net916 _01296_ net700 vssd1 vssd1 vccd1 vccd1 FPGA_INST.cell3.CB_1.config_dataB\[15\]
+ sky130_fd_sc_hd__dfstp_1
X_10901_ net829 _00251_ net613 vssd1 vssd1 vccd1 vccd1 FPGA_INST.cell1.SB0.route_sel\[110\]
+ sky130_fd_sc_hd__dfstp_1
XFILLER_84_371 vssd1 vssd1 vccd1 vccd1 sky130_fd_sc_hd__fill_2
XFILLER_72_511 vssd1 vssd1 vccd1 vccd1 sky130_fd_sc_hd__fill_4
XFILLER_57_574 vccd1 vssd1 vccd1 vssd1 sky130_ef_sc_hd__decap_40_12
XFILLER_45_725 vssd1 vssd1 vccd1 vccd1 sky130_fd_sc_hd__fill_2
X_11881_ net928 _01227_ net712 vssd1 vssd1 vccd1 vccd1 FPGA_INST.cell3.LE_0A.config_data\[11\]
+ sky130_fd_sc_hd__dfrtp_1
XFILLER_83_57 vssd1 vssd1 vccd1 vccd1 sky130_fd_sc_hd__fill_1
XFILLER_72_533 vssd1 vssd1 vccd1 vccd1 sky130_fd_sc_hd__fill_2
XFILLER_17_449 vssd1 vssd1 vccd1 vccd1 sky130_fd_sc_hd__fill_8
X_10832_ net800 _00182_ net585 vssd1 vssd1 vccd1 vccd1 FPGA_INST.cell1.SB0.route_sel\[41\]
+ sky130_fd_sc_hd__dfstp_1
XANTENNA__09277__A0 FPGA_INST.cell1.SB0.route_sel\[48\] vssd1 vssd1 vccd1 vccd1 sky130_fd_sc_hd__diode_2
XFILLER_60_728 vssd1 vssd1 vccd1 vccd1 sky130_fd_sc_hd__fill_2
XFILLER_16_73 vssd1 vssd1 vccd1 vccd1 sky130_fd_sc_hd__fill_1
X_10763_ net885 _00113_ net669 vssd1 vssd1 vccd1 vccd1 FPGA_INST.cell2.LE_1A.reset_val
+ sky130_fd_sc_hd__dfrtp_1
XANTENNA__08047__B _03728_ vssd1 vssd1 vccd1 vccd1 sky130_fd_sc_hd__diode_2
XANTENNA__08762__S _04959_ vssd1 vssd1 vccd1 vccd1 sky130_fd_sc_hd__diode_2
XTAP_TAPCELL_ROW_51_992 vssd1 vccd1 sky130_fd_sc_hd__tapvpwrvgnd_1
X_10694_ net880 _00044_ net665 vssd1 vssd1 vccd1 vccd1 FPGA_INST.cell2.LEI0.config_data\[43\]
+ sky130_fd_sc_hd__dfrtp_1
XANTENNA__08252__A1 FPGA_INST.bus1_0\[11\] vssd1 vssd1 vccd1 vccd1 sky130_fd_sc_hd__diode_2
X_11315_ net905 _00665_ net689 vssd1 vssd1 vccd1 vccd1 FPGA_INST.cell1.CB_0.config_dataB\[7\]
+ sky130_fd_sc_hd__dfstp_1
X_11246_ net767 _00596_ net552 vssd1 vssd1 vccd1 vccd1 FPGA_INST.cell0.SB0.route_sel\[91\]
+ sky130_fd_sc_hd__dfstp_1
XFILLER_121_240 vssd1 vssd1 vccd1 vccd1 sky130_fd_sc_hd__fill_4
X_11177_ net784 _00527_ net569 vssd1 vssd1 vccd1 vccd1 FPGA_INST.cell0.SB0.route_sel\[22\]
+ sky130_fd_sc_hd__dfstp_1
XFILLER_121_273 vssd1 vssd1 vccd1 vccd1 sky130_fd_sc_hd__fill_4
X_10128_ FPGA_INST.cell3.SB0.route_sel\[32\] FPGA_INST.cell3.SB0.route_sel\[33\] net277
+ vssd1 vssd1 vccd1 vccd1 _01009_ sky130_fd_sc_hd__mux2_1
XFILLER_0_581 vssd1 vssd1 vccd1 vccd1 sky130_fd_sc_hd__fill_1
X_10059_ FPGA_INST.cell0.CB_1.config_dataA\[8\] FPGA_INST.cell0.CB_1.config_dataA\[9\]
+ net203 vssd1 vssd1 vccd1 vccd1 _00940_ sky130_fd_sc_hd__mux2_1
XFILLER_48_530 vssd1 vssd1 vccd1 vccd1 sky130_fd_sc_hd__fill_2
XANTENNA__06318__A1 net8 vssd1 vssd1 vccd1 vccd1 sky130_fd_sc_hd__diode_2
XFILLER_36_736 vssd1 vssd1 vccd1 vccd1 sky130_fd_sc_hd__fill_1
XANTENNA__11107__RESET_B net733 vssd1 vssd1 vccd1 vccd1 sky130_fd_sc_hd__diode_2
XANTENNA__06869__A2 FPGA_INST.bus2_0\[10\] vssd1 vssd1 vccd1 vccd1 sky130_fd_sc_hd__diode_2
XTAP_TAPCELL_ROW_102_1704 vssd1 vccd1 sky130_fd_sc_hd__tapvpwrvgnd_1
XFILLER_50_205 vssd1 vssd1 vccd1 vccd1 sky130_fd_sc_hd__fill_4
XTAP_TAPCELL_ROW_102_1715 vssd1 vccd1 sky130_fd_sc_hd__tapvpwrvgnd_1
XFILLER_90_396 vccd1 vssd1 vccd1 vssd1 sky130_ef_sc_hd__decap_40_12
XANTENNA__09768__S net232 vssd1 vssd1 vccd1 vccd1 sky130_fd_sc_hd__diode_2
X_07270_ FPGA_INST.cell3.CB_0.config_dataA\[24\] FPGA_INST.cell3.CB_0.config_dataA\[20\]
+ FPGA_INST.cell3.CB_0.config_dataA\[21\] vssd1 vssd1 vccd1 vccd1 _03532_ sky130_fd_sc_hd__or3b_2
XFILLER_92_3 vssd1 vssd1 vccd1 vccd1 sky130_fd_sc_hd__fill_4
XANTENNA__06029__Y _02309_ vssd1 vssd1 vccd1 vccd1 sky130_fd_sc_hd__diode_2
X_06221_ FPGA_INST.cell2.LEI0.config_data\[14\] _02500_ vssd1 vssd1 vccd1 vccd1 _02501_
+ sky130_fd_sc_hd__nand2b_1
XFILLER_31_474 vssd1 vssd1 vccd1 vccd1 sky130_fd_sc_hd__fill_4
XFILLER_129_362 vssd1 vssd1 vccd1 vccd1 sky130_fd_sc_hd__fill_1
X_06152_ FPGA_INST.cell2.SB0.route_sel\[10\] FPGA_INST.cell2.SB0.route_sel\[11\] vssd1
+ vssd1 vccd1 vccd1 _02432_ sky130_fd_sc_hd__and2_1
X_06083_ net132 _02360_ _02362_ vssd1 vssd1 vccd1 vccd1 _02363_ sky130_fd_sc_hd__o21a_1
X_09911_ FPGA_INST.cell0.LE_0B.config_data\[15\] FPGA_INST.cell0.LE_0B.config_data\[16\]
+ net178 vssd1 vssd1 vccd1 vccd1 _00817_ sky130_fd_sc_hd__mux2_1
XTAP_TAPCELL_ROW_113_1866 vssd1 vccd1 sky130_fd_sc_hd__tapvpwrvgnd_1
Xfanout605 net607 vssd1 vssd1 vccd1 vccd1 net605 sky130_fd_sc_hd__clkbuf_4
XANTENNA__08546__A2 net82 vssd1 vssd1 vccd1 vccd1 sky130_fd_sc_hd__diode_2
XFILLER_113_774 vssd1 vssd1 vccd1 vccd1 sky130_fd_sc_hd__fill_4
Xfanout616 net617 vssd1 vssd1 vccd1 vccd1 net616 sky130_fd_sc_hd__clkbuf_4
Xfanout627 net628 vssd1 vssd1 vccd1 vccd1 net627 sky130_fd_sc_hd__clkbuf_4
Xfanout649 net650 vssd1 vssd1 vccd1 vccd1 net649 sky130_fd_sc_hd__clkbuf_2
X_09842_ FPGA_INST.cell0.LEI0.config_data\[20\] FPGA_INST.cell0.LEI0.config_data\[21\]
+ net175 vssd1 vssd1 vccd1 vccd1 _00750_ sky130_fd_sc_hd__mux2_1
Xfanout638 net639 vssd1 vssd1 vccd1 vccd1 net638 sky130_fd_sc_hd__clkbuf_4
X_09773_ FPGA_INST.cell1.CB_0.config_dataB\[24\] FPGA_INST.cell1.CB_0.config_dataB\[23\]
+ net343 vssd1 vssd1 vccd1 vccd1 _00682_ sky130_fd_sc_hd__mux2_1
XFILLER_86_636 vssd1 vssd1 vccd1 vccd1 sky130_fd_sc_hd__fill_8
XFILLER_85_113 vssd1 vssd1 vccd1 vccd1 sky130_fd_sc_hd__fill_8
XANTENNA_fanout284_A net285 vssd1 vssd1 vccd1 vccd1 sky130_fd_sc_hd__diode_2
X_08724_ net18 _04927_ _04932_ vssd1 vssd1 vccd1 vccd1 _04933_ sky130_fd_sc_hd__a21o_1
X_06985_ net433 _02350_ vssd1 vssd1 vccd1 vccd1 _03251_ sky130_fd_sc_hd__nand2_1
XTAP_TAPCELL_ROW_1_301 vssd1 vccd1 sky130_fd_sc_hd__tapvpwrvgnd_1
XANTENNA__06309__A1 _02293_ vssd1 vssd1 vccd1 vccd1 sky130_fd_sc_hd__diode_2
XANTENNA__06309__B2 _02330_ vssd1 vssd1 vccd1 vccd1 sky130_fd_sc_hd__diode_2
X_05936_ FPGA_INST.cell2.SB0.route_sel\[62\] _01563_ FPGA_INST.cell2.SB0.route_sel\[58\]
+ FPGA_INST.cell2.SB0.route_sel\[59\] _02215_ vssd1 vssd1 vccd1 vccd1 _02216_ sky130_fd_sc_hd__o221a_1
XFILLER_27_725 vssd1 vssd1 vccd1 vccd1 sky130_fd_sc_hd__fill_2
X_08655_ FPGA_INST.cell3.CB_0.config_dataA\[5\] FPGA_INST.cell3.CB_0.config_dataA\[6\]
+ vssd1 vssd1 vccd1 vccd1 _04864_ sky130_fd_sc_hd__or2_1
X_05867_ net168 net162 _02142_ _02144_ vssd1 vssd1 vccd1 vccd1 _02147_ sky130_fd_sc_hd__o22a_1
XANTENNA__06875__B _02350_ vssd1 vssd1 vccd1 vccd1 sky130_fd_sc_hd__diode_2
X_08586_ net401 net400 vssd1 vssd1 vccd1 vccd1 _04795_ sky130_fd_sc_hd__nor2_1
X_07606_ _03858_ _03859_ _03830_ _03857_ vssd1 vssd1 vccd1 vccd1 _03860_ sky130_fd_sc_hd__a211oi_1
XANTENNA__09259__A0 FPGA_INST.cell1.SB0.route_sel\[31\] vssd1 vssd1 vccd1 vccd1 sky130_fd_sc_hd__diode_2
XFILLER_53_27 vssd1 vssd1 vccd1 vccd1 sky130_fd_sc_hd__fill_1
XFILLER_14_419 vssd1 vssd1 vccd1 vccd1 sky130_fd_sc_hd__fill_1
X_07537_ _01788_ _03791_ vssd1 vssd1 vccd1 vccd1 _03792_ sky130_fd_sc_hd__nor2_1
XANTENNA__07809__A1 net89 vssd1 vssd1 vccd1 vccd1 sky130_fd_sc_hd__diode_2
X_05798_ FPGA_INST.bus3_2\[11\] _02075_ _02076_ _02077_ vssd1 vssd1 vccd1 vccd1 _02078_
+ sky130_fd_sc_hd__a211o_1
XFILLER_53_49 vssd1 vssd1 vccd1 vccd1 sky130_fd_sc_hd__fill_1
XANTENNA__05532__A2 net16 vssd1 vssd1 vccd1 vccd1 sky130_fd_sc_hd__diode_2
XFILLER_35_780 vssd1 vssd1 vccd1 vccd1 sky130_fd_sc_hd__fill_2
XTAP_TAPCELL_ROW_37_797 vssd1 vccd1 sky130_fd_sc_hd__tapvpwrvgnd_1
XANTENNA_fanout337_X net337 vssd1 vssd1 vccd1 vccd1 sky130_fd_sc_hd__diode_2
XANTENNA_fanout716_A net730 vssd1 vssd1 vccd1 vccd1 sky130_fd_sc_hd__diode_2
X_07468_ FPGA_INST.cell1.SB0.route_sel\[58\] FPGA_INST.cell1.SB0.route_sel\[59\] _03722_
+ _03724_ _03715_ vssd1 vssd1 vccd1 vccd1 _03725_ sky130_fd_sc_hd__a311oi_2
XANTENNA__10617__S net378 vssd1 vssd1 vccd1 vccd1 sky130_fd_sc_hd__diode_2
X_07399_ _02319_ _03655_ _03657_ vssd1 vssd1 vccd1 vccd1 _03658_ sky130_fd_sc_hd__o21ai_1
X_09207_ FPGA_INST.cell2.CB_1.config_dataB\[3\] FPGA_INST.cell2.CB_1.config_dataB\[4\]
+ net265 vssd1 vssd1 vccd1 vccd1 _00120_ sky130_fd_sc_hd__mux2_1
X_06419_ _02010_ _02692_ _02693_ _01966_ _01541_ vssd1 vssd1 vccd1 vccd1 _02697_ sky130_fd_sc_hd__a221o_1
XANTENNA__08234__A1 FPGA_INST.bus1_0\[13\] vssd1 vssd1 vccd1 vccd1 sky130_fd_sc_hd__diode_2
X_09138_ FPGA_INST.cell2.LE_0A.config_data\[1\] FPGA_INST.cell2.LE_0A.config_data\[2\]
+ net235 vssd1 vssd1 vccd1 vccd1 _00053_ sky130_fd_sc_hd__mux2_1
XTAP_TAPCELL_ROW_75_1327 vssd1 vccd1 sky130_fd_sc_hd__tapvpwrvgnd_1
X_11100_ net841 _00450_ net625 vssd1 vssd1 vccd1 vccd1 FPGA_INST.cell1.LE_0B.config_data\[13\]
+ sky130_fd_sc_hd__dfrtp_1
XFILLER_118_75 vssd1 vssd1 vccd1 vccd1 sky130_fd_sc_hd__fill_8
XFILLER_118_53 vssd1 vssd1 vccd1 vccd1 sky130_fd_sc_hd__fill_2
X_09069_ _03703_ _04838_ _03697_ vssd1 vssd1 vccd1 vccd1 _05202_ sky130_fd_sc_hd__a21o_1
XTAP_TAPCELL_ROW_75_1338 vssd1 vccd1 sky130_fd_sc_hd__tapvpwrvgnd_1
XTAP_TAPCELL_ROW_9_412 vssd1 vccd1 sky130_fd_sc_hd__tapvpwrvgnd_1
X_12080_ net850 _01426_ net635 vssd1 vssd1 vccd1 vccd1 FPGA_INST.cell2.SB0.route_sel\[120\]
+ sky130_fd_sc_hd__dfstp_1
X_11031_ net832 _00381_ net616 vssd1 vssd1 vccd1 vccd1 FPGA_INST.cell1.LEI0.config_data\[16\]
+ sky130_fd_sc_hd__dfrtp_1
XFILLER_78_79 vssd1 vssd1 vccd1 vccd1 sky130_fd_sc_hd__fill_4
XFILLER_49_327 vssd1 vssd1 vccd1 vccd1 sky130_fd_sc_hd__fill_2
XFILLER_57_371 vssd1 vssd1 vccd1 vccd1 sky130_fd_sc_hd__fill_4
XANTENNA__12045__CLK net851 vssd1 vssd1 vccd1 vccd1 sky130_fd_sc_hd__diode_2
XANTENNA_input12_A gpio_in[1] vssd1 vssd1 vccd1 vccd1 sky130_fd_sc_hd__diode_2
X_11933_ net940 _01279_ net724 vssd1 vssd1 vccd1 vccd1 FPGA_INST.cell3.LE_1A.reset_mode
+ sky130_fd_sc_hd__dfrtp_1
XFILLER_45_522 vssd1 vssd1 vccd1 vccd1 sky130_fd_sc_hd__fill_2
X_11864_ net935 _01210_ net719 vssd1 vssd1 vccd1 vccd1 FPGA_INST.cell3.LEI0.config_data\[44\]
+ sky130_fd_sc_hd__dfrtp_1
XTAP_TAPCELL_ROW_86_1489 vssd1 vccd1 sky130_fd_sc_hd__tapvpwrvgnd_1
XFILLER_72_341 vssd1 vssd1 vccd1 vccd1 sky130_fd_sc_hd__fill_2
X_10815_ net822 _00165_ net606 vssd1 vssd1 vccd1 vccd1 FPGA_INST.cell1.SB0.route_sel\[24\]
+ sky130_fd_sc_hd__dfstp_1
XANTENNA__06181__C1 net320 vssd1 vssd1 vccd1 vccd1 sky130_fd_sc_hd__diode_2
XANTENNA__12014__SET_B net563 vssd1 vssd1 vccd1 vccd1 sky130_fd_sc_hd__diode_2
X_11795_ net885 _01141_ net669 vssd1 vssd1 vccd1 vccd1 FPGA_INST.io_east_oeb\[10\]
+ sky130_fd_sc_hd__dfrtp_1
XFILLER_41_794 vssd1 vssd1 vccd1 vccd1 sky130_fd_sc_hd__fill_1
XFILLER_41_783 vssd1 vssd1 vccd1 vccd1 sky130_fd_sc_hd__fill_1
XFILLER_9_423 vssd1 vssd1 vccd1 vccd1 sky130_fd_sc_hd__fill_8
X_10746_ net885 _00096_ net669 vssd1 vssd1 vccd1 vccd1 FPGA_INST.cell2.LE_1A.config_data\[1\]
+ sky130_fd_sc_hd__dfrtp_1
XANTENNA__10527__S net352 vssd1 vssd1 vccd1 vccd1 sky130_fd_sc_hd__diode_2
XFILLER_9_445 vssd1 vssd1 vccd1 vccd1 sky130_fd_sc_hd__fill_2
X_10677_ net877 _00027_ net661 vssd1 vssd1 vccd1 vccd1 FPGA_INST.cell2.LEI0.config_data\[26\]
+ sky130_fd_sc_hd__dfrtp_1
XANTENNA__07863__A1_N _03613_ vssd1 vssd1 vccd1 vccd1 sky130_fd_sc_hd__diode_2
XANTENNA__08225__A1 FPGA_INST.bus1_0\[5\] vssd1 vssd1 vccd1 vccd1 sky130_fd_sc_hd__diode_2
XTAP_TAPCELL_ROW_130_2100 vssd1 vccd1 sky130_fd_sc_hd__tapvpwrvgnd_1
XANTENNA__10824__Q FPGA_INST.cell1.SB0.route_sel\[33\] vssd1 vssd1 vccd1 vccd1 sky130_fd_sc_hd__diode_2
XTAP_TAPCELL_ROW_130_2122 vssd1 vccd1 sky130_fd_sc_hd__tapvpwrvgnd_1
XTAP_TAPCELL_ROW_130_2111 vssd1 vccd1 sky130_fd_sc_hd__tapvpwrvgnd_1
XFILLER_126_387 vssd1 vssd1 vccd1 vccd1 sky130_fd_sc_hd__fill_2
XFILLER_126_365 vssd1 vssd1 vccd1 vccd1 sky130_fd_sc_hd__fill_2
XFILLER_114_527 vssd1 vssd1 vccd1 vccd1 sky130_fd_sc_hd__fill_4
XFILLER_99_227 vssd1 vssd1 vccd1 vccd1 sky130_fd_sc_hd__fill_1
XFILLER_5_695 vccd1 vssd1 vccd1 vssd1 sky130_ef_sc_hd__decap_40_12
XFILLER_4_183 vssd1 vssd1 vccd1 vccd1 sky130_fd_sc_hd__fill_1
X_11229_ net764 _00579_ net549 vssd1 vssd1 vccd1 vccd1 FPGA_INST.cell0.SB0.route_sel\[74\]
+ sky130_fd_sc_hd__dfstp_1
XFILLER_122_582 vssd1 vssd1 vccd1 vccd1 sky130_fd_sc_hd__fill_4
XFILLER_67_102 vssd1 vssd1 vccd1 vccd1 sky130_fd_sc_hd__fill_1
XFILLER_110_777 vssd1 vssd1 vccd1 vccd1 sky130_fd_sc_hd__fill_1
XTAP_TAPCELL_ROW_128_2073 vssd1 vccd1 sky130_fd_sc_hd__tapvpwrvgnd_1
XFILLER_83_639 vssd1 vssd1 vccd1 vccd1 sky130_fd_sc_hd__fill_4
XFILLER_76_680 vssd1 vssd1 vccd1 vccd1 sky130_fd_sc_hd__fill_1
XFILLER_48_371 vssd1 vssd1 vccd1 vccd1 sky130_fd_sc_hd__fill_2
X_06770_ net138 net127 net131 net102 FPGA_INST.cell2.LEI0.config_data\[33\] FPGA_INST.cell2.LEI0.config_data\[34\]
+ vssd1 vssd1 vccd1 vccd1 _03044_ sky130_fd_sc_hd__mux4_1
XANTENNA__08161__A0 net76 vssd1 vssd1 vccd1 vccd1 sky130_fd_sc_hd__diode_2
X_05721_ FPGA_INST.cell2.CB_0.config_dataA\[24\] FPGA_INST.cell2.CB_0.config_dataA\[21\]
+ FPGA_INST.cell2.CB_0.config_dataA\[20\] vssd1 vssd1 vccd1 vccd1 _02001_ sky130_fd_sc_hd__or3b_1
XANTENNA__05880__A FPGA_INST.cell2.CB_0.le_outB vssd1 vssd1 vccd1 vccd1 sky130_fd_sc_hd__diode_2
XANTENNA__07424__X _03682_ vssd1 vssd1 vccd1 vccd1 sky130_fd_sc_hd__diode_2
XFILLER_36_533 vssd1 vssd1 vccd1 vccd1 sky130_fd_sc_hd__fill_1
X_08440_ _04657_ vssd1 vssd1 vccd1 vccd1 _04658_ sky130_fd_sc_hd__inv_2
XFILLER_51_514 vssd1 vssd1 vccd1 vccd1 sky130_fd_sc_hd__fill_2
X_05652_ _01921_ _01931_ _01923_ _01919_ vssd1 vssd1 vccd1 vccd1 _01932_ sky130_fd_sc_hd__a211oi_1
X_08371_ _04591_ _04592_ FPGA_INST.cell0.CB_1.config_dataB\[12\] vssd1 vssd1 vccd1
+ vccd1 _04593_ sky130_fd_sc_hd__mux2_1
X_05583_ net135 _01861_ vssd1 vssd1 vccd1 vccd1 _01863_ sky130_fd_sc_hd__nor2_1
XTAP_TAPCELL_ROW_34_756 vssd1 vccd1 sky130_fd_sc_hd__tapvpwrvgnd_1
X_07322_ _03541_ _03575_ _03582_ vssd1 vssd1 vccd1 vccd1 _03583_ sky130_fd_sc_hd__a21o_2
X_07253_ FPGA_INST.cell1.SB0.route_sel\[17\] FPGA_INST.cell1.SB0.route_sel\[16\] _03500_
+ _03513_ _03514_ vssd1 vssd1 vccd1 vccd1 _03515_ sky130_fd_sc_hd__a221o_1
XTAP_TAPCELL_ROW_14_480 vssd1 vccd1 sky130_fd_sc_hd__tapvpwrvgnd_1
X_07184_ FPGA_INST.cell3.CB_1.config_dataA\[24\] FPGA_INST.cell3.CB_1.config_dataA\[21\]
+ FPGA_INST.cell3.CB_1.config_dataA\[20\] vssd1 vssd1 vccd1 vccd1 _03447_ sky130_fd_sc_hd__or3b_4
X_06204_ net243 _02477_ _02483_ vssd1 vssd1 vccd1 vccd1 _02484_ sky130_fd_sc_hd__and3_1
X_06135_ net120 net166 _02334_ _02333_ _01968_ vssd1 vssd1 vccd1 vccd1 _02415_ sky130_fd_sc_hd__o32a_1
XFILLER_105_505 vssd1 vssd1 vccd1 vccd1 sky130_fd_sc_hd__fill_1
XTAP_TAPCELL_ROW_57_1079 vssd1 vccd1 sky130_fd_sc_hd__tapvpwrvgnd_1
X_06066_ _02335_ _02344_ _02345_ vssd1 vssd1 vccd1 vccd1 _02346_ sky130_fd_sc_hd__o21ba_1
XANTENNA__08519__A2 FPGA_INST.cell3.CB_1.le_outA vssd1 vssd1 vccd1 vccd1 sky130_fd_sc_hd__diode_2
XFILLER_99_772 vssd1 vssd1 vccd1 vccd1 sky130_fd_sc_hd__fill_2
Xfanout402 FPGA_INST.cell0.CB_1.config_dataA\[16\] vssd1 vssd1 vccd1 vccd1 net402
+ sky130_fd_sc_hd__buf_2
Xfanout413 FPGA_INST.cell0.CB_1.config_dataA\[0\] vssd1 vssd1 vccd1 vccd1 net413 sky130_fd_sc_hd__clkbuf_2
XFILLER_113_582 vssd1 vssd1 vccd1 vccd1 sky130_fd_sc_hd__fill_8
Xfanout457 FPGA_INST.cell1.CB_0.config_dataB\[5\] vssd1 vssd1 vccd1 vccd1 net457 sky130_fd_sc_hd__buf_2
XTAP_TAPCELL_ROW_70_1257 vssd1 vccd1 sky130_fd_sc_hd__tapvpwrvgnd_1
Xfanout446 FPGA_INST.cell0.CB_1.config_dataB\[5\] vssd1 vssd1 vccd1 vccd1 net446 sky130_fd_sc_hd__buf_1
XANTENNA_input4_A gpio_in[12] vssd1 vssd1 vccd1 vccd1 sky130_fd_sc_hd__diode_2
Xfanout435 FPGA_INST.cell0.CB_0.config_dataA\[1\] vssd1 vssd1 vccd1 vccd1 net435 sky130_fd_sc_hd__buf_2
X_09825_ FPGA_INST.cell0.LEI0.config_data\[3\] FPGA_INST.cell0.LEI0.config_data\[4\]
+ net174 vssd1 vssd1 vccd1 vccd1 _00733_ sky130_fd_sc_hd__mux2_1
Xfanout424 FPGA_INST.cell0.CB_0.config_dataB\[0\] vssd1 vssd1 vccd1 vccd1 net424 sky130_fd_sc_hd__buf_2
Xfanout468 FPGA_INST.cell1.CB_0.config_dataA\[6\] vssd1 vssd1 vccd1 vccd1 net468 sky130_fd_sc_hd__buf_2
XFILLER_98_293 vssd1 vssd1 vccd1 vccd1 sky130_fd_sc_hd__fill_4
XTAP_TAPCELL_ROW_70_1268 vssd1 vccd1 sky130_fd_sc_hd__tapvpwrvgnd_1
Xfanout479 FPGA_INST.cell2.CB_1.config_dataA\[10\] vssd1 vssd1 vccd1 vccd1 net479
+ sky130_fd_sc_hd__buf_1
XANTENNA_fanout666_A net676 vssd1 vssd1 vccd1 vccd1 sky130_fd_sc_hd__diode_2
X_09756_ FPGA_INST.cell1.CB_0.config_dataB\[7\] net456 net369 vssd1 vssd1 vccd1 vccd1
+ _00665_ sky130_fd_sc_hd__mux2_1
XFILLER_86_477 vssd1 vssd1 vccd1 vccd1 sky130_fd_sc_hd__fill_2
X_06968_ FPGA_INST.cell0.LE_0B.config_data\[9\] FPGA_INST.cell0.LE_0B.config_data\[8\]
+ _03159_ vssd1 vssd1 vccd1 vccd1 _03236_ sky130_fd_sc_hd__mux2_1
XANTENNA__06950__A1 FPGA_INST.bus2_0\[7\] vssd1 vssd1 vccd1 vccd1 sky130_fd_sc_hd__diode_2
XFILLER_104_55 vssd1 vssd1 vccd1 vccd1 sky130_fd_sc_hd__fill_2
X_08707_ _04914_ _04915_ FPGA_INST.cell3.CB_0.config_dataA\[14\] vssd1 vssd1 vccd1
+ vccd1 _04916_ sky130_fd_sc_hd__o21bai_1
X_05919_ _01893_ _02197_ vssd1 vssd1 vccd1 vccd1 _02199_ sky130_fd_sc_hd__nand2_1
X_09687_ FPGA_INST.cell0.SB0.route_sel\[90\] FPGA_INST.cell0.SB0.route_sel\[91\] net188
+ vssd1 vssd1 vccd1 vccd1 _00596_ sky130_fd_sc_hd__mux2_1
XANTENNA_fanout833_A net843 vssd1 vssd1 vccd1 vccd1 sky130_fd_sc_hd__diode_2
X_08638_ _04795_ _04843_ _04846_ _04790_ _01763_ vssd1 vssd1 vccd1 vccd1 _04847_ sky130_fd_sc_hd__a221o_1
XFILLER_82_672 vssd1 vssd1 vccd1 vccd1 sky130_fd_sc_hd__fill_1
XFILLER_54_352 vssd1 vssd1 vccd1 vccd1 sky130_fd_sc_hd__fill_2
X_06899_ net418 _01839_ net417 vssd1 vssd1 vccd1 vccd1 _03167_ sky130_fd_sc_hd__o21ai_1
XFILLER_15_706 vssd1 vssd1 vccd1 vccd1 sky130_fd_sc_hd__fill_8
XANTENNA__06702__B2 _02780_ vssd1 vssd1 vccd1 vccd1 sky130_fd_sc_hd__diode_2
XANTENNA__06702__A1 _02784_ vssd1 vssd1 vccd1 vccd1 sky130_fd_sc_hd__diode_2
XFILLER_27_588 vssd1 vssd1 vccd1 vccd1 sky130_fd_sc_hd__fill_8
XFILLER_120_54 vssd1 vssd1 vccd1 vccd1 sky130_fd_sc_hd__fill_1
X_08569_ net156 _04778_ vssd1 vssd1 vccd1 vccd1 FPGA_INST.cell3.CB_1.le_outB sky130_fd_sc_hd__and2_1
X_10600_ FPGA_INST.cell3.CB_0.config_dataB\[20\] FPGA_INST.cell3.CB_0.config_dataB\[19\]
+ net371 vssd1 vssd1 vccd1 vccd1 _01479_ sky130_fd_sc_hd__mux2_1
XFILLER_23_783 vssd1 vssd1 vccd1 vccd1 sky130_fd_sc_hd__fill_1
XFILLER_23_794 vssd1 vssd1 vccd1 vccd1 sky130_fd_sc_hd__fill_4
X_11580_ net781 _00930_ net566 vssd1 vssd1 vccd1 vccd1 FPGA_INST.cell0.CB_0.config_dataB\[24\]
+ sky130_fd_sc_hd__dfstp_1
Xfanout86 net87 vssd1 vssd1 vccd1 vccd1 net86 sky130_fd_sc_hd__buf_1
XFILLER_80_69 vssd1 vssd1 vccd1 vccd1 sky130_fd_sc_hd__fill_2
Xfanout97 _01783_ vssd1 vssd1 vccd1 vccd1 net97 sky130_fd_sc_hd__clkbuf_2
X_10531_ FPGA_INST.cell2.SB0.route_sel\[103\] FPGA_INST.cell2.SB0.route_sel\[104\]
+ net247 vssd1 vssd1 vccd1 vccd1 _01410_ sky130_fd_sc_hd__mux2_1
XANTENNA__09201__S net266 vssd1 vssd1 vccd1 vccd1 sky130_fd_sc_hd__diode_2
XANTENNA__05984__B1_N FPGA_INST.bus2_0\[4\] vssd1 vssd1 vccd1 vccd1 sky130_fd_sc_hd__diode_2
XFILLER_127_107 vssd1 vssd1 vccd1 vccd1 sky130_fd_sc_hd__fill_1
XANTENNA__08207__A1 _03959_ vssd1 vssd1 vccd1 vccd1 sky130_fd_sc_hd__diode_2
XANTENNA__08207__B2 _03923_ vssd1 vssd1 vccd1 vccd1 sky130_fd_sc_hd__diode_2
X_10462_ FPGA_INST.cell2.SB0.route_sel\[34\] FPGA_INST.cell2.SB0.route_sel\[35\] net197
+ vssd1 vssd1 vccd1 vccd1 _01341_ sky130_fd_sc_hd__mux2_1
X_10393_ FPGA_INST.cell3.LE_1A.config_data\[11\] FPGA_INST.cell3.LE_1A.config_data\[12\]
+ net304 vssd1 vssd1 vccd1 vccd1 _01272_ sky130_fd_sc_hd__mux2_1
XFILLER_108_365 vssd1 vssd1 vccd1 vccd1 sky130_fd_sc_hd__fill_1
X_12132_ net936 _01478_ net720 vssd1 vssd1 vccd1 vccd1 FPGA_INST.cell3.CB_0.config_dataB\[19\]
+ sky130_fd_sc_hd__dfstp_1
X_12063_ net857 _01409_ net642 vssd1 vssd1 vccd1 vccd1 FPGA_INST.cell2.SB0.route_sel\[103\]
+ sky130_fd_sc_hd__dfstp_1
XFILLER_2_643 vssd1 vssd1 vccd1 vccd1 sky130_fd_sc_hd__fill_1
X_11014_ FPGA_INST.cell1.LE_0A.sel_clk _00364_ net732 vssd1 vssd1 vccd1 vccd1 FPGA_INST.cell1.LE_0A.dff1_out
+ sky130_fd_sc_hd__dfstp_1
XFILLER_77_444 vssd1 vssd1 vccd1 vccd1 sky130_fd_sc_hd__fill_1
XTAP_TAPCELL_ROW_88_1518 vssd1 vccd1 sky130_fd_sc_hd__tapvpwrvgnd_1
XFILLER_64_149 vssd1 vssd1 vccd1 vccd1 sky130_fd_sc_hd__fill_2
XFILLER_38_82 vssd1 vssd1 vccd1 vccd1 sky130_fd_sc_hd__fill_2
X_11916_ net943 _01262_ net727 vssd1 vssd1 vccd1 vccd1 FPGA_INST.cell3.LE_1A.config_data\[2\]
+ sky130_fd_sc_hd__dfrtp_1
XANTENNA__09891__A0 FPGA_INST.cell0.LE_0A.reset_val vssd1 vssd1 vccd1 vccd1 sky130_fd_sc_hd__diode_2
X_11847_ net933 _01193_ net717 vssd1 vssd1 vccd1 vccd1 FPGA_INST.cell3.LEI0.config_data\[27\]
+ sky130_fd_sc_hd__dfrtp_1
X_11778_ net925 _01124_ net709 vssd1 vssd1 vccd1 vccd1 FPGA_INST.io_south_oeb\[8\]
+ sky130_fd_sc_hd__dfrtp_1
XTAP_TAPCELL_ROW_31_715 vssd1 vccd1 sky130_fd_sc_hd__tapvpwrvgnd_1
X_10729_ net872 _00079_ net656 vssd1 vssd1 vccd1 vccd1 FPGA_INST.cell2.LE_0B.config_data\[6\]
+ sky130_fd_sc_hd__dfrtp_1
XANTENNA__06457__A0 net3 vssd1 vssd1 vccd1 vccd1 sky130_fd_sc_hd__diode_2
XTAP_TAPCELL_ROW_99_1669 vssd1 vccd1 sky130_fd_sc_hd__tapvpwrvgnd_1
XFILLER_9_297 vssd1 vssd1 vccd1 vccd1 sky130_fd_sc_hd__fill_1
XANTENNA__06472__A3 net13 vssd1 vssd1 vccd1 vccd1 sky130_fd_sc_hd__diode_2
XFILLER_126_195 vssd1 vssd1 vccd1 vccd1 sky130_fd_sc_hd__fill_1
XANTENNA__07419__X _03677_ vssd1 vssd1 vccd1 vccd1 sky130_fd_sc_hd__diode_2
XANTENNA__05875__A net129 vssd1 vssd1 vccd1 vccd1 sky130_fd_sc_hd__diode_2
X_07940_ _03810_ _04154_ _04166_ _04167_ vssd1 vssd1 vccd1 vccd1 _04168_ sky130_fd_sc_hd__o211a_1
XTAP_TAPCELL_ROW_110_1825 vssd1 vccd1 sky130_fd_sc_hd__tapvpwrvgnd_1
XANTENNA__09781__S net333 vssd1 vssd1 vccd1 vccd1 sky130_fd_sc_hd__diode_2
X_07871_ FPGA_INST.bus3_1\[8\] FPGA_INST.bus3_1\[9\] FPGA_INST.bus3_1\[10\] FPGA_INST.bus3_1\[11\]
+ net470 net468 vssd1 vssd1 vccd1 vccd1 _04099_ sky130_fd_sc_hd__mux4_1
XFILLER_83_403 vccd1 vssd1 vccd1 vssd1 sky130_ef_sc_hd__decap_40_12
X_09610_ FPGA_INST.cell0.SB0.route_sel\[13\] FPGA_INST.cell0.SB0.route_sel\[14\] net200
+ vssd1 vssd1 vccd1 vccd1 _00519_ sky130_fd_sc_hd__mux2_1
X_06822_ net659 FPGA_INST.cell2.LE_0B.reset_mode vssd1 vssd1 vccd1 vccd1 _06822_/X
+ sky130_fd_sc_hd__xor2_2
XTAP_TAPCELL_ROW_39_826 vssd1 vccd1 sky130_fd_sc_hd__tapvpwrvgnd_1
X_09541_ FPGA_INST.cell1.LE_0B.config_data\[13\] FPGA_INST.cell1.LE_0B.config_data\[14\]
+ net232 vssd1 vssd1 vccd1 vccd1 _00451_ sky130_fd_sc_hd__mux2_1
XFILLER_83_447 vssd1 vssd1 vccd1 vccd1 sky130_fd_sc_hd__fill_1
X_06753_ net515 _02836_ _03026_ net513 vssd1 vssd1 vccd1 vccd1 _03027_ sky130_fd_sc_hd__o211a_1
X_05704_ _01981_ _01983_ vssd1 vssd1 vccd1 vccd1 _01984_ sky130_fd_sc_hd__and2_2
XTAP_TAPCELL_ROW_19_550 vssd1 vccd1 sky130_fd_sc_hd__tapvpwrvgnd_1
XFILLER_36_363 vssd1 vssd1 vccd1 vccd1 sky130_fd_sc_hd__fill_1
X_09472_ FPGA_INST.cell1.LEI0.config_data\[18\] FPGA_INST.cell1.LEI0.config_data\[19\]
+ net214 vssd1 vssd1 vccd1 vccd1 _00384_ sky130_fd_sc_hd__mux2_1
XTAP_TAPCELL_ROW_108_1798 vssd1 vccd1 sky130_fd_sc_hd__tapvpwrvgnd_1
XFILLER_63_171 vssd1 vssd1 vccd1 vccd1 sky130_fd_sc_hd__fill_4
X_06684_ FPGA_INST.cell2.LE_1A.dff0_out FPGA_INST.cell2.LE_1A.dff1_out FPGA_INST.cell2.LE_1A.reset_val
+ vssd1 vssd1 vccd1 vccd1 FPGA_INST.cell2.LE_1A.dff_out sky130_fd_sc_hd__mux2_1
XFILLER_36_374 vssd1 vssd1 vccd1 vccd1 sky130_fd_sc_hd__fill_4
X_08423_ _04644_ _04643_ _04544_ vssd1 vssd1 vccd1 vccd1 _04645_ sky130_fd_sc_hd__mux2_1
X_05635_ net506 _01914_ vssd1 vssd1 vccd1 vccd1 _01915_ sky130_fd_sc_hd__nand2_1
XFILLER_24_569 vssd1 vssd1 vccd1 vccd1 sky130_fd_sc_hd__fill_1
XFILLER_34_29 vssd1 vssd1 vccd1 vccd1 sky130_fd_sc_hd__fill_2
XTAP_TAPCELL_ROW_121_1976 vssd1 vccd1 sky130_fd_sc_hd__tapvpwrvgnd_1
X_05566_ FPGA_INST.cell2.CB_1.config_dataB\[23\] FPGA_INST.cell2.CB_1.config_dataB\[22\]
+ vssd1 vssd1 vccd1 vccd1 _01846_ sky130_fd_sc_hd__and2_1
X_08354_ net441 net442 vssd1 vssd1 vccd1 vccd1 _04576_ sky130_fd_sc_hd__nor2_1
XFILLER_11_219 vssd1 vssd1 vccd1 vccd1 sky130_fd_sc_hd__fill_1
X_07305_ FPGA_INST.cell1.SB0.route_sel\[26\] FPGA_INST.cell1.SB0.route_sel\[27\] vssd1
+ vssd1 vccd1 vccd1 _03566_ sky130_fd_sc_hd__nor2_1
XFILLER_20_742 vssd1 vssd1 vccd1 vccd1 sky130_fd_sc_hd__fill_4
X_05497_ FPGA_INST.cell3.CB_0.config_dataB\[17\] vssd1 vssd1 vccd1 vccd1 _01779_ sky130_fd_sc_hd__inv_2
X_08285_ FPGA_INST.cell0.LE_1A.config_data\[10\] FPGA_INST.cell0.LE_1A.config_data\[11\]
+ _04410_ vssd1 vssd1 vccd1 vccd1 _04509_ sky130_fd_sc_hd__mux2_1
XANTENNA__08860__S _05032_ vssd1 vssd1 vccd1 vccd1 sky130_fd_sc_hd__diode_2
X_07236_ FPGA_INST.cell1.CB_0.config_dataB\[24\] FPGA_INST.cell1.CB_0.config_dataB\[20\]
+ FPGA_INST.cell1.CB_0.config_dataB\[21\] vssd1 vssd1 vccd1 vccd1 _03498_ sky130_fd_sc_hd__nor3b_2
XTAP_TAPCELL_ROW_59_1108 vssd1 vccd1 sky130_fd_sc_hd__tapvpwrvgnd_1
XFILLER_118_685 vccd1 vssd1 vccd1 vssd1 sky130_ef_sc_hd__decap_40_12
X_07167_ net81 _03428_ _03429_ _03430_ _03424_ vssd1 vssd1 vccd1 vccd1 _03431_ sky130_fd_sc_hd__o311a_1
XANTENNA_fanout202_X net202 vssd1 vssd1 vccd1 vccd1 sky130_fd_sc_hd__diode_2
X_06118_ _01845_ _02356_ vssd1 vssd1 vccd1 vccd1 _02398_ sky130_fd_sc_hd__and2b_1
X_07098_ FPGA_INST.bus2_0\[5\] _03352_ _03363_ FPGA_INST.cell0.CB_0.config_dataA\[16\]
+ vssd1 vssd1 vccd1 vccd1 _03364_ sky130_fd_sc_hd__a22o_1
Xfanout232 net233 vssd1 vssd1 vccd1 vccd1 net232 sky130_fd_sc_hd__buf_2
Xfanout210 net213 vssd1 vssd1 vccd1 vccd1 net210 sky130_fd_sc_hd__clkbuf_4
Xfanout221 net227 vssd1 vssd1 vccd1 vccd1 net221 sky130_fd_sc_hd__clkbuf_4
X_06049_ FPGA_INST.cell2.SB0.route_sel\[46\] _01559_ FPGA_INST.cell2.SB0.route_sel\[42\]
+ FPGA_INST.cell2.SB0.route_sel\[43\] _02328_ vssd1 vssd1 vccd1 vccd1 _02329_ sky130_fd_sc_hd__o221a_1
XANTENNA__07176__A1 net18 vssd1 vssd1 vccd1 vccd1 sky130_fd_sc_hd__diode_2
XFILLER_101_541 vssd1 vssd1 vccd1 vccd1 sky130_fd_sc_hd__fill_2
Xfanout265 net266 vssd1 vssd1 vccd1 vccd1 net265 sky130_fd_sc_hd__clkbuf_4
Xfanout243 net244 vssd1 vssd1 vccd1 vccd1 net243 sky130_fd_sc_hd__clkbuf_4
XANTENNA_input7_X net7 vssd1 vssd1 vccd1 vccd1 sky130_fd_sc_hd__diode_2
Xfanout254 net255 vssd1 vssd1 vccd1 vccd1 net254 sky130_fd_sc_hd__clkbuf_4
X_09808_ FPGA_INST.cell1.LE_1B.config_data\[9\] FPGA_INST.cell1.LE_1B.config_data\[8\]
+ net336 vssd1 vssd1 vccd1 vccd1 _00717_ sky130_fd_sc_hd__mux2_1
Xfanout298 net300 vssd1 vssd1 vccd1 vccd1 net298 sky130_fd_sc_hd__clkbuf_4
XFILLER_115_87 vssd1 vssd1 vccd1 vccd1 sky130_fd_sc_hd__fill_4
Xfanout276 net285 vssd1 vssd1 vccd1 vccd1 net276 sky130_fd_sc_hd__clkbuf_4
Xfanout287 net288 vssd1 vssd1 vccd1 vccd1 net287 sky130_fd_sc_hd__clkbuf_2
XFILLER_101_596 vssd1 vssd1 vccd1 vccd1 sky130_fd_sc_hd__fill_1
X_09739_ FPGA_INST.cell1.CB_0.config_dataA\[14\] net464 net230 vssd1 vssd1 vccd1 vccd1
+ _00648_ sky130_fd_sc_hd__mux2_1
XFILLER_27_385 vssd1 vssd1 vccd1 vccd1 sky130_fd_sc_hd__fill_4
XFILLER_91_57 vssd1 vssd1 vccd1 vccd1 sky130_fd_sc_hd__fill_1
X_11701_ net904 _01047_ net688 vssd1 vssd1 vccd1 vccd1 FPGA_INST.cell3.SB0.route_sel\[71\]
+ sky130_fd_sc_hd__dfstp_1
XTAP_TAPCELL_ROW_83_1448 vssd1 vccd1 sky130_fd_sc_hd__tapvpwrvgnd_1
X_11632_ net896 _00978_ net680 vssd1 vssd1 vccd1 vccd1 FPGA_INST.cell3.SB0.route_sel\[2\]
+ sky130_fd_sc_hd__dfstp_1
XPHY_EDGE_ROW_59_Left_190 vssd1 vssd1 vccd1 vccd1 sky130_fd_sc_hd__decap_3
XFILLER_30_506 vssd1 vssd1 vccd1 vccd1 sky130_fd_sc_hd__fill_1
XFILLER_128_427 vssd1 vssd1 vccd1 vccd1 sky130_fd_sc_hd__fill_1
X_11563_ net771 _00913_ net556 vssd1 vssd1 vccd1 vccd1 FPGA_INST.cell0.CB_0.config_dataB\[7\]
+ sky130_fd_sc_hd__dfstp_1
XFILLER_6_201 vssd1 vssd1 vccd1 vccd1 sky130_fd_sc_hd__fill_1
X_11494_ net797 _00844_ net582 vssd1 vssd1 vccd1 vccd1 FPGA_INST.cell0.CB_1.config_dataB\[0\]
+ sky130_fd_sc_hd__dfstp_1
XFILLER_10_274 vssd1 vssd1 vccd1 vccd1 sky130_fd_sc_hd__fill_4
X_10514_ FPGA_INST.cell2.SB0.route_sel\[86\] FPGA_INST.cell2.SB0.route_sel\[87\] net251
+ vssd1 vssd1 vccd1 vccd1 _01393_ sky130_fd_sc_hd__mux2_1
XFILLER_109_663 vssd1 vssd1 vccd1 vccd1 sky130_fd_sc_hd__fill_4
X_10445_ FPGA_INST.cell2.SB0.route_sel\[17\] FPGA_INST.cell2.SB0.route_sel\[18\] net235
+ vssd1 vssd1 vccd1 vccd1 _01324_ sky130_fd_sc_hd__mux2_1
XFILLER_108_195 vssd1 vssd1 vccd1 vccd1 sky130_fd_sc_hd__fill_1
XFILLER_40_83 vssd1 vssd1 vccd1 vccd1 sky130_fd_sc_hd__fill_1
X_10376_ FPGA_INST.cell3.LE_0B.reset_val FPGA_INST.cell3.LE_0B.edge_mode net377 vssd1
+ vssd1 vccd1 vccd1 _01256_ sky130_fd_sc_hd__mux2_1
X_12115_ net936 _01461_ net720 vssd1 vssd1 vccd1 vccd1 FPGA_INST.cell3.CB_0.config_dataB\[2\]
+ sky130_fd_sc_hd__dfstp_2
XTAP_TAPCELL_ROW_94_1599 vssd1 vccd1 sky130_fd_sc_hd__tapvpwrvgnd_1
XFILLER_41_9 vssd1 vssd1 vccd1 vccd1 sky130_fd_sc_hd__fill_4
XFILLER_124_699 vssd1 vssd1 vccd1 vccd1 sky130_fd_sc_hd__fill_1
XANTENNA__07167__A1 net81 vssd1 vssd1 vccd1 vccd1 sky130_fd_sc_hd__diode_2
XFILLER_78_753 vssd1 vssd1 vccd1 vccd1 sky130_fd_sc_hd__fill_2
XANTENNA__09156__A2 net524 vssd1 vssd1 vccd1 vccd1 sky130_fd_sc_hd__diode_2
X_12046_ net866 _01392_ net653 vssd1 vssd1 vccd1 vccd1 FPGA_INST.cell2.SB0.route_sel\[86\]
+ sky130_fd_sc_hd__dfstp_1
XFILLER_93_723 vssd1 vssd1 vccd1 vccd1 sky130_fd_sc_hd__fill_2
XTAP_TAPCELL_ROW_125_2032 vssd1 vccd1 sky130_fd_sc_hd__tapvpwrvgnd_1
XFILLER_93_767 vccd1 vssd1 vccd1 vssd1 sky130_ef_sc_hd__decap_40_12
XFILLER_80_439 vssd1 vssd1 vccd1 vccd1 sky130_fd_sc_hd__fill_1
XFILLER_33_311 vssd1 vssd1 vccd1 vccd1 sky130_fd_sc_hd__fill_2
X_05420_ FPGA_INST.cell3.SB0.route_sel\[16\] vssd1 vssd1 vccd1 vccd1 _01702_ sky130_fd_sc_hd__inv_2
X_05351_ FPGA_INST.cell3.SB0.route_sel\[92\] vssd1 vssd1 vccd1 vccd1 _01633_ sky130_fd_sc_hd__inv_2
XANTENNA__06693__A3 FPGA_INST.bus3_2\[15\] vssd1 vssd1 vccd1 vccd1 sky130_fd_sc_hd__diode_2
XTAP_TAPCELL_ROW_44_895 vssd1 vccd1 sky130_fd_sc_hd__tapvpwrvgnd_1
XFILLER_119_416 vssd1 vssd1 vccd1 vccd1 sky130_fd_sc_hd__fill_8
XANTENNA__12133__SET_B net701 vssd1 vssd1 vccd1 vccd1 sky130_fd_sc_hd__diode_2
XFILLER_119_449 vssd1 vssd1 vccd1 vccd1 sky130_fd_sc_hd__fill_2
X_08070_ _04292_ _04293_ _04295_ vssd1 vssd1 vccd1 vccd1 _04296_ sky130_fd_sc_hd__and3_4
XANTENNA__09776__S net333 vssd1 vssd1 vccd1 vccd1 sky130_fd_sc_hd__diode_2
X_05282_ FPGA_INST.cell2.SB0.route_sel\[64\] vssd1 vssd1 vccd1 vccd1 _01564_ sky130_fd_sc_hd__inv_2
XANTENNA__06850__A0 FPGA_INST.bus2_0\[12\] vssd1 vssd1 vccd1 vccd1 sky130_fd_sc_hd__diode_2
X_07021_ _01984_ _03282_ _03284_ _01937_ _03286_ vssd1 vssd1 vccd1 vccd1 _03287_ sky130_fd_sc_hd__a221o_1
XTAP_TAPCELL_ROW_54_1038 vssd1 vccd1 sky130_fd_sc_hd__tapvpwrvgnd_1
X_08972_ _01562_ FPGA_INST.cell2.SB0.route_sel\[57\] FPGA_INST.cell2.SB0.route_sel\[62\]
+ FPGA_INST.cell2.SB0.route_sel\[63\] _05154_ vssd1 vssd1 vccd1 vccd1 _05155_ sky130_fd_sc_hd__o221a_1
X_07923_ net466 _03728_ _04150_ vssd1 vssd1 vccd1 vccd1 _04151_ sky130_fd_sc_hd__a21o_1
XFILLER_29_29 vssd1 vssd1 vccd1 vccd1 sky130_fd_sc_hd__fill_4
X_07854_ net470 FPGA_INST.cell1.CB_0.config_dataA\[6\] vssd1 vssd1 vccd1 vccd1 _04082_
+ sky130_fd_sc_hd__nor2_1
XFILLER_56_414 vssd1 vssd1 vccd1 vccd1 sky130_fd_sc_hd__fill_4
XFILLER_29_617 vssd1 vssd1 vccd1 vccd1 sky130_fd_sc_hd__fill_1
XANTENNA__07325__A _03583_ vssd1 vssd1 vccd1 vccd1 sky130_fd_sc_hd__diode_2
X_06805_ FPGA_INST.cell2.LE_1B.config_data\[1\] FPGA_INST.cell2.LE_1B.config_data\[0\]
+ _02992_ vssd1 vssd1 vccd1 vccd1 _03079_ sky130_fd_sc_hd__mux2_1
XANTENNA__06905__A1 FPGA_INST.bus2_0\[9\] vssd1 vssd1 vccd1 vccd1 sky130_fd_sc_hd__diode_2
XANTENNA_fanout364_A net380 vssd1 vssd1 vccd1 vccd1 sky130_fd_sc_hd__diode_2
XFILLER_83_255 vssd1 vssd1 vccd1 vccd1 sky130_fd_sc_hd__fill_2
X_07785_ FPGA_INST.cell1.SB0.route_sel\[120\] FPGA_INST.cell1.SB0.route_sel\[121\]
+ vssd1 vssd1 vccd1 vccd1 _04034_ sky130_fd_sc_hd__nand2_1
XANTENNA__08370__A3 FPGA_INST.bus1_0\[7\] vssd1 vssd1 vccd1 vccd1 sky130_fd_sc_hd__diode_2
X_09524_ FPGA_INST.cell1.LE_0B.dff0_out net523 _05214_ vssd1 vssd1 vccd1 vccd1 _00435_
+ sky130_fd_sc_hd__a21bo_1
X_06736_ _02784_ _02780_ _02772_ _02776_ net517 net516 vssd1 vssd1 vccd1 vccd1 _03010_
+ sky130_fd_sc_hd__mux4_1
XFILLER_36_160 vssd1 vssd1 vccd1 vccd1 sky130_fd_sc_hd__fill_1
X_09455_ FPGA_INST.cell1.LEI0.config_data\[1\] FPGA_INST.cell1.LEI0.config_data\[2\]
+ net214 vssd1 vssd1 vccd1 vccd1 _00367_ sky130_fd_sc_hd__mux2_1
X_06667_ FPGA_INST.cell2.LEI0.config_data\[42\] net103 vssd1 vssd1 vccd1 vccd1 _02943_
+ sky130_fd_sc_hd__nand2_1
XFILLER_36_182 vssd1 vssd1 vccd1 vccd1 sky130_fd_sc_hd__fill_4
XFILLER_36_193 vssd1 vssd1 vccd1 vccd1 sky130_fd_sc_hd__fill_1
XANTENNA_fanout152_X net152 vssd1 vssd1 vccd1 vccd1 sky130_fd_sc_hd__diode_2
XANTENNA__07330__A1 net82 vssd1 vssd1 vccd1 vccd1 sky130_fd_sc_hd__diode_2
XTAP_TAPCELL_ROW_65_1189 vssd1 vccd1 sky130_fd_sc_hd__tapvpwrvgnd_1
X_05618_ net101 _01846_ _01893_ vssd1 vssd1 vccd1 vccd1 _01898_ sky130_fd_sc_hd__and3_1
X_08406_ net439 _03682_ _04627_ net438 vssd1 vssd1 vccd1 vccd1 _04628_ sky130_fd_sc_hd__o211a_1
XFILLER_52_686 vssd1 vssd1 vccd1 vccd1 sky130_fd_sc_hd__fill_4
X_06598_ _02856_ _02862_ _02873_ FPGA_INST.cell2.CB_1.config_dataA\[4\] vssd1 vssd1
+ vccd1 vccd1 _02874_ sky130_fd_sc_hd__a211o_1
X_09386_ FPGA_INST.cell2.CB_0.config_dataB\[4\] net495 net252 vssd1 vssd1 vccd1 vccd1
+ _00299_ sky130_fd_sc_hd__mux2_1
X_08337_ net448 _03558_ vssd1 vssd1 vccd1 vccd1 _04559_ sky130_fd_sc_hd__nand2_1
X_05549_ FPGA_INST.cell0.SB0.route_sel\[114\] FPGA_INST.cell0.SB0.route_sel\[115\]
+ _01824_ _01827_ _01828_ vssd1 vssd1 vccd1 vccd1 _01829_ sky130_fd_sc_hd__a221o_1
XFILLER_124_6 vssd1 vssd1 vccd1 vccd1 sky130_fd_sc_hd__fill_1
XANTENNA__07633__A2 _03885_ vssd1 vssd1 vccd1 vccd1 sky130_fd_sc_hd__diode_2
X_08268_ FPGA_INST.cell0.CB_1.config_dataA\[18\] _04491_ vssd1 vssd1 vccd1 vccd1 _04492_
+ sky130_fd_sc_hd__nor2_1
XFILLER_20_583 vssd1 vssd1 vccd1 vccd1 sky130_fd_sc_hd__fill_1
XTAP_TAPCELL_ROW_22_589 vssd1 vccd1 sky130_fd_sc_hd__tapvpwrvgnd_1
X_07219_ FPGA_INST.cell3.SB0.route_sel\[10\] FPGA_INST.cell3.SB0.route_sel\[11\] _03477_
+ _03481_ _03450_ vssd1 vssd1 vccd1 vccd1 _03482_ sky130_fd_sc_hd__a41o_1
XFILLER_106_622 vssd1 vssd1 vccd1 vccd1 sky130_fd_sc_hd__fill_1
X_10230_ FPGA_INST.io_west_oeb\[12\] FPGA_INST.io_west_oeb\[14\] net291 vssd1 vssd1
+ vccd1 vccd1 _01111_ sky130_fd_sc_hd__mux2_1
X_08199_ _04416_ _04417_ _04419_ _04412_ vssd1 vssd1 vccd1 vccd1 _04423_ sky130_fd_sc_hd__o22a_1
XFILLER_106_699 vssd1 vssd1 vccd1 vccd1 sky130_fd_sc_hd__fill_1
X_10161_ FPGA_INST.cell3.SB0.route_sel\[65\] FPGA_INST.cell3.SB0.route_sel\[66\] net276
+ vssd1 vssd1 vccd1 vccd1 _01042_ sky130_fd_sc_hd__mux2_1
XANTENNA__07149__A1 net141 vssd1 vssd1 vccd1 vccd1 sky130_fd_sc_hd__diode_2
X_10092_ FPGA_INST.cell0.LE_1B.config_data\[16\] FPGA_INST.cell0.LE_1B.edge_mode net172
+ vssd1 vssd1 vccd1 vccd1 _00973_ sky130_fd_sc_hd__mux2_1
XFILLER_87_561 vssd1 vssd1 vccd1 vccd1 sky130_fd_sc_hd__fill_1
XFILLER_74_222 vssd1 vssd1 vccd1 vccd1 sky130_fd_sc_hd__fill_4
XFILLER_19_138 vssd1 vssd1 vccd1 vccd1 sky130_fd_sc_hd__fill_1
XFILLER_62_417 vssd1 vssd1 vccd1 vccd1 sky130_fd_sc_hd__fill_2
X_10994_ net876 _00344_ net659 vssd1 vssd1 vccd1 vccd1 FPGA_INST.cell2.LE_1B.config_data\[0\]
+ sky130_fd_sc_hd__dfrtp_1
XFILLER_28_683 vssd1 vssd1 vccd1 vccd1 sky130_fd_sc_hd__fill_2
XFILLER_55_491 vccd1 vssd1 vccd1 vssd1 sky130_ef_sc_hd__decap_40_12
XFILLER_35_83 vssd1 vssd1 vccd1 vccd1 sky130_fd_sc_hd__fill_2
XTAP_TAPCELL_ROW_41_854 vssd1 vccd1 sky130_fd_sc_hd__tapvpwrvgnd_1
X_11615_ net741 _00965_ net526 vssd1 vssd1 vccd1 vccd1 FPGA_INST.cell0.LE_1B.config_data\[9\]
+ sky130_fd_sc_hd__dfrtp_1
XFILLER_129_747 vssd1 vssd1 vccd1 vccd1 sky130_fd_sc_hd__fill_1
X_11546_ net772 _00896_ net557 vssd1 vssd1 vccd1 vccd1 FPGA_INST.cell0.CB_0.config_dataA\[15\]
+ sky130_fd_sc_hd__dfstp_1
XFILLER_128_257 vssd1 vssd1 vccd1 vccd1 sky130_fd_sc_hd__fill_2
XTAP_TAPCELL_ROW_96_1628 vssd1 vccd1 sky130_fd_sc_hd__tapvpwrvgnd_1
XANTENNA__10535__S net352 vssd1 vssd1 vccd1 vccd1 sky130_fd_sc_hd__diode_2
X_11477_ net745 _00827_ net530 vssd1 vssd1 vccd1 vccd1 FPGA_INST.cell0.LE_1A.config_data\[4\]
+ sky130_fd_sc_hd__dfrtp_1
X_10428_ FPGA_INST.cell2.SB0.route_sel\[0\] FPGA_INST.cell2.SB0.route_sel\[1\] net242
+ vssd1 vssd1 vccd1 vccd1 _01307_ sky130_fd_sc_hd__mux2_1
XFILLER_124_474 vssd1 vssd1 vccd1 vccd1 sky130_fd_sc_hd__fill_2
XFILLER_112_625 vssd1 vssd1 vccd1 vccd1 sky130_fd_sc_hd__fill_1
X_10359_ FPGA_INST.cell3.LE_0B.config_data\[0\] FPGA_INST.cell3.LE_0B.config_data\[1\]
+ net302 vssd1 vssd1 vccd1 vccd1 _01239_ sky130_fd_sc_hd__mux2_1
XFILLER_112_669 vssd1 vssd1 vccd1 vccd1 sky130_fd_sc_hd__fill_1
XFILLER_112_647 vssd1 vssd1 vccd1 vccd1 sky130_fd_sc_hd__fill_1
XFILLER_111_113 vssd1 vssd1 vccd1 vccd1 sky130_fd_sc_hd__fill_2
X_12029_ net858 _01375_ net643 vssd1 vssd1 vccd1 vccd1 FPGA_INST.cell2.SB0.route_sel\[69\]
+ sky130_fd_sc_hd__dfstp_1
XFILLER_120_691 vssd1 vssd1 vccd1 vccd1 sky130_fd_sc_hd__fill_8
XFILLER_65_200 vssd1 vssd1 vccd1 vccd1 sky130_fd_sc_hd__fill_2
XFILLER_18_3 vccd1 vssd1 vccd1 vssd1 sky130_ef_sc_hd__decap_40_12
XFILLER_81_715 vccd1 vssd1 vccd1 vssd1 sky130_ef_sc_hd__decap_40_12
XFILLER_66_778 vssd1 vssd1 vccd1 vccd1 sky130_fd_sc_hd__fill_1
XTAP_TAPCELL_ROW_49_965 vssd1 vccd1 sky130_fd_sc_hd__tapvpwrvgnd_1
X_07570_ FPGA_INST.cell3.SB0.route_sel\[72\] FPGA_INST.cell3.SB0.route_sel\[73\] _03820_
+ _03824_ net374 vssd1 vssd1 vccd1 vccd1 _03825_ sky130_fd_sc_hd__a311oi_4
XFILLER_65_277 vssd1 vssd1 vccd1 vccd1 sky130_fd_sc_hd__fill_1
XFILLER_53_439 vssd1 vssd1 vccd1 vccd1 sky130_fd_sc_hd__fill_1
XTAP_TAPCELL_ROW_105_1757 vssd1 vccd1 sky130_fd_sc_hd__tapvpwrvgnd_1
XTAP_TAPCELL_ROW_105_1746 vssd1 vccd1 sky130_fd_sc_hd__tapvpwrvgnd_1
XANTENNA__07432__X _03690_ vssd1 vssd1 vccd1 vccd1 sky130_fd_sc_hd__diode_2
X_06521_ _02796_ vssd1 vssd1 vccd1 vccd1 _02797_ sky130_fd_sc_hd__inv_2
XFILLER_18_193 vssd1 vssd1 vccd1 vccd1 sky130_fd_sc_hd__fill_2
XANTENNA__07312__A1 net133 vssd1 vssd1 vccd1 vccd1 sky130_fd_sc_hd__diode_2
X_09240_ FPGA_INST.cell1.SB0.route_sel\[11\] FPGA_INST.cell1.SB0.route_sel\[12\] net221
+ vssd1 vssd1 vccd1 vccd1 _00153_ sky130_fd_sc_hd__mux2_1
X_06452_ _02450_ _02728_ _02729_ _02487_ FPGA_INST.cell2.CB_0.config_dataB\[17\] vssd1
+ vssd1 vccd1 vccd1 _02730_ sky130_fd_sc_hd__a221o_1
XFILLER_34_697 vssd1 vssd1 vccd1 vccd1 sky130_fd_sc_hd__fill_1
XFILLER_119_202 vssd1 vssd1 vccd1 vccd1 sky130_fd_sc_hd__fill_8
XANTENNA__09065__A1 _04794_ vssd1 vssd1 vccd1 vccd1 sky130_fd_sc_hd__diode_2
X_05403_ FPGA_INST.cell1.SB0.route_sel\[46\] vssd1 vssd1 vccd1 vccd1 _01685_ sky130_fd_sc_hd__inv_2
X_06383_ _02330_ _02655_ _02656_ _02293_ vssd1 vssd1 vccd1 vccd1 _02661_ sky130_fd_sc_hd__a22o_1
X_09171_ FPGA_INST.cell2.LE_0B.config_data\[11\] FPGA_INST.cell2.LE_0B.config_data\[12\]
+ net255 vssd1 vssd1 vccd1 vccd1 _00085_ sky130_fd_sc_hd__mux2_1
X_08122_ net452 _03889_ vssd1 vssd1 vccd1 vccd1 _04348_ sky130_fd_sc_hd__nand2_1
XANTENNA__08812__A1 _04794_ vssd1 vssd1 vccd1 vccd1 sky130_fd_sc_hd__diode_2
X_05334_ FPGA_INST.cell3.SB0.route_sel\[106\] vssd1 vssd1 vccd1 vccd1 _01616_ sky130_fd_sc_hd__inv_2
XANTENNA__07076__A0 FPGA_INST.bus2_0\[8\] vssd1 vssd1 vccd1 vccd1 sky130_fd_sc_hd__diode_2
X_08053_ net461 _03854_ _04278_ net459 vssd1 vssd1 vccd1 vccd1 _04279_ sky130_fd_sc_hd__o211a_1
XANTENNA__08812__B2 _04789_ vssd1 vssd1 vccd1 vccd1 sky130_fd_sc_hd__diode_2
X_05265_ FPGA_INST.cell2.CB_1.config_dataA\[4\] vssd1 vssd1 vccd1 vccd1 _01547_ sky130_fd_sc_hd__inv_2
X_07004_ _02146_ _03246_ _03247_ _02110_ FPGA_INST.cell0.CB_0.config_dataA\[7\] vssd1
+ vssd1 vccd1 vccd1 _03270_ sky130_fd_sc_hd__a221o_1
XANTENNA_fanout112_A FPGA_INST.cell0.CB_1.le_outA vssd1 vssd1 vccd1 vccd1 sky130_fd_sc_hd__diode_2
XFILLER_0_207 vssd1 vssd1 vccd1 vccd1 sky130_fd_sc_hd__fill_1
XFILLER_88_347 vssd1 vssd1 vccd1 vccd1 sky130_fd_sc_hd__fill_1
X_08955_ _05143_ _02128_ vssd1 vssd1 vccd1 vccd1 FPGA_INST.bus2_0\[9\] sky130_fd_sc_hd__and2b_4
X_07906_ FPGA_INST.cell1.CB_0.config_dataA\[2\] _04131_ _04133_ vssd1 vssd1 vccd1
+ vccd1 _04134_ sky130_fd_sc_hd__or3_1
XANTENNA__08328__A0 FPGA_INST.bus1_0\[14\] vssd1 vssd1 vccd1 vccd1 sky130_fd_sc_hd__diode_2
X_08886_ _04809_ _05072_ _05074_ _04813_ _01779_ vssd1 vssd1 vccd1 vccd1 _05093_ sky130_fd_sc_hd__a221o_1
XANTENNA__08343__A3 FPGA_INST.bus1_0\[7\] vssd1 vssd1 vccd1 vccd1 sky130_fd_sc_hd__diode_2
X_07837_ net123 _02255_ _02246_ vssd1 vssd1 vccd1 vccd1 _04072_ sky130_fd_sc_hd__mux2_1
XFILLER_29_458 vssd1 vssd1 vccd1 vccd1 sky130_fd_sc_hd__fill_1
XANTENNA_fanout367_X net367 vssd1 vssd1 vccd1 vccd1 sky130_fd_sc_hd__diode_2
X_07768_ _03987_ _04017_ _03983_ vssd1 vssd1 vccd1 vccd1 _04018_ sky130_fd_sc_hd__a21oi_1
XTAP_TAPCELL_ROW_67_1218 vssd1 vccd1 sky130_fd_sc_hd__tapvpwrvgnd_1
X_09507_ FPGA_INST.cell1.LE_0A.config_data\[3\] FPGA_INST.cell1.LE_0A.config_data\[2\]
+ net344 vssd1 vssd1 vccd1 vccd1 _00418_ sky130_fd_sc_hd__mux2_1
XFILLER_71_258 vccd1 vssd1 vccd1 vssd1 sky130_ef_sc_hd__decap_40_12
X_06719_ FPGA_INST.cell2.CB_1.config_dataB\[6\] net517 vssd1 vssd1 vccd1 vccd1 _02993_
+ sky130_fd_sc_hd__nor2_1
XTAP_TAPCELL_ROW_27_659 vssd1 vccd1 sky130_fd_sc_hd__tapvpwrvgnd_1
XFILLER_80_770 vssd1 vssd1 vccd1 vccd1 sky130_fd_sc_hd__fill_2
XTAP_TAPCELL_ROW_80_1407 vssd1 vccd1 sky130_fd_sc_hd__tapvpwrvgnd_1
X_07699_ FPGA_INST.cell3.SB0.route_sel\[110\] FPGA_INST.cell3.SB0.route_sel\[111\]
+ vssd1 vssd1 vccd1 vccd1 _03950_ sky130_fd_sc_hd__nand2_1
XFILLER_80_792 vssd1 vssd1 vccd1 vccd1 sky130_fd_sc_hd__fill_1
X_09438_ FPGA_INST.cell2.LE_1B.config_data\[7\] FPGA_INST.cell2.LE_1B.config_data\[6\]
+ net374 vssd1 vssd1 vccd1 vccd1 _00351_ sky130_fd_sc_hd__mux2_1
XANTENNA__06657__A3 FPGA_INST.bus3_2\[7\] vssd1 vssd1 vccd1 vccd1 sky130_fd_sc_hd__diode_2
XFILLER_40_645 vssd1 vssd1 vccd1 vccd1 sky130_fd_sc_hd__fill_4
XANTENNA_fanout701_X net701 vssd1 vssd1 vccd1 vccd1 sky130_fd_sc_hd__diode_2
XFILLER_8_307 vssd1 vssd1 vccd1 vccd1 sky130_fd_sc_hd__fill_1
X_09369_ FPGA_INST.cell2.CB_0.config_dataA\[13\] FPGA_INST.cell2.CB_0.config_dataA\[12\]
+ net350 vssd1 vssd1 vccd1 vccd1 _00282_ sky130_fd_sc_hd__mux2_1
XANTENNA__08803__A1 _04843_ vssd1 vssd1 vccd1 vccd1 sky130_fd_sc_hd__diode_2
X_11400_ net748 _00750_ net533 vssd1 vssd1 vccd1 vccd1 FPGA_INST.cell0.LEI0.config_data\[21\]
+ sky130_fd_sc_hd__dfrtp_1
XANTENNA__08803__B2 _04846_ vssd1 vssd1 vccd1 vccd1 sky130_fd_sc_hd__diode_2
XANTENNA__08614__A _03583_ vssd1 vssd1 vccd1 vccd1 sky130_fd_sc_hd__diode_2
X_11331_ net829 _00681_ net613 vssd1 vssd1 vccd1 vccd1 FPGA_INST.cell1.CB_0.config_dataB\[23\]
+ sky130_fd_sc_hd__dfstp_2
XFILLER_21_30 vssd1 vssd1 vccd1 vccd1 sky130_fd_sc_hd__fill_8
XANTENNA__10355__S net737 vssd1 vssd1 vccd1 vccd1 sky130_fd_sc_hd__diode_2
XTAP_TAPCELL_ROW_78_1369 vssd1 vccd1 sky130_fd_sc_hd__tapvpwrvgnd_1
X_11262_ net784 _00612_ net569 vssd1 vssd1 vccd1 vccd1 FPGA_INST.cell0.SB0.route_sel\[107\]
+ sky130_fd_sc_hd__dfstp_1
XANTENNA__07909__A3 FPGA_INST.bus3_1\[11\] vssd1 vssd1 vccd1 vccd1 sky130_fd_sc_hd__diode_2
XFILLER_97_45 vssd1 vssd1 vccd1 vccd1 sky130_fd_sc_hd__fill_2
XFILLER_79_314 vssd1 vssd1 vccd1 vccd1 sky130_fd_sc_hd__fill_1
X_10213_ FPGA_INST.cell3.SB0.route_sel\[117\] FPGA_INST.cell3.SB0.route_sel\[118\]
+ net269 vssd1 vssd1 vccd1 vccd1 _01094_ sky130_fd_sc_hd__mux2_1
X_11193_ net781 _00543_ net566 vssd1 vssd1 vccd1 vccd1 FPGA_INST.cell0.SB0.route_sel\[38\]
+ sky130_fd_sc_hd__dfstp_1
XFILLER_106_496 vssd1 vssd1 vccd1 vccd1 sky130_fd_sc_hd__fill_2
X_10144_ FPGA_INST.cell3.SB0.route_sel\[48\] FPGA_INST.cell3.SB0.route_sel\[49\] net277
+ vssd1 vssd1 vccd1 vccd1 _01025_ sky130_fd_sc_hd__mux2_1
XTAP_TAPCELL_ROW_91_1558 vssd1 vccd1 sky130_fd_sc_hd__tapvpwrvgnd_1
XFILLER_121_466 vssd1 vssd1 vccd1 vccd1 sky130_fd_sc_hd__fill_1
XFILLER_48_701 vssd1 vssd1 vccd1 vccd1 sky130_fd_sc_hd__fill_8
XANTENNA__06593__A2 _02793_ vssd1 vssd1 vccd1 vccd1 sky130_fd_sc_hd__diode_2
XTAP_TAPCELL_ROW_7_384 vssd1 vccd1 sky130_fd_sc_hd__tapvpwrvgnd_1
XFILLER_102_680 vssd1 vssd1 vccd1 vccd1 sky130_fd_sc_hd__fill_2
X_10075_ FPGA_INST.cell0.LE_0A.reset_mode FPGA_INST.cell0.LE_1B.config_data\[0\] net177
+ vssd1 vssd1 vccd1 vccd1 _00956_ sky130_fd_sc_hd__mux2_1
XANTENNA__08334__A3 FPGA_INST.bus1_0\[11\] vssd1 vssd1 vccd1 vccd1 sky130_fd_sc_hd__diode_2
XFILLER_75_597 vssd1 vssd1 vccd1 vccd1 sky130_fd_sc_hd__fill_4
XFILLER_47_277 vssd1 vssd1 vccd1 vccd1 sky130_fd_sc_hd__fill_2
XTAP_TAPCELL_ROW_46_924 vssd1 vccd1 sky130_fd_sc_hd__tapvpwrvgnd_1
XFILLER_47_266 vssd1 vssd1 vccd1 vccd1 sky130_fd_sc_hd__fill_2
XFILLER_63_748 vssd1 vssd1 vccd1 vccd1 sky130_fd_sc_hd__fill_1
XANTENNA__09180__A net524 vssd1 vssd1 vccd1 vccd1 sky130_fd_sc_hd__diode_2
X_10977_ net881 _00327_ net666 vssd1 vssd1 vccd1 vccd1 FPGA_INST.cell2.CB_1.config_dataA\[8\]
+ sky130_fd_sc_hd__dfstp_1
XFILLER_94_7 vssd1 vssd1 vccd1 vccd1 sky130_fd_sc_hd__fill_2
XFILLER_30_111 vssd1 vssd1 vccd1 vccd1 sky130_fd_sc_hd__fill_2
XFILLER_31_645 vssd1 vssd1 vccd1 vccd1 sky130_fd_sc_hd__fill_2
XFILLER_31_656 vccd1 vssd1 vccd1 vssd1 sky130_ef_sc_hd__decap_40_12
XTAP_TAPCELL_ROW_100_1687 vssd1 vccd1 sky130_fd_sc_hd__tapvpwrvgnd_1
XTAP_TAPCELL_ROW_100_1676 vssd1 vccd1 sky130_fd_sc_hd__tapvpwrvgnd_1
XANTENNA__07058__A0 FPGA_INST.bus2_0\[2\] vssd1 vssd1 vccd1 vccd1 sky130_fd_sc_hd__diode_2
X_11529_ net810 _00879_ net593 vssd1 vssd1 vccd1 vccd1 FPGA_INST.config_bits\[10\]
+ sky130_fd_sc_hd__dfstp_1
XANTENNA__06281__A1 net2 vssd1 vssd1 vccd1 vccd1 sky130_fd_sc_hd__diode_2
XFILLER_125_794 vssd1 vssd1 vccd1 vccd1 sky130_fd_sc_hd__fill_2
Xfanout809 net811 vssd1 vssd1 vccd1 vccd1 net809 sky130_fd_sc_hd__clkbuf_2
X_08740_ _04809_ _04927_ _04929_ _04813_ _01771_ vssd1 vssd1 vccd1 vccd1 _04949_ sky130_fd_sc_hd__a221o_1
XFILLER_66_520 vssd1 vssd1 vccd1 vccd1 sky130_fd_sc_hd__fill_1
X_05952_ FPGA_INST.cell0.SB0.route_sel\[52\] _01677_ _01678_ FPGA_INST.cell0.SB0.route_sel\[55\]
+ _02231_ vssd1 vssd1 vccd1 vccd1 _02232_ sky130_fd_sc_hd__a221o_1
X_08671_ net399 _04801_ _04879_ vssd1 vssd1 vccd1 vccd1 _04880_ sky130_fd_sc_hd__a21oi_1
X_05883_ _02161_ _02162_ vssd1 vssd1 vccd1 vccd1 _02163_ sky130_fd_sc_hd__or2_1
XANTENNA__07533__B2 FPGA_INST.cell3.SB0.route_sel\[68\] vssd1 vssd1 vccd1 vccd1 sky130_fd_sc_hd__diode_2
XFILLER_66_597 vssd1 vssd1 vccd1 vccd1 sky130_fd_sc_hd__fill_1
X_07622_ _02067_ _03874_ vssd1 vssd1 vccd1 vccd1 _03875_ sky130_fd_sc_hd__nor2_4
XFILLER_26_417 vssd1 vssd1 vccd1 vccd1 sky130_fd_sc_hd__fill_2
XFILLER_81_556 vssd1 vssd1 vccd1 vccd1 sky130_fd_sc_hd__fill_4
XANTENNA__05544__B1 FPGA_INST.bus1_0\[14\] vssd1 vssd1 vccd1 vccd1 sky130_fd_sc_hd__diode_2
XFILLER_53_225 vssd1 vssd1 vccd1 vccd1 sky130_fd_sc_hd__fill_2
XFILLER_38_299 vssd1 vssd1 vccd1 vccd1 sky130_fd_sc_hd__fill_1
X_07553_ FPGA_INST.cell1.SB0.route_sel\[74\] FPGA_INST.cell1.SB0.route_sel\[75\] vssd1
+ vssd1 vccd1 vccd1 _03808_ sky130_fd_sc_hd__nor2_1
XTAP_TAPCELL_ROW_24_618 vssd1 vccd1 sky130_fd_sc_hd__tapvpwrvgnd_1
X_07484_ FPGA_INST.cell3.SB0.route_sel\[56\] FPGA_INST.cell3.SB0.route_sel\[57\] _03735_
+ _03740_ net365 vssd1 vssd1 vccd1 vccd1 _03741_ sky130_fd_sc_hd__a311o_2
X_06504_ _02446_ _02779_ _02440_ vssd1 vssd1 vccd1 vccd1 _02780_ sky130_fd_sc_hd__nand3b_4
X_09223_ FPGA_INST.cell2.CB_1.config_dataB\[20\] FPGA_INST.cell2.CB_1.config_dataB\[19\]
+ net367 vssd1 vssd1 vccd1 vccd1 _00136_ sky130_fd_sc_hd__mux2_1
XTAP_TAPCELL_ROW_62_1148 vssd1 vccd1 sky130_fd_sc_hd__tapvpwrvgnd_1
XFILLER_42_29 vccd1 vssd1 vccd1 vssd1 sky130_ef_sc_hd__decap_40_12
X_06435_ net2 _02692_ _02693_ net30 _02712_ vssd1 vssd1 vccd1 vccd1 _02713_ sky130_fd_sc_hd__a221o_1
XFILLER_21_133 vssd1 vssd1 vccd1 vccd1 sky130_fd_sc_hd__fill_4
XANTENNA_fanout327_A net332 vssd1 vssd1 vccd1 vccd1 sky130_fd_sc_hd__diode_2
X_09154_ FPGA_INST.cell2.LE_0A.reset_val FPGA_INST.cell2.LE_0A.edge_mode net358 vssd1
+ vssd1 vccd1 vccd1 _00069_ sky130_fd_sc_hd__mux2_1
X_08105_ FPGA_INST.cell1.LE_0B.config_data\[7\] FPGA_INST.cell1.LE_0B.config_data\[6\]
+ _04296_ vssd1 vssd1 vccd1 vccd1 _04331_ sky130_fd_sc_hd__mux2_1
XTAP_TAPCELL_ROW_118_1937 vssd1 vccd1 sky130_fd_sc_hd__tapvpwrvgnd_1
X_06366_ _02131_ _02623_ _02624_ _02168_ FPGA_INST.cell2.CB_0.config_dataB\[7\] vssd1
+ vssd1 vccd1 vccd1 _02644_ sky130_fd_sc_hd__a221o_1
X_05317_ FPGA_INST.cell2.LE_1B.config_data\[16\] vssd1 vssd1 vccd1 vccd1 _01599_ sky130_fd_sc_hd__inv_2
XANTENNA_fanout115_X net115 vssd1 vssd1 vccd1 vccd1 sky130_fd_sc_hd__diode_2
X_06297_ net500 _02092_ vssd1 vssd1 vccd1 vccd1 _02577_ sky130_fd_sc_hd__nand2_1
X_09085_ FPGA_INST.cell2.LEI0.config_data\[0\] FPGA_INST.cell2.LE_1A.reset_mode net358
+ vssd1 vssd1 vccd1 vccd1 _00001_ sky130_fd_sc_hd__mux2_1
X_08036_ _04258_ _04259_ _04261_ vssd1 vssd1 vccd1 vccd1 _04262_ sky130_fd_sc_hd__and3b_1
X_05248_ FPGA_INST.cell2.CB_0.config_dataA\[2\] vssd1 vssd1 vccd1 vccd1 _01530_ sky130_fd_sc_hd__inv_2
XANTENNA_fanout696_A net701 vssd1 vssd1 vccd1 vccd1 sky130_fd_sc_hd__diode_2
XFILLER_107_11 vssd1 vssd1 vccd1 vccd1 sky130_fd_sc_hd__fill_2
XANTENNA__08013__A2 FPGA_INST.bus3_1\[6\] vssd1 vssd1 vccd1 vccd1 sky130_fd_sc_hd__diode_2
XFILLER_107_55 vssd1 vssd1 vccd1 vccd1 sky130_fd_sc_hd__fill_1
X_09987_ net738 FPGA_INST.config_bits\[7\] _05232_ FPGA_INST.config_bits\[8\] vssd1
+ vssd1 vccd1 vccd1 _05236_ sky130_fd_sc_hd__a31o_1
XTAP_TAPCELL_ROW_73_1299 vssd1 vccd1 sky130_fd_sc_hd__tapvpwrvgnd_1
X_08938_ FPGA_INST.cell3.SB0.route_sel\[89\] FPGA_INST.cell3.SB0.route_sel\[88\] vssd1
+ vssd1 vccd1 vccd1 _05132_ sky130_fd_sc_hd__nand2b_1
XTAP_TAPCELL_ROW_4_332 vssd1 vccd1 sky130_fd_sc_hd__tapvpwrvgnd_1
X_08869_ net25 net26 net387 vssd1 vssd1 vccd1 vccd1 _05076_ sky130_fd_sc_hd__mux2_1
XANTENNA__10871__SET_B net577 vssd1 vssd1 vccd1 vccd1 sky130_fd_sc_hd__diode_2
XTAP_TAPCELL_ROW_4_343 vssd1 vccd1 sky130_fd_sc_hd__tapvpwrvgnd_1
X_10900_ net829 _00250_ net613 vssd1 vssd1 vccd1 vccd1 FPGA_INST.cell1.SB0.route_sel\[109\]
+ sky130_fd_sc_hd__dfstp_1
XFILLER_57_597 vssd1 vssd1 vccd1 vccd1 sky130_fd_sc_hd__fill_4
XFILLER_57_586 vssd1 vssd1 vccd1 vccd1 sky130_fd_sc_hd__fill_1
XFILLER_29_277 vssd1 vssd1 vccd1 vccd1 sky130_fd_sc_hd__fill_2
X_11880_ net928 _01226_ net712 vssd1 vssd1 vccd1 vccd1 FPGA_INST.cell3.LE_0A.config_data\[10\]
+ sky130_fd_sc_hd__dfrtp_1
XANTENNA__09204__S net362 vssd1 vssd1 vccd1 vccd1 sky130_fd_sc_hd__diode_2
X_10831_ net801 _00181_ net586 vssd1 vssd1 vccd1 vccd1 FPGA_INST.cell1.SB0.route_sel\[40\]
+ sky130_fd_sc_hd__dfstp_1
XANTENNA__09277__A1 FPGA_INST.cell1.SB0.route_sel\[49\] vssd1 vssd1 vccd1 vccd1 sky130_fd_sc_hd__diode_2
XFILLER_72_589 vssd1 vssd1 vccd1 vccd1 sky130_fd_sc_hd__fill_8
XFILLER_60_718 vssd1 vssd1 vccd1 vccd1 sky130_fd_sc_hd__fill_8
XFILLER_53_781 vssd1 vssd1 vccd1 vccd1 sky130_fd_sc_hd__fill_2
XPHY_EDGE_ROW_11_Right_11 vssd1 vssd1 vccd1 vccd1 sky130_fd_sc_hd__decap_3
X_10762_ net883 _00112_ net667 vssd1 vssd1 vccd1 vccd1 FPGA_INST.cell2.LE_1A.edge_mode
+ sky130_fd_sc_hd__dfstp_1
XANTENNA__07800__X _04049_ vssd1 vssd1 vccd1 vccd1 sky130_fd_sc_hd__diode_2
XTAP_TAPCELL_ROW_51_993 vssd1 vccd1 sky130_fd_sc_hd__tapvpwrvgnd_1
X_10693_ net868 _00043_ net652 vssd1 vssd1 vccd1 vccd1 FPGA_INST.cell2.LEI0.config_data\[42\]
+ sky130_fd_sc_hd__dfrtp_1
XFILLER_40_475 vssd1 vssd1 vccd1 vccd1 sky130_fd_sc_hd__fill_1
XANTENNA__10085__S net173 vssd1 vssd1 vccd1 vccd1 sky130_fd_sc_hd__diode_2
X_11314_ net905 _00664_ net689 vssd1 vssd1 vccd1 vccd1 FPGA_INST.cell1.CB_0.config_dataB\[6\]
+ sky130_fd_sc_hd__dfstp_1
XFILLER_107_783 vssd1 vssd1 vccd1 vccd1 sky130_fd_sc_hd__fill_1
X_11245_ net767 _00595_ net552 vssd1 vssd1 vccd1 vccd1 FPGA_INST.cell0.SB0.route_sel\[90\]
+ sky130_fd_sc_hd__dfstp_1
XFILLER_4_365 vssd1 vssd1 vccd1 vccd1 sky130_fd_sc_hd__fill_4
XPHY_EDGE_ROW_20_Right_20 vssd1 vssd1 vccd1 vccd1 sky130_fd_sc_hd__decap_3
XFILLER_122_775 vssd1 vssd1 vccd1 vccd1 sky130_fd_sc_hd__fill_2
XFILLER_95_615 vssd1 vssd1 vccd1 vccd1 sky130_fd_sc_hd__fill_1
X_11176_ net785 _00526_ net570 vssd1 vssd1 vccd1 vccd1 FPGA_INST.cell0.SB0.route_sel\[21\]
+ sky130_fd_sc_hd__dfstp_1
XANTENNA__06151__X _02431_ vssd1 vssd1 vccd1 vccd1 sky130_fd_sc_hd__diode_2
X_10127_ FPGA_INST.cell3.SB0.route_sel\[32\] FPGA_INST.cell3.SB0.route_sel\[31\] net369
+ vssd1 vssd1 vccd1 vccd1 _01008_ sky130_fd_sc_hd__mux2_1
X_10058_ FPGA_INST.cell0.CB_1.config_dataA\[8\] FPGA_INST.cell0.CB_1.config_dataA\[7\]
+ net312 vssd1 vssd1 vccd1 vccd1 _00939_ sky130_fd_sc_hd__mux2_1
XFILLER_94_169 vssd1 vssd1 vccd1 vccd1 sky130_fd_sc_hd__fill_2
XFILLER_48_586 vssd1 vssd1 vccd1 vccd1 sky130_fd_sc_hd__fill_2
XANTENNA__06869__A3 FPGA_INST.bus2_0\[11\] vssd1 vssd1 vccd1 vccd1 sky130_fd_sc_hd__diode_2
XFILLER_35_236 vssd1 vssd1 vccd1 vccd1 sky130_fd_sc_hd__fill_1
XANTENNA__09268__A1 FPGA_INST.cell1.SB0.route_sel\[39\] vssd1 vssd1 vccd1 vccd1 sky130_fd_sc_hd__diode_2
XFILLER_51_707 vssd1 vssd1 vccd1 vccd1 sky130_fd_sc_hd__fill_1
XTAP_TAPCELL_ROW_102_1716 vssd1 vccd1 sky130_fd_sc_hd__tapvpwrvgnd_1
XTAP_TAPCELL_ROW_102_1705 vssd1 vccd1 sky130_fd_sc_hd__tapvpwrvgnd_1
XFILLER_85_3 vccd1 vssd1 vccd1 vssd1 sky130_ef_sc_hd__decap_40_12
X_06220_ net138 net127 net131 net102 FPGA_INST.cell2.LEI0.config_data\[12\] FPGA_INST.cell2.LEI0.config_data\[13\]
+ vssd1 vssd1 vccd1 vccd1 _02500_ sky130_fd_sc_hd__mux4_1
XFILLER_117_503 vssd1 vssd1 vccd1 vccd1 sky130_fd_sc_hd__fill_1
XANTENNA__05597__B net170 vssd1 vssd1 vccd1 vccd1 sky130_fd_sc_hd__diode_2
X_06151_ net117 _01967_ _02332_ _02415_ _02430_ vssd1 vssd1 vccd1 vccd1 _02431_ sky130_fd_sc_hd__a32o_1
X_06082_ FPGA_INST.bus3_2\[3\] _02357_ _02359_ _02361_ vssd1 vssd1 vccd1 vccd1 _02362_
+ sky130_fd_sc_hd__a211o_1
X_09910_ FPGA_INST.cell0.LE_0B.config_data\[15\] FPGA_INST.cell0.LE_0B.config_data\[14\]
+ net309 vssd1 vssd1 vccd1 vccd1 _00816_ sky130_fd_sc_hd__mux2_1
XTAP_TAPCELL_ROW_113_1867 vssd1 vccd1 sky130_fd_sc_hd__tapvpwrvgnd_1
XANTENNA__07157__X _03421_ vssd1 vssd1 vccd1 vccd1 sky130_fd_sc_hd__diode_2
Xfanout606 net607 vssd1 vssd1 vccd1 vccd1 net606 sky130_fd_sc_hd__clkbuf_4
XANTENNA__06006__A1 net5 vssd1 vssd1 vccd1 vccd1 sky130_fd_sc_hd__diode_2
XANTENNA__08546__A3 _01792_ vssd1 vssd1 vccd1 vccd1 sky130_fd_sc_hd__diode_2
Xfanout617 net627 vssd1 vssd1 vccd1 vccd1 net617 sky130_fd_sc_hd__clkbuf_2
Xfanout628 net31 vssd1 vssd1 vccd1 vccd1 net628 sky130_fd_sc_hd__clkbuf_4
X_09841_ FPGA_INST.cell0.LEI0.config_data\[19\] FPGA_INST.cell0.LEI0.config_data\[20\]
+ net183 vssd1 vssd1 vccd1 vccd1 _00749_ sky130_fd_sc_hd__mux2_1
Xfanout639 net647 vssd1 vssd1 vccd1 vccd1 net639 sky130_fd_sc_hd__clkbuf_2
X_09772_ FPGA_INST.cell1.CB_0.config_dataB\[23\] FPGA_INST.cell1.CB_0.config_dataB\[22\]
+ net343 vssd1 vssd1 vccd1 vccd1 _00681_ sky130_fd_sc_hd__mux2_1
XPHY_EDGE_ROW_13_Left_144 vssd1 vssd1 vccd1 vccd1 sky130_fd_sc_hd__decap_3
X_06984_ net432 net433 _02271_ _03245_ FPGA_INST.cell0.CB_0.config_dataA\[7\] vssd1
+ vssd1 vccd1 vccd1 _03250_ sky130_fd_sc_hd__o311a_1
X_08723_ net19 _04929_ _04931_ net393 FPGA_INST.cell3.CB_0.config_dataA\[17\] vssd1
+ vssd1 vccd1 vccd1 _04932_ sky130_fd_sc_hd__a221o_1
XFILLER_100_469 vssd1 vssd1 vccd1 vccd1 sky130_fd_sc_hd__fill_1
X_05935_ FPGA_INST.cell2.SB0.route_sel\[61\] FPGA_INST.cell2.SB0.route_sel\[60\] vssd1
+ vssd1 vccd1 vccd1 _02215_ sky130_fd_sc_hd__nand2b_1
XFILLER_37_29 vssd1 vssd1 vccd1 vccd1 sky130_fd_sc_hd__fill_4
XANTENNA_fanout277_A net285 vssd1 vssd1 vccd1 vccd1 sky130_fd_sc_hd__diode_2
XFILLER_85_169 vssd1 vssd1 vccd1 vccd1 sky130_fd_sc_hd__fill_4
XTAP_TAPCELL_ROW_1_302 vssd1 vccd1 sky130_fd_sc_hd__tapvpwrvgnd_1
XFILLER_27_715 vssd1 vssd1 vccd1 vccd1 sky130_fd_sc_hd__fill_1
X_08654_ FPGA_INST.cell3.CB_0.config_dataA\[5\] FPGA_INST.cell3.CB_0.config_dataA\[6\]
+ vssd1 vssd1 vccd1 vccd1 _04863_ sky130_fd_sc_hd__nor2_1
X_05866_ _02145_ vssd1 vssd1 vccd1 vccd1 _02146_ sky130_fd_sc_hd__inv_2
XFILLER_27_737 vssd1 vssd1 vccd1 vccd1 sky130_fd_sc_hd__fill_1
X_08585_ _03787_ _04793_ vssd1 vssd1 vccd1 vccd1 _04794_ sky130_fd_sc_hd__nand2_4
X_07605_ FPGA_INST.cell3.SB0.route_sel\[86\] FPGA_INST.cell3.SB0.route_sel\[87\] net130
+ _02040_ _03856_ vssd1 vssd1 vccd1 vccd1 _03859_ sky130_fd_sc_hd__a221oi_1
X_05797_ net101 _01893_ _02036_ vssd1 vssd1 vccd1 vccd1 _02077_ sky130_fd_sc_hd__and3_1
X_07536_ _03453_ _03747_ vssd1 vssd1 vccd1 vccd1 _03791_ sky130_fd_sc_hd__nand2_1
XANTENNA__09959__S net314 vssd1 vssd1 vccd1 vccd1 sky130_fd_sc_hd__diode_2
XANTENNA__05532__A3 net17 vssd1 vssd1 vccd1 vccd1 sky130_fd_sc_hd__diode_2
XTAP_TAPCELL_ROW_37_798 vssd1 vccd1 sky130_fd_sc_hd__tapvpwrvgnd_1
XPHY_EDGE_ROW_22_Left_153 vssd1 vssd1 vccd1 vccd1 sky130_fd_sc_hd__decap_3
XFILLER_34_291 vssd1 vssd1 vccd1 vccd1 sky130_fd_sc_hd__fill_1
XANTENNA_fanout232_X net232 vssd1 vssd1 vccd1 vccd1 sky130_fd_sc_hd__diode_2
X_07467_ net148 _03561_ _03607_ _03717_ _03723_ vssd1 vssd1 vccd1 vccd1 _03724_ sky130_fd_sc_hd__o311a_1
XANTENNA_fanout611_A net615 vssd1 vssd1 vccd1 vccd1 sky130_fd_sc_hd__diode_2
X_09206_ FPGA_INST.cell2.CB_1.config_dataB\[3\] FPGA_INST.cell2.CB_1.config_dataB\[2\]
+ net360 vssd1 vssd1 vccd1 vccd1 _00119_ sky130_fd_sc_hd__mux2_1
XFILLER_22_486 vccd1 vssd1 vccd1 vssd1 sky130_ef_sc_hd__decap_40_12
X_07398_ net133 _02318_ _03656_ FPGA_INST.cell3.SB0.route_sel\[44\] FPGA_INST.cell3.SB0.route_sel\[45\]
+ vssd1 vssd1 vccd1 vccd1 _03657_ sky130_fd_sc_hd__o2111a_1
X_06418_ net491 _01869_ _02695_ net490 vssd1 vssd1 vccd1 vccd1 _02696_ sky130_fd_sc_hd__o211a_1
XFILLER_108_525 vssd1 vssd1 vccd1 vccd1 sky130_fd_sc_hd__fill_1
XANTENNA__08234__A2 FPGA_INST.bus1_0\[14\] vssd1 vssd1 vccd1 vccd1 sky130_fd_sc_hd__diode_2
X_09137_ FPGA_INST.cell2.LE_0A.config_data\[1\] FPGA_INST.cell2.LE_0A.config_data\[0\]
+ net350 vssd1 vssd1 vccd1 vccd1 _00052_ sky130_fd_sc_hd__mux2_1
X_06349_ net494 _02217_ vssd1 vssd1 vccd1 vccd1 _02627_ sky130_fd_sc_hd__nand2_1
XANTENNA__09431__A1 FPGA_INST.cell2.LE_1B.config_data\[0\] vssd1 vssd1 vccd1 vccd1
+ sky130_fd_sc_hd__diode_2
XFILLER_108_569 vssd1 vssd1 vccd1 vccd1 sky130_fd_sc_hd__fill_4
X_09068_ net91 _05201_ _03737_ vssd1 vssd1 vccd1 vccd1 net67 sky130_fd_sc_hd__mux2_1
XANTENNA__09694__S net196 vssd1 vssd1 vccd1 vccd1 sky130_fd_sc_hd__diode_2
X_08019_ FPGA_INST.cell1.CB_0.config_dataB\[8\] _04240_ _04244_ vssd1 vssd1 vccd1
+ vccd1 _04245_ sky130_fd_sc_hd__or3b_1
XTAP_TAPCELL_ROW_75_1339 vssd1 vccd1 sky130_fd_sc_hd__tapvpwrvgnd_1
XTAP_TAPCELL_ROW_75_1328 vssd1 vccd1 sky130_fd_sc_hd__tapvpwrvgnd_1
XTAP_TAPCELL_ROW_9_413 vssd1 vccd1 sky130_fd_sc_hd__tapvpwrvgnd_1
XTAP_TAPCELL_ROW_9_402 vssd1 vccd1 sky130_fd_sc_hd__tapvpwrvgnd_1
XANTENNA__08611__B FPGA_INST.cell3.SB0.route_sel\[31\] vssd1 vssd1 vccd1 vccd1 sky130_fd_sc_hd__diode_2
X_11030_ net834 _00380_ net618 vssd1 vssd1 vccd1 vccd1 FPGA_INST.cell1.LEI0.config_data\[15\]
+ sky130_fd_sc_hd__dfrtp_1
XFILLER_104_753 vssd1 vssd1 vccd1 vccd1 sky130_fd_sc_hd__fill_2
XFILLER_1_335 vssd1 vssd1 vccd1 vccd1 sky130_fd_sc_hd__fill_1
XPHY_EDGE_ROW_31_Left_162 vssd1 vssd1 vccd1 vccd1 sky130_fd_sc_hd__decap_3
XFILLER_103_285 vssd1 vssd1 vccd1 vccd1 sky130_fd_sc_hd__fill_1
XFILLER_49_317 vssd1 vssd1 vccd1 vccd1 sky130_fd_sc_hd__fill_1
X_11932_ net940 _01278_ net724 vssd1 vssd1 vccd1 vccd1 FPGA_INST.cell3.LE_1A.reset_val
+ sky130_fd_sc_hd__dfrtp_1
XFILLER_57_383 vssd1 vssd1 vccd1 vccd1 sky130_fd_sc_hd__fill_8
X_11863_ net935 _01209_ net719 vssd1 vssd1 vccd1 vccd1 FPGA_INST.cell3.LEI0.config_data\[43\]
+ sky130_fd_sc_hd__dfrtp_1
X_10814_ net785 _00164_ net570 vssd1 vssd1 vccd1 vccd1 FPGA_INST.cell1.SB0.route_sel\[23\]
+ sky130_fd_sc_hd__dfstp_1
XFILLER_45_589 vssd1 vssd1 vccd1 vccd1 sky130_fd_sc_hd__fill_2
XPHY_EDGE_ROW_40_Left_171 vssd1 vssd1 vccd1 vccd1 sky130_fd_sc_hd__decap_3
X_11794_ net886 _01140_ net670 vssd1 vssd1 vccd1 vccd1 FPGA_INST.io_east_oeb\[8\]
+ sky130_fd_sc_hd__dfrtp_1
XFILLER_13_453 vssd1 vssd1 vccd1 vccd1 sky130_fd_sc_hd__fill_2
X_10745_ net876 _00095_ net659 vssd1 vssd1 vccd1 vccd1 FPGA_INST.cell2.LE_1A.config_data\[0\]
+ sky130_fd_sc_hd__dfrtp_1
XFILLER_40_261 vssd1 vssd1 vccd1 vccd1 sky130_fd_sc_hd__fill_1
XANTENNA__07681__B1 _03932_ vssd1 vssd1 vccd1 vccd1 sky130_fd_sc_hd__diode_2
XFILLER_9_457 vssd1 vssd1 vccd1 vccd1 sky130_fd_sc_hd__fill_1
X_10676_ net877 _00026_ net661 vssd1 vssd1 vccd1 vccd1 FPGA_INST.cell2.LEI0.config_data\[25\]
+ sky130_fd_sc_hd__dfrtp_1
XFILLER_9_479 vssd1 vssd1 vccd1 vccd1 sky130_fd_sc_hd__fill_2
XTAP_TAPCELL_ROW_130_2101 vssd1 vccd1 sky130_fd_sc_hd__tapvpwrvgnd_1
XANTENNA__07433__B1 _03690_ vssd1 vssd1 vccd1 vccd1 sky130_fd_sc_hd__diode_2
XTAP_TAPCELL_ROW_130_2123 vssd1 vccd1 sky130_fd_sc_hd__tapvpwrvgnd_1
XTAP_TAPCELL_ROW_130_2112 vssd1 vccd1 sky130_fd_sc_hd__tapvpwrvgnd_1
XFILLER_126_377 vssd1 vssd1 vccd1 vccd1 sky130_fd_sc_hd__fill_1
XFILLER_4_173 vssd1 vssd1 vccd1 vccd1 sky130_fd_sc_hd__fill_8
XANTENNA__10543__S net352 vssd1 vssd1 vccd1 vccd1 sky130_fd_sc_hd__diode_2
XANTENNA__07418__A FPGA_INST.cell1.SB0.route_sel\[48\] vssd1 vssd1 vccd1 vccd1 sky130_fd_sc_hd__diode_2
X_11228_ net764 _00578_ net549 vssd1 vssd1 vccd1 vccd1 FPGA_INST.cell0.SB0.route_sel\[73\]
+ sky130_fd_sc_hd__dfstp_1
XFILLER_4_195 vssd1 vssd1 vccd1 vccd1 sky130_fd_sc_hd__fill_1
XFILLER_122_572 vssd1 vssd1 vccd1 vccd1 sky130_fd_sc_hd__fill_1
XANTENNA__10840__Q FPGA_INST.cell1.SB0.route_sel\[49\] vssd1 vssd1 vccd1 vccd1 sky130_fd_sc_hd__diode_2
XANTENNA__07736__A1 net81 vssd1 vssd1 vccd1 vccd1 sky130_fd_sc_hd__diode_2
X_11159_ net821 _00509_ net605 vssd1 vssd1 vccd1 vccd1 FPGA_INST.cell0.SB0.route_sel\[4\]
+ sky130_fd_sc_hd__dfstp_1
XTAP_TAPCELL_ROW_128_2074 vssd1 vccd1 sky130_fd_sc_hd__tapvpwrvgnd_1
XFILLER_67_169 vssd1 vssd1 vccd1 vccd1 sky130_fd_sc_hd__fill_8
X_05720_ net485 net486 net163 vssd1 vssd1 vccd1 vccd1 _02000_ sky130_fd_sc_hd__and3_1
XANTENNA__08161__A1 FPGA_INST.bus1_0\[13\] vssd1 vssd1 vccd1 vccd1 sky130_fd_sc_hd__diode_2
X_05651_ net384 _01920_ FPGA_INST.bus2_0\[12\] vssd1 vssd1 vccd1 vccd1 _01931_ sky130_fd_sc_hd__o21bai_1
XFILLER_91_684 vccd1 vssd1 vccd1 vssd1 sky130_ef_sc_hd__decap_40_12
X_08370_ net75 FPGA_INST.bus1_0\[5\] net74 FPGA_INST.bus1_0\[7\] net442 net441 vssd1
+ vssd1 vccd1 vccd1 _04592_ sky130_fd_sc_hd__mux4_1
XFILLER_23_206 vssd1 vssd1 vccd1 vccd1 sky130_fd_sc_hd__fill_4
XANTENNA__08683__S _04860_ vssd1 vssd1 vccd1 vccd1 sky130_fd_sc_hd__diode_2
X_07321_ _03541_ _03581_ net269 vssd1 vssd1 vccd1 vccd1 _03582_ sky130_fd_sc_hd__o21ai_1
X_05582_ _01857_ net125 _01856_ vssd1 vssd1 vccd1 vccd1 _01862_ sky130_fd_sc_hd__or3b_1
XTAP_TAPCELL_ROW_34_757 vssd1 vccd1 sky130_fd_sc_hd__tapvpwrvgnd_1
XANTENNA__07600__B _03853_ vssd1 vssd1 vccd1 vccd1 sky130_fd_sc_hd__diode_2
X_07252_ _01787_ _03497_ vssd1 vssd1 vccd1 vccd1 _03514_ sky130_fd_sc_hd__and2_1
XTAP_TAPCELL_ROW_14_481 vssd1 vccd1 sky130_fd_sc_hd__tapvpwrvgnd_1
X_07183_ FPGA_INST.cell3.SB0.route_sel\[8\] FPGA_INST.cell3.SB0.route_sel\[9\] vssd1
+ vssd1 vccd1 vccd1 _03446_ sky130_fd_sc_hd__and2_1
X_06203_ FPGA_INST.cell2.SB0.route_sel\[0\] FPGA_INST.cell2.SB0.route_sel\[1\] _02481_
+ _02482_ vssd1 vssd1 vccd1 vccd1 _02483_ sky130_fd_sc_hd__a211o_1
XANTENNA__06227__A1 _02450_ vssd1 vssd1 vccd1 vccd1 sky130_fd_sc_hd__diode_2
XANTENNA__06227__B2 _02487_ vssd1 vssd1 vccd1 vccd1 sky130_fd_sc_hd__diode_2
X_06134_ net507 _02413_ _02377_ FPGA_INST.cell2.CB_0.config_dataA\[6\] vssd1 vssd1
+ vccd1 vccd1 _02414_ sky130_fd_sc_hd__o211a_1
XANTENNA__07975__A1 _03810_ vssd1 vssd1 vccd1 vccd1 sky130_fd_sc_hd__diode_2
XANTENNA__08271__X _04495_ vssd1 vssd1 vccd1 vccd1 sky130_fd_sc_hd__diode_2
X_06065_ net117 _01870_ _02332_ _02336_ vssd1 vssd1 vccd1 vccd1 _02345_ sky130_fd_sc_hd__a31o_1
XANTENNA__08519__A3 net79 vssd1 vssd1 vccd1 vccd1 sky130_fd_sc_hd__diode_2
Xfanout403 FPGA_INST.cell0.CB_1.config_dataA\[15\] vssd1 vssd1 vccd1 vccd1 net403
+ sky130_fd_sc_hd__buf_2
Xfanout414 FPGA_INST.cell0.CB_0.config_dataB\[16\] vssd1 vssd1 vccd1 vccd1 net414
+ sky130_fd_sc_hd__buf_2
XANTENNA__07727__A1 _03483_ vssd1 vssd1 vccd1 vccd1 sky130_fd_sc_hd__diode_2
Xfanout447 FPGA_INST.cell0.CB_1.config_dataB\[1\] vssd1 vssd1 vccd1 vccd1 net447 sky130_fd_sc_hd__buf_2
XFILLER_59_615 vssd1 vssd1 vccd1 vccd1 sky130_fd_sc_hd__fill_1
X_09824_ FPGA_INST.cell0.LEI0.config_data\[2\] FPGA_INST.cell0.LEI0.config_data\[3\]
+ net174 vssd1 vssd1 vccd1 vccd1 _00732_ sky130_fd_sc_hd__mux2_1
Xfanout436 net437 vssd1 vssd1 vccd1 vccd1 net436 sky130_fd_sc_hd__buf_2
Xfanout425 FPGA_INST.cell0.CB_0.config_dataB\[0\] vssd1 vssd1 vccd1 vccd1 net425 sky130_fd_sc_hd__clkbuf_2
Xfanout458 FPGA_INST.cell1.CB_0.config_dataB\[5\] vssd1 vssd1 vccd1 vccd1 net458 sky130_fd_sc_hd__clkbuf_2
Xfanout469 FPGA_INST.cell1.CB_0.config_dataA\[5\] vssd1 vssd1 vccd1 vccd1 net469 sky130_fd_sc_hd__clkbuf_2
XTAP_TAPCELL_ROW_70_1269 vssd1 vccd1 sky130_fd_sc_hd__tapvpwrvgnd_1
XTAP_TAPCELL_ROW_70_1258 vssd1 vccd1 sky130_fd_sc_hd__tapvpwrvgnd_1
XANTENNA__05738__B1 FPGA_INST.bus1_0\[10\] vssd1 vssd1 vccd1 vccd1 sky130_fd_sc_hd__diode_2
X_09755_ net456 net457 net369 vssd1 vssd1 vccd1 vccd1 _00664_ sky130_fd_sc_hd__mux2_1
X_06967_ FPGA_INST.cell0.LE_0B.config_data\[11\] FPGA_INST.cell0.LE_0B.config_data\[10\]
+ _03159_ vssd1 vssd1 vccd1 vccd1 _03235_ sky130_fd_sc_hd__mux2_1
XANTENNA_fanout561_A net575 vssd1 vssd1 vccd1 vccd1 sky130_fd_sc_hd__diode_2
XFILLER_39_361 vssd1 vssd1 vccd1 vccd1 sky130_fd_sc_hd__fill_2
XFILLER_104_78 vssd1 vssd1 vccd1 vccd1 sky130_fd_sc_hd__fill_4
X_08706_ FPGA_INST.cell3.CB_0.config_dataA\[12\] _04895_ net27 FPGA_INST.cell3.CB_0.config_dataA\[13\]
+ vssd1 vssd1 vccd1 vccd1 _04915_ sky130_fd_sc_hd__and4b_1
XFILLER_64_27 vssd1 vssd1 vccd1 vccd1 sky130_fd_sc_hd__fill_1
X_05918_ FPGA_INST.cell2.CB_1.config_dataB\[23\] FPGA_INST.cell2.CB_1.config_dataB\[22\]
+ vssd1 vssd1 vccd1 vccd1 _02198_ sky130_fd_sc_hd__nand2b_1
X_09686_ FPGA_INST.cell0.SB0.route_sel\[89\] FPGA_INST.cell0.SB0.route_sel\[90\] net188
+ vssd1 vssd1 vccd1 vccd1 _00595_ sky130_fd_sc_hd__mux2_1
X_06898_ _02110_ _03163_ _03165_ _02146_ FPGA_INST.cell0.CB_0.config_dataB\[12\] vssd1
+ vssd1 vccd1 vccd1 _03166_ sky130_fd_sc_hd__a221o_1
X_08637_ _03666_ _04845_ vssd1 vssd1 vccd1 vccd1 _04846_ sky130_fd_sc_hd__nand2_4
XFILLER_104_89 vssd1 vssd1 vccd1 vccd1 sky130_fd_sc_hd__fill_1
X_05849_ FPGA_INST.cell2.SB0.route_sel\[77\] FPGA_INST.cell2.SB0.route_sel\[76\] vssd1
+ vssd1 vccd1 vccd1 _02129_ sky130_fd_sc_hd__nand2b_1
XANTENNA_fanout826_A net831 vssd1 vssd1 vccd1 vccd1 sky130_fd_sc_hd__diode_2
XFILLER_15_729 vssd1 vssd1 vccd1 vccd1 sky130_fd_sc_hd__fill_4
X_08568_ _04777_ FPGA_INST.cell3.LE_1B.dff_out FPGA_INST.cell3.LE_1B.config_data\[16\]
+ vssd1 vssd1 vccd1 vccd1 _04778_ sky130_fd_sc_hd__mux2_1
XANTENNA_wire95_X net95 vssd1 vssd1 vccd1 vccd1 sky130_fd_sc_hd__diode_2
XFILLER_23_751 vssd1 vssd1 vccd1 vccd1 sky130_fd_sc_hd__fill_4
X_08499_ _04714_ _04707_ _04703_ vssd1 vssd1 vccd1 vccd1 _04715_ sky130_fd_sc_hd__mux2_1
XANTENNA__10628__S net369 vssd1 vssd1 vccd1 vccd1 sky130_fd_sc_hd__diode_2
X_07519_ FPGA_INST.cell3.CB_1.config_dataA\[22\] FPGA_INST.cell3.CB_1.config_dataA\[23\]
+ vssd1 vssd1 vccd1 vccd1 _03775_ sky130_fd_sc_hd__nand2b_2
XFILLER_80_15 vccd1 vssd1 vccd1 vssd1 sky130_ef_sc_hd__decap_40_12
Xfanout87 net88 vssd1 vssd1 vccd1 vccd1 net87 sky130_fd_sc_hd__clkbuf_2
XANTENNA__07663__B1 FPGA_INST.bus3_1\[12\] vssd1 vssd1 vccd1 vccd1 sky130_fd_sc_hd__diode_2
X_10530_ FPGA_INST.cell2.SB0.route_sel\[102\] FPGA_INST.cell2.SB0.route_sel\[103\]
+ net247 vssd1 vssd1 vccd1 vccd1 _01409_ sky130_fd_sc_hd__mux2_1
XFILLER_10_423 vssd1 vssd1 vccd1 vccd1 sky130_fd_sc_hd__fill_1
XFILLER_13_31 vssd1 vssd1 vccd1 vccd1 sky130_fd_sc_hd__fill_2
Xfanout98 net99 vssd1 vssd1 vccd1 vccd1 net98 sky130_fd_sc_hd__clkbuf_2
X_10461_ FPGA_INST.cell2.SB0.route_sel\[33\] FPGA_INST.cell2.SB0.route_sel\[34\] net197
+ vssd1 vssd1 vccd1 vccd1 _01340_ sky130_fd_sc_hd__mux2_1
XFILLER_129_53 vssd1 vssd1 vccd1 vccd1 sky130_fd_sc_hd__fill_2
XFILLER_108_344 vssd1 vssd1 vccd1 vccd1 sky130_fd_sc_hd__fill_4
X_10392_ FPGA_INST.cell3.LE_1A.config_data\[11\] FPGA_INST.cell3.LE_1A.config_data\[10\]
+ net375 vssd1 vssd1 vccd1 vccd1 _01271_ sky130_fd_sc_hd__mux2_1
X_12131_ net936 _01477_ net720 vssd1 vssd1 vccd1 vccd1 FPGA_INST.cell3.CB_0.config_dataB\[18\]
+ sky130_fd_sc_hd__dfstp_1
X_12062_ net857 _01408_ net642 vssd1 vssd1 vccd1 vccd1 FPGA_INST.cell2.SB0.route_sel\[102\]
+ sky130_fd_sc_hd__dfstp_1
X_11013_ net876 _00363_ net659 vssd1 vssd1 vccd1 vccd1 FPGA_INST.cell2.LE_1B.reset_mode
+ sky130_fd_sc_hd__dfrtp_1
XFILLER_89_294 vssd1 vssd1 vccd1 vccd1 sky130_fd_sc_hd__fill_2
XTAP_TAPCELL_ROW_88_1519 vssd1 vccd1 sky130_fd_sc_hd__tapvpwrvgnd_1
XTAP_TAPCELL_ROW_88_1508 vssd1 vccd1 sky130_fd_sc_hd__tapvpwrvgnd_1
XFILLER_38_50 vssd1 vssd1 vccd1 vccd1 sky130_fd_sc_hd__fill_2
XFILLER_38_72 vssd1 vssd1 vccd1 vccd1 sky130_fd_sc_hd__fill_1
XFILLER_92_448 vssd1 vssd1 vccd1 vccd1 sky130_fd_sc_hd__fill_1
XFILLER_58_692 vssd1 vssd1 vccd1 vccd1 sky130_fd_sc_hd__fill_8
X_11915_ net943 _01261_ net727 vssd1 vssd1 vccd1 vccd1 FPGA_INST.cell3.LE_1A.config_data\[1\]
+ sky130_fd_sc_hd__dfrtp_1
XFILLER_45_353 vssd1 vssd1 vccd1 vccd1 sky130_fd_sc_hd__fill_4
XFILLER_45_342 vssd1 vssd1 vccd1 vccd1 sky130_fd_sc_hd__fill_4
XFILLER_73_673 vssd1 vssd1 vccd1 vccd1 sky130_fd_sc_hd__fill_1
XFILLER_72_150 vssd1 vssd1 vccd1 vccd1 sky130_fd_sc_hd__fill_4
XFILLER_45_386 vssd1 vssd1 vccd1 vccd1 sky130_fd_sc_hd__fill_4
X_11846_ net933 _01192_ net717 vssd1 vssd1 vccd1 vccd1 FPGA_INST.cell3.LEI0.config_data\[26\]
+ sky130_fd_sc_hd__dfrtp_1
X_11777_ net925 _01123_ net709 vssd1 vssd1 vccd1 vccd1 FPGA_INST.io_south_oeb\[6\]
+ sky130_fd_sc_hd__dfrtp_1
XANTENNA__10538__S net244 vssd1 vssd1 vccd1 vccd1 sky130_fd_sc_hd__diode_2
XTAP_TAPCELL_ROW_31_716 vssd1 vccd1 sky130_fd_sc_hd__tapvpwrvgnd_1
X_10728_ net872 _00078_ net656 vssd1 vssd1 vccd1 vccd1 FPGA_INST.cell2.LE_0B.config_data\[5\]
+ sky130_fd_sc_hd__dfrtp_1
XFILLER_13_272 vssd1 vssd1 vccd1 vccd1 sky130_fd_sc_hd__fill_1
XANTENNA__06457__A1 net4 vssd1 vssd1 vccd1 vccd1 sky130_fd_sc_hd__diode_2
XTAP_TAPCELL_ROW_11_440 vssd1 vccd1 sky130_fd_sc_hd__tapvpwrvgnd_1
X_10659_ net883 _00009_ net667 vssd1 vssd1 vccd1 vccd1 FPGA_INST.cell2.LEI0.config_data\[8\]
+ sky130_fd_sc_hd__dfrtp_1
XFILLER_79_90 vssd1 vssd1 vccd1 vccd1 sky130_fd_sc_hd__fill_1
XTAP_TAPCELL_ROW_110_1826 vssd1 vccd1 sky130_fd_sc_hd__tapvpwrvgnd_1
X_07870_ FPGA_INST.cell1.CB_0.config_dataA\[7\] _04095_ _04097_ vssd1 vssd1 vccd1
+ vccd1 _04098_ sky130_fd_sc_hd__or3_1
XANTENNA__07185__A2 _03447_ vssd1 vssd1 vccd1 vccd1 sky130_fd_sc_hd__diode_2
XFILLER_83_415 vccd1 vssd1 vccd1 vssd1 sky130_ef_sc_hd__decap_40_12
XANTENNA__07435__X _03693_ vssd1 vssd1 vccd1 vccd1 sky130_fd_sc_hd__diode_2
X_06821_ FPGA_INST.cell2.LE_0A.edge_mode net869 vssd1 vssd1 vccd1 vccd1 FPGA_INST.cell2.LE_0A.sel_clk
+ sky130_fd_sc_hd__xnor2_1
XTAP_TAPCELL_ROW_39_827 vssd1 vccd1 sky130_fd_sc_hd__tapvpwrvgnd_1
X_09540_ FPGA_INST.cell1.LE_0B.config_data\[13\] FPGA_INST.cell1.LE_0B.config_data\[12\]
+ net347 vssd1 vssd1 vccd1 vccd1 _00450_ sky130_fd_sc_hd__mux2_1
X_06752_ net515 _02832_ vssd1 vssd1 vccd1 vccd1 _03026_ sky130_fd_sc_hd__nand2_1
XFILLER_49_681 vssd1 vssd1 vccd1 vccd1 sky130_fd_sc_hd__fill_1
XANTENNA__08134__A1 _03932_ vssd1 vssd1 vccd1 vccd1 sky130_fd_sc_hd__diode_2
X_09471_ FPGA_INST.cell1.LEI0.config_data\[17\] FPGA_INST.cell1.LEI0.config_data\[18\]
+ net215 vssd1 vssd1 vccd1 vccd1 _00383_ sky130_fd_sc_hd__mux2_1
XFILLER_64_651 vssd1 vssd1 vccd1 vccd1 sky130_fd_sc_hd__fill_1
XFILLER_36_353 vssd1 vssd1 vccd1 vccd1 sky130_fd_sc_hd__fill_1
X_05703_ FPGA_INST.cell0.SB0.route_sel\[110\] _01624_ _01982_ vssd1 vssd1 vccd1 vccd1
+ _01983_ sky130_fd_sc_hd__o21ai_1
XTAP_TAPCELL_ROW_108_1799 vssd1 vccd1 sky130_fd_sc_hd__tapvpwrvgnd_1
XTAP_TAPCELL_ROW_108_1788 vssd1 vccd1 sky130_fd_sc_hd__tapvpwrvgnd_1
XFILLER_91_470 vssd1 vssd1 vccd1 vccd1 sky130_fd_sc_hd__fill_1
XFILLER_64_673 vssd1 vssd1 vccd1 vccd1 sky130_fd_sc_hd__fill_4
X_06683_ _02958_ _02951_ _02947_ vssd1 vssd1 vccd1 vccd1 _02959_ sky130_fd_sc_hd__mux2_1
X_08422_ FPGA_INST.cell0.LE_1B.config_data\[11\] FPGA_INST.cell0.LE_1B.config_data\[10\]
+ _04574_ vssd1 vssd1 vccd1 vccd1 _04644_ sky130_fd_sc_hd__mux2_1
XTAP_TAPCELL_ROW_19_551 vssd1 vccd1 sky130_fd_sc_hd__tapvpwrvgnd_1
XFILLER_24_504 vssd1 vssd1 vccd1 vccd1 sky130_fd_sc_hd__fill_4
X_05634_ _01911_ _01913_ vssd1 vssd1 vccd1 vccd1 _01914_ sky130_fd_sc_hd__nand2_2
XTAP_TAPCELL_ROW_121_1977 vssd1 vccd1 sky130_fd_sc_hd__tapvpwrvgnd_1
XANTENNA__09302__S net332 vssd1 vssd1 vccd1 vccd1 sky130_fd_sc_hd__diode_2
X_05565_ FPGA_INST.cell2.CB_1.config_dataB\[24\] FPGA_INST.cell2.CB_1.config_dataB\[20\]
+ FPGA_INST.cell2.CB_1.config_dataB\[21\] vssd1 vssd1 vccd1 vccd1 _01845_ sky130_fd_sc_hd__or3b_2
X_08353_ FPGA_INST.cell0.LE_1B.config_data\[5\] FPGA_INST.cell0.LE_1B.config_data\[4\]
+ _04574_ vssd1 vssd1 vccd1 vccd1 _04575_ sky130_fd_sc_hd__mux2_1
X_07304_ FPGA_INST.cell1.SB0.route_sel\[26\] FPGA_INST.cell1.SB0.route_sel\[27\] _03560_
+ _03564_ _03554_ vssd1 vssd1 vccd1 vccd1 _03565_ sky130_fd_sc_hd__a311oi_2
X_08284_ _04506_ _04507_ _04440_ vssd1 vssd1 vccd1 vccd1 _04508_ sky130_fd_sc_hd__mux2_1
X_05496_ FPGA_INST.cell3.LEI0.config_data\[41\] vssd1 vssd1 vccd1 vccd1 _01778_ sky130_fd_sc_hd__inv_2
X_07235_ _03396_ _03496_ vssd1 vssd1 vccd1 vccd1 _03497_ sky130_fd_sc_hd__nor2_1
XANTENNA__06999__A2 _01839_ vssd1 vssd1 vccd1 vccd1 sky130_fd_sc_hd__diode_2
XFILLER_20_765 vssd1 vssd1 vccd1 vccd1 sky130_fd_sc_hd__fill_1
XFILLER_118_642 vssd1 vssd1 vccd1 vccd1 sky130_fd_sc_hd__fill_2
XTAP_TAPCELL_ROW_59_1109 vssd1 vccd1 sky130_fd_sc_hd__tapvpwrvgnd_1
X_07166_ _03428_ _03429_ net78 vssd1 vssd1 vccd1 vccd1 _03430_ sky130_fd_sc_hd__o21ai_1
XANTENNA__05671__A2 _01947_ vssd1 vssd1 vccd1 vccd1 sky130_fd_sc_hd__diode_2
XFILLER_118_697 vssd1 vssd1 vccd1 vccd1 sky130_fd_sc_hd__fill_2
X_06117_ FPGA_INST.cell2.SB0.route_sel\[16\] FPGA_INST.cell2.SB0.route_sel\[17\] vssd1
+ vssd1 vccd1 vccd1 _02397_ sky130_fd_sc_hd__nand2_1
X_07097_ FPGA_INST.bus2_0\[6\] FPGA_INST.bus2_0\[7\] net427 vssd1 vssd1 vccd1 vccd1
+ _03363_ sky130_fd_sc_hd__mux2_1
XFILLER_105_369 vssd1 vssd1 vccd1 vccd1 sky130_fd_sc_hd__fill_8
XFILLER_59_49 vssd1 vssd1 vccd1 vccd1 sky130_fd_sc_hd__fill_1
X_06048_ FPGA_INST.cell2.SB0.route_sel\[45\] FPGA_INST.cell2.SB0.route_sel\[44\] vssd1
+ vssd1 vccd1 vccd1 _02328_ sky130_fd_sc_hd__nand2b_1
Xfanout211 net212 vssd1 vssd1 vccd1 vccd1 net211 sky130_fd_sc_hd__buf_2
Xfanout222 net227 vssd1 vssd1 vccd1 vccd1 net222 sky130_fd_sc_hd__clkbuf_4
Xfanout200 net201 vssd1 vssd1 vccd1 vccd1 net200 sky130_fd_sc_hd__clkbuf_4
Xfanout233 net234 vssd1 vssd1 vccd1 vccd1 net233 sky130_fd_sc_hd__buf_2
XFILLER_115_55 vssd1 vssd1 vccd1 vccd1 sky130_fd_sc_hd__fill_1
Xfanout244 net268 vssd1 vssd1 vccd1 vccd1 net244 sky130_fd_sc_hd__clkbuf_4
XFILLER_59_423 vssd1 vssd1 vccd1 vccd1 sky130_fd_sc_hd__fill_8
Xfanout255 net258 vssd1 vssd1 vccd1 vccd1 net255 sky130_fd_sc_hd__buf_2
X_09807_ FPGA_INST.cell1.LE_1B.config_data\[7\] FPGA_INST.cell1.LE_1B.config_data\[8\]
+ net218 vssd1 vssd1 vccd1 vccd1 _00716_ sky130_fd_sc_hd__mux2_1
Xfanout299 net300 vssd1 vssd1 vccd1 vccd1 net299 sky130_fd_sc_hd__clkbuf_2
X_07999_ _04226_ _04225_ _04114_ vssd1 vssd1 vccd1 vccd1 _04227_ sky130_fd_sc_hd__mux2_1
XANTENNA_fanout943_A net945 vssd1 vssd1 vccd1 vccd1 sky130_fd_sc_hd__diode_2
Xfanout277 net285 vssd1 vssd1 vccd1 vccd1 net277 sky130_fd_sc_hd__clkbuf_4
XFILLER_101_553 vssd1 vssd1 vccd1 vccd1 sky130_fd_sc_hd__fill_1
Xfanout288 net295 vssd1 vssd1 vccd1 vccd1 net288 sky130_fd_sc_hd__clkbuf_4
XFILLER_87_798 vssd1 vssd1 vccd1 vccd1 sky130_fd_sc_hd__fill_1
Xfanout266 net267 vssd1 vssd1 vccd1 vccd1 net266 sky130_fd_sc_hd__clkbuf_4
XFILLER_47_629 vssd1 vssd1 vccd1 vccd1 sky130_fd_sc_hd__fill_1
X_09738_ FPGA_INST.cell1.CB_0.config_dataA\[13\] FPGA_INST.cell1.CB_0.config_dataA\[14\]
+ net230 vssd1 vssd1 vccd1 vccd1 _00647_ sky130_fd_sc_hd__mux2_1
XFILLER_46_139 vssd1 vssd1 vccd1 vccd1 sky130_fd_sc_hd__fill_1
XANTENNA__08125__A1 _03810_ vssd1 vssd1 vccd1 vccd1 sky130_fd_sc_hd__diode_2
XFILLER_61_109 vssd1 vssd1 vccd1 vccd1 sky130_fd_sc_hd__fill_1
X_09669_ FPGA_INST.cell0.SB0.route_sel\[72\] FPGA_INST.cell0.SB0.route_sel\[73\] net185
+ vssd1 vssd1 vccd1 vccd1 _00578_ sky130_fd_sc_hd__mux2_1
XANTENNA_fanout731_X net731 vssd1 vssd1 vccd1 vccd1 sky130_fd_sc_hd__diode_2
X_11700_ net904 _01046_ net688 vssd1 vssd1 vccd1 vccd1 FPGA_INST.cell3.SB0.route_sel\[70\]
+ sky130_fd_sc_hd__dfstp_1
XTAP_TAPCELL_ROW_83_1449 vssd1 vccd1 sky130_fd_sc_hd__tapvpwrvgnd_1
XTAP_TAPCELL_ROW_83_1438 vssd1 vccd1 sky130_fd_sc_hd__tapvpwrvgnd_1
XFILLER_70_654 vssd1 vssd1 vccd1 vccd1 sky130_fd_sc_hd__fill_4
XFILLER_42_345 vssd1 vssd1 vccd1 vccd1 sky130_fd_sc_hd__fill_1
XANTENNA__10358__S net377 vssd1 vssd1 vccd1 vccd1 sky130_fd_sc_hd__diode_2
XANTENNA__07521__A FPGA_INST.cell3.CB_1.le_outA vssd1 vssd1 vccd1 vccd1 sky130_fd_sc_hd__diode_2
X_11631_ net896 _00977_ net680 vssd1 vssd1 vccd1 vccd1 FPGA_INST.cell3.SB0.route_sel\[1\]
+ sky130_fd_sc_hd__dfstp_1
XFILLER_30_529 vssd1 vssd1 vccd1 vccd1 sky130_fd_sc_hd__fill_2
X_11562_ net771 _00912_ net556 vssd1 vssd1 vccd1 vccd1 FPGA_INST.cell0.CB_0.config_dataB\[6\]
+ sky130_fd_sc_hd__dfstp_1
XANTENNA__06137__A net165 vssd1 vssd1 vccd1 vccd1 sky130_fd_sc_hd__diode_2
X_10513_ FPGA_INST.cell2.SB0.route_sel\[85\] FPGA_INST.cell2.SB0.route_sel\[86\] net251
+ vssd1 vssd1 vccd1 vccd1 _01392_ sky130_fd_sc_hd__mux2_1
XFILLER_7_758 vssd1 vssd1 vccd1 vccd1 sky130_fd_sc_hd__fill_4
X_11493_ FPGA_INST.cell0.LE_1B.sel_clk _00843_ net732 vssd1 vssd1 vccd1 vccd1 FPGA_INST.cell0.LE_1B.dff0_out
+ sky130_fd_sc_hd__dfrtp_1
X_10444_ FPGA_INST.cell2.SB0.route_sel\[16\] FPGA_INST.cell2.SB0.route_sel\[17\] net235
+ vssd1 vssd1 vccd1 vccd1 _01323_ sky130_fd_sc_hd__mux2_1
X_10375_ FPGA_INST.cell3.LE_0B.config_data\[16\] FPGA_INST.cell3.LE_0B.edge_mode net301
+ vssd1 vssd1 vccd1 vccd1 _01255_ sky130_fd_sc_hd__mux2_1
X_12114_ net917 _01460_ net701 vssd1 vssd1 vccd1 vccd1 FPGA_INST.cell3.CB_0.config_dataB\[1\]
+ sky130_fd_sc_hd__dfstp_1
XANTENNA__06611__A1 _02804_ vssd1 vssd1 vccd1 vccd1 sky130_fd_sc_hd__diode_2
XFILLER_2_430 vssd1 vssd1 vccd1 vccd1 sky130_fd_sc_hd__fill_8
XFILLER_111_317 vssd1 vssd1 vccd1 vccd1 sky130_fd_sc_hd__fill_1
XFILLER_78_721 vssd1 vssd1 vccd1 vccd1 sky130_fd_sc_hd__fill_2
XANTENNA__06611__B2 _02801_ vssd1 vssd1 vccd1 vccd1 sky130_fd_sc_hd__diode_2
X_12045_ net851 _01391_ net636 vssd1 vssd1 vccd1 vccd1 FPGA_INST.cell2.SB0.route_sel\[85\]
+ sky130_fd_sc_hd__dfstp_1
XFILLER_78_798 vssd1 vssd1 vccd1 vccd1 sky130_fd_sc_hd__fill_1
XTAP_TAPCELL_ROW_125_2033 vssd1 vccd1 sky130_fd_sc_hd__tapvpwrvgnd_1
XFILLER_92_201 vssd1 vssd1 vccd1 vccd1 sky130_fd_sc_hd__fill_1
XFILLER_1_34 vssd1 vssd1 vccd1 vccd1 sky130_fd_sc_hd__fill_2
XFILLER_93_779 vssd1 vssd1 vccd1 vccd1 sky130_fd_sc_hd__fill_4
XANTENNA__08667__A2 _04785_ vssd1 vssd1 vccd1 vccd1 sky130_fd_sc_hd__diode_2
XFILLER_46_673 vssd1 vssd1 vccd1 vccd1 sky130_fd_sc_hd__fill_2
XFILLER_45_194 vssd1 vssd1 vccd1 vccd1 sky130_fd_sc_hd__fill_2
XTAP_TAPCELL_ROW_16_510 vssd1 vccd1 sky130_fd_sc_hd__tapvpwrvgnd_1
X_11829_ net941 _01175_ net725 vssd1 vssd1 vccd1 vccd1 FPGA_INST.cell3.LEI0.config_data\[9\]
+ sky130_fd_sc_hd__dfrtp_1
X_05350_ FPGA_INST.cell3.SB0.route_sel\[91\] vssd1 vssd1 vccd1 vccd1 _01632_ sky130_fd_sc_hd__inv_2
XFILLER_61_698 vssd1 vssd1 vccd1 vccd1 sky130_fd_sc_hd__fill_1
XTAP_TAPCELL_ROW_44_896 vssd1 vccd1 sky130_fd_sc_hd__tapvpwrvgnd_1
XPHY_EDGE_ROW_112_Right_112 vssd1 vssd1 vccd1 vccd1 sky130_fd_sc_hd__decap_3
X_05281_ FPGA_INST.cell2.SB0.route_sel\[63\] vssd1 vssd1 vccd1 vccd1 _01563_ sky130_fd_sc_hd__inv_2
XANTENNA__06850__A1 FPGA_INST.bus2_0\[14\] vssd1 vssd1 vccd1 vccd1 sky130_fd_sc_hd__diode_2
X_07020_ FPGA_INST.bus2_0\[12\] FPGA_INST.bus2_0\[14\] FPGA_INST.bus2_0\[13\] FPGA_INST.bus2_0\[15\]
+ net435 net436 vssd1 vssd1 vccd1 vccd1 _03286_ sky130_fd_sc_hd__mux4_1
XANTENNA__09077__B _04819_ vssd1 vssd1 vccd1 vccd1 sky130_fd_sc_hd__diode_2
XPHY_EDGE_ROW_49_Right_49 vssd1 vssd1 vccd1 vccd1 sky130_fd_sc_hd__decap_3
XANTENNA__09792__S net327 vssd1 vssd1 vccd1 vccd1 sky130_fd_sc_hd__diode_2
XTAP_TAPCELL_ROW_54_1039 vssd1 vccd1 sky130_fd_sc_hd__tapvpwrvgnd_1
X_08971_ FPGA_INST.cell2.SB0.route_sel\[58\] FPGA_INST.cell2.SB0.route_sel\[59\] vssd1
+ vssd1 vccd1 vccd1 _05154_ sky130_fd_sc_hd__nand2b_1
X_07922_ net466 _03690_ net465 vssd1 vssd1 vccd1 vccd1 _04150_ sky130_fd_sc_hd__o21ai_1
X_07853_ net470 _03519_ _04080_ net468 vssd1 vssd1 vccd1 vccd1 _04081_ sky130_fd_sc_hd__o211a_1
XFILLER_110_372 vssd1 vssd1 vccd1 vccd1 sky130_fd_sc_hd__fill_2
XFILLER_96_584 vssd1 vssd1 vccd1 vccd1 sky130_fd_sc_hd__fill_4
XFILLER_69_798 vssd1 vssd1 vccd1 vccd1 sky130_fd_sc_hd__fill_1
X_06804_ FPGA_INST.cell2.LE_1B.config_data\[3\] FPGA_INST.cell2.LE_1B.config_data\[2\]
+ _02992_ vssd1 vssd1 vccd1 vccd1 _03078_ sky130_fd_sc_hd__mux2_1
XANTENNA__06905__A2 FPGA_INST.bus2_0\[10\] vssd1 vssd1 vccd1 vccd1 sky130_fd_sc_hd__diode_2
X_07784_ net153 _04029_ vssd1 vssd1 vccd1 vccd1 _04033_ sky130_fd_sc_hd__and2b_1
XPHY_EDGE_ROW_58_Right_58 vssd1 vssd1 vccd1 vccd1 sky130_fd_sc_hd__decap_3
XFILLER_37_651 vccd1 vssd1 vccd1 vssd1 sky130_ef_sc_hd__decap_40_12
X_09523_ FPGA_INST.cell1.LE_0A.reset_val FPGA_INST.cell1.LE_0A.reset_mode net228 vssd1
+ vssd1 vccd1 vccd1 _00434_ sky130_fd_sc_hd__mux2_1
X_06735_ _02801_ _02804_ _02793_ _02797_ net517 FPGA_INST.cell2.CB_1.config_dataB\[6\]
+ vssd1 vssd1 vccd1 vccd1 _03009_ sky130_fd_sc_hd__mux4_1
XFILLER_52_610 vssd1 vssd1 vccd1 vccd1 sky130_fd_sc_hd__fill_1
XFILLER_43_109 vssd1 vssd1 vccd1 vccd1 sky130_fd_sc_hd__fill_2
XFILLER_37_673 vccd1 vssd1 vccd1 vssd1 sky130_ef_sc_hd__decap_40_12
X_09454_ FPGA_INST.cell1.LEI0.config_data\[0\] FPGA_INST.cell1.LEI0.config_data\[1\]
+ net210 vssd1 vssd1 vccd1 vccd1 _00366_ sky130_fd_sc_hd__mux2_1
X_06666_ FPGA_INST.cell2.LEI0.config_data\[43\] _02941_ vssd1 vssd1 vccd1 vccd1 _02942_
+ sky130_fd_sc_hd__nor2_1
XANTENNA_fanout357_A net363 vssd1 vssd1 vccd1 vccd1 sky130_fd_sc_hd__diode_2
XFILLER_101_57 vccd1 vssd1 vccd1 vssd1 sky130_ef_sc_hd__decap_40_12
X_05617_ _01850_ _01896_ vssd1 vssd1 vccd1 vccd1 _01897_ sky130_fd_sc_hd__nor2_1
X_08405_ net440 _03720_ vssd1 vssd1 vccd1 vccd1 _04627_ sky130_fd_sc_hd__nand2_1
X_09385_ FPGA_INST.cell2.CB_0.config_dataB\[3\] FPGA_INST.cell2.CB_0.config_dataB\[4\]
+ net252 vssd1 vssd1 vccd1 vccd1 _00298_ sky130_fd_sc_hd__mux2_1
XANTENNA_fanout524_A net525 vssd1 vssd1 vccd1 vccd1 sky130_fd_sc_hd__diode_2
XANTENNA_fanout145_X net145 vssd1 vssd1 vccd1 vccd1 sky130_fd_sc_hd__diode_2
X_08336_ _04549_ _04552_ _04555_ _04557_ vssd1 vssd1 vccd1 vccd1 _04558_ sky130_fd_sc_hd__a22o_1
XFILLER_61_28 vssd1 vssd1 vccd1 vccd1 sky130_fd_sc_hd__fill_1
XANTENNA__08156__B _04040_ vssd1 vssd1 vccd1 vccd1 sky130_fd_sc_hd__diode_2
X_06597_ _02864_ _02865_ _02872_ vssd1 vssd1 vccd1 vccd1 _02873_ sky130_fd_sc_hd__o21ba_1
X_05548_ net113 _01825_ _01826_ vssd1 vssd1 vccd1 vccd1 _01828_ sky130_fd_sc_hd__nor3_1
X_08267_ _04488_ _04490_ _01755_ vssd1 vssd1 vccd1 vccd1 _04491_ sky130_fd_sc_hd__mux2_1
X_05479_ FPGA_INST.cell0.LE_1B.config_data\[16\] vssd1 vssd1 vccd1 vccd1 _01761_ sky130_fd_sc_hd__inv_2
XPHY_EDGE_ROW_67_Right_67 vssd1 vssd1 vccd1 vccd1 sky130_fd_sc_hd__decap_3
X_07218_ FPGA_INST.cell3.SB0.route_sel\[14\] FPGA_INST.cell3.SB0.route_sel\[15\] _03478_
+ _03480_ vssd1 vssd1 vccd1 vccd1 _03481_ sky130_fd_sc_hd__a211o_1
X_08198_ FPGA_INST.cell0.CB_1.config_dataA\[8\] _04421_ vssd1 vssd1 vccd1 vccd1 _04422_
+ sky130_fd_sc_hd__nor2_1
XANTENNA__08043__A0 FPGA_INST.bus3_1\[0\] vssd1 vssd1 vccd1 vccd1 sky130_fd_sc_hd__diode_2
X_07149_ net150 net141 _03412_ vssd1 vssd1 vccd1 vccd1 _03413_ sky130_fd_sc_hd__mux2_1
XANTENNA_fanout893_A net899 vssd1 vssd1 vccd1 vccd1 sky130_fd_sc_hd__diode_2
XFILLER_105_111 vssd1 vssd1 vccd1 vccd1 sky130_fd_sc_hd__fill_1
XPHY_EDGE_ROW_5_Left_136 vssd1 vssd1 vccd1 vccd1 sky130_fd_sc_hd__decap_3
X_10160_ FPGA_INST.cell3.SB0.route_sel\[64\] FPGA_INST.cell3.SB0.route_sel\[65\] net276
+ vssd1 vssd1 vccd1 vccd1 _01041_ sky130_fd_sc_hd__mux2_1
XFILLER_121_637 vccd1 vssd1 vccd1 vssd1 sky130_ef_sc_hd__decap_40_12
X_10091_ FPGA_INST.cell0.LE_1B.config_data\[15\] FPGA_INST.cell0.LE_1B.config_data\[16\]
+ net172 vssd1 vssd1 vccd1 vccd1 _00972_ sky130_fd_sc_hd__mux2_1
XFILLER_75_713 vccd1 vssd1 vccd1 vssd1 sky130_ef_sc_hd__decap_40_12
XFILLER_59_264 vssd1 vssd1 vccd1 vccd1 sky130_fd_sc_hd__fill_4
XANTENNA__06357__A0 net7 vssd1 vssd1 vccd1 vccd1 sky130_fd_sc_hd__diode_2
XANTENNA_fanout946_X net946 vssd1 vssd1 vccd1 vccd1 sky130_fd_sc_hd__diode_2
XPHY_EDGE_ROW_76_Right_76 vssd1 vssd1 vccd1 vccd1 sky130_fd_sc_hd__decap_3
XFILLER_19_128 vssd1 vssd1 vccd1 vccd1 sky130_fd_sc_hd__fill_8
XANTENNA__06372__A3 net103 vssd1 vssd1 vccd1 vccd1 sky130_fd_sc_hd__diode_2
X_10993_ net859 _00343_ net645 vssd1 vssd1 vccd1 vccd1 FPGA_INST.cell2.CB_1.config_dataA\[24\]
+ sky130_fd_sc_hd__dfstp_1
XFILLER_15_312 vssd1 vssd1 vccd1 vccd1 sky130_fd_sc_hd__fill_1
XANTENNA__07321__A2 _03581_ vssd1 vssd1 vccd1 vccd1 sky130_fd_sc_hd__diode_2
XFILLER_42_197 vssd1 vssd1 vccd1 vccd1 sky130_fd_sc_hd__fill_2
XANTENNA__09877__S net319 vssd1 vssd1 vccd1 vccd1 sky130_fd_sc_hd__diode_2
XTAP_TAPCELL_ROW_41_855 vssd1 vccd1 sky130_fd_sc_hd__tapvpwrvgnd_1
X_11614_ net741 _00964_ net526 vssd1 vssd1 vccd1 vccd1 FPGA_INST.cell0.LE_1B.config_data\[8\]
+ sky130_fd_sc_hd__dfrtp_1
XFILLER_129_737 vssd1 vssd1 vccd1 vccd1 sky130_fd_sc_hd__fill_8
XPHY_EDGE_ROW_85_Right_85 vssd1 vssd1 vccd1 vccd1 sky130_fd_sc_hd__decap_3
X_11545_ net772 _00895_ net557 vssd1 vssd1 vccd1 vccd1 FPGA_INST.cell0.CB_0.config_dataA\[14\]
+ sky130_fd_sc_hd__dfstp_1
XTAP_TAPCELL_ROW_96_1629 vssd1 vccd1 sky130_fd_sc_hd__tapvpwrvgnd_1
X_11476_ net745 _00826_ net530 vssd1 vssd1 vccd1 vccd1 FPGA_INST.cell0.LE_1A.config_data\[3\]
+ sky130_fd_sc_hd__dfrtp_1
XANTENNA__08034__A0 net152 vssd1 vssd1 vccd1 vccd1 sky130_fd_sc_hd__diode_2
X_10427_ FPGA_INST.cell2.SB0.route_sel\[0\] FPGA_INST.cell2.CB_1.config_dataB\[24\]
+ net353 vssd1 vssd1 vccd1 vccd1 _01306_ sky130_fd_sc_hd__mux2_1
XANTENNA__05993__X _02273_ vssd1 vssd1 vccd1 vccd1 sky130_fd_sc_hd__diode_2
XFILLER_124_486 vssd1 vssd1 vccd1 vccd1 sky130_fd_sc_hd__fill_4
X_10358_ FPGA_INST.cell3.LE_0B.config_data\[0\] FPGA_INST.cell3.LE_1B.reset_mode net377
+ vssd1 vssd1 vccd1 vccd1 _01238_ sky130_fd_sc_hd__mux2_1
X_10289_ FPGA_INST.cell3.LEI0.config_data\[3\] FPGA_INST.cell3.LEI0.config_data\[4\]
+ net298 vssd1 vssd1 vccd1 vccd1 _01170_ sky130_fd_sc_hd__mux2_1
XFILLER_112_637 vssd1 vssd1 vccd1 vccd1 sky130_fd_sc_hd__fill_4
XFILLER_97_326 vssd1 vssd1 vccd1 vccd1 sky130_fd_sc_hd__fill_1
XANTENNA__10551__S net354 vssd1 vssd1 vccd1 vccd1 sky130_fd_sc_hd__diode_2
XFILLER_3_794 vssd1 vssd1 vccd1 vccd1 sky130_fd_sc_hd__fill_1
XFILLER_3_783 vssd1 vssd1 vccd1 vccd1 sky130_fd_sc_hd__fill_1
XPHY_EDGE_ROW_94_Right_94 vssd1 vssd1 vccd1 vccd1 sky130_fd_sc_hd__decap_3
X_12028_ net858 _01374_ net643 vssd1 vssd1 vccd1 vccd1 FPGA_INST.cell2.SB0.route_sel\[68\]
+ sky130_fd_sc_hd__dfstp_1
XFILLER_66_757 vssd1 vssd1 vccd1 vccd1 sky130_fd_sc_hd__fill_1
XTAP_TAPCELL_ROW_49_966 vssd1 vccd1 sky130_fd_sc_hd__tapvpwrvgnd_1
XFILLER_81_727 vssd1 vssd1 vccd1 vccd1 sky130_fd_sc_hd__fill_1
XFILLER_65_267 vssd1 vssd1 vccd1 vccd1 sky130_fd_sc_hd__fill_8
XFILLER_25_109 vssd1 vssd1 vccd1 vccd1 sky130_fd_sc_hd__fill_2
XTAP_TAPCELL_ROW_105_1747 vssd1 vccd1 sky130_fd_sc_hd__tapvpwrvgnd_1
XFILLER_46_481 vssd1 vssd1 vccd1 vccd1 sky130_fd_sc_hd__fill_2
X_06520_ net238 _02206_ _02213_ _02795_ vssd1 vssd1 vccd1 vccd1 _02796_ sky130_fd_sc_hd__and4_4
XTAP_TAPCELL_ROW_29_690 vssd1 vccd1 sky130_fd_sc_hd__tapvpwrvgnd_1
XTAP_TAPCELL_ROW_105_1758 vssd1 vccd1 sky130_fd_sc_hd__tapvpwrvgnd_1
X_06451_ net487 net489 vssd1 vssd1 vccd1 vccd1 _02729_ sky130_fd_sc_hd__nor2_2
X_05402_ FPGA_INST.cell1.SB0.route_sel\[45\] vssd1 vssd1 vccd1 vccd1 _01684_ sky130_fd_sc_hd__inv_2
XFILLER_33_164 vssd1 vssd1 vccd1 vccd1 sky130_fd_sc_hd__fill_1
X_06382_ net497 _02255_ _02659_ net496 vssd1 vssd1 vccd1 vccd1 _02660_ sky130_fd_sc_hd__o211a_1
X_09170_ FPGA_INST.cell2.LE_0B.config_data\[11\] FPGA_INST.cell2.LE_0B.config_data\[10\]
+ net358 vssd1 vssd1 vccd1 vccd1 _00084_ sky130_fd_sc_hd__mux2_1
X_08121_ _03613_ _04337_ _04345_ _04346_ vssd1 vssd1 vccd1 vccd1 _04347_ sky130_fd_sc_hd__a211o_1
X_05333_ FPGA_INST.cell3.SB0.route_sel\[105\] vssd1 vssd1 vccd1 vccd1 _01615_ sky130_fd_sc_hd__inv_2
XANTENNA__07076__A1 FPGA_INST.bus2_0\[9\] vssd1 vssd1 vccd1 vccd1 sky130_fd_sc_hd__diode_2
X_08052_ net461 _03889_ vssd1 vssd1 vccd1 vccd1 _04278_ sky130_fd_sc_hd__nand2_1
X_05264_ FPGA_INST.cell2.LE_0B.config_data\[16\] vssd1 vssd1 vccd1 vccd1 _01546_ sky130_fd_sc_hd__inv_2
XANTENNA__08025__A0 FPGA_INST.bus3_1\[8\] vssd1 vssd1 vccd1 vccd1 sky130_fd_sc_hd__diode_2
X_07003_ net433 _02030_ _03268_ net432 vssd1 vssd1 vccd1 vccd1 _03269_ sky130_fd_sc_hd__o211a_1
XANTENNA__09773__A0 FPGA_INST.cell1.CB_0.config_dataB\[24\] vssd1 vssd1 vccd1 vccd1
+ sky130_fd_sc_hd__diode_2
XANTENNA__06224__B _02413_ vssd1 vssd1 vccd1 vccd1 sky130_fd_sc_hd__diode_2
XFILLER_115_497 vssd1 vssd1 vccd1 vccd1 sky130_fd_sc_hd__fill_4
XFILLER_103_637 vssd1 vssd1 vccd1 vccd1 sky130_fd_sc_hd__fill_1
XANTENNA__06051__A2 _02293_ vssd1 vssd1 vccd1 vccd1 sky130_fd_sc_hd__diode_2
X_08954_ _01569_ FPGA_INST.cell2.SB0.route_sel\[73\] FPGA_INST.cell2.SB0.route_sel\[78\]
+ FPGA_INST.cell2.SB0.route_sel\[79\] _05142_ vssd1 vssd1 vccd1 vccd1 _05143_ sky130_fd_sc_hd__o221a_1
X_07905_ _03810_ _04118_ _04132_ vssd1 vssd1 vccd1 vccd1 _04133_ sky130_fd_sc_hd__o21ai_1
XANTENNA__08328__A1 FPGA_INST.bus1_0\[15\] vssd1 vssd1 vccd1 vccd1 sky130_fd_sc_hd__diode_2
X_08885_ net386 _04804_ _05091_ FPGA_INST.cell3.CB_0.config_dataB\[16\] vssd1 vssd1
+ vccd1 vccd1 _05092_ sky130_fd_sc_hd__o211a_1
XANTENNA__07000__A1 _01937_ vssd1 vssd1 vccd1 vccd1 sky130_fd_sc_hd__diode_2
XFILLER_29_415 vssd1 vssd1 vccd1 vccd1 sky130_fd_sc_hd__fill_2
XFILLER_56_245 vssd1 vssd1 vccd1 vccd1 sky130_fd_sc_hd__fill_1
X_07836_ net136 _04071_ _02210_ vssd1 vssd1 vccd1 vccd1 net51 sky130_fd_sc_hd__mux2_1
XANTENNA__07000__B2 _01984_ vssd1 vssd1 vccd1 vccd1 sky130_fd_sc_hd__diode_2
XFILLER_84_587 vssd1 vssd1 vccd1 vccd1 sky130_fd_sc_hd__fill_1
X_07767_ _03988_ _03990_ _04016_ _03985_ vssd1 vssd1 vccd1 vccd1 _04017_ sky130_fd_sc_hd__a211o_1
XTAP_TAPCELL_ROW_67_1219 vssd1 vccd1 sky130_fd_sc_hd__tapvpwrvgnd_1
XANTENNA_fanout641_A net647 vssd1 vssd1 vccd1 vccd1 sky130_fd_sc_hd__diode_2
XFILLER_44_418 vssd1 vssd1 vccd1 vccd1 sky130_fd_sc_hd__fill_2
X_09506_ FPGA_INST.cell1.LE_0A.config_data\[1\] FPGA_INST.cell1.LE_0A.config_data\[2\]
+ net229 vssd1 vssd1 vccd1 vccd1 _00417_ sky130_fd_sc_hd__mux2_1
XFILLER_112_67 vssd1 vssd1 vccd1 vccd1 sky130_fd_sc_hd__fill_8
X_06718_ FPGA_INST.cell2.CB_1.config_dataB\[4\] _02974_ _02985_ _02991_ vssd1 vssd1
+ vccd1 vccd1 _02992_ sky130_fd_sc_hd__o31a_4
XTAP_TAPCELL_ROW_80_1408 vssd1 vccd1 sky130_fd_sc_hd__tapvpwrvgnd_1
XFILLER_72_27 vssd1 vssd1 vccd1 vccd1 sky130_fd_sc_hd__fill_1
X_07698_ _01847_ _01991_ _02823_ vssd1 vssd1 vccd1 vccd1 _03949_ sky130_fd_sc_hd__o21a_1
X_09437_ FPGA_INST.cell2.LE_1B.config_data\[5\] FPGA_INST.cell2.LE_1B.config_data\[6\]
+ net290 vssd1 vssd1 vccd1 vccd1 _00350_ sky130_fd_sc_hd__mux2_1
X_06649_ net475 _02810_ _02924_ net474 vssd1 vssd1 vccd1 vccd1 _02925_ sky130_fd_sc_hd__o211a_1
XANTENNA__09697__S net196 vssd1 vssd1 vccd1 vccd1 sky130_fd_sc_hd__diode_2
X_09368_ FPGA_INST.cell2.CB_0.config_dataA\[12\] net502 net350 vssd1 vssd1 vccd1 vccd1
+ _00281_ sky130_fd_sc_hd__mux2_1
X_09299_ FPGA_INST.cell1.SB0.route_sel\[71\] FPGA_INST.cell1.SB0.route_sel\[70\] net331
+ vssd1 vssd1 vccd1 vccd1 _00212_ sky130_fd_sc_hd__mux2_1
XANTENNA__08264__A0 net75 vssd1 vssd1 vccd1 vccd1 sky130_fd_sc_hd__diode_2
X_08319_ FPGA_INST.cell0.CB_1.config_dataB\[8\] FPGA_INST.cell0.CB_1.config_dataB\[7\]
+ FPGA_INST.cell0.CB_1.config_dataB\[9\] _04517_ vssd1 vssd1 vccd1 vccd1 _04541_ sky130_fd_sc_hd__or4bb_1
XANTENNA__08614__B _04821_ vssd1 vssd1 vccd1 vccd1 sky130_fd_sc_hd__diode_2
X_11330_ net830 _00680_ net614 vssd1 vssd1 vccd1 vccd1 FPGA_INST.cell1.CB_0.config_dataB\[22\]
+ sky130_fd_sc_hd__dfstp_2
XFILLER_115_3 vccd1 vssd1 vccd1 vssd1 sky130_ef_sc_hd__decap_40_12
XFILLER_4_503 vssd1 vssd1 vccd1 vccd1 sky130_fd_sc_hd__fill_2
X_11261_ net784 _00611_ net569 vssd1 vssd1 vccd1 vccd1 FPGA_INST.cell0.SB0.route_sel\[106\]
+ sky130_fd_sc_hd__dfstp_1
XFILLER_106_475 vssd1 vssd1 vccd1 vccd1 sky130_fd_sc_hd__fill_1
X_10212_ FPGA_INST.cell3.SB0.route_sel\[117\] FPGA_INST.cell3.SB0.route_sel\[116\]
+ net364 vssd1 vssd1 vccd1 vccd1 _01093_ sky130_fd_sc_hd__mux2_1
X_11192_ net765 _00542_ net550 vssd1 vssd1 vccd1 vccd1 FPGA_INST.cell0.SB0.route_sel\[37\]
+ sky130_fd_sc_hd__dfstp_1
X_10143_ FPGA_INST.cell3.SB0.route_sel\[48\] FPGA_INST.cell3.SB0.route_sel\[47\] net369
+ vssd1 vssd1 vccd1 vccd1 _01024_ sky130_fd_sc_hd__mux2_1
XFILLER_97_79 vssd1 vssd1 vccd1 vccd1 sky130_fd_sc_hd__fill_8
XTAP_TAPCELL_ROW_91_1559 vssd1 vccd1 sky130_fd_sc_hd__tapvpwrvgnd_1
XTAP_TAPCELL_ROW_7_374 vssd1 vccd1 sky130_fd_sc_hd__tapvpwrvgnd_1
XANTENNA__10126__A1 FPGA_INST.cell3.SB0.route_sel\[31\] vssd1 vssd1 vccd1 vccd1 sky130_fd_sc_hd__diode_2
XFILLER_75_521 vssd1 vssd1 vccd1 vccd1 sky130_fd_sc_hd__fill_2
X_10074_ FPGA_INST.cell0.CB_1.config_dataA\[24\] FPGA_INST.cell0.CB_1.config_dataA\[23\]
+ net328 vssd1 vssd1 vccd1 vccd1 _00955_ sky130_fd_sc_hd__mux2_1
XTAP_TAPCELL_ROW_7_385 vssd1 vccd1 sky130_fd_sc_hd__tapvpwrvgnd_1
XFILLER_47_223 vssd1 vssd1 vccd1 vccd1 sky130_fd_sc_hd__fill_1
XFILLER_63_738 vssd1 vssd1 vccd1 vccd1 sky130_fd_sc_hd__fill_8
XTAP_TAPCELL_ROW_46_925 vssd1 vccd1 sky130_fd_sc_hd__tapvpwrvgnd_1
XFILLER_16_621 vssd1 vssd1 vccd1 vccd1 sky130_fd_sc_hd__fill_2
XFILLER_16_643 vssd1 vssd1 vccd1 vccd1 sky130_fd_sc_hd__fill_1
X_10976_ net881 _00326_ net666 vssd1 vssd1 vccd1 vccd1 FPGA_INST.cell2.CB_1.config_dataA\[7\]
+ sky130_fd_sc_hd__dfstp_2
XANTENNA__06149__X _02429_ vssd1 vssd1 vccd1 vccd1 sky130_fd_sc_hd__diode_2
XFILLER_43_473 vssd1 vssd1 vccd1 vccd1 sky130_fd_sc_hd__fill_1
XFILLER_87_7 vssd1 vssd1 vccd1 vccd1 sky130_fd_sc_hd__fill_1
XFILLER_31_668 vssd1 vssd1 vccd1 vccd1 sky130_fd_sc_hd__fill_4
XTAP_TAPCELL_ROW_100_1677 vssd1 vccd1 sky130_fd_sc_hd__tapvpwrvgnd_1
XANTENNA__08255__A0 _03923_ vssd1 vssd1 vccd1 vccd1 sky130_fd_sc_hd__diode_2
XANTENNA__07058__A1 FPGA_INST.bus2_0\[3\] vssd1 vssd1 vccd1 vccd1 sky130_fd_sc_hd__diode_2
XTAP_TAPCELL_ROW_100_1688 vssd1 vccd1 sky130_fd_sc_hd__tapvpwrvgnd_1
XANTENNA__06805__A1 FPGA_INST.cell2.LE_1B.config_data\[0\] vssd1 vssd1 vccd1 vccd1
+ sky130_fd_sc_hd__diode_2
X_11528_ net809 _00878_ net595 vssd1 vssd1 vccd1 vccd1 FPGA_INST.config_bits\[9\]
+ sky130_fd_sc_hd__dfstp_1
XFILLER_117_729 vssd1 vssd1 vccd1 vccd1 sky130_fd_sc_hd__fill_4
XFILLER_7_77 vssd1 vssd1 vccd1 vccd1 sky130_fd_sc_hd__fill_2
X_11459_ net751 _00809_ net536 vssd1 vssd1 vccd1 vccd1 FPGA_INST.cell0.LE_0B.config_data\[8\]
+ sky130_fd_sc_hd__dfrtp_1
XANTENNA__08022__A3 _03769_ vssd1 vssd1 vccd1 vccd1 sky130_fd_sc_hd__diode_2
XFILLER_112_456 vssd1 vssd1 vccd1 vccd1 sky130_fd_sc_hd__fill_1
XANTENNA__11674__Q FPGA_INST.cell3.SB0.route_sel\[44\] vssd1 vssd1 vccd1 vccd1 sky130_fd_sc_hd__diode_2
X_05951_ FPGA_INST.cell0.SB0.route_sel\[51\] FPGA_INST.cell0.SB0.route_sel\[50\] vssd1
+ vssd1 vccd1 vccd1 _02231_ sky130_fd_sc_hd__nor2_1
X_08670_ net399 _04804_ net398 vssd1 vssd1 vccd1 vccd1 _04879_ sky130_fd_sc_hd__o21ai_1
XPHY_EDGE_ROW_77_Left_208 vssd1 vssd1 vccd1 vccd1 sky130_fd_sc_hd__decap_3
X_05882_ _02158_ _02159_ _02160_ FPGA_INST.cell2.SB0.route_sel\[65\] FPGA_INST.cell2.SB0.route_sel\[64\]
+ vssd1 vssd1 vccd1 vccd1 _02162_ sky130_fd_sc_hd__a32o_1
XFILLER_39_768 vssd1 vssd1 vccd1 vccd1 sky130_fd_sc_hd__fill_1
XANTENNA__05544__A1 net383 vssd1 vssd1 vccd1 vccd1 sky130_fd_sc_hd__diode_2
X_07621_ FPGA_INST.cell0.SB0.route_sel\[88\] _01637_ FPGA_INST.cell0.SB0.route_sel\[92\]
+ FPGA_INST.cell0.SB0.route_sel\[93\] _03873_ vssd1 vssd1 vccd1 vccd1 _03874_ sky130_fd_sc_hd__o221a_1
X_07552_ _03802_ _03806_ net330 vssd1 vssd1 vccd1 vccd1 _03807_ sky130_fd_sc_hd__a21oi_1
XFILLER_53_248 vssd1 vssd1 vccd1 vccd1 sky130_fd_sc_hd__fill_1
XFILLER_19_492 vssd1 vssd1 vccd1 vccd1 sky130_fd_sc_hd__fill_2
X_06503_ _01550_ FPGA_INST.cell2.SB0.route_sel\[9\] FPGA_INST.cell2.SB0.route_sel\[14\]
+ _01551_ _02778_ vssd1 vssd1 vccd1 vccd1 _02779_ sky130_fd_sc_hd__a221o_1
X_07483_ FPGA_INST.cell3.SB0.route_sel\[56\] FPGA_INST.cell3.SB0.route_sel\[57\] _03739_
+ vssd1 vssd1 vccd1 vccd1 _03740_ sky130_fd_sc_hd__a21oi_1
XTAP_TAPCELL_ROW_24_619 vssd1 vccd1 sky130_fd_sc_hd__tapvpwrvgnd_1
XFILLER_34_484 vssd1 vssd1 vccd1 vccd1 sky130_fd_sc_hd__fill_1
X_09222_ FPGA_INST.cell2.CB_1.config_dataB\[18\] FPGA_INST.cell2.CB_1.config_dataB\[19\]
+ net287 vssd1 vssd1 vccd1 vccd1 _00135_ sky130_fd_sc_hd__mux2_1
XTAP_TAPCELL_ROW_62_1149 vssd1 vccd1 sky130_fd_sc_hd__tapvpwrvgnd_1
XFILLER_61_292 vssd1 vssd1 vccd1 vccd1 sky130_fd_sc_hd__fill_1
X_06434_ FPGA_INST.cell2.CB_0.config_dataB\[13\] FPGA_INST.cell2.CB_0.config_dataB\[12\]
+ vssd1 vssd1 vccd1 vccd1 _02712_ sky130_fd_sc_hd__or2_1
XPHY_EDGE_ROW_86_Left_217 vssd1 vssd1 vccd1 vccd1 sky130_fd_sc_hd__decap_3
X_09153_ FPGA_INST.cell2.LE_0A.config_data\[16\] FPGA_INST.cell2.LE_0A.edge_mode net255
+ vssd1 vssd1 vccd1 vccd1 _00068_ sky130_fd_sc_hd__mux2_1
X_06365_ net494 _02056_ _02642_ net493 vssd1 vssd1 vccd1 vccd1 _02643_ sky130_fd_sc_hd__o211a_1
X_08104_ _04326_ _04327_ _04329_ vssd1 vssd1 vccd1 vccd1 _04330_ sky130_fd_sc_hd__and3_1
XANTENNA_fanout222_A net227 vssd1 vssd1 vccd1 vccd1 sky130_fd_sc_hd__diode_2
X_05316_ FPGA_INST.cell2.CB_1.config_dataB\[17\] vssd1 vssd1 vccd1 vccd1 _01598_ sky130_fd_sc_hd__inv_2
XTAP_TAPCELL_ROW_118_1938 vssd1 vccd1 sky130_fd_sc_hd__tapvpwrvgnd_1
X_09084_ FPGA_INST.cell2.LE_0A.dff1_out net524 _05209_ vssd1 vssd1 vccd1 vccd1 _00000_
+ sky130_fd_sc_hd__a21bo_1
X_06296_ net9 net10 net11 net13 net500 net499 vssd1 vssd1 vccd1 vccd1 _02576_ sky130_fd_sc_hd__mux4_1
X_05247_ FPGA_INST.config_en_q vssd1 vssd1 vccd1 vccd1 _01529_ sky130_fd_sc_hd__inv_2
X_08035_ FPGA_INST.cell1.LEI0.config_data\[17\] _04260_ vssd1 vssd1 vccd1 vccd1 _04261_
+ sky130_fd_sc_hd__nand2b_1
XANTENNA__06272__A2 _02413_ vssd1 vssd1 vccd1 vccd1 sky130_fd_sc_hd__diode_2
XANTENNA__08013__A3 FPGA_INST.bus3_1\[7\] vssd1 vssd1 vccd1 vccd1 sky130_fd_sc_hd__diode_2
XANTENNA_fanout591_A net596 vssd1 vssd1 vccd1 vccd1 sky130_fd_sc_hd__diode_2
XFILLER_130_253 vssd1 vssd1 vccd1 vccd1 sky130_fd_sc_hd__fill_1
X_09986_ FPGA_INST.config_bits\[7\] _05233_ _05235_ _05232_ vssd1 vssd1 vccd1 vccd1
+ _00876_ sky130_fd_sc_hd__a22o_1
XFILLER_88_145 vssd1 vssd1 vccd1 vccd1 sky130_fd_sc_hd__fill_1
XFILLER_76_307 vssd1 vssd1 vccd1 vccd1 sky130_fd_sc_hd__fill_1
XFILLER_130_275 vssd1 vssd1 vccd1 vccd1 sky130_fd_sc_hd__fill_1
XPHY_EDGE_ROW_95_Left_226 vssd1 vssd1 vccd1 vccd1 sky130_fd_sc_hd__decap_3
XANTENNA_fanout856_A net862 vssd1 vssd1 vccd1 vccd1 sky130_fd_sc_hd__diode_2
XFILLER_57_521 vssd1 vssd1 vccd1 vccd1 sky130_fd_sc_hd__fill_2
XTAP_TAPCELL_ROW_4_333 vssd1 vccd1 sky130_fd_sc_hd__tapvpwrvgnd_1
X_08937_ _02089_ _05131_ vssd1 vssd1 vccd1 vccd1 FPGA_INST.bus2_0\[11\] sky130_fd_sc_hd__and2_2
X_08868_ _04828_ _05073_ _05074_ _04831_ vssd1 vssd1 vccd1 vccd1 _05075_ sky130_fd_sc_hd__a2bb2o_1
XFILLER_57_543 vssd1 vssd1 vccd1 vccd1 sky130_fd_sc_hd__fill_8
XTAP_TAPCELL_ROW_4_344 vssd1 vccd1 sky130_fd_sc_hd__tapvpwrvgnd_1
XFILLER_29_223 vssd1 vssd1 vccd1 vccd1 sky130_fd_sc_hd__fill_1
XANTENNA__08721__B2 _04831_ vssd1 vssd1 vccd1 vccd1 sky130_fd_sc_hd__diode_2
XANTENNA__07353__X _03613_ vssd1 vssd1 vccd1 vccd1 sky130_fd_sc_hd__diode_2
XFILLER_83_15 vccd1 vssd1 vccd1 vssd1 sky130_ef_sc_hd__decap_40_12
XFILLER_45_727 vssd1 vssd1 vccd1 vccd1 sky130_fd_sc_hd__fill_1
X_07819_ _01906_ _01907_ _04062_ _01908_ vssd1 vssd1 vccd1 vccd1 net59 sky130_fd_sc_hd__a31o_1
X_08799_ net392 _01775_ vssd1 vssd1 vccd1 vccd1 _05006_ sky130_fd_sc_hd__nand2_1
X_10830_ net797 _00180_ net582 vssd1 vssd1 vccd1 vccd1 FPGA_INST.cell1.SB0.route_sel\[39\]
+ sky130_fd_sc_hd__dfstp_1
XFILLER_16_42 vssd1 vssd1 vccd1 vccd1 sky130_fd_sc_hd__fill_2
XANTENNA_fanout811_X net811 vssd1 vssd1 vccd1 vccd1 sky130_fd_sc_hd__diode_2
X_10761_ net886 _00111_ net670 vssd1 vssd1 vccd1 vccd1 FPGA_INST.cell2.LE_1A.config_data\[16\]
+ sky130_fd_sc_hd__dfrtp_1
XFILLER_13_624 vssd1 vssd1 vccd1 vccd1 sky130_fd_sc_hd__fill_1
X_10692_ net866 _00042_ net653 vssd1 vssd1 vccd1 vccd1 FPGA_INST.cell2.LEI0.config_data\[41\]
+ sky130_fd_sc_hd__dfrtp_1
XFILLER_40_443 vssd1 vssd1 vccd1 vccd1 sky130_fd_sc_hd__fill_1
XANTENNA__08237__A0 FPGA_INST.bus1_0\[10\] vssd1 vssd1 vccd1 vccd1 sky130_fd_sc_hd__diode_2
XFILLER_8_105 vccd1 vssd1 vccd1 vssd1 sky130_ef_sc_hd__decap_40_12
XTAP_TAPCELL_ROW_51_994 vssd1 vccd1 sky130_fd_sc_hd__tapvpwrvgnd_1
X_11313_ net905 _00663_ net689 vssd1 vssd1 vccd1 vccd1 FPGA_INST.cell1.CB_0.config_dataB\[5\]
+ sky130_fd_sc_hd__dfstp_1
XFILLER_4_311 vssd1 vssd1 vccd1 vccd1 sky130_fd_sc_hd__fill_2
X_11244_ net768 _00594_ net553 vssd1 vssd1 vccd1 vccd1 FPGA_INST.cell0.SB0.route_sel\[89\]
+ sky130_fd_sc_hd__dfstp_1
XFILLER_4_399 vccd1 vssd1 vccd1 vssd1 sky130_ef_sc_hd__decap_40_12
X_11175_ net785 _00525_ net570 vssd1 vssd1 vccd1 vccd1 FPGA_INST.cell0.SB0.route_sel\[20\]
+ sky130_fd_sc_hd__dfstp_1
X_10126_ FPGA_INST.cell3.SB0.route_sel\[30\] FPGA_INST.cell3.SB0.route_sel\[31\] net272
+ vssd1 vssd1 vccd1 vccd1 _01007_ sky130_fd_sc_hd__mux2_1
X_10057_ FPGA_INST.cell0.CB_1.config_dataA\[7\] net408 net312 vssd1 vssd1 vccd1 vccd1
+ _00938_ sky130_fd_sc_hd__mux2_1
XFILLER_48_543 vssd1 vssd1 vccd1 vccd1 sky130_fd_sc_hd__fill_1
XANTENNA__07515__A2 FPGA_INST.cell3.SB0.route_sel\[68\] vssd1 vssd1 vccd1 vccd1 sky130_fd_sc_hd__diode_2
XFILLER_36_705 vssd1 vssd1 vccd1 vccd1 sky130_fd_sc_hd__fill_1
XTAP_TAPCELL_ROW_102_1717 vssd1 vccd1 sky130_fd_sc_hd__tapvpwrvgnd_1
XTAP_TAPCELL_ROW_102_1706 vssd1 vccd1 sky130_fd_sc_hd__tapvpwrvgnd_1
XFILLER_16_462 vssd1 vssd1 vccd1 vccd1 sky130_fd_sc_hd__fill_2
XFILLER_16_473 vssd1 vssd1 vccd1 vccd1 sky130_fd_sc_hd__fill_2
X_10959_ net867 _00309_ net651 vssd1 vssd1 vccd1 vccd1 FPGA_INST.cell2.CB_0.config_dataB\[15\]
+ sky130_fd_sc_hd__dfstp_1
XFILLER_78_3 vccd1 vssd1 vccd1 vssd1 sky130_ef_sc_hd__decap_40_12
X_06150_ _01970_ _02334_ _02425_ _02428_ vssd1 vssd1 vccd1 vccd1 _02430_ sky130_fd_sc_hd__a2bb2o_1
XFILLER_117_559 vssd1 vssd1 vccd1 vccd1 sky130_fd_sc_hd__fill_1
XANTENNA__07451__A1 net81 vssd1 vssd1 vccd1 vccd1 sky130_fd_sc_hd__diode_2
X_06081_ net100 _01893_ _02356_ vssd1 vssd1 vccd1 vccd1 _02361_ sky130_fd_sc_hd__and3_1
XANTENNA__06342__X FPGA_INST.cell2.CB_0.le_outA vssd1 vssd1 vccd1 vccd1 sky130_fd_sc_hd__diode_2
Xfanout618 net621 vssd1 vssd1 vccd1 vccd1 net618 sky130_fd_sc_hd__clkbuf_4
XTAP_TAPCELL_ROW_113_1868 vssd1 vccd1 sky130_fd_sc_hd__tapvpwrvgnd_1
XFILLER_86_605 vssd1 vssd1 vccd1 vccd1 sky130_fd_sc_hd__fill_1
Xfanout607 net610 vssd1 vssd1 vccd1 vccd1 net607 sky130_fd_sc_hd__buf_2
Xfanout629 net634 vssd1 vssd1 vccd1 vccd1 net629 sky130_fd_sc_hd__clkbuf_4
X_09840_ FPGA_INST.cell0.LEI0.config_data\[18\] FPGA_INST.cell0.LEI0.config_data\[19\]
+ net182 vssd1 vssd1 vccd1 vccd1 _00748_ sky130_fd_sc_hd__mux2_1
XFILLER_113_798 vssd1 vssd1 vccd1 vccd1 sky130_fd_sc_hd__fill_1
X_09771_ FPGA_INST.cell1.CB_0.config_dataB\[21\] FPGA_INST.cell1.CB_0.config_dataB\[22\]
+ net226 vssd1 vssd1 vccd1 vccd1 _00680_ sky130_fd_sc_hd__mux2_1
XFILLER_58_318 vssd1 vssd1 vccd1 vccd1 sky130_fd_sc_hd__fill_2
XFILLER_58_307 vssd1 vssd1 vccd1 vccd1 sky130_fd_sc_hd__fill_1
X_06983_ _02309_ _03247_ vssd1 vssd1 vccd1 vccd1 _03249_ sky130_fd_sc_hd__nand2_1
X_08722_ net20 net21 net394 vssd1 vssd1 vccd1 vccd1 _04931_ sky130_fd_sc_hd__mux2_1
X_05934_ net238 _02206_ _02213_ vssd1 vssd1 vccd1 vccd1 _02214_ sky130_fd_sc_hd__and3_1
XFILLER_37_19 vssd1 vssd1 vccd1 vccd1 sky130_fd_sc_hd__fill_1
XFILLER_39_532 vssd1 vssd1 vccd1 vccd1 sky130_fd_sc_hd__fill_1
XTAP_TAPCELL_ROW_1_303 vssd1 vccd1 sky130_fd_sc_hd__tapvpwrvgnd_1
XFILLER_27_727 vssd1 vssd1 vccd1 vccd1 sky130_fd_sc_hd__fill_1
XFILLER_39_565 vssd1 vssd1 vccd1 vccd1 sky130_fd_sc_hd__fill_2
XFILLER_39_576 vssd1 vssd1 vccd1 vccd1 sky130_fd_sc_hd__fill_2
X_08653_ net399 _04835_ vssd1 vssd1 vccd1 vccd1 _04862_ sky130_fd_sc_hd__nand2_1
X_05865_ _02142_ _02144_ vssd1 vssd1 vccd1 vccd1 _02145_ sky130_fd_sc_hd__or2_1
XANTENNA_fanout172_A net173 vssd1 vssd1 vccd1 vccd1 sky130_fd_sc_hd__diode_2
X_08584_ _01655_ _01656_ _01657_ FPGA_INST.cell3.SB0.route_sel\[68\] _04792_ vssd1
+ vssd1 vccd1 vccd1 _04793_ sky130_fd_sc_hd__a221o_1
X_07604_ _02038_ _02836_ _02041_ vssd1 vssd1 vccd1 vccd1 _03858_ sky130_fd_sc_hd__o21ai_1
X_05796_ _01896_ _02039_ vssd1 vssd1 vccd1 vccd1 _02076_ sky130_fd_sc_hd__nor2_1
XFILLER_26_259 vssd1 vssd1 vccd1 vccd1 sky130_fd_sc_hd__fill_1
X_07535_ _03451_ _03745_ vssd1 vssd1 vccd1 vccd1 _03790_ sky130_fd_sc_hd__nor2_1
XTAP_TAPCELL_ROW_37_799 vssd1 vccd1 sky130_fd_sc_hd__tapvpwrvgnd_1
X_07466_ _03561_ _03607_ net140 vssd1 vssd1 vccd1 vccd1 _03723_ sky130_fd_sc_hd__o21ai_1
XFILLER_50_741 vssd1 vssd1 vccd1 vccd1 sky130_fd_sc_hd__fill_4
XFILLER_22_421 vssd1 vssd1 vccd1 vccd1 sky130_fd_sc_hd__fill_4
X_09205_ FPGA_INST.cell2.CB_1.config_dataB\[2\] net519 net360 vssd1 vssd1 vccd1 vccd1
+ _00118_ sky130_fd_sc_hd__mux2_1
X_06417_ net491 _01914_ vssd1 vssd1 vccd1 vccd1 _02695_ sky130_fd_sc_hd__nand2_1
X_07397_ FPGA_INST.cell3.SB0.route_sel\[46\] FPGA_INST.cell3.SB0.route_sel\[47\] vssd1
+ vssd1 vccd1 vccd1 _03656_ sky130_fd_sc_hd__nand2_1
XANTENNA_fanout604_A net627 vssd1 vssd1 vccd1 vccd1 sky130_fd_sc_hd__diode_2
XANTENNA__07690__A1 net89 vssd1 vssd1 vccd1 vccd1 sky130_fd_sc_hd__diode_2
XFILLER_22_498 vssd1 vssd1 vccd1 vccd1 sky130_fd_sc_hd__fill_2
XANTENNA__08234__A3 FPGA_INST.bus1_0\[15\] vssd1 vssd1 vccd1 vccd1 sky130_fd_sc_hd__diode_2
X_09136_ FPGA_INST.cell2.LE_0A.config_data\[0\] FPGA_INST.cell1.SB0.config_data_out
+ net353 vssd1 vssd1 vccd1 vccd1 _00051_ sky130_fd_sc_hd__mux2_1
X_06348_ net493 _02621_ _02622_ _02625_ vssd1 vssd1 vccd1 vccd1 _02626_ sky130_fd_sc_hd__a31o_1
XANTENNA__07442__A1 net25 vssd1 vssd1 vccd1 vccd1 sky130_fd_sc_hd__diode_2
X_09067_ net85 _04835_ _03736_ vssd1 vssd1 vccd1 vccd1 _05201_ sky130_fd_sc_hd__mux2_1
X_06279_ FPGA_INST.cell2.CB_0.config_dataA\[13\] FPGA_INST.cell2.CB_0.config_dataA\[12\]
+ vssd1 vssd1 vccd1 vccd1 _02559_ sky130_fd_sc_hd__nor2_1
XANTENNA__06245__A2 _01869_ vssd1 vssd1 vccd1 vccd1 sky130_fd_sc_hd__diode_2
X_08018_ _01728_ _04233_ _04237_ _04242_ _04243_ vssd1 vssd1 vccd1 vccd1 _04244_ sky130_fd_sc_hd__o32a_1
XFILLER_78_15 vccd1 vssd1 vccd1 vssd1 sky130_ef_sc_hd__decap_40_12
XTAP_TAPCELL_ROW_75_1329 vssd1 vccd1 sky130_fd_sc_hd__tapvpwrvgnd_1
XTAP_TAPCELL_ROW_9_414 vssd1 vccd1 sky130_fd_sc_hd__tapvpwrvgnd_1
XTAP_TAPCELL_ROW_9_403 vssd1 vccd1 sky130_fd_sc_hd__tapvpwrvgnd_1
XANTENNA__06412__B _02092_ vssd1 vssd1 vccd1 vccd1 sky130_fd_sc_hd__diode_2
X_09969_ FPGA_INST.config_bits\[2\] FPGA_INST.config_bits\[1\] FPGA_INST.config_bits\[0\]
+ vssd1 vssd1 vccd1 vccd1 _05224_ sky130_fd_sc_hd__and3_1
XFILLER_104_798 vssd1 vssd1 vccd1 vccd1 sky130_fd_sc_hd__fill_1
XFILLER_49_329 vssd1 vssd1 vccd1 vccd1 sky130_fd_sc_hd__fill_1
XANTENNA__06953__A0 FPGA_INST.bus2_0\[2\] vssd1 vssd1 vccd1 vccd1 sky130_fd_sc_hd__diode_2
XANTENNA__08155__C1 net155 vssd1 vssd1 vccd1 vccd1 sky130_fd_sc_hd__diode_2
XFILLER_85_671 vssd1 vssd1 vccd1 vccd1 sky130_fd_sc_hd__fill_1
XANTENNA__09215__S net367 vssd1 vssd1 vccd1 vccd1 sky130_fd_sc_hd__diode_2
XFILLER_57_351 vssd1 vssd1 vccd1 vccd1 sky130_fd_sc_hd__fill_2
X_11931_ net941 _01277_ net725 vssd1 vssd1 vccd1 vccd1 FPGA_INST.cell3.LE_1A.edge_mode
+ sky130_fd_sc_hd__dfstp_1
XFILLER_85_693 vssd1 vssd1 vccd1 vccd1 sky130_fd_sc_hd__fill_2
XANTENNA__08339__B _03720_ vssd1 vssd1 vccd1 vccd1 sky130_fd_sc_hd__diode_2
XANTENNA__06705__A0 FPGA_INST.bus3_2\[4\] vssd1 vssd1 vccd1 vccd1 sky130_fd_sc_hd__diode_2
XFILLER_45_546 vccd1 vssd1 vccd1 vssd1 sky130_ef_sc_hd__decap_40_12
XFILLER_45_524 vssd1 vssd1 vccd1 vccd1 sky130_fd_sc_hd__fill_1
X_11862_ net935 _01208_ net719 vssd1 vssd1 vccd1 vccd1 FPGA_INST.cell3.LEI0.config_data\[42\]
+ sky130_fd_sc_hd__dfrtp_1
XFILLER_17_259 vssd1 vssd1 vccd1 vccd1 sky130_fd_sc_hd__fill_1
XFILLER_72_398 vssd1 vssd1 vccd1 vccd1 sky130_fd_sc_hd__fill_8
X_10813_ net785 _00163_ net570 vssd1 vssd1 vccd1 vccd1 FPGA_INST.cell1.SB0.route_sel\[22\]
+ sky130_fd_sc_hd__dfstp_1
X_11793_ net886 _01139_ net670 vssd1 vssd1 vccd1 vccd1 FPGA_INST.io_east_oeb\[6\]
+ sky130_fd_sc_hd__dfrtp_1
XFILLER_13_432 vccd1 vssd1 vccd1 vssd1 sky130_ef_sc_hd__decap_40_12
X_10744_ FPGA_INST.cell2.LE_1B.sel_clk _00094_ net734 vssd1 vssd1 vccd1 vccd1 FPGA_INST.cell2.LE_1B.dff1_out
+ sky130_fd_sc_hd__dfstp_1
XFILLER_40_251 vssd1 vssd1 vccd1 vccd1 sky130_fd_sc_hd__fill_1
XFILLER_9_447 vssd1 vssd1 vccd1 vccd1 sky130_fd_sc_hd__fill_1
X_10675_ net877 _00025_ net661 vssd1 vssd1 vccd1 vccd1 FPGA_INST.cell2.LEI0.config_data\[24\]
+ sky130_fd_sc_hd__dfrtp_1
XFILLER_40_273 vssd1 vssd1 vccd1 vccd1 sky130_fd_sc_hd__fill_8
XANTENNA__08225__A3 FPGA_INST.bus1_0\[7\] vssd1 vssd1 vccd1 vccd1 sky130_fd_sc_hd__diode_2
XTAP_TAPCELL_ROW_130_2113 vssd1 vccd1 sky130_fd_sc_hd__tapvpwrvgnd_1
XTAP_TAPCELL_ROW_130_2102 vssd1 vccd1 sky130_fd_sc_hd__tapvpwrvgnd_1
XFILLER_126_367 vssd1 vssd1 vccd1 vccd1 sky130_fd_sc_hd__fill_1
XFILLER_4_141 vssd1 vssd1 vccd1 vccd1 sky130_fd_sc_hd__fill_2
XFILLER_126_389 vssd1 vssd1 vccd1 vccd1 sky130_fd_sc_hd__fill_1
XANTENNA__07418__B FPGA_INST.cell1.SB0.route_sel\[49\] vssd1 vssd1 vccd1 vccd1 sky130_fd_sc_hd__diode_2
X_11227_ net764 _00577_ net549 vssd1 vssd1 vccd1 vccd1 FPGA_INST.cell0.SB0.route_sel\[72\]
+ sky130_fd_sc_hd__dfstp_1
XANTENNA__07736__A2 _03526_ vssd1 vssd1 vccd1 vccd1 sky130_fd_sc_hd__diode_2
X_11158_ net821 _00508_ net605 vssd1 vssd1 vccd1 vccd1 FPGA_INST.cell0.SB0.route_sel\[3\]
+ sky130_fd_sc_hd__dfstp_1
XFILLER_4_78 vssd1 vssd1 vccd1 vccd1 sky130_fd_sc_hd__fill_4
XFILLER_110_757 vssd1 vssd1 vccd1 vccd1 sky130_fd_sc_hd__fill_4
X_10109_ FPGA_INST.cell3.SB0.route_sel\[13\] FPGA_INST.cell3.SB0.route_sel\[14\] net244
+ vssd1 vssd1 vccd1 vccd1 _00990_ sky130_fd_sc_hd__mux2_1
XFILLER_0_391 vssd1 vssd1 vccd1 vccd1 sky130_fd_sc_hd__fill_1
XTAP_TAPCELL_ROW_128_2075 vssd1 vccd1 sky130_fd_sc_hd__tapvpwrvgnd_1
X_11089_ net839 _00439_ net623 vssd1 vssd1 vccd1 vccd1 FPGA_INST.cell1.LE_0B.config_data\[2\]
+ sky130_fd_sc_hd__dfrtp_1
XFILLER_84_91 vssd1 vssd1 vccd1 vccd1 sky130_fd_sc_hd__fill_2
XANTENNA__11596__SET_B net588 vssd1 vssd1 vccd1 vccd1 sky130_fd_sc_hd__diode_2
X_05650_ FPGA_INST.cell0.SB0.route_sel\[98\] FPGA_INST.cell0.SB0.route_sel\[99\] _01926_
+ _01928_ _01929_ vssd1 vssd1 vccd1 vccd1 _01930_ sky130_fd_sc_hd__a221o_1
XANTENNA__08161__A2 FPGA_INST.bus1_0\[14\] vssd1 vssd1 vccd1 vccd1 sky130_fd_sc_hd__diode_2
XFILLER_36_579 vssd1 vssd1 vccd1 vccd1 sky130_fd_sc_hd__fill_4
XFILLER_91_696 vssd1 vssd1 vccd1 vccd1 sky130_fd_sc_hd__fill_1
XFILLER_63_387 vssd1 vssd1 vccd1 vccd1 sky130_fd_sc_hd__fill_1
X_05581_ _01859_ _01860_ vssd1 vssd1 vccd1 vccd1 _01861_ sky130_fd_sc_hd__or2_1
X_07320_ _03580_ net94 _03579_ vssd1 vssd1 vccd1 vccd1 _03581_ sky130_fd_sc_hd__mux2_1
XTAP_TAPCELL_ROW_34_758 vssd1 vccd1 sky130_fd_sc_hd__tapvpwrvgnd_1
X_07251_ _03400_ _03498_ FPGA_INST.bus3_1\[2\] vssd1 vssd1 vccd1 vccd1 _03513_ sky130_fd_sc_hd__a21bo_1
XTAP_TAPCELL_ROW_14_482 vssd1 vccd1 sky130_fd_sc_hd__tapvpwrvgnd_1
X_07182_ _03443_ _03445_ vssd1 vssd1 vccd1 vccd1 FPGA_INST.bus3_2\[0\] sky130_fd_sc_hd__and2_4
X_06202_ net135 _02479_ vssd1 vssd1 vccd1 vccd1 _02482_ sky130_fd_sc_hd__nor2_1
XFILLER_117_334 vssd1 vssd1 vccd1 vccd1 sky130_fd_sc_hd__fill_2
X_06133_ _02412_ _02410_ vssd1 vssd1 vccd1 vccd1 _02413_ sky130_fd_sc_hd__and2b_2
XANTENNA__07609__A net94 vssd1 vssd1 vccd1 vccd1 sky130_fd_sc_hd__diode_2
X_06064_ net171 net158 FPGA_INST.bus2_0\[3\] vssd1 vssd1 vccd1 vccd1 _02344_ sky130_fd_sc_hd__o21ba_1
XANTENNA__06072__X _02352_ vssd1 vssd1 vccd1 vccd1 sky130_fd_sc_hd__diode_2
Xfanout404 FPGA_INST.cell0.CB_1.config_dataA\[15\] vssd1 vssd1 vccd1 vccd1 net404
+ sky130_fd_sc_hd__dlymetal6s2s_1
XFILLER_99_774 vssd1 vssd1 vccd1 vccd1 sky130_fd_sc_hd__fill_1
XFILLER_98_273 vssd1 vssd1 vccd1 vccd1 sky130_fd_sc_hd__fill_8
XANTENNA__08924__B2 FPGA_INST.cell1.SB0.route_sel\[96\] vssd1 vssd1 vccd1 vccd1 sky130_fd_sc_hd__diode_2
Xfanout448 net449 vssd1 vssd1 vccd1 vccd1 net448 sky130_fd_sc_hd__clkbuf_2
XANTENNA__05738__A1 net383 vssd1 vssd1 vccd1 vccd1 sky130_fd_sc_hd__diode_2
XFILLER_48_29 vssd1 vssd1 vccd1 vccd1 sky130_fd_sc_hd__fill_1
Xfanout426 FPGA_INST.cell0.CB_0.config_dataA\[16\] vssd1 vssd1 vccd1 vccd1 net426
+ sky130_fd_sc_hd__buf_2
Xfanout415 FPGA_INST.cell0.CB_0.config_dataB\[15\] vssd1 vssd1 vccd1 vccd1 net415
+ sky130_fd_sc_hd__buf_2
X_09823_ FPGA_INST.cell0.LEI0.config_data\[1\] FPGA_INST.cell0.LEI0.config_data\[2\]
+ net174 vssd1 vssd1 vccd1 vccd1 _00731_ sky130_fd_sc_hd__mux2_1
Xfanout437 FPGA_INST.cell0.CB_0.config_dataA\[0\] vssd1 vssd1 vccd1 vccd1 net437 sky130_fd_sc_hd__clkbuf_2
Xfanout459 FPGA_INST.cell1.CB_0.config_dataB\[1\] vssd1 vssd1 vccd1 vccd1 net459 sky130_fd_sc_hd__clkbuf_2
XTAP_TAPCELL_ROW_70_1259 vssd1 vccd1 sky130_fd_sc_hd__tapvpwrvgnd_1
XFILLER_59_649 vssd1 vssd1 vccd1 vccd1 sky130_fd_sc_hd__fill_1
X_09754_ FPGA_INST.cell1.CB_0.config_dataB\[4\] net457 net277 vssd1 vssd1 vccd1 vccd1
+ _00663_ sky130_fd_sc_hd__mux2_1
XFILLER_67_671 vssd1 vssd1 vccd1 vccd1 sky130_fd_sc_hd__fill_1
X_06966_ _03197_ _03233_ _03195_ vssd1 vssd1 vccd1 vccd1 _03234_ sky130_fd_sc_hd__mux2_1
X_08705_ FPGA_INST.cell3.CB_0.config_dataA\[13\] _04901_ _04905_ _04913_ vssd1 vssd1
+ vccd1 vccd1 _04914_ sky130_fd_sc_hd__o31a_1
X_05917_ FPGA_INST.cell2.CB_1.config_dataB\[23\] FPGA_INST.cell2.CB_1.config_dataB\[22\]
+ vssd1 vssd1 vccd1 vccd1 _02197_ sky130_fd_sc_hd__and2b_1
X_09685_ FPGA_INST.cell0.SB0.route_sel\[88\] FPGA_INST.cell0.SB0.route_sel\[89\] net187
+ vssd1 vssd1 vccd1 vccd1 _00594_ sky130_fd_sc_hd__mux2_1
X_06897_ net417 net419 vssd1 vssd1 vccd1 vccd1 _03165_ sky130_fd_sc_hd__nor2_1
XANTENNA_fanout554_A net628 vssd1 vssd1 vccd1 vccd1 sky130_fd_sc_hd__diode_2
XFILLER_39_384 vssd1 vssd1 vccd1 vccd1 sky130_fd_sc_hd__fill_8
XPHY_EDGE_ROW_126_Right_126 vssd1 vssd1 vccd1 vccd1 sky130_fd_sc_hd__decap_3
X_08636_ _01681_ FPGA_INST.cell3.SB0.route_sel\[44\] _01682_ FPGA_INST.cell3.SB0.route_sel\[47\]
+ _04844_ vssd1 vssd1 vccd1 vccd1 _04845_ sky130_fd_sc_hd__a221o_1
XFILLER_54_354 vssd1 vssd1 vccd1 vccd1 sky130_fd_sc_hd__fill_1
X_05848_ _02121_ _02127_ vssd1 vssd1 vccd1 vccd1 _02128_ sky130_fd_sc_hd__nor2_1
XFILLER_42_527 vssd1 vssd1 vccd1 vccd1 sky130_fd_sc_hd__fill_4
XANTENNA_fanout819_A net820 vssd1 vssd1 vccd1 vccd1 sky130_fd_sc_hd__diode_2
X_08567_ FPGA_INST.cell3.LE_1B.dff0_out FPGA_INST.cell3.LE_1B.dff1_out FPGA_INST.cell3.LE_1B.reset_val
+ vssd1 vssd1 vccd1 vccd1 FPGA_INST.cell3.LE_1B.dff_out sky130_fd_sc_hd__mux2_1
XANTENNA_fanout721_A net729 vssd1 vssd1 vccd1 vccd1 sky130_fd_sc_hd__diode_2
XANTENNA__05799__A net129 vssd1 vssd1 vccd1 vccd1 sky130_fd_sc_hd__diode_2
X_05779_ net170 net161 vssd1 vssd1 vccd1 vccd1 _02059_ sky130_fd_sc_hd__nor2_1
X_08498_ _04710_ _04713_ _04697_ vssd1 vssd1 vccd1 vccd1 _04714_ sky130_fd_sc_hd__mux2_1
X_07518_ _01657_ _03773_ _03772_ _02155_ vssd1 vssd1 vccd1 vccd1 _03774_ sky130_fd_sc_hd__or4b_1
XFILLER_80_27 vssd1 vssd1 vccd1 vccd1 sky130_fd_sc_hd__fill_1
XANTENNA__07112__A0 net115 vssd1 vssd1 vccd1 vccd1 sky130_fd_sc_hd__diode_2
Xfanout88 FPGA_INST.cell3.CB_0.le_outB vssd1 vssd1 vccd1 vccd1 net88 sky130_fd_sc_hd__dlymetal6s2s_1
X_07449_ _03542_ _03587_ net78 vssd1 vssd1 vccd1 vccd1 _03706_ sky130_fd_sc_hd__o21ai_1
Xfanout99 FPGA_INST.cell0.CB_1.le_outB vssd1 vssd1 vccd1 vccd1 net99 sky130_fd_sc_hd__buf_2
XFILLER_13_54 vssd1 vssd1 vccd1 vccd1 sky130_fd_sc_hd__fill_2
X_10460_ FPGA_INST.cell2.SB0.route_sel\[32\] FPGA_INST.cell2.SB0.route_sel\[33\] net243
+ vssd1 vssd1 vccd1 vccd1 _01339_ sky130_fd_sc_hd__mux2_1
X_09119_ FPGA_INST.cell2.LEI0.config_data\[33\] FPGA_INST.cell2.LEI0.config_data\[34\]
+ net259 vssd1 vssd1 vccd1 vccd1 _00035_ sky130_fd_sc_hd__mux2_1
X_10391_ FPGA_INST.cell3.LE_1A.config_data\[9\] FPGA_INST.cell3.LE_1A.config_data\[10\]
+ net304 vssd1 vssd1 vccd1 vccd1 _01270_ sky130_fd_sc_hd__mux2_1
XFILLER_123_337 vssd1 vssd1 vccd1 vccd1 sky130_fd_sc_hd__fill_4
X_12130_ net936 _01476_ net720 vssd1 vssd1 vccd1 vccd1 FPGA_INST.cell3.CB_0.config_dataB\[17\]
+ sky130_fd_sc_hd__dfstp_1
XFILLER_89_240 vssd1 vssd1 vccd1 vccd1 sky130_fd_sc_hd__fill_1
XFILLER_8_3 vssd1 vssd1 vccd1 vccd1 sky130_fd_sc_hd__fill_4
XFILLER_1_111 vssd1 vssd1 vccd1 vccd1 sky130_fd_sc_hd__fill_1
X_12061_ net853 _01407_ net638 vssd1 vssd1 vccd1 vccd1 FPGA_INST.cell2.SB0.route_sel\[101\]
+ sky130_fd_sc_hd__dfstp_1
X_11012_ net889 _00362_ net673 vssd1 vssd1 vccd1 vccd1 FPGA_INST.cell2.LE_1B.reset_val
+ sky130_fd_sc_hd__dfrtp_1
XFILLER_77_435 vssd1 vssd1 vccd1 vccd1 sky130_fd_sc_hd__fill_2
XFILLER_49_137 vssd1 vssd1 vccd1 vccd1 sky130_fd_sc_hd__fill_8
XTAP_TAPCELL_ROW_88_1509 vssd1 vccd1 sky130_fd_sc_hd__tapvpwrvgnd_1
XFILLER_77_479 vssd1 vssd1 vccd1 vccd1 sky130_fd_sc_hd__fill_4
XFILLER_49_159 vssd1 vssd1 vccd1 vccd1 sky130_fd_sc_hd__fill_8
XFILLER_64_118 vssd1 vssd1 vccd1 vccd1 sky130_fd_sc_hd__fill_1
X_11914_ net940 _01260_ net724 vssd1 vssd1 vccd1 vccd1 FPGA_INST.cell3.LE_1A.config_data\[0\]
+ sky130_fd_sc_hd__dfrtp_1
XFILLER_18_546 vssd1 vssd1 vccd1 vccd1 sky130_fd_sc_hd__fill_2
X_11845_ net916 _01191_ net700 vssd1 vssd1 vccd1 vccd1 FPGA_INST.cell3.LEI0.config_data\[25\]
+ sky130_fd_sc_hd__dfrtp_1
XFILLER_72_195 vssd1 vssd1 vccd1 vccd1 sky130_fd_sc_hd__fill_1
X_11776_ net925 _01122_ net709 vssd1 vssd1 vccd1 vccd1 FPGA_INST.io_south_oeb\[4\]
+ sky130_fd_sc_hd__dfrtp_1
XTAP_TAPCELL_ROW_31_717 vssd1 vccd1 sky130_fd_sc_hd__tapvpwrvgnd_1
XFILLER_41_593 vssd1 vssd1 vccd1 vccd1 sky130_fd_sc_hd__fill_2
X_10727_ net872 _00077_ net656 vssd1 vssd1 vccd1 vccd1 FPGA_INST.cell2.LE_0B.config_data\[4\]
+ sky130_fd_sc_hd__dfrtp_1
XFILLER_118_109 vssd1 vssd1 vccd1 vccd1 sky130_fd_sc_hd__fill_2
XANTENNA__05665__B1 FPGA_INST.bus3_2\[12\] vssd1 vssd1 vccd1 vccd1 sky130_fd_sc_hd__diode_2
XTAP_TAPCELL_ROW_11_430 vssd1 vccd1 sky130_fd_sc_hd__tapvpwrvgnd_1
XTAP_TAPCELL_ROW_11_441 vssd1 vccd1 sky130_fd_sc_hd__tapvpwrvgnd_1
XFILLER_70_93 vssd1 vssd1 vccd1 vccd1 sky130_fd_sc_hd__fill_8
X_10658_ net883 _00008_ net667 vssd1 vssd1 vccd1 vccd1 FPGA_INST.cell2.LEI0.config_data\[7\]
+ sky130_fd_sc_hd__dfrtp_1
X_10589_ FPGA_INST.cell3.CB_0.config_dataB\[8\] FPGA_INST.cell3.CB_0.config_dataB\[9\]
+ net302 vssd1 vssd1 vccd1 vccd1 _01468_ sky130_fd_sc_hd__mux2_1
XANTENNA__05968__A1 net7 vssd1 vssd1 vccd1 vccd1 sky130_fd_sc_hd__diode_2
XTAP_TAPCELL_ROW_110_1827 vssd1 vccd1 sky130_fd_sc_hd__tapvpwrvgnd_1
XTAP_TAPCELL_ROW_110_1816 vssd1 vccd1 sky130_fd_sc_hd__tapvpwrvgnd_1
XANTENNA__07709__A2 _03959_ vssd1 vssd1 vccd1 vccd1 sky130_fd_sc_hd__diode_2
XTAP_TAPCELL_ROW_56_1070 vssd1 vccd1 sky130_fd_sc_hd__tapvpwrvgnd_1
XFILLER_96_755 vssd1 vssd1 vccd1 vccd1 sky130_fd_sc_hd__fill_1
XFILLER_96_744 vssd1 vssd1 vccd1 vccd1 sky130_fd_sc_hd__fill_2
X_06820_ net660 FPGA_INST.cell2.LE_0A.reset_mode vssd1 vssd1 vccd1 vccd1 _06820_/X
+ sky130_fd_sc_hd__xor2_2
XFILLER_83_427 vccd1 vssd1 vccd1 vssd1 sky130_ef_sc_hd__decap_40_12
X_06751_ _03023_ _03024_ FPGA_INST.cell2.CB_1.config_dataB\[12\] vssd1 vssd1 vccd1
+ vccd1 _03025_ sky130_fd_sc_hd__o21ai_1
XTAP_TAPCELL_ROW_39_828 vssd1 vccd1 sky130_fd_sc_hd__tapvpwrvgnd_1
X_09470_ FPGA_INST.cell1.LEI0.config_data\[16\] FPGA_INST.cell1.LEI0.config_data\[17\]
+ net230 vssd1 vssd1 vccd1 vccd1 _00382_ sky130_fd_sc_hd__mux2_1
X_06682_ _02957_ _02954_ _02911_ vssd1 vssd1 vccd1 vccd1 _02958_ sky130_fd_sc_hd__mux2_1
X_05702_ _01623_ FPGA_INST.cell0.SB0.route_sel\[109\] FPGA_INST.cell0.SB0.route_sel\[106\]
+ FPGA_INST.cell0.SB0.route_sel\[107\] vssd1 vssd1 vccd1 vccd1 _01982_ sky130_fd_sc_hd__o22a_1
XTAP_TAPCELL_ROW_108_1789 vssd1 vccd1 sky130_fd_sc_hd__tapvpwrvgnd_1
XFILLER_63_140 vssd1 vssd1 vccd1 vccd1 sky130_fd_sc_hd__fill_1
X_08421_ FPGA_INST.cell0.LE_1B.config_data\[9\] FPGA_INST.cell0.LE_1B.config_data\[8\]
+ _04574_ vssd1 vssd1 vccd1 vccd1 _04643_ sky130_fd_sc_hd__mux2_1
XTAP_TAPCELL_ROW_19_552 vssd1 vccd1 sky130_fd_sc_hd__tapvpwrvgnd_1
XANTENNA__07893__A1 _03613_ vssd1 vssd1 vccd1 vccd1 sky130_fd_sc_hd__diode_2
X_05633_ _01585_ FPGA_INST.cell2.SB0.route_sel\[125\] _01912_ vssd1 vssd1 vccd1 vccd1
+ _01913_ sky130_fd_sc_hd__o21ai_2
XTAP_TAPCELL_ROW_121_1978 vssd1 vccd1 sky130_fd_sc_hd__tapvpwrvgnd_1
X_05564_ FPGA_INST.cell2.SB0.route_sel\[112\] FPGA_INST.cell2.SB0.route_sel\[113\]
+ vssd1 vssd1 vccd1 vccd1 _01844_ sky130_fd_sc_hd__nand2_1
X_08352_ FPGA_INST.cell0.LEI0.config_data\[11\] _04573_ _04571_ _04570_ vssd1 vssd1
+ vccd1 vccd1 _04574_ sky130_fd_sc_hd__o211a_4
X_05495_ FPGA_INST.cell3.CB_0.config_dataB\[12\] vssd1 vssd1 vccd1 vccd1 _01777_ sky130_fd_sc_hd__inv_2
XANTENNA__07645__A1 net81 vssd1 vssd1 vccd1 vccd1 sky130_fd_sc_hd__diode_2
X_07303_ FPGA_INST.cell1.SB0.route_sel\[26\] FPGA_INST.cell1.SB0.route_sel\[27\] _03563_
+ vssd1 vssd1 vccd1 vccd1 _03564_ sky130_fd_sc_hd__a21oi_1
X_08283_ FPGA_INST.cell0.LE_1A.config_data\[14\] FPGA_INST.cell0.LE_1A.config_data\[15\]
+ _04410_ vssd1 vssd1 vccd1 vccd1 _04507_ sky130_fd_sc_hd__mux2_1
X_07234_ FPGA_INST.cell1.CB_0.config_dataA\[24\] FPGA_INST.cell1.CB_0.config_dataA\[20\]
+ FPGA_INST.cell1.CB_0.config_dataA\[21\] vssd1 vssd1 vccd1 vccd1 _03496_ sky130_fd_sc_hd__or3b_2
XANTENNA__09819__A net736 vssd1 vssd1 vccd1 vccd1 sky130_fd_sc_hd__diode_2
XFILLER_117_142 vssd1 vssd1 vccd1 vccd1 sky130_fd_sc_hd__fill_4
XANTENNA_fanout302_A net305 vssd1 vssd1 vccd1 vccd1 sky130_fd_sc_hd__diode_2
X_07165_ FPGA_INST.cell3.CB_1.config_dataA\[23\] FPGA_INST.cell3.CB_1.config_dataA\[22\]
+ vssd1 vssd1 vccd1 vccd1 _03429_ sky130_fd_sc_hd__or2_2
X_06116_ FPGA_INST.cell2.SB0.route_sel\[20\] FPGA_INST.cell2.SB0.route_sel\[21\] _02395_
+ vssd1 vssd1 vccd1 vccd1 _02396_ sky130_fd_sc_hd__a21oi_1
X_07096_ FPGA_INST.bus2_0\[0\] _03353_ _03361_ vssd1 vssd1 vccd1 vccd1 _03362_ sky130_fd_sc_hd__a21o_1
XFILLER_105_348 vssd1 vssd1 vccd1 vccd1 sky130_fd_sc_hd__fill_1
X_06047_ net353 _02321_ _02326_ vssd1 vssd1 vccd1 vccd1 _02327_ sky130_fd_sc_hd__nor3_1
XFILLER_120_307 vssd1 vssd1 vccd1 vccd1 sky130_fd_sc_hd__fill_1
Xfanout212 net213 vssd1 vssd1 vccd1 vccd1 net212 sky130_fd_sc_hd__clkbuf_4
Xfanout223 net227 vssd1 vssd1 vccd1 vccd1 net223 sky130_fd_sc_hd__clkbuf_2
Xfanout201 net202 vssd1 vssd1 vccd1 vccd1 net201 sky130_fd_sc_hd__clkbuf_2
Xfanout234 _01831_ vssd1 vssd1 vccd1 vccd1 net234 sky130_fd_sc_hd__clkbuf_4
XFILLER_86_210 vssd1 vssd1 vccd1 vccd1 sky130_fd_sc_hd__fill_1
XANTENNA_fanout769_A net790 vssd1 vssd1 vccd1 vccd1 sky130_fd_sc_hd__diode_2
XANTENNA_fanout671_A net675 vssd1 vssd1 vccd1 vccd1 sky130_fd_sc_hd__diode_2
Xfanout245 net268 vssd1 vssd1 vccd1 vccd1 net245 sky130_fd_sc_hd__clkbuf_2
Xfanout256 net258 vssd1 vssd1 vccd1 vccd1 net256 sky130_fd_sc_hd__clkbuf_4
X_09806_ FPGA_INST.cell1.LE_1B.config_data\[7\] FPGA_INST.cell1.LE_1B.config_data\[6\]
+ net337 vssd1 vssd1 vccd1 vccd1 _00715_ sky130_fd_sc_hd__mux2_1
X_07998_ FPGA_INST.cell1.LE_0A.config_data\[11\] FPGA_INST.cell1.LE_0A.config_data\[10\]
+ _04148_ vssd1 vssd1 vccd1 vccd1 _04226_ sky130_fd_sc_hd__mux2_1
Xfanout278 net285 vssd1 vssd1 vccd1 vccd1 net278 sky130_fd_sc_hd__clkbuf_2
Xfanout289 net290 vssd1 vssd1 vccd1 vccd1 net289 sky130_fd_sc_hd__clkbuf_4
XFILLER_75_27 vssd1 vssd1 vccd1 vccd1 sky130_fd_sc_hd__fill_2
Xfanout267 net268 vssd1 vssd1 vccd1 vccd1 net267 sky130_fd_sc_hd__buf_2
XFILLER_59_457 vssd1 vssd1 vccd1 vccd1 sky130_fd_sc_hd__fill_1
X_09737_ FPGA_INST.cell1.CB_0.config_dataA\[13\] FPGA_INST.cell1.CB_0.config_dataA\[12\]
+ net344 vssd1 vssd1 vccd1 vccd1 _00646_ sky130_fd_sc_hd__mux2_1
X_06949_ _03212_ _03213_ _03215_ _03216_ vssd1 vssd1 vccd1 vccd1 _03217_ sky130_fd_sc_hd__o2bb2a_1
XANTENNA_fanout936_A net946 vssd1 vssd1 vccd1 vccd1 sky130_fd_sc_hd__diode_2
XFILLER_82_471 vssd1 vssd1 vccd1 vccd1 sky130_fd_sc_hd__fill_2
XANTENNA__07802__A FPGA_INST.cell3.SB0.route_sel\[125\] vssd1 vssd1 vccd1 vccd1 sky130_fd_sc_hd__diode_2
XFILLER_54_162 vssd1 vssd1 vccd1 vccd1 sky130_fd_sc_hd__fill_1
XFILLER_42_302 vssd1 vssd1 vccd1 vccd1 sky130_fd_sc_hd__fill_4
X_09668_ FPGA_INST.cell0.SB0.route_sel\[72\] FPGA_INST.cell0.SB0.route_sel\[71\] net313
+ vssd1 vssd1 vccd1 vccd1 _00577_ sky130_fd_sc_hd__mux2_1
XFILLER_27_354 vssd1 vssd1 vccd1 vccd1 sky130_fd_sc_hd__fill_8
X_08619_ _04826_ _04827_ _03443_ vssd1 vssd1 vccd1 vccd1 _04828_ sky130_fd_sc_hd__a21boi_4
XTAP_TAPCELL_ROW_83_1439 vssd1 vccd1 sky130_fd_sc_hd__tapvpwrvgnd_1
X_09599_ FPGA_INST.cell0.SB0.route_sel\[3\] FPGA_INST.cell0.SB0.route_sel\[2\] net338
+ vssd1 vssd1 vccd1 vccd1 _00508_ sky130_fd_sc_hd__mux2_1
XFILLER_42_313 vssd1 vssd1 vccd1 vccd1 sky130_fd_sc_hd__fill_1
X_11630_ net908 _00976_ net692 vssd1 vssd1 vccd1 vccd1 FPGA_INST.cell3.SB0.route_sel\[0\]
+ sky130_fd_sc_hd__dfstp_1
X_11561_ net756 _00911_ net541 vssd1 vssd1 vccd1 vccd1 FPGA_INST.cell0.CB_0.config_dataB\[5\]
+ sky130_fd_sc_hd__dfstp_1
XFILLER_24_75 vssd1 vssd1 vccd1 vccd1 sky130_fd_sc_hd__fill_2
XFILLER_10_221 vssd1 vssd1 vccd1 vccd1 sky130_fd_sc_hd__fill_2
X_10512_ FPGA_INST.cell2.SB0.route_sel\[84\] FPGA_INST.cell2.SB0.route_sel\[85\] net240
+ vssd1 vssd1 vccd1 vccd1 _01391_ sky130_fd_sc_hd__mux2_1
XFILLER_109_621 vssd1 vssd1 vccd1 vccd1 sky130_fd_sc_hd__fill_1
X_11492_ net745 _00842_ net530 vssd1 vssd1 vccd1 vccd1 FPGA_INST.cell0.LE_1A.reset_mode
+ sky130_fd_sc_hd__dfrtp_1
XANTENNA__10374__S net305 vssd1 vssd1 vccd1 vccd1 sky130_fd_sc_hd__diode_2
XTAP_TAPCELL_ROW_98_1660 vssd1 vccd1 sky130_fd_sc_hd__tapvpwrvgnd_1
XFILLER_6_269 vssd1 vssd1 vccd1 vccd1 sky130_fd_sc_hd__fill_2
X_10443_ FPGA_INST.cell2.SB0.route_sel\[15\] FPGA_INST.cell2.SB0.route_sel\[16\] net236
+ vssd1 vssd1 vccd1 vccd1 _01322_ sky130_fd_sc_hd__mux2_1
XFILLER_40_52 vssd1 vssd1 vccd1 vccd1 sky130_fd_sc_hd__fill_2
X_10374_ FPGA_INST.cell3.LE_0B.config_data\[15\] FPGA_INST.cell3.LE_0B.config_data\[16\]
+ net305 vssd1 vssd1 vccd1 vccd1 _01254_ sky130_fd_sc_hd__mux2_1
XFILLER_123_134 vssd1 vssd1 vccd1 vccd1 sky130_fd_sc_hd__fill_2
X_12113_ net904 _01459_ net688 vssd1 vssd1 vccd1 vccd1 FPGA_INST.cell3.CB_0.config_dataB\[0\]
+ sky130_fd_sc_hd__dfstp_1
XFILLER_123_156 vssd1 vssd1 vccd1 vccd1 sky130_fd_sc_hd__fill_2
XFILLER_111_307 vssd1 vssd1 vccd1 vccd1 sky130_fd_sc_hd__fill_1
XFILLER_111_329 vssd1 vssd1 vccd1 vccd1 sky130_fd_sc_hd__fill_1
XFILLER_78_755 vssd1 vssd1 vccd1 vccd1 sky130_fd_sc_hd__fill_1
XFILLER_78_733 vccd1 vssd1 vccd1 vssd1 sky130_ef_sc_hd__decap_40_12
XFILLER_2_497 vssd1 vssd1 vccd1 vccd1 sky130_fd_sc_hd__fill_1
X_12044_ net878 _01390_ net663 vssd1 vssd1 vccd1 vccd1 FPGA_INST.cell2.SB0.route_sel\[84\]
+ sky130_fd_sc_hd__dfstp_1
XFILLER_78_766 vssd1 vssd1 vccd1 vccd1 sky130_fd_sc_hd__fill_8
XFILLER_38_619 vssd1 vssd1 vccd1 vccd1 sky130_fd_sc_hd__fill_1
XTAP_TAPCELL_ROW_125_2034 vssd1 vccd1 sky130_fd_sc_hd__tapvpwrvgnd_1
XANTENNA_input20_X net20 vssd1 vssd1 vccd1 vccd1 sky130_fd_sc_hd__diode_2
XFILLER_93_725 vssd1 vssd1 vccd1 vccd1 sky130_fd_sc_hd__fill_1
Xfanout790 net1 vssd1 vssd1 vccd1 vccd1 net790 sky130_fd_sc_hd__clkbuf_4
XFILLER_46_652 vssd1 vssd1 vccd1 vccd1 sky130_fd_sc_hd__fill_2
XFILLER_1_57 vssd1 vssd1 vccd1 vccd1 sky130_fd_sc_hd__fill_4
XFILLER_61_600 vssd1 vssd1 vccd1 vccd1 sky130_fd_sc_hd__fill_1
XANTENNA__06127__A1 net3 vssd1 vssd1 vccd1 vccd1 sky130_fd_sc_hd__diode_2
XFILLER_18_365 vssd1 vssd1 vccd1 vccd1 sky130_fd_sc_hd__fill_1
XANTENNA__09403__S net240 vssd1 vssd1 vccd1 vccd1 sky130_fd_sc_hd__diode_2
XTAP_TAPCELL_ROW_16_500 vssd1 vccd1 sky130_fd_sc_hd__tapvpwrvgnd_1
XTAP_TAPCELL_ROW_16_511 vssd1 vccd1 sky130_fd_sc_hd__tapvpwrvgnd_1
XFILLER_33_313 vssd1 vssd1 vccd1 vccd1 sky130_fd_sc_hd__fill_1
XFILLER_33_335 vssd1 vssd1 vccd1 vccd1 sky130_fd_sc_hd__fill_1
X_11828_ net941 _01174_ net725 vssd1 vssd1 vccd1 vccd1 FPGA_INST.cell3.LEI0.config_data\[8\]
+ sky130_fd_sc_hd__dfrtp_1
XFILLER_60_165 vssd1 vssd1 vccd1 vccd1 sky130_fd_sc_hd__fill_2
XANTENNA__07627__A1 net148 vssd1 vssd1 vccd1 vccd1 sky130_fd_sc_hd__diode_2
XTAP_TAPCELL_ROW_44_897 vssd1 vccd1 sky130_fd_sc_hd__tapvpwrvgnd_1
X_11759_ net920 _01105_ net704 vssd1 vssd1 vccd1 vccd1 FPGA_INST.io_west_oeb\[2\]
+ sky130_fd_sc_hd__dfrtp_1
XFILLER_41_390 vssd1 vssd1 vccd1 vccd1 sky130_fd_sc_hd__fill_2
X_05280_ FPGA_INST.cell2.SB0.route_sel\[56\] vssd1 vssd1 vccd1 vccd1 _01562_ sky130_fd_sc_hd__inv_2
XANTENNA__10284__S net737 vssd1 vssd1 vccd1 vccd1 sky130_fd_sc_hd__diode_2
XFILLER_60_3 vssd1 vssd1 vccd1 vccd1 sky130_fd_sc_hd__fill_8
XANTENNA__06850__A2 FPGA_INST.bus2_0\[13\] vssd1 vssd1 vccd1 vccd1 sky130_fd_sc_hd__diode_2
XFILLER_115_613 vssd1 vssd1 vccd1 vccd1 sky130_fd_sc_hd__fill_2
XFILLER_115_668 vssd1 vssd1 vccd1 vccd1 sky130_fd_sc_hd__fill_4
X_08970_ _03716_ _03725_ _05153_ net220 vssd1 vssd1 vccd1 vccd1 FPGA_INST.bus1_0\[7\]
+ sky130_fd_sc_hd__o211a_2
X_07921_ FPGA_INST.cell1.LE_0A.config_data\[5\] FPGA_INST.cell1.LE_0A.config_data\[4\]
+ _04148_ vssd1 vssd1 vccd1 vccd1 _04149_ sky130_fd_sc_hd__mux2_1
XFILLER_110_340 vssd1 vssd1 vccd1 vccd1 sky130_fd_sc_hd__fill_1
X_07852_ net470 _03568_ vssd1 vssd1 vccd1 vccd1 _04080_ sky130_fd_sc_hd__nand2_1
XANTENNA__06366__A1 _02131_ vssd1 vssd1 vccd1 vccd1 sky130_fd_sc_hd__diode_2
Xinput1 gpio_in[0] vssd1 vssd1 vccd1 vccd1 net1 sky130_fd_sc_hd__clkbuf_4
XANTENNA__07563__B1 net80 vssd1 vssd1 vccd1 vccd1 sky130_fd_sc_hd__diode_2
X_06803_ FPGA_INST.cell2.CB_1.config_dataB\[19\] _03052_ _03066_ _03074_ _03076_ vssd1
+ vssd1 vccd1 vccd1 _03077_ sky130_fd_sc_hd__a311o_1
XANTENNA__06366__B2 _02168_ vssd1 vssd1 vccd1 vccd1 sky130_fd_sc_hd__diode_2
XANTENNA__06905__A3 FPGA_INST.bus2_0\[11\] vssd1 vssd1 vccd1 vccd1 sky130_fd_sc_hd__diode_2
XFILLER_28_118 vssd1 vssd1 vccd1 vccd1 sky130_fd_sc_hd__fill_8
X_09522_ FPGA_INST.cell1.LE_0A.reset_val FPGA_INST.cell1.LE_0A.edge_mode net345 vssd1
+ vssd1 vccd1 vccd1 _00433_ sky130_fd_sc_hd__mux2_1
X_07783_ _03549_ _03913_ FPGA_INST.bus3_1\[15\] vssd1 vssd1 vccd1 vccd1 _04032_ sky130_fd_sc_hd__o21ai_1
X_06734_ FPGA_INST.cell2.CB_1.config_dataB\[7\] _03007_ FPGA_INST.cell2.CB_1.config_dataB\[8\]
+ vssd1 vssd1 vccd1 vccd1 _03008_ sky130_fd_sc_hd__a21oi_1
XTAP_TAPCELL_ROW_69_1250 vssd1 vccd1 sky130_fd_sc_hd__tapvpwrvgnd_1
XFILLER_37_663 vssd1 vssd1 vccd1 vccd1 sky130_fd_sc_hd__fill_8
X_09453_ FPGA_INST.cell1.LEI0.config_data\[0\] FPGA_INST.cell1.LE_1A.reset_mode net333
+ vssd1 vssd1 vccd1 vccd1 _00365_ sky130_fd_sc_hd__mux2_1
XFILLER_91_290 vssd1 vssd1 vccd1 vccd1 sky130_fd_sc_hd__fill_2
X_06665_ net138 net128 FPGA_INST.cell2.LEI0.config_data\[42\] vssd1 vssd1 vccd1 vccd1
+ _02941_ sky130_fd_sc_hd__mux2_1
XANTENNA_fanout252_A net267 vssd1 vssd1 vccd1 vccd1 sky130_fd_sc_hd__diode_2
X_05616_ FPGA_INST.cell2.CB_1.config_dataA\[24\] FPGA_INST.cell2.CB_1.config_dataA\[21\]
+ FPGA_INST.cell2.CB_1.config_dataA\[20\] vssd1 vssd1 vccd1 vccd1 _01896_ sky130_fd_sc_hd__nand3b_2
X_08404_ FPGA_INST.cell0.CB_1.config_dataB\[18\] _04625_ vssd1 vssd1 vccd1 vccd1 _04626_
+ sky130_fd_sc_hd__nor2_1
X_09384_ FPGA_INST.cell2.CB_0.config_dataB\[3\] FPGA_INST.cell2.CB_0.config_dataB\[2\]
+ net356 vssd1 vssd1 vccd1 vccd1 _00297_ sky130_fd_sc_hd__mux2_1
XFILLER_101_69 vssd1 vssd1 vccd1 vccd1 sky130_fd_sc_hd__fill_4
X_08335_ FPGA_INST.cell0.CB_1.config_dataB\[2\] _04556_ vssd1 vssd1 vccd1 vccd1 _04557_
+ sky130_fd_sc_hd__nor2_1
XFILLER_51_198 vssd1 vssd1 vccd1 vccd1 sky130_fd_sc_hd__fill_4
XFILLER_51_165 vssd1 vssd1 vccd1 vccd1 sky130_fd_sc_hd__fill_2
X_06596_ FPGA_INST.cell2.CB_1.config_dataA\[2\] _02870_ _02871_ _02868_ FPGA_INST.cell2.CB_1.config_dataA\[3\]
+ vssd1 vssd1 vccd1 vccd1 _02872_ sky130_fd_sc_hd__a311o_1
X_05547_ net96 net383 net382 _01825_ _01826_ vssd1 vssd1 vccd1 vccd1 _01827_ sky130_fd_sc_hd__o32a_1
X_08266_ net73 net95 FPGA_INST.bus1_0\[2\] FPGA_INST.bus1_0\[3\] net404 FPGA_INST.cell0.CB_1.config_dataA\[16\]
+ vssd1 vssd1 vccd1 vccd1 _04490_ sky130_fd_sc_hd__mux4_1
X_05478_ FPGA_INST.cell0.CB_1.config_dataB\[17\] vssd1 vssd1 vccd1 vccd1 _01760_ sky130_fd_sc_hd__inv_2
XANTENNA__06525__X _02801_ vssd1 vssd1 vccd1 vccd1 sky130_fd_sc_hd__diode_2
XANTENNA__06672__S _02878_ vssd1 vssd1 vccd1 vccd1 sky130_fd_sc_hd__diode_2
XANTENNA_fanout305_X net305 vssd1 vssd1 vccd1 vccd1 sky130_fd_sc_hd__diode_2
X_08197_ _04418_ _04420_ _01754_ vssd1 vssd1 vccd1 vccd1 _04421_ sky130_fd_sc_hd__mux2_1
X_07217_ _03479_ vssd1 vssd1 vccd1 vccd1 _03480_ sky130_fd_sc_hd__inv_2
XANTENNA__08043__A1 FPGA_INST.bus3_1\[1\] vssd1 vssd1 vccd1 vccd1 sky130_fd_sc_hd__diode_2
X_07148_ FPGA_INST.cell1.CB_1.config_dataA\[23\] FPGA_INST.cell1.CB_1.config_dataA\[22\]
+ _03411_ vssd1 vssd1 vccd1 vccd1 _03412_ sky130_fd_sc_hd__or3_1
XFILLER_106_668 vssd1 vssd1 vccd1 vccd1 sky130_fd_sc_hd__fill_1
XFILLER_10_33 vssd1 vssd1 vccd1 vccd1 sky130_fd_sc_hd__fill_1
XFILLER_105_178 vssd1 vssd1 vccd1 vccd1 sky130_fd_sc_hd__fill_8
XFILLER_105_167 vssd1 vssd1 vccd1 vccd1 sky130_fd_sc_hd__fill_1
X_07079_ net114 net118 net110 net98 FPGA_INST.cell0.LEI0.config_data\[24\] FPGA_INST.cell0.LEI0.config_data\[25\]
+ vssd1 vssd1 vccd1 vccd1 _03345_ sky130_fd_sc_hd__mux4_1
XFILLER_126_88 vssd1 vssd1 vccd1 vccd1 sky130_fd_sc_hd__fill_8
XFILLER_121_649 vssd1 vssd1 vccd1 vccd1 sky130_fd_sc_hd__fill_2
XFILLER_120_115 vssd1 vssd1 vccd1 vccd1 sky130_fd_sc_hd__fill_8
XTAP_TAPCELL_ROW_93_1590 vssd1 vccd1 sky130_fd_sc_hd__tapvpwrvgnd_1
XANTENNA__07356__X _03616_ vssd1 vssd1 vccd1 vccd1 sky130_fd_sc_hd__diode_2
X_10090_ FPGA_INST.cell0.LE_1B.config_data\[15\] FPGA_INST.cell0.LE_1B.config_data\[14\]
+ net307 vssd1 vssd1 vccd1 vccd1 _00971_ sky130_fd_sc_hd__mux2_1
XANTENNA__06357__A1 net8 vssd1 vssd1 vccd1 vccd1 sky130_fd_sc_hd__diode_2
XFILLER_75_725 vssd1 vssd1 vccd1 vccd1 sky130_fd_sc_hd__fill_2
XFILLER_59_276 vssd1 vssd1 vccd1 vccd1 sky130_fd_sc_hd__fill_2
XFILLER_75_758 vssd1 vssd1 vccd1 vccd1 sky130_fd_sc_hd__fill_2
XANTENNA__07306__B1 FPGA_INST.cell1.SB0.route_sel\[31\] vssd1 vssd1 vccd1 vccd1 sky130_fd_sc_hd__diode_2
X_10992_ net856 _00342_ net641 vssd1 vssd1 vccd1 vccd1 FPGA_INST.cell2.CB_1.config_dataA\[23\]
+ sky130_fd_sc_hd__dfstp_1
XFILLER_62_419 vssd1 vssd1 vccd1 vccd1 sky130_fd_sc_hd__fill_1
XFILLER_15_302 vssd1 vssd1 vccd1 vccd1 sky130_fd_sc_hd__fill_1
XFILLER_28_685 vssd1 vssd1 vccd1 vccd1 sky130_fd_sc_hd__fill_1
XANTENNA__07857__B2 _03475_ vssd1 vssd1 vccd1 vccd1 sky130_fd_sc_hd__diode_2
XANTENNA__07857__A1 _03421_ vssd1 vssd1 vccd1 vccd1 sky130_fd_sc_hd__diode_2
XANTENNA__09223__S net367 vssd1 vssd1 vccd1 vccd1 sky130_fd_sc_hd__diode_2
XFILLER_15_335 vssd1 vssd1 vccd1 vccd1 sky130_fd_sc_hd__fill_1
XFILLER_27_195 vssd1 vssd1 vccd1 vccd1 sky130_fd_sc_hd__fill_4
XPHY_EDGE_ROW_106_Left_237 vssd1 vssd1 vccd1 vccd1 sky130_fd_sc_hd__decap_3
XANTENNA__08806__A0 net22 vssd1 vssd1 vccd1 vccd1 sky130_fd_sc_hd__diode_2
X_11613_ net741 _00963_ net526 vssd1 vssd1 vccd1 vccd1 FPGA_INST.cell0.LE_1B.config_data\[7\]
+ sky130_fd_sc_hd__dfrtp_1
XANTENNA__08634__Y _04843_ vssd1 vssd1 vccd1 vccd1 sky130_fd_sc_hd__diode_2
XTAP_TAPCELL_ROW_41_856 vssd1 vccd1 sky130_fd_sc_hd__tapvpwrvgnd_1
X_11544_ net772 _00894_ net557 vssd1 vssd1 vccd1 vccd1 FPGA_INST.cell0.CB_0.config_dataA\[13\]
+ sky130_fd_sc_hd__dfstp_1
XFILLER_128_259 vssd1 vssd1 vccd1 vccd1 sky130_fd_sc_hd__fill_1
XFILLER_109_440 vssd1 vssd1 vccd1 vccd1 sky130_fd_sc_hd__fill_4
XTAP_TAPCELL_ROW_21_580 vssd1 vccd1 sky130_fd_sc_hd__tapvpwrvgnd_1
X_11475_ net745 _00825_ net530 vssd1 vssd1 vccd1 vccd1 FPGA_INST.cell0.LE_1A.config_data\[2\]
+ sky130_fd_sc_hd__dfrtp_1
X_10426_ FPGA_INST.cell3.CB_1.config_dataB\[24\] FPGA_INST.cell3.CB_1.config_dataB\[23\]
+ net368 vssd1 vssd1 vccd1 vccd1 _01305_ sky130_fd_sc_hd__mux2_1
XANTENNA__08034__A1 net145 vssd1 vssd1 vccd1 vccd1 sky130_fd_sc_hd__diode_2
XFILLER_109_462 vccd1 vssd1 vccd1 vssd1 sky130_ef_sc_hd__decap_40_12
XPHY_EDGE_ROW_115_Left_246 vssd1 vssd1 vccd1 vccd1 sky130_fd_sc_hd__decap_3
X_10357_ FPGA_INST.cell3.LE_1A.dff1_out net525 _05245_ vssd1 vssd1 vccd1 vccd1 _01237_
+ sky130_fd_sc_hd__a21bo_1
X_10288_ FPGA_INST.cell3.LEI0.config_data\[2\] FPGA_INST.cell3.LEI0.config_data\[3\]
+ net296 vssd1 vssd1 vccd1 vccd1 _01169_ sky130_fd_sc_hd__mux2_1
XFILLER_78_530 vssd1 vssd1 vccd1 vccd1 sky130_fd_sc_hd__fill_2
X_12027_ net858 _01373_ net643 vssd1 vssd1 vccd1 vccd1 FPGA_INST.cell2.SB0.route_sel\[67\]
+ sky130_fd_sc_hd__dfstp_1
XFILLER_120_660 vssd1 vssd1 vccd1 vccd1 sky130_fd_sc_hd__fill_1
XFILLER_93_511 vssd1 vssd1 vccd1 vccd1 sky130_fd_sc_hd__fill_1
XANTENNA__07545__B1 net141 vssd1 vssd1 vccd1 vccd1 sky130_fd_sc_hd__diode_2
XFILLER_38_405 vccd1 vssd1 vccd1 vssd1 sky130_ef_sc_hd__decap_40_12
XFILLER_76_81 vssd1 vssd1 vccd1 vccd1 sky130_fd_sc_hd__fill_2
XTAP_TAPCELL_ROW_49_967 vssd1 vccd1 sky130_fd_sc_hd__tapvpwrvgnd_1
XANTENNA__06899__A2 _01839_ vssd1 vssd1 vccd1 vccd1 sky130_fd_sc_hd__diode_2
XPHY_EDGE_ROW_124_Left_255 vssd1 vssd1 vccd1 vccd1 sky130_fd_sc_hd__decap_3
XTAP_TAPCELL_ROW_105_1748 vssd1 vccd1 sky130_fd_sc_hd__tapvpwrvgnd_1
XFILLER_74_780 vccd1 vssd1 vccd1 vssd1 sky130_ef_sc_hd__decap_40_12
XFILLER_46_493 vssd1 vssd1 vccd1 vccd1 sky130_fd_sc_hd__fill_2
XFILLER_18_195 vssd1 vssd1 vccd1 vccd1 sky130_fd_sc_hd__fill_1
XTAP_TAPCELL_ROW_29_691 vssd1 vccd1 sky130_fd_sc_hd__tapvpwrvgnd_1
XTAP_TAPCELL_ROW_105_1759 vssd1 vccd1 sky130_fd_sc_hd__tapvpwrvgnd_1
X_06450_ net487 net489 vssd1 vssd1 vccd1 vccd1 _02728_ sky130_fd_sc_hd__and2b_2
X_05401_ FPGA_INST.cell1.SB0.route_sel\[42\] vssd1 vssd1 vccd1 vccd1 _01683_ sky130_fd_sc_hd__inv_2
XANTENNA__06058__A net170 vssd1 vssd1 vccd1 vccd1 sky130_fd_sc_hd__diode_2
XTAP_TAPCELL_ROW_64_1180 vssd1 vccd1 sky130_fd_sc_hd__tapvpwrvgnd_1
X_06381_ net497 _02217_ vssd1 vssd1 vccd1 vccd1 _02659_ sky130_fd_sc_hd__nand2_1
X_08120_ _03652_ _04335_ FPGA_INST.cell1.CB_0.config_dataB\[17\] vssd1 vssd1 vccd1
+ vccd1 _04346_ sky130_fd_sc_hd__o21ai_1
X_05332_ FPGA_INST.cell0.SB0.route_sel\[118\] vssd1 vssd1 vccd1 vccd1 _01614_ sky130_fd_sc_hd__inv_2
XANTENNA__07076__A2 FPGA_INST.bus2_0\[10\] vssd1 vssd1 vccd1 vccd1 sky130_fd_sc_hd__diode_2
X_08051_ _04264_ _04268_ _04272_ _04276_ vssd1 vssd1 vccd1 vccd1 _04277_ sky130_fd_sc_hd__o211a_1
X_05263_ FPGA_INST.cell2.CB_0.config_dataB\[19\] vssd1 vssd1 vccd1 vccd1 _01545_ sky130_fd_sc_hd__inv_2
XFILLER_128_793 vssd1 vssd1 vccd1 vccd1 sky130_fd_sc_hd__fill_2
XANTENNA__08025__A1 FPGA_INST.bus3_1\[9\] vssd1 vssd1 vccd1 vccd1 sky130_fd_sc_hd__diode_2
X_07002_ net433 _02070_ vssd1 vssd1 vccd1 vccd1 _03268_ sky130_fd_sc_hd__nand2_1
XFILLER_127_270 vssd1 vssd1 vccd1 vccd1 sky130_fd_sc_hd__fill_1
XANTENNA__06036__B1 FPGA_INST.bus3_2\[5\] vssd1 vssd1 vccd1 vccd1 sky130_fd_sc_hd__diode_2
XANTENNA__09308__S net327 vssd1 vssd1 vccd1 vccd1 sky130_fd_sc_hd__diode_2
XANTENNA__06521__A _02796_ vssd1 vssd1 vccd1 vccd1 sky130_fd_sc_hd__diode_2
X_08953_ FPGA_INST.cell2.SB0.route_sel\[74\] FPGA_INST.cell2.SB0.route_sel\[75\] vssd1
+ vssd1 vccd1 vccd1 _05142_ sky130_fd_sc_hd__nand2b_1
XFILLER_130_468 vssd1 vssd1 vccd1 vccd1 sky130_fd_sc_hd__fill_4
X_07904_ net471 net473 _03769_ vssd1 vssd1 vccd1 vccd1 _04132_ sky130_fd_sc_hd__or3_1
X_08884_ net386 _04801_ vssd1 vssd1 vccd1 vccd1 _05091_ sky130_fd_sc_hd__nand2_1
XFILLER_56_202 vssd1 vssd1 vccd1 vccd1 sky130_fd_sc_hd__fill_4
X_07835_ net123 _02208_ _04070_ vssd1 vssd1 vccd1 vccd1 _04071_ sky130_fd_sc_hd__o21a_1
X_07766_ _03991_ _03993_ _04014_ _04015_ vssd1 vssd1 vccd1 vccd1 _04016_ sky130_fd_sc_hd__a31oi_2
XANTENNA__10927__SET_B net636 vssd1 vssd1 vccd1 vccd1 sky130_fd_sc_hd__diode_2
X_09505_ FPGA_INST.cell1.LE_0A.config_data\[1\] FPGA_INST.cell1.LE_0A.config_data\[0\]
+ net344 vssd1 vssd1 vccd1 vccd1 _00416_ sky130_fd_sc_hd__mux2_1
X_06717_ FPGA_INST.cell2.LEI0.config_data\[11\] _02987_ _02989_ _02990_ vssd1 vssd1
+ vccd1 vccd1 _02991_ sky130_fd_sc_hd__o31a_1
XANTENNA__07839__A1 _02330_ vssd1 vssd1 vccd1 vccd1 sky130_fd_sc_hd__diode_2
X_07697_ net81 _03447_ _03907_ _03946_ _03947_ vssd1 vssd1 vccd1 vccd1 _03948_ sky130_fd_sc_hd__o311a_1
XTAP_TAPCELL_ROW_80_1409 vssd1 vccd1 sky130_fd_sc_hd__tapvpwrvgnd_1
X_09436_ FPGA_INST.cell2.LE_1B.config_data\[5\] FPGA_INST.cell2.LE_1B.config_data\[4\]
+ net379 vssd1 vssd1 vccd1 vccd1 _00349_ sky130_fd_sc_hd__mux2_1
XFILLER_52_452 vssd1 vssd1 vccd1 vccd1 sky130_fd_sc_hd__fill_2
XANTENNA_fanout634_A net676 vssd1 vssd1 vccd1 vccd1 sky130_fd_sc_hd__diode_2
X_06648_ net475 _02814_ vssd1 vssd1 vccd1 vccd1 _02924_ sky130_fd_sc_hd__nand2_1
XFILLER_12_305 vssd1 vssd1 vccd1 vccd1 sky130_fd_sc_hd__fill_1
X_06579_ _02824_ _02850_ _02851_ _02819_ _02854_ vssd1 vssd1 vccd1 vccd1 _02855_ sky130_fd_sc_hd__a221oi_1
XFILLER_8_309 vccd1 vssd1 vccd1 vssd1 sky130_ef_sc_hd__decap_40_12
X_09367_ net503 net502 net237 vssd1 vssd1 vccd1 vccd1 _00280_ sky130_fd_sc_hd__mux2_1
X_09298_ FPGA_INST.cell1.SB0.route_sel\[69\] FPGA_INST.cell1.SB0.route_sel\[70\] net209
+ vssd1 vssd1 vccd1 vccd1 _00211_ sky130_fd_sc_hd__mux2_1
XANTENNA__08264__A1 FPGA_INST.bus1_0\[5\] vssd1 vssd1 vccd1 vccd1 sky130_fd_sc_hd__diode_2
X_08318_ FPGA_INST.cell0.CB_1.config_dataB\[8\] _04528_ _04535_ _04539_ FPGA_INST.cell0.CB_1.config_dataB\[9\]
+ vssd1 vssd1 vccd1 vccd1 _04540_ sky130_fd_sc_hd__a221o_1
XANTENNA__07517__B1_N FPGA_INST.cell3.SB0.route_sel\[68\] vssd1 vssd1 vccd1 vccd1
+ sky130_fd_sc_hd__diode_2
X_08249_ net402 net403 vssd1 vssd1 vccd1 vccd1 _04473_ sky130_fd_sc_hd__nor2_1
XFILLER_125_207 vccd1 vssd1 vccd1 vssd1 sky130_ef_sc_hd__decap_40_12
XFILLER_118_292 vssd1 vssd1 vccd1 vccd1 sky130_fd_sc_hd__fill_8
XFILLER_118_270 vssd1 vssd1 vccd1 vccd1 sky130_fd_sc_hd__fill_2
XFILLER_108_3 vssd1 vssd1 vccd1 vccd1 sky130_fd_sc_hd__fill_1
X_11260_ net784 _00610_ net569 vssd1 vssd1 vccd1 vccd1 FPGA_INST.cell0.SB0.route_sel\[105\]
+ sky130_fd_sc_hd__dfstp_1
XFILLER_97_47 vssd1 vssd1 vccd1 vccd1 sky130_fd_sc_hd__fill_1
XFILLER_97_25 vssd1 vssd1 vccd1 vccd1 sky130_fd_sc_hd__fill_1
X_10211_ FPGA_INST.cell3.SB0.route_sel\[115\] FPGA_INST.cell3.SB0.route_sel\[116\]
+ net269 vssd1 vssd1 vccd1 vccd1 _01092_ sky130_fd_sc_hd__mux2_1
X_11191_ net779 _00541_ net564 vssd1 vssd1 vccd1 vccd1 FPGA_INST.cell0.SB0.route_sel\[36\]
+ sky130_fd_sc_hd__dfstp_1
X_10142_ FPGA_INST.cell3.SB0.route_sel\[46\] FPGA_INST.cell3.SB0.route_sel\[47\] net277
+ vssd1 vssd1 vccd1 vccd1 _01023_ sky130_fd_sc_hd__mux2_1
XFILLER_79_349 vssd1 vssd1 vccd1 vccd1 sky130_fd_sc_hd__fill_4
XFILLER_121_446 vssd1 vssd1 vccd1 vccd1 sky130_fd_sc_hd__fill_2
X_10073_ FPGA_INST.cell0.CB_1.config_dataA\[22\] FPGA_INST.cell0.CB_1.config_dataA\[23\]
+ net187 vssd1 vssd1 vccd1 vccd1 _00954_ sky130_fd_sc_hd__mux2_1
XTAP_TAPCELL_ROW_7_375 vssd1 vccd1 sky130_fd_sc_hd__tapvpwrvgnd_1
XFILLER_102_682 vssd1 vssd1 vccd1 vccd1 sky130_fd_sc_hd__fill_1
XFILLER_47_202 vssd1 vssd1 vccd1 vccd1 sky130_fd_sc_hd__fill_2
XTAP_TAPCELL_ROW_7_386 vssd1 vccd1 sky130_fd_sc_hd__tapvpwrvgnd_1
XFILLER_0_798 vssd1 vssd1 vccd1 vccd1 sky130_fd_sc_hd__fill_1
XANTENNA_input28_A gpio_in[7] vssd1 vssd1 vccd1 vccd1 sky130_fd_sc_hd__diode_2
XTAP_TAPCELL_ROW_46_926 vssd1 vccd1 sky130_fd_sc_hd__tapvpwrvgnd_1
XFILLER_47_279 vssd1 vssd1 vccd1 vccd1 sky130_fd_sc_hd__fill_1
XFILLER_47_268 vssd1 vssd1 vccd1 vccd1 sky130_fd_sc_hd__fill_1
XFILLER_35_419 vssd1 vssd1 vccd1 vccd1 sky130_fd_sc_hd__fill_1
XANTENNA__06750__A1 _02823_ vssd1 vssd1 vccd1 vccd1 sky130_fd_sc_hd__diode_2
Xmax_cap74 FPGA_INST.bus1_0\[6\] vssd1 vssd1 vccd1 vccd1 net74 sky130_fd_sc_hd__clkbuf_2
XFILLER_71_761 vssd1 vssd1 vccd1 vccd1 sky130_fd_sc_hd__fill_2
X_10975_ net881 _00325_ net666 vssd1 vssd1 vccd1 vccd1 FPGA_INST.cell2.CB_1.config_dataA\[6\]
+ sky130_fd_sc_hd__dfstp_1
XFILLER_16_666 vssd1 vssd1 vccd1 vccd1 sky130_fd_sc_hd__fill_1
XFILLER_94_9 vssd1 vssd1 vccd1 vccd1 sky130_fd_sc_hd__fill_1
XFILLER_71_794 vssd1 vssd1 vccd1 vccd1 sky130_fd_sc_hd__fill_4
XFILLER_15_176 vssd1 vssd1 vccd1 vccd1 sky130_fd_sc_hd__fill_1
XFILLER_16_688 vssd1 vssd1 vccd1 vccd1 sky130_fd_sc_hd__fill_2
XFILLER_16_699 vssd1 vssd1 vccd1 vccd1 sky130_fd_sc_hd__fill_1
XTAP_TAPCELL_ROW_26_650 vssd1 vccd1 sky130_fd_sc_hd__tapvpwrvgnd_1
XFILLER_30_113 vssd1 vssd1 vccd1 vccd1 sky130_fd_sc_hd__fill_1
XTAP_TAPCELL_ROW_100_1678 vssd1 vccd1 sky130_fd_sc_hd__tapvpwrvgnd_1
XANTENNA__08255__A1 _03959_ vssd1 vssd1 vccd1 vccd1 sky130_fd_sc_hd__diode_2
X_11527_ net810 _00877_ net593 vssd1 vssd1 vccd1 vccd1 FPGA_INST.config_bits\[8\]
+ sky130_fd_sc_hd__dfstp_1
XANTENNA__05510__A net79 vssd1 vssd1 vccd1 vccd1 sky130_fd_sc_hd__diode_2
XTAP_TAPCELL_ROW_100_1689 vssd1 vccd1 sky130_fd_sc_hd__tapvpwrvgnd_1
XFILLER_11_393 vssd1 vssd1 vccd1 vccd1 sky130_fd_sc_hd__fill_1
XFILLER_7_67 vssd1 vssd1 vccd1 vccd1 sky130_fd_sc_hd__fill_2
XFILLER_109_281 vssd1 vssd1 vccd1 vccd1 sky130_fd_sc_hd__fill_1
X_11458_ net751 _00808_ net536 vssd1 vssd1 vccd1 vccd1 FPGA_INST.cell0.LE_0B.config_data\[7\]
+ sky130_fd_sc_hd__dfrtp_1
X_10409_ FPGA_INST.cell3.CB_1.config_dataB\[7\] FPGA_INST.cell3.CB_1.config_dataB\[6\]
+ net370 vssd1 vssd1 vccd1 vccd1 _01288_ sky130_fd_sc_hd__mux2_1
XFILLER_125_763 vssd1 vssd1 vccd1 vccd1 sky130_fd_sc_hd__fill_8
XANTENNA__10562__S net374 vssd1 vssd1 vccd1 vccd1 sky130_fd_sc_hd__diode_2
XANTENNA__07708__Y _03959_ vssd1 vssd1 vccd1 vccd1 sky130_fd_sc_hd__diode_2
X_11389_ net761 _00739_ net546 vssd1 vssd1 vccd1 vccd1 FPGA_INST.cell0.LEI0.config_data\[10\]
+ sky130_fd_sc_hd__dfrtp_1
XFILLER_112_468 vssd1 vssd1 vccd1 vccd1 sky130_fd_sc_hd__fill_8
XFILLER_23_3 vssd1 vssd1 vccd1 vccd1 sky130_fd_sc_hd__fill_4
X_05950_ _02220_ _02225_ _02228_ net317 vssd1 vssd1 vccd1 vccd1 _02230_ sky130_fd_sc_hd__a211o_1
XFILLER_93_330 vssd1 vssd1 vccd1 vccd1 sky130_fd_sc_hd__fill_4
X_05881_ net135 _02159_ vssd1 vssd1 vccd1 vccd1 _02161_ sky130_fd_sc_hd__nor2_1
XFILLER_81_503 vssd1 vssd1 vccd1 vccd1 sky130_fd_sc_hd__fill_1
X_07620_ FPGA_INST.cell0.SB0.route_sel\[94\] _01638_ vssd1 vssd1 vccd1 vccd1 _03873_
+ sky130_fd_sc_hd__nand2_1
XFILLER_26_419 vssd1 vssd1 vccd1 vccd1 sky130_fd_sc_hd__fill_1
X_07551_ _03790_ _03803_ _03804_ vssd1 vssd1 vccd1 vccd1 _03806_ sky130_fd_sc_hd__o21ai_2
XFILLER_62_750 vssd1 vssd1 vccd1 vccd1 sky130_fd_sc_hd__fill_4
X_06502_ FPGA_INST.cell2.SB0.route_sel\[12\] FPGA_INST.cell2.SB0.route_sel\[13\] vssd1
+ vssd1 vccd1 vccd1 _02778_ sky130_fd_sc_hd__nor2_1
X_07482_ net94 _03738_ _03737_ vssd1 vssd1 vccd1 vccd1 _03739_ sky130_fd_sc_hd__mux2_1
XFILLER_21_102 vssd1 vssd1 vccd1 vccd1 sky130_fd_sc_hd__fill_1
X_09221_ FPGA_INST.cell2.CB_1.config_dataB\[18\] FPGA_INST.cell2.CB_1.config_dataB\[17\]
+ net373 vssd1 vssd1 vccd1 vccd1 _00134_ sky130_fd_sc_hd__mux2_1
X_06433_ FPGA_INST.cell2.CB_0.config_dataB\[11\] _02710_ vssd1 vssd1 vccd1 vccd1 _02711_
+ sky130_fd_sc_hd__and2_1
X_09152_ FPGA_INST.cell2.LE_0A.config_data\[15\] FPGA_INST.cell2.LE_0A.config_data\[16\]
+ net252 vssd1 vssd1 vccd1 vccd1 _00067_ sky130_fd_sc_hd__mux2_1
X_06364_ net494 _02092_ vssd1 vssd1 vccd1 vccd1 _02642_ sky130_fd_sc_hd__nand2_1
XTAP_TAPCELL_ROW_118_1928 vssd1 vccd1 sky130_fd_sc_hd__tapvpwrvgnd_1
X_08103_ FPGA_INST.cell1.LEI0.config_data\[29\] _04328_ vssd1 vssd1 vccd1 vccd1 _04329_
+ sky130_fd_sc_hd__nand2b_1
X_05315_ FPGA_INST.cell2.CB_1.config_dataB\[14\] vssd1 vssd1 vccd1 vccd1 _01597_ sky130_fd_sc_hd__inv_2
XTAP_TAPCELL_ROW_118_1939 vssd1 vccd1 sky130_fd_sc_hd__tapvpwrvgnd_1
X_09083_ net736 _02618_ vssd1 vssd1 vccd1 vccd1 _05209_ sky130_fd_sc_hd__nand2_1
X_06295_ net499 net500 vssd1 vssd1 vccd1 vccd1 _02575_ sky130_fd_sc_hd__and2b_2
X_08034_ net152 net145 FPGA_INST.cell1.CB_1.le_outA net143 FPGA_INST.cell1.LEI0.config_data\[15\]
+ FPGA_INST.cell1.LEI0.config_data\[16\] vssd1 vssd1 vccd1 vccd1 _04260_ sky130_fd_sc_hd__mux4_1
XTAP_TAPCELL_ROW_77_1360 vssd1 vccd1 sky130_fd_sc_hd__tapvpwrvgnd_1
XFILLER_107_24 vssd1 vssd1 vccd1 vccd1 sky130_fd_sc_hd__fill_4
XFILLER_89_625 vssd1 vssd1 vccd1 vccd1 sky130_fd_sc_hd__fill_4
XFILLER_88_124 vssd1 vssd1 vccd1 vccd1 sky130_fd_sc_hd__fill_2
X_09985_ FPGA_INST.config_bits\[7\] _05221_ vssd1 vssd1 vccd1 vccd1 _05235_ sky130_fd_sc_hd__nor2_1
XANTENNA_fanout584_A net588 vssd1 vssd1 vccd1 vccd1 sky130_fd_sc_hd__diode_2
X_08936_ FPGA_INST.cell2.SB0.route_sel\[88\] _01574_ _01576_ _01577_ _05130_ vssd1
+ vssd1 vccd1 vccd1 _05131_ sky130_fd_sc_hd__a221o_1
XANTENNA_fanout372_X net372 vssd1 vssd1 vccd1 vccd1 sky130_fd_sc_hd__diode_2
X_08867_ FPGA_INST.cell3.CB_0.config_dataB\[16\] net387 vssd1 vssd1 vccd1 vccd1 _05074_
+ sky130_fd_sc_hd__and2b_1
XTAP_TAPCELL_ROW_4_345 vssd1 vccd1 sky130_fd_sc_hd__tapvpwrvgnd_1
XTAP_TAPCELL_ROW_4_334 vssd1 vccd1 sky130_fd_sc_hd__tapvpwrvgnd_1
XFILLER_29_235 vssd1 vssd1 vccd1 vccd1 sky130_fd_sc_hd__fill_1
XFILLER_84_363 vssd1 vssd1 vccd1 vccd1 sky130_fd_sc_hd__fill_1
X_07818_ net485 net486 _01903_ _01911_ _01913_ vssd1 vssd1 vccd1 vccd1 _04062_ sky130_fd_sc_hd__a32o_1
XFILLER_29_257 vccd1 vssd1 vccd1 vssd1 sky130_ef_sc_hd__decap_40_12
XFILLER_29_279 vssd1 vssd1 vccd1 vccd1 sky130_fd_sc_hd__fill_1
XANTENNA_fanout849_A net862 vssd1 vssd1 vccd1 vccd1 sky130_fd_sc_hd__diode_2
X_08798_ _01774_ net391 vssd1 vssd1 vccd1 vccd1 _05005_ sky130_fd_sc_hd__nor2_1
XFILLER_84_396 vssd1 vssd1 vccd1 vccd1 sky130_fd_sc_hd__fill_4
XFILLER_83_27 vccd1 vssd1 vccd1 vssd1 sky130_ef_sc_hd__decap_40_12
XFILLER_72_547 vssd1 vssd1 vccd1 vccd1 sky130_fd_sc_hd__fill_4
X_07749_ FPGA_INST.cell1.SB0.route_sel\[114\] FPGA_INST.cell1.SB0.route_sel\[115\]
+ vssd1 vssd1 vccd1 vccd1 _03999_ sky130_fd_sc_hd__nand2_1
XFILLER_53_750 vccd1 vssd1 vccd1 vssd1 sky130_ef_sc_hd__decap_40_12
XFILLER_53_783 vssd1 vssd1 vccd1 vccd1 sky130_fd_sc_hd__fill_1
X_10760_ net884 _00110_ net668 vssd1 vssd1 vccd1 vccd1 FPGA_INST.cell2.LE_1A.config_data\[15\]
+ sky130_fd_sc_hd__dfrtp_1
X_09419_ FPGA_INST.cell2.CB_1.config_dataA\[13\] FPGA_INST.cell2.CB_1.config_dataA\[12\]
+ net360 vssd1 vssd1 vccd1 vccd1 _00332_ sky130_fd_sc_hd__mux2_1
XFILLER_12_124 vssd1 vssd1 vccd1 vccd1 sky130_fd_sc_hd__fill_1
XFILLER_13_658 vssd1 vssd1 vccd1 vccd1 sky130_fd_sc_hd__fill_1
X_10691_ net866 _00041_ net652 vssd1 vssd1 vccd1 vccd1 FPGA_INST.cell2.LEI0.config_data\[40\]
+ sky130_fd_sc_hd__dfrtp_1
XANTENNA__08237__A1 FPGA_INST.bus1_0\[11\] vssd1 vssd1 vccd1 vccd1 sky130_fd_sc_hd__diode_2
XFILLER_8_117 vssd1 vssd1 vccd1 vccd1 sky130_fd_sc_hd__fill_4
XFILLER_12_146 vssd1 vssd1 vccd1 vccd1 sky130_fd_sc_hd__fill_1
XTAP_TAPCELL_ROW_51_995 vssd1 vccd1 sky130_fd_sc_hd__tapvpwrvgnd_1
XFILLER_126_516 vssd1 vssd1 vccd1 vccd1 sky130_fd_sc_hd__fill_1
XFILLER_20_190 vssd1 vssd1 vccd1 vccd1 sky130_fd_sc_hd__fill_4
X_11312_ net905 _00662_ net689 vssd1 vssd1 vccd1 vccd1 FPGA_INST.cell1.CB_0.config_dataB\[4\]
+ sky130_fd_sc_hd__dfstp_1
XFILLER_4_334 vssd1 vssd1 vccd1 vccd1 sky130_fd_sc_hd__fill_2
X_11243_ net768 _00593_ net553 vssd1 vssd1 vccd1 vccd1 FPGA_INST.cell0.SB0.route_sel\[88\]
+ sky130_fd_sc_hd__dfstp_1
XFILLER_79_113 vssd1 vssd1 vccd1 vccd1 sky130_fd_sc_hd__fill_1
X_11174_ net785 _00524_ net570 vssd1 vssd1 vccd1 vccd1 FPGA_INST.cell0.SB0.route_sel\[19\]
+ sky130_fd_sc_hd__dfstp_1
X_10125_ FPGA_INST.cell3.SB0.route_sel\[29\] FPGA_INST.cell3.SB0.route_sel\[30\] net270
+ vssd1 vssd1 vccd1 vccd1 _01006_ sky130_fd_sc_hd__mux2_1
XFILLER_121_298 vssd1 vssd1 vccd1 vccd1 sky130_fd_sc_hd__fill_2
XFILLER_102_490 vssd1 vssd1 vccd1 vccd1 sky130_fd_sc_hd__fill_2
X_10056_ net408 net409 net312 vssd1 vssd1 vccd1 vccd1 _00937_ sky130_fd_sc_hd__mux2_1
XANTENNA__08173__A0 net73 vssd1 vssd1 vccd1 vccd1 sky130_fd_sc_hd__diode_2
XFILLER_90_311 vssd1 vssd1 vccd1 vccd1 sky130_fd_sc_hd__fill_2
XFILLER_29_780 vssd1 vssd1 vccd1 vccd1 sky130_fd_sc_hd__fill_4
XFILLER_44_750 vssd1 vssd1 vccd1 vccd1 sky130_fd_sc_hd__fill_4
XTAP_TAPCELL_ROW_102_1707 vssd1 vccd1 sky130_fd_sc_hd__tapvpwrvgnd_1
X_10958_ net867 _00308_ net651 vssd1 vssd1 vccd1 vccd1 FPGA_INST.cell2.CB_0.config_dataB\[14\]
+ sky130_fd_sc_hd__dfstp_1
XANTENNA__10557__S net374 vssd1 vssd1 vccd1 vccd1 sky130_fd_sc_hd__diode_2
XFILLER_43_293 vccd1 vssd1 vccd1 vssd1 sky130_ef_sc_hd__decap_40_12
X_10889_ net825 _00239_ net609 vssd1 vssd1 vccd1 vccd1 FPGA_INST.cell1.SB0.route_sel\[98\]
+ sky130_fd_sc_hd__dfstp_1
XFILLER_117_505 vssd1 vssd1 vccd1 vccd1 sky130_fd_sc_hd__fill_4
XANTENNA__07451__A2 _03542_ vssd1 vssd1 vccd1 vccd1 sky130_fd_sc_hd__diode_2
X_06080_ _01896_ _02358_ vssd1 vssd1 vccd1 vccd1 _02360_ sky130_fd_sc_hd__or2_1
XPHY_EDGE_ROW_9_Right_9 vssd1 vssd1 vccd1 vccd1 sky130_fd_sc_hd__decap_3
XFILLER_113_733 vssd1 vssd1 vccd1 vccd1 sky130_fd_sc_hd__fill_2
XFILLER_113_711 vssd1 vssd1 vccd1 vccd1 sky130_fd_sc_hd__fill_1
XTAP_TAPCELL_ROW_113_1858 vssd1 vccd1 sky130_fd_sc_hd__tapvpwrvgnd_1
XANTENNA__07739__B1 net130 vssd1 vssd1 vccd1 vccd1 sky130_fd_sc_hd__diode_2
Xfanout619 net621 vssd1 vssd1 vccd1 vccd1 net619 sky130_fd_sc_hd__clkbuf_2
XTAP_TAPCELL_ROW_113_1869 vssd1 vccd1 sky130_fd_sc_hd__tapvpwrvgnd_1
Xfanout608 net609 vssd1 vssd1 vccd1 vccd1 net608 sky130_fd_sc_hd__clkbuf_4
XANTENNA__08400__A1 _03465_ vssd1 vssd1 vccd1 vccd1 sky130_fd_sc_hd__diode_2
XANTENNA__08400__B2 _03408_ vssd1 vssd1 vccd1 vccd1 sky130_fd_sc_hd__diode_2
XPHY_EDGE_ROW_107_Right_107 vssd1 vssd1 vccd1 vccd1 sky130_fd_sc_hd__decap_3
X_09770_ FPGA_INST.cell1.CB_0.config_dataB\[20\] FPGA_INST.cell1.CB_0.config_dataB\[21\]
+ net226 vssd1 vssd1 vccd1 vccd1 _00679_ sky130_fd_sc_hd__mux2_1
X_06982_ net432 net434 vssd1 vssd1 vccd1 vccd1 _03248_ sky130_fd_sc_hd__nand2b_1
XFILLER_112_298 vssd1 vssd1 vccd1 vccd1 sky130_fd_sc_hd__fill_1
X_08721_ _04828_ _04928_ _04929_ _04831_ vssd1 vssd1 vccd1 vccd1 _04930_ sky130_fd_sc_hd__a2bb2o_1
XTAP_TAPCELL_ROW_72_1290 vssd1 vccd1 sky130_fd_sc_hd__tapvpwrvgnd_1
X_05933_ net135 _02210_ _02212_ _02196_ vssd1 vssd1 vccd1 vccd1 _02213_ sky130_fd_sc_hd__o211ai_1
X_08652_ net399 _04839_ vssd1 vssd1 vccd1 vccd1 _04861_ sky130_fd_sc_hd__or2_1
XFILLER_66_352 vccd1 vssd1 vccd1 vssd1 sky130_ef_sc_hd__decap_40_12
X_07603_ _03834_ _03855_ _03856_ _03847_ vssd1 vssd1 vccd1 vccd1 _03857_ sky130_fd_sc_hd__o211a_1
X_05864_ FPGA_INST.cell0.SB0.route_sel\[70\] _01661_ FPGA_INST.cell0.SB0.route_sel\[66\]
+ FPGA_INST.cell0.SB0.route_sel\[67\] _02143_ vssd1 vssd1 vccd1 vccd1 _02144_ sky130_fd_sc_hd__o221a_1
X_08583_ FPGA_INST.cell3.SB0.route_sel\[70\] FPGA_INST.cell3.SB0.route_sel\[71\] vssd1
+ vssd1 vccd1 vccd1 _04792_ sky130_fd_sc_hd__and2b_1
X_05795_ _01893_ _02036_ vssd1 vssd1 vccd1 vccd1 _02075_ sky130_fd_sc_hd__nand2_1
X_07534_ _03789_ _03787_ vssd1 vssd1 vccd1 vccd1 FPGA_INST.bus3_2\[8\] sky130_fd_sc_hd__and2b_1
X_07465_ FPGA_INST.cell1.SB0.route_sel\[63\] FPGA_INST.cell1.SB0.route_sel\[62\] _02182_
+ _03721_ _02183_ vssd1 vssd1 vccd1 vccd1 _03722_ sky130_fd_sc_hd__a221o_1
XANTENNA_fanout332_A net337 vssd1 vssd1 vccd1 vccd1 sky130_fd_sc_hd__diode_2
X_09204_ net519 net521 net362 vssd1 vssd1 vccd1 vccd1 _00117_ sky130_fd_sc_hd__mux2_1
X_06416_ _02131_ _02692_ _02693_ _02168_ FPGA_INST.cell2.CB_0.config_dataB\[12\] vssd1
+ vssd1 vccd1 vccd1 _02694_ sky130_fd_sc_hd__a221o_1
XANTENNA__06517__Y _02793_ vssd1 vssd1 vccd1 vccd1 sky130_fd_sc_hd__diode_2
X_07396_ _01990_ _02197_ _02804_ vssd1 vssd1 vccd1 vccd1 _03655_ sky130_fd_sc_hd__a21oi_1
X_06347_ _02450_ _02623_ _02624_ _02487_ FPGA_INST.cell2.CB_0.config_dataB\[7\] vssd1
+ vssd1 vccd1 vccd1 _02625_ sky130_fd_sc_hd__a221o_1
X_09135_ FPGA_INST.cell2.LE_0B.dff1_out net524 _05210_ vssd1 vssd1 vccd1 vccd1 _00050_
+ sky130_fd_sc_hd__a21bo_1
X_09066_ _03782_ _05200_ _03784_ vssd1 vssd1 vccd1 vccd1 net68 sky130_fd_sc_hd__o21ai_1
XANTENNA__06680__S _02878_ vssd1 vssd1 vccd1 vccd1 sky130_fd_sc_hd__diode_2
X_06278_ net3 net4 net503 vssd1 vssd1 vccd1 vccd1 _02558_ sky130_fd_sc_hd__mux2_1
X_08017_ _03475_ _04235_ _04236_ _03421_ FPGA_INST.cell1.CB_0.config_dataB\[7\] vssd1
+ vssd1 vccd1 vccd1 _04243_ sky130_fd_sc_hd__a221o_1
XANTENNA_fanout799_A net803 vssd1 vssd1 vccd1 vccd1 sky130_fd_sc_hd__diode_2
XTAP_TAPCELL_ROW_9_415 vssd1 vccd1 sky130_fd_sc_hd__tapvpwrvgnd_1
XTAP_TAPCELL_ROW_9_404 vssd1 vccd1 sky130_fd_sc_hd__tapvpwrvgnd_1
XFILLER_118_89 vssd1 vssd1 vccd1 vccd1 sky130_fd_sc_hd__fill_2
XFILLER_116_582 vssd1 vssd1 vccd1 vccd1 sky130_fd_sc_hd__fill_2
XFILLER_78_27 vssd1 vssd1 vccd1 vccd1 sky130_fd_sc_hd__fill_1
XFILLER_104_755 vssd1 vssd1 vccd1 vccd1 sky130_fd_sc_hd__fill_1
XFILLER_1_337 vssd1 vssd1 vccd1 vccd1 sky130_fd_sc_hd__fill_4
X_09968_ FPGA_INST.config_bits\[1\] FPGA_INST.config_bits\[0\] _05222_ _05223_ vssd1
+ vssd1 vccd1 vccd1 _00870_ sky130_fd_sc_hd__o22a_1
XFILLER_77_617 vssd1 vssd1 vccd1 vccd1 sky130_fd_sc_hd__fill_2
XANTENNA_fanout78_A net80 vssd1 vssd1 vccd1 vccd1 sky130_fd_sc_hd__diode_2
X_08919_ _05119_ _02007_ vssd1 vssd1 vccd1 vccd1 FPGA_INST.bus2_0\[13\] sky130_fd_sc_hd__and2b_2
XANTENNA__06953__A1 FPGA_INST.bus2_0\[3\] vssd1 vssd1 vccd1 vccd1 sky130_fd_sc_hd__diode_2
X_11930_ net943 _01276_ net727 vssd1 vssd1 vccd1 vccd1 FPGA_INST.cell3.LE_1A.config_data\[16\]
+ sky130_fd_sc_hd__dfrtp_1
XFILLER_69_190 vssd1 vssd1 vccd1 vccd1 sky130_fd_sc_hd__fill_1
X_09899_ FPGA_INST.cell0.LE_0B.config_data\[3\] FPGA_INST.cell0.LE_0B.config_data\[4\]
+ net177 vssd1 vssd1 vccd1 vccd1 _00805_ sky130_fd_sc_hd__mux2_1
XANTENNA__06705__A1 FPGA_INST.bus3_2\[5\] vssd1 vssd1 vccd1 vccd1 sky130_fd_sc_hd__diode_2
XFILLER_18_739 vssd1 vssd1 vccd1 vccd1 sky130_fd_sc_hd__fill_8
X_11861_ net937 _01207_ net721 vssd1 vssd1 vccd1 vccd1 FPGA_INST.cell3.LEI0.config_data\[41\]
+ sky130_fd_sc_hd__dfrtp_1
XFILLER_45_558 vssd1 vssd1 vccd1 vccd1 sky130_fd_sc_hd__fill_2
XANTENNA__08907__Y FPGA_INST.bus1_0\[14\] vssd1 vssd1 vccd1 vccd1 sky130_fd_sc_hd__diode_2
X_10812_ net827 _00162_ net611 vssd1 vssd1 vccd1 vccd1 FPGA_INST.cell1.SB0.route_sel\[21\]
+ sky130_fd_sc_hd__dfstp_1
X_11792_ net890 _01138_ net674 vssd1 vssd1 vccd1 vccd1 FPGA_INST.io_east_oeb\[4\]
+ sky130_fd_sc_hd__dfrtp_1
X_10743_ FPGA_INST.cell2.LE_1A.sel_clk _00093_ net734 vssd1 vssd1 vccd1 vccd1 FPGA_INST.cell2.LE_1A.dff0_out
+ sky130_fd_sc_hd__dfrtp_1
XANTENNA__10377__S net305 vssd1 vssd1 vccd1 vccd1 sky130_fd_sc_hd__diode_2
XFILLER_13_444 vssd1 vssd1 vccd1 vccd1 sky130_fd_sc_hd__fill_4
X_10674_ net884 _00024_ net668 vssd1 vssd1 vccd1 vccd1 FPGA_INST.cell2.LEI0.config_data\[23\]
+ sky130_fd_sc_hd__dfrtp_1
XANTENNA__10674__Q FPGA_INST.cell2.LEI0.config_data\[23\] vssd1 vssd1 vccd1 vccd1
+ sky130_fd_sc_hd__diode_2
XTAP_TAPCELL_ROW_130_2114 vssd1 vccd1 sky130_fd_sc_hd__tapvpwrvgnd_1
XTAP_TAPCELL_ROW_130_2103 vssd1 vccd1 sky130_fd_sc_hd__tapvpwrvgnd_1
X_11226_ net766 _00576_ net551 vssd1 vssd1 vccd1 vccd1 FPGA_INST.cell0.SB0.route_sel\[71\]
+ sky130_fd_sc_hd__dfstp_1
XFILLER_4_197 vccd1 vssd1 vccd1 vssd1 sky130_ef_sc_hd__decap_40_12
XFILLER_110_703 vssd1 vssd1 vccd1 vccd1 sky130_fd_sc_hd__fill_4
X_11157_ net779 _00507_ net564 vssd1 vssd1 vccd1 vccd1 FPGA_INST.cell0.SB0.route_sel\[2\]
+ sky130_fd_sc_hd__dfstp_1
XANTENNA__07274__X _03536_ vssd1 vssd1 vccd1 vccd1 sky130_fd_sc_hd__diode_2
X_10108_ FPGA_INST.cell3.SB0.route_sel\[13\] FPGA_INST.cell3.SB0.route_sel\[12\] net353
+ vssd1 vssd1 vccd1 vccd1 _00989_ sky130_fd_sc_hd__mux2_1
XANTENNA__09406__S net354 vssd1 vssd1 vccd1 vccd1 sky130_fd_sc_hd__diode_2
XTAP_TAPCELL_ROW_128_2076 vssd1 vccd1 sky130_fd_sc_hd__tapvpwrvgnd_1
X_11088_ net839 _00438_ net623 vssd1 vssd1 vccd1 vccd1 FPGA_INST.cell1.LE_0B.config_data\[1\]
+ sky130_fd_sc_hd__dfrtp_1
XFILLER_82_119 vssd1 vssd1 vccd1 vccd1 sky130_fd_sc_hd__fill_1
XFILLER_48_363 vssd1 vssd1 vccd1 vccd1 sky130_fd_sc_hd__fill_1
X_10039_ FPGA_INST.cell0.CB_0.config_dataB\[13\] FPGA_INST.cell0.CB_0.config_dataB\[14\]
+ net190 vssd1 vssd1 vccd1 vccd1 _00920_ sky130_fd_sc_hd__mux2_1
XFILLER_63_333 vssd1 vssd1 vccd1 vccd1 sky130_fd_sc_hd__fill_2
XANTENNA__08161__A3 FPGA_INST.bus1_0\[15\] vssd1 vssd1 vccd1 vccd1 sky130_fd_sc_hd__diode_2
X_05580_ FPGA_INST.cell2.CB_0.config_dataA\[23\] FPGA_INST.cell2.CB_0.config_dataA\[22\]
+ vssd1 vssd1 vccd1 vccd1 _01860_ sky130_fd_sc_hd__nand2_1
XANTENNA__09141__S net350 vssd1 vssd1 vccd1 vccd1 sky130_fd_sc_hd__diode_2
XTAP_TAPCELL_ROW_34_759 vssd1 vccd1 sky130_fd_sc_hd__tapvpwrvgnd_1
X_07250_ FPGA_INST.cell1.SB0.route_sel\[18\] FPGA_INST.cell1.SB0.route_sel\[19\] _03506_
+ _03510_ _03511_ vssd1 vssd1 vccd1 vccd1 _03512_ sky130_fd_sc_hd__a311o_1
XTAP_TAPCELL_ROW_14_472 vssd1 vccd1 sky130_fd_sc_hd__tapvpwrvgnd_1
XTAP_TAPCELL_ROW_14_483 vssd1 vccd1 sky130_fd_sc_hd__tapvpwrvgnd_1
XFILLER_32_797 vssd1 vssd1 vccd1 vccd1 sky130_fd_sc_hd__fill_2
X_07181_ FPGA_INST.cell3.SB0.route_sel\[5\] _01720_ _03444_ vssd1 vssd1 vccd1 vccd1
+ _03445_ sky130_fd_sc_hd__a21bo_1
X_06201_ net30 _02478_ _02479_ _02480_ vssd1 vssd1 vccd1 vccd1 _02481_ sky130_fd_sc_hd__o211a_1
X_06132_ FPGA_INST.cell2.SB0.route_sel\[22\] _01553_ FPGA_INST.cell2.SB0.route_sel\[18\]
+ FPGA_INST.cell2.SB0.route_sel\[19\] _02411_ vssd1 vssd1 vccd1 vccd1 _02412_ sky130_fd_sc_hd__o221a_1
XFILLER_105_508 vssd1 vssd1 vccd1 vccd1 sky130_fd_sc_hd__fill_8
X_06063_ FPGA_INST.cell0.SB0.route_sel\[27\] FPGA_INST.cell0.SB0.route_sel\[26\] _02339_
+ _02341_ _02342_ vssd1 vssd1 vccd1 vccd1 _02343_ sky130_fd_sc_hd__a221o_1
XFILLER_99_753 vssd1 vssd1 vccd1 vccd1 sky130_fd_sc_hd__fill_1
Xfanout405 FPGA_INST.cell0.CB_1.config_dataA\[11\] vssd1 vssd1 vccd1 vccd1 net405
+ sky130_fd_sc_hd__buf_2
XFILLER_101_725 vssd1 vssd1 vccd1 vccd1 sky130_fd_sc_hd__fill_1
Xfanout438 FPGA_INST.cell0.CB_1.config_dataB\[16\] vssd1 vssd1 vccd1 vccd1 net438
+ sky130_fd_sc_hd__buf_2
Xfanout416 FPGA_INST.cell0.CB_0.config_dataB\[15\] vssd1 vssd1 vccd1 vccd1 net416
+ sky130_fd_sc_hd__clkbuf_2
X_09822_ FPGA_INST.cell0.LEI0.config_data\[0\] FPGA_INST.cell0.LEI0.config_data\[1\]
+ net175 vssd1 vssd1 vccd1 vccd1 _00730_ sky130_fd_sc_hd__mux2_1
Xfanout427 FPGA_INST.cell0.CB_0.config_dataA\[15\] vssd1 vssd1 vccd1 vccd1 net427
+ sky130_fd_sc_hd__buf_2
X_09753_ FPGA_INST.cell1.CB_0.config_dataB\[3\] FPGA_INST.cell1.CB_0.config_dataB\[4\]
+ net232 vssd1 vssd1 vccd1 vccd1 _00662_ sky130_fd_sc_hd__mux2_1
XANTENNA__07184__X _03447_ vssd1 vssd1 vccd1 vccd1 sky130_fd_sc_hd__diode_2
Xfanout449 FPGA_INST.cell0.CB_1.config_dataB\[0\] vssd1 vssd1 vccd1 vccd1 net449 sky130_fd_sc_hd__clkbuf_2
X_08704_ FPGA_INST.cell3.CB_0.config_dataA\[12\] _04911_ _04912_ _04909_ _01770_ vssd1
+ vssd1 vccd1 vccd1 _04913_ sky130_fd_sc_hd__a311o_1
XFILLER_86_458 vssd1 vssd1 vccd1 vccd1 sky130_fd_sc_hd__fill_2
X_06965_ _03232_ _03231_ _03124_ vssd1 vssd1 vccd1 vccd1 _03233_ sky130_fd_sc_hd__mux2_1
XANTENNA__08688__A1 _04831_ vssd1 vssd1 vccd1 vccd1 sky130_fd_sc_hd__diode_2
X_09684_ FPGA_INST.cell0.SB0.route_sel\[88\] FPGA_INST.cell0.SB0.route_sel\[87\] net314
+ vssd1 vssd1 vccd1 vccd1 _00593_ sky130_fd_sc_hd__mux2_1
X_06896_ net417 net419 vssd1 vssd1 vccd1 vccd1 _03164_ sky130_fd_sc_hd__nand2b_1
X_05916_ FPGA_INST.cell2.SB0.route_sel\[56\] FPGA_INST.cell2.SB0.route_sel\[57\] vssd1
+ vssd1 vccd1 vccd1 _02196_ sky130_fd_sc_hd__nand2_1
XFILLER_27_503 vssd1 vssd1 vccd1 vccd1 sky130_fd_sc_hd__fill_1
XFILLER_27_536 vssd1 vssd1 vccd1 vccd1 sky130_fd_sc_hd__fill_1
X_08635_ FPGA_INST.cell3.SB0.route_sel\[42\] FPGA_INST.cell3.SB0.route_sel\[43\] vssd1
+ vssd1 vccd1 vccd1 _04844_ sky130_fd_sc_hd__nor2_1
XFILLER_82_642 vssd1 vssd1 vccd1 vccd1 sky130_fd_sc_hd__fill_2
X_05847_ _02115_ _02125_ _02126_ net355 vssd1 vssd1 vccd1 vccd1 _02127_ sky130_fd_sc_hd__a31o_1
XFILLER_27_558 vssd1 vssd1 vccd1 vccd1 sky130_fd_sc_hd__fill_2
XFILLER_27_569 vssd1 vssd1 vccd1 vccd1 sky130_fd_sc_hd__fill_8
X_08566_ _04776_ _04769_ _04765_ vssd1 vssd1 vccd1 vccd1 _04777_ sky130_fd_sc_hd__mux2_1
XFILLER_82_686 vssd1 vssd1 vccd1 vccd1 sky130_fd_sc_hd__fill_4
XANTENNA_fanout547_A net554 vssd1 vssd1 vccd1 vccd1 sky130_fd_sc_hd__diode_2
X_07517_ FPGA_INST.cell3.SB0.route_sel\[70\] FPGA_INST.cell3.SB0.route_sel\[71\] FPGA_INST.cell3.SB0.route_sel\[68\]
+ vssd1 vssd1 vccd1 vccd1 _03773_ sky130_fd_sc_hd__a21bo_1
XTAP_TAPCELL_ROW_85_1470 vssd1 vccd1 sky130_fd_sc_hd__tapvpwrvgnd_1
X_05778_ FPGA_INST.cell0.SB0.route_sel\[88\] FPGA_INST.cell0.SB0.route_sel\[89\] vssd1
+ vssd1 vccd1 vccd1 _02058_ sky130_fd_sc_hd__and2_1
XANTENNA__06528__X _02804_ vssd1 vssd1 vccd1 vccd1 sky130_fd_sc_hd__diode_2
X_08497_ _04712_ _04711_ _04688_ vssd1 vssd1 vccd1 vccd1 _04713_ sky130_fd_sc_hd__mux2_1
XFILLER_23_775 vssd1 vssd1 vccd1 vccd1 sky130_fd_sc_hd__fill_8
Xfanout89 _01785_ vssd1 vssd1 vccd1 vccd1 net89 sky130_fd_sc_hd__clkbuf_4
X_07448_ _03705_ _03703_ vssd1 vssd1 vccd1 vccd1 FPGA_INST.bus3_2\[6\] sky130_fd_sc_hd__and2b_4
Xfanout78 net80 vssd1 vssd1 vccd1 vccd1 net78 sky130_fd_sc_hd__buf_2
XFILLER_10_403 vccd1 vssd1 vccd1 vssd1 sky130_ef_sc_hd__decap_40_12
XFILLER_13_33 vssd1 vssd1 vccd1 vccd1 sky130_fd_sc_hd__fill_1
X_07379_ FPGA_INST.cell0.SB0.route_sel\[46\] _01686_ vssd1 vssd1 vccd1 vccd1 _03638_
+ sky130_fd_sc_hd__nand2_1
XFILLER_129_55 vssd1 vssd1 vccd1 vccd1 sky130_fd_sc_hd__fill_1
XFILLER_13_77 vssd1 vssd1 vccd1 vccd1 sky130_fd_sc_hd__fill_1
X_09118_ FPGA_INST.cell2.LEI0.config_data\[32\] FPGA_INST.cell2.LEI0.config_data\[33\]
+ net259 vssd1 vssd1 vccd1 vccd1 _00034_ sky130_fd_sc_hd__mux2_1
X_10390_ FPGA_INST.cell3.LE_1A.config_data\[9\] FPGA_INST.cell3.LE_1A.config_data\[8\]
+ net375 vssd1 vssd1 vccd1 vccd1 _01269_ sky130_fd_sc_hd__mux2_1
X_09049_ net775 FPGA_INST.cell0.LE_0A.edge_mode vssd1 vssd1 vccd1 vccd1 FPGA_INST.cell0.LE_0A.sel_clk
+ sky130_fd_sc_hd__xnor2_1
X_12060_ net853 _01406_ net638 vssd1 vssd1 vccd1 vccd1 FPGA_INST.cell2.SB0.route_sel\[100\]
+ sky130_fd_sc_hd__dfstp_1
X_11011_ net889 _00361_ net673 vssd1 vssd1 vccd1 vccd1 FPGA_INST.cell2.LE_1B.edge_mode
+ sky130_fd_sc_hd__dfstp_1
XFILLER_2_679 vssd1 vssd1 vccd1 vccd1 sky130_fd_sc_hd__fill_1
XFILLER_104_585 vssd1 vssd1 vccd1 vccd1 sky130_fd_sc_hd__fill_1
XANTENNA__09226__S net354 vssd1 vssd1 vccd1 vccd1 sky130_fd_sc_hd__diode_2
XANTENNA__08128__A0 FPGA_INST.bus3_1\[12\] vssd1 vssd1 vccd1 vccd1 sky130_fd_sc_hd__diode_2
X_11913_ FPGA_INST.cell3.LE_1B.sel_clk _01259_ net735 vssd1 vssd1 vccd1 vccd1 FPGA_INST.cell3.LE_1B.dff1_out
+ sky130_fd_sc_hd__dfstp_1
XANTENNA_input10_A gpio_in[18] vssd1 vssd1 vccd1 vccd1 sky130_fd_sc_hd__diode_2
X_11844_ net916 _01190_ net700 vssd1 vssd1 vccd1 vccd1 FPGA_INST.cell3.LEI0.config_data\[24\]
+ sky130_fd_sc_hd__dfrtp_1
XANTENNA__08637__Y _04846_ vssd1 vssd1 vccd1 vccd1 sky130_fd_sc_hd__diode_2
X_11775_ net925 _01121_ net709 vssd1 vssd1 vccd1 vccd1 FPGA_INST.io_south_oeb\[2\]
+ sky130_fd_sc_hd__dfrtp_1
XFILLER_60_369 vssd1 vssd1 vccd1 vccd1 sky130_fd_sc_hd__fill_2
XFILLER_13_230 vssd1 vssd1 vccd1 vccd1 sky130_fd_sc_hd__fill_2
XFILLER_9_234 vssd1 vssd1 vccd1 vccd1 sky130_fd_sc_hd__fill_2
X_10726_ net872 _00076_ net656 vssd1 vssd1 vccd1 vccd1 FPGA_INST.cell2.LE_0B.config_data\[3\]
+ sky130_fd_sc_hd__dfrtp_1
XTAP_TAPCELL_ROW_31_718 vssd1 vccd1 sky130_fd_sc_hd__tapvpwrvgnd_1
XFILLER_70_50 vssd1 vssd1 vccd1 vccd1 sky130_fd_sc_hd__fill_1
XFILLER_9_267 vssd1 vssd1 vccd1 vccd1 sky130_fd_sc_hd__fill_2
XTAP_TAPCELL_ROW_11_431 vssd1 vccd1 sky130_fd_sc_hd__tapvpwrvgnd_1
X_10657_ net883 _00007_ net667 vssd1 vssd1 vccd1 vccd1 FPGA_INST.cell2.LEI0.config_data\[6\]
+ sky130_fd_sc_hd__dfrtp_1
XFILLER_9_289 vssd1 vssd1 vccd1 vccd1 sky130_fd_sc_hd__fill_8
XTAP_TAPCELL_ROW_11_442 vssd1 vccd1 sky130_fd_sc_hd__tapvpwrvgnd_1
X_10588_ FPGA_INST.cell3.CB_0.config_dataB\[8\] FPGA_INST.cell3.CB_0.config_dataB\[7\]
+ net377 vssd1 vssd1 vccd1 vccd1 _01467_ sky130_fd_sc_hd__mux2_1
XFILLER_62_7 vssd1 vssd1 vccd1 vccd1 sky130_fd_sc_hd__fill_2
XFILLER_114_327 vccd1 vssd1 vccd1 vssd1 sky130_ef_sc_hd__decap_40_12
XFILLER_5_451 vssd1 vssd1 vccd1 vccd1 sky130_fd_sc_hd__fill_4
XFILLER_79_70 vssd1 vssd1 vccd1 vccd1 sky130_fd_sc_hd__fill_2
XANTENNA__06090__A1 net4 vssd1 vssd1 vccd1 vccd1 sky130_fd_sc_hd__diode_2
XTAP_TAPCELL_ROW_110_1828 vssd1 vccd1 sky130_fd_sc_hd__tapvpwrvgnd_1
XTAP_TAPCELL_ROW_110_1817 vssd1 vccd1 sky130_fd_sc_hd__tapvpwrvgnd_1
XTAP_TAPCELL_ROW_56_1071 vssd1 vccd1 sky130_fd_sc_hd__tapvpwrvgnd_1
XTAP_TAPCELL_ROW_56_1060 vssd1 vccd1 sky130_fd_sc_hd__tapvpwrvgnd_1
X_11209_ net755 _00559_ net540 vssd1 vssd1 vccd1 vccd1 FPGA_INST.cell0.SB0.route_sel\[54\]
+ sky130_fd_sc_hd__dfstp_1
XFILLER_96_734 vssd1 vssd1 vccd1 vccd1 sky130_fd_sc_hd__fill_1
XANTENNA__06917__A1 FPGA_INST.bus2_0\[5\] vssd1 vssd1 vccd1 vccd1 sky130_fd_sc_hd__diode_2
XANTENNA__06917__B2 FPGA_INST.bus2_0\[4\] vssd1 vssd1 vccd1 vccd1 sky130_fd_sc_hd__diode_2
XFILLER_96_778 vssd1 vssd1 vccd1 vccd1 sky130_fd_sc_hd__fill_1
XFILLER_95_288 vssd1 vssd1 vccd1 vccd1 sky130_fd_sc_hd__fill_1
XFILLER_83_439 vssd1 vssd1 vccd1 vccd1 sky130_fd_sc_hd__fill_2
X_06750_ _02820_ _02823_ _02811_ _02814_ net514 net513 vssd1 vssd1 vccd1 vccd1 _03024_
+ sky130_fd_sc_hd__mux4_1
XTAP_TAPCELL_ROW_39_829 vssd1 vccd1 sky130_fd_sc_hd__tapvpwrvgnd_1
XANTENNA__07732__X FPGA_INST.bus3_2\[13\] vssd1 vssd1 vccd1 vccd1 sky130_fd_sc_hd__diode_2
X_06681_ _02955_ _02956_ _02849_ vssd1 vssd1 vccd1 vccd1 _02957_ sky130_fd_sc_hd__mux2_1
X_05701_ FPGA_INST.cell0.SB0.route_sel\[104\] FPGA_INST.cell0.SB0.route_sel\[105\]
+ _01978_ _01980_ net322 vssd1 vssd1 vccd1 vccd1 _01981_ sky130_fd_sc_hd__a311oi_4
X_05632_ FPGA_INST.cell2.SB0.route_sel\[126\] _01587_ FPGA_INST.cell2.SB0.route_sel\[122\]
+ FPGA_INST.cell2.SB0.route_sel\[123\] vssd1 vssd1 vccd1 vccd1 _01912_ sky130_fd_sc_hd__o22a_1
X_08420_ _04641_ _04640_ _04544_ vssd1 vssd1 vccd1 vccd1 _04642_ sky130_fd_sc_hd__mux2_1
XTAP_TAPCELL_ROW_19_542 vssd1 vccd1 sky130_fd_sc_hd__tapvpwrvgnd_1
XTAP_TAPCELL_ROW_19_553 vssd1 vccd1 sky130_fd_sc_hd__tapvpwrvgnd_1
XFILLER_24_528 vssd1 vssd1 vccd1 vccd1 sky130_fd_sc_hd__fill_1
XFILLER_63_185 vssd1 vssd1 vccd1 vccd1 sky130_fd_sc_hd__fill_2
X_05563_ FPGA_INST.cell2.SB0.route_sel\[116\] FPGA_INST.cell2.SB0.route_sel\[117\]
+ _01842_ vssd1 vssd1 vccd1 vccd1 _01843_ sky130_fd_sc_hd__a21oi_1
X_08351_ _04572_ vssd1 vssd1 vccd1 vccd1 _04573_ sky130_fd_sc_hd__inv_2
XTAP_TAPCELL_ROW_121_1979 vssd1 vccd1 sky130_fd_sc_hd__tapvpwrvgnd_1
X_05494_ FPGA_INST.cell3.CB_0.config_dataB\[7\] vssd1 vssd1 vccd1 vccd1 _01776_ sky130_fd_sc_hd__inv_2
XANTENNA__07645__A2 _03542_ vssd1 vssd1 vccd1 vccd1 sky130_fd_sc_hd__diode_2
X_07302_ net150 net140 _03562_ vssd1 vssd1 vccd1 vccd1 _03563_ sky130_fd_sc_hd__mux2_1
XFILLER_20_701 vssd1 vssd1 vccd1 vccd1 sky130_fd_sc_hd__fill_2
XFILLER_32_561 vssd1 vssd1 vccd1 vccd1 sky130_fd_sc_hd__fill_1
X_08282_ FPGA_INST.cell0.LE_1A.config_data\[12\] FPGA_INST.cell0.LE_1A.config_data\[13\]
+ _04410_ vssd1 vssd1 vccd1 vccd1 _04506_ sky130_fd_sc_hd__mux2_1
X_07233_ FPGA_INST.cell3.SB0.route_sel\[16\] FPGA_INST.cell3.SB0.route_sel\[17\] vssd1
+ vssd1 vccd1 vccd1 _03495_ sky130_fd_sc_hd__and2_1
XANTENNA_fanout128_A FPGA_INST.cell2.CB_0.le_outB vssd1 vssd1 vccd1 vccd1 sky130_fd_sc_hd__diode_2
X_07164_ FPGA_INST.cell3.CB_1.config_dataA\[24\] FPGA_INST.cell3.CB_1.config_dataA\[21\]
+ FPGA_INST.cell3.CB_1.config_dataA\[20\] vssd1 vssd1 vccd1 vccd1 _03428_ sky130_fd_sc_hd__or3_4
XANTENNA__06083__X _02363_ vssd1 vssd1 vccd1 vccd1 sky130_fd_sc_hd__diode_2
XFILLER_118_699 vssd1 vssd1 vccd1 vccd1 sky130_fd_sc_hd__fill_1
X_07095_ FPGA_INST.bus2_0\[1\] _03352_ _03359_ net426 _03360_ vssd1 vssd1 vccd1 vccd1
+ _03361_ sky130_fd_sc_hd__a221o_1
X_06115_ FPGA_INST.cell2.SB0.route_sel\[18\] FPGA_INST.cell2.SB0.route_sel\[19\] vssd1
+ vssd1 vccd1 vccd1 _02395_ sky130_fd_sc_hd__nand2_1
X_06046_ _02325_ _02315_ vssd1 vssd1 vccd1 vccd1 _02326_ sky130_fd_sc_hd__and2b_1
Xfanout213 net219 vssd1 vssd1 vccd1 vccd1 net213 sky130_fd_sc_hd__buf_2
XANTENNA__11675__SET_B net626 vssd1 vssd1 vccd1 vccd1 sky130_fd_sc_hd__diode_2
Xfanout202 net234 vssd1 vssd1 vccd1 vccd1 net202 sky130_fd_sc_hd__buf_2
XANTENNA__10480__S net319 vssd1 vssd1 vccd1 vccd1 sky130_fd_sc_hd__diode_2
Xfanout224 net225 vssd1 vssd1 vccd1 vccd1 net224 sky130_fd_sc_hd__clkbuf_4
Xfanout235 net237 vssd1 vssd1 vccd1 vccd1 net235 sky130_fd_sc_hd__clkbuf_4
Xfanout246 net247 vssd1 vssd1 vccd1 vccd1 net246 sky130_fd_sc_hd__clkbuf_4
X_09805_ FPGA_INST.cell1.LE_1B.config_data\[5\] FPGA_INST.cell1.LE_1B.config_data\[6\]
+ net229 vssd1 vssd1 vccd1 vccd1 _00714_ sky130_fd_sc_hd__mux2_1
Xfanout279 net280 vssd1 vssd1 vccd1 vccd1 net279 sky130_fd_sc_hd__clkbuf_4
XANTENNA_fanout285_X net285 vssd1 vssd1 vccd1 vccd1 sky130_fd_sc_hd__diode_2
X_07997_ FPGA_INST.cell1.LE_0A.config_data\[9\] FPGA_INST.cell1.LE_0A.config_data\[8\]
+ _04148_ vssd1 vssd1 vccd1 vccd1 _04225_ sky130_fd_sc_hd__mux2_1
XANTENNA__09570__A2 net523 vssd1 vssd1 vccd1 vccd1 sky130_fd_sc_hd__diode_2
XFILLER_86_244 vssd1 vssd1 vccd1 vccd1 sky130_fd_sc_hd__fill_8
Xfanout268 net306 vssd1 vssd1 vccd1 vccd1 net268 sky130_fd_sc_hd__buf_2
XANTENNA_input2_A gpio_in[10] vssd1 vssd1 vccd1 vccd1 sky130_fd_sc_hd__diode_2
Xfanout257 net258 vssd1 vssd1 vccd1 vccd1 net257 sky130_fd_sc_hd__clkbuf_4
X_09736_ FPGA_INST.cell1.CB_0.config_dataA\[12\] net465 net344 vssd1 vssd1 vccd1 vccd1
+ _00645_ sky130_fd_sc_hd__mux2_1
XFILLER_101_599 vssd1 vssd1 vccd1 vccd1 sky130_fd_sc_hd__fill_4
XFILLER_74_417 vssd1 vssd1 vccd1 vccd1 sky130_fd_sc_hd__fill_2
X_06948_ _02465_ _03198_ _03199_ _02429_ FPGA_INST.cell0.CB_0.config_dataB\[17\] vssd1
+ vssd1 vccd1 vccd1 _03216_ sky130_fd_sc_hd__a221o_1
X_09667_ FPGA_INST.cell0.SB0.route_sel\[70\] FPGA_INST.cell0.SB0.route_sel\[71\] net186
+ vssd1 vssd1 vccd1 vccd1 _00576_ sky130_fd_sc_hd__mux2_1
XPHY_EDGE_ROW_19_Left_150 vssd1 vssd1 vccd1 vccd1 sky130_fd_sc_hd__decap_3
XFILLER_27_333 vssd1 vssd1 vccd1 vccd1 sky130_fd_sc_hd__fill_2
XANTENNA_fanout831_A net843 vssd1 vssd1 vccd1 vccd1 sky130_fd_sc_hd__diode_2
X_08618_ FPGA_INST.cell3.SB0.route_sel\[2\] FPGA_INST.cell3.SB0.route_sel\[3\] FPGA_INST.cell3.SB0.route_sel\[5\]
+ _01720_ vssd1 vssd1 vccd1 vccd1 _04827_ sky130_fd_sc_hd__o22a_1
XFILLER_54_152 vssd1 vssd1 vccd1 vccd1 sky130_fd_sc_hd__fill_1
X_06879_ FPGA_INST.bus2_0\[6\] FPGA_INST.bus2_0\[7\] net424 vssd1 vssd1 vccd1 vccd1
+ _03147_ sky130_fd_sc_hd__mux2_1
XANTENNA__07802__B FPGA_INST.cell3.SB0.route_sel\[124\] vssd1 vssd1 vccd1 vccd1 sky130_fd_sc_hd__diode_2
X_09598_ FPGA_INST.cell0.SB0.route_sel\[1\] FPGA_INST.cell0.SB0.route_sel\[2\] net195
+ vssd1 vssd1 vccd1 vccd1 _00507_ sky130_fd_sc_hd__mux2_1
X_08549_ FPGA_INST.cell3.LE_1B.config_data\[2\] FPGA_INST.cell3.LE_1B.config_data\[3\]
+ _04755_ vssd1 vssd1 vccd1 vccd1 _04760_ sky130_fd_sc_hd__mux2_1
XANTENNA__07097__A0 FPGA_INST.bus2_0\[6\] vssd1 vssd1 vccd1 vccd1 sky130_fd_sc_hd__diode_2
X_11560_ net756 _00910_ net541 vssd1 vssd1 vccd1 vccd1 FPGA_INST.cell0.CB_0.config_dataB\[4\]
+ sky130_fd_sc_hd__dfstp_1
X_10511_ FPGA_INST.cell2.SB0.route_sel\[84\] FPGA_INST.cell2.SB0.route_sel\[83\] net362
+ vssd1 vssd1 vccd1 vccd1 _01390_ sky130_fd_sc_hd__mux2_1
XTAP_TAPCELL_ROW_98_1650 vssd1 vccd1 sky130_fd_sc_hd__tapvpwrvgnd_1
XFILLER_11_778 vssd1 vssd1 vccd1 vccd1 sky130_fd_sc_hd__fill_2
X_11491_ net745 _00841_ net530 vssd1 vssd1 vccd1 vccd1 FPGA_INST.cell0.LE_1A.reset_val
+ sky130_fd_sc_hd__dfrtp_1
XTAP_TAPCELL_ROW_98_1661 vssd1 vccd1 sky130_fd_sc_hd__tapvpwrvgnd_1
X_10442_ FPGA_INST.cell2.SB0.route_sel\[14\] FPGA_INST.cell2.SB0.route_sel\[15\] net236
+ vssd1 vssd1 vccd1 vccd1 _01321_ sky130_fd_sc_hd__mux2_1
X_10373_ FPGA_INST.cell3.LE_0B.config_data\[14\] FPGA_INST.cell3.LE_0B.config_data\[15\]
+ net305 vssd1 vssd1 vccd1 vccd1 _01253_ sky130_fd_sc_hd__mux2_1
XANTENNA__07939__A3 _03769_ vssd1 vssd1 vccd1 vccd1 sky130_fd_sc_hd__diode_2
XANTENNA__10877__SET_B net577 vssd1 vssd1 vccd1 vccd1 sky130_fd_sc_hd__diode_2
XFILLER_108_187 vssd1 vssd1 vccd1 vccd1 sky130_fd_sc_hd__fill_8
X_12112_ net904 _01458_ net687 vssd1 vssd1 vccd1 vccd1 FPGA_INST.cell3.CB_0.config_dataA\[24\]
+ sky130_fd_sc_hd__dfstp_1
X_12043_ net878 _01389_ net663 vssd1 vssd1 vccd1 vccd1 FPGA_INST.cell2.SB0.route_sel\[83\]
+ sky130_fd_sc_hd__dfstp_1
XFILLER_78_745 vssd1 vssd1 vccd1 vccd1 sky130_fd_sc_hd__fill_8
XFILLER_78_723 vssd1 vssd1 vccd1 vccd1 sky130_fd_sc_hd__fill_1
Xfanout791 net792 vssd1 vssd1 vccd1 vccd1 net791 sky130_fd_sc_hd__clkbuf_2
XFILLER_77_277 vssd1 vssd1 vccd1 vccd1 sky130_fd_sc_hd__fill_2
Xfanout780 net782 vssd1 vssd1 vccd1 vccd1 net780 sky130_fd_sc_hd__buf_2
XTAP_TAPCELL_ROW_125_2035 vssd1 vccd1 sky130_fd_sc_hd__tapvpwrvgnd_1
XFILLER_92_247 vssd1 vssd1 vccd1 vccd1 sky130_fd_sc_hd__fill_2
XFILLER_92_225 vssd1 vssd1 vccd1 vccd1 sky130_fd_sc_hd__fill_2
XANTENNA_input13_X net13 vssd1 vssd1 vccd1 vccd1 sky130_fd_sc_hd__diode_2
XANTENNA__10459__A1 FPGA_INST.cell2.SB0.route_sel\[32\] vssd1 vssd1 vccd1 vccd1 sky130_fd_sc_hd__diode_2
XFILLER_73_461 vssd1 vssd1 vccd1 vccd1 sky130_fd_sc_hd__fill_1
XFILLER_46_675 vssd1 vssd1 vccd1 vccd1 sky130_fd_sc_hd__fill_1
XFILLER_45_152 vssd1 vssd1 vccd1 vccd1 sky130_fd_sc_hd__fill_4
XTAP_TAPCELL_ROW_16_501 vssd1 vccd1 sky130_fd_sc_hd__tapvpwrvgnd_1
XTAP_TAPCELL_ROW_16_512 vssd1 vccd1 sky130_fd_sc_hd__tapvpwrvgnd_1
X_11827_ net941 _01173_ net725 vssd1 vssd1 vccd1 vccd1 FPGA_INST.cell3.LEI0.config_data\[7\]
+ sky130_fd_sc_hd__dfrtp_1
XANTENNA__05513__A FPGA_INST.bus3_2\[2\] vssd1 vssd1 vccd1 vccd1 sky130_fd_sc_hd__diode_2
X_11758_ net920 _01104_ net704 vssd1 vssd1 vccd1 vccd1 FPGA_INST.io_west_oeb\[0\]
+ sky130_fd_sc_hd__dfrtp_1
XTAP_TAPCELL_ROW_44_898 vssd1 vccd1 sky130_fd_sc_hd__tapvpwrvgnd_1
X_10709_ net865 _00059_ net650 vssd1 vssd1 vccd1 vccd1 FPGA_INST.cell2.LE_0A.config_data\[8\]
+ sky130_fd_sc_hd__dfrtp_1
X_11689_ net897 _01035_ net682 vssd1 vssd1 vccd1 vccd1 FPGA_INST.cell3.SB0.route_sel\[59\]
+ sky130_fd_sc_hd__dfstp_1
XTAP_TAPCELL_ROW_58_1100 vssd1 vccd1 sky130_fd_sc_hd__tapvpwrvgnd_1
XANTENNA__06850__A3 FPGA_INST.bus2_0\[15\] vssd1 vssd1 vccd1 vccd1 sky130_fd_sc_hd__diode_2
XFILLER_53_3 vssd1 vssd1 vccd1 vccd1 sky130_fd_sc_hd__fill_8
X_07920_ _04144_ _04145_ _04147_ vssd1 vssd1 vccd1 vccd1 _04148_ sky130_fd_sc_hd__and3_4
XFILLER_5_292 vssd1 vssd1 vccd1 vccd1 sky130_fd_sc_hd__fill_2
XANTENNA__06998__B _01888_ vssd1 vssd1 vccd1 vccd1 sky130_fd_sc_hd__diode_2
XFILLER_68_255 vssd1 vssd1 vccd1 vccd1 sky130_fd_sc_hd__fill_4
XFILLER_68_244 vssd1 vssd1 vccd1 vccd1 sky130_fd_sc_hd__fill_8
XFILLER_68_233 vssd1 vssd1 vccd1 vccd1 sky130_fd_sc_hd__fill_2
X_07851_ _02479_ _04079_ _02482_ vssd1 vssd1 vccd1 vccd1 net72 sky130_fd_sc_hd__a21o_1
XFILLER_110_374 vssd1 vssd1 vccd1 vccd1 sky130_fd_sc_hd__fill_1
XANTENNA__07563__A1 _03447_ vssd1 vssd1 vccd1 vccd1 sky130_fd_sc_hd__diode_2
X_07782_ _04030_ vssd1 vssd1 vccd1 vccd1 _04031_ sky130_fd_sc_hd__inv_2
Xinput2 gpio_in[10] vssd1 vssd1 vccd1 vccd1 net2 sky130_fd_sc_hd__clkbuf_4
X_06802_ FPGA_INST.cell2.CB_0.config_data_inA _03075_ vssd1 vssd1 vccd1 vccd1 _03076_
+ sky130_fd_sc_hd__and2b_1
X_09521_ FPGA_INST.cell1.LE_0A.config_data\[16\] FPGA_INST.cell1.LE_0A.edge_mode net229
+ vssd1 vssd1 vccd1 vccd1 _00432_ sky130_fd_sc_hd__mux2_1
X_06733_ FPGA_INST.bus3_2\[4\] FPGA_INST.bus3_2\[5\] FPGA_INST.bus3_2\[6\] FPGA_INST.bus3_2\[7\]
+ net517 net516 vssd1 vssd1 vccd1 vccd1 _03007_ sky130_fd_sc_hd__mux4_1
XTAP_TAPCELL_ROW_69_1251 vssd1 vccd1 sky130_fd_sc_hd__tapvpwrvgnd_1
XFILLER_36_141 vssd1 vssd1 vccd1 vccd1 sky130_fd_sc_hd__fill_4
X_09452_ FPGA_INST.cell1.LE_0A.dff1_out net522 _05213_ vssd1 vssd1 vccd1 vccd1 _00364_
+ sky130_fd_sc_hd__a21o_1
X_06664_ FPGA_INST.cell2.CB_1.config_dataA\[19\] _02928_ _02939_ vssd1 vssd1 vccd1
+ vccd1 _02940_ sky130_fd_sc_hd__or3_1
X_08403_ _04623_ _04624_ FPGA_INST.cell0.CB_1.config_dataB\[17\] vssd1 vssd1 vccd1
+ vccd1 _04625_ sky130_fd_sc_hd__mux2_1
X_05615_ FPGA_INST.bus3_2\[15\] _01894_ vssd1 vssd1 vccd1 vccd1 _01895_ sky130_fd_sc_hd__and2_1
X_06595_ _02804_ _02850_ _02851_ _02801_ vssd1 vssd1 vccd1 vccd1 _02871_ sky130_fd_sc_hd__a22oi_1
XANTENNA__05877__A1 _02148_ vssd1 vssd1 vccd1 vccd1 sky130_fd_sc_hd__diode_2
X_09383_ FPGA_INST.cell2.CB_0.config_dataB\[2\] net496 net356 vssd1 vssd1 vccd1 vccd1
+ _00296_ sky130_fd_sc_hd__mux2_1
X_08334_ FPGA_INST.bus1_0\[8\] FPGA_INST.bus1_0\[10\] FPGA_INST.bus1_0\[9\] FPGA_INST.bus1_0\[11\]
+ net447 net449 vssd1 vssd1 vccd1 vccd1 _04556_ sky130_fd_sc_hd__mux4_1
X_05546_ FPGA_INST.cell0.CB_1.config_dataA\[22\] FPGA_INST.cell0.CB_1.config_dataA\[23\]
+ vssd1 vssd1 vccd1 vccd1 _01826_ sky130_fd_sc_hd__nand2_2
XANTENNA_fanout245_A net268 vssd1 vssd1 vccd1 vccd1 sky130_fd_sc_hd__diode_2
XFILLER_51_177 vssd1 vssd1 vccd1 vccd1 sky130_fd_sc_hd__fill_2
X_08265_ _03604_ _04473_ _04474_ _03639_ _01755_ vssd1 vssd1 vccd1 vccd1 _04489_ sky130_fd_sc_hd__a221o_1
X_05477_ FPGA_INST.cell0.CB_1.config_dataB\[12\] vssd1 vssd1 vccd1 vccd1 _01759_ sky130_fd_sc_hd__inv_2
X_07216_ net133 _01993_ _02358_ FPGA_INST.cell3.SB0.route_sel\[12\] FPGA_INST.cell3.SB0.route_sel\[13\]
+ vssd1 vssd1 vccd1 vccd1 _03479_ sky130_fd_sc_hd__o311a_1
X_08196_ net73 net95 FPGA_INST.bus1_0\[2\] FPGA_INST.bus1_0\[3\] net410 FPGA_INST.cell0.CB_1.config_dataA\[6\]
+ vssd1 vssd1 vccd1 vccd1 _04420_ sky130_fd_sc_hd__mux4_1
XFILLER_20_586 vssd1 vssd1 vccd1 vccd1 sky130_fd_sc_hd__fill_2
XANTENNA__08043__A2 FPGA_INST.bus3_1\[2\] vssd1 vssd1 vccd1 vccd1 sky130_fd_sc_hd__diode_2
X_07147_ FPGA_INST.cell1.CB_1.config_dataA\[24\] FPGA_INST.cell1.CB_1.config_dataA\[21\]
+ FPGA_INST.cell1.CB_1.config_dataA\[20\] vssd1 vssd1 vccd1 vccd1 _03411_ sky130_fd_sc_hd__or3_4
XFILLER_105_113 vssd1 vssd1 vccd1 vccd1 sky130_fd_sc_hd__fill_4
XFILLER_3_229 vssd1 vssd1 vccd1 vccd1 sky130_fd_sc_hd__fill_2
XTAP_TAPCELL_ROW_93_1580 vssd1 vccd1 sky130_fd_sc_hd__tapvpwrvgnd_1
XANTENNA_fanout781_A net790 vssd1 vssd1 vccd1 vccd1 sky130_fd_sc_hd__diode_2
X_07078_ _01733_ _03340_ _03343_ _01735_ _03332_ vssd1 vssd1 vccd1 vccd1 _03344_ sky130_fd_sc_hd__o311a_1
XANTENNA__05801__A1 _02072_ vssd1 vssd1 vccd1 vccd1 sky130_fd_sc_hd__diode_2
XTAP_TAPCELL_ROW_93_1591 vssd1 vccd1 sky130_fd_sc_hd__tapvpwrvgnd_1
XFILLER_86_38 vssd1 vssd1 vccd1 vccd1 sky130_fd_sc_hd__fill_2
XFILLER_86_27 vssd1 vssd1 vccd1 vccd1 sky130_fd_sc_hd__fill_1
X_06029_ _02306_ _02308_ vssd1 vssd1 vccd1 vccd1 _02309_ sky130_fd_sc_hd__nor2_2
XFILLER_59_233 vssd1 vssd1 vccd1 vccd1 sky130_fd_sc_hd__fill_8
XANTENNA_input5_X net5 vssd1 vssd1 vccd1 vccd1 sky130_fd_sc_hd__diode_2
XFILLER_101_363 vssd1 vssd1 vccd1 vccd1 sky130_fd_sc_hd__fill_2
XFILLER_47_406 vssd1 vssd1 vccd1 vccd1 sky130_fd_sc_hd__fill_4
XANTENNA__09504__S net230 vssd1 vssd1 vccd1 vccd1 sky130_fd_sc_hd__diode_2
XANTENNA__08468__X FPGA_INST.cell1.CB_1.le_outA vssd1 vssd1 vccd1 vccd1 sky130_fd_sc_hd__diode_2
X_10991_ net859 _00341_ net645 vssd1 vssd1 vccd1 vccd1 FPGA_INST.cell2.CB_1.config_dataA\[22\]
+ sky130_fd_sc_hd__dfstp_1
X_09719_ FPGA_INST.cell0.SB0.route_sel\[122\] FPGA_INST.cell0.SB0.route_sel\[123\]
+ net199 vssd1 vssd1 vccd1 vccd1 _00628_ sky130_fd_sc_hd__mux2_1
XFILLER_55_472 vssd1 vssd1 vccd1 vccd1 sky130_fd_sc_hd__fill_8
XFILLER_15_369 vssd1 vssd1 vccd1 vccd1 sky130_fd_sc_hd__fill_2
X_11612_ net741 _00962_ net526 vssd1 vssd1 vccd1 vccd1 FPGA_INST.cell0.LE_1B.config_data\[6\]
+ sky130_fd_sc_hd__dfrtp_1
XANTENNA__08806__A1 net24 vssd1 vssd1 vccd1 vccd1 sky130_fd_sc_hd__diode_2
XTAP_TAPCELL_ROW_41_857 vssd1 vccd1 sky130_fd_sc_hd__tapvpwrvgnd_1
XFILLER_11_520 vssd1 vssd1 vccd1 vccd1 sky130_fd_sc_hd__fill_1
XFILLER_23_391 vssd1 vssd1 vccd1 vccd1 sky130_fd_sc_hd__fill_1
XFILLER_7_513 vssd1 vssd1 vccd1 vccd1 sky130_fd_sc_hd__fill_1
X_11543_ net777 _00893_ net563 vssd1 vssd1 vccd1 vccd1 FPGA_INST.cell0.CB_0.config_dataA\[12\]
+ sky130_fd_sc_hd__dfstp_1
XANTENNA__08931__X FPGA_INST.bus3_1\[12\] vssd1 vssd1 vccd1 vccd1 sky130_fd_sc_hd__diode_2
X_11474_ net745 _00824_ net530 vssd1 vssd1 vccd1 vccd1 FPGA_INST.cell0.LE_1A.config_data\[1\]
+ sky130_fd_sc_hd__dfrtp_1
XTAP_TAPCELL_ROW_21_570 vssd1 vccd1 sky130_fd_sc_hd__tapvpwrvgnd_1
XTAP_TAPCELL_ROW_21_581 vssd1 vccd1 sky130_fd_sc_hd__tapvpwrvgnd_1
X_10425_ FPGA_INST.cell3.CB_1.config_dataB\[22\] FPGA_INST.cell3.CB_1.config_dataB\[23\]
+ net279 vssd1 vssd1 vccd1 vccd1 _01304_ sky130_fd_sc_hd__mux2_1
XANTENNA__08034__A2 FPGA_INST.cell1.CB_1.le_outA vssd1 vssd1 vccd1 vccd1 sky130_fd_sc_hd__diode_2
XFILLER_109_474 vssd1 vssd1 vccd1 vccd1 sky130_fd_sc_hd__fill_8
XFILLER_109_485 vssd1 vssd1 vccd1 vccd1 sky130_fd_sc_hd__fill_4
X_10356_ net737 _04747_ vssd1 vssd1 vccd1 vccd1 _05245_ sky130_fd_sc_hd__nand2_1
X_10287_ FPGA_INST.cell3.LEI0.config_data\[1\] FPGA_INST.cell3.LEI0.config_data\[2\]
+ net296 vssd1 vssd1 vccd1 vccd1 _01168_ sky130_fd_sc_hd__mux2_1
XTAP_TAPCELL_ROW_53_1030 vssd1 vccd1 sky130_fd_sc_hd__tapvpwrvgnd_1
XFILLER_2_251 vssd1 vssd1 vccd1 vccd1 sky130_fd_sc_hd__fill_1
XANTENNA__06170__Y _02450_ vssd1 vssd1 vccd1 vccd1 sky130_fd_sc_hd__diode_2
XANTENNA__05508__A net134 vssd1 vssd1 vccd1 vccd1 sky130_fd_sc_hd__diode_2
XFILLER_78_564 vccd1 vssd1 vccd1 vssd1 sky130_ef_sc_hd__decap_40_12
X_12026_ net857 _01372_ net642 vssd1 vssd1 vccd1 vccd1 FPGA_INST.cell2.SB0.route_sel\[66\]
+ sky130_fd_sc_hd__dfstp_1
XFILLER_93_501 vssd1 vssd1 vccd1 vccd1 sky130_fd_sc_hd__fill_2
XFILLER_65_214 vssd1 vssd1 vccd1 vccd1 sky130_fd_sc_hd__fill_1
XFILLER_38_417 vssd1 vssd1 vccd1 vccd1 sky130_fd_sc_hd__fill_2
XFILLER_74_770 vssd1 vssd1 vccd1 vccd1 sky130_fd_sc_hd__fill_1
XTAP_TAPCELL_ROW_49_968 vssd1 vccd1 sky130_fd_sc_hd__tapvpwrvgnd_1
XFILLER_18_141 vssd1 vssd1 vccd1 vccd1 sky130_fd_sc_hd__fill_4
XFILLER_74_792 vssd1 vssd1 vccd1 vccd1 sky130_fd_sc_hd__fill_4
XANTENNA__07848__A2 _02450_ vssd1 vssd1 vccd1 vccd1 sky130_fd_sc_hd__diode_2
XTAP_TAPCELL_ROW_105_1749 vssd1 vccd1 sky130_fd_sc_hd__tapvpwrvgnd_1
XTAP_TAPCELL_ROW_29_692 vssd1 vccd1 sky130_fd_sc_hd__tapvpwrvgnd_1
XFILLER_33_122 vssd1 vssd1 vccd1 vccd1 sky130_fd_sc_hd__fill_2
X_05400_ FPGA_INST.cell3.SB0.route_sel\[46\] vssd1 vssd1 vccd1 vccd1 _01682_ sky130_fd_sc_hd__inv_2
XANTENNA__08825__Y _05032_ vssd1 vssd1 vccd1 vccd1 sky130_fd_sc_hd__diode_2
XFILLER_33_188 vssd1 vssd1 vccd1 vccd1 sky130_fd_sc_hd__fill_4
XTAP_TAPCELL_ROW_64_1181 vssd1 vccd1 sky130_fd_sc_hd__tapvpwrvgnd_1
X_06380_ net496 _02653_ _02654_ _02657_ vssd1 vssd1 vccd1 vccd1 _02658_ sky130_fd_sc_hd__a31o_1
XFILLER_14_391 vssd1 vssd1 vccd1 vccd1 sky130_fd_sc_hd__fill_1
X_05331_ FPGA_INST.cell0.SB0.route_sel\[117\] vssd1 vssd1 vccd1 vccd1 _01613_ sky130_fd_sc_hd__inv_2
XANTENNA__07076__A3 FPGA_INST.bus2_0\[11\] vssd1 vssd1 vccd1 vccd1 sky130_fd_sc_hd__diode_2
X_08050_ _04274_ _04275_ FPGA_INST.cell1.CB_0.config_dataB\[2\] vssd1 vssd1 vccd1
+ vccd1 _04276_ sky130_fd_sc_hd__or3b_1
X_05262_ FPGA_INST.cell2.CB_0.config_dataB\[17\] vssd1 vssd1 vccd1 vccd1 _01544_ sky130_fd_sc_hd__inv_2
X_07001_ _03265_ _03266_ FPGA_INST.cell0.CB_0.config_dataA\[7\] vssd1 vssd1 vccd1
+ vccd1 _03267_ sky130_fd_sc_hd__or3b_1
XANTENNA__08025__A2 FPGA_INST.bus3_1\[10\] vssd1 vssd1 vccd1 vccd1 sky130_fd_sc_hd__diode_2
X_08952_ _03802_ _03805_ _03807_ _05141_ vssd1 vssd1 vccd1 vccd1 FPGA_INST.bus1_0\[9\]
+ sky130_fd_sc_hd__o211a_4
X_08883_ _01662_ FPGA_INST.cell3.CB_0.config_dataB\[17\] _05073_ vssd1 vssd1 vccd1
+ vccd1 _05090_ sky130_fd_sc_hd__or3_1
X_07903_ net473 _03854_ _04130_ net471 vssd1 vssd1 vccd1 vccd1 _04131_ sky130_fd_sc_hd__o211a_1
XFILLER_84_501 vssd1 vssd1 vccd1 vccd1 sky130_fd_sc_hd__fill_1
XANTENNA_fanout195_A net196 vssd1 vssd1 vccd1 vccd1 sky130_fd_sc_hd__diode_2
X_07834_ _02208_ _02217_ vssd1 vssd1 vccd1 vccd1 _04070_ sky130_fd_sc_hd__nand2_1
XFILLER_29_417 vssd1 vssd1 vccd1 vccd1 sky130_fd_sc_hd__fill_1
XANTENNA__05547__B1 _01825_ vssd1 vssd1 vccd1 vccd1 sky130_fd_sc_hd__diode_2
X_07765_ net153 _03991_ FPGA_INST.cell3.SB0.route_sel\[117\] FPGA_INST.cell3.SB0.route_sel\[116\]
+ vssd1 vssd1 vccd1 vccd1 _04015_ sky130_fd_sc_hd__a2bb2o_1
XANTENNA_fanout362_A net363 vssd1 vssd1 vccd1 vccd1 sky130_fd_sc_hd__diode_2
X_09504_ FPGA_INST.cell0.SB0.config_data_out FPGA_INST.cell1.LE_0A.config_data\[0\]
+ net230 vssd1 vssd1 vccd1 vccd1 _00415_ sky130_fd_sc_hd__mux2_1
X_07696_ FPGA_INST.cell3.SB0.route_sel\[106\] FPGA_INST.cell3.SB0.route_sel\[107\]
+ vssd1 vssd1 vccd1 vccd1 _03947_ sky130_fd_sc_hd__nand2_1
X_06716_ FPGA_INST.cell2.CB_1.config_dataB\[3\] FPGA_INST.cell2.CB_1.config_dataB\[2\]
+ FPGA_INST.cell2.CB_1.config_dataB\[4\] _02964_ vssd1 vssd1 vccd1 vccd1 _02990_ sky130_fd_sc_hd__or4bb_1
X_09435_ FPGA_INST.cell2.LE_1B.config_data\[3\] FPGA_INST.cell2.LE_1B.config_data\[4\]
+ net290 vssd1 vssd1 vccd1 vccd1 _00348_ sky130_fd_sc_hd__mux2_1
X_06647_ _02921_ _02922_ FPGA_INST.cell2.CB_1.config_dataA\[17\] vssd1 vssd1 vccd1
+ vccd1 _02923_ sky130_fd_sc_hd__mux2_1
XANTENNA_fanout150_X net150 vssd1 vssd1 vccd1 vccd1 sky130_fd_sc_hd__diode_2
XANTENNA_fanout627_A net628 vssd1 vssd1 vccd1 vccd1 sky130_fd_sc_hd__diode_2
XFILLER_52_486 vssd1 vssd1 vccd1 vccd1 sky130_fd_sc_hd__fill_4
X_06578_ net483 _02810_ _02853_ FPGA_INST.cell2.CB_1.config_dataA\[1\] vssd1 vssd1
+ vccd1 vccd1 _02854_ sky130_fd_sc_hd__o211a_1
X_09366_ FPGA_INST.cell2.CB_0.config_dataA\[9\] net503 net237 vssd1 vssd1 vccd1 vccd1
+ _00279_ sky130_fd_sc_hd__mux2_1
X_05529_ net740 _01805_ _01809_ FPGA_INST.config_en_q vssd1 vssd1 vccd1 vccd1 FPGA_INST.cfg_error_d\[0\]
+ sky130_fd_sc_hd__and4b_1
X_09297_ FPGA_INST.cell1.SB0.route_sel\[68\] FPGA_INST.cell1.SB0.route_sel\[69\] net207
+ vssd1 vssd1 vccd1 vccd1 _00210_ sky130_fd_sc_hd__mux2_1
XANTENNA__08264__A2 net74 vssd1 vssd1 vccd1 vccd1 sky130_fd_sc_hd__diode_2
X_08317_ _04530_ _04531_ _04537_ _04538_ vssd1 vssd1 vccd1 vccd1 _04539_ sky130_fd_sc_hd__o22a_1
XANTENNA__06255__Y _02535_ vssd1 vssd1 vccd1 vccd1 sky130_fd_sc_hd__diode_2
XFILLER_122_6 vccd1 vssd1 vccd1 vssd1 sky130_ef_sc_hd__decap_40_12
XANTENNA__07472__B1 _03728_ vssd1 vssd1 vccd1 vccd1 sky130_fd_sc_hd__diode_2
X_08248_ net403 _03840_ _04471_ net402 vssd1 vssd1 vccd1 vccd1 _04472_ sky130_fd_sc_hd__o211a_1
XFILLER_125_219 vssd1 vssd1 vccd1 vccd1 sky130_fd_sc_hd__fill_4
XFILLER_119_783 vssd1 vssd1 vccd1 vccd1 sky130_fd_sc_hd__fill_1
XFILLER_21_55 vssd1 vssd1 vccd1 vccd1 sky130_fd_sc_hd__fill_1
XANTENNA__08016__A2 _03519_ vssd1 vssd1 vccd1 vccd1 sky130_fd_sc_hd__diode_2
X_10210_ FPGA_INST.cell3.SB0.route_sel\[114\] FPGA_INST.cell3.SB0.route_sel\[115\]
+ net269 vssd1 vssd1 vccd1 vccd1 _01091_ sky130_fd_sc_hd__mux2_1
X_08179_ net412 _03504_ _04402_ FPGA_INST.cell0.CB_1.config_dataA\[1\] vssd1 vssd1
+ vccd1 vccd1 _04403_ sky130_fd_sc_hd__o211a_1
XFILLER_4_538 vssd1 vssd1 vccd1 vccd1 sky130_fd_sc_hd__fill_1
XFILLER_97_37 vssd1 vssd1 vccd1 vccd1 sky130_fd_sc_hd__fill_8
X_11190_ net779 _00540_ net564 vssd1 vssd1 vccd1 vccd1 FPGA_INST.cell0.SB0.route_sel\[35\]
+ sky130_fd_sc_hd__dfstp_1
XANTENNA__06578__A2 _02810_ vssd1 vssd1 vccd1 vccd1 sky130_fd_sc_hd__diode_2
X_10141_ FPGA_INST.cell3.SB0.route_sel\[45\] FPGA_INST.cell3.SB0.route_sel\[46\] net277
+ vssd1 vssd1 vccd1 vccd1 _01022_ sky130_fd_sc_hd__mux2_1
XFILLER_0_711 vccd1 vssd1 vccd1 vssd1 sky130_ef_sc_hd__decap_40_12
XFILLER_121_458 vssd1 vssd1 vccd1 vccd1 sky130_fd_sc_hd__fill_8
X_10072_ FPGA_INST.cell0.CB_1.config_dataA\[21\] FPGA_INST.cell0.CB_1.config_dataA\[22\]
+ net188 vssd1 vssd1 vccd1 vccd1 _00953_ sky130_fd_sc_hd__mux2_1
XFILLER_0_755 vssd1 vssd1 vccd1 vccd1 sky130_fd_sc_hd__fill_1
XANTENNA__07527__A1 net27 vssd1 vssd1 vccd1 vccd1 sky130_fd_sc_hd__diode_2
XTAP_TAPCELL_ROW_7_387 vssd1 vccd1 sky130_fd_sc_hd__tapvpwrvgnd_1
XTAP_TAPCELL_ROW_7_376 vssd1 vccd1 sky130_fd_sc_hd__tapvpwrvgnd_1
XFILLER_102_694 vssd1 vssd1 vccd1 vccd1 sky130_fd_sc_hd__fill_4
XFILLER_101_182 vssd1 vssd1 vccd1 vccd1 sky130_fd_sc_hd__fill_1
XANTENNA__08639__A net25 vssd1 vssd1 vccd1 vccd1 sky130_fd_sc_hd__diode_2
X_10974_ net881 _00324_ net666 vssd1 vssd1 vccd1 vccd1 FPGA_INST.cell2.CB_1.config_dataA\[5\]
+ sky130_fd_sc_hd__dfstp_1
XTAP_TAPCELL_ROW_46_927 vssd1 vccd1 sky130_fd_sc_hd__tapvpwrvgnd_1
XFILLER_16_601 vssd1 vssd1 vccd1 vccd1 sky130_fd_sc_hd__fill_1
XFILLER_71_740 vssd1 vssd1 vccd1 vccd1 sky130_fd_sc_hd__fill_1
XTAP_TAPCELL_ROW_26_640 vssd1 vccd1 sky130_fd_sc_hd__tapvpwrvgnd_1
XTAP_TAPCELL_ROW_26_651 vssd1 vccd1 sky130_fd_sc_hd__tapvpwrvgnd_1
XFILLER_31_626 vssd1 vssd1 vccd1 vccd1 sky130_fd_sc_hd__fill_4
XANTENNA__08255__A2 _03997_ vssd1 vssd1 vccd1 vccd1 sky130_fd_sc_hd__diode_2
X_11526_ net810 _00876_ net593 vssd1 vssd1 vccd1 vccd1 FPGA_INST.config_bits\[7\]
+ sky130_fd_sc_hd__dfstp_1
XTAP_TAPCELL_ROW_100_1679 vssd1 vccd1 sky130_fd_sc_hd__tapvpwrvgnd_1
XANTENNA__06266__B2 _01966_ vssd1 vssd1 vccd1 vccd1 sky130_fd_sc_hd__diode_2
XFILLER_7_24 vssd1 vssd1 vccd1 vccd1 sky130_fd_sc_hd__fill_2
XANTENNA__06266__A1 _02010_ vssd1 vssd1 vccd1 vccd1 sky130_fd_sc_hd__diode_2
XFILLER_7_354 vssd1 vssd1 vccd1 vccd1 sky130_fd_sc_hd__fill_1
XFILLER_109_260 vssd1 vssd1 vccd1 vccd1 sky130_fd_sc_hd__fill_1
XANTENNA__08007__A2 _03690_ vssd1 vssd1 vccd1 vccd1 sky130_fd_sc_hd__diode_2
X_11457_ net751 _00807_ net536 vssd1 vssd1 vccd1 vccd1 FPGA_INST.cell0.LE_0B.config_data\[6\]
+ sky130_fd_sc_hd__dfrtp_1
X_10408_ FPGA_INST.cell3.CB_1.config_dataB\[5\] FPGA_INST.cell3.CB_1.config_dataB\[6\]
+ net281 vssd1 vssd1 vccd1 vccd1 _01287_ sky130_fd_sc_hd__mux2_1
XANTENNA__09409__S net362 vssd1 vssd1 vccd1 vccd1 sky130_fd_sc_hd__diode_2
X_11388_ net759 _00738_ net544 vssd1 vssd1 vccd1 vccd1 FPGA_INST.cell0.LEI0.config_data\[9\]
+ sky130_fd_sc_hd__dfrtp_1
XANTENNA__07437__B _03693_ vssd1 vssd1 vccd1 vccd1 sky130_fd_sc_hd__diode_2
X_10339_ FPGA_INST.cell3.LE_0A.config_data\[3\] FPGA_INST.cell3.LE_0A.config_data\[4\]
+ net294 vssd1 vssd1 vccd1 vccd1 _01220_ sky130_fd_sc_hd__mux2_1
XFILLER_97_136 vssd1 vssd1 vccd1 vccd1 sky130_fd_sc_hd__fill_2
XFILLER_78_372 vccd1 vssd1 vccd1 vssd1 sky130_ef_sc_hd__decap_40_12
XFILLER_78_361 vssd1 vssd1 vccd1 vccd1 sky130_fd_sc_hd__fill_2
X_12009_ net776 _01355_ net562 vssd1 vssd1 vccd1 vccd1 FPGA_INST.cell2.SB0.route_sel\[49\]
+ sky130_fd_sc_hd__dfstp_1
XFILLER_16_3 vccd1 vssd1 vccd1 vssd1 sky130_ef_sc_hd__decap_40_12
X_05880_ FPGA_INST.cell2.CB_0.le_outB _01955_ _02046_ vssd1 vssd1 vccd1 vccd1 _02160_
+ sky130_fd_sc_hd__or3_1
X_07550_ FPGA_INST.cell1.SB0.route_sel\[74\] FPGA_INST.cell1.SB0.route_sel\[75\] _03799_
+ _03801_ vssd1 vssd1 vccd1 vccd1 _03805_ sky130_fd_sc_hd__a31oi_2
XTAP_TAPCELL_ROW_66_1210 vssd1 vccd1 sky130_fd_sc_hd__tapvpwrvgnd_1
X_06501_ _02772_ _02776_ FPGA_INST.cell2.CB_1.config_dataA\[5\] vssd1 vssd1 vccd1
+ vccd1 _02777_ sky130_fd_sc_hd__mux2_1
XANTENNA__11579__SET_B net558 vssd1 vssd1 vccd1 vccd1 sky130_fd_sc_hd__diode_2
X_07481_ net85 net26 _03736_ vssd1 vssd1 vccd1 vccd1 _03738_ sky130_fd_sc_hd__mux2_1
X_09220_ FPGA_INST.cell2.CB_1.config_dataB\[17\] net511 net373 vssd1 vssd1 vccd1 vccd1
+ _00133_ sky130_fd_sc_hd__mux2_1
XFILLER_62_795 vssd1 vssd1 vccd1 vccd1 sky130_fd_sc_hd__fill_4
X_06432_ net3 net4 net492 vssd1 vssd1 vccd1 vccd1 _02710_ sky130_fd_sc_hd__mux2_1
X_09151_ FPGA_INST.cell2.LE_0A.config_data\[15\] FPGA_INST.cell2.LE_0A.config_data\[14\]
+ net356 vssd1 vssd1 vccd1 vccd1 _00066_ sky130_fd_sc_hd__mux2_1
X_06363_ _02010_ _02623_ _02624_ _01966_ _01539_ vssd1 vssd1 vccd1 vccd1 _02641_ sky130_fd_sc_hd__a221o_1
XFILLER_21_158 vssd1 vssd1 vccd1 vccd1 sky130_fd_sc_hd__fill_1
X_09082_ _05208_ net91 _03439_ vssd1 vssd1 vccd1 vccd1 net60 sky130_fd_sc_hd__mux2_1
X_08102_ net152 net145 FPGA_INST.cell1.CB_1.le_outA net143 FPGA_INST.cell1.LEI0.config_data\[27\]
+ FPGA_INST.cell1.LEI0.config_data\[28\] vssd1 vssd1 vccd1 vccd1 _04328_ sky130_fd_sc_hd__mux4_1
X_05314_ FPGA_INST.cell2.CB_1.config_dataB\[7\] vssd1 vssd1 vccd1 vccd1 _01596_ sky130_fd_sc_hd__inv_2
XTAP_TAPCELL_ROW_118_1929 vssd1 vccd1 sky130_fd_sc_hd__tapvpwrvgnd_1
X_08033_ FPGA_INST.cell1.CB_0.config_dataB\[8\] _04234_ FPGA_INST.cell1.CB_0.config_dataB\[7\]
+ FPGA_INST.cell1.CB_0.config_dataB\[9\] vssd1 vssd1 vccd1 vccd1 _04259_ sky130_fd_sc_hd__or4b_1
XFILLER_107_208 vssd1 vssd1 vccd1 vccd1 sky130_fd_sc_hd__fill_2
X_06294_ FPGA_INST.cell2.CB_0.config_dataA\[16\] net501 vssd1 vssd1 vccd1 vccd1 _02574_
+ sky130_fd_sc_hd__nor2_1
XANTENNA_fanout208_A net219 vssd1 vssd1 vccd1 vccd1 sky130_fd_sc_hd__diode_2
XTAP_TAPCELL_ROW_77_1361 vssd1 vccd1 sky130_fd_sc_hd__tapvpwrvgnd_1
XANTENNA__08083__A1_N _03613_ vssd1 vssd1 vccd1 vccd1 sky130_fd_sc_hd__diode_2
X_09984_ _05233_ _05234_ vssd1 vssd1 vccd1 vccd1 _00875_ sky130_fd_sc_hd__and2_1
XFILLER_97_681 vssd1 vssd1 vccd1 vccd1 sky130_fd_sc_hd__fill_4
XFILLER_97_670 vssd1 vssd1 vccd1 vccd1 sky130_fd_sc_hd__fill_2
XANTENNA_fanout577_A net588 vssd1 vssd1 vccd1 vccd1 sky130_fd_sc_hd__diode_2
X_08935_ FPGA_INST.cell2.SB0.route_sel\[90\] FPGA_INST.cell2.SB0.route_sel\[91\] vssd1
+ vssd1 vccd1 vccd1 _05130_ sky130_fd_sc_hd__and2b_1
X_08866_ _05072_ vssd1 vssd1 vccd1 vccd1 _05073_ sky130_fd_sc_hd__inv_2
XTAP_TAPCELL_ROW_4_335 vssd1 vccd1 sky130_fd_sc_hd__tapvpwrvgnd_1
X_08797_ net392 net391 vssd1 vssd1 vccd1 vccd1 _05004_ sky130_fd_sc_hd__or2_1
X_07817_ net889 FPGA_INST.cell2.LE_1B.edge_mode vssd1 vssd1 vccd1 vccd1 FPGA_INST.cell2.LE_1B.sel_clk
+ sky130_fd_sc_hd__xnor2_1
XFILLER_29_269 vssd1 vssd1 vccd1 vccd1 sky130_fd_sc_hd__fill_8
XFILLER_84_375 vccd1 vssd1 vccd1 vssd1 sky130_ef_sc_hd__decap_40_12
XFILLER_83_39 vssd1 vssd1 vccd1 vccd1 sky130_fd_sc_hd__fill_8
XFILLER_72_515 vssd1 vssd1 vccd1 vccd1 sky130_fd_sc_hd__fill_2
X_07748_ _03994_ _03995_ _03996_ _01836_ _01823_ vssd1 vssd1 vccd1 vccd1 _03998_ sky130_fd_sc_hd__a311o_1
XANTENNA__08178__B _03558_ vssd1 vssd1 vccd1 vccd1 sky130_fd_sc_hd__diode_2
XFILLER_45_729 vssd1 vssd1 vccd1 vccd1 sky130_fd_sc_hd__fill_1
XANTENNA__07518__D_N _02155_ vssd1 vssd1 vccd1 vccd1 sky130_fd_sc_hd__diode_2
XFILLER_16_44 vssd1 vssd1 vccd1 vccd1 sky130_fd_sc_hd__fill_1
XANTENNA_fanout911_A net918 vssd1 vssd1 vccd1 vccd1 sky130_fd_sc_hd__diode_2
X_07679_ FPGA_INST.cell1.SB0.route_sel\[99\] FPGA_INST.cell1.SB0.route_sel\[98\] _01630_
+ FPGA_INST.cell1.SB0.route_sel\[102\] _03930_ vssd1 vssd1 vccd1 vccd1 _03931_ sky130_fd_sc_hd__o221a_1
XFILLER_53_773 vssd1 vssd1 vccd1 vccd1 sky130_fd_sc_hd__fill_8
XFILLER_53_762 vssd1 vssd1 vccd1 vccd1 sky130_fd_sc_hd__fill_2
XFILLER_13_615 vssd1 vssd1 vccd1 vccd1 sky130_fd_sc_hd__fill_1
X_09418_ FPGA_INST.cell2.CB_1.config_dataA\[12\] net477 net360 vssd1 vssd1 vccd1 vccd1
+ _00331_ sky130_fd_sc_hd__mux2_1
X_10690_ net867 _00040_ net651 vssd1 vssd1 vccd1 vccd1 FPGA_INST.cell2.LEI0.config_data\[39\]
+ sky130_fd_sc_hd__dfrtp_1
XTAP_TAPCELL_ROW_23_610 vssd1 vccd1 sky130_fd_sc_hd__tapvpwrvgnd_1
X_09349_ FPGA_INST.cell1.SB0.route_sel\[120\] FPGA_INST.cell1.SB0.route_sel\[121\]
+ net225 vssd1 vssd1 vccd1 vccd1 _00262_ sky130_fd_sc_hd__mux2_1
XFILLER_40_467 vssd1 vssd1 vccd1 vccd1 sky130_fd_sc_hd__fill_8
XTAP_TAPCELL_ROW_51_996 vssd1 vccd1 sky130_fd_sc_hd__tapvpwrvgnd_1
XFILLER_21_681 vssd1 vssd1 vccd1 vccd1 sky130_fd_sc_hd__fill_2
X_11311_ net842 _00661_ net626 vssd1 vssd1 vccd1 vccd1 FPGA_INST.cell1.CB_0.config_dataB\[3\]
+ sky130_fd_sc_hd__dfstp_1
XFILLER_32_76 vssd1 vssd1 vccd1 vccd1 sky130_fd_sc_hd__fill_8
X_11242_ net768 _00592_ net553 vssd1 vssd1 vccd1 vccd1 FPGA_INST.cell0.SB0.route_sel\[87\]
+ sky130_fd_sc_hd__dfstp_1
X_11173_ net785 _00523_ net570 vssd1 vssd1 vccd1 vccd1 FPGA_INST.cell0.SB0.route_sel\[18\]
+ sky130_fd_sc_hd__dfstp_1
XFILLER_121_244 vssd1 vssd1 vccd1 vccd1 sky130_fd_sc_hd__fill_1
X_10124_ FPGA_INST.cell3.SB0.route_sel\[29\] FPGA_INST.cell3.SB0.route_sel\[28\] net364
+ vssd1 vssd1 vccd1 vccd1 _01005_ sky130_fd_sc_hd__mux2_1
XFILLER_121_277 vssd1 vssd1 vccd1 vccd1 sky130_fd_sc_hd__fill_1
X_10055_ FPGA_INST.cell0.CB_1.config_dataA\[4\] net409 net184 vssd1 vssd1 vccd1 vccd1
+ _00936_ sky130_fd_sc_hd__mux2_1
XFILLER_57_40 vssd1 vssd1 vccd1 vccd1 sky130_fd_sc_hd__fill_1
XFILLER_48_512 vssd1 vssd1 vccd1 vccd1 sky130_fd_sc_hd__fill_2
XANTENNA__08173__A1 net95 vssd1 vssd1 vccd1 vccd1 sky130_fd_sc_hd__diode_2
XFILLER_48_556 vssd1 vssd1 vccd1 vccd1 sky130_fd_sc_hd__fill_2
XFILLER_48_589 vssd1 vssd1 vccd1 vccd1 sky130_fd_sc_hd__fill_4
XFILLER_16_442 vssd1 vssd1 vccd1 vccd1 sky130_fd_sc_hd__fill_1
XTAP_TAPCELL_ROW_102_1708 vssd1 vccd1 sky130_fd_sc_hd__tapvpwrvgnd_1
XFILLER_50_209 vssd1 vssd1 vccd1 vccd1 sky130_fd_sc_hd__fill_1
XFILLER_44_762 vssd1 vssd1 vccd1 vccd1 sky130_fd_sc_hd__fill_1
XFILLER_16_475 vssd1 vssd1 vccd1 vccd1 sky130_fd_sc_hd__fill_1
X_10957_ net867 _00307_ net651 vssd1 vssd1 vccd1 vccd1 FPGA_INST.cell2.CB_0.config_dataB\[13\]
+ sky130_fd_sc_hd__dfstp_1
XFILLER_92_7 vssd1 vssd1 vccd1 vccd1 sky130_fd_sc_hd__fill_2
XFILLER_43_272 vssd1 vssd1 vccd1 vccd1 sky130_fd_sc_hd__fill_4
X_10888_ net829 _00238_ net613 vssd1 vssd1 vccd1 vccd1 FPGA_INST.cell1.SB0.route_sel\[97\]
+ sky130_fd_sc_hd__dfstp_1
XTAP_TAPCELL_ROW_61_1140 vssd1 vccd1 sky130_fd_sc_hd__tapvpwrvgnd_1
XFILLER_31_478 vssd1 vssd1 vccd1 vccd1 sky130_fd_sc_hd__fill_2
XANTENNA__07436__B1 net130 vssd1 vssd1 vccd1 vccd1 sky130_fd_sc_hd__diode_2
XANTENNA__06239__A1 net5 vssd1 vssd1 vccd1 vccd1 sky130_fd_sc_hd__diode_2
X_11509_ net763 _00859_ net548 vssd1 vssd1 vccd1 vccd1 FPGA_INST.cell0.CB_1.config_dataB\[15\]
+ sky130_fd_sc_hd__dfstp_1
XANTENNA__09139__S net350 vssd1 vssd1 vccd1 vccd1 sky130_fd_sc_hd__diode_2
XFILLER_98_80 vssd1 vssd1 vccd1 vccd1 sky130_fd_sc_hd__fill_4
XTAP_TAPCELL_ROW_113_1859 vssd1 vccd1 sky130_fd_sc_hd__tapvpwrvgnd_1
Xfanout609 net610 vssd1 vssd1 vccd1 vccd1 net609 sky130_fd_sc_hd__clkbuf_4
XFILLER_112_266 vssd1 vssd1 vccd1 vccd1 sky130_fd_sc_hd__fill_1
XFILLER_79_670 vssd1 vssd1 vccd1 vccd1 sky130_fd_sc_hd__fill_2
X_06981_ net432 net434 vssd1 vssd1 vccd1 vccd1 _03247_ sky130_fd_sc_hd__and2b_1
X_08720_ net393 net394 vssd1 vssd1 vccd1 vccd1 _04929_ sky130_fd_sc_hd__and2b_1
XTAP_TAPCELL_ROW_72_1291 vssd1 vccd1 sky130_fd_sc_hd__tapvpwrvgnd_1
X_05932_ _02210_ _02211_ vssd1 vssd1 vccd1 vccd1 _02212_ sky130_fd_sc_hd__nand2_1
X_08651_ _01765_ _04856_ _04859_ vssd1 vssd1 vccd1 vccd1 _04860_ sky130_fd_sc_hd__a21oi_4
X_05863_ FPGA_INST.cell0.SB0.route_sel\[69\] FPGA_INST.cell0.SB0.route_sel\[68\] vssd1
+ vssd1 vccd1 vccd1 _02143_ sky130_fd_sc_hd__nand2b_1
X_07602_ FPGA_INST.cell3.SB0.route_sel\[85\] FPGA_INST.cell3.SB0.route_sel\[84\] vssd1
+ vssd1 vccd1 vccd1 _03856_ sky130_fd_sc_hd__nand2_2
XANTENNA__06175__B1 FPGA_INST.bus1_0\[0\] vssd1 vssd1 vccd1 vccd1 sky130_fd_sc_hd__diode_2
XFILLER_54_515 vccd1 vssd1 vccd1 vssd1 sky130_ef_sc_hd__decap_40_12
XFILLER_26_206 vssd1 vssd1 vccd1 vccd1 sky130_fd_sc_hd__fill_1
X_08582_ _03825_ _04788_ _04790_ vssd1 vssd1 vccd1 vccd1 _04791_ sky130_fd_sc_hd__a21boi_1
XFILLER_35_740 vssd1 vssd1 vccd1 vccd1 sky130_fd_sc_hd__fill_4
XANTENNA__06142__B1_N FPGA_INST.bus2_0\[1\] vssd1 vssd1 vccd1 vccd1 sky130_fd_sc_hd__diode_2
X_05794_ FPGA_INST.cell2.SB0.route_sel\[92\] FPGA_INST.cell2.SB0.route_sel\[93\] _02073_
+ vssd1 vssd1 vccd1 vccd1 _02074_ sky130_fd_sc_hd__a21o_1
X_07533_ _01655_ FPGA_INST.cell3.SB0.route_sel\[67\] _01657_ FPGA_INST.cell3.SB0.route_sel\[68\]
+ _03788_ vssd1 vssd1 vccd1 vccd1 _03789_ sky130_fd_sc_hd__o221a_1
XFILLER_81_389 vssd1 vssd1 vccd1 vccd1 sky130_fd_sc_hd__fill_2
XFILLER_62_581 vssd1 vssd1 vccd1 vccd1 sky130_fd_sc_hd__fill_4
X_07464_ _02179_ _02188_ _03719_ vssd1 vssd1 vccd1 vccd1 _03721_ sky130_fd_sc_hd__or3_1
X_09203_ FPGA_INST.cell2.CB_1.config_dataA\[24\] net521 net249 vssd1 vssd1 vccd1 vccd1
+ _00116_ sky130_fd_sc_hd__mux2_1
XANTENNA__07122__S _03313_ vssd1 vssd1 vccd1 vccd1 sky130_fd_sc_hd__diode_2
X_06415_ net491 net490 vssd1 vssd1 vccd1 vccd1 _02693_ sky130_fd_sc_hd__nor2_1
X_07395_ FPGA_INST.cell3.SB0.route_sel\[45\] FPGA_INST.cell3.SB0.route_sel\[44\] _03634_
+ _03653_ _03646_ vssd1 vssd1 vccd1 vccd1 _03654_ sky130_fd_sc_hd__a221o_1
XANTENNA_fanout325_A net381 vssd1 vssd1 vccd1 vccd1 sky130_fd_sc_hd__diode_2
X_09134_ net736 _02768_ vssd1 vssd1 vccd1 vccd1 _05210_ sky130_fd_sc_hd__nand2_1
XANTENNA__07427__B1 net141 vssd1 vssd1 vccd1 vccd1 sky130_fd_sc_hd__diode_2
X_06346_ net495 net493 vssd1 vssd1 vccd1 vccd1 _02624_ sky130_fd_sc_hd__nor2_1
X_09065_ net84 _04794_ _03780_ vssd1 vssd1 vccd1 vccd1 _05200_ sky130_fd_sc_hd__mux2_1
X_06277_ _02552_ _02553_ _02555_ _02556_ vssd1 vssd1 vccd1 vccd1 _02557_ sky130_fd_sc_hd__o22a_1
X_08016_ net458 _03519_ _04241_ net456 vssd1 vssd1 vccd1 vccd1 _04242_ sky130_fd_sc_hd__o211a_1
XANTENNA__06650__A1 _02823_ vssd1 vssd1 vccd1 vccd1 sky130_fd_sc_hd__diode_2
XTAP_TAPCELL_ROW_9_405 vssd1 vccd1 sky130_fd_sc_hd__tapvpwrvgnd_1
XANTENNA_fanout694_A net695 vssd1 vssd1 vccd1 vccd1 sky130_fd_sc_hd__diode_2
X_09967_ FPGA_INST.config_bits\[1\] FPGA_INST.config_bits\[0\] _05221_ vssd1 vssd1
+ vccd1 vccd1 _05223_ sky130_fd_sc_hd__a21oi_1
XFILLER_103_266 vssd1 vssd1 vccd1 vccd1 sky130_fd_sc_hd__fill_1
XFILLER_76_106 vssd1 vssd1 vccd1 vccd1 sky130_fd_sc_hd__fill_1
XANTENNA_fanout861_A net862 vssd1 vssd1 vccd1 vccd1 sky130_fd_sc_hd__diode_2
XFILLER_76_128 vssd1 vssd1 vccd1 vccd1 sky130_fd_sc_hd__fill_4
X_08918_ _01580_ FPGA_INST.cell2.SB0.route_sel\[105\] FPGA_INST.cell2.SB0.route_sel\[110\]
+ FPGA_INST.cell2.SB0.route_sel\[111\] _05118_ vssd1 vssd1 vccd1 vccd1 _05119_ sky130_fd_sc_hd__o221a_1
XFILLER_57_353 vssd1 vssd1 vccd1 vccd1 sky130_fd_sc_hd__fill_1
X_09898_ FPGA_INST.cell0.LE_0B.config_data\[3\] FPGA_INST.cell0.LE_0B.config_data\[2\]
+ net309 vssd1 vssd1 vccd1 vccd1 _00804_ sky130_fd_sc_hd__mux2_1
X_08849_ FPGA_INST.cell3.CB_0.config_dataB\[11\] _05053_ _05054_ _05055_ vssd1 vssd1
+ vccd1 vccd1 _05056_ sky130_fd_sc_hd__a31o_1
XFILLER_85_673 vccd1 vssd1 vccd1 vssd1 sky130_ef_sc_hd__decap_40_12
XFILLER_85_695 vssd1 vssd1 vccd1 vccd1 sky130_fd_sc_hd__fill_1
XFILLER_84_150 vccd1 vssd1 vccd1 vssd1 sky130_ef_sc_hd__decap_40_12
XANTENNA__06705__A2 FPGA_INST.bus3_2\[6\] vssd1 vssd1 vccd1 vccd1 sky130_fd_sc_hd__diode_2
XFILLER_57_375 vssd1 vssd1 vccd1 vccd1 sky130_fd_sc_hd__fill_2
XFILLER_27_54 vssd1 vssd1 vccd1 vccd1 sky130_fd_sc_hd__fill_2
X_11860_ net936 _01206_ net720 vssd1 vssd1 vccd1 vccd1 FPGA_INST.cell3.LEI0.config_data\[40\]
+ sky130_fd_sc_hd__dfrtp_1
XFILLER_84_194 vssd1 vssd1 vccd1 vccd1 sky130_fd_sc_hd__fill_2
XFILLER_72_345 vssd1 vssd1 vccd1 vccd1 sky130_fd_sc_hd__fill_1
XANTENNA__07380__X _03639_ vssd1 vssd1 vccd1 vccd1 sky130_fd_sc_hd__diode_2
X_10811_ net827 _00161_ net611 vssd1 vssd1 vccd1 vccd1 FPGA_INST.cell1.SB0.route_sel\[20\]
+ sky130_fd_sc_hd__dfstp_1
X_11791_ net890 _01137_ net673 vssd1 vssd1 vccd1 vccd1 FPGA_INST.io_east_oeb\[2\]
+ sky130_fd_sc_hd__dfrtp_1
XFILLER_41_710 vssd1 vssd1 vccd1 vccd1 sky130_fd_sc_hd__fill_2
X_10742_ net875 _00092_ net659 vssd1 vssd1 vccd1 vccd1 FPGA_INST.cell2.LE_0B.reset_mode
+ sky130_fd_sc_hd__dfrtp_1
XTAP_TAPCELL_ROW_36_790 vssd1 vccd1 sky130_fd_sc_hd__tapvpwrvgnd_1
XFILLER_40_231 vssd1 vssd1 vccd1 vccd1 sky130_fd_sc_hd__fill_4
XANTENNA__06156__B FPGA_INST.bus3_2\[1\] vssd1 vssd1 vccd1 vccd1 sky130_fd_sc_hd__diode_2
X_10673_ net884 _00023_ net668 vssd1 vssd1 vccd1 vccd1 FPGA_INST.cell2.LEI0.config_data\[22\]
+ sky130_fd_sc_hd__dfrtp_1
XFILLER_9_449 vssd1 vssd1 vccd1 vccd1 sky130_fd_sc_hd__fill_2
XANTENNA__08091__A0 FPGA_INST.bus3_1\[8\] vssd1 vssd1 vccd1 vccd1 sky130_fd_sc_hd__diode_2
XANTENNA__07969__B2 _03652_ vssd1 vssd1 vccd1 vccd1 sky130_fd_sc_hd__diode_2
XTAP_TAPCELL_ROW_130_2115 vssd1 vccd1 sky130_fd_sc_hd__tapvpwrvgnd_1
XTAP_TAPCELL_ROW_130_2104 vssd1 vccd1 sky130_fd_sc_hd__tapvpwrvgnd_1
XFILLER_126_358 vssd1 vssd1 vccd1 vccd1 sky130_fd_sc_hd__fill_4
X_11225_ net766 _00575_ net551 vssd1 vssd1 vccd1 vccd1 FPGA_INST.cell0.SB0.route_sel\[70\]
+ sky130_fd_sc_hd__dfstp_1
XFILLER_4_143 vssd1 vssd1 vccd1 vccd1 sky130_fd_sc_hd__fill_1
XFILLER_107_594 vssd1 vssd1 vccd1 vccd1 sky130_fd_sc_hd__fill_2
XANTENNA__08394__A1 _03797_ vssd1 vssd1 vccd1 vccd1 sky130_fd_sc_hd__diode_2
XANTENNA__11555__CLK net778 vssd1 vssd1 vccd1 vccd1 sky130_fd_sc_hd__diode_2
XANTENNA__07555__X _03810_ vssd1 vssd1 vccd1 vccd1 sky130_fd_sc_hd__diode_2
X_11156_ net779 _00506_ net564 vssd1 vssd1 vccd1 vccd1 FPGA_INST.cell0.SB0.route_sel\[1\]
+ sky130_fd_sc_hd__dfstp_1
XANTENNA__08394__B2 _03759_ vssd1 vssd1 vccd1 vccd1 sky130_fd_sc_hd__diode_2
X_11087_ net839 _00437_ net623 vssd1 vssd1 vccd1 vccd1 FPGA_INST.cell1.LE_0B.config_data\[0\]
+ sky130_fd_sc_hd__dfrtp_1
XFILLER_122_586 vssd1 vssd1 vccd1 vccd1 sky130_fd_sc_hd__fill_2
XFILLER_68_83 vssd1 vssd1 vccd1 vccd1 sky130_fd_sc_hd__fill_1
X_10107_ FPGA_INST.cell3.SB0.route_sel\[11\] FPGA_INST.cell3.SB0.route_sel\[12\] net270
+ vssd1 vssd1 vccd1 vccd1 _00988_ sky130_fd_sc_hd__mux2_1
XANTENNA__06944__A2 _02191_ vssd1 vssd1 vccd1 vccd1 sky130_fd_sc_hd__diode_2
XTAP_TAPCELL_ROW_128_2077 vssd1 vccd1 sky130_fd_sc_hd__tapvpwrvgnd_1
XFILLER_95_459 vssd1 vssd1 vccd1 vccd1 sky130_fd_sc_hd__fill_1
XANTENNA__05516__A FPGA_INST.bus3_2\[14\] vssd1 vssd1 vccd1 vccd1 sky130_fd_sc_hd__diode_2
X_10038_ FPGA_INST.cell0.CB_0.config_dataB\[13\] FPGA_INST.cell0.CB_0.config_dataB\[12\]
+ net318 vssd1 vssd1 vccd1 vccd1 _00919_ sky130_fd_sc_hd__mux2_1
XFILLER_84_82 vssd1 vssd1 vccd1 vccd1 sky130_fd_sc_hd__fill_2
XFILLER_36_548 vssd1 vssd1 vccd1 vccd1 sky130_fd_sc_hd__fill_1
XANTENNA__10568__S net379 vssd1 vssd1 vccd1 vccd1 sky130_fd_sc_hd__diode_2
XFILLER_84_93 vssd1 vssd1 vccd1 vccd1 sky130_fd_sc_hd__fill_1
X_11989_ net774 _01335_ net560 vssd1 vssd1 vccd1 vccd1 FPGA_INST.cell2.SB0.route_sel\[29\]
+ sky130_fd_sc_hd__dfstp_1
XFILLER_83_3 vccd1 vssd1 vccd1 vssd1 sky130_ef_sc_hd__decap_40_12
XTAP_TAPCELL_ROW_14_473 vssd1 vccd1 sky130_fd_sc_hd__tapvpwrvgnd_1
X_06200_ net124 _01955_ _02366_ vssd1 vssd1 vccd1 vccd1 _02480_ sky130_fd_sc_hd__or3b_1
X_07180_ FPGA_INST.cell3.SB0.route_sel\[0\] FPGA_INST.cell3.SB0.route_sel\[1\] _01719_
+ FPGA_INST.cell3.SB0.route_sel\[3\] vssd1 vssd1 vccd1 vccd1 _03444_ sky130_fd_sc_hd__o22a_1
XTAP_TAPCELL_ROW_14_484 vssd1 vccd1 sky130_fd_sc_hd__tapvpwrvgnd_1
XFILLER_8_482 vssd1 vssd1 vccd1 vccd1 sky130_fd_sc_hd__fill_1
X_06131_ FPGA_INST.cell2.SB0.route_sel\[21\] FPGA_INST.cell2.SB0.route_sel\[20\] vssd1
+ vssd1 vccd1 vccd1 _02411_ sky130_fd_sc_hd__nand2b_1
X_06062_ net113 _01879_ _02340_ vssd1 vssd1 vccd1 vccd1 _02342_ sky130_fd_sc_hd__nor3_1
XTAP_TAPCELL_ROW_74_1320 vssd1 vccd1 sky130_fd_sc_hd__tapvpwrvgnd_1
XFILLER_125_380 vssd1 vssd1 vccd1 vccd1 sky130_fd_sc_hd__fill_2
XFILLER_99_798 vssd1 vssd1 vccd1 vccd1 sky130_fd_sc_hd__fill_1
Xfanout406 FPGA_INST.cell0.CB_1.config_dataA\[10\] vssd1 vssd1 vccd1 vccd1 net406
+ sky130_fd_sc_hd__buf_2
Xfanout439 net440 vssd1 vssd1 vccd1 vccd1 net439 sky130_fd_sc_hd__clkbuf_2
Xfanout417 FPGA_INST.cell0.CB_0.config_dataB\[11\] vssd1 vssd1 vccd1 vccd1 net417
+ sky130_fd_sc_hd__buf_2
X_09821_ FPGA_INST.cell0.LEI0.config_data\[0\] FPGA_INST.cell0.LE_1A.reset_mode net308
+ vssd1 vssd1 vccd1 vccd1 _00729_ sky130_fd_sc_hd__mux2_1
Xfanout428 FPGA_INST.cell0.CB_0.config_dataA\[15\] vssd1 vssd1 vccd1 vccd1 net428
+ sky130_fd_sc_hd__dlymetal6s2s_1
X_09752_ FPGA_INST.cell1.CB_0.config_dataB\[3\] FPGA_INST.cell1.CB_0.config_dataB\[2\]
+ net348 vssd1 vssd1 vccd1 vccd1 _00661_ sky130_fd_sc_hd__mux2_1
XFILLER_98_297 vssd1 vssd1 vccd1 vccd1 sky130_fd_sc_hd__fill_1
XANTENNA__06935__A2 _01839_ vssd1 vssd1 vccd1 vccd1 sky130_fd_sc_hd__diode_2
XFILLER_104_26 vssd1 vssd1 vccd1 vccd1 sky130_fd_sc_hd__fill_2
X_08703_ _04809_ _04895_ _04896_ _04813_ vssd1 vssd1 vccd1 vccd1 _04912_ sky130_fd_sc_hd__a22oi_1
XFILLER_67_640 vssd1 vssd1 vccd1 vccd1 sky130_fd_sc_hd__fill_1
X_06964_ FPGA_INST.cell0.LE_0B.config_data\[1\] FPGA_INST.cell0.LE_0B.config_data\[0\]
+ _03159_ vssd1 vssd1 vccd1 vccd1 _03232_ sky130_fd_sc_hd__mux2_1
XFILLER_39_353 vssd1 vssd1 vccd1 vccd1 sky130_fd_sc_hd__fill_1
XFILLER_67_673 vssd1 vssd1 vccd1 vccd1 sky130_fd_sc_hd__fill_1
X_09683_ FPGA_INST.cell0.SB0.route_sel\[86\] FPGA_INST.cell0.SB0.route_sel\[87\] net187
+ vssd1 vssd1 vccd1 vccd1 _00592_ sky130_fd_sc_hd__mux2_1
XFILLER_54_301 vssd1 vssd1 vccd1 vccd1 sky130_fd_sc_hd__fill_4
X_06895_ FPGA_INST.cell0.CB_0.config_dataB\[11\] net418 vssd1 vssd1 vccd1 vccd1 _03163_
+ sky130_fd_sc_hd__and2b_1
X_05915_ FPGA_INST.cell2.SB0.route_sel\[60\] FPGA_INST.cell2.SB0.route_sel\[61\] _02194_
+ vssd1 vssd1 vccd1 vccd1 _02195_ sky130_fd_sc_hd__a21o_1
X_08634_ _03628_ _04842_ vssd1 vssd1 vccd1 vccd1 _04843_ sky130_fd_sc_hd__nand2_4
XFILLER_66_194 vssd1 vssd1 vccd1 vccd1 sky130_fd_sc_hd__fill_2
XANTENNA__06699__A1 _02819_ vssd1 vssd1 vccd1 vccd1 sky130_fd_sc_hd__diode_2
X_05846_ net135 _02123_ vssd1 vssd1 vccd1 vccd1 _02126_ sky130_fd_sc_hd__or2_1
X_08565_ _04772_ _04775_ _04759_ vssd1 vssd1 vccd1 vccd1 _04776_ sky130_fd_sc_hd__mux2_1
X_05777_ net120 net171 net162 _02013_ _01871_ vssd1 vssd1 vccd1 vccd1 _02057_ sky130_fd_sc_hd__o32ai_2
XANTENNA__10478__S net319 vssd1 vssd1 vccd1 vccd1 sky130_fd_sc_hd__diode_2
XTAP_TAPCELL_ROW_85_1471 vssd1 vccd1 sky130_fd_sc_hd__tapvpwrvgnd_1
X_07516_ _02151_ _02840_ _02153_ vssd1 vssd1 vccd1 vccd1 _03772_ sky130_fd_sc_hd__o21a_1
X_08496_ FPGA_INST.cell1.LE_1B.config_data\[10\] FPGA_INST.cell1.LE_1B.config_data\[11\]
+ _04692_ vssd1 vssd1 vccd1 vccd1 _04712_ sky130_fd_sc_hd__mux2_1
XFILLER_80_29 vssd1 vssd1 vccd1 vccd1 sky130_fd_sc_hd__fill_4
XANTENNA_fanout230_X net230 vssd1 vssd1 vccd1 vccd1 sky130_fd_sc_hd__diode_2
Xfanout79 net80 vssd1 vssd1 vccd1 vccd1 net79 sky130_fd_sc_hd__clkbuf_4
X_07447_ _01672_ FPGA_INST.cell3.SB0.route_sel\[51\] _01673_ FPGA_INST.cell3.SB0.route_sel\[52\]
+ _03704_ vssd1 vssd1 vccd1 vccd1 _03705_ sky130_fd_sc_hd__o221a_1
XFILLER_10_415 vssd1 vssd1 vccd1 vccd1 sky130_fd_sc_hd__fill_4
XFILLER_23_798 vssd1 vssd1 vccd1 vccd1 sky130_fd_sc_hd__fill_1
X_07378_ FPGA_INST.cell0.SB0.route_sel\[40\] FPGA_INST.cell0.SB0.route_sel\[41\] vssd1
+ vssd1 vccd1 vccd1 _03637_ sky130_fd_sc_hd__nand2b_1
X_06329_ _02607_ _02608_ _02502_ vssd1 vssd1 vccd1 vccd1 _02609_ sky130_fd_sc_hd__mux2_1
X_09117_ FPGA_INST.cell2.LEI0.config_data\[31\] FPGA_INST.cell2.LEI0.config_data\[32\]
+ net259 vssd1 vssd1 vccd1 vccd1 _00033_ sky130_fd_sc_hd__mux2_1
XANTENNA__08191__B _03558_ vssd1 vssd1 vccd1 vccd1 sky130_fd_sc_hd__diode_2
X_09048_ net535 FPGA_INST.cell0.LE_0A.reset_mode vssd1 vssd1 vccd1 vccd1 _09048_/X
+ sky130_fd_sc_hd__xor2_2
XANTENNA__11578__CLK net778 vssd1 vssd1 vccd1 vccd1 sky130_fd_sc_hd__diode_2
XANTENNA__07820__B1 _01869_ vssd1 vssd1 vccd1 vccd1 sky130_fd_sc_hd__diode_2
XFILLER_1_113 vssd1 vssd1 vccd1 vccd1 sky130_fd_sc_hd__fill_4
XFILLER_2_658 vssd1 vssd1 vccd1 vccd1 sky130_fd_sc_hd__fill_1
XANTENNA__09507__S net344 vssd1 vssd1 vccd1 vccd1 sky130_fd_sc_hd__diode_2
X_11010_ net888 _00360_ net672 vssd1 vssd1 vccd1 vccd1 FPGA_INST.cell2.LE_1B.config_data\[16\]
+ sky130_fd_sc_hd__dfrtp_1
Xfanout940 net945 vssd1 vssd1 vccd1 vccd1 net940 sky130_fd_sc_hd__dlymetal6s2s_1
XFILLER_77_437 vssd1 vssd1 vccd1 vccd1 sky130_fd_sc_hd__fill_1
XANTENNA__08128__A1 FPGA_INST.bus3_1\[13\] vssd1 vssd1 vccd1 vccd1 sky130_fd_sc_hd__diode_2
XANTENNA__08679__A2 net82 vssd1 vssd1 vccd1 vccd1 sky130_fd_sc_hd__diode_2
XFILLER_100_770 vssd1 vssd1 vccd1 vccd1 sky130_fd_sc_hd__fill_1
X_11912_ FPGA_INST.cell3.LE_1A.sel_clk _01258_ net735 vssd1 vssd1 vccd1 vccd1 FPGA_INST.cell3.LE_1A.dff0_out
+ sky130_fd_sc_hd__dfrtp_1
XFILLER_85_481 vccd1 vssd1 vccd1 vssd1 sky130_ef_sc_hd__decap_40_12
XFILLER_45_334 vssd1 vssd1 vccd1 vccd1 sky130_fd_sc_hd__fill_2
X_11843_ net916 _01189_ net700 vssd1 vssd1 vccd1 vccd1 FPGA_INST.cell3.LEI0.config_data\[23\]
+ sky130_fd_sc_hd__dfrtp_1
XFILLER_72_197 vssd1 vssd1 vccd1 vccd1 sky130_fd_sc_hd__fill_2
XANTENNA__08366__B _03558_ vssd1 vssd1 vccd1 vccd1 sky130_fd_sc_hd__diode_2
X_11774_ net928 _01120_ net712 vssd1 vssd1 vccd1 vccd1 FPGA_INST.io_south_oeb\[0\]
+ sky130_fd_sc_hd__dfrtp_1
XANTENNA__08934__X FPGA_INST.bus1_0\[11\] vssd1 vssd1 vccd1 vccd1 sky130_fd_sc_hd__diode_2
XFILLER_41_551 vssd1 vssd1 vccd1 vccd1 sky130_fd_sc_hd__fill_1
XFILLER_13_242 vssd1 vssd1 vccd1 vccd1 sky130_fd_sc_hd__fill_1
X_10725_ net872 _00075_ net656 vssd1 vssd1 vccd1 vccd1 FPGA_INST.cell2.LE_0B.config_data\[2\]
+ sky130_fd_sc_hd__dfrtp_1
XTAP_TAPCELL_ROW_31_719 vssd1 vccd1 sky130_fd_sc_hd__tapvpwrvgnd_1
XTAP_TAPCELL_ROW_11_432 vssd1 vccd1 sky130_fd_sc_hd__tapvpwrvgnd_1
X_10656_ net883 _00006_ net667 vssd1 vssd1 vccd1 vccd1 FPGA_INST.cell2.LEI0.config_data\[5\]
+ sky130_fd_sc_hd__dfrtp_1
XFILLER_9_279 vssd1 vssd1 vccd1 vccd1 sky130_fd_sc_hd__fill_1
XTAP_TAPCELL_ROW_11_443 vssd1 vccd1 sky130_fd_sc_hd__tapvpwrvgnd_1
X_10587_ FPGA_INST.cell3.CB_0.config_dataB\[7\] net389 net377 vssd1 vssd1 vccd1 vccd1
+ _01466_ sky130_fd_sc_hd__mux2_1
XTAP_TAPCELL_ROW_110_1829 vssd1 vccd1 sky130_fd_sc_hd__tapvpwrvgnd_1
XTAP_TAPCELL_ROW_110_1818 vssd1 vccd1 sky130_fd_sc_hd__tapvpwrvgnd_1
XTAP_TAPCELL_ROW_56_1072 vssd1 vccd1 sky130_fd_sc_hd__tapvpwrvgnd_1
XTAP_TAPCELL_ROW_56_1061 vssd1 vccd1 sky130_fd_sc_hd__tapvpwrvgnd_1
X_11208_ net754 _00558_ net539 vssd1 vssd1 vccd1 vccd1 FPGA_INST.cell0.SB0.route_sel\[53\]
+ sky130_fd_sc_hd__dfstp_1
XFILLER_96_746 vssd1 vssd1 vccd1 vccd1 sky130_fd_sc_hd__fill_1
XFILLER_95_223 vssd1 vssd1 vccd1 vccd1 sky130_fd_sc_hd__fill_1
XFILLER_68_415 vssd1 vssd1 vccd1 vccd1 sky130_fd_sc_hd__fill_4
X_11139_ net817 _00489_ net602 vssd1 vssd1 vccd1 vccd1 FPGA_INST.cell1.CB_1.config_dataB\[9\]
+ sky130_fd_sc_hd__dfstp_1
XFILLER_96_757 vssd1 vssd1 vccd1 vccd1 sky130_fd_sc_hd__fill_1
XFILLER_110_589 vssd1 vssd1 vccd1 vccd1 sky130_fd_sc_hd__fill_1
XFILLER_48_150 vssd1 vssd1 vccd1 vccd1 sky130_fd_sc_hd__fill_1
XFILLER_64_643 vssd1 vssd1 vccd1 vccd1 sky130_fd_sc_hd__fill_1
XFILLER_64_621 vssd1 vssd1 vccd1 vccd1 sky130_fd_sc_hd__fill_1
X_06680_ FPGA_INST.cell2.LE_1A.config_data\[15\] FPGA_INST.cell2.LE_1A.config_data\[14\]
+ _02878_ vssd1 vssd1 vccd1 vccd1 _02956_ sky130_fd_sc_hd__mux2_1
X_05700_ FPGA_INST.cell0.SB0.route_sel\[104\] FPGA_INST.cell0.SB0.route_sel\[105\]
+ _01971_ _01979_ _01969_ vssd1 vssd1 vccd1 vccd1 _01980_ sky130_fd_sc_hd__a221oi_2
XFILLER_91_440 vssd1 vssd1 vccd1 vccd1 sky130_fd_sc_hd__fill_8
X_05631_ net247 _01902_ _01910_ vssd1 vssd1 vccd1 vccd1 _01911_ sky130_fd_sc_hd__and3_1
XTAP_TAPCELL_ROW_19_543 vssd1 vccd1 sky130_fd_sc_hd__tapvpwrvgnd_1
XTAP_TAPCELL_ROW_19_554 vssd1 vccd1 sky130_fd_sc_hd__tapvpwrvgnd_1
XFILLER_63_175 vssd1 vssd1 vccd1 vccd1 sky130_fd_sc_hd__fill_1
X_08350_ net115 net119 net112 net99 FPGA_INST.cell0.LEI0.config_data\[9\] FPGA_INST.cell0.LEI0.config_data\[10\]
+ vssd1 vssd1 vccd1 vccd1 _04572_ sky130_fd_sc_hd__mux4_1
X_07301_ FPGA_INST.cell1.CB_1.config_dataA\[23\] FPGA_INST.cell1.CB_1.config_dataA\[22\]
+ _03561_ vssd1 vssd1 vccd1 vccd1 _03562_ sky130_fd_sc_hd__or3_1
X_05562_ FPGA_INST.cell2.SB0.route_sel\[114\] FPGA_INST.cell2.SB0.route_sel\[115\]
+ vssd1 vssd1 vccd1 vccd1 _01842_ sky130_fd_sc_hd__nand2_1
X_05493_ FPGA_INST.cell3.CB_0.config_dataB\[1\] vssd1 vssd1 vccd1 vccd1 _01775_ sky130_fd_sc_hd__inv_2
XANTENNA__07645__A3 _03775_ vssd1 vssd1 vccd1 vccd1 sky130_fd_sc_hd__diode_2
XANTENNA__06302__A0 net14 vssd1 vssd1 vccd1 vccd1 sky130_fd_sc_hd__diode_2
XFILLER_20_724 vssd1 vssd1 vccd1 vccd1 sky130_fd_sc_hd__fill_2
X_08281_ _04504_ _04501_ _04470_ vssd1 vssd1 vccd1 vccd1 _04505_ sky130_fd_sc_hd__mux2_1
X_07232_ _03494_ _03492_ vssd1 vssd1 vccd1 vccd1 FPGA_INST.bus3_2\[1\] sky130_fd_sc_hd__and2b_2
XFILLER_20_768 vssd1 vssd1 vccd1 vccd1 sky130_fd_sc_hd__fill_4
X_07163_ FPGA_INST.cell3.SB0.route_sel\[6\] FPGA_INST.cell3.SB0.route_sel\[7\] _03425_
+ _03426_ vssd1 vssd1 vccd1 vccd1 _03427_ sky130_fd_sc_hd__a211o_1
XFILLER_117_111 vssd1 vssd1 vccd1 vccd1 sky130_fd_sc_hd__fill_1
X_06114_ net117 _01814_ _02332_ _02378_ _02393_ vssd1 vssd1 vccd1 vccd1 _02394_ sky130_fd_sc_hd__a32o_1
XANTENNA__10401__A2 net525 vssd1 vssd1 vccd1 vccd1 sky130_fd_sc_hd__diode_2
X_07094_ FPGA_INST.cell0.CB_0.config_dataA\[18\] FPGA_INST.cell0.CB_0.config_dataA\[17\]
+ vssd1 vssd1 vccd1 vccd1 _03360_ sky130_fd_sc_hd__or2_1
X_06045_ _02324_ net136 _02323_ vssd1 vssd1 vccd1 vccd1 _02325_ sky130_fd_sc_hd__mux2_1
Xfanout214 net216 vssd1 vssd1 vccd1 vccd1 net214 sky130_fd_sc_hd__clkbuf_4
Xfanout203 net206 vssd1 vssd1 vccd1 vccd1 net203 sky130_fd_sc_hd__clkbuf_4
X_09804_ FPGA_INST.cell1.LE_1B.config_data\[5\] FPGA_INST.cell1.LE_1B.config_data\[4\]
+ net345 vssd1 vssd1 vccd1 vccd1 _00713_ sky130_fd_sc_hd__mux2_1
Xfanout225 net226 vssd1 vssd1 vccd1 vccd1 net225 sky130_fd_sc_hd__clkbuf_2
Xfanout247 net249 vssd1 vssd1 vccd1 vccd1 net247 sky130_fd_sc_hd__clkbuf_4
Xfanout236 net237 vssd1 vssd1 vccd1 vccd1 net236 sky130_fd_sc_hd__dlymetal6s2s_1
X_07996_ _04223_ _04222_ _04114_ vssd1 vssd1 vccd1 vccd1 _04224_ sky130_fd_sc_hd__mux2_1
Xfanout269 net273 vssd1 vssd1 vccd1 vccd1 net269 sky130_fd_sc_hd__clkbuf_4
Xfanout258 net267 vssd1 vssd1 vccd1 vccd1 net258 sky130_fd_sc_hd__clkbuf_2
X_09735_ net466 net465 net230 vssd1 vssd1 vccd1 vccd1 _00644_ sky130_fd_sc_hd__mux2_1
XTAP_TAPCELL_ROW_87_1500 vssd1 vccd1 sky130_fd_sc_hd__tapvpwrvgnd_1
X_06947_ net416 _02392_ _03214_ net414 vssd1 vssd1 vccd1 vccd1 _03215_ sky130_fd_sc_hd__o211a_1
X_09666_ FPGA_INST.cell0.SB0.route_sel\[69\] FPGA_INST.cell0.SB0.route_sel\[70\] net186
+ vssd1 vssd1 vccd1 vccd1 _00575_ sky130_fd_sc_hd__mux2_1
XANTENNA_fanout657_A net662 vssd1 vssd1 vccd1 vccd1 sky130_fd_sc_hd__diode_2
X_08617_ FPGA_INST.cell3.SB0.route_sel\[6\] FPGA_INST.cell3.SB0.route_sel\[7\] vssd1
+ vssd1 vccd1 vccd1 _04826_ sky130_fd_sc_hd__nand2b_1
X_06878_ _03141_ _03142_ _03144_ _03145_ vssd1 vssd1 vccd1 vccd1 _03146_ sky130_fd_sc_hd__o2bb2a_1
X_09597_ FPGA_INST.cell0.SB0.route_sel\[0\] FPGA_INST.cell0.SB0.route_sel\[1\] net195
+ vssd1 vssd1 vccd1 vccd1 _00506_ sky130_fd_sc_hd__mux2_1
XFILLER_55_698 vssd1 vssd1 vccd1 vccd1 sky130_fd_sc_hd__fill_1
X_05829_ _02106_ _02108_ vssd1 vssd1 vccd1 vccd1 _02109_ sky130_fd_sc_hd__or2_1
XFILLER_27_389 vssd1 vssd1 vccd1 vccd1 sky130_fd_sc_hd__fill_2
X_08548_ FPGA_INST.cell3.LEI0.config_data\[35\] _04757_ _04758_ FPGA_INST.cell3.CB_1.config_dataB\[14\]
+ vssd1 vssd1 vccd1 vccd1 _04759_ sky130_fd_sc_hd__o211a_1
XFILLER_70_668 vssd1 vssd1 vccd1 vccd1 sky130_fd_sc_hd__fill_8
XFILLER_42_359 vssd1 vssd1 vccd1 vccd1 sky130_fd_sc_hd__fill_1
XFILLER_23_540 vssd1 vssd1 vccd1 vccd1 sky130_fd_sc_hd__fill_1
X_08479_ FPGA_INST.cell1.LEI0.config_data\[35\] _04694_ vssd1 vssd1 vccd1 vccd1 _04695_
+ sky130_fd_sc_hd__nand2b_1
XANTENNA__07097__A1 FPGA_INST.bus2_0\[7\] vssd1 vssd1 vccd1 vccd1 sky130_fd_sc_hd__diode_2
XANTENNA__06844__B2 _01984_ vssd1 vssd1 vccd1 vccd1 sky130_fd_sc_hd__diode_2
XANTENNA__06844__A1 _01937_ vssd1 vssd1 vccd1 vccd1 sky130_fd_sc_hd__diode_2
XFILLER_24_77 vssd1 vssd1 vccd1 vccd1 sky130_fd_sc_hd__fill_1
X_11490_ net746 _00840_ net531 vssd1 vssd1 vccd1 vccd1 FPGA_INST.cell0.LE_1A.edge_mode
+ sky130_fd_sc_hd__dfstp_1
X_10510_ FPGA_INST.cell2.SB0.route_sel\[82\] FPGA_INST.cell2.SB0.route_sel\[83\] net260
+ vssd1 vssd1 vccd1 vccd1 _01389_ sky130_fd_sc_hd__mux2_1
X_10441_ FPGA_INST.cell2.SB0.route_sel\[13\] FPGA_INST.cell2.SB0.route_sel\[14\] net235
+ vssd1 vssd1 vccd1 vccd1 _01320_ sky130_fd_sc_hd__mux2_1
XFILLER_109_667 vssd1 vssd1 vccd1 vccd1 sky130_fd_sc_hd__fill_2
XTAP_TAPCELL_ROW_98_1651 vssd1 vccd1 sky130_fd_sc_hd__tapvpwrvgnd_1
XFILLER_40_54 vssd1 vssd1 vccd1 vccd1 sky130_fd_sc_hd__fill_1
X_10372_ FPGA_INST.cell3.LE_0B.config_data\[13\] FPGA_INST.cell3.LE_0B.config_data\[14\]
+ net301 vssd1 vssd1 vccd1 vccd1 _01252_ sky130_fd_sc_hd__mux2_1
X_12111_ net912 _01457_ net696 vssd1 vssd1 vccd1 vccd1 FPGA_INST.cell3.CB_0.config_dataA\[23\]
+ sky130_fd_sc_hd__dfstp_1
XFILLER_123_169 vssd1 vssd1 vccd1 vccd1 sky130_fd_sc_hd__fill_4
XFILLER_123_158 vssd1 vssd1 vccd1 vccd1 sky130_fd_sc_hd__fill_1
X_12042_ net866 _01388_ net653 vssd1 vssd1 vccd1 vccd1 FPGA_INST.cell2.SB0.route_sel\[82\]
+ sky130_fd_sc_hd__dfstp_1
XANTENNA__07021__A1 _01984_ vssd1 vssd1 vccd1 vccd1 sky130_fd_sc_hd__diode_2
XANTENNA__07021__B2 _01937_ vssd1 vssd1 vccd1 vccd1 sky130_fd_sc_hd__diode_2
XFILLER_93_738 vssd1 vssd1 vccd1 vccd1 sky130_fd_sc_hd__fill_1
Xfanout792 net803 vssd1 vssd1 vccd1 vccd1 net792 sky130_fd_sc_hd__clkbuf_2
Xfanout781 net790 vssd1 vssd1 vccd1 vccd1 net781 sky130_fd_sc_hd__buf_2
Xfanout770 net772 vssd1 vssd1 vccd1 vccd1 net770 sky130_fd_sc_hd__clkbuf_2
XANTENNA__07833__X net52 vssd1 vssd1 vccd1 vccd1 sky130_fd_sc_hd__diode_2
XTAP_TAPCELL_ROW_125_2036 vssd1 vccd1 sky130_fd_sc_hd__tapvpwrvgnd_1
XFILLER_65_62 vssd1 vssd1 vccd1 vccd1 sky130_fd_sc_hd__fill_1
XFILLER_46_665 vssd1 vssd1 vccd1 vccd1 sky130_fd_sc_hd__fill_2
XANTENNA__08096__B _04049_ vssd1 vssd1 vccd1 vccd1 sky130_fd_sc_hd__diode_2
XTAP_TAPCELL_ROW_107_1780 vssd1 vccd1 sky130_fd_sc_hd__tapvpwrvgnd_1
XFILLER_60_112 vssd1 vssd1 vccd1 vccd1 sky130_fd_sc_hd__fill_1
XTAP_TAPCELL_ROW_16_502 vssd1 vccd1 sky130_fd_sc_hd__tapvpwrvgnd_1
XTAP_TAPCELL_ROW_16_513 vssd1 vccd1 sky130_fd_sc_hd__tapvpwrvgnd_1
XFILLER_33_337 vssd1 vssd1 vccd1 vccd1 sky130_fd_sc_hd__fill_4
X_11826_ net941 _01172_ net725 vssd1 vssd1 vccd1 vccd1 FPGA_INST.cell3.LEI0.config_data\[6\]
+ sky130_fd_sc_hd__dfrtp_1
X_11757_ net900 _01103_ net684 vssd1 vssd1 vccd1 vccd1 FPGA_INST.cell3.SB0.config_data_out
+ sky130_fd_sc_hd__dfstp_1
XTAP_TAPCELL_ROW_44_899 vssd1 vccd1 sky130_fd_sc_hd__tapvpwrvgnd_1
XANTENNA__07088__B2 _02465_ vssd1 vssd1 vccd1 vccd1 sky130_fd_sc_hd__diode_2
XANTENNA__07088__A1 _02429_ vssd1 vssd1 vccd1 vccd1 sky130_fd_sc_hd__diode_2
X_10708_ net851 _00058_ net636 vssd1 vssd1 vccd1 vccd1 FPGA_INST.cell2.LE_0A.config_data\[7\]
+ sky130_fd_sc_hd__dfrtp_1
XANTENNA__06835__A1 FPGA_INST.bus2_0\[5\] vssd1 vssd1 vccd1 vccd1 sky130_fd_sc_hd__diode_2
X_11688_ net897 _01034_ net681 vssd1 vssd1 vccd1 vccd1 FPGA_INST.cell3.SB0.route_sel\[58\]
+ sky130_fd_sc_hd__dfstp_1
X_10639_ FPGA_INST.cell3.LE_1B.config_data\[9\] FPGA_INST.cell3.LE_1B.config_data\[8\]
+ net368 vssd1 vssd1 vccd1 vccd1 _01518_ sky130_fd_sc_hd__mux2_1
XTAP_TAPCELL_ROW_58_1101 vssd1 vccd1 sky130_fd_sc_hd__tapvpwrvgnd_1
XANTENNA__06344__B _02376_ vssd1 vssd1 vccd1 vccd1 sky130_fd_sc_hd__diode_2
XFILLER_115_615 vssd1 vssd1 vccd1 vccd1 sky130_fd_sc_hd__fill_1
XANTENNA__10581__S net284 vssd1 vssd1 vccd1 vccd1 sky130_fd_sc_hd__diode_2
XFILLER_123_670 vssd1 vssd1 vccd1 vccd1 sky130_fd_sc_hd__fill_2
XPHY_EDGE_ROW_18_Right_18 vssd1 vssd1 vccd1 vccd1 sky130_fd_sc_hd__decap_3
X_07850_ _02478_ _02487_ _02480_ vssd1 vssd1 vccd1 vccd1 _04079_ sky130_fd_sc_hd__o21a_1
XFILLER_83_204 vssd1 vssd1 vccd1 vccd1 sky130_fd_sc_hd__fill_1
XANTENNA__07563__A2 _03775_ vssd1 vssd1 vccd1 vccd1 sky130_fd_sc_hd__diode_2
X_07781_ net146 _03548_ _03912_ _04029_ vssd1 vssd1 vccd1 vccd1 _04030_ sky130_fd_sc_hd__a31o_1
XANTENNA__05574__A1 net133 vssd1 vssd1 vccd1 vccd1 sky130_fd_sc_hd__diode_2
XFILLER_56_418 vssd1 vssd1 vccd1 vccd1 sky130_fd_sc_hd__fill_2
XANTENNA__11273__CLK net789 vssd1 vssd1 vccd1 vccd1 sky130_fd_sc_hd__diode_2
X_06801_ net139 net127 net131 net102 FPGA_INST.cell2.LEI0.config_data\[45\] FPGA_INST.cell2.LEI0.config_data\[46\]
+ vssd1 vssd1 vccd1 vccd1 _03075_ sky130_fd_sc_hd__mux4_1
X_09520_ FPGA_INST.cell1.LE_0A.config_data\[15\] FPGA_INST.cell1.LE_0A.config_data\[16\]
+ net228 vssd1 vssd1 vccd1 vccd1 _00431_ sky130_fd_sc_hd__mux2_1
X_06732_ _03000_ _03001_ _03005_ vssd1 vssd1 vccd1 vccd1 _03006_ sky130_fd_sc_hd__o21ai_1
Xinput3 gpio_in[11] vssd1 vssd1 vccd1 vccd1 net3 sky130_fd_sc_hd__buf_2
XANTENNA__07191__A FPGA_INST.cell1.CB_0.config_dataB\[24\] vssd1 vssd1 vccd1 vccd1
+ sky130_fd_sc_hd__diode_2
XTAP_TAPCELL_ROW_69_1252 vssd1 vccd1 sky130_fd_sc_hd__tapvpwrvgnd_1
X_09451_ net522 _04230_ vssd1 vssd1 vccd1 vccd1 _05213_ sky130_fd_sc_hd__nor2_1
X_06663_ _02930_ _02931_ _02938_ vssd1 vssd1 vccd1 vccd1 _02939_ sky130_fd_sc_hd__o21ba_1
XFILLER_36_186 vssd1 vssd1 vccd1 vccd1 sky130_fd_sc_hd__fill_1
XFILLER_101_38 vssd1 vssd1 vccd1 vccd1 sky130_fd_sc_hd__fill_4
XFILLER_91_292 vssd1 vssd1 vccd1 vccd1 sky130_fd_sc_hd__fill_1
XTAP_TAPCELL_ROW_82_1430 vssd1 vccd1 sky130_fd_sc_hd__tapvpwrvgnd_1
X_08402_ net75 FPGA_INST.bus1_0\[5\] net74 FPGA_INST.bus1_0\[7\] net440 FPGA_INST.cell0.CB_1.config_dataB\[16\]
+ vssd1 vssd1 vccd1 vccd1 _04624_ sky130_fd_sc_hd__mux4_1
X_05614_ _01846_ _01893_ vssd1 vssd1 vccd1 vccd1 _01894_ sky130_fd_sc_hd__nand2_1
X_06594_ net483 _02796_ _02869_ vssd1 vssd1 vccd1 vccd1 _02870_ sky130_fd_sc_hd__a21o_1
X_09382_ net496 net497 net356 vssd1 vssd1 vccd1 vccd1 _00295_ sky130_fd_sc_hd__mux2_1
XPHY_EDGE_ROW_27_Right_27 vssd1 vssd1 vccd1 vccd1 sky130_fd_sc_hd__decap_3
X_08333_ _03797_ _04547_ _04548_ _03759_ _04554_ vssd1 vssd1 vccd1 vccd1 _04555_ sky130_fd_sc_hd__a221o_1
X_05545_ FPGA_INST.cell0.CB_1.config_dataA\[24\] FPGA_INST.cell0.CB_1.config_dataA\[20\]
+ FPGA_INST.cell0.CB_1.config_dataA\[21\] vssd1 vssd1 vccd1 vccd1 _01825_ sky130_fd_sc_hd__or3b_4
XFILLER_51_167 vssd1 vssd1 vccd1 vccd1 sky130_fd_sc_hd__fill_1
XANTENNA__08734__B _04785_ vssd1 vssd1 vccd1 vccd1 sky130_fd_sc_hd__diode_2
XANTENNA_fanout140_A net141 vssd1 vssd1 vccd1 vccd1 sky130_fd_sc_hd__diode_2
X_08264_ net75 FPGA_INST.bus1_0\[5\] net74 FPGA_INST.bus1_0\[7\] net404 FPGA_INST.cell0.CB_1.config_dataA\[16\]
+ vssd1 vssd1 vccd1 vccd1 _04488_ sky130_fd_sc_hd__mux4_1
XANTENNA__06535__A _02810_ vssd1 vssd1 vccd1 vccd1 sky130_fd_sc_hd__diode_2
X_05476_ FPGA_INST.cell0.CB_1.config_dataB\[7\] vssd1 vssd1 vccd1 vccd1 _01758_ sky130_fd_sc_hd__inv_2
X_07215_ _02435_ _02780_ _02438_ vssd1 vssd1 vccd1 vccd1 _03478_ sky130_fd_sc_hd__o21a_1
X_08195_ _03639_ _04413_ _04414_ _03604_ _01754_ vssd1 vssd1 vccd1 vccd1 _04419_ sky130_fd_sc_hd__a221o_1
X_07146_ FPGA_INST.cell1.SB0.route_sel\[7\] FPGA_INST.cell1.SB0.route_sel\[6\] _02456_
+ _03409_ net104 vssd1 vssd1 vccd1 vccd1 _03410_ sky130_fd_sc_hd__a221oi_4
XANTENNA__08043__A3 FPGA_INST.bus3_1\[3\] vssd1 vssd1 vccd1 vccd1 sky130_fd_sc_hd__diode_2
X_07077_ _03341_ _03342_ _01734_ vssd1 vssd1 vccd1 vccd1 _03343_ sky130_fd_sc_hd__mux2_1
XFILLER_126_46 vssd1 vssd1 vccd1 vccd1 sky130_fd_sc_hd__fill_2
X_06028_ FPGA_INST.cell0.SB0.route_sel\[46\] _01686_ FPGA_INST.cell0.SB0.route_sel\[42\]
+ FPGA_INST.cell0.SB0.route_sel\[43\] _02307_ vssd1 vssd1 vccd1 vccd1 _02308_ sky130_fd_sc_hd__o221a_1
XPHY_EDGE_ROW_36_Right_36 vssd1 vssd1 vccd1 vccd1 sky130_fd_sc_hd__decap_3
XTAP_TAPCELL_ROW_93_1581 vssd1 vccd1 sky130_fd_sc_hd__tapvpwrvgnd_1
XFILLER_87_521 vccd1 vssd1 vccd1 vssd1 sky130_ef_sc_hd__decap_40_12
XFILLER_101_331 vssd1 vssd1 vccd1 vccd1 sky130_fd_sc_hd__fill_1
XFILLER_75_727 vssd1 vssd1 vccd1 vccd1 sky130_fd_sc_hd__fill_1
XFILLER_59_256 vssd1 vssd1 vccd1 vccd1 sky130_fd_sc_hd__fill_2
XFILLER_19_55 vssd1 vssd1 vccd1 vccd1 sky130_fd_sc_hd__fill_1
XANTENNA_fanout941_A net945 vssd1 vssd1 vccd1 vccd1 sky130_fd_sc_hd__diode_2
X_07979_ _04206_ vssd1 vssd1 vccd1 vccd1 _04207_ sky130_fd_sc_hd__inv_2
XFILLER_74_226 vssd1 vssd1 vccd1 vccd1 sky130_fd_sc_hd__fill_2
X_09718_ FPGA_INST.cell0.SB0.route_sel\[121\] FPGA_INST.cell0.SB0.route_sel\[122\]
+ net199 vssd1 vssd1 vccd1 vccd1 _00627_ sky130_fd_sc_hd__mux2_1
XFILLER_19_77 vccd1 vssd1 vccd1 vssd1 sky130_ef_sc_hd__decap_40_12
XFILLER_28_621 vccd1 vssd1 vccd1 vssd1 sky130_ef_sc_hd__decap_40_12
X_10990_ net859 _00340_ net645 vssd1 vssd1 vccd1 vccd1 FPGA_INST.cell2.CB_1.config_dataA\[21\]
+ sky130_fd_sc_hd__dfstp_1
XFILLER_28_654 vssd1 vssd1 vccd1 vccd1 sky130_fd_sc_hd__fill_4
XFILLER_83_782 vssd1 vssd1 vccd1 vccd1 sky130_fd_sc_hd__fill_2
XFILLER_70_421 vssd1 vssd1 vccd1 vccd1 sky130_fd_sc_hd__fill_1
XPHY_EDGE_ROW_45_Right_45 vssd1 vssd1 vccd1 vccd1 sky130_fd_sc_hd__decap_3
XFILLER_43_635 vssd1 vssd1 vccd1 vccd1 sky130_fd_sc_hd__fill_1
X_09649_ FPGA_INST.cell0.SB0.route_sel\[52\] FPGA_INST.cell0.SB0.route_sel\[53\] net179
+ vssd1 vssd1 vccd1 vccd1 _00558_ sky130_fd_sc_hd__mux2_1
XFILLER_70_443 vssd1 vssd1 vccd1 vccd1 sky130_fd_sc_hd__fill_2
XFILLER_15_337 vssd1 vssd1 vccd1 vccd1 sky130_fd_sc_hd__fill_1
XFILLER_42_156 vccd1 vssd1 vccd1 vssd1 sky130_ef_sc_hd__decap_40_12
X_11611_ net741 _00961_ net526 vssd1 vssd1 vccd1 vccd1 FPGA_INST.cell0.LE_1B.config_data\[5\]
+ sky130_fd_sc_hd__dfrtp_1
XANTENNA__08806__A2 net25 vssd1 vssd1 vccd1 vccd1 sky130_fd_sc_hd__diode_2
XTAP_TAPCELL_ROW_41_858 vssd1 vccd1 sky130_fd_sc_hd__tapvpwrvgnd_1
XFILLER_7_503 vssd1 vssd1 vccd1 vccd1 sky130_fd_sc_hd__fill_1
X_11542_ net777 _00892_ net563 vssd1 vssd1 vccd1 vccd1 FPGA_INST.cell0.CB_0.config_dataA\[11\]
+ sky130_fd_sc_hd__dfstp_1
XFILLER_7_547 vssd1 vssd1 vccd1 vccd1 sky130_fd_sc_hd__fill_1
X_11473_ net745 _00823_ net530 vssd1 vssd1 vccd1 vccd1 FPGA_INST.cell0.LE_1A.config_data\[0\]
+ sky130_fd_sc_hd__dfrtp_1
XTAP_TAPCELL_ROW_21_571 vssd1 vccd1 sky130_fd_sc_hd__tapvpwrvgnd_1
XTAP_TAPCELL_ROW_21_582 vssd1 vccd1 sky130_fd_sc_hd__tapvpwrvgnd_1
X_10424_ FPGA_INST.cell3.CB_1.config_dataB\[21\] FPGA_INST.cell3.CB_1.config_dataB\[22\]
+ net279 vssd1 vssd1 vccd1 vccd1 _01303_ sky130_fd_sc_hd__mux2_1
XPHY_EDGE_ROW_54_Right_54 vssd1 vssd1 vccd1 vccd1 sky130_fd_sc_hd__decap_3
X_10355_ FPGA_INST.cell3.LE_0B.dff0_out _05108_ net737 vssd1 vssd1 vccd1 vccd1 _01236_
+ sky130_fd_sc_hd__mux2_1
XFILLER_3_753 vccd1 vssd1 vccd1 vssd1 sky130_ef_sc_hd__decap_40_12
X_10286_ FPGA_INST.cell3.LEI0.config_data\[0\] FPGA_INST.cell3.LEI0.config_data\[1\]
+ net296 vssd1 vssd1 vccd1 vccd1 _01167_ sky130_fd_sc_hd__mux2_1
XTAP_TAPCELL_ROW_53_1031 vssd1 vccd1 sky130_fd_sc_hd__tapvpwrvgnd_1
XTAP_TAPCELL_ROW_53_1020 vssd1 vccd1 sky130_fd_sc_hd__tapvpwrvgnd_1
XFILLER_78_554 vssd1 vssd1 vccd1 vccd1 sky130_fd_sc_hd__fill_1
X_12025_ net857 _01371_ net642 vssd1 vssd1 vccd1 vccd1 FPGA_INST.cell2.SB0.route_sel\[65\]
+ sky130_fd_sc_hd__dfstp_1
XFILLER_78_587 vssd1 vssd1 vccd1 vccd1 sky130_fd_sc_hd__fill_1
XFILLER_76_83 vssd1 vssd1 vccd1 vccd1 sky130_fd_sc_hd__fill_1
XPHY_EDGE_ROW_63_Right_63 vssd1 vssd1 vccd1 vccd1 sky130_fd_sc_hd__decap_3
XTAP_TAPCELL_ROW_49_969 vssd1 vccd1 sky130_fd_sc_hd__tapvpwrvgnd_1
XTAP_TAPCELL_ROW_29_682 vssd1 vccd1 sky130_fd_sc_hd__tapvpwrvgnd_1
XTAP_TAPCELL_ROW_29_693 vssd1 vccd1 sky130_fd_sc_hd__tapvpwrvgnd_1
XANTENNA__09430__S net354 vssd1 vssd1 vccd1 vccd1 sky130_fd_sc_hd__diode_2
XPHY_EDGE_ROW_1_Left_132 vssd1 vssd1 vccd1 vccd1 sky130_fd_sc_hd__decap_3
X_11809_ net871 _01155_ net655 vssd1 vssd1 vccd1 vccd1 net34 sky130_fd_sc_hd__dfrtp_1
XPHY_EDGE_ROW_38_Left_169 vssd1 vssd1 vccd1 vccd1 sky130_fd_sc_hd__decap_3
X_05330_ FPGA_INST.cell1.SB0.route_sel\[114\] vssd1 vssd1 vccd1 vccd1 _01612_ sky130_fd_sc_hd__inv_2
XTAP_TAPCELL_ROW_64_1182 vssd1 vccd1 sky130_fd_sc_hd__tapvpwrvgnd_1
XFILLER_42_690 vssd1 vssd1 vccd1 vccd1 sky130_fd_sc_hd__fill_1
XANTENNA__07481__A1 net26 vssd1 vssd1 vccd1 vccd1 sky130_fd_sc_hd__diode_2
X_05261_ FPGA_INST.cell2.CB_0.config_dataB\[18\] vssd1 vssd1 vccd1 vccd1 _01543_ sky130_fd_sc_hd__inv_2
XPHY_EDGE_ROW_72_Right_72 vssd1 vssd1 vccd1 vccd1 sky130_fd_sc_hd__decap_3
X_07000_ _01937_ _03246_ _03247_ _01984_ vssd1 vssd1 vccd1 vccd1 _03266_ sky130_fd_sc_hd__a22o_1
XFILLER_128_795 vssd1 vssd1 vccd1 vccd1 sky130_fd_sc_hd__fill_1
XANTENNA__08025__A3 FPGA_INST.bus3_1\[11\] vssd1 vssd1 vccd1 vccd1 sky130_fd_sc_hd__diode_2
X_08951_ FPGA_INST.cell1.SB0.route_sel\[76\] _01651_ _05140_ vssd1 vssd1 vccd1 vccd1
+ _05141_ sky130_fd_sc_hd__o21ai_1
XPHY_EDGE_ROW_47_Left_178 vssd1 vssd1 vccd1 vccd1 sky130_fd_sc_hd__decap_3
XANTENNA__06992__A0 FPGA_INST.bus2_0\[2\] vssd1 vssd1 vccd1 vccd1 sky130_fd_sc_hd__diode_2
X_07902_ net473 _03889_ vssd1 vssd1 vccd1 vccd1 _04130_ sky130_fd_sc_hd__nand2_1
X_08882_ _04794_ _05072_ _05074_ _04789_ FPGA_INST.cell3.CB_0.config_dataB\[17\] vssd1
+ vssd1 vccd1 vccd1 _05089_ sky130_fd_sc_hd__a221o_1
XFILLER_111_673 vssd1 vssd1 vccd1 vccd1 sky130_fd_sc_hd__fill_1
XANTENNA__09605__S net196 vssd1 vssd1 vccd1 vccd1 sky130_fd_sc_hd__diode_2
X_07833_ _02159_ _02160_ _04069_ _02161_ vssd1 vssd1 vccd1 vccd1 net52 sky130_fd_sc_hd__a31o_1
XPHY_EDGE_ROW_81_Right_81 vssd1 vssd1 vccd1 vccd1 sky130_fd_sc_hd__decap_3
XFILLER_112_15 vccd1 vssd1 vccd1 vssd1 sky130_ef_sc_hd__decap_40_12
X_07764_ _04010_ _04011_ _04012_ _04009_ _03992_ vssd1 vssd1 vccd1 vccd1 _04014_ sky130_fd_sc_hd__a311o_1
X_09503_ FPGA_INST.cell1.LE_0B.dff1_out net523 _05214_ vssd1 vssd1 vccd1 vccd1 _00414_
+ sky130_fd_sc_hd__a21bo_1
XFILLER_112_37 vssd1 vssd1 vccd1 vccd1 sky130_fd_sc_hd__fill_2
X_07695_ _03447_ _03907_ net78 vssd1 vssd1 vccd1 vccd1 _03946_ sky130_fd_sc_hd__o21ai_1
X_06715_ FPGA_INST.cell2.LEI0.config_data\[10\] _02988_ vssd1 vssd1 vccd1 vccd1 _02989_
+ sky130_fd_sc_hd__nor2_1
XFILLER_37_462 vssd1 vssd1 vccd1 vccd1 sky130_fd_sc_hd__fill_1
XFILLER_37_484 vccd1 vssd1 vccd1 vssd1 sky130_ef_sc_hd__decap_40_12
X_09434_ FPGA_INST.cell2.LE_1B.config_data\[3\] FPGA_INST.cell2.LE_1B.config_data\[2\]
+ net360 vssd1 vssd1 vccd1 vccd1 _00347_ sky130_fd_sc_hd__mux2_1
XANTENNA_fanout355_A net381 vssd1 vssd1 vccd1 vccd1 sky130_fd_sc_hd__diode_2
XFILLER_64_292 vssd1 vssd1 vccd1 vccd1 sky130_fd_sc_hd__fill_1
X_06646_ FPGA_INST.bus3_2\[12\] FPGA_INST.bus3_2\[13\] FPGA_INST.bus3_2\[14\] FPGA_INST.bus3_2\[15\]
+ net476 FPGA_INST.cell2.CB_1.config_dataA\[16\] vssd1 vssd1 vccd1 vccd1 _02922_ sky130_fd_sc_hd__mux4_1
XPHY_EDGE_ROW_56_Left_187 vssd1 vssd1 vccd1 vccd1 sky130_fd_sc_hd__decap_3
XFILLER_52_432 vccd1 vssd1 vccd1 vssd1 sky130_ef_sc_hd__decap_40_12
XFILLER_52_421 vssd1 vssd1 vccd1 vccd1 sky130_fd_sc_hd__fill_2
XFILLER_52_454 vssd1 vssd1 vccd1 vccd1 sky130_fd_sc_hd__fill_1
XANTENNA_fanout522_A net525 vssd1 vssd1 vccd1 vccd1 sky130_fd_sc_hd__diode_2
X_06577_ net483 _02814_ vssd1 vssd1 vccd1 vccd1 _02853_ sky130_fd_sc_hd__nand2_1
X_09365_ FPGA_INST.cell2.CB_0.config_dataA\[8\] FPGA_INST.cell2.CB_0.config_dataA\[9\]
+ net240 vssd1 vssd1 vccd1 vccd1 _00278_ sky130_fd_sc_hd__mux2_1
XFILLER_40_638 vssd1 vssd1 vccd1 vccd1 sky130_fd_sc_hd__fill_4
XFILLER_40_649 vssd1 vssd1 vccd1 vccd1 sky130_fd_sc_hd__fill_2
X_05528_ net740 _01805_ _01808_ FPGA_INST.config_en_q vssd1 vssd1 vccd1 vccd1 FPGA_INST.cfg_error_d\[1\]
+ sky130_fd_sc_hd__and4b_1
X_09296_ FPGA_INST.cell1.SB0.route_sel\[67\] FPGA_INST.cell1.SB0.route_sel\[68\] net209
+ vssd1 vssd1 vccd1 vccd1 _00209_ sky130_fd_sc_hd__mux2_1
XANTENNA__08264__A3 FPGA_INST.bus1_0\[7\] vssd1 vssd1 vccd1 vccd1 sky130_fd_sc_hd__diode_2
X_08316_ _03639_ _04517_ _04518_ _03604_ _01758_ vssd1 vssd1 vccd1 vccd1 _04538_ sky130_fd_sc_hd__a221o_1
XPHY_EDGE_ROW_90_Right_90 vssd1 vssd1 vccd1 vccd1 sky130_fd_sc_hd__decap_3
X_08247_ net403 _03875_ vssd1 vssd1 vccd1 vccd1 _04471_ sky130_fd_sc_hd__nand2_1
XANTENNA__06275__A2 _02255_ vssd1 vssd1 vccd1 vccd1 sky130_fd_sc_hd__diode_2
X_05459_ FPGA_INST.cell0.CB_0.config_dataB\[2\] vssd1 vssd1 vccd1 vccd1 _01741_ sky130_fd_sc_hd__inv_2
XFILLER_119_773 vssd1 vssd1 vccd1 vccd1 sky130_fd_sc_hd__fill_1
XTAP_TAPCELL_ROW_95_1610 vssd1 vccd1 sky130_fd_sc_hd__tapvpwrvgnd_1
XANTENNA_fanout891_A net892 vssd1 vssd1 vccd1 vccd1 sky130_fd_sc_hd__diode_2
X_08178_ net413 _03558_ vssd1 vssd1 vccd1 vccd1 _04402_ sky130_fd_sc_hd__nand2_1
XPHY_EDGE_ROW_65_Left_196 vssd1 vssd1 vccd1 vccd1 sky130_fd_sc_hd__decap_3
XANTENNA__06712__B net103 vssd1 vssd1 vccd1 vccd1 sky130_fd_sc_hd__diode_2
X_07129_ FPGA_INST.cell0.LE_0A.config_data\[16\] _03392_ _03393_ net155 vssd1 vssd1
+ vccd1 vccd1 FPGA_INST.cell0.CB_0.le_outA sky130_fd_sc_hd__o211a_2
XFILLER_121_415 vssd1 vssd1 vccd1 vccd1 sky130_fd_sc_hd__fill_2
X_10140_ FPGA_INST.cell3.SB0.route_sel\[45\] FPGA_INST.cell3.SB0.route_sel\[44\] net348
+ vssd1 vssd1 vccd1 vccd1 _01021_ sky130_fd_sc_hd__mux2_1
XFILLER_0_723 vssd1 vssd1 vccd1 vccd1 sky130_fd_sc_hd__fill_4
X_10071_ FPGA_INST.cell0.CB_1.config_dataA\[20\] FPGA_INST.cell0.CB_1.config_dataA\[21\]
+ net188 vssd1 vssd1 vccd1 vccd1 _00952_ sky130_fd_sc_hd__mux2_1
XANTENNA__09515__S net344 vssd1 vssd1 vccd1 vccd1 sky130_fd_sc_hd__diode_2
XANTENNA__08724__A1 net18 vssd1 vssd1 vccd1 vccd1 sky130_fd_sc_hd__diode_2
XFILLER_47_204 vssd1 vssd1 vccd1 vccd1 sky130_fd_sc_hd__fill_1
XTAP_TAPCELL_ROW_7_377 vssd1 vccd1 sky130_fd_sc_hd__tapvpwrvgnd_1
XFILLER_87_395 vssd1 vssd1 vccd1 vccd1 sky130_fd_sc_hd__fill_4
XANTENNA__06735__A0 _02801_ vssd1 vssd1 vccd1 vccd1 sky130_fd_sc_hd__diode_2
XANTENNA__06750__A3 _02814_ vssd1 vssd1 vccd1 vccd1 sky130_fd_sc_hd__diode_2
X_10973_ net879 _00323_ net664 vssd1 vssd1 vccd1 vccd1 FPGA_INST.cell2.CB_1.config_dataA\[4\]
+ sky130_fd_sc_hd__dfstp_1
XTAP_TAPCELL_ROW_46_928 vssd1 vccd1 sky130_fd_sc_hd__tapvpwrvgnd_1
XFILLER_55_292 vssd1 vssd1 vccd1 vccd1 sky130_fd_sc_hd__fill_2
Xmax_cap76 net77 vssd1 vssd1 vccd1 vccd1 net76 sky130_fd_sc_hd__clkbuf_2
XFILLER_71_763 vssd1 vssd1 vccd1 vccd1 sky130_fd_sc_hd__fill_1
XFILLER_70_262 vssd1 vssd1 vccd1 vccd1 sky130_fd_sc_hd__fill_4
XFILLER_15_167 vssd1 vssd1 vccd1 vccd1 sky130_fd_sc_hd__fill_1
XTAP_TAPCELL_ROW_26_641 vssd1 vccd1 sky130_fd_sc_hd__tapvpwrvgnd_1
XTAP_TAPCELL_ROW_26_652 vssd1 vccd1 sky130_fd_sc_hd__tapvpwrvgnd_1
XFILLER_70_295 vssd1 vssd1 vccd1 vccd1 sky130_fd_sc_hd__fill_1
XANTENNA__09452__A2 net522 vssd1 vssd1 vccd1 vccd1 sky130_fd_sc_hd__diode_2
X_11525_ net810 _00875_ net593 vssd1 vssd1 vccd1 vccd1 FPGA_INST.config_bits\[6\]
+ sky130_fd_sc_hd__dfstp_1
XANTENNA__08660__A0 net22 vssd1 vssd1 vccd1 vccd1 sky130_fd_sc_hd__diode_2
XFILLER_7_366 vssd1 vssd1 vccd1 vccd1 sky130_fd_sc_hd__fill_2
XFILLER_7_69 vssd1 vssd1 vccd1 vccd1 sky130_fd_sc_hd__fill_1
X_11456_ net751 _00806_ net536 vssd1 vssd1 vccd1 vccd1 FPGA_INST.cell0.LE_0B.config_data\[5\]
+ sky130_fd_sc_hd__dfrtp_1
X_10407_ FPGA_INST.cell3.CB_1.config_dataB\[4\] FPGA_INST.cell3.CB_1.config_dataB\[5\]
+ net281 vssd1 vssd1 vccd1 vccd1 _01286_ sky130_fd_sc_hd__mux2_1
X_11387_ net759 _00737_ net544 vssd1 vssd1 vccd1 vccd1 FPGA_INST.cell0.LEI0.config_data\[8\]
+ sky130_fd_sc_hd__dfrtp_1
XFILLER_124_253 vssd1 vssd1 vccd1 vccd1 sky130_fd_sc_hd__fill_4
XTAP_TAPCELL_ROW_115_1890 vssd1 vccd1 sky130_fd_sc_hd__tapvpwrvgnd_1
X_10338_ FPGA_INST.cell3.LE_0A.config_data\[2\] FPGA_INST.cell3.LE_0A.config_data\[3\]
+ net294 vssd1 vssd1 vccd1 vccd1 _01219_ sky130_fd_sc_hd__mux2_1
XANTENNA__08963__A1 FPGA_INST.cell2.SB0.route_sel\[64\] vssd1 vssd1 vccd1 vccd1 sky130_fd_sc_hd__diode_2
XFILLER_87_93 vssd1 vssd1 vccd1 vccd1 sky130_fd_sc_hd__fill_4
X_10269_ FPGA_INST.io_east_oeb\[26\] FPGA_INST.io_east_oeb\[28\] net253 vssd1 vssd1
+ vccd1 vccd1 _01150_ sky130_fd_sc_hd__mux2_1
X_12008_ net783 _01354_ net568 vssd1 vssd1 vccd1 vccd1 FPGA_INST.cell2.SB0.route_sel\[48\]
+ sky130_fd_sc_hd__dfstp_1
XFILLER_78_384 vccd1 vssd1 vccd1 vssd1 sky130_ef_sc_hd__decap_40_12
XFILLER_93_376 vssd1 vssd1 vccd1 vccd1 sky130_fd_sc_hd__fill_1
XTAP_TAPCELL_ROW_66_1211 vssd1 vccd1 sky130_fd_sc_hd__tapvpwrvgnd_1
XTAP_TAPCELL_ROW_66_1200 vssd1 vccd1 sky130_fd_sc_hd__tapvpwrvgnd_1
X_07480_ _03578_ _03622_ vssd1 vssd1 vccd1 vccd1 _03737_ sky130_fd_sc_hd__or2_1
X_06500_ _02775_ vssd1 vssd1 vccd1 vccd1 _02776_ sky130_fd_sc_hd__inv_2
XFILLER_34_421 vssd1 vssd1 vccd1 vccd1 sky130_fd_sc_hd__fill_1
XANTENNA__11311__CLK net842 vssd1 vssd1 vccd1 vccd1 sky130_fd_sc_hd__diode_2
XANTENNA__05541__X _01821_ vssd1 vssd1 vccd1 vccd1 sky130_fd_sc_hd__diode_2
X_06431_ _02704_ _02705_ _02707_ _02708_ vssd1 vssd1 vccd1 vccd1 _02709_ sky130_fd_sc_hd__o22a_1
X_09150_ FPGA_INST.cell2.LE_0A.config_data\[13\] FPGA_INST.cell2.LE_0A.config_data\[14\]
+ net252 vssd1 vssd1 vccd1 vccd1 _00065_ sky130_fd_sc_hd__mux2_1
X_06362_ net494 _01869_ _02639_ net493 vssd1 vssd1 vccd1 vccd1 _02640_ sky130_fd_sc_hd__o211a_1
X_08101_ FPGA_INST.cell1.CB_0.config_dataB\[13\] _04301_ FPGA_INST.cell1.CB_0.config_dataB\[12\]
+ FPGA_INST.cell1.CB_0.config_dataB\[14\] vssd1 vssd1 vccd1 vccd1 _04327_ sky130_fd_sc_hd__or4b_1
X_09081_ net86 _04828_ _03436_ vssd1 vssd1 vccd1 vccd1 _05208_ sky130_fd_sc_hd__mux2_1
X_05313_ FPGA_INST.cell2.LEI0.config_data\[23\] vssd1 vssd1 vccd1 vccd1 _01595_ sky130_fd_sc_hd__inv_2
X_06293_ _02572_ _02537_ _02502_ vssd1 vssd1 vccd1 vccd1 _02573_ sky130_fd_sc_hd__mux2_1
X_08032_ FPGA_INST.cell1.CB_0.config_dataB\[9\] _04245_ _04257_ vssd1 vssd1 vccd1
+ vccd1 _04258_ sky130_fd_sc_hd__and3b_1
XTAP_TAPCELL_ROW_77_1362 vssd1 vccd1 sky130_fd_sc_hd__tapvpwrvgnd_1
X_09983_ net738 FPGA_INST.config_bits\[5\] _05228_ FPGA_INST.config_bits\[6\] vssd1
+ vssd1 vccd1 vccd1 _05234_ sky130_fd_sc_hd__a31o_1
XFILLER_107_59 vssd1 vssd1 vccd1 vccd1 sky130_fd_sc_hd__fill_4
XTAP_TAPCELL_ROW_90_1540 vssd1 vccd1 sky130_fd_sc_hd__tapvpwrvgnd_1
XFILLER_89_649 vssd1 vssd1 vccd1 vccd1 sky130_fd_sc_hd__fill_4
X_08934_ _03881_ _03884_ _03886_ _05129_ vssd1 vssd1 vccd1 vccd1 FPGA_INST.bus1_0\[11\]
+ sky130_fd_sc_hd__o211a_2
XFILLER_69_362 vssd1 vssd1 vccd1 vccd1 sky130_fd_sc_hd__fill_4
X_08865_ net386 FPGA_INST.cell3.CB_0.config_dataB\[16\] vssd1 vssd1 vccd1 vccd1 _05072_
+ sky130_fd_sc_hd__nor2_2
XFILLER_96_170 vssd1 vssd1 vccd1 vccd1 sky130_fd_sc_hd__fill_1
XFILLER_69_395 vssd1 vssd1 vccd1 vccd1 sky130_fd_sc_hd__fill_1
XTAP_TAPCELL_ROW_4_336 vssd1 vccd1 sky130_fd_sc_hd__tapvpwrvgnd_1
XFILLER_96_192 vssd1 vssd1 vccd1 vccd1 sky130_fd_sc_hd__fill_1
X_08796_ net392 net391 vssd1 vssd1 vccd1 vccd1 _05003_ sky130_fd_sc_hd__nor2_1
X_07816_ net659 FPGA_INST.cell2.LE_1B.reset_mode vssd1 vssd1 vccd1 vccd1 _07816_/X
+ sky130_fd_sc_hd__xor2_2
XFILLER_84_387 vssd1 vssd1 vccd1 vccd1 sky130_fd_sc_hd__fill_1
X_07747_ _03994_ _03995_ _03996_ _01836_ vssd1 vssd1 vccd1 vccd1 _03997_ sky130_fd_sc_hd__a31o_4
XANTENNA_fanout737_A net28 vssd1 vssd1 vccd1 vccd1 sky130_fd_sc_hd__diode_2
XANTENNA_fanout358_X net358 vssd1 vssd1 vccd1 vccd1 sky130_fd_sc_hd__diode_2
X_07678_ FPGA_INST.cell1.SB0.route_sel\[101\] FPGA_INST.cell1.SB0.route_sel\[100\]
+ vssd1 vssd1 vccd1 vccd1 _03930_ sky130_fd_sc_hd__nand2b_1
XFILLER_53_785 vssd1 vssd1 vccd1 vccd1 sky130_fd_sc_hd__fill_2
XANTENNA__06547__X _02823_ vssd1 vssd1 vccd1 vccd1 sky130_fd_sc_hd__diode_2
XPHY_EDGE_ROW_0_Right_0 vssd1 vssd1 vccd1 vccd1 sky130_fd_sc_hd__decap_3
XANTENNA_fanout525_X net525 vssd1 vssd1 vccd1 vccd1 sky130_fd_sc_hd__diode_2
XANTENNA_fanout904_A net918 vssd1 vssd1 vccd1 vccd1 sky130_fd_sc_hd__diode_2
XFILLER_80_593 vssd1 vssd1 vccd1 vccd1 sky130_fd_sc_hd__fill_1
X_09417_ net477 net479 net360 vssd1 vssd1 vccd1 vccd1 _00330_ sky130_fd_sc_hd__mux2_1
XFILLER_53_796 vssd1 vssd1 vccd1 vccd1 sky130_fd_sc_hd__fill_2
XTAP_TAPCELL_ROW_23_600 vssd1 vccd1 sky130_fd_sc_hd__tapvpwrvgnd_1
XTAP_TAPCELL_ROW_23_611 vssd1 vccd1 sky130_fd_sc_hd__tapvpwrvgnd_1
X_06629_ net138 net127 FPGA_INST.cell2.LEI0.config_data\[30\] vssd1 vssd1 vccd1 vccd1
+ _02905_ sky130_fd_sc_hd__mux2_1
X_09348_ FPGA_INST.cell1.SB0.route_sel\[120\] FPGA_INST.cell1.SB0.route_sel\[119\]
+ net342 vssd1 vssd1 vccd1 vccd1 _00261_ sky130_fd_sc_hd__mux2_1
XANTENNA__06707__B _02796_ vssd1 vssd1 vccd1 vccd1 sky130_fd_sc_hd__diode_2
XANTENNA__08642__A0 net20 vssd1 vssd1 vccd1 vccd1 sky130_fd_sc_hd__diode_2
XTAP_TAPCELL_ROW_51_997 vssd1 vccd1 sky130_fd_sc_hd__tapvpwrvgnd_1
XANTENNA__06248__A2 net11 vssd1 vssd1 vccd1 vccd1 sky130_fd_sc_hd__diode_2
XFILLER_21_671 vssd1 vssd1 vccd1 vccd1 sky130_fd_sc_hd__fill_1
X_11310_ net842 _00660_ net626 vssd1 vssd1 vccd1 vccd1 FPGA_INST.cell1.CB_0.config_dataB\[2\]
+ sky130_fd_sc_hd__dfstp_2
X_09279_ FPGA_INST.cell1.SB0.route_sel\[50\] FPGA_INST.cell1.SB0.route_sel\[51\] net207
+ vssd1 vssd1 vccd1 vccd1 _00192_ sky130_fd_sc_hd__mux2_1
XFILLER_119_570 vssd1 vssd1 vccd1 vccd1 sky130_fd_sc_hd__fill_2
XFILLER_113_3 vccd1 vssd1 vccd1 vssd1 sky130_ef_sc_hd__decap_40_12
XPHY_EDGE_ROW_73_Left_204 vssd1 vssd1 vccd1 vccd1 sky130_fd_sc_hd__decap_3
XANTENNA__08414__S _04574_ vssd1 vssd1 vccd1 vccd1 sky130_fd_sc_hd__diode_2
XFILLER_106_231 vssd1 vssd1 vccd1 vccd1 sky130_fd_sc_hd__fill_1
X_11241_ net768 _00591_ net553 vssd1 vssd1 vccd1 vccd1 FPGA_INST.cell0.SB0.route_sel\[86\]
+ sky130_fd_sc_hd__dfstp_1
XFILLER_107_798 vssd1 vssd1 vccd1 vccd1 sky130_fd_sc_hd__fill_1
X_11172_ net786 _00522_ net571 vssd1 vssd1 vccd1 vccd1 FPGA_INST.cell0.SB0.route_sel\[17\]
+ sky130_fd_sc_hd__dfstp_1
XFILLER_4_369 vssd1 vssd1 vccd1 vccd1 sky130_fd_sc_hd__fill_1
XFILLER_121_223 vssd1 vssd1 vccd1 vccd1 sky130_fd_sc_hd__fill_1
XFILLER_79_137 vssd1 vssd1 vccd1 vccd1 sky130_fd_sc_hd__fill_4
X_10123_ FPGA_INST.cell3.SB0.route_sel\[27\] FPGA_INST.cell3.SB0.route_sel\[28\] net270
+ vssd1 vssd1 vccd1 vccd1 _01004_ sky130_fd_sc_hd__mux2_1
XFILLER_48_524 vssd1 vssd1 vccd1 vccd1 sky130_fd_sc_hd__fill_1
X_10054_ FPGA_INST.cell0.CB_1.config_dataA\[3\] FPGA_INST.cell0.CB_1.config_dataA\[4\]
+ net183 vssd1 vssd1 vccd1 vccd1 _00935_ sky130_fd_sc_hd__mux2_1
XFILLER_102_492 vssd1 vssd1 vccd1 vccd1 sky130_fd_sc_hd__fill_1
XPHY_EDGE_ROW_82_Left_213 vssd1 vssd1 vccd1 vccd1 sky130_fd_sc_hd__decap_3
XFILLER_75_354 vssd1 vssd1 vccd1 vccd1 sky130_fd_sc_hd__fill_1
XANTENNA__08173__A2 FPGA_INST.bus1_0\[2\] vssd1 vssd1 vccd1 vccd1 sky130_fd_sc_hd__diode_2
XANTENNA__08088__C _03769_ vssd1 vssd1 vccd1 vccd1 sky130_fd_sc_hd__diode_2
XANTENNA__08937__X FPGA_INST.bus2_0\[11\] vssd1 vssd1 vccd1 vccd1 sky130_fd_sc_hd__diode_2
XPHY_EDGE_ROW_121_Right_121 vssd1 vssd1 vccd1 vccd1 sky130_fd_sc_hd__decap_3
XANTENNA__05931__A1 net8 vssd1 vssd1 vccd1 vccd1 sky130_fd_sc_hd__diode_2
XTAP_TAPCELL_ROW_102_1709 vssd1 vccd1 sky130_fd_sc_hd__tapvpwrvgnd_1
XFILLER_44_774 vssd1 vssd1 vccd1 vccd1 sky130_fd_sc_hd__fill_4
X_10956_ net867 _00306_ net651 vssd1 vssd1 vccd1 vccd1 FPGA_INST.cell2.CB_0.config_dataB\[12\]
+ sky130_fd_sc_hd__dfstp_1
XANTENNA__07684__A1 net133 vssd1 vssd1 vccd1 vccd1 sky130_fd_sc_hd__diode_2
XFILLER_71_593 vssd1 vssd1 vccd1 vccd1 sky130_fd_sc_hd__fill_2
X_10887_ net797 _00237_ net582 vssd1 vssd1 vccd1 vccd1 FPGA_INST.cell1.SB0.route_sel\[96\]
+ sky130_fd_sc_hd__dfstp_1
XFILLER_16_487 vssd1 vssd1 vccd1 vccd1 sky130_fd_sc_hd__fill_1
XTAP_TAPCELL_ROW_61_1141 vssd1 vccd1 sky130_fd_sc_hd__tapvpwrvgnd_1
XTAP_TAPCELL_ROW_61_1130 vssd1 vccd1 sky130_fd_sc_hd__tapvpwrvgnd_1
XANTENNA__06617__B _02836_ vssd1 vssd1 vccd1 vccd1 sky130_fd_sc_hd__diode_2
XPHY_EDGE_ROW_91_Left_222 vssd1 vssd1 vccd1 vccd1 sky130_fd_sc_hd__decap_3
XANTENNA__07436__B2 _02240_ vssd1 vssd1 vccd1 vccd1 sky130_fd_sc_hd__diode_2
XFILLER_7_141 vssd1 vssd1 vccd1 vccd1 sky130_fd_sc_hd__fill_8
XFILLER_7_130 vssd1 vssd1 vccd1 vccd1 sky130_fd_sc_hd__fill_2
XANTENNA__06192__X _02472_ vssd1 vssd1 vccd1 vccd1 sky130_fd_sc_hd__diode_2
X_11508_ net762 _00858_ net547 vssd1 vssd1 vccd1 vccd1 FPGA_INST.cell0.CB_1.config_dataB\[14\]
+ sky130_fd_sc_hd__dfstp_1
X_11439_ net773 _00789_ net559 vssd1 vssd1 vccd1 vccd1 FPGA_INST.cell0.LE_0A.config_data\[10\]
+ sky130_fd_sc_hd__dfrtp_1
XFILLER_98_446 vssd1 vssd1 vccd1 vccd1 sky130_fd_sc_hd__fill_1
XFILLER_3_380 vssd1 vssd1 vccd1 vccd1 sky130_fd_sc_hd__fill_1
XFILLER_100_407 vssd1 vssd1 vccd1 vccd1 sky130_fd_sc_hd__fill_4
XFILLER_85_107 vssd1 vssd1 vccd1 vccd1 sky130_fd_sc_hd__fill_4
X_06980_ net432 net434 vssd1 vssd1 vccd1 vccd1 _03246_ sky130_fd_sc_hd__nor2_1
XTAP_TAPCELL_ROW_72_1292 vssd1 vccd1 sky130_fd_sc_hd__tapvpwrvgnd_1
X_05931_ net123 net8 _02208_ vssd1 vssd1 vccd1 vccd1 _02211_ sky130_fd_sc_hd__mux2_1
X_08650_ _01762_ _01763_ FPGA_INST.cell3.CB_0.config_dataA\[4\] _04790_ _04858_ vssd1
+ vssd1 vccd1 vccd1 _04859_ sky130_fd_sc_hd__a41o_1
XANTENNA__08164__A2 _03840_ vssd1 vssd1 vccd1 vccd1 sky130_fd_sc_hd__diode_2
X_05862_ _02133_ _02138_ _02141_ net314 vssd1 vssd1 vccd1 vccd1 _02142_ sky130_fd_sc_hd__a211o_1
XANTENNA__07372__B1 net79 vssd1 vssd1 vccd1 vccd1 sky130_fd_sc_hd__diode_2
X_07601_ _03833_ _03851_ _03853_ vssd1 vssd1 vccd1 vccd1 _03855_ sky130_fd_sc_hd__and3b_1
XFILLER_66_365 vssd1 vssd1 vccd1 vccd1 sky130_fd_sc_hd__fill_2
XFILLER_54_527 vssd1 vssd1 vccd1 vccd1 sky130_fd_sc_hd__fill_4
X_08581_ _01764_ net400 vssd1 vssd1 vccd1 vccd1 _04790_ sky130_fd_sc_hd__nor2_2
XFILLER_81_346 vssd1 vssd1 vccd1 vccd1 sky130_fd_sc_hd__fill_1
X_05793_ FPGA_INST.cell2.SB0.route_sel\[90\] FPGA_INST.cell2.SB0.route_sel\[91\] vssd1
+ vssd1 vccd1 vccd1 _02073_ sky130_fd_sc_hd__nand2_1
X_07532_ FPGA_INST.cell3.SB0.route_sel\[64\] FPGA_INST.cell3.SB0.route_sel\[65\] vssd1
+ vssd1 vccd1 vccd1 _03788_ sky130_fd_sc_hd__or2_1
XANTENNA__08872__A0 net20 vssd1 vssd1 vccd1 vccd1 sky130_fd_sc_hd__diode_2
X_07463_ _02188_ _03719_ vssd1 vssd1 vccd1 vccd1 _03720_ sky130_fd_sc_hd__nor2_4
X_09202_ FPGA_INST.cell2.LE_1B.dff0_out net524 _05212_ vssd1 vssd1 vccd1 vccd1 _00115_
+ sky130_fd_sc_hd__a21o_1
XFILLER_50_766 vssd1 vssd1 vccd1 vccd1 sky130_fd_sc_hd__fill_1
X_06414_ FPGA_INST.cell2.CB_0.config_dataB\[11\] net492 vssd1 vssd1 vccd1 vccd1 _02692_
+ sky130_fd_sc_hd__and2b_2
X_07394_ _03454_ _03594_ _03652_ vssd1 vssd1 vccd1 vccd1 _03653_ sky130_fd_sc_hd__o21ai_1
X_09133_ FPGA_INST.cell2.LE_0A.dff0_out net524 _05209_ vssd1 vssd1 vccd1 vccd1 _00049_
+ sky130_fd_sc_hd__a21bo_1
X_06345_ net493 net495 vssd1 vssd1 vccd1 vccd1 _02623_ sky130_fd_sc_hd__and2b_2
XANTENNA_fanout318_A net319 vssd1 vssd1 vccd1 vccd1 sky130_fd_sc_hd__diode_2
X_09064_ net908 FPGA_INST.cell3.LE_1B.edge_mode vssd1 vssd1 vccd1 vccd1 FPGA_INST.cell3.LE_1B.sel_clk
+ sky130_fd_sc_hd__xnor2_1
X_06276_ _02330_ _02540_ _02541_ _02293_ _01533_ vssd1 vssd1 vccd1 vccd1 _02556_ sky130_fd_sc_hd__a221o_1
X_08015_ net457 _03568_ vssd1 vssd1 vccd1 vccd1 _04241_ sky130_fd_sc_hd__nand2_1
XTAP_TAPCELL_ROW_9_406 vssd1 vccd1 sky130_fd_sc_hd__tapvpwrvgnd_1
XFILLER_78_29 vccd1 vssd1 vccd1 vssd1 sky130_ef_sc_hd__decap_40_12
XFILLER_104_757 vssd1 vssd1 vccd1 vccd1 sky130_fd_sc_hd__fill_2
XANTENNA_fanout687_A net702 vssd1 vssd1 vccd1 vccd1 sky130_fd_sc_hd__diode_2
X_09966_ net738 FPGA_INST.config_bits\[1\] vssd1 vssd1 vccd1 vccd1 _05222_ sky130_fd_sc_hd__and2b_1
XANTENNA__06402__A2 net11 vssd1 vssd1 vccd1 vccd1 sky130_fd_sc_hd__diode_2
X_08917_ FPGA_INST.cell2.SB0.route_sel\[106\] FPGA_INST.cell2.SB0.route_sel\[107\]
+ vssd1 vssd1 vccd1 vccd1 _05118_ sky130_fd_sc_hd__nand2b_1
X_09897_ FPGA_INST.cell0.LE_0B.config_data\[1\] FPGA_INST.cell0.LE_0B.config_data\[2\]
+ net177 vssd1 vssd1 vccd1 vccd1 _00803_ sky130_fd_sc_hd__mux2_1
X_08848_ _04809_ _05036_ _05038_ _04813_ _01777_ vssd1 vssd1 vccd1 vccd1 _05055_ sky130_fd_sc_hd__a221o_1
XFILLER_57_343 vssd1 vssd1 vccd1 vccd1 sky130_fd_sc_hd__fill_8
XANTENNA_fanout854_A net862 vssd1 vssd1 vccd1 vccd1 sky130_fd_sc_hd__diode_2
XFILLER_85_685 vssd1 vssd1 vccd1 vccd1 sky130_fd_sc_hd__fill_8
XFILLER_84_162 vssd1 vssd1 vccd1 vccd1 sky130_fd_sc_hd__fill_2
XANTENNA__06705__A3 FPGA_INST.bus3_2\[7\] vssd1 vssd1 vccd1 vccd1 sky130_fd_sc_hd__diode_2
X_08779_ FPGA_INST.cell3.CB_0.config_dataB\[5\] _04781_ vssd1 vssd1 vccd1 vccd1 _04986_
+ sky130_fd_sc_hd__or2_1
X_10810_ net827 _00160_ net611 vssd1 vssd1 vccd1 vccd1 FPGA_INST.cell1.SB0.route_sel\[19\]
+ sky130_fd_sc_hd__dfstp_1
XFILLER_60_519 vccd1 vssd1 vccd1 vssd1 sky130_ef_sc_hd__decap_40_12
XFILLER_60_508 vssd1 vssd1 vccd1 vccd1 sky130_fd_sc_hd__fill_1
X_11790_ net889 _01136_ net673 vssd1 vssd1 vccd1 vccd1 FPGA_INST.io_east_oeb\[0\]
+ sky130_fd_sc_hd__dfrtp_1
XFILLER_25_251 vssd1 vssd1 vccd1 vccd1 sky130_fd_sc_hd__fill_1
XFILLER_53_582 vssd1 vssd1 vccd1 vccd1 sky130_fd_sc_hd__fill_1
XANTENNA__06469__A2 _01869_ vssd1 vssd1 vccd1 vccd1 sky130_fd_sc_hd__diode_2
X_10741_ net875 _00091_ net660 vssd1 vssd1 vccd1 vccd1 FPGA_INST.cell2.LE_0B.reset_val
+ sky130_fd_sc_hd__dfrtp_1
XTAP_TAPCELL_ROW_36_780 vssd1 vccd1 sky130_fd_sc_hd__tapvpwrvgnd_1
XTAP_TAPCELL_ROW_36_791 vssd1 vccd1 sky130_fd_sc_hd__tapvpwrvgnd_1
X_10672_ net884 _00022_ net668 vssd1 vssd1 vccd1 vccd1 FPGA_INST.cell2.LEI0.config_data\[21\]
+ sky130_fd_sc_hd__dfrtp_1
XFILLER_126_304 vssd1 vssd1 vccd1 vccd1 sky130_fd_sc_hd__fill_4
XANTENNA__08091__A1 FPGA_INST.bus3_1\[9\] vssd1 vssd1 vccd1 vccd1 sky130_fd_sc_hd__diode_2
XTAP_TAPCELL_ROW_130_2116 vssd1 vccd1 sky130_fd_sc_hd__tapvpwrvgnd_1
XTAP_TAPCELL_ROW_130_2105 vssd1 vccd1 sky130_fd_sc_hd__tapvpwrvgnd_1
X_11224_ net766 _00574_ net551 vssd1 vssd1 vccd1 vccd1 FPGA_INST.cell0.SB0.route_sel\[69\]
+ sky130_fd_sc_hd__dfstp_1
XFILLER_4_15 vssd1 vssd1 vccd1 vccd1 sky130_fd_sc_hd__fill_4
XFILLER_122_521 vssd1 vssd1 vccd1 vccd1 sky130_fd_sc_hd__fill_2
X_11155_ net779 _00505_ net564 vssd1 vssd1 vccd1 vccd1 FPGA_INST.cell0.SB0.route_sel\[0\]
+ sky130_fd_sc_hd__dfstp_1
X_11086_ FPGA_INST.cell1.LE_1A.sel_clk _00436_ net733 vssd1 vssd1 vccd1 vccd1 FPGA_INST.cell1.LE_1A.dff1_out
+ sky130_fd_sc_hd__dfstp_1
X_10106_ FPGA_INST.cell3.SB0.route_sel\[10\] FPGA_INST.cell3.SB0.route_sel\[11\] net270
+ vssd1 vssd1 vccd1 vccd1 _00987_ sky130_fd_sc_hd__mux2_1
XFILLER_68_73 vssd1 vssd1 vccd1 vccd1 sky130_fd_sc_hd__fill_1
X_10037_ FPGA_INST.cell0.CB_0.config_dataB\[12\] net417 net316 vssd1 vssd1 vccd1 vccd1
+ _00918_ sky130_fd_sc_hd__mux2_1
XTAP_TAPCELL_ROW_128_2078 vssd1 vccd1 sky130_fd_sc_hd__tapvpwrvgnd_1
XANTENNA__07354__B1 _03613_ vssd1 vssd1 vccd1 vccd1 sky130_fd_sc_hd__diode_2
XANTENNA__09894__A2 net522 vssd1 vssd1 vccd1 vccd1 sky130_fd_sc_hd__diode_2
XFILLER_36_516 vssd1 vssd1 vccd1 vccd1 sky130_fd_sc_hd__fill_2
XFILLER_75_173 vssd1 vssd1 vccd1 vccd1 sky130_fd_sc_hd__fill_1
XFILLER_63_346 vssd1 vssd1 vccd1 vccd1 sky130_fd_sc_hd__fill_1
XFILLER_63_335 vssd1 vssd1 vccd1 vccd1 sky130_fd_sc_hd__fill_1
XANTENNA__05904__B2 _02182_ vssd1 vssd1 vccd1 vccd1 sky130_fd_sc_hd__diode_2
XFILLER_44_560 vssd1 vssd1 vccd1 vccd1 sky130_fd_sc_hd__fill_2
X_11988_ net774 _01334_ net560 vssd1 vssd1 vccd1 vccd1 FPGA_INST.cell2.SB0.route_sel\[28\]
+ sky130_fd_sc_hd__dfstp_1
X_10939_ net850 _00289_ net635 vssd1 vssd1 vccd1 vccd1 FPGA_INST.cell2.CB_0.config_dataA\[20\]
+ sky130_fd_sc_hd__dfstp_1
XTAP_TAPCELL_ROW_14_474 vssd1 vccd1 sky130_fd_sc_hd__tapvpwrvgnd_1
XANTENNA__07409__B2 FPGA_INST.cell3.SB0.route_sel\[44\] vssd1 vssd1 vccd1 vccd1 sky130_fd_sc_hd__diode_2
XTAP_TAPCELL_ROW_14_485 vssd1 vccd1 sky130_fd_sc_hd__tapvpwrvgnd_1
XFILLER_117_326 vssd1 vssd1 vccd1 vccd1 sky130_fd_sc_hd__fill_8
X_06130_ net235 _02404_ _02409_ vssd1 vssd1 vccd1 vccd1 _02410_ sky130_fd_sc_hd__and3_1
X_06061_ net97 net170 net157 _02340_ _01879_ vssd1 vssd1 vccd1 vccd1 _02341_ sky130_fd_sc_hd__o32a_1
XANTENNA__06632__A2 net129 vssd1 vssd1 vccd1 vccd1 sky130_fd_sc_hd__diode_2
XTAP_TAPCELL_ROW_74_1321 vssd1 vccd1 sky130_fd_sc_hd__tapvpwrvgnd_1
Xfanout407 FPGA_INST.cell0.CB_1.config_dataA\[10\] vssd1 vssd1 vccd1 vccd1 net407
+ sky130_fd_sc_hd__buf_1
XFILLER_59_619 vssd1 vssd1 vccd1 vccd1 sky130_fd_sc_hd__fill_1
XANTENNA__08385__A2 _03997_ vssd1 vssd1 vccd1 vccd1 sky130_fd_sc_hd__diode_2
XANTENNA__06396__A1 _02131_ vssd1 vssd1 vccd1 vccd1 sky130_fd_sc_hd__diode_2
X_09820_ FPGA_INST.cell0.LE_0A.dff1_out net522 _05217_ vssd1 vssd1 vccd1 vccd1 _00728_
+ sky130_fd_sc_hd__a21bo_1
Xfanout418 net419 vssd1 vssd1 vccd1 vccd1 net418 sky130_fd_sc_hd__buf_2
Xfanout429 FPGA_INST.cell0.CB_0.config_dataA\[11\] vssd1 vssd1 vccd1 vccd1 net429
+ sky130_fd_sc_hd__buf_2
X_09751_ FPGA_INST.cell1.CB_0.config_dataB\[2\] FPGA_INST.cell1.CB_0.config_dataB\[1\]
+ net348 vssd1 vssd1 vccd1 vccd1 _00660_ sky130_fd_sc_hd__mux2_1
XFILLER_101_738 vssd1 vssd1 vccd1 vccd1 sky130_fd_sc_hd__fill_4
XFILLER_86_416 vssd1 vssd1 vccd1 vccd1 sky130_fd_sc_hd__fill_4
XANTENNA__06396__B2 _02168_ vssd1 vssd1 vccd1 vccd1 sky130_fd_sc_hd__diode_2
X_06963_ FPGA_INST.cell0.LE_0B.config_data\[3\] FPGA_INST.cell0.LE_0B.config_data\[2\]
+ _03159_ vssd1 vssd1 vccd1 vccd1 _03231_ sky130_fd_sc_hd__mux2_1
X_08702_ net397 _04801_ _04910_ vssd1 vssd1 vccd1 vccd1 _04911_ sky130_fd_sc_hd__a21o_1
X_05914_ FPGA_INST.cell2.SB0.route_sel\[58\] FPGA_INST.cell2.SB0.route_sel\[59\] vssd1
+ vssd1 vccd1 vccd1 _02194_ sky130_fd_sc_hd__nand2_1
X_09682_ FPGA_INST.cell0.SB0.route_sel\[85\] FPGA_INST.cell0.SB0.route_sel\[86\] net187
+ vssd1 vssd1 vccd1 vccd1 _00591_ sky130_fd_sc_hd__mux2_1
X_06894_ net418 _02030_ _03161_ FPGA_INST.cell0.CB_0.config_dataB\[11\] vssd1 vssd1
+ vccd1 vccd1 _03162_ sky130_fd_sc_hd__o211a_1
XFILLER_27_516 vssd1 vssd1 vccd1 vccd1 sky130_fd_sc_hd__fill_1
X_08633_ _01689_ FPGA_INST.cell3.SB0.route_sel\[36\] _01690_ FPGA_INST.cell3.SB0.route_sel\[39\]
+ _04841_ vssd1 vssd1 vccd1 vccd1 _04842_ sky130_fd_sc_hd__a221o_1
XFILLER_81_110 vssd1 vssd1 vccd1 vccd1 sky130_fd_sc_hd__fill_2
X_05845_ _02123_ _02124_ vssd1 vssd1 vccd1 vccd1 _02125_ sky130_fd_sc_hd__nand2_1
X_08564_ _04774_ _04773_ _04751_ vssd1 vssd1 vccd1 vccd1 _04775_ sky130_fd_sc_hd__mux2_1
XANTENNA_fanout268_A net306 vssd1 vssd1 vccd1 vccd1 sky130_fd_sc_hd__diode_2
X_05776_ _02055_ _02053_ vssd1 vssd1 vccd1 vccd1 _02056_ sky130_fd_sc_hd__and2b_2
XFILLER_120_26 vssd1 vssd1 vccd1 vccd1 sky130_fd_sc_hd__fill_2
X_07515_ FPGA_INST.cell3.SB0.route_sel\[69\] FPGA_INST.cell3.SB0.route_sel\[68\] _03750_
+ _03770_ _03752_ vssd1 vssd1 vccd1 vccd1 _03771_ sky130_fd_sc_hd__a221o_1
XTAP_TAPCELL_ROW_85_1472 vssd1 vccd1 sky130_fd_sc_hd__tapvpwrvgnd_1
XFILLER_81_198 vssd1 vssd1 vccd1 vccd1 sky130_fd_sc_hd__fill_1
XFILLER_23_733 vssd1 vssd1 vccd1 vccd1 sky130_fd_sc_hd__fill_2
XFILLER_35_582 vccd1 vssd1 vccd1 vssd1 sky130_ef_sc_hd__decap_40_12
X_08495_ FPGA_INST.cell1.LE_1B.config_data\[8\] FPGA_INST.cell1.LE_1B.config_data\[9\]
+ _04692_ vssd1 vssd1 vccd1 vccd1 _04711_ sky130_fd_sc_hd__mux2_1
XFILLER_23_755 vssd1 vssd1 vccd1 vccd1 sky130_fd_sc_hd__fill_2
X_07446_ FPGA_INST.cell3.SB0.route_sel\[48\] FPGA_INST.cell3.SB0.route_sel\[49\] vssd1
+ vssd1 vccd1 vccd1 _03704_ sky130_fd_sc_hd__or2_1
XANTENNA__06320__A1 net6 vssd1 vssd1 vccd1 vccd1 sky130_fd_sc_hd__diode_2
XTAP_TAPCELL_ROW_33_750 vssd1 vccd1 sky130_fd_sc_hd__tapvpwrvgnd_1
XANTENNA_fanout602_A net604 vssd1 vssd1 vccd1 vccd1 sky130_fd_sc_hd__diode_2
X_07377_ FPGA_INST.cell0.SB0.route_sel\[44\] FPGA_INST.cell0.SB0.route_sel\[45\] vssd1
+ vssd1 vccd1 vccd1 _03636_ sky130_fd_sc_hd__or2_1
XFILLER_129_57 vssd1 vssd1 vccd1 vccd1 sky130_fd_sc_hd__fill_1
X_06328_ FPGA_INST.cell2.LE_0A.config_data\[1\] FPGA_INST.cell2.LE_0A.config_data\[0\]
+ _02536_ vssd1 vssd1 vccd1 vccd1 _02608_ sky130_fd_sc_hd__mux2_1
X_09116_ FPGA_INST.cell2.LEI0.config_data\[30\] FPGA_INST.cell2.LEI0.config_data\[31\]
+ net262 vssd1 vssd1 vccd1 vccd1 _00032_ sky130_fd_sc_hd__mux2_1
XFILLER_129_79 vssd1 vssd1 vccd1 vccd1 sky130_fd_sc_hd__fill_2
X_09047_ net818 FPGA_INST.cell1.LE_1B.edge_mode vssd1 vssd1 vccd1 vccd1 FPGA_INST.cell1.LE_1B.sel_clk
+ sky130_fd_sc_hd__xnor2_1
XFILLER_108_348 vssd1 vssd1 vccd1 vccd1 sky130_fd_sc_hd__fill_1
X_06259_ net504 _02056_ vssd1 vssd1 vccd1 vccd1 _02539_ sky130_fd_sc_hd__or2_1
XFILLER_89_221 vssd1 vssd1 vccd1 vccd1 sky130_fd_sc_hd__fill_2
XANTENNA__06387__A1 net6 vssd1 vssd1 vccd1 vccd1 sky130_fd_sc_hd__diode_2
XFILLER_1_147 vssd1 vssd1 vccd1 vccd1 sky130_fd_sc_hd__fill_1
Xfanout941 net945 vssd1 vssd1 vccd1 vccd1 net941 sky130_fd_sc_hd__clkbuf_2
Xfanout930 net931 vssd1 vssd1 vccd1 vccd1 net930 sky130_fd_sc_hd__dlymetal6s2s_1
X_09949_ FPGA_INST.cell0.CB_1.config_dataB\[9\] net443 net184 vssd1 vssd1 vccd1 vccd1
+ _00854_ sky130_fd_sc_hd__mux2_1
XANTENNA__08128__A2 FPGA_INST.bus3_1\[14\] vssd1 vssd1 vccd1 vccd1 sky130_fd_sc_hd__diode_2
XANTENNA__09325__A1 FPGA_INST.cell1.SB0.route_sel\[96\] vssd1 vssd1 vccd1 vccd1 sky130_fd_sc_hd__diode_2
XFILLER_77_449 vssd1 vssd1 vccd1 vccd1 sky130_fd_sc_hd__fill_2
XFILLER_58_674 vssd1 vssd1 vccd1 vccd1 sky130_fd_sc_hd__fill_4
X_11911_ net940 _01257_ net724 vssd1 vssd1 vccd1 vccd1 FPGA_INST.cell3.LE_0B.reset_mode
+ sky130_fd_sc_hd__dfrtp_1
X_11842_ net915 _01188_ net699 vssd1 vssd1 vccd1 vccd1 FPGA_INST.cell3.LEI0.config_data\[22\]
+ sky130_fd_sc_hd__dfrtp_1
XFILLER_45_357 vssd1 vssd1 vccd1 vccd1 sky130_fd_sc_hd__fill_1
X_11773_ net928 _01119_ net712 vssd1 vssd1 vccd1 vccd1 FPGA_INST.io_west_oeb\[30\]
+ sky130_fd_sc_hd__dfrtp_1
XFILLER_53_390 vssd1 vssd1 vccd1 vccd1 sky130_fd_sc_hd__fill_2
XFILLER_9_214 vssd1 vssd1 vccd1 vccd1 sky130_fd_sc_hd__fill_2
X_10724_ net875 _00074_ net660 vssd1 vssd1 vccd1 vccd1 FPGA_INST.cell2.LE_0B.config_data\[1\]
+ sky130_fd_sc_hd__dfrtp_1
X_10655_ net883 _00005_ net667 vssd1 vssd1 vccd1 vccd1 FPGA_INST.cell2.LEI0.config_data\[4\]
+ sky130_fd_sc_hd__dfrtp_1
XANTENNA__08064__A1 _03973_ vssd1 vssd1 vccd1 vccd1 sky130_fd_sc_hd__diode_2
XANTENNA__09261__A0 FPGA_INST.cell1.SB0.route_sel\[32\] vssd1 vssd1 vccd1 vccd1 sky130_fd_sc_hd__diode_2
XFILLER_70_85 vssd1 vssd1 vccd1 vccd1 sky130_fd_sc_hd__fill_1
XFILLER_9_269 vssd1 vssd1 vccd1 vccd1 sky130_fd_sc_hd__fill_1
XTAP_TAPCELL_ROW_11_433 vssd1 vccd1 sky130_fd_sc_hd__tapvpwrvgnd_1
X_10586_ FPGA_INST.cell3.CB_0.config_dataB\[5\] FPGA_INST.cell3.CB_0.config_dataB\[6\]
+ net302 vssd1 vssd1 vccd1 vccd1 _01465_ sky130_fd_sc_hd__mux2_1
XFILLER_62_9 vssd1 vssd1 vccd1 vccd1 sky130_fd_sc_hd__fill_1
XTAP_TAPCELL_ROW_110_1819 vssd1 vccd1 sky130_fd_sc_hd__tapvpwrvgnd_1
XTAP_TAPCELL_ROW_56_1073 vssd1 vccd1 sky130_fd_sc_hd__tapvpwrvgnd_1
XTAP_TAPCELL_ROW_56_1062 vssd1 vccd1 sky130_fd_sc_hd__tapvpwrvgnd_1
XANTENNA__08367__A2 _03504_ vssd1 vssd1 vccd1 vccd1 sky130_fd_sc_hd__diode_2
X_11207_ net754 _00557_ net539 vssd1 vssd1 vccd1 vccd1 FPGA_INST.cell0.SB0.route_sel\[52\]
+ sky130_fd_sc_hd__dfstp_1
X_11138_ net817 _00488_ net602 vssd1 vssd1 vccd1 vccd1 FPGA_INST.cell1.CB_1.config_dataB\[8\]
+ sky130_fd_sc_hd__dfstp_1
XANTENNA__07575__B1 net80 vssd1 vssd1 vccd1 vccd1 sky130_fd_sc_hd__diode_2
XFILLER_68_438 vssd1 vssd1 vccd1 vccd1 sky130_fd_sc_hd__fill_4
XANTENNA__08119__A2 _03690_ vssd1 vssd1 vccd1 vccd1 sky130_fd_sc_hd__diode_2
X_11069_ net838 _00419_ net622 vssd1 vssd1 vccd1 vccd1 FPGA_INST.cell1.LE_0A.config_data\[4\]
+ sky130_fd_sc_hd__dfrtp_1
XANTENNA__07878__A1 _03973_ vssd1 vssd1 vccd1 vccd1 sky130_fd_sc_hd__diode_2
XANTENNA__09433__S net266 vssd1 vssd1 vccd1 vccd1 sky130_fd_sc_hd__diode_2
XFILLER_48_195 vssd1 vssd1 vccd1 vccd1 sky130_fd_sc_hd__fill_1
XFILLER_64_677 vssd1 vssd1 vccd1 vccd1 sky130_fd_sc_hd__fill_1
XTAP_TAPCELL_ROW_19_544 vssd1 vccd1 sky130_fd_sc_hd__tapvpwrvgnd_1
XTAP_TAPCELL_ROW_19_555 vssd1 vccd1 sky130_fd_sc_hd__tapvpwrvgnd_1
X_05630_ _01908_ _01909_ vssd1 vssd1 vccd1 vccd1 _01910_ sky130_fd_sc_hd__or2_1
XFILLER_64_688 vssd1 vssd1 vccd1 vccd1 sky130_fd_sc_hd__fill_2
X_07300_ FPGA_INST.cell1.CB_1.config_dataA\[24\] FPGA_INST.cell1.CB_1.config_dataA\[21\]
+ FPGA_INST.cell1.CB_1.config_dataA\[20\] vssd1 vssd1 vccd1 vccd1 _03561_ sky130_fd_sc_hd__nand3b_4
XFILLER_44_390 vssd1 vssd1 vccd1 vccd1 sky130_fd_sc_hd__fill_4
X_05561_ net117 _01814_ _01816_ _01820_ _01840_ vssd1 vssd1 vccd1 vccd1 _01841_ sky130_fd_sc_hd__a32o_1
X_05492_ FPGA_INST.cell3.CB_0.config_dataB\[0\] vssd1 vssd1 vccd1 vccd1 _01774_ sky130_fd_sc_hd__inv_2
XFILLER_20_703 vssd1 vssd1 vccd1 vccd1 sky130_fd_sc_hd__fill_1
X_08280_ _04503_ _04502_ _04440_ vssd1 vssd1 vccd1 vccd1 _04504_ sky130_fd_sc_hd__mux2_1
X_07231_ _01711_ FPGA_INST.cell3.SB0.route_sel\[11\] _01712_ FPGA_INST.cell3.SB0.route_sel\[12\]
+ _03493_ vssd1 vssd1 vccd1 vccd1 _03494_ sky130_fd_sc_hd__o221a_1
XANTENNA__08055__A1 _03810_ vssd1 vssd1 vccd1 vccd1 sky130_fd_sc_hd__diode_2
X_07162_ net133 _02472_ FPGA_INST.cell3.SB0.route_sel\[5\] FPGA_INST.cell3.SB0.route_sel\[4\]
+ vssd1 vssd1 vccd1 vccd1 _03426_ sky130_fd_sc_hd__o211ai_1
X_06113_ _01818_ net158 _02388_ _02391_ vssd1 vssd1 vccd1 vccd1 _02393_ sky130_fd_sc_hd__a2bb2o_1
XFILLER_117_167 vssd1 vssd1 vccd1 vccd1 sky130_fd_sc_hd__fill_1
X_07093_ FPGA_INST.bus2_0\[2\] FPGA_INST.bus2_0\[3\] net427 vssd1 vssd1 vccd1 vccd1
+ _03359_ sky130_fd_sc_hd__mux2_1
XFILLER_126_690 vssd1 vssd1 vccd1 vccd1 sky130_fd_sc_hd__fill_1
X_06044_ net124 net6 _02322_ vssd1 vssd1 vccd1 vccd1 _02324_ sky130_fd_sc_hd__mux2_1
XFILLER_99_541 vssd1 vssd1 vccd1 vccd1 sky130_fd_sc_hd__fill_4
Xfanout204 net206 vssd1 vssd1 vccd1 vccd1 net204 sky130_fd_sc_hd__clkbuf_4
XFILLER_87_703 vssd1 vssd1 vccd1 vccd1 sky130_fd_sc_hd__fill_1
XFILLER_5_91 vssd1 vssd1 vccd1 vccd1 sky130_fd_sc_hd__fill_1
X_09803_ FPGA_INST.cell1.LE_1B.config_data\[3\] FPGA_INST.cell1.LE_1B.config_data\[4\]
+ net218 vssd1 vssd1 vccd1 vccd1 _00712_ sky130_fd_sc_hd__mux2_1
XFILLER_115_15 vccd1 vssd1 vccd1 vssd1 sky130_ef_sc_hd__decap_40_12
Xfanout215 net216 vssd1 vssd1 vccd1 vccd1 net215 sky130_fd_sc_hd__clkbuf_4
XFILLER_101_502 vssd1 vssd1 vccd1 vccd1 sky130_fd_sc_hd__fill_2
Xfanout226 net227 vssd1 vssd1 vccd1 vccd1 net226 sky130_fd_sc_hd__buf_2
Xfanout237 net241 vssd1 vssd1 vccd1 vccd1 net237 sky130_fd_sc_hd__clkbuf_4
X_07995_ FPGA_INST.cell1.LE_0A.config_data\[15\] FPGA_INST.cell1.LE_0A.config_data\[14\]
+ _04148_ vssd1 vssd1 vccd1 vccd1 _04223_ sky130_fd_sc_hd__mux2_1
XFILLER_87_758 vssd1 vssd1 vccd1 vccd1 sky130_fd_sc_hd__fill_4
Xfanout248 net249 vssd1 vssd1 vccd1 vccd1 net248 sky130_fd_sc_hd__clkbuf_4
Xfanout259 net261 vssd1 vssd1 vccd1 vccd1 net259 sky130_fd_sc_hd__clkbuf_4
XANTENNA__07030__A2 _02191_ vssd1 vssd1 vccd1 vccd1 sky130_fd_sc_hd__diode_2
X_09734_ FPGA_INST.cell1.CB_0.config_dataA\[9\] FPGA_INST.cell1.CB_0.config_dataA\[10\]
+ net229 vssd1 vssd1 vccd1 vccd1 _00643_ sky130_fd_sc_hd__mux2_1
XTAP_TAPCELL_ROW_87_1501 vssd1 vccd1 sky130_fd_sc_hd__tapvpwrvgnd_1
XFILLER_74_419 vssd1 vssd1 vccd1 vccd1 sky130_fd_sc_hd__fill_1
X_06946_ net415 _02350_ vssd1 vssd1 vccd1 vccd1 _03214_ sky130_fd_sc_hd__nand2_1
XFILLER_27_302 vssd1 vssd1 vccd1 vccd1 sky130_fd_sc_hd__fill_4
XANTENNA__07869__A1 _03810_ vssd1 vssd1 vccd1 vccd1 sky130_fd_sc_hd__diode_2
XFILLER_67_493 vssd1 vssd1 vccd1 vccd1 sky130_fd_sc_hd__fill_8
X_09665_ FPGA_INST.cell0.SB0.route_sel\[69\] FPGA_INST.cell0.SB0.route_sel\[68\] net313
+ vssd1 vssd1 vccd1 vccd1 _00574_ sky130_fd_sc_hd__mux2_1
X_06877_ _02465_ _03127_ _03129_ _02429_ FPGA_INST.cell0.CB_0.config_dataB\[2\] vssd1
+ vssd1 vccd1 vccd1 _03145_ sky130_fd_sc_hd__a221o_1
XFILLER_27_335 vssd1 vssd1 vccd1 vccd1 sky130_fd_sc_hd__fill_1
XTAP_TAPCELL_ROW_38_820 vssd1 vccd1 sky130_fd_sc_hd__tapvpwrvgnd_1
X_08616_ net401 _04819_ _04824_ net400 vssd1 vssd1 vccd1 vccd1 _04825_ sky130_fd_sc_hd__o211a_1
X_05828_ FPGA_INST.cell0.SB0.route_sel\[78\] _01653_ FPGA_INST.cell0.SB0.route_sel\[74\]
+ FPGA_INST.cell0.SB0.route_sel\[75\] _02107_ vssd1 vssd1 vccd1 vccd1 _02108_ sky130_fd_sc_hd__o221a_1
XANTENNA_fanout173_X net173 vssd1 vssd1 vccd1 vccd1 sky130_fd_sc_hd__diode_2
XFILLER_82_496 vssd1 vssd1 vccd1 vccd1 sky130_fd_sc_hd__fill_1
X_09596_ FPGA_INST.cell0.CB_1.config_dataB\[24\] FPGA_INST.cell0.SB0.route_sel\[0\]
+ net195 vssd1 vssd1 vccd1 vccd1 _00505_ sky130_fd_sc_hd__mux2_1
X_08547_ FPGA_INST.cell3.CB_1.config_dataB\[13\] FPGA_INST.cell3.CB_1.config_dataB\[12\]
+ FPGA_INST.cell3.CB_1.config_dataB\[11\] FPGA_INST.cell3.CB_1.config_dataB\[10\]
+ vssd1 vssd1 vccd1 vccd1 _04758_ sky130_fd_sc_hd__or4b_1
XFILLER_70_658 vssd1 vssd1 vccd1 vccd1 sky130_fd_sc_hd__fill_1
X_05759_ FPGA_INST.cell2.CB_1.config_dataA\[22\] FPGA_INST.cell2.CB_1.config_dataA\[23\]
+ vssd1 vssd1 vccd1 vccd1 _02039_ sky130_fd_sc_hd__nand2b_2
X_08478_ net151 net144 net149 net142 FPGA_INST.cell1.LEI0.config_data\[33\] FPGA_INST.cell1.LEI0.config_data\[34\]
+ vssd1 vssd1 vccd1 vccd1 _04694_ sky130_fd_sc_hd__mux4_1
XANTENNA__11545__CLK net772 vssd1 vssd1 vccd1 vccd1 sky130_fd_sc_hd__diode_2
X_07429_ FPGA_INST.cell1.SB0.route_sel\[50\] FPGA_INST.cell1.SB0.route_sel\[51\] _03684_
+ _03686_ _03676_ vssd1 vssd1 vccd1 vccd1 _03687_ sky130_fd_sc_hd__a311o_1
XFILLER_50_371 vssd1 vssd1 vccd1 vccd1 sky130_fd_sc_hd__fill_1
X_10440_ FPGA_INST.cell2.SB0.route_sel\[12\] FPGA_INST.cell2.SB0.route_sel\[13\] net238
+ vssd1 vssd1 vccd1 vccd1 _01319_ sky130_fd_sc_hd__mux2_1
XTAP_TAPCELL_ROW_98_1652 vssd1 vccd1 sky130_fd_sc_hd__tapvpwrvgnd_1
XFILLER_40_33 vssd1 vssd1 vccd1 vccd1 sky130_fd_sc_hd__fill_1
X_10371_ FPGA_INST.cell3.LE_0B.config_data\[12\] FPGA_INST.cell3.LE_0B.config_data\[13\]
+ net301 vssd1 vssd1 vccd1 vccd1 _01251_ sky130_fd_sc_hd__mux2_1
X_12110_ net912 _01456_ net696 vssd1 vssd1 vccd1 vccd1 FPGA_INST.cell3.CB_0.config_dataA\[22\]
+ sky130_fd_sc_hd__dfstp_1
XANTENNA__08422__S _04574_ vssd1 vssd1 vccd1 vccd1 sky130_fd_sc_hd__diode_2
XANTENNA__06290__X _02570_ vssd1 vssd1 vccd1 vccd1 sky130_fd_sc_hd__diode_2
XANTENNA__09546__A1 FPGA_INST.cell1.LE_0B.reset_mode vssd1 vssd1 vccd1 vccd1 sky130_fd_sc_hd__diode_2
XFILLER_6_3 vccd1 vssd1 vccd1 vssd1 sky130_ef_sc_hd__decap_40_12
X_12041_ net878 _01387_ net663 vssd1 vssd1 vccd1 vccd1 FPGA_INST.cell2.SB0.route_sel\[81\]
+ sky130_fd_sc_hd__dfstp_1
XFILLER_77_202 vssd1 vssd1 vccd1 vccd1 sky130_fd_sc_hd__fill_1
Xfanout760 net762 vssd1 vssd1 vccd1 vccd1 net760 sky130_fd_sc_hd__buf_1
Xfanout793 net796 vssd1 vssd1 vccd1 vccd1 net793 sky130_fd_sc_hd__clkbuf_2
XFILLER_77_279 vssd1 vssd1 vccd1 vccd1 sky130_fd_sc_hd__fill_1
Xfanout782 net790 vssd1 vssd1 vccd1 vccd1 net782 sky130_fd_sc_hd__buf_1
Xfanout771 net772 vssd1 vssd1 vccd1 vccd1 net771 sky130_fd_sc_hd__clkbuf_2
XTAP_TAPCELL_ROW_125_2037 vssd1 vccd1 sky130_fd_sc_hd__tapvpwrvgnd_1
XTAP_TAPCELL_ROW_125_2026 vssd1 vccd1 sky130_fd_sc_hd__tapvpwrvgnd_1
XFILLER_92_249 vssd1 vssd1 vccd1 vccd1 sky130_fd_sc_hd__fill_1
XANTENNA__09253__S net227 vssd1 vssd1 vccd1 vccd1 sky130_fd_sc_hd__diode_2
XFILLER_65_41 vssd1 vssd1 vccd1 vccd1 sky130_fd_sc_hd__fill_1
XFILLER_85_290 vssd1 vssd1 vccd1 vccd1 sky130_fd_sc_hd__fill_8
XFILLER_46_699 vssd1 vssd1 vccd1 vccd1 sky130_fd_sc_hd__fill_1
XTAP_TAPCELL_ROW_16_503 vssd1 vccd1 sky130_fd_sc_hd__tapvpwrvgnd_1
X_11825_ net935 _01171_ net719 vssd1 vssd1 vccd1 vccd1 FPGA_INST.cell3.LEI0.config_data\[5\]
+ sky130_fd_sc_hd__dfrtp_1
XTAP_TAPCELL_ROW_107_1781 vssd1 vccd1 sky130_fd_sc_hd__tapvpwrvgnd_1
XFILLER_81_40 vccd1 vssd1 vccd1 vssd1 sky130_ef_sc_hd__decap_40_12
X_11756_ net900 _01102_ net684 vssd1 vssd1 vccd1 vccd1 FPGA_INST.cell3.SB0.route_sel\[126\]
+ sky130_fd_sc_hd__dfstp_1
XFILLER_41_393 vssd1 vssd1 vccd1 vccd1 sky130_fd_sc_hd__fill_2
XFILLER_41_371 vssd1 vssd1 vccd1 vccd1 sky130_fd_sc_hd__fill_2
X_10707_ net846 _00057_ net631 vssd1 vssd1 vccd1 vccd1 FPGA_INST.cell2.LE_0A.config_data\[6\]
+ sky130_fd_sc_hd__dfrtp_1
X_11687_ net907 _01033_ net691 vssd1 vssd1 vccd1 vccd1 FPGA_INST.cell3.SB0.route_sel\[57\]
+ sky130_fd_sc_hd__dfstp_1
X_10638_ FPGA_INST.cell3.LE_1B.config_data\[7\] FPGA_INST.cell3.LE_1B.config_data\[8\]
+ net279 vssd1 vssd1 vccd1 vccd1 _01517_ sky130_fd_sc_hd__mux2_1
XANTENNA__08680__X _04889_ vssd1 vssd1 vccd1 vccd1 sky130_fd_sc_hd__diode_2
X_10569_ FPGA_INST.cell3.CB_0.config_dataA\[13\] FPGA_INST.cell3.CB_0.config_dataA\[14\]
+ net294 vssd1 vssd1 vccd1 vccd1 _01448_ sky130_fd_sc_hd__mux2_1
XFILLER_39_3 vccd1 vssd1 vccd1 vssd1 sky130_ef_sc_hd__decap_40_12
XFILLER_96_533 vssd1 vssd1 vccd1 vccd1 sky130_fd_sc_hd__fill_2
XFILLER_110_365 vssd1 vssd1 vccd1 vccd1 sky130_fd_sc_hd__fill_1
XFILLER_96_566 vssd1 vssd1 vccd1 vccd1 sky130_fd_sc_hd__fill_1
X_07780_ _03546_ _03911_ vssd1 vssd1 vccd1 vccd1 _04029_ sky130_fd_sc_hd__nor2_1
X_06800_ FPGA_INST.cell2.CB_1.config_dataB\[19\] _03062_ _03073_ vssd1 vssd1 vccd1
+ vccd1 _03074_ sky130_fd_sc_hd__and3b_1
XFILLER_110_387 vssd1 vssd1 vccd1 vccd1 sky130_fd_sc_hd__fill_4
X_06731_ FPGA_INST.cell2.CB_1.config_dataB\[7\] _02996_ _03004_ FPGA_INST.cell2.CB_1.config_dataB\[8\]
+ vssd1 vssd1 vccd1 vccd1 _03005_ sky130_fd_sc_hd__o211a_1
Xinput4 gpio_in[12] vssd1 vssd1 vccd1 vccd1 net4 sky130_fd_sc_hd__buf_2
XTAP_TAPCELL_ROW_69_1253 vssd1 vccd1 sky130_fd_sc_hd__tapvpwrvgnd_1
XTAP_TAPCELL_ROW_69_1242 vssd1 vccd1 sky130_fd_sc_hd__tapvpwrvgnd_1
X_09450_ FPGA_INST.cell2.LE_1B.reset_val FPGA_INST.cell2.LE_1B.reset_mode net257 vssd1
+ vssd1 vccd1 vccd1 _00363_ sky130_fd_sc_hd__mux2_1
X_08401_ net73 net95 FPGA_INST.bus1_0\[2\] FPGA_INST.bus1_0\[3\] net440 FPGA_INST.cell0.CB_1.config_dataB\[16\]
+ vssd1 vssd1 vccd1 vccd1 _04623_ sky130_fd_sc_hd__mux4_1
XFILLER_52_614 vssd1 vssd1 vccd1 vccd1 sky130_fd_sc_hd__fill_1
X_06662_ FPGA_INST.cell2.CB_1.config_dataA\[17\] _02936_ _02937_ _02934_ FPGA_INST.cell2.CB_1.config_dataA\[18\]
+ vssd1 vssd1 vccd1 vccd1 _02938_ sky130_fd_sc_hd__a311o_1
XANTENNA__11568__CLK net772 vssd1 vssd1 vccd1 vccd1 sky130_fd_sc_hd__diode_2
XTAP_TAPCELL_ROW_82_1431 vssd1 vccd1 sky130_fd_sc_hd__tapvpwrvgnd_1
X_05613_ FPGA_INST.cell2.CB_1.config_dataB\[24\] FPGA_INST.cell2.CB_1.config_dataB\[21\]
+ FPGA_INST.cell2.CB_1.config_dataB\[20\] vssd1 vssd1 vccd1 vccd1 _01893_ sky130_fd_sc_hd__and3b_2
X_06593_ net483 _02793_ net482 vssd1 vssd1 vccd1 vccd1 _02869_ sky130_fd_sc_hd__o21ai_1
X_09381_ FPGA_INST.cell2.CB_0.config_dataB\[0\] FPGA_INST.cell2.CB_0.config_dataA\[24\]
+ net350 vssd1 vssd1 vccd1 vccd1 _00294_ sky130_fd_sc_hd__mux2_1
X_08332_ net448 _03840_ _04553_ net447 vssd1 vssd1 vccd1 vccd1 _04554_ sky130_fd_sc_hd__o211a_1
X_05544_ net383 net382 FPGA_INST.bus1_0\[14\] vssd1 vssd1 vccd1 vccd1 _01824_ sky130_fd_sc_hd__o21ai_1
XFILLER_51_157 vssd1 vssd1 vccd1 vccd1 sky130_fd_sc_hd__fill_8
X_08263_ _03408_ _04473_ _04474_ _03465_ FPGA_INST.cell0.CB_1.config_dataA\[17\] vssd1
+ vssd1 vccd1 vccd1 _04487_ sky130_fd_sc_hd__a221o_1
X_07214_ FPGA_INST.cell3.SB0.route_sel\[13\] FPGA_INST.cell3.SB0.route_sel\[12\] _03457_
+ _03476_ _03459_ vssd1 vssd1 vccd1 vccd1 _03477_ sky130_fd_sc_hd__a221o_1
X_05475_ FPGA_INST.cell0.CB_1.config_dataB\[2\] vssd1 vssd1 vccd1 vccd1 _01757_ sky130_fd_sc_hd__inv_2
XANTENNA_fanout133_A net134 vssd1 vssd1 vccd1 vccd1 sky130_fd_sc_hd__diode_2
XFILLER_118_421 vccd1 vssd1 vccd1 vssd1 sky130_ef_sc_hd__decap_40_12
X_08194_ net75 FPGA_INST.bus1_0\[5\] net74 FPGA_INST.bus1_0\[7\] net410 net408 vssd1
+ vssd1 vccd1 vccd1 _04418_ sky130_fd_sc_hd__mux4_1
XANTENNA_fanout300_A net306 vssd1 vssd1 vccd1 vccd1 sky130_fd_sc_hd__diode_2
X_07145_ _03405_ _03406_ _03407_ _02462_ _02454_ vssd1 vssd1 vccd1 vccd1 _03409_ sky130_fd_sc_hd__a311o_1
XFILLER_118_487 vssd1 vssd1 vccd1 vccd1 sky130_fd_sc_hd__fill_4
X_07076_ FPGA_INST.bus2_0\[8\] FPGA_INST.bus2_0\[9\] FPGA_INST.bus2_0\[10\] FPGA_INST.bus2_0\[11\]
+ net430 net429 vssd1 vssd1 vccd1 vccd1 _03342_ sky130_fd_sc_hd__mux4_1
XFILLER_105_137 vssd1 vssd1 vccd1 vccd1 sky130_fd_sc_hd__fill_4
X_06027_ FPGA_INST.cell0.SB0.route_sel\[45\] FPGA_INST.cell0.SB0.route_sel\[44\] vssd1
+ vssd1 vccd1 vccd1 _02307_ sky130_fd_sc_hd__nand2b_1
XTAP_TAPCELL_ROW_93_1582 vssd1 vccd1 sky130_fd_sc_hd__tapvpwrvgnd_1
XFILLER_87_500 vssd1 vssd1 vccd1 vccd1 sky130_fd_sc_hd__fill_4
XFILLER_99_393 vssd1 vssd1 vccd1 vccd1 sky130_fd_sc_hd__fill_1
XFILLER_87_533 vssd1 vssd1 vccd1 vccd1 sky130_fd_sc_hd__fill_2
XANTENNA__07003__A2 _02030_ vssd1 vssd1 vccd1 vccd1 sky130_fd_sc_hd__diode_2
X_07978_ _04205_ _04204_ FPGA_INST.cell1.CB_0.config_dataA\[17\] vssd1 vssd1 vccd1
+ vccd1 _04206_ sky130_fd_sc_hd__mux2_1
XFILLER_19_23 vssd1 vssd1 vccd1 vccd1 sky130_fd_sc_hd__fill_2
XFILLER_87_599 vssd1 vssd1 vccd1 vccd1 sky130_fd_sc_hd__fill_2
X_09717_ FPGA_INST.cell0.SB0.route_sel\[120\] FPGA_INST.cell0.SB0.route_sel\[121\]
+ net199 vssd1 vssd1 vccd1 vccd1 _00626_ sky130_fd_sc_hd__mux2_1
X_06929_ _03160_ _03196_ _03124_ vssd1 vssd1 vccd1 vccd1 _03197_ sky130_fd_sc_hd__mux2_1
XFILLER_19_89 vssd1 vssd1 vccd1 vccd1 sky130_fd_sc_hd__fill_2
XFILLER_28_633 vssd1 vssd1 vccd1 vccd1 sky130_fd_sc_hd__fill_8
XFILLER_90_709 vssd1 vssd1 vccd1 vccd1 sky130_fd_sc_hd__fill_2
XFILLER_83_794 vssd1 vssd1 vccd1 vccd1 sky130_fd_sc_hd__fill_1
XFILLER_82_271 vssd1 vssd1 vccd1 vccd1 sky130_fd_sc_hd__fill_2
XFILLER_27_165 vssd1 vssd1 vccd1 vccd1 sky130_fd_sc_hd__fill_2
XANTENNA__10012__S net319 vssd1 vssd1 vccd1 vccd1 sky130_fd_sc_hd__diode_2
X_09648_ FPGA_INST.cell0.SB0.route_sel\[52\] FPGA_INST.cell0.SB0.route_sel\[51\] net310
+ vssd1 vssd1 vccd1 vccd1 _00557_ sky130_fd_sc_hd__mux2_1
X_09579_ FPGA_INST.cell1.CB_1.config_dataB\[8\] FPGA_INST.cell1.CB_1.config_dataB\[7\]
+ net335 vssd1 vssd1 vccd1 vccd1 _00488_ sky130_fd_sc_hd__mux2_1
XANTENNA__10935__CLK net851 vssd1 vssd1 vccd1 vccd1 sky130_fd_sc_hd__diode_2
XFILLER_42_168 vssd1 vssd1 vccd1 vccd1 sky130_fd_sc_hd__fill_2
XFILLER_42_146 vssd1 vssd1 vccd1 vccd1 sky130_fd_sc_hd__fill_1
X_11610_ net741 _00960_ net526 vssd1 vssd1 vccd1 vccd1 FPGA_INST.cell0.LE_1B.config_data\[4\]
+ sky130_fd_sc_hd__dfrtp_1
XANTENNA__08806__A3 net26 vssd1 vssd1 vccd1 vccd1 sky130_fd_sc_hd__diode_2
XANTENNA__06278__A0 net3 vssd1 vssd1 vccd1 vccd1 sky130_fd_sc_hd__diode_2
XFILLER_11_511 vssd1 vssd1 vccd1 vccd1 sky130_fd_sc_hd__fill_1
X_11541_ net776 _00891_ net562 vssd1 vssd1 vccd1 vccd1 FPGA_INST.cell0.CB_0.config_dataA\[10\]
+ sky130_fd_sc_hd__dfstp_1
XFILLER_23_393 vssd1 vssd1 vccd1 vccd1 sky130_fd_sc_hd__fill_4
XTAP_TAPCELL_ROW_41_859 vssd1 vccd1 sky130_fd_sc_hd__tapvpwrvgnd_1
XFILLER_7_537 vssd1 vssd1 vccd1 vccd1 sky130_fd_sc_hd__fill_1
X_11472_ FPGA_INST.cell0.LE_1B.sel_clk _00822_ net732 vssd1 vssd1 vccd1 vccd1 FPGA_INST.cell0.LE_1B.dff1_out
+ sky130_fd_sc_hd__dfstp_1
XTAP_TAPCELL_ROW_21_572 vssd1 vccd1 sky130_fd_sc_hd__tapvpwrvgnd_1
X_10423_ FPGA_INST.cell3.CB_1.config_dataB\[20\] FPGA_INST.cell3.CB_1.config_dataB\[21\]
+ net279 vssd1 vssd1 vccd1 vccd1 _01302_ sky130_fd_sc_hd__mux2_1
XANTENNA__11449__RESET_B net732 vssd1 vssd1 vccd1 vccd1 sky130_fd_sc_hd__diode_2
XTAP_TAPCELL_ROW_21_583 vssd1 vccd1 sky130_fd_sc_hd__tapvpwrvgnd_1
XFILLER_124_413 vssd1 vssd1 vccd1 vccd1 sky130_fd_sc_hd__fill_4
X_10354_ FPGA_INST.cell3.LE_0A.reset_val FPGA_INST.cell3.LE_0A.reset_mode net302 vssd1
+ vssd1 vccd1 vccd1 _01235_ sky130_fd_sc_hd__mux2_1
X_10285_ FPGA_INST.cell3.LEI0.config_data\[0\] FPGA_INST.cell3.LE_1A.reset_mode net375
+ vssd1 vssd1 vccd1 vccd1 _01166_ sky130_fd_sc_hd__mux2_1
XFILLER_105_671 vssd1 vssd1 vccd1 vccd1 sky130_fd_sc_hd__fill_1
XTAP_TAPCELL_ROW_53_1021 vssd1 vccd1 sky130_fd_sc_hd__tapvpwrvgnd_1
XFILLER_3_765 vccd1 vssd1 vccd1 vssd1 sky130_ef_sc_hd__decap_40_12
XFILLER_2_253 vssd1 vssd1 vccd1 vccd1 sky130_fd_sc_hd__fill_2
XFILLER_120_641 vssd1 vssd1 vccd1 vccd1 sky130_fd_sc_hd__fill_2
XFILLER_78_533 vssd1 vssd1 vccd1 vccd1 sky130_fd_sc_hd__fill_4
XFILLER_2_297 vssd1 vssd1 vccd1 vccd1 sky130_fd_sc_hd__fill_2
X_12024_ net847 _01370_ net632 vssd1 vssd1 vccd1 vccd1 FPGA_INST.cell2.SB0.route_sel\[64\]
+ sky130_fd_sc_hd__dfstp_1
XFILLER_93_514 vssd1 vssd1 vccd1 vccd1 sky130_fd_sc_hd__fill_4
XFILLER_93_503 vssd1 vssd1 vccd1 vccd1 sky130_fd_sc_hd__fill_1
XFILLER_38_419 vssd1 vssd1 vccd1 vccd1 sky130_fd_sc_hd__fill_1
XTAP_TAPCELL_ROW_109_1810 vssd1 vccd1 sky130_fd_sc_hd__tapvpwrvgnd_1
XANTENNA__07950__A0 net152 vssd1 vssd1 vccd1 vccd1 sky130_fd_sc_hd__diode_2
Xfanout590 net596 vssd1 vssd1 vccd1 vccd1 net590 sky130_fd_sc_hd__clkbuf_2
XFILLER_18_165 vssd1 vssd1 vccd1 vccd1 sky130_fd_sc_hd__fill_2
XTAP_TAPCELL_ROW_29_683 vssd1 vccd1 sky130_fd_sc_hd__tapvpwrvgnd_1
XTAP_TAPCELL_ROW_29_694 vssd1 vccd1 sky130_fd_sc_hd__tapvpwrvgnd_1
XFILLER_33_124 vssd1 vssd1 vccd1 vccd1 sky130_fd_sc_hd__fill_1
XANTENNA__11472__SET_B net732 vssd1 vssd1 vccd1 vccd1 sky130_fd_sc_hd__diode_2
X_11808_ net871 _01154_ net655 vssd1 vssd1 vccd1 vccd1 net33 sky130_fd_sc_hd__dfrtp_1
XANTENNA__09012__A _03583_ vssd1 vssd1 vccd1 vccd1 sky130_fd_sc_hd__diode_2
XTAP_TAPCELL_ROW_64_1183 vssd1 vccd1 sky130_fd_sc_hd__tapvpwrvgnd_1
XTAP_TAPCELL_ROW_64_1172 vssd1 vccd1 sky130_fd_sc_hd__tapvpwrvgnd_1
X_11739_ net896 _01085_ net680 vssd1 vssd1 vccd1 vccd1 FPGA_INST.cell3.SB0.route_sel\[109\]
+ sky130_fd_sc_hd__dfstp_1
X_05260_ FPGA_INST.cell2.LEI0.config_data\[41\] vssd1 vssd1 vccd1 vccd1 _01542_ sky130_fd_sc_hd__inv_2
XANTENNA__10592__S net377 vssd1 vssd1 vccd1 vccd1 sky130_fd_sc_hd__diode_2
X_08950_ _01650_ FPGA_INST.cell1.SB0.route_sel\[75\] FPGA_INST.cell1.SB0.route_sel\[72\]
+ FPGA_INST.cell1.SB0.route_sel\[73\] vssd1 vssd1 vccd1 vccd1 _05140_ sky130_fd_sc_hd__o22a_1
XANTENNA__06992__A1 FPGA_INST.bus2_0\[3\] vssd1 vssd1 vccd1 vccd1 sky130_fd_sc_hd__diode_2
X_07901_ _04127_ _04128_ _04121_ _04125_ vssd1 vssd1 vccd1 vccd1 _04129_ sky130_fd_sc_hd__o211a_1
X_08881_ net386 _04781_ _05087_ FPGA_INST.cell3.CB_0.config_dataB\[16\] vssd1 vssd1
+ vccd1 vccd1 _05088_ sky130_fd_sc_hd__o211a_1
XPHY_EDGE_ROW_102_Left_233 vssd1 vssd1 vccd1 vccd1 sky130_fd_sc_hd__decap_3
XANTENNA__08194__A0 net75 vssd1 vssd1 vccd1 vccd1 sky130_fd_sc_hd__diode_2
X_07832_ _01955_ _02046_ _02167_ vssd1 vssd1 vccd1 vccd1 _04069_ sky130_fd_sc_hd__o21ai_1
XFILLER_110_184 vccd1 vssd1 vccd1 vssd1 sky130_ef_sc_hd__decap_40_12
XANTENNA__07941__A0 FPGA_INST.bus3_1\[8\] vssd1 vssd1 vccd1 vccd1 sky130_fd_sc_hd__diode_2
XFILLER_57_739 vssd1 vssd1 vccd1 vccd1 sky130_fd_sc_hd__fill_8
XANTENNA__05547__A2 net383 vssd1 vssd1 vccd1 vccd1 sky130_fd_sc_hd__diode_2
XFILLER_56_238 vssd1 vssd1 vccd1 vccd1 sky130_fd_sc_hd__fill_2
XFILLER_56_227 vssd1 vssd1 vccd1 vccd1 sky130_fd_sc_hd__fill_2
X_09502_ net736 _04378_ vssd1 vssd1 vccd1 vccd1 _05214_ sky130_fd_sc_hd__nand2_1
X_07763_ _04010_ _04011_ _04012_ _04009_ vssd1 vssd1 vccd1 vccd1 _04013_ sky130_fd_sc_hd__a31o_4
XFILLER_112_27 vssd1 vssd1 vccd1 vccd1 sky130_fd_sc_hd__fill_1
X_07694_ _03945_ _03943_ vssd1 vssd1 vccd1 vccd1 FPGA_INST.bus3_2\[12\] sky130_fd_sc_hd__and2b_2
XFILLER_65_794 vssd1 vssd1 vccd1 vccd1 sky130_fd_sc_hd__fill_4
XFILLER_65_783 vssd1 vssd1 vccd1 vccd1 sky130_fd_sc_hd__fill_1
X_06714_ net138 net127 FPGA_INST.cell2.LEI0.config_data\[9\] vssd1 vssd1 vccd1 vccd1
+ _02988_ sky130_fd_sc_hd__mux2_1
X_09433_ FPGA_INST.cell2.LE_1B.config_data\[1\] FPGA_INST.cell2.LE_1B.config_data\[2\]
+ net266 vssd1 vssd1 vccd1 vccd1 _00346_ sky130_fd_sc_hd__mux2_1
X_06645_ FPGA_INST.bus3_2\[8\] FPGA_INST.bus3_2\[10\] FPGA_INST.bus3_2\[9\] FPGA_INST.bus3_2\[11\]
+ FPGA_INST.cell2.CB_1.config_dataA\[16\] FPGA_INST.cell2.CB_1.config_dataA\[15\]
+ vssd1 vssd1 vccd1 vccd1 _02921_ sky130_fd_sc_hd__mux4_1
XFILLER_52_444 vssd1 vssd1 vccd1 vccd1 sky130_fd_sc_hd__fill_4
XFILLER_37_496 vssd1 vssd1 vccd1 vccd1 sky130_fd_sc_hd__fill_8
XANTENNA_fanout348_A net349 vssd1 vssd1 vccd1 vccd1 sky130_fd_sc_hd__diode_2
XPHY_EDGE_ROW_111_Left_242 vssd1 vssd1 vccd1 vccd1 sky130_fd_sc_hd__decap_3
X_09364_ FPGA_INST.cell2.CB_0.config_dataA\[8\] FPGA_INST.cell2.CB_0.config_dataA\[7\]
+ net351 vssd1 vssd1 vccd1 vccd1 _00277_ sky130_fd_sc_hd__mux2_1
X_08315_ net446 _03682_ _04536_ FPGA_INST.cell0.CB_1.config_dataB\[6\] vssd1 vssd1
+ vccd1 vccd1 _04537_ sky130_fd_sc_hd__o211a_1
X_06576_ FPGA_INST.bus3_2\[12\] FPGA_INST.bus3_2\[13\] FPGA_INST.bus3_2\[14\] FPGA_INST.bus3_2\[15\]
+ net484 net482 vssd1 vssd1 vccd1 vccd1 _02852_ sky130_fd_sc_hd__mux4_1
XFILLER_40_628 vssd1 vssd1 vccd1 vccd1 sky130_fd_sc_hd__fill_1
X_05527_ _01808_ vssd1 vssd1 vccd1 vccd1 _01809_ sky130_fd_sc_hd__inv_2
X_09295_ FPGA_INST.cell1.SB0.route_sel\[67\] FPGA_INST.cell1.SB0.route_sel\[66\] net331
+ vssd1 vssd1 vccd1 vccd1 _00208_ sky130_fd_sc_hd__mux2_1
X_08246_ _04466_ _04467_ _04469_ vssd1 vssd1 vccd1 vccd1 _04470_ sky130_fd_sc_hd__and3_1
X_05458_ FPGA_INST.cell0.LE_0A.config_data\[16\] vssd1 vssd1 vccd1 vccd1 _01740_ sky130_fd_sc_hd__inv_2
XTAP_TAPCELL_ROW_95_1611 vssd1 vccd1 sky130_fd_sc_hd__tapvpwrvgnd_1
X_08177_ FPGA_INST.cell0.CB_1.config_dataA\[3\] _04400_ vssd1 vssd1 vccd1 vccd1 _04401_
+ sky130_fd_sc_hd__nor2_1
XFILLER_119_785 vccd1 vssd1 vccd1 vssd1 sky130_ef_sc_hd__decap_40_12
XFILLER_118_262 vssd1 vssd1 vccd1 vccd1 sky130_fd_sc_hd__fill_8
X_05389_ FPGA_INST.cell3.SB0.route_sel\[49\] vssd1 vssd1 vccd1 vccd1 _01671_ sky130_fd_sc_hd__inv_2
X_07128_ _01740_ FPGA_INST.cell0.LE_0A.dff_out vssd1 vssd1 vccd1 vccd1 _03393_ sky130_fd_sc_hd__or2_1
XFILLER_21_57 vssd1 vssd1 vccd1 vccd1 sky130_fd_sc_hd__fill_1
XPHY_EDGE_ROW_120_Left_251 vssd1 vssd1 vccd1 vccd1 sky130_fd_sc_hd__decap_3
XANTENNA__06432__A0 net3 vssd1 vssd1 vccd1 vccd1 sky130_fd_sc_hd__diode_2
XANTENNA__10007__S net319 vssd1 vssd1 vccd1 vccd1 sky130_fd_sc_hd__diode_2
X_07059_ FPGA_INST.cell0.CB_0.config_dataA\[13\] FPGA_INST.cell0.CB_0.config_dataA\[12\]
+ vssd1 vssd1 vccd1 vccd1 _03325_ sky130_fd_sc_hd__nor2_1
XFILLER_121_438 vssd1 vssd1 vccd1 vccd1 sky130_fd_sc_hd__fill_8
XFILLER_114_490 vssd1 vssd1 vccd1 vccd1 sky130_fd_sc_hd__fill_1
X_10070_ FPGA_INST.cell0.CB_1.config_dataA\[20\] FPGA_INST.cell0.CB_1.config_dataA\[19\]
+ net329 vssd1 vssd1 vccd1 vccd1 _00951_ sky130_fd_sc_hd__mux2_1
XPHY_EDGE_ROW_102_Right_102 vssd1 vssd1 vccd1 vccd1 sky130_fd_sc_hd__decap_3
XFILLER_75_503 vssd1 vssd1 vccd1 vccd1 sky130_fd_sc_hd__fill_1
XTAP_TAPCELL_ROW_7_378 vssd1 vccd1 sky130_fd_sc_hd__tapvpwrvgnd_1
XFILLER_102_685 vssd1 vssd1 vccd1 vccd1 sky130_fd_sc_hd__fill_2
XFILLER_101_162 vssd1 vssd1 vccd1 vccd1 sky130_fd_sc_hd__fill_4
XFILLER_87_374 vssd1 vssd1 vccd1 vccd1 sky130_fd_sc_hd__fill_1
XANTENNA__06735__A1 _02804_ vssd1 vssd1 vccd1 vccd1 sky130_fd_sc_hd__diode_2
XFILLER_75_547 vssd1 vssd1 vccd1 vccd1 sky130_fd_sc_hd__fill_4
XTAP_TAPCELL_ROW_46_929 vssd1 vccd1 sky130_fd_sc_hd__tapvpwrvgnd_1
X_10972_ net879 _00322_ net664 vssd1 vssd1 vccd1 vccd1 FPGA_INST.cell2.CB_1.config_dataA\[3\]
+ sky130_fd_sc_hd__dfstp_1
XFILLER_43_433 vccd1 vssd1 vccd1 vssd1 sky130_ef_sc_hd__decap_40_12
XTAP_TAPCELL_ROW_104_1740 vssd1 vccd1 sky130_fd_sc_hd__tapvpwrvgnd_1
XFILLER_43_477 vssd1 vssd1 vccd1 vccd1 sky130_fd_sc_hd__fill_4
XTAP_TAPCELL_ROW_26_642 vssd1 vccd1 sky130_fd_sc_hd__tapvpwrvgnd_1
XTAP_TAPCELL_ROW_26_653 vssd1 vccd1 sky130_fd_sc_hd__tapvpwrvgnd_1
X_11524_ net810 _00874_ net593 vssd1 vssd1 vccd1 vccd1 FPGA_INST.config_bits\[5\]
+ sky130_fd_sc_hd__dfstp_1
XANTENNA__08660__A1 net24 vssd1 vssd1 vccd1 vccd1 sky130_fd_sc_hd__diode_2
XFILLER_7_26 vssd1 vssd1 vccd1 vccd1 sky130_fd_sc_hd__fill_1
XANTENNA__07558__Y _03813_ vssd1 vssd1 vccd1 vccd1 sky130_fd_sc_hd__diode_2
XFILLER_7_59 vssd1 vssd1 vccd1 vccd1 sky130_fd_sc_hd__fill_8
X_11455_ net751 _00805_ net536 vssd1 vssd1 vccd1 vccd1 FPGA_INST.cell0.LE_0B.config_data\[4\]
+ sky130_fd_sc_hd__dfrtp_1
XFILLER_125_733 vssd1 vssd1 vccd1 vccd1 sky130_fd_sc_hd__fill_2
XFILLER_125_722 vssd1 vssd1 vccd1 vccd1 sky130_fd_sc_hd__fill_4
X_10406_ FPGA_INST.cell3.CB_1.config_dataB\[3\] FPGA_INST.cell3.CB_1.config_dataB\[4\]
+ net283 vssd1 vssd1 vccd1 vccd1 _01285_ sky130_fd_sc_hd__mux2_1
XFILLER_109_251 vssd1 vssd1 vccd1 vccd1 sky130_fd_sc_hd__fill_1
XFILLER_7_378 vccd1 vssd1 vccd1 vssd1 sky130_ef_sc_hd__decap_40_12
XFILLER_124_232 vssd1 vssd1 vccd1 vccd1 sky130_fd_sc_hd__fill_2
XANTENNA__07215__A2 _02780_ vssd1 vssd1 vccd1 vccd1 sky130_fd_sc_hd__diode_2
X_11386_ net762 _00736_ net547 vssd1 vssd1 vccd1 vccd1 FPGA_INST.cell0.LEI0.config_data\[7\]
+ sky130_fd_sc_hd__dfrtp_1
X_10337_ FPGA_INST.cell3.LE_0A.config_data\[1\] FPGA_INST.cell3.LE_0A.config_data\[2\]
+ net294 vssd1 vssd1 vccd1 vccd1 _01218_ sky130_fd_sc_hd__mux2_1
XANTENNA__05777__A2 net171 vssd1 vssd1 vccd1 vccd1 sky130_fd_sc_hd__diode_2
XTAP_TAPCELL_ROW_115_1891 vssd1 vccd1 sky130_fd_sc_hd__tapvpwrvgnd_1
XFILLER_97_138 vssd1 vssd1 vccd1 vccd1 sky130_fd_sc_hd__fill_1
XFILLER_87_61 vssd1 vssd1 vccd1 vccd1 sky130_fd_sc_hd__fill_2
XFILLER_87_50 vssd1 vssd1 vccd1 vccd1 sky130_fd_sc_hd__fill_4
X_10268_ FPGA_INST.io_east_oeb\[24\] FPGA_INST.io_east_oeb\[26\] net254 vssd1 vssd1
+ vccd1 vccd1 _01149_ sky130_fd_sc_hd__mux2_1
XFILLER_78_363 vssd1 vssd1 vccd1 vccd1 sky130_fd_sc_hd__fill_1
X_12007_ net854 _01353_ net639 vssd1 vssd1 vccd1 vccd1 FPGA_INST.cell2.SB0.route_sel\[47\]
+ sky130_fd_sc_hd__dfstp_1
X_10199_ FPGA_INST.cell3.SB0.route_sel\[104\] FPGA_INST.cell3.SB0.route_sel\[103\]
+ net366 vssd1 vssd1 vccd1 vccd1 _01080_ sky130_fd_sc_hd__mux2_1
XFILLER_78_396 vssd1 vssd1 vccd1 vccd1 sky130_fd_sc_hd__fill_2
XTAP_TAPCELL_ROW_66_1212 vssd1 vccd1 sky130_fd_sc_hd__tapvpwrvgnd_1
XTAP_TAPCELL_ROW_66_1201 vssd1 vccd1 sky130_fd_sc_hd__tapvpwrvgnd_1
XANTENNA__10587__S net377 vssd1 vssd1 vccd1 vccd1 sky130_fd_sc_hd__diode_2
XFILLER_62_720 vssd1 vssd1 vccd1 vccd1 sky130_fd_sc_hd__fill_1
XFILLER_47_794 vssd1 vssd1 vccd1 vccd1 sky130_fd_sc_hd__fill_4
X_06430_ _02330_ _02692_ _02693_ _02293_ _01541_ vssd1 vssd1 vccd1 vccd1 _02708_ sky130_fd_sc_hd__a221o_1
XFILLER_34_466 vssd1 vssd1 vccd1 vccd1 sky130_fd_sc_hd__fill_2
XFILLER_14_190 vssd1 vssd1 vccd1 vccd1 sky130_fd_sc_hd__fill_4
X_06361_ net494 _01914_ vssd1 vssd1 vccd1 vccd1 _02639_ sky130_fd_sc_hd__nand2_1
X_08100_ _04316_ _04321_ _04325_ _04311_ FPGA_INST.cell1.CB_0.config_dataB\[14\] vssd1
+ vssd1 vccd1 vccd1 _04326_ sky130_fd_sc_hd__a311o_1
X_09080_ _05207_ net91 _03487_ vssd1 vssd1 vccd1 vccd1 net61 sky130_fd_sc_hd__mux2_1
X_05312_ FPGA_INST.cell2.CB_1.config_dataB\[2\] vssd1 vssd1 vccd1 vccd1 _01594_ sky130_fd_sc_hd__inv_2
X_06292_ FPGA_INST.cell2.LE_0A.config_data\[7\] FPGA_INST.cell2.LE_0A.config_data\[6\]
+ _02536_ vssd1 vssd1 vccd1 vccd1 _02572_ sky130_fd_sc_hd__mux2_1
X_08031_ _04249_ _04252_ _04256_ FPGA_INST.cell1.CB_0.config_dataB\[8\] vssd1 vssd1
+ vccd1 vccd1 _04257_ sky130_fd_sc_hd__or4b_1
XFILLER_116_766 vssd1 vssd1 vccd1 vccd1 sky130_fd_sc_hd__fill_4
XTAP_TAPCELL_ROW_77_1363 vssd1 vccd1 sky130_fd_sc_hd__tapvpwrvgnd_1
X_09982_ _01529_ _05232_ net738 vssd1 vssd1 vccd1 vccd1 _05233_ sky130_fd_sc_hd__o21ai_1
XTAP_TAPCELL_ROW_90_1541 vssd1 vccd1 sky130_fd_sc_hd__tapvpwrvgnd_1
XFILLER_88_116 vssd1 vssd1 vccd1 vccd1 sky130_fd_sc_hd__fill_8
X_08933_ FPGA_INST.cell1.SB0.route_sel\[88\] FPGA_INST.cell1.SB0.route_sel\[89\] _05128_
+ vssd1 vssd1 vccd1 vccd1 _05129_ sky130_fd_sc_hd__o21ai_1
XANTENNA_fanout298_A net300 vssd1 vssd1 vccd1 vccd1 sky130_fd_sc_hd__diode_2
XFILLER_69_352 vssd1 vssd1 vccd1 vccd1 sky130_fd_sc_hd__fill_1
X_08864_ net386 _04819_ _05070_ FPGA_INST.cell3.CB_0.config_dataB\[16\] vssd1 vssd1
+ vccd1 vccd1 _05071_ sky130_fd_sc_hd__o211a_1
XTAP_TAPCELL_ROW_4_337 vssd1 vccd1 sky130_fd_sc_hd__tapvpwrvgnd_1
XFILLER_29_227 vssd1 vssd1 vccd1 vccd1 sky130_fd_sc_hd__fill_1
XFILLER_123_48 vssd1 vssd1 vccd1 vccd1 sky130_fd_sc_hd__fill_1
XFILLER_111_493 vssd1 vssd1 vccd1 vccd1 sky130_fd_sc_hd__fill_2
X_08795_ FPGA_INST.cell3.CB_0.config_dataB\[0\] _04819_ _05001_ net391 vssd1 vssd1
+ vccd1 vccd1 _05002_ sky130_fd_sc_hd__o211a_1
X_07815_ net883 FPGA_INST.cell2.LE_1A.edge_mode vssd1 vssd1 vccd1 vccd1 FPGA_INST.cell2.LE_1A.sel_clk
+ sky130_fd_sc_hd__xnor2_1
X_07746_ _01614_ FPGA_INST.cell0.SB0.route_sel\[119\] vssd1 vssd1 vccd1 vccd1 _03996_
+ sky130_fd_sc_hd__or2_1
XFILLER_38_761 vssd1 vssd1 vccd1 vccd1 sky130_fd_sc_hd__fill_2
X_07677_ FPGA_INST.cell1.SB0.route_sel\[99\] FPGA_INST.cell1.SB0.route_sel\[98\] _03925_
+ _03928_ _03917_ vssd1 vssd1 vccd1 vccd1 _03929_ sky130_fd_sc_hd__a311o_1
X_09416_ FPGA_INST.cell2.CB_1.config_dataA\[9\] net479 net265 vssd1 vssd1 vccd1 vccd1
+ _00329_ sky130_fd_sc_hd__mux2_1
X_06628_ _02895_ _02903_ FPGA_INST.cell2.CB_1.config_dataA\[14\] _02891_ vssd1 vssd1
+ vccd1 vccd1 _02904_ sky130_fd_sc_hd__a211o_1
XFILLER_52_274 vssd1 vssd1 vccd1 vccd1 sky130_fd_sc_hd__fill_2
XTAP_TAPCELL_ROW_23_601 vssd1 vccd1 sky130_fd_sc_hd__tapvpwrvgnd_1
X_09347_ FPGA_INST.cell1.SB0.route_sel\[119\] FPGA_INST.cell1.SB0.route_sel\[118\]
+ net324 vssd1 vssd1 vccd1 vccd1 _00260_ sky130_fd_sc_hd__mux2_1
X_06559_ _01571_ FPGA_INST.cell2.SB0.route_sel\[81\] FPGA_INST.cell2.SB0.route_sel\[86\]
+ _01572_ _02834_ vssd1 vssd1 vccd1 vccd1 _02835_ sky130_fd_sc_hd__a221o_1
XANTENNA__08642__A1 net21 vssd1 vssd1 vccd1 vccd1 sky130_fd_sc_hd__diode_2
X_09278_ FPGA_INST.cell1.SB0.route_sel\[50\] FPGA_INST.cell1.SB0.route_sel\[49\] net330
+ vssd1 vssd1 vccd1 vccd1 _00191_ sky130_fd_sc_hd__mux2_1
XTAP_TAPCELL_ROW_51_998 vssd1 vccd1 sky130_fd_sc_hd__tapvpwrvgnd_1
XANTENNA__06248__A3 net13 vssd1 vssd1 vccd1 vccd1 sky130_fd_sc_hd__diode_2
XFILLER_21_650 vssd1 vssd1 vccd1 vccd1 sky130_fd_sc_hd__fill_1
X_08229_ FPGA_INST.cell0.CB_1.config_dataA\[13\] _04452_ vssd1 vssd1 vccd1 vccd1 _04453_
+ sky130_fd_sc_hd__nor2_1
XANTENNA__06723__B _02832_ vssd1 vssd1 vccd1 vccd1 sky130_fd_sc_hd__diode_2
XFILLER_107_755 vssd1 vssd1 vccd1 vccd1 sky130_fd_sc_hd__fill_4
X_11240_ net768 _00590_ net553 vssd1 vssd1 vccd1 vccd1 FPGA_INST.cell0.SB0.route_sel\[85\]
+ sky130_fd_sc_hd__dfstp_1
X_11171_ net787 _00521_ net572 vssd1 vssd1 vccd1 vccd1 FPGA_INST.cell0.SB0.route_sel\[16\]
+ sky130_fd_sc_hd__dfstp_1
X_10122_ FPGA_INST.cell3.SB0.route_sel\[26\] FPGA_INST.cell3.SB0.route_sel\[27\] net270
+ vssd1 vssd1 vccd1 vccd1 _01003_ sky130_fd_sc_hd__mux2_1
XANTENNA__06956__A1 FPGA_INST.bus2_0\[0\] vssd1 vssd1 vccd1 vccd1 sky130_fd_sc_hd__diode_2
XANTENNA__06956__B2 FPGA_INST.bus2_0\[1\] vssd1 vssd1 vccd1 vccd1 sky130_fd_sc_hd__diode_2
XFILLER_88_661 vssd1 vssd1 vccd1 vccd1 sky130_fd_sc_hd__fill_2
XFILLER_79_149 vssd1 vssd1 vccd1 vccd1 sky130_fd_sc_hd__fill_1
XFILLER_87_171 vccd1 vssd1 vccd1 vssd1 sky130_ef_sc_hd__decap_40_12
XFILLER_48_514 vssd1 vssd1 vccd1 vccd1 sky130_fd_sc_hd__fill_1
X_10053_ FPGA_INST.cell0.CB_1.config_dataA\[3\] FPGA_INST.cell0.CB_1.config_dataA\[2\]
+ net311 vssd1 vssd1 vccd1 vccd1 _00934_ sky130_fd_sc_hd__mux2_1
XANTENNA_input26_A gpio_in[32] vssd1 vssd1 vccd1 vccd1 sky130_fd_sc_hd__diode_2
XANTENNA__08173__A3 FPGA_INST.bus1_0\[3\] vssd1 vssd1 vccd1 vccd1 sky130_fd_sc_hd__diode_2
XFILLER_48_558 vssd1 vssd1 vccd1 vccd1 sky130_fd_sc_hd__fill_1
XANTENNA__09261__S net230 vssd1 vssd1 vccd1 vccd1 sky130_fd_sc_hd__diode_2
XFILLER_75_399 vssd1 vssd1 vccd1 vccd1 sky130_fd_sc_hd__fill_1
XFILLER_73_30 vssd1 vssd1 vccd1 vccd1 sky130_fd_sc_hd__fill_1
XFILLER_29_794 vssd1 vssd1 vccd1 vccd1 sky130_fd_sc_hd__fill_4
XFILLER_71_561 vssd1 vssd1 vccd1 vccd1 sky130_fd_sc_hd__fill_4
XFILLER_43_252 vccd1 vssd1 vccd1 vssd1 sky130_ef_sc_hd__decap_40_12
XFILLER_16_466 vssd1 vssd1 vccd1 vccd1 sky130_fd_sc_hd__fill_4
X_10955_ net864 _00305_ net649 vssd1 vssd1 vccd1 vccd1 FPGA_INST.cell2.CB_0.config_dataB\[11\]
+ sky130_fd_sc_hd__dfstp_1
XANTENNA__07684__A2 _01947_ vssd1 vssd1 vccd1 vccd1 sky130_fd_sc_hd__diode_2
X_10886_ net797 _00236_ net582 vssd1 vssd1 vccd1 vccd1 FPGA_INST.cell1.SB0.route_sel\[95\]
+ sky130_fd_sc_hd__dfstp_1
XFILLER_16_477 vssd1 vssd1 vccd1 vccd1 sky130_fd_sc_hd__fill_8
XFILLER_92_9 vssd1 vssd1 vccd1 vccd1 sky130_fd_sc_hd__fill_1
XTAP_TAPCELL_ROW_61_1142 vssd1 vccd1 sky130_fd_sc_hd__tapvpwrvgnd_1
XTAP_TAPCELL_ROW_61_1131 vssd1 vccd1 sky130_fd_sc_hd__tapvpwrvgnd_1
XFILLER_12_672 vssd1 vssd1 vccd1 vccd1 sky130_fd_sc_hd__fill_4
X_11507_ net762 _00857_ net547 vssd1 vssd1 vccd1 vccd1 FPGA_INST.cell0.CB_1.config_dataB\[13\]
+ sky130_fd_sc_hd__dfstp_1
XFILLER_8_643 vssd1 vssd1 vccd1 vccd1 sky130_fd_sc_hd__fill_1
XTAP_TAPCELL_ROW_117_1920 vssd1 vccd1 sky130_fd_sc_hd__tapvpwrvgnd_1
X_11438_ net773 _00788_ net559 vssd1 vssd1 vccd1 vccd1 FPGA_INST.cell0.LE_0A.config_data\[9\]
+ sky130_fd_sc_hd__dfrtp_1
X_11369_ net817 _00719_ net602 vssd1 vssd1 vccd1 vccd1 FPGA_INST.cell1.LE_1B.config_data\[11\]
+ sky130_fd_sc_hd__dfrtp_1
XFILLER_113_714 vccd1 vssd1 vccd1 vssd1 sky130_ef_sc_hd__decap_40_12
XFILLER_98_436 vssd1 vssd1 vccd1 vccd1 sky130_fd_sc_hd__fill_1
XANTENNA__09436__S net379 vssd1 vssd1 vccd1 vccd1 sky130_fd_sc_hd__diode_2
XFILLER_98_469 vssd1 vssd1 vccd1 vccd1 sky130_fd_sc_hd__fill_1
XTAP_TAPCELL_ROW_72_1293 vssd1 vccd1 sky130_fd_sc_hd__tapvpwrvgnd_1
X_05930_ _01905_ _02209_ vssd1 vssd1 vccd1 vccd1 _02210_ sky130_fd_sc_hd__or2_1
XFILLER_21_3 vssd1 vssd1 vccd1 vccd1 sky130_fd_sc_hd__fill_4
X_05861_ _02132_ _02139_ _02140_ vssd1 vssd1 vccd1 vccd1 _02141_ sky130_fd_sc_hd__o21ba_1
XFILLER_39_558 vssd1 vssd1 vccd1 vccd1 sky130_fd_sc_hd__fill_2
XANTENNA__07372__A1 _03447_ vssd1 vssd1 vccd1 vccd1 sky130_fd_sc_hd__diode_2
XFILLER_93_163 vssd1 vssd1 vccd1 vccd1 sky130_fd_sc_hd__fill_1
X_08580_ _03825_ _04788_ vssd1 vssd1 vccd1 vccd1 _04789_ sky130_fd_sc_hd__nand2_4
X_07600_ _03851_ _03853_ vssd1 vssd1 vccd1 vccd1 _03854_ sky130_fd_sc_hd__nand2_4
X_07531_ _03744_ _03779_ _03786_ net367 vssd1 vssd1 vccd1 vccd1 _03787_ sky130_fd_sc_hd__a211oi_2
X_05792_ _01782_ _01871_ _02013_ _02057_ _02071_ vssd1 vssd1 vccd1 vccd1 _02072_ sky130_fd_sc_hd__o32a_2
XFILLER_35_764 vccd1 vssd1 vccd1 vssd1 sky130_ef_sc_hd__decap_40_12
XANTENNA__08872__A1 net21 vssd1 vssd1 vccd1 vccd1 sky130_fd_sc_hd__diode_2
XANTENNA__10110__S net244 vssd1 vssd1 vccd1 vccd1 sky130_fd_sc_hd__diode_2
XFILLER_22_425 vssd1 vssd1 vccd1 vccd1 sky130_fd_sc_hd__fill_2
X_07462_ FPGA_INST.cell0.SB0.route_sel\[56\] _01669_ FPGA_INST.cell0.SB0.route_sel\[60\]
+ FPGA_INST.cell0.SB0.route_sel\[61\] _03718_ vssd1 vssd1 vccd1 vccd1 _03719_ sky130_fd_sc_hd__o221a_1
X_07393_ _03642_ _03647_ _03649_ _03651_ vssd1 vssd1 vccd1 vccd1 _03652_ sky130_fd_sc_hd__o211a_4
X_06413_ net491 _02056_ _02690_ net490 vssd1 vssd1 vccd1 vccd1 _02691_ sky130_fd_sc_hd__o211a_1
XANTENNA__06883__A0 FPGA_INST.bus2_0\[2\] vssd1 vssd1 vccd1 vccd1 sky130_fd_sc_hd__diode_2
X_09201_ FPGA_INST.cell2.LE_1A.reset_val FPGA_INST.cell2.LE_1A.reset_mode net266 vssd1
+ vssd1 vccd1 vccd1 _00114_ sky130_fd_sc_hd__mux2_1
XFILLER_50_778 vssd1 vssd1 vccd1 vccd1 sky130_fd_sc_hd__fill_1
X_06344_ net494 _02376_ vssd1 vssd1 vccd1 vccd1 _02622_ sky130_fd_sc_hd__nand2_1
X_09132_ FPGA_INST.cell2.LEI0.config_data\[46\] FPGA_INST.cell2.CB_0.config_data_inA
+ net259 vssd1 vssd1 vccd1 vccd1 _00048_ sky130_fd_sc_hd__mux2_1
XANTENNA_fanout213_A net219 vssd1 vssd1 vccd1 vccd1 sky130_fd_sc_hd__diode_2
XFILLER_118_15 vccd1 vssd1 vccd1 vssd1 sky130_ef_sc_hd__decap_40_12
X_09063_ net721 FPGA_INST.cell3.LE_1B.reset_mode vssd1 vssd1 vccd1 vccd1 _09063_/X
+ sky130_fd_sc_hd__xor2_2
X_06275_ net503 _02255_ _02554_ net502 vssd1 vssd1 vccd1 vccd1 _02555_ sky130_fd_sc_hd__o211a_1
X_08014_ _04238_ _04239_ FPGA_INST.cell1.CB_0.config_dataB\[7\] vssd1 vssd1 vccd1
+ vccd1 _04240_ sky130_fd_sc_hd__mux2_1
XANTENNA__07358__C _03616_ vssd1 vssd1 vccd1 vccd1 sky130_fd_sc_hd__diode_2
XTAP_TAPCELL_ROW_9_407 vssd1 vccd1 sky130_fd_sc_hd__tapvpwrvgnd_1
X_09965_ net738 _05221_ FPGA_INST.config_bits\[0\] vssd1 vssd1 vccd1 vccd1 _00869_
+ sky130_fd_sc_hd__mux2_1
XANTENNA_fanout582_A net588 vssd1 vssd1 vccd1 vccd1 sky130_fd_sc_hd__diode_2
XANTENNA__06402__A3 net13 vssd1 vssd1 vccd1 vccd1 sky130_fd_sc_hd__diode_2
X_08916_ net221 _03966_ _03970_ _05117_ vssd1 vssd1 vccd1 vccd1 FPGA_INST.bus1_0\[13\]
+ sky130_fd_sc_hd__and4_4
X_09896_ FPGA_INST.cell0.LE_0B.config_data\[1\] FPGA_INST.cell0.LE_0B.config_data\[0\]
+ net309 vssd1 vssd1 vccd1 vccd1 _00802_ sky130_fd_sc_hd__mux2_1
X_08847_ FPGA_INST.cell3.CB_0.config_dataB\[10\] _04804_ vssd1 vssd1 vccd1 vccd1 _05054_
+ sky130_fd_sc_hd__or2_1
XFILLER_94_29 vssd1 vssd1 vccd1 vccd1 sky130_fd_sc_hd__fill_4
XFILLER_85_642 vssd1 vssd1 vccd1 vccd1 sky130_fd_sc_hd__fill_1
XANTENNA__09870__A net736 vssd1 vssd1 vccd1 vccd1 sky130_fd_sc_hd__diode_2
XFILLER_57_377 vssd1 vssd1 vccd1 vccd1 sky130_fd_sc_hd__fill_1
XFILLER_27_23 vssd1 vssd1 vccd1 vccd1 sky130_fd_sc_hd__fill_4
XANTENNA_fanout847_A net849 vssd1 vssd1 vccd1 vccd1 sky130_fd_sc_hd__diode_2
X_08778_ net389 _04982_ _04983_ _04984_ vssd1 vssd1 vccd1 vccd1 _04985_ sky130_fd_sc_hd__a31o_1
X_07729_ FPGA_INST.cell3.SB0.route_sel\[104\] FPGA_INST.cell3.SB0.route_sel\[105\]
+ _03976_ _03979_ net366 vssd1 vssd1 vccd1 vccd1 _03980_ sky130_fd_sc_hd__a311oi_4
XFILLER_72_358 vssd1 vssd1 vccd1 vccd1 sky130_fd_sc_hd__fill_4
XFILLER_53_550 vssd1 vssd1 vccd1 vccd1 sky130_fd_sc_hd__fill_8
XFILLER_25_230 vssd1 vssd1 vccd1 vccd1 sky130_fd_sc_hd__fill_1
XANTENNA__07666__A2 FPGA_INST.cell1.SB0.route_sel\[96\] vssd1 vssd1 vccd1 vccd1 sky130_fd_sc_hd__diode_2
XFILLER_41_712 vssd1 vssd1 vccd1 vccd1 sky130_fd_sc_hd__fill_1
X_10740_ net874 _00090_ net658 vssd1 vssd1 vccd1 vccd1 FPGA_INST.cell2.LE_0B.edge_mode
+ sky130_fd_sc_hd__dfstp_1
XANTENNA__10020__S net317 vssd1 vssd1 vccd1 vccd1 sky130_fd_sc_hd__diode_2
XTAP_TAPCELL_ROW_36_781 vssd1 vccd1 sky130_fd_sc_hd__tapvpwrvgnd_1
X_10671_ net880 _00021_ net665 vssd1 vssd1 vccd1 vccd1 FPGA_INST.cell2.LEI0.config_data\[20\]
+ sky130_fd_sc_hd__dfrtp_1
XFILLER_43_55 vssd1 vssd1 vccd1 vccd1 sky130_fd_sc_hd__fill_1
XFILLER_41_756 vccd1 vssd1 vccd1 vssd1 sky130_ef_sc_hd__decap_40_12
XTAP_TAPCELL_ROW_36_792 vssd1 vccd1 sky130_fd_sc_hd__tapvpwrvgnd_1
XANTENNA__07389__X _03648_ vssd1 vssd1 vccd1 vccd1 sky130_fd_sc_hd__diode_2
XANTENNA__08091__A2 FPGA_INST.bus3_1\[10\] vssd1 vssd1 vccd1 vccd1 sky130_fd_sc_hd__diode_2
XANTENNA__06453__B _02217_ vssd1 vssd1 vccd1 vccd1 sky130_fd_sc_hd__diode_2
XTAP_TAPCELL_ROW_130_2117 vssd1 vccd1 sky130_fd_sc_hd__tapvpwrvgnd_1
XTAP_TAPCELL_ROW_130_2106 vssd1 vccd1 sky130_fd_sc_hd__tapvpwrvgnd_1
XFILLER_107_563 vccd1 vssd1 vccd1 vssd1 sky130_ef_sc_hd__decap_40_12
X_11223_ net765 _00573_ net550 vssd1 vssd1 vccd1 vccd1 FPGA_INST.cell0.SB0.route_sel\[68\]
+ sky130_fd_sc_hd__dfstp_1
XFILLER_107_596 vssd1 vssd1 vccd1 vccd1 sky130_fd_sc_hd__fill_1
XTAP_TAPCELL_ROW_112_1850 vssd1 vccd1 sky130_fd_sc_hd__tapvpwrvgnd_1
X_11154_ net812 _00504_ net597 vssd1 vssd1 vccd1 vccd1 FPGA_INST.cell1.CB_1.config_dataB\[24\]
+ sky130_fd_sc_hd__dfstp_1
X_11085_ FPGA_INST.cell1.LE_0B.sel_clk _00435_ net733 vssd1 vssd1 vccd1 vccd1 FPGA_INST.cell1.LE_0B.dff0_out
+ sky130_fd_sc_hd__dfrtp_1
XFILLER_95_439 vssd1 vssd1 vccd1 vccd1 sky130_fd_sc_hd__fill_2
X_10105_ FPGA_INST.cell3.SB0.route_sel\[9\] FPGA_INST.cell3.SB0.route_sel\[10\] net270
+ vssd1 vssd1 vccd1 vccd1 _00986_ sky130_fd_sc_hd__mux2_1
XTAP_TAPCELL_ROW_128_2068 vssd1 vccd1 sky130_fd_sc_hd__tapvpwrvgnd_1
XFILLER_76_642 vssd1 vssd1 vccd1 vccd1 sky130_fd_sc_hd__fill_2
XANTENNA_input29_X net29 vssd1 vssd1 vccd1 vccd1 sky130_fd_sc_hd__diode_2
X_10036_ net417 net419 net317 vssd1 vssd1 vccd1 vccd1 _00917_ sky130_fd_sc_hd__mux2_1
XTAP_TAPCELL_ROW_128_2079 vssd1 vccd1 sky130_fd_sc_hd__tapvpwrvgnd_1
XFILLER_124_91 vssd1 vssd1 vccd1 vccd1 sky130_fd_sc_hd__fill_1
XFILLER_84_62 vccd1 vssd1 vccd1 vssd1 sky130_ef_sc_hd__decap_40_12
XFILLER_48_388 vssd1 vssd1 vccd1 vccd1 sky130_fd_sc_hd__fill_1
XANTENNA__08303__A0 FPGA_INST.bus1_0\[10\] vssd1 vssd1 vccd1 vccd1 sky130_fd_sc_hd__diode_2
X_11987_ net773 _01333_ net559 vssd1 vssd1 vccd1 vccd1 FPGA_INST.cell2.SB0.route_sel\[27\]
+ sky130_fd_sc_hd__dfstp_1
XANTENNA__07106__A1 _01984_ vssd1 vssd1 vccd1 vccd1 sky130_fd_sc_hd__diode_2
XANTENNA__07106__B2 _01937_ vssd1 vssd1 vccd1 vccd1 sky130_fd_sc_hd__diode_2
XFILLER_17_742 vssd1 vssd1 vccd1 vccd1 sky130_fd_sc_hd__fill_2
X_10938_ net850 _00288_ net635 vssd1 vssd1 vccd1 vccd1 FPGA_INST.cell2.CB_0.config_dataA\[19\]
+ sky130_fd_sc_hd__dfstp_1
XFILLER_32_712 vssd1 vssd1 vccd1 vccd1 sky130_fd_sc_hd__fill_4
XFILLER_71_391 vssd1 vssd1 vccd1 vccd1 sky130_fd_sc_hd__fill_1
XFILLER_31_233 vssd1 vssd1 vccd1 vccd1 sky130_fd_sc_hd__fill_1
XFILLER_31_244 vssd1 vssd1 vccd1 vccd1 sky130_fd_sc_hd__fill_1
XANTENNA__08843__B _04781_ vssd1 vssd1 vccd1 vccd1 sky130_fd_sc_hd__diode_2
X_10869_ net799 _00219_ net584 vssd1 vssd1 vccd1 vccd1 FPGA_INST.cell1.SB0.route_sel\[78\]
+ sky130_fd_sc_hd__dfstp_1
XFILLER_31_266 vssd1 vssd1 vccd1 vccd1 sky130_fd_sc_hd__fill_1
XTAP_TAPCELL_ROW_14_475 vssd1 vccd1 sky130_fd_sc_hd__tapvpwrvgnd_1
XANTENNA__08082__A2 _03690_ vssd1 vssd1 vccd1 vccd1 sky130_fd_sc_hd__diode_2
XFILLER_69_3 vssd1 vssd1 vccd1 vccd1 sky130_fd_sc_hd__fill_8
X_06060_ FPGA_INST.cell0.CB_1.config_dataA\[22\] FPGA_INST.cell0.CB_1.config_dataA\[23\]
+ vssd1 vssd1 vccd1 vccd1 _02340_ sky130_fd_sc_hd__or2_2
XTAP_TAPCELL_ROW_74_1322 vssd1 vccd1 sky130_fd_sc_hd__tapvpwrvgnd_1
XFILLER_125_382 vssd1 vssd1 vccd1 vccd1 sky130_fd_sc_hd__fill_1
XANTENNA__09166__S net358 vssd1 vssd1 vccd1 vccd1 sky130_fd_sc_hd__diode_2
XFILLER_125_393 vssd1 vssd1 vccd1 vccd1 sky130_fd_sc_hd__fill_4
Xfanout408 FPGA_INST.cell0.CB_1.config_dataA\[6\] vssd1 vssd1 vccd1 vccd1 net408 sky130_fd_sc_hd__clkbuf_2
Xfanout419 FPGA_INST.cell0.CB_0.config_dataB\[10\] vssd1 vssd1 vccd1 vccd1 net419
+ sky130_fd_sc_hd__buf_2
X_09750_ net460 net459 net232 vssd1 vssd1 vccd1 vccd1 _00659_ sky130_fd_sc_hd__mux2_1
X_06962_ _01750_ _03200_ _03223_ _03229_ vssd1 vssd1 vccd1 vccd1 _03230_ sky130_fd_sc_hd__o31a_1
X_08701_ FPGA_INST.cell3.CB_0.config_dataA\[10\] _04804_ FPGA_INST.cell3.CB_0.config_dataA\[11\]
+ vssd1 vssd1 vccd1 vccd1 _04910_ sky130_fd_sc_hd__o21ai_1
X_09681_ FPGA_INST.cell0.SB0.route_sel\[84\] FPGA_INST.cell0.SB0.route_sel\[85\] net187
+ vssd1 vssd1 vccd1 vccd1 _00590_ sky130_fd_sc_hd__mux2_1
X_05913_ _01782_ _01871_ _02174_ _02176_ _02192_ vssd1 vssd1 vccd1 vccd1 _02193_ sky130_fd_sc_hd__o32a_2
X_08632_ FPGA_INST.cell3.SB0.route_sel\[34\] FPGA_INST.cell3.SB0.route_sel\[35\] vssd1
+ vssd1 vccd1 vccd1 _04841_ sky130_fd_sc_hd__nor2_1
X_06893_ net418 _02070_ vssd1 vssd1 vccd1 vccd1 _03161_ sky130_fd_sc_hd__nand2_1
XFILLER_82_645 vssd1 vssd1 vccd1 vccd1 sky130_fd_sc_hd__fill_2
X_05844_ net126 net10 _02122_ vssd1 vssd1 vccd1 vccd1 _02124_ sky130_fd_sc_hd__mux2_1
X_08563_ FPGA_INST.cell3.LE_1B.config_data\[10\] FPGA_INST.cell3.LE_1B.config_data\[11\]
+ _04755_ vssd1 vssd1 vccd1 vccd1 _04774_ sky130_fd_sc_hd__mux2_1
X_05775_ FPGA_INST.cell2.SB0.route_sel\[86\] _01572_ FPGA_INST.cell2.SB0.route_sel\[82\]
+ FPGA_INST.cell2.SB0.route_sel\[83\] _02054_ vssd1 vssd1 vccd1 vccd1 _02055_ sky130_fd_sc_hd__o221a_1
X_08494_ _04709_ _04708_ _04688_ vssd1 vssd1 vccd1 vccd1 _04710_ sky130_fd_sc_hd__mux2_1
XTAP_TAPCELL_ROW_85_1473 vssd1 vccd1 sky130_fd_sc_hd__tapvpwrvgnd_1
X_07514_ _03399_ _03748_ _03769_ vssd1 vssd1 vccd1 vccd1 _03770_ sky130_fd_sc_hd__o21ai_1
X_07445_ _03669_ _03696_ _03702_ vssd1 vssd1 vccd1 vccd1 _03703_ sky130_fd_sc_hd__a21oi_2
XFILLER_35_594 vccd1 vssd1 vccd1 vssd1 sky130_ef_sc_hd__decap_40_12
XANTENNA_fanout330_A net332 vssd1 vssd1 vccd1 vccd1 sky130_fd_sc_hd__diode_2
XTAP_TAPCELL_ROW_33_740 vssd1 vccd1 sky130_fd_sc_hd__tapvpwrvgnd_1
XTAP_TAPCELL_ROW_33_751 vssd1 vccd1 sky130_fd_sc_hd__tapvpwrvgnd_1
X_07376_ FPGA_INST.cell1.SB0.route_sel\[43\] FPGA_INST.cell1.SB0.route_sel\[42\] vssd1
+ vssd1 vccd1 vccd1 _03635_ sky130_fd_sc_hd__nand2_1
XANTENNA__06608__A0 _02784_ vssd1 vssd1 vccd1 vccd1 sky130_fd_sc_hd__diode_2
XANTENNA__08073__A2 _03519_ vssd1 vssd1 vccd1 vccd1 sky130_fd_sc_hd__diode_2
X_06327_ FPGA_INST.cell2.LE_0A.config_data\[3\] FPGA_INST.cell2.LE_0A.config_data\[2\]
+ _02536_ vssd1 vssd1 vccd1 vccd1 _02607_ sky130_fd_sc_hd__mux2_1
X_09115_ FPGA_INST.cell2.LEI0.config_data\[29\] FPGA_INST.cell2.LEI0.config_data\[30\]
+ net256 vssd1 vssd1 vccd1 vccd1 _00031_ sky130_fd_sc_hd__mux2_1
X_09046_ net622 FPGA_INST.cell1.LE_1B.reset_mode vssd1 vssd1 vccd1 vccd1 _09046_/X
+ sky130_fd_sc_hd__xor2_2
X_06258_ net504 _02092_ vssd1 vssd1 vccd1 vccd1 _02538_ sky130_fd_sc_hd__nand2_1
XANTENNA_fanout797_A net803 vssd1 vssd1 vccd1 vccd1 sky130_fd_sc_hd__diode_2
XFILLER_116_382 vssd1 vssd1 vccd1 vccd1 sky130_fd_sc_hd__fill_1
XFILLER_8_7 vssd1 vssd1 vccd1 vccd1 sky130_fd_sc_hd__fill_1
XANTENNA__06560__Y _02836_ vssd1 vssd1 vccd1 vccd1 sky130_fd_sc_hd__diode_2
X_06189_ FPGA_INST.cell2.SB0.route_sel\[4\] FPGA_INST.cell2.SB0.route_sel\[5\] _02468_
+ vssd1 vssd1 vccd1 vccd1 _02469_ sky130_fd_sc_hd__a21oi_1
XFILLER_89_244 vssd1 vssd1 vccd1 vccd1 sky130_fd_sc_hd__fill_2
Xfanout942 net945 vssd1 vssd1 vccd1 vccd1 net942 sky130_fd_sc_hd__buf_1
Xfanout931 net947 vssd1 vssd1 vccd1 vccd1 net931 sky130_fd_sc_hd__clkbuf_2
Xfanout920 net922 vssd1 vssd1 vccd1 vccd1 net920 sky130_fd_sc_hd__buf_2
X_09948_ FPGA_INST.cell0.CB_1.config_dataB\[8\] FPGA_INST.cell0.CB_1.config_dataB\[9\]
+ net184 vssd1 vssd1 vccd1 vccd1 _00853_ sky130_fd_sc_hd__mux2_1
XANTENNA__08128__A3 FPGA_INST.bus3_1\[15\] vssd1 vssd1 vccd1 vccd1 sky130_fd_sc_hd__diode_2
X_09879_ FPGA_INST.cell0.LE_0A.config_data\[7\] FPGA_INST.cell0.LE_0A.config_data\[6\]
+ net318 vssd1 vssd1 vccd1 vccd1 _00786_ sky130_fd_sc_hd__mux2_1
X_11910_ net940 _01256_ net724 vssd1 vssd1 vccd1 vccd1 FPGA_INST.cell3.LE_0B.reset_val
+ sky130_fd_sc_hd__dfrtp_1
XFILLER_57_163 vssd1 vssd1 vccd1 vccd1 sky130_fd_sc_hd__fill_4
XFILLER_18_528 vssd1 vssd1 vccd1 vccd1 sky130_fd_sc_hd__fill_4
X_11841_ net932 _01187_ net716 vssd1 vssd1 vccd1 vccd1 FPGA_INST.cell3.LEI0.config_data\[21\]
+ sky130_fd_sc_hd__dfrtp_1
X_11772_ net928 _01118_ net712 vssd1 vssd1 vccd1 vccd1 FPGA_INST.io_west_oeb\[28\]
+ sky130_fd_sc_hd__dfrtp_1
XFILLER_14_701 vssd1 vssd1 vccd1 vccd1 sky130_fd_sc_hd__fill_4
XANTENNA__06448__B _02376_ vssd1 vssd1 vccd1 vccd1 sky130_fd_sc_hd__diode_2
XFILLER_72_199 vssd1 vssd1 vccd1 vccd1 sky130_fd_sc_hd__fill_1
XFILLER_13_222 vssd1 vssd1 vccd1 vccd1 sky130_fd_sc_hd__fill_2
X_10723_ net875 _00073_ net659 vssd1 vssd1 vccd1 vccd1 FPGA_INST.cell2.LE_0B.config_data\[0\]
+ sky130_fd_sc_hd__dfrtp_1
XFILLER_9_204 vssd1 vssd1 vccd1 vccd1 sky130_fd_sc_hd__fill_1
XFILLER_13_266 vssd1 vssd1 vccd1 vccd1 sky130_fd_sc_hd__fill_4
XANTENNA__06311__A2 _02413_ vssd1 vssd1 vccd1 vccd1 sky130_fd_sc_hd__diode_2
XFILLER_110_82 vssd1 vssd1 vccd1 vccd1 sky130_fd_sc_hd__fill_2
XFILLER_41_597 vssd1 vssd1 vccd1 vccd1 sky130_fd_sc_hd__fill_4
X_10654_ net883 _00004_ net667 vssd1 vssd1 vccd1 vccd1 FPGA_INST.cell2.LEI0.config_data\[3\]
+ sky130_fd_sc_hd__dfrtp_1
X_10585_ FPGA_INST.cell3.CB_0.config_dataB\[4\] net390 net300 vssd1 vssd1 vccd1 vccd1
+ _01464_ sky130_fd_sc_hd__mux2_1
XANTENNA__09261__A1 FPGA_INST.cell1.SB0.route_sel\[33\] vssd1 vssd1 vccd1 vccd1 sky130_fd_sc_hd__diode_2
XTAP_TAPCELL_ROW_11_434 vssd1 vccd1 sky130_fd_sc_hd__tapvpwrvgnd_1
XFILLER_5_498 vssd1 vssd1 vccd1 vccd1 sky130_fd_sc_hd__fill_4
XANTENNA__06911__B _02191_ vssd1 vssd1 vccd1 vccd1 sky130_fd_sc_hd__diode_2
XTAP_TAPCELL_ROW_56_1063 vssd1 vccd1 sky130_fd_sc_hd__tapvpwrvgnd_1
X_11206_ net764 _00556_ net549 vssd1 vssd1 vccd1 vccd1 FPGA_INST.cell0.SB0.route_sel\[51\]
+ sky130_fd_sc_hd__dfstp_1
X_11137_ net817 _00487_ net602 vssd1 vssd1 vccd1 vccd1 FPGA_INST.cell1.CB_1.config_dataB\[7\]
+ sky130_fd_sc_hd__dfstp_1
XANTENNA__08772__A0 net22 vssd1 vssd1 vccd1 vccd1 sky130_fd_sc_hd__diode_2
XANTENNA__07575__A1 _03526_ vssd1 vssd1 vccd1 vccd1 sky130_fd_sc_hd__diode_2
XFILLER_1_671 vssd1 vssd1 vccd1 vccd1 sky130_fd_sc_hd__fill_1
X_11068_ net836 _00418_ net620 vssd1 vssd1 vccd1 vccd1 FPGA_INST.cell1.LE_0A.config_data\[3\]
+ sky130_fd_sc_hd__dfrtp_1
XFILLER_110_569 vssd1 vssd1 vccd1 vccd1 sky130_fd_sc_hd__fill_8
XFILLER_76_450 vssd1 vssd1 vccd1 vccd1 sky130_fd_sc_hd__fill_1
XFILLER_49_664 vssd1 vssd1 vccd1 vccd1 sky130_fd_sc_hd__fill_1
XFILLER_76_483 vssd1 vssd1 vccd1 vccd1 sky130_fd_sc_hd__fill_2
X_10019_ FPGA_INST.cell0.CB_0.config_dataA\[18\] FPGA_INST.cell0.CB_0.config_dataA\[19\]
+ net190 vssd1 vssd1 vccd1 vccd1 _00900_ sky130_fd_sc_hd__mux2_1
XFILLER_36_336 vssd1 vssd1 vccd1 vccd1 sky130_fd_sc_hd__fill_2
XFILLER_91_431 vssd1 vssd1 vccd1 vccd1 sky130_fd_sc_hd__fill_1
XANTENNA__05543__A net383 vssd1 vssd1 vccd1 vccd1 sky130_fd_sc_hd__diode_2
XTAP_TAPCELL_ROW_19_545 vssd1 vccd1 sky130_fd_sc_hd__tapvpwrvgnd_1
XFILLER_36_347 vssd1 vssd1 vccd1 vccd1 sky130_fd_sc_hd__fill_4
X_05560_ net385 _01819_ _01835_ _01838_ vssd1 vssd1 vccd1 vccd1 _01840_ sky130_fd_sc_hd__a2bb2o_1
XANTENNA__10595__S net300 vssd1 vssd1 vccd1 vccd1 sky130_fd_sc_hd__diode_2
X_05491_ FPGA_INST.cell3.CB_0.config_dataB\[2\] vssd1 vssd1 vccd1 vccd1 _01773_ sky130_fd_sc_hd__inv_2
XANTENNA__06302__A2 net16 vssd1 vssd1 vccd1 vccd1 sky130_fd_sc_hd__diode_2
XANTENNA__09021__Y FPGA_INST.bus3_1\[2\] vssd1 vssd1 vccd1 vccd1 sky130_fd_sc_hd__diode_2
X_07230_ FPGA_INST.cell3.SB0.route_sel\[8\] FPGA_INST.cell3.SB0.route_sel\[9\] vssd1
+ vssd1 vccd1 vccd1 _03493_ sky130_fd_sc_hd__or2_1
XFILLER_20_748 vssd1 vssd1 vccd1 vccd1 sky130_fd_sc_hd__fill_4
X_07161_ _02471_ _02784_ _02474_ _02472_ vssd1 vssd1 vccd1 vccd1 _03425_ sky130_fd_sc_hd__o211a_1
XANTENNA__10708__RESET_B net636 vssd1 vssd1 vccd1 vccd1 sky130_fd_sc_hd__diode_2
X_06112_ _02388_ _02391_ vssd1 vssd1 vccd1 vccd1 _02392_ sky130_fd_sc_hd__and2_2
X_07092_ _03351_ _03354_ _03356_ _03357_ vssd1 vssd1 vccd1 vccd1 _03358_ sky130_fd_sc_hd__o22a_1
X_06043_ _02001_ _02209_ vssd1 vssd1 vccd1 vccd1 _02323_ sky130_fd_sc_hd__nor2_1
Xfanout205 net206 vssd1 vssd1 vccd1 vccd1 net205 sky130_fd_sc_hd__clkbuf_2
X_09802_ FPGA_INST.cell1.LE_1B.config_data\[3\] FPGA_INST.cell1.LE_1B.config_data\[2\]
+ net335 vssd1 vssd1 vccd1 vccd1 _00711_ sky130_fd_sc_hd__mux2_1
XFILLER_115_27 vccd1 vssd1 vccd1 vssd1 sky130_ef_sc_hd__decap_40_12
Xfanout216 net219 vssd1 vssd1 vccd1 vccd1 net216 sky130_fd_sc_hd__clkbuf_2
Xfanout227 net233 vssd1 vssd1 vccd1 vccd1 net227 sky130_fd_sc_hd__clkbuf_2
XANTENNA__06369__A2 net11 vssd1 vssd1 vccd1 vccd1 sky130_fd_sc_hd__diode_2
Xfanout238 net239 vssd1 vssd1 vccd1 vccd1 net238 sky130_fd_sc_hd__clkbuf_4
X_07994_ FPGA_INST.cell1.LE_0A.config_data\[13\] FPGA_INST.cell1.LE_0A.config_data\[12\]
+ _04148_ vssd1 vssd1 vccd1 vccd1 _04222_ sky130_fd_sc_hd__mux2_1
XFILLER_87_748 vssd1 vssd1 vccd1 vccd1 sky130_fd_sc_hd__fill_1
Xfanout249 net268 vssd1 vssd1 vccd1 vccd1 net249 sky130_fd_sc_hd__clkbuf_4
XANTENNA_fanout280_A net285 vssd1 vssd1 vccd1 vccd1 sky130_fd_sc_hd__diode_2
X_09733_ FPGA_INST.cell1.CB_0.config_dataA\[8\] FPGA_INST.cell1.CB_0.config_dataA\[9\]
+ net229 vssd1 vssd1 vccd1 vccd1 _00642_ sky130_fd_sc_hd__mux2_1
XTAP_TAPCELL_ROW_87_1502 vssd1 vccd1 sky130_fd_sc_hd__tapvpwrvgnd_1
X_06945_ _02270_ _03198_ _03199_ _02309_ _01749_ vssd1 vssd1 vccd1 vccd1 _03213_ sky130_fd_sc_hd__a221oi_1
XANTENNA_fanout378_A net379 vssd1 vssd1 vccd1 vccd1 sky130_fd_sc_hd__diode_2
XFILLER_95_781 vssd1 vssd1 vccd1 vccd1 sky130_fd_sc_hd__fill_2
X_09664_ FPGA_INST.cell0.SB0.route_sel\[68\] FPGA_INST.cell0.SB0.route_sel\[67\] net313
+ vssd1 vssd1 vccd1 vccd1 _00573_ sky130_fd_sc_hd__mux2_1
X_06876_ net425 _02392_ _03143_ FPGA_INST.cell0.CB_0.config_dataB\[1\] vssd1 vssd1
+ vccd1 vccd1 _03144_ sky130_fd_sc_hd__o211a_1
XTAP_TAPCELL_ROW_38_810 vssd1 vccd1 sky130_fd_sc_hd__tapvpwrvgnd_1
XTAP_TAPCELL_ROW_38_821 vssd1 vccd1 sky130_fd_sc_hd__tapvpwrvgnd_1
X_09595_ FPGA_INST.cell1.CB_1.config_dataB\[24\] FPGA_INST.cell1.CB_1.config_dataB\[23\]
+ net336 vssd1 vssd1 vccd1 vccd1 _00504_ sky130_fd_sc_hd__mux2_1
X_08615_ _01764_ _03583_ _04821_ vssd1 vssd1 vccd1 vccd1 _04824_ sky130_fd_sc_hd__or3_1
X_05827_ FPGA_INST.cell0.SB0.route_sel\[77\] FPGA_INST.cell0.SB0.route_sel\[76\] vssd1
+ vssd1 vccd1 vccd1 _02107_ sky130_fd_sc_hd__nand2b_1
XFILLER_82_486 vssd1 vssd1 vccd1 vccd1 sky130_fd_sc_hd__fill_1
XFILLER_42_306 vssd1 vssd1 vccd1 vccd1 sky130_fd_sc_hd__fill_2
X_08546_ net90 net84 net82 _01792_ FPGA_INST.cell3.LEI0.config_data\[33\] FPGA_INST.cell3.LEI0.config_data\[34\]
+ vssd1 vssd1 vccd1 vccd1 _04757_ sky130_fd_sc_hd__mux4_1
X_05758_ _01845_ _02037_ vssd1 vssd1 vccd1 vccd1 _02038_ sky130_fd_sc_hd__nor2_1
XFILLER_23_520 vccd1 vssd1 vccd1 vssd1 sky130_ef_sc_hd__decap_40_12
X_08477_ FPGA_INST.cell1.LE_1B.config_data\[4\] FPGA_INST.cell1.LE_1B.config_data\[5\]
+ _04692_ vssd1 vssd1 vccd1 vccd1 _04693_ sky130_fd_sc_hd__mux2_1
XANTENNA_fanout333_X net333 vssd1 vssd1 vccd1 vccd1 sky130_fd_sc_hd__diode_2
XANTENNA__10625__A1 FPGA_INST.cell3.CB_1.config_dataA\[19\] vssd1 vssd1 vccd1 vccd1
+ sky130_fd_sc_hd__diode_2
XANTENNA__08294__A2 _03997_ vssd1 vssd1 vccd1 vccd1 sky130_fd_sc_hd__diode_2
XFILLER_50_361 vssd1 vssd1 vccd1 vccd1 sky130_fd_sc_hd__fill_2
XFILLER_23_553 vssd1 vssd1 vccd1 vccd1 sky130_fd_sc_hd__fill_1
X_05689_ net117 _01816_ _01967_ vssd1 vssd1 vccd1 vccd1 _01969_ sky130_fd_sc_hd__and3_1
X_07428_ net148 _03507_ _03607_ _03678_ _03685_ vssd1 vssd1 vccd1 vccd1 _03686_ sky130_fd_sc_hd__o311a_1
X_07359_ FPGA_INST.cell3.SB0.route_sel\[34\] FPGA_INST.cell3.SB0.route_sel\[35\] _03615_
+ _03618_ _03590_ vssd1 vssd1 vccd1 vccd1 _03619_ sky130_fd_sc_hd__a41o_1
XFILLER_109_647 vssd1 vssd1 vccd1 vccd1 sky130_fd_sc_hd__fill_4
XTAP_TAPCELL_ROW_98_1653 vssd1 vccd1 sky130_fd_sc_hd__tapvpwrvgnd_1
X_10370_ FPGA_INST.cell3.LE_0B.config_data\[11\] FPGA_INST.cell3.LE_0B.config_data\[12\]
+ net301 vssd1 vssd1 vccd1 vccd1 _01250_ sky130_fd_sc_hd__mux2_1
X_09029_ FPGA_INST.cell3.SB0.route_sel\[8\] _01710_ _01711_ FPGA_INST.cell3.SB0.route_sel\[11\]
+ _05192_ vssd1 vssd1 vccd1 vccd1 _05193_ sky130_fd_sc_hd__a221o_1
XFILLER_2_402 vccd1 vssd1 vccd1 vssd1 sky130_ef_sc_hd__decap_40_12
XANTENNA__07006__A0 FPGA_INST.bus2_0\[12\] vssd1 vssd1 vccd1 vccd1 sky130_fd_sc_hd__diode_2
X_12040_ net878 _01386_ net663 vssd1 vssd1 vccd1 vccd1 FPGA_INST.cell2.SB0.route_sel\[80\]
+ sky130_fd_sc_hd__dfstp_1
XANTENNA_fanout79_X net79 vssd1 vssd1 vccd1 vccd1 sky130_fd_sc_hd__diode_2
XFILLER_49_98 vssd1 vssd1 vccd1 vccd1 sky130_fd_sc_hd__fill_1
XFILLER_49_65 vssd1 vssd1 vccd1 vccd1 sky130_fd_sc_hd__fill_1
Xfanout750 net753 vssd1 vssd1 vccd1 vccd1 net750 sky130_fd_sc_hd__buf_2
XANTENNA__08506__A0 net89 vssd1 vssd1 vccd1 vccd1 sky130_fd_sc_hd__diode_2
Xfanout794 net796 vssd1 vssd1 vccd1 vccd1 net794 sky130_fd_sc_hd__buf_1
XFILLER_77_269 vssd1 vssd1 vccd1 vccd1 sky130_fd_sc_hd__fill_8
Xfanout783 net784 vssd1 vssd1 vccd1 vccd1 net783 sky130_fd_sc_hd__clkbuf_2
Xfanout761 net762 vssd1 vssd1 vccd1 vccd1 net761 sky130_fd_sc_hd__clkbuf_2
Xfanout772 net778 vssd1 vssd1 vccd1 vccd1 net772 sky130_fd_sc_hd__buf_2
XTAP_TAPCELL_ROW_125_2038 vssd1 vccd1 sky130_fd_sc_hd__tapvpwrvgnd_1
XTAP_TAPCELL_ROW_125_2027 vssd1 vccd1 sky130_fd_sc_hd__tapvpwrvgnd_1
XFILLER_92_217 vssd1 vssd1 vccd1 vccd1 sky130_fd_sc_hd__fill_8
XFILLER_58_483 vssd1 vssd1 vccd1 vccd1 sky130_fd_sc_hd__fill_4
XFILLER_100_591 vssd1 vssd1 vccd1 vccd1 sky130_fd_sc_hd__fill_2
XFILLER_73_442 vssd1 vssd1 vccd1 vccd1 sky130_fd_sc_hd__fill_4
XTAP_TAPCELL_ROW_16_504 vssd1 vccd1 sky130_fd_sc_hd__tapvpwrvgnd_1
X_11824_ net935 _01170_ net719 vssd1 vssd1 vccd1 vccd1 FPGA_INST.cell3.LEI0.config_data\[4\]
+ sky130_fd_sc_hd__dfrtp_1
XTAP_TAPCELL_ROW_107_1782 vssd1 vccd1 sky130_fd_sc_hd__tapvpwrvgnd_1
XFILLER_81_52 vssd1 vssd1 vccd1 vccd1 sky130_fd_sc_hd__fill_4
X_11755_ net900 _01101_ net684 vssd1 vssd1 vccd1 vccd1 FPGA_INST.cell3.SB0.route_sel\[125\]
+ sky130_fd_sc_hd__dfstp_1
XTAP_TAPCELL_ROW_120_1960 vssd1 vccd1 sky130_fd_sc_hd__tapvpwrvgnd_1
XANTENNA__08961__X FPGA_INST.bus1_0\[8\] vssd1 vssd1 vccd1 vccd1 sky130_fd_sc_hd__diode_2
XFILLER_41_383 vssd1 vssd1 vccd1 vccd1 sky130_fd_sc_hd__fill_1
X_10706_ net846 _00056_ net631 vssd1 vssd1 vccd1 vccd1 FPGA_INST.cell2.LE_0A.config_data\[5\]
+ sky130_fd_sc_hd__dfrtp_1
X_11686_ net897 _01032_ net681 vssd1 vssd1 vccd1 vccd1 FPGA_INST.cell3.SB0.route_sel\[56\]
+ sky130_fd_sc_hd__dfstp_1
X_10637_ FPGA_INST.cell3.LE_1B.config_data\[7\] FPGA_INST.cell3.LE_1B.config_data\[6\]
+ net372 vssd1 vssd1 vccd1 vccd1 _01516_ sky130_fd_sc_hd__mux2_1
XPHY_EDGE_ROW_116_Right_116 vssd1 vssd1 vccd1 vccd1 sky130_fd_sc_hd__decap_3
X_10568_ FPGA_INST.cell3.CB_0.config_dataA\[13\] FPGA_INST.cell3.CB_0.config_dataA\[12\]
+ net379 vssd1 vssd1 vccd1 vccd1 _01447_ sky130_fd_sc_hd__mux2_1
XANTENNA__07796__A1 net148 vssd1 vssd1 vccd1 vccd1 sky130_fd_sc_hd__diode_2
X_10499_ FPGA_INST.cell2.SB0.route_sel\[71\] FPGA_INST.cell2.SB0.route_sel\[72\] net248
+ vssd1 vssd1 vccd1 vccd1 _01378_ sky130_fd_sc_hd__mux2_1
XANTENNA__05538__A FPGA_INST.cell0.CB_0.config_dataB\[24\] vssd1 vssd1 vccd1 vccd1
+ sky130_fd_sc_hd__diode_2
XANTENNA__07548__A1 FPGA_INST.bus3_1\[9\] vssd1 vssd1 vccd1 vccd1 sky130_fd_sc_hd__diode_2
XANTENNA__11495__SET_B net577 vssd1 vssd1 vccd1 vccd1 sky130_fd_sc_hd__diode_2
XFILLER_69_715 vssd1 vssd1 vccd1 vccd1 sky130_fd_sc_hd__fill_2
X_12169_ net910 _01515_ net694 vssd1 vssd1 vccd1 vccd1 FPGA_INST.cell3.LE_1B.config_data\[6\]
+ sky130_fd_sc_hd__dfrtp_1
X_06730_ FPGA_INST.cell2.CB_1.config_dataB\[7\] _03002_ _03003_ _02998_ vssd1 vssd1
+ vccd1 vccd1 _03004_ sky130_fd_sc_hd__o2bb2a_1
Xinput5 gpio_in[13] vssd1 vssd1 vccd1 vccd1 net5 sky130_fd_sc_hd__clkbuf_4
XANTENNA__10887__Q FPGA_INST.cell1.SB0.route_sel\[96\] vssd1 vssd1 vccd1 vccd1 sky130_fd_sc_hd__diode_2
XTAP_TAPCELL_ROW_69_1254 vssd1 vccd1 sky130_fd_sc_hd__tapvpwrvgnd_1
XTAP_TAPCELL_ROW_69_1243 vssd1 vccd1 sky130_fd_sc_hd__tapvpwrvgnd_1
X_06661_ _02804_ _02916_ _02918_ _02801_ vssd1 vssd1 vccd1 vccd1 _02937_ sky130_fd_sc_hd__a22oi_1
X_08400_ _03465_ _04608_ _04609_ _03408_ FPGA_INST.cell0.CB_1.config_dataB\[17\] vssd1
+ vssd1 vccd1 vccd1 _04622_ sky130_fd_sc_hd__a221o_1
X_05612_ FPGA_INST.cell2.SB0.route_sel\[120\] FPGA_INST.cell2.SB0.route_sel\[121\]
+ vssd1 vssd1 vccd1 vccd1 _01892_ sky130_fd_sc_hd__nand2_1
XANTENNA__12015__SET_B net563 vssd1 vssd1 vccd1 vccd1 sky130_fd_sc_hd__diode_2
XTAP_TAPCELL_ROW_82_1432 vssd1 vccd1 sky130_fd_sc_hd__tapvpwrvgnd_1
X_06592_ _02866_ _02867_ FPGA_INST.cell2.CB_1.config_dataA\[2\] vssd1 vssd1 vccd1
+ vccd1 _02868_ sky130_fd_sc_hd__mux2_1
XANTENNA__05731__B1 _02010_ vssd1 vssd1 vccd1 vccd1 sky130_fd_sc_hd__diode_2
XFILLER_17_391 vssd1 vssd1 vccd1 vccd1 sky130_fd_sc_hd__fill_1
X_09380_ FPGA_INST.cell2.CB_0.config_dataA\[24\] FPGA_INST.cell2.CB_0.config_dataA\[23\]
+ net351 vssd1 vssd1 vccd1 vccd1 _00293_ sky130_fd_sc_hd__mux2_1
X_08331_ net448 _03875_ vssd1 vssd1 vccd1 vccd1 _04553_ sky130_fd_sc_hd__nand2_1
XFILLER_51_169 vssd1 vssd1 vccd1 vccd1 sky130_fd_sc_hd__fill_8
X_05543_ net383 _01822_ vssd1 vssd1 vccd1 vccd1 _01823_ sky130_fd_sc_hd__nor2_1
X_08262_ net403 _03504_ _04485_ net402 vssd1 vssd1 vccd1 vccd1 _04486_ sky130_fd_sc_hd__o211a_1
X_05474_ FPGA_INST.cell0.LE_1A.config_data\[16\] vssd1 vssd1 vccd1 vccd1 _01756_ sky130_fd_sc_hd__inv_2
XFILLER_32_361 vssd1 vssd1 vccd1 vccd1 sky130_fd_sc_hd__fill_2
X_07213_ _03475_ _03455_ vssd1 vssd1 vccd1 vccd1 _03476_ sky130_fd_sc_hd__nand2b_1
XTAP_TAPCELL_ROW_43_890 vssd1 vccd1 sky130_fd_sc_hd__tapvpwrvgnd_1
XFILLER_118_433 vssd1 vssd1 vccd1 vccd1 sky130_fd_sc_hd__fill_2
XANTENNA__08028__A2 _04013_ vssd1 vssd1 vccd1 vccd1 sky130_fd_sc_hd__diode_2
X_08193_ _03465_ _04413_ _04414_ _03408_ FPGA_INST.cell0.CB_1.config_dataA\[7\] vssd1
+ vssd1 vccd1 vccd1 _04417_ sky130_fd_sc_hd__a221o_1
XANTENNA_fanout126_A FPGA_INST.cell2.CB_0.le_outB vssd1 vssd1 vccd1 vccd1 sky130_fd_sc_hd__diode_2
XFILLER_118_444 vssd1 vssd1 vccd1 vccd1 sky130_fd_sc_hd__fill_1
X_07144_ _03405_ _03406_ _03407_ _02462_ vssd1 vssd1 vccd1 vccd1 _03408_ sky130_fd_sc_hd__a31o_4
XANTENNA__09619__S net201 vssd1 vssd1 vccd1 vccd1 sky130_fd_sc_hd__diode_2
XFILLER_10_15 vssd1 vssd1 vccd1 vccd1 sky130_fd_sc_hd__fill_1
X_07075_ FPGA_INST.bus2_0\[12\] FPGA_INST.bus2_0\[14\] FPGA_INST.bus2_0\[13\] FPGA_INST.bus2_0\[15\]
+ net429 net430 vssd1 vssd1 vccd1 vccd1 _03341_ sky130_fd_sc_hd__mux4_1
XFILLER_126_26 vssd1 vssd1 vccd1 vccd1 sky130_fd_sc_hd__fill_2
X_06026_ _02297_ _02303_ _02305_ net313 vssd1 vssd1 vccd1 vccd1 _02306_ sky130_fd_sc_hd__a211o_2
XTAP_TAPCELL_ROW_93_1583 vssd1 vccd1 sky130_fd_sc_hd__tapvpwrvgnd_1
XFILLER_113_160 vssd1 vssd1 vccd1 vccd1 sky130_fd_sc_hd__fill_2
X_07977_ FPGA_INST.bus3_1\[8\] FPGA_INST.bus3_1\[9\] FPGA_INST.bus3_1\[10\] FPGA_INST.bus3_1\[11\]
+ net463 net462 vssd1 vssd1 vccd1 vccd1 _04205_ sky130_fd_sc_hd__mux4_1
XFILLER_59_247 vssd1 vssd1 vccd1 vccd1 sky130_fd_sc_hd__fill_4
XANTENNA_fanout662_A net676 vssd1 vssd1 vccd1 vccd1 sky130_fd_sc_hd__diode_2
XFILLER_74_228 vssd1 vssd1 vccd1 vccd1 sky130_fd_sc_hd__fill_1
X_09716_ FPGA_INST.cell0.SB0.route_sel\[120\] FPGA_INST.cell0.SB0.route_sel\[119\]
+ net324 vssd1 vssd1 vccd1 vccd1 _00625_ sky130_fd_sc_hd__mux2_1
X_06928_ FPGA_INST.cell0.LE_0B.config_data\[7\] FPGA_INST.cell0.LE_0B.config_data\[6\]
+ _03159_ vssd1 vssd1 vccd1 vccd1 _03196_ sky130_fd_sc_hd__mux2_1
XFILLER_19_57 vssd1 vssd1 vccd1 vccd1 sky130_fd_sc_hd__fill_2
X_06859_ FPGA_INST.cell0.CB_0.config_dataB\[1\] net425 vssd1 vssd1 vccd1 vccd1 _03127_
+ sky130_fd_sc_hd__nor2_1
X_09647_ FPGA_INST.cell0.SB0.route_sel\[51\] FPGA_INST.cell0.SB0.route_sel\[50\] net313
+ vssd1 vssd1 vccd1 vccd1 _00556_ sky130_fd_sc_hd__mux2_1
X_09578_ FPGA_INST.cell1.CB_1.config_dataB\[7\] FPGA_INST.cell1.CB_1.config_dataB\[6\]
+ net335 vssd1 vssd1 vccd1 vccd1 _00487_ sky130_fd_sc_hd__mux2_1
XFILLER_27_199 vssd1 vssd1 vccd1 vccd1 sky130_fd_sc_hd__fill_2
X_08529_ _04740_ _04741_ _04721_ vssd1 vssd1 vccd1 vccd1 _04742_ sky130_fd_sc_hd__mux2_1
XFILLER_30_309 vssd1 vssd1 vccd1 vccd1 sky130_fd_sc_hd__fill_1
XANTENNA__06278__A1 net4 vssd1 vssd1 vccd1 vccd1 sky130_fd_sc_hd__diode_2
X_11540_ net774 _00890_ net560 vssd1 vssd1 vccd1 vccd1 FPGA_INST.cell0.CB_0.config_dataA\[9\]
+ sky130_fd_sc_hd__dfstp_1
XFILLER_23_372 vssd1 vssd1 vccd1 vccd1 sky130_fd_sc_hd__fill_4
XFILLER_51_55 vssd1 vssd1 vccd1 vccd1 sky130_fd_sc_hd__fill_1
XTAP_TAPCELL_ROW_21_573 vssd1 vccd1 sky130_fd_sc_hd__tapvpwrvgnd_1
X_11471_ FPGA_INST.cell0.LE_1A.sel_clk _00821_ net732 vssd1 vssd1 vccd1 vccd1 FPGA_INST.cell0.LE_1A.dff0_out
+ sky130_fd_sc_hd__dfrtp_1
X_10422_ FPGA_INST.cell3.CB_1.config_dataB\[19\] FPGA_INST.cell3.CB_1.config_dataB\[20\]
+ net279 vssd1 vssd1 vccd1 vccd1 _01301_ sky130_fd_sc_hd__mux2_1
XFILLER_109_444 vssd1 vssd1 vccd1 vccd1 sky130_fd_sc_hd__fill_2
X_10353_ FPGA_INST.cell3.LE_0A.reset_val FPGA_INST.cell3.LE_0A.edge_mode net374 vssd1
+ vssd1 vccd1 vccd1 _01234_ sky130_fd_sc_hd__mux2_1
X_10284_ FPGA_INST.cell3.LE_0A.dff1_out _04971_ net737 vssd1 vssd1 vccd1 vccd1 _01165_
+ sky130_fd_sc_hd__mux2_1
XTAP_TAPCELL_ROW_53_1022 vssd1 vccd1 sky130_fd_sc_hd__tapvpwrvgnd_1
XFILLER_3_777 vssd1 vssd1 vccd1 vccd1 sky130_fd_sc_hd__fill_4
X_12023_ net847 _01369_ net632 vssd1 vssd1 vccd1 vccd1 FPGA_INST.cell2.SB0.route_sel\[63\]
+ sky130_fd_sc_hd__dfstp_1
XANTENNA__11568__SET_B net558 vssd1 vssd1 vccd1 vccd1 sky130_fd_sc_hd__diode_2
XTAP_TAPCELL_ROW_109_1811 vssd1 vccd1 sky130_fd_sc_hd__tapvpwrvgnd_1
XANTENNA__07950__A1 net145 vssd1 vssd1 vccd1 vccd1 sky130_fd_sc_hd__diode_2
Xfanout591 net596 vssd1 vssd1 vccd1 vccd1 net591 sky130_fd_sc_hd__clkbuf_4
Xfanout580 net581 vssd1 vssd1 vccd1 vccd1 net580 sky130_fd_sc_hd__clkbuf_4
XANTENNA__06753__A2 _02836_ vssd1 vssd1 vccd1 vccd1 sky130_fd_sc_hd__diode_2
XFILLER_93_548 vssd1 vssd1 vccd1 vccd1 sky130_fd_sc_hd__fill_2
XANTENNA__05961__B1 _02240_ vssd1 vssd1 vccd1 vccd1 sky130_fd_sc_hd__diode_2
XANTENNA_input11_X net11 vssd1 vssd1 vccd1 vccd1 sky130_fd_sc_hd__diode_2
XFILLER_61_434 vssd1 vssd1 vccd1 vccd1 sky130_fd_sc_hd__fill_2
XTAP_TAPCELL_ROW_29_684 vssd1 vccd1 sky130_fd_sc_hd__tapvpwrvgnd_1
XTAP_TAPCELL_ROW_29_695 vssd1 vccd1 sky130_fd_sc_hd__tapvpwrvgnd_1
XFILLER_34_659 vssd1 vssd1 vccd1 vccd1 sky130_fd_sc_hd__fill_2
X_11807_ net869 _01153_ net654 vssd1 vssd1 vccd1 vccd1 net32 sky130_fd_sc_hd__dfrtp_1
XTAP_TAPCELL_ROW_64_1184 vssd1 vccd1 sky130_fd_sc_hd__tapvpwrvgnd_1
XTAP_TAPCELL_ROW_64_1173 vssd1 vccd1 sky130_fd_sc_hd__tapvpwrvgnd_1
X_11738_ net897 _01084_ net681 vssd1 vssd1 vccd1 vccd1 FPGA_INST.cell3.SB0.route_sel\[108\]
+ sky130_fd_sc_hd__dfstp_1
XFILLER_41_191 vssd1 vssd1 vccd1 vccd1 sky130_fd_sc_hd__fill_8
X_11669_ net907 _01015_ net691 vssd1 vssd1 vccd1 vccd1 FPGA_INST.cell3.SB0.route_sel\[39\]
+ sky130_fd_sc_hd__dfstp_1
XFILLER_127_241 vssd1 vssd1 vccd1 vccd1 sky130_fd_sc_hd__fill_8
XANTENNA__06977__C1 net155 vssd1 vssd1 vccd1 vccd1 sky130_fd_sc_hd__diode_2
XFILLER_88_309 vssd1 vssd1 vccd1 vccd1 sky130_fd_sc_hd__fill_2
XFILLER_123_491 vccd1 vssd1 vccd1 vssd1 sky130_ef_sc_hd__decap_40_12
X_07900_ _03421_ _04117_ _04119_ _03475_ FPGA_INST.cell1.CB_0.config_dataA\[2\] vssd1
+ vssd1 vccd1 vccd1 _04128_ sky130_fd_sc_hd__a221o_1
X_08880_ net386 _04785_ vssd1 vssd1 vccd1 vccd1 _05087_ sky130_fd_sc_hd__nand2_1
XFILLER_110_141 vssd1 vssd1 vccd1 vccd1 sky130_fd_sc_hd__fill_1
XFILLER_69_567 vssd1 vssd1 vccd1 vccd1 sky130_fd_sc_hd__fill_1
XANTENNA__08194__A1 FPGA_INST.bus1_0\[5\] vssd1 vssd1 vccd1 vccd1 sky130_fd_sc_hd__diode_2
X_07831_ net137 _04068_ _02123_ vssd1 vssd1 vccd1 vccd1 net53 sky130_fd_sc_hd__mux2_1
XFILLER_110_163 vssd1 vssd1 vccd1 vccd1 sky130_fd_sc_hd__fill_1
XANTENNA__07941__A1 FPGA_INST.bus3_1\[9\] vssd1 vssd1 vccd1 vccd1 sky130_fd_sc_hd__diode_2
XFILLER_56_206 vssd1 vssd1 vccd1 vccd1 sky130_fd_sc_hd__fill_1
X_09501_ FPGA_INST.cell1.LE_0A.dff0_out net523 _05213_ vssd1 vssd1 vccd1 vccd1 _00413_
+ sky130_fd_sc_hd__a21o_1
X_07762_ FPGA_INST.cell1.SB0.route_sel\[117\] FPGA_INST.cell1.SB0.route_sel\[116\]
+ vssd1 vssd1 vccd1 vccd1 _04012_ sky130_fd_sc_hd__nand2b_1
XFILLER_112_39 vssd1 vssd1 vccd1 vccd1 sky130_fd_sc_hd__fill_1
XANTENNA__08585__Y _04794_ vssd1 vssd1 vccd1 vccd1 sky130_fd_sc_hd__diode_2
X_07693_ _01626_ FPGA_INST.cell3.SB0.route_sel\[99\] _01627_ FPGA_INST.cell3.SB0.route_sel\[100\]
+ _03944_ vssd1 vssd1 vccd1 vccd1 _03945_ sky130_fd_sc_hd__o221a_1
X_06713_ FPGA_INST.cell2.LEI0.config_data\[9\] net130 _02986_ FPGA_INST.cell2.LEI0.config_data\[10\]
+ vssd1 vssd1 vccd1 vccd1 _02987_ sky130_fd_sc_hd__o211a_1
XTAP_TAPCELL_ROW_48_960 vssd1 vccd1 sky130_fd_sc_hd__tapvpwrvgnd_1
XFILLER_25_615 vssd1 vssd1 vccd1 vccd1 sky130_fd_sc_hd__fill_1
X_09432_ FPGA_INST.cell2.LE_1B.config_data\[1\] FPGA_INST.cell2.LE_1B.config_data\[0\]
+ net360 vssd1 vssd1 vccd1 vccd1 _00345_ sky130_fd_sc_hd__mux2_1
X_06644_ _02915_ _02919_ vssd1 vssd1 vccd1 vccd1 _02920_ sky130_fd_sc_hd__nor2_1
X_06575_ net482 net483 vssd1 vssd1 vccd1 vccd1 _02851_ sky130_fd_sc_hd__nor2_1
X_09363_ FPGA_INST.cell2.CB_0.config_dataA\[7\] net505 net351 vssd1 vssd1 vccd1 vccd1
+ _00276_ sky130_fd_sc_hd__mux2_1
X_05526_ _01802_ _01806_ _01807_ FPGA_INST.config_bits\[11\] vssd1 vssd1 vccd1 vccd1
+ _01808_ sky130_fd_sc_hd__o22a_1
X_08314_ net446 _03720_ vssd1 vssd1 vccd1 vccd1 _04536_ sky130_fd_sc_hd__nand2_1
XANTENNA_fanout243_A net244 vssd1 vssd1 vccd1 vccd1 sky130_fd_sc_hd__diode_2
X_09294_ FPGA_INST.cell1.SB0.route_sel\[66\] FPGA_INST.cell1.SB0.route_sel\[65\] net330
+ vssd1 vssd1 vccd1 vccd1 _00207_ sky130_fd_sc_hd__mux2_1
X_05457_ FPGA_INST.cell0.CB_0.config_dataA\[19\] vssd1 vssd1 vccd1 vccd1 _01739_ sky130_fd_sc_hd__inv_2
X_08245_ FPGA_INST.cell0.LEI0.config_data\[32\] _04468_ vssd1 vssd1 vccd1 vccd1 _04469_
+ sky130_fd_sc_hd__nand2b_1
XTAP_TAPCELL_ROW_95_1612 vssd1 vccd1 sky130_fd_sc_hd__tapvpwrvgnd_1
X_08176_ _04397_ _04399_ FPGA_INST.cell0.CB_1.config_dataA\[2\] vssd1 vssd1 vccd1
+ vccd1 _04400_ sky130_fd_sc_hd__mux2_1
X_05388_ FPGA_INST.cell0.SB0.route_sel\[63\] vssd1 vssd1 vccd1 vccd1 _01670_ sky130_fd_sc_hd__inv_2
XANTENNA_fanout129_X net129 vssd1 vssd1 vccd1 vccd1 sky130_fd_sc_hd__diode_2
XFILLER_119_797 vssd1 vssd1 vccd1 vccd1 sky130_fd_sc_hd__fill_2
X_07127_ FPGA_INST.cell0.LE_0A.dff0_out FPGA_INST.cell0.LE_0A.dff1_out FPGA_INST.cell0.LE_0A.reset_val
+ vssd1 vssd1 vccd1 vccd1 FPGA_INST.cell0.LE_0A.dff_out sky130_fd_sc_hd__mux2_1
XANTENNA__06432__A1 net4 vssd1 vssd1 vccd1 vccd1 sky130_fd_sc_hd__diode_2
X_07058_ FPGA_INST.bus2_0\[2\] FPGA_INST.bus2_0\[3\] net430 vssd1 vssd1 vccd1 vccd1
+ _03324_ sky130_fd_sc_hd__mux2_1
XANTENNA_fanout877_A net892 vssd1 vssd1 vccd1 vccd1 sky130_fd_sc_hd__diode_2
X_06009_ net352 _02283_ _02288_ vssd1 vssd1 vccd1 vccd1 _02289_ sky130_fd_sc_hd__nor3_1
XFILLER_101_141 vssd1 vssd1 vccd1 vccd1 sky130_fd_sc_hd__fill_1
XTAP_TAPCELL_ROW_7_379 vssd1 vccd1 sky130_fd_sc_hd__tapvpwrvgnd_1
XANTENNA_input3_X net3 vssd1 vssd1 vccd1 vccd1 sky130_fd_sc_hd__diode_2
XANTENNA__06735__A2 _02793_ vssd1 vssd1 vccd1 vccd1 sky130_fd_sc_hd__diode_2
XANTENNA__07680__X _03932_ vssd1 vssd1 vccd1 vccd1 sky130_fd_sc_hd__diode_2
XFILLER_46_33 vssd1 vssd1 vccd1 vccd1 sky130_fd_sc_hd__fill_1
XANTENNA__10023__S net317 vssd1 vssd1 vccd1 vccd1 sky130_fd_sc_hd__diode_2
X_10971_ net878 _00321_ net663 vssd1 vssd1 vccd1 vccd1 FPGA_INST.cell2.CB_1.config_dataA\[2\]
+ sky130_fd_sc_hd__dfstp_2
XFILLER_46_77 vssd1 vssd1 vccd1 vccd1 sky130_fd_sc_hd__fill_4
XFILLER_28_475 vssd1 vssd1 vccd1 vccd1 sky130_fd_sc_hd__fill_1
XFILLER_70_220 vssd1 vssd1 vccd1 vccd1 sky130_fd_sc_hd__fill_4
XFILLER_43_423 vssd1 vssd1 vccd1 vccd1 sky130_fd_sc_hd__fill_1
XFILLER_28_486 vssd1 vssd1 vccd1 vccd1 sky130_fd_sc_hd__fill_2
XTAP_TAPCELL_ROW_104_1741 vssd1 vccd1 sky130_fd_sc_hd__tapvpwrvgnd_1
XFILLER_43_445 vssd1 vssd1 vccd1 vccd1 sky130_fd_sc_hd__fill_2
XTAP_TAPCELL_ROW_26_643 vssd1 vccd1 sky130_fd_sc_hd__tapvpwrvgnd_1
XFILLER_71_798 vssd1 vssd1 vccd1 vccd1 sky130_fd_sc_hd__fill_1
X_11523_ net810 _00873_ net593 vssd1 vssd1 vccd1 vccd1 FPGA_INST.config_bits\[4\]
+ sky130_fd_sc_hd__dfstp_1
XANTENNA__08660__A2 net25 vssd1 vssd1 vccd1 vccd1 sky130_fd_sc_hd__diode_2
X_11454_ net751 _00804_ net536 vssd1 vssd1 vccd1 vccd1 FPGA_INST.cell0.LE_0B.config_data\[3\]
+ sky130_fd_sc_hd__dfrtp_1
X_10405_ FPGA_INST.cell3.CB_1.config_dataB\[3\] FPGA_INST.cell3.CB_1.config_dataB\[2\]
+ net370 vssd1 vssd1 vccd1 vccd1 _01284_ sky130_fd_sc_hd__mux2_1
XFILLER_7_368 vssd1 vssd1 vccd1 vccd1 sky130_fd_sc_hd__fill_1
X_11385_ net748 _00735_ net533 vssd1 vssd1 vccd1 vccd1 FPGA_INST.cell0.LEI0.config_data\[6\]
+ sky130_fd_sc_hd__dfrtp_1
XFILLER_124_244 vssd1 vssd1 vccd1 vccd1 sky130_fd_sc_hd__fill_8
X_10336_ FPGA_INST.cell3.LE_0A.config_data\[0\] FPGA_INST.cell3.LE_0A.config_data\[1\]
+ net288 vssd1 vssd1 vccd1 vccd1 _01217_ sky130_fd_sc_hd__mux2_1
XTAP_TAPCELL_ROW_115_1892 vssd1 vccd1 sky130_fd_sc_hd__tapvpwrvgnd_1
X_10267_ FPGA_INST.io_east_oeb\[22\] FPGA_INST.io_east_oeb\[24\] net257 vssd1 vssd1
+ vccd1 vccd1 _01148_ sky130_fd_sc_hd__mux2_1
X_12006_ net786 _01352_ net571 vssd1 vssd1 vccd1 vccd1 FPGA_INST.cell2.SB0.route_sel\[46\]
+ sky130_fd_sc_hd__dfstp_1
XFILLER_23_7 vssd1 vssd1 vccd1 vccd1 sky130_fd_sc_hd__fill_1
X_10198_ FPGA_INST.cell3.SB0.route_sel\[102\] FPGA_INST.cell3.SB0.route_sel\[103\]
+ net271 vssd1 vssd1 vccd1 vccd1 _01079_ sky130_fd_sc_hd__mux2_1
XANTENNA__06726__A2 _02810_ vssd1 vssd1 vccd1 vccd1 sky130_fd_sc_hd__diode_2
XFILLER_93_334 vssd1 vssd1 vccd1 vccd1 sky130_fd_sc_hd__fill_2
XFILLER_81_507 vssd1 vssd1 vccd1 vccd1 sky130_fd_sc_hd__fill_1
XTAP_TAPCELL_ROW_66_1202 vssd1 vccd1 sky130_fd_sc_hd__tapvpwrvgnd_1
XANTENNA__08846__B _04801_ vssd1 vssd1 vccd1 vccd1 sky130_fd_sc_hd__diode_2
XTAP_TAPCELL_ROW_66_1213 vssd1 vccd1 sky130_fd_sc_hd__tapvpwrvgnd_1
X_06360_ _02626_ _02630_ _02634_ _02637_ vssd1 vssd1 vccd1 vccd1 _02638_ sky130_fd_sc_hd__a22o_1
XANTENNA__12157__Q FPGA_INST.cell3.CB_1.config_dataA\[19\] vssd1 vssd1 vccd1 vccd1
+ sky130_fd_sc_hd__diode_2
X_05311_ FPGA_INST.cell2.LE_1A.config_data\[16\] vssd1 vssd1 vccd1 vccd1 _01593_ sky130_fd_sc_hd__inv_2
X_06291_ FPGA_INST.cell2.CB_0.config_dataA\[14\] _02540_ _02559_ _02568_ _02570_ vssd1
+ vssd1 vccd1 vccd1 _02571_ sky130_fd_sc_hd__a311o_1
X_08030_ _03973_ _04234_ _04255_ vssd1 vssd1 vccd1 vccd1 _04256_ sky130_fd_sc_hd__o21ba_1
Xinput30 gpio_in[9] vssd1 vssd1 vccd1 vccd1 net30 sky130_fd_sc_hd__clkbuf_4
XTAP_TAPCELL_ROW_77_1364 vssd1 vccd1 sky130_fd_sc_hd__tapvpwrvgnd_1
X_09981_ FPGA_INST.config_bits\[6\] FPGA_INST.config_bits\[5\] _05228_ vssd1 vssd1
+ vccd1 vccd1 _05232_ sky130_fd_sc_hd__and3_1
XFILLER_107_28 vssd1 vssd1 vccd1 vccd1 sky130_fd_sc_hd__fill_1
XFILLER_89_629 vssd1 vssd1 vccd1 vccd1 sky130_fd_sc_hd__fill_2
XFILLER_130_225 vssd1 vssd1 vccd1 vccd1 sky130_fd_sc_hd__fill_1
XTAP_TAPCELL_ROW_90_1542 vssd1 vccd1 sky130_fd_sc_hd__tapvpwrvgnd_1
X_08932_ _01634_ FPGA_INST.cell1.SB0.route_sel\[91\] FPGA_INST.cell1.SB0.route_sel\[92\]
+ _01635_ vssd1 vssd1 vccd1 vccd1 _05128_ sky130_fd_sc_hd__o22a_1
XANTENNA__10925__CLK net851 vssd1 vssd1 vccd1 vccd1 sky130_fd_sc_hd__diode_2
XANTENNA__08167__A1 FPGA_INST.bus1_0\[9\] vssd1 vssd1 vccd1 vccd1 sky130_fd_sc_hd__diode_2
XANTENNA__08167__B2 FPGA_INST.bus1_0\[8\] vssd1 vssd1 vccd1 vccd1 sky130_fd_sc_hd__diode_2
XFILLER_111_461 vssd1 vssd1 vccd1 vccd1 sky130_fd_sc_hd__fill_1
XANTENNA__07914__A1 _03973_ vssd1 vssd1 vccd1 vccd1 sky130_fd_sc_hd__diode_2
X_08863_ net386 _04822_ vssd1 vssd1 vccd1 vccd1 _05070_ sky130_fd_sc_hd__nand2_1
XFILLER_57_526 vssd1 vssd1 vccd1 vccd1 sky130_fd_sc_hd__fill_4
XFILLER_57_515 vssd1 vssd1 vccd1 vccd1 sky130_fd_sc_hd__fill_1
XTAP_TAPCELL_ROW_4_338 vssd1 vccd1 sky130_fd_sc_hd__tapvpwrvgnd_1
XFILLER_111_483 vssd1 vssd1 vccd1 vccd1 sky130_fd_sc_hd__fill_1
X_08794_ _01774_ _03583_ _04821_ vssd1 vssd1 vccd1 vccd1 _05001_ sky130_fd_sc_hd__or3_1
XFILLER_57_559 vssd1 vssd1 vccd1 vccd1 sky130_fd_sc_hd__fill_1
X_07814_ net669 FPGA_INST.cell2.LE_1A.reset_mode vssd1 vssd1 vccd1 vccd1 _07814_/X
+ sky130_fd_sc_hd__xor2_2
XFILLER_38_740 vssd1 vssd1 vccd1 vccd1 sky130_fd_sc_hd__fill_2
XANTENNA__07390__A2 _03648_ vssd1 vssd1 vccd1 vccd1 sky130_fd_sc_hd__diode_2
XANTENNA_fanout360_A net361 vssd1 vssd1 vccd1 vccd1 sky130_fd_sc_hd__diode_2
X_07745_ FPGA_INST.cell0.SB0.route_sel\[116\] FPGA_INST.cell0.SB0.route_sel\[117\]
+ vssd1 vssd1 vccd1 vccd1 _03995_ sky130_fd_sc_hd__or2_1
XFILLER_65_570 vssd1 vssd1 vccd1 vccd1 sky130_fd_sc_hd__fill_1
XFILLER_53_710 vccd1 vssd1 vccd1 vssd1 sky130_ef_sc_hd__decap_40_12
X_07676_ net148 _03411_ _03926_ _03927_ _03919_ vssd1 vssd1 vccd1 vccd1 _03928_ sky130_fd_sc_hd__o311a_1
X_09415_ FPGA_INST.cell2.CB_1.config_dataA\[8\] FPGA_INST.cell2.CB_1.config_dataA\[9\]
+ net261 vssd1 vssd1 vccd1 vccd1 _00328_ sky130_fd_sc_hd__mux2_1
XANTENNA_fanout625_A net626 vssd1 vssd1 vccd1 vccd1 sky130_fd_sc_hd__diode_2
XANTENNA__08890__A2 FPGA_INST.cell3.CB_1.le_outA vssd1 vssd1 vccd1 vccd1 sky130_fd_sc_hd__diode_2
X_06627_ FPGA_INST.cell2.CB_1.config_dataA\[12\] _02896_ _02898_ _02902_ FPGA_INST.cell2.CB_1.config_dataA\[13\]
+ vssd1 vssd1 vccd1 vccd1 _02903_ sky130_fd_sc_hd__o2111a_1
XFILLER_53_798 vssd1 vssd1 vccd1 vccd1 sky130_fd_sc_hd__fill_1
XFILLER_52_286 vssd1 vssd1 vccd1 vccd1 sky130_fd_sc_hd__fill_1
XTAP_TAPCELL_ROW_23_602 vssd1 vccd1 sky130_fd_sc_hd__tapvpwrvgnd_1
X_09346_ FPGA_INST.cell1.SB0.route_sel\[117\] FPGA_INST.cell1.SB0.route_sel\[118\]
+ net224 vssd1 vssd1 vccd1 vccd1 _00259_ sky130_fd_sc_hd__mux2_1
X_06558_ FPGA_INST.cell2.SB0.route_sel\[84\] FPGA_INST.cell2.SB0.route_sel\[85\] vssd1
+ vssd1 vccd1 vccd1 _02834_ sky130_fd_sc_hd__nor2_1
X_05509_ FPGA_INST.cell3.CB_1.le_outA vssd1 vssd1 vccd1 vccd1 _01791_ sky130_fd_sc_hd__inv_2
X_09277_ FPGA_INST.cell1.SB0.route_sel\[48\] FPGA_INST.cell1.SB0.route_sel\[49\] net223
+ vssd1 vssd1 vccd1 vccd1 _00190_ sky130_fd_sc_hd__mux2_1
XTAP_TAPCELL_ROW_51_999 vssd1 vccd1 sky130_fd_sc_hd__tapvpwrvgnd_1
XANTENNA__05824__B1_N FPGA_INST.bus2_0\[9\] vssd1 vssd1 vccd1 vccd1 sky130_fd_sc_hd__diode_2
X_06489_ _02766_ _02763_ _02723_ vssd1 vssd1 vccd1 vccd1 _02767_ sky130_fd_sc_hd__mux2_1
XFILLER_21_673 vssd1 vssd1 vccd1 vccd1 sky130_fd_sc_hd__fill_1
XFILLER_120_6 vccd1 vssd1 vccd1 vssd1 sky130_ef_sc_hd__decap_40_12
X_08228_ _04451_ _04449_ FPGA_INST.cell0.CB_1.config_dataA\[12\] vssd1 vssd1 vccd1
+ vccd1 _04452_ sky130_fd_sc_hd__mux2_1
XFILLER_20_194 vssd1 vssd1 vccd1 vccd1 sky130_fd_sc_hd__fill_2
X_08159_ net412 net411 vssd1 vssd1 vccd1 vccd1 _04383_ sky130_fd_sc_hd__nor2_1
XFILLER_4_349 vssd1 vssd1 vccd1 vccd1 sky130_fd_sc_hd__fill_2
XFILLER_4_338 vssd1 vssd1 vccd1 vccd1 sky130_fd_sc_hd__fill_2
X_11170_ net787 _00520_ net572 vssd1 vssd1 vccd1 vccd1 FPGA_INST.cell0.SB0.route_sel\[15\]
+ sky130_fd_sc_hd__dfstp_1
XFILLER_121_225 vssd1 vssd1 vccd1 vccd1 sky130_fd_sc_hd__fill_4
X_10121_ FPGA_INST.cell3.SB0.route_sel\[25\] FPGA_INST.cell3.SB0.route_sel\[26\] net270
+ vssd1 vssd1 vccd1 vccd1 _01002_ sky130_fd_sc_hd__mux2_1
X_10052_ FPGA_INST.cell0.CB_1.config_dataA\[2\] net411 net311 vssd1 vssd1 vccd1 vccd1
+ _00933_ sky130_fd_sc_hd__mux2_1
XANTENNA__07905__A1 _03810_ vssd1 vssd1 vccd1 vccd1 sky130_fd_sc_hd__diode_2
XANTENNA__06708__A2 _02793_ vssd1 vssd1 vccd1 vccd1 sky130_fd_sc_hd__diode_2
XFILLER_87_183 vssd1 vssd1 vccd1 vccd1 sky130_fd_sc_hd__fill_2
XFILLER_48_548 vssd1 vssd1 vccd1 vccd1 sky130_fd_sc_hd__fill_2
XANTENNA_input19_A gpio_in[26] vssd1 vssd1 vccd1 vccd1 sky130_fd_sc_hd__diode_2
XFILLER_57_98 vssd1 vssd1 vccd1 vccd1 sky130_fd_sc_hd__fill_1
XFILLER_73_42 vccd1 vssd1 vccd1 vssd1 sky130_ef_sc_hd__decap_40_12
XFILLER_44_754 vssd1 vssd1 vccd1 vccd1 sky130_fd_sc_hd__fill_2
X_10954_ net870 _00304_ net657 vssd1 vssd1 vccd1 vccd1 FPGA_INST.cell2.CB_0.config_dataB\[10\]
+ sky130_fd_sc_hd__dfstp_1
XANTENNA__08881__A2 _04781_ vssd1 vssd1 vccd1 vccd1 sky130_fd_sc_hd__diode_2
X_10885_ net797 _00235_ net582 vssd1 vssd1 vccd1 vccd1 FPGA_INST.cell1.SB0.route_sel\[94\]
+ sky130_fd_sc_hd__dfstp_1
XFILLER_43_264 vssd1 vssd1 vccd1 vccd1 sky130_fd_sc_hd__fill_2
XTAP_TAPCELL_ROW_61_1132 vssd1 vccd1 sky130_fd_sc_hd__tapvpwrvgnd_1
XFILLER_12_640 vssd1 vssd1 vccd1 vccd1 sky130_fd_sc_hd__fill_1
XFILLER_31_437 vssd1 vssd1 vccd1 vccd1 sky130_fd_sc_hd__fill_2
XTAP_TAPCELL_ROW_61_1143 vssd1 vccd1 sky130_fd_sc_hd__tapvpwrvgnd_1
X_11506_ net760 _00856_ net545 vssd1 vssd1 vccd1 vccd1 FPGA_INST.cell0.CB_1.config_dataB\[12\]
+ sky130_fd_sc_hd__dfstp_2
XFILLER_7_110 vssd1 vssd1 vccd1 vccd1 sky130_fd_sc_hd__fill_2
XTAP_TAPCELL_ROW_117_1921 vssd1 vccd1 sky130_fd_sc_hd__tapvpwrvgnd_1
XFILLER_7_165 vssd1 vssd1 vccd1 vccd1 sky130_fd_sc_hd__fill_2
XANTENNA__11433__RESET_B net561 vssd1 vssd1 vccd1 vccd1 sky130_fd_sc_hd__diode_2
X_11437_ net773 _00787_ net559 vssd1 vssd1 vccd1 vccd1 FPGA_INST.cell0.LE_0A.config_data\[8\]
+ sky130_fd_sc_hd__dfrtp_1
XFILLER_22_90 vssd1 vssd1 vccd1 vccd1 sky130_fd_sc_hd__fill_1
X_11368_ net817 _00718_ net602 vssd1 vssd1 vccd1 vccd1 FPGA_INST.cell1.LE_1B.config_data\[10\]
+ sky130_fd_sc_hd__dfrtp_1
X_10319_ FPGA_INST.cell3.LEI0.config_data\[33\] FPGA_INST.cell3.LEI0.config_data\[34\]
+ net282 vssd1 vssd1 vccd1 vccd1 _01200_ sky130_fd_sc_hd__mux2_1
XFILLER_113_726 vssd1 vssd1 vccd1 vccd1 sky130_fd_sc_hd__fill_2
X_11299_ net824 _00649_ net608 vssd1 vssd1 vccd1 vccd1 FPGA_INST.cell1.CB_0.config_dataA\[16\]
+ sky130_fd_sc_hd__dfstp_1
XFILLER_79_673 vssd1 vssd1 vccd1 vccd1 sky130_fd_sc_hd__fill_4
XTAP_TAPCELL_ROW_72_1294 vssd1 vccd1 sky130_fd_sc_hd__tapvpwrvgnd_1
XFILLER_94_643 vssd1 vssd1 vccd1 vccd1 sky130_fd_sc_hd__fill_1
XFILLER_66_345 vssd1 vssd1 vccd1 vccd1 sky130_fd_sc_hd__fill_2
XFILLER_14_3 vccd1 vssd1 vccd1 vssd1 sky130_ef_sc_hd__decap_40_12
X_05860_ net116 net169 _02012_ _02133_ vssd1 vssd1 vccd1 vccd1 _02140_ sky130_fd_sc_hd__a31o_1
XANTENNA__10598__S net378 vssd1 vssd1 vccd1 vccd1 sky130_fd_sc_hd__diode_2
X_05791_ net171 net162 _02067_ _02069_ vssd1 vssd1 vccd1 vccd1 _02071_ sky130_fd_sc_hd__o22a_1
X_07530_ _03744_ _03785_ vssd1 vssd1 vccd1 vccd1 _03786_ sky130_fd_sc_hd__nor2_1
X_07461_ FPGA_INST.cell0.SB0.route_sel\[62\] _01670_ vssd1 vssd1 vccd1 vccd1 _03718_
+ sky130_fd_sc_hd__nand2_1
XFILLER_35_776 vssd1 vssd1 vccd1 vccd1 sky130_fd_sc_hd__fill_4
XFILLER_35_798 vssd1 vssd1 vccd1 vccd1 sky130_fd_sc_hd__fill_1
X_07392_ FPGA_INST.cell1.SB0.route_sel\[44\] _01684_ FPGA_INST.cell1.SB0.route_sel\[47\]
+ _01685_ _03650_ vssd1 vssd1 vccd1 vccd1 _03651_ sky130_fd_sc_hd__a221o_1
X_06412_ net491 _02092_ vssd1 vssd1 vccd1 vccd1 _02690_ sky130_fd_sc_hd__nand2_1
XANTENNA__06883__A1 FPGA_INST.bus2_0\[3\] vssd1 vssd1 vccd1 vccd1 sky130_fd_sc_hd__diode_2
X_09200_ FPGA_INST.cell2.LE_1A.reset_val FPGA_INST.cell2.LE_1A.edge_mode net361 vssd1
+ vssd1 vccd1 vccd1 _00113_ sky130_fd_sc_hd__mux2_1
X_06343_ net494 _02413_ vssd1 vssd1 vccd1 vccd1 _02621_ sky130_fd_sc_hd__or2_1
X_09131_ FPGA_INST.cell2.LEI0.config_data\[45\] FPGA_INST.cell2.LEI0.config_data\[46\]
+ net259 vssd1 vssd1 vccd1 vccd1 _00047_ sky130_fd_sc_hd__mux2_1
X_09062_ net943 FPGA_INST.cell3.LE_1A.edge_mode vssd1 vssd1 vccd1 vccd1 FPGA_INST.cell3.LE_1A.sel_clk
+ sky130_fd_sc_hd__xnor2_1
XFILLER_30_470 vssd1 vssd1 vccd1 vccd1 sky130_fd_sc_hd__fill_4
X_06274_ net503 _02217_ vssd1 vssd1 vccd1 vccd1 _02554_ sky130_fd_sc_hd__nand2_1
XFILLER_118_27 vssd1 vssd1 vccd1 vccd1 sky130_fd_sc_hd__fill_1
XFILLER_116_531 vssd1 vssd1 vccd1 vccd1 sky130_fd_sc_hd__fill_1
X_08013_ FPGA_INST.bus3_1\[4\] FPGA_INST.bus3_1\[5\] FPGA_INST.bus3_1\[6\] FPGA_INST.bus3_1\[7\]
+ net457 FPGA_INST.cell1.CB_0.config_dataB\[6\] vssd1 vssd1 vccd1 vccd1 _04239_ sky130_fd_sc_hd__mux4_1
XANTENNA_fanout206_A net219 vssd1 vssd1 vccd1 vccd1 sky130_fd_sc_hd__diode_2
XFILLER_116_542 vssd1 vssd1 vccd1 vccd1 sky130_fd_sc_hd__fill_1
XFILLER_104_704 vssd1 vssd1 vccd1 vccd1 sky130_fd_sc_hd__fill_2
XANTENNA__08388__A1 _03959_ vssd1 vssd1 vccd1 vccd1 sky130_fd_sc_hd__diode_2
XANTENNA__08388__B2 _03923_ vssd1 vssd1 vccd1 vccd1 sky130_fd_sc_hd__diode_2
XTAP_TAPCELL_ROW_9_408 vssd1 vccd1 sky130_fd_sc_hd__tapvpwrvgnd_1
XFILLER_116_597 vssd1 vssd1 vccd1 vccd1 sky130_fd_sc_hd__fill_1
XFILLER_103_225 vssd1 vssd1 vccd1 vccd1 sky130_fd_sc_hd__fill_1
XANTENNA__06938__A2 _02030_ vssd1 vssd1 vccd1 vccd1 sky130_fd_sc_hd__diode_2
X_09964_ FPGA_INST.config_en_q net738 vssd1 vssd1 vccd1 vccd1 _05221_ sky130_fd_sc_hd__nand2_1
XANTENNA__08103__Y _04329_ vssd1 vssd1 vccd1 vccd1 sky130_fd_sc_hd__diode_2
XFILLER_104_759 vssd1 vssd1 vccd1 vccd1 sky130_fd_sc_hd__fill_1
XFILLER_89_459 vssd1 vssd1 vccd1 vccd1 sky130_fd_sc_hd__fill_2
X_08915_ FPGA_INST.cell1.SB0.route_sel\[108\] _01620_ _05116_ vssd1 vssd1 vccd1 vccd1
+ _05117_ sky130_fd_sc_hd__o21ai_1
XANTENNA_fanout196_X net196 vssd1 vssd1 vccd1 vccd1 sky130_fd_sc_hd__diode_2
X_09895_ FPGA_INST.cell0.LE_0B.config_data\[0\] FPGA_INST.cell0.LE_1B.reset_mode net309
+ vssd1 vssd1 vccd1 vccd1 _00801_ sky130_fd_sc_hd__mux2_1
XANTENNA_fanout575_A net628 vssd1 vssd1 vccd1 vccd1 sky130_fd_sc_hd__diode_2
X_08846_ net388 _04801_ vssd1 vssd1 vccd1 vccd1 _05053_ sky130_fd_sc_hd__nand2_1
XANTENNA__09362__S net240 vssd1 vssd1 vccd1 vccd1 sky130_fd_sc_hd__diode_2
X_08777_ _04843_ _04974_ _04975_ _04846_ _01776_ vssd1 vssd1 vccd1 vccd1 _04984_ sky130_fd_sc_hd__a221o_1
XFILLER_84_197 vssd1 vssd1 vccd1 vccd1 sky130_fd_sc_hd__fill_1
XANTENNA_fanout363_X net363 vssd1 vssd1 vccd1 vccd1 sky130_fd_sc_hd__diode_2
X_05989_ FPGA_INST.cell0.SB0.route_sel\[38\] _01693_ FPGA_INST.cell0.SB0.route_sel\[34\]
+ FPGA_INST.cell0.SB0.route_sel\[35\] _02268_ vssd1 vssd1 vccd1 vccd1 _02269_ sky130_fd_sc_hd__o221a_1
X_07728_ net89 _03977_ _03978_ vssd1 vssd1 vccd1 vccd1 _03979_ sky130_fd_sc_hd__o21ba_1
XFILLER_26_743 vssd1 vssd1 vccd1 vccd1 sky130_fd_sc_hd__fill_2
XTAP_TAPCELL_ROW_101_1700 vssd1 vccd1 sky130_fd_sc_hd__tapvpwrvgnd_1
X_07659_ FPGA_INST.cell1.CB_0.config_dataA\[23\] FPGA_INST.cell1.CB_0.config_dataA\[22\]
+ vssd1 vssd1 vccd1 vccd1 _03911_ sky130_fd_sc_hd__nand2_1
XFILLER_26_798 vssd1 vssd1 vccd1 vccd1 sky130_fd_sc_hd__fill_1
X_10670_ net880 _00020_ net665 vssd1 vssd1 vccd1 vccd1 FPGA_INST.cell2.LEI0.config_data\[19\]
+ sky130_fd_sc_hd__dfrtp_1
XANTENNA_fanout628_X net628 vssd1 vssd1 vccd1 vccd1 sky130_fd_sc_hd__diode_2
XTAP_TAPCELL_ROW_36_782 vssd1 vccd1 sky130_fd_sc_hd__tapvpwrvgnd_1
XTAP_TAPCELL_ROW_36_793 vssd1 vccd1 sky130_fd_sc_hd__tapvpwrvgnd_1
X_09329_ FPGA_INST.cell1.SB0.route_sel\[100\] FPGA_INST.cell1.SB0.route_sel\[101\]
+ net223 vssd1 vssd1 vccd1 vccd1 _00242_ sky130_fd_sc_hd__mux2_1
XANTENNA__08091__A3 FPGA_INST.bus3_1\[11\] vssd1 vssd1 vccd1 vccd1 sky130_fd_sc_hd__diode_2
XTAP_TAPCELL_ROW_130_2107 vssd1 vccd1 sky130_fd_sc_hd__tapvpwrvgnd_1
XFILLER_126_339 vssd1 vssd1 vccd1 vccd1 sky130_fd_sc_hd__fill_1
XFILLER_119_391 vssd1 vssd1 vccd1 vccd1 sky130_fd_sc_hd__fill_1
XFILLER_4_102 vccd1 vssd1 vccd1 vssd1 sky130_ef_sc_hd__decap_40_12
XTAP_TAPCELL_ROW_130_2118 vssd1 vccd1 sky130_fd_sc_hd__tapvpwrvgnd_1
X_11222_ net767 _00572_ net552 vssd1 vssd1 vccd1 vccd1 FPGA_INST.cell0.SB0.route_sel\[67\]
+ sky130_fd_sc_hd__dfstp_1
XFILLER_107_586 vssd1 vssd1 vccd1 vccd1 sky130_fd_sc_hd__fill_1
XFILLER_107_575 vssd1 vssd1 vccd1 vccd1 sky130_fd_sc_hd__fill_4
XFILLER_68_20 vssd1 vssd1 vccd1 vccd1 sky130_fd_sc_hd__fill_8
XFILLER_122_556 vccd1 vssd1 vccd1 vssd1 sky130_ef_sc_hd__decap_40_12
XTAP_TAPCELL_ROW_112_1851 vssd1 vccd1 sky130_fd_sc_hd__tapvpwrvgnd_1
X_11153_ net807 _00503_ net592 vssd1 vssd1 vccd1 vccd1 FPGA_INST.cell1.CB_1.config_dataB\[23\]
+ sky130_fd_sc_hd__dfstp_1
XFILLER_110_707 vssd1 vssd1 vccd1 vccd1 sky130_fd_sc_hd__fill_2
X_11084_ net834 _00434_ net618 vssd1 vssd1 vccd1 vccd1 FPGA_INST.cell1.LE_0A.reset_mode
+ sky130_fd_sc_hd__dfrtp_1
X_10104_ FPGA_INST.cell3.SB0.route_sel\[8\] FPGA_INST.cell3.SB0.route_sel\[9\] net270
+ vssd1 vssd1 vccd1 vccd1 _00985_ sky130_fd_sc_hd__mux2_1
XFILLER_0_363 vssd1 vssd1 vccd1 vccd1 sky130_fd_sc_hd__fill_1
X_10035_ FPGA_INST.cell0.CB_0.config_dataB\[9\] net419 net190 vssd1 vssd1 vccd1 vccd1
+ _00916_ sky130_fd_sc_hd__mux2_1
XFILLER_0_385 vssd1 vssd1 vccd1 vccd1 sky130_fd_sc_hd__fill_4
XTAP_TAPCELL_ROW_128_2069 vssd1 vccd1 sky130_fd_sc_hd__tapvpwrvgnd_1
XFILLER_90_123 vssd1 vssd1 vccd1 vccd1 sky130_fd_sc_hd__fill_8
XFILLER_84_74 vssd1 vssd1 vccd1 vccd1 sky130_fd_sc_hd__fill_8
XFILLER_17_710 vssd1 vssd1 vccd1 vccd1 sky130_fd_sc_hd__fill_1
XFILLER_90_134 vssd1 vssd1 vccd1 vccd1 sky130_fd_sc_hd__fill_4
XANTENNA__08303__A1 FPGA_INST.bus1_0\[11\] vssd1 vssd1 vccd1 vccd1 sky130_fd_sc_hd__diode_2
X_11986_ net773 _01332_ net559 vssd1 vssd1 vccd1 vccd1 FPGA_INST.cell2.SB0.route_sel\[26\]
+ sky130_fd_sc_hd__dfstp_1
XANTENNA__05813__B _02092_ vssd1 vssd1 vccd1 vccd1 sky130_fd_sc_hd__diode_2
XANTENNA__08964__X FPGA_INST.bus2_0\[8\] vssd1 vssd1 vccd1 vccd1 sky130_fd_sc_hd__diode_2
XANTENNA__08854__A2 net83 vssd1 vssd1 vccd1 vccd1 sky130_fd_sc_hd__diode_2
XANTENNA__06314__A0 net3 vssd1 vssd1 vccd1 vccd1 sky130_fd_sc_hd__diode_2
X_10937_ net850 _00287_ net635 vssd1 vssd1 vccd1 vccd1 FPGA_INST.cell2.CB_0.config_dataA\[18\]
+ sky130_fd_sc_hd__dfstp_1
XFILLER_31_223 vssd1 vssd1 vccd1 vccd1 sky130_fd_sc_hd__fill_1
X_10868_ net792 _00218_ net577 vssd1 vssd1 vccd1 vccd1 FPGA_INST.cell1.SB0.route_sel\[77\]
+ sky130_fd_sc_hd__dfstp_1
X_10799_ net822 _00149_ net606 vssd1 vssd1 vccd1 vccd1 FPGA_INST.cell1.SB0.route_sel\[8\]
+ sky130_fd_sc_hd__dfstp_1
XTAP_TAPCELL_ROW_14_476 vssd1 vccd1 sky130_fd_sc_hd__tapvpwrvgnd_1
XTAP_TAPCELL_ROW_74_1312 vssd1 vccd1 sky130_fd_sc_hd__tapvpwrvgnd_1
XTAP_TAPCELL_ROW_74_1323 vssd1 vccd1 sky130_fd_sc_hd__tapvpwrvgnd_1
XANTENNA__07042__A1 FPGA_INST.bus2_0\[0\] vssd1 vssd1 vccd1 vccd1 sky130_fd_sc_hd__diode_2
XFILLER_113_556 vssd1 vssd1 vccd1 vccd1 sky130_fd_sc_hd__fill_2
Xfanout409 FPGA_INST.cell0.CB_1.config_dataA\[5\] vssd1 vssd1 vccd1 vccd1 net409 sky130_fd_sc_hd__buf_2
XFILLER_98_289 vssd1 vssd1 vccd1 vccd1 sky130_fd_sc_hd__fill_2
X_06961_ _01750_ _03226_ _03228_ FPGA_INST.cell0.LEI0.config_data\[41\] vssd1 vssd1
+ vccd1 vccd1 _03229_ sky130_fd_sc_hd__o2bb2a_1
X_08700_ _04906_ _04907_ _04908_ vssd1 vssd1 vccd1 vccd1 _04909_ sky130_fd_sc_hd__a21oi_1
X_09680_ FPGA_INST.cell0.SB0.route_sel\[84\] FPGA_INST.cell0.SB0.route_sel\[83\] net314
+ vssd1 vssd1 vccd1 vccd1 _00589_ sky130_fd_sc_hd__mux2_1
X_05912_ net171 net160 _02188_ _02190_ vssd1 vssd1 vccd1 vccd1 _02192_ sky130_fd_sc_hd__o22a_1
X_08631_ net401 _04839_ _04836_ net400 vssd1 vssd1 vccd1 vccd1 _04840_ sky130_fd_sc_hd__o211a_1
X_06892_ FPGA_INST.cell0.LE_0B.config_data\[5\] FPGA_INST.cell0.LE_0B.config_data\[4\]
+ _03159_ vssd1 vssd1 vccd1 vccd1 _03160_ sky130_fd_sc_hd__mux2_1
XFILLER_27_507 vssd1 vssd1 vccd1 vccd1 sky130_fd_sc_hd__fill_1
XFILLER_66_186 vssd1 vssd1 vccd1 vccd1 sky130_fd_sc_hd__fill_8
X_05843_ _02001_ _02048_ vssd1 vssd1 vccd1 vccd1 _02123_ sky130_fd_sc_hd__or2_1
X_08562_ FPGA_INST.cell3.LE_1B.config_data\[8\] FPGA_INST.cell3.LE_1B.config_data\[9\]
+ _04755_ vssd1 vssd1 vccd1 vccd1 _04773_ sky130_fd_sc_hd__mux2_1
XFILLER_82_668 vssd1 vssd1 vccd1 vccd1 sky130_fd_sc_hd__fill_4
XFILLER_66_197 vssd1 vssd1 vccd1 vccd1 sky130_fd_sc_hd__fill_8
X_05774_ FPGA_INST.cell2.SB0.route_sel\[85\] FPGA_INST.cell2.SB0.route_sel\[84\] vssd1
+ vssd1 vccd1 vccd1 _02054_ sky130_fd_sc_hd__nand2b_1
X_08493_ FPGA_INST.cell1.LE_1B.config_data\[14\] FPGA_INST.cell1.LE_1B.config_data\[15\]
+ _04692_ vssd1 vssd1 vccd1 vccd1 _04709_ sky130_fd_sc_hd__mux2_1
XTAP_TAPCELL_ROW_85_1474 vssd1 vccd1 sky130_fd_sc_hd__tapvpwrvgnd_1
X_07513_ _03754_ _03766_ _03768_ net222 vssd1 vssd1 vccd1 vccd1 _03769_ sky130_fd_sc_hd__o211a_4
X_07444_ _03669_ _03700_ _03701_ net284 vssd1 vssd1 vccd1 vccd1 _03702_ sky130_fd_sc_hd__o31ai_1
XFILLER_90_690 vssd1 vssd1 vccd1 vccd1 sky130_fd_sc_hd__fill_1
XANTENNA_fanout156_A _02619_ vssd1 vssd1 vccd1 vccd1 sky130_fd_sc_hd__diode_2
XFILLER_13_15 vccd1 vssd1 vccd1 vssd1 sky130_ef_sc_hd__decap_40_12
XTAP_TAPCELL_ROW_33_741 vssd1 vccd1 sky130_fd_sc_hd__tapvpwrvgnd_1
X_07375_ _01788_ _03454_ _03594_ _03591_ _03451_ vssd1 vssd1 vccd1 vccd1 _03634_ sky130_fd_sc_hd__o32a_1
XANTENNA_fanout323_A net324 vssd1 vssd1 vccd1 vccd1 sky130_fd_sc_hd__diode_2
XANTENNA__06608__A1 _02780_ vssd1 vssd1 vccd1 vccd1 sky130_fd_sc_hd__diode_2
X_06326_ _02595_ _02602_ _02605_ vssd1 vssd1 vccd1 vccd1 _02606_ sky130_fd_sc_hd__o21a_1
X_09114_ FPGA_INST.cell2.LEI0.config_data\[28\] FPGA_INST.cell2.LEI0.config_data\[29\]
+ net256 vssd1 vssd1 vccd1 vccd1 _00030_ sky130_fd_sc_hd__mux2_1
X_09045_ net795 FPGA_INST.cell1.LE_1A.edge_mode vssd1 vssd1 vccd1 vccd1 FPGA_INST.cell1.LE_1A.sel_clk
+ sky130_fd_sc_hd__xnor2_1
X_06257_ FPGA_INST.cell2.LE_0A.config_data\[5\] FPGA_INST.cell2.LE_0A.config_data\[4\]
+ _02536_ vssd1 vssd1 vccd1 vccd1 _02537_ sky130_fd_sc_hd__mux2_1
XANTENNA__06084__A2 _02363_ vssd1 vssd1 vccd1 vccd1 sky130_fd_sc_hd__diode_2
XFILLER_116_361 vssd1 vssd1 vccd1 vccd1 sky130_fd_sc_hd__fill_2
XFILLER_1_105 vssd1 vssd1 vccd1 vccd1 sky130_fd_sc_hd__fill_4
X_06188_ FPGA_INST.cell2.SB0.route_sel\[2\] FPGA_INST.cell2.SB0.route_sel\[3\] vssd1
+ vssd1 vccd1 vccd1 _02468_ sky130_fd_sc_hd__nand2_1
XFILLER_89_234 vssd1 vssd1 vccd1 vccd1 sky130_fd_sc_hd__fill_4
XFILLER_89_223 vssd1 vssd1 vccd1 vccd1 sky130_fd_sc_hd__fill_1
Xfanout910 net911 vssd1 vssd1 vccd1 vccd1 net910 sky130_fd_sc_hd__clkbuf_2
Xfanout932 net946 vssd1 vssd1 vccd1 vccd1 net932 sky130_fd_sc_hd__clkbuf_2
Xfanout943 net945 vssd1 vssd1 vccd1 vccd1 net943 sky130_fd_sc_hd__buf_2
XFILLER_104_589 vssd1 vssd1 vccd1 vccd1 sky130_fd_sc_hd__fill_1
XANTENNA__08781__B2 _04789_ vssd1 vssd1 vccd1 vccd1 sky130_fd_sc_hd__diode_2
XANTENNA__08781__A1 _04794_ vssd1 vssd1 vccd1 vccd1 sky130_fd_sc_hd__diode_2
Xfanout921 net922 vssd1 vssd1 vccd1 vccd1 net921 sky130_fd_sc_hd__clkbuf_2
XFILLER_89_267 vccd1 vssd1 vccd1 vssd1 sky130_ef_sc_hd__decap_40_12
X_09947_ FPGA_INST.cell0.CB_1.config_dataB\[8\] FPGA_INST.cell0.CB_1.config_dataB\[7\]
+ net312 vssd1 vssd1 vccd1 vccd1 _00852_ sky130_fd_sc_hd__mux2_1
XFILLER_58_643 vssd1 vssd1 vccd1 vccd1 sky130_fd_sc_hd__fill_1
XFILLER_38_23 vssd1 vssd1 vccd1 vccd1 sky130_fd_sc_hd__fill_4
X_09878_ FPGA_INST.cell0.LE_0A.config_data\[5\] FPGA_INST.cell0.LE_0A.config_data\[6\]
+ net192 vssd1 vssd1 vccd1 vccd1 _00785_ sky130_fd_sc_hd__mux2_1
X_08829_ net388 FPGA_INST.cell3.CB_0.config_dataB\[11\] vssd1 vssd1 vccd1 vccd1 _05036_
+ sky130_fd_sc_hd__nor2_1
X_11840_ net932 _01186_ net716 vssd1 vssd1 vccd1 vccd1 FPGA_INST.cell3.LEI0.config_data\[20\]
+ sky130_fd_sc_hd__dfrtp_1
XFILLER_73_668 vssd1 vssd1 vccd1 vccd1 sky130_fd_sc_hd__fill_4
X_11771_ net925 _01117_ net709 vssd1 vssd1 vccd1 vccd1 FPGA_INST.io_west_oeb\[26\]
+ sky130_fd_sc_hd__dfrtp_1
XFILLER_41_532 vssd1 vssd1 vccd1 vccd1 sky130_fd_sc_hd__fill_8
X_10722_ FPGA_INST.cell2.LE_1A.sel_clk _00072_ net734 vssd1 vssd1 vccd1 vccd1 FPGA_INST.cell2.LE_1A.dff1_out
+ sky130_fd_sc_hd__dfstp_1
XANTENNA__08049__B1 _03613_ vssd1 vssd1 vccd1 vccd1 sky130_fd_sc_hd__diode_2
XFILLER_22_790 vssd1 vssd1 vccd1 vccd1 sky130_fd_sc_hd__fill_8
X_10653_ net874 _00003_ net658 vssd1 vssd1 vccd1 vccd1 FPGA_INST.cell2.LEI0.config_data\[2\]
+ sky130_fd_sc_hd__dfrtp_1
X_10584_ FPGA_INST.cell3.CB_0.config_dataB\[3\] FPGA_INST.cell3.CB_0.config_dataB\[4\]
+ net288 vssd1 vssd1 vccd1 vccd1 _01463_ sky130_fd_sc_hd__mux2_1
XTAP_TAPCELL_ROW_11_435 vssd1 vccd1 sky130_fd_sc_hd__tapvpwrvgnd_1
XFILLER_114_309 vssd1 vssd1 vccd1 vccd1 sky130_fd_sc_hd__fill_1
XFILLER_5_455 vssd1 vssd1 vccd1 vccd1 sky130_fd_sc_hd__fill_1
XPHY_EDGE_ROW_79_Left_210 vssd1 vssd1 vccd1 vccd1 sky130_fd_sc_hd__decap_3
XTAP_TAPCELL_ROW_56_1064 vssd1 vccd1 sky130_fd_sc_hd__tapvpwrvgnd_1
X_11205_ net764 _00555_ net549 vssd1 vssd1 vccd1 vccd1 FPGA_INST.cell0.SB0.route_sel\[50\]
+ sky130_fd_sc_hd__dfstp_1
X_11136_ net816 _00486_ net601 vssd1 vssd1 vccd1 vccd1 FPGA_INST.cell1.CB_1.config_dataB\[6\]
+ sky130_fd_sc_hd__dfstp_1
XANTENNA__08772__A1 net24 vssd1 vssd1 vccd1 vccd1 sky130_fd_sc_hd__diode_2
XANTENNA__07575__A2 _03775_ vssd1 vssd1 vccd1 vccd1 sky130_fd_sc_hd__diode_2
XFILLER_49_621 vssd1 vssd1 vccd1 vccd1 sky130_fd_sc_hd__fill_1
X_11067_ net836 _00417_ net620 vssd1 vssd1 vccd1 vccd1 FPGA_INST.cell1.LE_0A.config_data\[2\]
+ sky130_fd_sc_hd__dfrtp_1
XFILLER_110_559 vssd1 vssd1 vccd1 vccd1 sky130_fd_sc_hd__fill_1
XFILLER_49_654 vssd1 vssd1 vccd1 vccd1 sky130_fd_sc_hd__fill_2
XFILLER_0_193 vssd1 vssd1 vccd1 vccd1 sky130_fd_sc_hd__fill_2
X_10018_ FPGA_INST.cell0.CB_0.config_dataA\[18\] FPGA_INST.cell0.CB_0.config_dataA\[17\]
+ net316 vssd1 vssd1 vccd1 vccd1 _00899_ sky130_fd_sc_hd__mux2_1
XFILLER_36_326 vssd1 vssd1 vccd1 vccd1 sky130_fd_sc_hd__fill_2
XANTENNA__05889__A2 net11 vssd1 vssd1 vccd1 vccd1 sky130_fd_sc_hd__diode_2
XTAP_TAPCELL_ROW_19_546 vssd1 vccd1 sky130_fd_sc_hd__tapvpwrvgnd_1
XANTENNA__09730__S net230 vssd1 vssd1 vccd1 vccd1 sky130_fd_sc_hd__diode_2
X_11969_ net847 _01315_ net632 vssd1 vssd1 vccd1 vccd1 FPGA_INST.cell2.SB0.route_sel\[9\]
+ sky130_fd_sc_hd__dfstp_1
X_05490_ FPGA_INST.cell3.LE_0A.config_data\[16\] vssd1 vssd1 vccd1 vccd1 _01772_ sky130_fd_sc_hd__inv_2
XANTENNA__06302__A3 net17 vssd1 vssd1 vccd1 vccd1 sky130_fd_sc_hd__diode_2
XFILLER_81_3 vccd1 vssd1 vccd1 vssd1 sky130_ef_sc_hd__decap_40_12
XTAP_TAPCELL_ROW_30_700 vssd1 vccd1 sky130_fd_sc_hd__tapvpwrvgnd_1
XFILLER_32_587 vssd1 vssd1 vccd1 vccd1 sky130_fd_sc_hd__fill_1
X_07160_ FPGA_INST.cell3.SB0.route_sel\[2\] FPGA_INST.cell3.SB0.route_sel\[3\] vssd1
+ vssd1 vccd1 vccd1 _03424_ sky130_fd_sc_hd__nand2_1
X_06111_ FPGA_INST.cell0.SB0.route_sel\[20\] _01708_ _01709_ FPGA_INST.cell0.SB0.route_sel\[23\]
+ _02390_ vssd1 vssd1 vccd1 vccd1 _02391_ sky130_fd_sc_hd__a221o_1
XFILLER_9_794 vssd1 vssd1 vccd1 vccd1 sky130_fd_sc_hd__fill_1
X_07091_ _02309_ _03352_ _03353_ _02270_ _01738_ vssd1 vssd1 vccd1 vccd1 _03357_ sky130_fd_sc_hd__a221o_1
XANTENNA__08832__A1_N _04828_ vssd1 vssd1 vccd1 vccd1 sky130_fd_sc_hd__diode_2
X_06042_ net163 _02207_ vssd1 vssd1 vccd1 vccd1 _02322_ sky130_fd_sc_hd__nand2_1
Xfanout228 net229 vssd1 vssd1 vccd1 vccd1 net228 sky130_fd_sc_hd__clkbuf_4
Xfanout217 net218 vssd1 vssd1 vccd1 vccd1 net217 sky130_fd_sc_hd__clkbuf_4
X_09801_ FPGA_INST.cell1.LE_1B.config_data\[1\] FPGA_INST.cell1.LE_1B.config_data\[2\]
+ net218 vssd1 vssd1 vccd1 vccd1 _00710_ sky130_fd_sc_hd__mux2_1
Xfanout206 net219 vssd1 vssd1 vccd1 vccd1 net206 sky130_fd_sc_hd__clkbuf_2
XANTENNA__06369__A3 net13 vssd1 vssd1 vccd1 vccd1 sky130_fd_sc_hd__diode_2
X_07993_ _04220_ _04185_ _04183_ vssd1 vssd1 vccd1 vccd1 _04221_ sky130_fd_sc_hd__mux2_1
XFILLER_115_39 vccd1 vssd1 vccd1 vssd1 sky130_ef_sc_hd__decap_40_12
X_09732_ FPGA_INST.cell1.CB_0.config_dataA\[8\] FPGA_INST.cell1.CB_0.config_dataA\[7\]
+ net344 vssd1 vssd1 vccd1 vccd1 _00641_ sky130_fd_sc_hd__mux2_1
Xfanout239 net241 vssd1 vssd1 vccd1 vccd1 net239 sky130_fd_sc_hd__buf_2
X_06944_ net416 _02191_ _03211_ vssd1 vssd1 vccd1 vccd1 _03212_ sky130_fd_sc_hd__a21o_1
XANTENNA_fanout273_A net285 vssd1 vssd1 vccd1 vccd1 sky130_fd_sc_hd__diode_2
XTAP_TAPCELL_ROW_87_1503 vssd1 vccd1 sky130_fd_sc_hd__tapvpwrvgnd_1
XFILLER_82_410 vssd1 vssd1 vccd1 vccd1 sky130_fd_sc_hd__fill_1
X_09663_ FPGA_INST.cell0.SB0.route_sel\[66\] FPGA_INST.cell0.SB0.route_sel\[67\] net188
+ vssd1 vssd1 vccd1 vccd1 _00572_ sky130_fd_sc_hd__mux2_1
X_06875_ net425 _02350_ vssd1 vssd1 vccd1 vccd1 _03143_ sky130_fd_sc_hd__nand2_1
XTAP_TAPCELL_ROW_38_811 vssd1 vccd1 sky130_fd_sc_hd__tapvpwrvgnd_1
XFILLER_39_164 vssd1 vssd1 vccd1 vccd1 sky130_fd_sc_hd__fill_4
X_09594_ FPGA_INST.cell1.CB_1.config_dataB\[22\] FPGA_INST.cell1.CB_1.config_dataB\[23\]
+ net211 vssd1 vssd1 vccd1 vccd1 _00503_ sky130_fd_sc_hd__mux2_1
X_08614_ _03583_ _04821_ vssd1 vssd1 vccd1 vccd1 _04823_ sky130_fd_sc_hd__or2_1
X_05826_ FPGA_INST.cell0.SB0.route_sel\[72\] FPGA_INST.cell0.SB0.route_sel\[73\] _02103_
+ _02105_ net313 vssd1 vssd1 vccd1 vccd1 _02106_ sky130_fd_sc_hd__a311o_1
XFILLER_27_348 vssd1 vssd1 vccd1 vccd1 sky130_fd_sc_hd__fill_4
X_08545_ FPGA_INST.cell3.LE_1B.config_data\[0\] FPGA_INST.cell3.LE_1B.config_data\[1\]
+ _04755_ vssd1 vssd1 vccd1 vccd1 _04756_ sky130_fd_sc_hd__mux2_1
X_05757_ FPGA_INST.cell2.CB_1.config_dataB\[22\] FPGA_INST.cell2.CB_1.config_dataB\[23\]
+ vssd1 vssd1 vccd1 vccd1 _02037_ sky130_fd_sc_hd__nand2b_1
XFILLER_35_370 vssd1 vssd1 vccd1 vccd1 sky130_fd_sc_hd__fill_1
X_08476_ FPGA_INST.cell1.LEI0.config_data\[11\] _04690_ _04691_ FPGA_INST.cell1.CB_1.config_dataB\[4\]
+ vssd1 vssd1 vccd1 vccd1 _04692_ sky130_fd_sc_hd__o211ai_4
X_05688_ FPGA_INST.cell0.CB_0.config_dataA\[24\] FPGA_INST.cell0.CB_0.config_dataA\[21\]
+ FPGA_INST.cell0.CB_0.config_dataA\[20\] vssd1 vssd1 vccd1 vccd1 _01968_ sky130_fd_sc_hd__or3b_4
X_07427_ _03507_ _03607_ net141 vssd1 vssd1 vccd1 vccd1 _03685_ sky130_fd_sc_hd__o21ai_1
XFILLER_11_727 vssd1 vssd1 vccd1 vccd1 sky130_fd_sc_hd__fill_1
X_07358_ _01689_ _03617_ _03616_ _02281_ vssd1 vssd1 vccd1 vccd1 _03618_ sky130_fd_sc_hd__or4b_1
XTAP_TAPCELL_ROW_98_1654 vssd1 vccd1 sky130_fd_sc_hd__tapvpwrvgnd_1
X_06309_ _02293_ _02574_ _02575_ _02330_ vssd1 vssd1 vccd1 vccd1 _02589_ sky130_fd_sc_hd__a22o_1
XFILLER_40_24 vssd1 vssd1 vccd1 vccd1 sky130_fd_sc_hd__fill_4
XFILLER_108_158 vssd1 vssd1 vccd1 vccd1 sky130_fd_sc_hd__fill_2
X_07289_ _03400_ _03548_ vssd1 vssd1 vccd1 vccd1 _03550_ sky130_fd_sc_hd__nand2_1
XANTENNA_fanout695_X net695 vssd1 vssd1 vccd1 vccd1 sky130_fd_sc_hd__diode_2
X_09028_ FPGA_INST.cell3.SB0.route_sel\[14\] FPGA_INST.cell3.SB0.route_sel\[15\] vssd1
+ vssd1 vccd1 vccd1 _05192_ sky130_fd_sc_hd__nor2_1
XFILLER_2_414 vssd1 vssd1 vccd1 vccd1 sky130_fd_sc_hd__fill_4
XANTENNA__08203__A0 FPGA_INST.bus1_0\[8\] vssd1 vssd1 vccd1 vccd1 sky130_fd_sc_hd__diode_2
XANTENNA__07006__A1 FPGA_INST.bus2_0\[14\] vssd1 vssd1 vccd1 vccd1 sky130_fd_sc_hd__diode_2
Xfanout740 net12 vssd1 vssd1 vccd1 vccd1 net740 sky130_fd_sc_hd__clkbuf_2
XFILLER_77_237 vssd1 vssd1 vccd1 vccd1 sky130_fd_sc_hd__fill_2
XANTENNA_fanout862_X net862 vssd1 vssd1 vccd1 vccd1 sky130_fd_sc_hd__diode_2
Xfanout751 net753 vssd1 vssd1 vccd1 vccd1 net751 sky130_fd_sc_hd__clkbuf_2
XANTENNA__08506__A1 net84 vssd1 vssd1 vccd1 vccd1 sky130_fd_sc_hd__diode_2
XFILLER_93_719 vssd1 vssd1 vccd1 vccd1 sky130_fd_sc_hd__fill_4
Xfanout784 net789 vssd1 vssd1 vccd1 vccd1 net784 sky130_fd_sc_hd__clkbuf_2
Xfanout762 net769 vssd1 vssd1 vccd1 vccd1 net762 sky130_fd_sc_hd__dlymetal6s2s_1
Xfanout773 net775 vssd1 vssd1 vccd1 vccd1 net773 sky130_fd_sc_hd__clkbuf_2
XFILLER_1_18 vccd1 vssd1 vccd1 vssd1 sky130_ef_sc_hd__decap_40_12
XANTENNA__07843__B _02376_ vssd1 vssd1 vccd1 vccd1 sky130_fd_sc_hd__diode_2
XTAP_TAPCELL_ROW_125_2039 vssd1 vccd1 sky130_fd_sc_hd__tapvpwrvgnd_1
XTAP_TAPCELL_ROW_125_2028 vssd1 vccd1 sky130_fd_sc_hd__tapvpwrvgnd_1
Xfanout795 net796 vssd1 vssd1 vccd1 vccd1 net795 sky130_fd_sc_hd__clkbuf_2
XFILLER_58_473 vssd1 vssd1 vccd1 vccd1 sky130_fd_sc_hd__fill_2
XFILLER_46_602 vssd1 vssd1 vccd1 vccd1 sky130_fd_sc_hd__fill_1
X_11823_ net932 _01169_ net716 vssd1 vssd1 vccd1 vccd1 FPGA_INST.cell3.LEI0.config_data\[3\]
+ sky130_fd_sc_hd__dfrtp_1
XFILLER_45_178 vssd1 vssd1 vccd1 vccd1 sky130_fd_sc_hd__fill_2
XFILLER_45_156 vssd1 vssd1 vccd1 vccd1 sky130_fd_sc_hd__fill_2
XTAP_TAPCELL_ROW_16_505 vssd1 vccd1 sky130_fd_sc_hd__tapvpwrvgnd_1
XTAP_TAPCELL_ROW_107_1783 vssd1 vccd1 sky130_fd_sc_hd__tapvpwrvgnd_1
XANTENNA__05740__B2 _01825_ vssd1 vssd1 vccd1 vccd1 sky130_fd_sc_hd__diode_2
XFILLER_81_31 vssd1 vssd1 vccd1 vccd1 sky130_fd_sc_hd__fill_2
X_11754_ net900 _01100_ net684 vssd1 vssd1 vccd1 vccd1 FPGA_INST.cell3.SB0.route_sel\[124\]
+ sky130_fd_sc_hd__dfstp_2
XTAP_TAPCELL_ROW_120_1961 vssd1 vccd1 sky130_fd_sc_hd__tapvpwrvgnd_1
XANTENNA__08690__A0 net18 vssd1 vssd1 vccd1 vccd1 sky130_fd_sc_hd__diode_2
X_11685_ net898 _01031_ net682 vssd1 vssd1 vccd1 vccd1 FPGA_INST.cell3.SB0.route_sel\[55\]
+ sky130_fd_sc_hd__dfstp_1
XANTENNA__07493__A1 net147 vssd1 vssd1 vccd1 vccd1 sky130_fd_sc_hd__diode_2
XFILLER_41_373 vssd1 vssd1 vccd1 vccd1 sky130_fd_sc_hd__fill_1
X_10705_ net846 _00055_ net631 vssd1 vssd1 vccd1 vccd1 FPGA_INST.cell2.LE_0A.config_data\[4\]
+ sky130_fd_sc_hd__dfrtp_1
XANTENNA__06296__A2 net11 vssd1 vssd1 vccd1 vccd1 sky130_fd_sc_hd__diode_2
X_10636_ FPGA_INST.cell3.LE_1B.config_data\[5\] FPGA_INST.cell3.LE_1B.config_data\[6\]
+ net280 vssd1 vssd1 vccd1 vccd1 _01515_ sky130_fd_sc_hd__mux2_1
XFILLER_41_395 vssd1 vssd1 vccd1 vccd1 sky130_fd_sc_hd__fill_1
X_10567_ FPGA_INST.cell3.CB_0.config_dataA\[12\] net396 net374 vssd1 vssd1 vccd1 vccd1
+ _01446_ sky130_fd_sc_hd__mux2_1
XFILLER_6_742 vccd1 vssd1 vccd1 vssd1 sky130_ef_sc_hd__decap_40_12
XANTENNA__05819__A net165 vssd1 vssd1 vccd1 vccd1 sky130_fd_sc_hd__diode_2
XFILLER_6_797 vssd1 vssd1 vccd1 vccd1 sky130_fd_sc_hd__fill_2
X_10498_ FPGA_INST.cell2.SB0.route_sel\[70\] FPGA_INST.cell2.SB0.route_sel\[71\] net248
+ vssd1 vssd1 vccd1 vccd1 _01377_ sky130_fd_sc_hd__mux2_1
XANTENNA__09725__S net344 vssd1 vssd1 vccd1 vccd1 sky130_fd_sc_hd__diode_2
X_12168_ net910 _01514_ net694 vssd1 vssd1 vccd1 vccd1 FPGA_INST.cell3.LE_1B.config_data\[5\]
+ sky130_fd_sc_hd__dfrtp_1
XFILLER_96_535 vssd1 vssd1 vccd1 vccd1 sky130_fd_sc_hd__fill_1
XFILLER_69_738 vssd1 vssd1 vccd1 vccd1 sky130_fd_sc_hd__fill_4
X_12099_ net927 _01445_ net711 vssd1 vssd1 vccd1 vccd1 FPGA_INST.cell3.CB_0.config_dataA\[11\]
+ sky130_fd_sc_hd__dfstp_1
X_11119_ net793 _00469_ net578 vssd1 vssd1 vccd1 vccd1 FPGA_INST.cell1.LE_1A.config_data\[10\]
+ sky130_fd_sc_hd__dfrtp_1
Xinput6 gpio_in[14] vssd1 vssd1 vccd1 vccd1 net6 sky130_fd_sc_hd__clkbuf_4
XTAP_TAPCELL_ROW_69_1255 vssd1 vccd1 sky130_fd_sc_hd__tapvpwrvgnd_1
XTAP_TAPCELL_ROW_69_1244 vssd1 vccd1 sky130_fd_sc_hd__tapvpwrvgnd_1
X_06660_ net475 _02796_ _02935_ vssd1 vssd1 vccd1 vccd1 _02936_ sky130_fd_sc_hd__a21o_1
XFILLER_91_251 vssd1 vssd1 vccd1 vccd1 sky130_fd_sc_hd__fill_1
X_05611_ _01585_ _01586_ FPGA_INST.cell2.SB0.route_sel\[122\] FPGA_INST.cell2.SB0.route_sel\[123\]
+ vssd1 vssd1 vccd1 vccd1 _01891_ sky130_fd_sc_hd__o211a_1
XFILLER_36_145 vssd1 vssd1 vccd1 vccd1 sky130_fd_sc_hd__fill_2
XFILLER_36_156 vssd1 vssd1 vccd1 vccd1 sky130_fd_sc_hd__fill_4
XFILLER_91_273 vssd1 vssd1 vccd1 vccd1 sky130_fd_sc_hd__fill_4
X_06591_ FPGA_INST.bus3_2\[4\] FPGA_INST.bus3_2\[5\] FPGA_INST.bus3_2\[6\] FPGA_INST.bus3_2\[7\]
+ net484 net482 vssd1 vssd1 vccd1 vccd1 _02867_ sky130_fd_sc_hd__mux4_1
XFILLER_51_126 vssd1 vssd1 vccd1 vccd1 sky130_fd_sc_hd__fill_1
XTAP_TAPCELL_ROW_82_1433 vssd1 vccd1 sky130_fd_sc_hd__tapvpwrvgnd_1
X_08330_ net447 _04550_ _04551_ vssd1 vssd1 vccd1 vccd1 _04552_ sky130_fd_sc_hd__a21oi_1
X_05542_ FPGA_INST.cell0.CB_1.config_dataB\[22\] FPGA_INST.cell0.CB_1.config_dataB\[23\]
+ vssd1 vssd1 vccd1 vccd1 _01822_ sky130_fd_sc_hd__nand2_1
XFILLER_32_340 vssd1 vssd1 vccd1 vccd1 sky130_fd_sc_hd__fill_1
X_05473_ FPGA_INST.cell0.CB_1.config_dataA\[17\] vssd1 vssd1 vccd1 vccd1 _01755_ sky130_fd_sc_hd__inv_2
X_08261_ net403 _03558_ vssd1 vssd1 vccd1 vccd1 _04485_ sky130_fd_sc_hd__nand2_1
XTAP_TAPCELL_ROW_43_880 vssd1 vccd1 sky130_fd_sc_hd__tapvpwrvgnd_1
XFILLER_20_524 vssd1 vssd1 vccd1 vccd1 sky130_fd_sc_hd__fill_8
X_07212_ _03460_ _03472_ _03474_ net342 vssd1 vssd1 vccd1 vccd1 _03475_ sky130_fd_sc_hd__a211o_4
XTAP_TAPCELL_ROW_43_891 vssd1 vccd1 sky130_fd_sc_hd__tapvpwrvgnd_1
X_08192_ net410 _03504_ _04415_ net408 vssd1 vssd1 vccd1 vccd1 _04416_ sky130_fd_sc_hd__o211a_1
XANTENNA__07487__Y FPGA_INST.bus3_2\[7\] vssd1 vssd1 vccd1 vccd1 sky130_fd_sc_hd__diode_2
X_07143_ _01724_ FPGA_INST.cell0.SB0.route_sel\[7\] vssd1 vssd1 vccd1 vccd1 _03407_
+ sky130_fd_sc_hd__or2_1
XFILLER_10_27 vssd1 vssd1 vccd1 vccd1 sky130_fd_sc_hd__fill_1
XANTENNA_fanout119_A net122 vssd1 vssd1 vccd1 vccd1 sky130_fd_sc_hd__diode_2
X_07074_ _03334_ _03335_ _03339_ vssd1 vssd1 vccd1 vccd1 _03340_ sky130_fd_sc_hd__o21a_1
X_06025_ _02296_ _02304_ _02298_ _02295_ vssd1 vssd1 vccd1 vccd1 _02305_ sky130_fd_sc_hd__o211a_1
XANTENNA__08736__A1 _04794_ vssd1 vssd1 vccd1 vccd1 sky130_fd_sc_hd__diode_2
XANTENNA__08736__B2 _04789_ vssd1 vssd1 vccd1 vccd1 sky130_fd_sc_hd__diode_2
XTAP_TAPCELL_ROW_93_1584 vssd1 vccd1 sky130_fd_sc_hd__tapvpwrvgnd_1
XFILLER_114_695 vssd1 vssd1 vccd1 vccd1 sky130_fd_sc_hd__fill_4
XFILLER_113_194 vssd1 vssd1 vccd1 vccd1 sky130_fd_sc_hd__fill_4
X_07976_ FPGA_INST.bus3_1\[12\] FPGA_INST.bus3_1\[13\] FPGA_INST.bus3_1\[14\] FPGA_INST.bus3_1\[15\]
+ net463 net462 vssd1 vssd1 vccd1 vccd1 _04204_ sky130_fd_sc_hd__mux4_1
XFILLER_87_557 vssd1 vssd1 vccd1 vccd1 sky130_fd_sc_hd__fill_1
XFILLER_19_25 vssd1 vssd1 vccd1 vccd1 sky130_fd_sc_hd__fill_1
XFILLER_68_782 vssd1 vssd1 vccd1 vccd1 sky130_fd_sc_hd__fill_8
XFILLER_55_410 vssd1 vssd1 vccd1 vccd1 sky130_fd_sc_hd__fill_2
X_09715_ FPGA_INST.cell0.SB0.route_sel\[118\] FPGA_INST.cell0.SB0.route_sel\[119\]
+ net197 vssd1 vssd1 vccd1 vccd1 _00624_ sky130_fd_sc_hd__mux2_1
X_06927_ _01747_ _03164_ _03188_ _03192_ _03194_ vssd1 vssd1 vccd1 vccd1 _03195_ sky130_fd_sc_hd__o311a_1
X_09646_ FPGA_INST.cell0.SB0.route_sel\[49\] FPGA_INST.cell0.SB0.route_sel\[50\] net185
+ vssd1 vssd1 vccd1 vccd1 _00555_ sky130_fd_sc_hd__mux2_1
XFILLER_70_402 vssd1 vssd1 vccd1 vccd1 sky130_fd_sc_hd__fill_2
XFILLER_15_307 vssd1 vssd1 vccd1 vccd1 sky130_fd_sc_hd__fill_1
XFILLER_27_167 vssd1 vssd1 vccd1 vccd1 sky130_fd_sc_hd__fill_1
X_06858_ net424 _02070_ _03125_ vssd1 vssd1 vccd1 vccd1 _03126_ sky130_fd_sc_hd__a21o_1
X_09577_ FPGA_INST.cell1.CB_1.config_dataB\[5\] FPGA_INST.cell1.CB_1.config_dataB\[6\]
+ net217 vssd1 vssd1 vccd1 vccd1 _00486_ sky130_fd_sc_hd__mux2_1
X_06789_ _02793_ _02797_ net512 vssd1 vssd1 vccd1 vccd1 _03063_ sky130_fd_sc_hd__mux2_1
XFILLER_43_627 vssd1 vssd1 vccd1 vccd1 sky130_fd_sc_hd__fill_8
X_05809_ net246 _02081_ _02088_ vssd1 vssd1 vccd1 vccd1 _02089_ sky130_fd_sc_hd__and3_1
X_08528_ FPGA_INST.cell3.LE_1A.config_data\[8\] FPGA_INST.cell3.LE_1A.config_data\[9\]
+ _04725_ vssd1 vssd1 vccd1 vccd1 _04741_ sky130_fd_sc_hd__mux2_1
XFILLER_35_68 vssd1 vssd1 vccd1 vccd1 sky130_fd_sc_hd__fill_2
XFILLER_35_79 vssd1 vssd1 vccd1 vccd1 sky130_fd_sc_hd__fill_4
X_08459_ FPGA_INST.cell1.LE_1A.config_data\[14\] FPGA_INST.cell1.LE_1A.config_data\[15\]
+ _04660_ vssd1 vssd1 vccd1 vccd1 _04677_ sky130_fd_sc_hd__mux2_1
XFILLER_51_671 vssd1 vssd1 vccd1 vccd1 sky130_fd_sc_hd__fill_1
XFILLER_11_546 vssd1 vssd1 vccd1 vccd1 sky130_fd_sc_hd__fill_1
XPHY_EDGE_ROW_14_Right_14 vssd1 vssd1 vccd1 vccd1 sky130_fd_sc_hd__decap_3
XANTENNA__08714__S _04860_ vssd1 vssd1 vccd1 vccd1 sky130_fd_sc_hd__diode_2
XFILLER_51_78 vssd1 vssd1 vccd1 vccd1 sky130_fd_sc_hd__fill_1
X_11470_ net742 _00820_ net527 vssd1 vssd1 vccd1 vccd1 FPGA_INST.cell0.LE_0B.reset_mode
+ sky130_fd_sc_hd__dfrtp_1
X_10421_ FPGA_INST.cell3.CB_1.config_dataB\[18\] FPGA_INST.cell3.CB_1.config_dataB\[19\]
+ net281 vssd1 vssd1 vccd1 vccd1 _01300_ sky130_fd_sc_hd__mux2_1
XTAP_TAPCELL_ROW_21_574 vssd1 vccd1 sky130_fd_sc_hd__tapvpwrvgnd_1
XFILLER_109_489 vssd1 vssd1 vccd1 vccd1 sky130_fd_sc_hd__fill_2
X_10352_ FPGA_INST.cell3.LE_0A.config_data\[16\] FPGA_INST.cell3.LE_0A.edge_mode net294
+ vssd1 vssd1 vccd1 vccd1 _01233_ sky130_fd_sc_hd__mux2_1
XANTENNA__05639__A FPGA_INST.cell0.CB_0.le_outA vssd1 vssd1 vccd1 vccd1 sky130_fd_sc_hd__diode_2
XFILLER_2_255 vssd1 vssd1 vccd1 vccd1 sky130_fd_sc_hd__fill_1
X_10283_ net42 net43 net254 vssd1 vssd1 vccd1 vccd1 _01164_ sky130_fd_sc_hd__mux2_1
X_12022_ net847 _01368_ net632 vssd1 vssd1 vccd1 vccd1 FPGA_INST.cell2.SB0.route_sel\[62\]
+ sky130_fd_sc_hd__dfstp_1
XFILLER_78_546 vssd1 vssd1 vccd1 vccd1 sky130_fd_sc_hd__fill_8
XTAP_TAPCELL_ROW_53_1023 vssd1 vccd1 sky130_fd_sc_hd__tapvpwrvgnd_1
XPHY_EDGE_ROW_23_Right_23 vssd1 vssd1 vccd1 vccd1 sky130_fd_sc_hd__decap_3
XFILLER_120_643 vssd1 vssd1 vccd1 vccd1 sky130_fd_sc_hd__fill_1
XFILLER_93_505 vssd1 vssd1 vccd1 vccd1 sky130_fd_sc_hd__fill_4
XTAP_TAPCELL_ROW_109_1812 vssd1 vccd1 sky130_fd_sc_hd__tapvpwrvgnd_1
Xfanout592 net596 vssd1 vssd1 vccd1 vccd1 net592 sky130_fd_sc_hd__buf_2
Xfanout581 net588 vssd1 vssd1 vccd1 vccd1 net581 sky130_fd_sc_hd__clkbuf_2
Xfanout570 net573 vssd1 vssd1 vccd1 vccd1 net570 sky130_fd_sc_hd__clkbuf_4
XFILLER_74_741 vccd1 vssd1 vccd1 vssd1 sky130_ef_sc_hd__decap_40_12
XFILLER_46_421 vssd1 vssd1 vccd1 vccd1 sky130_fd_sc_hd__fill_2
XFILLER_61_402 vssd1 vssd1 vccd1 vccd1 sky130_fd_sc_hd__fill_4
XFILLER_18_167 vssd1 vssd1 vccd1 vccd1 sky130_fd_sc_hd__fill_1
XFILLER_74_796 vssd1 vssd1 vccd1 vccd1 sky130_fd_sc_hd__fill_2
XTAP_TAPCELL_ROW_29_685 vssd1 vccd1 sky130_fd_sc_hd__tapvpwrvgnd_1
X_11806_ net869 _01152_ net654 vssd1 vssd1 vccd1 vccd1 net44 sky130_fd_sc_hd__dfrtp_1
XPHY_EDGE_ROW_32_Right_32 vssd1 vssd1 vccd1 vccd1 sky130_fd_sc_hd__decap_3
XANTENNA__08663__A0 _04819_ vssd1 vssd1 vccd1 vccd1 sky130_fd_sc_hd__diode_2
X_11737_ net897 _01083_ net681 vssd1 vssd1 vccd1 vccd1 FPGA_INST.cell3.SB0.route_sel\[107\]
+ sky130_fd_sc_hd__dfstp_1
XTAP_TAPCELL_ROW_64_1185 vssd1 vccd1 sky130_fd_sc_hd__tapvpwrvgnd_1
XTAP_TAPCELL_ROW_64_1174 vssd1 vccd1 sky130_fd_sc_hd__tapvpwrvgnd_1
XANTENNA__06269__A2 net11 vssd1 vssd1 vccd1 vccd1 sky130_fd_sc_hd__diode_2
X_11668_ net906 _01014_ net690 vssd1 vssd1 vccd1 vccd1 FPGA_INST.cell3.SB0.route_sel\[38\]
+ sky130_fd_sc_hd__dfstp_1
XFILLER_128_743 vssd1 vssd1 vccd1 vccd1 sky130_fd_sc_hd__fill_4
X_10619_ FPGA_INST.cell3.CB_1.config_dataA\[13\] FPGA_INST.cell3.CB_1.config_dataA\[14\]
+ net299 vssd1 vssd1 vccd1 vccd1 _01498_ sky130_fd_sc_hd__mux2_1
XFILLER_127_231 vssd1 vssd1 vccd1 vccd1 sky130_fd_sc_hd__fill_1
X_11599_ net799 _00949_ net584 vssd1 vssd1 vccd1 vccd1 FPGA_INST.cell0.CB_1.config_dataA\[18\]
+ sky130_fd_sc_hd__dfstp_1
XFILLER_115_437 vssd1 vssd1 vccd1 vccd1 sky130_fd_sc_hd__fill_2
XPHY_EDGE_ROW_41_Right_41 vssd1 vssd1 vccd1 vccd1 sky130_fd_sc_hd__decap_3
XFILLER_111_610 vssd1 vssd1 vccd1 vccd1 sky130_fd_sc_hd__fill_4
XFILLER_69_557 vssd1 vssd1 vccd1 vccd1 sky130_fd_sc_hd__fill_1
XANTENNA__08194__A2 net74 vssd1 vssd1 vccd1 vccd1 sky130_fd_sc_hd__diode_2
XANTENNA__09027__Y FPGA_INST.bus2_0\[1\] vssd1 vssd1 vccd1 vccd1 sky130_fd_sc_hd__diode_2
X_07830_ net126 _02131_ _02122_ vssd1 vssd1 vccd1 vccd1 _04068_ sky130_fd_sc_hd__mux2_1
XANTENNA__07941__A2 FPGA_INST.bus3_1\[10\] vssd1 vssd1 vccd1 vccd1 sky130_fd_sc_hd__diode_2
X_07761_ FPGA_INST.cell1.SB0.route_sel\[114\] FPGA_INST.cell1.SB0.route_sel\[115\]
+ vssd1 vssd1 vccd1 vccd1 _04011_ sky130_fd_sc_hd__or2_1
XPHY_EDGE_ROW_16_Left_147 vssd1 vssd1 vccd1 vccd1 sky130_fd_sc_hd__decap_3
X_09500_ FPGA_INST.cell1.LEI0.config_data\[46\] FPGA_INST.cell1.CB_0.config_data_inA
+ net210 vssd1 vssd1 vccd1 vccd1 _00412_ sky130_fd_sc_hd__mux2_1
X_06712_ FPGA_INST.cell2.LEI0.config_data\[9\] net103 vssd1 vssd1 vccd1 vccd1 _02986_
+ sky130_fd_sc_hd__nand2_1
XFILLER_49_281 vssd1 vssd1 vccd1 vccd1 sky130_fd_sc_hd__fill_4
XFILLER_112_29 vssd1 vssd1 vccd1 vccd1 sky130_fd_sc_hd__fill_8
X_07692_ FPGA_INST.cell3.SB0.route_sel\[96\] FPGA_INST.cell3.SB0.route_sel\[97\] vssd1
+ vssd1 vccd1 vccd1 _03944_ sky130_fd_sc_hd__or2_1
XFILLER_65_785 vssd1 vssd1 vccd1 vccd1 sky130_fd_sc_hd__fill_2
XTAP_TAPCELL_ROW_48_961 vssd1 vccd1 sky130_fd_sc_hd__tapvpwrvgnd_1
XTAP_TAPCELL_ROW_48_950 vssd1 vccd1 sky130_fd_sc_hd__tapvpwrvgnd_1
XANTENNA__09190__S net266 vssd1 vssd1 vccd1 vccd1 sky130_fd_sc_hd__diode_2
X_06643_ _02843_ _02916_ _02918_ _02840_ FPGA_INST.cell2.CB_1.config_dataA\[17\] vssd1
+ vssd1 vccd1 vccd1 _02919_ sky130_fd_sc_hd__a221o_1
XPHY_EDGE_ROW_50_Right_50 vssd1 vssd1 vccd1 vccd1 sky130_fd_sc_hd__decap_3
XFILLER_25_638 vssd1 vssd1 vccd1 vccd1 sky130_fd_sc_hd__fill_2
X_09431_ FPGA_INST.cell2.LE_0A.reset_mode FPGA_INST.cell2.LE_1B.config_data\[0\] net257
+ vssd1 vssd1 vccd1 vccd1 _00344_ sky130_fd_sc_hd__mux2_1
XFILLER_80_766 vssd1 vssd1 vccd1 vccd1 sky130_fd_sc_hd__fill_4
X_06574_ net482 net483 vssd1 vssd1 vccd1 vccd1 _02850_ sky130_fd_sc_hd__and2b_1
X_09362_ net506 net505 net240 vssd1 vssd1 vccd1 vccd1 _00275_ sky130_fd_sc_hd__mux2_1
X_05525_ FPGA_INST.config_bits\[9\] FPGA_INST.config_bits\[8\] FPGA_INST.config_bits\[10\]
+ vssd1 vssd1 vccd1 vccd1 _01807_ sky130_fd_sc_hd__o21a_1
X_08313_ FPGA_INST.cell0.CB_1.config_dataB\[8\] _04534_ vssd1 vssd1 vccd1 vccd1 _04535_
+ sky130_fd_sc_hd__nor2_1
XFILLER_33_660 vssd1 vssd1 vccd1 vccd1 sky130_fd_sc_hd__fill_1
X_09293_ FPGA_INST.cell1.SB0.route_sel\[64\] FPGA_INST.cell1.SB0.route_sel\[65\] net222
+ vssd1 vssd1 vccd1 vccd1 _00206_ sky130_fd_sc_hd__mux2_1
XFILLER_20_332 vssd1 vssd1 vccd1 vccd1 sky130_fd_sc_hd__fill_1
XFILLER_32_192 vssd1 vssd1 vccd1 vccd1 sky130_fd_sc_hd__fill_4
XANTENNA__11511__SET_B net554 vssd1 vssd1 vccd1 vccd1 sky130_fd_sc_hd__diode_2
X_05456_ FPGA_INST.cell0.CB_0.config_dataA\[17\] vssd1 vssd1 vccd1 vccd1 _01738_ sky130_fd_sc_hd__inv_2
X_08244_ net114 net118 net110 net98 FPGA_INST.cell0.LEI0.config_data\[30\] FPGA_INST.cell0.LEI0.config_data\[31\]
+ vssd1 vssd1 vccd1 vccd1 _04468_ sky130_fd_sc_hd__mux4_1
XPHY_EDGE_ROW_25_Left_156 vssd1 vssd1 vccd1 vccd1 sky130_fd_sc_hd__decap_3
XTAP_TAPCELL_ROW_95_1613 vssd1 vccd1 sky130_fd_sc_hd__tapvpwrvgnd_1
X_08175_ net75 FPGA_INST.bus1_0\[5\] net74 FPGA_INST.bus1_0\[7\] net412 FPGA_INST.cell0.CB_1.config_dataA\[1\]
+ vssd1 vssd1 vccd1 vccd1 _04399_ sky130_fd_sc_hd__mux4_1
X_05387_ FPGA_INST.cell0.SB0.route_sel\[57\] vssd1 vssd1 vccd1 vccd1 _01669_ sky130_fd_sc_hd__inv_2
XFILLER_118_253 vssd1 vssd1 vccd1 vccd1 sky130_fd_sc_hd__fill_1
X_07126_ _03384_ _03391_ _03380_ vssd1 vssd1 vccd1 vccd1 _03392_ sky130_fd_sc_hd__mux2_1
XFILLER_106_448 vssd1 vssd1 vccd1 vccd1 sky130_fd_sc_hd__fill_1
XANTENNA__09365__S net240 vssd1 vssd1 vccd1 vccd1 sky130_fd_sc_hd__diode_2
X_07057_ _03316_ _03319_ _03321_ _03322_ vssd1 vssd1 vccd1 vccd1 _03323_ sky130_fd_sc_hd__o2bb2a_1
XANTENNA_fanout772_A net778 vssd1 vssd1 vccd1 vccd1 sky130_fd_sc_hd__diode_2
X_06008_ _02287_ _02276_ vssd1 vssd1 vccd1 vccd1 _02288_ sky130_fd_sc_hd__and2b_1
XANTENNA__06196__A1 net132 vssd1 vssd1 vccd1 vccd1 sky130_fd_sc_hd__diode_2
XPHY_EDGE_ROW_34_Left_165 vssd1 vssd1 vccd1 vccd1 sky130_fd_sc_hd__decap_3
XFILLER_102_698 vssd1 vssd1 vccd1 vccd1 sky130_fd_sc_hd__fill_2
XFILLER_102_676 vssd1 vssd1 vccd1 vccd1 sky130_fd_sc_hd__fill_4
XFILLER_87_365 vssd1 vssd1 vccd1 vccd1 sky130_fd_sc_hd__fill_1
X_07959_ net463 _03519_ _04186_ net462 vssd1 vssd1 vccd1 vccd1 _04187_ sky130_fd_sc_hd__o211a_1
XANTENNA__05943__B2 _01825_ vssd1 vssd1 vccd1 vccd1 sky130_fd_sc_hd__diode_2
XFILLER_28_421 vssd1 vssd1 vccd1 vccd1 sky130_fd_sc_hd__fill_8
X_10970_ net878 _00320_ net663 vssd1 vssd1 vccd1 vccd1 FPGA_INST.cell2.CB_1.config_dataA\[1\]
+ sky130_fd_sc_hd__dfstp_1
X_09629_ FPGA_INST.cell0.SB0.route_sel\[32\] FPGA_INST.cell0.SB0.route_sel\[33\] net196
+ vssd1 vssd1 vccd1 vccd1 _00538_ sky130_fd_sc_hd__mux2_1
XTAP_TAPCELL_ROW_104_1742 vssd1 vccd1 sky130_fd_sc_hd__tapvpwrvgnd_1
XFILLER_15_137 vssd1 vssd1 vccd1 vccd1 sky130_fd_sc_hd__fill_1
XTAP_TAPCELL_ROW_26_644 vssd1 vccd1 sky130_fd_sc_hd__tapvpwrvgnd_1
XPHY_EDGE_ROW_43_Left_174 vssd1 vssd1 vccd1 vccd1 sky130_fd_sc_hd__decap_3
X_11522_ net809 _00872_ net595 vssd1 vssd1 vccd1 vccd1 FPGA_INST.config_bits\[3\]
+ sky130_fd_sc_hd__dfstp_1
XFILLER_109_220 vssd1 vssd1 vccd1 vccd1 sky130_fd_sc_hd__fill_2
XANTENNA__08660__A3 net26 vssd1 vssd1 vccd1 vccd1 sky130_fd_sc_hd__diode_2
X_11453_ net750 _00803_ net535 vssd1 vssd1 vccd1 vccd1 FPGA_INST.cell0.LE_0B.config_data\[2\]
+ sky130_fd_sc_hd__dfrtp_1
X_10404_ FPGA_INST.cell3.CB_1.config_dataB\[2\] FPGA_INST.cell3.CB_1.config_dataB\[1\]
+ net370 vssd1 vssd1 vccd1 vccd1 _01283_ sky130_fd_sc_hd__mux2_1
XFILLER_125_735 vssd1 vssd1 vccd1 vccd1 sky130_fd_sc_hd__fill_1
XFILLER_124_234 vssd1 vssd1 vccd1 vccd1 sky130_fd_sc_hd__fill_1
XANTENNA__06959__A0 net115 vssd1 vssd1 vccd1 vccd1 sky130_fd_sc_hd__diode_2
X_11384_ net747 _00734_ net532 vssd1 vssd1 vccd1 vccd1 FPGA_INST.cell0.LEI0.config_data\[5\]
+ sky130_fd_sc_hd__dfrtp_1
XFILLER_124_267 vssd1 vssd1 vccd1 vccd1 sky130_fd_sc_hd__fill_1
X_10335_ FPGA_INST.cell2.SB0.config_data_out FPGA_INST.cell3.LE_0A.config_data\[0\]
+ net286 vssd1 vssd1 vccd1 vccd1 _01216_ sky130_fd_sc_hd__mux2_1
XFILLER_11_70 vssd1 vssd1 vccd1 vccd1 sky130_fd_sc_hd__fill_2
XTAP_TAPCELL_ROW_115_1893 vssd1 vccd1 sky130_fd_sc_hd__tapvpwrvgnd_1
XPHY_EDGE_ROW_52_Left_183 vssd1 vssd1 vccd1 vccd1 sky130_fd_sc_hd__decap_3
X_10266_ FPGA_INST.io_east_oeb\[20\] FPGA_INST.io_east_oeb\[22\] net257 vssd1 vssd1
+ vccd1 vccd1 _01147_ sky130_fd_sc_hd__mux2_1
XFILLER_78_321 vssd1 vssd1 vccd1 vccd1 sky130_fd_sc_hd__fill_2
X_12005_ net855 _01351_ net640 vssd1 vssd1 vccd1 vccd1 FPGA_INST.cell2.SB0.route_sel\[45\]
+ sky130_fd_sc_hd__dfstp_1
XANTENNA__07923__A2 _03728_ vssd1 vssd1 vccd1 vccd1 sky130_fd_sc_hd__diode_2
XANTENNA__07384__B1 net141 vssd1 vssd1 vccd1 vccd1 sky130_fd_sc_hd__diode_2
XANTENNA__08967__X FPGA_INST.bus3_1\[8\] vssd1 vssd1 vccd1 vccd1 sky130_fd_sc_hd__diode_2
X_10197_ FPGA_INST.cell3.SB0.route_sel\[101\] FPGA_INST.cell3.SB0.route_sel\[102\]
+ net271 vssd1 vssd1 vccd1 vccd1 _01078_ sky130_fd_sc_hd__mux2_1
XTAP_TAPCELL_ROW_66_1203 vssd1 vccd1 sky130_fd_sc_hd__tapvpwrvgnd_1
XFILLER_46_251 vssd1 vssd1 vccd1 vccd1 sky130_fd_sc_hd__fill_1
XPHY_EDGE_ROW_61_Left_192 vssd1 vssd1 vccd1 vccd1 sky130_fd_sc_hd__decap_3
XFILLER_46_295 vccd1 vssd1 vccd1 vssd1 sky130_ef_sc_hd__decap_40_12
XFILLER_34_468 vssd1 vssd1 vccd1 vccd1 sky130_fd_sc_hd__fill_1
XFILLER_15_682 vssd1 vssd1 vccd1 vccd1 sky130_fd_sc_hd__fill_2
XFILLER_30_641 vssd1 vssd1 vccd1 vccd1 sky130_fd_sc_hd__fill_2
X_05310_ FPGA_INST.cell2.CB_1.config_dataA\[12\] vssd1 vssd1 vccd1 vccd1 _01592_ sky130_fd_sc_hd__inv_2
X_06290_ FPGA_INST.cell2.LEI0.config_data\[26\] _02569_ vssd1 vssd1 vccd1 vccd1 _02570_
+ sky130_fd_sc_hd__and2b_1
Xinput20 gpio_in[27] vssd1 vssd1 vccd1 vccd1 net20 sky130_fd_sc_hd__buf_2
Xinput31 nrst vssd1 vssd1 vccd1 vccd1 net31 sky130_fd_sc_hd__clkbuf_2
XTAP_TAPCELL_ROW_77_1365 vssd1 vccd1 sky130_fd_sc_hd__tapvpwrvgnd_1
XTAP_TAPCELL_ROW_77_1354 vssd1 vccd1 sky130_fd_sc_hd__tapvpwrvgnd_1
X_09980_ FPGA_INST.config_bits\[5\] _05229_ _05231_ _05228_ vssd1 vssd1 vccd1 vccd1
+ _00874_ sky130_fd_sc_hd__a22o_1
X_08931_ _03943_ _05127_ vssd1 vssd1 vccd1 vccd1 FPGA_INST.bus3_1\[12\] sky130_fd_sc_hd__and2_2
XTAP_TAPCELL_ROW_90_1543 vssd1 vccd1 sky130_fd_sc_hd__tapvpwrvgnd_1
XANTENNA__09185__S net361 vssd1 vssd1 vccd1 vccd1 sky130_fd_sc_hd__diode_2
X_08862_ _05063_ _05068_ vssd1 vssd1 vccd1 vccd1 _05069_ sky130_fd_sc_hd__or2_1
XANTENNA__10124__S net364 vssd1 vssd1 vccd1 vccd1 sky130_fd_sc_hd__diode_2
XFILLER_84_313 vssd1 vssd1 vccd1 vccd1 sky130_fd_sc_hd__fill_2
X_07813_ _04059_ _04061_ vssd1 vssd1 vccd1 vccd1 FPGA_INST.bus3_2\[15\] sky130_fd_sc_hd__nor2_2
XTAP_TAPCELL_ROW_4_339 vssd1 vccd1 sky130_fd_sc_hd__tapvpwrvgnd_1
XFILLER_111_495 vssd1 vssd1 vccd1 vccd1 sky130_fd_sc_hd__fill_1
X_08793_ _04996_ _04997_ _04999_ vssd1 vssd1 vccd1 vccd1 _05000_ sky130_fd_sc_hd__or3_2
XFILLER_57_538 vssd1 vssd1 vccd1 vccd1 sky130_fd_sc_hd__fill_1
XFILLER_72_519 vccd1 vssd1 vccd1 vssd1 sky130_ef_sc_hd__decap_40_12
X_07744_ FPGA_INST.cell0.SB0.route_sel\[112\] FPGA_INST.cell0.SB0.route_sel\[113\]
+ vssd1 vssd1 vccd1 vccd1 _03994_ sky130_fd_sc_hd__nand2b_1
XFILLER_38_763 vssd1 vssd1 vccd1 vccd1 sky130_fd_sc_hd__fill_1
X_07675_ _03411_ _03926_ net140 vssd1 vssd1 vccd1 vccd1 _03927_ sky130_fd_sc_hd__o21ai_1
XFILLER_53_722 vssd1 vssd1 vccd1 vccd1 sky130_fd_sc_hd__fill_4
XFILLER_16_15 vssd1 vssd1 vccd1 vccd1 sky130_fd_sc_hd__fill_1
XANTENNA_fanout353_A net355 vssd1 vssd1 vccd1 vccd1 sky130_fd_sc_hd__diode_2
X_06626_ FPGA_INST.cell2.CB_1.config_dataA\[11\] _02899_ _02900_ _02901_ vssd1 vssd1
+ vccd1 vccd1 _02902_ sky130_fd_sc_hd__a31o_1
XANTENNA__06557__B _02832_ vssd1 vssd1 vccd1 vccd1 sky130_fd_sc_hd__diode_2
X_09414_ FPGA_INST.cell2.CB_1.config_dataA\[8\] FPGA_INST.cell2.CB_1.config_dataA\[7\]
+ net360 vssd1 vssd1 vccd1 vccd1 _00327_ sky130_fd_sc_hd__mux2_1
XANTENNA__08890__A3 net80 vssd1 vssd1 vccd1 vccd1 sky130_fd_sc_hd__diode_2
XTAP_TAPCELL_ROW_23_603 vssd1 vccd1 sky130_fd_sc_hd__tapvpwrvgnd_1
XANTENNA_fanout141_X net141 vssd1 vssd1 vccd1 vccd1 sky130_fd_sc_hd__diode_2
X_09345_ FPGA_INST.cell1.SB0.route_sel\[116\] FPGA_INST.cell1.SB0.route_sel\[117\]
+ net225 vssd1 vssd1 vccd1 vccd1 _00258_ sky130_fd_sc_hd__mux2_1
X_06557_ net481 _02832_ vssd1 vssd1 vccd1 vccd1 _02833_ sky130_fd_sc_hd__nand2_1
X_09276_ FPGA_INST.cell1.SB0.route_sel\[48\] FPGA_INST.cell1.SB0.route_sel\[47\] net330
+ vssd1 vssd1 vccd1 vccd1 _00189_ sky130_fd_sc_hd__mux2_1
X_05508_ net134 vssd1 vssd1 vccd1 vccd1 _01790_ sky130_fd_sc_hd__inv_2
X_06488_ _02764_ _02765_ _02652_ vssd1 vssd1 vccd1 vccd1 _02766_ sky130_fd_sc_hd__mux2_1
X_05439_ FPGA_INST.cell1.SB0.route_sel\[2\] vssd1 vssd1 vccd1 vccd1 _01721_ sky130_fd_sc_hd__inv_2
X_08227_ net73 net95 FPGA_INST.bus1_0\[2\] FPGA_INST.bus1_0\[3\] net406 net405 vssd1
+ vssd1 vccd1 vccd1 _04451_ sky130_fd_sc_hd__mux4_1
XANTENNA__06102__B2 _01825_ vssd1 vssd1 vccd1 vccd1 sky130_fd_sc_hd__diode_2
X_08158_ net411 net413 vssd1 vssd1 vccd1 vccd1 _04382_ sky130_fd_sc_hd__and2b_1
XFILLER_4_317 vssd1 vssd1 vccd1 vccd1 sky130_fd_sc_hd__fill_2
XFILLER_122_705 vssd1 vssd1 vccd1 vccd1 sky130_fd_sc_hd__fill_1
X_08089_ _03810_ _04301_ _04314_ vssd1 vssd1 vccd1 vccd1 _04315_ sky130_fd_sc_hd__o21ai_1
X_07109_ FPGA_INST.bus2_0\[8\] FPGA_INST.bus2_0\[9\] FPGA_INST.bus2_0\[10\] FPGA_INST.bus2_0\[11\]
+ net428 net426 vssd1 vssd1 vccd1 vccd1 _03375_ sky130_fd_sc_hd__mux4_1
X_10120_ FPGA_INST.cell3.SB0.route_sel\[24\] FPGA_INST.cell3.SB0.route_sel\[25\] net270
+ vssd1 vssd1 vccd1 vccd1 _01001_ sky130_fd_sc_hd__mux2_1
Xteam_15_970 vssd1 vssd1 vccd1 vccd1 gpio_oeb[4] team_15_970/LO sky130_fd_sc_hd__conb_1
X_10051_ net413 net411 net183 vssd1 vssd1 vccd1 vccd1 _00932_ sky130_fd_sc_hd__mux2_1
XFILLER_130_782 vssd1 vssd1 vccd1 vccd1 sky130_fd_sc_hd__fill_2
XFILLER_102_462 vssd1 vssd1 vccd1 vccd1 sky130_fd_sc_hd__fill_1
XFILLER_88_663 vssd1 vssd1 vccd1 vccd1 sky130_fd_sc_hd__fill_1
XFILLER_87_162 vssd1 vssd1 vccd1 vccd1 sky130_fd_sc_hd__fill_2
XFILLER_57_11 vssd1 vssd1 vccd1 vccd1 sky130_fd_sc_hd__fill_2
XFILLER_0_567 vssd1 vssd1 vccd1 vccd1 sky130_fd_sc_hd__fill_1
XFILLER_102_495 vssd1 vssd1 vccd1 vccd1 sky130_fd_sc_hd__fill_4
XFILLER_75_324 vssd1 vssd1 vccd1 vccd1 sky130_fd_sc_hd__fill_2
XFILLER_57_66 vssd1 vssd1 vccd1 vccd1 sky130_fd_sc_hd__fill_1
XFILLER_57_55 vssd1 vssd1 vccd1 vccd1 sky130_fd_sc_hd__fill_1
XFILLER_113_61 vssd1 vssd1 vccd1 vccd1 sky130_fd_sc_hd__fill_2
XFILLER_56_571 vssd1 vssd1 vccd1 vccd1 sky130_fd_sc_hd__fill_8
X_10953_ net870 _00303_ net657 vssd1 vssd1 vccd1 vccd1 FPGA_INST.cell2.CB_0.config_dataB\[9\]
+ sky130_fd_sc_hd__dfstp_1
XFILLER_28_251 vssd1 vssd1 vccd1 vccd1 sky130_fd_sc_hd__fill_1
XFILLER_83_390 vssd1 vssd1 vccd1 vccd1 sky130_fd_sc_hd__fill_2
XFILLER_73_54 vssd1 vssd1 vccd1 vccd1 sky130_fd_sc_hd__fill_2
XFILLER_71_541 vssd1 vssd1 vccd1 vccd1 sky130_fd_sc_hd__fill_2
X_10884_ net797 _00234_ net582 vssd1 vssd1 vccd1 vccd1 FPGA_INST.cell1.SB0.route_sel\[93\]
+ sky130_fd_sc_hd__dfstp_1
XFILLER_43_276 vssd1 vssd1 vccd1 vccd1 sky130_fd_sc_hd__fill_2
XFILLER_31_405 vssd1 vssd1 vccd1 vccd1 sky130_fd_sc_hd__fill_2
XTAP_TAPCELL_ROW_61_1133 vssd1 vccd1 sky130_fd_sc_hd__tapvpwrvgnd_1
XFILLER_129_337 vssd1 vssd1 vccd1 vccd1 sky130_fd_sc_hd__fill_1
X_11505_ net760 _00855_ net544 vssd1 vssd1 vccd1 vccd1 FPGA_INST.cell0.CB_1.config_dataB\[11\]
+ sky130_fd_sc_hd__dfstp_1
XFILLER_7_122 vssd1 vssd1 vccd1 vccd1 sky130_fd_sc_hd__fill_8
XANTENNA__07841__A1 _02293_ vssd1 vssd1 vccd1 vccd1 sky130_fd_sc_hd__diode_2
XTAP_TAPCELL_ROW_117_1922 vssd1 vccd1 sky130_fd_sc_hd__tapvpwrvgnd_1
XFILLER_8_678 vccd1 vssd1 vccd1 vssd1 sky130_ef_sc_hd__decap_40_12
X_11436_ net773 _00786_ net559 vssd1 vssd1 vccd1 vccd1 FPGA_INST.cell0.LE_0A.config_data\[7\]
+ sky130_fd_sc_hd__dfrtp_1
XANTENNA__05946__B1_N FPGA_INST.bus2_0\[6\] vssd1 vssd1 vccd1 vccd1 sky130_fd_sc_hd__diode_2
X_11367_ net819 _00717_ net604 vssd1 vssd1 vccd1 vccd1 FPGA_INST.cell1.LE_1B.config_data\[9\]
+ sky130_fd_sc_hd__dfrtp_1
XFILLER_125_543 vssd1 vssd1 vccd1 vccd1 sky130_fd_sc_hd__fill_2
XANTENNA__11675__CLK net842 vssd1 vssd1 vccd1 vccd1 sky130_fd_sc_hd__diode_2
XFILLER_125_598 vssd1 vssd1 vccd1 vccd1 sky130_fd_sc_hd__fill_1
X_10318_ FPGA_INST.cell3.LEI0.config_data\[32\] FPGA_INST.cell3.LEI0.config_data\[33\]
+ net297 vssd1 vssd1 vccd1 vccd1 _01199_ sky130_fd_sc_hd__mux2_1
XFILLER_3_361 vssd1 vssd1 vccd1 vccd1 sky130_fd_sc_hd__fill_2
X_11298_ net832 _00648_ net616 vssd1 vssd1 vccd1 vccd1 FPGA_INST.cell1.CB_0.config_dataA\[15\]
+ sky130_fd_sc_hd__dfstp_1
XTAP_TAPCELL_ROW_72_1295 vssd1 vccd1 sky130_fd_sc_hd__tapvpwrvgnd_1
XTAP_TAPCELL_ROW_72_1284 vssd1 vccd1 sky130_fd_sc_hd__tapvpwrvgnd_1
X_10249_ FPGA_INST.io_south_oeb\[18\] FPGA_INST.io_south_oeb\[20\] net290 vssd1 vssd1
+ vccd1 vccd1 _01130_ sky130_fd_sc_hd__mux2_1
XFILLER_78_195 vssd1 vssd1 vccd1 vccd1 sky130_fd_sc_hd__fill_1
XFILLER_39_527 vssd1 vssd1 vccd1 vccd1 sky130_fd_sc_hd__fill_1
X_05790_ _02067_ _02069_ vssd1 vssd1 vccd1 vccd1 _02070_ sky130_fd_sc_hd__or2_4
XANTENNA__07109__A0 FPGA_INST.bus2_0\[8\] vssd1 vssd1 vccd1 vccd1 sky130_fd_sc_hd__diode_2
XFILLER_94_699 vssd1 vssd1 vccd1 vccd1 sky130_fd_sc_hd__fill_1
XFILLER_19_251 vssd1 vssd1 vccd1 vccd1 sky130_fd_sc_hd__fill_2
X_07460_ FPGA_INST.cell1.SB0.route_sel\[58\] FPGA_INST.cell1.SB0.route_sel\[59\] vssd1
+ vssd1 vccd1 vccd1 _03717_ sky130_fd_sc_hd__nand2_1
XFILLER_62_585 vssd1 vssd1 vccd1 vccd1 sky130_fd_sc_hd__fill_2
X_07391_ FPGA_INST.cell1.SB0.route_sel\[43\] FPGA_INST.cell1.SB0.route_sel\[42\] vssd1
+ vssd1 vccd1 vccd1 _03650_ sky130_fd_sc_hd__nor2_1
X_06411_ FPGA_INST.cell2.LE_0B.config_data\[5\] FPGA_INST.cell2.LE_0B.config_data\[4\]
+ _02688_ vssd1 vssd1 vccd1 vccd1 _02689_ sky130_fd_sc_hd__mux2_1
XFILLER_22_427 vssd1 vssd1 vccd1 vccd1 sky130_fd_sc_hd__fill_1
XFILLER_22_438 vssd1 vssd1 vccd1 vccd1 sky130_fd_sc_hd__fill_2
X_09130_ FPGA_INST.cell2.LEI0.config_data\[44\] FPGA_INST.cell2.LEI0.config_data\[45\]
+ net259 vssd1 vssd1 vccd1 vccd1 _00046_ sky130_fd_sc_hd__mux2_1
X_06342_ FPGA_INST.cell2.LE_0A.config_data\[16\] _02618_ net155 _02620_ vssd1 vssd1
+ vccd1 vccd1 FPGA_INST.cell2.CB_0.le_outA sky130_fd_sc_hd__o211a_1
X_09061_ net723 FPGA_INST.cell3.LE_1A.reset_mode vssd1 vssd1 vccd1 vccd1 _09061_/X
+ sky130_fd_sc_hd__xor2_2
X_08012_ FPGA_INST.bus3_1\[0\] FPGA_INST.bus3_1\[1\] FPGA_INST.bus3_1\[2\] FPGA_INST.bus3_1\[3\]
+ net457 FPGA_INST.cell1.CB_0.config_dataB\[6\] vssd1 vssd1 vccd1 vccd1 _04238_ sky130_fd_sc_hd__mux4_1
XANTENNA__07776__X FPGA_INST.bus3_2\[14\] vssd1 vssd1 vccd1 vccd1 sky130_fd_sc_hd__diode_2
XANTENNA__10119__S net364 vssd1 vssd1 vccd1 vccd1 sky130_fd_sc_hd__diode_2
X_06273_ _02450_ _02540_ _02541_ _02487_ FPGA_INST.cell2.CB_0.config_dataA\[12\] vssd1
+ vssd1 vccd1 vccd1 _02553_ sky130_fd_sc_hd__a221o_1
XTAP_TAPCELL_ROW_9_409 vssd1 vccd1 sky130_fd_sc_hd__tapvpwrvgnd_1
XANTENNA__06399__A1 _02010_ vssd1 vssd1 vccd1 vccd1 sky130_fd_sc_hd__diode_2
X_09963_ FPGA_INST.cell0.CB_1.config_dataB\[24\] FPGA_INST.cell0.CB_1.config_dataB\[23\]
+ net320 vssd1 vssd1 vccd1 vccd1 _00868_ sky130_fd_sc_hd__mux2_1
XANTENNA__05737__A net383 vssd1 vssd1 vccd1 vccd1 sky130_fd_sc_hd__diode_2
XANTENNA__06332__S _02536_ vssd1 vssd1 vccd1 vccd1 sky130_fd_sc_hd__diode_2
XPHY_EDGE_ROW_4_Right_4 vssd1 vssd1 vccd1 vccd1 sky130_fd_sc_hd__decap_3
XFILLER_1_309 vssd1 vssd1 vccd1 vccd1 sky130_fd_sc_hd__fill_4
XANTENNA__06399__B2 _01966_ vssd1 vssd1 vccd1 vccd1 sky130_fd_sc_hd__diode_2
X_08914_ _01619_ FPGA_INST.cell1.SB0.route_sel\[107\] FPGA_INST.cell1.SB0.route_sel\[104\]
+ FPGA_INST.cell1.SB0.route_sel\[105\] vssd1 vssd1 vccd1 vccd1 _05116_ sky130_fd_sc_hd__o22a_1
XFILLER_103_259 vssd1 vssd1 vccd1 vccd1 sky130_fd_sc_hd__fill_2
XANTENNA__07348__B1 net141 vssd1 vssd1 vccd1 vccd1 sky130_fd_sc_hd__diode_2
X_09894_ FPGA_INST.cell0.LE_1A.dff1_out net522 _05219_ vssd1 vssd1 vccd1 vccd1 _00800_
+ sky130_fd_sc_hd__a21o_1
X_08845_ FPGA_INST.cell3.CB_0.config_dataB\[11\] _05049_ _05050_ _05051_ vssd1 vssd1
+ vccd1 vccd1 _05052_ sky130_fd_sc_hd__a31o_1
XFILLER_84_121 vccd1 vssd1 vccd1 vssd1 sky130_ef_sc_hd__decap_40_12
XFILLER_57_324 vssd1 vssd1 vccd1 vccd1 sky130_fd_sc_hd__fill_1
X_08776_ net390 _04835_ vssd1 vssd1 vccd1 vccd1 _04983_ sky130_fd_sc_hd__nand2_1
XANTENNA__06020__B1 FPGA_INST.bus1_0\[5\] vssd1 vssd1 vccd1 vccd1 sky130_fd_sc_hd__diode_2
X_07727_ _03483_ _03940_ _03977_ FPGA_INST.cell3.SB0.route_sel\[105\] FPGA_INST.cell3.SB0.route_sel\[104\]
+ vssd1 vssd1 vccd1 vccd1 _03978_ sky130_fd_sc_hd__a32o_1
X_05988_ FPGA_INST.cell0.SB0.route_sel\[37\] FPGA_INST.cell0.SB0.route_sel\[36\] vssd1
+ vssd1 vccd1 vccd1 _02268_ sky130_fd_sc_hd__nand2b_1
XANTENNA_fanout735_A net29 vssd1 vssd1 vccd1 vccd1 sky130_fd_sc_hd__diode_2
X_07658_ net83 _03428_ _03907_ _03908_ _03909_ vssd1 vssd1 vccd1 vccd1 _03910_ sky130_fd_sc_hd__o311a_1
XANTENNA_fanout523_X net523 vssd1 vssd1 vccd1 vccd1 sky130_fd_sc_hd__diode_2
XTAP_TAPCELL_ROW_101_1701 vssd1 vccd1 sky130_fd_sc_hd__tapvpwrvgnd_1
XANTENNA_fanout902_A net918 vssd1 vssd1 vccd1 vccd1 sky130_fd_sc_hd__diode_2
X_07589_ _02020_ _03841_ _03842_ vssd1 vssd1 vccd1 vccd1 _03843_ sky130_fd_sc_hd__a21oi_1
X_06609_ _02883_ _02884_ vssd1 vssd1 vccd1 vccd1 _02885_ sky130_fd_sc_hd__and2b_1
XFILLER_13_449 vssd1 vssd1 vccd1 vccd1 sky130_fd_sc_hd__fill_4
XTAP_TAPCELL_ROW_36_783 vssd1 vccd1 sky130_fd_sc_hd__tapvpwrvgnd_1
XFILLER_40_213 vssd1 vssd1 vccd1 vccd1 sky130_fd_sc_hd__fill_1
XFILLER_40_235 vssd1 vssd1 vccd1 vccd1 sky130_fd_sc_hd__fill_2
X_09328_ FPGA_INST.cell1.SB0.route_sel\[99\] FPGA_INST.cell1.SB0.route_sel\[100\]
+ net222 vssd1 vssd1 vccd1 vccd1 _00241_ sky130_fd_sc_hd__mux2_1
XFILLER_43_57 vccd1 vssd1 vccd1 vssd1 sky130_ef_sc_hd__decap_40_12
XFILLER_126_318 vssd1 vssd1 vccd1 vccd1 sky130_fd_sc_hd__fill_2
X_09259_ FPGA_INST.cell1.SB0.route_sel\[31\] FPGA_INST.cell1.SB0.route_sel\[30\] net338
+ vssd1 vssd1 vccd1 vccd1 _00172_ sky130_fd_sc_hd__mux2_1
XTAP_TAPCELL_ROW_130_2108 vssd1 vccd1 sky130_fd_sc_hd__tapvpwrvgnd_1
XFILLER_111_3 vccd1 vssd1 vccd1 vssd1 sky130_ef_sc_hd__decap_40_12
XFILLER_107_521 vssd1 vssd1 vccd1 vccd1 sky130_fd_sc_hd__fill_1
XANTENNA_fanout892_X net892 vssd1 vssd1 vccd1 vccd1 sky130_fd_sc_hd__diode_2
XFILLER_4_114 vssd1 vssd1 vccd1 vccd1 sky130_fd_sc_hd__fill_4
XTAP_TAPCELL_ROW_130_2119 vssd1 vccd1 sky130_fd_sc_hd__tapvpwrvgnd_1
X_11221_ net765 _00571_ net550 vssd1 vssd1 vccd1 vccd1 FPGA_INST.cell0.SB0.route_sel\[66\]
+ sky130_fd_sc_hd__dfstp_1
XFILLER_122_513 vssd1 vssd1 vccd1 vccd1 sky130_fd_sc_hd__fill_8
X_11152_ net804 _00502_ net589 vssd1 vssd1 vccd1 vccd1 FPGA_INST.cell1.CB_1.config_dataB\[22\]
+ sky130_fd_sc_hd__dfstp_1
XTAP_TAPCELL_ROW_112_1852 vssd1 vccd1 sky130_fd_sc_hd__tapvpwrvgnd_1
XFILLER_108_83 vssd1 vssd1 vccd1 vccd1 sky130_fd_sc_hd__fill_1
X_10103_ FPGA_INST.cell3.SB0.route_sel\[8\] FPGA_INST.cell3.SB0.route_sel\[7\] net364
+ vssd1 vssd1 vccd1 vccd1 _00984_ sky130_fd_sc_hd__mux2_1
XFILLER_68_54 vssd1 vssd1 vccd1 vccd1 sky130_fd_sc_hd__fill_1
XFILLER_122_568 vssd1 vssd1 vccd1 vccd1 sky130_fd_sc_hd__fill_4
X_11083_ net834 _00433_ net618 vssd1 vssd1 vccd1 vccd1 FPGA_INST.cell1.LE_0A.reset_val
+ sky130_fd_sc_hd__dfrtp_1
XANTENNA__09553__S net333 vssd1 vssd1 vccd1 vccd1 sky130_fd_sc_hd__diode_2
X_10034_ FPGA_INST.cell0.CB_0.config_dataB\[8\] FPGA_INST.cell0.CB_0.config_dataB\[9\]
+ net190 vssd1 vssd1 vccd1 vccd1 _00915_ sky130_fd_sc_hd__mux2_1
XANTENNA_input31_A nrst vssd1 vssd1 vccd1 vccd1 sky130_fd_sc_hd__diode_2
XANTENNA__08551__A2 FPGA_INST.cell3.CB_1.le_outA vssd1 vssd1 vccd1 vccd1 sky130_fd_sc_hd__diode_2
XFILLER_76_666 vccd1 vssd1 vccd1 vssd1 sky130_ef_sc_hd__decap_40_12
XFILLER_48_368 vssd1 vssd1 vccd1 vccd1 sky130_fd_sc_hd__fill_1
XFILLER_56_390 vssd1 vssd1 vccd1 vccd1 sky130_fd_sc_hd__fill_2
X_11985_ net845 _01331_ net630 vssd1 vssd1 vccd1 vccd1 FPGA_INST.cell2.SB0.route_sel\[25\]
+ sky130_fd_sc_hd__dfstp_1
XANTENNA__06314__A1 net4 vssd1 vssd1 vccd1 vccd1 sky130_fd_sc_hd__diode_2
X_10936_ net851 _00286_ net636 vssd1 vssd1 vccd1 vccd1 FPGA_INST.cell2.CB_0.config_dataA\[17\]
+ sky130_fd_sc_hd__dfstp_1
XANTENNA__08854__A3 _01792_ vssd1 vssd1 vccd1 vccd1 sky130_fd_sc_hd__diode_2
X_10867_ net792 _00217_ net577 vssd1 vssd1 vccd1 vccd1 FPGA_INST.cell1.SB0.route_sel\[76\]
+ sky130_fd_sc_hd__dfstp_1
XFILLER_71_393 vssd1 vssd1 vccd1 vccd1 sky130_fd_sc_hd__fill_4
XANTENNA__06865__A2 _01888_ vssd1 vssd1 vccd1 vccd1 sky130_fd_sc_hd__diode_2
X_10798_ net825 _00148_ net609 vssd1 vssd1 vccd1 vccd1 FPGA_INST.cell1.SB0.route_sel\[7\]
+ sky130_fd_sc_hd__dfstp_1
XTAP_TAPCELL_ROW_14_477 vssd1 vccd1 sky130_fd_sc_hd__tapvpwrvgnd_1
XFILLER_129_167 vssd1 vssd1 vccd1 vccd1 sky130_fd_sc_hd__fill_1
XANTENNA__09728__S net230 vssd1 vssd1 vccd1 vccd1 sky130_fd_sc_hd__diode_2
XTAP_TAPCELL_ROW_74_1313 vssd1 vccd1 sky130_fd_sc_hd__tapvpwrvgnd_1
X_11419_ net750 _00769_ net538 vssd1 vssd1 vccd1 vccd1 FPGA_INST.cell0.LEI0.config_data\[40\]
+ sky130_fd_sc_hd__dfrtp_1
XTAP_TAPCELL_ROW_74_1324 vssd1 vccd1 sky130_fd_sc_hd__tapvpwrvgnd_1
XFILLER_67_600 vssd1 vssd1 vccd1 vccd1 sky130_fd_sc_hd__fill_2
X_06960_ _03227_ vssd1 vssd1 vccd1 vccd1 _03228_ sky130_fd_sc_hd__inv_2
XFILLER_121_590 vssd1 vssd1 vccd1 vccd1 sky130_fd_sc_hd__fill_1
XFILLER_67_633 vssd1 vssd1 vccd1 vccd1 sky130_fd_sc_hd__fill_1
X_06891_ _01742_ _03130_ _03152_ _03156_ _03158_ vssd1 vssd1 vccd1 vccd1 _03159_ sky130_fd_sc_hd__o311a_4
X_05911_ _02188_ _02190_ vssd1 vssd1 vccd1 vccd1 _02191_ sky130_fd_sc_hd__or2_4
XFILLER_39_302 vssd1 vssd1 vccd1 vccd1 sky130_fd_sc_hd__fill_4
X_08630_ _03703_ _04838_ vssd1 vssd1 vccd1 vccd1 _04839_ sky130_fd_sc_hd__nand2_2
XFILLER_94_430 vccd1 vssd1 vccd1 vssd1 sky130_ef_sc_hd__decap_40_12
XFILLER_66_143 vssd1 vssd1 vccd1 vccd1 sky130_fd_sc_hd__fill_1
X_05842_ _01999_ _02045_ vssd1 vssd1 vccd1 vccd1 _02122_ sky130_fd_sc_hd__nand2_1
XFILLER_39_357 vssd1 vssd1 vccd1 vccd1 sky130_fd_sc_hd__fill_4
XFILLER_54_305 vssd1 vssd1 vccd1 vccd1 sky130_fd_sc_hd__fill_2
X_08561_ _04771_ _04770_ _04751_ vssd1 vssd1 vccd1 vccd1 _04772_ sky130_fd_sc_hd__mux2_1
XFILLER_81_124 vssd1 vssd1 vccd1 vccd1 sky130_fd_sc_hd__fill_2
X_05773_ net240 _02044_ _02052_ vssd1 vssd1 vccd1 vccd1 _02053_ sky130_fd_sc_hd__and3_1
X_08492_ FPGA_INST.cell1.LE_1B.config_data\[12\] FPGA_INST.cell1.LE_1B.config_data\[13\]
+ _04692_ vssd1 vssd1 vccd1 vccd1 _04708_ sky130_fd_sc_hd__mux2_1
XFILLER_120_29 vssd1 vssd1 vccd1 vccd1 sky130_fd_sc_hd__fill_4
XFILLER_120_18 vssd1 vssd1 vccd1 vccd1 sky130_fd_sc_hd__fill_8
XTAP_TAPCELL_ROW_85_1475 vssd1 vccd1 sky130_fd_sc_hd__tapvpwrvgnd_1
X_07512_ FPGA_INST.cell1.SB0.route_sel\[68\] _01659_ FPGA_INST.cell1.SB0.route_sel\[71\]
+ _01660_ _03767_ vssd1 vssd1 vccd1 vccd1 _03768_ sky130_fd_sc_hd__a221o_1
X_07443_ net89 _03698_ vssd1 vssd1 vccd1 vccd1 _03701_ sky130_fd_sc_hd__nor2_1
XFILLER_62_371 vssd1 vssd1 vccd1 vccd1 sky130_fd_sc_hd__fill_1
XFILLER_50_522 vssd1 vssd1 vccd1 vccd1 sky130_fd_sc_hd__fill_1
XANTENNA_fanout149_A net150 vssd1 vssd1 vccd1 vccd1 sky130_fd_sc_hd__diode_2
XTAP_TAPCELL_ROW_33_742 vssd1 vccd1 sky130_fd_sc_hd__tapvpwrvgnd_1
X_07374_ net82 _03447_ _03587_ _03631_ _03632_ vssd1 vssd1 vccd1 vccd1 _03633_ sky130_fd_sc_hd__o311a_1
XFILLER_10_419 vssd1 vssd1 vccd1 vccd1 sky130_fd_sc_hd__fill_1
XANTENNA__06327__S _02536_ vssd1 vssd1 vccd1 vccd1 sky130_fd_sc_hd__diode_2
XFILLER_13_27 vssd1 vssd1 vccd1 vccd1 sky130_fd_sc_hd__fill_4
X_09113_ FPGA_INST.cell2.LEI0.config_data\[27\] FPGA_INST.cell2.LEI0.config_data\[28\]
+ net250 vssd1 vssd1 vccd1 vccd1 _00029_ sky130_fd_sc_hd__mux2_1
XFILLER_31_780 vssd1 vssd1 vccd1 vccd1 sky130_fd_sc_hd__fill_4
XANTENNA__06608__A2 _02772_ vssd1 vssd1 vccd1 vccd1 sky130_fd_sc_hd__diode_2
XANTENNA_fanout316_A net317 vssd1 vssd1 vccd1 vccd1 sky130_fd_sc_hd__diode_2
X_06325_ FPGA_INST.cell2.CB_0.config_dataA\[19\] _02586_ _02601_ _02604_ FPGA_INST.cell2.LEI0.config_data\[38\]
+ vssd1 vssd1 vccd1 vccd1 _02605_ sky130_fd_sc_hd__o32a_1
X_09044_ net591 FPGA_INST.cell1.LE_1A.reset_mode vssd1 vssd1 vccd1 vccd1 _09044_/X
+ sky130_fd_sc_hd__xor2_2
X_06256_ _02514_ _02533_ _02535_ _02532_ vssd1 vssd1 vccd1 vccd1 _02536_ sky130_fd_sc_hd__o211a_4
X_06187_ _02452_ _02466_ _02451_ vssd1 vssd1 vccd1 vccd1 _02467_ sky130_fd_sc_hd__a21o_1
Xfanout900 net902 vssd1 vssd1 vccd1 vccd1 net900 sky130_fd_sc_hd__clkbuf_2
XFILLER_1_139 vssd1 vssd1 vccd1 vccd1 sky130_fd_sc_hd__fill_8
XFILLER_1_117 vssd1 vssd1 vccd1 vccd1 sky130_fd_sc_hd__fill_2
Xfanout911 net918 vssd1 vssd1 vccd1 vccd1 net911 sky130_fd_sc_hd__clkbuf_2
Xfanout933 net946 vssd1 vssd1 vccd1 vccd1 net933 sky130_fd_sc_hd__buf_1
Xfanout922 net947 vssd1 vssd1 vccd1 vccd1 net922 sky130_fd_sc_hd__clkbuf_2
XFILLER_89_279 vssd1 vssd1 vccd1 vccd1 sky130_fd_sc_hd__fill_1
X_09946_ FPGA_INST.cell0.CB_1.config_dataB\[7\] net444 net312 vssd1 vssd1 vccd1 vccd1
+ _00851_ sky130_fd_sc_hd__mux2_1
XPHY_EDGE_ROW_8_Left_139 vssd1 vssd1 vccd1 vccd1 sky130_fd_sc_hd__decap_3
Xfanout944 net945 vssd1 vssd1 vccd1 vccd1 net944 sky130_fd_sc_hd__buf_1
XANTENNA__09373__S net351 vssd1 vssd1 vccd1 vccd1 sky130_fd_sc_hd__diode_2
X_09877_ FPGA_INST.cell0.LE_0A.config_data\[5\] FPGA_INST.cell0.LE_0A.config_data\[4\]
+ net319 vssd1 vssd1 vccd1 vccd1 _00784_ sky130_fd_sc_hd__mux2_1
X_08828_ _04819_ _04823_ net388 vssd1 vssd1 vccd1 vccd1 _05035_ sky130_fd_sc_hd__mux2_1
XFILLER_85_496 vssd1 vssd1 vccd1 vccd1 sky130_fd_sc_hd__fill_2
XPHY_EDGE_ROW_79_Right_79 vssd1 vssd1 vccd1 vccd1 sky130_fd_sc_hd__decap_3
XFILLER_73_625 vccd1 vssd1 vccd1 vssd1 sky130_ef_sc_hd__decap_40_12
X_08759_ FPGA_INST.cell3.LE_0A.config_data\[9\] FPGA_INST.cell3.LE_0A.config_data\[8\]
+ _04860_ vssd1 vssd1 vccd1 vccd1 _04968_ sky130_fd_sc_hd__mux2_1
X_11770_ net925 _01116_ net709 vssd1 vssd1 vccd1 vccd1 FPGA_INST.io_west_oeb\[24\]
+ sky130_fd_sc_hd__dfrtp_1
XANTENNA__08297__B2 _03923_ vssd1 vssd1 vccd1 vccd1 sky130_fd_sc_hd__diode_2
XFILLER_53_360 vccd1 vssd1 vccd1 vssd1 sky130_ef_sc_hd__decap_40_12
XANTENNA__08297__A1 _03959_ vssd1 vssd1 vccd1 vccd1 sky130_fd_sc_hd__diode_2
XFILLER_54_67 vssd1 vssd1 vccd1 vccd1 sky130_fd_sc_hd__fill_1
XFILLER_53_393 vssd1 vssd1 vccd1 vccd1 sky130_fd_sc_hd__fill_4
XANTENNA__06847__A2 _02030_ vssd1 vssd1 vccd1 vccd1 sky130_fd_sc_hd__diode_2
X_10721_ FPGA_INST.cell2.LE_0B.sel_clk _00071_ net734 vssd1 vssd1 vccd1 vccd1 FPGA_INST.cell2.LE_0B.dff0_out
+ sky130_fd_sc_hd__dfrtp_1
XFILLER_9_239 vssd1 vssd1 vccd1 vccd1 sky130_fd_sc_hd__fill_2
X_10652_ net874 _00002_ net658 vssd1 vssd1 vccd1 vccd1 FPGA_INST.cell2.LEI0.config_data\[1\]
+ sky130_fd_sc_hd__dfrtp_1
X_10583_ FPGA_INST.cell3.CB_0.config_dataB\[3\] FPGA_INST.cell3.CB_0.config_dataB\[2\]
+ net378 vssd1 vssd1 vccd1 vccd1 _01462_ sky130_fd_sc_hd__mux2_1
XTAP_TAPCELL_ROW_11_436 vssd1 vccd1 sky130_fd_sc_hd__tapvpwrvgnd_1
XFILLER_21_290 vssd1 vssd1 vccd1 vccd1 sky130_fd_sc_hd__fill_4
XPHY_EDGE_ROW_88_Right_88 vssd1 vssd1 vccd1 vccd1 sky130_fd_sc_hd__decap_3
X_11204_ net747 _00554_ net532 vssd1 vssd1 vccd1 vccd1 FPGA_INST.cell0.SB0.route_sel\[49\]
+ sky130_fd_sc_hd__dfstp_1
XFILLER_79_86 vssd1 vssd1 vccd1 vccd1 sky130_fd_sc_hd__fill_4
XANTENNA__08221__A1 _03639_ vssd1 vssd1 vccd1 vccd1 sky130_fd_sc_hd__diode_2
XANTENNA__08221__B2 _03604_ vssd1 vssd1 vccd1 vccd1 sky130_fd_sc_hd__diode_2
XTAP_TAPCELL_ROW_56_1065 vssd1 vccd1 sky130_fd_sc_hd__tapvpwrvgnd_1
XANTENNA__07024__A2 _02030_ vssd1 vssd1 vccd1 vccd1 sky130_fd_sc_hd__diode_2
XFILLER_122_365 vssd1 vssd1 vccd1 vccd1 sky130_fd_sc_hd__fill_2
XFILLER_122_343 vccd1 vssd1 vccd1 vssd1 sky130_ef_sc_hd__decap_40_12
X_11135_ net816 _00485_ net601 vssd1 vssd1 vccd1 vccd1 FPGA_INST.cell1.CB_1.config_dataB\[5\]
+ sky130_fd_sc_hd__dfstp_1
XANTENNA__08772__A2 net25 vssd1 vssd1 vccd1 vccd1 sky130_fd_sc_hd__diode_2
XFILLER_68_419 vssd1 vssd1 vccd1 vccd1 sky130_fd_sc_hd__fill_1
X_11066_ net836 _00416_ net620 vssd1 vssd1 vccd1 vccd1 FPGA_INST.cell1.LE_0A.config_data\[1\]
+ sky130_fd_sc_hd__dfrtp_1
XPHY_EDGE_ROW_97_Right_97 vssd1 vssd1 vccd1 vccd1 sky130_fd_sc_hd__decap_3
XFILLER_95_74 vssd1 vssd1 vccd1 vccd1 sky130_fd_sc_hd__fill_2
XFILLER_76_430 vssd1 vssd1 vccd1 vccd1 sky130_fd_sc_hd__fill_8
XFILLER_48_143 vssd1 vssd1 vccd1 vccd1 sky130_fd_sc_hd__fill_2
X_10017_ FPGA_INST.cell0.CB_0.config_dataA\[17\] net426 net316 vssd1 vssd1 vccd1 vccd1
+ _00898_ sky130_fd_sc_hd__mux2_1
XANTENNA__08200__B _03875_ vssd1 vssd1 vccd1 vccd1 sky130_fd_sc_hd__diode_2
XFILLER_48_176 vssd1 vssd1 vccd1 vccd1 sky130_fd_sc_hd__fill_8
XFILLER_63_113 vssd1 vssd1 vccd1 vccd1 sky130_fd_sc_hd__fill_1
XANTENNA__06001__A net129 vssd1 vssd1 vccd1 vccd1 sky130_fd_sc_hd__diode_2
XANTENNA__05889__A3 net13 vssd1 vssd1 vccd1 vccd1 sky130_fd_sc_hd__diode_2
XTAP_TAPCELL_ROW_19_547 vssd1 vccd1 sky130_fd_sc_hd__tapvpwrvgnd_1
XFILLER_36_338 vssd1 vssd1 vccd1 vccd1 sky130_fd_sc_hd__fill_1
XFILLER_17_563 vssd1 vssd1 vccd1 vccd1 sky130_fd_sc_hd__fill_4
X_11968_ net847 _01314_ net632 vssd1 vssd1 vccd1 vccd1 FPGA_INST.cell2.SB0.route_sel\[8\]
+ sky130_fd_sc_hd__dfstp_1
XFILLER_32_511 vssd1 vssd1 vccd1 vccd1 sky130_fd_sc_hd__fill_1
XFILLER_32_533 vssd1 vssd1 vccd1 vccd1 sky130_fd_sc_hd__fill_4
X_11899_ net929 _01245_ net713 vssd1 vssd1 vccd1 vccd1 FPGA_INST.cell3.LE_0B.config_data\[7\]
+ sky130_fd_sc_hd__dfrtp_1
X_10919_ net863 _00269_ net648 vssd1 vssd1 vccd1 vccd1 FPGA_INST.cell2.CB_0.config_dataA\[0\]
+ sky130_fd_sc_hd__dfstp_1
XFILLER_32_544 vssd1 vssd1 vccd1 vccd1 sky130_fd_sc_hd__fill_1
XTAP_TAPCELL_ROW_30_701 vssd1 vccd1 sky130_fd_sc_hd__tapvpwrvgnd_1
XFILLER_9_740 vssd1 vssd1 vccd1 vccd1 sky130_fd_sc_hd__fill_2
XFILLER_118_638 vssd1 vssd1 vccd1 vccd1 sky130_fd_sc_hd__fill_4
X_06110_ FPGA_INST.cell0.SB0.route_sel\[19\] FPGA_INST.cell0.SB0.route_sel\[18\] vssd1
+ vssd1 vccd1 vccd1 _02390_ sky130_fd_sc_hd__nor2_1
X_07090_ net428 _02233_ _03355_ net426 vssd1 vssd1 vccd1 vccd1 _03356_ sky130_fd_sc_hd__o211a_1
X_06041_ _02312_ _02314_ _02315_ _02320_ vssd1 vssd1 vccd1 vccd1 _02321_ sky130_fd_sc_hd__a211oi_1
XFILLER_99_555 vssd1 vssd1 vccd1 vccd1 sky130_fd_sc_hd__fill_1
XANTENNA__07015__A2 _01839_ vssd1 vssd1 vccd1 vccd1 sky130_fd_sc_hd__diode_2
Xfanout229 net230 vssd1 vssd1 vccd1 vccd1 net229 sky130_fd_sc_hd__clkbuf_4
Xfanout218 net219 vssd1 vssd1 vccd1 vccd1 net218 sky130_fd_sc_hd__buf_2
X_07992_ _04218_ _04219_ _04114_ vssd1 vssd1 vccd1 vccd1 _04220_ sky130_fd_sc_hd__mux2_1
X_09800_ FPGA_INST.cell1.LE_1B.config_data\[1\] FPGA_INST.cell1.LE_1B.config_data\[0\]
+ net336 vssd1 vssd1 vccd1 vccd1 _00709_ sky130_fd_sc_hd__mux2_1
XANTENNA__12181__Q FPGA_INST.cell3.LE_1B.reset_val vssd1 vssd1 vccd1 vccd1 sky130_fd_sc_hd__diode_2
Xfanout207 net209 vssd1 vssd1 vccd1 vccd1 net207 sky130_fd_sc_hd__clkbuf_4
XFILLER_5_83 vssd1 vssd1 vccd1 vccd1 sky130_fd_sc_hd__fill_8
X_09731_ FPGA_INST.cell1.CB_0.config_dataA\[7\] FPGA_INST.cell1.CB_0.config_dataA\[6\]
+ net344 vssd1 vssd1 vccd1 vccd1 _00640_ sky130_fd_sc_hd__mux2_1
XANTENNA__09193__S net362 vssd1 vssd1 vccd1 vccd1 sky130_fd_sc_hd__diode_2
X_06943_ net415 _02233_ FPGA_INST.cell0.CB_0.config_dataB\[16\] vssd1 vssd1 vccd1
+ vccd1 _03211_ sky130_fd_sc_hd__o21ai_1
XFILLER_39_110 vssd1 vssd1 vccd1 vccd1 sky130_fd_sc_hd__fill_2
XFILLER_95_750 vssd1 vssd1 vccd1 vccd1 sky130_fd_sc_hd__fill_2
XANTENNA__10132__S net369 vssd1 vssd1 vccd1 vccd1 sky130_fd_sc_hd__diode_2
XFILLER_95_783 vssd1 vssd1 vccd1 vccd1 sky130_fd_sc_hd__fill_1
XTAP_TAPCELL_ROW_87_1504 vssd1 vccd1 sky130_fd_sc_hd__tapvpwrvgnd_1
X_09662_ FPGA_INST.cell0.SB0.route_sel\[65\] FPGA_INST.cell0.SB0.route_sel\[66\] net185
+ vssd1 vssd1 vccd1 vccd1 _00571_ sky130_fd_sc_hd__mux2_1
X_06874_ _02271_ _03128_ _03130_ _02310_ FPGA_INST.cell0.CB_0.config_dataB\[2\] vssd1
+ vssd1 vccd1 vccd1 _03142_ sky130_fd_sc_hd__o221a_1
XFILLER_27_316 vssd1 vssd1 vccd1 vccd1 sky130_fd_sc_hd__fill_1
XTAP_TAPCELL_ROW_38_812 vssd1 vccd1 sky130_fd_sc_hd__tapvpwrvgnd_1
X_09593_ FPGA_INST.cell1.CB_1.config_dataB\[21\] FPGA_INST.cell1.CB_1.config_dataB\[22\]
+ net212 vssd1 vssd1 vccd1 vccd1 _00502_ sky130_fd_sc_hd__mux2_1
X_08613_ _03583_ _04821_ vssd1 vssd1 vccd1 vccd1 _04822_ sky130_fd_sc_hd__nor2_1
X_05825_ _02097_ _02104_ _02098_ _02096_ vssd1 vssd1 vccd1 vccd1 _02105_ sky130_fd_sc_hd__o211a_1
X_08544_ FPGA_INST.cell3.LEI0.config_data\[11\] _04753_ _04754_ FPGA_INST.cell3.CB_1.config_dataB\[4\]
+ vssd1 vssd1 vccd1 vccd1 _04755_ sky130_fd_sc_hd__o211ai_4
XANTENNA_fanout266_A net267 vssd1 vssd1 vccd1 vccd1 sky130_fd_sc_hd__diode_2
X_05756_ FPGA_INST.cell2.CB_1.config_dataB\[22\] FPGA_INST.cell2.CB_1.config_dataB\[23\]
+ vssd1 vssd1 vccd1 vccd1 _02036_ sky130_fd_sc_hd__and2b_1
XFILLER_23_500 vssd1 vssd1 vccd1 vccd1 sky130_fd_sc_hd__fill_1
X_08475_ FPGA_INST.cell1.CB_1.config_dataB\[3\] FPGA_INST.cell1.CB_1.config_dataB\[2\]
+ FPGA_INST.cell1.CB_1.config_dataB\[1\] FPGA_INST.cell1.CB_1.config_dataB\[0\] vssd1
+ vssd1 vccd1 vccd1 _04691_ sky130_fd_sc_hd__or4b_2
XFILLER_24_48 vssd1 vssd1 vccd1 vccd1 sky130_fd_sc_hd__fill_2
X_05687_ FPGA_INST.cell0.CB_0.config_dataA\[24\] FPGA_INST.cell0.CB_0.config_dataA\[21\]
+ FPGA_INST.cell0.CB_0.config_dataA\[20\] vssd1 vssd1 vccd1 vccd1 _01967_ sky130_fd_sc_hd__nor3b_2
X_07426_ FPGA_INST.cell1.SB0.route_sel\[55\] FPGA_INST.cell1.SB0.route_sel\[54\] _02223_
+ _03683_ _02224_ vssd1 vssd1 vccd1 vccd1 _03684_ sky130_fd_sc_hd__a221o_1
XFILLER_50_363 vssd1 vssd1 vccd1 vccd1 sky130_fd_sc_hd__fill_1
XANTENNA_fanout600_A net604 vssd1 vssd1 vccd1 vccd1 sky130_fd_sc_hd__diode_2
X_07357_ FPGA_INST.cell3.SB0.route_sel\[38\] FPGA_INST.cell3.SB0.route_sel\[39\] FPGA_INST.cell3.SB0.route_sel\[36\]
+ vssd1 vssd1 vccd1 vccd1 _03617_ sky130_fd_sc_hd__a21bo_1
XFILLER_10_249 vssd1 vssd1 vccd1 vccd1 sky130_fd_sc_hd__fill_2
XTAP_TAPCELL_ROW_98_1655 vssd1 vccd1 sky130_fd_sc_hd__tapvpwrvgnd_1
XANTENNA__08780__B _04785_ vssd1 vssd1 vccd1 vccd1 sky130_fd_sc_hd__diode_2
XANTENNA__09368__S net350 vssd1 vssd1 vccd1 vccd1 sky130_fd_sc_hd__diode_2
X_06308_ net500 _02255_ _02587_ net499 vssd1 vssd1 vccd1 vccd1 _02588_ sky130_fd_sc_hd__o211a_1
XANTENNA_fanout319_X net319 vssd1 vssd1 vccd1 vccd1 sky130_fd_sc_hd__diode_2
X_07288_ FPGA_INST.cell1.CB_0.config_dataB\[24\] FPGA_INST.cell1.CB_0.config_dataB\[20\]
+ FPGA_INST.cell1.CB_0.config_dataB\[21\] vssd1 vssd1 vccd1 vccd1 _03549_ sky130_fd_sc_hd__nand3b_2
X_09027_ _02447_ _05191_ vssd1 vssd1 vccd1 vccd1 FPGA_INST.bus2_0\[1\] sky130_fd_sc_hd__nor2_4
X_06239_ net5 _02506_ _02518_ FPGA_INST.cell2.CB_0.config_dataA\[3\] vssd1 vssd1 vccd1
+ vccd1 _02519_ sky130_fd_sc_hd__a211o_1
XANTENNA__08203__A1 FPGA_INST.bus1_0\[10\] vssd1 vssd1 vccd1 vccd1 sky130_fd_sc_hd__diode_2
XANTENNA__07006__A2 FPGA_INST.bus2_0\[13\] vssd1 vssd1 vccd1 vccd1 sky130_fd_sc_hd__diode_2
XANTENNA__06214__A0 net7 vssd1 vssd1 vccd1 vccd1 sky130_fd_sc_hd__diode_2
XANTENNA_fanout81_A net83 vssd1 vssd1 vccd1 vccd1 sky130_fd_sc_hd__diode_2
Xfanout730 net731 vssd1 vssd1 vccd1 vccd1 net730 sky130_fd_sc_hd__buf_2
XANTENNA__06765__B2 _02801_ vssd1 vssd1 vccd1 vccd1 sky130_fd_sc_hd__diode_2
XANTENNA__06765__A1 _02804_ vssd1 vssd1 vccd1 vccd1 sky130_fd_sc_hd__diode_2
Xfanout741 net749 vssd1 vssd1 vccd1 vccd1 net741 sky130_fd_sc_hd__clkbuf_2
XPHY_EDGE_ROW_130_Right_130 vssd1 vssd1 vccd1 vccd1 sky130_fd_sc_hd__decap_3
XANTENNA__08506__A2 net82 vssd1 vssd1 vccd1 vccd1 sky130_fd_sc_hd__diode_2
Xfanout763 net769 vssd1 vssd1 vccd1 vccd1 net763 sky130_fd_sc_hd__clkbuf_2
Xfanout785 net788 vssd1 vssd1 vccd1 vccd1 net785 sky130_fd_sc_hd__clkbuf_2
Xfanout752 net753 vssd1 vssd1 vccd1 vccd1 net752 sky130_fd_sc_hd__buf_1
Xfanout774 net775 vssd1 vssd1 vccd1 vccd1 net774 sky130_fd_sc_hd__clkbuf_2
X_09929_ FPGA_INST.cell0.LE_1A.config_data\[11\] FPGA_INST.cell0.LE_1A.config_data\[10\]
+ net311 vssd1 vssd1 vccd1 vccd1 _00834_ sky130_fd_sc_hd__mux2_1
XTAP_TAPCELL_ROW_125_2029 vssd1 vccd1 sky130_fd_sc_hd__tapvpwrvgnd_1
XFILLER_105_84 vssd1 vssd1 vccd1 vccd1 sky130_fd_sc_hd__fill_2
Xfanout796 net803 vssd1 vssd1 vccd1 vccd1 net796 sky130_fd_sc_hd__clkbuf_2
XFILLER_100_593 vssd1 vssd1 vccd1 vccd1 sky130_fd_sc_hd__fill_1
XFILLER_45_113 vssd1 vssd1 vccd1 vccd1 sky130_fd_sc_hd__fill_1
X_11822_ net932 _01168_ net716 vssd1 vssd1 vccd1 vccd1 FPGA_INST.cell3.LEI0.config_data\[2\]
+ sky130_fd_sc_hd__dfrtp_1
XFILLER_46_669 vssd1 vssd1 vccd1 vccd1 sky130_fd_sc_hd__fill_4
XTAP_TAPCELL_ROW_16_506 vssd1 vccd1 sky130_fd_sc_hd__tapvpwrvgnd_1
XTAP_TAPCELL_ROW_107_1784 vssd1 vccd1 sky130_fd_sc_hd__tapvpwrvgnd_1
XFILLER_60_116 vssd1 vssd1 vccd1 vccd1 sky130_fd_sc_hd__fill_1
XANTENNA__05740__A2 net383 vssd1 vssd1 vccd1 vccd1 sky130_fd_sc_hd__diode_2
XFILLER_26_382 vssd1 vssd1 vccd1 vccd1 sky130_fd_sc_hd__fill_2
X_11753_ net900 _01099_ net684 vssd1 vssd1 vccd1 vccd1 FPGA_INST.cell3.SB0.route_sel\[123\]
+ sky130_fd_sc_hd__dfstp_1
XFILLER_14_544 vssd1 vssd1 vccd1 vccd1 sky130_fd_sc_hd__fill_2
XTAP_TAPCELL_ROW_120_1962 vssd1 vccd1 sky130_fd_sc_hd__tapvpwrvgnd_1
X_11684_ net898 _01030_ net682 vssd1 vssd1 vccd1 vccd1 FPGA_INST.cell3.SB0.route_sel\[54\]
+ sky130_fd_sc_hd__dfstp_1
XANTENNA__08690__A1 net19 vssd1 vssd1 vccd1 vccd1 sky130_fd_sc_hd__diode_2
X_10704_ net846 _00054_ net631 vssd1 vssd1 vccd1 vccd1 FPGA_INST.cell2.LE_0A.config_data\[3\]
+ sky130_fd_sc_hd__dfrtp_1
XANTENNA__06296__A3 net13 vssd1 vssd1 vccd1 vccd1 sky130_fd_sc_hd__diode_2
X_10635_ FPGA_INST.cell3.LE_1B.config_data\[5\] FPGA_INST.cell3.LE_1B.config_data\[4\]
+ net372 vssd1 vssd1 vccd1 vccd1 _01514_ sky130_fd_sc_hd__mux2_1
XANTENNA__05659__X _01939_ vssd1 vssd1 vccd1 vccd1 sky130_fd_sc_hd__diode_2
X_10566_ FPGA_INST.cell3.CB_0.config_dataA\[10\] net396 net294 vssd1 vssd1 vccd1 vccd1
+ _01445_ sky130_fd_sc_hd__mux2_1
XFILLER_6_754 vssd1 vssd1 vccd1 vccd1 sky130_fd_sc_hd__fill_2
XFILLER_108_671 vssd1 vssd1 vccd1 vccd1 sky130_fd_sc_hd__fill_1
X_10497_ FPGA_INST.cell2.SB0.route_sel\[69\] FPGA_INST.cell2.SB0.route_sel\[70\] net248
+ vssd1 vssd1 vccd1 vccd1 _01376_ sky130_fd_sc_hd__mux2_1
X_12167_ net910 _01513_ net694 vssd1 vssd1 vccd1 vccd1 FPGA_INST.cell3.LE_1B.config_data\[4\]
+ sky130_fd_sc_hd__dfrtp_1
XANTENNA__08745__A2 net82 vssd1 vssd1 vccd1 vccd1 sky130_fd_sc_hd__diode_2
X_11118_ net793 _00468_ net578 vssd1 vssd1 vccd1 vccd1 FPGA_INST.cell1.LE_1A.config_data\[9\]
+ sky130_fd_sc_hd__dfrtp_1
X_12098_ net927 _01444_ net711 vssd1 vssd1 vccd1 vccd1 FPGA_INST.cell3.CB_0.config_dataA\[10\]
+ sky130_fd_sc_hd__dfstp_1
XFILLER_110_368 vssd1 vssd1 vccd1 vccd1 sky130_fd_sc_hd__fill_4
X_11049_ net813 _00399_ net598 vssd1 vssd1 vccd1 vccd1 FPGA_INST.cell1.LEI0.config_data\[34\]
+ sky130_fd_sc_hd__dfrtp_1
XFILLER_77_794 vssd1 vssd1 vccd1 vccd1 sky130_fd_sc_hd__fill_4
XFILLER_77_772 vssd1 vssd1 vccd1 vccd1 sky130_fd_sc_hd__fill_2
Xinput7 gpio_in[15] vssd1 vssd1 vccd1 vccd1 net7 sky130_fd_sc_hd__buf_2
XFILLER_37_625 vssd1 vssd1 vccd1 vccd1 sky130_fd_sc_hd__fill_4
XTAP_TAPCELL_ROW_69_1245 vssd1 vccd1 sky130_fd_sc_hd__tapvpwrvgnd_1
XFILLER_36_135 vssd1 vssd1 vccd1 vccd1 sky130_fd_sc_hd__fill_4
X_05610_ _01874_ _01889_ _01872_ vssd1 vssd1 vccd1 vccd1 _01890_ sky130_fd_sc_hd__o21ai_1
XFILLER_92_797 vssd1 vssd1 vccd1 vccd1 sky130_fd_sc_hd__fill_2
XFILLER_64_488 vssd1 vssd1 vccd1 vccd1 sky130_fd_sc_hd__fill_2
X_06590_ FPGA_INST.bus3_2\[0\] FPGA_INST.bus3_2\[1\] FPGA_INST.bus3_2\[2\] FPGA_INST.bus3_2\[3\]
+ net484 FPGA_INST.cell2.CB_1.config_dataA\[1\] vssd1 vssd1 vccd1 vccd1 _02866_ sky130_fd_sc_hd__mux4_1
XANTENNA__05731__A2 _01966_ vssd1 vssd1 vccd1 vccd1 sky130_fd_sc_hd__diode_2
XTAP_TAPCELL_ROW_82_1434 vssd1 vccd1 sky130_fd_sc_hd__tapvpwrvgnd_1
X_05541_ FPGA_INST.cell0.CB_1.config_dataB\[24\] FPGA_INST.cell0.CB_1.config_dataB\[20\]
+ FPGA_INST.cell0.CB_1.config_dataB\[21\] vssd1 vssd1 vccd1 vccd1 _01821_ sky130_fd_sc_hd__or3b_2
XFILLER_17_393 vssd1 vssd1 vccd1 vccd1 sky130_fd_sc_hd__fill_1
X_08260_ net403 _03682_ _04483_ net402 vssd1 vssd1 vccd1 vccd1 _04484_ sky130_fd_sc_hd__o211a_1
X_05472_ FPGA_INST.cell0.CB_1.config_dataA\[7\] vssd1 vssd1 vccd1 vccd1 _01754_ sky130_fd_sc_hd__inv_2
XFILLER_32_363 vssd1 vssd1 vccd1 vccd1 sky130_fd_sc_hd__fill_1
X_07211_ FPGA_INST.cell1.SB0.route_sel\[10\] FPGA_INST.cell1.SB0.route_sel\[11\] _01715_
+ FPGA_INST.cell1.SB0.route_sel\[14\] _03473_ vssd1 vssd1 vccd1 vccd1 _03474_ sky130_fd_sc_hd__o221a_1
X_08191_ net410 _03558_ vssd1 vssd1 vccd1 vccd1 _04415_ sky130_fd_sc_hd__nand2_1
XTAP_TAPCELL_ROW_43_881 vssd1 vccd1 sky130_fd_sc_hd__tapvpwrvgnd_1
X_07142_ FPGA_INST.cell0.SB0.route_sel\[0\] FPGA_INST.cell0.SB0.route_sel\[1\] vssd1
+ vssd1 vccd1 vccd1 _03406_ sky130_fd_sc_hd__nand2b_1
XANTENNA__09188__S net266 vssd1 vssd1 vccd1 vccd1 sky130_fd_sc_hd__diode_2
XANTENNA__08433__B2 FPGA_INST.cell2.SB0.config_data_out vssd1 vssd1 vccd1 vccd1 sky130_fd_sc_hd__diode_2
XANTENNA__10127__S net369 vssd1 vssd1 vccd1 vccd1 sky130_fd_sc_hd__diode_2
XFILLER_105_107 vssd1 vssd1 vccd1 vccd1 sky130_fd_sc_hd__fill_4
X_07073_ _01734_ _03337_ _03338_ vssd1 vssd1 vccd1 vccd1 _03339_ sky130_fd_sc_hd__or3_1
XFILLER_126_490 vssd1 vssd1 vccd1 vccd1 sky130_fd_sc_hd__fill_2
X_06024_ net166 net160 FPGA_INST.bus2_0\[5\] vssd1 vssd1 vccd1 vccd1 _02304_ sky130_fd_sc_hd__o21ba_1
XTAP_TAPCELL_ROW_93_1585 vssd1 vccd1 sky130_fd_sc_hd__tapvpwrvgnd_1
XANTENNA__07944__B _04049_ vssd1 vssd1 vccd1 vccd1 sky130_fd_sc_hd__diode_2
X_07975_ _03810_ _04189_ _04202_ vssd1 vssd1 vccd1 vccd1 _04203_ sky130_fd_sc_hd__o21ai_1
XANTENNA_fanout383_A _01821_ vssd1 vssd1 vccd1 vccd1 sky130_fd_sc_hd__diode_2
XFILLER_19_15 vssd1 vssd1 vccd1 vccd1 sky130_fd_sc_hd__fill_8
XFILLER_101_368 vssd1 vssd1 vccd1 vccd1 sky130_fd_sc_hd__fill_1
XPHY_EDGE_ROW_98_Left_229 vssd1 vssd1 vccd1 vccd1 sky130_fd_sc_hd__decap_3
XFILLER_68_761 vssd1 vssd1 vccd1 vccd1 sky130_fd_sc_hd__fill_1
X_09714_ FPGA_INST.cell0.SB0.route_sel\[117\] FPGA_INST.cell0.SB0.route_sel\[118\]
+ net198 vssd1 vssd1 vccd1 vccd1 _00623_ sky130_fd_sc_hd__mux2_1
X_06926_ FPGA_INST.cell0.LEI0.config_data\[29\] _03193_ vssd1 vssd1 vccd1 vccd1 _03194_
+ sky130_fd_sc_hd__nand2b_1
XFILLER_83_753 vssd1 vssd1 vccd1 vccd1 sky130_fd_sc_hd__fill_2
XFILLER_27_113 vccd1 vssd1 vccd1 vssd1 sky130_ef_sc_hd__decap_40_12
XFILLER_28_658 vssd1 vssd1 vccd1 vccd1 sky130_fd_sc_hd__fill_2
X_06857_ net424 _02030_ net423 vssd1 vssd1 vccd1 vccd1 _03125_ sky130_fd_sc_hd__o21ai_1
X_09645_ FPGA_INST.cell0.SB0.route_sel\[48\] FPGA_INST.cell0.SB0.route_sel\[49\] net176
+ vssd1 vssd1 vccd1 vccd1 _00554_ sky130_fd_sc_hd__mux2_1
XFILLER_82_230 vssd1 vssd1 vccd1 vccd1 sky130_fd_sc_hd__fill_1
XFILLER_43_617 vssd1 vssd1 vccd1 vccd1 sky130_fd_sc_hd__fill_1
X_05808_ _02086_ _02087_ vssd1 vssd1 vccd1 vccd1 _02088_ sky130_fd_sc_hd__or2_1
XANTENNA_fanout171_X net171 vssd1 vssd1 vccd1 vccd1 sky130_fd_sc_hd__diode_2
X_09576_ FPGA_INST.cell1.CB_1.config_dataB\[4\] FPGA_INST.cell1.CB_1.config_dataB\[5\]
+ net217 vssd1 vssd1 vccd1 vccd1 _00485_ sky130_fd_sc_hd__mux2_1
XFILLER_70_414 vssd1 vssd1 vccd1 vccd1 sky130_fd_sc_hd__fill_1
X_06788_ _03054_ _03057_ _03061_ FPGA_INST.cell2.CB_1.config_dataB\[18\] vssd1 vssd1
+ vccd1 vccd1 _03062_ sky130_fd_sc_hd__or4b_1
X_08527_ FPGA_INST.cell3.LE_1A.config_data\[10\] FPGA_INST.cell3.LE_1A.config_data\[11\]
+ _04725_ vssd1 vssd1 vccd1 vccd1 _04740_ sky130_fd_sc_hd__mux2_1
XANTENNA_fanout815_A net820 vssd1 vssd1 vccd1 vccd1 sky130_fd_sc_hd__diode_2
X_05739_ FPGA_INST.cell0.CB_1.config_dataA\[22\] FPGA_INST.cell0.CB_1.config_dataA\[23\]
+ vssd1 vssd1 vccd1 vccd1 _02019_ sky130_fd_sc_hd__nand2b_2
X_08458_ FPGA_INST.cell1.LE_1A.config_data\[12\] FPGA_INST.cell1.LE_1A.config_data\[13\]
+ _04660_ vssd1 vssd1 vccd1 vccd1 _04676_ sky130_fd_sc_hd__mux2_1
XFILLER_11_503 vssd1 vssd1 vccd1 vccd1 sky130_fd_sc_hd__fill_1
XFILLER_11_514 vssd1 vssd1 vccd1 vccd1 sky130_fd_sc_hd__fill_4
X_07409_ _01680_ FPGA_INST.cell3.SB0.route_sel\[43\] _01681_ FPGA_INST.cell3.SB0.route_sel\[44\]
+ _03667_ vssd1 vssd1 vccd1 vccd1 _03668_ sky130_fd_sc_hd__o221a_1
X_10420_ FPGA_INST.cell3.CB_1.config_dataB\[18\] FPGA_INST.cell3.CB_1.config_dataB\[17\]
+ net370 vssd1 vssd1 vccd1 vccd1 _01299_ sky130_fd_sc_hd__mux2_1
X_08389_ FPGA_INST.bus1_0\[14\] FPGA_INST.bus1_0\[15\] net440 vssd1 vssd1 vccd1 vccd1
+ _04611_ sky130_fd_sc_hd__mux2_1
XFILLER_11_569 vssd1 vssd1 vccd1 vccd1 sky130_fd_sc_hd__fill_1
XTAP_TAPCELL_ROW_21_575 vssd1 vccd1 sky130_fd_sc_hd__tapvpwrvgnd_1
X_10351_ FPGA_INST.cell3.LE_0A.config_data\[15\] FPGA_INST.cell3.LE_0A.config_data\[16\]
+ net293 vssd1 vssd1 vccd1 vccd1 _01232_ sky130_fd_sc_hd__mux2_1
XANTENNA__08015__B _03568_ vssd1 vssd1 vccd1 vccd1 sky130_fd_sc_hd__diode_2
XANTENNA__07694__X FPGA_INST.bus3_2\[12\] vssd1 vssd1 vccd1 vccd1 sky130_fd_sc_hd__diode_2
X_10282_ net41 net42 net254 vssd1 vssd1 vccd1 vccd1 _01163_ sky130_fd_sc_hd__mux2_1
XFILLER_4_3 vccd1 vssd1 vccd1 vssd1 sky130_ef_sc_hd__decap_40_12
X_12021_ net847 _01367_ net632 vssd1 vssd1 vccd1 vccd1 FPGA_INST.cell2.SB0.route_sel\[61\]
+ sky130_fd_sc_hd__dfstp_1
XANTENNA_fanout84_X net84 vssd1 vssd1 vccd1 vccd1 sky130_fd_sc_hd__diode_2
XANTENNA__06738__B2 FPGA_INST.bus3_2\[1\] vssd1 vssd1 vccd1 vccd1 sky130_fd_sc_hd__diode_2
XANTENNA__06738__A1 FPGA_INST.bus3_2\[0\] vssd1 vssd1 vccd1 vccd1 sky130_fd_sc_hd__diode_2
XTAP_TAPCELL_ROW_53_1024 vssd1 vccd1 sky130_fd_sc_hd__tapvpwrvgnd_1
XFILLER_104_195 vssd1 vssd1 vccd1 vccd1 sky130_fd_sc_hd__fill_1
XFILLER_78_558 vssd1 vssd1 vccd1 vccd1 sky130_fd_sc_hd__fill_2
Xfanout560 net561 vssd1 vssd1 vccd1 vccd1 net560 sky130_fd_sc_hd__buf_2
XFILLER_120_699 vssd1 vssd1 vccd1 vccd1 sky130_fd_sc_hd__fill_1
Xfanout593 net596 vssd1 vssd1 vccd1 vccd1 net593 sky130_fd_sc_hd__clkbuf_4
XTAP_TAPCELL_ROW_109_1813 vssd1 vccd1 sky130_fd_sc_hd__tapvpwrvgnd_1
XTAP_TAPCELL_ROW_109_1802 vssd1 vccd1 sky130_fd_sc_hd__tapvpwrvgnd_1
XFILLER_76_65 vssd1 vssd1 vccd1 vccd1 sky130_fd_sc_hd__fill_2
Xfanout582 net588 vssd1 vssd1 vccd1 vccd1 net582 sky130_fd_sc_hd__clkbuf_4
Xfanout571 net573 vssd1 vssd1 vccd1 vccd1 net571 sky130_fd_sc_hd__clkbuf_4
XFILLER_86_591 vssd1 vssd1 vccd1 vccd1 sky130_fd_sc_hd__fill_1
XFILLER_74_731 vssd1 vssd1 vccd1 vccd1 sky130_fd_sc_hd__fill_1
XFILLER_58_293 vssd1 vssd1 vccd1 vccd1 sky130_fd_sc_hd__fill_1
XFILLER_74_753 vssd1 vssd1 vccd1 vccd1 sky130_fd_sc_hd__fill_2
XANTENNA__06910__B2 _02465_ vssd1 vssd1 vccd1 vccd1 sky130_fd_sc_hd__diode_2
XANTENNA__06910__A1 _02429_ vssd1 vssd1 vccd1 vccd1 sky130_fd_sc_hd__diode_2
XTAP_TAPCELL_ROW_29_686 vssd1 vccd1 sky130_fd_sc_hd__tapvpwrvgnd_1
XFILLER_92_64 vssd1 vssd1 vccd1 vccd1 sky130_fd_sc_hd__fill_1
XFILLER_61_447 vssd1 vssd1 vccd1 vccd1 sky130_fd_sc_hd__fill_1
XANTENNA__11427__RESET_B net732 vssd1 vssd1 vccd1 vccd1 sky130_fd_sc_hd__diode_2
X_11805_ net871 _01151_ net655 vssd1 vssd1 vccd1 vccd1 FPGA_INST.io_east_oeb\[30\]
+ sky130_fd_sc_hd__dfrtp_1
X_11736_ net897 _01082_ net681 vssd1 vssd1 vccd1 vccd1 FPGA_INST.cell3.SB0.route_sel\[106\]
+ sky130_fd_sc_hd__dfstp_1
XTAP_TAPCELL_ROW_64_1175 vssd1 vccd1 sky130_fd_sc_hd__tapvpwrvgnd_1
XANTENNA__06269__A3 net13 vssd1 vssd1 vccd1 vccd1 sky130_fd_sc_hd__diode_2
XFILLER_41_171 vssd1 vssd1 vccd1 vccd1 sky130_fd_sc_hd__fill_1
X_11667_ net905 _01013_ net689 vssd1 vssd1 vccd1 vccd1 FPGA_INST.cell3.SB0.route_sel\[37\]
+ sky130_fd_sc_hd__dfstp_1
XTAP_TAPCELL_ROW_40_840 vssd1 vccd1 sky130_fd_sc_hd__tapvpwrvgnd_1
X_10618_ FPGA_INST.cell3.CB_1.config_dataA\[13\] FPGA_INST.cell3.CB_1.config_dataA\[12\]
+ net378 vssd1 vssd1 vccd1 vccd1 _01497_ sky130_fd_sc_hd__mux2_1
X_11598_ net799 _00948_ net584 vssd1 vssd1 vccd1 vccd1 FPGA_INST.cell0.CB_1.config_dataA\[17\]
+ sky130_fd_sc_hd__dfstp_1
X_10549_ FPGA_INST.cell2.SB0.route_sel\[121\] FPGA_INST.cell2.SB0.route_sel\[122\]
+ net247 vssd1 vssd1 vccd1 vccd1 _01428_ sky130_fd_sc_hd__mux2_1
XANTENNA__09736__S net344 vssd1 vssd1 vccd1 vccd1 sky130_fd_sc_hd__diode_2
XFILLER_130_419 vssd1 vssd1 vccd1 vccd1 sky130_fd_sc_hd__fill_1
XFILLER_96_311 vssd1 vssd1 vccd1 vccd1 sky130_fd_sc_hd__fill_1
XANTENNA__06729__B2 _02843_ vssd1 vssd1 vccd1 vccd1 sky130_fd_sc_hd__diode_2
XANTENNA__06729__A1 _02840_ vssd1 vssd1 vccd1 vccd1 sky130_fd_sc_hd__diode_2
XFILLER_37_3 vssd1 vssd1 vccd1 vccd1 sky130_fd_sc_hd__fill_4
XANTENNA__08194__A3 FPGA_INST.bus1_0\[7\] vssd1 vssd1 vccd1 vccd1 sky130_fd_sc_hd__diode_2
XANTENNA__07941__A3 FPGA_INST.bus3_1\[11\] vssd1 vssd1 vccd1 vccd1 sky130_fd_sc_hd__diode_2
XFILLER_96_388 vssd1 vssd1 vccd1 vccd1 sky130_fd_sc_hd__fill_1
X_07760_ FPGA_INST.cell1.SB0.route_sel\[118\] FPGA_INST.cell1.SB0.route_sel\[119\]
+ vssd1 vssd1 vccd1 vccd1 _04010_ sky130_fd_sc_hd__nand2b_1
X_06711_ FPGA_INST.cell2.CB_1.config_dataB\[3\] _02980_ _02984_ _02977_ vssd1 vssd1
+ vccd1 vccd1 _02985_ sky130_fd_sc_hd__and4bb_1
X_07691_ FPGA_INST.cell3.SB0.route_sel\[96\] FPGA_INST.cell3.SB0.route_sel\[97\] _03938_
+ _03942_ net366 vssd1 vssd1 vccd1 vccd1 _03943_ sky130_fd_sc_hd__a311oi_4
XFILLER_80_701 vssd1 vssd1 vccd1 vccd1 sky130_fd_sc_hd__fill_2
X_09430_ FPGA_INST.cell2.CB_1.config_dataA\[24\] FPGA_INST.cell2.CB_1.config_dataA\[23\]
+ net354 vssd1 vssd1 vccd1 vccd1 _00343_ sky130_fd_sc_hd__mux2_1
XTAP_TAPCELL_ROW_48_951 vssd1 vccd1 sky130_fd_sc_hd__tapvpwrvgnd_1
XFILLER_37_444 vssd1 vssd1 vccd1 vccd1 sky130_fd_sc_hd__fill_4
X_06642_ net475 net474 vssd1 vssd1 vccd1 vccd1 _02918_ sky130_fd_sc_hd__nor2_1
XANTENNA__06901__A1 _01984_ vssd1 vssd1 vccd1 vccd1 sky130_fd_sc_hd__diode_2
XFILLER_24_105 vssd1 vssd1 vccd1 vccd1 sky130_fd_sc_hd__fill_2
X_06573_ _01589_ _01590_ FPGA_INST.cell2.CB_1.config_dataA\[9\] _02781_ _02848_ vssd1
+ vssd1 vccd1 vccd1 _02849_ sky130_fd_sc_hd__a41o_2
X_09361_ FPGA_INST.cell2.CB_0.config_dataA\[4\] net506 net240 vssd1 vssd1 vccd1 vccd1
+ _00274_ sky130_fd_sc_hd__mux2_1
XANTENNA__06901__B2 _01937_ vssd1 vssd1 vccd1 vccd1 sky130_fd_sc_hd__diode_2
XFILLER_17_190 vssd1 vssd1 vccd1 vccd1 sky130_fd_sc_hd__fill_1
X_05524_ FPGA_INST.config_bits\[6\] FPGA_INST.config_bits\[4\] FPGA_INST.config_bits\[5\]
+ FPGA_INST.config_bits\[7\] vssd1 vssd1 vccd1 vccd1 _01806_ sky130_fd_sc_hd__o31a_1
X_09292_ FPGA_INST.cell1.SB0.route_sel\[64\] FPGA_INST.cell1.SB0.route_sel\[63\] net339
+ vssd1 vssd1 vccd1 vccd1 _00205_ sky130_fd_sc_hd__mux2_1
X_08312_ _04532_ _04533_ FPGA_INST.cell0.CB_1.config_dataB\[7\] vssd1 vssd1 vccd1
+ vccd1 _04534_ sky130_fd_sc_hd__mux2_1
X_08243_ FPGA_INST.cell0.CB_1.config_dataA\[13\] FPGA_INST.cell0.CB_1.config_dataA\[12\]
+ FPGA_INST.cell0.CB_1.config_dataA\[14\] _04443_ vssd1 vssd1 vccd1 vccd1 _04467_
+ sky130_fd_sc_hd__or4bb_1
XFILLER_60_491 vssd1 vssd1 vccd1 vccd1 sky130_fd_sc_hd__fill_2
XFILLER_20_311 vssd1 vssd1 vccd1 vccd1 sky130_fd_sc_hd__fill_1
XANTENNA_fanout229_A net230 vssd1 vssd1 vccd1 vccd1 sky130_fd_sc_hd__diode_2
X_05455_ FPGA_INST.cell0.CB_0.config_dataA\[18\] vssd1 vssd1 vccd1 vccd1 _01737_ sky130_fd_sc_hd__inv_2
XANTENNA_fanout131_A net132 vssd1 vssd1 vccd1 vccd1 sky130_fd_sc_hd__diode_2
X_05386_ FPGA_INST.cell1.SB0.route_sel\[62\] vssd1 vssd1 vccd1 vccd1 _01668_ sky130_fd_sc_hd__inv_2
X_08174_ FPGA_INST.cell0.CB_1.config_dataA\[3\] FPGA_INST.cell0.CB_1.config_dataA\[2\]
+ vssd1 vssd1 vccd1 vccd1 _04398_ sky130_fd_sc_hd__nor2_1
XANTENNA__06335__S _02536_ vssd1 vssd1 vccd1 vccd1 sky130_fd_sc_hd__diode_2
XFILLER_118_243 vssd1 vssd1 vccd1 vccd1 sky130_fd_sc_hd__fill_1
XTAP_TAPCELL_ROW_95_1614 vssd1 vccd1 sky130_fd_sc_hd__tapvpwrvgnd_1
X_07125_ _03387_ _03390_ _03347_ vssd1 vssd1 vccd1 vccd1 _03391_ sky130_fd_sc_hd__mux2_1
X_07056_ _02465_ _03317_ _03318_ _02429_ FPGA_INST.cell0.CB_0.config_dataA\[12\] vssd1
+ vssd1 vccd1 vccd1 _03322_ sky130_fd_sc_hd__a221o_1
XANTENNA_fanout598_A net604 vssd1 vssd1 vccd1 vccd1 sky130_fd_sc_hd__diode_2
X_06007_ _02286_ net136 _02285_ vssd1 vssd1 vccd1 vccd1 _02287_ sky130_fd_sc_hd__mux2_1
XFILLER_87_300 vssd1 vssd1 vccd1 vccd1 sky130_fd_sc_hd__fill_1
XFILLER_0_727 vssd1 vssd1 vccd1 vccd1 sky130_fd_sc_hd__fill_1
XFILLER_87_322 vccd1 vssd1 vccd1 vssd1 sky130_ef_sc_hd__decap_40_12
XFILLER_48_709 vssd1 vssd1 vccd1 vccd1 sky130_fd_sc_hd__fill_2
XFILLER_75_517 vssd1 vssd1 vccd1 vccd1 sky130_fd_sc_hd__fill_4
XANTENNA__06196__A2 _02472_ vssd1 vssd1 vccd1 vccd1 sky130_fd_sc_hd__diode_2
X_07958_ net463 _03568_ vssd1 vssd1 vccd1 vccd1 _04186_ sky130_fd_sc_hd__nand2_1
XANTENNA__05943__A2 net383 vssd1 vssd1 vccd1 vccd1 sky130_fd_sc_hd__diode_2
XFILLER_56_731 vssd1 vssd1 vccd1 vccd1 sky130_fd_sc_hd__fill_4
XFILLER_46_24 vssd1 vssd1 vccd1 vccd1 sky130_fd_sc_hd__fill_4
XANTENNA__09381__S net350 vssd1 vssd1 vccd1 vccd1 sky130_fd_sc_hd__diode_2
XANTENNA_fanout932_A net946 vssd1 vssd1 vccd1 vccd1 sky130_fd_sc_hd__diode_2
X_07889_ FPGA_INST.cell1.CB_0.config_dataA\[1\] net472 vssd1 vssd1 vccd1 vccd1 _04117_
+ sky130_fd_sc_hd__nor2_1
XANTENNA__08342__A0 net73 vssd1 vssd1 vccd1 vccd1 sky130_fd_sc_hd__diode_2
X_06909_ net419 _02392_ _03176_ net417 vssd1 vssd1 vccd1 vccd1 _03177_ sky130_fd_sc_hd__o211a_1
XFILLER_56_797 vssd1 vssd1 vccd1 vccd1 sky130_fd_sc_hd__fill_2
X_09628_ FPGA_INST.cell0.SB0.route_sel\[32\] FPGA_INST.cell0.SB0.route_sel\[31\] net321
+ vssd1 vssd1 vccd1 vccd1 _00537_ sky130_fd_sc_hd__mux2_1
XTAP_TAPCELL_ROW_104_1743 vssd1 vccd1 sky130_fd_sc_hd__tapvpwrvgnd_1
XTAP_TAPCELL_ROW_104_1732 vssd1 vccd1 sky130_fd_sc_hd__tapvpwrvgnd_1
X_09559_ FPGA_INST.cell1.LE_1A.config_data\[9\] FPGA_INST.cell1.LE_1A.config_data\[8\]
+ net326 vssd1 vssd1 vccd1 vccd1 _00468_ sky130_fd_sc_hd__mux2_1
XFILLER_43_447 vssd1 vssd1 vccd1 vccd1 sky130_fd_sc_hd__fill_1
XTAP_TAPCELL_ROW_26_645 vssd1 vccd1 sky130_fd_sc_hd__tapvpwrvgnd_1
XFILLER_102_85 vssd1 vssd1 vccd1 vccd1 sky130_fd_sc_hd__fill_4
XFILLER_70_266 vssd1 vssd1 vccd1 vccd1 sky130_fd_sc_hd__fill_2
XANTENNA__06656__A0 FPGA_INST.bus3_2\[0\] vssd1 vssd1 vccd1 vccd1 sky130_fd_sc_hd__diode_2
XFILLER_23_182 vssd1 vssd1 vccd1 vccd1 sky130_fd_sc_hd__fill_2
X_11521_ net809 _00871_ net595 vssd1 vssd1 vccd1 vccd1 FPGA_INST.config_bits\[2\]
+ sky130_fd_sc_hd__dfstp_1
X_11452_ net750 _00802_ net535 vssd1 vssd1 vccd1 vccd1 FPGA_INST.cell0.LE_0B.config_data\[1\]
+ sky130_fd_sc_hd__dfrtp_1
XFILLER_11_388 vssd1 vssd1 vccd1 vccd1 sky130_fd_sc_hd__fill_4
X_10403_ FPGA_INST.cell3.CB_1.config_dataB\[0\] FPGA_INST.cell3.CB_1.config_dataB\[1\]
+ net281 vssd1 vssd1 vccd1 vccd1 _01282_ sky130_fd_sc_hd__mux2_1
XANTENNA__07605__C1 _03856_ vssd1 vssd1 vccd1 vccd1 sky130_fd_sc_hd__diode_2
X_11383_ net747 _00733_ net532 vssd1 vssd1 vccd1 vccd1 FPGA_INST.cell0.LEI0.config_data\[4\]
+ sky130_fd_sc_hd__dfrtp_1
X_10334_ FPGA_INST.cell3.LE_0B.dff1_out _05108_ net737 vssd1 vssd1 vccd1 vccd1 _01215_
+ sky130_fd_sc_hd__mux2_1
XANTENNA__06959__A1 net119 vssd1 vssd1 vccd1 vccd1 sky130_fd_sc_hd__diode_2
XFILLER_124_257 vssd1 vssd1 vccd1 vccd1 sky130_fd_sc_hd__fill_1
XTAP_TAPCELL_ROW_115_1894 vssd1 vccd1 sky130_fd_sc_hd__tapvpwrvgnd_1
X_10265_ FPGA_INST.io_east_oeb\[18\] FPGA_INST.io_east_oeb\[20\] net257 vssd1 vssd1
+ vccd1 vccd1 _01146_ sky130_fd_sc_hd__mux2_1
XFILLER_120_430 vssd1 vssd1 vccd1 vccd1 sky130_fd_sc_hd__fill_4
X_10196_ FPGA_INST.cell3.SB0.route_sel\[101\] FPGA_INST.cell3.SB0.route_sel\[100\]
+ net365 vssd1 vssd1 vccd1 vccd1 _01077_ sky130_fd_sc_hd__mux2_1
X_12004_ net855 _01350_ net640 vssd1 vssd1 vccd1 vccd1 FPGA_INST.cell2.SB0.route_sel\[44\]
+ sky130_fd_sc_hd__dfstp_1
XFILLER_87_97 vssd1 vssd1 vccd1 vccd1 sky130_fd_sc_hd__fill_2
XTAP_TAPCELL_ROW_6_370 vssd1 vccd1 sky130_fd_sc_hd__tapvpwrvgnd_1
Xfanout390 FPGA_INST.cell3.CB_0.config_dataB\[5\] vssd1 vssd1 vccd1 vccd1 net390 sky130_fd_sc_hd__buf_2
XFILLER_47_731 vssd1 vssd1 vccd1 vccd1 sky130_fd_sc_hd__fill_1
XFILLER_62_701 vssd1 vssd1 vccd1 vccd1 sky130_fd_sc_hd__fill_1
XTAP_TAPCELL_ROW_66_1204 vssd1 vccd1 sky130_fd_sc_hd__tapvpwrvgnd_1
XTAP_TAPCELL_ROW_45_910 vssd1 vccd1 sky130_fd_sc_hd__tapvpwrvgnd_1
XFILLER_19_488 vssd1 vssd1 vccd1 vccd1 sky130_fd_sc_hd__fill_4
XANTENNA__07599__X _03853_ vssd1 vssd1 vccd1 vccd1 sky130_fd_sc_hd__diode_2
XFILLER_61_255 vssd1 vssd1 vccd1 vccd1 sky130_fd_sc_hd__fill_2
XANTENNA__11014__SET_B net732 vssd1 vssd1 vccd1 vccd1 sky130_fd_sc_hd__diode_2
X_11719_ net901 _01065_ net685 vssd1 vssd1 vccd1 vccd1 FPGA_INST.cell3.SB0.route_sel\[89\]
+ sky130_fd_sc_hd__dfstp_1
Xinput21 gpio_in[28] vssd1 vssd1 vccd1 vccd1 net21 sky130_fd_sc_hd__buf_2
Xinput10 gpio_in[18] vssd1 vssd1 vccd1 vccd1 net10 sky130_fd_sc_hd__clkbuf_2
XTAP_TAPCELL_ROW_77_1355 vssd1 vccd1 sky130_fd_sc_hd__tapvpwrvgnd_1
XTAP_TAPCELL_ROW_77_1366 vssd1 vccd1 sky130_fd_sc_hd__tapvpwrvgnd_1
XFILLER_115_279 vssd1 vssd1 vccd1 vccd1 sky130_fd_sc_hd__fill_1
X_08930_ FPGA_INST.cell3.SB0.route_sel\[96\] _01625_ _01626_ FPGA_INST.cell3.SB0.route_sel\[99\]
+ _05126_ vssd1 vssd1 vccd1 vccd1 _05127_ sky130_fd_sc_hd__a221o_1
XFILLER_69_311 vssd1 vssd1 vccd1 vccd1 sky130_fd_sc_hd__fill_4
X_08861_ _05066_ _05067_ _05000_ vssd1 vssd1 vccd1 vccd1 _05068_ sky130_fd_sc_hd__mux2_1
XTAP_TAPCELL_ROW_90_1544 vssd1 vccd1 sky130_fd_sc_hd__tapvpwrvgnd_1
XFILLER_97_675 vssd1 vssd1 vccd1 vccd1 sky130_fd_sc_hd__fill_2
XFILLER_97_664 vssd1 vssd1 vccd1 vccd1 sky130_fd_sc_hd__fill_4
XFILLER_96_141 vssd1 vssd1 vccd1 vccd1 sky130_fd_sc_hd__fill_4
X_07812_ FPGA_INST.cell3.SB0.route_sel\[120\] FPGA_INST.cell3.SB0.route_sel\[121\]
+ _01601_ FPGA_INST.cell3.SB0.route_sel\[123\] _04060_ vssd1 vssd1 vccd1 vccd1 _04061_
+ sky130_fd_sc_hd__o221a_1
XFILLER_29_208 vssd1 vssd1 vccd1 vccd1 sky130_fd_sc_hd__fill_1
X_08792_ FPGA_INST.cell3.LEI0.config_data\[17\] _04998_ vssd1 vssd1 vccd1 vccd1 _04999_
+ sky130_fd_sc_hd__nor2_1
XFILLER_97_697 vssd1 vssd1 vccd1 vccd1 sky130_fd_sc_hd__fill_2
XFILLER_84_325 vssd1 vssd1 vccd1 vccd1 sky130_fd_sc_hd__fill_4
XANTENNA__05925__A2 _02204_ vssd1 vssd1 vccd1 vccd1 sky130_fd_sc_hd__diode_2
X_07743_ net146 _03992_ vssd1 vssd1 vccd1 vccd1 _03993_ sky130_fd_sc_hd__nand2_1
XFILLER_38_742 vssd1 vssd1 vccd1 vccd1 sky130_fd_sc_hd__fill_1
XFILLER_38_753 vssd1 vssd1 vccd1 vccd1 sky130_fd_sc_hd__fill_2
XANTENNA__10140__S net348 vssd1 vssd1 vccd1 vccd1 sky130_fd_sc_hd__diode_2
X_07674_ FPGA_INST.cell1.CB_1.config_dataA\[23\] FPGA_INST.cell1.CB_1.config_dataA\[22\]
+ vssd1 vssd1 vccd1 vccd1 _03926_ sky130_fd_sc_hd__nand2_2
X_06625_ _02824_ _02880_ _02882_ _02819_ _01592_ vssd1 vssd1 vccd1 vccd1 _02901_ sky130_fd_sc_hd__a221o_1
X_09413_ FPGA_INST.cell2.CB_1.config_dataA\[7\] net480 net362 vssd1 vssd1 vccd1 vccd1
+ _00326_ sky130_fd_sc_hd__mux2_1
XFILLER_16_27 vssd1 vssd1 vccd1 vccd1 sky130_fd_sc_hd__fill_1
XANTENNA_fanout346_A net348 vssd1 vssd1 vccd1 vccd1 sky130_fd_sc_hd__diode_2
XANTENNA__06350__A2 _02255_ vssd1 vssd1 vccd1 vccd1 sky130_fd_sc_hd__diode_2
XTAP_TAPCELL_ROW_23_604 vssd1 vccd1 sky130_fd_sc_hd__tapvpwrvgnd_1
XFILLER_25_469 vssd1 vssd1 vccd1 vccd1 sky130_fd_sc_hd__fill_1
X_09344_ FPGA_INST.cell1.SB0.route_sel\[115\] FPGA_INST.cell1.SB0.route_sel\[116\]
+ net225 vssd1 vssd1 vccd1 vccd1 _00257_ sky130_fd_sc_hd__mux2_1
XFILLER_21_620 vssd1 vssd1 vccd1 vccd1 sky130_fd_sc_hd__fill_1
X_06556_ net246 _02081_ _02088_ _02831_ vssd1 vssd1 vccd1 vccd1 _02832_ sky130_fd_sc_hd__and4_4
X_05507_ net150 vssd1 vssd1 vccd1 vccd1 _01789_ sky130_fd_sc_hd__inv_2
X_09275_ FPGA_INST.cell1.SB0.route_sel\[47\] FPGA_INST.cell1.SB0.route_sel\[46\] net330
+ vssd1 vssd1 vccd1 vccd1 _00188_ sky130_fd_sc_hd__mux2_1
XANTENNA__06102__A2 net383 vssd1 vssd1 vccd1 vccd1 sky130_fd_sc_hd__diode_2
XANTENNA_fanout134_X net134 vssd1 vssd1 vccd1 vccd1 sky130_fd_sc_hd__diode_2
X_06487_ FPGA_INST.cell2.LE_0B.config_data\[11\] FPGA_INST.cell2.LE_0B.config_data\[10\]
+ _02688_ vssd1 vssd1 vccd1 vccd1 _02765_ sky130_fd_sc_hd__mux2_1
XFILLER_20_141 vssd1 vssd1 vccd1 vccd1 sky130_fd_sc_hd__fill_4
XFILLER_21_653 vssd1 vssd1 vccd1 vccd1 sky130_fd_sc_hd__fill_8
XFILLER_32_26 vssd1 vssd1 vccd1 vccd1 sky130_fd_sc_hd__fill_2
XANTENNA__11327__CLK net842 vssd1 vssd1 vccd1 vccd1 sky130_fd_sc_hd__diode_2
X_05438_ FPGA_INST.cell3.SB0.route_sel\[4\] vssd1 vssd1 vccd1 vccd1 _01720_ sky130_fd_sc_hd__inv_2
X_08226_ _04442_ _04445_ FPGA_INST.cell0.CB_1.config_dataA\[12\] vssd1 vssd1 vccd1
+ vccd1 _04450_ sky130_fd_sc_hd__or3b_1
X_08157_ net412 _03997_ _04380_ net411 vssd1 vssd1 vccd1 vccd1 _04381_ sky130_fd_sc_hd__o211a_1
XANTENNA__07850__A2 _02487_ vssd1 vssd1 vccd1 vccd1 sky130_fd_sc_hd__diode_2
X_05369_ FPGA_INST.cell1.SB0.route_sel\[77\] vssd1 vssd1 vccd1 vccd1 _01651_ sky130_fd_sc_hd__inv_2
X_07108_ FPGA_INST.bus2_0\[12\] FPGA_INST.bus2_0\[14\] FPGA_INST.bus2_0\[13\] FPGA_INST.bus2_0\[15\]
+ net426 net428 vssd1 vssd1 vccd1 vccd1 _03374_ sky130_fd_sc_hd__mux4_1
XANTENNA__09376__S net240 vssd1 vssd1 vccd1 vccd1 sky130_fd_sc_hd__diode_2
XANTENNA__07063__A0 FPGA_INST.bus2_0\[6\] vssd1 vssd1 vccd1 vccd1 sky130_fd_sc_hd__diode_2
X_08088_ net453 net455 _03769_ vssd1 vssd1 vccd1 vccd1 _04314_ sky130_fd_sc_hd__or3_1
XANTENNA_fanout882_A net892 vssd1 vssd1 vccd1 vccd1 sky130_fd_sc_hd__diode_2
X_07039_ FPGA_INST.bus2_0\[2\] FPGA_INST.bus2_0\[3\] net436 vssd1 vssd1 vccd1 vccd1
+ _03305_ sky130_fd_sc_hd__mux2_1
Xteam_15_960 vssd1 vssd1 vccd1 vccd1 team_15_960/HI gpio_oeb[28] sky130_fd_sc_hd__conb_1
XFILLER_88_631 vssd1 vssd1 vccd1 vccd1 sky130_fd_sc_hd__fill_2
X_10050_ FPGA_INST.cell0.CB_0.config_dataB\[24\] net413 net183 vssd1 vssd1 vccd1 vccd1
+ _00931_ sky130_fd_sc_hd__mux2_1
Xteam_15_971 vssd1 vssd1 vccd1 vccd1 gpio_oeb[5] team_15_971/LO sky130_fd_sc_hd__conb_1
XFILLER_87_185 vssd1 vssd1 vccd1 vccd1 sky130_fd_sc_hd__fill_1
XFILLER_28_230 vssd1 vssd1 vccd1 vccd1 sky130_fd_sc_hd__fill_1
XFILLER_29_742 vssd1 vssd1 vccd1 vccd1 sky130_fd_sc_hd__fill_4
XFILLER_113_51 vssd1 vssd1 vccd1 vccd1 sky130_fd_sc_hd__fill_4
XFILLER_44_701 vssd1 vssd1 vccd1 vccd1 sky130_fd_sc_hd__fill_8
X_10952_ net864 _00302_ net649 vssd1 vssd1 vccd1 vccd1 FPGA_INST.cell2.CB_0.config_dataB\[8\]
+ sky130_fd_sc_hd__dfstp_1
X_10883_ net797 _00233_ net582 vssd1 vssd1 vccd1 vccd1 FPGA_INST.cell1.SB0.route_sel\[92\]
+ sky130_fd_sc_hd__dfstp_1
XFILLER_73_66 vssd1 vssd1 vccd1 vccd1 sky130_fd_sc_hd__fill_4
XFILLER_71_553 vssd1 vssd1 vccd1 vccd1 sky130_fd_sc_hd__fill_4
XFILLER_44_778 vssd1 vssd1 vccd1 vccd1 sky130_fd_sc_hd__fill_1
XFILLER_43_266 vssd1 vssd1 vccd1 vccd1 sky130_fd_sc_hd__fill_1
XANTENNA__07212__X _03475_ vssd1 vssd1 vccd1 vccd1 sky130_fd_sc_hd__diode_2
XTAP_TAPCELL_ROW_61_1134 vssd1 vccd1 sky130_fd_sc_hd__tapvpwrvgnd_1
X_11504_ net763 _00854_ net548 vssd1 vssd1 vccd1 vccd1 FPGA_INST.cell0.CB_1.config_dataB\[10\]
+ sky130_fd_sc_hd__dfstp_1
XTAP_TAPCELL_ROW_117_1923 vssd1 vccd1 sky130_fd_sc_hd__tapvpwrvgnd_1
XFILLER_7_134 vssd1 vssd1 vccd1 vccd1 sky130_fd_sc_hd__fill_4
XANTENNA__05667__X _01947_ vssd1 vssd1 vccd1 vccd1 sky130_fd_sc_hd__diode_2
XFILLER_7_167 vssd1 vssd1 vccd1 vccd1 sky130_fd_sc_hd__fill_1
X_11435_ net774 _00785_ net559 vssd1 vssd1 vccd1 vccd1 FPGA_INST.cell0.LE_0A.config_data\[6\]
+ sky130_fd_sc_hd__dfrtp_1
X_11366_ net819 _00716_ net603 vssd1 vssd1 vccd1 vccd1 FPGA_INST.cell1.LE_1B.config_data\[8\]
+ sky130_fd_sc_hd__dfrtp_1
XFILLER_125_555 vssd1 vssd1 vccd1 vccd1 sky130_fd_sc_hd__fill_1
X_10317_ FPGA_INST.cell3.LEI0.config_data\[31\] FPGA_INST.cell3.LEI0.config_data\[32\]
+ net297 vssd1 vssd1 vccd1 vccd1 _01198_ sky130_fd_sc_hd__mux2_1
X_11297_ net832 _00647_ net616 vssd1 vssd1 vccd1 vccd1 FPGA_INST.cell1.CB_0.config_dataA\[14\]
+ sky130_fd_sc_hd__dfstp_1
XFILLER_106_791 vssd1 vssd1 vccd1 vccd1 sky130_fd_sc_hd__fill_4
X_10248_ FPGA_INST.io_south_oeb\[16\] FPGA_INST.io_south_oeb\[18\] net290 vssd1 vssd1
+ vccd1 vccd1 _01129_ sky130_fd_sc_hd__mux2_1
XFILLER_78_141 vssd1 vssd1 vccd1 vccd1 sky130_fd_sc_hd__fill_1
XTAP_TAPCELL_ROW_72_1285 vssd1 vccd1 sky130_fd_sc_hd__tapvpwrvgnd_1
XFILLER_121_794 vssd1 vssd1 vccd1 vccd1 sky130_fd_sc_hd__fill_4
XFILLER_121_783 vssd1 vssd1 vccd1 vccd1 sky130_fd_sc_hd__fill_1
X_10179_ FPGA_INST.cell3.SB0.route_sel\[83\] FPGA_INST.cell3.SB0.route_sel\[84\] net287
+ vssd1 vssd1 vccd1 vccd1 _01060_ sky130_fd_sc_hd__mux2_1
XTAP_TAPCELL_ROW_72_1296 vssd1 vccd1 sky130_fd_sc_hd__tapvpwrvgnd_1
XANTENNA__07109__A1 FPGA_INST.bus2_0\[9\] vssd1 vssd1 vccd1 vccd1 sky130_fd_sc_hd__diode_2
XFILLER_93_177 vssd1 vssd1 vccd1 vccd1 sky130_fd_sc_hd__fill_4
XFILLER_74_380 vssd1 vssd1 vccd1 vccd1 sky130_fd_sc_hd__fill_4
XFILLER_62_531 vssd1 vssd1 vccd1 vccd1 sky130_fd_sc_hd__fill_1
XFILLER_19_285 vssd1 vssd1 vccd1 vccd1 sky130_fd_sc_hd__fill_1
XANTENNA__06868__A0 FPGA_INST.bus2_0\[12\] vssd1 vssd1 vccd1 vccd1 sky130_fd_sc_hd__diode_2
XFILLER_34_222 vssd1 vssd1 vccd1 vccd1 sky130_fd_sc_hd__fill_1
XFILLER_62_564 vssd1 vssd1 vccd1 vccd1 sky130_fd_sc_hd__fill_4
X_06410_ _02667_ _02685_ _02687_ _02684_ vssd1 vssd1 vccd1 vccd1 _02688_ sky130_fd_sc_hd__o211a_4
XFILLER_22_406 vccd1 vssd1 vccd1 vssd1 sky130_ef_sc_hd__decap_40_12
X_07390_ _03642_ _03648_ net330 vssd1 vssd1 vccd1 vccd1 _03649_ sky130_fd_sc_hd__a21oi_1
X_06341_ _01536_ FPGA_INST.cell2.LE_0A.dff_out vssd1 vssd1 vccd1 vccd1 _02620_ sky130_fd_sc_hd__or2_1
X_09060_ net939 FPGA_INST.cell3.LE_0B.edge_mode vssd1 vssd1 vccd1 vccd1 FPGA_INST.cell3.LE_0B.sel_clk
+ sky130_fd_sc_hd__xnor2_1
X_06272_ net503 _02413_ _02551_ net502 vssd1 vssd1 vccd1 vccd1 _02552_ sky130_fd_sc_hd__o211a_1
X_08011_ _03652_ _04234_ _04236_ _03613_ vssd1 vssd1 vccd1 vccd1 _04237_ sky130_fd_sc_hd__a2bb2o_1
XFILLER_8_83 vssd1 vssd1 vccd1 vccd1 sky130_fd_sc_hd__fill_1
XFILLER_118_29 vccd1 vssd1 vccd1 vssd1 sky130_ef_sc_hd__decap_40_12
XFILLER_104_706 vssd1 vssd1 vccd1 vccd1 sky130_fd_sc_hd__fill_1
XANTENNA__10135__S net369 vssd1 vssd1 vccd1 vccd1 sky130_fd_sc_hd__diode_2
XFILLER_89_428 vssd1 vssd1 vccd1 vccd1 sky130_fd_sc_hd__fill_2
X_09962_ FPGA_INST.cell0.CB_1.config_dataB\[22\] FPGA_INST.cell0.CB_1.config_dataB\[23\]
+ net195 vssd1 vssd1 vccd1 vccd1 _00867_ sky130_fd_sc_hd__mux2_1
XFILLER_103_249 vssd1 vssd1 vccd1 vccd1 sky130_fd_sc_hd__fill_2
X_08913_ _04023_ _05115_ vssd1 vssd1 vccd1 vccd1 FPGA_INST.bus3_1\[14\] sky130_fd_sc_hd__and2_2
XANTENNA_fanout296_A net300 vssd1 vssd1 vccd1 vccd1 sky130_fd_sc_hd__diode_2
X_09893_ net736 _04513_ vssd1 vssd1 vccd1 vccd1 _05219_ sky130_fd_sc_hd__and2_1
XANTENNA__07899__A2 _03519_ vssd1 vssd1 vccd1 vccd1 sky130_fd_sc_hd__diode_2
X_08844_ _04794_ _05036_ _05038_ _04789_ FPGA_INST.cell3.CB_0.config_dataB\[12\] vssd1
+ vssd1 vccd1 vccd1 _05051_ sky130_fd_sc_hd__a221o_1
X_08775_ net390 _04839_ vssd1 vssd1 vccd1 vccd1 _04982_ sky130_fd_sc_hd__or2_1
XFILLER_85_667 vssd1 vssd1 vccd1 vccd1 sky130_fd_sc_hd__fill_4
XFILLER_84_133 vssd1 vssd1 vccd1 vccd1 sky130_fd_sc_hd__fill_4
XANTENNA__06020__A1 net165 vssd1 vssd1 vccd1 vccd1 sky130_fd_sc_hd__diode_2
X_05987_ _02258_ _02263_ _02266_ net320 vssd1 vssd1 vccd1 vccd1 _02267_ sky130_fd_sc_hd__a211o_2
X_07726_ _03486_ _03939_ vssd1 vssd1 vccd1 vccd1 _03977_ sky130_fd_sc_hd__or2_1
XFILLER_72_306 vssd1 vssd1 vccd1 vccd1 sky130_fd_sc_hd__fill_2
XANTENNA__06571__A2 net132 vssd1 vssd1 vccd1 vccd1 sky130_fd_sc_hd__diode_2
XFILLER_26_712 vssd1 vssd1 vccd1 vccd1 sky130_fd_sc_hd__fill_2
XFILLER_38_550 vccd1 vssd1 vccd1 vssd1 sky130_ef_sc_hd__decap_40_12
XFILLER_38_583 vssd1 vssd1 vccd1 vccd1 sky130_fd_sc_hd__fill_1
XFILLER_65_391 vssd1 vssd1 vccd1 vccd1 sky130_fd_sc_hd__fill_1
XANTENNA_fanout349_X net349 vssd1 vssd1 vccd1 vccd1 sky130_fd_sc_hd__diode_2
XANTENNA_fanout728_A net729 vssd1 vssd1 vccd1 vccd1 sky130_fd_sc_hd__diode_2
X_07657_ FPGA_INST.cell3.SB0.route_sel\[98\] FPGA_INST.cell3.SB0.route_sel\[99\] vssd1
+ vssd1 vccd1 vccd1 _03909_ sky130_fd_sc_hd__nand2_1
XFILLER_41_715 vccd1 vssd1 vccd1 vssd1 sky130_ef_sc_hd__decap_40_12
XTAP_TAPCELL_ROW_101_1702 vssd1 vccd1 sky130_fd_sc_hd__tapvpwrvgnd_1
X_07588_ FPGA_INST.cell1.SB0.route_sel\[87\] FPGA_INST.cell1.SB0.route_sel\[86\] net108
+ _03836_ vssd1 vssd1 vccd1 vccd1 _03842_ sky130_fd_sc_hd__a211o_1
X_06608_ _02784_ _02780_ _02772_ _02776_ net478 net477 vssd1 vssd1 vccd1 vccd1 _02884_
+ sky130_fd_sc_hd__mux4_1
XTAP_TAPCELL_ROW_36_784 vssd1 vccd1 sky130_fd_sc_hd__tapvpwrvgnd_1
X_09327_ FPGA_INST.cell1.SB0.route_sel\[99\] FPGA_INST.cell1.SB0.route_sel\[98\] net340
+ vssd1 vssd1 vccd1 vccd1 _00240_ sky130_fd_sc_hd__mux2_1
X_06539_ net481 _02814_ vssd1 vssd1 vccd1 vccd1 _02815_ sky130_fd_sc_hd__nand2_1
XFILLER_43_69 vccd1 vssd1 vccd1 vssd1 sky130_ef_sc_hd__decap_40_12
XFILLER_21_461 vssd1 vssd1 vccd1 vccd1 sky130_fd_sc_hd__fill_4
X_09258_ FPGA_INST.cell1.SB0.route_sel\[29\] FPGA_INST.cell1.SB0.route_sel\[30\] net220
+ vssd1 vssd1 vccd1 vccd1 _00171_ sky130_fd_sc_hd__mux2_1
XFILLER_21_494 vssd1 vssd1 vccd1 vccd1 sky130_fd_sc_hd__fill_2
X_08209_ FPGA_INST.bus1_0\[13\] _04413_ _04432_ net408 _01754_ vssd1 vssd1 vccd1 vccd1
+ _04433_ sky130_fd_sc_hd__a221o_1
X_09189_ FPGA_INST.cell2.LE_1A.config_data\[7\] FPGA_INST.cell2.LE_1A.config_data\[6\]
+ net361 vssd1 vssd1 vccd1 vccd1 _00102_ sky130_fd_sc_hd__mux2_1
XANTENNA__07036__A0 FPGA_INST.bus2_0\[6\] vssd1 vssd1 vccd1 vccd1 sky130_fd_sc_hd__diode_2
XTAP_TAPCELL_ROW_130_2109 vssd1 vccd1 sky130_fd_sc_hd__tapvpwrvgnd_1
XFILLER_119_393 vssd1 vssd1 vccd1 vccd1 sky130_fd_sc_hd__fill_2
XFILLER_104_3 vssd1 vssd1 vccd1 vccd1 sky130_fd_sc_hd__fill_2
X_11220_ net765 _00570_ net550 vssd1 vssd1 vccd1 vccd1 FPGA_INST.cell0.SB0.route_sel\[65\]
+ sky130_fd_sc_hd__dfstp_1
X_11151_ net810 _00501_ net593 vssd1 vssd1 vccd1 vccd1 FPGA_INST.cell1.CB_1.config_dataB\[21\]
+ sky130_fd_sc_hd__dfstp_1
XTAP_TAPCELL_ROW_112_1853 vssd1 vccd1 sky130_fd_sc_hd__tapvpwrvgnd_1
X_10102_ FPGA_INST.cell3.SB0.route_sel\[6\] FPGA_INST.cell3.SB0.route_sel\[7\] net272
+ vssd1 vssd1 vccd1 vccd1 _00983_ sky130_fd_sc_hd__mux2_1
XFILLER_68_33 vssd1 vssd1 vccd1 vccd1 sky130_fd_sc_hd__fill_2
XANTENNA__05598__B1 FPGA_INST.bus1_0\[15\] vssd1 vssd1 vccd1 vccd1 sky130_fd_sc_hd__diode_2
X_11082_ net835 _00432_ net619 vssd1 vssd1 vccd1 vccd1 FPGA_INST.cell1.LE_0A.edge_mode
+ sky130_fd_sc_hd__dfstp_1
XFILLER_110_709 vssd1 vssd1 vccd1 vccd1 sky130_fd_sc_hd__fill_1
XANTENNA__07339__A1 FPGA_INST.cell1.SB0.route_sel\[32\] vssd1 vssd1 vccd1 vccd1 sky130_fd_sc_hd__diode_2
XFILLER_102_271 vssd1 vssd1 vccd1 vccd1 sky130_fd_sc_hd__fill_1
XFILLER_76_634 vssd1 vssd1 vccd1 vccd1 sky130_fd_sc_hd__fill_8
XFILLER_75_100 vssd1 vssd1 vccd1 vccd1 sky130_fd_sc_hd__fill_2
X_10033_ FPGA_INST.cell0.CB_0.config_dataB\[8\] FPGA_INST.cell0.CB_0.config_dataB\[7\]
+ net316 vssd1 vssd1 vccd1 vccd1 _00914_ sky130_fd_sc_hd__mux2_1
XANTENNA_input24_A gpio_in[30] vssd1 vssd1 vccd1 vccd1 sky130_fd_sc_hd__diode_2
XANTENNA__08551__A3 net79 vssd1 vssd1 vccd1 vccd1 sky130_fd_sc_hd__diode_2
XFILLER_76_678 vssd1 vssd1 vccd1 vccd1 sky130_fd_sc_hd__fill_2
XANTENNA__10928__SET_B net636 vssd1 vssd1 vccd1 vccd1 sky130_fd_sc_hd__diode_2
XFILLER_75_166 vssd1 vssd1 vccd1 vccd1 sky130_fd_sc_hd__fill_2
XFILLER_63_317 vccd1 vssd1 vccd1 vssd1 sky130_ef_sc_hd__decap_40_12
XFILLER_84_87 vssd1 vssd1 vccd1 vccd1 sky130_fd_sc_hd__fill_4
XFILLER_44_531 vssd1 vssd1 vccd1 vccd1 sky130_fd_sc_hd__fill_1
XFILLER_44_520 vssd1 vssd1 vccd1 vccd1 sky130_fd_sc_hd__fill_4
X_11984_ net844 _01330_ net629 vssd1 vssd1 vccd1 vccd1 FPGA_INST.cell2.SB0.route_sel\[24\]
+ sky130_fd_sc_hd__dfstp_1
X_10935_ net851 _00285_ net636 vssd1 vssd1 vccd1 vccd1 FPGA_INST.cell2.CB_0.config_dataA\[16\]
+ sky130_fd_sc_hd__dfstp_1
X_10866_ net795 _00216_ net580 vssd1 vssd1 vccd1 vccd1 FPGA_INST.cell1.SB0.route_sel\[75\]
+ sky130_fd_sc_hd__dfstp_1
XFILLER_31_214 vssd1 vssd1 vccd1 vccd1 sky130_fd_sc_hd__fill_1
XFILLER_129_113 vssd1 vssd1 vccd1 vccd1 sky130_fd_sc_hd__fill_1
X_10797_ net824 _00147_ net608 vssd1 vssd1 vccd1 vccd1 FPGA_INST.cell1.SB0.route_sel\[6\]
+ sky130_fd_sc_hd__dfstp_1
XFILLER_8_421 vssd1 vssd1 vccd1 vccd1 sky130_fd_sc_hd__fill_4
XFILLER_12_461 vssd1 vssd1 vccd1 vccd1 sky130_fd_sc_hd__fill_1
XTAP_TAPCELL_ROW_14_478 vssd1 vccd1 sky130_fd_sc_hd__tapvpwrvgnd_1
XFILLER_40_770 vssd1 vssd1 vccd1 vccd1 sky130_fd_sc_hd__fill_2
XFILLER_8_465 vssd1 vssd1 vccd1 vccd1 sky130_fd_sc_hd__fill_2
XANTENNA__06153__B1_N _02432_ vssd1 vssd1 vccd1 vccd1 sky130_fd_sc_hd__diode_2
X_11418_ net752 _00768_ net537 vssd1 vssd1 vccd1 vccd1 FPGA_INST.cell0.LEI0.config_data\[39\]
+ sky130_fd_sc_hd__dfrtp_1
XFILLER_125_363 vssd1 vssd1 vccd1 vccd1 sky130_fd_sc_hd__fill_4
XTAP_TAPCELL_ROW_74_1325 vssd1 vccd1 sky130_fd_sc_hd__tapvpwrvgnd_1
XTAP_TAPCELL_ROW_74_1314 vssd1 vccd1 sky130_fd_sc_hd__tapvpwrvgnd_1
XFILLER_113_536 vssd1 vssd1 vccd1 vccd1 sky130_fd_sc_hd__fill_2
X_11349_ net795 _00699_ net580 vssd1 vssd1 vccd1 vccd1 FPGA_INST.cell1.CB_1.config_dataA\[16\]
+ sky130_fd_sc_hd__dfstp_1
XFILLER_3_192 vssd1 vssd1 vccd1 vccd1 sky130_fd_sc_hd__fill_2
X_06890_ FPGA_INST.cell0.LEI0.config_data\[5\] _03157_ vssd1 vssd1 vccd1 vccd1 _03158_
+ sky130_fd_sc_hd__nand2b_1
X_05910_ FPGA_INST.cell0.SB0.route_sel\[62\] _01670_ FPGA_INST.cell0.SB0.route_sel\[58\]
+ FPGA_INST.cell0.SB0.route_sel\[59\] _02189_ vssd1 vssd1 vccd1 vccd1 _02190_ sky130_fd_sc_hd__o221a_1
XFILLER_94_442 vssd1 vssd1 vccd1 vccd1 sky130_fd_sc_hd__fill_2
XFILLER_67_656 vssd1 vssd1 vccd1 vccd1 sky130_fd_sc_hd__fill_1
X_05841_ _02112_ _02114_ _02115_ _02120_ vssd1 vssd1 vccd1 vccd1 _02121_ sky130_fd_sc_hd__a211oi_1
XFILLER_54_328 vccd1 vssd1 vccd1 vssd1 sky130_ef_sc_hd__decap_40_12
XFILLER_54_317 vssd1 vssd1 vccd1 vccd1 sky130_fd_sc_hd__fill_2
X_08560_ FPGA_INST.cell3.LE_1B.config_data\[14\] FPGA_INST.cell3.LE_1B.config_data\[15\]
+ _04755_ vssd1 vssd1 vccd1 vccd1 _04771_ sky130_fd_sc_hd__mux2_1
XFILLER_81_147 vssd1 vssd1 vccd1 vccd1 sky130_fd_sc_hd__fill_1
X_05772_ _02049_ _02050_ _02051_ vssd1 vssd1 vccd1 vccd1 _02052_ sky130_fd_sc_hd__a21bo_1
X_08491_ _04699_ _04706_ _04697_ vssd1 vssd1 vccd1 vccd1 _04707_ sky130_fd_sc_hd__mux2_1
XTAP_TAPCELL_ROW_85_1476 vssd1 vccd1 sky130_fd_sc_hd__tapvpwrvgnd_1
X_07511_ FPGA_INST.cell1.SB0.route_sel\[67\] FPGA_INST.cell1.SB0.route_sel\[66\] vssd1
+ vssd1 vccd1 vccd1 _03767_ sky130_fd_sc_hd__nor2_1
X_07442_ net25 _03697_ _03698_ _03699_ vssd1 vssd1 vccd1 vccd1 _03700_ sky130_fd_sc_hd__o211a_1
X_07373_ FPGA_INST.cell3.SB0.route_sel\[42\] FPGA_INST.cell3.SB0.route_sel\[43\] vssd1
+ vssd1 vccd1 vccd1 _03632_ sky130_fd_sc_hd__nand2_1
XTAP_TAPCELL_ROW_33_743 vssd1 vccd1 sky130_fd_sc_hd__tapvpwrvgnd_1
XANTENNA__08108__B _03568_ vssd1 vssd1 vccd1 vccd1 sky130_fd_sc_hd__diode_2
X_06324_ _02603_ vssd1 vssd1 vccd1 vccd1 _02604_ sky130_fd_sc_hd__inv_2
X_09112_ FPGA_INST.cell2.LEI0.config_data\[26\] FPGA_INST.cell2.LEI0.config_data\[27\]
+ net256 vssd1 vssd1 vccd1 vccd1 _00028_ sky130_fd_sc_hd__mux2_1
X_09043_ net838 FPGA_INST.cell1.LE_0B.edge_mode vssd1 vssd1 vccd1 vccd1 FPGA_INST.cell1.LE_0B.sel_clk
+ sky130_fd_sc_hd__xnor2_1
X_06255_ FPGA_INST.cell2.LEI0.config_data\[2\] _02534_ vssd1 vssd1 vccd1 vccd1 _02535_
+ sky130_fd_sc_hd__nand2b_2
XFILLER_128_190 vssd1 vssd1 vccd1 vccd1 sky130_fd_sc_hd__fill_2
XPHY_EDGE_ROW_111_Right_111 vssd1 vssd1 vccd1 vccd1 sky130_fd_sc_hd__decap_3
X_06186_ net168 net158 _02461_ _02464_ vssd1 vssd1 vccd1 vccd1 _02466_ sky130_fd_sc_hd__a2bb2o_1
XANTENNA_fanout309_A net315 vssd1 vssd1 vccd1 vccd1 sky130_fd_sc_hd__diode_2
XFILLER_116_363 vssd1 vssd1 vccd1 vccd1 sky130_fd_sc_hd__fill_1
XANTENNA__08766__A0 _04819_ vssd1 vssd1 vccd1 vccd1 sky130_fd_sc_hd__diode_2
XANTENNA__07569__A1 net89 vssd1 vssd1 vccd1 vccd1 sky130_fd_sc_hd__diode_2
XFILLER_104_536 vssd1 vssd1 vccd1 vccd1 sky130_fd_sc_hd__fill_1
Xfanout934 net935 vssd1 vssd1 vccd1 vccd1 net934 sky130_fd_sc_hd__clkbuf_2
Xfanout912 net917 vssd1 vssd1 vccd1 vccd1 net912 sky130_fd_sc_hd__clkbuf_2
Xfanout901 net902 vssd1 vssd1 vccd1 vccd1 net901 sky130_fd_sc_hd__clkbuf_2
Xfanout923 net931 vssd1 vssd1 vccd1 vccd1 net923 sky130_fd_sc_hd__clkbuf_2
X_09945_ net445 net444 net184 vssd1 vssd1 vccd1 vccd1 _00850_ sky130_fd_sc_hd__mux2_1
Xfanout945 net946 vssd1 vssd1 vccd1 vccd1 net945 sky130_fd_sc_hd__buf_2
XANTENNA_fanout678_A net683 vssd1 vssd1 vccd1 vccd1 sky130_fd_sc_hd__diode_2
X_09876_ FPGA_INST.cell0.LE_0A.config_data\[3\] FPGA_INST.cell0.LE_0A.config_data\[4\]
+ net193 vssd1 vssd1 vccd1 vccd1 _00783_ sky130_fd_sc_hd__mux2_1
X_08827_ _05000_ _05033_ vssd1 vssd1 vccd1 vccd1 _05034_ sky130_fd_sc_hd__nand2b_1
XFILLER_100_753 vssd1 vssd1 vccd1 vccd1 sky130_fd_sc_hd__fill_2
XTAP_TAPCELL_ROW_127_2060 vssd1 vccd1 sky130_fd_sc_hd__tapvpwrvgnd_1
XFILLER_73_615 vssd1 vssd1 vccd1 vccd1 sky130_fd_sc_hd__fill_1
XANTENNA_fanout845_A net849 vssd1 vssd1 vccd1 vccd1 sky130_fd_sc_hd__diode_2
XFILLER_18_509 vssd1 vssd1 vccd1 vccd1 sky130_fd_sc_hd__fill_8
X_08758_ FPGA_INST.cell3.LE_0A.config_data\[11\] FPGA_INST.cell3.LE_0A.config_data\[10\]
+ _04860_ vssd1 vssd1 vccd1 vccd1 _04967_ sky130_fd_sc_hd__mux2_1
XFILLER_73_637 vssd1 vssd1 vccd1 vccd1 sky130_fd_sc_hd__fill_1
X_08689_ net397 net396 _04828_ _04897_ vssd1 vssd1 vccd1 vccd1 _04898_ sky130_fd_sc_hd__o31a_1
X_07709_ _01973_ _03959_ _01976_ vssd1 vssd1 vccd1 vccd1 _03960_ sky130_fd_sc_hd__o21ai_1
XFILLER_81_670 vssd1 vssd1 vccd1 vccd1 sky130_fd_sc_hd__fill_2
XFILLER_53_372 vssd1 vssd1 vccd1 vccd1 sky130_fd_sc_hd__fill_4
X_10720_ net871 _00070_ net655 vssd1 vssd1 vccd1 vccd1 FPGA_INST.cell2.LE_0A.reset_mode
+ sky130_fd_sc_hd__dfrtp_1
XFILLER_13_225 vssd1 vssd1 vccd1 vccd1 sky130_fd_sc_hd__fill_1
XFILLER_110_41 vssd1 vssd1 vccd1 vccd1 sky130_fd_sc_hd__fill_2
XFILLER_110_85 vssd1 vssd1 vccd1 vccd1 sky130_fd_sc_hd__fill_4
XFILLER_110_74 vssd1 vssd1 vccd1 vccd1 sky130_fd_sc_hd__fill_8
X_10651_ net875 _00001_ net659 vssd1 vssd1 vccd1 vccd1 FPGA_INST.cell2.LEI0.config_data\[0\]
+ sky130_fd_sc_hd__dfrtp_1
X_10582_ FPGA_INST.cell3.CB_0.config_dataB\[2\] net391 net378 vssd1 vssd1 vccd1 vccd1
+ _01461_ sky130_fd_sc_hd__mux2_1
XTAP_TAPCELL_ROW_11_437 vssd1 vccd1 sky130_fd_sc_hd__tapvpwrvgnd_1
XFILLER_126_116 vssd1 vssd1 vccd1 vccd1 sky130_fd_sc_hd__fill_1
XANTENNA__09549__A2 net523 vssd1 vssd1 vccd1 vccd1 sky130_fd_sc_hd__diode_2
X_11203_ net747 _00553_ net532 vssd1 vssd1 vccd1 vccd1 FPGA_INST.cell0.SB0.route_sel\[48\]
+ sky130_fd_sc_hd__dfstp_1
X_11134_ net816 _00484_ net601 vssd1 vssd1 vccd1 vccd1 FPGA_INST.cell1.CB_1.config_dataB\[4\]
+ sky130_fd_sc_hd__dfstp_1
XPHY_EDGE_ROW_118_Left_249 vssd1 vssd1 vccd1 vccd1 sky130_fd_sc_hd__decap_3
XFILLER_96_707 vssd1 vssd1 vccd1 vccd1 sky130_fd_sc_hd__fill_2
XANTENNA__08772__A3 net26 vssd1 vssd1 vccd1 vccd1 sky130_fd_sc_hd__diode_2
XTAP_TAPCELL_ROW_56_1066 vssd1 vccd1 sky130_fd_sc_hd__tapvpwrvgnd_1
X_11065_ net836 _00415_ net620 vssd1 vssd1 vccd1 vccd1 FPGA_INST.cell1.LE_0A.config_data\[0\]
+ sky130_fd_sc_hd__dfrtp_1
XFILLER_95_228 vssd1 vssd1 vccd1 vccd1 sky130_fd_sc_hd__fill_1
XANTENNA__10503__S net362 vssd1 vssd1 vccd1 vccd1 sky130_fd_sc_hd__diode_2
XANTENNA_input27_X net27 vssd1 vssd1 vccd1 vccd1 sky130_fd_sc_hd__diode_2
X_10016_ net426 net427 net317 vssd1 vssd1 vccd1 vccd1 _00897_ sky130_fd_sc_hd__mux2_1
XFILLER_0_195 vssd1 vssd1 vccd1 vccd1 sky130_fd_sc_hd__fill_1
XFILLER_91_401 vssd1 vssd1 vccd1 vccd1 sky130_fd_sc_hd__fill_8
XFILLER_76_475 vssd1 vssd1 vccd1 vccd1 sky130_fd_sc_hd__fill_1
XTAP_TAPCELL_ROW_19_548 vssd1 vccd1 sky130_fd_sc_hd__tapvpwrvgnd_1
X_11967_ net847 _01313_ net632 vssd1 vssd1 vccd1 vccd1 FPGA_INST.cell2.SB0.route_sel\[7\]
+ sky130_fd_sc_hd__dfstp_1
XPHY_EDGE_ROW_127_Left_258 vssd1 vssd1 vccd1 vccd1 sky130_fd_sc_hd__decap_3
XFILLER_72_670 vssd1 vssd1 vccd1 vccd1 sky130_fd_sc_hd__fill_4
X_10918_ net855 _00268_ net640 vssd1 vssd1 vccd1 vccd1 FPGA_INST.cell1.SB0.config_data_out
+ sky130_fd_sc_hd__dfstp_1
XANTENNA__06299__A1 _02168_ vssd1 vssd1 vccd1 vccd1 sky130_fd_sc_hd__diode_2
XANTENNA__06299__B2 _02131_ vssd1 vssd1 vccd1 vccd1 sky130_fd_sc_hd__diode_2
X_11898_ net929 _01244_ net713 vssd1 vssd1 vccd1 vccd1 FPGA_INST.cell3.LE_0B.config_data\[6\]
+ sky130_fd_sc_hd__dfrtp_1
XFILLER_71_191 vssd1 vssd1 vccd1 vccd1 sky130_fd_sc_hd__fill_1
XANTENNA__08991__X FPGA_INST.bus2_0\[5\] vssd1 vssd1 vccd1 vccd1 sky130_fd_sc_hd__diode_2
XFILLER_44_394 vssd1 vssd1 vccd1 vccd1 sky130_fd_sc_hd__fill_2
XFILLER_32_567 vssd1 vssd1 vccd1 vccd1 sky130_fd_sc_hd__fill_4
X_10849_ net798 _00199_ net583 vssd1 vssd1 vccd1 vccd1 FPGA_INST.cell1.SB0.route_sel\[58\]
+ sky130_fd_sc_hd__dfstp_1
XTAP_TAPCELL_ROW_30_702 vssd1 vccd1 sky130_fd_sc_hd__tapvpwrvgnd_1
XANTENNA__09739__S net230 vssd1 vssd1 vccd1 vccd1 sky130_fd_sc_hd__diode_2
XFILLER_9_763 vccd1 vssd1 vccd1 vssd1 sky130_ef_sc_hd__decap_40_12
XANTENNA__08996__B1 FPGA_INST.cell1.SB0.route_sel\[32\] vssd1 vssd1 vccd1 vccd1 sky130_fd_sc_hd__diode_2
X_06040_ net133 _02318_ _02319_ _02316_ _02313_ vssd1 vssd1 vccd1 vccd1 _02320_ sky130_fd_sc_hd__o221a_1
XANTENNA__10555__A0 FPGA_INST.cell3.CB_0.config_dataA\[0\] vssd1 vssd1 vccd1 vccd1
+ sky130_fd_sc_hd__diode_2
Xfanout219 net233 vssd1 vssd1 vccd1 vccd1 net219 sky130_fd_sc_hd__clkbuf_2
X_07991_ FPGA_INST.cell1.LE_0A.config_data\[1\] FPGA_INST.cell1.LE_0A.config_data\[0\]
+ _04148_ vssd1 vssd1 vccd1 vccd1 _04219_ sky130_fd_sc_hd__mux2_1
XFILLER_113_333 vssd1 vssd1 vccd1 vccd1 sky130_fd_sc_hd__fill_1
Xfanout208 net219 vssd1 vssd1 vccd1 vccd1 net208 sky130_fd_sc_hd__clkbuf_4
X_09730_ net469 net468 net230 vssd1 vssd1 vccd1 vccd1 _00639_ sky130_fd_sc_hd__mux2_1
X_06942_ _03201_ _03207_ _01749_ vssd1 vssd1 vccd1 vccd1 _03210_ sky130_fd_sc_hd__mux2_1
XFILLER_95_795 vssd1 vssd1 vccd1 vccd1 sky130_fd_sc_hd__fill_2
XTAP_TAPCELL_ROW_87_1505 vssd1 vccd1 sky130_fd_sc_hd__tapvpwrvgnd_1
XFILLER_67_453 vssd1 vssd1 vccd1 vccd1 sky130_fd_sc_hd__fill_1
X_06873_ net425 _02191_ _03140_ vssd1 vssd1 vccd1 vccd1 _03141_ sky130_fd_sc_hd__a21o_1
XTAP_TAPCELL_ROW_38_813 vssd1 vccd1 sky130_fd_sc_hd__tapvpwrvgnd_1
X_09661_ FPGA_INST.cell0.SB0.route_sel\[64\] FPGA_INST.cell0.SB0.route_sel\[65\] net186
+ vssd1 vssd1 vccd1 vccd1 _00570_ sky130_fd_sc_hd__mux2_1
X_09592_ FPGA_INST.cell1.CB_1.config_dataB\[20\] FPGA_INST.cell1.CB_1.config_dataB\[21\]
+ net213 vssd1 vssd1 vccd1 vccd1 _00501_ sky130_fd_sc_hd__mux2_1
X_08612_ FPGA_INST.cell3.SB0.route_sel\[26\] FPGA_INST.cell3.SB0.route_sel\[27\] FPGA_INST.cell3.SB0.route_sel\[29\]
+ _01696_ _04820_ vssd1 vssd1 vccd1 vccd1 _04821_ sky130_fd_sc_hd__o221a_2
XFILLER_54_114 vssd1 vssd1 vccd1 vccd1 sky130_fd_sc_hd__fill_1
X_05824_ net166 _02014_ FPGA_INST.bus2_0\[9\] vssd1 vssd1 vccd1 vccd1 _02104_ sky130_fd_sc_hd__o21ba_1
X_08543_ FPGA_INST.cell3.CB_1.config_dataB\[3\] FPGA_INST.cell3.CB_1.config_dataB\[2\]
+ FPGA_INST.cell3.CB_1.config_dataB\[1\] FPGA_INST.cell3.CB_1.config_dataB\[0\] vssd1
+ vssd1 vccd1 vccd1 _04754_ sky130_fd_sc_hd__or4b_2
XFILLER_42_309 vssd1 vssd1 vccd1 vccd1 sky130_fd_sc_hd__fill_4
X_05755_ FPGA_INST.cell2.SB0.route_sel\[80\] FPGA_INST.cell2.SB0.route_sel\[81\] vssd1
+ vssd1 vccd1 vccd1 _02035_ sky130_fd_sc_hd__nand2_1
XANTENNA__06846__B _02070_ vssd1 vssd1 vccd1 vccd1 sky130_fd_sc_hd__diode_2
X_08474_ _04689_ vssd1 vssd1 vccd1 vccd1 _04690_ sky130_fd_sc_hd__inv_2
XFILLER_24_38 vssd1 vssd1 vccd1 vccd1 sky130_fd_sc_hd__fill_1
X_05686_ _01965_ _01963_ vssd1 vssd1 vccd1 vccd1 _01966_ sky130_fd_sc_hd__and2b_2
XFILLER_11_729 vssd1 vssd1 vccd1 vccd1 sky130_fd_sc_hd__fill_2
X_07425_ _03679_ _03680_ _03681_ _02230_ _02221_ vssd1 vssd1 vccd1 vccd1 _03683_ sky130_fd_sc_hd__a311o_1
X_07356_ _02277_ _02801_ _02279_ vssd1 vssd1 vccd1 vccd1 _03616_ sky130_fd_sc_hd__o21a_1
XFILLER_108_105 vssd1 vssd1 vccd1 vccd1 sky130_fd_sc_hd__fill_2
XTAP_TAPCELL_ROW_98_1656 vssd1 vccd1 sky130_fd_sc_hd__tapvpwrvgnd_1
X_07287_ FPGA_INST.cell1.CB_0.config_dataB\[24\] FPGA_INST.cell1.CB_0.config_dataB\[20\]
+ FPGA_INST.cell1.CB_0.config_dataB\[21\] vssd1 vssd1 vccd1 vccd1 _03548_ sky130_fd_sc_hd__and3b_1
X_06307_ net500 _02217_ vssd1 vssd1 vccd1 vccd1 _02587_ sky130_fd_sc_hd__nand2_1
XANTENNA__06581__B _02832_ vssd1 vssd1 vccd1 vccd1 sky130_fd_sc_hd__diode_2
X_06238_ net6 _02505_ _02517_ net508 _01530_ vssd1 vssd1 vccd1 vccd1 _02518_ sky130_fd_sc_hd__a221o_1
XANTENNA__06462__A1 net5 vssd1 vssd1 vccd1 vccd1 sky130_fd_sc_hd__diode_2
X_09026_ _01550_ FPGA_INST.cell2.SB0.route_sel\[9\] FPGA_INST.cell2.SB0.route_sel\[14\]
+ FPGA_INST.cell2.SB0.route_sel\[15\] _05190_ vssd1 vssd1 vccd1 vccd1 _05191_ sky130_fd_sc_hd__o221a_1
XANTENNA__08203__A2 FPGA_INST.bus1_0\[9\] vssd1 vssd1 vccd1 vccd1 sky130_fd_sc_hd__diode_2
X_06169_ FPGA_INST.cell2.SB0.route_sel\[14\] _01551_ FPGA_INST.cell2.SB0.route_sel\[10\]
+ FPGA_INST.cell2.SB0.route_sel\[11\] _02448_ vssd1 vssd1 vccd1 vccd1 _02449_ sky130_fd_sc_hd__o221a_1
XANTENNA__07006__A3 FPGA_INST.bus2_0\[15\] vssd1 vssd1 vccd1 vccd1 sky130_fd_sc_hd__diode_2
XANTENNA__06214__A1 net8 vssd1 vssd1 vccd1 vccd1 sky130_fd_sc_hd__diode_2
Xfanout720 net730 vssd1 vssd1 vccd1 vccd1 net720 sky130_fd_sc_hd__clkbuf_4
Xfanout742 net749 vssd1 vssd1 vccd1 vccd1 net742 sky130_fd_sc_hd__clkbuf_1
Xfanout731 net31 vssd1 vssd1 vccd1 vccd1 net731 sky130_fd_sc_hd__clkbuf_4
X_09928_ FPGA_INST.cell0.LE_1A.config_data\[9\] FPGA_INST.cell0.LE_1A.config_data\[10\]
+ net183 vssd1 vssd1 vccd1 vccd1 _00833_ sky130_fd_sc_hd__mux2_1
Xfanout764 net766 vssd1 vssd1 vccd1 vccd1 net764 sky130_fd_sc_hd__clkbuf_2
Xfanout753 net758 vssd1 vssd1 vccd1 vccd1 net753 sky130_fd_sc_hd__buf_1
Xfanout775 net778 vssd1 vssd1 vccd1 vccd1 net775 sky130_fd_sc_hd__buf_2
XANTENNA__08506__A3 _01792_ vssd1 vssd1 vccd1 vccd1 sky130_fd_sc_hd__diode_2
XFILLER_105_63 vssd1 vssd1 vccd1 vccd1 sky130_fd_sc_hd__fill_1
XANTENNA__07714__A1 net150 vssd1 vssd1 vccd1 vccd1 sky130_fd_sc_hd__diode_2
Xfanout797 net803 vssd1 vssd1 vccd1 vccd1 net797 sky130_fd_sc_hd__clkbuf_2
Xfanout786 net788 vssd1 vssd1 vccd1 vccd1 net786 sky130_fd_sc_hd__clkbuf_2
XFILLER_58_475 vssd1 vssd1 vccd1 vccd1 sky130_fd_sc_hd__fill_1
X_09859_ FPGA_INST.cell0.LEI0.config_data\[37\] FPGA_INST.cell0.LEI0.config_data\[38\]
+ net178 vssd1 vssd1 vccd1 vccd1 _00767_ sky130_fd_sc_hd__mux2_1
XFILLER_46_648 vssd1 vssd1 vccd1 vccd1 sky130_fd_sc_hd__fill_4
XFILLER_18_339 vssd1 vssd1 vccd1 vccd1 sky130_fd_sc_hd__fill_1
X_11821_ net932 _01167_ net716 vssd1 vssd1 vccd1 vccd1 FPGA_INST.cell3.LEI0.config_data\[1\]
+ sky130_fd_sc_hd__dfrtp_1
XANTENNA__05941__A net383 vssd1 vssd1 vccd1 vccd1 sky130_fd_sc_hd__diode_2
XFILLER_45_158 vssd1 vssd1 vccd1 vccd1 sky130_fd_sc_hd__fill_1
XTAP_TAPCELL_ROW_107_1785 vssd1 vccd1 sky130_fd_sc_hd__tapvpwrvgnd_1
XTAP_TAPCELL_ROW_107_1774 vssd1 vccd1 sky130_fd_sc_hd__tapvpwrvgnd_1
XTAP_TAPCELL_ROW_16_507 vssd1 vccd1 sky130_fd_sc_hd__tapvpwrvgnd_1
XFILLER_81_33 vssd1 vssd1 vccd1 vccd1 sky130_fd_sc_hd__fill_1
X_11752_ net901 _01098_ net685 vssd1 vssd1 vccd1 vccd1 FPGA_INST.cell3.SB0.route_sel\[122\]
+ sky130_fd_sc_hd__dfstp_1
XTAP_TAPCELL_ROW_120_1963 vssd1 vccd1 sky130_fd_sc_hd__tapvpwrvgnd_1
XANTENNA__08690__A2 net20 vssd1 vssd1 vccd1 vccd1 sky130_fd_sc_hd__diode_2
X_11683_ net898 _01029_ net682 vssd1 vssd1 vccd1 vccd1 FPGA_INST.cell3.SB0.route_sel\[53\]
+ sky130_fd_sc_hd__dfstp_1
XFILLER_81_66 vssd1 vssd1 vccd1 vccd1 sky130_fd_sc_hd__fill_2
X_10703_ net844 _00053_ net629 vssd1 vssd1 vccd1 vccd1 FPGA_INST.cell2.LE_0A.config_data\[2\]
+ sky130_fd_sc_hd__dfrtp_1
X_10634_ FPGA_INST.cell3.LE_1B.config_data\[3\] FPGA_INST.cell3.LE_1B.config_data\[4\]
+ net280 vssd1 vssd1 vccd1 vccd1 _01513_ sky130_fd_sc_hd__mux2_1
XFILLER_41_386 vssd1 vssd1 vccd1 vccd1 sky130_fd_sc_hd__fill_4
XANTENNA__08978__B1 FPGA_INST.cell1.SB0.route_sel\[48\] vssd1 vssd1 vccd1 vccd1 sky130_fd_sc_hd__diode_2
X_10565_ FPGA_INST.cell3.CB_0.config_dataA\[9\] FPGA_INST.cell3.CB_0.config_dataA\[10\]
+ net294 vssd1 vssd1 vccd1 vccd1 _01444_ sky130_fd_sc_hd__mux2_1
XFILLER_5_221 vssd1 vssd1 vccd1 vccd1 sky130_fd_sc_hd__fill_2
XFILLER_108_661 vssd1 vssd1 vccd1 vccd1 sky130_fd_sc_hd__fill_8
X_10496_ FPGA_INST.cell2.SB0.route_sel\[68\] FPGA_INST.cell2.SB0.route_sel\[69\] net248
+ vssd1 vssd1 vccd1 vccd1 _01375_ sky130_fd_sc_hd__mux2_1
X_12166_ net910 _01512_ net694 vssd1 vssd1 vccd1 vccd1 FPGA_INST.cell3.LE_1B.config_data\[3\]
+ sky130_fd_sc_hd__dfrtp_1
XFILLER_122_163 vssd1 vssd1 vccd1 vccd1 sky130_fd_sc_hd__fill_4
X_11117_ net793 _00467_ net578 vssd1 vssd1 vccd1 vccd1 FPGA_INST.cell1.LE_1A.config_data\[8\]
+ sky130_fd_sc_hd__dfrtp_1
X_12097_ net922 _01443_ net706 vssd1 vssd1 vccd1 vccd1 FPGA_INST.cell3.CB_0.config_dataA\[9\]
+ sky130_fd_sc_hd__dfstp_1
X_11048_ net806 _00398_ net591 vssd1 vssd1 vccd1 vccd1 FPGA_INST.cell1.LEI0.config_data\[33\]
+ sky130_fd_sc_hd__dfrtp_1
XANTENNA_output55_A net55 vssd1 vssd1 vccd1 vccd1 sky130_fd_sc_hd__diode_2
Xinput8 gpio_in[16] vssd1 vssd1 vccd1 vccd1 net8 sky130_fd_sc_hd__buf_2
XANTENNA__06012__A net352 vssd1 vssd1 vccd1 vccd1 sky130_fd_sc_hd__diode_2
XFILLER_92_743 vssd1 vssd1 vccd1 vccd1 sky130_fd_sc_hd__fill_4
XTAP_TAPCELL_ROW_69_1246 vssd1 vccd1 sky130_fd_sc_hd__tapvpwrvgnd_1
XFILLER_64_423 vssd1 vssd1 vccd1 vccd1 sky130_fd_sc_hd__fill_1
XFILLER_36_125 vssd1 vssd1 vccd1 vccd1 sky130_fd_sc_hd__fill_1
XFILLER_24_309 vssd1 vssd1 vccd1 vccd1 sky130_fd_sc_hd__fill_2
XFILLER_45_670 vssd1 vssd1 vccd1 vccd1 sky130_fd_sc_hd__fill_2
X_05540_ net121 net385 net384 _01815_ _01817_ vssd1 vssd1 vccd1 vccd1 _01820_ sky130_fd_sc_hd__o32a_1
XANTENNA__09042__B FPGA_INST.cell1.LE_0B.reset_mode vssd1 vssd1 vccd1 vccd1 sky130_fd_sc_hd__diode_2
XTAP_TAPCELL_ROW_82_1435 vssd1 vccd1 sky130_fd_sc_hd__tapvpwrvgnd_1
XTAP_TAPCELL_ROW_82_1424 vssd1 vccd1 sky130_fd_sc_hd__tapvpwrvgnd_1
XFILLER_60_640 vssd1 vssd1 vccd1 vccd1 sky130_fd_sc_hd__fill_1
X_05471_ FPGA_INST.cell0.LEI0.config_data\[20\] vssd1 vssd1 vccd1 vccd1 _01753_ sky130_fd_sc_hd__inv_2
X_07210_ FPGA_INST.cell1.SB0.route_sel\[13\] FPGA_INST.cell1.SB0.route_sel\[12\] vssd1
+ vssd1 vccd1 vccd1 _03473_ sky130_fd_sc_hd__nand2b_1
X_08190_ net408 net409 vssd1 vssd1 vccd1 vccd1 _04414_ sky130_fd_sc_hd__nor2_1
XTAP_TAPCELL_ROW_43_882 vssd1 vccd1 sky130_fd_sc_hd__tapvpwrvgnd_1
X_07141_ FPGA_INST.cell0.SB0.route_sel\[5\] FPGA_INST.cell0.SB0.route_sel\[4\] vssd1
+ vssd1 vccd1 vccd1 _03405_ sky130_fd_sc_hd__or2_1
XFILLER_9_571 vssd1 vssd1 vccd1 vccd1 sky130_fd_sc_hd__fill_1
XANTENNA__07287__A_N FPGA_INST.cell1.CB_0.config_dataB\[24\] vssd1 vssd1 vccd1 vccd1
+ sky130_fd_sc_hd__diode_2
X_07072_ _01937_ _03317_ _03318_ _01984_ vssd1 vssd1 vccd1 vccd1 _03338_ sky130_fd_sc_hd__a22o_1
XFILLER_126_18 vssd1 vssd1 vccd1 vccd1 sky130_fd_sc_hd__fill_8
X_06023_ FPGA_INST.cell0.SB0.route_sel\[42\] FPGA_INST.cell0.SB0.route_sel\[43\] _02300_
+ _02301_ _02302_ vssd1 vssd1 vccd1 vccd1 _02303_ sky130_fd_sc_hd__a221o_1
XFILLER_10_29 vssd1 vssd1 vccd1 vccd1 sky130_fd_sc_hd__fill_4
XANTENNA__10928__CLK net851 vssd1 vssd1 vccd1 vccd1 sky130_fd_sc_hd__diode_2
XTAP_TAPCELL_ROW_93_1586 vssd1 vccd1 sky130_fd_sc_hd__tapvpwrvgnd_1
XFILLER_87_537 vccd1 vssd1 vccd1 vssd1 sky130_ef_sc_hd__decap_40_12
XANTENNA__10143__S net369 vssd1 vssd1 vccd1 vccd1 sky130_fd_sc_hd__diode_2
X_07974_ net464 net462 _03769_ vssd1 vssd1 vccd1 vccd1 _04202_ sky130_fd_sc_hd__or3_1
XFILLER_67_261 vccd1 vssd1 vccd1 vssd1 sky130_ef_sc_hd__decap_40_12
X_09713_ FPGA_INST.cell0.SB0.route_sel\[116\] FPGA_INST.cell0.SB0.route_sel\[117\]
+ net198 vssd1 vssd1 vccd1 vccd1 _00622_ sky130_fd_sc_hd__mux2_1
X_06925_ net114 net118 net110 net98 FPGA_INST.cell0.LEI0.config_data\[27\] FPGA_INST.cell0.LEI0.config_data\[28\]
+ vssd1 vssd1 vccd1 vccd1 _03193_ sky130_fd_sc_hd__mux4_1
XANTENNA_fanout376_A net377 vssd1 vssd1 vccd1 vccd1 sky130_fd_sc_hd__diode_2
XFILLER_55_434 vssd1 vssd1 vccd1 vccd1 sky130_fd_sc_hd__fill_4
XFILLER_55_412 vssd1 vssd1 vccd1 vccd1 sky130_fd_sc_hd__fill_1
X_06856_ FPGA_INST.cell0.CB_0.config_dataB\[9\] _03095_ _03105_ _03121_ _03123_ vssd1
+ vssd1 vccd1 vccd1 _03124_ sky130_fd_sc_hd__a311o_2
XFILLER_27_125 vccd1 vssd1 vccd1 vssd1 sky130_ef_sc_hd__decap_40_12
X_09644_ FPGA_INST.cell0.SB0.route_sel\[48\] FPGA_INST.cell0.SB0.route_sel\[47\] net311
+ vssd1 vssd1 vccd1 vccd1 _00553_ sky130_fd_sc_hd__mux2_1
XFILLER_43_607 vssd1 vssd1 vccd1 vccd1 sky130_fd_sc_hd__fill_2
X_05807_ _02083_ _02084_ _02085_ FPGA_INST.cell2.SB0.route_sel\[89\] FPGA_INST.cell2.SB0.route_sel\[88\]
+ vssd1 vssd1 vccd1 vccd1 _02087_ sky130_fd_sc_hd__a32o_1
XANTENNA__10379__A net737 vssd1 vssd1 vccd1 vccd1 sky130_fd_sc_hd__diode_2
X_09575_ FPGA_INST.cell1.CB_1.config_dataB\[3\] FPGA_INST.cell1.CB_1.config_dataB\[4\]
+ net217 vssd1 vssd1 vccd1 vccd1 _00484_ sky130_fd_sc_hd__mux2_1
XFILLER_70_404 vssd1 vssd1 vccd1 vccd1 sky130_fd_sc_hd__fill_1
X_06787_ _03059_ _03060_ vssd1 vssd1 vccd1 vccd1 _03061_ sky130_fd_sc_hd__nor2_1
XANTENNA_fanout543_A net628 vssd1 vssd1 vccd1 vccd1 sky130_fd_sc_hd__diode_2
X_08526_ _04731_ _04738_ _04729_ vssd1 vssd1 vccd1 vccd1 _04739_ sky130_fd_sc_hd__mux2_1
XANTENNA__08121__A1 _03613_ vssd1 vssd1 vccd1 vccd1 sky130_fd_sc_hd__diode_2
X_05738_ net383 net161 FPGA_INST.bus1_0\[10\] vssd1 vssd1 vccd1 vccd1 _02018_ sky130_fd_sc_hd__o21ai_1
X_08457_ _04674_ _04667_ _04665_ vssd1 vssd1 vccd1 vccd1 _04675_ sky130_fd_sc_hd__mux2_1
X_05669_ _01948_ vssd1 vssd1 vccd1 vccd1 _01949_ sky130_fd_sc_hd__inv_2
XANTENNA_fanout808_A net811 vssd1 vssd1 vccd1 vccd1 sky130_fd_sc_hd__diode_2
X_07408_ FPGA_INST.cell3.SB0.route_sel\[40\] FPGA_INST.cell3.SB0.route_sel\[41\] vssd1
+ vssd1 vccd1 vccd1 _03667_ sky130_fd_sc_hd__or2_1
XFILLER_11_537 vssd1 vssd1 vccd1 vccd1 sky130_fd_sc_hd__fill_1
XANTENNA__09379__S net350 vssd1 vssd1 vccd1 vccd1 sky130_fd_sc_hd__diode_2
XFILLER_23_386 vssd1 vssd1 vccd1 vccd1 sky130_fd_sc_hd__fill_2
XANTENNA_wire77_X net77 vssd1 vssd1 vccd1 vccd1 sky130_fd_sc_hd__diode_2
X_08388_ _03959_ _04608_ _04609_ _03923_ _04607_ vssd1 vssd1 vccd1 vccd1 _04610_ sky130_fd_sc_hd__a221o_1
XFILLER_7_519 vssd1 vssd1 vccd1 vccd1 sky130_fd_sc_hd__fill_1
X_07339_ FPGA_INST.cell1.SB0.route_sel\[32\] FPGA_INST.cell1.SB0.route_sel\[33\] _03596_
+ _03597_ _03598_ vssd1 vssd1 vccd1 vccd1 _03599_ sky130_fd_sc_hd__a221o_1
XTAP_TAPCELL_ROW_21_576 vssd1 vccd1 sky130_fd_sc_hd__tapvpwrvgnd_1
X_10350_ FPGA_INST.cell3.LE_0A.config_data\[14\] FPGA_INST.cell3.LE_0A.config_data\[15\]
+ net292 vssd1 vssd1 vccd1 vccd1 _01231_ sky130_fd_sc_hd__mux2_1
XANTENNA__06435__B2 net30 vssd1 vssd1 vccd1 vccd1 sky130_fd_sc_hd__diode_2
XANTENNA__06435__A1 net2 vssd1 vssd1 vccd1 vccd1 sky130_fd_sc_hd__diode_2
XFILLER_124_417 vssd1 vssd1 vccd1 vccd1 sky130_fd_sc_hd__fill_2
X_10281_ net40 net41 net254 vssd1 vssd1 vccd1 vccd1 _01162_ sky130_fd_sc_hd__mux2_1
X_09009_ _05179_ _02373_ vssd1 vssd1 vccd1 vccd1 FPGA_INST.bus2_0\[3\] sky130_fd_sc_hd__and2b_2
XFILLER_117_491 vccd1 vssd1 vccd1 vssd1 sky130_ef_sc_hd__decap_40_12
X_12020_ net847 _01366_ net632 vssd1 vssd1 vccd1 vccd1 FPGA_INST.cell2.SB0.route_sel\[60\]
+ sky130_fd_sc_hd__dfstp_1
XFILLER_104_141 vccd1 vssd1 vccd1 vssd1 sky130_ef_sc_hd__decap_40_12
XFILLER_78_526 vssd1 vssd1 vccd1 vccd1 sky130_fd_sc_hd__fill_4
XTAP_TAPCELL_ROW_53_1025 vssd1 vccd1 sky130_fd_sc_hd__tapvpwrvgnd_1
XFILLER_120_656 vssd1 vssd1 vccd1 vccd1 sky130_fd_sc_hd__fill_4
XFILLER_120_645 vssd1 vssd1 vccd1 vccd1 sky130_fd_sc_hd__fill_2
XFILLER_76_33 vssd1 vssd1 vccd1 vccd1 sky130_fd_sc_hd__fill_2
XFILLER_76_11 vccd1 vssd1 vccd1 vssd1 sky130_ef_sc_hd__decap_40_12
Xfanout550 net551 vssd1 vssd1 vccd1 vccd1 net550 sky130_fd_sc_hd__clkbuf_4
XFILLER_120_678 vssd1 vssd1 vccd1 vccd1 sky130_fd_sc_hd__fill_1
XTAP_TAPCELL_ROW_109_1803 vssd1 vccd1 sky130_fd_sc_hd__tapvpwrvgnd_1
XFILLER_93_518 vssd1 vssd1 vccd1 vccd1 sky130_fd_sc_hd__fill_1
Xfanout583 net584 vssd1 vssd1 vccd1 vccd1 net583 sky130_fd_sc_hd__buf_2
Xfanout572 net573 vssd1 vssd1 vccd1 vccd1 net572 sky130_fd_sc_hd__clkbuf_2
Xfanout561 net575 vssd1 vssd1 vccd1 vccd1 net561 sky130_fd_sc_hd__clkbuf_4
XFILLER_19_615 vssd1 vssd1 vccd1 vccd1 sky130_fd_sc_hd__fill_1
Xfanout594 net596 vssd1 vssd1 vccd1 vccd1 net594 sky130_fd_sc_hd__clkbuf_4
XTAP_TAPCELL_ROW_109_1814 vssd1 vccd1 sky130_fd_sc_hd__tapvpwrvgnd_1
XFILLER_86_581 vssd1 vssd1 vccd1 vccd1 sky130_fd_sc_hd__fill_4
XFILLER_74_721 vssd1 vssd1 vccd1 vccd1 sky130_fd_sc_hd__fill_8
XFILLER_92_43 vssd1 vssd1 vccd1 vccd1 sky130_fd_sc_hd__fill_1
XFILLER_74_798 vssd1 vssd1 vccd1 vccd1 sky130_fd_sc_hd__fill_1
XFILLER_73_275 vssd1 vssd1 vccd1 vccd1 sky130_fd_sc_hd__fill_4
XTAP_TAPCELL_ROW_29_687 vssd1 vccd1 sky130_fd_sc_hd__tapvpwrvgnd_1
XANTENNA__08112__A1 _03475_ vssd1 vssd1 vccd1 vccd1 sky130_fd_sc_hd__diode_2
X_11804_ net871 _01150_ net655 vssd1 vssd1 vccd1 vccd1 FPGA_INST.io_east_oeb\[28\]
+ sky130_fd_sc_hd__dfrtp_1
XTAP_TAPCELL_ROW_1_290 vssd1 vccd1 sky130_fd_sc_hd__tapvpwrvgnd_1
XANTENNA__08112__B2 _03421_ vssd1 vssd1 vccd1 vccd1 sky130_fd_sc_hd__diode_2
X_11735_ net903 _01081_ net687 vssd1 vssd1 vccd1 vccd1 FPGA_INST.cell3.SB0.route_sel\[105\]
+ sky130_fd_sc_hd__dfstp_2
XTAP_TAPCELL_ROW_64_1176 vssd1 vccd1 sky130_fd_sc_hd__tapvpwrvgnd_1
XANTENNA__07871__A0 FPGA_INST.bus3_1\[8\] vssd1 vssd1 vccd1 vccd1 sky130_fd_sc_hd__diode_2
XFILLER_128_712 vssd1 vssd1 vccd1 vccd1 sky130_fd_sc_hd__fill_1
X_11666_ net906 _01012_ net690 vssd1 vssd1 vccd1 vccd1 FPGA_INST.cell3.SB0.route_sel\[36\]
+ sky130_fd_sc_hd__dfstp_1
XTAP_TAPCELL_ROW_40_841 vssd1 vccd1 sky130_fd_sc_hd__tapvpwrvgnd_1
X_10617_ FPGA_INST.cell3.CB_1.config_dataA\[12\] FPGA_INST.cell3.CB_1.config_dataA\[11\]
+ net378 vssd1 vssd1 vccd1 vccd1 _01496_ sky130_fd_sc_hd__mux2_1
X_11597_ net799 _00947_ net584 vssd1 vssd1 vccd1 vccd1 FPGA_INST.cell0.CB_1.config_dataA\[16\]
+ sky130_fd_sc_hd__dfstp_1
XFILLER_128_789 vssd1 vssd1 vccd1 vccd1 sky130_fd_sc_hd__fill_4
X_10548_ FPGA_INST.cell2.SB0.route_sel\[120\] FPGA_INST.cell2.SB0.route_sel\[121\]
+ net241 vssd1 vssd1 vccd1 vccd1 _01427_ sky130_fd_sc_hd__mux2_1
XFILLER_115_439 vssd1 vssd1 vccd1 vccd1 sky130_fd_sc_hd__fill_1
XANTENNA__05846__A net135 vssd1 vssd1 vccd1 vccd1 sky130_fd_sc_hd__diode_2
X_10479_ FPGA_INST.cell2.SB0.route_sel\[52\] FPGA_INST.cell2.SB0.route_sel\[51\] net319
+ vssd1 vssd1 vccd1 vccd1 _01358_ sky130_fd_sc_hd__mux2_1
XFILLER_69_526 vssd1 vssd1 vccd1 vccd1 sky130_fd_sc_hd__fill_2
XANTENNA__09915__A2 net522 vssd1 vssd1 vccd1 vccd1 sky130_fd_sc_hd__diode_2
X_12149_ net934 _01495_ net718 vssd1 vssd1 vccd1 vccd1 FPGA_INST.cell3.CB_1.config_dataA\[11\]
+ sky130_fd_sc_hd__dfstp_1
XFILLER_110_111 vssd1 vssd1 vccd1 vccd1 sky130_fd_sc_hd__fill_4
XANTENNA__06013__Y _02293_ vssd1 vssd1 vccd1 vccd1 sky130_fd_sc_hd__diode_2
XANTENNA__09752__S net348 vssd1 vssd1 vccd1 vccd1 sky130_fd_sc_hd__diode_2
XFILLER_49_250 vccd1 vssd1 vccd1 vssd1 sky130_ef_sc_hd__decap_40_12
X_06710_ _02982_ _02983_ FPGA_INST.cell2.CB_1.config_dataB\[2\] vssd1 vssd1 vccd1
+ vccd1 _02984_ sky130_fd_sc_hd__or3b_1
X_07690_ net89 _03437_ _03939_ _03941_ _03906_ vssd1 vssd1 vccd1 vccd1 _03942_ sky130_fd_sc_hd__o311a_1
XTAP_TAPCELL_ROW_48_952 vssd1 vccd1 sky130_fd_sc_hd__tapvpwrvgnd_1
XFILLER_65_798 vssd1 vssd1 vccd1 vccd1 sky130_fd_sc_hd__fill_1
XFILLER_65_787 vssd1 vssd1 vccd1 vccd1 sky130_fd_sc_hd__fill_1
X_06641_ net474 net476 vssd1 vssd1 vccd1 vccd1 _02917_ sky130_fd_sc_hd__nand2b_1
XFILLER_52_448 vssd1 vssd1 vccd1 vccd1 sky130_fd_sc_hd__fill_2
X_06572_ _01591_ _02807_ _02846_ _02847_ _01588_ vssd1 vssd1 vccd1 vccd1 _02848_ sky130_fd_sc_hd__a32o_1
X_09360_ FPGA_INST.cell2.CB_0.config_dataA\[3\] FPGA_INST.cell2.CB_0.config_dataA\[4\]
+ net240 vssd1 vssd1 vccd1 vccd1 _00273_ sky130_fd_sc_hd__mux2_1
X_05523_ _01802_ _01803_ _01804_ vssd1 vssd1 vccd1 vccd1 _01805_ sky130_fd_sc_hd__or3_1
XANTENNA__11890__RESET_B net735 vssd1 vssd1 vccd1 vccd1 sky130_fd_sc_hd__diode_2
X_09291_ FPGA_INST.cell1.SB0.route_sel\[63\] FPGA_INST.cell1.SB0.route_sel\[62\] net338
+ vssd1 vssd1 vccd1 vccd1 _00204_ sky130_fd_sc_hd__mux2_1
X_08311_ net75 FPGA_INST.bus1_0\[5\] net74 FPGA_INST.bus1_0\[7\] net446 FPGA_INST.cell0.CB_1.config_dataB\[6\]
+ vssd1 vssd1 vccd1 vccd1 _04533_ sky130_fd_sc_hd__mux4_1
X_08242_ FPGA_INST.cell0.CB_1.config_dataA\[13\] _04465_ _04454_ FPGA_INST.cell0.CB_1.config_dataA\[14\]
+ vssd1 vssd1 vccd1 vccd1 _04466_ sky130_fd_sc_hd__a211o_1
X_05454_ FPGA_INST.cell0.LEI0.config_data\[38\] vssd1 vssd1 vccd1 vccd1 _01736_ sky130_fd_sc_hd__inv_2
X_05385_ FPGA_INST.cell1.SB0.route_sel\[61\] vssd1 vssd1 vccd1 vccd1 _01667_ sky130_fd_sc_hd__inv_2
XANTENNA__08406__A2 _03682_ vssd1 vssd1 vccd1 vccd1 sky130_fd_sc_hd__diode_2
X_08173_ net73 net95 FPGA_INST.bus1_0\[2\] FPGA_INST.bus1_0\[3\] net413 net411 vssd1
+ vssd1 vccd1 vccd1 _04397_ sky130_fd_sc_hd__mux4_1
XANTENNA__11891__SET_B net735 vssd1 vssd1 vccd1 vccd1 sky130_fd_sc_hd__diode_2
XTAP_TAPCELL_ROW_95_1615 vssd1 vccd1 sky130_fd_sc_hd__tapvpwrvgnd_1
X_07124_ _03389_ _03388_ _03279_ vssd1 vssd1 vccd1 vccd1 _03390_ sky130_fd_sc_hd__mux2_1
X_07055_ net431 _02392_ _03320_ net429 vssd1 vssd1 vccd1 vccd1 _03321_ sky130_fd_sc_hd__o211a_1
X_06006_ net124 net5 _02284_ vssd1 vssd1 vccd1 vccd1 _02286_ sky130_fd_sc_hd__mux2_1
XFILLER_87_334 vssd1 vssd1 vccd1 vccd1 sky130_fd_sc_hd__fill_2
X_07957_ _04184_ _04149_ _04114_ vssd1 vssd1 vccd1 vccd1 _04185_ sky130_fd_sc_hd__mux2_1
XANTENNA_fanout379_X net379 vssd1 vssd1 vccd1 vccd1 sky130_fd_sc_hd__diode_2
XFILLER_101_166 vssd1 vssd1 vccd1 vccd1 sky130_fd_sc_hd__fill_2
X_06908_ net418 _02350_ vssd1 vssd1 vccd1 vccd1 _03176_ sky130_fd_sc_hd__nand2_1
XANTENNA_fanout758_A net790 vssd1 vssd1 vccd1 vccd1 sky130_fd_sc_hd__diode_2
X_07888_ net472 _03690_ _04115_ FPGA_INST.cell1.CB_0.config_dataA\[1\] vssd1 vssd1
+ vccd1 vccd1 _04116_ sky130_fd_sc_hd__o211a_1
XANTENNA__08342__A1 net95 vssd1 vssd1 vccd1 vccd1 sky130_fd_sc_hd__diode_2
XFILLER_55_242 vssd1 vssd1 vccd1 vccd1 sky130_fd_sc_hd__fill_4
XFILLER_46_58 vssd1 vssd1 vccd1 vccd1 sky130_fd_sc_hd__fill_1
X_09627_ FPGA_INST.cell0.SB0.route_sel\[30\] FPGA_INST.cell0.SB0.route_sel\[31\] net195
+ vssd1 vssd1 vccd1 vccd1 _00536_ sky130_fd_sc_hd__mux2_1
X_06839_ FPGA_INST.bus2_0\[0\] _03094_ _03095_ FPGA_INST.bus2_0\[1\] _03106_ vssd1
+ vssd1 vccd1 vccd1 _03107_ sky130_fd_sc_hd__a221o_1
XANTENNA__06353__A0 net3 vssd1 vssd1 vccd1 vccd1 sky130_fd_sc_hd__diode_2
XTAP_TAPCELL_ROW_104_1733 vssd1 vccd1 sky130_fd_sc_hd__tapvpwrvgnd_1
X_09558_ FPGA_INST.cell1.LE_1A.config_data\[7\] FPGA_INST.cell1.LE_1A.config_data\[8\]
+ net204 vssd1 vssd1 vccd1 vccd1 _00467_ sky130_fd_sc_hd__mux2_1
XTAP_TAPCELL_ROW_26_646 vssd1 vccd1 sky130_fd_sc_hd__tapvpwrvgnd_1
X_08509_ net93 net88 FPGA_INST.cell3.CB_1.le_outA net79 FPGA_INST.cell3.LEI0.config_data\[6\]
+ FPGA_INST.cell3.LEI0.config_data\[7\] vssd1 vssd1 vccd1 vccd1 _04722_ sky130_fd_sc_hd__mux4_1
XTAP_TAPCELL_ROW_104_1744 vssd1 vccd1 sky130_fd_sc_hd__tapvpwrvgnd_1
X_11520_ net808 _00870_ net594 vssd1 vssd1 vccd1 vccd1 FPGA_INST.config_bits\[1\]
+ sky130_fd_sc_hd__dfstp_1
X_09489_ FPGA_INST.cell1.LEI0.config_data\[36\] FPGA_INST.cell1.LEI0.config_data\[35\]
+ net336 vssd1 vssd1 vccd1 vccd1 _00401_ sky130_fd_sc_hd__mux2_1
XANTENNA__06656__A1 FPGA_INST.bus3_2\[1\] vssd1 vssd1 vccd1 vccd1 sky130_fd_sc_hd__diode_2
XFILLER_51_481 vssd1 vssd1 vccd1 vccd1 sky130_fd_sc_hd__fill_2
XFILLER_24_695 vssd1 vssd1 vccd1 vccd1 sky130_fd_sc_hd__fill_4
XFILLER_11_345 vssd1 vssd1 vccd1 vccd1 sky130_fd_sc_hd__fill_2
X_11451_ net750 _00801_ net535 vssd1 vssd1 vccd1 vccd1 FPGA_INST.cell0.LE_0B.config_data\[0\]
+ sky130_fd_sc_hd__dfrtp_1
XFILLER_125_704 vssd1 vssd1 vccd1 vccd1 sky130_fd_sc_hd__fill_1
X_10402_ FPGA_INST.cell3.CB_1.config_dataA\[24\] FPGA_INST.cell3.CB_1.config_dataB\[0\]
+ net281 vssd1 vssd1 vccd1 vccd1 _01281_ sky130_fd_sc_hd__mux2_1
XANTENNA__07605__B1 net130 vssd1 vssd1 vccd1 vccd1 sky130_fd_sc_hd__diode_2
X_11382_ net747 _00732_ net532 vssd1 vssd1 vccd1 vccd1 FPGA_INST.cell0.LEI0.config_data\[3\]
+ sky130_fd_sc_hd__dfrtp_1
XFILLER_125_726 vssd1 vssd1 vccd1 vccd1 sky130_fd_sc_hd__fill_2
XFILLER_109_277 vssd1 vssd1 vccd1 vccd1 sky130_fd_sc_hd__fill_1
X_10333_ FPGA_INST.cell3.LE_0A.dff0_out _04971_ net737 vssd1 vssd1 vccd1 vccd1 _01214_
+ sky130_fd_sc_hd__mux2_1
XFILLER_11_50 vssd1 vssd1 vccd1 vccd1 sky130_fd_sc_hd__fill_4
XANTENNA__05937__Y _02217_ vssd1 vssd1 vccd1 vccd1 sky130_fd_sc_hd__diode_2
XFILLER_3_555 vssd1 vssd1 vccd1 vccd1 sky130_fd_sc_hd__fill_1
XFILLER_3_533 vssd1 vssd1 vccd1 vccd1 sky130_fd_sc_hd__fill_1
XTAP_TAPCELL_ROW_115_1895 vssd1 vccd1 sky130_fd_sc_hd__tapvpwrvgnd_1
X_10264_ FPGA_INST.io_east_oeb\[16\] FPGA_INST.io_east_oeb\[18\] net257 vssd1 vssd1
+ vccd1 vccd1 _01145_ sky130_fd_sc_hd__mux2_1
XFILLER_105_494 vssd1 vssd1 vccd1 vccd1 sky130_fd_sc_hd__fill_8
X_10195_ FPGA_INST.cell3.SB0.route_sel\[99\] FPGA_INST.cell3.SB0.route_sel\[100\]
+ net271 vssd1 vssd1 vccd1 vccd1 _01076_ sky130_fd_sc_hd__mux2_1
XFILLER_87_54 vssd1 vssd1 vccd1 vccd1 sky130_fd_sc_hd__fill_2
XFILLER_78_323 vssd1 vssd1 vccd1 vccd1 sky130_fd_sc_hd__fill_1
X_12003_ net855 _01349_ net640 vssd1 vssd1 vccd1 vccd1 FPGA_INST.cell2.SB0.route_sel\[43\]
+ sky130_fd_sc_hd__dfstp_1
XTAP_TAPCELL_ROW_6_371 vssd1 vccd1 sky130_fd_sc_hd__tapvpwrvgnd_1
XTAP_TAPCELL_ROW_6_360 vssd1 vccd1 sky130_fd_sc_hd__tapvpwrvgnd_1
Xfanout380 net381 vssd1 vssd1 vccd1 vccd1 net380 sky130_fd_sc_hd__buf_2
Xfanout391 FPGA_INST.cell3.CB_0.config_dataB\[1\] vssd1 vssd1 vccd1 vccd1 net391 sky130_fd_sc_hd__buf_2
XANTENNA__08333__A1 _03797_ vssd1 vssd1 vccd1 vccd1 sky130_fd_sc_hd__diode_2
XANTENNA__10511__S net362 vssd1 vssd1 vccd1 vccd1 sky130_fd_sc_hd__diode_2
XANTENNA__10140__A1 FPGA_INST.cell3.SB0.route_sel\[44\] vssd1 vssd1 vccd1 vccd1 sky130_fd_sc_hd__diode_2
XTAP_TAPCELL_ROW_66_1205 vssd1 vccd1 sky130_fd_sc_hd__tapvpwrvgnd_1
XANTENNA__08333__B2 _03759_ vssd1 vssd1 vccd1 vccd1 sky130_fd_sc_hd__diode_2
XFILLER_47_798 vssd1 vssd1 vccd1 vccd1 sky130_fd_sc_hd__fill_1
XTAP_TAPCELL_ROW_45_911 vssd1 vccd1 sky130_fd_sc_hd__tapvpwrvgnd_1
XFILLER_61_267 vccd1 vssd1 vccd1 vssd1 sky130_ef_sc_hd__decap_40_12
XANTENNA__08636__A2 FPGA_INST.cell3.SB0.route_sel\[44\] vssd1 vssd1 vccd1 vccd1 sky130_fd_sc_hd__diode_2
XFILLER_15_684 vssd1 vssd1 vccd1 vccd1 sky130_fd_sc_hd__fill_1
X_11718_ net920 _01064_ net704 vssd1 vssd1 vccd1 vccd1 FPGA_INST.cell3.SB0.route_sel\[88\]
+ sky130_fd_sc_hd__dfstp_1
XFILLER_14_194 vssd1 vssd1 vccd1 vccd1 sky130_fd_sc_hd__fill_2
XFILLER_30_643 vssd1 vssd1 vccd1 vccd1 sky130_fd_sc_hd__fill_1
XFILLER_30_665 vssd1 vssd1 vccd1 vccd1 sky130_fd_sc_hd__fill_4
Xinput22 gpio_in[29] vssd1 vssd1 vccd1 vccd1 net22 sky130_fd_sc_hd__buf_2
X_11649_ net895 _00995_ net679 vssd1 vssd1 vccd1 vccd1 FPGA_INST.cell3.SB0.route_sel\[19\]
+ sky130_fd_sc_hd__dfstp_1
Xinput11 gpio_in[19] vssd1 vssd1 vccd1 vccd1 net11 sky130_fd_sc_hd__clkbuf_2
XANTENNA__10878__SET_B net577 vssd1 vssd1 vccd1 vccd1 sky130_fd_sc_hd__diode_2
XTAP_TAPCELL_ROW_77_1356 vssd1 vccd1 sky130_fd_sc_hd__tapvpwrvgnd_1
XANTENNA__07072__A1 _01937_ vssd1 vssd1 vccd1 vccd1 sky130_fd_sc_hd__diode_2
XTAP_TAPCELL_ROW_77_1367 vssd1 vccd1 sky130_fd_sc_hd__tapvpwrvgnd_1
XANTENNA__07072__B2 _01984_ vssd1 vssd1 vccd1 vccd1 sky130_fd_sc_hd__diode_2
XFILLER_97_621 vssd1 vssd1 vccd1 vccd1 sky130_fd_sc_hd__fill_1
X_08860_ FPGA_INST.cell3.LE_0B.config_data\[6\] FPGA_INST.cell3.LE_0B.config_data\[7\]
+ _05032_ vssd1 vssd1 vccd1 vccd1 _05067_ sky130_fd_sc_hd__mux2_1
XTAP_TAPCELL_ROW_90_1545 vssd1 vccd1 sky130_fd_sc_hd__tapvpwrvgnd_1
XFILLER_69_334 vssd1 vssd1 vccd1 vccd1 sky130_fd_sc_hd__fill_2
X_07811_ FPGA_INST.cell3.SB0.route_sel\[125\] _01602_ vssd1 vssd1 vccd1 vccd1 _04060_
+ sky130_fd_sc_hd__nand2_1
XFILLER_69_345 vssd1 vssd1 vccd1 vccd1 sky130_fd_sc_hd__fill_4
XFILLER_57_507 vssd1 vssd1 vccd1 vccd1 sky130_fd_sc_hd__fill_4
X_08791_ net90 net84 net83 _01792_ FPGA_INST.cell3.LEI0.config_data\[15\] FPGA_INST.cell3.LEI0.config_data\[16\]
+ vssd1 vssd1 vccd1 vccd1 _04998_ sky130_fd_sc_hd__mux4_1
XFILLER_96_197 vssd1 vssd1 vccd1 vccd1 sky130_fd_sc_hd__fill_1
XFILLER_84_315 vssd1 vssd1 vccd1 vccd1 sky130_fd_sc_hd__fill_1
XFILLER_84_359 vssd1 vssd1 vccd1 vccd1 sky130_fd_sc_hd__fill_4
X_07742_ _03499_ _03913_ vssd1 vssd1 vccd1 vccd1 _03992_ sky130_fd_sc_hd__nor2_1
XFILLER_65_551 vssd1 vssd1 vccd1 vccd1 sky130_fd_sc_hd__fill_2
X_07673_ FPGA_INST.cell1.SB0.route_sel\[103\] FPGA_INST.cell1.SB0.route_sel\[102\]
+ _01928_ _03924_ _01929_ vssd1 vssd1 vccd1 vccd1 _03925_ sky130_fd_sc_hd__a221o_1
X_06624_ net478 _02810_ vssd1 vssd1 vccd1 vccd1 _02900_ sky130_fd_sc_hd__or2_1
X_09412_ net480 net481 net362 vssd1 vssd1 vccd1 vccd1 _00325_ sky130_fd_sc_hd__mux2_1
XANTENNA__06886__A1 FPGA_INST.bus2_0\[0\] vssd1 vssd1 vccd1 vccd1 sky130_fd_sc_hd__diode_2
XANTENNA__08826__S _05032_ vssd1 vssd1 vccd1 vccd1 sky130_fd_sc_hd__diode_2
X_09343_ FPGA_INST.cell1.SB0.route_sel\[114\] FPGA_INST.cell1.SB0.route_sel\[115\]
+ net224 vssd1 vssd1 vccd1 vccd1 _00256_ sky130_fd_sc_hd__mux2_1
XFILLER_52_245 vssd1 vssd1 vccd1 vccd1 sky130_fd_sc_hd__fill_2
XTAP_TAPCELL_ROW_23_605 vssd1 vccd1 sky130_fd_sc_hd__tapvpwrvgnd_1
XANTENNA_fanout339_A net341 vssd1 vssd1 vccd1 vccd1 sky130_fd_sc_hd__diode_2
XANTENNA_fanout241_A net268 vssd1 vssd1 vccd1 vccd1 sky130_fd_sc_hd__diode_2
X_06555_ _01573_ FPGA_INST.cell2.SB0.route_sel\[89\] FPGA_INST.cell2.SB0.route_sel\[94\]
+ _01577_ _02830_ vssd1 vssd1 vccd1 vccd1 _02831_ sky130_fd_sc_hd__a221o_1
X_05506_ net146 vssd1 vssd1 vccd1 vccd1 _01788_ sky130_fd_sc_hd__inv_2
X_09274_ FPGA_INST.cell1.SB0.route_sel\[45\] FPGA_INST.cell1.SB0.route_sel\[46\] net207
+ vssd1 vssd1 vccd1 vccd1 _00187_ sky130_fd_sc_hd__mux2_1
X_06486_ FPGA_INST.cell2.LE_0B.config_data\[9\] FPGA_INST.cell2.LE_0B.config_data\[8\]
+ _02688_ vssd1 vssd1 vccd1 vccd1 _02764_ sky130_fd_sc_hd__mux2_1
XFILLER_21_665 vssd1 vssd1 vccd1 vccd1 sky130_fd_sc_hd__fill_4
X_05437_ FPGA_INST.cell3.SB0.route_sel\[2\] vssd1 vssd1 vccd1 vccd1 _01719_ sky130_fd_sc_hd__inv_2
X_08225_ net75 FPGA_INST.bus1_0\[5\] FPGA_INST.bus1_0\[6\] FPGA_INST.bus1_0\[7\] net406
+ net405 vssd1 vssd1 vccd1 vccd1 _04449_ sky130_fd_sc_hd__mux4_1
X_05368_ FPGA_INST.cell1.SB0.route_sel\[74\] vssd1 vssd1 vccd1 vccd1 _01650_ sky130_fd_sc_hd__inv_2
X_08156_ net412 _04040_ vssd1 vssd1 vccd1 vccd1 _04380_ sky130_fd_sc_hd__nand2_1
XFILLER_4_319 vssd1 vssd1 vccd1 vccd1 sky130_fd_sc_hd__fill_1
X_07107_ _01738_ _03371_ _03372_ _03368_ _03369_ vssd1 vssd1 vccd1 vccd1 _03373_ sky130_fd_sc_hd__o32a_1
XANTENNA__07063__A1 FPGA_INST.bus2_0\[7\] vssd1 vssd1 vccd1 vccd1 sky130_fd_sc_hd__diode_2
X_08087_ net455 _03854_ _04312_ net453 vssd1 vssd1 vccd1 vccd1 _04313_ sky130_fd_sc_hd__o211a_1
X_05299_ FPGA_INST.cell2.SB0.route_sel\[111\] vssd1 vssd1 vccd1 vccd1 _01581_ sky130_fd_sc_hd__inv_2
X_07038_ FPGA_INST.bus2_0\[4\] _03284_ _03303_ _01730_ FPGA_INST.cell0.CB_0.config_dataA\[3\]
+ vssd1 vssd1 vccd1 vccd1 _03304_ sky130_fd_sc_hd__a2111o_1
Xteam_15_950 vssd1 vssd1 vccd1 vccd1 team_15_950/HI gpio_oeb[2] sky130_fd_sc_hd__conb_1
XANTENNA__08012__A0 FPGA_INST.bus3_1\[0\] vssd1 vssd1 vccd1 vccd1 sky130_fd_sc_hd__diode_2
XFILLER_88_643 vssd1 vssd1 vccd1 vccd1 sky130_fd_sc_hd__fill_1
Xteam_15_961 vssd1 vssd1 vccd1 vccd1 team_15_961/HI gpio_oeb[30] sky130_fd_sc_hd__conb_1
XANTENNA_input1_X net1 vssd1 vssd1 vccd1 vccd1 sky130_fd_sc_hd__diode_2
XFILLER_102_442 vccd1 vssd1 vccd1 vssd1 sky130_ef_sc_hd__decap_40_12
XFILLER_88_687 vccd1 vssd1 vccd1 vssd1 sky130_ef_sc_hd__decap_40_12
XFILLER_57_13 vssd1 vssd1 vccd1 vccd1 sky130_fd_sc_hd__fill_1
Xteam_15_972 vssd1 vssd1 vccd1 vccd1 gpio_oeb[6] team_15_972/LO sky130_fd_sc_hd__conb_1
XFILLER_102_486 vssd1 vssd1 vccd1 vccd1 sky130_fd_sc_hd__fill_4
X_08989_ FPGA_INST.cell2.SB0.route_sel\[42\] FPGA_INST.cell2.SB0.route_sel\[43\] vssd1
+ vssd1 vccd1 vccd1 _05166_ sky130_fd_sc_hd__nand2b_1
XTAP_TAPCELL_ROW_3_330 vssd1 vccd1 sky130_fd_sc_hd__tapvpwrvgnd_1
X_10951_ net864 _00301_ net649 vssd1 vssd1 vccd1 vccd1 FPGA_INST.cell2.CB_0.config_dataB\[7\]
+ sky130_fd_sc_hd__dfstp_1
XFILLER_29_798 vssd1 vssd1 vccd1 vccd1 sky130_fd_sc_hd__fill_1
XFILLER_71_543 vssd1 vssd1 vccd1 vccd1 sky130_fd_sc_hd__fill_1
XFILLER_44_757 vssd1 vssd1 vccd1 vccd1 sky130_fd_sc_hd__fill_1
XFILLER_43_223 vssd1 vssd1 vccd1 vccd1 sky130_fd_sc_hd__fill_1
XANTENNA__06877__B2 _02429_ vssd1 vssd1 vccd1 vccd1 sky130_fd_sc_hd__diode_2
XANTENNA__06877__A1 _02465_ vssd1 vssd1 vccd1 vccd1 sky130_fd_sc_hd__diode_2
XANTENNA__08079__A0 FPGA_INST.bus3_1\[4\] vssd1 vssd1 vccd1 vccd1 sky130_fd_sc_hd__diode_2
X_10882_ net798 _00232_ net583 vssd1 vssd1 vccd1 vccd1 FPGA_INST.cell1.SB0.route_sel\[91\]
+ sky130_fd_sc_hd__dfstp_1
XFILLER_71_565 vssd1 vssd1 vccd1 vccd1 sky130_fd_sc_hd__fill_2
XFILLER_31_407 vssd1 vssd1 vccd1 vccd1 sky130_fd_sc_hd__fill_1
XPHY_EDGE_ROW_125_Right_125 vssd1 vssd1 vccd1 vccd1 sky130_fd_sc_hd__decap_3
XFILLER_12_621 vssd1 vssd1 vccd1 vccd1 sky130_fd_sc_hd__fill_1
XFILLER_31_429 vssd1 vssd1 vccd1 vccd1 sky130_fd_sc_hd__fill_8
XTAP_TAPCELL_ROW_61_1135 vssd1 vccd1 sky130_fd_sc_hd__tapvpwrvgnd_1
XFILLER_12_643 vssd1 vssd1 vccd1 vccd1 sky130_fd_sc_hd__fill_1
X_11503_ net763 _00853_ net548 vssd1 vssd1 vccd1 vccd1 FPGA_INST.cell0.CB_1.config_dataB\[9\]
+ sky130_fd_sc_hd__dfstp_1
XTAP_TAPCELL_ROW_50_980 vssd1 vccd1 sky130_fd_sc_hd__tapvpwrvgnd_1
XFILLER_8_647 vssd1 vssd1 vccd1 vccd1 sky130_fd_sc_hd__fill_1
XFILLER_11_142 vssd1 vssd1 vccd1 vccd1 sky130_fd_sc_hd__fill_2
XFILLER_12_676 vssd1 vssd1 vccd1 vccd1 sky130_fd_sc_hd__fill_1
XFILLER_12_698 vssd1 vssd1 vccd1 vccd1 sky130_fd_sc_hd__fill_2
XTAP_TAPCELL_ROW_117_1924 vssd1 vccd1 sky130_fd_sc_hd__tapvpwrvgnd_1
X_11434_ net775 _00784_ net561 vssd1 vssd1 vccd1 vccd1 FPGA_INST.cell0.LE_0A.config_data\[5\]
+ sky130_fd_sc_hd__dfrtp_1
XFILLER_22_71 vssd1 vssd1 vccd1 vccd1 sky130_fd_sc_hd__fill_4
X_11365_ net818 _00715_ net603 vssd1 vssd1 vccd1 vccd1 FPGA_INST.cell1.LE_1B.config_data\[7\]
+ sky130_fd_sc_hd__dfrtp_1
XFILLER_125_545 vssd1 vssd1 vccd1 vccd1 sky130_fd_sc_hd__fill_1
XFILLER_98_42 vssd1 vssd1 vccd1 vccd1 sky130_fd_sc_hd__fill_4
XFILLER_98_31 vssd1 vssd1 vccd1 vccd1 sky130_fd_sc_hd__fill_2
X_10316_ FPGA_INST.cell3.LEI0.config_data\[30\] FPGA_INST.cell3.LEI0.config_data\[31\]
+ net296 vssd1 vssd1 vccd1 vccd1 _01197_ sky130_fd_sc_hd__mux2_1
XFILLER_113_729 vssd1 vssd1 vccd1 vccd1 sky130_fd_sc_hd__fill_4
X_11296_ net832 _00646_ net616 vssd1 vssd1 vccd1 vccd1 FPGA_INST.cell1.CB_0.config_dataA\[13\]
+ sky130_fd_sc_hd__dfstp_1
XFILLER_3_363 vssd1 vssd1 vccd1 vccd1 sky130_fd_sc_hd__fill_1
X_10247_ FPGA_INST.io_south_oeb\[14\] FPGA_INST.io_south_oeb\[16\] net290 vssd1 vssd1
+ vccd1 vccd1 _01128_ sky130_fd_sc_hd__mux2_1
XFILLER_79_654 vccd1 vssd1 vccd1 vssd1 sky130_ef_sc_hd__decap_40_12
XTAP_TAPCELL_ROW_72_1286 vssd1 vccd1 sky130_fd_sc_hd__tapvpwrvgnd_1
X_10178_ FPGA_INST.cell3.SB0.route_sel\[82\] FPGA_INST.cell3.SB0.route_sel\[83\] net287
+ vssd1 vssd1 vccd1 vccd1 _01059_ sky130_fd_sc_hd__mux2_1
XTAP_TAPCELL_ROW_72_1297 vssd1 vccd1 sky130_fd_sc_hd__tapvpwrvgnd_1
XFILLER_21_7 vssd1 vssd1 vccd1 vccd1 sky130_fd_sc_hd__fill_2
XFILLER_120_294 vssd1 vssd1 vccd1 vccd1 sky130_fd_sc_hd__fill_4
XANTENNA__08994__X FPGA_INST.bus3_1\[5\] vssd1 vssd1 vccd1 vccd1 sky130_fd_sc_hd__diode_2
XANTENNA__07109__A2 FPGA_INST.bus2_0\[10\] vssd1 vssd1 vccd1 vccd1 sky130_fd_sc_hd__diode_2
XFILLER_19_253 vssd1 vssd1 vccd1 vccd1 sky130_fd_sc_hd__fill_1
XANTENNA__06868__A1 FPGA_INST.bus2_0\[14\] vssd1 vssd1 vccd1 vccd1 sky130_fd_sc_hd__diode_2
XFILLER_62_554 vssd1 vssd1 vccd1 vccd1 sky130_fd_sc_hd__fill_8
XFILLER_97_3 vssd1 vssd1 vccd1 vccd1 sky130_fd_sc_hd__fill_1
XFILLER_62_587 vssd1 vssd1 vccd1 vccd1 sky130_fd_sc_hd__fill_1
XFILLER_22_418 vssd1 vssd1 vccd1 vccd1 sky130_fd_sc_hd__fill_2
X_06340_ FPGA_INST.cell2.LE_0A.dff0_out FPGA_INST.cell2.LE_0A.dff1_out FPGA_INST.cell2.LE_0A.reset_val
+ vssd1 vssd1 vccd1 vccd1 FPGA_INST.cell2.LE_0A.dff_out sky130_fd_sc_hd__mux2_1
XFILLER_8_40 vssd1 vssd1 vccd1 vccd1 sky130_fd_sc_hd__fill_8
X_06271_ net503 _02376_ vssd1 vssd1 vccd1 vccd1 _02551_ sky130_fd_sc_hd__nand2_1
XANTENNA__09477__S net336 vssd1 vssd1 vccd1 vccd1 sky130_fd_sc_hd__diode_2
X_08010_ net456 net458 vssd1 vssd1 vccd1 vccd1 _04236_ sky130_fd_sc_hd__nor2_1
XFILLER_116_523 vssd1 vssd1 vccd1 vccd1 sky130_fd_sc_hd__fill_8
XANTENNA__07596__A2 _03849_ vssd1 vssd1 vccd1 vccd1 sky130_fd_sc_hd__diode_2
X_09961_ FPGA_INST.cell0.CB_1.config_dataB\[21\] FPGA_INST.cell0.CB_1.config_dataB\[22\]
+ net195 vssd1 vssd1 vccd1 vccd1 _00866_ sky130_fd_sc_hd__mux2_1
X_08912_ FPGA_INST.cell3.SB0.route_sel\[112\] _01609_ _01610_ FPGA_INST.cell3.SB0.route_sel\[115\]
+ _05114_ vssd1 vssd1 vccd1 vccd1 _05115_ sky130_fd_sc_hd__a221o_1
X_09892_ FPGA_INST.cell0.LE_0B.dff0_out net522 _05218_ vssd1 vssd1 vccd1 vccd1 _00799_
+ sky130_fd_sc_hd__a21bo_1
X_08843_ FPGA_INST.cell3.CB_0.config_dataB\[10\] _04781_ vssd1 vssd1 vccd1 vccd1 _05050_
+ sky130_fd_sc_hd__or2_1
XFILLER_69_164 vssd1 vssd1 vccd1 vccd1 sky130_fd_sc_hd__fill_4
XANTENNA_fanout191_A net202 vssd1 vssd1 vccd1 vccd1 sky130_fd_sc_hd__diode_2
X_08774_ FPGA_INST.cell3.CB_0.config_dataB\[8\] _04980_ vssd1 vssd1 vccd1 vccd1 _04981_
+ sky130_fd_sc_hd__nor2_1
XANTENNA__10151__S net364 vssd1 vssd1 vccd1 vccd1 sky130_fd_sc_hd__diode_2
XFILLER_27_27 vssd1 vssd1 vccd1 vccd1 sky130_fd_sc_hd__fill_2
X_05986_ _02257_ _02264_ _02265_ vssd1 vssd1 vccd1 vccd1 _02266_ sky130_fd_sc_hd__o21ba_1
X_07725_ FPGA_INST.cell3.SB0.route_sel\[106\] FPGA_INST.cell3.SB0.route_sel\[107\]
+ _03952_ _03975_ _03948_ vssd1 vssd1 vccd1 vccd1 _03976_ sky130_fd_sc_hd__a41o_1
XFILLER_72_318 vssd1 vssd1 vccd1 vccd1 sky130_fd_sc_hd__fill_4
XANTENNA__06571__A3 net103 vssd1 vssd1 vccd1 vccd1 sky130_fd_sc_hd__diode_2
XFILLER_26_735 vssd1 vssd1 vccd1 vccd1 sky130_fd_sc_hd__fill_8
XFILLER_26_757 vssd1 vssd1 vccd1 vccd1 sky130_fd_sc_hd__fill_1
X_07656_ _03428_ _03907_ net78 vssd1 vssd1 vccd1 vccd1 _03908_ sky130_fd_sc_hd__o21ai_1
XANTENNA__08409__X _04631_ vssd1 vssd1 vccd1 vccd1 sky130_fd_sc_hd__diode_2
XFILLER_25_245 vssd1 vssd1 vccd1 vccd1 sky130_fd_sc_hd__fill_4
XFILLER_25_267 vssd1 vssd1 vccd1 vccd1 sky130_fd_sc_hd__fill_2
XANTENNA_fanout623_A net626 vssd1 vssd1 vccd1 vccd1 sky130_fd_sc_hd__diode_2
XTAP_TAPCELL_ROW_101_1703 vssd1 vccd1 sky130_fd_sc_hd__tapvpwrvgnd_1
XANTENNA_fanout244_X net244 vssd1 vssd1 vccd1 vccd1 sky130_fd_sc_hd__diode_2
X_06607_ FPGA_INST.bus3_2\[0\] FPGA_INST.bus3_2\[1\] FPGA_INST.bus3_2\[2\] FPGA_INST.bus3_2\[3\]
+ net478 net477 vssd1 vssd1 vccd1 vccd1 _02883_ sky130_fd_sc_hd__mux4_1
X_07587_ _03837_ _03838_ _03839_ _02027_ _02017_ vssd1 vssd1 vccd1 vccd1 _03841_ sky130_fd_sc_hd__a311o_1
XFILLER_41_727 vssd1 vssd1 vccd1 vccd1 sky130_fd_sc_hd__fill_1
XTAP_TAPCELL_ROW_36_785 vssd1 vccd1 sky130_fd_sc_hd__tapvpwrvgnd_1
X_09326_ FPGA_INST.cell1.SB0.route_sel\[98\] FPGA_INST.cell1.SB0.route_sel\[97\] net340
+ vssd1 vssd1 vccd1 vccd1 _00239_ sky130_fd_sc_hd__mux2_1
X_06538_ net247 _01902_ _01910_ _02813_ vssd1 vssd1 vccd1 vccd1 _02814_ sky130_fd_sc_hd__and4_4
XFILLER_40_237 vssd1 vssd1 vccd1 vccd1 sky130_fd_sc_hd__fill_1
XFILLER_40_259 vssd1 vssd1 vccd1 vccd1 sky130_fd_sc_hd__fill_2
X_09257_ FPGA_INST.cell1.SB0.route_sel\[28\] FPGA_INST.cell1.SB0.route_sel\[29\] net220
+ vssd1 vssd1 vccd1 vccd1 _00170_ sky130_fd_sc_hd__mux2_1
X_08208_ FPGA_INST.bus1_0\[14\] FPGA_INST.bus1_0\[15\] net409 vssd1 vssd1 vccd1 vccd1
+ _04432_ sky130_fd_sc_hd__mux2_1
X_06469_ net488 _01869_ _02746_ net487 vssd1 vssd1 vccd1 vccd1 _02747_ sky130_fd_sc_hd__o211a_1
XFILLER_119_372 vssd1 vssd1 vccd1 vccd1 sky130_fd_sc_hd__fill_1
XFILLER_5_617 vssd1 vssd1 vccd1 vccd1 sky130_fd_sc_hd__fill_1
X_09188_ FPGA_INST.cell2.LE_1A.config_data\[5\] FPGA_INST.cell2.LE_1A.config_data\[6\]
+ net266 vssd1 vssd1 vccd1 vccd1 _00101_ sky130_fd_sc_hd__mux2_1
XANTENNA__10326__S net300 vssd1 vssd1 vccd1 vccd1 sky130_fd_sc_hd__diode_2
XFILLER_107_545 vssd1 vssd1 vccd1 vccd1 sky130_fd_sc_hd__fill_2
X_08139_ FPGA_INST.cell1.LEI0.config_data\[41\] _04364_ vssd1 vssd1 vccd1 vccd1 _04365_
+ sky130_fd_sc_hd__nand2b_1
XANTENNA__07036__A1 FPGA_INST.bus2_0\[7\] vssd1 vssd1 vccd1 vccd1 sky130_fd_sc_hd__diode_2
X_11150_ net810 _00500_ net593 vssd1 vssd1 vccd1 vccd1 FPGA_INST.cell1.CB_1.config_dataB\[20\]
+ sky130_fd_sc_hd__dfstp_1
XFILLER_107_589 vssd1 vssd1 vccd1 vccd1 sky130_fd_sc_hd__fill_1
XTAP_TAPCELL_ROW_8_400 vssd1 vccd1 sky130_fd_sc_hd__tapvpwrvgnd_1
XTAP_TAPCELL_ROW_112_1854 vssd1 vccd1 sky130_fd_sc_hd__tapvpwrvgnd_1
X_10101_ FPGA_INST.cell3.SB0.route_sel\[5\] FPGA_INST.cell3.SB0.route_sel\[6\] net272
+ vssd1 vssd1 vccd1 vccd1 _00982_ sky130_fd_sc_hd__mux2_1
X_11081_ net835 _00431_ net619 vssd1 vssd1 vccd1 vccd1 FPGA_INST.cell1.LE_0A.config_data\[16\]
+ sky130_fd_sc_hd__dfrtp_1
XANTENNA__07339__A2 FPGA_INST.cell1.SB0.route_sel\[33\] vssd1 vssd1 vccd1 vccd1 sky130_fd_sc_hd__diode_2
XANTENNA__05944__A net112 vssd1 vssd1 vccd1 vccd1 sky130_fd_sc_hd__diode_2
XFILLER_0_333 vssd1 vssd1 vccd1 vccd1 sky130_fd_sc_hd__fill_2
XFILLER_76_624 vssd1 vssd1 vccd1 vccd1 sky130_fd_sc_hd__fill_1
XFILLER_76_613 vssd1 vssd1 vccd1 vccd1 sky130_fd_sc_hd__fill_2
XFILLER_48_315 vssd1 vssd1 vccd1 vccd1 sky130_fd_sc_hd__fill_1
X_10032_ FPGA_INST.cell0.CB_0.config_dataB\[7\] net420 net316 vssd1 vssd1 vccd1 vccd1
+ _00913_ sky130_fd_sc_hd__mux2_1
XANTENNA__10061__S net327 vssd1 vssd1 vccd1 vccd1 sky130_fd_sc_hd__diode_2
XFILLER_75_156 vssd1 vssd1 vccd1 vccd1 sky130_fd_sc_hd__fill_1
XANTENNA_input17_A gpio_in[24] vssd1 vssd1 vccd1 vccd1 sky130_fd_sc_hd__diode_2
XFILLER_63_329 vssd1 vssd1 vccd1 vccd1 sky130_fd_sc_hd__fill_4
XFILLER_56_392 vssd1 vssd1 vccd1 vccd1 sky130_fd_sc_hd__fill_1
X_11983_ net844 _01329_ net629 vssd1 vssd1 vccd1 vccd1 FPGA_INST.cell2.SB0.route_sel\[23\]
+ sky130_fd_sc_hd__dfstp_1
XANTENNA__05770__A1 net11 vssd1 vssd1 vccd1 vccd1 sky130_fd_sc_hd__diode_2
X_10934_ net846 _00284_ net631 vssd1 vssd1 vccd1 vccd1 FPGA_INST.cell2.CB_0.config_dataA\[15\]
+ sky130_fd_sc_hd__dfstp_1
X_10865_ net795 _00215_ net580 vssd1 vssd1 vccd1 vccd1 FPGA_INST.cell1.SB0.route_sel\[74\]
+ sky130_fd_sc_hd__dfstp_1
X_10796_ net824 _00146_ net608 vssd1 vssd1 vccd1 vccd1 FPGA_INST.cell1.SB0.route_sel\[5\]
+ sky130_fd_sc_hd__dfstp_1
XTAP_TAPCELL_ROW_14_479 vssd1 vccd1 sky130_fd_sc_hd__tapvpwrvgnd_1
XPHY_EDGE_ROW_49_Left_180 vssd1 vssd1 vccd1 vccd1 sky130_fd_sc_hd__decap_3
X_11417_ net751 _00767_ net536 vssd1 vssd1 vccd1 vccd1 FPGA_INST.cell0.LEI0.config_data\[38\]
+ sky130_fd_sc_hd__dfrtp_1
X_11348_ net793 _00698_ net578 vssd1 vssd1 vccd1 vccd1 FPGA_INST.cell1.CB_1.config_dataA\[15\]
+ sky130_fd_sc_hd__dfstp_1
XTAP_TAPCELL_ROW_74_1315 vssd1 vccd1 sky130_fd_sc_hd__tapvpwrvgnd_1
XFILLER_113_526 vssd1 vssd1 vccd1 vccd1 sky130_fd_sc_hd__fill_1
X_11279_ net786 _00629_ net571 vssd1 vssd1 vccd1 vccd1 FPGA_INST.cell0.SB0.route_sel\[124\]
+ sky130_fd_sc_hd__dfstp_1
XFILLER_67_602 vssd1 vssd1 vccd1 vccd1 sky130_fd_sc_hd__fill_1
X_05840_ _02116_ _02118_ _02119_ _02113_ vssd1 vssd1 vccd1 vccd1 _02120_ sky130_fd_sc_hd__o211a_1
XFILLER_12_3 vccd1 vssd1 vccd1 vssd1 sky130_ef_sc_hd__decap_40_12
XFILLER_54_307 vssd1 vssd1 vccd1 vccd1 sky130_fd_sc_hd__fill_1
XANTENNA__08884__B _04801_ vssd1 vssd1 vccd1 vccd1 sky130_fd_sc_hd__diode_2
X_07510_ _03755_ _03761_ _03765_ FPGA_INST.cell1.SB0.route_sel\[65\] FPGA_INST.cell1.SB0.route_sel\[64\]
+ vssd1 vssd1 vccd1 vccd1 _03766_ sky130_fd_sc_hd__o2111a_1
XFILLER_81_126 vssd1 vssd1 vccd1 vccd1 sky130_fd_sc_hd__fill_1
XANTENNA__05761__A1 net103 vssd1 vssd1 vccd1 vccd1 sky130_fd_sc_hd__diode_2
X_05771_ net135 _02049_ _02035_ vssd1 vssd1 vccd1 vccd1 _02051_ sky130_fd_sc_hd__o21a_1
X_08490_ _04704_ _04705_ _04688_ vssd1 vssd1 vccd1 vccd1 _04706_ sky130_fd_sc_hd__mux2_1
XTAP_TAPCELL_ROW_85_1466 vssd1 vccd1 sky130_fd_sc_hd__tapvpwrvgnd_1
XFILLER_62_351 vccd1 vssd1 vccd1 vssd1 sky130_ef_sc_hd__decap_40_12
X_07441_ net84 _03697_ vssd1 vssd1 vccd1 vccd1 _03699_ sky130_fd_sc_hd__nand2_1
XTAP_TAPCELL_ROW_85_1477 vssd1 vccd1 sky130_fd_sc_hd__tapvpwrvgnd_1
XFILLER_23_727 vssd1 vssd1 vccd1 vccd1 sky130_fd_sc_hd__fill_1
X_07372_ _03447_ _03587_ net79 vssd1 vssd1 vccd1 vccd1 _03631_ sky130_fd_sc_hd__o21ai_1
XTAP_TAPCELL_ROW_33_744 vssd1 vccd1 sky130_fd_sc_hd__tapvpwrvgnd_1
XANTENNA__07266__A1 net81 vssd1 vssd1 vccd1 vccd1 sky130_fd_sc_hd__diode_2
X_06323_ net139 net128 net131 net102 FPGA_INST.cell2.LEI0.config_data\[36\] FPGA_INST.cell2.LEI0.config_data\[37\]
+ vssd1 vssd1 vccd1 vccd1 _02603_ sky130_fd_sc_hd__mux4_1
X_09111_ FPGA_INST.cell2.LEI0.config_data\[25\] FPGA_INST.cell2.LEI0.config_data\[26\]
+ net258 vssd1 vssd1 vccd1 vccd1 _00027_ sky130_fd_sc_hd__mux2_1
X_09042_ net593 FPGA_INST.cell1.LE_0B.reset_mode vssd1 vssd1 vccd1 vccd1 _09042_/X
+ sky130_fd_sc_hd__xor2_2
X_06254_ net138 net127 net131 net102 FPGA_INST.cell2.LEI0.config_data\[0\] FPGA_INST.cell2.LEI0.config_data\[1\]
+ vssd1 vssd1 vccd1 vccd1 _02534_ sky130_fd_sc_hd__mux4_1
X_06185_ _02461_ _02464_ vssd1 vssd1 vccd1 vccd1 _02465_ sky130_fd_sc_hd__and2_2
XANTENNA__08215__A0 net115 vssd1 vssd1 vccd1 vccd1 sky130_fd_sc_hd__diode_2
Xmax_cap163 _01999_ vssd1 vssd1 vccd1 vccd1 net163 sky130_fd_sc_hd__buf_1
Xfanout913 net914 vssd1 vssd1 vccd1 vccd1 net913 sky130_fd_sc_hd__clkbuf_2
Xfanout902 net918 vssd1 vssd1 vccd1 vccd1 net902 sky130_fd_sc_hd__buf_1
Xfanout924 net931 vssd1 vssd1 vccd1 vccd1 net924 sky130_fd_sc_hd__buf_1
X_09944_ FPGA_INST.cell0.CB_1.config_dataB\[4\] FPGA_INST.cell0.CB_1.config_dataB\[5\]
+ net203 vssd1 vssd1 vccd1 vccd1 _00849_ sky130_fd_sc_hd__mux2_1
Xfanout946 net947 vssd1 vssd1 vccd1 vccd1 net946 sky130_fd_sc_hd__clkbuf_2
Xfanout935 net946 vssd1 vssd1 vccd1 vccd1 net935 sky130_fd_sc_hd__clkbuf_2
XANTENNA__06529__B1 _02804_ vssd1 vssd1 vccd1 vccd1 sky130_fd_sc_hd__diode_2
XANTENNA_input9_A gpio_in[17] vssd1 vssd1 vccd1 vccd1 sky130_fd_sc_hd__diode_2
X_09875_ FPGA_INST.cell0.LE_0A.config_data\[3\] FPGA_INST.cell0.LE_0A.config_data\[2\]
+ net318 vssd1 vssd1 vccd1 vccd1 _00782_ sky130_fd_sc_hd__mux2_1
X_08826_ FPGA_INST.cell3.LE_0B.config_data\[0\] FPGA_INST.cell3.LE_0B.config_data\[1\]
+ _05032_ vssd1 vssd1 vccd1 vccd1 _05033_ sky130_fd_sc_hd__mux2_1
XTAP_TAPCELL_ROW_127_2061 vssd1 vccd1 sky130_fd_sc_hd__tapvpwrvgnd_1
XFILLER_57_167 vssd1 vssd1 vccd1 vccd1 sky130_fd_sc_hd__fill_1
XANTENNA_fanout838_A net842 vssd1 vssd1 vccd1 vccd1 sky130_fd_sc_hd__diode_2
XANTENNA__08794__B _03583_ vssd1 vssd1 vccd1 vccd1 sky130_fd_sc_hd__diode_2
X_08757_ _04964_ _04965_ _04891_ vssd1 vssd1 vccd1 vccd1 _04966_ sky130_fd_sc_hd__mux2_1
XANTENNA_fanout361_X net361 vssd1 vssd1 vccd1 vccd1 sky130_fd_sc_hd__diode_2
X_05969_ _02247_ _02248_ vssd1 vssd1 vccd1 vccd1 _02249_ sky130_fd_sc_hd__nand2b_1
X_08688_ _04831_ _04896_ FPGA_INST.cell3.CB_0.config_dataA\[12\] vssd1 vssd1 vccd1
+ vccd1 _04897_ sky130_fd_sc_hd__a21oi_1
X_07708_ _01981_ _03958_ vssd1 vssd1 vccd1 vccd1 _03959_ sky130_fd_sc_hd__nand2_4
XFILLER_14_705 vssd1 vssd1 vccd1 vccd1 sky130_fd_sc_hd__fill_2
XFILLER_26_543 vssd1 vssd1 vccd1 vccd1 sky130_fd_sc_hd__fill_1
X_07639_ FPGA_INST.cell3.SB0.route_sel\[90\] FPGA_INST.cell3.SB0.route_sel\[91\] vssd1
+ vssd1 vccd1 vccd1 _03892_ sky130_fd_sc_hd__nand2_1
XANTENNA__06701__A0 _02772_ vssd1 vssd1 vccd1 vccd1 sky130_fd_sc_hd__diode_2
XFILLER_41_502 vssd1 vssd1 vccd1 vccd1 sky130_fd_sc_hd__fill_2
XFILLER_13_204 vssd1 vssd1 vccd1 vccd1 sky130_fd_sc_hd__fill_1
XFILLER_14_727 vccd1 vssd1 vccd1 vssd1 sky130_ef_sc_hd__decap_40_12
XFILLER_26_587 vssd1 vssd1 vccd1 vccd1 sky130_fd_sc_hd__fill_1
XANTENNA_fanout626_X net626 vssd1 vssd1 vccd1 vccd1 sky130_fd_sc_hd__diode_2
X_10650_ FPGA_INST.cell2.LE_0A.sel_clk _00000_ net734 vssd1 vssd1 vccd1 vccd1 FPGA_INST.cell2.LE_0A.dff1_out
+ sky130_fd_sc_hd__dfstp_1
X_09309_ FPGA_INST.cell1.SB0.route_sel\[80\] FPGA_INST.cell1.SB0.route_sel\[81\] net204
+ vssd1 vssd1 vccd1 vccd1 _00222_ sky130_fd_sc_hd__mux2_1
XFILLER_70_24 vssd1 vssd1 vccd1 vccd1 sky130_fd_sc_hd__fill_4
X_10581_ net392 net391 net284 vssd1 vssd1 vccd1 vccd1 _01460_ sky130_fd_sc_hd__mux2_1
XTAP_TAPCELL_ROW_11_438 vssd1 vccd1 sky130_fd_sc_hd__tapvpwrvgnd_1
XFILLER_21_281 vssd1 vssd1 vccd1 vccd1 sky130_fd_sc_hd__fill_1
XFILLER_107_331 vssd1 vssd1 vccd1 vccd1 sky130_fd_sc_hd__fill_1
XFILLER_5_447 vssd1 vssd1 vccd1 vccd1 sky130_fd_sc_hd__fill_1
X_11202_ net761 _00552_ net546 vssd1 vssd1 vccd1 vccd1 FPGA_INST.cell0.SB0.route_sel\[47\]
+ sky130_fd_sc_hd__dfstp_1
X_12182_ net938 _01528_ net722 vssd1 vssd1 vccd1 vccd1 FPGA_INST.cell3.LE_1B.reset_mode
+ sky130_fd_sc_hd__dfrtp_1
XFILLER_107_397 vssd1 vssd1 vccd1 vccd1 sky130_fd_sc_hd__fill_1
XFILLER_79_66 vssd1 vssd1 vccd1 vccd1 sky130_fd_sc_hd__fill_1
X_11133_ net816 _00483_ net601 vssd1 vssd1 vccd1 vccd1 FPGA_INST.cell1.CB_1.config_dataB\[3\]
+ sky130_fd_sc_hd__dfstp_1
XTAP_TAPCELL_ROW_56_1067 vssd1 vccd1 sky130_fd_sc_hd__tapvpwrvgnd_1
XFILLER_122_367 vssd1 vssd1 vccd1 vccd1 sky130_fd_sc_hd__fill_1
X_11064_ FPGA_INST.cell1.LE_0B.sel_clk _00414_ net733 vssd1 vssd1 vccd1 vccd1 FPGA_INST.cell1.LE_0B.dff1_out
+ sky130_fd_sc_hd__dfstp_1
XFILLER_110_518 vccd1 vssd1 vccd1 vssd1 sky130_ef_sc_hd__decap_40_12
XFILLER_0_141 vccd1 vssd1 vccd1 vssd1 sky130_ef_sc_hd__decap_40_12
XFILLER_103_581 vssd1 vssd1 vccd1 vccd1 sky130_fd_sc_hd__fill_2
X_10015_ FPGA_INST.cell0.CB_0.config_dataA\[14\] net427 net191 vssd1 vssd1 vccd1 vccd1
+ _00896_ sky130_fd_sc_hd__mux2_1
XFILLER_28_81 vssd1 vssd1 vccd1 vccd1 sky130_fd_sc_hd__fill_1
XTAP_TAPCELL_ROW_19_549 vssd1 vccd1 sky130_fd_sc_hd__tapvpwrvgnd_1
X_11966_ net852 _01312_ net637 vssd1 vssd1 vccd1 vccd1 FPGA_INST.cell2.SB0.route_sel\[6\]
+ sky130_fd_sc_hd__dfstp_1
X_10917_ net855 _00267_ net572 vssd1 vssd1 vccd1 vccd1 FPGA_INST.cell1.SB0.route_sel\[126\]
+ sky130_fd_sc_hd__dfstp_1
X_11897_ net929 _01243_ net713 vssd1 vssd1 vccd1 vccd1 FPGA_INST.cell3.LE_0B.config_data\[5\]
+ sky130_fd_sc_hd__dfrtp_1
X_10848_ net797 _00198_ net582 vssd1 vssd1 vccd1 vccd1 FPGA_INST.cell1.SB0.route_sel\[57\]
+ sky130_fd_sc_hd__dfstp_1
XTAP_TAPCELL_ROW_30_703 vssd1 vccd1 sky130_fd_sc_hd__tapvpwrvgnd_1
XTAP_TAPCELL_ROW_80_1396 vssd1 vccd1 sky130_fd_sc_hd__tapvpwrvgnd_1
X_10779_ net901 _00129_ net685 vssd1 vssd1 vccd1 vccd1 FPGA_INST.cell2.CB_1.config_dataB\[13\]
+ sky130_fd_sc_hd__dfstp_1
XFILLER_9_742 vssd1 vssd1 vccd1 vccd1 sky130_fd_sc_hd__fill_1
XANTENNA__08996__B2 FPGA_INST.cell1.SB0.route_sel\[33\] vssd1 vssd1 vccd1 vccd1 sky130_fd_sc_hd__diode_2
XFILLER_74_5 vccd1 vssd1 vccd1 vssd1 sky130_ef_sc_hd__decap_40_12
XFILLER_60_90 vssd1 vssd1 vccd1 vccd1 sky130_fd_sc_hd__fill_1
XANTENNA__09755__S net369 vssd1 vssd1 vccd1 vccd1 sky130_fd_sc_hd__diode_2
XFILLER_99_502 vssd1 vssd1 vccd1 vccd1 sky130_fd_sc_hd__fill_2
XFILLER_125_183 vssd1 vssd1 vccd1 vccd1 sky130_fd_sc_hd__fill_4
XFILLER_125_161 vssd1 vssd1 vccd1 vccd1 sky130_fd_sc_hd__fill_4
X_07990_ FPGA_INST.cell1.LE_0A.config_data\[3\] FPGA_INST.cell1.LE_0A.config_data\[2\]
+ _04148_ vssd1 vssd1 vccd1 vccd1 _04218_ sky130_fd_sc_hd__mux2_1
Xfanout209 net219 vssd1 vssd1 vccd1 vccd1 net209 sky130_fd_sc_hd__clkbuf_2
X_06941_ _01749_ _03203_ _03204_ _03206_ _03208_ vssd1 vssd1 vccd1 vccd1 _03209_ sky130_fd_sc_hd__o32a_1
X_09660_ FPGA_INST.cell0.SB0.route_sel\[64\] FPGA_INST.cell0.SB0.route_sel\[63\] net314
+ vssd1 vssd1 vccd1 vccd1 _00569_ sky130_fd_sc_hd__mux2_1
XFILLER_95_785 vssd1 vssd1 vccd1 vccd1 sky130_fd_sc_hd__fill_1
XTAP_TAPCELL_ROW_87_1506 vssd1 vccd1 sky130_fd_sc_hd__tapvpwrvgnd_1
XANTENNA__07723__A2 _03973_ vssd1 vssd1 vccd1 vccd1 sky130_fd_sc_hd__diode_2
X_08611_ FPGA_INST.cell3.SB0.route_sel\[30\] FPGA_INST.cell3.SB0.route_sel\[31\] vssd1
+ vssd1 vccd1 vccd1 _04820_ sky130_fd_sc_hd__nand2b_1
X_06872_ net424 _02233_ net423 vssd1 vssd1 vccd1 vccd1 _03140_ sky130_fd_sc_hd__o21ai_1
X_09591_ FPGA_INST.cell1.CB_1.config_dataB\[19\] FPGA_INST.cell1.CB_1.config_dataB\[20\]
+ net213 vssd1 vssd1 vccd1 vccd1 _00500_ sky130_fd_sc_hd__mux2_1
X_05823_ FPGA_INST.cell0.SB0.route_sel\[74\] FPGA_INST.cell0.SB0.route_sel\[75\] _02100_
+ _02101_ _02102_ vssd1 vssd1 vccd1 vccd1 _02103_ sky130_fd_sc_hd__a221o_1
XTAP_TAPCELL_ROW_38_814 vssd1 vccd1 sky130_fd_sc_hd__tapvpwrvgnd_1
X_08542_ _04752_ vssd1 vssd1 vccd1 vccd1 _04753_ sky130_fd_sc_hd__inv_2
X_05754_ FPGA_INST.cell2.SB0.route_sel\[84\] FPGA_INST.cell2.SB0.route_sel\[85\] _02033_
+ vssd1 vssd1 vccd1 vccd1 _02034_ sky130_fd_sc_hd__a21oi_1
X_08473_ net151 net144 net149 net142 FPGA_INST.cell1.LEI0.config_data\[9\] FPGA_INST.cell1.LEI0.config_data\[10\]
+ vssd1 vssd1 vccd1 vccd1 _04689_ sky130_fd_sc_hd__mux4_1
XANTENNA__08684__A0 _04819_ vssd1 vssd1 vccd1 vccd1 sky130_fd_sc_hd__diode_2
XFILLER_63_671 vssd1 vssd1 vccd1 vccd1 sky130_fd_sc_hd__fill_1
XFILLER_62_192 vssd1 vssd1 vccd1 vccd1 sky130_fd_sc_hd__fill_4
XFILLER_62_181 vssd1 vssd1 vccd1 vccd1 sky130_fd_sc_hd__fill_1
X_05685_ FPGA_INST.cell2.SB0.route_sel\[102\] _01579_ FPGA_INST.cell2.SB0.route_sel\[98\]
+ FPGA_INST.cell2.SB0.route_sel\[99\] _01964_ vssd1 vssd1 vccd1 vccd1 _01965_ sky130_fd_sc_hd__o221a_1
XFILLER_23_557 vssd1 vssd1 vccd1 vccd1 sky130_fd_sc_hd__fill_1
X_07424_ _03679_ _03680_ _03681_ _02230_ vssd1 vssd1 vccd1 vccd1 _03682_ sky130_fd_sc_hd__a31o_4
XFILLER_50_365 vssd1 vssd1 vccd1 vccd1 sky130_fd_sc_hd__fill_4
XANTENNA__07023__B _02070_ vssd1 vssd1 vccd1 vccd1 sky130_fd_sc_hd__diode_2
X_07355_ FPGA_INST.cell3.SB0.route_sel\[37\] FPGA_INST.cell3.SB0.route_sel\[36\] _03596_
+ _03614_ _03598_ vssd1 vssd1 vccd1 vccd1 _03615_ sky130_fd_sc_hd__a221o_1
XANTENNA__07958__B _03568_ vssd1 vssd1 vccd1 vccd1 sky130_fd_sc_hd__diode_2
XANTENNA_fanout321_A net325 vssd1 vssd1 vccd1 vccd1 sky130_fd_sc_hd__diode_2
X_07286_ _03396_ _03546_ vssd1 vssd1 vccd1 vccd1 _03547_ sky130_fd_sc_hd__nor2_1
X_06306_ _02584_ _02585_ FPGA_INST.cell2.CB_0.config_dataA\[18\] vssd1 vssd1 vccd1
+ vccd1 _02586_ sky130_fd_sc_hd__nor3b_1
XANTENNA__06207__X _02487_ vssd1 vssd1 vccd1 vccd1 sky130_fd_sc_hd__diode_2
XFILLER_108_128 vccd1 vssd1 vccd1 vssd1 sky130_ef_sc_hd__decap_40_12
XTAP_TAPCELL_ROW_98_1657 vssd1 vccd1 sky130_fd_sc_hd__tapvpwrvgnd_1
X_06237_ net7 net8 net510 vssd1 vssd1 vccd1 vccd1 _02517_ sky130_fd_sc_hd__mux2_1
X_09025_ FPGA_INST.cell2.SB0.route_sel\[10\] FPGA_INST.cell2.SB0.route_sel\[11\] vssd1
+ vssd1 vccd1 vccd1 _05190_ sky130_fd_sc_hd__nand2b_1
XFILLER_117_651 vssd1 vssd1 vccd1 vccd1 sky130_fd_sc_hd__fill_2
XANTENNA_fanout690_A net695 vssd1 vssd1 vccd1 vccd1 sky130_fd_sc_hd__diode_2
XANTENNA__08203__A3 FPGA_INST.bus1_0\[11\] vssd1 vssd1 vccd1 vccd1 sky130_fd_sc_hd__diode_2
X_06168_ FPGA_INST.cell2.SB0.route_sel\[13\] FPGA_INST.cell2.SB0.route_sel\[12\] vssd1
+ vssd1 vccd1 vccd1 _02448_ sky130_fd_sc_hd__nand2b_1
XANTENNA__10604__S net284 vssd1 vssd1 vccd1 vccd1 sky130_fd_sc_hd__diode_2
XANTENNA_fanout788_A net789 vssd1 vssd1 vccd1 vccd1 sky130_fd_sc_hd__diode_2
X_06099_ FPGA_INST.cell0.SB0.route_sel\[16\] FPGA_INST.cell0.SB0.route_sel\[17\] vssd1
+ vssd1 vccd1 vccd1 _02379_ sky130_fd_sc_hd__and2_1
XFILLER_104_389 vssd1 vssd1 vccd1 vccd1 sky130_fd_sc_hd__fill_1
Xfanout721 net729 vssd1 vssd1 vccd1 vccd1 net721 sky130_fd_sc_hd__clkbuf_4
XFILLER_77_229 vssd1 vssd1 vccd1 vccd1 sky130_fd_sc_hd__fill_8
Xfanout710 net715 vssd1 vssd1 vccd1 vccd1 net710 sky130_fd_sc_hd__clkbuf_4
Xfanout732 net29 vssd1 vssd1 vccd1 vccd1 net732 sky130_fd_sc_hd__clkbuf_8
X_09927_ FPGA_INST.cell0.LE_1A.config_data\[9\] FPGA_INST.cell0.LE_1A.config_data\[8\]
+ net311 vssd1 vssd1 vccd1 vccd1 _00832_ sky130_fd_sc_hd__mux2_1
Xfanout765 net766 vssd1 vssd1 vccd1 vccd1 net765 sky130_fd_sc_hd__clkbuf_2
Xfanout743 net749 vssd1 vssd1 vccd1 vccd1 net743 sky130_fd_sc_hd__buf_2
Xfanout776 net777 vssd1 vssd1 vccd1 vccd1 net776 sky130_fd_sc_hd__clkbuf_2
Xfanout754 net758 vssd1 vssd1 vccd1 vccd1 net754 sky130_fd_sc_hd__clkbuf_2
Xfanout798 net799 vssd1 vssd1 vccd1 vccd1 net798 sky130_fd_sc_hd__buf_1
Xfanout787 net788 vssd1 vssd1 vccd1 vccd1 net787 sky130_fd_sc_hd__buf_1
XFILLER_58_465 vssd1 vssd1 vccd1 vccd1 sky130_fd_sc_hd__fill_2
XFILLER_58_454 vssd1 vssd1 vccd1 vccd1 sky130_fd_sc_hd__fill_4
X_09858_ FPGA_INST.cell0.LEI0.config_data\[36\] FPGA_INST.cell0.LEI0.config_data\[37\]
+ net177 vssd1 vssd1 vccd1 vccd1 _00766_ sky130_fd_sc_hd__mux2_1
XFILLER_105_86 vssd1 vssd1 vccd1 vccd1 sky130_fd_sc_hd__fill_1
X_08809_ FPGA_INST.cell3.CB_0.config_dataB\[3\] _05015_ vssd1 vssd1 vccd1 vccd1 _05016_
+ sky130_fd_sc_hd__and2b_1
X_09789_ FPGA_INST.cell1.CB_1.config_dataA\[14\] FPGA_INST.cell1.CB_1.config_dataA\[15\]
+ net204 vssd1 vssd1 vccd1 vccd1 _00698_ sky130_fd_sc_hd__mux2_1
XFILLER_58_487 vssd1 vssd1 vccd1 vccd1 sky130_fd_sc_hd__fill_1
X_11820_ net943 _01166_ net727 vssd1 vssd1 vccd1 vccd1 FPGA_INST.cell3.LEI0.config_data\[0\]
+ sky130_fd_sc_hd__dfrtp_1
XFILLER_73_446 vssd1 vssd1 vccd1 vccd1 sky130_fd_sc_hd__fill_2
XFILLER_121_30 vssd1 vssd1 vccd1 vccd1 sky130_fd_sc_hd__fill_2
XTAP_TAPCELL_ROW_107_1786 vssd1 vccd1 sky130_fd_sc_hd__tapvpwrvgnd_1
XTAP_TAPCELL_ROW_107_1775 vssd1 vccd1 sky130_fd_sc_hd__tapvpwrvgnd_1
X_11751_ net901 _01097_ net685 vssd1 vssd1 vccd1 vccd1 FPGA_INST.cell3.SB0.route_sel\[121\]
+ sky130_fd_sc_hd__dfstp_1
XFILLER_54_682 vssd1 vssd1 vccd1 vccd1 sky130_fd_sc_hd__fill_1
XTAP_TAPCELL_ROW_16_508 vssd1 vccd1 sky130_fd_sc_hd__tapvpwrvgnd_1
X_10702_ net844 _00052_ net629 vssd1 vssd1 vccd1 vccd1 FPGA_INST.cell2.LE_0A.config_data\[1\]
+ sky130_fd_sc_hd__dfrtp_1
XFILLER_14_535 vssd1 vssd1 vccd1 vccd1 sky130_fd_sc_hd__fill_1
XFILLER_14_546 vssd1 vssd1 vccd1 vccd1 sky130_fd_sc_hd__fill_1
XTAP_TAPCELL_ROW_120_1964 vssd1 vccd1 sky130_fd_sc_hd__tapvpwrvgnd_1
X_11682_ net905 _01028_ net689 vssd1 vssd1 vccd1 vccd1 FPGA_INST.cell3.SB0.route_sel\[52\]
+ sky130_fd_sc_hd__dfstp_1
XANTENNA__08690__A3 net21 vssd1 vssd1 vccd1 vccd1 sky130_fd_sc_hd__diode_2
XANTENNA__06686__C1 net156 vssd1 vssd1 vccd1 vccd1 sky130_fd_sc_hd__diode_2
X_10633_ FPGA_INST.cell3.LE_1B.config_data\[3\] FPGA_INST.cell3.LE_1B.config_data\[2\]
+ net368 vssd1 vssd1 vccd1 vccd1 _01512_ sky130_fd_sc_hd__mux2_1
XANTENNA__07220__Y _03483_ vssd1 vssd1 vccd1 vccd1 sky130_fd_sc_hd__diode_2
XANTENNA__08978__B2 FPGA_INST.cell1.SB0.route_sel\[49\] vssd1 vssd1 vccd1 vccd1 sky130_fd_sc_hd__diode_2
X_10564_ FPGA_INST.cell3.CB_0.config_dataA\[8\] FPGA_INST.cell3.CB_0.config_dataA\[9\]
+ net288 vssd1 vssd1 vccd1 vccd1 _01443_ sky130_fd_sc_hd__mux2_1
XFILLER_5_200 vssd1 vssd1 vccd1 vccd1 sky130_fd_sc_hd__fill_8
XANTENNA__06989__A0 FPGA_INST.bus2_0\[6\] vssd1 vssd1 vccd1 vccd1 sky130_fd_sc_hd__diode_2
X_10495_ FPGA_INST.cell2.SB0.route_sel\[68\] FPGA_INST.cell2.SB0.route_sel\[67\] net354
+ vssd1 vssd1 vccd1 vccd1 _01374_ sky130_fd_sc_hd__mux2_1
X_12165_ net910 _01511_ net694 vssd1 vssd1 vccd1 vccd1 FPGA_INST.cell3.LE_1B.config_data\[2\]
+ sky130_fd_sc_hd__dfrtp_1
XANTENNA__06105__B1_N FPGA_INST.bus2_0\[2\] vssd1 vssd1 vccd1 vccd1 sky130_fd_sc_hd__diode_2
X_11116_ net804 _00466_ net589 vssd1 vssd1 vccd1 vccd1 FPGA_INST.cell1.LE_1A.config_data\[7\]
+ sky130_fd_sc_hd__dfrtp_1
XFILLER_68_229 vssd1 vssd1 vccd1 vccd1 sky130_fd_sc_hd__fill_4
X_12096_ net922 _01442_ net706 vssd1 vssd1 vccd1 vccd1 FPGA_INST.cell3.CB_0.config_dataA\[8\]
+ sky130_fd_sc_hd__dfstp_1
X_11047_ net806 _00397_ net591 vssd1 vssd1 vccd1 vccd1 FPGA_INST.cell1.LEI0.config_data\[32\]
+ sky130_fd_sc_hd__dfrtp_1
XANTENNA__07166__B1 net78 vssd1 vssd1 vccd1 vccd1 sky130_fd_sc_hd__diode_2
XFILLER_77_774 vssd1 vssd1 vccd1 vccd1 sky130_fd_sc_hd__fill_1
Xinput9 gpio_in[17] vssd1 vssd1 vccd1 vccd1 net9 sky130_fd_sc_hd__clkbuf_2
XFILLER_36_115 vssd1 vssd1 vccd1 vccd1 sky130_fd_sc_hd__fill_1
XTAP_TAPCELL_ROW_69_1247 vssd1 vccd1 sky130_fd_sc_hd__tapvpwrvgnd_1
XFILLER_64_468 vssd1 vssd1 vccd1 vccd1 sky130_fd_sc_hd__fill_8
X_11949_ net916 _01295_ net700 vssd1 vssd1 vccd1 vccd1 FPGA_INST.cell3.CB_1.config_dataB\[14\]
+ sky130_fd_sc_hd__dfstp_1
XTAP_TAPCELL_ROW_82_1436 vssd1 vccd1 sky130_fd_sc_hd__tapvpwrvgnd_1
XTAP_TAPCELL_ROW_82_1425 vssd1 vccd1 sky130_fd_sc_hd__tapvpwrvgnd_1
X_05470_ FPGA_INST.cell0.CB_1.config_dataA\[2\] vssd1 vssd1 vccd1 vccd1 _01752_ sky130_fd_sc_hd__inv_2
XTAP_TAPCELL_ROW_43_883 vssd1 vccd1 sky130_fd_sc_hd__tapvpwrvgnd_1
XFILLER_118_415 vssd1 vssd1 vccd1 vccd1 sky130_fd_sc_hd__fill_4
X_07140_ FPGA_INST.cell1.SB0.route_sel\[3\] FPGA_INST.cell1.SB0.route_sel\[2\] vssd1
+ vssd1 vccd1 vccd1 _03404_ sky130_fd_sc_hd__nand2_1
X_07071_ net430 _01839_ _03336_ FPGA_INST.cell0.CB_0.config_dataA\[11\] vssd1 vssd1
+ vccd1 vccd1 _03337_ sky130_fd_sc_hd__o211a_1
X_06022_ net112 _01975_ _02181_ vssd1 vssd1 vccd1 vccd1 _02302_ sky130_fd_sc_hd__nor3_1
XFILLER_126_492 vssd1 vssd1 vccd1 vccd1 sky130_fd_sc_hd__fill_1
XTAP_TAPCELL_ROW_93_1587 vssd1 vccd1 sky130_fd_sc_hd__tapvpwrvgnd_1
XFILLER_59_207 vssd1 vssd1 vccd1 vccd1 sky130_fd_sc_hd__fill_1
X_07973_ net464 _03854_ _04200_ net462 vssd1 vssd1 vccd1 vccd1 _04201_ sky130_fd_sc_hd__o211a_1
XFILLER_87_549 vssd1 vssd1 vccd1 vccd1 sky130_fd_sc_hd__fill_8
X_09712_ FPGA_INST.cell0.SB0.route_sel\[116\] FPGA_INST.cell0.SB0.route_sel\[115\]
+ net322 vssd1 vssd1 vccd1 vccd1 _00621_ sky130_fd_sc_hd__mux2_1
XFILLER_68_752 vssd1 vssd1 vccd1 vccd1 sky130_fd_sc_hd__fill_4
X_06924_ FPGA_INST.cell0.CB_0.config_dataB\[14\] _03175_ _03191_ vssd1 vssd1 vccd1
+ vccd1 _03192_ sky130_fd_sc_hd__or3_1
XTAP_TAPCELL_ROW_124_2020 vssd1 vccd1 sky130_fd_sc_hd__tapvpwrvgnd_1
XANTENNA_fanout271_A net273 vssd1 vssd1 vccd1 vccd1 sky130_fd_sc_hd__diode_2
XFILLER_67_273 vssd1 vssd1 vccd1 vccd1 sky130_fd_sc_hd__fill_4
XFILLER_55_402 vssd1 vssd1 vccd1 vccd1 sky130_fd_sc_hd__fill_8
X_06855_ FPGA_INST.cell0.LEI0.config_data\[17\] _03122_ vssd1 vssd1 vccd1 vccd1 _03123_
+ sky130_fd_sc_hd__and2b_1
X_09643_ FPGA_INST.cell0.SB0.route_sel\[46\] FPGA_INST.cell0.SB0.route_sel\[47\] net182
+ vssd1 vssd1 vccd1 vccd1 _00552_ sky130_fd_sc_hd__mux2_1
XANTENNA_fanout369_A net372 vssd1 vssd1 vccd1 vccd1 sky130_fd_sc_hd__diode_2
X_09574_ FPGA_INST.cell1.CB_1.config_dataB\[3\] FPGA_INST.cell1.CB_1.config_dataB\[2\]
+ net335 vssd1 vssd1 vccd1 vccd1 _00483_ sky130_fd_sc_hd__mux2_1
XFILLER_83_755 vssd1 vssd1 vccd1 vccd1 sky130_fd_sc_hd__fill_1
X_05806_ _01784_ _02084_ vssd1 vssd1 vccd1 vccd1 _02086_ sky130_fd_sc_hd__nor2_1
XFILLER_27_137 vssd1 vssd1 vccd1 vccd1 sky130_fd_sc_hd__fill_2
X_08525_ _04736_ _04737_ _04721_ vssd1 vssd1 vccd1 vccd1 _04738_ sky130_fd_sc_hd__mux2_1
X_06786_ _02819_ _03051_ _03052_ _02824_ _01598_ vssd1 vssd1 vccd1 vccd1 _03060_ sky130_fd_sc_hd__a221o_1
XFILLER_42_118 vssd1 vssd1 vccd1 vccd1 sky130_fd_sc_hd__fill_1
X_05737_ net383 net161 vssd1 vssd1 vccd1 vccd1 _02017_ sky130_fd_sc_hd__nor2_1
X_08456_ _04673_ _04672_ _04656_ vssd1 vssd1 vccd1 vccd1 _04674_ sky130_fd_sc_hd__mux2_1
X_05668_ net100 _01846_ _01942_ vssd1 vssd1 vccd1 vccd1 _01948_ sky130_fd_sc_hd__and3_1
X_07407_ FPGA_INST.cell3.SB0.route_sel\[40\] FPGA_INST.cell3.SB0.route_sel\[41\] _03659_
+ _03665_ net369 vssd1 vssd1 vccd1 vccd1 _03666_ sky130_fd_sc_hd__a311oi_4
X_08387_ net438 net439 vssd1 vssd1 vccd1 vccd1 _04609_ sky130_fd_sc_hd__nor2_1
XFILLER_23_376 vssd1 vssd1 vccd1 vccd1 sky130_fd_sc_hd__fill_1
X_07338_ net154 _03592_ vssd1 vssd1 vccd1 vccd1 _03598_ sky130_fd_sc_hd__and2b_1
XANTENNA_fanout324_X net324 vssd1 vssd1 vccd1 vccd1 sky130_fd_sc_hd__diode_2
X_05599_ FPGA_INST.cell0.CB_1.config_dataA\[24\] FPGA_INST.cell0.CB_1.config_dataA\[20\]
+ FPGA_INST.cell0.CB_1.config_dataA\[21\] vssd1 vssd1 vccd1 vccd1 _01879_ sky130_fd_sc_hd__nand3b_4
XFILLER_50_195 vssd1 vssd1 vccd1 vccd1 sky130_fd_sc_hd__fill_1
XTAP_TAPCELL_ROW_21_577 vssd1 vccd1 sky130_fd_sc_hd__tapvpwrvgnd_1
X_07269_ FPGA_INST.cell3.CB_0.config_dataB\[23\] FPGA_INST.cell3.CB_0.config_dataB\[22\]
+ _03530_ vssd1 vssd1 vccd1 vccd1 _03531_ sky130_fd_sc_hd__or3_1
XFILLER_117_470 vssd1 vssd1 vccd1 vccd1 sky130_fd_sc_hd__fill_1
X_10280_ net39 net40 net253 vssd1 vssd1 vccd1 vccd1 _01161_ sky130_fd_sc_hd__mux2_1
XFILLER_3_715 vccd1 vssd1 vccd1 vssd1 sky130_ef_sc_hd__decap_40_12
X_09008_ _01554_ FPGA_INST.cell2.SB0.route_sel\[25\] FPGA_INST.cell2.SB0.route_sel\[30\]
+ FPGA_INST.cell2.SB0.route_sel\[31\] _05178_ vssd1 vssd1 vccd1 vccd1 _05179_ sky130_fd_sc_hd__o221a_1
XANTENNA__10334__S net737 vssd1 vssd1 vccd1 vccd1 sky130_fd_sc_hd__diode_2
XFILLER_104_131 vssd1 vssd1 vccd1 vccd1 sky130_fd_sc_hd__fill_8
XANTENNA__08188__A2 _03682_ vssd1 vssd1 vccd1 vccd1 sky130_fd_sc_hd__diode_2
XFILLER_116_41 vccd1 vssd1 vccd1 vssd1 sky130_ef_sc_hd__decap_40_12
XFILLER_104_153 vssd1 vssd1 vccd1 vccd1 sky130_fd_sc_hd__fill_2
XANTENNA__07396__B1 _02804_ vssd1 vssd1 vccd1 vccd1 sky130_fd_sc_hd__diode_2
XTAP_TAPCELL_ROW_53_1026 vssd1 vccd1 sky130_fd_sc_hd__tapvpwrvgnd_1
XFILLER_76_23 vssd1 vssd1 vccd1 vccd1 sky130_fd_sc_hd__fill_4
XANTENNA__09137__A1 FPGA_INST.cell2.LE_0A.config_data\[0\] vssd1 vssd1 vccd1 vccd1
+ sky130_fd_sc_hd__diode_2
Xfanout540 net543 vssd1 vssd1 vccd1 vccd1 net540 sky130_fd_sc_hd__clkbuf_2
Xfanout551 net554 vssd1 vssd1 vccd1 vccd1 net551 sky130_fd_sc_hd__buf_2
XTAP_TAPCELL_ROW_109_1804 vssd1 vccd1 sky130_fd_sc_hd__tapvpwrvgnd_1
Xfanout584 net588 vssd1 vssd1 vccd1 vccd1 net584 sky130_fd_sc_hd__clkbuf_4
Xfanout573 net574 vssd1 vssd1 vccd1 vccd1 net573 sky130_fd_sc_hd__clkbuf_2
Xfanout562 net563 vssd1 vssd1 vccd1 vccd1 net562 sky130_fd_sc_hd__clkbuf_4
Xfanout595 net596 vssd1 vssd1 vccd1 vccd1 net595 sky130_fd_sc_hd__buf_2
XTAP_TAPCELL_ROW_109_1815 vssd1 vccd1 sky130_fd_sc_hd__tapvpwrvgnd_1
XFILLER_76_78 vssd1 vssd1 vccd1 vccd1 sky130_fd_sc_hd__fill_1
XFILLER_59_796 vssd1 vssd1 vccd1 vccd1 sky130_fd_sc_hd__fill_2
XFILLER_74_766 vssd1 vssd1 vccd1 vccd1 sky130_fd_sc_hd__fill_4
XFILLER_74_755 vssd1 vssd1 vccd1 vccd1 sky130_fd_sc_hd__fill_1
XANTENNA__08360__A2 _03997_ vssd1 vssd1 vccd1 vccd1 sky130_fd_sc_hd__diode_2
XFILLER_92_33 vssd1 vssd1 vccd1 vccd1 sky130_fd_sc_hd__fill_1
XFILLER_27_660 vssd1 vssd1 vccd1 vccd1 sky130_fd_sc_hd__fill_2
XTAP_TAPCELL_ROW_29_688 vssd1 vccd1 sky130_fd_sc_hd__tapvpwrvgnd_1
XFILLER_34_619 vssd1 vssd1 vccd1 vccd1 sky130_fd_sc_hd__fill_4
XANTENNA__08648__A0 net89 vssd1 vssd1 vccd1 vccd1 sky130_fd_sc_hd__diode_2
X_11803_ net871 _01149_ net655 vssd1 vssd1 vccd1 vccd1 FPGA_INST.io_east_oeb\[26\]
+ sky130_fd_sc_hd__dfrtp_1
XTAP_TAPCELL_ROW_1_291 vssd1 vccd1 sky130_fd_sc_hd__tapvpwrvgnd_1
X_11734_ net903 _01080_ net687 vssd1 vssd1 vccd1 vccd1 FPGA_INST.cell3.SB0.route_sel\[104\]
+ sky130_fd_sc_hd__dfstp_1
XFILLER_14_365 vssd1 vssd1 vccd1 vccd1 sky130_fd_sc_hd__fill_4
X_11665_ net910 _01011_ net694 vssd1 vssd1 vccd1 vccd1 FPGA_INST.cell3.SB0.route_sel\[35\]
+ sky130_fd_sc_hd__dfstp_1
XANTENNA__07871__A1 FPGA_INST.bus3_1\[9\] vssd1 vssd1 vccd1 vccd1 sky130_fd_sc_hd__diode_2
XTAP_TAPCELL_ROW_64_1177 vssd1 vccd1 sky130_fd_sc_hd__tapvpwrvgnd_1
X_10616_ FPGA_INST.cell3.CB_1.config_dataA\[10\] FPGA_INST.cell3.CB_1.config_dataA\[11\]
+ net299 vssd1 vssd1 vccd1 vccd1 _01495_ sky130_fd_sc_hd__mux2_1
XTAP_TAPCELL_ROW_40_842 vssd1 vccd1 sky130_fd_sc_hd__tapvpwrvgnd_1
XFILLER_128_757 vssd1 vssd1 vccd1 vccd1 sky130_fd_sc_hd__fill_2
XFILLER_127_223 vssd1 vssd1 vccd1 vccd1 sky130_fd_sc_hd__fill_1
X_11596_ net803 _00946_ net588 vssd1 vssd1 vccd1 vccd1 FPGA_INST.cell0.CB_1.config_dataA\[15\]
+ sky130_fd_sc_hd__dfstp_1
XANTENNA__06426__A2 _02413_ vssd1 vssd1 vccd1 vccd1 sky130_fd_sc_hd__diode_2
X_10547_ FPGA_INST.cell2.SB0.route_sel\[119\] FPGA_INST.cell2.SB0.route_sel\[120\]
+ net240 vssd1 vssd1 vccd1 vccd1 _01426_ sky130_fd_sc_hd__mux2_1
XFILLER_108_470 vssd1 vssd1 vccd1 vccd1 sky130_fd_sc_hd__fill_4
X_10478_ FPGA_INST.cell2.SB0.route_sel\[51\] FPGA_INST.cell2.SB0.route_sel\[50\] net319
+ vssd1 vssd1 vccd1 vccd1 _01357_ sky130_fd_sc_hd__mux2_1
XANTENNA__05686__X _01966_ vssd1 vssd1 vccd1 vccd1 sky130_fd_sc_hd__diode_2
XANTENNA__08179__A2 _03504_ vssd1 vssd1 vccd1 vccd1 sky130_fd_sc_hd__diode_2
XANTENNA__08222__B _03558_ vssd1 vssd1 vccd1 vccd1 sky130_fd_sc_hd__diode_2
X_12148_ net934 _01494_ net718 vssd1 vssd1 vccd1 vccd1 FPGA_INST.cell3.CB_1.config_dataA\[10\]
+ sky130_fd_sc_hd__dfstp_1
XFILLER_69_549 vssd1 vssd1 vccd1 vccd1 sky130_fd_sc_hd__fill_8
XFILLER_2_53 vssd1 vssd1 vccd1 vccd1 sky130_fd_sc_hd__fill_1
XPHY_EDGE_ROW_10_Right_10 vssd1 vssd1 vccd1 vccd1 sky130_fd_sc_hd__decap_3
X_12079_ net848 _01425_ net633 vssd1 vssd1 vccd1 vccd1 FPGA_INST.cell2.SB0.route_sel\[119\]
+ sky130_fd_sc_hd__dfstp_1
XFILLER_92_541 vssd1 vssd1 vccd1 vccd1 sky130_fd_sc_hd__fill_2
X_06640_ net474 net475 vssd1 vssd1 vccd1 vccd1 _02916_ sky130_fd_sc_hd__and2b_1
XTAP_TAPCELL_ROW_48_953 vssd1 vccd1 sky130_fd_sc_hd__tapvpwrvgnd_1
XFILLER_24_107 vssd1 vssd1 vccd1 vccd1 sky130_fd_sc_hd__fill_1
X_06571_ net138 net127 net132 net103 FPGA_INST.cell2.LEI0.config_data\[18\] FPGA_INST.cell2.LEI0.config_data\[19\]
+ vssd1 vssd1 vccd1 vccd1 _02847_ sky130_fd_sc_hd__mux4_1
X_05522_ FPGA_INST.config_bits\[6\] FPGA_INST.config_bits\[1\] FPGA_INST.config_bits\[0\]
+ FPGA_INST.config_bits\[7\] vssd1 vssd1 vccd1 vccd1 _01804_ sky130_fd_sc_hd__or4b_1
X_09290_ FPGA_INST.cell1.SB0.route_sel\[61\] FPGA_INST.cell1.SB0.route_sel\[62\] net221
+ vssd1 vssd1 vccd1 vccd1 _00203_ sky130_fd_sc_hd__mux2_1
X_08310_ net73 net95 FPGA_INST.bus1_0\[2\] FPGA_INST.bus1_0\[3\] net445 net444 vssd1
+ vssd1 vccd1 vccd1 _04532_ sky130_fd_sc_hd__mux4_1
X_08241_ FPGA_INST.cell0.CB_1.config_dataA\[12\] _04457_ _04459_ _04464_ vssd1 vssd1
+ vccd1 vccd1 _04465_ sky130_fd_sc_hd__a31o_1
X_05453_ FPGA_INST.cell0.CB_0.config_dataA\[14\] vssd1 vssd1 vccd1 vccd1 _01735_ sky130_fd_sc_hd__inv_2
XFILLER_119_746 vssd1 vssd1 vccd1 vccd1 sky130_fd_sc_hd__fill_2
X_05384_ FPGA_INST.cell1.SB0.route_sel\[58\] vssd1 vssd1 vccd1 vccd1 _01666_ sky130_fd_sc_hd__inv_2
X_08172_ _03639_ _04382_ _04383_ _03604_ _01752_ vssd1 vssd1 vccd1 vccd1 _04396_ sky130_fd_sc_hd__a221o_1
XFILLER_118_234 vssd1 vssd1 vccd1 vccd1 sky130_fd_sc_hd__fill_2
XTAP_TAPCELL_ROW_95_1616 vssd1 vccd1 sky130_fd_sc_hd__tapvpwrvgnd_1
XFILLER_9_391 vssd1 vssd1 vccd1 vccd1 sky130_fd_sc_hd__fill_1
X_07123_ FPGA_INST.cell0.LE_0A.config_data\[15\] FPGA_INST.cell0.LE_0A.config_data\[14\]
+ _03313_ vssd1 vssd1 vccd1 vccd1 _03389_ sky130_fd_sc_hd__mux2_1
X_07054_ net431 _02350_ vssd1 vssd1 vccd1 vccd1 _03320_ sky130_fd_sc_hd__nand2_1
XANTENNA_fanout117_A FPGA_INST.cell0.CB_0.le_outA vssd1 vssd1 vccd1 vccd1 sky130_fd_sc_hd__diode_2
X_06005_ _01957_ _02209_ vssd1 vssd1 vccd1 vccd1 _02285_ sky130_fd_sc_hd__nor2_1
XFILLER_99_140 vssd1 vssd1 vccd1 vccd1 sky130_fd_sc_hd__fill_4
XANTENNA__10154__S net273 vssd1 vssd1 vccd1 vccd1 sky130_fd_sc_hd__diode_2
XFILLER_0_729 vssd1 vssd1 vccd1 vccd1 sky130_fd_sc_hd__fill_2
X_07956_ FPGA_INST.cell1.LE_0A.config_data\[7\] FPGA_INST.cell1.LE_0A.config_data\[6\]
+ _04148_ vssd1 vssd1 vccd1 vccd1 _04184_ sky130_fd_sc_hd__mux2_1
XFILLER_101_178 vssd1 vssd1 vccd1 vccd1 sky130_fd_sc_hd__fill_4
X_06907_ FPGA_INST.cell0.CB_0.config_dataB\[12\] _03174_ _03170_ FPGA_INST.cell0.CB_0.config_dataB\[13\]
+ _03172_ vssd1 vssd1 vccd1 vccd1 _03175_ sky130_fd_sc_hd__o2111a_1
X_07887_ net472 _03728_ vssd1 vssd1 vccd1 vccd1 _04115_ sky130_fd_sc_hd__nand2_1
XPHY_EDGE_ROW_106_Right_106 vssd1 vssd1 vccd1 vccd1 sky130_fd_sc_hd__decap_3
XANTENNA__08342__A2 FPGA_INST.bus1_0\[2\] vssd1 vssd1 vccd1 vccd1 sky130_fd_sc_hd__diode_2
XFILLER_55_221 vssd1 vssd1 vccd1 vccd1 sky130_fd_sc_hd__fill_2
XANTENNA__06587__B _02775_ vssd1 vssd1 vccd1 vccd1 sky130_fd_sc_hd__diode_2
XANTENNA_fanout653_A net662 vssd1 vssd1 vccd1 vccd1 sky130_fd_sc_hd__diode_2
X_09626_ FPGA_INST.cell0.SB0.route_sel\[29\] FPGA_INST.cell0.SB0.route_sel\[30\] net195
+ vssd1 vssd1 vccd1 vccd1 _00535_ sky130_fd_sc_hd__mux2_1
X_06838_ FPGA_INST.cell0.CB_0.config_dataB\[8\] FPGA_INST.cell0.CB_0.config_dataB\[7\]
+ vssd1 vssd1 vccd1 vccd1 _03106_ sky130_fd_sc_hd__or2_1
XANTENNA__06353__A1 net4 vssd1 vssd1 vccd1 vccd1 sky130_fd_sc_hd__diode_2
XANTENNA_fanout820_A net843 vssd1 vssd1 vccd1 vccd1 sky130_fd_sc_hd__diode_2
XTAP_TAPCELL_ROW_104_1734 vssd1 vccd1 sky130_fd_sc_hd__tapvpwrvgnd_1
X_09557_ FPGA_INST.cell1.LE_1A.config_data\[7\] FPGA_INST.cell1.LE_1A.config_data\[6\]
+ net333 vssd1 vssd1 vccd1 vccd1 _00466_ sky130_fd_sc_hd__mux2_1
XFILLER_70_224 vssd1 vssd1 vccd1 vccd1 sky130_fd_sc_hd__fill_2
X_06769_ FPGA_INST.cell2.CB_1.config_dataB\[13\] FPGA_INST.cell2.CB_1.config_dataB\[12\]
+ _03021_ vssd1 vssd1 vccd1 vccd1 _03043_ sky130_fd_sc_hd__or3b_1
XANTENNA__11282__Q FPGA_INST.cell0.SB0.config_data_out vssd1 vssd1 vccd1 vccd1 sky130_fd_sc_hd__diode_2
XTAP_TAPCELL_ROW_26_647 vssd1 vccd1 sky130_fd_sc_hd__tapvpwrvgnd_1
XANTENNA_fanout918_A net947 vssd1 vssd1 vccd1 vccd1 sky130_fd_sc_hd__diode_2
X_08508_ FPGA_INST.cell3.LEI0.config_data\[20\] _04719_ _04720_ FPGA_INST.cell3.CB_1.config_dataA\[9\]
+ vssd1 vssd1 vccd1 vccd1 _04721_ sky130_fd_sc_hd__o211a_1
X_09488_ FPGA_INST.cell1.LEI0.config_data\[34\] FPGA_INST.cell1.LEI0.config_data\[35\]
+ net214 vssd1 vssd1 vccd1 vccd1 _00400_ sky130_fd_sc_hd__mux2_1
XTAP_TAPCELL_ROW_104_1745 vssd1 vccd1 sky130_fd_sc_hd__tapvpwrvgnd_1
XANTENNA__07302__A0 net150 vssd1 vssd1 vccd1 vccd1 sky130_fd_sc_hd__diode_2
XFILLER_70_268 vssd1 vssd1 vccd1 vccd1 sky130_fd_sc_hd__fill_1
X_08439_ net151 net144 net149 net142 FPGA_INST.cell1.LEI0.config_data\[6\] FPGA_INST.cell1.LEI0.config_data\[7\]
+ vssd1 vssd1 vccd1 vccd1 _04657_ sky130_fd_sc_hd__mux4_1
XFILLER_24_685 vssd1 vssd1 vccd1 vccd1 sky130_fd_sc_hd__fill_4
XANTENNA__08307__B _03558_ vssd1 vssd1 vccd1 vccd1 sky130_fd_sc_hd__diode_2
XANTENNA__06656__A2 FPGA_INST.bus3_2\[2\] vssd1 vssd1 vccd1 vccd1 sky130_fd_sc_hd__diode_2
XFILLER_11_335 vssd1 vssd1 vccd1 vccd1 sky130_fd_sc_hd__fill_1
XFILLER_23_184 vssd1 vssd1 vccd1 vccd1 sky130_fd_sc_hd__fill_1
XFILLER_7_339 vssd1 vssd1 vccd1 vccd1 sky130_fd_sc_hd__fill_2
X_11450_ FPGA_INST.cell0.LE_1A.sel_clk _00800_ net732 vssd1 vssd1 vccd1 vccd1 FPGA_INST.cell0.LE_1A.dff1_out
+ sky130_fd_sc_hd__dfstp_1
X_10401_ FPGA_INST.cell3.LE_1B.dff0_out net525 _05246_ vssd1 vssd1 vccd1 vccd1 _01280_
+ sky130_fd_sc_hd__a21bo_1
XPHY_EDGE_ROW_12_Left_143 vssd1 vssd1 vccd1 vccd1 sky130_fd_sc_hd__decap_3
X_11381_ net747 _00731_ net532 vssd1 vssd1 vccd1 vccd1 FPGA_INST.cell0.LEI0.config_data\[2\]
+ sky130_fd_sc_hd__dfrtp_1
X_10332_ FPGA_INST.cell3.LEI0.config_data\[46\] FPGA_INST.cell3.CB_0.config_data_inA
+ net281 vssd1 vssd1 vccd1 vccd1 _01213_ sky130_fd_sc_hd__mux2_1
XTAP_TAPCELL_ROW_115_1896 vssd1 vccd1 sky130_fd_sc_hd__tapvpwrvgnd_1
XFILLER_105_462 vssd1 vssd1 vccd1 vccd1 sky130_fd_sc_hd__fill_2
XFILLER_105_440 vssd1 vssd1 vccd1 vccd1 sky130_fd_sc_hd__fill_1
X_12002_ net855 _01348_ net640 vssd1 vssd1 vccd1 vccd1 FPGA_INST.cell2.SB0.route_sel\[42\]
+ sky130_fd_sc_hd__dfstp_1
X_10263_ FPGA_INST.io_east_oeb\[14\] FPGA_INST.io_east_oeb\[16\] net257 vssd1 vssd1
+ vccd1 vccd1 _01144_ sky130_fd_sc_hd__mux2_1
XANTENNA__08030__A1 _03973_ vssd1 vssd1 vccd1 vccd1 sky130_fd_sc_hd__diode_2
X_10194_ FPGA_INST.cell3.SB0.route_sel\[98\] FPGA_INST.cell3.SB0.route_sel\[99\] net271
+ vssd1 vssd1 vccd1 vccd1 _01075_ sky130_fd_sc_hd__mux2_1
XANTENNA__08610__X _04819_ vssd1 vssd1 vccd1 vccd1 sky130_fd_sc_hd__diode_2
XANTENNA__09853__S net173 vssd1 vssd1 vccd1 vccd1 sky130_fd_sc_hd__diode_2
XFILLER_87_99 vssd1 vssd1 vccd1 vccd1 sky130_fd_sc_hd__fill_1
XTAP_TAPCELL_ROW_6_361 vssd1 vccd1 sky130_fd_sc_hd__tapvpwrvgnd_1
Xfanout381 _01830_ vssd1 vssd1 vccd1 vccd1 net381 sky130_fd_sc_hd__buf_4
Xfanout370 net372 vssd1 vssd1 vccd1 vccd1 net370 sky130_fd_sc_hd__clkbuf_4
XANTENNA__08869__A0 net25 vssd1 vssd1 vccd1 vccd1 sky130_fd_sc_hd__diode_2
Xfanout392 FPGA_INST.cell3.CB_0.config_dataB\[0\] vssd1 vssd1 vccd1 vccd1 net392 sky130_fd_sc_hd__buf_2
XTAP_TAPCELL_ROW_6_372 vssd1 vccd1 sky130_fd_sc_hd__tapvpwrvgnd_1
XPHY_EDGE_ROW_21_Left_152 vssd1 vssd1 vccd1 vccd1 sky130_fd_sc_hd__decap_3
XFILLER_46_221 vssd1 vssd1 vccd1 vccd1 sky130_fd_sc_hd__fill_4
XTAP_TAPCELL_ROW_66_1206 vssd1 vccd1 sky130_fd_sc_hd__tapvpwrvgnd_1
XTAP_TAPCELL_ROW_45_912 vssd1 vccd1 sky130_fd_sc_hd__tapvpwrvgnd_1
XFILLER_61_235 vssd1 vssd1 vccd1 vccd1 sky130_fd_sc_hd__fill_2
XFILLER_27_490 vssd1 vssd1 vccd1 vccd1 sky130_fd_sc_hd__fill_1
XFILLER_34_427 vssd1 vssd1 vccd1 vccd1 sky130_fd_sc_hd__fill_2
XFILLER_36_81 vssd1 vssd1 vccd1 vccd1 sky130_fd_sc_hd__fill_2
XFILLER_61_279 vssd1 vssd1 vccd1 vccd1 sky130_fd_sc_hd__fill_1
X_11717_ net920 _01063_ net704 vssd1 vssd1 vccd1 vccd1 FPGA_INST.cell3.SB0.route_sel\[87\]
+ sky130_fd_sc_hd__dfstp_1
XANTENNA__08217__B _03720_ vssd1 vssd1 vccd1 vccd1 sky130_fd_sc_hd__diode_2
XFILLER_42_493 vssd1 vssd1 vccd1 vccd1 sky130_fd_sc_hd__fill_2
Xinput12 gpio_in[1] vssd1 vssd1 vccd1 vccd1 net12 sky130_fd_sc_hd__clkbuf_1
X_11648_ net895 _00994_ net679 vssd1 vssd1 vccd1 vccd1 FPGA_INST.cell3.SB0.route_sel\[18\]
+ sky130_fd_sc_hd__dfstp_1
XANTENNA__05855__B1 FPGA_INST.bus1_0\[8\] vssd1 vssd1 vccd1 vccd1 sky130_fd_sc_hd__diode_2
XPHY_EDGE_ROW_30_Left_161 vssd1 vssd1 vccd1 vccd1 sky130_fd_sc_hd__decap_3
Xinput23 gpio_in[2] vssd1 vssd1 vccd1 vccd1 net23 sky130_fd_sc_hd__clkbuf_1
X_11579_ net778 _00929_ net558 vssd1 vssd1 vccd1 vccd1 FPGA_INST.cell0.CB_0.config_dataB\[23\]
+ sky130_fd_sc_hd__dfstp_1
XFILLER_128_587 vssd1 vssd1 vccd1 vccd1 sky130_fd_sc_hd__fill_1
XANTENNA__05857__A net112 vssd1 vssd1 vccd1 vccd1 sky130_fd_sc_hd__diode_2
XTAP_TAPCELL_ROW_77_1357 vssd1 vccd1 sky130_fd_sc_hd__tapvpwrvgnd_1
XFILLER_42_3 vssd1 vssd1 vccd1 vccd1 sky130_fd_sc_hd__fill_2
XTAP_TAPCELL_ROW_90_1546 vssd1 vccd1 sky130_fd_sc_hd__tapvpwrvgnd_1
X_08790_ FPGA_INST.cell3.CB_0.config_dataB\[8\] _01776_ FPGA_INST.cell3.CB_0.config_dataB\[9\]
+ _04975_ vssd1 vssd1 vccd1 vccd1 _04997_ sky130_fd_sc_hd__and4b_1
XFILLER_96_154 vccd1 vssd1 vccd1 vssd1 sky130_ef_sc_hd__decap_40_12
X_07810_ FPGA_INST.cell3.SB0.route_sel\[120\] FPGA_INST.cell3.SB0.route_sel\[121\]
+ _04055_ _04058_ net366 vssd1 vssd1 vccd1 vccd1 _04059_ sky130_fd_sc_hd__a311o_4
XFILLER_111_498 vssd1 vssd1 vccd1 vccd1 sky130_fd_sc_hd__fill_4
X_07741_ _03496_ _03911_ vssd1 vssd1 vccd1 vccd1 _03991_ sky130_fd_sc_hd__or2_1
XANTENNA__06583__B2 _02840_ vssd1 vssd1 vccd1 vccd1 sky130_fd_sc_hd__diode_2
XANTENNA__06583__A1 _02843_ vssd1 vssd1 vccd1 vccd1 sky130_fd_sc_hd__diode_2
XANTENNA__08324__A2 _03997_ vssd1 vssd1 vccd1 vccd1 sky130_fd_sc_hd__diode_2
XFILLER_38_755 vssd1 vssd1 vccd1 vccd1 sky130_fd_sc_hd__fill_1
XFILLER_80_500 vssd1 vssd1 vccd1 vccd1 sky130_fd_sc_hd__fill_2
X_07672_ _03920_ _03921_ _03922_ _01933_ _01925_ vssd1 vssd1 vccd1 vccd1 _03924_ sky130_fd_sc_hd__a311o_1
XFILLER_37_254 vssd1 vssd1 vccd1 vccd1 sky130_fd_sc_hd__fill_4
XFILLER_38_777 vssd1 vssd1 vccd1 vccd1 sky130_fd_sc_hd__fill_2
XFILLER_92_393 vssd1 vssd1 vccd1 vccd1 sky130_fd_sc_hd__fill_4
XFILLER_80_533 vssd1 vssd1 vccd1 vccd1 sky130_fd_sc_hd__fill_8
X_06623_ net478 _02814_ vssd1 vssd1 vccd1 vccd1 _02899_ sky130_fd_sc_hd__nand2_1
X_09411_ FPGA_INST.cell2.CB_1.config_dataA\[4\] net481 net261 vssd1 vssd1 vccd1 vccd1
+ _00324_ sky130_fd_sc_hd__mux2_1
X_09342_ FPGA_INST.cell1.SB0.route_sel\[114\] FPGA_INST.cell1.SB0.route_sel\[113\]
+ net342 vssd1 vssd1 vccd1 vccd1 _00255_ sky130_fd_sc_hd__mux2_1
X_06554_ FPGA_INST.cell2.SB0.route_sel\[92\] FPGA_INST.cell2.SB0.route_sel\[93\] vssd1
+ vssd1 vccd1 vccd1 _02830_ sky130_fd_sc_hd__nor2_1
X_05505_ net153 vssd1 vssd1 vccd1 vccd1 _01787_ sky130_fd_sc_hd__inv_2
XTAP_TAPCELL_ROW_23_606 vssd1 vccd1 sky130_fd_sc_hd__tapvpwrvgnd_1
XANTENNA_fanout234_A _01831_ vssd1 vssd1 vccd1 vccd1 sky130_fd_sc_hd__diode_2
X_09273_ FPGA_INST.cell1.SB0.route_sel\[44\] FPGA_INST.cell1.SB0.route_sel\[45\] net207
+ vssd1 vssd1 vccd1 vccd1 _00186_ sky130_fd_sc_hd__mux2_1
X_06485_ _02761_ _02762_ _02652_ vssd1 vssd1 vccd1 vccd1 _02763_ sky130_fd_sc_hd__mux2_1
X_05436_ FPGA_INST.cell3.SB0.route_sel\[1\] vssd1 vssd1 vccd1 vccd1 _01718_ sky130_fd_sc_hd__inv_2
X_08224_ _03465_ _04443_ _04444_ _03408_ FPGA_INST.cell0.CB_1.config_dataA\[12\] vssd1
+ vssd1 vccd1 vccd1 _04448_ sky130_fd_sc_hd__a221o_1
XFILLER_21_677 vssd1 vssd1 vccd1 vccd1 sky130_fd_sc_hd__fill_4
X_08155_ FPGA_INST.cell1.LE_0B.config_data\[16\] _04378_ _04379_ net155 vssd1 vssd1
+ vccd1 vccd1 FPGA_INST.cell1.CB_0.le_outB sky130_fd_sc_hd__o211a_1
XANTENNA_fanout401_A FPGA_INST.cell3.CB_0.config_dataA\[0\] vssd1 vssd1 vccd1 vccd1
+ sky130_fd_sc_hd__diode_2
X_05367_ FPGA_INST.cell3.SB0.route_sel\[78\] vssd1 vssd1 vccd1 vccd1 _01649_ sky130_fd_sc_hd__inv_2
X_07106_ _01984_ _03352_ _03353_ _01937_ vssd1 vssd1 vccd1 vccd1 _03372_ sky130_fd_sc_hd__a22o_1
X_08086_ net455 _03889_ vssd1 vssd1 vccd1 vccd1 _04312_ sky130_fd_sc_hd__nand2_1
X_05298_ FPGA_INST.cell2.SB0.route_sel\[104\] vssd1 vssd1 vccd1 vccd1 _01580_ sky130_fd_sc_hd__inv_2
X_07037_ FPGA_INST.bus2_0\[5\] _03282_ _03302_ net435 vssd1 vssd1 vccd1 vccd1 _03303_
+ sky130_fd_sc_hd__a22o_1
XFILLER_121_229 vssd1 vssd1 vccd1 vccd1 sky130_fd_sc_hd__fill_2
XANTENNA__08012__A1 FPGA_INST.bus3_1\[1\] vssd1 vssd1 vccd1 vccd1 sky130_fd_sc_hd__diode_2
XFILLER_102_421 vccd1 vssd1 vccd1 vssd1 sky130_ef_sc_hd__decap_40_12
XFILLER_88_633 vssd1 vssd1 vccd1 vccd1 sky130_fd_sc_hd__fill_1
XANTENNA_fanout770_A net772 vssd1 vssd1 vccd1 vccd1 sky130_fd_sc_hd__diode_2
Xteam_15_951 vssd1 vssd1 vccd1 vccd1 team_15_951/HI gpio_oeb[10] sky130_fd_sc_hd__conb_1
XFILLER_102_454 vssd1 vssd1 vccd1 vccd1 sky130_fd_sc_hd__fill_1
XFILLER_48_508 vssd1 vssd1 vccd1 vccd1 sky130_fd_sc_hd__fill_4
Xteam_15_973 vssd1 vssd1 vccd1 vccd1 gpio_oeb[7] team_15_973/LO sky130_fd_sc_hd__conb_1
Xteam_15_962 vssd1 vssd1 vccd1 vccd1 team_15_962/HI gpio_oeb[32] sky130_fd_sc_hd__conb_1
XANTENNA_fanout868_A net892 vssd1 vssd1 vccd1 vccd1 sky130_fd_sc_hd__diode_2
XFILLER_130_785 vssd1 vssd1 vccd1 vccd1 sky130_fd_sc_hd__fill_4
XFILLER_102_465 vssd1 vssd1 vccd1 vccd1 sky130_fd_sc_hd__fill_8
X_08988_ _03642_ _03647_ _03649_ _05165_ vssd1 vssd1 vccd1 vccd1 FPGA_INST.bus1_0\[5\]
+ sky130_fd_sc_hd__o211a_2
XFILLER_88_699 vssd1 vssd1 vccd1 vccd1 sky130_fd_sc_hd__fill_1
XTAP_TAPCELL_ROW_3_320 vssd1 vccd1 sky130_fd_sc_hd__tapvpwrvgnd_1
X_07939_ net466 net465 _03769_ _01725_ vssd1 vssd1 vccd1 vccd1 _04167_ sky130_fd_sc_hd__o31a_1
XTAP_TAPCELL_ROW_3_331 vssd1 vccd1 sky130_fd_sc_hd__tapvpwrvgnd_1
XANTENNA__08315__A2 _03682_ vssd1 vssd1 vccd1 vccd1 sky130_fd_sc_hd__diode_2
X_10950_ net864 _00300_ net649 vssd1 vssd1 vccd1 vccd1 FPGA_INST.cell2.CB_0.config_dataB\[6\]
+ sky130_fd_sc_hd__dfstp_1
X_10881_ net798 _00231_ net583 vssd1 vssd1 vccd1 vccd1 FPGA_INST.cell1.SB0.route_sel\[90\]
+ sky130_fd_sc_hd__dfstp_1
X_09609_ FPGA_INST.cell0.SB0.route_sel\[13\] FPGA_INST.cell0.SB0.route_sel\[12\] net323
+ vssd1 vssd1 vccd1 vccd1 _00518_ sky130_fd_sc_hd__mux2_1
XANTENNA__08079__A1 FPGA_INST.bus3_1\[5\] vssd1 vssd1 vccd1 vccd1 sky130_fd_sc_hd__diode_2
XANTENNA__09276__A0 FPGA_INST.cell1.SB0.route_sel\[48\] vssd1 vssd1 vccd1 vccd1 sky130_fd_sc_hd__diode_2
XFILLER_12_600 vssd1 vssd1 vccd1 vccd1 sky130_fd_sc_hd__fill_1
XANTENNA__08037__B _03568_ vssd1 vssd1 vccd1 vccd1 sky130_fd_sc_hd__diode_2
XTAP_TAPCELL_ROW_61_1136 vssd1 vccd1 sky130_fd_sc_hd__tapvpwrvgnd_1
XANTENNA__08752__S _04860_ vssd1 vssd1 vccd1 vccd1 sky130_fd_sc_hd__diode_2
X_11502_ net763 _00852_ net548 vssd1 vssd1 vccd1 vccd1 FPGA_INST.cell0.CB_1.config_dataB\[8\]
+ sky130_fd_sc_hd__dfstp_1
XTAP_TAPCELL_ROW_117_1914 vssd1 vccd1 sky130_fd_sc_hd__tapvpwrvgnd_1
XANTENNA__07876__B _04049_ vssd1 vssd1 vccd1 vccd1 sky130_fd_sc_hd__diode_2
XTAP_TAPCELL_ROW_50_981 vssd1 vccd1 sky130_fd_sc_hd__tapvpwrvgnd_1
X_11433_ net775 _00783_ net561 vssd1 vssd1 vccd1 vccd1 FPGA_INST.cell0.LE_0A.config_data\[4\]
+ sky130_fd_sc_hd__dfrtp_1
XFILLER_22_50 vssd1 vssd1 vccd1 vccd1 sky130_fd_sc_hd__fill_1
XTAP_TAPCELL_ROW_117_1925 vssd1 vccd1 sky130_fd_sc_hd__tapvpwrvgnd_1
X_11364_ net835 _00714_ net619 vssd1 vssd1 vccd1 vccd1 FPGA_INST.cell1.LE_1B.config_data\[6\]
+ sky130_fd_sc_hd__dfrtp_1
XANTENNA__08251__A1 _03759_ vssd1 vssd1 vccd1 vccd1 sky130_fd_sc_hd__diode_2
XANTENNA__08251__B2 _03797_ vssd1 vssd1 vccd1 vccd1 sky130_fd_sc_hd__diode_2
X_10315_ FPGA_INST.cell3.LEI0.config_data\[29\] FPGA_INST.cell3.LEI0.config_data\[30\]
+ net298 vssd1 vssd1 vccd1 vccd1 _01196_ sky130_fd_sc_hd__mux2_1
X_11295_ net832 _00645_ net616 vssd1 vssd1 vccd1 vccd1 FPGA_INST.cell1.CB_0.config_dataA\[12\]
+ sky130_fd_sc_hd__dfstp_2
X_10246_ FPGA_INST.io_south_oeb\[12\] FPGA_INST.io_south_oeb\[14\] net290 vssd1 vssd1
+ vccd1 vccd1 _01127_ sky130_fd_sc_hd__mux2_1
XFILLER_79_666 vssd1 vssd1 vccd1 vccd1 sky130_fd_sc_hd__fill_4
X_10177_ FPGA_INST.cell3.SB0.route_sel\[81\] FPGA_INST.cell3.SB0.route_sel\[82\] net286
+ vssd1 vssd1 vccd1 vccd1 _01058_ sky130_fd_sc_hd__mux2_1
XFILLER_78_187 vssd1 vssd1 vccd1 vccd1 sky130_fd_sc_hd__fill_8
XTAP_TAPCELL_ROW_72_1287 vssd1 vccd1 sky130_fd_sc_hd__tapvpwrvgnd_1
XFILLER_39_519 vssd1 vssd1 vccd1 vccd1 sky130_fd_sc_hd__fill_8
XANTENNA__10649__A0 FPGA_INST.cell3.LE_1B.reset_val vssd1 vssd1 vccd1 vccd1 sky130_fd_sc_hd__diode_2
XANTENNA__07109__A3 FPGA_INST.bus2_0\[11\] vssd1 vssd1 vccd1 vccd1 sky130_fd_sc_hd__diode_2
XFILLER_35_703 vssd1 vssd1 vccd1 vccd1 sky130_fd_sc_hd__fill_2
XANTENNA__07514__B1 _03769_ vssd1 vssd1 vccd1 vccd1 sky130_fd_sc_hd__diode_2
XFILLER_74_371 vssd1 vssd1 vccd1 vccd1 sky130_fd_sc_hd__fill_4
XFILLER_62_511 vssd1 vssd1 vccd1 vccd1 sky130_fd_sc_hd__fill_2
XANTENNA__06868__A2 FPGA_INST.bus2_0\[13\] vssd1 vssd1 vccd1 vccd1 sky130_fd_sc_hd__diode_2
XANTENNA__09267__A0 FPGA_INST.cell1.SB0.route_sel\[39\] vssd1 vssd1 vccd1 vccd1 sky130_fd_sc_hd__diode_2
X_06270_ _02548_ _02549_ _01533_ vssd1 vssd1 vccd1 vccd1 _02550_ sky130_fd_sc_hd__mux2_1
XFILLER_30_474 vssd1 vssd1 vccd1 vccd1 sky130_fd_sc_hd__fill_2
XFILLER_8_85 vssd1 vssd1 vccd1 vccd1 sky130_fd_sc_hd__fill_2
XFILLER_30_485 vssd1 vssd1 vccd1 vccd1 sky130_fd_sc_hd__fill_1
X_09960_ FPGA_INST.cell0.CB_1.config_dataB\[20\] FPGA_INST.cell0.CB_1.config_dataB\[21\]
+ net188 vssd1 vssd1 vccd1 vccd1 _00865_ sky130_fd_sc_hd__mux2_1
X_08911_ FPGA_INST.cell3.SB0.route_sel\[118\] FPGA_INST.cell3.SB0.route_sel\[119\]
+ vssd1 vssd1 vccd1 vccd1 _05114_ sky130_fd_sc_hd__nor2_1
X_09891_ FPGA_INST.cell0.LE_0A.reset_val FPGA_INST.cell0.LE_0A.reset_mode net177 vssd1
+ vssd1 vccd1 vccd1 _00798_ sky130_fd_sc_hd__mux2_1
XANTENNA__05593__Y _01873_ vssd1 vssd1 vccd1 vccd1 sky130_fd_sc_hd__diode_2
X_08842_ net388 _04785_ vssd1 vssd1 vccd1 vccd1 _05049_ sky130_fd_sc_hd__nand2_1
XFILLER_57_316 vssd1 vssd1 vccd1 vccd1 sky130_fd_sc_hd__fill_8
X_08773_ _04978_ _04979_ FPGA_INST.cell3.CB_0.config_dataB\[7\] vssd1 vssd1 vccd1
+ vccd1 _04980_ sky130_fd_sc_hd__mux2_1
X_05985_ net116 net169 _02173_ _02258_ vssd1 vssd1 vccd1 vccd1 _02265_ sky130_fd_sc_hd__a31o_1
X_07724_ FPGA_INST.cell3.SB0.route_sel\[109\] FPGA_INST.cell3.SB0.route_sel\[108\]
+ _03967_ _03974_ vssd1 vssd1 vccd1 vccd1 _03975_ sky130_fd_sc_hd__a211o_1
X_07655_ FPGA_INST.cell3.CB_1.config_dataA\[23\] FPGA_INST.cell3.CB_1.config_dataA\[22\]
+ vssd1 vssd1 vccd1 vccd1 _03907_ sky130_fd_sc_hd__nand2_2
XFILLER_92_190 vssd1 vssd1 vccd1 vccd1 sky130_fd_sc_hd__fill_4
X_06606_ FPGA_INST.cell2.CB_1.config_dataA\[11\] net478 vssd1 vssd1 vccd1 vccd1 _02882_
+ sky130_fd_sc_hd__nor2_1
XANTENNA_fanout351_A net355 vssd1 vssd1 vccd1 vccd1 sky130_fd_sc_hd__diode_2
XFILLER_80_363 vssd1 vssd1 vccd1 vccd1 sky130_fd_sc_hd__fill_1
X_07586_ _03837_ _03838_ _03839_ _02027_ vssd1 vssd1 vccd1 vccd1 _03840_ sky130_fd_sc_hd__a31o_2
XFILLER_43_38 vssd1 vssd1 vccd1 vccd1 sky130_fd_sc_hd__fill_2
XTAP_TAPCELL_ROW_36_786 vssd1 vccd1 sky130_fd_sc_hd__tapvpwrvgnd_1
X_09325_ FPGA_INST.cell1.SB0.route_sel\[97\] FPGA_INST.cell1.SB0.route_sel\[96\] net343
+ vssd1 vssd1 vccd1 vccd1 _00238_ sky130_fd_sc_hd__mux2_1
X_06537_ _01584_ FPGA_INST.cell2.SB0.route_sel\[121\] FPGA_INST.cell2.SB0.route_sel\[126\]
+ _01587_ _02812_ vssd1 vssd1 vccd1 vccd1 _02813_ sky130_fd_sc_hd__a221o_1
X_09256_ FPGA_INST.cell1.SB0.route_sel\[27\] FPGA_INST.cell1.SB0.route_sel\[28\] net220
+ vssd1 vssd1 vccd1 vccd1 _00169_ sky130_fd_sc_hd__mux2_1
X_06468_ net488 _01914_ vssd1 vssd1 vccd1 vccd1 _02746_ sky130_fd_sc_hd__nand2_1
X_08207_ _03959_ _04413_ _04414_ _03923_ _04430_ vssd1 vssd1 vccd1 vccd1 _04431_ sky130_fd_sc_hd__a221o_1
X_05419_ FPGA_INST.cell0.SB0.route_sel\[31\] vssd1 vssd1 vccd1 vccd1 _01701_ sky130_fd_sc_hd__inv_2
XFILLER_21_496 vssd1 vssd1 vccd1 vccd1 sky130_fd_sc_hd__fill_1
XFILLER_119_351 vssd1 vssd1 vccd1 vccd1 sky130_fd_sc_hd__fill_1
X_09187_ FPGA_INST.cell2.LE_1A.config_data\[5\] FPGA_INST.cell2.LE_1A.config_data\[4\]
+ net361 vssd1 vssd1 vccd1 vccd1 _00100_ sky130_fd_sc_hd__mux2_1
X_06399_ _02010_ _02655_ _02656_ _01966_ vssd1 vssd1 vccd1 vccd1 _02677_ sky130_fd_sc_hd__a22o_1
X_08138_ net152 net144 FPGA_INST.cell1.CB_1.le_outA net143 FPGA_INST.cell1.LEI0.config_data\[39\]
+ FPGA_INST.cell1.LEI0.config_data\[40\] vssd1 vssd1 vccd1 vccd1 _04364_ sky130_fd_sc_hd__mux4_1
XANTENNA__08233__B2 _03923_ vssd1 vssd1 vccd1 vccd1 sky130_fd_sc_hd__diode_2
XANTENNA__08233__A1 _03959_ vssd1 vssd1 vccd1 vccd1 sky130_fd_sc_hd__diode_2
XFILLER_107_557 vssd1 vssd1 vccd1 vccd1 sky130_fd_sc_hd__fill_2
X_08069_ FPGA_INST.cell1.LEI0.config_data\[5\] _04294_ vssd1 vssd1 vccd1 vccd1 _04295_
+ sky130_fd_sc_hd__nand2b_1
XTAP_TAPCELL_ROW_8_401 vssd1 vccd1 sky130_fd_sc_hd__tapvpwrvgnd_1
X_11080_ net834 _00430_ net618 vssd1 vssd1 vccd1 vccd1 FPGA_INST.cell1.LE_0A.config_data\[15\]
+ sky130_fd_sc_hd__dfrtp_1
XTAP_TAPCELL_ROW_112_1844 vssd1 vccd1 sky130_fd_sc_hd__tapvpwrvgnd_1
X_10100_ FPGA_INST.cell3.SB0.route_sel\[5\] FPGA_INST.cell3.SB0.route_sel\[4\] net365
+ vssd1 vssd1 vccd1 vccd1 _00981_ sky130_fd_sc_hd__mux2_1
XTAP_TAPCELL_ROW_112_1855 vssd1 vccd1 sky130_fd_sc_hd__tapvpwrvgnd_1
X_10031_ net421 net420 net190 vssd1 vssd1 vccd1 vccd1 _00912_ sky130_fd_sc_hd__mux2_1
XFILLER_103_796 vssd1 vssd1 vccd1 vccd1 sky130_fd_sc_hd__fill_2
XANTENNA__05944__B _01825_ vssd1 vssd1 vccd1 vccd1 sky130_fd_sc_hd__diode_2
XFILLER_0_389 vssd1 vssd1 vccd1 vccd1 sky130_fd_sc_hd__fill_2
XFILLER_124_85 vssd1 vssd1 vccd1 vccd1 sky130_fd_sc_hd__fill_4
XFILLER_29_552 vssd1 vssd1 vccd1 vccd1 sky130_fd_sc_hd__fill_1
XFILLER_90_138 vssd1 vssd1 vccd1 vccd1 sky130_fd_sc_hd__fill_2
XANTENNA__07504__X _03760_ vssd1 vssd1 vccd1 vccd1 sky130_fd_sc_hd__diode_2
X_11982_ net844 _01328_ net629 vssd1 vssd1 vccd1 vccd1 FPGA_INST.cell2.SB0.route_sel\[22\]
+ sky130_fd_sc_hd__dfstp_1
XFILLER_29_596 vssd1 vssd1 vccd1 vccd1 sky130_fd_sc_hd__fill_2
XANTENNA__06775__B _02832_ vssd1 vssd1 vccd1 vccd1 sky130_fd_sc_hd__diode_2
X_10933_ net846 _00283_ net631 vssd1 vssd1 vccd1 vccd1 FPGA_INST.cell2.CB_0.config_dataA\[14\]
+ sky130_fd_sc_hd__dfstp_1
X_10864_ net795 _00214_ net580 vssd1 vssd1 vccd1 vccd1 FPGA_INST.cell1.SB0.route_sel\[73\]
+ sky130_fd_sc_hd__dfstp_1
X_10795_ net824 _00145_ net608 vssd1 vssd1 vccd1 vccd1 FPGA_INST.cell1.SB0.route_sel\[4\]
+ sky130_fd_sc_hd__dfstp_1
XFILLER_40_772 vssd1 vssd1 vccd1 vccd1 sky130_fd_sc_hd__fill_1
XANTENNA__08224__B2 _03408_ vssd1 vssd1 vccd1 vccd1 sky130_fd_sc_hd__diode_2
XANTENNA__08224__A1 _03465_ vssd1 vssd1 vccd1 vccd1 sky130_fd_sc_hd__diode_2
X_11416_ net751 _00766_ net536 vssd1 vssd1 vccd1 vccd1 FPGA_INST.cell0.LEI0.config_data\[37\]
+ sky130_fd_sc_hd__dfrtp_1
X_11347_ net793 _00697_ net578 vssd1 vssd1 vccd1 vccd1 FPGA_INST.cell1.CB_1.config_dataA\[14\]
+ sky130_fd_sc_hd__dfstp_1
XTAP_TAPCELL_ROW_74_1316 vssd1 vccd1 sky130_fd_sc_hd__tapvpwrvgnd_1
XFILLER_125_376 vssd1 vssd1 vccd1 vccd1 sky130_fd_sc_hd__fill_4
XANTENNA__06786__A1 _02819_ vssd1 vssd1 vccd1 vccd1 sky130_fd_sc_hd__diode_2
X_11278_ net786 _00628_ net571 vssd1 vssd1 vccd1 vccd1 FPGA_INST.cell0.SB0.route_sel\[123\]
+ sky130_fd_sc_hd__dfstp_1
XFILLER_94_400 vccd1 vssd1 vccd1 vssd1 sky130_ef_sc_hd__decap_40_12
XFILLER_79_463 vssd1 vssd1 vccd1 vccd1 sky130_fd_sc_hd__fill_1
X_10229_ FPGA_INST.io_west_oeb\[10\] FPGA_INST.io_west_oeb\[12\] net291 vssd1 vssd1
+ vccd1 vccd1 _01110_ sky130_fd_sc_hd__mux2_1
XANTENNA__06002__A3 _02281_ vssd1 vssd1 vccd1 vccd1 sky130_fd_sc_hd__diode_2
XANTENNA__05746__C1 net314 vssd1 vssd1 vccd1 vccd1 sky130_fd_sc_hd__diode_2
XFILLER_39_349 vssd1 vssd1 vccd1 vccd1 sky130_fd_sc_hd__fill_4
XFILLER_82_628 vssd1 vssd1 vccd1 vccd1 sky130_fd_sc_hd__fill_8
X_05770_ net126 net11 _02047_ vssd1 vssd1 vccd1 vccd1 _02050_ sky130_fd_sc_hd__mux2_1
XTAP_TAPCELL_ROW_85_1467 vssd1 vccd1 sky130_fd_sc_hd__tapvpwrvgnd_1
X_07440_ _03532_ _03622_ vssd1 vssd1 vccd1 vccd1 _03698_ sky130_fd_sc_hd__or2_1
XTAP_TAPCELL_ROW_85_1478 vssd1 vccd1 sky130_fd_sc_hd__tapvpwrvgnd_1
XFILLER_62_363 vssd1 vssd1 vccd1 vccd1 sky130_fd_sc_hd__fill_1
XPHY_EDGE_ROW_8_Right_8 vssd1 vssd1 vccd1 vccd1 sky130_fd_sc_hd__decap_3
XFILLER_22_205 vssd1 vssd1 vccd1 vccd1 sky130_fd_sc_hd__fill_1
X_07371_ _03630_ _03628_ vssd1 vssd1 vccd1 vccd1 FPGA_INST.bus3_2\[4\] sky130_fd_sc_hd__and2b_4
XTAP_TAPCELL_ROW_33_745 vssd1 vccd1 sky130_fd_sc_hd__tapvpwrvgnd_1
X_06322_ FPGA_INST.cell2.CB_0.config_dataA\[19\] _02575_ vssd1 vssd1 vccd1 vccd1 _02602_
+ sky130_fd_sc_hd__nand2_1
X_09110_ FPGA_INST.cell2.LEI0.config_data\[24\] FPGA_INST.cell2.LEI0.config_data\[25\]
+ net256 vssd1 vssd1 vccd1 vccd1 _00026_ sky130_fd_sc_hd__mux2_1
X_09041_ net834 FPGA_INST.cell1.LE_0A.edge_mode vssd1 vssd1 vccd1 vccd1 FPGA_INST.cell1.LE_0A.sel_clk
+ sky130_fd_sc_hd__xnor2_1
XFILLER_31_794 vssd1 vssd1 vccd1 vccd1 sky130_fd_sc_hd__fill_4
XFILLER_129_671 vssd1 vssd1 vccd1 vccd1 sky130_fd_sc_hd__fill_1
XANTENNA__08405__B _03720_ vssd1 vssd1 vccd1 vccd1 sky130_fd_sc_hd__diode_2
X_06253_ FPGA_INST.cell2.CB_0.config_dataA\[4\] _02505_ vssd1 vssd1 vccd1 vccd1 _02533_
+ sky130_fd_sc_hd__nand2_1
X_06184_ _01723_ FPGA_INST.cell0.SB0.route_sel\[4\] _01724_ FPGA_INST.cell0.SB0.route_sel\[7\]
+ _02463_ vssd1 vssd1 vccd1 vccd1 _02464_ sky130_fd_sc_hd__a221o_1
XANTENNA__08215__A1 net119 vssd1 vssd1 vccd1 vccd1 sky130_fd_sc_hd__diode_2
XFILLER_128_192 vssd1 vssd1 vccd1 vccd1 sky130_fd_sc_hd__fill_1
XFILLER_116_365 vssd1 vssd1 vccd1 vccd1 sky130_fd_sc_hd__fill_4
XANTENNA__08124__C _03769_ vssd1 vssd1 vccd1 vccd1 sky130_fd_sc_hd__diode_2
XANTENNA__11450__SET_B net732 vssd1 vssd1 vccd1 vccd1 sky130_fd_sc_hd__diode_2
XFILLER_89_238 vssd1 vssd1 vccd1 vccd1 sky130_fd_sc_hd__fill_2
Xmax_cap164 _01990_ vssd1 vssd1 vccd1 vccd1 net164 sky130_fd_sc_hd__clkbuf_2
XFILLER_1_109 vssd1 vssd1 vccd1 vccd1 sky130_fd_sc_hd__fill_2
Xfanout914 net917 vssd1 vssd1 vccd1 vccd1 net914 sky130_fd_sc_hd__clkbuf_2
Xfanout903 net904 vssd1 vssd1 vccd1 vccd1 net903 sky130_fd_sc_hd__clkbuf_2
Xfanout925 net926 vssd1 vssd1 vccd1 vccd1 net925 sky130_fd_sc_hd__clkbuf_2
X_09943_ FPGA_INST.cell0.CB_1.config_dataB\[3\] FPGA_INST.cell0.CB_1.config_dataB\[4\]
+ net203 vssd1 vssd1 vccd1 vccd1 _00848_ sky130_fd_sc_hd__mux2_1
XPHY_EDGE_ROW_39_Right_39 vssd1 vssd1 vccd1 vccd1 sky130_fd_sc_hd__decap_3
Xfanout947 net1 vssd1 vssd1 vccd1 vccd1 net947 sky130_fd_sc_hd__clkbuf_4
Xfanout936 net946 vssd1 vssd1 vccd1 vccd1 net936 sky130_fd_sc_hd__clkbuf_2
X_09874_ FPGA_INST.cell0.LE_0A.config_data\[1\] FPGA_INST.cell0.LE_0A.config_data\[2\]
+ net190 vssd1 vssd1 vccd1 vccd1 _00781_ sky130_fd_sc_hd__mux2_1
XFILLER_38_27 vssd1 vssd1 vccd1 vccd1 sky130_fd_sc_hd__fill_1
X_08825_ FPGA_INST.cell3.CB_0.config_dataB\[4\] _05027_ _05031_ vssd1 vssd1 vccd1
+ vccd1 _05032_ sky130_fd_sc_hd__o21ai_4
XFILLER_97_293 vssd1 vssd1 vccd1 vccd1 sky130_fd_sc_hd__fill_1
XFILLER_57_113 vssd1 vssd1 vccd1 vccd1 sky130_fd_sc_hd__fill_1
XFILLER_38_38 vccd1 vssd1 vccd1 vssd1 sky130_ef_sc_hd__decap_40_12
XTAP_TAPCELL_ROW_127_2062 vssd1 vccd1 sky130_fd_sc_hd__tapvpwrvgnd_1
XFILLER_100_755 vssd1 vssd1 vccd1 vccd1 sky130_fd_sc_hd__fill_1
XANTENNA_fanout566_A net575 vssd1 vssd1 vccd1 vccd1 sky130_fd_sc_hd__diode_2
XANTENNA__08567__S FPGA_INST.cell3.LE_1B.reset_val vssd1 vssd1 vccd1 vccd1 sky130_fd_sc_hd__diode_2
X_08756_ FPGA_INST.cell3.LE_0A.config_data\[13\] FPGA_INST.cell3.LE_0A.config_data\[12\]
+ _04860_ vssd1 vssd1 vccd1 vccd1 _04965_ sky130_fd_sc_hd__mux2_1
XANTENNA__08794__C _04821_ vssd1 vssd1 vccd1 vccd1 sky130_fd_sc_hd__diode_2
X_05968_ net123 net7 _02246_ vssd1 vssd1 vccd1 vccd1 _02248_ sky130_fd_sc_hd__mux2_1
X_08687_ net396 FPGA_INST.cell3.CB_0.config_dataA\[10\] vssd1 vssd1 vccd1 vccd1 _04896_
+ sky130_fd_sc_hd__and2b_1
XANTENNA_fanout733_A net29 vssd1 vssd1 vccd1 vccd1 sky130_fd_sc_hd__diode_2
XFILLER_81_650 vssd1 vssd1 vccd1 vccd1 sky130_fd_sc_hd__fill_2
XANTENNA_fanout354_X net354 vssd1 vssd1 vccd1 vccd1 sky130_fd_sc_hd__diode_2
X_05899_ net170 net159 vssd1 vssd1 vccd1 vccd1 _02179_ sky130_fd_sc_hd__nor2_1
X_07707_ _01622_ FPGA_INST.cell0.SB0.route_sel\[105\] FPGA_INST.cell0.SB0.route_sel\[110\]
+ _01624_ _03957_ vssd1 vssd1 vccd1 vccd1 _03958_ sky130_fd_sc_hd__a221o_1
XFILLER_26_555 vssd1 vssd1 vccd1 vccd1 sky130_fd_sc_hd__fill_1
XANTENNA__07338__A_N net154 vssd1 vssd1 vccd1 vccd1 sky130_fd_sc_hd__diode_2
X_07638_ FPGA_INST.cell3.SB0.route_sel\[93\] FPGA_INST.cell3.SB0.route_sel\[92\] _03871_
+ _03890_ _03883_ vssd1 vssd1 vccd1 vccd1 _03891_ sky130_fd_sc_hd__a221o_1
XFILLER_14_739 vssd1 vssd1 vccd1 vccd1 sky130_fd_sc_hd__fill_8
XFILLER_110_43 vssd1 vssd1 vccd1 vccd1 sky130_fd_sc_hd__fill_1
X_07569_ net89 _03821_ _03823_ vssd1 vssd1 vccd1 vccd1 _03824_ sky130_fd_sc_hd__o21ba_1
XFILLER_81_694 vccd1 vssd1 vccd1 vssd1 sky130_ef_sc_hd__decap_40_12
XPHY_EDGE_ROW_48_Right_48 vssd1 vssd1 vccd1 vccd1 sky130_fd_sc_hd__decap_3
X_09308_ FPGA_INST.cell1.SB0.route_sel\[80\] FPGA_INST.cell1.SB0.route_sel\[79\] net327
+ vssd1 vssd1 vccd1 vccd1 _00221_ sky130_fd_sc_hd__mux2_1
XANTENNA__09398__S net357 vssd1 vssd1 vccd1 vccd1 sky130_fd_sc_hd__diode_2
X_10580_ FPGA_INST.cell3.CB_0.config_dataA\[24\] net392 net276 vssd1 vssd1 vccd1 vccd1
+ _01459_ sky130_fd_sc_hd__mux2_1
X_09239_ FPGA_INST.cell1.SB0.route_sel\[10\] FPGA_INST.cell1.SB0.route_sel\[11\] net221
+ vssd1 vssd1 vccd1 vccd1 _00152_ sky130_fd_sc_hd__mux2_1
XTAP_TAPCELL_ROW_11_439 vssd1 vccd1 sky130_fd_sc_hd__tapvpwrvgnd_1
XFILLER_119_30 vccd1 vssd1 vccd1 vssd1 sky130_ef_sc_hd__decap_40_12
X_12181_ net910 _01527_ net694 vssd1 vssd1 vccd1 vccd1 FPGA_INST.cell3.LE_1B.reset_val
+ sky130_fd_sc_hd__dfrtp_2
X_11201_ net761 _00551_ net546 vssd1 vssd1 vccd1 vccd1 FPGA_INST.cell0.SB0.route_sel\[46\]
+ sky130_fd_sc_hd__dfstp_1
X_11132_ net816 _00482_ net601 vssd1 vssd1 vccd1 vccd1 FPGA_INST.cell1.CB_1.config_dataB\[2\]
+ sky130_fd_sc_hd__dfstp_1
XANTENNA__07965__A0 FPGA_INST.bus3_1\[4\] vssd1 vssd1 vccd1 vccd1 sky130_fd_sc_hd__diode_2
XPHY_EDGE_ROW_57_Right_57 vssd1 vssd1 vccd1 vccd1 sky130_fd_sc_hd__decap_3
XTAP_TAPCELL_ROW_56_1068 vssd1 vccd1 sky130_fd_sc_hd__tapvpwrvgnd_1
X_11063_ FPGA_INST.cell1.LE_0A.sel_clk _00413_ net732 vssd1 vssd1 vccd1 vccd1 FPGA_INST.cell1.LE_0A.dff0_out
+ sky130_fd_sc_hd__dfrtp_1
XANTENNA__08509__A2 FPGA_INST.cell3.CB_1.le_outA vssd1 vssd1 vccd1 vccd1 sky130_fd_sc_hd__diode_2
XFILLER_110_508 vssd1 vssd1 vccd1 vccd1 sky130_fd_sc_hd__fill_8
XANTENNA__12067__CLK net862 vssd1 vssd1 vccd1 vccd1 sky130_fd_sc_hd__diode_2
XFILLER_0_153 vssd1 vssd1 vccd1 vccd1 sky130_fd_sc_hd__fill_2
XFILLER_89_794 vssd1 vssd1 vccd1 vccd1 sky130_fd_sc_hd__fill_4
XFILLER_0_197 vssd1 vssd1 vccd1 vccd1 sky130_fd_sc_hd__fill_8
X_10014_ FPGA_INST.cell0.CB_0.config_dataA\[13\] FPGA_INST.cell0.CB_0.config_dataA\[14\]
+ net191 vssd1 vssd1 vccd1 vccd1 _00895_ sky130_fd_sc_hd__mux2_1
XANTENNA__05690__A FPGA_INST.cell0.CB_0.config_dataB\[24\] vssd1 vssd1 vccd1 vccd1
+ sky130_fd_sc_hd__diode_2
X_11965_ net783 _01311_ net568 vssd1 vssd1 vccd1 vccd1 FPGA_INST.cell2.SB0.route_sel\[5\]
+ sky130_fd_sc_hd__dfstp_1
XPHY_EDGE_ROW_66_Right_66 vssd1 vssd1 vccd1 vccd1 sky130_fd_sc_hd__decap_3
X_10916_ net787 _00266_ net572 vssd1 vssd1 vccd1 vccd1 FPGA_INST.cell1.SB0.route_sel\[125\]
+ sky130_fd_sc_hd__dfstp_1
XANTENNA__09890__A0 FPGA_INST.cell0.LE_0A.reset_val vssd1 vssd1 vccd1 vccd1 sky130_fd_sc_hd__diode_2
X_11896_ net939 _01242_ net723 vssd1 vssd1 vccd1 vccd1 FPGA_INST.cell3.LE_0B.config_data\[4\]
+ sky130_fd_sc_hd__dfrtp_1
XANTENNA__07350__D1 FPGA_INST.cell1.SB0.route_sel\[32\] vssd1 vssd1 vccd1 vccd1 sky130_fd_sc_hd__diode_2
XFILLER_44_396 vssd1 vssd1 vccd1 vccd1 sky130_fd_sc_hd__fill_1
XFILLER_32_547 vccd1 vssd1 vccd1 vssd1 sky130_ef_sc_hd__decap_40_12
X_10847_ net799 _00197_ net584 vssd1 vssd1 vccd1 vccd1 FPGA_INST.cell1.SB0.route_sel\[56\]
+ sky130_fd_sc_hd__dfstp_1
XFILLER_44_81 vssd1 vssd1 vccd1 vccd1 sky130_fd_sc_hd__fill_2
XFILLER_9_710 vssd1 vssd1 vccd1 vccd1 sky130_fd_sc_hd__fill_2
XPHY_EDGE_ROW_4_Left_135 vssd1 vssd1 vccd1 vccd1 sky130_fd_sc_hd__decap_3
XFILLER_13_750 vssd1 vssd1 vccd1 vccd1 sky130_fd_sc_hd__fill_2
XTAP_TAPCELL_ROW_30_704 vssd1 vccd1 sky130_fd_sc_hd__tapvpwrvgnd_1
XTAP_TAPCELL_ROW_80_1397 vssd1 vccd1 sky130_fd_sc_hd__tapvpwrvgnd_1
X_10778_ net901 _00128_ net685 vssd1 vssd1 vccd1 vccd1 FPGA_INST.cell2.CB_1.config_dataB\[12\]
+ sky130_fd_sc_hd__dfstp_2
XANTENNA__09101__S net267 vssd1 vssd1 vccd1 vccd1 sky130_fd_sc_hd__diode_2
XPHY_EDGE_ROW_75_Right_75 vssd1 vssd1 vccd1 vccd1 sky130_fd_sc_hd__decap_3
XANTENNA__06208__B1 _02487_ vssd1 vssd1 vccd1 vccd1 sky130_fd_sc_hd__diode_2
XFILLER_125_173 vssd1 vssd1 vccd1 vccd1 sky130_fd_sc_hd__fill_1
XFILLER_99_547 vssd1 vssd1 vccd1 vccd1 sky130_fd_sc_hd__fill_8
X_06940_ _02146_ _03198_ _03199_ _02110_ FPGA_INST.cell0.CB_0.config_dataB\[17\] vssd1
+ vssd1 vccd1 vccd1 _03208_ sky130_fd_sc_hd__a221o_1
XANTENNA__06032__Y _02312_ vssd1 vssd1 vccd1 vccd1 sky130_fd_sc_hd__diode_2
XFILLER_79_271 vssd1 vssd1 vccd1 vccd1 sky130_fd_sc_hd__fill_8
XFILLER_67_422 vssd1 vssd1 vccd1 vccd1 sky130_fd_sc_hd__fill_4
X_06871_ _03138_ vssd1 vssd1 vccd1 vccd1 _03139_ sky130_fd_sc_hd__inv_2
XFILLER_39_113 vccd1 vssd1 vccd1 vssd1 sky130_ef_sc_hd__decap_40_12
XTAP_TAPCELL_ROW_87_1507 vssd1 vccd1 sky130_fd_sc_hd__tapvpwrvgnd_1
X_08610_ _03538_ _04818_ vssd1 vssd1 vccd1 vccd1 _04819_ sky130_fd_sc_hd__or2_4
X_05822_ net112 _01975_ _02019_ vssd1 vssd1 vccd1 vccd1 _02102_ sky130_fd_sc_hd__nor3_1
XFILLER_55_617 vssd1 vssd1 vccd1 vccd1 sky130_fd_sc_hd__fill_1
X_09590_ FPGA_INST.cell1.CB_1.config_dataB\[18\] FPGA_INST.cell1.CB_1.config_dataB\[19\]
+ net213 vssd1 vssd1 vccd1 vccd1 _00499_ sky130_fd_sc_hd__mux2_1
XPHY_EDGE_ROW_84_Right_84 vssd1 vssd1 vccd1 vccd1 sky130_fd_sc_hd__decap_3
XANTENNA__07144__X _03408_ vssd1 vssd1 vccd1 vccd1 sky130_fd_sc_hd__diode_2
XTAP_TAPCELL_ROW_38_815 vssd1 vccd1 sky130_fd_sc_hd__tapvpwrvgnd_1
X_08541_ net92 net87 FPGA_INST.cell3.CB_1.le_outA net79 FPGA_INST.cell3.LEI0.config_data\[9\]
+ FPGA_INST.cell3.LEI0.config_data\[10\] vssd1 vssd1 vccd1 vccd1 _04752_ sky130_fd_sc_hd__mux4_1
X_05753_ FPGA_INST.cell2.SB0.route_sel\[82\] FPGA_INST.cell2.SB0.route_sel\[83\] vssd1
+ vssd1 vccd1 vccd1 _02033_ sky130_fd_sc_hd__nand2_1
X_08472_ FPGA_INST.cell1.CB_1.config_dataB\[9\] _04686_ _04687_ vssd1 vssd1 vccd1
+ vccd1 _04688_ sky130_fd_sc_hd__and3_1
XFILLER_63_661 vssd1 vssd1 vccd1 vccd1 sky130_fd_sc_hd__fill_2
X_05684_ FPGA_INST.cell2.SB0.route_sel\[101\] FPGA_INST.cell2.SB0.route_sel\[100\]
+ vssd1 vssd1 vccd1 vccd1 _01964_ sky130_fd_sc_hd__nand2b_1
XFILLER_90_491 vssd1 vssd1 vccd1 vccd1 sky130_fd_sc_hd__fill_1
XFILLER_90_480 vssd1 vssd1 vccd1 vccd1 sky130_fd_sc_hd__fill_4
X_07423_ _01678_ FPGA_INST.cell0.SB0.route_sel\[55\] vssd1 vssd1 vccd1 vccd1 _03681_
+ sky130_fd_sc_hd__or2_1
XANTENNA__10491__A1 FPGA_INST.cell2.SB0.route_sel\[64\] vssd1 vssd1 vccd1 vccd1 sky130_fd_sc_hd__diode_2
X_07354_ _03398_ _03593_ _03613_ vssd1 vssd1 vccd1 vccd1 _03614_ sky130_fd_sc_hd__a21o_1
XFILLER_108_107 vssd1 vssd1 vccd1 vccd1 sky130_fd_sc_hd__fill_1
X_07285_ FPGA_INST.cell1.CB_0.config_dataA\[24\] FPGA_INST.cell1.CB_0.config_dataA\[21\]
+ FPGA_INST.cell1.CB_0.config_dataA\[20\] vssd1 vssd1 vccd1 vccd1 _03546_ sky130_fd_sc_hd__nand3b_2
XANTENNA_fanout314_A net315 vssd1 vssd1 vccd1 vccd1 sky130_fd_sc_hd__diode_2
X_06305_ _02576_ _02582_ FPGA_INST.cell2.CB_0.config_dataA\[17\] vssd1 vssd1 vccd1
+ vccd1 _02585_ sky130_fd_sc_hd__mux2_1
XTAP_TAPCELL_ROW_98_1658 vssd1 vccd1 sky130_fd_sc_hd__tapvpwrvgnd_1
XPHY_EDGE_ROW_93_Right_93 vssd1 vssd1 vccd1 vccd1 sky130_fd_sc_hd__decap_3
X_09024_ _03460_ _03472_ _05189_ net341 vssd1 vssd1 vccd1 vccd1 FPGA_INST.bus1_0\[1\]
+ sky130_fd_sc_hd__a211oi_2
X_06236_ net508 _02513_ _02515_ vssd1 vssd1 vccd1 vccd1 _02516_ sky130_fd_sc_hd__a21o_1
XFILLER_117_696 vssd1 vssd1 vccd1 vccd1 sky130_fd_sc_hd__fill_1
XFILLER_2_418 vssd1 vssd1 vccd1 vccd1 sky130_fd_sc_hd__fill_2
X_06167_ _02446_ _02440_ vssd1 vssd1 vccd1 vccd1 _02447_ sky130_fd_sc_hd__nand2b_2
Xfanout700 net701 vssd1 vssd1 vccd1 vccd1 net700 sky130_fd_sc_hd__buf_2
XANTENNA_fanout683_A net702 vssd1 vssd1 vccd1 vccd1 sky130_fd_sc_hd__diode_2
XPHY_EDGE_ROW_68_Left_199 vssd1 vssd1 vccd1 vccd1 sky130_fd_sc_hd__decap_3
XFILLER_49_37 vssd1 vssd1 vccd1 vccd1 sky130_fd_sc_hd__fill_1
X_06098_ net120 _01818_ net158 _02333_ _01815_ vssd1 vssd1 vccd1 vccd1 _02378_ sky130_fd_sc_hd__o32a_1
Xfanout722 net729 vssd1 vssd1 vccd1 vccd1 net722 sky130_fd_sc_hd__clkbuf_2
XANTENNA__08721__A1_N _04828_ vssd1 vssd1 vccd1 vccd1 sky130_fd_sc_hd__diode_2
Xfanout733 net29 vssd1 vssd1 vccd1 vccd1 net733 sky130_fd_sc_hd__clkbuf_4
Xfanout711 net714 vssd1 vssd1 vccd1 vccd1 net711 sky130_fd_sc_hd__clkbuf_4
X_09926_ FPGA_INST.cell0.LE_1A.config_data\[7\] FPGA_INST.cell0.LE_1A.config_data\[8\]
+ net183 vssd1 vssd1 vccd1 vccd1 _00831_ sky130_fd_sc_hd__mux2_1
Xfanout766 net769 vssd1 vssd1 vccd1 vccd1 net766 sky130_fd_sc_hd__clkbuf_2
Xfanout744 net749 vssd1 vssd1 vccd1 vccd1 net744 sky130_fd_sc_hd__buf_1
Xfanout755 net758 vssd1 vssd1 vccd1 vccd1 net755 sky130_fd_sc_hd__clkbuf_1
XFILLER_86_753 vssd1 vssd1 vccd1 vccd1 sky130_fd_sc_hd__fill_2
Xfanout799 net803 vssd1 vssd1 vccd1 vccd1 net799 sky130_fd_sc_hd__clkbuf_2
Xfanout788 net789 vssd1 vssd1 vccd1 vccd1 net788 sky130_fd_sc_hd__dlymetal6s2s_1
X_09857_ FPGA_INST.cell0.LEI0.config_data\[36\] FPGA_INST.cell0.LEI0.config_data\[35\]
+ net307 vssd1 vssd1 vccd1 vccd1 _00765_ sky130_fd_sc_hd__mux2_1
Xfanout777 net778 vssd1 vssd1 vccd1 vccd1 net777 sky130_fd_sc_hd__clkbuf_2
XANTENNA_fanout850_A net851 vssd1 vssd1 vccd1 vccd1 sky130_fd_sc_hd__diode_2
X_08808_ _01773_ _05013_ _05014_ vssd1 vssd1 vccd1 vccd1 _05015_ sky130_fd_sc_hd__o21ai_1
X_09788_ FPGA_INST.cell1.CB_1.config_dataA\[13\] FPGA_INST.cell1.CB_1.config_dataA\[14\]
+ net204 vssd1 vssd1 vccd1 vccd1 _00697_ sky130_fd_sc_hd__mux2_1
XFILLER_45_105 vssd1 vssd1 vccd1 vccd1 sky130_fd_sc_hd__fill_1
XANTENNA__06922__A1 FPGA_INST.bus2_0\[1\] vssd1 vssd1 vccd1 vccd1 sky130_fd_sc_hd__diode_2
X_08739_ net394 _04804_ vssd1 vssd1 vccd1 vccd1 _04948_ sky130_fd_sc_hd__or2_1
XFILLER_26_330 vssd1 vssd1 vccd1 vccd1 sky130_fd_sc_hd__fill_1
XTAP_TAPCELL_ROW_107_1776 vssd1 vccd1 sky130_fd_sc_hd__tapvpwrvgnd_1
XANTENNA_fanout736_X net736 vssd1 vssd1 vccd1 vccd1 sky130_fd_sc_hd__diode_2
X_11750_ net900 _01096_ net684 vssd1 vssd1 vccd1 vccd1 FPGA_INST.cell3.SB0.route_sel\[120\]
+ sky130_fd_sc_hd__dfstp_1
XTAP_TAPCELL_ROW_16_509 vssd1 vccd1 sky130_fd_sc_hd__tapvpwrvgnd_1
XFILLER_26_363 vssd1 vssd1 vccd1 vccd1 sky130_fd_sc_hd__fill_1
XTAP_TAPCELL_ROW_107_1787 vssd1 vccd1 sky130_fd_sc_hd__tapvpwrvgnd_1
X_10701_ net855 _00051_ net640 vssd1 vssd1 vccd1 vccd1 FPGA_INST.cell2.LE_0A.config_data\[0\]
+ sky130_fd_sc_hd__dfrtp_2
X_11681_ net905 _01027_ net689 vssd1 vssd1 vccd1 vccd1 FPGA_INST.cell3.SB0.route_sel\[51\]
+ sky130_fd_sc_hd__dfstp_1
X_10632_ FPGA_INST.cell3.LE_1B.config_data\[1\] FPGA_INST.cell3.LE_1B.config_data\[2\]
+ net280 vssd1 vssd1 vccd1 vccd1 _01511_ sky130_fd_sc_hd__mux2_1
XTAP_TAPCELL_ROW_120_1965 vssd1 vccd1 sky130_fd_sc_hd__tapvpwrvgnd_1
XANTENNA__07868__C _03769_ vssd1 vssd1 vccd1 vccd1 sky130_fd_sc_hd__diode_2
X_10563_ FPGA_INST.cell3.CB_0.config_dataA\[8\] FPGA_INST.cell3.CB_0.config_dataA\[7\]
+ net373 vssd1 vssd1 vccd1 vccd1 _01442_ sky130_fd_sc_hd__mux2_1
XFILLER_10_753 vssd1 vssd1 vccd1 vccd1 sky130_fd_sc_hd__fill_1
XFILLER_127_449 vssd1 vssd1 vccd1 vccd1 sky130_fd_sc_hd__fill_4
XFILLER_127_438 vssd1 vssd1 vccd1 vccd1 sky130_fd_sc_hd__fill_1
XANTENNA__06989__A1 FPGA_INST.bus2_0\[7\] vssd1 vssd1 vccd1 vccd1 sky130_fd_sc_hd__diode_2
X_10494_ FPGA_INST.cell2.SB0.route_sel\[66\] FPGA_INST.cell2.SB0.route_sel\[67\] net248
+ vssd1 vssd1 vccd1 vccd1 _01373_ sky130_fd_sc_hd__mux2_1
XFILLER_5_223 vssd1 vssd1 vccd1 vccd1 sky130_fd_sc_hd__fill_1
XFILLER_30_61 vssd1 vssd1 vccd1 vccd1 sky130_fd_sc_hd__fill_2
XFILLER_30_83 vssd1 vssd1 vccd1 vccd1 sky130_fd_sc_hd__fill_1
X_12164_ net910 _01510_ net694 vssd1 vssd1 vccd1 vccd1 FPGA_INST.cell3.LE_1B.config_data\[1\]
+ sky130_fd_sc_hd__dfrtp_1
XANTENNA__09157__A net737 vssd1 vssd1 vccd1 vccd1 sky130_fd_sc_hd__diode_2
XANTENNA__06133__X _02413_ vssd1 vssd1 vccd1 vccd1 sky130_fd_sc_hd__diode_2
XANTENNA__05949__C1 net317 vssd1 vssd1 vccd1 vccd1 sky130_fd_sc_hd__diode_2
X_11115_ net804 _00465_ net589 vssd1 vssd1 vccd1 vccd1 FPGA_INST.cell1.LE_1A.config_data\[6\]
+ sky130_fd_sc_hd__dfrtp_1
X_12095_ net921 _01441_ net705 vssd1 vssd1 vccd1 vccd1 FPGA_INST.cell3.CB_0.config_dataA\[7\]
+ sky130_fd_sc_hd__dfstp_2
XANTENNA__06610__A0 _02793_ vssd1 vssd1 vccd1 vccd1 sky130_fd_sc_hd__diode_2
X_11046_ net806 _00396_ net591 vssd1 vssd1 vccd1 vccd1 FPGA_INST.cell1.LEI0.config_data\[31\]
+ sky130_fd_sc_hd__dfrtp_1
XFILLER_77_742 vssd1 vssd1 vccd1 vccd1 sky130_fd_sc_hd__fill_2
XFILLER_77_764 vssd1 vssd1 vccd1 vccd1 sky130_fd_sc_hd__fill_8
XANTENNA__06913__A1 _02309_ vssd1 vssd1 vccd1 vccd1 sky130_fd_sc_hd__diode_2
XANTENNA__08115__A0 FPGA_INST.bus3_1\[4\] vssd1 vssd1 vccd1 vccd1 sky130_fd_sc_hd__diode_2
XTAP_TAPCELL_ROW_69_1248 vssd1 vccd1 sky130_fd_sc_hd__tapvpwrvgnd_1
XFILLER_91_277 vssd1 vssd1 vccd1 vccd1 sky130_fd_sc_hd__fill_2
XFILLER_51_108 vssd1 vssd1 vccd1 vccd1 sky130_fd_sc_hd__fill_4
XFILLER_45_650 vssd1 vssd1 vccd1 vccd1 sky130_fd_sc_hd__fill_2
X_11948_ net913 _01294_ net697 vssd1 vssd1 vccd1 vccd1 FPGA_INST.cell3.CB_1.config_dataB\[13\]
+ sky130_fd_sc_hd__dfstp_1
XTAP_TAPCELL_ROW_82_1437 vssd1 vccd1 sky130_fd_sc_hd__tapvpwrvgnd_1
XTAP_TAPCELL_ROW_82_1426 vssd1 vccd1 sky130_fd_sc_hd__tapvpwrvgnd_1
XFILLER_32_322 vccd1 vssd1 vccd1 vssd1 sky130_ef_sc_hd__decap_40_12
X_11879_ net928 _01225_ net712 vssd1 vssd1 vccd1 vccd1 FPGA_INST.cell3.LE_0A.config_data\[9\]
+ sky130_fd_sc_hd__dfrtp_1
XTAP_TAPCELL_ROW_43_884 vssd1 vccd1 sky130_fd_sc_hd__tapvpwrvgnd_1
XFILLER_32_399 vssd1 vssd1 vccd1 vccd1 sky130_fd_sc_hd__fill_1
XFILLER_9_540 vssd1 vssd1 vccd1 vccd1 sky130_fd_sc_hd__fill_1
XFILLER_72_3 vssd1 vssd1 vccd1 vccd1 sky130_fd_sc_hd__fill_2
X_07070_ net430 _01888_ vssd1 vssd1 vccd1 vccd1 _03336_ sky130_fd_sc_hd__nand2_1
X_06021_ net96 net165 net159 _02181_ _01975_ vssd1 vssd1 vccd1 vccd1 _02301_ sky130_fd_sc_hd__o32a_1
XFILLER_126_471 vssd1 vssd1 vccd1 vccd1 sky130_fd_sc_hd__fill_2
XANTENNA__07929__A0 FPGA_INST.bus3_1\[0\] vssd1 vssd1 vccd1 vccd1 sky130_fd_sc_hd__diode_2
XTAP_TAPCELL_ROW_93_1588 vssd1 vccd1 sky130_fd_sc_hd__tapvpwrvgnd_1
XFILLER_114_699 vssd1 vssd1 vccd1 vccd1 sky130_fd_sc_hd__fill_1
X_07972_ net464 _03889_ vssd1 vssd1 vccd1 vccd1 _04200_ sky130_fd_sc_hd__nand2_1
XFILLER_68_742 vssd1 vssd1 vccd1 vccd1 sky130_fd_sc_hd__fill_1
X_09711_ FPGA_INST.cell0.SB0.route_sel\[114\] FPGA_INST.cell0.SB0.route_sel\[115\]
+ net200 vssd1 vssd1 vccd1 vccd1 _00620_ sky130_fd_sc_hd__mux2_1
X_06923_ _03186_ _03190_ _03182_ vssd1 vssd1 vccd1 vccd1 _03191_ sky130_fd_sc_hd__a21oi_1
XFILLER_83_723 vssd1 vssd1 vccd1 vccd1 sky130_fd_sc_hd__fill_4
X_06854_ net114 net118 net110 net98 FPGA_INST.cell0.LEI0.config_data\[15\] FPGA_INST.cell0.LEI0.config_data\[16\]
+ vssd1 vssd1 vccd1 vccd1 _03122_ sky130_fd_sc_hd__mux4_1
X_09642_ FPGA_INST.cell0.SB0.route_sel\[45\] FPGA_INST.cell0.SB0.route_sel\[46\] net182
+ vssd1 vssd1 vccd1 vccd1 _00551_ sky130_fd_sc_hd__mux2_1
XTAP_TAPCELL_ROW_124_2021 vssd1 vccd1 sky130_fd_sc_hd__tapvpwrvgnd_1
X_09573_ FPGA_INST.cell1.CB_1.config_dataB\[2\] FPGA_INST.cell1.CB_1.config_dataB\[1\]
+ net335 vssd1 vssd1 vccd1 vccd1 _00482_ sky130_fd_sc_hd__mux2_1
X_06785_ net512 _02810_ _03058_ net511 vssd1 vssd1 vccd1 vccd1 _03059_ sky130_fd_sc_hd__o211a_1
XFILLER_55_447 vssd1 vssd1 vccd1 vccd1 sky130_fd_sc_hd__fill_1
X_05805_ net126 _02082_ vssd1 vssd1 vccd1 vccd1 _02085_ sky130_fd_sc_hd__or2_1
X_08524_ FPGA_INST.cell3.LE_1A.config_data\[0\] FPGA_INST.cell3.LE_1A.config_data\[1\]
+ _04725_ vssd1 vssd1 vccd1 vccd1 _04737_ sky130_fd_sc_hd__mux2_1
X_05736_ FPGA_INST.cell0.CB_1.config_dataB\[22\] FPGA_INST.cell0.CB_1.config_dataB\[23\]
+ vssd1 vssd1 vccd1 vccd1 _02016_ sky130_fd_sc_hd__nand2b_1
XFILLER_43_609 vssd1 vssd1 vccd1 vccd1 sky130_fd_sc_hd__fill_1
XANTENNA__08657__A1 _04843_ vssd1 vssd1 vccd1 vccd1 sky130_fd_sc_hd__diode_2
XANTENNA__08657__B2 _04846_ vssd1 vssd1 vccd1 vccd1 sky130_fd_sc_hd__diode_2
XFILLER_35_171 vssd1 vssd1 vccd1 vccd1 sky130_fd_sc_hd__fill_4
X_08455_ FPGA_INST.cell1.LE_1A.config_data\[6\] FPGA_INST.cell1.LE_1A.config_data\[7\]
+ _04660_ vssd1 vssd1 vccd1 vccd1 _04673_ sky130_fd_sc_hd__mux2_1
X_05667_ _01850_ _01946_ vssd1 vssd1 vccd1 vccd1 _01947_ sky130_fd_sc_hd__or2_2
XFILLER_51_675 vssd1 vssd1 vccd1 vccd1 sky130_fd_sc_hd__fill_2
X_07406_ FPGA_INST.cell3.SB0.route_sel\[40\] FPGA_INST.cell3.SB0.route_sel\[41\] _03664_
+ vssd1 vssd1 vccd1 vccd1 _03665_ sky130_fd_sc_hd__a21oi_1
X_05598_ net382 _01876_ FPGA_INST.bus1_0\[15\] vssd1 vssd1 vccd1 vccd1 _01878_ sky130_fd_sc_hd__o21ai_1
X_08386_ net438 net439 vssd1 vssd1 vccd1 vccd1 _04608_ sky130_fd_sc_hd__and2b_1
XFILLER_23_388 vssd1 vssd1 vccd1 vccd1 sky130_fd_sc_hd__fill_1
X_07337_ _03399_ _03594_ FPGA_INST.bus3_1\[4\] vssd1 vssd1 vccd1 vccd1 _03597_ sky130_fd_sc_hd__o21ai_1
XANTENNA__07093__A0 FPGA_INST.bus2_0\[2\] vssd1 vssd1 vccd1 vccd1 sky130_fd_sc_hd__diode_2
XTAP_TAPCELL_ROW_21_578 vssd1 vccd1 sky130_fd_sc_hd__tapvpwrvgnd_1
XANTENNA_fanout317_X net317 vssd1 vssd1 vccd1 vccd1 sky130_fd_sc_hd__diode_2
X_07268_ FPGA_INST.cell3.CB_0.config_dataB\[20\] FPGA_INST.cell3.CB_0.config_dataB\[24\]
+ FPGA_INST.cell3.CB_0.config_dataB\[21\] vssd1 vssd1 vccd1 vccd1 _03530_ sky130_fd_sc_hd__or3b_2
XANTENNA_fanout898_A net899 vssd1 vssd1 vccd1 vccd1 sky130_fd_sc_hd__diode_2
XFILLER_124_419 vssd1 vssd1 vccd1 vccd1 sky130_fd_sc_hd__fill_1
XPHY_EDGE_ROW_76_Left_207 vssd1 vssd1 vccd1 vccd1 sky130_fd_sc_hd__decap_3
X_07199_ FPGA_INST.cell0.SB0.route_sel\[13\] FPGA_INST.cell0.SB0.route_sel\[12\] vssd1
+ vssd1 vccd1 vccd1 _03462_ sky130_fd_sc_hd__or2_1
X_06219_ FPGA_INST.cell2.CB_0.config_dataA\[9\] _01810_ vssd1 vssd1 vccd1 vccd1 _02499_
+ sky130_fd_sc_hd__nand2_1
XFILLER_3_727 vssd1 vssd1 vccd1 vccd1 sky130_fd_sc_hd__fill_1
X_09007_ FPGA_INST.cell2.SB0.route_sel\[26\] FPGA_INST.cell2.SB0.route_sel\[27\] vssd1
+ vssd1 vccd1 vccd1 _05178_ sky130_fd_sc_hd__nand2b_1
XFILLER_105_655 vssd1 vssd1 vccd1 vccd1 sky130_fd_sc_hd__fill_1
XTAP_TAPCELL_ROW_53_1027 vssd1 vccd1 sky130_fd_sc_hd__tapvpwrvgnd_1
XFILLER_116_53 vssd1 vssd1 vccd1 vccd1 sky130_fd_sc_hd__fill_1
XFILLER_59_720 vssd1 vssd1 vccd1 vccd1 sky130_fd_sc_hd__fill_2
Xfanout530 net534 vssd1 vssd1 vccd1 vccd1 net530 sky130_fd_sc_hd__clkbuf_4
Xfanout541 net543 vssd1 vssd1 vccd1 vccd1 net541 sky130_fd_sc_hd__clkbuf_4
XANTENNA__05792__X _02072_ vssd1 vssd1 vccd1 vccd1 sky130_fd_sc_hd__diode_2
XFILLER_93_509 vssd1 vssd1 vccd1 vccd1 sky130_fd_sc_hd__fill_2
XFILLER_59_753 vssd1 vssd1 vccd1 vccd1 sky130_fd_sc_hd__fill_1
Xfanout552 net553 vssd1 vssd1 vccd1 vccd1 net552 sky130_fd_sc_hd__clkbuf_4
X_09909_ FPGA_INST.cell0.LE_0B.config_data\[13\] FPGA_INST.cell0.LE_0B.config_data\[14\]
+ net178 vssd1 vssd1 vccd1 vccd1 _00815_ sky130_fd_sc_hd__mux2_1
Xfanout563 net575 vssd1 vssd1 vccd1 vccd1 net563 sky130_fd_sc_hd__buf_2
Xfanout574 net575 vssd1 vssd1 vccd1 vccd1 net574 sky130_fd_sc_hd__clkbuf_2
XTAP_TAPCELL_ROW_109_1805 vssd1 vccd1 sky130_fd_sc_hd__tapvpwrvgnd_1
Xfanout596 net627 vssd1 vssd1 vccd1 vccd1 net596 sky130_fd_sc_hd__buf_2
Xfanout585 net587 vssd1 vssd1 vccd1 vccd1 net585 sky130_fd_sc_hd__clkbuf_4
XPHY_EDGE_ROW_85_Left_216 vssd1 vssd1 vccd1 vccd1 sky130_fd_sc_hd__decap_3
XFILLER_73_222 vssd1 vssd1 vccd1 vccd1 sky130_fd_sc_hd__fill_2
XFILLER_61_406 vssd1 vssd1 vccd1 vccd1 sky130_fd_sc_hd__fill_2
X_11802_ net875 _01148_ net660 vssd1 vssd1 vccd1 vccd1 FPGA_INST.io_east_oeb\[24\]
+ sky130_fd_sc_hd__dfrtp_1
XTAP_TAPCELL_ROW_29_689 vssd1 vccd1 sky130_fd_sc_hd__tapvpwrvgnd_1
XANTENNA__08648__A1 net84 vssd1 vssd1 vccd1 vccd1 sky130_fd_sc_hd__diode_2
XANTENNA__08755__S _04860_ vssd1 vssd1 vccd1 vccd1 sky130_fd_sc_hd__diode_2
XTAP_TAPCELL_ROW_1_292 vssd1 vccd1 sky130_fd_sc_hd__tapvpwrvgnd_1
XFILLER_26_160 vccd1 vssd1 vccd1 vssd1 sky130_ef_sc_hd__decap_40_12
XANTENNA__07320__A1 net94 vssd1 vssd1 vccd1 vccd1 sky130_fd_sc_hd__diode_2
X_11733_ net903 _01079_ net681 vssd1 vssd1 vccd1 vccd1 FPGA_INST.cell3.SB0.route_sel\[103\]
+ sky130_fd_sc_hd__dfstp_1
X_11664_ net906 _01010_ net690 vssd1 vssd1 vccd1 vccd1 FPGA_INST.cell3.SB0.route_sel\[34\]
+ sky130_fd_sc_hd__dfstp_1
XTAP_TAPCELL_ROW_64_1178 vssd1 vccd1 sky130_fd_sc_hd__tapvpwrvgnd_1
X_10615_ FPGA_INST.cell3.CB_1.config_dataA\[9\] FPGA_INST.cell3.CB_1.config_dataA\[10\]
+ net303 vssd1 vssd1 vccd1 vccd1 _01494_ sky130_fd_sc_hd__mux2_1
XANTENNA__07871__A2 FPGA_INST.bus3_1\[10\] vssd1 vssd1 vccd1 vccd1 sky130_fd_sc_hd__diode_2
XANTENNA__05882__B2 FPGA_INST.cell2.SB0.route_sel\[64\] vssd1 vssd1 vccd1 vccd1 sky130_fd_sc_hd__diode_2
XTAP_TAPCELL_ROW_40_843 vssd1 vccd1 sky130_fd_sc_hd__tapvpwrvgnd_1
X_11595_ net791 _00945_ net576 vssd1 vssd1 vccd1 vccd1 FPGA_INST.cell0.CB_1.config_dataA\[14\]
+ sky130_fd_sc_hd__dfstp_1
XFILLER_6_510 vssd1 vssd1 vccd1 vccd1 sky130_fd_sc_hd__fill_1
XPHY_EDGE_ROW_94_Left_225 vssd1 vssd1 vccd1 vccd1 sky130_fd_sc_hd__decap_3
X_10546_ FPGA_INST.cell2.SB0.route_sel\[118\] FPGA_INST.cell2.SB0.route_sel\[119\]
+ net239 vssd1 vssd1 vccd1 vccd1 _01425_ sky130_fd_sc_hd__mux2_1
X_10477_ FPGA_INST.cell2.SB0.route_sel\[49\] FPGA_INST.cell2.SB0.route_sel\[50\] net194
+ vssd1 vssd1 vccd1 vccd1 _01356_ sky130_fd_sc_hd__mux2_1
XANTENNA__08997__Y FPGA_INST.bus1_0\[4\] vssd1 vssd1 vccd1 vccd1 sky130_fd_sc_hd__diode_2
XANTENNA__10822__Q FPGA_INST.cell1.SB0.route_sel\[31\] vssd1 vssd1 vccd1 vccd1 sky130_fd_sc_hd__diode_2
X_12147_ net942 _01493_ net726 vssd1 vssd1 vccd1 vccd1 FPGA_INST.cell3.CB_1.config_dataA\[9\]
+ sky130_fd_sc_hd__dfstp_1
XFILLER_111_614 vssd1 vssd1 vccd1 vccd1 sky130_fd_sc_hd__fill_2
XFILLER_110_135 vssd1 vssd1 vccd1 vccd1 sky130_fd_sc_hd__fill_4
XFILLER_49_241 vssd1 vssd1 vccd1 vccd1 sky130_fd_sc_hd__fill_2
XFILLER_1_281 vssd1 vssd1 vccd1 vccd1 sky130_fd_sc_hd__fill_4
X_12078_ net853 _01424_ net638 vssd1 vssd1 vccd1 vccd1 FPGA_INST.cell2.SB0.route_sel\[118\]
+ sky130_fd_sc_hd__dfstp_1
X_11029_ net834 _00379_ net618 vssd1 vssd1 vccd1 vccd1 FPGA_INST.cell1.LEI0.config_data\[14\]
+ sky130_fd_sc_hd__dfrtp_1
XFILLER_77_561 vssd1 vssd1 vccd1 vccd1 sky130_fd_sc_hd__fill_1
XFILLER_2_76 vssd1 vssd1 vccd1 vccd1 sky130_fd_sc_hd__fill_8
XANTENNA__07135__A FPGA_INST.cell1.CB_0.config_dataB\[24\] vssd1 vssd1 vccd1 vccd1
+ sky130_fd_sc_hd__diode_2
XFILLER_92_531 vssd1 vssd1 vccd1 vccd1 sky130_fd_sc_hd__fill_1
XFILLER_92_520 vssd1 vssd1 vccd1 vccd1 sky130_fd_sc_hd__fill_8
XTAP_TAPCELL_ROW_48_954 vssd1 vccd1 sky130_fd_sc_hd__tapvpwrvgnd_1
XFILLER_64_266 vssd1 vssd1 vccd1 vccd1 sky130_fd_sc_hd__fill_1
XFILLER_52_417 vssd1 vssd1 vccd1 vccd1 sky130_fd_sc_hd__fill_2
XANTENNA__06362__A2 _01869_ vssd1 vssd1 vccd1 vccd1 sky130_fd_sc_hd__diode_2
X_06570_ _02816_ _02825_ _02829_ _02845_ vssd1 vssd1 vccd1 vccd1 _02846_ sky130_fd_sc_hd__o211ai_1
XFILLER_33_631 vssd1 vssd1 vccd1 vccd1 sky130_fd_sc_hd__fill_2
X_05521_ FPGA_INST.config_bits\[5\] FPGA_INST.config_bits\[3\] FPGA_INST.config_bits\[2\]
+ FPGA_INST.config_bits\[4\] vssd1 vssd1 vccd1 vccd1 _01803_ sky130_fd_sc_hd__or4b_1
X_08240_ _04460_ _04463_ vssd1 vssd1 vccd1 vccd1 _04464_ sky130_fd_sc_hd__and2_1
X_05452_ FPGA_INST.cell0.CB_0.config_dataA\[12\] vssd1 vssd1 vccd1 vccd1 _01734_ sky130_fd_sc_hd__inv_2
XANTENNA__07862__A2 _03728_ vssd1 vssd1 vccd1 vccd1 sky130_fd_sc_hd__diode_2
X_08171_ net412 _03682_ _04394_ net411 vssd1 vssd1 vccd1 vccd1 _04395_ sky130_fd_sc_hd__o211a_1
X_05383_ FPGA_INST.cell3.SB0.route_sel\[60\] vssd1 vssd1 vccd1 vccd1 _01665_ sky130_fd_sc_hd__inv_2
XFILLER_9_370 vccd1 vssd1 vccd1 vssd1 sky130_ef_sc_hd__decap_40_12
X_07122_ FPGA_INST.cell0.LE_0A.config_data\[13\] FPGA_INST.cell0.LE_0A.config_data\[12\]
+ _03313_ vssd1 vssd1 vccd1 vccd1 _03388_ sky130_fd_sc_hd__mux2_1
XANTENNA__07075__A0 FPGA_INST.bus2_0\[12\] vssd1 vssd1 vccd1 vccd1 sky130_fd_sc_hd__diode_2
XFILLER_119_769 vssd1 vssd1 vccd1 vccd1 sky130_fd_sc_hd__fill_4
XTAP_TAPCELL_ROW_95_1617 vssd1 vccd1 sky130_fd_sc_hd__tapvpwrvgnd_1
XTAP_TAPCELL_ROW_95_1606 vssd1 vccd1 sky130_fd_sc_hd__tapvpwrvgnd_1
XFILLER_106_419 vssd1 vssd1 vccd1 vccd1 sky130_fd_sc_hd__fill_1
X_07053_ _02270_ _03317_ _03318_ _02309_ _01734_ vssd1 vssd1 vccd1 vccd1 _03319_ sky130_fd_sc_hd__a221oi_1
XFILLER_126_290 vssd1 vssd1 vccd1 vccd1 sky130_fd_sc_hd__fill_2
X_06004_ _01954_ _02207_ vssd1 vssd1 vccd1 vccd1 _02284_ sky130_fd_sc_hd__nand2_1
XFILLER_102_636 vssd1 vssd1 vccd1 vccd1 sky130_fd_sc_hd__fill_1
X_07955_ FPGA_INST.cell1.CB_0.config_dataA\[14\] _04153_ _04156_ _04177_ _04182_ vssd1
+ vssd1 vccd1 vccd1 _04183_ sky130_fd_sc_hd__a311o_1
XANTENNA__09525__A net736 vssd1 vssd1 vccd1 vccd1 sky130_fd_sc_hd__diode_2
X_06906_ _03173_ vssd1 vssd1 vccd1 vccd1 _03174_ sky130_fd_sc_hd__inv_2
X_07886_ _04111_ _04112_ _04113_ _04108_ vssd1 vssd1 vccd1 vccd1 _04114_ sky130_fd_sc_hd__o211a_1
XANTENNA__08342__A3 FPGA_INST.bus1_0\[3\] vssd1 vssd1 vccd1 vccd1 sky130_fd_sc_hd__diode_2
X_09625_ FPGA_INST.cell0.SB0.route_sel\[29\] FPGA_INST.cell0.SB0.route_sel\[28\] net320
+ vssd1 vssd1 vccd1 vccd1 _00534_ sky130_fd_sc_hd__mux2_1
XANTENNA_fanout267_X net267 vssd1 vssd1 vccd1 vccd1 sky130_fd_sc_hd__diode_2
XANTENNA_fanout646_A net647 vssd1 vssd1 vccd1 vccd1 sky130_fd_sc_hd__diode_2
X_06837_ FPGA_INST.cell0.CB_0.config_dataB\[8\] FPGA_INST.cell0.CB_0.config_dataB\[7\]
+ vssd1 vssd1 vccd1 vccd1 _03105_ sky130_fd_sc_hd__nor2_1
XFILLER_102_33 vssd1 vssd1 vccd1 vccd1 sky130_fd_sc_hd__fill_2
X_09556_ FPGA_INST.cell1.LE_1A.config_data\[5\] FPGA_INST.cell1.LE_1A.config_data\[6\]
+ net212 vssd1 vssd1 vccd1 vccd1 _00465_ sky130_fd_sc_hd__mux2_1
X_06768_ _03025_ _03030_ _03041_ FPGA_INST.cell2.CB_1.config_dataB\[14\] vssd1 vssd1
+ vccd1 vccd1 _03042_ sky130_fd_sc_hd__a211o_1
X_08507_ FPGA_INST.cell3.CB_1.config_dataA\[8\] FPGA_INST.cell3.CB_1.config_dataA\[7\]
+ FPGA_INST.cell3.CB_1.config_dataA\[6\] FPGA_INST.cell3.CB_1.config_dataA\[5\] vssd1
+ vssd1 vccd1 vccd1 _04720_ sky130_fd_sc_hd__or4b_1
XANTENNA_fanout813_A net820 vssd1 vssd1 vccd1 vccd1 sky130_fd_sc_hd__diode_2
X_09487_ FPGA_INST.cell1.LEI0.config_data\[33\] FPGA_INST.cell1.LEI0.config_data\[34\]
+ net211 vssd1 vssd1 vccd1 vccd1 _00399_ sky130_fd_sc_hd__mux2_1
XTAP_TAPCELL_ROW_104_1735 vssd1 vccd1 sky130_fd_sc_hd__tapvpwrvgnd_1
X_06699_ _02819_ _02963_ _02964_ _02824_ _01594_ vssd1 vssd1 vccd1 vccd1 _02973_ sky130_fd_sc_hd__a221o_1
X_05719_ FPGA_INST.cell2.CB_0.config_dataB\[24\] FPGA_INST.cell2.CB_0.config_dataB\[21\]
+ FPGA_INST.cell2.CB_0.config_dataB\[20\] vssd1 vssd1 vccd1 vccd1 _01999_ sky130_fd_sc_hd__nor3b_1
XTAP_TAPCELL_ROW_26_648 vssd1 vccd1 sky130_fd_sc_hd__tapvpwrvgnd_1
X_08438_ FPGA_INST.cell1.CB_1.config_dataA\[9\] _04654_ _04655_ vssd1 vssd1 vccd1
+ vccd1 _04656_ sky130_fd_sc_hd__and3_1
XANTENNA__07853__A2 _03519_ vssd1 vssd1 vccd1 vccd1 sky130_fd_sc_hd__diode_2
XANTENNA__06656__A3 FPGA_INST.bus3_2\[3\] vssd1 vssd1 vccd1 vccd1 sky130_fd_sc_hd__diode_2
X_08369_ net73 net95 FPGA_INST.bus1_0\[2\] FPGA_INST.bus1_0\[3\] net442 net441 vssd1
+ vssd1 vccd1 vccd1 _04591_ sky130_fd_sc_hd__mux4_1
X_10400_ FPGA_INST.cell3.LE_1A.reset_val FPGA_INST.cell3.LE_1A.reset_mode net305 vssd1
+ vssd1 vccd1 vccd1 _01279_ sky130_fd_sc_hd__mux2_1
XFILLER_109_246 vssd1 vssd1 vccd1 vccd1 sky130_fd_sc_hd__fill_1
X_11380_ net747 _00730_ net532 vssd1 vssd1 vccd1 vccd1 FPGA_INST.cell0.LEI0.config_data\[1\]
+ sky130_fd_sc_hd__dfrtp_1
X_10331_ FPGA_INST.cell3.LEI0.config_data\[45\] FPGA_INST.cell3.LEI0.config_data\[46\]
+ net281 vssd1 vssd1 vccd1 vccd1 _01212_ sky130_fd_sc_hd__mux2_1
XANTENNA__08323__B _04040_ vssd1 vssd1 vccd1 vccd1 sky130_fd_sc_hd__diode_2
X_10262_ FPGA_INST.io_east_oeb\[12\] FPGA_INST.io_east_oeb\[14\] net257 vssd1 vssd1
+ vccd1 vccd1 _01143_ sky130_fd_sc_hd__mux2_1
XFILLER_127_74 vssd1 vssd1 vccd1 vccd1 sky130_fd_sc_hd__fill_1
XTAP_TAPCELL_ROW_115_1897 vssd1 vccd1 sky130_fd_sc_hd__tapvpwrvgnd_1
XTAP_TAPCELL_ROW_115_1886 vssd1 vccd1 sky130_fd_sc_hd__tapvpwrvgnd_1
X_12001_ net852 _01347_ net637 vssd1 vssd1 vccd1 vccd1 FPGA_INST.cell2.SB0.route_sel\[41\]
+ sky130_fd_sc_hd__dfstp_1
XANTENNA_fanout82_X net82 vssd1 vssd1 vccd1 vccd1 sky130_fd_sc_hd__diode_2
X_10193_ FPGA_INST.cell3.SB0.route_sel\[97\] FPGA_INST.cell3.SB0.route_sel\[98\] net285
+ vssd1 vssd1 vccd1 vccd1 _01074_ sky130_fd_sc_hd__mux2_1
XANTENNA__05963__A net129 vssd1 vssd1 vccd1 vccd1 sky130_fd_sc_hd__diode_2
XANTENNA__06041__A1 _02312_ vssd1 vssd1 vccd1 vccd1 sky130_fd_sc_hd__diode_2
XTAP_TAPCELL_ROW_6_362 vssd1 vccd1 sky130_fd_sc_hd__tapvpwrvgnd_1
XFILLER_120_477 vssd1 vssd1 vccd1 vccd1 sky130_fd_sc_hd__fill_1
Xfanout371 net372 vssd1 vssd1 vccd1 vccd1 net371 sky130_fd_sc_hd__buf_4
Xfanout393 FPGA_INST.cell3.CB_0.config_dataA\[16\] vssd1 vssd1 vccd1 vccd1 net393
+ sky130_fd_sc_hd__clkbuf_2
Xfanout360 net361 vssd1 vssd1 vccd1 vccd1 net360 sky130_fd_sc_hd__clkbuf_4
XFILLER_59_561 vssd1 vssd1 vccd1 vccd1 sky130_fd_sc_hd__fill_2
Xfanout382 _01822_ vssd1 vssd1 vccd1 vccd1 net382 sky130_fd_sc_hd__buf_2
XTAP_TAPCELL_ROW_6_373 vssd1 vccd1 sky130_fd_sc_hd__tapvpwrvgnd_1
XANTENNA__08869__A1 net26 vssd1 vssd1 vccd1 vccd1 sky130_fd_sc_hd__diode_2
XFILLER_86_391 vssd1 vssd1 vccd1 vccd1 sky130_fd_sc_hd__fill_4
XTAP_TAPCELL_ROW_66_1207 vssd1 vccd1 sky130_fd_sc_hd__tapvpwrvgnd_1
XTAP_TAPCELL_ROW_45_913 vssd1 vccd1 sky130_fd_sc_hd__tapvpwrvgnd_1
XFILLER_61_225 vssd1 vssd1 vccd1 vccd1 sky130_fd_sc_hd__fill_1
XANTENNA__08097__A2 _04013_ vssd1 vssd1 vccd1 vccd1 sky130_fd_sc_hd__diode_2
XANTENNA__07242__X _03504_ vssd1 vssd1 vccd1 vccd1 sky130_fd_sc_hd__diode_2
X_11716_ net922 _01062_ net706 vssd1 vssd1 vccd1 vccd1 FPGA_INST.cell3.SB0.route_sel\[86\]
+ sky130_fd_sc_hd__dfstp_1
XFILLER_70_770 vssd1 vssd1 vccd1 vccd1 sky130_fd_sc_hd__fill_2
X_11647_ net856 _00993_ net641 vssd1 vssd1 vccd1 vccd1 FPGA_INST.cell3.SB0.route_sel\[17\]
+ sky130_fd_sc_hd__dfstp_1
Xinput13 gpio_in[20] vssd1 vssd1 vccd1 vccd1 net13 sky130_fd_sc_hd__clkbuf_2
Xinput24 gpio_in[30] vssd1 vssd1 vccd1 vccd1 net24 sky130_fd_sc_hd__buf_2
X_11578_ net778 _00928_ net557 vssd1 vssd1 vccd1 vccd1 FPGA_INST.cell0.CB_0.config_dataB\[22\]
+ sky130_fd_sc_hd__dfstp_1
XFILLER_116_739 vssd1 vssd1 vccd1 vccd1 sky130_fd_sc_hd__fill_1
X_10529_ FPGA_INST.cell2.SB0.route_sel\[101\] FPGA_INST.cell2.SB0.route_sel\[102\]
+ net246 vssd1 vssd1 vccd1 vccd1 _01408_ sky130_fd_sc_hd__mux2_1
XTAP_TAPCELL_ROW_77_1358 vssd1 vccd1 sky130_fd_sc_hd__tapvpwrvgnd_1
XFILLER_123_260 vssd1 vssd1 vccd1 vccd1 sky130_fd_sc_hd__fill_2
XANTENNA__08021__A2 _03889_ vssd1 vssd1 vccd1 vccd1 sky130_fd_sc_hd__diode_2
XFILLER_111_422 vssd1 vssd1 vccd1 vccd1 sky130_fd_sc_hd__fill_4
XTAP_TAPCELL_ROW_90_1547 vssd1 vccd1 sky130_fd_sc_hd__tapvpwrvgnd_1
XTAP_TAPCELL_ROW_90_1536 vssd1 vccd1 sky130_fd_sc_hd__tapvpwrvgnd_1
XFILLER_35_3 vssd1 vssd1 vccd1 vccd1 sky130_fd_sc_hd__fill_2
XFILLER_97_689 vssd1 vssd1 vccd1 vccd1 sky130_fd_sc_hd__fill_1
XFILLER_96_166 vssd1 vssd1 vccd1 vccd1 sky130_fd_sc_hd__fill_4
X_07740_ FPGA_INST.cell3.SB0.route_sel\[117\] FPGA_INST.cell3.SB0.route_sel\[116\]
+ _03989_ vssd1 vssd1 vccd1 vccd1 _03990_ sky130_fd_sc_hd__and3_1
XANTENNA__06688__B _02836_ vssd1 vssd1 vccd1 vccd1 sky130_fd_sc_hd__diode_2
XFILLER_77_391 vssd1 vssd1 vccd1 vccd1 sky130_fd_sc_hd__fill_1
XFILLER_65_553 vssd1 vssd1 vccd1 vccd1 sky130_fd_sc_hd__fill_1
X_07671_ _03920_ _03921_ _03922_ _01933_ vssd1 vssd1 vccd1 vccd1 _03923_ sky130_fd_sc_hd__a31o_4
X_06622_ FPGA_INST.cell2.CB_1.config_dataA\[12\] _02897_ vssd1 vssd1 vccd1 vccd1 _02898_
+ sky130_fd_sc_hd__nand2_1
XFILLER_53_726 vssd1 vssd1 vccd1 vccd1 sky130_fd_sc_hd__fill_2
X_09410_ FPGA_INST.cell2.CB_1.config_dataA\[3\] FPGA_INST.cell2.CB_1.config_dataA\[4\]
+ net260 vssd1 vssd1 vccd1 vccd1 _00323_ sky130_fd_sc_hd__mux2_1
XFILLER_16_19 vssd1 vssd1 vccd1 vccd1 sky130_fd_sc_hd__fill_8
XFILLER_37_288 vssd1 vssd1 vccd1 vccd1 sky130_fd_sc_hd__fill_1
X_09341_ FPGA_INST.cell1.SB0.route_sel\[112\] FPGA_INST.cell1.SB0.route_sel\[113\]
+ net224 vssd1 vssd1 vccd1 vccd1 _00254_ sky130_fd_sc_hd__mux2_1
X_06553_ FPGA_INST.cell2.CB_1.config_dataA\[7\] _02826_ _02828_ FPGA_INST.cell2.CB_1.config_dataA\[8\]
+ vssd1 vssd1 vccd1 vccd1 _02829_ sky130_fd_sc_hd__o211a_1
X_05504_ net87 vssd1 vssd1 vccd1 vccd1 _01786_ sky130_fd_sc_hd__inv_2
XTAP_TAPCELL_ROW_23_607 vssd1 vccd1 sky130_fd_sc_hd__tapvpwrvgnd_1
X_09272_ FPGA_INST.cell1.SB0.route_sel\[43\] FPGA_INST.cell1.SB0.route_sel\[44\] net207
+ vssd1 vssd1 vccd1 vccd1 _00185_ sky130_fd_sc_hd__mux2_1
X_06484_ FPGA_INST.cell2.LE_0B.config_data\[15\] FPGA_INST.cell2.LE_0B.config_data\[14\]
+ _02688_ vssd1 vssd1 vccd1 vccd1 _02762_ sky130_fd_sc_hd__mux2_1
X_08223_ net407 _03504_ _04446_ FPGA_INST.cell0.CB_1.config_dataA\[11\] vssd1 vssd1
+ vccd1 vccd1 _04447_ sky130_fd_sc_hd__o211a_1
X_05435_ FPGA_INST.cell0.SB0.route_sel\[14\] vssd1 vssd1 vccd1 vccd1 _01717_ sky130_fd_sc_hd__inv_2
X_08154_ _01729_ FPGA_INST.cell1.LE_0B.dff_out vssd1 vssd1 vccd1 vccd1 _04379_ sky130_fd_sc_hd__or2_1
XANTENNA_fanout227_A net233 vssd1 vssd1 vccd1 vccd1 sky130_fd_sc_hd__diode_2
X_05366_ FPGA_INST.cell3.SB0.route_sel\[77\] vssd1 vssd1 vccd1 vccd1 _01648_ sky130_fd_sc_hd__inv_2
X_08085_ _04299_ _04303_ _04310_ vssd1 vssd1 vccd1 vccd1 _04311_ sky130_fd_sc_hd__o21ba_1
X_07105_ net427 _01839_ _03370_ net426 vssd1 vssd1 vccd1 vccd1 _03371_ sky130_fd_sc_hd__o211a_1
XANTENNA__08260__A2 _03682_ vssd1 vssd1 vccd1 vccd1 sky130_fd_sc_hd__diode_2
XANTENNA__09954__S net184 vssd1 vssd1 vccd1 vccd1 sky130_fd_sc_hd__diode_2
X_05297_ FPGA_INST.cell2.SB0.route_sel\[103\] vssd1 vssd1 vccd1 vccd1 _01579_ sky130_fd_sc_hd__inv_2
X_07036_ FPGA_INST.bus2_0\[6\] FPGA_INST.bus2_0\[7\] net436 vssd1 vssd1 vccd1 vccd1
+ _03302_ sky130_fd_sc_hd__mux2_1
XANTENNA__08711__X _04920_ vssd1 vssd1 vccd1 vccd1 sky130_fd_sc_hd__diode_2
XFILLER_106_249 vssd1 vssd1 vccd1 vccd1 sky130_fd_sc_hd__fill_1
XANTENNA_fanout596_A net627 vssd1 vssd1 vccd1 vccd1 sky130_fd_sc_hd__diode_2
XFILLER_121_219 vssd1 vssd1 vccd1 vccd1 sky130_fd_sc_hd__fill_4
Xteam_15_952 vssd1 vssd1 vccd1 vccd1 team_15_952/HI gpio_oeb[12] sky130_fd_sc_hd__conb_1
XANTENNA__08012__A2 FPGA_INST.bus3_1\[2\] vssd1 vssd1 vccd1 vccd1 sky130_fd_sc_hd__diode_2
XFILLER_88_623 vssd1 vssd1 vccd1 vccd1 sky130_fd_sc_hd__fill_8
XFILLER_88_612 vssd1 vssd1 vccd1 vccd1 sky130_fd_sc_hd__fill_1
XFILLER_87_111 vssd1 vssd1 vccd1 vccd1 sky130_fd_sc_hd__fill_1
XFILLER_0_527 vssd1 vssd1 vccd1 vccd1 sky130_fd_sc_hd__fill_1
Xteam_15_963 vssd1 vssd1 vccd1 vccd1 team_15_963/HI gpio_out[0] sky130_fd_sc_hd__conb_1
XFILLER_88_667 vssd1 vssd1 vccd1 vccd1 sky130_fd_sc_hd__fill_1
XFILLER_88_645 vccd1 vssd1 vccd1 vssd1 sky130_ef_sc_hd__decap_40_12
Xteam_15_974 vssd1 vssd1 vccd1 vccd1 gpio_oeb[8] team_15_974/LO sky130_fd_sc_hd__conb_1
X_08987_ FPGA_INST.cell1.SB0.route_sel\[44\] _01684_ _05164_ vssd1 vssd1 vccd1 vccd1
+ _05165_ sky130_fd_sc_hd__o21ai_1
XANTENNA_fanout763_A net769 vssd1 vssd1 vccd1 vccd1 sky130_fd_sc_hd__diode_2
XFILLER_29_712 vccd1 vssd1 vccd1 vssd1 sky130_ef_sc_hd__decap_40_12
XFILLER_102_499 vssd1 vssd1 vccd1 vccd1 sky130_fd_sc_hd__fill_2
X_07938_ net466 _03889_ _04165_ vssd1 vssd1 vccd1 vccd1 _04166_ sky130_fd_sc_hd__a21o_1
XFILLER_56_520 vssd1 vssd1 vccd1 vccd1 sky130_fd_sc_hd__fill_8
XTAP_TAPCELL_ROW_3_321 vssd1 vccd1 sky130_fd_sc_hd__tapvpwrvgnd_1
X_07869_ _03810_ _04083_ _04096_ vssd1 vssd1 vccd1 vccd1 _04097_ sky130_fd_sc_hd__o21ai_1
XANTENNA_fanout930_A net931 vssd1 vssd1 vccd1 vccd1 sky130_fd_sc_hd__diode_2
X_10880_ net798 _00230_ net583 vssd1 vssd1 vccd1 vccd1 FPGA_INST.cell1.SB0.route_sel\[89\]
+ sky130_fd_sc_hd__dfstp_1
X_09608_ FPGA_INST.cell0.SB0.route_sel\[12\] FPGA_INST.cell0.SB0.route_sel\[11\] net323
+ vssd1 vssd1 vccd1 vccd1 _00517_ sky130_fd_sc_hd__mux2_1
XFILLER_43_225 vssd1 vssd1 vccd1 vccd1 sky130_fd_sc_hd__fill_1
XFILLER_28_277 vssd1 vssd1 vccd1 vccd1 sky130_fd_sc_hd__fill_1
X_09539_ FPGA_INST.cell1.LE_0B.config_data\[11\] FPGA_INST.cell1.LE_0B.config_data\[12\]
+ net232 vssd1 vssd1 vccd1 vccd1 _00449_ sky130_fd_sc_hd__mux2_1
XFILLER_71_567 vssd1 vssd1 vccd1 vccd1 sky130_fd_sc_hd__fill_1
XANTENNA__08079__A2 FPGA_INST.bus3_1\[6\] vssd1 vssd1 vccd1 vccd1 sky130_fd_sc_hd__diode_2
XFILLER_71_589 vssd1 vssd1 vccd1 vccd1 sky130_fd_sc_hd__fill_4
XANTENNA__07222__B _03483_ vssd1 vssd1 vccd1 vccd1 sky130_fd_sc_hd__diode_2
XTAP_TAPCELL_ROW_61_1137 vssd1 vccd1 sky130_fd_sc_hd__tapvpwrvgnd_1
X_11501_ net763 _00851_ net548 vssd1 vssd1 vccd1 vccd1 FPGA_INST.cell0.CB_1.config_dataB\[7\]
+ sky130_fd_sc_hd__dfstp_1
XFILLER_11_144 vssd1 vssd1 vccd1 vccd1 sky130_fd_sc_hd__fill_1
XTAP_TAPCELL_ROW_117_1915 vssd1 vccd1 sky130_fd_sc_hd__tapvpwrvgnd_1
XTAP_TAPCELL_ROW_50_982 vssd1 vccd1 sky130_fd_sc_hd__tapvpwrvgnd_1
X_11432_ net775 _00782_ net561 vssd1 vssd1 vccd1 vccd1 FPGA_INST.cell0.LE_0A.config_data\[3\]
+ sky130_fd_sc_hd__dfrtp_1
XANTENNA__07039__A0 FPGA_INST.bus2_0\[2\] vssd1 vssd1 vccd1 vccd1 sky130_fd_sc_hd__diode_2
XFILLER_125_503 vssd1 vssd1 vccd1 vccd1 sky130_fd_sc_hd__fill_1
XTAP_TAPCELL_ROW_117_1926 vssd1 vccd1 sky130_fd_sc_hd__tapvpwrvgnd_1
X_11363_ net835 _00713_ net619 vssd1 vssd1 vccd1 vccd1 FPGA_INST.cell1.LE_1B.config_data\[5\]
+ sky130_fd_sc_hd__dfrtp_1
XANTENNA__06262__A1 _02131_ vssd1 vssd1 vccd1 vccd1 sky130_fd_sc_hd__diode_2
X_10314_ FPGA_INST.cell3.LEI0.config_data\[28\] FPGA_INST.cell3.LEI0.config_data\[29\]
+ net298 vssd1 vssd1 vccd1 vccd1 _01195_ sky130_fd_sc_hd__mux2_1
X_11294_ net832 _00644_ net616 vssd1 vssd1 vccd1 vccd1 FPGA_INST.cell1.CB_0.config_dataA\[11\]
+ sky130_fd_sc_hd__dfstp_1
XFILLER_98_55 vssd1 vssd1 vccd1 vccd1 sky130_fd_sc_hd__fill_1
XANTENNA__06262__B2 _02168_ vssd1 vssd1 vccd1 vccd1 sky130_fd_sc_hd__diode_2
XFILLER_121_720 vssd1 vssd1 vccd1 vccd1 sky130_fd_sc_hd__fill_8
X_10245_ FPGA_INST.io_south_oeb\[10\] FPGA_INST.io_south_oeb\[12\] net289 vssd1 vssd1
+ vccd1 vccd1 _01126_ sky130_fd_sc_hd__mux2_1
XFILLER_3_376 vssd1 vssd1 vccd1 vccd1 sky130_fd_sc_hd__fill_4
XFILLER_121_753 vssd1 vssd1 vccd1 vccd1 sky130_fd_sc_hd__fill_4
X_10176_ FPGA_INST.cell3.SB0.route_sel\[80\] FPGA_INST.cell3.SB0.route_sel\[81\] net288
+ vssd1 vssd1 vccd1 vccd1 _01057_ sky130_fd_sc_hd__mux2_1
XTAP_TAPCELL_ROW_72_1288 vssd1 vccd1 sky130_fd_sc_hd__tapvpwrvgnd_1
XFILLER_21_9 vssd1 vssd1 vccd1 vccd1 sky130_fd_sc_hd__fill_1
XFILLER_66_339 vssd1 vssd1 vccd1 vccd1 sky130_fd_sc_hd__fill_4
XFILLER_59_391 vssd1 vssd1 vccd1 vccd1 sky130_fd_sc_hd__fill_1
Xfanout190 net202 vssd1 vssd1 vccd1 vccd1 net190 sky130_fd_sc_hd__clkbuf_4
XANTENNA__09503__A2 net523 vssd1 vssd1 vccd1 vccd1 sky130_fd_sc_hd__diode_2
XFILLER_19_244 vssd1 vssd1 vccd1 vccd1 sky130_fd_sc_hd__fill_2
XFILLER_19_288 vssd1 vssd1 vccd1 vccd1 sky130_fd_sc_hd__fill_1
XFILLER_35_726 vssd1 vssd1 vccd1 vccd1 sky130_fd_sc_hd__fill_2
XANTENNA__06868__A3 FPGA_INST.bus2_0\[15\] vssd1 vssd1 vccd1 vccd1 sky130_fd_sc_hd__diode_2
X_09890_ FPGA_INST.cell0.LE_0A.reset_val FPGA_INST.cell0.LE_0A.edge_mode net318 vssd1
+ vssd1 vccd1 vccd1 _00797_ sky130_fd_sc_hd__mux2_1
X_08910_ _05113_ _01866_ vssd1 vssd1 vccd1 vccd1 FPGA_INST.bus2_0\[14\] sky130_fd_sc_hd__and2b_2
XFILLER_112_731 vssd1 vssd1 vccd1 vccd1 sky130_fd_sc_hd__fill_4
X_08841_ _05046_ _05047_ _05040_ _05044_ vssd1 vssd1 vccd1 vccd1 _05048_ sky130_fd_sc_hd__o211a_1
XFILLER_85_615 vssd1 vssd1 vccd1 vccd1 sky130_fd_sc_hd__fill_1
XANTENNA__07753__A1 net150 vssd1 vssd1 vccd1 vccd1 sky130_fd_sc_hd__diode_2
XFILLER_112_797 vssd1 vssd1 vccd1 vccd1 sky130_fd_sc_hd__fill_2
XFILLER_111_285 vssd1 vssd1 vccd1 vccd1 sky130_fd_sc_hd__fill_1
X_08772_ net22 net24 net25 net26 net390 net389 vssd1 vssd1 vccd1 vccd1 _04979_ sky130_fd_sc_hd__mux4_1
X_05984_ net168 net160 FPGA_INST.bus2_0\[4\] vssd1 vssd1 vccd1 vccd1 _02264_ sky130_fd_sc_hd__o21ba_1
XFILLER_38_531 vssd1 vssd1 vccd1 vccd1 sky130_fd_sc_hd__fill_1
X_07723_ _03954_ _03973_ _03956_ vssd1 vssd1 vccd1 vccd1 _03974_ sky130_fd_sc_hd__a21oi_1
XANTENNA__06308__A2 _02255_ vssd1 vssd1 vccd1 vccd1 sky130_fd_sc_hd__diode_2
X_07654_ FPGA_INST.cell3.SB0.route_sel\[96\] FPGA_INST.cell3.SB0.route_sel\[97\] vssd1
+ vssd1 vccd1 vccd1 _03906_ sky130_fd_sc_hd__nand2_1
XANTENNA__07505__B2 _03760_ vssd1 vssd1 vccd1 vccd1 sky130_fd_sc_hd__diode_2
XFILLER_53_501 vssd1 vssd1 vccd1 vccd1 sky130_fd_sc_hd__fill_2
X_06605_ net477 net478 vssd1 vssd1 vccd1 vccd1 _02881_ sky130_fd_sc_hd__nand2b_1
XFILLER_53_534 vssd1 vssd1 vccd1 vccd1 sky130_fd_sc_hd__fill_4
XFILLER_25_258 vssd1 vssd1 vccd1 vccd1 sky130_fd_sc_hd__fill_1
XANTENNA_fanout344_A net349 vssd1 vssd1 vccd1 vccd1 sky130_fd_sc_hd__diode_2
X_07585_ _01645_ FPGA_INST.cell0.SB0.route_sel\[87\] vssd1 vssd1 vccd1 vccd1 _03839_
+ sky130_fd_sc_hd__or2_1
XTAP_TAPCELL_ROW_36_787 vssd1 vccd1 sky130_fd_sc_hd__tapvpwrvgnd_1
X_09324_ FPGA_INST.cell1.SB0.route_sel\[96\] FPGA_INST.cell1.SB0.route_sel\[95\] net328
+ vssd1 vssd1 vccd1 vccd1 _00237_ sky130_fd_sc_hd__mux2_1
X_06536_ FPGA_INST.cell2.SB0.route_sel\[124\] FPGA_INST.cell2.SB0.route_sel\[125\]
+ vssd1 vssd1 vccd1 vccd1 _02812_ sky130_fd_sc_hd__nor2_1
XANTENNA__09949__S net184 vssd1 vssd1 vccd1 vccd1 sky130_fd_sc_hd__diode_2
X_09255_ FPGA_INST.cell1.SB0.route_sel\[26\] FPGA_INST.cell1.SB0.route_sel\[27\] net220
+ vssd1 vssd1 vccd1 vccd1 _00168_ sky130_fd_sc_hd__mux2_1
XANTENNA_fanout132_X net132 vssd1 vssd1 vccd1 vccd1 sky130_fd_sc_hd__diode_2
X_06467_ _02131_ _02728_ _02729_ _02168_ FPGA_INST.cell2.CB_0.config_dataB\[17\] vssd1
+ vssd1 vccd1 vccd1 _02745_ sky130_fd_sc_hd__a221o_1
X_08206_ net409 _03997_ _04429_ net408 vssd1 vssd1 vccd1 vccd1 _04430_ sky130_fd_sc_hd__o211a_1
X_05418_ FPGA_INST.cell0.SB0.route_sel\[30\] vssd1 vssd1 vccd1 vccd1 _01700_ sky130_fd_sc_hd__inv_2
X_06398_ net497 _01869_ _02675_ net496 vssd1 vssd1 vccd1 vccd1 _02676_ sky130_fd_sc_hd__o211a_1
X_09186_ FPGA_INST.cell2.LE_1A.config_data\[3\] FPGA_INST.cell2.LE_1A.config_data\[4\]
+ net263 vssd1 vssd1 vccd1 vccd1 _00099_ sky130_fd_sc_hd__mux2_1
X_08137_ FPGA_INST.cell1.CB_0.config_dataB\[18\] _04335_ FPGA_INST.cell1.CB_0.config_dataB\[17\]
+ FPGA_INST.cell1.CB_0.config_dataB\[19\] vssd1 vssd1 vccd1 vccd1 _04363_ sky130_fd_sc_hd__or4b_1
X_05349_ FPGA_INST.cell0.SB0.route_sel\[103\] vssd1 vssd1 vccd1 vccd1 _01631_ sky130_fd_sc_hd__inv_2
XFILLER_4_118 vssd1 vssd1 vccd1 vccd1 sky130_fd_sc_hd__fill_2
X_08068_ net151 net144 net149 net142 FPGA_INST.cell1.LEI0.config_data\[3\] FPGA_INST.cell1.LEI0.config_data\[4\]
+ vssd1 vssd1 vccd1 vccd1 _04294_ sky130_fd_sc_hd__mux4_1
XANTENNA__09684__S net314 vssd1 vssd1 vccd1 vccd1 sky130_fd_sc_hd__diode_2
XANTENNA__10623__S net378 vssd1 vssd1 vccd1 vccd1 sky130_fd_sc_hd__diode_2
XTAP_TAPCELL_ROW_112_1845 vssd1 vccd1 sky130_fd_sc_hd__tapvpwrvgnd_1
X_07019_ _03284_ vssd1 vssd1 vccd1 vccd1 _03285_ sky130_fd_sc_hd__inv_2
XTAP_TAPCELL_ROW_112_1856 vssd1 vccd1 sky130_fd_sc_hd__tapvpwrvgnd_1
XFILLER_103_753 vssd1 vssd1 vccd1 vccd1 sky130_fd_sc_hd__fill_2
XFILLER_0_335 vssd1 vssd1 vccd1 vccd1 sky130_fd_sc_hd__fill_1
X_10030_ FPGA_INST.cell0.CB_0.config_dataB\[4\] net421 net180 vssd1 vssd1 vccd1 vccd1
+ _00911_ sky130_fd_sc_hd__mux2_1
XFILLER_88_486 vccd1 vssd1 vccd1 vssd1 sky130_ef_sc_hd__decap_40_12
XFILLER_88_475 vssd1 vssd1 vccd1 vccd1 sky130_fd_sc_hd__fill_1
XFILLER_75_169 vssd1 vssd1 vccd1 vccd1 sky130_fd_sc_hd__fill_4
X_11981_ net844 _01327_ net629 vssd1 vssd1 vccd1 vccd1 FPGA_INST.cell2.SB0.route_sel\[21\]
+ sky130_fd_sc_hd__dfstp_1
XFILLER_17_704 vssd1 vssd1 vccd1 vccd1 sky130_fd_sc_hd__fill_4
XFILLER_56_361 vssd1 vssd1 vccd1 vccd1 sky130_fd_sc_hd__fill_2
X_10932_ net846 _00282_ net631 vssd1 vssd1 vccd1 vccd1 FPGA_INST.cell2.CB_0.config_dataA\[13\]
+ sky130_fd_sc_hd__dfstp_1
XFILLER_17_726 vssd1 vssd1 vccd1 vccd1 sky130_fd_sc_hd__fill_2
X_10863_ net800 _00213_ net585 vssd1 vssd1 vccd1 vccd1 FPGA_INST.cell1.SB0.route_sel\[72\]
+ sky130_fd_sc_hd__dfstp_1
X_10794_ net824 _00144_ net608 vssd1 vssd1 vccd1 vccd1 FPGA_INST.cell1.SB0.route_sel\[3\]
+ sky130_fd_sc_hd__dfstp_1
XFILLER_71_397 vssd1 vssd1 vccd1 vccd1 sky130_fd_sc_hd__fill_2
XANTENNA__07887__B _03728_ vssd1 vssd1 vccd1 vccd1 sky130_fd_sc_hd__diode_2
XFILLER_12_464 vccd1 vssd1 vccd1 vssd1 sky130_ef_sc_hd__decap_40_12
XFILLER_8_457 vssd1 vssd1 vccd1 vccd1 sky130_fd_sc_hd__fill_8
X_11415_ net744 _00765_ net529 vssd1 vssd1 vccd1 vccd1 FPGA_INST.cell0.LEI0.config_data\[36\]
+ sky130_fd_sc_hd__dfrtp_1
XFILLER_125_344 vssd1 vssd1 vccd1 vccd1 sky130_fd_sc_hd__fill_1
X_11346_ net793 _00696_ net578 vssd1 vssd1 vccd1 vccd1 FPGA_INST.cell1.CB_1.config_dataA\[13\]
+ sky130_fd_sc_hd__dfstp_1
XTAP_TAPCELL_ROW_74_1317 vssd1 vccd1 sky130_fd_sc_hd__tapvpwrvgnd_1
XANTENNA__06235__A1 net2 vssd1 vssd1 vccd1 vccd1 sky130_fd_sc_hd__diode_2
XANTENNA__06235__B2 net30 vssd1 vssd1 vccd1 vccd1 sky130_fd_sc_hd__diode_2
XANTENNA__05975__X _02255_ vssd1 vssd1 vccd1 vccd1 sky130_fd_sc_hd__diode_2
XANTENNA__07983__A1 _03932_ vssd1 vssd1 vccd1 vccd1 sky130_fd_sc_hd__diode_2
XANTENNA__10533__S net244 vssd1 vssd1 vccd1 vccd1 sky130_fd_sc_hd__diode_2
X_11277_ net786 _00627_ net571 vssd1 vssd1 vccd1 vccd1 FPGA_INST.cell0.SB0.route_sel\[122\]
+ sky130_fd_sc_hd__dfstp_1
XFILLER_3_173 vssd1 vssd1 vccd1 vccd1 sky130_fd_sc_hd__fill_1
XFILLER_121_561 vssd1 vssd1 vccd1 vccd1 sky130_fd_sc_hd__fill_4
X_10228_ FPGA_INST.io_west_oeb\[8\] FPGA_INST.io_west_oeb\[10\] net291 vssd1 vssd1
+ vccd1 vccd1 _01109_ sky130_fd_sc_hd__mux2_1
XANTENNA__10830__Q FPGA_INST.cell1.SB0.route_sel\[39\] vssd1 vssd1 vccd1 vccd1 sky130_fd_sc_hd__diode_2
XFILLER_39_306 vssd1 vssd1 vccd1 vccd1 sky130_fd_sc_hd__fill_1
XFILLER_39_317 vccd1 vssd1 vccd1 vssd1 sky130_ef_sc_hd__decap_40_12
XFILLER_94_412 vssd1 vssd1 vccd1 vccd1 sky130_fd_sc_hd__fill_8
X_10159_ FPGA_INST.cell3.SB0.route_sel\[64\] FPGA_INST.cell3.SB0.route_sel\[63\] net366
+ vssd1 vssd1 vccd1 vccd1 _01040_ sky130_fd_sc_hd__mux2_1
XFILLER_66_103 vssd1 vssd1 vccd1 vccd1 sky130_fd_sc_hd__fill_1
XFILLER_82_618 vssd1 vssd1 vccd1 vccd1 sky130_fd_sc_hd__fill_8
XANTENNA__08160__A1 _03959_ vssd1 vssd1 vccd1 vccd1 sky130_fd_sc_hd__diode_2
XANTENNA__08160__B2 _03923_ vssd1 vssd1 vccd1 vccd1 sky130_fd_sc_hd__diode_2
XTAP_TAPCELL_ROW_85_1479 vssd1 vccd1 sky130_fd_sc_hd__tapvpwrvgnd_1
XTAP_TAPCELL_ROW_85_1468 vssd1 vccd1 sky130_fd_sc_hd__tapvpwrvgnd_1
XANTENNA__11661__Q FPGA_INST.cell3.SB0.route_sel\[31\] vssd1 vssd1 vccd1 vccd1 sky130_fd_sc_hd__diode_2
XFILLER_23_729 vssd1 vssd1 vccd1 vccd1 sky130_fd_sc_hd__fill_4
X_07370_ _01688_ FPGA_INST.cell3.SB0.route_sel\[35\] _01689_ FPGA_INST.cell3.SB0.route_sel\[36\]
+ _03629_ vssd1 vssd1 vccd1 vccd1 _03630_ sky130_fd_sc_hd__o221a_1
XANTENNA__09769__S net348 vssd1 vssd1 vccd1 vccd1 sky130_fd_sc_hd__diode_2
XTAP_TAPCELL_ROW_33_746 vssd1 vccd1 sky130_fd_sc_hd__tapvpwrvgnd_1
X_06321_ _02597_ _02600_ _02593_ vssd1 vssd1 vccd1 vccd1 _02601_ sky130_fd_sc_hd__a21oi_1
X_09040_ net618 FPGA_INST.cell1.LE_0A.reset_mode vssd1 vssd1 vccd1 vccd1 _09040_/X
+ sky130_fd_sc_hd__xor2_2
XANTENNA__07266__A3 _03526_ vssd1 vssd1 vccd1 vccd1 sky130_fd_sc_hd__diode_2
X_06252_ FPGA_INST.cell2.CB_0.config_dataA\[4\] _02520_ _02531_ vssd1 vssd1 vccd1
+ vccd1 _02532_ sky130_fd_sc_hd__or3b_1
XTAP_TAPCELL_ROW_13_470 vssd1 vccd1 sky130_fd_sc_hd__tapvpwrvgnd_1
X_06183_ FPGA_INST.cell0.SB0.route_sel\[3\] FPGA_INST.cell0.SB0.route_sel\[2\] vssd1
+ vssd1 vccd1 vccd1 _02463_ sky130_fd_sc_hd__nor2_1
XFILLER_89_217 vssd1 vssd1 vccd1 vccd1 sky130_fd_sc_hd__fill_4
X_09942_ FPGA_INST.cell0.CB_1.config_dataB\[3\] FPGA_INST.cell0.CB_1.config_dataB\[2\]
+ net327 vssd1 vssd1 vccd1 vccd1 _00847_ sky130_fd_sc_hd__mux2_1
Xfanout915 net917 vssd1 vssd1 vccd1 vccd1 net915 sky130_fd_sc_hd__clkbuf_2
Xfanout904 net918 vssd1 vssd1 vccd1 vccd1 net904 sky130_fd_sc_hd__clkbuf_2
Xfanout937 net945 vssd1 vssd1 vccd1 vccd1 net937 sky130_fd_sc_hd__clkbuf_2
XANTENNA_fanout294_A net295 vssd1 vssd1 vccd1 vccd1 sky130_fd_sc_hd__diode_2
Xfanout926 net931 vssd1 vssd1 vccd1 vccd1 net926 sky130_fd_sc_hd__clkbuf_2
XANTENNA__06529__A2 _02801_ vssd1 vssd1 vccd1 vccd1 sky130_fd_sc_hd__diode_2
X_09873_ FPGA_INST.cell0.LE_0A.config_data\[1\] FPGA_INST.cell0.LE_0A.config_data\[0\]
+ net316 vssd1 vssd1 vccd1 vccd1 _00780_ sky130_fd_sc_hd__mux2_1
X_08824_ _05006_ _05028_ _05030_ FPGA_INST.cell3.LEI0.config_data\[5\] vssd1 vssd1
+ vccd1 vccd1 _05031_ sky130_fd_sc_hd__o22a_1
XTAP_TAPCELL_ROW_127_2063 vssd1 vccd1 sky130_fd_sc_hd__tapvpwrvgnd_1
X_08755_ FPGA_INST.cell3.LE_0A.config_data\[15\] FPGA_INST.cell3.LE_0A.config_data\[14\]
+ _04860_ vssd1 vssd1 vccd1 vccd1 _04964_ sky130_fd_sc_hd__mux2_1
XFILLER_85_445 vssd1 vssd1 vccd1 vccd1 sky130_fd_sc_hd__fill_1
XFILLER_72_106 vssd1 vssd1 vccd1 vccd1 sky130_fd_sc_hd__fill_1
XANTENNA_fanout559_A net561 vssd1 vssd1 vccd1 vccd1 sky130_fd_sc_hd__diode_2
X_05967_ _01859_ _02209_ vssd1 vssd1 vccd1 vccd1 _02247_ sky130_fd_sc_hd__nor2_1
X_07706_ FPGA_INST.cell0.SB0.route_sel\[108\] FPGA_INST.cell0.SB0.route_sel\[109\]
+ vssd1 vssd1 vccd1 vccd1 _03957_ sky130_fd_sc_hd__nor2_1
X_08686_ net397 net396 vssd1 vssd1 vccd1 vccd1 _04895_ sky130_fd_sc_hd__nor2_1
X_05898_ FPGA_INST.cell0.CB_1.config_dataB\[23\] FPGA_INST.cell0.CB_1.config_dataB\[22\]
+ vssd1 vssd1 vccd1 vccd1 _02178_ sky130_fd_sc_hd__nand2b_1
XANTENNA_fanout726_A net729 vssd1 vssd1 vccd1 vccd1 sky130_fd_sc_hd__diode_2
X_07637_ _03549_ _03748_ _03889_ vssd1 vssd1 vccd1 vccd1 _03890_ sky130_fd_sc_hd__o21ai_1
X_07568_ _03483_ _03821_ _03822_ FPGA_INST.cell3.SB0.route_sel\[73\] FPGA_INST.cell3.SB0.route_sel\[72\]
+ vssd1 vssd1 vccd1 vccd1 _03823_ sky130_fd_sc_hd__a32o_1
XFILLER_53_386 vssd1 vssd1 vccd1 vccd1 sky130_fd_sc_hd__fill_4
XFILLER_53_397 vssd1 vssd1 vccd1 vccd1 sky130_fd_sc_hd__fill_2
X_09307_ FPGA_INST.cell1.SB0.route_sel\[79\] FPGA_INST.cell1.SB0.route_sel\[78\] net328
+ vssd1 vssd1 vccd1 vccd1 _00220_ sky130_fd_sc_hd__mux2_1
X_06519_ _01562_ FPGA_INST.cell2.SB0.route_sel\[57\] FPGA_INST.cell2.SB0.route_sel\[62\]
+ _01563_ _02794_ vssd1 vssd1 vccd1 vccd1 _02795_ sky130_fd_sc_hd__a221o_1
XANTENNA__10618__S net378 vssd1 vssd1 vccd1 vccd1 sky130_fd_sc_hd__diode_2
XFILLER_110_99 vccd1 vssd1 vccd1 vssd1 sky130_ef_sc_hd__decap_40_12
X_07499_ FPGA_INST.cell1.SB0.route_sel\[67\] FPGA_INST.cell1.SB0.route_sel\[66\] vssd1
+ vssd1 vccd1 vccd1 _03755_ sky130_fd_sc_hd__nand2_1
X_09238_ FPGA_INST.cell1.SB0.route_sel\[10\] FPGA_INST.cell1.SB0.route_sel\[9\] net341
+ vssd1 vssd1 vccd1 vccd1 _00151_ sky130_fd_sc_hd__mux2_1
XFILLER_119_42 vccd1 vssd1 vccd1 vssd1 sky130_ef_sc_hd__decap_40_12
XANTENNA__08206__A2 _03997_ vssd1 vssd1 vccd1 vccd1 sky130_fd_sc_hd__diode_2
XFILLER_5_405 vccd1 vssd1 vccd1 vssd1 sky130_ef_sc_hd__decap_40_12
X_09169_ FPGA_INST.cell2.LE_0B.config_data\[9\] FPGA_INST.cell2.LE_0B.config_data\[10\]
+ net255 vssd1 vssd1 vccd1 vccd1 _00083_ sky130_fd_sc_hd__mux2_1
X_12180_ net909 _01526_ net693 vssd1 vssd1 vccd1 vccd1 FPGA_INST.cell3.LE_1B.edge_mode
+ sky130_fd_sc_hd__dfstp_1
X_11200_ net761 _00550_ net546 vssd1 vssd1 vccd1 vccd1 FPGA_INST.cell0.SB0.route_sel\[45\]
+ sky130_fd_sc_hd__dfstp_1
X_11131_ net816 _00481_ net601 vssd1 vssd1 vccd1 vccd1 FPGA_INST.cell1.CB_1.config_dataB\[1\]
+ sky130_fd_sc_hd__dfstp_1
XFILLER_102_3 vccd1 vssd1 vccd1 vssd1 sky130_ef_sc_hd__decap_40_12
XANTENNA__07965__A1 FPGA_INST.bus3_1\[5\] vssd1 vssd1 vccd1 vccd1 sky130_fd_sc_hd__diode_2
XANTENNA__10353__S net374 vssd1 vssd1 vccd1 vccd1 sky130_fd_sc_hd__diode_2
XANTENNA__08331__B _03875_ vssd1 vssd1 vccd1 vccd1 sky130_fd_sc_hd__diode_2
XTAP_TAPCELL_ROW_56_1069 vssd1 vccd1 sky130_fd_sc_hd__tapvpwrvgnd_1
XFILLER_0_110 vssd1 vssd1 vccd1 vccd1 sky130_fd_sc_hd__fill_2
XANTENNA__08509__A3 net79 vssd1 vssd1 vccd1 vccd1 sky130_fd_sc_hd__diode_2
X_11062_ net807 _00412_ net598 vssd1 vssd1 vccd1 vccd1 FPGA_INST.cell1.CB_0.config_data_inA
+ sky130_fd_sc_hd__dfrtp_1
XFILLER_103_561 vssd1 vssd1 vccd1 vccd1 sky130_fd_sc_hd__fill_1
XFILLER_95_23 vssd1 vssd1 vccd1 vccd1 sky130_fd_sc_hd__fill_1
XFILLER_49_615 vssd1 vssd1 vccd1 vccd1 sky130_fd_sc_hd__fill_1
XFILLER_103_583 vssd1 vssd1 vccd1 vccd1 sky130_fd_sc_hd__fill_1
XANTENNA__08758__S _04860_ vssd1 vssd1 vccd1 vccd1 sky130_fd_sc_hd__diode_2
X_10013_ FPGA_INST.cell0.CB_0.config_dataA\[13\] FPGA_INST.cell0.CB_0.config_dataA\[12\]
+ net319 vssd1 vssd1 vccd1 vccd1 _00894_ sky130_fd_sc_hd__mux2_1
XANTENNA_input22_A gpio_in[29] vssd1 vssd1 vccd1 vccd1 sky130_fd_sc_hd__diode_2
XANTENNA__07515__X _03771_ vssd1 vssd1 vccd1 vccd1 sky130_fd_sc_hd__diode_2
XANTENNA__08390__B2 net77 vssd1 vssd1 vccd1 vccd1 sky130_fd_sc_hd__diode_2
XANTENNA__08390__A1 FPGA_INST.bus1_0\[13\] vssd1 vssd1 vccd1 vccd1 sky130_fd_sc_hd__diode_2
XFILLER_48_136 vssd1 vssd1 vccd1 vccd1 sky130_fd_sc_hd__fill_4
X_11964_ net783 _01310_ net568 vssd1 vssd1 vccd1 vccd1 FPGA_INST.cell2.SB0.route_sel\[4\]
+ sky130_fd_sc_hd__dfstp_1
X_11895_ net939 _01241_ net723 vssd1 vssd1 vccd1 vccd1 FPGA_INST.cell3.LE_0B.config_data\[3\]
+ sky130_fd_sc_hd__dfrtp_1
X_10915_ net787 _00265_ net572 vssd1 vssd1 vccd1 vccd1 FPGA_INST.cell1.SB0.route_sel\[124\]
+ sky130_fd_sc_hd__dfstp_1
XANTENNA__07350__C1 FPGA_INST.cell1.SB0.route_sel\[33\] vssd1 vssd1 vccd1 vccd1 sky130_fd_sc_hd__diode_2
X_10846_ net799 _00196_ net584 vssd1 vssd1 vccd1 vccd1 FPGA_INST.cell1.SB0.route_sel\[55\]
+ sky130_fd_sc_hd__dfstp_1
XFILLER_32_537 vssd1 vssd1 vccd1 vccd1 sky130_fd_sc_hd__fill_2
XANTENNA__05900__B1 FPGA_INST.bus1_0\[7\] vssd1 vssd1 vccd1 vccd1 sky130_fd_sc_hd__diode_2
XFILLER_13_740 vssd1 vssd1 vccd1 vccd1 sky130_fd_sc_hd__fill_1
X_10777_ net901 _00127_ net685 vssd1 vssd1 vccd1 vccd1 FPGA_INST.cell2.CB_1.config_dataB\[11\]
+ sky130_fd_sc_hd__dfstp_1
XFILLER_9_722 vssd1 vssd1 vccd1 vccd1 sky130_fd_sc_hd__fill_4
XFILLER_8_210 vssd1 vssd1 vccd1 vccd1 sky130_fd_sc_hd__fill_2
XTAP_TAPCELL_ROW_30_705 vssd1 vccd1 sky130_fd_sc_hd__tapvpwrvgnd_1
XTAP_TAPCELL_ROW_80_1398 vssd1 vccd1 sky130_fd_sc_hd__tapvpwrvgnd_1
XFILLER_125_196 vssd1 vssd1 vccd1 vccd1 sky130_fd_sc_hd__fill_2
X_11329_ net830 _00679_ net614 vssd1 vssd1 vccd1 vccd1 FPGA_INST.cell1.CB_0.config_dataB\[21\]
+ sky130_fd_sc_hd__dfstp_2
XPHY_EDGE_ROW_105_Left_236 vssd1 vssd1 vccd1 vccd1 sky130_fd_sc_hd__decap_3
X_06870_ _03136_ _03137_ _01741_ vssd1 vssd1 vccd1 vccd1 _03138_ sky130_fd_sc_hd__mux2_1
XFILLER_39_125 vssd1 vssd1 vccd1 vccd1 sky130_fd_sc_hd__fill_2
X_05821_ net96 net165 net161 _02019_ _01975_ vssd1 vssd1 vccd1 vccd1 _02101_ sky130_fd_sc_hd__o32a_1
XANTENNA__05881__A net135 vssd1 vssd1 vccd1 vccd1 sky130_fd_sc_hd__diode_2
XANTENNA__07425__X _03683_ vssd1 vssd1 vccd1 vccd1 sky130_fd_sc_hd__diode_2
XFILLER_39_136 vssd1 vssd1 vccd1 vccd1 sky130_fd_sc_hd__fill_1
XFILLER_54_106 vssd1 vssd1 vccd1 vccd1 sky130_fd_sc_hd__fill_1
XTAP_TAPCELL_ROW_38_816 vssd1 vccd1 sky130_fd_sc_hd__tapvpwrvgnd_1
XFILLER_39_169 vssd1 vssd1 vccd1 vccd1 sky130_fd_sc_hd__fill_2
X_08540_ FPGA_INST.cell3.LEI0.config_data\[23\] _04749_ _04750_ FPGA_INST.cell3.CB_1.config_dataB\[9\]
+ vssd1 vssd1 vccd1 vccd1 _04751_ sky130_fd_sc_hd__o211a_1
XANTENNA__08133__A1 _03973_ vssd1 vssd1 vccd1 vccd1 sky130_fd_sc_hd__diode_2
XFILLER_47_180 vssd1 vssd1 vccd1 vccd1 sky130_fd_sc_hd__fill_1
X_05752_ net116 _01814_ _02012_ _02015_ _02031_ vssd1 vssd1 vccd1 vccd1 _02032_ sky130_fd_sc_hd__a32o_2
X_08471_ FPGA_INST.cell1.CB_1.config_dataB\[8\] FPGA_INST.cell1.CB_1.config_dataB\[7\]
+ FPGA_INST.cell1.CB_1.config_dataB\[6\] FPGA_INST.cell1.CB_1.config_dataB\[5\] vssd1
+ vssd1 vccd1 vccd1 _04687_ sky130_fd_sc_hd__or4b_1
X_05683_ net246 _01953_ _01962_ vssd1 vssd1 vccd1 vccd1 _01963_ sky130_fd_sc_hd__and3_1
XTAP_TAPCELL_ROW_18_540 vssd1 vccd1 sky130_fd_sc_hd__tapvpwrvgnd_1
XFILLER_23_537 vssd1 vssd1 vccd1 vccd1 sky130_fd_sc_hd__fill_1
X_07422_ FPGA_INST.cell0.SB0.route_sel\[48\] FPGA_INST.cell0.SB0.route_sel\[49\] vssd1
+ vssd1 vccd1 vccd1 _03680_ sky130_fd_sc_hd__nand2b_1
XPHY_EDGE_ROW_114_Left_245 vssd1 vssd1 vccd1 vccd1 sky130_fd_sc_hd__decap_3
X_07353_ _03599_ _03610_ _03612_ net339 vssd1 vssd1 vccd1 vccd1 _03613_ sky130_fd_sc_hd__a211o_2
XANTENNA__10438__S net202 vssd1 vssd1 vccd1 vccd1 sky130_fd_sc_hd__diode_2
XANTENNA__07644__B1 net78 vssd1 vssd1 vccd1 vccd1 sky130_fd_sc_hd__diode_2
X_07284_ FPGA_INST.cell3.SB0.route_sel\[26\] FPGA_INST.cell3.SB0.route_sel\[27\] vssd1
+ vssd1 vccd1 vccd1 _03545_ sky130_fd_sc_hd__nand2_1
X_06304_ _02578_ _02579_ _02581_ _02583_ vssd1 vssd1 vccd1 vccd1 _02584_ sky130_fd_sc_hd__o22a_1
XTAP_TAPCELL_ROW_98_1659 vssd1 vccd1 sky130_fd_sc_hd__tapvpwrvgnd_1
XTAP_TAPCELL_ROW_98_1648 vssd1 vccd1 sky130_fd_sc_hd__tapvpwrvgnd_1
X_09023_ _01714_ FPGA_INST.cell1.SB0.route_sel\[11\] FPGA_INST.cell1.SB0.route_sel\[8\]
+ FPGA_INST.cell1.SB0.route_sel\[9\] _05188_ vssd1 vssd1 vccd1 vccd1 _05189_ sky130_fd_sc_hd__o221a_1
X_06235_ net2 _02505_ _02506_ net30 _02514_ vssd1 vssd1 vccd1 vccd1 _02515_ sky130_fd_sc_hd__a221o_1
XFILLER_40_29 vssd1 vssd1 vccd1 vccd1 sky130_fd_sc_hd__fill_4
XFILLER_117_653 vssd1 vssd1 vccd1 vccd1 sky130_fd_sc_hd__fill_1
XFILLER_117_631 vssd1 vssd1 vccd1 vccd1 sky130_fd_sc_hd__fill_2
XANTENNA_fanout307_A net315 vssd1 vssd1 vccd1 vccd1 sky130_fd_sc_hd__diode_2
XFILLER_116_141 vssd1 vssd1 vccd1 vccd1 sky130_fd_sc_hd__fill_8
XANTENNA__07947__A1 _03973_ vssd1 vssd1 vccd1 vccd1 sky130_fd_sc_hd__diode_2
XANTENNA__07974__C _03769_ vssd1 vssd1 vccd1 vccd1 sky130_fd_sc_hd__diode_2
X_06166_ _02444_ _02445_ net239 vssd1 vssd1 vccd1 vccd1 _02446_ sky130_fd_sc_hd__o21ai_1
XFILLER_104_347 vssd1 vssd1 vccd1 vccd1 sky130_fd_sc_hd__fill_1
X_06097_ net507 _02376_ vssd1 vssd1 vccd1 vccd1 _02377_ sky130_fd_sc_hd__nand2_1
XPHY_EDGE_ROW_123_Left_254 vssd1 vssd1 vccd1 vccd1 sky130_fd_sc_hd__decap_3
Xfanout723 net729 vssd1 vssd1 vccd1 vccd1 net723 sky130_fd_sc_hd__buf_4
Xfanout701 net702 vssd1 vssd1 vccd1 vccd1 net701 sky130_fd_sc_hd__buf_2
Xfanout712 net714 vssd1 vssd1 vccd1 vccd1 net712 sky130_fd_sc_hd__clkbuf_4
X_09925_ FPGA_INST.cell0.LE_1A.config_data\[7\] FPGA_INST.cell0.LE_1A.config_data\[6\]
+ net308 vssd1 vssd1 vccd1 vccd1 _00830_ sky130_fd_sc_hd__mux2_1
XFILLER_105_11 vssd1 vssd1 vccd1 vccd1 sky130_fd_sc_hd__fill_2
Xfanout734 net29 vssd1 vssd1 vccd1 vccd1 net734 sky130_fd_sc_hd__buf_4
Xfanout767 net768 vssd1 vssd1 vccd1 vccd1 net767 sky130_fd_sc_hd__clkbuf_2
XANTENNA_fanout676_A net731 vssd1 vssd1 vccd1 vccd1 sky130_fd_sc_hd__diode_2
X_09856_ FPGA_INST.cell0.LEI0.config_data\[34\] FPGA_INST.cell0.LEI0.config_data\[35\]
+ net172 vssd1 vssd1 vccd1 vccd1 _00764_ sky130_fd_sc_hd__mux2_1
Xfanout745 net749 vssd1 vssd1 vccd1 vccd1 net745 sky130_fd_sc_hd__clkbuf_2
Xfanout756 net758 vssd1 vssd1 vccd1 vccd1 net756 sky130_fd_sc_hd__clkbuf_2
X_08807_ FPGA_INST.cell3.CB_0.config_dataB\[2\] _05012_ FPGA_INST.cell3.CB_0.config_dataB\[3\]
+ vssd1 vssd1 vccd1 vccd1 _05014_ sky130_fd_sc_hd__o21ba_1
Xfanout789 net790 vssd1 vssd1 vccd1 vccd1 net789 sky130_fd_sc_hd__clkbuf_2
Xfanout778 net790 vssd1 vssd1 vccd1 vccd1 net778 sky130_fd_sc_hd__clkbuf_2
XANTENNA_fanout843_A net1 vssd1 vssd1 vccd1 vccd1 sky130_fd_sc_hd__diode_2
X_09787_ FPGA_INST.cell1.CB_1.config_dataA\[13\] FPGA_INST.cell1.CB_1.config_dataA\[12\]
+ net326 vssd1 vssd1 vccd1 vccd1 _00696_ sky130_fd_sc_hd__mux2_1
XFILLER_18_309 vssd1 vssd1 vccd1 vccd1 sky130_fd_sc_hd__fill_1
X_06999_ net433 _01839_ _03264_ net432 vssd1 vssd1 vccd1 vccd1 _03265_ sky130_fd_sc_hd__o211a_1
X_08738_ net394 _04801_ vssd1 vssd1 vccd1 vccd1 _04947_ sky130_fd_sc_hd__nand2_1
XANTENNA__05651__B1_N FPGA_INST.bus2_0\[12\] vssd1 vssd1 vccd1 vccd1 sky130_fd_sc_hd__diode_2
XTAP_TAPCELL_ROW_107_1777 vssd1 vccd1 sky130_fd_sc_hd__tapvpwrvgnd_1
X_08669_ _01662_ FPGA_INST.cell3.CB_0.config_dataA\[7\] _04864_ vssd1 vssd1 vccd1
+ vccd1 _04878_ sky130_fd_sc_hd__or3_1
XFILLER_121_87 vssd1 vssd1 vccd1 vccd1 sky130_fd_sc_hd__fill_2
XANTENNA_fanout729_X net729 vssd1 vssd1 vccd1 vccd1 sky130_fd_sc_hd__diode_2
X_10700_ FPGA_INST.cell2.LE_0B.sel_clk _00050_ net734 vssd1 vssd1 vccd1 vccd1 FPGA_INST.cell2.LE_0B.dff1_out
+ sky130_fd_sc_hd__dfstp_1
X_11680_ net905 _01026_ net689 vssd1 vssd1 vccd1 vccd1 FPGA_INST.cell3.SB0.route_sel\[50\]
+ sky130_fd_sc_hd__dfstp_1
XTAP_TAPCELL_ROW_120_1966 vssd1 vccd1 sky130_fd_sc_hd__tapvpwrvgnd_1
X_10631_ FPGA_INST.cell3.LE_1B.config_data\[1\] FPGA_INST.cell3.LE_1B.config_data\[0\]
+ net368 vssd1 vssd1 vccd1 vccd1 _01510_ sky130_fd_sc_hd__mux2_1
X_10562_ FPGA_INST.cell3.CB_0.config_dataA\[7\] net398 net374 vssd1 vssd1 vccd1 vccd1
+ _01441_ sky130_fd_sc_hd__mux2_1
XFILLER_14_85 vssd1 vssd1 vccd1 vccd1 sky130_fd_sc_hd__fill_1
XANTENNA__06438__A1 net6 vssd1 vssd1 vccd1 vccd1 sky130_fd_sc_hd__diode_2
XFILLER_108_620 vssd1 vssd1 vccd1 vccd1 sky130_fd_sc_hd__fill_1
X_10493_ FPGA_INST.cell2.SB0.route_sel\[65\] FPGA_INST.cell2.SB0.route_sel\[66\] net247
+ vssd1 vssd1 vccd1 vccd1 _01372_ sky130_fd_sc_hd__mux2_1
XFILLER_10_798 vssd1 vssd1 vccd1 vccd1 sky130_fd_sc_hd__fill_1
X_12163_ net910 _01509_ net694 vssd1 vssd1 vccd1 vccd1 FPGA_INST.cell3.LE_1B.config_data\[0\]
+ sky130_fd_sc_hd__dfrtp_1
XANTENNA__10083__S net173 vssd1 vssd1 vccd1 vccd1 sky130_fd_sc_hd__diode_2
XFILLER_122_133 vssd1 vssd1 vccd1 vccd1 sky130_fd_sc_hd__fill_4
X_11114_ net804 _00464_ net589 vssd1 vssd1 vccd1 vccd1 FPGA_INST.cell1.LE_1A.config_data\[5\]
+ sky130_fd_sc_hd__dfrtp_1
X_12094_ net921 _01440_ net705 vssd1 vssd1 vccd1 vccd1 FPGA_INST.cell3.CB_0.config_dataA\[6\]
+ sky130_fd_sc_hd__dfstp_1
X_11045_ net807 _00395_ net592 vssd1 vssd1 vccd1 vccd1 FPGA_INST.cell1.LEI0.config_data\[30\]
+ sky130_fd_sc_hd__dfrtp_1
XFILLER_77_721 vssd1 vssd1 vccd1 vccd1 sky130_fd_sc_hd__fill_4
XANTENNA__08363__B2 FPGA_INST.bus1_0\[13\] vssd1 vssd1 vccd1 vccd1 sky130_fd_sc_hd__diode_2
XANTENNA__08363__A1 net76 vssd1 vssd1 vccd1 vccd1 sky130_fd_sc_hd__diode_2
XANTENNA_input25_X net25 vssd1 vssd1 vccd1 vccd1 sky130_fd_sc_hd__diode_2
XFILLER_77_798 vssd1 vssd1 vccd1 vccd1 sky130_fd_sc_hd__fill_1
XFILLER_76_286 vssd1 vssd1 vccd1 vccd1 sky130_fd_sc_hd__fill_2
XFILLER_37_629 vssd1 vssd1 vccd1 vccd1 sky130_fd_sc_hd__fill_1
XFILLER_92_757 vssd1 vssd1 vccd1 vccd1 sky130_fd_sc_hd__fill_1
XFILLER_91_223 vssd1 vssd1 vccd1 vccd1 sky130_fd_sc_hd__fill_1
XFILLER_76_297 vssd1 vssd1 vccd1 vccd1 sky130_fd_sc_hd__fill_8
XTAP_TAPCELL_ROW_69_1249 vssd1 vccd1 sky130_fd_sc_hd__tapvpwrvgnd_1
XFILLER_36_139 vssd1 vssd1 vccd1 vccd1 sky130_fd_sc_hd__fill_1
X_11947_ net916 _01293_ net700 vssd1 vssd1 vccd1 vccd1 FPGA_INST.cell3.CB_1.config_dataB\[12\]
+ sky130_fd_sc_hd__dfstp_1
XANTENNA__08115__A1 FPGA_INST.bus3_1\[5\] vssd1 vssd1 vccd1 vccd1 sky130_fd_sc_hd__diode_2
XFILLER_45_673 vssd1 vssd1 vccd1 vccd1 sky130_fd_sc_hd__fill_8
XFILLER_45_662 vssd1 vssd1 vccd1 vccd1 sky130_fd_sc_hd__fill_8
XANTENNA__08666__A2 _04781_ vssd1 vssd1 vccd1 vccd1 sky130_fd_sc_hd__diode_2
XTAP_TAPCELL_ROW_82_1427 vssd1 vccd1 sky130_fd_sc_hd__tapvpwrvgnd_1
XFILLER_72_470 vssd1 vssd1 vccd1 vccd1 sky130_fd_sc_hd__fill_4
X_11878_ net928 _01224_ net712 vssd1 vssd1 vccd1 vccd1 FPGA_INST.cell3.LE_0A.config_data\[8\]
+ sky130_fd_sc_hd__dfrtp_1
XFILLER_32_334 vssd1 vssd1 vccd1 vccd1 sky130_fd_sc_hd__fill_4
X_10829_ net801 _00179_ net586 vssd1 vssd1 vccd1 vccd1 FPGA_INST.cell1.SB0.route_sel\[38\]
+ sky130_fd_sc_hd__dfstp_1
XTAP_TAPCELL_ROW_43_885 vssd1 vccd1 sky130_fd_sc_hd__tapvpwrvgnd_1
X_06020_ net165 net159 FPGA_INST.bus1_0\[5\] vssd1 vssd1 vccd1 vccd1 _02300_ sky130_fd_sc_hd__o21ai_1
XANTENNA__07929__A1 FPGA_INST.bus3_1\[1\] vssd1 vssd1 vccd1 vccd1 sky130_fd_sc_hd__diode_2
XANTENNA__09782__S net333 vssd1 vssd1 vccd1 vccd1 sky130_fd_sc_hd__diode_2
X_07971_ _04187_ _04191_ _04198_ vssd1 vssd1 vccd1 vccd1 _04199_ sky130_fd_sc_hd__o21ba_1
XTAP_TAPCELL_ROW_93_1589 vssd1 vccd1 sky130_fd_sc_hd__tapvpwrvgnd_1
XTAP_TAPCELL_ROW_93_1578 vssd1 vccd1 sky130_fd_sc_hd__tapvpwrvgnd_1
XFILLER_68_710 vssd1 vssd1 vccd1 vccd1 sky130_fd_sc_hd__fill_2
X_09710_ FPGA_INST.cell0.SB0.route_sel\[113\] FPGA_INST.cell0.SB0.route_sel\[114\]
+ net198 vssd1 vssd1 vccd1 vccd1 _00619_ sky130_fd_sc_hd__mux2_1
X_06922_ FPGA_INST.bus2_0\[1\] _03163_ _03189_ vssd1 vssd1 vccd1 vccd1 _03190_ sky130_fd_sc_hd__a21o_1
XFILLER_95_551 vssd1 vssd1 vccd1 vccd1 sky130_fd_sc_hd__fill_1
XANTENNA__09083__A net736 vssd1 vssd1 vccd1 vccd1 sky130_fd_sc_hd__diode_2
XANTENNA__11551__CLK net772 vssd1 vssd1 vccd1 vccd1 sky130_fd_sc_hd__diode_2
XFILLER_68_798 vssd1 vssd1 vccd1 vccd1 sky130_fd_sc_hd__fill_1
XANTENNA__06500__A _02775_ vssd1 vssd1 vccd1 vccd1 sky130_fd_sc_hd__diode_2
X_06853_ _01743_ _03117_ _03120_ _01745_ _03109_ vssd1 vssd1 vccd1 vccd1 _03121_ sky130_fd_sc_hd__o311a_1
X_09641_ FPGA_INST.cell0.SB0.route_sel\[44\] FPGA_INST.cell0.SB0.route_sel\[45\] net182
+ vssd1 vssd1 vccd1 vccd1 _00550_ sky130_fd_sc_hd__mux2_1
XTAP_TAPCELL_ROW_124_2022 vssd1 vccd1 sky130_fd_sc_hd__tapvpwrvgnd_1
X_09572_ FPGA_INST.cell1.CB_1.config_dataB\[1\] FPGA_INST.cell1.CB_1.config_dataB\[0\]
+ net335 vssd1 vssd1 vccd1 vccd1 _00481_ sky130_fd_sc_hd__mux2_1
X_06784_ net512 _02814_ vssd1 vssd1 vccd1 vccd1 _03058_ sky130_fd_sc_hd__nand2_1
X_05804_ _01905_ _02048_ vssd1 vssd1 vccd1 vccd1 _02084_ sky130_fd_sc_hd__or2_1
XFILLER_27_139 vssd1 vssd1 vccd1 vccd1 sky130_fd_sc_hd__fill_1
X_08523_ FPGA_INST.cell3.LE_1A.config_data\[2\] FPGA_INST.cell3.LE_1A.config_data\[3\]
+ _04725_ vssd1 vssd1 vccd1 vccd1 _04736_ sky130_fd_sc_hd__mux2_1
XFILLER_82_267 vssd1 vssd1 vccd1 vccd1 sky130_fd_sc_hd__fill_4
X_05735_ net122 net385 net162 _02013_ _01815_ vssd1 vssd1 vccd1 vccd1 _02015_ sky130_fd_sc_hd__o32a_1
X_08454_ FPGA_INST.cell1.LE_1A.config_data\[4\] FPGA_INST.cell1.LE_1A.config_data\[5\]
+ _04660_ vssd1 vssd1 vccd1 vccd1 _04672_ sky130_fd_sc_hd__mux2_1
XANTENNA__07602__Y _03856_ vssd1 vssd1 vccd1 vccd1 sky130_fd_sc_hd__diode_2
X_05666_ FPGA_INST.cell2.CB_1.config_dataA\[24\] FPGA_INST.cell2.CB_1.config_dataA\[21\]
+ FPGA_INST.cell2.CB_1.config_dataA\[20\] vssd1 vssd1 vccd1 vccd1 _01946_ sky130_fd_sc_hd__or3_2
XFILLER_51_643 vssd1 vssd1 vccd1 vccd1 sky130_fd_sc_hd__fill_1
X_07405_ net91 _03663_ _03661_ vssd1 vssd1 vccd1 vccd1 _03664_ sky130_fd_sc_hd__mux2_1
X_08385_ net439 _03997_ _04606_ net438 vssd1 vssd1 vccd1 vccd1 _04607_ sky130_fd_sc_hd__o211a_1
X_05597_ _01822_ net170 vssd1 vssd1 vccd1 vccd1 _01877_ sky130_fd_sc_hd__nor2_1
XFILLER_11_507 vssd1 vssd1 vccd1 vccd1 sky130_fd_sc_hd__fill_4
XFILLER_11_518 vssd1 vssd1 vccd1 vccd1 sky130_fd_sc_hd__fill_2
X_07336_ _03595_ vssd1 vssd1 vccd1 vccd1 _03596_ sky130_fd_sc_hd__inv_2
XANTENNA__09957__S net315 vssd1 vssd1 vccd1 vccd1 sky130_fd_sc_hd__diode_2
XFILLER_109_428 vssd1 vssd1 vccd1 vccd1 sky130_fd_sc_hd__fill_1
XANTENNA__07093__A1 FPGA_INST.bus2_0\[3\] vssd1 vssd1 vccd1 vccd1 sky130_fd_sc_hd__diode_2
XTAP_TAPCELL_ROW_21_579 vssd1 vccd1 sky130_fd_sc_hd__tapvpwrvgnd_1
X_09006_ _03555_ _03565_ _05177_ net220 vssd1 vssd1 vccd1 vccd1 FPGA_INST.bus1_0\[3\]
+ sky130_fd_sc_hd__o211a_2
X_07267_ FPGA_INST.cell3.SB0.route_sel\[18\] FPGA_INST.cell3.SB0.route_sel\[19\] _03521_
+ _03525_ _03528_ vssd1 vssd1 vccd1 vccd1 _03529_ sky130_fd_sc_hd__a41o_1
X_07198_ FPGA_INST.cell1.SB0.route_sel\[10\] FPGA_INST.cell1.SB0.route_sel\[11\] vssd1
+ vssd1 vccd1 vccd1 _03461_ sky130_fd_sc_hd__nand2_1
X_06218_ FPGA_INST.cell2.CB_0.config_dataA\[9\] _02172_ _02497_ vssd1 vssd1 vccd1
+ vccd1 _02498_ sky130_fd_sc_hd__or3_1
X_06149_ _02425_ _02428_ vssd1 vssd1 vccd1 vccd1 _02429_ sky130_fd_sc_hd__and2_2
XTAP_TAPCELL_ROW_53_1028 vssd1 vccd1 sky130_fd_sc_hd__tapvpwrvgnd_1
XANTENNA__09692__S net320 vssd1 vssd1 vccd1 vccd1 sky130_fd_sc_hd__diode_2
XFILLER_2_249 vssd1 vssd1 vccd1 vccd1 sky130_fd_sc_hd__fill_2
XFILLER_120_637 vssd1 vssd1 vccd1 vccd1 sky130_fd_sc_hd__fill_4
XFILLER_120_615 vssd1 vssd1 vccd1 vccd1 sky130_fd_sc_hd__fill_2
Xfanout520 net521 vssd1 vssd1 vccd1 vccd1 net520 sky130_fd_sc_hd__buf_2
Xfanout531 net534 vssd1 vssd1 vccd1 vccd1 net531 sky130_fd_sc_hd__clkbuf_2
Xfanout542 net543 vssd1 vssd1 vccd1 vccd1 net542 sky130_fd_sc_hd__buf_2
Xfanout553 net554 vssd1 vssd1 vccd1 vccd1 net553 sky130_fd_sc_hd__clkbuf_4
Xfanout564 net565 vssd1 vssd1 vccd1 vccd1 net564 sky130_fd_sc_hd__clkbuf_4
X_09908_ FPGA_INST.cell0.LE_0B.config_data\[13\] FPGA_INST.cell0.LE_0B.config_data\[12\]
+ net316 vssd1 vssd1 vccd1 vccd1 _00814_ sky130_fd_sc_hd__mux2_1
Xfanout575 net628 vssd1 vssd1 vccd1 vccd1 net575 sky130_fd_sc_hd__buf_2
XTAP_TAPCELL_ROW_109_1806 vssd1 vccd1 sky130_fd_sc_hd__tapvpwrvgnd_1
Xfanout597 net604 vssd1 vssd1 vccd1 vccd1 net597 sky130_fd_sc_hd__clkbuf_4
Xfanout586 net587 vssd1 vssd1 vccd1 vccd1 net586 sky130_fd_sc_hd__clkbuf_4
XFILLER_59_798 vssd1 vssd1 vccd1 vccd1 sky130_fd_sc_hd__fill_1
XFILLER_46_404 vccd1 vssd1 vccd1 vssd1 sky130_ef_sc_hd__decap_40_12
X_09839_ FPGA_INST.cell0.LEI0.config_data\[17\] FPGA_INST.cell0.LEI0.config_data\[18\]
+ net172 vssd1 vssd1 vccd1 vccd1 _00747_ sky130_fd_sc_hd__mux2_1
X_11801_ net875 _01147_ net660 vssd1 vssd1 vccd1 vccd1 FPGA_INST.io_east_oeb\[22\]
+ sky130_fd_sc_hd__dfrtp_1
XFILLER_27_662 vssd1 vssd1 vccd1 vccd1 sky130_fd_sc_hd__fill_1
XANTENNA__08648__A2 net82 vssd1 vssd1 vccd1 vccd1 sky130_fd_sc_hd__diode_2
XANTENNA__10867__SET_B net577 vssd1 vssd1 vccd1 vccd1 sky130_fd_sc_hd__diode_2
XTAP_TAPCELL_ROW_1_293 vssd1 vccd1 sky130_fd_sc_hd__tapvpwrvgnd_1
XFILLER_26_172 vssd1 vssd1 vccd1 vccd1 sky130_fd_sc_hd__fill_2
X_11732_ net897 _01078_ net681 vssd1 vssd1 vccd1 vccd1 FPGA_INST.cell3.SB0.route_sel\[102\]
+ sky130_fd_sc_hd__dfstp_1
XFILLER_42_665 vssd1 vssd1 vccd1 vccd1 sky130_fd_sc_hd__fill_1
X_11663_ net906 _01009_ net690 vssd1 vssd1 vccd1 vccd1 FPGA_INST.cell3.SB0.route_sel\[33\]
+ sky130_fd_sc_hd__dfstp_1
XTAP_TAPCELL_ROW_64_1179 vssd1 vccd1 sky130_fd_sc_hd__tapvpwrvgnd_1
XFILLER_41_142 vssd1 vssd1 vccd1 vccd1 sky130_fd_sc_hd__fill_2
X_10614_ FPGA_INST.cell3.CB_1.config_dataA\[8\] FPGA_INST.cell3.CB_1.config_dataA\[9\]
+ net303 vssd1 vssd1 vccd1 vccd1 _01493_ sky130_fd_sc_hd__mux2_1
XANTENNA__07871__A3 FPGA_INST.bus3_1\[11\] vssd1 vssd1 vccd1 vccd1 sky130_fd_sc_hd__diode_2
XTAP_TAPCELL_ROW_40_844 vssd1 vccd1 sky130_fd_sc_hd__tapvpwrvgnd_1
X_11594_ net792 _00944_ net577 vssd1 vssd1 vccd1 vccd1 FPGA_INST.cell0.CB_1.config_dataA\[13\]
+ sky130_fd_sc_hd__dfstp_1
XFILLER_128_759 vssd1 vssd1 vccd1 vccd1 sky130_fd_sc_hd__fill_1
X_10545_ FPGA_INST.cell2.SB0.route_sel\[117\] FPGA_INST.cell2.SB0.route_sel\[118\]
+ net242 vssd1 vssd1 vccd1 vccd1 _01424_ sky130_fd_sc_hd__mux2_1
XFILLER_6_566 vssd1 vssd1 vccd1 vccd1 sky130_fd_sc_hd__fill_1
XANTENNA__06831__A1 _02465_ vssd1 vssd1 vccd1 vccd1 sky130_fd_sc_hd__diode_2
XANTENNA__06831__B2 _02429_ vssd1 vssd1 vccd1 vccd1 sky130_fd_sc_hd__diode_2
X_10476_ FPGA_INST.cell2.SB0.route_sel\[48\] FPGA_INST.cell2.SB0.route_sel\[49\] net194
+ vssd1 vssd1 vccd1 vccd1 _01355_ sky130_fd_sc_hd__mux2_1
X_12146_ net942 _01492_ net726 vssd1 vssd1 vccd1 vccd1 FPGA_INST.cell3.CB_1.config_dataA\[8\]
+ sky130_fd_sc_hd__dfstp_1
XANTENNA__08584__B2 FPGA_INST.cell3.SB0.route_sel\[68\] vssd1 vssd1 vccd1 vccd1 sky130_fd_sc_hd__diode_2
XFILLER_37_7 vssd1 vssd1 vccd1 vccd1 sky130_fd_sc_hd__fill_2
X_12077_ net853 _01423_ net638 vssd1 vssd1 vccd1 vccd1 FPGA_INST.cell2.SB0.route_sel\[117\]
+ sky130_fd_sc_hd__dfstp_1
X_11028_ net834 _00378_ net618 vssd1 vssd1 vccd1 vccd1 FPGA_INST.cell1.LEI0.config_data\[13\]
+ sky130_fd_sc_hd__dfrtp_1
XFILLER_49_264 vssd1 vssd1 vccd1 vccd1 sky130_fd_sc_hd__fill_4
XFILLER_92_543 vssd1 vssd1 vccd1 vccd1 sky130_fd_sc_hd__fill_1
XFILLER_65_779 vssd1 vssd1 vccd1 vccd1 sky130_fd_sc_hd__fill_4
XTAP_TAPCELL_ROW_48_955 vssd1 vccd1 sky130_fd_sc_hd__tapvpwrvgnd_1
XANTENNA__11445__RESET_B net561 vssd1 vssd1 vccd1 vccd1 sky130_fd_sc_hd__diode_2
XFILLER_92_587 vssd1 vssd1 vccd1 vccd1 sky130_fd_sc_hd__fill_1
XFILLER_45_470 vssd1 vssd1 vccd1 vccd1 sky130_fd_sc_hd__fill_1
X_05520_ FPGA_INST.config_bits\[11\] FPGA_INST.config_bits\[9\] FPGA_INST.config_bits\[8\]
+ FPGA_INST.config_bits\[10\] vssd1 vssd1 vccd1 vccd1 _01802_ sky130_fd_sc_hd__or4bb_1
XFILLER_33_654 vssd1 vssd1 vccd1 vccd1 sky130_fd_sc_hd__fill_4
X_05451_ FPGA_INST.cell0.CB_0.config_dataA\[13\] vssd1 vssd1 vccd1 vccd1 _01733_ sky130_fd_sc_hd__inv_2
XPHY_EDGE_ROW_120_Right_120 vssd1 vssd1 vccd1 vccd1 sky130_fd_sc_hd__decap_3
XANTENNA__09777__S net333 vssd1 vssd1 vccd1 vccd1 sky130_fd_sc_hd__diode_2
X_08170_ net412 _03720_ vssd1 vssd1 vccd1 vccd1 _04394_ sky130_fd_sc_hd__nand2_1
XFILLER_20_348 vssd1 vssd1 vccd1 vccd1 sky130_fd_sc_hd__fill_1
XFILLER_32_197 vssd1 vssd1 vccd1 vccd1 sky130_fd_sc_hd__fill_4
X_05382_ FPGA_INST.cell3.SB0.route_sel\[58\] vssd1 vssd1 vccd1 vccd1 _01664_ sky130_fd_sc_hd__inv_2
X_07121_ _03385_ _03386_ _03279_ vssd1 vssd1 vccd1 vccd1 _03387_ sky130_fd_sc_hd__mux2_1
XANTENNA__07075__A1 FPGA_INST.bus2_0\[14\] vssd1 vssd1 vccd1 vccd1 sky130_fd_sc_hd__diode_2
XFILLER_119_748 vssd1 vssd1 vccd1 vccd1 sky130_fd_sc_hd__fill_1
XFILLER_118_236 vssd1 vssd1 vccd1 vccd1 sky130_fd_sc_hd__fill_1
XANTENNA__08811__A2 _04785_ vssd1 vssd1 vccd1 vccd1 sky130_fd_sc_hd__diode_2
XTAP_TAPCELL_ROW_95_1618 vssd1 vccd1 sky130_fd_sc_hd__tapvpwrvgnd_1
XTAP_TAPCELL_ROW_95_1607 vssd1 vccd1 sky130_fd_sc_hd__tapvpwrvgnd_1
X_07052_ net429 net431 vssd1 vssd1 vccd1 vccd1 _03318_ sky130_fd_sc_hd__and2b_2
XANTENNA__08024__A0 FPGA_INST.bus3_1\[12\] vssd1 vssd1 vccd1 vccd1 sky130_fd_sc_hd__diode_2
X_06003_ _02273_ _02275_ _02282_ vssd1 vssd1 vccd1 vccd1 _02283_ sky130_fd_sc_hd__o21ba_1
X_07954_ FPGA_INST.cell1.LEI0.config_data\[25\] _04178_ _04181_ vssd1 vssd1 vccd1
+ vccd1 _04182_ sky130_fd_sc_hd__o21a_1
XANTENNA__08327__A1 _03959_ vssd1 vssd1 vccd1 vccd1 sky130_fd_sc_hd__diode_2
X_07885_ FPGA_INST.cell1.CB_0.config_dataA\[8\] _04083_ FPGA_INST.cell1.CB_0.config_dataA\[7\]
+ FPGA_INST.cell1.CB_0.config_dataA\[9\] vssd1 vssd1 vccd1 vccd1 _04113_ sky130_fd_sc_hd__or4b_1
XFILLER_110_670 vssd1 vssd1 vccd1 vccd1 sky130_fd_sc_hd__fill_2
XANTENNA__08327__B2 _03923_ vssd1 vssd1 vccd1 vccd1 sky130_fd_sc_hd__diode_2
X_06905_ FPGA_INST.bus2_0\[8\] FPGA_INST.bus2_0\[9\] FPGA_INST.bus2_0\[10\] FPGA_INST.bus2_0\[11\]
+ net419 net417 vssd1 vssd1 vccd1 vccd1 _03173_ sky130_fd_sc_hd__mux4_1
XANTENNA_fanout374_A net379 vssd1 vssd1 vccd1 vccd1 sky130_fd_sc_hd__diode_2
XFILLER_55_223 vssd1 vssd1 vccd1 vccd1 sky130_fd_sc_hd__fill_1
X_09624_ FPGA_INST.cell0.SB0.route_sel\[28\] FPGA_INST.cell0.SB0.route_sel\[27\] net321
+ vssd1 vssd1 vccd1 vccd1 _00533_ sky130_fd_sc_hd__mux2_1
X_06836_ FPGA_INST.bus2_0\[2\] FPGA_INST.bus2_0\[3\] net422 vssd1 vssd1 vccd1 vccd1
+ _03104_ sky130_fd_sc_hd__mux2_1
XFILLER_83_554 vssd1 vssd1 vccd1 vccd1 sky130_fd_sc_hd__fill_4
XFILLER_55_267 vccd1 vssd1 vccd1 vssd1 sky130_ef_sc_hd__decap_40_12
X_09555_ FPGA_INST.cell1.LE_1A.config_data\[5\] FPGA_INST.cell1.LE_1A.config_data\[4\]
+ net333 vssd1 vssd1 vccd1 vccd1 _00464_ sky130_fd_sc_hd__mux2_1
XFILLER_71_738 vssd1 vssd1 vccd1 vccd1 sky130_fd_sc_hd__fill_2
XFILLER_71_727 vssd1 vssd1 vccd1 vccd1 sky130_fd_sc_hd__fill_1
XFILLER_70_226 vssd1 vssd1 vccd1 vccd1 sky130_fd_sc_hd__fill_1
X_06767_ FPGA_INST.cell2.CB_1.config_dataB\[13\] _03036_ _03040_ _03033_ vssd1 vssd1
+ vccd1 vccd1 _03041_ sky130_fd_sc_hd__and4bb_1
XFILLER_24_621 vccd1 vssd1 vccd1 vssd1 sky130_ef_sc_hd__decap_40_12
XANTENNA_fanout639_A net647 vssd1 vssd1 vccd1 vccd1 sky130_fd_sc_hd__diode_2
X_08506_ net89 net84 net82 _01792_ FPGA_INST.cell3.LEI0.config_data\[18\] FPGA_INST.cell3.LEI0.config_data\[19\]
+ vssd1 vssd1 vccd1 vccd1 _04719_ sky130_fd_sc_hd__mux4_1
XTAP_TAPCELL_ROW_104_1736 vssd1 vccd1 sky130_fd_sc_hd__tapvpwrvgnd_1
X_09486_ FPGA_INST.cell1.LEI0.config_data\[32\] FPGA_INST.cell1.LEI0.config_data\[33\]
+ net210 vssd1 vssd1 vccd1 vccd1 _00398_ sky130_fd_sc_hd__mux2_1
XFILLER_102_67 vssd1 vssd1 vccd1 vccd1 sky130_fd_sc_hd__fill_8
XFILLER_70_248 vssd1 vssd1 vccd1 vccd1 sky130_fd_sc_hd__fill_2
X_06698_ net521 _02810_ _02971_ net519 vssd1 vssd1 vccd1 vccd1 _02972_ sky130_fd_sc_hd__o211a_1
XFILLER_51_440 vssd1 vssd1 vccd1 vccd1 sky130_fd_sc_hd__fill_8
X_05718_ _01986_ _01988_ _01989_ _01997_ vssd1 vssd1 vccd1 vccd1 _01998_ sky130_fd_sc_hd__a211o_1
XTAP_TAPCELL_ROW_26_649 vssd1 vccd1 sky130_fd_sc_hd__tapvpwrvgnd_1
X_08437_ FPGA_INST.cell1.CB_1.config_dataA\[8\] FPGA_INST.cell1.CB_1.config_dataA\[7\]
+ FPGA_INST.cell1.CB_1.config_dataA\[6\] FPGA_INST.cell1.CB_1.config_dataA\[5\] vssd1
+ vssd1 vccd1 vccd1 _04655_ sky130_fd_sc_hd__or4b_1
XFILLER_102_89 vssd1 vssd1 vccd1 vccd1 sky130_fd_sc_hd__fill_1
X_05649_ net113 _01826_ _01927_ vssd1 vssd1 vccd1 vccd1 _01929_ sky130_fd_sc_hd__nor3_1
XANTENNA_fanout806_A net811 vssd1 vssd1 vccd1 vccd1 sky130_fd_sc_hd__diode_2
XANTENNA__06510__B1 _02784_ vssd1 vssd1 vccd1 vccd1 sky130_fd_sc_hd__diode_2
XFILLER_109_203 vssd1 vssd1 vccd1 vccd1 sky130_fd_sc_hd__fill_1
XANTENNA_wire75_X net75 vssd1 vssd1 vccd1 vccd1 sky130_fd_sc_hd__diode_2
X_08368_ _03408_ _04576_ _04577_ _03465_ FPGA_INST.cell0.CB_1.config_dataB\[12\] vssd1
+ vssd1 vccd1 vccd1 _04590_ sky130_fd_sc_hd__a221o_1
X_07319_ net85 net21 _03577_ vssd1 vssd1 vccd1 vccd1 _03580_ sky130_fd_sc_hd__mux2_1
X_08299_ _01758_ _04520_ vssd1 vssd1 vccd1 vccd1 _04521_ sky130_fd_sc_hd__nor2_1
XFILLER_125_729 vssd1 vssd1 vccd1 vccd1 sky130_fd_sc_hd__fill_4
XFILLER_124_206 vssd1 vssd1 vccd1 vccd1 sky130_fd_sc_hd__fill_1
X_10330_ FPGA_INST.cell3.LEI0.config_data\[44\] FPGA_INST.cell3.LEI0.config_data\[45\]
+ net281 vssd1 vssd1 vccd1 vccd1 _01211_ sky130_fd_sc_hd__mux2_1
XFILLER_109_269 vssd1 vssd1 vccd1 vccd1 sky130_fd_sc_hd__fill_1
XFILLER_124_228 vssd1 vssd1 vccd1 vccd1 sky130_fd_sc_hd__fill_4
X_10261_ FPGA_INST.io_east_oeb\[10\] FPGA_INST.io_east_oeb\[12\] net257 vssd1 vssd1
+ vccd1 vccd1 _01142_ sky130_fd_sc_hd__mux2_1
XTAP_TAPCELL_ROW_115_1887 vssd1 vccd1 sky130_fd_sc_hd__tapvpwrvgnd_1
XFILLER_105_453 vssd1 vssd1 vccd1 vccd1 sky130_fd_sc_hd__fill_2
X_12000_ net852 _01346_ net637 vssd1 vssd1 vccd1 vccd1 FPGA_INST.cell2.SB0.route_sel\[40\]
+ sky130_fd_sc_hd__dfstp_1
XFILLER_127_86 vssd1 vssd1 vccd1 vccd1 sky130_fd_sc_hd__fill_1
XTAP_TAPCELL_ROW_115_1898 vssd1 vccd1 sky130_fd_sc_hd__tapvpwrvgnd_1
X_10192_ FPGA_INST.cell3.SB0.route_sel\[96\] FPGA_INST.cell3.SB0.route_sel\[97\] net285
+ vssd1 vssd1 vccd1 vccd1 _01073_ sky130_fd_sc_hd__mux2_1
XFILLER_87_57 vssd1 vssd1 vccd1 vccd1 sky130_fd_sc_hd__fill_4
XFILLER_120_434 vssd1 vssd1 vccd1 vccd1 sky130_fd_sc_hd__fill_2
XANTENNA__05963__B _02240_ vssd1 vssd1 vccd1 vccd1 sky130_fd_sc_hd__diode_2
Xfanout350 net351 vssd1 vssd1 vccd1 vccd1 net350 sky130_fd_sc_hd__clkbuf_4
Xfanout372 net380 vssd1 vssd1 vccd1 vccd1 net372 sky130_fd_sc_hd__buf_2
XFILLER_120_489 vssd1 vssd1 vccd1 vccd1 sky130_fd_sc_hd__fill_2
XANTENNA__07236__A FPGA_INST.cell1.CB_0.config_dataB\[24\] vssd1 vssd1 vccd1 vccd1
+ sky130_fd_sc_hd__diode_2
XFILLER_93_318 vccd1 vssd1 vccd1 vssd1 sky130_ef_sc_hd__decap_40_12
XANTENNA__11754__Q FPGA_INST.cell3.SB0.route_sel\[124\] vssd1 vssd1 vccd1 vccd1 sky130_fd_sc_hd__diode_2
Xfanout361 net362 vssd1 vssd1 vccd1 vccd1 net361 sky130_fd_sc_hd__clkbuf_4
XFILLER_59_551 vssd1 vssd1 vccd1 vccd1 sky130_fd_sc_hd__fill_8
Xfanout383 _01821_ vssd1 vssd1 vccd1 vccd1 net383 sky130_fd_sc_hd__clkbuf_4
XTAP_TAPCELL_ROW_6_363 vssd1 vccd1 sky130_fd_sc_hd__tapvpwrvgnd_1
Xfanout394 net395 vssd1 vssd1 vccd1 vccd1 net394 sky130_fd_sc_hd__clkbuf_2
XFILLER_101_670 vssd1 vssd1 vccd1 vccd1 sky130_fd_sc_hd__fill_2
XANTENNA__09451__A net522 vssd1 vssd1 vccd1 vccd1 sky130_fd_sc_hd__diode_2
XFILLER_74_576 vssd1 vssd1 vccd1 vccd1 sky130_fd_sc_hd__fill_2
XTAP_TAPCELL_ROW_66_1208 vssd1 vccd1 sky130_fd_sc_hd__tapvpwrvgnd_1
XFILLER_74_598 vssd1 vssd1 vccd1 vccd1 sky130_fd_sc_hd__fill_1
XTAP_TAPCELL_ROW_45_914 vssd1 vccd1 sky130_fd_sc_hd__tapvpwrvgnd_1
XFILLER_34_418 vssd1 vssd1 vccd1 vccd1 sky130_fd_sc_hd__fill_2
XANTENNA__07829__A0 FPGA_INST.cell2.CB_0.le_outA vssd1 vssd1 vccd1 vccd1 sky130_fd_sc_hd__diode_2
XFILLER_36_83 vssd1 vssd1 vccd1 vccd1 sky130_fd_sc_hd__fill_1
X_11715_ net922 _01061_ net706 vssd1 vssd1 vccd1 vccd1 FPGA_INST.cell3.SB0.route_sel\[85\]
+ sky130_fd_sc_hd__dfstp_1
XANTENNA__06501__A0 _02772_ vssd1 vssd1 vccd1 vccd1 sky130_fd_sc_hd__diode_2
XFILLER_70_793 vssd1 vssd1 vccd1 vccd1 sky130_fd_sc_hd__fill_4
XFILLER_42_495 vssd1 vssd1 vccd1 vccd1 sky130_fd_sc_hd__fill_1
X_11646_ net893 _00992_ net677 vssd1 vssd1 vccd1 vccd1 FPGA_INST.cell3.SB0.route_sel\[16\]
+ sky130_fd_sc_hd__dfstp_1
Xinput25 gpio_in[31] vssd1 vssd1 vccd1 vccd1 net25 sky130_fd_sc_hd__buf_2
XANTENNA__10536__S net244 vssd1 vssd1 vccd1 vccd1 sky130_fd_sc_hd__diode_2
Xinput14 gpio_in[21] vssd1 vssd1 vccd1 vccd1 net14 sky130_fd_sc_hd__clkbuf_2
X_11577_ net757 _00927_ net542 vssd1 vssd1 vccd1 vccd1 FPGA_INST.cell0.CB_0.config_dataB\[21\]
+ sky130_fd_sc_hd__dfstp_1
XFILLER_6_352 vccd1 vssd1 vccd1 vssd1 sky130_ef_sc_hd__decap_40_12
X_10528_ FPGA_INST.cell2.SB0.route_sel\[100\] FPGA_INST.cell2.SB0.route_sel\[101\]
+ net242 vssd1 vssd1 vccd1 vccd1 _01407_ sky130_fd_sc_hd__mux2_1
XTAP_TAPCELL_ROW_77_1359 vssd1 vccd1 sky130_fd_sc_hd__tapvpwrvgnd_1
XFILLER_42_5 vssd1 vssd1 vccd1 vccd1 sky130_fd_sc_hd__fill_1
X_10459_ FPGA_INST.cell2.SB0.route_sel\[31\] FPGA_INST.cell2.SB0.route_sel\[32\] net192
+ vssd1 vssd1 vccd1 vccd1 _01338_ sky130_fd_sc_hd__mux2_1
XTAP_TAPCELL_ROW_90_1548 vssd1 vccd1 sky130_fd_sc_hd__tapvpwrvgnd_1
XTAP_TAPCELL_ROW_90_1537 vssd1 vccd1 sky130_fd_sc_hd__tapvpwrvgnd_1
XANTENNA__06602__X _02878_ vssd1 vssd1 vccd1 vccd1 sky130_fd_sc_hd__diode_2
XANTENNA__06568__B1 _02843_ vssd1 vssd1 vccd1 vccd1 sky130_fd_sc_hd__diode_2
X_12129_ net936 _01475_ net720 vssd1 vssd1 vccd1 vccd1 FPGA_INST.cell3.CB_0.config_dataB\[16\]
+ sky130_fd_sc_hd__dfstp_2
XANTENNA__08309__B2 _03408_ vssd1 vssd1 vccd1 vccd1 sky130_fd_sc_hd__diode_2
XANTENNA__08309__A1 _03465_ vssd1 vssd1 vccd1 vccd1 sky130_fd_sc_hd__diode_2
XFILLER_84_329 vssd1 vssd1 vccd1 vccd1 sky130_fd_sc_hd__fill_2
XANTENNA__05791__A1 net171 vssd1 vssd1 vccd1 vccd1 sky130_fd_sc_hd__diode_2
XFILLER_37_223 vssd1 vssd1 vccd1 vccd1 sky130_fd_sc_hd__fill_1
XFILLER_38_757 vssd1 vssd1 vccd1 vccd1 sky130_fd_sc_hd__fill_4
X_07670_ FPGA_INST.cell0.SB0.route_sel\[102\] _01631_ vssd1 vssd1 vccd1 vccd1 _03922_
+ sky130_fd_sc_hd__nand2_1
X_06621_ FPGA_INST.bus3_2\[12\] FPGA_INST.bus3_2\[13\] FPGA_INST.bus3_2\[14\] FPGA_INST.bus3_2\[15\]
+ net478 net477 vssd1 vssd1 vccd1 vccd1 _02897_ sky130_fd_sc_hd__mux4_1
XFILLER_53_738 vccd1 vssd1 vccd1 vssd1 sky130_ef_sc_hd__decap_40_12
X_09340_ FPGA_INST.cell1.SB0.route_sel\[112\] FPGA_INST.cell1.SB0.route_sel\[111\]
+ net342 vssd1 vssd1 vccd1 vccd1 _00253_ sky130_fd_sc_hd__mux2_1
X_06552_ FPGA_INST.cell2.CB_1.config_dataA\[7\] _02827_ vssd1 vssd1 vccd1 vccd1 _02828_
+ sky130_fd_sc_hd__nand2_1
X_05503_ net92 vssd1 vssd1 vccd1 vccd1 _01785_ sky130_fd_sc_hd__inv_2
X_09271_ FPGA_INST.cell1.SB0.route_sel\[43\] FPGA_INST.cell1.SB0.route_sel\[42\] net330
+ vssd1 vssd1 vccd1 vccd1 _00184_ sky130_fd_sc_hd__mux2_1
XFILLER_61_771 vccd1 vssd1 vccd1 vssd1 sky130_ef_sc_hd__decap_40_12
XTAP_TAPCELL_ROW_23_608 vssd1 vccd1 sky130_fd_sc_hd__tapvpwrvgnd_1
X_08222_ net407 _03558_ vssd1 vssd1 vccd1 vccd1 _04446_ sky130_fd_sc_hd__nand2_1
X_06483_ FPGA_INST.cell2.LE_0B.config_data\[13\] FPGA_INST.cell2.LE_0B.config_data\[12\]
+ _02688_ vssd1 vssd1 vccd1 vccd1 _02761_ sky130_fd_sc_hd__mux2_1
XFILLER_21_646 vssd1 vssd1 vccd1 vccd1 sky130_fd_sc_hd__fill_4
X_05434_ FPGA_INST.cell0.SB0.route_sel\[13\] vssd1 vssd1 vccd1 vccd1 _01716_ sky130_fd_sc_hd__inv_2
XFILLER_20_145 vssd1 vssd1 vccd1 vccd1 sky130_fd_sc_hd__fill_2
X_08153_ FPGA_INST.cell1.LE_0B.dff0_out FPGA_INST.cell1.LE_0B.dff1_out FPGA_INST.cell1.LE_0B.reset_val
+ vssd1 vssd1 vccd1 vccd1 FPGA_INST.cell1.LE_0B.dff_out sky130_fd_sc_hd__mux2_1
X_05365_ FPGA_INST.cell3.SB0.route_sel\[74\] vssd1 vssd1 vccd1 vccd1 _01647_ sky130_fd_sc_hd__inv_2
X_08084_ FPGA_INST.cell1.CB_0.config_dataB\[12\] _04308_ _04309_ _04306_ FPGA_INST.cell1.CB_0.config_dataB\[13\]
+ vssd1 vssd1 vccd1 vccd1 _04310_ sky130_fd_sc_hd__a311o_1
XFILLER_107_729 vssd1 vssd1 vccd1 vccd1 sky130_fd_sc_hd__fill_1
X_07104_ net427 _01888_ vssd1 vssd1 vccd1 vccd1 _03370_ sky130_fd_sc_hd__nand2_1
X_05296_ FPGA_INST.cell2.SB0.route_sel\[96\] vssd1 vssd1 vccd1 vccd1 _01578_ sky130_fd_sc_hd__inv_2
X_07035_ _03296_ _03297_ _03299_ _03300_ vssd1 vssd1 vccd1 vccd1 _03301_ sky130_fd_sc_hd__o2bb2a_1
XFILLER_115_740 vssd1 vssd1 vccd1 vccd1 sky130_fd_sc_hd__fill_1
XANTENNA__08012__A3 FPGA_INST.bus3_1\[3\] vssd1 vssd1 vccd1 vccd1 sky130_fd_sc_hd__diode_2
XANTENNA__11496__SET_B net577 vssd1 vssd1 vccd1 vccd1 sky130_fd_sc_hd__diode_2
XFILLER_130_743 vssd1 vssd1 vccd1 vccd1 sky130_fd_sc_hd__fill_4
Xteam_15_964 vssd1 vssd1 vccd1 vccd1 team_15_964/HI gpio_out[1] sky130_fd_sc_hd__conb_1
XFILLER_114_294 vssd1 vssd1 vccd1 vccd1 sky130_fd_sc_hd__fill_8
XANTENNA_fanout589_A net596 vssd1 vssd1 vccd1 vccd1 sky130_fd_sc_hd__diode_2
X_08986_ FPGA_INST.cell1.SB0.route_sel\[43\] _01683_ FPGA_INST.cell1.SB0.route_sel\[40\]
+ FPGA_INST.cell1.SB0.route_sel\[41\] vssd1 vssd1 vccd1 vccd1 _05164_ sky130_fd_sc_hd__o22a_1
XFILLER_88_657 vssd1 vssd1 vccd1 vccd1 sky130_fd_sc_hd__fill_4
Xteam_15_953 vssd1 vssd1 vccd1 vccd1 team_15_953/HI gpio_oeb[14] sky130_fd_sc_hd__conb_1
XANTENNA__11367__RESET_B net604 vssd1 vssd1 vccd1 vccd1 sky130_fd_sc_hd__diode_2
X_07937_ net466 _03854_ net465 vssd1 vssd1 vccd1 vccd1 _04165_ sky130_fd_sc_hd__o21ai_1
XANTENNA_fanout377_X net377 vssd1 vssd1 vccd1 vccd1 sky130_fd_sc_hd__diode_2
XTAP_TAPCELL_ROW_3_322 vssd1 vccd1 sky130_fd_sc_hd__tapvpwrvgnd_1
XFILLER_29_724 vssd1 vssd1 vccd1 vccd1 sky130_fd_sc_hd__fill_4
XFILLER_29_746 vssd1 vssd1 vccd1 vccd1 sky130_fd_sc_hd__fill_1
X_07868_ net469 net468 _03769_ vssd1 vssd1 vccd1 vccd1 _04096_ sky130_fd_sc_hd__or3_1
XFILLER_113_55 vssd1 vssd1 vccd1 vccd1 sky130_fd_sc_hd__fill_1
XFILLER_83_351 vssd1 vssd1 vccd1 vccd1 sky130_fd_sc_hd__fill_1
XANTENNA_fanout923_A net931 vssd1 vssd1 vccd1 vccd1 sky130_fd_sc_hd__diode_2
X_09607_ FPGA_INST.cell0.SB0.route_sel\[11\] FPGA_INST.cell0.SB0.route_sel\[10\] net323
+ vssd1 vssd1 vccd1 vccd1 _00516_ sky130_fd_sc_hd__mux2_1
X_07799_ FPGA_INST.cell1.SB0.route_sel\[124\] _01604_ FPGA_INST.cell1.SB0.config_data_out
+ _01605_ _04047_ vssd1 vssd1 vccd1 vccd1 _04048_ sky130_fd_sc_hd__a221o_1
X_06819_ _01599_ FPGA_INST.cell2.LE_1B.dff_out _03091_ net156 vssd1 vssd1 vccd1 vccd1
+ FPGA_INST.cell2.CB_1.le_outB sky130_fd_sc_hd__o211a_1
XFILLER_56_587 vssd1 vssd1 vccd1 vccd1 sky130_fd_sc_hd__fill_1
X_09538_ FPGA_INST.cell1.LE_0B.config_data\[11\] FPGA_INST.cell1.LE_0B.config_data\[10\]
+ net368 vssd1 vssd1 vccd1 vccd1 _00448_ sky130_fd_sc_hd__mux2_1
XFILLER_71_557 vssd1 vssd1 vccd1 vccd1 sky130_fd_sc_hd__fill_2
XANTENNA__08079__A3 FPGA_INST.bus3_1\[7\] vssd1 vssd1 vccd1 vccd1 sky130_fd_sc_hd__diode_2
X_09469_ FPGA_INST.cell1.LEI0.config_data\[15\] FPGA_INST.cell1.LEI0.config_data\[16\]
+ net228 vssd1 vssd1 vccd1 vccd1 _00381_ sky130_fd_sc_hd__mux2_1
XTAP_TAPCELL_ROW_61_1138 vssd1 vccd1 sky130_fd_sc_hd__tapvpwrvgnd_1
X_11500_ net763 _00850_ net548 vssd1 vssd1 vccd1 vccd1 FPGA_INST.cell0.CB_1.config_dataB\[6\]
+ sky130_fd_sc_hd__dfstp_1
XFILLER_51_281 vccd1 vssd1 vccd1 vssd1 sky130_ef_sc_hd__decap_40_12
XFILLER_11_123 vssd1 vssd1 vccd1 vccd1 sky130_fd_sc_hd__fill_2
XFILLER_12_624 vssd1 vssd1 vccd1 vccd1 sky130_fd_sc_hd__fill_4
XFILLER_11_134 vssd1 vssd1 vccd1 vccd1 sky130_fd_sc_hd__fill_8
XANTENNA__09210__S net379 vssd1 vssd1 vccd1 vccd1 sky130_fd_sc_hd__diode_2
XANTENNA__08236__A0 _03759_ vssd1 vssd1 vccd1 vccd1 sky130_fd_sc_hd__diode_2
XTAP_TAPCELL_ROW_50_983 vssd1 vccd1 sky130_fd_sc_hd__tapvpwrvgnd_1
XFILLER_7_138 vssd1 vssd1 vccd1 vccd1 sky130_fd_sc_hd__fill_1
X_11431_ net770 _00781_ net555 vssd1 vssd1 vccd1 vccd1 FPGA_INST.cell0.LE_0A.config_data\[2\]
+ sky130_fd_sc_hd__dfrtp_1
XFILLER_11_167 vssd1 vssd1 vccd1 vccd1 sky130_fd_sc_hd__fill_1
XFILLER_11_178 vssd1 vssd1 vccd1 vccd1 sky130_fd_sc_hd__fill_1
XANTENNA__07039__A1 FPGA_INST.bus2_0\[3\] vssd1 vssd1 vccd1 vccd1 sky130_fd_sc_hd__diode_2
X_11362_ net818 _00712_ net603 vssd1 vssd1 vccd1 vccd1 FPGA_INST.cell1.LE_1B.config_data\[4\]
+ sky130_fd_sc_hd__dfrtp_1
XTAP_TAPCELL_ROW_117_1927 vssd1 vccd1 sky130_fd_sc_hd__tapvpwrvgnd_1
XTAP_TAPCELL_ROW_117_1916 vssd1 vccd1 sky130_fd_sc_hd__tapvpwrvgnd_1
XFILLER_7_149 vssd1 vssd1 vccd1 vccd1 sky130_fd_sc_hd__fill_1
X_10313_ FPGA_INST.cell3.LEI0.config_data\[27\] FPGA_INST.cell3.LEI0.config_data\[28\]
+ net296 vssd1 vssd1 vccd1 vccd1 _01194_ sky130_fd_sc_hd__mux2_1
X_11293_ net836 _00643_ net620 vssd1 vssd1 vccd1 vccd1 FPGA_INST.cell1.CB_0.config_dataA\[10\]
+ sky130_fd_sc_hd__dfstp_1
XFILLER_112_209 vssd1 vssd1 vccd1 vccd1 sky130_fd_sc_hd__fill_1
XFILLER_106_795 vssd1 vssd1 vccd1 vccd1 sky130_fd_sc_hd__fill_2
X_10244_ FPGA_INST.io_south_oeb\[8\] FPGA_INST.io_south_oeb\[10\] net289 vssd1 vssd1
+ vccd1 vccd1 _01125_ sky130_fd_sc_hd__mux2_1
XFILLER_3_366 vssd1 vssd1 vccd1 vccd1 sky130_fd_sc_hd__fill_1
X_10175_ FPGA_INST.cell3.SB0.route_sel\[80\] FPGA_INST.cell3.SB0.route_sel\[79\] net373
+ vssd1 vssd1 vccd1 vccd1 _01056_ sky130_fd_sc_hd__mux2_1
XANTENNA__05693__B net165 vssd1 vssd1 vccd1 vccd1 sky130_fd_sc_hd__diode_2
XFILLER_94_627 vssd1 vssd1 vccd1 vccd1 sky130_fd_sc_hd__fill_1
XTAP_TAPCELL_ROW_72_1289 vssd1 vccd1 sky130_fd_sc_hd__tapvpwrvgnd_1
XFILLER_66_307 vssd1 vssd1 vccd1 vccd1 sky130_fd_sc_hd__fill_1
XFILLER_121_798 vssd1 vssd1 vccd1 vccd1 sky130_fd_sc_hd__fill_1
XFILLER_94_638 vssd1 vssd1 vccd1 vccd1 sky130_fd_sc_hd__fill_1
Xfanout180 net181 vssd1 vssd1 vccd1 vccd1 net180 sky130_fd_sc_hd__clkbuf_4
Xfanout191 net202 vssd1 vssd1 vccd1 vccd1 net191 sky130_fd_sc_hd__buf_2
XFILLER_35_705 vssd1 vssd1 vccd1 vccd1 sky130_fd_sc_hd__fill_1
XFILLER_62_513 vssd1 vssd1 vccd1 vccd1 sky130_fd_sc_hd__fill_1
XFILLER_30_421 vssd1 vssd1 vccd1 vccd1 sky130_fd_sc_hd__fill_4
X_11629_ net809 net739 net595 vssd1 vssd1 vccd1 vccd1 FPGA_INST.config_en_q sky130_fd_sc_hd__dfrtp_1
XANTENNA__08227__A0 net73 vssd1 vssd1 vccd1 vccd1 sky130_fd_sc_hd__diode_2
XANTENNA__06789__A0 _02793_ vssd1 vssd1 vccd1 vccd1 sky130_fd_sc_hd__diode_2
XFILLER_6_160 vssd1 vssd1 vccd1 vccd1 sky130_fd_sc_hd__fill_1
XFILLER_103_209 vssd1 vssd1 vccd1 vccd1 sky130_fd_sc_hd__fill_4
X_08840_ _04843_ _05036_ _05038_ _04846_ _01777_ vssd1 vssd1 vccd1 vccd1 _05047_ sky130_fd_sc_hd__a221o_1
XANTENNA__11569__SET_B net561 vssd1 vssd1 vccd1 vccd1 sky130_fd_sc_hd__diode_2
X_08771_ net18 net19 net20 net21 net390 net389 vssd1 vssd1 vccd1 vccd1 _04978_ sky130_fd_sc_hd__mux4_1
XFILLER_84_137 vssd1 vssd1 vccd1 vccd1 sky130_fd_sc_hd__fill_2
X_05983_ FPGA_INST.cell0.SB0.route_sel\[34\] FPGA_INST.cell0.SB0.route_sel\[35\] _02260_
+ _02261_ _02262_ vssd1 vssd1 vccd1 vccd1 _02263_ sky130_fd_sc_hd__a221o_1
XANTENNA__05764__A1 _02032_ vssd1 vssd1 vccd1 vccd1 sky130_fd_sc_hd__diode_2
X_07722_ net222 _03966_ _03970_ _03972_ vssd1 vssd1 vccd1 vccd1 _03973_ sky130_fd_sc_hd__and4_4
X_07653_ _03903_ _03905_ vssd1 vssd1 vccd1 vccd1 FPGA_INST.bus3_2\[11\] sky130_fd_sc_hd__and2b_2
XFILLER_65_362 vssd1 vssd1 vccd1 vccd1 sky130_fd_sc_hd__fill_1
XFILLER_80_343 vssd1 vssd1 vccd1 vccd1 sky130_fd_sc_hd__fill_4
XFILLER_80_321 vssd1 vssd1 vccd1 vccd1 sky130_fd_sc_hd__fill_1
X_06604_ net477 net479 vssd1 vssd1 vccd1 vccd1 _02880_ sky130_fd_sc_hd__and2b_1
X_09323_ FPGA_INST.cell1.SB0.route_sel\[95\] FPGA_INST.cell1.SB0.route_sel\[94\] net329
+ vssd1 vssd1 vccd1 vccd1 _00236_ sky130_fd_sc_hd__mux2_1
X_07584_ FPGA_INST.cell0.SB0.route_sel\[80\] FPGA_INST.cell0.SB0.route_sel\[81\] vssd1
+ vssd1 vccd1 vccd1 _03838_ sky130_fd_sc_hd__nand2b_1
XTAP_TAPCELL_ROW_36_788 vssd1 vccd1 sky130_fd_sc_hd__tapvpwrvgnd_1
XANTENNA_fanout337_A net381 vssd1 vssd1 vccd1 vccd1 sky130_fd_sc_hd__diode_2
XFILLER_80_398 vssd1 vssd1 vccd1 vccd1 sky130_fd_sc_hd__fill_1
X_06535_ _02810_ vssd1 vssd1 vccd1 vccd1 _02811_ sky130_fd_sc_hd__inv_2
X_09254_ FPGA_INST.cell1.SB0.route_sel\[26\] FPGA_INST.cell1.SB0.route_sel\[25\] net338
+ vssd1 vssd1 vccd1 vccd1 _00167_ sky130_fd_sc_hd__mux2_1
X_06466_ net488 _02056_ _02743_ net487 vssd1 vssd1 vccd1 vccd1 _02744_ sky130_fd_sc_hd__o211a_1
X_05417_ FPGA_INST.cell1.SB0.route_sel\[30\] vssd1 vssd1 vccd1 vccd1 _01699_ sky130_fd_sc_hd__inv_2
X_08205_ net409 _04040_ vssd1 vssd1 vccd1 vccd1 _04429_ sky130_fd_sc_hd__nand2_1
XFILLER_21_465 vssd1 vssd1 vccd1 vccd1 sky130_fd_sc_hd__fill_1
X_09185_ FPGA_INST.cell2.LE_1A.config_data\[3\] FPGA_INST.cell2.LE_1A.config_data\[2\]
+ net361 vssd1 vssd1 vccd1 vccd1 _00098_ sky130_fd_sc_hd__mux2_1
X_08136_ _04339_ _04343_ _04347_ _04361_ FPGA_INST.cell1.CB_0.config_dataB\[19\] vssd1
+ vssd1 vccd1 vccd1 _04362_ sky130_fd_sc_hd__a311o_1
XANTENNA__08769__B2 _04831_ vssd1 vssd1 vccd1 vccd1 sky130_fd_sc_hd__diode_2
X_06397_ net497 _01914_ vssd1 vssd1 vccd1 vccd1 _02675_ sky130_fd_sc_hd__nand2_1
X_05348_ FPGA_INST.cell1.SB0.route_sel\[103\] vssd1 vssd1 vccd1 vccd1 _01630_ sky130_fd_sc_hd__inv_2
XFILLER_107_559 vssd1 vssd1 vccd1 vccd1 sky130_fd_sc_hd__fill_1
X_08067_ FPGA_INST.cell1.CB_0.config_dataB\[3\] _04266_ FPGA_INST.cell1.CB_0.config_dataB\[2\]
+ FPGA_INST.cell1.CB_0.config_dataB\[4\] vssd1 vssd1 vccd1 vccd1 _04293_ sky130_fd_sc_hd__or4b_1
X_05279_ FPGA_INST.cell2.SB0.route_sel\[55\] vssd1 vssd1 vccd1 vccd1 _01561_ sky130_fd_sc_hd__inv_2
X_07018_ net436 FPGA_INST.cell0.CB_0.config_dataA\[1\] vssd1 vssd1 vccd1 vccd1 _03284_
+ sky130_fd_sc_hd__nor2_2
XTAP_TAPCELL_ROW_112_1857 vssd1 vccd1 sky130_fd_sc_hd__tapvpwrvgnd_1
XTAP_TAPCELL_ROW_112_1846 vssd1 vccd1 sky130_fd_sc_hd__tapvpwrvgnd_1
XANTENNA_fanout873_A net892 vssd1 vssd1 vccd1 vccd1 sky130_fd_sc_hd__diode_2
XFILLER_102_231 vssd1 vssd1 vccd1 vccd1 sky130_fd_sc_hd__fill_1
XFILLER_103_798 vssd1 vssd1 vccd1 vccd1 sky130_fd_sc_hd__fill_1
XFILLER_88_498 vssd1 vssd1 vccd1 vccd1 sky130_fd_sc_hd__fill_1
X_08969_ FPGA_INST.cell1.SB0.route_sel\[60\] _01667_ _05152_ vssd1 vssd1 vccd1 vccd1
+ _05153_ sky130_fd_sc_hd__o21ai_1
XFILLER_75_126 vssd1 vssd1 vccd1 vccd1 sky130_fd_sc_hd__fill_1
XFILLER_75_148 vssd1 vssd1 vccd1 vccd1 sky130_fd_sc_hd__fill_8
X_11980_ net844 _01326_ net629 vssd1 vssd1 vccd1 vccd1 FPGA_INST.cell2.SB0.route_sel\[20\]
+ sky130_fd_sc_hd__dfstp_1
XANTENNA__06704__A0 FPGA_INST.bus3_2\[0\] vssd1 vssd1 vccd1 vccd1 sky130_fd_sc_hd__diode_2
X_10931_ net846 _00281_ net631 vssd1 vssd1 vccd1 vccd1 FPGA_INST.cell2.CB_0.config_dataA\[12\]
+ sky130_fd_sc_hd__dfstp_1
XFILLER_84_693 vssd1 vssd1 vccd1 vccd1 sky130_fd_sc_hd__fill_1
X_10862_ net798 _00212_ net583 vssd1 vssd1 vccd1 vccd1 FPGA_INST.cell1.SB0.route_sel\[71\]
+ sky130_fd_sc_hd__dfstp_1
X_10793_ net824 _00143_ net608 vssd1 vssd1 vccd1 vccd1 FPGA_INST.cell1.SB0.route_sel\[2\]
+ sky130_fd_sc_hd__dfstp_1
XFILLER_8_425 vssd1 vssd1 vccd1 vccd1 sky130_fd_sc_hd__fill_2
X_11414_ net744 _00764_ net529 vssd1 vssd1 vccd1 vccd1 FPGA_INST.cell0.LEI0.config_data\[35\]
+ sky130_fd_sc_hd__dfrtp_1
XANTENNA__07432__A1 _03677_ vssd1 vssd1 vccd1 vccd1 sky130_fd_sc_hd__diode_2
X_11345_ net793 _00695_ net578 vssd1 vssd1 vccd1 vccd1 FPGA_INST.cell1.CB_1.config_dataA\[12\]
+ sky130_fd_sc_hd__dfstp_1
XTAP_TAPCELL_ROW_74_1318 vssd1 vccd1 sky130_fd_sc_hd__tapvpwrvgnd_1
X_11276_ net786 _00626_ net571 vssd1 vssd1 vccd1 vccd1 FPGA_INST.cell0.SB0.route_sel\[121\]
+ sky130_fd_sc_hd__dfstp_1
XANTENNA__06152__X _02432_ vssd1 vssd1 vccd1 vccd1 sky130_fd_sc_hd__diode_2
XFILLER_106_581 vssd1 vssd1 vccd1 vccd1 sky130_fd_sc_hd__fill_2
X_10227_ FPGA_INST.io_west_oeb\[6\] FPGA_INST.io_west_oeb\[8\] net291 vssd1 vssd1
+ vccd1 vccd1 _01108_ sky130_fd_sc_hd__mux2_1
XFILLER_121_551 vssd1 vssd1 vccd1 vccd1 sky130_fd_sc_hd__fill_8
X_10158_ FPGA_INST.cell3.SB0.route_sel\[62\] FPGA_INST.cell3.SB0.route_sel\[63\] net271
+ vssd1 vssd1 vccd1 vccd1 _01039_ sky130_fd_sc_hd__mux2_1
X_10089_ FPGA_INST.cell0.LE_1B.config_data\[13\] FPGA_INST.cell0.LE_1B.config_data\[14\]
+ net173 vssd1 vssd1 vccd1 vccd1 _00970_ sky130_fd_sc_hd__mux2_1
XFILLER_35_502 vssd1 vssd1 vccd1 vccd1 sky130_fd_sc_hd__fill_2
XFILLER_47_395 vssd1 vssd1 vccd1 vccd1 sky130_fd_sc_hd__fill_2
XTAP_TAPCELL_ROW_85_1469 vssd1 vccd1 sky130_fd_sc_hd__tapvpwrvgnd_1
XFILLER_74_80 vssd1 vssd1 vccd1 vccd1 sky130_fd_sc_hd__fill_2
XFILLER_62_365 vssd1 vssd1 vccd1 vccd1 sky130_fd_sc_hd__fill_4
X_06320_ net6 _02575_ _02599_ FPGA_INST.cell2.CB_0.config_dataA\[18\] vssd1 vssd1
+ vccd1 vccd1 _02600_ sky130_fd_sc_hd__a211o_1
XTAP_TAPCELL_ROW_33_747 vssd1 vccd1 sky130_fd_sc_hd__tapvpwrvgnd_1
X_06251_ _02527_ _02530_ FPGA_INST.cell2.CB_0.config_dataA\[3\] vssd1 vssd1 vccd1
+ vccd1 _02531_ sky130_fd_sc_hd__or3b_1
XTAP_TAPCELL_ROW_13_460 vssd1 vccd1 sky130_fd_sc_hd__tapvpwrvgnd_1
XFILLER_30_251 vssd1 vssd1 vccd1 vccd1 sky130_fd_sc_hd__fill_1
XFILLER_30_262 vssd1 vssd1 vccd1 vccd1 sky130_fd_sc_hd__fill_1
XTAP_TAPCELL_ROW_13_471 vssd1 vccd1 sky130_fd_sc_hd__tapvpwrvgnd_1
X_06182_ _02453_ _02458_ _02460_ net321 vssd1 vssd1 vccd1 vccd1 _02462_ sky130_fd_sc_hd__a211o_1
XANTENNA__08215__A3 net99 vssd1 vssd1 vccd1 vccd1 sky130_fd_sc_hd__diode_2
XFILLER_116_378 vssd1 vssd1 vccd1 vccd1 sky130_fd_sc_hd__fill_4
X_09941_ FPGA_INST.cell0.CB_1.config_dataB\[2\] FPGA_INST.cell0.CB_1.config_dataB\[1\]
+ net327 vssd1 vssd1 vccd1 vccd1 _00846_ sky130_fd_sc_hd__mux2_1
Xfanout916 net917 vssd1 vssd1 vccd1 vccd1 net916 sky130_fd_sc_hd__clkbuf_2
Xfanout905 net906 vssd1 vssd1 vccd1 vccd1 net905 sky130_fd_sc_hd__clkbuf_2
Xfanout938 net945 vssd1 vssd1 vccd1 vccd1 net938 sky130_fd_sc_hd__clkbuf_1
Xfanout927 net930 vssd1 vssd1 vccd1 vccd1 net927 sky130_fd_sc_hd__buf_2
X_09872_ FPGA_INST.cell0.LE_0A.config_data\[0\] net23 net316 vssd1 vssd1 vccd1 vccd1
+ _00779_ sky130_fd_sc_hd__mux2_1
X_08823_ _05029_ vssd1 vssd1 vccd1 vccd1 _05030_ sky130_fd_sc_hd__inv_2
XTAP_TAPCELL_ROW_127_2064 vssd1 vccd1 sky130_fd_sc_hd__tapvpwrvgnd_1
XFILLER_100_768 vssd1 vssd1 vccd1 vccd1 sky130_fd_sc_hd__fill_2
X_08754_ _04924_ _04962_ _04922_ vssd1 vssd1 vccd1 vccd1 _04963_ sky130_fd_sc_hd__mux2_1
X_05966_ _01856_ _02207_ vssd1 vssd1 vccd1 vccd1 _02246_ sky130_fd_sc_hd__nand2_1
X_07705_ _03953_ _03955_ vssd1 vssd1 vccd1 vccd1 _03956_ sky130_fd_sc_hd__nand2_1
XFILLER_38_351 vssd1 vssd1 vccd1 vccd1 sky130_fd_sc_hd__fill_1
X_08685_ net396 _04893_ vssd1 vssd1 vccd1 vccd1 _04894_ sky130_fd_sc_hd__nand2_1
XFILLER_53_332 vssd1 vssd1 vccd1 vccd1 sky130_fd_sc_hd__fill_4
XFILLER_26_535 vssd1 vssd1 vccd1 vccd1 sky130_fd_sc_hd__fill_8
X_05897_ FPGA_INST.cell0.SB0.route_sel\[56\] FPGA_INST.cell0.SB0.route_sel\[57\] vssd1
+ vssd1 vccd1 vccd1 _02177_ sky130_fd_sc_hd__and2_1
X_07636_ _03881_ _03884_ _03886_ _03888_ vssd1 vssd1 vccd1 vccd1 _03889_ sky130_fd_sc_hd__o211a_4
XFILLER_13_207 vssd1 vssd1 vccd1 vccd1 sky130_fd_sc_hd__fill_2
XANTENNA_fanout621_A net627 vssd1 vssd1 vccd1 vccd1 sky130_fd_sc_hd__diode_2
X_07567_ FPGA_INST.cell3.CB_0.config_dataB\[22\] net85 FPGA_INST.cell3.CB_0.config_dataB\[23\]
+ vssd1 vssd1 vccd1 vccd1 _03822_ sky130_fd_sc_hd__and3b_1
XFILLER_53_376 vssd1 vssd1 vccd1 vccd1 sky130_fd_sc_hd__fill_1
XFILLER_41_549 vssd1 vssd1 vccd1 vccd1 sky130_fd_sc_hd__fill_2
XANTENNA_fanout719_A net730 vssd1 vssd1 vccd1 vccd1 sky130_fd_sc_hd__diode_2
X_09306_ FPGA_INST.cell1.SB0.route_sel\[77\] FPGA_INST.cell1.SB0.route_sel\[78\] net208
+ vssd1 vssd1 vccd1 vccd1 _00219_ sky130_fd_sc_hd__mux2_1
X_06518_ FPGA_INST.cell2.SB0.route_sel\[60\] FPGA_INST.cell2.SB0.route_sel\[61\] vssd1
+ vssd1 vccd1 vccd1 _02794_ sky130_fd_sc_hd__nor2_1
XFILLER_110_89 vssd1 vssd1 vccd1 vccd1 sky130_fd_sc_hd__fill_1
X_07498_ _03753_ vssd1 vssd1 vccd1 vccd1 _03754_ sky130_fd_sc_hd__inv_2
X_09237_ FPGA_INST.cell1.SB0.route_sel\[8\] FPGA_INST.cell1.SB0.route_sel\[9\] net224
+ vssd1 vssd1 vccd1 vccd1 _00150_ sky130_fd_sc_hd__mux2_1
XFILLER_21_262 vssd1 vssd1 vccd1 vccd1 sky130_fd_sc_hd__fill_1
XANTENNA__09695__S net196 vssd1 vssd1 vccd1 vccd1 sky130_fd_sc_hd__diode_2
X_06449_ net488 _02413_ _02726_ net487 vssd1 vssd1 vccd1 vccd1 _02727_ sky130_fd_sc_hd__o211a_1
XFILLER_119_54 vssd1 vssd1 vccd1 vccd1 sky130_fd_sc_hd__fill_2
XFILLER_107_312 vssd1 vssd1 vccd1 vccd1 sky130_fd_sc_hd__fill_1
X_09168_ FPGA_INST.cell2.LE_0B.config_data\[9\] FPGA_INST.cell2.LE_0B.config_data\[8\]
+ net358 vssd1 vssd1 vccd1 vccd1 _00082_ sky130_fd_sc_hd__mux2_1
XFILLER_5_417 vccd1 vssd1 vccd1 vssd1 sky130_ef_sc_hd__decap_40_12
X_08119_ net451 _03690_ _04344_ net450 vssd1 vssd1 vccd1 vccd1 _04345_ sky130_fd_sc_hd__o211a_1
XANTENNA__07414__A1 net81 vssd1 vssd1 vccd1 vccd1 sky130_fd_sc_hd__diode_2
X_09099_ FPGA_INST.cell2.LEI0.config_data\[13\] FPGA_INST.cell2.LEI0.config_data\[14\]
+ net256 vssd1 vssd1 vccd1 vccd1 _00015_ sky130_fd_sc_hd__mux2_1
X_11130_ net812 _00480_ net597 vssd1 vssd1 vccd1 vccd1 FPGA_INST.cell1.CB_1.config_dataB\[0\]
+ sky130_fd_sc_hd__dfstp_1
XANTENNA__07965__A2 FPGA_INST.bus3_1\[6\] vssd1 vssd1 vccd1 vccd1 sky130_fd_sc_hd__diode_2
X_11061_ net807 _00411_ net592 vssd1 vssd1 vccd1 vccd1 FPGA_INST.cell1.LEI0.config_data\[46\]
+ sky130_fd_sc_hd__dfrtp_1
XFILLER_88_251 vssd1 vssd1 vccd1 vccd1 sky130_fd_sc_hd__fill_1
XANTENNA__07228__B _03490_ vssd1 vssd1 vccd1 vccd1 sky130_fd_sc_hd__diode_2
XFILLER_103_573 vssd1 vssd1 vccd1 vccd1 sky130_fd_sc_hd__fill_8
XFILLER_48_126 vssd1 vssd1 vccd1 vccd1 sky130_fd_sc_hd__fill_8
XFILLER_0_155 vssd1 vssd1 vccd1 vccd1 sky130_fd_sc_hd__fill_1
X_10012_ FPGA_INST.cell0.CB_0.config_dataA\[12\] net429 net319 vssd1 vssd1 vccd1 vccd1
+ _00893_ sky130_fd_sc_hd__mux2_1
XANTENNA_input15_A gpio_in[22] vssd1 vssd1 vccd1 vccd1 sky130_fd_sc_hd__diode_2
X_11963_ net852 _01309_ net637 vssd1 vssd1 vccd1 vccd1 FPGA_INST.cell2.SB0.route_sel\[3\]
+ sky130_fd_sc_hd__dfstp_1
XANTENNA__12170__RESET_B net695 vssd1 vssd1 vccd1 vccd1 sky130_fd_sc_hd__diode_2
X_11894_ net939 _01240_ net723 vssd1 vssd1 vccd1 vccd1 FPGA_INST.cell3.LE_0B.config_data\[2\]
+ sky130_fd_sc_hd__dfrtp_1
X_10914_ net786 _00264_ net571 vssd1 vssd1 vccd1 vccd1 FPGA_INST.cell1.SB0.route_sel\[123\]
+ sky130_fd_sc_hd__dfstp_1
XANTENNA__07898__B _03568_ vssd1 vssd1 vccd1 vccd1 sky130_fd_sc_hd__diode_2
X_10845_ net800 _00195_ net585 vssd1 vssd1 vccd1 vccd1 FPGA_INST.cell1.SB0.route_sel\[54\]
+ sky130_fd_sc_hd__dfstp_1
XANTENNA__05900__A1 net170 vssd1 vssd1 vccd1 vccd1 sky130_fd_sc_hd__diode_2
XFILLER_44_83 vssd1 vssd1 vccd1 vccd1 sky130_fd_sc_hd__fill_1
XFILLER_13_752 vssd1 vssd1 vccd1 vccd1 sky130_fd_sc_hd__fill_1
XFILLER_25_590 vssd1 vssd1 vccd1 vccd1 sky130_fd_sc_hd__fill_4
X_10776_ net919 _00126_ net703 vssd1 vssd1 vccd1 vccd1 FPGA_INST.cell2.CB_1.config_dataB\[10\]
+ sky130_fd_sc_hd__dfstp_1
XFILLER_12_262 vssd1 vssd1 vccd1 vccd1 sky130_fd_sc_hd__fill_1
XTAP_TAPCELL_ROW_30_706 vssd1 vccd1 sky130_fd_sc_hd__tapvpwrvgnd_1
XTAP_TAPCELL_ROW_80_1399 vssd1 vccd1 sky130_fd_sc_hd__tapvpwrvgnd_1
XFILLER_8_244 vssd1 vssd1 vccd1 vccd1 sky130_fd_sc_hd__fill_2
XANTENNA__06307__B _02217_ vssd1 vssd1 vccd1 vccd1 sky130_fd_sc_hd__diode_2
XFILLER_8_266 vssd1 vssd1 vccd1 vccd1 sky130_fd_sc_hd__fill_2
XFILLER_126_643 vssd1 vssd1 vccd1 vccd1 sky130_fd_sc_hd__fill_1
XFILLER_8_299 vssd1 vssd1 vccd1 vccd1 sky130_fd_sc_hd__fill_8
XANTENNA__06208__A2 _02450_ vssd1 vssd1 vccd1 vccd1 sky130_fd_sc_hd__diode_2
XFILLER_99_505 vssd1 vssd1 vccd1 vccd1 sky130_fd_sc_hd__fill_2
X_11328_ net842 _00678_ net626 vssd1 vssd1 vccd1 vccd1 FPGA_INST.cell1.CB_0.config_dataB\[20\]
+ sky130_fd_sc_hd__dfstp_2
XFILLER_113_337 vssd1 vssd1 vccd1 vccd1 sky130_fd_sc_hd__fill_1
X_11259_ net784 _00609_ net569 vssd1 vssd1 vccd1 vccd1 FPGA_INST.cell0.SB0.route_sel\[104\]
+ sky130_fd_sc_hd__dfstp_2
XFILLER_67_468 vssd1 vssd1 vccd1 vccd1 sky130_fd_sc_hd__fill_4
X_05820_ net165 net161 FPGA_INST.bus1_0\[9\] vssd1 vssd1 vccd1 vccd1 _02100_ sky130_fd_sc_hd__o21ai_1
XFILLER_10_3 vccd1 vssd1 vccd1 vssd1 sky130_ef_sc_hd__decap_40_12
XTAP_TAPCELL_ROW_38_817 vssd1 vccd1 sky130_fd_sc_hd__tapvpwrvgnd_1
X_05751_ net385 net162 _02026_ _02029_ vssd1 vssd1 vccd1 vccd1 _02031_ sky130_fd_sc_hd__a2bb2o_1
XANTENNA__08537__X FPGA_INST.cell3.CB_1.le_outA vssd1 vssd1 vccd1 vccd1 sky130_fd_sc_hd__diode_2
X_08470_ FPGA_INST.cell1.LEI0.config_data\[23\] _04685_ vssd1 vssd1 vccd1 vccd1 _04686_
+ sky130_fd_sc_hd__nand2b_1
XFILLER_90_460 vssd1 vssd1 vccd1 vccd1 sky130_fd_sc_hd__fill_1
XTAP_TAPCELL_ROW_18_530 vssd1 vccd1 sky130_fd_sc_hd__tapvpwrvgnd_1
XTAP_TAPCELL_ROW_18_541 vssd1 vccd1 sky130_fd_sc_hd__tapvpwrvgnd_1
XFILLER_23_505 vssd1 vssd1 vccd1 vccd1 sky130_fd_sc_hd__fill_1
X_05682_ _01960_ _01961_ vssd1 vssd1 vccd1 vccd1 _01962_ sky130_fd_sc_hd__or2_1
XANTENNA__07892__A1 _03652_ vssd1 vssd1 vccd1 vccd1 sky130_fd_sc_hd__diode_2
XFILLER_50_302 vssd1 vssd1 vccd1 vccd1 sky130_fd_sc_hd__fill_2
X_07421_ FPGA_INST.cell0.SB0.route_sel\[52\] FPGA_INST.cell0.SB0.route_sel\[53\] vssd1
+ vssd1 vccd1 vccd1 _03679_ sky130_fd_sc_hd__or2_1
X_07352_ FPGA_INST.cell1.SB0.route_sel\[34\] FPGA_INST.cell1.SB0.route_sel\[35\] _01692_
+ FPGA_INST.cell1.SB0.route_sel\[37\] _03611_ vssd1 vssd1 vccd1 vccd1 _03612_ sky130_fd_sc_hd__o221a_1
X_06303_ _01966_ _02574_ _02575_ _02010_ _01535_ vssd1 vssd1 vccd1 vccd1 _02583_ sky130_fd_sc_hd__a221o_1
XANTENNA__07644__A1 _03542_ vssd1 vssd1 vccd1 vccd1 sky130_fd_sc_hd__diode_2
X_07283_ _03429_ _03542_ net78 vssd1 vssd1 vccd1 vccd1 _03544_ sky130_fd_sc_hd__o21ai_1
XTAP_TAPCELL_ROW_98_1649 vssd1 vccd1 sky130_fd_sc_hd__tapvpwrvgnd_1
X_09022_ FPGA_INST.cell1.SB0.route_sel\[12\] FPGA_INST.cell1.SB0.route_sel\[13\] vssd1
+ vssd1 vccd1 vccd1 _05188_ sky130_fd_sc_hd__nand2b_1
X_06234_ FPGA_INST.cell2.CB_0.config_dataA\[3\] FPGA_INST.cell2.CB_0.config_dataA\[2\]
+ vssd1 vssd1 vccd1 vccd1 _02514_ sky130_fd_sc_hd__or2_1
XFILLER_117_643 vssd1 vssd1 vccd1 vccd1 sky130_fd_sc_hd__fill_8
X_06165_ net135 _02442_ _02434_ vssd1 vssd1 vccd1 vccd1 _02445_ sky130_fd_sc_hd__o21ai_1
XANTENNA_fanout202_A net234 vssd1 vssd1 vccd1 vccd1 sky130_fd_sc_hd__diode_2
XANTENNA__06504__Y _02780_ vssd1 vssd1 vccd1 vccd1 sky130_fd_sc_hd__diode_2
XFILLER_116_197 vssd1 vssd1 vccd1 vccd1 sky130_fd_sc_hd__fill_4
X_06096_ _02375_ _02373_ vssd1 vssd1 vccd1 vccd1 _02376_ sky130_fd_sc_hd__nand2b_4
Xfanout724 net729 vssd1 vssd1 vccd1 vccd1 net724 sky130_fd_sc_hd__buf_2
XANTENNA__08859__S _05032_ vssd1 vssd1 vccd1 vccd1 sky130_fd_sc_hd__diode_2
Xfanout713 net714 vssd1 vssd1 vccd1 vccd1 net713 sky130_fd_sc_hd__buf_2
Xfanout702 net731 vssd1 vssd1 vccd1 vccd1 net702 sky130_fd_sc_hd__buf_2
X_09924_ FPGA_INST.cell0.LE_1A.config_data\[5\] FPGA_INST.cell0.LE_1A.config_data\[6\]
+ net175 vssd1 vssd1 vccd1 vccd1 _00829_ sky130_fd_sc_hd__mux2_1
Xfanout735 net29 vssd1 vssd1 vccd1 vccd1 net735 sky130_fd_sc_hd__buf_2
XFILLER_105_23 vssd1 vssd1 vccd1 vccd1 sky130_fd_sc_hd__fill_1
XANTENNA_input7_A gpio_in[15] vssd1 vssd1 vccd1 vccd1 sky130_fd_sc_hd__diode_2
X_09855_ FPGA_INST.cell0.LEI0.config_data\[33\] FPGA_INST.cell0.LEI0.config_data\[34\]
+ net174 vssd1 vssd1 vccd1 vccd1 _00763_ sky130_fd_sc_hd__mux2_1
XANTENNA__06520__X _02796_ vssd1 vssd1 vccd1 vccd1 sky130_fd_sc_hd__diode_2
Xfanout746 net749 vssd1 vssd1 vccd1 vccd1 net746 sky130_fd_sc_hd__buf_1
Xfanout757 net758 vssd1 vssd1 vccd1 vccd1 net757 sky130_fd_sc_hd__dlymetal6s2s_1
XFILLER_100_543 vssd1 vssd1 vccd1 vccd1 sky130_fd_sc_hd__fill_4
X_08806_ net22 net24 net25 net26 net392 net391 vssd1 vssd1 vccd1 vccd1 _05013_ sky130_fd_sc_hd__mux4_1
XFILLER_86_755 vssd1 vssd1 vccd1 vccd1 sky130_fd_sc_hd__fill_1
Xfanout779 net780 vssd1 vssd1 vccd1 vccd1 net779 sky130_fd_sc_hd__clkbuf_2
Xfanout768 net769 vssd1 vssd1 vccd1 vccd1 net768 sky130_fd_sc_hd__clkbuf_2
XANTENNA_fanout669_A net675 vssd1 vssd1 vccd1 vccd1 sky130_fd_sc_hd__diode_2
XFILLER_86_777 vssd1 vssd1 vccd1 vccd1 sky130_fd_sc_hd__fill_2
X_09786_ FPGA_INST.cell1.CB_1.config_dataA\[12\] FPGA_INST.cell1.CB_1.config_dataA\[11\]
+ net326 vssd1 vssd1 vccd1 vccd1 _00695_ sky130_fd_sc_hd__mux2_1
XFILLER_73_405 vssd1 vssd1 vccd1 vccd1 sky130_fd_sc_hd__fill_2
XANTENNA__06383__B2 _02293_ vssd1 vssd1 vccd1 vccd1 sky130_fd_sc_hd__diode_2
XANTENNA__06383__A1 _02330_ vssd1 vssd1 vccd1 vccd1 sky130_fd_sc_hd__diode_2
X_06998_ net433 _01888_ vssd1 vssd1 vccd1 vccd1 _03264_ sky130_fd_sc_hd__nand2_1
XFILLER_39_671 vssd1 vssd1 vccd1 vccd1 sky130_fd_sc_hd__fill_1
X_08737_ net393 _04943_ _04944_ _04945_ vssd1 vssd1 vccd1 vccd1 _04946_ sky130_fd_sc_hd__a31o_1
XFILLER_85_298 vssd1 vssd1 vccd1 vccd1 sky130_fd_sc_hd__fill_2
XFILLER_73_449 vccd1 vssd1 vccd1 vssd1 sky130_ef_sc_hd__decap_40_12
X_05949_ _02220_ _02225_ _02228_ net317 vssd1 vssd1 vccd1 vccd1 _02229_ sky130_fd_sc_hd__a211oi_1
X_08668_ _04794_ _04863_ _04865_ _04789_ FPGA_INST.cell3.CB_0.config_dataA\[7\] vssd1
+ vssd1 vccd1 vccd1 _04877_ sky130_fd_sc_hd__a221o_1
XFILLER_26_365 vssd1 vssd1 vccd1 vccd1 sky130_fd_sc_hd__fill_2
XTAP_TAPCELL_ROW_107_1778 vssd1 vccd1 sky130_fd_sc_hd__tapvpwrvgnd_1
XFILLER_81_15 vccd1 vssd1 vccd1 vssd1 sky130_ef_sc_hd__decap_40_12
X_07619_ FPGA_INST.cell1.SB0.route_sel\[90\] FPGA_INST.cell1.SB0.route_sel\[91\] vssd1
+ vssd1 vccd1 vccd1 _03872_ sky130_fd_sc_hd__nand2_1
XFILLER_53_151 vssd1 vssd1 vccd1 vccd1 sky130_fd_sc_hd__fill_8
X_10630_ FPGA_INST.cell3.LE_0A.reset_mode FPGA_INST.cell3.LE_1B.config_data\[0\] net280
+ vssd1 vssd1 vccd1 vccd1 _01509_ sky130_fd_sc_hd__mux2_1
X_08599_ _01627_ FPGA_INST.cell3.SB0.route_sel\[100\] _01628_ FPGA_INST.cell3.SB0.route_sel\[103\]
+ _04807_ vssd1 vssd1 vccd1 vccd1 _04808_ sky130_fd_sc_hd__a221o_1
XTAP_TAPCELL_ROW_120_1967 vssd1 vccd1 sky130_fd_sc_hd__tapvpwrvgnd_1
XTAP_TAPCELL_ROW_120_1956 vssd1 vccd1 sky130_fd_sc_hd__tapvpwrvgnd_1
X_10561_ net399 net398 net288 vssd1 vssd1 vccd1 vccd1 _01440_ sky130_fd_sc_hd__mux2_1
XANTENNA__05646__B1 net77 vssd1 vssd1 vccd1 vccd1 sky130_fd_sc_hd__diode_2
XFILLER_10_777 vssd1 vssd1 vccd1 vccd1 sky130_fd_sc_hd__fill_1
X_10492_ FPGA_INST.cell2.SB0.route_sel\[64\] FPGA_INST.cell2.SB0.route_sel\[65\] net246
+ vssd1 vssd1 vccd1 vccd1 _01371_ sky130_fd_sc_hd__mux2_1
XFILLER_5_225 vssd1 vssd1 vccd1 vccd1 sky130_fd_sc_hd__fill_2
XFILLER_30_41 vccd1 vssd1 vccd1 vssd1 sky130_ef_sc_hd__decap_40_12
XFILLER_123_613 vssd1 vssd1 vccd1 vccd1 sky130_fd_sc_hd__fill_2
XFILLER_107_164 vssd1 vssd1 vccd1 vccd1 sky130_fd_sc_hd__fill_2
XANTENNA__07938__A2 _03889_ vssd1 vssd1 vccd1 vccd1 sky130_fd_sc_hd__diode_2
XFILLER_122_123 vssd1 vssd1 vccd1 vccd1 sky130_fd_sc_hd__fill_1
X_12162_ net912 _01508_ net696 vssd1 vssd1 vccd1 vccd1 FPGA_INST.cell3.CB_1.config_dataA\[24\]
+ sky130_fd_sc_hd__dfstp_1
XANTENNA__08910__X FPGA_INST.bus2_0\[14\] vssd1 vssd1 vccd1 vccd1 sky130_fd_sc_hd__diode_2
XANTENNA__11913__SET_B net735 vssd1 vssd1 vccd1 vccd1 sky130_fd_sc_hd__diode_2
X_11113_ net804 _00463_ net589 vssd1 vssd1 vccd1 vccd1 FPGA_INST.cell1.LE_1A.config_data\[4\]
+ sky130_fd_sc_hd__dfrtp_1
XFILLER_96_519 vssd1 vssd1 vccd1 vccd1 sky130_fd_sc_hd__fill_4
X_12093_ net921 _01439_ net705 vssd1 vssd1 vccd1 vccd1 FPGA_INST.cell3.CB_0.config_dataA\[5\]
+ sky130_fd_sc_hd__dfstp_1
XFILLER_77_700 vssd1 vssd1 vccd1 vccd1 sky130_fd_sc_hd__fill_2
X_11044_ net815 _00394_ net600 vssd1 vssd1 vccd1 vccd1 FPGA_INST.cell1.LEI0.config_data\[29\]
+ sky130_fd_sc_hd__dfrtp_1
XANTENNA__05982__A net112 vssd1 vssd1 vccd1 vccd1 sky130_fd_sc_hd__diode_2
XANTENNA_input18_X net18 vssd1 vssd1 vccd1 vccd1 sky130_fd_sc_hd__diode_2
XPHY_EDGE_ROW_101_Right_101 vssd1 vssd1 vccd1 vccd1 sky130_fd_sc_hd__decap_3
XFILLER_92_769 vssd1 vssd1 vccd1 vccd1 sky130_fd_sc_hd__fill_8
X_11946_ net916 _01292_ net700 vssd1 vssd1 vccd1 vccd1 FPGA_INST.cell3.CB_1.config_dataB\[11\]
+ sky130_fd_sc_hd__dfstp_1
XANTENNA__08115__A2 FPGA_INST.bus3_1\[6\] vssd1 vssd1 vccd1 vccd1 sky130_fd_sc_hd__diode_2
XFILLER_91_279 vssd1 vssd1 vccd1 vccd1 sky130_fd_sc_hd__fill_1
XFILLER_91_246 vssd1 vssd1 vccd1 vccd1 sky130_fd_sc_hd__fill_2
XFILLER_17_354 vssd1 vssd1 vccd1 vccd1 sky130_fd_sc_hd__fill_1
XTAP_TAPCELL_ROW_82_1428 vssd1 vccd1 sky130_fd_sc_hd__tapvpwrvgnd_1
X_11877_ net928 _01223_ net712 vssd1 vssd1 vccd1 vccd1 FPGA_INST.cell3.LE_0A.config_data\[7\]
+ sky130_fd_sc_hd__dfrtp_1
XFILLER_44_195 vssd1 vssd1 vccd1 vccd1 sky130_fd_sc_hd__fill_1
XFILLER_32_357 vssd1 vssd1 vccd1 vccd1 sky130_fd_sc_hd__fill_4
X_10828_ net801 _00178_ net586 vssd1 vssd1 vccd1 vccd1 FPGA_INST.cell1.SB0.route_sel\[37\]
+ sky130_fd_sc_hd__dfstp_1
XTAP_TAPCELL_ROW_43_886 vssd1 vccd1 sky130_fd_sc_hd__tapvpwrvgnd_1
X_10759_ net889 _00109_ net673 vssd1 vssd1 vccd1 vccd1 FPGA_INST.cell2.LE_1A.config_data\[14\]
+ sky130_fd_sc_hd__dfrtp_1
XANTENNA__06429__A2 _02255_ vssd1 vssd1 vccd1 vccd1 sky130_fd_sc_hd__diode_2
XANTENNA__10630__A0 FPGA_INST.cell3.LE_0A.reset_mode vssd1 vssd1 vccd1 vccd1 sky130_fd_sc_hd__diode_2
XFILLER_72_5 vssd1 vssd1 vccd1 vccd1 sky130_fd_sc_hd__fill_1
XFILLER_126_440 vssd1 vssd1 vccd1 vccd1 sky130_fd_sc_hd__fill_8
XANTENNA__07929__A2 FPGA_INST.bus3_1\[2\] vssd1 vssd1 vccd1 vccd1 sky130_fd_sc_hd__diode_2
XFILLER_58_3 vssd1 vssd1 vccd1 vccd1 sky130_fd_sc_hd__fill_2
X_07970_ FPGA_INST.cell1.CB_0.config_dataA\[17\] _04196_ _04197_ _04194_ FPGA_INST.cell1.CB_0.config_dataA\[18\]
+ vssd1 vssd1 vccd1 vccd1 _04198_ sky130_fd_sc_hd__a311o_1
XTAP_TAPCELL_ROW_93_1579 vssd1 vccd1 sky130_fd_sc_hd__tapvpwrvgnd_1
X_06921_ FPGA_INST.bus2_0\[0\] _03165_ _03187_ net417 _03188_ vssd1 vssd1 vccd1 vccd1
+ _03189_ sky130_fd_sc_hd__a221o_1
XFILLER_122_690 vssd1 vssd1 vccd1 vccd1 sky130_fd_sc_hd__fill_8
XFILLER_95_563 vssd1 vssd1 vccd1 vccd1 sky130_fd_sc_hd__fill_4
X_06852_ _03118_ _03119_ _01744_ vssd1 vssd1 vccd1 vccd1 _03120_ sky130_fd_sc_hd__mux2_1
X_09640_ FPGA_INST.cell0.SB0.route_sel\[44\] FPGA_INST.cell0.SB0.route_sel\[43\] net313
+ vssd1 vssd1 vccd1 vccd1 _00549_ sky130_fd_sc_hd__mux2_1
XTAP_TAPCELL_ROW_124_2023 vssd1 vccd1 sky130_fd_sc_hd__tapvpwrvgnd_1
XTAP_TAPCELL_ROW_124_2012 vssd1 vccd1 sky130_fd_sc_hd__tapvpwrvgnd_1
X_09571_ FPGA_INST.cell1.CB_1.config_dataA\[24\] FPGA_INST.cell1.CB_1.config_dataB\[0\]
+ net214 vssd1 vssd1 vccd1 vccd1 _00480_ sky130_fd_sc_hd__mux2_1
XFILLER_82_224 vssd1 vssd1 vccd1 vccd1 sky130_fd_sc_hd__fill_4
XFILLER_82_213 vssd1 vssd1 vccd1 vccd1 sky130_fd_sc_hd__fill_2
X_06783_ _03055_ _03056_ FPGA_INST.cell2.CB_1.config_dataB\[17\] vssd1 vssd1 vccd1
+ vccd1 _03057_ sky130_fd_sc_hd__mux2_1
XFILLER_55_438 vssd1 vssd1 vccd1 vccd1 sky130_fd_sc_hd__fill_1
X_05803_ _01903_ _02045_ net13 vssd1 vssd1 vccd1 vccd1 _02083_ sky130_fd_sc_hd__a21o_1
X_08522_ FPGA_INST.cell3.LEI0.config_data\[44\] _04733_ _04734_ FPGA_INST.cell3.CB_1.config_dataA\[19\]
+ vssd1 vssd1 vccd1 vccd1 _04735_ sky130_fd_sc_hd__o211a_1
X_05734_ FPGA_INST.cell0.CB_0.config_dataB\[22\] FPGA_INST.cell0.CB_0.config_dataB\[23\]
+ vssd1 vssd1 vccd1 vccd1 _02014_ sky130_fd_sc_hd__nand2b_1
X_08453_ FPGA_INST.cell1.LEI0.config_data\[44\] _04669_ _04670_ FPGA_INST.cell1.CB_1.config_dataA\[19\]
+ vssd1 vssd1 vccd1 vccd1 _04671_ sky130_fd_sc_hd__o211a_1
X_07404_ net24 net86 _03660_ vssd1 vssd1 vccd1 vccd1 _03663_ sky130_fd_sc_hd__mux2_1
XFILLER_90_290 vssd1 vssd1 vccd1 vccd1 sky130_fd_sc_hd__fill_4
X_05665_ _01847_ _01943_ FPGA_INST.bus3_2\[12\] vssd1 vssd1 vccd1 vccd1 _01945_ sky130_fd_sc_hd__o21ai_1
XANTENNA__06668__A2 net130 vssd1 vssd1 vccd1 vccd1 sky130_fd_sc_hd__diode_2
X_05596_ FPGA_INST.cell0.CB_1.config_dataB\[24\] FPGA_INST.cell0.CB_1.config_dataB\[20\]
+ FPGA_INST.cell0.CB_1.config_dataB\[21\] vssd1 vssd1 vccd1 vccd1 _01876_ sky130_fd_sc_hd__nand3b_2
X_08384_ net439 _04040_ vssd1 vssd1 vccd1 vccd1 _04606_ sky130_fd_sc_hd__nand2_1
X_07335_ net147 _03398_ _03593_ _03592_ vssd1 vssd1 vccd1 vccd1 _03595_ sky130_fd_sc_hd__a31o_1
X_07266_ net81 _03429_ _03526_ _03527_ _03522_ vssd1 vssd1 vccd1 vccd1 _03528_ sky130_fd_sc_hd__o311a_1
XFILLER_31_390 vssd1 vssd1 vccd1 vccd1 sky130_fd_sc_hd__fill_2
X_09005_ _01697_ FPGA_INST.cell1.SB0.route_sel\[27\] _05176_ vssd1 vssd1 vccd1 vccd1
+ _05177_ sky130_fd_sc_hd__o21ai_1
X_06217_ _02493_ _02496_ _02489_ vssd1 vssd1 vccd1 vccd1 _02497_ sky130_fd_sc_hd__a21oi_1
X_07197_ FPGA_INST.cell1.SB0.route_sel\[8\] FPGA_INST.cell1.SB0.route_sel\[9\] _03458_
+ _03459_ vssd1 vssd1 vccd1 vccd1 _03460_ sky130_fd_sc_hd__a211o_1
XFILLER_105_646 vssd1 vssd1 vccd1 vccd1 sky130_fd_sc_hd__fill_4
XANTENNA__08042__B2 _03475_ vssd1 vssd1 vccd1 vccd1 sky130_fd_sc_hd__diode_2
XANTENNA__08042__A1 _03421_ vssd1 vssd1 vccd1 vccd1 sky130_fd_sc_hd__diode_2
X_06148_ _01716_ FPGA_INST.cell0.SB0.route_sel\[12\] _01717_ FPGA_INST.cell0.SB0.route_sel\[15\]
+ _02427_ vssd1 vssd1 vccd1 vccd1 _02428_ sky130_fd_sc_hd__a221o_1
XFILLER_3_729 vssd1 vssd1 vccd1 vccd1 sky130_fd_sc_hd__fill_4
X_06079_ _01896_ _02358_ vssd1 vssd1 vccd1 vccd1 _02359_ sky130_fd_sc_hd__nor2_1
XTAP_TAPCELL_ROW_53_1029 vssd1 vccd1 sky130_fd_sc_hd__tapvpwrvgnd_1
XTAP_TAPCELL_ROW_53_1018 vssd1 vccd1 sky130_fd_sc_hd__tapvpwrvgnd_1
Xfanout521 FPGA_INST.cell2.CB_1.config_dataB\[0\] vssd1 vssd1 vccd1 vccd1 net521 sky130_fd_sc_hd__clkbuf_2
XFILLER_59_722 vssd1 vssd1 vccd1 vccd1 sky130_fd_sc_hd__fill_1
X_09907_ FPGA_INST.cell0.LE_0B.config_data\[11\] FPGA_INST.cell0.LE_0B.config_data\[12\]
+ net190 vssd1 vssd1 vccd1 vccd1 _00813_ sky130_fd_sc_hd__mux2_1
Xfanout510 FPGA_INST.cell2.CB_0.config_dataA\[0\] vssd1 vssd1 vccd1 vccd1 net510 sky130_fd_sc_hd__dlymetal6s2s_1
Xfanout532 net534 vssd1 vssd1 vccd1 vccd1 net532 sky130_fd_sc_hd__clkbuf_4
Xfanout565 net567 vssd1 vssd1 vccd1 vccd1 net565 sky130_fd_sc_hd__clkbuf_4
Xfanout543 net628 vssd1 vssd1 vccd1 vccd1 net543 sky130_fd_sc_hd__dlymetal6s2s_1
Xfanout554 net628 vssd1 vssd1 vccd1 vccd1 net554 sky130_fd_sc_hd__clkbuf_2
XTAP_TAPCELL_ROW_109_1807 vssd1 vccd1 sky130_fd_sc_hd__tapvpwrvgnd_1
Xfanout598 net604 vssd1 vssd1 vccd1 vccd1 net598 sky130_fd_sc_hd__buf_2
XFILLER_86_585 vssd1 vssd1 vccd1 vccd1 sky130_fd_sc_hd__fill_2
Xfanout587 net588 vssd1 vssd1 vccd1 vccd1 net587 sky130_fd_sc_hd__buf_2
Xfanout576 net577 vssd1 vssd1 vccd1 vccd1 net576 sky130_fd_sc_hd__clkbuf_4
XFILLER_58_265 vssd1 vssd1 vccd1 vccd1 sky130_fd_sc_hd__fill_2
XFILLER_46_416 vssd1 vssd1 vccd1 vccd1 sky130_fd_sc_hd__fill_4
X_09838_ FPGA_INST.cell0.LEI0.config_data\[16\] FPGA_INST.cell0.LEI0.config_data\[17\]
+ net172 vssd1 vssd1 vccd1 vccd1 _00746_ sky130_fd_sc_hd__mux2_1
XFILLER_19_619 vssd1 vssd1 vccd1 vccd1 sky130_fd_sc_hd__fill_1
X_09769_ FPGA_INST.cell1.CB_0.config_dataB\[20\] FPGA_INST.cell1.CB_0.config_dataB\[19\]
+ net348 vssd1 vssd1 vccd1 vccd1 _00678_ sky130_fd_sc_hd__mux2_1
XFILLER_73_202 vssd1 vssd1 vccd1 vccd1 sky130_fd_sc_hd__fill_2
XFILLER_61_408 vssd1 vssd1 vccd1 vccd1 sky130_fd_sc_hd__fill_1
X_11800_ net875 _01146_ net660 vssd1 vssd1 vccd1 vccd1 FPGA_INST.io_east_oeb\[20\]
+ sky130_fd_sc_hd__dfrtp_1
XANTENNA__08648__A3 _01792_ vssd1 vssd1 vccd1 vccd1 sky130_fd_sc_hd__diode_2
XFILLER_73_279 vssd1 vssd1 vccd1 vccd1 sky130_fd_sc_hd__fill_1
XTAP_TAPCELL_ROW_1_294 vssd1 vccd1 sky130_fd_sc_hd__tapvpwrvgnd_1
X_11731_ net897 _01077_ net681 vssd1 vssd1 vccd1 vccd1 FPGA_INST.cell3.SB0.route_sel\[101\]
+ sky130_fd_sc_hd__dfstp_1
XANTENNA__08337__B _03558_ vssd1 vssd1 vccd1 vccd1 sky130_fd_sc_hd__diode_2
XANTENNA__06659__A2 _02793_ vssd1 vssd1 vccd1 vccd1 sky130_fd_sc_hd__diode_2
XANTENNA__06409__Y _02687_ vssd1 vssd1 vccd1 vccd1 sky130_fd_sc_hd__diode_2
X_11662_ net906 _01008_ net690 vssd1 vssd1 vccd1 vccd1 FPGA_INST.cell3.SB0.route_sel\[32\]
+ sky130_fd_sc_hd__dfstp_1
XFILLER_42_688 vssd1 vssd1 vccd1 vccd1 sky130_fd_sc_hd__fill_2
X_10613_ FPGA_INST.cell3.CB_1.config_dataA\[8\] FPGA_INST.cell3.CB_1.config_dataA\[7\]
+ net375 vssd1 vssd1 vccd1 vccd1 _01492_ sky130_fd_sc_hd__mux2_1
XANTENNA__08805__A0 net18 vssd1 vssd1 vccd1 vccd1 sky130_fd_sc_hd__diode_2
X_11593_ net791 _00943_ net576 vssd1 vssd1 vccd1 vccd1 FPGA_INST.cell0.CB_1.config_dataA\[12\]
+ sky130_fd_sc_hd__dfstp_1
XTAP_TAPCELL_ROW_40_845 vssd1 vccd1 sky130_fd_sc_hd__tapvpwrvgnd_1
XFILLER_10_541 vssd1 vssd1 vccd1 vccd1 sky130_fd_sc_hd__fill_1
X_10544_ FPGA_INST.cell2.SB0.route_sel\[116\] FPGA_INST.cell2.SB0.route_sel\[117\]
+ net242 vssd1 vssd1 vccd1 vccd1 _01423_ sky130_fd_sc_hd__mux2_1
XANTENNA__08072__B _03568_ vssd1 vssd1 vccd1 vccd1 sky130_fd_sc_hd__diode_2
X_10475_ FPGA_INST.cell2.SB0.route_sel\[47\] FPGA_INST.cell2.SB0.route_sel\[48\] net197
+ vssd1 vssd1 vccd1 vccd1 _01354_ sky130_fd_sc_hd__mux2_1
XTAP_TAPCELL_ROW_79_1390 vssd1 vccd1 sky130_fd_sc_hd__tapvpwrvgnd_1
X_12145_ net942 _01491_ net726 vssd1 vssd1 vccd1 vccd1 FPGA_INST.cell3.CB_1.config_dataA\[7\]
+ sky130_fd_sc_hd__dfstp_1
XFILLER_2_751 vssd1 vssd1 vccd1 vccd1 sky130_fd_sc_hd__fill_1
XANTENNA__06595__B2 _02801_ vssd1 vssd1 vccd1 vccd1 sky130_fd_sc_hd__diode_2
XANTENNA__06595__A1 _02804_ vssd1 vssd1 vccd1 vccd1 sky130_fd_sc_hd__diode_2
X_12076_ net853 _01422_ net638 vssd1 vssd1 vccd1 vccd1 FPGA_INST.cell2.SB0.route_sel\[116\]
+ sky130_fd_sc_hd__dfstp_1
X_11027_ net818 _00377_ net603 vssd1 vssd1 vccd1 vccd1 FPGA_INST.cell1.LEI0.config_data\[12\]
+ sky130_fd_sc_hd__dfrtp_1
XFILLER_49_243 vssd1 vssd1 vccd1 vccd1 sky130_fd_sc_hd__fill_1
XANTENNA__06347__A1 _02450_ vssd1 vssd1 vccd1 vccd1 sky130_fd_sc_hd__diode_2
XANTENNA__06347__B2 _02487_ vssd1 vssd1 vccd1 vccd1 sky130_fd_sc_hd__diode_2
XFILLER_92_533 vssd1 vssd1 vccd1 vccd1 sky130_fd_sc_hd__fill_8
XFILLER_65_747 vssd1 vssd1 vccd1 vccd1 sky130_fd_sc_hd__fill_2
XFILLER_37_449 vssd1 vssd1 vccd1 vccd1 sky130_fd_sc_hd__fill_2
XTAP_TAPCELL_ROW_48_956 vssd1 vccd1 sky130_fd_sc_hd__tapvpwrvgnd_1
XFILLER_80_728 vssd1 vssd1 vccd1 vccd1 sky130_fd_sc_hd__fill_8
XFILLER_52_419 vssd1 vssd1 vccd1 vccd1 sky130_fd_sc_hd__fill_1
X_11929_ net943 _01275_ net727 vssd1 vssd1 vccd1 vccd1 FPGA_INST.cell3.LE_1A.config_data\[15\]
+ sky130_fd_sc_hd__dfrtp_1
XANTENNA__08247__B _03875_ vssd1 vssd1 vccd1 vccd1 sky130_fd_sc_hd__diode_2
XTAP_TAPCELL_ROW_28_680 vssd1 vccd1 sky130_fd_sc_hd__tapvpwrvgnd_1
X_05450_ FPGA_INST.cell0.CB_0.config_dataA\[9\] vssd1 vssd1 vccd1 vccd1 _01732_ sky130_fd_sc_hd__inv_2
X_05381_ FPGA_INST.cell3.SB0.route_sel\[56\] vssd1 vssd1 vccd1 vccd1 _01663_ sky130_fd_sc_hd__inv_2
XFILLER_119_738 vssd1 vssd1 vccd1 vccd1 sky130_fd_sc_hd__fill_8
X_07120_ FPGA_INST.cell0.LE_0A.config_data\[9\] FPGA_INST.cell0.LE_0A.config_data\[8\]
+ _03313_ vssd1 vssd1 vccd1 vccd1 _03386_ sky130_fd_sc_hd__mux2_1
XFILLER_118_226 vssd1 vssd1 vccd1 vccd1 sky130_fd_sc_hd__fill_8
XTAP_TAPCELL_ROW_95_1619 vssd1 vccd1 sky130_fd_sc_hd__tapvpwrvgnd_1
XTAP_TAPCELL_ROW_95_1608 vssd1 vccd1 sky130_fd_sc_hd__tapvpwrvgnd_1
XANTENNA__06283__A0 net7 vssd1 vssd1 vccd1 vccd1 sky130_fd_sc_hd__diode_2
XANTENNA__08272__A1 net119 vssd1 vssd1 vccd1 vccd1 sky130_fd_sc_hd__diode_2
XANTENNA__07075__A2 FPGA_INST.bus2_0\[13\] vssd1 vssd1 vccd1 vccd1 sky130_fd_sc_hd__diode_2
X_07051_ net431 FPGA_INST.cell0.CB_0.config_dataA\[11\] vssd1 vssd1 vccd1 vccd1 _03317_
+ sky130_fd_sc_hd__nor2_1
XANTENNA__08024__A1 FPGA_INST.bus3_1\[13\] vssd1 vssd1 vccd1 vccd1 sky130_fd_sc_hd__diode_2
X_06002_ _02274_ _02280_ _02281_ _02276_ vssd1 vssd1 vccd1 vccd1 _02282_ sky130_fd_sc_hd__a31o_1
XFILLER_126_292 vssd1 vssd1 vccd1 vccd1 sky130_fd_sc_hd__fill_1
XANTENNA__07783__B1 FPGA_INST.bus3_1\[15\] vssd1 vssd1 vccd1 vccd1 sky130_fd_sc_hd__diode_2
X_07953_ FPGA_INST.cell1.LEI0.config_data\[26\] _04180_ vssd1 vssd1 vccd1 vccd1 _04181_
+ sky130_fd_sc_hd__nor2_1
XANTENNA__06070__X _02350_ vssd1 vssd1 vccd1 vccd1 sky130_fd_sc_hd__diode_2
X_07884_ FPGA_INST.cell1.LEI0.config_data\[13\] _04109_ FPGA_INST.cell1.LEI0.config_data\[14\]
+ vssd1 vssd1 vccd1 vccd1 _04112_ sky130_fd_sc_hd__o21bai_1
X_06904_ FPGA_INST.cell0.CB_0.config_dataB\[12\] _03171_ vssd1 vssd1 vccd1 vccd1 _03172_
+ sky130_fd_sc_hd__nand2_1
X_09623_ FPGA_INST.cell0.SB0.route_sel\[27\] FPGA_INST.cell0.SB0.route_sel\[26\] net320
+ vssd1 vssd1 vccd1 vccd1 _00532_ sky130_fd_sc_hd__mux2_1
XFILLER_46_29 vssd1 vssd1 vccd1 vccd1 sky130_fd_sc_hd__fill_4
X_06835_ FPGA_INST.bus2_0\[5\] _03095_ _03102_ _01744_ FPGA_INST.cell0.CB_0.config_dataB\[8\]
+ vssd1 vssd1 vccd1 vccd1 _03103_ sky130_fd_sc_hd__a2111o_1
XANTENNA_fanout367_A net380 vssd1 vssd1 vccd1 vccd1 sky130_fd_sc_hd__diode_2
XFILLER_102_35 vssd1 vssd1 vccd1 vccd1 sky130_fd_sc_hd__fill_1
XFILLER_102_24 vssd1 vssd1 vccd1 vccd1 sky130_fd_sc_hd__fill_4
X_09554_ FPGA_INST.cell1.LE_1A.config_data\[3\] FPGA_INST.cell1.LE_1A.config_data\[4\]
+ net212 vssd1 vssd1 vccd1 vccd1 _00463_ sky130_fd_sc_hd__mux2_1
X_06766_ _03038_ _03039_ FPGA_INST.cell2.CB_1.config_dataB\[12\] vssd1 vssd1 vccd1
+ vccd1 _03040_ sky130_fd_sc_hd__or3b_1
XFILLER_55_279 vssd1 vssd1 vccd1 vccd1 sky130_fd_sc_hd__fill_1
XTAP_TAPCELL_ROW_104_1737 vssd1 vccd1 sky130_fd_sc_hd__tapvpwrvgnd_1
X_09485_ FPGA_INST.cell1.LEI0.config_data\[31\] FPGA_INST.cell1.LEI0.config_data\[32\]
+ net210 vssd1 vssd1 vccd1 vccd1 _00397_ sky130_fd_sc_hd__mux2_1
X_08505_ _04059_ _04718_ vssd1 vssd1 vccd1 vccd1 FPGA_INST.bus3_1\[15\] sky130_fd_sc_hd__nor2_4
X_06697_ net521 _02814_ vssd1 vssd1 vccd1 vccd1 _02971_ sky130_fd_sc_hd__nand2_1
X_05717_ net133 _01995_ _01996_ _01992_ _01987_ vssd1 vssd1 vccd1 vccd1 _01997_ sky130_fd_sc_hd__o221a_1
XANTENNA_fanout534_A net628 vssd1 vssd1 vccd1 vccd1 sky130_fd_sc_hd__diode_2
XANTENNA_fanout155_X net155 vssd1 vssd1 vccd1 vccd1 sky130_fd_sc_hd__diode_2
XFILLER_36_493 vssd1 vssd1 vccd1 vccd1 sky130_fd_sc_hd__fill_2
X_08436_ FPGA_INST.cell1.LEI0.config_data\[20\] _04653_ vssd1 vssd1 vccd1 vccd1 _04654_
+ sky130_fd_sc_hd__nand2b_1
X_05648_ net97 net382 net167 _01927_ _01826_ vssd1 vssd1 vccd1 vccd1 _01928_ sky130_fd_sc_hd__o32a_1
XANTENNA__06510__A1 _02780_ vssd1 vssd1 vccd1 vccd1 sky130_fd_sc_hd__diode_2
X_08367_ net442 _03504_ _04588_ net441 vssd1 vssd1 vccd1 vccd1 _04589_ sky130_fd_sc_hd__o211a_1
XANTENNA__05603__B1_N FPGA_INST.bus2_0\[15\] vssd1 vssd1 vccd1 vccd1 sky130_fd_sc_hd__diode_2
XFILLER_24_699 vssd1 vssd1 vccd1 vccd1 sky130_fd_sc_hd__fill_1
X_07318_ _03438_ _03578_ vssd1 vssd1 vccd1 vccd1 _03579_ sky130_fd_sc_hd__nor2_1
XANTENNA_fanout701_A net702 vssd1 vssd1 vccd1 vccd1 sky130_fd_sc_hd__diode_2
X_05579_ FPGA_INST.cell2.CB_0.config_dataA\[24\] FPGA_INST.cell2.CB_0.config_dataA\[20\]
+ FPGA_INST.cell2.CB_0.config_dataA\[21\] vssd1 vssd1 vccd1 vccd1 _01859_ sky130_fd_sc_hd__or3b_1
XFILLER_127_6 vssd1 vssd1 vccd1 vccd1 sky130_fd_sc_hd__fill_8
XANTENNA__08263__B2 _03465_ vssd1 vssd1 vccd1 vccd1 sky130_fd_sc_hd__diode_2
XANTENNA__08263__A1 _03408_ vssd1 vssd1 vccd1 vccd1 sky130_fd_sc_hd__diode_2
X_08298_ net76 FPGA_INST.bus1_0\[13\] FPGA_INST.bus1_0\[14\] FPGA_INST.bus1_0\[15\]
+ net445 net444 vssd1 vssd1 vccd1 vccd1 _04520_ sky130_fd_sc_hd__mux4_1
X_07249_ FPGA_INST.cell1.SB0.route_sel\[17\] FPGA_INST.cell1.SB0.route_sel\[16\] vssd1
+ vssd1 vccd1 vccd1 _03511_ sky130_fd_sc_hd__nand2_1
XFILLER_11_54 vssd1 vssd1 vccd1 vccd1 sky130_fd_sc_hd__fill_2
X_10260_ FPGA_INST.io_east_oeb\[8\] FPGA_INST.io_east_oeb\[10\] net263 vssd1 vssd1
+ vccd1 vccd1 _01141_ sky130_fd_sc_hd__mux2_1
XFILLER_117_281 vssd1 vssd1 vccd1 vccd1 sky130_fd_sc_hd__fill_1
XTAP_TAPCELL_ROW_115_1888 vssd1 vccd1 sky130_fd_sc_hd__tapvpwrvgnd_1
XANTENNA_fanout789_X net789 vssd1 vssd1 vccd1 vccd1 sky130_fd_sc_hd__diode_2
XTAP_TAPCELL_ROW_115_1899 vssd1 vccd1 sky130_fd_sc_hd__tapvpwrvgnd_1
X_10191_ FPGA_INST.cell3.SB0.route_sel\[96\] FPGA_INST.cell3.SB0.route_sel\[95\] net366
+ vssd1 vssd1 vccd1 vccd1 _01072_ sky130_fd_sc_hd__mux2_1
XFILLER_78_305 vssd1 vssd1 vccd1 vccd1 sky130_fd_sc_hd__fill_2
Xfanout340 net341 vssd1 vssd1 vccd1 vccd1 net340 sky130_fd_sc_hd__clkbuf_2
XFILLER_59_541 vssd1 vssd1 vccd1 vccd1 sky130_fd_sc_hd__fill_1
Xfanout373 net374 vssd1 vssd1 vccd1 vccd1 net373 sky130_fd_sc_hd__clkbuf_4
Xfanout362 net363 vssd1 vssd1 vccd1 vccd1 net362 sky130_fd_sc_hd__buf_4
XFILLER_59_563 vssd1 vssd1 vccd1 vccd1 sky130_fd_sc_hd__fill_1
XFILLER_47_703 vssd1 vssd1 vccd1 vccd1 sky130_fd_sc_hd__fill_1
XTAP_TAPCELL_ROW_6_364 vssd1 vccd1 sky130_fd_sc_hd__tapvpwrvgnd_1
Xfanout351 net355 vssd1 vssd1 vccd1 vccd1 net351 sky130_fd_sc_hd__clkbuf_4
Xfanout384 _01819_ vssd1 vssd1 vccd1 vccd1 net384 sky130_fd_sc_hd__buf_2
Xfanout395 FPGA_INST.cell3.CB_0.config_dataA\[15\] vssd1 vssd1 vccd1 vccd1 net395
+ sky130_fd_sc_hd__buf_1
XANTENNA__08619__Y _04828_ vssd1 vssd1 vccd1 vccd1 sky130_fd_sc_hd__diode_2
XANTENNA__11744__SET_B net683 vssd1 vssd1 vccd1 vccd1 sky130_fd_sc_hd__diode_2
XTAP_TAPCELL_ROW_66_1209 vssd1 vccd1 sky130_fd_sc_hd__tapvpwrvgnd_1
XTAP_TAPCELL_ROW_45_915 vssd1 vccd1 sky130_fd_sc_hd__tapvpwrvgnd_1
XANTENNA__10089__S net173 vssd1 vssd1 vccd1 vccd1 sky130_fd_sc_hd__diode_2
X_11714_ net919 _01060_ net703 vssd1 vssd1 vccd1 vccd1 FPGA_INST.cell3.SB0.route_sel\[84\]
+ sky130_fd_sc_hd__dfstp_1
XFILLER_70_772 vssd1 vssd1 vccd1 vccd1 sky130_fd_sc_hd__fill_1
XFILLER_42_452 vssd1 vssd1 vccd1 vccd1 sky130_fd_sc_hd__fill_2
XFILLER_42_441 vssd1 vssd1 vccd1 vccd1 sky130_fd_sc_hd__fill_1
XFILLER_52_50 vssd1 vssd1 vccd1 vccd1 sky130_fd_sc_hd__fill_1
X_11645_ net855 _00991_ net640 vssd1 vssd1 vccd1 vccd1 FPGA_INST.cell3.SB0.route_sel\[15\]
+ sky130_fd_sc_hd__dfstp_1
XFILLER_30_669 vssd1 vssd1 vccd1 vccd1 sky130_fd_sc_hd__fill_2
Xinput26 gpio_in[32] vssd1 vssd1 vccd1 vccd1 net26 sky130_fd_sc_hd__buf_2
XFILLER_10_371 vssd1 vssd1 vccd1 vccd1 sky130_fd_sc_hd__fill_1
Xinput15 gpio_in[22] vssd1 vssd1 vccd1 vccd1 net15 sky130_fd_sc_hd__clkbuf_2
X_11576_ net756 _00926_ net541 vssd1 vssd1 vccd1 vccd1 FPGA_INST.cell0.CB_0.config_dataB\[20\]
+ sky130_fd_sc_hd__dfstp_1
X_10527_ FPGA_INST.cell2.SB0.route_sel\[100\] FPGA_INST.cell2.SB0.route_sel\[99\]
+ net352 vssd1 vssd1 vccd1 vccd1 _01406_ sky130_fd_sc_hd__mux2_1
XFILLER_10_393 vssd1 vssd1 vccd1 vccd1 sky130_fd_sc_hd__fill_2
XANTENNA__05500__A FPGA_INST.cell0.CB_0.le_outA vssd1 vssd1 vccd1 vccd1 sky130_fd_sc_hd__diode_2
X_10458_ FPGA_INST.cell2.SB0.route_sel\[30\] FPGA_INST.cell2.SB0.route_sel\[31\] net192
+ vssd1 vssd1 vccd1 vccd1 _01337_ sky130_fd_sc_hd__mux2_1
XFILLER_124_752 vssd1 vssd1 vccd1 vccd1 sky130_fd_sc_hd__fill_4
X_10389_ FPGA_INST.cell3.LE_1A.config_data\[7\] FPGA_INST.cell3.LE_1A.config_data\[8\]
+ net304 vssd1 vssd1 vccd1 vccd1 _01268_ sky130_fd_sc_hd__mux2_1
XFILLER_97_603 vssd1 vssd1 vccd1 vccd1 sky130_fd_sc_hd__fill_1
XTAP_TAPCELL_ROW_90_1549 vssd1 vccd1 sky130_fd_sc_hd__tapvpwrvgnd_1
XTAP_TAPCELL_ROW_90_1538 vssd1 vccd1 sky130_fd_sc_hd__tapvpwrvgnd_1
X_12128_ net936 _01474_ net720 vssd1 vssd1 vccd1 vccd1 FPGA_INST.cell3.CB_0.config_dataB\[15\]
+ sky130_fd_sc_hd__dfstp_1
XFILLER_35_5 vssd1 vssd1 vccd1 vccd1 sky130_fd_sc_hd__fill_1
X_12059_ net859 _01405_ net641 vssd1 vssd1 vccd1 vccd1 FPGA_INST.cell2.SB0.route_sel\[99\]
+ sky130_fd_sc_hd__dfstp_1
XFILLER_77_360 vssd1 vssd1 vccd1 vccd1 sky130_fd_sc_hd__fill_1
X_06620_ _01796_ _01800_ _01801_ _01799_ net477 net478 vssd1 vssd1 vccd1 vccd1 _02896_
+ sky130_fd_sc_hd__mux4_1
XANTENNA__06985__B _02350_ vssd1 vssd1 vccd1 vccd1 sky130_fd_sc_hd__diode_2
X_06551_ FPGA_INST.bus3_2\[12\] FPGA_INST.bus3_2\[13\] FPGA_INST.bus3_2\[14\] FPGA_INST.bus3_2\[15\]
+ net481 FPGA_INST.cell2.CB_1.config_dataA\[6\] vssd1 vssd1 vccd1 vccd1 _02827_ sky130_fd_sc_hd__mux4_1
X_09270_ FPGA_INST.cell1.SB0.route_sel\[42\] FPGA_INST.cell1.SB0.route_sel\[41\] net330
+ vssd1 vssd1 vccd1 vccd1 _00183_ sky130_fd_sc_hd__mux2_1
X_06482_ _02759_ _02725_ _02723_ vssd1 vssd1 vccd1 vccd1 _02760_ sky130_fd_sc_hd__mux2_1
XTAP_TAPCELL_ROW_23_609 vssd1 vccd1 sky130_fd_sc_hd__tapvpwrvgnd_1
X_05502_ net136 vssd1 vssd1 vccd1 vccd1 _01784_ sky130_fd_sc_hd__inv_2
X_05433_ FPGA_INST.cell1.SB0.route_sel\[15\] vssd1 vssd1 vccd1 vccd1 _01715_ sky130_fd_sc_hd__inv_2
X_08221_ _03639_ _04443_ _04444_ _03604_ vssd1 vssd1 vccd1 vccd1 _04445_ sky130_fd_sc_hd__a22o_1
XFILLER_61_794 vssd1 vssd1 vccd1 vccd1 sky130_fd_sc_hd__fill_4
XFILLER_61_783 vssd1 vssd1 vccd1 vccd1 sky130_fd_sc_hd__fill_1
XFILLER_60_271 vssd1 vssd1 vccd1 vccd1 sky130_fd_sc_hd__fill_1
XFILLER_21_669 vssd1 vssd1 vccd1 vccd1 sky130_fd_sc_hd__fill_2
XANTENNA__05888__Y _02168_ vssd1 vssd1 vccd1 vccd1 sky130_fd_sc_hd__diode_2
X_08152_ _04377_ _04370_ _04366_ vssd1 vssd1 vccd1 vccd1 _04378_ sky130_fd_sc_hd__mux2_1
X_05364_ FPGA_INST.cell3.SB0.route_sel\[73\] vssd1 vssd1 vccd1 vccd1 _01646_ sky130_fd_sc_hd__inv_2
X_08083_ _03613_ _04300_ _04301_ _03652_ vssd1 vssd1 vccd1 vccd1 _04309_ sky130_fd_sc_hd__o2bb2a_1
XFILLER_9_191 vssd1 vssd1 vccd1 vccd1 sky130_fd_sc_hd__fill_4
XANTENNA__06256__B1 _02535_ vssd1 vssd1 vccd1 vccd1 sky130_fd_sc_hd__diode_2
X_07103_ _02110_ _03352_ _03353_ _02146_ FPGA_INST.cell0.CB_0.config_dataA\[17\] vssd1
+ vssd1 vccd1 vccd1 _03369_ sky130_fd_sc_hd__a221o_1
X_05295_ FPGA_INST.cell2.SB0.route_sel\[95\] vssd1 vssd1 vccd1 vccd1 _01577_ sky130_fd_sc_hd__inv_2
XANTENNA_fanout115_A FPGA_INST.cell0.CB_0.le_outA vssd1 vssd1 vccd1 vccd1 sky130_fd_sc_hd__diode_2
X_07034_ _02429_ _03282_ _03284_ _02465_ FPGA_INST.cell0.CB_0.config_dataA\[2\] vssd1
+ vssd1 vccd1 vccd1 _03300_ sky130_fd_sc_hd__a221o_1
XFILLER_115_785 vccd1 vssd1 vccd1 vssd1 sky130_ef_sc_hd__decap_40_12
XFILLER_88_603 vssd1 vssd1 vccd1 vccd1 sky130_fd_sc_hd__fill_1
XFILLER_130_755 vssd1 vssd1 vccd1 vccd1 sky130_fd_sc_hd__fill_1
X_08985_ _03703_ _05163_ vssd1 vssd1 vccd1 vccd1 FPGA_INST.bus3_1\[6\] sky130_fd_sc_hd__and2_2
XFILLER_87_113 vssd1 vssd1 vccd1 vccd1 sky130_fd_sc_hd__fill_2
Xteam_15_965 vssd1 vssd1 vccd1 vccd1 team_15_965/HI gpio_out[2] sky130_fd_sc_hd__conb_1
Xteam_15_954 vssd1 vssd1 vccd1 vccd1 team_15_954/HI gpio_oeb[16] sky130_fd_sc_hd__conb_1
XFILLER_130_766 vccd1 vssd1 vccd1 vssd1 sky130_ef_sc_hd__decap_40_12
X_07936_ FPGA_INST.cell1.CB_0.config_dataA\[12\] _04151_ _04155_ _04159_ FPGA_INST.cell1.CB_0.config_dataA\[13\]
+ vssd1 vssd1 vccd1 vccd1 _04164_ sky130_fd_sc_hd__a311o_1
XFILLER_87_146 vssd1 vssd1 vccd1 vccd1 sky130_fd_sc_hd__fill_1
XFILLER_96_680 vssd1 vssd1 vccd1 vccd1 sky130_fd_sc_hd__fill_1
XFILLER_56_500 vssd1 vssd1 vccd1 vccd1 sky130_fd_sc_hd__fill_8
XTAP_TAPCELL_ROW_3_323 vssd1 vccd1 sky130_fd_sc_hd__tapvpwrvgnd_1
X_07867_ net469 _03854_ _04094_ net468 vssd1 vssd1 vccd1 vccd1 _04095_ sky130_fd_sc_hd__o211a_1
XANTENNA_fanout651_A net662 vssd1 vssd1 vccd1 vccd1 sky130_fd_sc_hd__diode_2
XANTENNA_fanout749_A net790 vssd1 vssd1 vccd1 vccd1 sky130_fd_sc_hd__diode_2
XANTENNA__07523__A3 _03771_ vssd1 vssd1 vccd1 vccd1 sky130_fd_sc_hd__diode_2
X_07798_ FPGA_INST.cell1.SB0.route_sel\[122\] FPGA_INST.cell1.SB0.route_sel\[123\]
+ vssd1 vssd1 vccd1 vccd1 _04047_ sky130_fd_sc_hd__nor2_1
X_09606_ FPGA_INST.cell0.SB0.route_sel\[9\] FPGA_INST.cell0.SB0.route_sel\[10\] net201
+ vssd1 vssd1 vccd1 vccd1 _00515_ sky130_fd_sc_hd__mux2_1
X_06818_ FPGA_INST.cell2.LE_1B.dff0_out FPGA_INST.cell2.LE_1B.dff1_out FPGA_INST.cell2.LE_1B.reset_val
+ vssd1 vssd1 vccd1 vccd1 FPGA_INST.cell2.LE_1B.dff_out sky130_fd_sc_hd__mux2_1
X_09537_ FPGA_INST.cell1.LE_0B.config_data\[9\] FPGA_INST.cell1.LE_0B.config_data\[10\]
+ net231 vssd1 vssd1 vccd1 vccd1 _00447_ sky130_fd_sc_hd__mux2_1
X_06749_ FPGA_INST.bus3_2\[12\] FPGA_INST.bus3_2\[13\] FPGA_INST.bus3_2\[14\] FPGA_INST.bus3_2\[15\]
+ net514 net513 vssd1 vssd1 vccd1 vccd1 _03023_ sky130_fd_sc_hd__mux4_1
XANTENNA_fanout916_A net917 vssd1 vssd1 vccd1 vccd1 sky130_fd_sc_hd__diode_2
XFILLER_52_750 vssd1 vssd1 vccd1 vccd1 sky130_fd_sc_hd__fill_4
XANTENNA__09698__S net196 vssd1 vssd1 vccd1 vccd1 sky130_fd_sc_hd__diode_2
X_09468_ FPGA_INST.cell1.LEI0.config_data\[14\] FPGA_INST.cell1.LEI0.config_data\[15\]
+ net228 vssd1 vssd1 vccd1 vccd1 _00380_ sky130_fd_sc_hd__mux2_1
XTAP_TAPCELL_ROW_61_1139 vssd1 vccd1 sky130_fd_sc_hd__tapvpwrvgnd_1
XFILLER_11_113 vssd1 vssd1 vccd1 vccd1 sky130_fd_sc_hd__fill_4
XANTENNA__10637__S net372 vssd1 vssd1 vccd1 vccd1 sky130_fd_sc_hd__diode_2
XANTENNA__08615__B _03583_ vssd1 vssd1 vccd1 vccd1 sky130_fd_sc_hd__diode_2
X_08419_ FPGA_INST.cell0.LE_1B.config_data\[15\] FPGA_INST.cell0.LE_1B.config_data\[14\]
+ _04574_ vssd1 vssd1 vccd1 vccd1 _04641_ sky130_fd_sc_hd__mux2_1
XFILLER_12_647 vssd1 vssd1 vccd1 vccd1 sky130_fd_sc_hd__fill_2
X_09399_ FPGA_INST.cell2.CB_0.config_dataB\[18\] FPGA_INST.cell2.CB_0.config_dataB\[17\]
+ net357 vssd1 vssd1 vccd1 vccd1 _00312_ sky130_fd_sc_hd__mux2_1
XANTENNA__08236__A1 _03797_ vssd1 vssd1 vccd1 vccd1 sky130_fd_sc_hd__diode_2
XTAP_TAPCELL_ROW_50_984 vssd1 vccd1 sky130_fd_sc_hd__tapvpwrvgnd_1
X_11430_ net770 _00780_ net555 vssd1 vssd1 vccd1 vccd1 FPGA_INST.cell0.LE_0A.config_data\[1\]
+ sky130_fd_sc_hd__dfrtp_1
X_11361_ net818 _00711_ net603 vssd1 vssd1 vccd1 vccd1 FPGA_INST.cell1.LE_1B.config_data\[3\]
+ sky130_fd_sc_hd__dfrtp_1
XTAP_TAPCELL_ROW_117_1917 vssd1 vccd1 sky130_fd_sc_hd__tapvpwrvgnd_1
XANTENNA__05320__A FPGA_INST.cell3.SB0.route_sel\[124\] vssd1 vssd1 vccd1 vccd1 sky130_fd_sc_hd__diode_2
X_10312_ FPGA_INST.cell3.LEI0.config_data\[26\] FPGA_INST.cell3.LEI0.config_data\[27\]
+ net296 vssd1 vssd1 vccd1 vccd1 _01193_ sky130_fd_sc_hd__mux2_1
XFILLER_3_312 vccd1 vssd1 vccd1 vssd1 sky130_ef_sc_hd__decap_40_12
X_11292_ net836 _00642_ net620 vssd1 vssd1 vccd1 vccd1 FPGA_INST.cell1.CB_0.config_dataA\[9\]
+ sky130_fd_sc_hd__dfstp_1
XFILLER_98_46 vssd1 vssd1 vccd1 vccd1 sky130_fd_sc_hd__fill_2
X_10243_ FPGA_INST.io_south_oeb\[6\] FPGA_INST.io_south_oeb\[8\] net289 vssd1 vssd1
+ vccd1 vccd1 _01124_ sky130_fd_sc_hd__mux2_1
X_10174_ FPGA_INST.cell3.SB0.route_sel\[78\] FPGA_INST.cell3.SB0.route_sel\[79\] net286
+ vssd1 vssd1 vccd1 vccd1 _01055_ sky130_fd_sc_hd__mux2_1
XFILLER_121_766 vssd1 vssd1 vccd1 vccd1 sky130_fd_sc_hd__fill_8
Xfanout170 _01876_ vssd1 vssd1 vccd1 vccd1 net170 sky130_fd_sc_hd__clkbuf_4
XFILLER_47_500 vssd1 vssd1 vccd1 vccd1 sky130_fd_sc_hd__fill_4
Xfanout192 net193 vssd1 vssd1 vccd1 vccd1 net192 sky130_fd_sc_hd__clkbuf_4
Xfanout181 net234 vssd1 vssd1 vccd1 vccd1 net181 sky130_fd_sc_hd__clkbuf_2
XFILLER_86_190 vssd1 vssd1 vccd1 vccd1 sky130_fd_sc_hd__fill_2
XFILLER_19_246 vssd1 vssd1 vccd1 vccd1 sky130_fd_sc_hd__fill_1
XANTENNA__07683__C1 _01947_ vssd1 vssd1 vccd1 vccd1 sky130_fd_sc_hd__diode_2
XANTENNA__10547__S net240 vssd1 vssd1 vccd1 vccd1 sky130_fd_sc_hd__diode_2
X_11628_ net809 FPGA_INST.cfg_done_d net595 vssd1 vssd1 vccd1 vccd1 FPGA_INST.cfg_done
+ sky130_fd_sc_hd__dfrtp_1
XANTENNA__08227__A1 net95 vssd1 vssd1 vccd1 vccd1 sky130_fd_sc_hd__diode_2
XFILLER_30_477 vssd1 vssd1 vccd1 vccd1 sky130_fd_sc_hd__fill_8
XFILLER_128_365 vssd1 vssd1 vccd1 vccd1 sky130_fd_sc_hd__fill_1
XFILLER_7_673 vssd1 vssd1 vccd1 vccd1 sky130_fd_sc_hd__fill_4
XFILLER_6_150 vssd1 vssd1 vccd1 vccd1 sky130_fd_sc_hd__fill_1
X_11559_ net756 _00909_ net541 vssd1 vssd1 vccd1 vccd1 FPGA_INST.cell0.CB_0.config_dataB\[3\]
+ sky130_fd_sc_hd__dfstp_1
XFILLER_40_3 vssd1 vssd1 vccd1 vccd1 sky130_fd_sc_hd__fill_1
XFILLER_124_593 vssd1 vssd1 vccd1 vccd1 sky130_fd_sc_hd__fill_2
XFILLER_85_617 vssd1 vssd1 vccd1 vccd1 sky130_fd_sc_hd__fill_1
XANTENNA__06410__B1 _02687_ vssd1 vssd1 vccd1 vccd1 sky130_fd_sc_hd__diode_2
X_08770_ net390 net389 _04828_ _04976_ vssd1 vssd1 vccd1 vccd1 _04977_ sky130_fd_sc_hd__o31ai_1
X_05982_ net112 _01927_ _02181_ vssd1 vssd1 vccd1 vccd1 _02262_ sky130_fd_sc_hd__nor3_1
XFILLER_38_511 vccd1 vssd1 vccd1 vssd1 sky130_ef_sc_hd__decap_40_12
X_07721_ FPGA_INST.cell1.SB0.route_sel\[108\] _01620_ FPGA_INST.cell1.SB0.route_sel\[111\]
+ _01621_ _03971_ vssd1 vssd1 vccd1 vccd1 _03972_ sky130_fd_sc_hd__a221o_1
XANTENNA__08702__A2 _04801_ vssd1 vssd1 vccd1 vccd1 sky130_fd_sc_hd__diode_2
X_07652_ FPGA_INST.cell3.SB0.route_sel\[90\] _01632_ FPGA_INST.cell3.SB0.route_sel\[93\]
+ _01633_ _03904_ vssd1 vssd1 vccd1 vccd1 _03905_ sky130_fd_sc_hd__a221o_1
XFILLER_53_503 vssd1 vssd1 vccd1 vccd1 sky130_fd_sc_hd__fill_1
XFILLER_65_396 vssd1 vssd1 vccd1 vccd1 sky130_fd_sc_hd__fill_1
X_07583_ FPGA_INST.cell0.SB0.route_sel\[84\] FPGA_INST.cell0.SB0.route_sel\[85\] vssd1
+ vssd1 vccd1 vccd1 _03837_ sky130_fd_sc_hd__or2_1
X_06603_ FPGA_INST.cell2.LE_1A.config_data\[5\] FPGA_INST.cell2.LE_1A.config_data\[4\]
+ _02878_ vssd1 vssd1 vccd1 vccd1 _02879_ sky130_fd_sc_hd__mux2_1
XFILLER_25_249 vssd1 vssd1 vccd1 vccd1 sky130_fd_sc_hd__fill_2
X_09322_ FPGA_INST.cell1.SB0.route_sel\[93\] FPGA_INST.cell1.SB0.route_sel\[94\] net208
+ vssd1 vssd1 vccd1 vccd1 _00235_ sky130_fd_sc_hd__mux2_1
X_06534_ net246 _01855_ _01865_ _02809_ vssd1 vssd1 vccd1 vccd1 _02810_ sky130_fd_sc_hd__nand4_4
XTAP_TAPCELL_ROW_36_789 vssd1 vccd1 sky130_fd_sc_hd__tapvpwrvgnd_1
XANTENNA_fanout232_A net233 vssd1 vssd1 vccd1 vccd1 sky130_fd_sc_hd__diode_2
X_09253_ FPGA_INST.cell1.SB0.route_sel\[24\] FPGA_INST.cell1.SB0.route_sel\[25\] net227
+ vssd1 vssd1 vccd1 vccd1 _00166_ sky130_fd_sc_hd__mux2_1
XFILLER_21_455 vssd1 vssd1 vccd1 vccd1 sky130_fd_sc_hd__fill_4
X_06465_ net488 _02092_ vssd1 vssd1 vccd1 vccd1 _02743_ sky130_fd_sc_hd__nand2_1
XFILLER_33_293 vssd1 vssd1 vccd1 vccd1 sky130_fd_sc_hd__fill_1
XFILLER_119_321 vccd1 vssd1 vccd1 vssd1 sky130_ef_sc_hd__decap_40_12
X_05416_ FPGA_INST.cell1.SB0.route_sel\[29\] vssd1 vssd1 vccd1 vccd1 _01698_ sky130_fd_sc_hd__inv_2
X_08204_ FPGA_INST.cell0.CB_1.config_dataA\[7\] _04427_ vssd1 vssd1 vccd1 vccd1 _04428_
+ sky130_fd_sc_hd__nor2_1
X_06396_ _02131_ _02655_ _02656_ _02168_ FPGA_INST.cell2.CB_0.config_dataB\[2\] vssd1
+ vssd1 vccd1 vccd1 _02674_ sky130_fd_sc_hd__a221o_1
XFILLER_21_488 vssd1 vssd1 vccd1 vccd1 sky130_fd_sc_hd__fill_1
X_09184_ FPGA_INST.cell2.LE_1A.config_data\[1\] FPGA_INST.cell2.LE_1A.config_data\[2\]
+ net263 vssd1 vssd1 vccd1 vccd1 _00097_ sky130_fd_sc_hd__mux2_1
X_08135_ FPGA_INST.cell1.CB_0.config_dataB\[18\] _04352_ _04356_ _04360_ vssd1 vssd1
+ vccd1 vccd1 _04361_ sky130_fd_sc_hd__and4_1
X_05347_ FPGA_INST.cell1.SB0.route_sel\[98\] vssd1 vssd1 vccd1 vccd1 _01629_ sky130_fd_sc_hd__inv_2
XANTENNA__07977__A0 FPGA_INST.bus3_1\[8\] vssd1 vssd1 vccd1 vccd1 sky130_fd_sc_hd__diode_2
XFILLER_107_549 vssd1 vssd1 vccd1 vccd1 sky130_fd_sc_hd__fill_8
X_08066_ _04282_ _04287_ _04291_ _04277_ FPGA_INST.cell1.CB_0.config_dataB\[4\] vssd1
+ vssd1 vccd1 vccd1 _04292_ sky130_fd_sc_hd__a311o_1
X_05278_ FPGA_INST.cell2.SB0.route_sel\[48\] vssd1 vssd1 vccd1 vccd1 _01560_ sky130_fd_sc_hd__inv_2
XANTENNA_fanout699_A net701 vssd1 vssd1 vccd1 vccd1 sky130_fd_sc_hd__diode_2
XANTENNA__10192__S net285 vssd1 vssd1 vccd1 vccd1 sky130_fd_sc_hd__diode_2
X_07017_ net435 net436 vssd1 vssd1 vccd1 vccd1 _03283_ sky130_fd_sc_hd__nand2b_1
XTAP_TAPCELL_ROW_112_1847 vssd1 vccd1 sky130_fd_sc_hd__tapvpwrvgnd_1
XFILLER_103_733 vssd1 vssd1 vccd1 vccd1 sky130_fd_sc_hd__fill_2
XTAP_TAPCELL_ROW_58_1090 vssd1 vccd1 sky130_fd_sc_hd__tapvpwrvgnd_1
XANTENNA__08170__B _03720_ vssd1 vssd1 vccd1 vccd1 sky130_fd_sc_hd__diode_2
XFILLER_130_541 vssd1 vssd1 vccd1 vccd1 sky130_fd_sc_hd__fill_1
XFILLER_0_359 vssd1 vssd1 vccd1 vccd1 sky130_fd_sc_hd__fill_4
X_08968_ _01666_ FPGA_INST.cell1.SB0.route_sel\[59\] FPGA_INST.cell1.SB0.route_sel\[56\]
+ FPGA_INST.cell1.SB0.route_sel\[57\] vssd1 vssd1 vccd1 vccd1 _05152_ sky130_fd_sc_hd__o22a_1
XANTENNA__06952__A1 FPGA_INST.bus2_0\[4\] vssd1 vssd1 vccd1 vccd1 sky130_fd_sc_hd__diode_2
X_08899_ _05104_ _05105_ _05000_ vssd1 vssd1 vccd1 vccd1 _05106_ sky130_fd_sc_hd__mux2_1
X_07919_ FPGA_INST.cell1.LEI0.config_data\[2\] _04146_ vssd1 vssd1 vccd1 vccd1 _04147_
+ sky130_fd_sc_hd__nand2b_1
XFILLER_84_15 vccd1 vssd1 vccd1 vssd1 sky130_ef_sc_hd__decap_40_12
XFILLER_83_160 vssd1 vssd1 vccd1 vccd1 sky130_fd_sc_hd__fill_1
XFILLER_56_363 vssd1 vssd1 vccd1 vccd1 sky130_fd_sc_hd__fill_1
X_10930_ net846 _00280_ net631 vssd1 vssd1 vccd1 vccd1 FPGA_INST.cell2.CB_0.config_dataA\[11\]
+ sky130_fd_sc_hd__dfstp_1
XANTENNA__06704__A1 FPGA_INST.bus3_2\[1\] vssd1 vssd1 vccd1 vccd1 sky130_fd_sc_hd__diode_2
X_10861_ net801 _00211_ net586 vssd1 vssd1 vccd1 vccd1 FPGA_INST.cell1.SB0.route_sel\[70\]
+ sky130_fd_sc_hd__dfstp_1
XFILLER_25_750 vccd1 vssd1 vccd1 vssd1 sky130_ef_sc_hd__decap_40_12
XTAP_TAPCELL_ROW_123_1998 vssd1 vccd1 sky130_fd_sc_hd__tapvpwrvgnd_1
X_10792_ net824 _00142_ net608 vssd1 vssd1 vccd1 vccd1 FPGA_INST.cell1.SB0.route_sel\[1\]
+ sky130_fd_sc_hd__dfstp_1
XFILLER_71_377 vssd1 vssd1 vccd1 vccd1 sky130_fd_sc_hd__fill_2
XFILLER_25_783 vssd1 vssd1 vccd1 vccd1 sky130_fd_sc_hd__fill_1
XANTENNA__08209__A1 FPGA_INST.bus1_0\[13\] vssd1 vssd1 vccd1 vccd1 sky130_fd_sc_hd__diode_2
XFILLER_12_477 vssd1 vssd1 vccd1 vccd1 sky130_fd_sc_hd__fill_2
XFILLER_40_797 vssd1 vssd1 vccd1 vccd1 sky130_fd_sc_hd__fill_2
XANTENNA__08913__X FPGA_INST.bus3_1\[14\] vssd1 vssd1 vccd1 vccd1 sky130_fd_sc_hd__diode_2
X_11413_ net747 _00763_ net532 vssd1 vssd1 vccd1 vccd1 FPGA_INST.cell0.LEI0.config_data\[34\]
+ sky130_fd_sc_hd__dfrtp_1
X_11344_ net793 _00694_ net578 vssd1 vssd1 vccd1 vccd1 FPGA_INST.cell1.CB_1.config_dataA\[11\]
+ sky130_fd_sc_hd__dfstp_1
XTAP_TAPCELL_ROW_74_1319 vssd1 vccd1 sky130_fd_sc_hd__tapvpwrvgnd_1
XFILLER_4_643 vssd1 vssd1 vccd1 vccd1 sky130_fd_sc_hd__fill_1
XFILLER_4_632 vssd1 vssd1 vccd1 vccd1 sky130_fd_sc_hd__fill_1
X_11275_ net789 _00625_ net574 vssd1 vssd1 vccd1 vccd1 FPGA_INST.cell0.SB0.route_sel\[120\]
+ sky130_fd_sc_hd__dfstp_1
XFILLER_79_433 vssd1 vssd1 vccd1 vccd1 sky130_fd_sc_hd__fill_1
X_10226_ FPGA_INST.io_west_oeb\[4\] FPGA_INST.io_west_oeb\[6\] net291 vssd1 vssd1
+ vccd1 vccd1 _01107_ sky130_fd_sc_hd__mux2_1
X_10157_ FPGA_INST.cell3.SB0.route_sel\[61\] FPGA_INST.cell3.SB0.route_sel\[62\] net271
+ vssd1 vssd1 vccd1 vccd1 _01038_ sky130_fd_sc_hd__mux2_1
XANTENNA__07264__X _03526_ vssd1 vssd1 vccd1 vccd1 sky130_fd_sc_hd__diode_2
X_10088_ FPGA_INST.cell0.LE_1B.config_data\[13\] FPGA_INST.cell0.LE_1B.config_data\[12\]
+ net307 vssd1 vssd1 vccd1 vccd1 _00969_ sky130_fd_sc_hd__mux2_1
XANTENNA__10839__Q FPGA_INST.cell1.SB0.route_sel\[48\] vssd1 vssd1 vccd1 vccd1 sky130_fd_sc_hd__diode_2
XFILLER_90_642 vssd1 vssd1 vccd1 vccd1 sky130_fd_sc_hd__fill_2
XFILLER_62_344 vssd1 vssd1 vccd1 vccd1 sky130_fd_sc_hd__fill_2
XFILLER_15_271 vssd1 vssd1 vccd1 vccd1 sky130_fd_sc_hd__fill_1
XTAP_TAPCELL_ROW_33_748 vssd1 vccd1 sky130_fd_sc_hd__tapvpwrvgnd_1
X_06250_ _02528_ _02529_ FPGA_INST.cell2.CB_0.config_dataA\[2\] vssd1 vssd1 vccd1
+ vccd1 _02530_ sky130_fd_sc_hd__mux2_1
XTAP_TAPCELL_ROW_13_461 vssd1 vccd1 sky130_fd_sc_hd__tapvpwrvgnd_1
X_06181_ _02453_ _02458_ _02460_ net320 vssd1 vssd1 vccd1 vccd1 _02461_ sky130_fd_sc_hd__a211oi_1
X_09940_ net449 FPGA_INST.cell0.CB_1.config_dataB\[1\] net203 vssd1 vssd1 vccd1 vccd1
+ _00845_ sky130_fd_sc_hd__mux2_1
XPHY_EDGE_ROW_115_Right_115 vssd1 vssd1 vccd1 vccd1 sky130_fd_sc_hd__decap_3
Xfanout906 net911 vssd1 vssd1 vccd1 vccd1 net906 sky130_fd_sc_hd__clkbuf_2
Xfanout917 net918 vssd1 vssd1 vccd1 vccd1 net917 sky130_fd_sc_hd__buf_2
Xfanout939 net945 vssd1 vssd1 vccd1 vccd1 net939 sky130_fd_sc_hd__buf_2
XFILLER_100_703 vssd1 vssd1 vccd1 vccd1 sky130_fd_sc_hd__fill_2
Xfanout928 net930 vssd1 vssd1 vccd1 vccd1 net928 sky130_fd_sc_hd__clkbuf_2
XANTENNA__07187__A1 net81 vssd1 vssd1 vccd1 vccd1 sky130_fd_sc_hd__diode_2
X_09871_ FPGA_INST.cell0.LE_0B.dff1_out net522 _05218_ vssd1 vssd1 vccd1 vccd1 _00778_
+ sky130_fd_sc_hd__a21bo_1
X_08822_ net93 net88 FPGA_INST.cell3.CB_1.le_outA net80 FPGA_INST.cell3.LEI0.config_data\[3\]
+ FPGA_INST.cell3.LEI0.config_data\[4\] vssd1 vssd1 vccd1 vccd1 _05029_ sky130_fd_sc_hd__mux4_1
XFILLER_112_585 vssd1 vssd1 vccd1 vccd1 sky130_fd_sc_hd__fill_1
XTAP_TAPCELL_ROW_127_2054 vssd1 vccd1 sky130_fd_sc_hd__tapvpwrvgnd_1
X_08753_ _04960_ _04961_ _04891_ vssd1 vssd1 vccd1 vccd1 _04962_ sky130_fd_sc_hd__mux2_1
XFILLER_85_469 vccd1 vssd1 vccd1 vssd1 sky130_ef_sc_hd__decap_40_12
XFILLER_85_458 vssd1 vssd1 vccd1 vccd1 sky130_fd_sc_hd__fill_1
X_05965_ _02235_ _02237_ _02244_ vssd1 vssd1 vccd1 vccd1 _02245_ sky130_fd_sc_hd__a21o_1
XTAP_TAPCELL_ROW_127_2065 vssd1 vccd1 sky130_fd_sc_hd__tapvpwrvgnd_1
X_07704_ _01788_ _03954_ vssd1 vssd1 vccd1 vccd1 _03955_ sky130_fd_sc_hd__or2_1
XFILLER_38_363 vssd1 vssd1 vccd1 vccd1 sky130_fd_sc_hd__fill_1
X_08684_ _04819_ _04823_ net397 vssd1 vssd1 vccd1 vccd1 _04893_ sky130_fd_sc_hd__mux2_1
XFILLER_93_491 vssd1 vssd1 vccd1 vccd1 sky130_fd_sc_hd__fill_1
XFILLER_81_631 vssd1 vssd1 vccd1 vccd1 sky130_fd_sc_hd__fill_2
XFILLER_53_311 vssd1 vssd1 vccd1 vccd1 sky130_fd_sc_hd__fill_1
XFILLER_53_322 vssd1 vssd1 vccd1 vccd1 sky130_fd_sc_hd__fill_1
X_05896_ net121 net171 net160 _02174_ _01871_ vssd1 vssd1 vccd1 vccd1 _02176_ sky130_fd_sc_hd__o32ai_2
X_07635_ FPGA_INST.cell1.SB0.route_sel\[92\] _01635_ FPGA_INST.cell1.SB0.route_sel\[95\]
+ _01636_ _03887_ vssd1 vssd1 vccd1 vccd1 _03888_ sky130_fd_sc_hd__a221o_1
X_07566_ _03486_ _03781_ vssd1 vssd1 vccd1 vccd1 _03821_ sky130_fd_sc_hd__or2_1
XFILLER_53_399 vssd1 vssd1 vccd1 vccd1 sky130_fd_sc_hd__fill_1
X_09305_ FPGA_INST.cell1.SB0.route_sel\[76\] FPGA_INST.cell1.SB0.route_sel\[77\] net206
+ vssd1 vssd1 vccd1 vccd1 _00218_ sky130_fd_sc_hd__mux2_1
XFILLER_22_753 vssd1 vssd1 vccd1 vccd1 sky130_fd_sc_hd__fill_1
X_06517_ _02251_ _02792_ _02245_ vssd1 vssd1 vccd1 vccd1 _02793_ sky130_fd_sc_hd__nand3b_4
XANTENNA_fanout614_A net615 vssd1 vssd1 vccd1 vccd1 sky130_fd_sc_hd__diode_2
X_07497_ FPGA_INST.cell1.SB0.route_sel\[64\] FPGA_INST.cell1.SB0.route_sel\[65\] _03750_
+ _03751_ _03752_ vssd1 vssd1 vccd1 vccd1 _03753_ sky130_fd_sc_hd__a221o_1
X_09236_ FPGA_INST.cell1.SB0.route_sel\[8\] FPGA_INST.cell1.SB0.route_sel\[7\] net338
+ vssd1 vssd1 vccd1 vccd1 _00149_ sky130_fd_sc_hd__mux2_1
XANTENNA__05673__A1 _01939_ vssd1 vssd1 vccd1 vccd1 sky130_fd_sc_hd__diode_2
X_06448_ net488 _02376_ vssd1 vssd1 vccd1 vccd1 _02726_ sky130_fd_sc_hd__nand2_1
XPHY_EDGE_ROW_17_Right_17 vssd1 vssd1 vccd1 vccd1 sky130_fd_sc_hd__decap_3
X_06379_ _02450_ _02655_ _02656_ _02487_ FPGA_INST.cell2.CB_0.config_dataB\[2\] vssd1
+ vssd1 vccd1 vccd1 _02657_ sky130_fd_sc_hd__a221o_1
X_09167_ FPGA_INST.cell2.LE_0B.config_data\[7\] FPGA_INST.cell2.LE_0B.config_data\[8\]
+ net254 vssd1 vssd1 vccd1 vccd1 _00081_ sky130_fd_sc_hd__mux2_1
X_08118_ net451 _03728_ vssd1 vssd1 vccd1 vccd1 _04344_ sky130_fd_sc_hd__nand2_1
XANTENNA__07414__A2 _03526_ vssd1 vssd1 vccd1 vccd1 sky130_fd_sc_hd__diode_2
XFILLER_79_15 vccd1 vssd1 vccd1 vssd1 sky130_ef_sc_hd__decap_40_12
X_09098_ FPGA_INST.cell2.LEI0.config_data\[12\] FPGA_INST.cell2.LEI0.config_data\[13\]
+ net250 vssd1 vssd1 vccd1 vccd1 _00014_ sky130_fd_sc_hd__mux2_1
X_08049_ _04266_ _03652_ _03613_ _04265_ vssd1 vssd1 vccd1 vccd1 _04275_ sky130_fd_sc_hd__a2bb2o_1
XANTENNA__07965__A3 FPGA_INST.bus3_1\[7\] vssd1 vssd1 vccd1 vccd1 sky130_fd_sc_hd__diode_2
X_11060_ net806 _00410_ net591 vssd1 vssd1 vccd1 vccd1 FPGA_INST.cell1.LEI0.config_data\[45\]
+ sky130_fd_sc_hd__dfrtp_1
XFILLER_89_742 vssd1 vssd1 vccd1 vccd1 sky130_fd_sc_hd__fill_4
XANTENNA__05976__A2 _02255_ vssd1 vssd1 vccd1 vccd1 sky130_fd_sc_hd__diode_2
X_10011_ net430 net429 net194 vssd1 vssd1 vccd1 vccd1 _00892_ sky130_fd_sc_hd__mux2_1
XFILLER_49_617 vssd1 vssd1 vccd1 vccd1 sky130_fd_sc_hd__fill_1
XPHY_EDGE_ROW_26_Right_26 vssd1 vssd1 vccd1 vccd1 sky130_fd_sc_hd__decap_3
XANTENNA__08127__A0 FPGA_INST.bus3_1\[8\] vssd1 vssd1 vccd1 vccd1 sky130_fd_sc_hd__diode_2
XANTENNA__09216__S net367 vssd1 vssd1 vccd1 vccd1 sky130_fd_sc_hd__diode_2
XFILLER_0_189 vssd1 vssd1 vccd1 vccd1 sky130_fd_sc_hd__fill_4
XANTENNA__12108__CLK net917 vssd1 vssd1 vccd1 vccd1 sky130_fd_sc_hd__diode_2
XFILLER_28_52 vssd1 vssd1 vccd1 vccd1 sky130_fd_sc_hd__fill_2
X_11962_ net852 _01308_ net637 vssd1 vssd1 vccd1 vccd1 FPGA_INST.cell2.SB0.route_sel\[2\]
+ sky130_fd_sc_hd__dfstp_1
X_11893_ net937 _01239_ net721 vssd1 vssd1 vccd1 vccd1 FPGA_INST.cell3.LE_0B.config_data\[1\]
+ sky130_fd_sc_hd__dfrtp_1
X_10913_ net828 _00263_ net612 vssd1 vssd1 vccd1 vccd1 FPGA_INST.cell1.SB0.route_sel\[122\]
+ sky130_fd_sc_hd__dfstp_1
XANTENNA__06179__B1_N FPGA_INST.bus2_0\[0\] vssd1 vssd1 vccd1 vccd1 sky130_fd_sc_hd__diode_2
X_10844_ net800 _00194_ net585 vssd1 vssd1 vccd1 vccd1 FPGA_INST.cell1.SB0.route_sel\[53\]
+ sky130_fd_sc_hd__dfstp_1
XFILLER_32_528 vssd1 vssd1 vccd1 vccd1 sky130_fd_sc_hd__fill_4
XFILLER_9_702 vssd1 vssd1 vccd1 vccd1 sky130_fd_sc_hd__fill_8
X_10775_ net919 _00125_ net703 vssd1 vssd1 vccd1 vccd1 FPGA_INST.cell2.CB_1.config_dataB\[9\]
+ sky130_fd_sc_hd__dfstp_1
XTAP_TAPCELL_ROW_30_707 vssd1 vccd1 sky130_fd_sc_hd__tapvpwrvgnd_1
XPHY_EDGE_ROW_35_Right_35 vssd1 vssd1 vccd1 vccd1 sky130_fd_sc_hd__decap_3
XFILLER_40_583 vssd1 vssd1 vccd1 vccd1 sky130_fd_sc_hd__fill_2
XTAP_TAPCELL_ROW_10_420 vssd1 vccd1 sky130_fd_sc_hd__tapvpwrvgnd_1
XFILLER_125_165 vssd1 vssd1 vccd1 vccd1 sky130_fd_sc_hd__fill_2
X_11327_ net842 _00677_ net626 vssd1 vssd1 vccd1 vccd1 FPGA_INST.cell1.CB_0.config_dataB\[19\]
+ sky130_fd_sc_hd__dfstp_1
XANTENNA__06613__A0 FPGA_INST.bus3_2\[4\] vssd1 vssd1 vccd1 vccd1 sky130_fd_sc_hd__diode_2
XFILLER_5_23 vssd1 vssd1 vccd1 vccd1 sky130_fd_sc_hd__fill_2
XFILLER_4_473 vssd1 vssd1 vccd1 vccd1 sky130_fd_sc_hd__fill_2
XANTENNA__09158__A2 net524 vssd1 vssd1 vccd1 vccd1 sky130_fd_sc_hd__diode_2
XFILLER_69_92 vssd1 vssd1 vccd1 vccd1 sky130_fd_sc_hd__fill_1
XFILLER_69_70 vssd1 vssd1 vccd1 vccd1 sky130_fd_sc_hd__fill_4
X_11258_ net784 _00608_ net569 vssd1 vssd1 vccd1 vccd1 FPGA_INST.cell0.SB0.route_sel\[103\]
+ sky130_fd_sc_hd__dfstp_1
XPHY_EDGE_ROW_44_Right_44 vssd1 vssd1 vccd1 vccd1 sky130_fd_sc_hd__decap_3
X_10209_ FPGA_INST.cell3.SB0.route_sel\[113\] FPGA_INST.cell3.SB0.route_sel\[114\]
+ net269 vssd1 vssd1 vccd1 vccd1 _01090_ sky130_fd_sc_hd__mux2_1
X_11189_ net781 _00539_ net566 vssd1 vssd1 vccd1 vccd1 FPGA_INST.cell0.SB0.route_sel\[34\]
+ sky130_fd_sc_hd__dfstp_1
XFILLER_121_393 vssd1 vssd1 vccd1 vccd1 sky130_fd_sc_hd__fill_1
XFILLER_121_382 vssd1 vssd1 vccd1 vccd1 sky130_fd_sc_hd__fill_1
XFILLER_82_406 vssd1 vssd1 vccd1 vccd1 sky130_fd_sc_hd__fill_4
X_05750_ _02026_ _02029_ vssd1 vssd1 vccd1 vccd1 _02030_ sky130_fd_sc_hd__and2_2
XTAP_TAPCELL_ROW_38_818 vssd1 vccd1 sky130_fd_sc_hd__tapvpwrvgnd_1
XANTENNA__07722__X _03973_ vssd1 vssd1 vccd1 vccd1 sky130_fd_sc_hd__diode_2
XFILLER_82_428 vssd1 vssd1 vccd1 vccd1 sky130_fd_sc_hd__fill_1
XTAP_TAPCELL_ROW_18_531 vssd1 vccd1 sky130_fd_sc_hd__tapvpwrvgnd_1
X_05681_ _01956_ _01958_ _01959_ FPGA_INST.cell2.SB0.route_sel\[97\] FPGA_INST.cell2.SB0.route_sel\[96\]
+ vssd1 vssd1 vccd1 vccd1 _01961_ sky130_fd_sc_hd__a32o_1
X_07420_ FPGA_INST.cell1.SB0.route_sel\[50\] FPGA_INST.cell1.SB0.route_sel\[51\] vssd1
+ vssd1 vccd1 vccd1 _03678_ sky130_fd_sc_hd__nand2_1
XFILLER_63_675 vssd1 vssd1 vccd1 vccd1 sky130_fd_sc_hd__fill_1
X_07351_ FPGA_INST.cell1.SB0.route_sel\[38\] FPGA_INST.cell1.SB0.route_sel\[39\] vssd1
+ vssd1 vccd1 vccd1 _03611_ sky130_fd_sc_hd__nand2b_1
XPHY_EDGE_ROW_53_Right_53 vssd1 vssd1 vccd1 vccd1 sky130_fd_sc_hd__decap_3
XANTENNA__07601__C _03853_ vssd1 vssd1 vccd1 vccd1 sky130_fd_sc_hd__diode_2
XFILLER_50_369 vssd1 vssd1 vccd1 vccd1 sky130_fd_sc_hd__fill_2
X_06302_ net14 net15 net16 net17 net501 net499 vssd1 vssd1 vccd1 vccd1 _02582_ sky130_fd_sc_hd__mux4_1
XANTENNA__07644__A2 _03775_ vssd1 vssd1 vccd1 vccd1 sky130_fd_sc_hd__diode_2
X_07282_ net81 _03429_ _03542_ vssd1 vssd1 vccd1 vccd1 _03543_ sky130_fd_sc_hd__or3_1
X_09021_ _03538_ _05187_ vssd1 vssd1 vccd1 vccd1 FPGA_INST.bus3_1\[2\] sky130_fd_sc_hd__nor2_4
X_06233_ net3 net4 net510 vssd1 vssd1 vccd1 vccd1 _02513_ sky130_fd_sc_hd__mux2_1
XPHY_EDGE_ROW_28_Left_159 vssd1 vssd1 vccd1 vccd1 sky130_fd_sc_hd__decap_3
XFILLER_117_633 vssd1 vssd1 vccd1 vccd1 sky130_fd_sc_hd__fill_1
XANTENNA__08713__B _04920_ vssd1 vssd1 vccd1 vccd1 sky130_fd_sc_hd__diode_2
X_06164_ net2 _02441_ _02442_ _02443_ vssd1 vssd1 vccd1 vccd1 _02444_ sky130_fd_sc_hd__o211a_1
XPHY_EDGE_ROW_62_Right_62 vssd1 vssd1 vccd1 vccd1 sky130_fd_sc_hd__decap_3
X_06095_ FPGA_INST.cell2.SB0.route_sel\[30\] _01555_ FPGA_INST.cell2.SB0.route_sel\[26\]
+ FPGA_INST.cell2.SB0.route_sel\[27\] _02374_ vssd1 vssd1 vccd1 vccd1 _02375_ sky130_fd_sc_hd__o221a_1
Xfanout714 net715 vssd1 vssd1 vccd1 vccd1 net714 sky130_fd_sc_hd__clkbuf_2
Xfanout703 net704 vssd1 vssd1 vccd1 vccd1 net703 sky130_fd_sc_hd__clkbuf_4
XANTENNA__08357__A0 FPGA_INST.bus1_0\[8\] vssd1 vssd1 vccd1 vccd1 sky130_fd_sc_hd__diode_2
X_09923_ FPGA_INST.cell0.LE_1A.config_data\[5\] FPGA_INST.cell0.LE_1A.config_data\[4\]
+ net308 vssd1 vssd1 vccd1 vccd1 _00828_ sky130_fd_sc_hd__mux2_1
Xfanout725 net729 vssd1 vssd1 vccd1 vccd1 net725 sky130_fd_sc_hd__clkbuf_4
XFILLER_105_13 vssd1 vssd1 vccd1 vccd1 sky130_fd_sc_hd__fill_1
Xfanout736 net28 vssd1 vssd1 vccd1 vccd1 net736 sky130_fd_sc_hd__buf_6
XFILLER_86_712 vssd1 vssd1 vccd1 vccd1 sky130_fd_sc_hd__fill_4
X_09854_ FPGA_INST.cell0.LEI0.config_data\[32\] FPGA_INST.cell0.LEI0.config_data\[33\]
+ net173 vssd1 vssd1 vccd1 vccd1 _00762_ sky130_fd_sc_hd__mux2_1
XANTENNA__12024__Q FPGA_INST.cell2.SB0.route_sel\[64\] vssd1 vssd1 vccd1 vccd1 sky130_fd_sc_hd__diode_2
Xfanout747 net749 vssd1 vssd1 vccd1 vccd1 net747 sky130_fd_sc_hd__clkbuf_2
Xfanout758 net790 vssd1 vssd1 vccd1 vccd1 net758 sky130_fd_sc_hd__dlymetal6s2s_1
X_08805_ net18 net19 net20 net21 net392 net391 vssd1 vssd1 vccd1 vccd1 _05012_ sky130_fd_sc_hd__mux4_1
Xfanout769 net790 vssd1 vssd1 vccd1 vccd1 net769 sky130_fd_sc_hd__clkbuf_2
XPHY_EDGE_ROW_0_Left_131 vssd1 vssd1 vccd1 vccd1 sky130_fd_sc_hd__decap_3
XPHY_EDGE_ROW_37_Left_168 vssd1 vssd1 vccd1 vccd1 sky130_fd_sc_hd__decap_3
X_09785_ FPGA_INST.cell1.CB_1.config_dataA\[11\] FPGA_INST.cell1.CB_1.config_dataA\[10\]
+ net326 vssd1 vssd1 vccd1 vccd1 _00694_ sky130_fd_sc_hd__mux2_1
X_06997_ _03254_ _03262_ vssd1 vssd1 vccd1 vccd1 _03263_ sky130_fd_sc_hd__nor2_1
X_08736_ _04794_ _04927_ _04929_ _04789_ FPGA_INST.cell3.CB_0.config_dataA\[17\] vssd1
+ vssd1 vccd1 vccd1 _04945_ sky130_fd_sc_hd__a221o_1
XFILLER_66_491 vssd1 vssd1 vccd1 vccd1 sky130_fd_sc_hd__fill_4
X_05948_ _02219_ _02226_ _02227_ vssd1 vssd1 vccd1 vccd1 _02228_ sky130_fd_sc_hd__a21oi_1
X_08667_ net399 _04785_ _04875_ vssd1 vssd1 vccd1 vccd1 _04876_ sky130_fd_sc_hd__a21oi_1
XANTENNA__07632__X _03885_ vssd1 vssd1 vccd1 vccd1 sky130_fd_sc_hd__diode_2
XANTENNA_fanout352_X net352 vssd1 vssd1 vccd1 vccd1 sky130_fd_sc_hd__diode_2
XANTENNA_fanout731_A net31 vssd1 vssd1 vccd1 vccd1 sky130_fd_sc_hd__diode_2
X_05879_ _01957_ _02048_ vssd1 vssd1 vccd1 vccd1 _02159_ sky130_fd_sc_hd__or2_1
XTAP_TAPCELL_ROW_107_1779 vssd1 vccd1 sky130_fd_sc_hd__tapvpwrvgnd_1
XANTENNA_fanout829_A net831 vssd1 vssd1 vccd1 vccd1 sky130_fd_sc_hd__diode_2
XFILLER_81_27 vssd1 vssd1 vccd1 vccd1 sky130_fd_sc_hd__fill_4
X_07618_ _03870_ vssd1 vssd1 vccd1 vccd1 _03871_ sky130_fd_sc_hd__inv_2
XPHY_EDGE_ROW_71_Right_71 vssd1 vssd1 vccd1 vccd1 sky130_fd_sc_hd__decap_3
XFILLER_14_517 vssd1 vssd1 vccd1 vccd1 sky130_fd_sc_hd__fill_1
XANTENNA__07883__A2 net148 vssd1 vssd1 vccd1 vccd1 sky130_fd_sc_hd__diode_2
X_08598_ FPGA_INST.cell3.SB0.route_sel\[98\] FPGA_INST.cell3.SB0.route_sel\[99\] vssd1
+ vssd1 vccd1 vccd1 _04807_ sky130_fd_sc_hd__nor2_1
XANTENNA__10219__A1 FPGA_INST.cell3.SB0.route_sel\[124\] vssd1 vssd1 vccd1 vccd1 sky130_fd_sc_hd__diode_2
XTAP_TAPCELL_ROW_120_1968 vssd1 vccd1 sky130_fd_sc_hd__tapvpwrvgnd_1
XTAP_TAPCELL_ROW_120_1957 vssd1 vccd1 sky130_fd_sc_hd__tapvpwrvgnd_1
X_07549_ net153 _03451_ _03745_ vssd1 vssd1 vccd1 vccd1 _03804_ sky130_fd_sc_hd__or3_1
XFILLER_10_701 vssd1 vssd1 vccd1 vccd1 sky130_fd_sc_hd__fill_4
XANTENNA__08832__B2 _04831_ vssd1 vssd1 vccd1 vccd1 sky130_fd_sc_hd__diode_2
X_10560_ FPGA_INST.cell3.CB_0.config_dataA\[4\] net399 net288 vssd1 vssd1 vccd1 vccd1
+ _01439_ sky130_fd_sc_hd__mux2_1
XPHY_EDGE_ROW_46_Left_177 vssd1 vssd1 vccd1 vccd1 sky130_fd_sc_hd__decap_3
XFILLER_127_408 vssd1 vssd1 vccd1 vccd1 sky130_fd_sc_hd__fill_1
XANTENNA__10645__S net369 vssd1 vssd1 vccd1 vccd1 sky130_fd_sc_hd__diode_2
X_09219_ net511 FPGA_INST.cell2.CB_1.config_dataB\[15\] net373 vssd1 vssd1 vccd1 vccd1
+ _00132_ sky130_fd_sc_hd__mux2_1
X_10491_ FPGA_INST.cell2.SB0.route_sel\[63\] FPGA_INST.cell2.SB0.route_sel\[64\] net238
+ vssd1 vssd1 vccd1 vccd1 _01370_ sky130_fd_sc_hd__mux2_1
XPHY_EDGE_ROW_80_Right_80 vssd1 vssd1 vccd1 vccd1 sky130_fd_sc_hd__decap_3
XFILLER_5_248 vssd1 vssd1 vccd1 vccd1 sky130_fd_sc_hd__fill_2
XFILLER_30_53 vssd1 vssd1 vccd1 vccd1 sky130_fd_sc_hd__fill_8
XFILLER_108_699 vssd1 vssd1 vccd1 vccd1 sky130_fd_sc_hd__fill_1
X_12161_ net907 _01507_ net691 vssd1 vssd1 vccd1 vccd1 FPGA_INST.cell3.CB_1.config_dataA\[23\]
+ sky130_fd_sc_hd__dfstp_1
XANTENNA__06071__A1 net171 vssd1 vssd1 vccd1 vccd1 sky130_fd_sc_hd__diode_2
X_11112_ net806 _00462_ net591 vssd1 vssd1 vccd1 vccd1 FPGA_INST.cell1.LE_1A.config_data\[3\]
+ sky130_fd_sc_hd__dfrtp_1
X_12092_ net921 _01438_ net705 vssd1 vssd1 vccd1 vccd1 FPGA_INST.cell3.CB_0.config_dataA\[4\]
+ sky130_fd_sc_hd__dfstp_1
X_11043_ net815 _00393_ net600 vssd1 vssd1 vccd1 vccd1 FPGA_INST.cell1.LEI0.config_data\[28\]
+ sky130_fd_sc_hd__dfrtp_1
XFILLER_89_561 vssd1 vssd1 vccd1 vccd1 sky130_fd_sc_hd__fill_1
XPHY_EDGE_ROW_55_Left_186 vssd1 vssd1 vccd1 vccd1 sky130_fd_sc_hd__decap_3
XANTENNA__07020__A0 FPGA_INST.bus2_0\[12\] vssd1 vssd1 vccd1 vccd1 sky130_fd_sc_hd__diode_2
XFILLER_76_266 vccd1 vssd1 vccd1 vssd1 sky130_ef_sc_hd__decap_40_12
X_11945_ net913 _01291_ net697 vssd1 vssd1 vccd1 vccd1 FPGA_INST.cell3.CB_1.config_dataB\[10\]
+ sky130_fd_sc_hd__dfstp_1
XANTENNA__08115__A3 FPGA_INST.bus3_1\[7\] vssd1 vssd1 vccd1 vccd1 sky130_fd_sc_hd__diode_2
XFILLER_44_141 vssd1 vssd1 vccd1 vccd1 sky130_fd_sc_hd__fill_1
XANTENNA__07542__X _03797_ vssd1 vssd1 vccd1 vccd1 sky130_fd_sc_hd__diode_2
XFILLER_29_182 vssd1 vssd1 vccd1 vccd1 sky130_fd_sc_hd__fill_4
XTAP_TAPCELL_ROW_82_1429 vssd1 vccd1 sky130_fd_sc_hd__tapvpwrvgnd_1
X_11876_ net927 _01222_ net711 vssd1 vssd1 vccd1 vccd1 FPGA_INST.cell3.LE_0A.config_data\[6\]
+ sky130_fd_sc_hd__dfrtp_1
X_10827_ net814 _00177_ net599 vssd1 vssd1 vccd1 vccd1 FPGA_INST.cell1.SB0.route_sel\[36\]
+ sky130_fd_sc_hd__dfstp_1
XPHY_EDGE_ROW_64_Left_195 vssd1 vssd1 vccd1 vccd1 sky130_fd_sc_hd__decap_3
XTAP_TAPCELL_ROW_43_887 vssd1 vccd1 sky130_fd_sc_hd__tapvpwrvgnd_1
XFILLER_13_561 vssd1 vssd1 vccd1 vccd1 sky130_fd_sc_hd__fill_4
X_10758_ net889 _00108_ net673 vssd1 vssd1 vccd1 vccd1 FPGA_INST.cell2.LE_1A.config_data\[13\]
+ sky130_fd_sc_hd__dfrtp_1
XFILLER_118_419 vssd1 vssd1 vccd1 vccd1 sky130_fd_sc_hd__fill_1
X_10689_ net867 _00039_ net651 vssd1 vssd1 vccd1 vccd1 FPGA_INST.cell2.LEI0.config_data\[38\]
+ sky130_fd_sc_hd__dfrtp_1
XANTENNA__07929__A3 FPGA_INST.bus3_1\[3\] vssd1 vssd1 vccd1 vccd1 sky130_fd_sc_hd__diode_2
XFILLER_68_712 vssd1 vssd1 vccd1 vccd1 sky130_fd_sc_hd__fill_1
X_06920_ FPGA_INST.cell0.CB_0.config_dataB\[13\] FPGA_INST.cell0.CB_0.config_dataB\[12\]
+ vssd1 vssd1 vccd1 vccd1 _03188_ sky130_fd_sc_hd__or2_1
XFILLER_122_680 vssd1 vssd1 vccd1 vccd1 sky130_fd_sc_hd__fill_1
X_06851_ FPGA_INST.bus2_0\[8\] FPGA_INST.bus2_0\[9\] FPGA_INST.bus2_0\[10\] FPGA_INST.bus2_0\[11\]
+ net421 net420 vssd1 vssd1 vccd1 vccd1 _03119_ sky130_fd_sc_hd__mux4_1
XTAP_TAPCELL_ROW_124_2024 vssd1 vccd1 sky130_fd_sc_hd__tapvpwrvgnd_1
XTAP_TAPCELL_ROW_124_2013 vssd1 vccd1 sky130_fd_sc_hd__tapvpwrvgnd_1
X_09570_ FPGA_INST.cell1.LE_1B.dff0_out net523 _05216_ vssd1 vssd1 vccd1 vccd1 _00479_
+ sky130_fd_sc_hd__a21bo_1
X_06782_ FPGA_INST.bus3_2\[12\] FPGA_INST.bus3_2\[13\] FPGA_INST.bus3_2\[14\] FPGA_INST.bus3_2\[15\]
+ FPGA_INST.cell2.CB_1.config_dataB\[15\] net511 vssd1 vssd1 vccd1 vccd1 _03056_ sky130_fd_sc_hd__mux4_1
XFILLER_67_277 vssd1 vssd1 vccd1 vccd1 sky130_fd_sc_hd__fill_2
X_05802_ _01903_ _02045_ vssd1 vssd1 vccd1 vccd1 _02082_ sky130_fd_sc_hd__nand2_1
XFILLER_27_108 vssd1 vssd1 vccd1 vccd1 sky130_fd_sc_hd__fill_4
X_08521_ FPGA_INST.cell3.CB_1.config_dataA\[18\] FPGA_INST.cell3.CB_1.config_dataA\[17\]
+ FPGA_INST.cell3.CB_1.config_dataA\[16\] FPGA_INST.cell3.CB_1.config_dataA\[15\]
+ vssd1 vssd1 vccd1 vccd1 _04734_ sky130_fd_sc_hd__or4b_1
X_05733_ FPGA_INST.cell0.CB_0.config_dataA\[22\] FPGA_INST.cell0.CB_0.config_dataA\[23\]
+ vssd1 vssd1 vccd1 vccd1 _02013_ sky130_fd_sc_hd__nand2b_4
XFILLER_36_642 vssd1 vssd1 vccd1 vccd1 sky130_fd_sc_hd__fill_2
X_08452_ FPGA_INST.cell1.CB_1.config_dataA\[18\] FPGA_INST.cell1.CB_1.config_dataA\[17\]
+ FPGA_INST.cell1.CB_1.config_dataA\[16\] FPGA_INST.cell1.CB_1.config_dataA\[15\]
+ vssd1 vssd1 vccd1 vccd1 _04670_ sky130_fd_sc_hd__or4b_1
XFILLER_63_472 vssd1 vssd1 vccd1 vccd1 sky130_fd_sc_hd__fill_2
X_07403_ net86 _03484_ _03620_ _03661_ vssd1 vssd1 vccd1 vccd1 _03662_ sky130_fd_sc_hd__o31a_1
X_05664_ _01847_ _01943_ vssd1 vssd1 vccd1 vccd1 _01944_ sky130_fd_sc_hd__nor2_1
XFILLER_50_100 vssd1 vssd1 vccd1 vccd1 sky130_fd_sc_hd__fill_1
X_05595_ _01606_ _01607_ vssd1 vssd1 vccd1 vccd1 _01875_ sky130_fd_sc_hd__nor2_1
X_08383_ _04604_ _04575_ _04544_ vssd1 vssd1 vccd1 vccd1 _04605_ sky130_fd_sc_hd__mux2_1
X_07334_ FPGA_INST.cell1.CB_0.config_dataB\[23\] FPGA_INST.cell1.CB_0.config_dataB\[22\]
+ vssd1 vssd1 vccd1 vccd1 _03594_ sky130_fd_sc_hd__nand2b_2
X_07265_ _03429_ _03526_ net78 vssd1 vssd1 vccd1 vccd1 _03527_ sky130_fd_sc_hd__o21ai_1
X_09004_ FPGA_INST.cell1.SB0.route_sel\[28\] _01698_ FPGA_INST.cell1.SB0.route_sel\[24\]
+ FPGA_INST.cell1.SB0.route_sel\[25\] vssd1 vssd1 vccd1 vccd1 _05176_ sky130_fd_sc_hd__o22a_1
XANTENNA_fanout312_A net315 vssd1 vssd1 vccd1 vccd1 sky130_fd_sc_hd__diode_2
X_06216_ net5 _01811_ _02495_ FPGA_INST.cell2.CB_0.config_dataA\[8\] vssd1 vssd1 vccd1
+ vccd1 _02496_ sky130_fd_sc_hd__a211o_1
X_07196_ _01787_ _03452_ vssd1 vssd1 vccd1 vccd1 _03459_ sky130_fd_sc_hd__and2_1
XFILLER_105_625 vssd1 vssd1 vccd1 vccd1 sky130_fd_sc_hd__fill_1
XFILLER_105_614 vssd1 vssd1 vccd1 vccd1 sky130_fd_sc_hd__fill_2
X_06147_ FPGA_INST.cell0.SB0.route_sel\[11\] FPGA_INST.cell0.SB0.route_sel\[10\] vssd1
+ vssd1 vccd1 vccd1 _02427_ sky130_fd_sc_hd__nor2_1
X_06078_ FPGA_INST.cell2.CB_1.config_dataA\[23\] FPGA_INST.cell2.CB_1.config_dataA\[22\]
+ vssd1 vssd1 vccd1 vccd1 _02358_ sky130_fd_sc_hd__or2_2
XTAP_TAPCELL_ROW_53_1019 vssd1 vccd1 sky130_fd_sc_hd__tapvpwrvgnd_1
Xfanout522 net525 vssd1 vssd1 vccd1 vccd1 net522 sky130_fd_sc_hd__buf_4
Xfanout511 FPGA_INST.cell2.CB_1.config_dataB\[16\] vssd1 vssd1 vccd1 vccd1 net511
+ sky130_fd_sc_hd__buf_2
X_09906_ FPGA_INST.cell0.LE_0B.config_data\[11\] FPGA_INST.cell0.LE_0B.config_data\[10\]
+ net316 vssd1 vssd1 vccd1 vccd1 _00812_ sky130_fd_sc_hd__mux2_1
Xfanout500 FPGA_INST.cell2.CB_0.config_dataA\[15\] vssd1 vssd1 vccd1 vccd1 net500
+ sky130_fd_sc_hd__buf_2
Xfanout533 net534 vssd1 vssd1 vccd1 vccd1 net533 sky130_fd_sc_hd__clkbuf_2
XFILLER_76_27 vssd1 vssd1 vccd1 vccd1 sky130_fd_sc_hd__fill_1
Xfanout555 net558 vssd1 vssd1 vccd1 vccd1 net555 sky130_fd_sc_hd__clkbuf_4
Xfanout566 net575 vssd1 vssd1 vccd1 vccd1 net566 sky130_fd_sc_hd__clkbuf_4
Xfanout544 net547 vssd1 vssd1 vccd1 vccd1 net544 sky130_fd_sc_hd__clkbuf_4
XANTENNA_fanout946_A net947 vssd1 vssd1 vccd1 vccd1 sky130_fd_sc_hd__diode_2
XFILLER_112_190 vssd1 vssd1 vccd1 vccd1 sky130_fd_sc_hd__fill_2
XTAP_TAPCELL_ROW_109_1808 vssd1 vccd1 sky130_fd_sc_hd__tapvpwrvgnd_1
Xfanout599 net604 vssd1 vssd1 vccd1 vccd1 net599 sky130_fd_sc_hd__clkbuf_4
Xfanout577 net588 vssd1 vssd1 vccd1 vccd1 net577 sky130_fd_sc_hd__clkbuf_4
Xfanout588 net627 vssd1 vssd1 vccd1 vccd1 net588 sky130_fd_sc_hd__clkbuf_2
X_09837_ FPGA_INST.cell0.LEI0.config_data\[15\] FPGA_INST.cell0.LEI0.config_data\[16\]
+ net172 vssd1 vssd1 vccd1 vccd1 _00745_ sky130_fd_sc_hd__mux2_1
X_09768_ FPGA_INST.cell1.CB_0.config_dataB\[18\] FPGA_INST.cell1.CB_0.config_dataB\[19\]
+ net232 vssd1 vssd1 vccd1 vccd1 _00677_ sky130_fd_sc_hd__mux2_1
XFILLER_73_214 vssd1 vssd1 vccd1 vccd1 sky130_fd_sc_hd__fill_8
X_08719_ net395 net393 vssd1 vssd1 vccd1 vccd1 _04928_ sky130_fd_sc_hd__or2_1
XTAP_TAPCELL_ROW_68_1240 vssd1 vccd1 sky130_fd_sc_hd__tapvpwrvgnd_1
XFILLER_27_631 vssd1 vssd1 vccd1 vccd1 sky130_fd_sc_hd__fill_2
X_11730_ net898 _01076_ net682 vssd1 vssd1 vccd1 vccd1 FPGA_INST.cell3.SB0.route_sel\[100\]
+ sky130_fd_sc_hd__dfstp_1
XANTENNA_fanout734_X net734 vssd1 vssd1 vccd1 vccd1 sky130_fd_sc_hd__diode_2
X_09699_ FPGA_INST.cell0.SB0.route_sel\[102\] FPGA_INST.cell0.SB0.route_sel\[103\]
+ net198 vssd1 vssd1 vccd1 vccd1 _00608_ sky130_fd_sc_hd__mux2_1
XFILLER_26_141 vssd1 vssd1 vccd1 vccd1 sky130_fd_sc_hd__fill_1
XFILLER_26_152 vssd1 vssd1 vccd1 vccd1 sky130_fd_sc_hd__fill_4
XTAP_TAPCELL_ROW_1_295 vssd1 vccd1 sky130_fd_sc_hd__tapvpwrvgnd_1
XFILLER_26_174 vssd1 vssd1 vccd1 vccd1 sky130_fd_sc_hd__fill_1
X_11661_ net896 _01007_ net680 vssd1 vssd1 vccd1 vccd1 FPGA_INST.cell3.SB0.route_sel\[31\]
+ sky130_fd_sc_hd__dfstp_1
XFILLER_14_369 vssd1 vssd1 vccd1 vccd1 sky130_fd_sc_hd__fill_1
XFILLER_41_144 vssd1 vssd1 vccd1 vccd1 sky130_fd_sc_hd__fill_1
XFILLER_41_166 vssd1 vssd1 vccd1 vccd1 sky130_fd_sc_hd__fill_2
X_10612_ FPGA_INST.cell3.CB_1.config_dataA\[7\] FPGA_INST.cell3.CB_1.config_dataA\[6\]
+ net375 vssd1 vssd1 vccd1 vccd1 _01491_ sky130_fd_sc_hd__mux2_1
XANTENNA__08805__A1 net19 vssd1 vssd1 vccd1 vccd1 sky130_fd_sc_hd__diode_2
X_11592_ net791 _00942_ net576 vssd1 vssd1 vccd1 vccd1 FPGA_INST.cell0.CB_1.config_dataA\[11\]
+ sky130_fd_sc_hd__dfstp_1
XFILLER_41_199 vssd1 vssd1 vccd1 vccd1 sky130_fd_sc_hd__fill_2
X_10543_ FPGA_INST.cell2.SB0.route_sel\[116\] FPGA_INST.cell2.SB0.route_sel\[115\]
+ net352 vssd1 vssd1 vccd1 vccd1 _01422_ sky130_fd_sc_hd__mux2_1
XTAP_TAPCELL_ROW_40_846 vssd1 vccd1 sky130_fd_sc_hd__tapvpwrvgnd_1
XFILLER_41_30 vssd1 vssd1 vccd1 vccd1 sky130_fd_sc_hd__fill_2
XFILLER_127_249 vssd1 vssd1 vccd1 vccd1 sky130_fd_sc_hd__fill_1
XFILLER_127_227 vssd1 vssd1 vccd1 vccd1 sky130_fd_sc_hd__fill_4
XFILLER_10_575 vssd1 vssd1 vccd1 vccd1 sky130_fd_sc_hd__fill_1
XFILLER_41_52 vssd1 vssd1 vccd1 vccd1 sky130_fd_sc_hd__fill_4
X_10474_ FPGA_INST.cell2.SB0.route_sel\[46\] FPGA_INST.cell2.SB0.route_sel\[47\] net198
+ vssd1 vssd1 vccd1 vccd1 _01353_ sky130_fd_sc_hd__mux2_1
XFILLER_108_474 vssd1 vssd1 vccd1 vccd1 sky130_fd_sc_hd__fill_2
XTAP_TAPCELL_ROW_79_1391 vssd1 vccd1 sky130_fd_sc_hd__tapvpwrvgnd_1
X_12144_ net942 _01490_ net726 vssd1 vssd1 vccd1 vccd1 FPGA_INST.cell3.CB_1.config_dataA\[6\]
+ sky130_fd_sc_hd__dfstp_1
XFILLER_2_730 vssd1 vssd1 vccd1 vccd1 sky130_fd_sc_hd__fill_1
XANTENNA__06044__A1 net6 vssd1 vssd1 vccd1 vccd1 sky130_fd_sc_hd__diode_2
XFILLER_37_9 vssd1 vssd1 vccd1 vccd1 sky130_fd_sc_hd__fill_1
XFILLER_77_531 vssd1 vssd1 vccd1 vccd1 sky130_fd_sc_hd__fill_2
XFILLER_49_211 vssd1 vssd1 vccd1 vccd1 sky130_fd_sc_hd__fill_1
XANTENNA_input30_X net30 vssd1 vssd1 vccd1 vccd1 sky130_fd_sc_hd__diode_2
X_12075_ net848 _01421_ net633 vssd1 vssd1 vccd1 vccd1 FPGA_INST.cell2.SB0.route_sel\[115\]
+ sky130_fd_sc_hd__dfstp_1
X_11026_ net816 _00376_ net601 vssd1 vssd1 vccd1 vccd1 FPGA_INST.cell1.LEI0.config_data\[11\]
+ sky130_fd_sc_hd__dfrtp_1
XTAP_TAPCELL_ROW_48_957 vssd1 vccd1 sky130_fd_sc_hd__tapvpwrvgnd_1
XANTENNA__09404__S net355 vssd1 vssd1 vccd1 vccd1 sky130_fd_sc_hd__diode_2
XPHY_EDGE_ROW_72_Left_203 vssd1 vssd1 vccd1 vccd1 sky130_fd_sc_hd__decap_3
X_11928_ net944 _01274_ net728 vssd1 vssd1 vccd1 vccd1 FPGA_INST.cell3.LE_1A.config_data\[14\]
+ sky130_fd_sc_hd__dfrtp_1
XTAP_TAPCELL_ROW_28_670 vssd1 vccd1 sky130_fd_sc_hd__tapvpwrvgnd_1
XTAP_TAPCELL_ROW_28_681 vssd1 vccd1 sky130_fd_sc_hd__tapvpwrvgnd_1
X_11859_ net935 _01205_ net719 vssd1 vssd1 vccd1 vccd1 FPGA_INST.cell3.LEI0.config_data\[39\]
+ sky130_fd_sc_hd__dfrtp_1
X_05380_ net27 vssd1 vssd1 vccd1 vccd1 _01662_ sky130_fd_sc_hd__inv_2
XFILLER_20_339 vssd1 vssd1 vccd1 vccd1 sky130_fd_sc_hd__fill_1
XTAP_TAPCELL_ROW_95_1609 vssd1 vccd1 sky130_fd_sc_hd__tapvpwrvgnd_1
XANTENNA__06283__A1 net8 vssd1 vssd1 vccd1 vccd1 sky130_fd_sc_hd__diode_2
XANTENNA__07075__A3 FPGA_INST.bus2_0\[15\] vssd1 vssd1 vccd1 vccd1 sky130_fd_sc_hd__diode_2
X_07050_ net431 _02191_ _03315_ vssd1 vssd1 vccd1 vccd1 _03316_ sky130_fd_sc_hd__a21o_1
XFILLER_127_761 vssd1 vssd1 vccd1 vccd1 sky130_fd_sc_hd__fill_2
X_06001_ net129 _02278_ vssd1 vssd1 vccd1 vccd1 _02281_ sky130_fd_sc_hd__nand2_2
XFILLER_127_794 vssd1 vssd1 vccd1 vccd1 sky130_fd_sc_hd__fill_2
XFILLER_126_271 vccd1 vssd1 vccd1 vssd1 sky130_ef_sc_hd__decap_40_12
XANTENNA__08024__A2 FPGA_INST.bus3_1\[14\] vssd1 vssd1 vccd1 vccd1 sky130_fd_sc_hd__diode_2
XPHY_EDGE_ROW_81_Left_212 vssd1 vssd1 vccd1 vccd1 sky130_fd_sc_hd__decap_3
XFILLER_99_155 vccd1 vssd1 vccd1 vssd1 sky130_ef_sc_hd__decap_40_12
X_07952_ FPGA_INST.cell1.LEI0.config_data\[24\] _01789_ _04179_ FPGA_INST.cell1.LEI0.config_data\[25\]
+ vssd1 vssd1 vccd1 vccd1 _04180_ sky130_fd_sc_hd__o211a_1
XANTENNA__09524__A2 net523 vssd1 vssd1 vccd1 vccd1 sky130_fd_sc_hd__diode_2
X_07883_ FPGA_INST.cell1.LEI0.config_data\[12\] net148 _04110_ FPGA_INST.cell1.LEI0.config_data\[13\]
+ vssd1 vssd1 vccd1 vccd1 _04111_ sky130_fd_sc_hd__o211a_1
X_06903_ FPGA_INST.bus2_0\[12\] FPGA_INST.bus2_0\[14\] FPGA_INST.bus2_0\[13\] FPGA_INST.bus2_0\[15\]
+ net417 net419 vssd1 vssd1 vccd1 vccd1 _03171_ sky130_fd_sc_hd__mux4_1
XFILLER_68_586 vssd1 vssd1 vccd1 vccd1 sky130_fd_sc_hd__fill_2
X_09622_ FPGA_INST.cell0.SB0.route_sel\[25\] FPGA_INST.cell0.SB0.route_sel\[26\] net195
+ vssd1 vssd1 vccd1 vccd1 _00531_ sky130_fd_sc_hd__mux2_1
XFILLER_55_225 vssd1 vssd1 vccd1 vccd1 sky130_fd_sc_hd__fill_8
X_06834_ FPGA_INST.bus2_0\[4\] _03094_ _03101_ net420 vssd1 vssd1 vccd1 vccd1 _03102_
+ sky130_fd_sc_hd__a22o_1
X_09553_ FPGA_INST.cell1.LE_1A.config_data\[3\] FPGA_INST.cell1.LE_1A.config_data\[2\]
+ net333 vssd1 vssd1 vccd1 vccd1 _00462_ sky130_fd_sc_hd__mux2_1
XPHY_EDGE_ROW_90_Left_221 vssd1 vssd1 vccd1 vccd1 sky130_fd_sc_hd__decap_3
XANTENNA__07182__X FPGA_INST.bus3_2\[0\] vssd1 vssd1 vccd1 vccd1 sky130_fd_sc_hd__diode_2
XANTENNA__07623__A _03875_ vssd1 vssd1 vccd1 vccd1 sky130_fd_sc_hd__diode_2
XANTENNA__06889__A3 net99 vssd1 vssd1 vccd1 vccd1 sky130_fd_sc_hd__diode_2
X_08504_ _01600_ FPGA_INST.cell3.SB0.route_sel\[121\] FPGA_INST.cell3.SB0.route_sel\[126\]
+ FPGA_INST.cell3.SB0.config_data_out _04717_ vssd1 vssd1 vccd1 vccd1 _04718_ sky130_fd_sc_hd__o221a_1
X_06765_ _02804_ _03021_ _03022_ _02801_ vssd1 vssd1 vccd1 vccd1 _03039_ sky130_fd_sc_hd__a22o_1
XTAP_TAPCELL_ROW_104_1738 vssd1 vccd1 sky130_fd_sc_hd__tapvpwrvgnd_1
X_09484_ FPGA_INST.cell1.LEI0.config_data\[30\] FPGA_INST.cell1.LEI0.config_data\[31\]
+ net210 vssd1 vssd1 vccd1 vccd1 _00396_ sky130_fd_sc_hd__mux2_1
X_06696_ FPGA_INST.cell2.CB_1.config_dataB\[2\] _02969_ _02968_ FPGA_INST.cell2.CB_1.config_dataB\[3\]
+ vssd1 vssd1 vccd1 vccd1 _02970_ sky130_fd_sc_hd__o211a_1
X_05716_ net100 _01846_ net164 _01994_ vssd1 vssd1 vccd1 vccd1 _01996_ sky130_fd_sc_hd__a31o_1
XFILLER_23_111 vssd1 vssd1 vccd1 vccd1 sky130_fd_sc_hd__fill_1
XFILLER_24_645 vssd1 vssd1 vccd1 vccd1 sky130_fd_sc_hd__fill_1
X_08435_ net151 net144 net149 net142 FPGA_INST.cell1.LEI0.config_data\[18\] FPGA_INST.cell1.LEI0.config_data\[19\]
+ vssd1 vssd1 vccd1 vccd1 _04653_ sky130_fd_sc_hd__mux4_1
X_05647_ FPGA_INST.cell0.CB_1.config_dataA\[24\] FPGA_INST.cell0.CB_1.config_dataA\[20\]
+ FPGA_INST.cell0.CB_1.config_dataA\[21\] vssd1 vssd1 vccd1 vccd1 _01927_ sky130_fd_sc_hd__or3_4
XANTENNA_fanout148_X net148 vssd1 vssd1 vccd1 vccd1 sky130_fd_sc_hd__diode_2
XTAP_TAPCELL_ROW_63_1170 vssd1 vccd1 sky130_fd_sc_hd__tapvpwrvgnd_1
X_08366_ net442 _03558_ vssd1 vssd1 vccd1 vccd1 _04588_ sky130_fd_sc_hd__nand2_1
XANTENNA__06673__S _02878_ vssd1 vssd1 vccd1 vccd1 sky130_fd_sc_hd__diode_2
X_07317_ FPGA_INST.cell3.CB_0.config_dataA\[24\] FPGA_INST.cell3.CB_0.config_dataA\[21\]
+ FPGA_INST.cell3.CB_0.config_dataA\[20\] vssd1 vssd1 vccd1 vccd1 _03578_ sky130_fd_sc_hd__nand3b_1
X_05578_ net485 net486 _01856_ net16 vssd1 vssd1 vccd1 vccd1 _01858_ sky130_fd_sc_hd__a31o_1
XANTENNA_fanout315_X net315 vssd1 vssd1 vccd1 vccd1 sky130_fd_sc_hd__diode_2
X_08297_ _03959_ _04517_ _04518_ _03923_ _04516_ vssd1 vssd1 vccd1 vccd1 _04519_ sky130_fd_sc_hd__a221o_1
XFILLER_109_249 vssd1 vssd1 vccd1 vccd1 sky130_fd_sc_hd__fill_2
X_07248_ FPGA_INST.cell1.SB0.route_sel\[18\] FPGA_INST.cell1.SB0.route_sel\[19\] _03509_
+ vssd1 vssd1 vccd1 vccd1 _03510_ sky130_fd_sc_hd__a21oi_1
X_07179_ _03394_ _03432_ _03442_ vssd1 vssd1 vccd1 vccd1 _03443_ sky130_fd_sc_hd__a21oi_1
XFILLER_3_505 vssd1 vssd1 vccd1 vccd1 sky130_fd_sc_hd__fill_1
XFILLER_11_66 vssd1 vssd1 vccd1 vccd1 sky130_fd_sc_hd__fill_4
XFILLER_117_293 vssd1 vssd1 vccd1 vccd1 sky130_fd_sc_hd__fill_2
X_10190_ FPGA_INST.cell3.SB0.route_sel\[94\] FPGA_INST.cell3.SB0.route_sel\[95\] net274
+ vssd1 vssd1 vccd1 vccd1 _01071_ sky130_fd_sc_hd__mux2_1
XFILLER_2_6 vccd1 vssd1 vccd1 vssd1 sky130_ef_sc_hd__decap_40_12
XTAP_TAPCELL_ROW_115_1889 vssd1 vccd1 sky130_fd_sc_hd__tapvpwrvgnd_1
XFILLER_105_466 vssd1 vssd1 vccd1 vccd1 sky130_fd_sc_hd__fill_8
Xfanout341 net349 vssd1 vssd1 vccd1 vccd1 net341 sky130_fd_sc_hd__buf_2
Xfanout330 net332 vssd1 vssd1 vccd1 vccd1 net330 sky130_fd_sc_hd__clkbuf_4
XFILLER_120_458 vssd1 vssd1 vccd1 vccd1 sky130_fd_sc_hd__fill_1
Xfanout374 net379 vssd1 vssd1 vccd1 vccd1 net374 sky130_fd_sc_hd__buf_4
XFILLER_86_350 vssd1 vssd1 vccd1 vccd1 sky130_fd_sc_hd__fill_1
Xfanout363 net381 vssd1 vssd1 vccd1 vccd1 net363 sky130_fd_sc_hd__buf_2
Xfanout352 net355 vssd1 vssd1 vccd1 vccd1 net352 sky130_fd_sc_hd__clkbuf_4
XTAP_TAPCELL_ROW_6_365 vssd1 vccd1 sky130_fd_sc_hd__tapvpwrvgnd_1
XANTENNA_fanout851_X net851 vssd1 vssd1 vccd1 vccd1 sky130_fd_sc_hd__diode_2
XPHY_EDGE_ROW_129_Left_260 vssd1 vssd1 vccd1 vccd1 sky130_fd_sc_hd__decap_3
Xfanout396 FPGA_INST.cell3.CB_0.config_dataA\[11\] vssd1 vssd1 vccd1 vccd1 net396
+ sky130_fd_sc_hd__clkbuf_2
XFILLER_46_203 vssd1 vssd1 vccd1 vccd1 sky130_fd_sc_hd__fill_1
Xfanout385 _01818_ vssd1 vssd1 vccd1 vccd1 net385 sky130_fd_sc_hd__buf_2
XFILLER_100_182 vccd1 vssd1 vccd1 vssd1 sky130_ef_sc_hd__decap_40_12
XFILLER_74_545 vssd1 vssd1 vccd1 vccd1 sky130_fd_sc_hd__fill_2
XANTENNA__09224__S net352 vssd1 vssd1 vccd1 vccd1 sky130_fd_sc_hd__diode_2
XFILLER_46_247 vssd1 vssd1 vccd1 vccd1 sky130_fd_sc_hd__fill_4
XFILLER_46_225 vssd1 vssd1 vccd1 vccd1 sky130_fd_sc_hd__fill_1
XFILLER_74_578 vssd1 vssd1 vccd1 vccd1 sky130_fd_sc_hd__fill_1
XTAP_TAPCELL_ROW_45_916 vssd1 vccd1 sky130_fd_sc_hd__tapvpwrvgnd_1
XANTENNA__08916__X FPGA_INST.bus1_0\[13\] vssd1 vssd1 vccd1 vccd1 sky130_fd_sc_hd__diode_2
X_11713_ net919 _01059_ net703 vssd1 vssd1 vccd1 vccd1 FPGA_INST.cell3.SB0.route_sel\[83\]
+ sky130_fd_sc_hd__dfstp_1
X_11644_ net855 _00990_ net640 vssd1 vssd1 vccd1 vccd1 FPGA_INST.cell3.SB0.route_sel\[14\]
+ sky130_fd_sc_hd__dfstp_1
XFILLER_42_475 vssd1 vssd1 vccd1 vccd1 sky130_fd_sc_hd__fill_1
XFILLER_52_62 vssd1 vssd1 vccd1 vccd1 sky130_fd_sc_hd__fill_1
Xinput27 gpio_in[33] vssd1 vssd1 vccd1 vccd1 net27 sky130_fd_sc_hd__clkbuf_2
Xinput16 gpio_in[23] vssd1 vssd1 vccd1 vccd1 net16 sky130_fd_sc_hd__buf_2
X_11575_ net752 _00925_ net537 vssd1 vssd1 vccd1 vccd1 FPGA_INST.cell0.CB_0.config_dataB\[19\]
+ sky130_fd_sc_hd__dfstp_1
X_10526_ FPGA_INST.cell2.SB0.route_sel\[98\] FPGA_INST.cell2.SB0.route_sel\[99\] net245
+ vssd1 vssd1 vccd1 vccd1 _01405_ sky130_fd_sc_hd__mux2_1
XFILLER_109_783 vssd1 vssd1 vccd1 vccd1 sky130_fd_sc_hd__fill_1
XFILLER_6_365 vssd1 vssd1 vccd1 vccd1 sky130_fd_sc_hd__fill_2
X_10457_ FPGA_INST.cell2.SB0.route_sel\[29\] FPGA_INST.cell2.SB0.route_sel\[30\] net192
+ vssd1 vssd1 vccd1 vccd1 _01336_ sky130_fd_sc_hd__mux2_1
X_10388_ FPGA_INST.cell3.LE_1A.config_data\[7\] FPGA_INST.cell3.LE_1A.config_data\[6\]
+ net375 vssd1 vssd1 vccd1 vccd1 _01267_ sky130_fd_sc_hd__mux2_1
XTAP_TAPCELL_ROW_90_1539 vssd1 vccd1 sky130_fd_sc_hd__tapvpwrvgnd_1
XANTENNA__06568__A2 _02840_ vssd1 vssd1 vccd1 vccd1 sky130_fd_sc_hd__diode_2
X_12127_ net938 _01473_ net722 vssd1 vssd1 vccd1 vccd1 FPGA_INST.cell3.CB_0.config_dataB\[14\]
+ sky130_fd_sc_hd__dfstp_1
XFILLER_111_447 vssd1 vssd1 vccd1 vccd1 sky130_fd_sc_hd__fill_1
XFILLER_84_309 vssd1 vssd1 vccd1 vccd1 sky130_fd_sc_hd__fill_4
X_12058_ net859 _01404_ net645 vssd1 vssd1 vccd1 vccd1 FPGA_INST.cell2.SB0.route_sel\[98\]
+ sky130_fd_sc_hd__dfstp_1
XFILLER_65_501 vssd1 vssd1 vccd1 vccd1 sky130_fd_sc_hd__fill_2
X_11009_ net888 _00359_ net672 vssd1 vssd1 vccd1 vccd1 FPGA_INST.cell2.LE_1B.config_data\[15\]
+ sky130_fd_sc_hd__dfrtp_1
XANTENNA__07443__A net89 vssd1 vssd1 vccd1 vccd1 sky130_fd_sc_hd__diode_2
XFILLER_65_589 vssd1 vssd1 vccd1 vccd1 sky130_fd_sc_hd__fill_1
XFILLER_37_269 vssd1 vssd1 vccd1 vccd1 sky130_fd_sc_hd__fill_1
XFILLER_92_397 vssd1 vssd1 vccd1 vccd1 sky130_fd_sc_hd__fill_2
X_06550_ _01796_ _01800_ _01801_ _01799_ FPGA_INST.cell2.CB_1.config_dataA\[6\] net481
+ vssd1 vssd1 vccd1 vccd1 _02826_ sky130_fd_sc_hd__mux4_1
XFILLER_52_228 vssd1 vssd1 vccd1 vccd1 sky130_fd_sc_hd__fill_8
XFILLER_18_472 vssd1 vssd1 vccd1 vccd1 sky130_fd_sc_hd__fill_4
X_05501_ net99 vssd1 vssd1 vccd1 vccd1 _01783_ sky130_fd_sc_hd__inv_2
X_06481_ _02758_ _02757_ _02652_ vssd1 vssd1 vccd1 vccd1 _02759_ sky130_fd_sc_hd__mux2_1
X_05432_ FPGA_INST.cell1.SB0.route_sel\[10\] vssd1 vssd1 vccd1 vccd1 _01714_ sky130_fd_sc_hd__inv_2
X_08220_ net405 net406 vssd1 vssd1 vccd1 vccd1 _04444_ sky130_fd_sc_hd__nor2_1
XFILLER_20_114 vssd1 vssd1 vccd1 vccd1 sky130_fd_sc_hd__fill_2
XANTENNA__12045__SET_B net636 vssd1 vssd1 vccd1 vccd1 sky130_fd_sc_hd__diode_2
XFILLER_20_147 vssd1 vssd1 vccd1 vccd1 sky130_fd_sc_hd__fill_1
XFILLER_20_125 vccd1 vssd1 vccd1 vssd1 sky130_ef_sc_hd__decap_40_12
X_08151_ _04373_ _04376_ _04330_ vssd1 vssd1 vccd1 vccd1 _04377_ sky130_fd_sc_hd__mux2_1
XFILLER_119_514 vssd1 vssd1 vccd1 vccd1 sky130_fd_sc_hd__fill_2
X_05363_ FPGA_INST.cell0.SB0.route_sel\[86\] vssd1 vssd1 vccd1 vccd1 _01645_ sky130_fd_sc_hd__inv_2
X_08082_ net454 _03690_ _04307_ net453 vssd1 vssd1 vccd1 vccd1 _04308_ sky130_fd_sc_hd__o211ai_1
X_07102_ net427 _02030_ _03367_ net426 vssd1 vssd1 vccd1 vccd1 _03368_ sky130_fd_sc_hd__o211a_1
X_05294_ FPGA_INST.cell2.SB0.route_sel\[94\] vssd1 vssd1 vccd1 vccd1 _01576_ sky130_fd_sc_hd__inv_2
X_07033_ net436 _02392_ _03298_ net435 vssd1 vssd1 vccd1 vccd1 _03299_ sky130_fd_sc_hd__o211a_1
XFILLER_115_764 vccd1 vssd1 vccd1 vssd1 sky130_ef_sc_hd__decap_40_12
Xteam_15_966 vssd1 vssd1 vccd1 vccd1 team_15_966/HI gpio_out[3] sky130_fd_sc_hd__conb_1
Xteam_15_955 vssd1 vssd1 vccd1 vccd1 team_15_955/HI gpio_oeb[18] sky130_fd_sc_hd__conb_1
XFILLER_115_797 vssd1 vssd1 vccd1 vccd1 sky130_fd_sc_hd__fill_2
X_08984_ FPGA_INST.cell3.SB0.route_sel\[48\] _01671_ _01672_ FPGA_INST.cell3.SB0.route_sel\[51\]
+ _05162_ vssd1 vssd1 vccd1 vccd1 _05163_ sky130_fd_sc_hd__a221o_1
XANTENNA__06241__B _02092_ vssd1 vssd1 vccd1 vccd1 sky130_fd_sc_hd__diode_2
XFILLER_130_778 vssd1 vssd1 vccd1 vccd1 sky130_fd_sc_hd__fill_4
X_07935_ _04161_ _04162_ vssd1 vssd1 vccd1 vccd1 _04163_ sky130_fd_sc_hd__nor2_1
XFILLER_57_29 vssd1 vssd1 vccd1 vccd1 sky130_fd_sc_hd__fill_4
XFILLER_130_789 vssd1 vssd1 vccd1 vccd1 sky130_fd_sc_hd__fill_1
XANTENNA__07508__A1 net148 vssd1 vssd1 vccd1 vccd1 sky130_fd_sc_hd__diode_2
XTAP_TAPCELL_ROW_3_324 vssd1 vccd1 sky130_fd_sc_hd__tapvpwrvgnd_1
X_07866_ net469 _03889_ vssd1 vssd1 vccd1 vccd1 _04094_ sky130_fd_sc_hd__nand2_1
XFILLER_83_320 vccd1 vssd1 vccd1 vssd1 sky130_ef_sc_hd__decap_40_12
XFILLER_68_394 vssd1 vssd1 vccd1 vccd1 sky130_fd_sc_hd__fill_4
X_09605_ FPGA_INST.cell0.SB0.route_sel\[8\] FPGA_INST.cell0.SB0.route_sel\[9\] net196
+ vssd1 vssd1 vccd1 vccd1 _00514_ sky130_fd_sc_hd__mux2_1
XFILLER_113_57 vssd1 vssd1 vccd1 vccd1 sky130_fd_sc_hd__fill_4
X_07797_ FPGA_INST.cell1.SB0.route_sel\[122\] FPGA_INST.cell1.SB0.route_sel\[123\]
+ _04043_ _04045_ _04034_ vssd1 vssd1 vccd1 vccd1 _04046_ sky130_fd_sc_hd__a311oi_2
X_06817_ _01599_ _03090_ vssd1 vssd1 vccd1 vccd1 _03091_ sky130_fd_sc_hd__nand2_1
XFILLER_28_258 vssd1 vssd1 vccd1 vccd1 sky130_fd_sc_hd__fill_1
XANTENNA_fanout644_A net647 vssd1 vssd1 vccd1 vccd1 sky130_fd_sc_hd__diode_2
X_09536_ FPGA_INST.cell1.LE_0B.config_data\[9\] FPGA_INST.cell1.LE_0B.config_data\[8\]
+ net347 vssd1 vssd1 vccd1 vccd1 _00446_ sky130_fd_sc_hd__mux2_1
XFILLER_71_559 vssd1 vssd1 vccd1 vccd1 sky130_fd_sc_hd__fill_1
X_06748_ net514 net513 vssd1 vssd1 vccd1 vccd1 _03022_ sky130_fd_sc_hd__nor2_1
X_09467_ FPGA_INST.cell1.LEI0.config_data\[13\] FPGA_INST.cell1.LEI0.config_data\[14\]
+ net228 vssd1 vssd1 vccd1 vccd1 _00379_ sky130_fd_sc_hd__mux2_1
Xwire95 FPGA_INST.bus1_0\[1\] vssd1 vssd1 vccd1 vccd1 net95 sky130_fd_sc_hd__clkbuf_2
Xwire73 FPGA_INST.bus1_0\[0\] vssd1 vssd1 vccd1 vccd1 net73 sky130_fd_sc_hd__clkbuf_2
XANTENNA_fanout811_A net843 vssd1 vssd1 vccd1 vccd1 sky130_fd_sc_hd__diode_2
X_06679_ FPGA_INST.cell2.LE_1A.config_data\[13\] FPGA_INST.cell2.LE_1A.config_data\[12\]
+ _02878_ vssd1 vssd1 vccd1 vccd1 _02955_ sky130_fd_sc_hd__mux2_1
X_08418_ FPGA_INST.cell0.LE_1B.config_data\[13\] FPGA_INST.cell0.LE_1B.config_data\[12\]
+ _04574_ vssd1 vssd1 vccd1 vccd1 _04640_ sky130_fd_sc_hd__mux2_1
XANTENNA__06256__X _02536_ vssd1 vssd1 vccd1 vccd1 sky130_fd_sc_hd__diode_2
X_09398_ FPGA_INST.cell2.CB_0.config_dataB\[17\] net487 net357 vssd1 vssd1 vccd1 vccd1
+ _00311_ sky130_fd_sc_hd__mux2_1
XANTENNA__08615__C _04821_ vssd1 vssd1 vccd1 vccd1 sky130_fd_sc_hd__diode_2
X_08349_ FPGA_INST.cell0.CB_1.config_dataB\[3\] FPGA_INST.cell0.CB_1.config_dataB\[2\]
+ FPGA_INST.cell0.CB_1.config_dataB\[4\] _04547_ vssd1 vssd1 vccd1 vccd1 _04571_ sky130_fd_sc_hd__or4bb_2
XANTENNA__08236__A2 _03840_ vssd1 vssd1 vccd1 vccd1 sky130_fd_sc_hd__diode_2
XTAP_TAPCELL_ROW_50_985 vssd1 vccd1 sky130_fd_sc_hd__tapvpwrvgnd_1
XPHY_EDGE_ROW_129_Right_129 vssd1 vssd1 vccd1 vccd1 sky130_fd_sc_hd__decap_3
X_11360_ net818 _00710_ net603 vssd1 vssd1 vccd1 vccd1 FPGA_INST.cell1.LE_1B.config_data\[2\]
+ sky130_fd_sc_hd__dfrtp_1
XTAP_TAPCELL_ROW_117_1918 vssd1 vccd1 sky130_fd_sc_hd__tapvpwrvgnd_1
XANTENNA__07444__B1 net284 vssd1 vssd1 vccd1 vccd1 sky130_fd_sc_hd__diode_2
X_10311_ FPGA_INST.cell3.LEI0.config_data\[25\] FPGA_INST.cell3.LEI0.config_data\[26\]
+ net297 vssd1 vssd1 vccd1 vccd1 _01192_ sky130_fd_sc_hd__mux2_1
XFILLER_118_3 vccd1 vssd1 vccd1 vssd1 sky130_ef_sc_hd__decap_40_12
XANTENNA_fanout899_X net899 vssd1 vssd1 vccd1 vccd1 sky130_fd_sc_hd__diode_2
X_11291_ net836 _00641_ net620 vssd1 vssd1 vccd1 vccd1 FPGA_INST.cell1.CB_0.config_dataA\[8\]
+ sky130_fd_sc_hd__dfstp_1
XTAP_TAPCELL_ROW_76_1350 vssd1 vccd1 sky130_fd_sc_hd__tapvpwrvgnd_1
XFILLER_3_324 vssd1 vssd1 vccd1 vccd1 sky130_fd_sc_hd__fill_2
XFILLER_105_252 vssd1 vssd1 vccd1 vccd1 sky130_fd_sc_hd__fill_4
XFILLER_79_604 vssd1 vssd1 vccd1 vccd1 sky130_fd_sc_hd__fill_2
X_10242_ FPGA_INST.io_south_oeb\[4\] FPGA_INST.io_south_oeb\[6\] net290 vssd1 vssd1
+ vccd1 vccd1 _01123_ sky130_fd_sc_hd__mux2_1
XFILLER_3_357 vssd1 vssd1 vccd1 vccd1 sky130_fd_sc_hd__fill_4
XANTENNA_fanout80_X net80 vssd1 vssd1 vccd1 vccd1 sky130_fd_sc_hd__diode_2
X_10173_ FPGA_INST.cell3.SB0.route_sel\[77\] FPGA_INST.cell3.SB0.route_sel\[78\] net286
+ vssd1 vssd1 vccd1 vccd1 _01054_ sky130_fd_sc_hd__mux2_1
XFILLER_94_618 vssd1 vssd1 vccd1 vccd1 sky130_fd_sc_hd__fill_1
XFILLER_87_681 vssd1 vssd1 vccd1 vccd1 sky130_fd_sc_hd__fill_1
Xfanout182 net183 vssd1 vssd1 vccd1 vccd1 net182 sky130_fd_sc_hd__clkbuf_4
Xfanout171 _01873_ vssd1 vssd1 vccd1 vccd1 net171 sky130_fd_sc_hd__clkbuf_4
Xfanout160 _02175_ vssd1 vssd1 vccd1 vccd1 net160 sky130_fd_sc_hd__buf_2
XANTENNA__08172__A1 _03639_ vssd1 vssd1 vccd1 vccd1 sky130_fd_sc_hd__diode_2
XANTENNA__08172__B2 _03604_ vssd1 vssd1 vccd1 vccd1 sky130_fd_sc_hd__diode_2
Xfanout193 net194 vssd1 vssd1 vccd1 vccd1 net193 sky130_fd_sc_hd__clkbuf_2
XFILLER_19_225 vssd1 vssd1 vccd1 vccd1 sky130_fd_sc_hd__fill_1
XFILLER_19_258 vssd1 vssd1 vccd1 vccd1 sky130_fd_sc_hd__fill_1
X_11627_ net809 FPGA_INST.cfg_error_d\[1\] net595 vssd1 vssd1 vccd1 vccd1 net71 sky130_fd_sc_hd__dfstp_1
XANTENNA__08227__A2 FPGA_INST.bus1_0\[2\] vssd1 vssd1 vccd1 vccd1 sky130_fd_sc_hd__diode_2
XANTENNA__05511__A FPGA_INST.bus3_2\[6\] vssd1 vssd1 vccd1 vccd1 sky130_fd_sc_hd__diode_2
XANTENNA__06238__A1 net6 vssd1 vssd1 vccd1 vccd1 sky130_fd_sc_hd__diode_2
X_11558_ net757 _00908_ net542 vssd1 vssd1 vccd1 vccd1 FPGA_INST.cell0.CB_0.config_dataB\[2\]
+ sky130_fd_sc_hd__dfstp_1
X_10509_ FPGA_INST.cell2.SB0.route_sel\[81\] FPGA_INST.cell2.SB0.route_sel\[82\] net251
+ vssd1 vssd1 vccd1 vccd1 _01388_ sky130_fd_sc_hd__mux2_1
X_11489_ net746 _00839_ net531 vssd1 vssd1 vccd1 vccd1 FPGA_INST.cell0.LE_1A.config_data\[16\]
+ sky130_fd_sc_hd__dfrtp_1
XFILLER_124_561 vssd1 vssd1 vccd1 vccd1 sky130_fd_sc_hd__fill_4
X_07720_ FPGA_INST.cell1.SB0.route_sel\[106\] FPGA_INST.cell1.SB0.route_sel\[107\]
+ vssd1 vssd1 vccd1 vccd1 _03971_ sky130_fd_sc_hd__nor2_1
X_05981_ net96 net167 net159 _02181_ _01927_ vssd1 vssd1 vccd1 vccd1 _02261_ sky130_fd_sc_hd__o32a_1
XFILLER_84_139 vssd1 vssd1 vccd1 vccd1 sky130_fd_sc_hd__fill_1
XFILLER_38_523 vssd1 vssd1 vccd1 vccd1 sky130_fd_sc_hd__fill_8
X_07651_ FPGA_INST.cell3.SB0.route_sel\[88\] FPGA_INST.cell3.SB0.route_sel\[89\] vssd1
+ vssd1 vccd1 vccd1 _03904_ sky130_fd_sc_hd__nor2_1
XFILLER_92_194 vssd1 vssd1 vccd1 vccd1 sky130_fd_sc_hd__fill_2
X_07582_ FPGA_INST.cell1.SB0.route_sel\[82\] FPGA_INST.cell1.SB0.route_sel\[83\] vssd1
+ vssd1 vccd1 vccd1 _03836_ sky130_fd_sc_hd__nand2_1
XANTENNA__06713__A2 net130 vssd1 vssd1 vccd1 vccd1 sky130_fd_sc_hd__diode_2
X_06602_ _01547_ _02875_ _02877_ _02874_ vssd1 vssd1 vccd1 vccd1 _02878_ sky130_fd_sc_hd__o211a_4
XFILLER_19_781 vssd1 vssd1 vccd1 vccd1 sky130_fd_sc_hd__fill_2
XFILLER_80_367 vssd1 vssd1 vccd1 vccd1 sky130_fd_sc_hd__fill_2
X_09321_ FPGA_INST.cell1.SB0.route_sel\[92\] FPGA_INST.cell1.SB0.route_sel\[93\] net208
+ vssd1 vssd1 vccd1 vccd1 _00234_ sky130_fd_sc_hd__mux2_1
X_06533_ _01582_ FPGA_INST.cell2.SB0.route_sel\[113\] FPGA_INST.cell2.SB0.route_sel\[118\]
+ _01583_ _02808_ vssd1 vssd1 vccd1 vccd1 _02809_ sky130_fd_sc_hd__a221o_1
X_09252_ FPGA_INST.cell1.SB0.route_sel\[24\] FPGA_INST.cell1.SB0.route_sel\[23\] net341
+ vssd1 vssd1 vccd1 vccd1 _00165_ sky130_fd_sc_hd__mux2_1
X_06464_ FPGA_INST.cell2.CB_0.config_dataB\[18\] _02741_ _02738_ vssd1 vssd1 vccd1
+ vccd1 _02742_ sky130_fd_sc_hd__o21a_1
XANTENNA__06802__A_N FPGA_INST.cell2.CB_0.config_data_inA vssd1 vssd1 vccd1 vccd1
+ sky130_fd_sc_hd__diode_2
XFILLER_119_311 vssd1 vssd1 vccd1 vccd1 sky130_fd_sc_hd__fill_2
X_05415_ FPGA_INST.cell1.SB0.route_sel\[26\] vssd1 vssd1 vccd1 vccd1 _01697_ sky130_fd_sc_hd__inv_2
XANTENNA__08218__A2 _03682_ vssd1 vssd1 vccd1 vccd1 sky130_fd_sc_hd__diode_2
X_08203_ FPGA_INST.bus1_0\[8\] FPGA_INST.bus1_0\[10\] FPGA_INST.bus1_0\[9\] FPGA_INST.bus1_0\[11\]
+ FPGA_INST.cell0.CB_1.config_dataA\[6\] net409 vssd1 vssd1 vccd1 vccd1 _04427_ sky130_fd_sc_hd__mux4_1
X_06395_ net497 _02056_ _02672_ net496 vssd1 vssd1 vccd1 vccd1 _02673_ sky130_fd_sc_hd__o211a_1
X_09183_ FPGA_INST.cell2.LE_1A.config_data\[1\] FPGA_INST.cell2.LE_1A.config_data\[0\]
+ net361 vssd1 vssd1 vccd1 vccd1 _00096_ sky130_fd_sc_hd__mux2_1
XFILLER_119_333 vssd1 vssd1 vccd1 vccd1 sky130_fd_sc_hd__fill_2
X_08134_ _03932_ _04337_ _04358_ _04359_ vssd1 vssd1 vccd1 vccd1 _04360_ sky130_fd_sc_hd__a211o_1
X_05346_ FPGA_INST.cell3.SB0.route_sel\[102\] vssd1 vssd1 vccd1 vccd1 _01628_ sky130_fd_sc_hd__inv_2
XFILLER_119_377 vccd1 vssd1 vccd1 vssd1 sky130_ef_sc_hd__decap_40_12
XANTENNA__07977__A1 FPGA_INST.bus3_1\[9\] vssd1 vssd1 vccd1 vccd1 sky130_fd_sc_hd__diode_2
X_08065_ _03932_ _04265_ _04289_ _04290_ vssd1 vssd1 vccd1 vccd1 _04291_ sky130_fd_sc_hd__a211o_1
X_05277_ FPGA_INST.cell2.SB0.route_sel\[47\] vssd1 vssd1 vccd1 vccd1 _01559_ sky130_fd_sc_hd__inv_2
X_07016_ net435 net436 vssd1 vssd1 vccd1 vccd1 _03282_ sky130_fd_sc_hd__and2b_1
XANTENNA_fanout594_A net596 vssd1 vssd1 vccd1 vccd1 sky130_fd_sc_hd__diode_2
XTAP_TAPCELL_ROW_112_1848 vssd1 vccd1 sky130_fd_sc_hd__tapvpwrvgnd_1
XFILLER_103_723 vssd1 vssd1 vccd1 vccd1 sky130_fd_sc_hd__fill_4
XTAP_TAPCELL_ROW_58_1091 vssd1 vccd1 sky130_fd_sc_hd__tapvpwrvgnd_1
XANTENNA__07067__B _02070_ vssd1 vssd1 vccd1 vccd1 sky130_fd_sc_hd__diode_2
XFILLER_124_45 vssd1 vssd1 vccd1 vccd1 sky130_fd_sc_hd__fill_2
X_08967_ _03787_ _05151_ vssd1 vssd1 vccd1 vccd1 FPGA_INST.bus3_1\[8\] sky130_fd_sc_hd__and2_2
XTAP_TAPCELL_ROW_71_1280 vssd1 vccd1 sky130_fd_sc_hd__tapvpwrvgnd_1
XFILLER_124_89 vssd1 vssd1 vccd1 vccd1 sky130_fd_sc_hd__fill_2
X_08898_ FPGA_INST.cell3.LE_0B.config_data\[10\] FPGA_INST.cell3.LE_0B.config_data\[11\]
+ _05032_ vssd1 vssd1 vccd1 vccd1 _05105_ sky130_fd_sc_hd__mux2_1
X_07918_ net151 net144 net149 net142 FPGA_INST.cell1.LEI0.config_data\[0\] FPGA_INST.cell1.LEI0.config_data\[1\]
+ vssd1 vssd1 vccd1 vccd1 _04146_ sky130_fd_sc_hd__mux4_1
XFILLER_84_27 vssd1 vssd1 vccd1 vccd1 sky130_fd_sc_hd__fill_1
XFILLER_68_191 vssd1 vssd1 vccd1 vccd1 sky130_fd_sc_hd__fill_1
X_07849_ net136 _04078_ _02442_ vssd1 vssd1 vccd1 vccd1 net45 sky130_fd_sc_hd__mux2_1
X_10860_ net801 _00210_ net586 vssd1 vssd1 vccd1 vccd1 FPGA_INST.cell1.SB0.route_sel\[69\]
+ sky130_fd_sc_hd__dfstp_1
XANTENNA__06704__A2 FPGA_INST.bus3_2\[2\] vssd1 vssd1 vccd1 vccd1 sky130_fd_sc_hd__diode_2
XFILLER_56_386 vssd1 vssd1 vccd1 vccd1 sky130_fd_sc_hd__fill_4
XFILLER_56_375 vssd1 vssd1 vccd1 vccd1 sky130_fd_sc_hd__fill_2
XANTENNA_fanout647_X net647 vssd1 vssd1 vccd1 vccd1 sky130_fd_sc_hd__diode_2
X_09519_ FPGA_INST.cell1.LE_0A.config_data\[15\] FPGA_INST.cell1.LE_0A.config_data\[14\]
+ net345 vssd1 vssd1 vccd1 vccd1 _00430_ sky130_fd_sc_hd__mux2_1
XANTENNA__07811__A FPGA_INST.cell3.SB0.route_sel\[125\] vssd1 vssd1 vccd1 vccd1 sky130_fd_sc_hd__diode_2
XFILLER_25_762 vssd1 vssd1 vccd1 vccd1 sky130_fd_sc_hd__fill_2
XANTENNA__11106__Q FPGA_INST.cell1.LE_0B.reset_mode vssd1 vssd1 vccd1 vccd1 sky130_fd_sc_hd__diode_2
X_10791_ net812 _00141_ net597 vssd1 vssd1 vccd1 vccd1 FPGA_INST.cell1.SB0.route_sel\[0\]
+ sky130_fd_sc_hd__dfstp_2
XTAP_TAPCELL_ROW_123_1999 vssd1 vccd1 sky130_fd_sc_hd__tapvpwrvgnd_1
X_11412_ net741 _00762_ net527 vssd1 vssd1 vccd1 vccd1 FPGA_INST.cell0.LEI0.config_data\[33\]
+ sky130_fd_sc_hd__dfrtp_1
X_11343_ net804 _00693_ net589 vssd1 vssd1 vccd1 vccd1 FPGA_INST.cell1.CB_1.config_dataA\[10\]
+ sky130_fd_sc_hd__dfstp_1
XFILLER_3_110 vssd1 vssd1 vccd1 vccd1 sky130_fd_sc_hd__fill_2
X_11274_ net789 _00624_ net574 vssd1 vssd1 vccd1 vccd1 FPGA_INST.cell0.SB0.route_sel\[119\]
+ sky130_fd_sc_hd__dfstp_1
XFILLER_79_423 vssd1 vssd1 vccd1 vccd1 sky130_fd_sc_hd__fill_1
X_10225_ FPGA_INST.io_west_oeb\[2\] FPGA_INST.io_west_oeb\[4\] net291 vssd1 vssd1
+ vccd1 vccd1 _01106_ sky130_fd_sc_hd__mux2_1
X_10156_ FPGA_INST.cell3.SB0.route_sel\[61\] FPGA_INST.cell3.SB0.route_sel\[60\] net365
+ vssd1 vssd1 vccd1 vccd1 _01037_ sky130_fd_sc_hd__mux2_1
XTAP_TAPCELL_ROW_89_1530 vssd1 vccd1 sky130_fd_sc_hd__tapvpwrvgnd_1
XFILLER_66_139 vssd1 vssd1 vccd1 vccd1 sky130_fd_sc_hd__fill_1
X_10087_ FPGA_INST.cell0.LE_1B.config_data\[11\] FPGA_INST.cell0.LE_1B.config_data\[12\]
+ net173 vssd1 vssd1 vccd1 vccd1 _00968_ sky130_fd_sc_hd__mux2_1
XFILLER_74_183 vssd1 vssd1 vccd1 vccd1 sky130_fd_sc_hd__fill_1
XFILLER_62_301 vssd1 vssd1 vccd1 vccd1 sky130_fd_sc_hd__fill_4
XFILLER_74_194 vssd1 vssd1 vccd1 vccd1 sky130_fd_sc_hd__fill_2
XANTENNA__09412__S net362 vssd1 vssd1 vccd1 vccd1 sky130_fd_sc_hd__diode_2
XFILLER_35_559 vssd1 vssd1 vccd1 vccd1 sky130_fd_sc_hd__fill_1
X_10989_ net859 _00339_ net645 vssd1 vssd1 vccd1 vccd1 FPGA_INST.cell2.CB_1.config_dataA\[20\]
+ sky130_fd_sc_hd__dfstp_1
XFILLER_50_518 vssd1 vssd1 vccd1 vccd1 sky130_fd_sc_hd__fill_4
XFILLER_16_784 vssd1 vssd1 vccd1 vccd1 sky130_fd_sc_hd__fill_1
XANTENNA__07656__B1 net78 vssd1 vssd1 vccd1 vccd1 sky130_fd_sc_hd__diode_2
XANTENNA__06459__A1 net30 vssd1 vssd1 vccd1 vccd1 sky130_fd_sc_hd__diode_2
XTAP_TAPCELL_ROW_33_738 vssd1 vccd1 sky130_fd_sc_hd__tapvpwrvgnd_1
XTAP_TAPCELL_ROW_33_749 vssd1 vccd1 sky130_fd_sc_hd__tapvpwrvgnd_1
XTAP_TAPCELL_ROW_13_462 vssd1 vccd1 sky130_fd_sc_hd__tapvpwrvgnd_1
XFILLER_31_798 vssd1 vssd1 vccd1 vccd1 sky130_fd_sc_hd__fill_1
X_06180_ _02452_ _02459_ _02453_ _02451_ vssd1 vssd1 vccd1 vccd1 _02460_ sky130_fd_sc_hd__a211oi_2
XANTENNA__09000__X FPGA_INST.bus2_0\[4\] vssd1 vssd1 vccd1 vccd1 sky130_fd_sc_hd__diode_2
Xfanout907 net911 vssd1 vssd1 vccd1 vccd1 net907 sky130_fd_sc_hd__buf_1
X_09870_ net736 _03242_ vssd1 vssd1 vccd1 vccd1 _05218_ sky130_fd_sc_hd__nand2_1
Xfanout918 net947 vssd1 vssd1 vccd1 vccd1 net918 sky130_fd_sc_hd__buf_2
X_08821_ FPGA_INST.cell3.CB_0.config_dataB\[3\] FPGA_INST.cell3.CB_0.config_dataB\[2\]
+ FPGA_INST.cell3.CB_0.config_dataB\[4\] vssd1 vssd1 vccd1 vccd1 _05028_ sky130_fd_sc_hd__or3b_1
Xfanout929 net930 vssd1 vssd1 vccd1 vccd1 net929 sky130_fd_sc_hd__clkbuf_2
XANTENNA__11554__CLK net772 vssd1 vssd1 vccd1 vccd1 sky130_fd_sc_hd__diode_2
XFILLER_100_715 vssd1 vssd1 vccd1 vccd1 sky130_fd_sc_hd__fill_2
XTAP_TAPCELL_ROW_127_2055 vssd1 vccd1 sky130_fd_sc_hd__tapvpwrvgnd_1
X_08752_ FPGA_INST.cell3.LE_0A.config_data\[1\] FPGA_INST.cell3.LE_0A.config_data\[0\]
+ _04860_ vssd1 vssd1 vccd1 vccd1 _04961_ sky130_fd_sc_hd__mux2_1
X_05964_ _02236_ _02242_ _02243_ _02238_ vssd1 vssd1 vccd1 vccd1 _02244_ sky130_fd_sc_hd__a31o_1
XTAP_TAPCELL_ROW_127_2066 vssd1 vccd1 sky130_fd_sc_hd__tapvpwrvgnd_1
X_08683_ FPGA_INST.cell3.LE_0A.config_data\[7\] FPGA_INST.cell3.LE_0A.config_data\[6\]
+ _04860_ vssd1 vssd1 vccd1 vccd1 _04892_ sky130_fd_sc_hd__mux2_1
X_07703_ _03453_ _03912_ vssd1 vssd1 vccd1 vccd1 _03954_ sky130_fd_sc_hd__nand2_1
XANTENNA__07895__A0 FPGA_INST.bus3_1\[4\] vssd1 vssd1 vccd1 vccd1 sky130_fd_sc_hd__diode_2
X_07634_ FPGA_INST.cell1.SB0.route_sel\[90\] FPGA_INST.cell1.SB0.route_sel\[91\] vssd1
+ vssd1 vccd1 vccd1 _03887_ sky130_fd_sc_hd__nor2_1
X_05895_ FPGA_INST.cell0.CB_0.config_dataB\[23\] FPGA_INST.cell0.CB_0.config_dataB\[22\]
+ vssd1 vssd1 vccd1 vccd1 _02175_ sky130_fd_sc_hd__nand2b_1
XFILLER_80_131 vssd1 vssd1 vccd1 vccd1 sky130_fd_sc_hd__fill_2
X_07565_ FPGA_INST.cell3.SB0.route_sel\[74\] FPGA_INST.cell3.SB0.route_sel\[75\] _03813_
+ _03817_ _03819_ vssd1 vssd1 vccd1 vccd1 _03820_ sky130_fd_sc_hd__a41o_1
XANTENNA_fanout342_A net349 vssd1 vssd1 vccd1 vccd1 sky130_fd_sc_hd__diode_2
XFILLER_80_175 vssd1 vssd1 vccd1 vccd1 sky130_fd_sc_hd__fill_2
X_07496_ net154 _03746_ vssd1 vssd1 vccd1 vccd1 _03752_ sky130_fd_sc_hd__and2b_1
X_09304_ FPGA_INST.cell1.SB0.route_sel\[75\] FPGA_INST.cell1.SB0.route_sel\[76\] net206
+ vssd1 vssd1 vccd1 vccd1 _00217_ sky130_fd_sc_hd__mux2_1
XFILLER_22_721 vssd1 vssd1 vccd1 vccd1 sky130_fd_sc_hd__fill_4
X_06516_ _01560_ FPGA_INST.cell2.SB0.route_sel\[49\] FPGA_INST.cell2.SB0.route_sel\[54\]
+ _01561_ _02791_ vssd1 vssd1 vccd1 vccd1 _02792_ sky130_fd_sc_hd__a221o_1
X_09235_ FPGA_INST.cell1.SB0.route_sel\[7\] FPGA_INST.cell1.SB0.route_sel\[6\] net340
+ vssd1 vssd1 vccd1 vccd1 _00148_ sky130_fd_sc_hd__mux2_1
X_06447_ _02689_ _02724_ _02652_ vssd1 vssd1 vccd1 vccd1 _02725_ sky130_fd_sc_hd__mux2_1
XANTENNA_fanout130_X net130 vssd1 vssd1 vccd1 vccd1 sky130_fd_sc_hd__diode_2
XFILLER_22_798 vssd1 vssd1 vccd1 vccd1 sky130_fd_sc_hd__fill_1
XFILLER_119_163 vssd1 vssd1 vccd1 vccd1 sky130_fd_sc_hd__fill_2
X_06378_ FPGA_INST.cell2.CB_0.config_dataB\[1\] net498 vssd1 vssd1 vccd1 vccd1 _02656_
+ sky130_fd_sc_hd__nor2_2
X_09166_ FPGA_INST.cell2.LE_0B.config_data\[7\] FPGA_INST.cell2.LE_0B.config_data\[6\]
+ net358 vssd1 vssd1 vccd1 vccd1 _00080_ sky130_fd_sc_hd__mux2_1
X_08117_ FPGA_INST.cell1.CB_0.config_dataB\[18\] _04342_ vssd1 vssd1 vccd1 vccd1 _04343_
+ sky130_fd_sc_hd__nor2_1
XFILLER_79_27 vssd1 vssd1 vccd1 vccd1 sky130_fd_sc_hd__fill_4
X_05329_ FPGA_INST.cell3.SB0.route_sel\[116\] vssd1 vssd1 vccd1 vccd1 _01611_ sky130_fd_sc_hd__inv_2
X_09097_ FPGA_INST.cell2.LEI0.config_data\[12\] FPGA_INST.cell2.LEI0.config_data\[11\]
+ net361 vssd1 vssd1 vccd1 vccd1 _00013_ sky130_fd_sc_hd__mux2_1
X_08048_ net460 _03690_ _04273_ net459 vssd1 vssd1 vccd1 vccd1 _04274_ sky130_fd_sc_hd__o211a_1
XANTENNA__08375__A1 _03604_ vssd1 vssd1 vccd1 vccd1 sky130_fd_sc_hd__diode_2
XANTENNA__08375__B2 _03639_ vssd1 vssd1 vccd1 vccd1 sky130_fd_sc_hd__diode_2
XFILLER_0_113 vccd1 vssd1 vccd1 vssd1 sky130_ef_sc_hd__decap_40_12
X_10010_ FPGA_INST.cell0.CB_0.config_dataA\[9\] net430 net194 vssd1 vssd1 vccd1 vccd1
+ _00891_ sky130_fd_sc_hd__mux2_1
XFILLER_130_361 vssd1 vssd1 vccd1 vccd1 sky130_fd_sc_hd__fill_2
X_09999_ _05244_ _05242_ FPGA_INST.config_bits\[11\] vssd1 vssd1 vccd1 vccd1 _00880_
+ sky130_fd_sc_hd__mux2_1
XFILLER_89_798 vssd1 vssd1 vccd1 vccd1 sky130_fd_sc_hd__fill_1
XANTENNA__08127__A1 FPGA_INST.bus3_1\[9\] vssd1 vssd1 vccd1 vccd1 sky130_fd_sc_hd__diode_2
XANTENNA__09324__A0 FPGA_INST.cell1.SB0.route_sel\[96\] vssd1 vssd1 vccd1 vccd1 sky130_fd_sc_hd__diode_2
XANTENNA__05326__A FPGA_INST.cell0.SB0.config_data_out vssd1 vssd1 vccd1 vccd1 sky130_fd_sc_hd__diode_2
X_11961_ net853 _01307_ net638 vssd1 vssd1 vccd1 vccd1 FPGA_INST.cell2.SB0.route_sel\[1\]
+ sky130_fd_sc_hd__dfstp_1
XANTENNA_fanout931_X net931 vssd1 vssd1 vccd1 vccd1 sky130_fd_sc_hd__diode_2
X_10912_ net828 _00262_ net612 vssd1 vssd1 vccd1 vccd1 FPGA_INST.cell1.SB0.route_sel\[121\]
+ sky130_fd_sc_hd__dfstp_1
X_11892_ net938 _01238_ net722 vssd1 vssd1 vccd1 vccd1 FPGA_INST.cell3.LE_0B.config_data\[0\]
+ sky130_fd_sc_hd__dfrtp_1
XFILLER_71_131 vssd1 vssd1 vccd1 vccd1 sky130_fd_sc_hd__fill_1
XFILLER_44_356 vssd1 vssd1 vccd1 vccd1 sky130_fd_sc_hd__fill_8
X_10843_ net800 _00193_ net585 vssd1 vssd1 vccd1 vccd1 FPGA_INST.cell1.SB0.route_sel\[52\]
+ sky130_fd_sc_hd__dfstp_1
XTAP_TAPCELL_ROW_84_1460 vssd1 vccd1 sky130_fd_sc_hd__tapvpwrvgnd_1
XFILLER_71_153 vccd1 vssd1 vccd1 vssd1 sky130_ef_sc_hd__decap_40_12
XFILLER_44_378 vccd1 vssd1 vccd1 vssd1 sky130_ef_sc_hd__decap_40_12
X_10774_ net923 _00124_ net707 vssd1 vssd1 vccd1 vccd1 FPGA_INST.cell2.CB_1.config_dataB\[8\]
+ sky130_fd_sc_hd__dfstp_1
XANTENNA__07102__A2 _02030_ vssd1 vssd1 vccd1 vccd1 sky130_fd_sc_hd__diode_2
XTAP_TAPCELL_ROW_30_708 vssd1 vccd1 sky130_fd_sc_hd__tapvpwrvgnd_1
XFILLER_13_798 vssd1 vssd1 vccd1 vccd1 sky130_fd_sc_hd__fill_1
XANTENNA__05996__A FPGA_INST.cell2.SB0.route_sel\[32\] vssd1 vssd1 vccd1 vccd1 sky130_fd_sc_hd__diode_2
XFILLER_126_612 vssd1 vssd1 vccd1 vccd1 sky130_fd_sc_hd__fill_1
XTAP_TAPCELL_ROW_10_421 vssd1 vccd1 sky130_fd_sc_hd__tapvpwrvgnd_1
XFILLER_126_645 vssd1 vssd1 vccd1 vccd1 sky130_fd_sc_hd__fill_1
XFILLER_125_111 vssd1 vssd1 vccd1 vccd1 sky130_fd_sc_hd__fill_1
X_11326_ net838 _00676_ net622 vssd1 vssd1 vccd1 vccd1 FPGA_INST.cell1.CB_0.config_dataB\[18\]
+ sky130_fd_sc_hd__dfstp_1
XFILLER_99_507 vssd1 vssd1 vccd1 vccd1 sky130_fd_sc_hd__fill_1
XANTENNA__06613__A1 FPGA_INST.bus3_2\[5\] vssd1 vssd1 vccd1 vccd1 sky130_fd_sc_hd__diode_2
XFILLER_4_430 vssd1 vssd1 vccd1 vccd1 sky130_fd_sc_hd__fill_2
XFILLER_5_57 vssd1 vssd1 vccd1 vccd1 sky130_fd_sc_hd__fill_1
X_11257_ net781 _00607_ net566 vssd1 vssd1 vccd1 vccd1 FPGA_INST.cell0.SB0.route_sel\[102\]
+ sky130_fd_sc_hd__dfstp_1
XFILLER_121_350 vssd1 vssd1 vccd1 vccd1 sky130_fd_sc_hd__fill_4
X_10208_ FPGA_INST.cell3.SB0.route_sel\[112\] FPGA_INST.cell3.SB0.route_sel\[113\]
+ net273 vssd1 vssd1 vccd1 vccd1 _01089_ sky130_fd_sc_hd__mux2_1
XANTENNA__09407__S net362 vssd1 vssd1 vccd1 vccd1 sky130_fd_sc_hd__diode_2
X_11188_ net781 _00538_ net566 vssd1 vssd1 vccd1 vccd1 FPGA_INST.cell0.SB0.route_sel\[33\]
+ sky130_fd_sc_hd__dfstp_1
XFILLER_39_106 vssd1 vssd1 vccd1 vccd1 sky130_fd_sc_hd__fill_4
X_10139_ FPGA_INST.cell3.SB0.route_sel\[43\] FPGA_INST.cell3.SB0.route_sel\[44\] net277
+ vssd1 vssd1 vccd1 vccd1 _01020_ sky130_fd_sc_hd__mux2_1
XFILLER_94_223 vssd1 vssd1 vccd1 vccd1 sky130_fd_sc_hd__fill_1
XFILLER_67_426 vssd1 vssd1 vccd1 vccd1 sky130_fd_sc_hd__fill_1
XFILLER_54_109 vssd1 vssd1 vccd1 vccd1 sky130_fd_sc_hd__fill_1
XTAP_TAPCELL_ROW_38_808 vssd1 vccd1 sky130_fd_sc_hd__tapvpwrvgnd_1
XTAP_TAPCELL_ROW_38_819 vssd1 vccd1 sky130_fd_sc_hd__tapvpwrvgnd_1
XFILLER_48_684 vssd1 vssd1 vccd1 vccd1 sky130_fd_sc_hd__fill_1
XTAP_TAPCELL_ROW_18_532 vssd1 vccd1 sky130_fd_sc_hd__tapvpwrvgnd_1
X_05680_ net135 _01958_ vssd1 vssd1 vccd1 vccd1 _01960_ sky130_fd_sc_hd__nor2_1
XFILLER_90_484 vssd1 vssd1 vccd1 vccd1 sky130_fd_sc_hd__fill_1
XFILLER_50_304 vssd1 vssd1 vccd1 vccd1 sky130_fd_sc_hd__fill_1
X_07350_ _03600_ _03606_ _03609_ FPGA_INST.cell1.SB0.route_sel\[33\] FPGA_INST.cell1.SB0.route_sel\[32\]
+ vssd1 vssd1 vccd1 vccd1 _03610_ sky130_fd_sc_hd__o2111ai_2
XANTENNA__07629__B1 FPGA_INST.bus3_1\[11\] vssd1 vssd1 vccd1 vccd1 sky130_fd_sc_hd__diode_2
XFILLER_62_197 vssd1 vssd1 vccd1 vccd1 sky130_fd_sc_hd__fill_2
X_06301_ net501 _01869_ _02580_ FPGA_INST.cell2.CB_0.config_dataA\[16\] vssd1 vssd1
+ vccd1 vccd1 _02581_ sky130_fd_sc_hd__o211a_1
X_07281_ FPGA_INST.cell3.CB_1.config_dataA\[24\] FPGA_INST.cell3.CB_1.config_dataA\[21\]
+ FPGA_INST.cell3.CB_1.config_dataA\[20\] vssd1 vssd1 vccd1 vccd1 _03542_ sky130_fd_sc_hd__nand3b_4
X_09020_ _01702_ FPGA_INST.cell3.SB0.route_sel\[17\] FPGA_INST.cell3.SB0.route_sel\[22\]
+ FPGA_INST.cell3.SB0.route_sel\[23\] _05186_ vssd1 vssd1 vccd1 vccd1 _05187_ sky130_fd_sc_hd__o221a_1
X_06232_ _02510_ _02511_ _02508_ vssd1 vssd1 vccd1 vccd1 _02512_ sky130_fd_sc_hd__o21a_1
X_06163_ net124 _02441_ vssd1 vssd1 vccd1 vccd1 _02443_ sky130_fd_sc_hd__nand2b_1
XANTENNA__07801__B1 _04049_ vssd1 vssd1 vccd1 vccd1 sky130_fd_sc_hd__diode_2
XANTENNA__10944__CLK net849 vssd1 vssd1 vccd1 vccd1 sky130_fd_sc_hd__diode_2
X_06094_ FPGA_INST.cell2.SB0.route_sel\[29\] FPGA_INST.cell2.SB0.route_sel\[28\] vssd1
+ vssd1 vccd1 vccd1 _02374_ sky130_fd_sc_hd__nand2b_1
Xfanout704 net706 vssd1 vssd1 vccd1 vccd1 net704 sky130_fd_sc_hd__clkbuf_4
Xfanout715 net731 vssd1 vssd1 vccd1 vccd1 net715 sky130_fd_sc_hd__clkbuf_2
XTAP_TAPCELL_ROW_55_1050 vssd1 vccd1 sky130_fd_sc_hd__tapvpwrvgnd_1
XANTENNA__08357__A1 FPGA_INST.bus1_0\[10\] vssd1 vssd1 vccd1 vccd1 sky130_fd_sc_hd__diode_2
X_09922_ FPGA_INST.cell0.LE_1A.config_data\[3\] FPGA_INST.cell0.LE_1A.config_data\[4\]
+ net175 vssd1 vssd1 vccd1 vccd1 _00827_ sky130_fd_sc_hd__mux2_1
Xfanout726 net729 vssd1 vssd1 vccd1 vccd1 net726 sky130_fd_sc_hd__clkbuf_2
Xfanout737 net28 vssd1 vssd1 vccd1 vccd1 net737 sky130_fd_sc_hd__buf_4
XANTENNA__10164__A1 FPGA_INST.cell3.SB0.route_sel\[68\] vssd1 vssd1 vccd1 vccd1 sky130_fd_sc_hd__diode_2
XANTENNA__06368__A0 net14 vssd1 vssd1 vccd1 vccd1 sky130_fd_sc_hd__diode_2
X_09853_ FPGA_INST.cell0.LEI0.config_data\[31\] FPGA_INST.cell0.LEI0.config_data\[32\]
+ net173 vssd1 vssd1 vccd1 vccd1 _00761_ sky130_fd_sc_hd__mux2_1
Xfanout748 net749 vssd1 vssd1 vccd1 vccd1 net748 sky130_fd_sc_hd__buf_1
X_09784_ FPGA_INST.cell1.CB_1.config_dataA\[9\] FPGA_INST.cell1.CB_1.config_dataA\[10\]
+ net212 vssd1 vssd1 vccd1 vccd1 _00693_ sky130_fd_sc_hd__mux2_1
X_08804_ FPGA_INST.cell3.CB_0.config_dataB\[2\] _05002_ _05007_ _05009_ _05010_ vssd1
+ vssd1 vccd1 vccd1 _05011_ sky130_fd_sc_hd__o32a_1
XANTENNA_fanout292_A net295 vssd1 vssd1 vccd1 vccd1 sky130_fd_sc_hd__diode_2
Xfanout759 net762 vssd1 vssd1 vccd1 vccd1 net759 sky130_fd_sc_hd__clkbuf_2
X_08735_ net394 _04781_ vssd1 vssd1 vccd1 vccd1 _04944_ sky130_fd_sc_hd__or2_1
XFILLER_100_578 vssd1 vssd1 vccd1 vccd1 sky130_fd_sc_hd__fill_1
XFILLER_73_407 vssd1 vssd1 vccd1 vccd1 sky130_fd_sc_hd__fill_1
X_06996_ FPGA_INST.cell0.CB_0.config_dataA\[8\] _03256_ _03257_ _03261_ vssd1 vssd1
+ vccd1 vccd1 _03262_ sky130_fd_sc_hd__o31a_1
XANTENNA_fanout557_A net558 vssd1 vssd1 vccd1 vccd1 sky130_fd_sc_hd__diode_2
X_05947_ net116 _01814_ _02173_ _02220_ vssd1 vssd1 vccd1 vccd1 _02227_ sky130_fd_sc_hd__a31o_1
X_08666_ net399 _04781_ net398 vssd1 vssd1 vccd1 vccd1 _04875_ sky130_fd_sc_hd__o21ai_1
XANTENNA__06676__S _02878_ vssd1 vssd1 vccd1 vccd1 sky130_fd_sc_hd__diode_2
X_05878_ _01954_ _02045_ net9 vssd1 vssd1 vccd1 vccd1 _02158_ sky130_fd_sc_hd__a21o_1
XFILLER_121_57 vssd1 vssd1 vccd1 vccd1 sky130_fd_sc_hd__fill_2
X_08597_ _01764_ _04059_ _04800_ _04805_ net400 vssd1 vssd1 vccd1 vccd1 _04806_ sky130_fd_sc_hd__o311a_1
X_07617_ net146 _03548_ _03747_ _03869_ vssd1 vssd1 vccd1 vccd1 _03870_ sky130_fd_sc_hd__a31o_1
XFILLER_121_79 vssd1 vssd1 vccd1 vccd1 sky130_fd_sc_hd__fill_8
XANTENNA_fanout724_A net729 vssd1 vssd1 vccd1 vccd1 sky130_fd_sc_hd__diode_2
X_07548_ FPGA_INST.bus3_1\[9\] _03791_ _03792_ vssd1 vssd1 vccd1 vccd1 _03803_ sky130_fd_sc_hd__a21o_1
XFILLER_53_197 vssd1 vssd1 vccd1 vccd1 sky130_fd_sc_hd__fill_1
XFILLER_41_337 vssd1 vssd1 vccd1 vccd1 sky130_fd_sc_hd__fill_1
XTAP_TAPCELL_ROW_120_1969 vssd1 vccd1 sky130_fd_sc_hd__tapvpwrvgnd_1
XTAP_TAPCELL_ROW_120_1958 vssd1 vccd1 sky130_fd_sc_hd__tapvpwrvgnd_1
XANTENNA__07096__A1 FPGA_INST.bus2_0\[0\] vssd1 vssd1 vccd1 vccd1 sky130_fd_sc_hd__diode_2
X_07479_ FPGA_INST.cell3.CB_0.config_dataB\[23\] FPGA_INST.cell3.CB_0.config_dataB\[22\]
+ _03576_ vssd1 vssd1 vccd1 vccd1 _03736_ sky130_fd_sc_hd__nand3b_1
XPHY_EDGE_ROW_101_Left_232 vssd1 vssd1 vccd1 vccd1 sky130_fd_sc_hd__decap_3
X_09218_ FPGA_INST.cell2.CB_1.config_dataB\[14\] FPGA_INST.cell2.CB_1.config_dataB\[15\]
+ net286 vssd1 vssd1 vccd1 vccd1 _00131_ sky130_fd_sc_hd__mux2_1
X_10490_ FPGA_INST.cell2.SB0.route_sel\[62\] FPGA_INST.cell2.SB0.route_sel\[63\] net238
+ vssd1 vssd1 vccd1 vccd1 _01369_ sky130_fd_sc_hd__mux2_1
X_09149_ FPGA_INST.cell2.LE_0A.config_data\[13\] FPGA_INST.cell2.LE_0A.config_data\[12\]
+ net358 vssd1 vssd1 vccd1 vccd1 _00064_ sky130_fd_sc_hd__mux2_1
X_12160_ net907 _01506_ net691 vssd1 vssd1 vccd1 vccd1 FPGA_INST.cell3.CB_1.config_dataA\[22\]
+ sky130_fd_sc_hd__dfstp_1
XFILLER_123_615 vssd1 vssd1 vccd1 vccd1 sky130_fd_sc_hd__fill_1
X_11111_ net804 _00461_ net589 vssd1 vssd1 vccd1 vccd1 FPGA_INST.cell1.LE_1A.config_data\[2\]
+ sky130_fd_sc_hd__dfrtp_1
XFILLER_89_540 vssd1 vssd1 vccd1 vccd1 sky130_fd_sc_hd__fill_1
X_12091_ net921 _01437_ net705 vssd1 vssd1 vccd1 vccd1 FPGA_INST.cell3.CB_0.config_dataA\[3\]
+ sky130_fd_sc_hd__dfstp_1
XFILLER_110_309 vssd1 vssd1 vccd1 vccd1 sky130_fd_sc_hd__fill_1
X_11042_ net815 _00392_ net600 vssd1 vssd1 vccd1 vccd1 FPGA_INST.cell1.LEI0.config_data\[27\]
+ sky130_fd_sc_hd__dfrtp_1
XFILLER_77_702 vssd1 vssd1 vccd1 vccd1 sky130_fd_sc_hd__fill_1
XANTENNA__09227__S net352 vssd1 vssd1 vccd1 vccd1 sky130_fd_sc_hd__diode_2
XANTENNA__05608__X _01888_ vssd1 vssd1 vccd1 vccd1 sky130_fd_sc_hd__diode_2
XPHY_EDGE_ROW_110_Left_241 vssd1 vssd1 vccd1 vccd1 sky130_fd_sc_hd__decap_3
XANTENNA__07020__A1 FPGA_INST.bus2_0\[14\] vssd1 vssd1 vccd1 vccd1 sky130_fd_sc_hd__diode_2
XANTENNA_input20_A gpio_in[27] vssd1 vssd1 vccd1 vccd1 sky130_fd_sc_hd__diode_2
XANTENNA__08919__X FPGA_INST.bus2_0\[13\] vssd1 vssd1 vccd1 vccd1 sky130_fd_sc_hd__diode_2
XFILLER_76_278 vssd1 vssd1 vccd1 vccd1 sky130_fd_sc_hd__fill_8
X_11944_ net913 _01290_ net697 vssd1 vssd1 vccd1 vccd1 FPGA_INST.cell3.CB_1.config_dataB\[9\]
+ sky130_fd_sc_hd__dfstp_1
XANTENNA__07859__A0 FPGA_INST.bus3_1\[4\] vssd1 vssd1 vccd1 vccd1 sky130_fd_sc_hd__diode_2
XFILLER_91_248 vssd1 vssd1 vccd1 vccd1 sky130_fd_sc_hd__fill_1
XFILLER_44_131 vssd1 vssd1 vccd1 vccd1 sky130_fd_sc_hd__fill_1
XFILLER_44_120 vssd1 vssd1 vccd1 vccd1 sky130_fd_sc_hd__fill_2
X_11875_ net927 _01221_ net711 vssd1 vssd1 vccd1 vccd1 FPGA_INST.cell3.LE_0A.config_data\[5\]
+ sky130_fd_sc_hd__dfrtp_1
XANTENNA__08086__B _03889_ vssd1 vssd1 vccd1 vccd1 sky130_fd_sc_hd__diode_2
X_10826_ net814 _00176_ net599 vssd1 vssd1 vccd1 vccd1 FPGA_INST.cell1.SB0.route_sel\[35\]
+ sky130_fd_sc_hd__dfstp_1
XFILLER_32_315 vssd1 vssd1 vccd1 vccd1 sky130_fd_sc_hd__fill_4
XFILLER_111_90 vssd1 vssd1 vccd1 vccd1 sky130_fd_sc_hd__fill_2
X_10757_ net889 _00107_ net673 vssd1 vssd1 vccd1 vccd1 FPGA_INST.cell2.LE_1A.config_data\[12\]
+ sky130_fd_sc_hd__dfrtp_1
XTAP_TAPCELL_ROW_43_888 vssd1 vccd1 sky130_fd_sc_hd__tapvpwrvgnd_1
XANTENNA__06834__A1 FPGA_INST.bus2_0\[4\] vssd1 vssd1 vccd1 vccd1 sky130_fd_sc_hd__diode_2
X_10688_ net867 _00038_ net651 vssd1 vssd1 vccd1 vccd1 FPGA_INST.cell2.LEI0.config_data\[37\]
+ sky130_fd_sc_hd__dfrtp_1
XTAP_TAPCELL_ROW_97_1640 vssd1 vccd1 sky130_fd_sc_hd__tapvpwrvgnd_1
XFILLER_126_486 vssd1 vssd1 vccd1 vccd1 sky130_fd_sc_hd__fill_4
XFILLER_126_475 vssd1 vssd1 vccd1 vccd1 sky130_fd_sc_hd__fill_1
XFILLER_114_637 vssd1 vssd1 vccd1 vccd1 sky130_fd_sc_hd__fill_1
XANTENNA__10571__S net284 vssd1 vssd1 vccd1 vccd1 sky130_fd_sc_hd__diode_2
X_11309_ net842 _00659_ net626 vssd1 vssd1 vccd1 vccd1 FPGA_INST.cell1.CB_0.config_dataB\[1\]
+ sky130_fd_sc_hd__dfstp_1
XFILLER_5_794 vssd1 vssd1 vccd1 vccd1 sky130_fd_sc_hd__fill_1
XANTENNA__09137__S net350 vssd1 vssd1 vccd1 vccd1 sky130_fd_sc_hd__diode_2
XFILLER_68_757 vssd1 vssd1 vccd1 vccd1 sky130_fd_sc_hd__fill_4
X_06850_ FPGA_INST.bus2_0\[12\] FPGA_INST.bus2_0\[14\] FPGA_INST.bus2_0\[13\] FPGA_INST.bus2_0\[15\]
+ net420 net422 vssd1 vssd1 vccd1 vccd1 _03118_ sky130_fd_sc_hd__mux4_1
XFILLER_95_554 vssd1 vssd1 vccd1 vccd1 sky130_fd_sc_hd__fill_4
X_05801_ _02072_ _02074_ _02080_ vssd1 vssd1 vccd1 vccd1 _02081_ sky130_fd_sc_hd__o21bai_1
XTAP_TAPCELL_ROW_124_2025 vssd1 vccd1 sky130_fd_sc_hd__tapvpwrvgnd_1
XTAP_TAPCELL_ROW_124_2014 vssd1 vccd1 sky130_fd_sc_hd__tapvpwrvgnd_1
XFILLER_83_727 vssd1 vssd1 vccd1 vccd1 sky130_fd_sc_hd__fill_1
X_06781_ FPGA_INST.bus3_2\[8\] FPGA_INST.bus3_2\[10\] FPGA_INST.bus3_2\[9\] FPGA_INST.bus3_2\[11\]
+ net511 net512 vssd1 vssd1 vccd1 vccd1 _03055_ sky130_fd_sc_hd__mux4_1
XFILLER_48_470 vssd1 vssd1 vccd1 vccd1 sky130_fd_sc_hd__fill_2
X_08520_ _04732_ vssd1 vssd1 vccd1 vccd1 _04733_ sky130_fd_sc_hd__inv_2
X_05732_ FPGA_INST.cell0.CB_0.config_dataA\[22\] FPGA_INST.cell0.CB_0.config_dataA\[23\]
+ vssd1 vssd1 vccd1 vccd1 _02012_ sky130_fd_sc_hd__and2b_1
X_08451_ _04668_ vssd1 vssd1 vccd1 vccd1 _04669_ sky130_fd_sc_hd__inv_2
X_05663_ FPGA_INST.cell2.CB_1.config_dataB\[24\] FPGA_INST.cell2.CB_1.config_dataB\[21\]
+ FPGA_INST.cell2.CB_1.config_dataB\[20\] vssd1 vssd1 vccd1 vccd1 _01943_ sky130_fd_sc_hd__or3_2
XANTENNA__06522__A0 _02793_ vssd1 vssd1 vccd1 vccd1 sky130_fd_sc_hd__diode_2
X_07402_ _03486_ _03622_ vssd1 vssd1 vccd1 vccd1 _03661_ sky130_fd_sc_hd__or2_1
XFILLER_23_337 vssd1 vssd1 vccd1 vccd1 sky130_fd_sc_hd__fill_2
XFILLER_50_156 vssd1 vssd1 vccd1 vccd1 sky130_fd_sc_hd__fill_1
X_05594_ net120 net384 _01873_ _01871_ _01817_ vssd1 vssd1 vccd1 vccd1 _01874_ sky130_fd_sc_hd__o32ai_2
X_08382_ FPGA_INST.cell0.LE_1B.config_data\[7\] FPGA_INST.cell0.LE_1B.config_data\[6\]
+ _04574_ vssd1 vssd1 vccd1 vccd1 _04604_ sky130_fd_sc_hd__mux2_1
X_07333_ FPGA_INST.cell1.CB_0.config_dataB\[23\] FPGA_INST.cell1.CB_0.config_dataB\[22\]
+ vssd1 vssd1 vccd1 vccd1 _03593_ sky130_fd_sc_hd__and2b_1
X_07264_ FPGA_INST.cell3.CB_1.config_dataA\[24\] FPGA_INST.cell3.CB_1.config_dataA\[20\]
+ FPGA_INST.cell3.CB_1.config_dataA\[21\] vssd1 vssd1 vccd1 vccd1 _03526_ sky130_fd_sc_hd__or3b_4
XFILLER_31_381 vssd1 vssd1 vccd1 vccd1 sky130_fd_sc_hd__fill_4
X_09003_ _03628_ _05175_ vssd1 vssd1 vccd1 vccd1 FPGA_INST.bus3_1\[4\] sky130_fd_sc_hd__and2_2
XANTENNA__07120__S _03313_ vssd1 vssd1 vccd1 vccd1 sky130_fd_sc_hd__diode_2
X_06215_ net6 _01810_ _02494_ net505 _01531_ vssd1 vssd1 vccd1 vccd1 _02495_ sky130_fd_sc_hd__a221o_1
XANTENNA__06525__A net352 vssd1 vssd1 vccd1 vccd1 sky130_fd_sc_hd__diode_2
XANTENNA_fanout305_A net306 vssd1 vssd1 vccd1 vccd1 sky130_fd_sc_hd__diode_2
X_07195_ FPGA_INST.bus3_1\[1\] _03455_ _03456_ vssd1 vssd1 vccd1 vccd1 _03458_ sky130_fd_sc_hd__a21oi_1
X_06146_ _02416_ _02421_ _02424_ net323 vssd1 vssd1 vccd1 vccd1 _02426_ sky130_fd_sc_hd__a211o_1
X_06077_ _01893_ _02356_ vssd1 vssd1 vccd1 vccd1 _02357_ sky130_fd_sc_hd__nand2_1
Xfanout523 net525 vssd1 vssd1 vccd1 vccd1 net523 sky130_fd_sc_hd__buf_2
Xfanout512 FPGA_INST.cell2.CB_1.config_dataB\[15\] vssd1 vssd1 vccd1 vccd1 net512
+ sky130_fd_sc_hd__buf_2
X_09905_ FPGA_INST.cell0.LE_0B.config_data\[9\] FPGA_INST.cell0.LE_0B.config_data\[10\]
+ net190 vssd1 vssd1 vccd1 vccd1 _00811_ sky130_fd_sc_hd__mux2_1
Xfanout501 FPGA_INST.cell2.CB_0.config_dataA\[15\] vssd1 vssd1 vccd1 vccd1 net501
+ sky130_fd_sc_hd__clkbuf_2
XANTENNA_fanout295_X net295 vssd1 vssd1 vccd1 vccd1 sky130_fd_sc_hd__diode_2
XFILLER_86_521 vssd1 vssd1 vccd1 vccd1 sky130_fd_sc_hd__fill_4
XANTENNA_fanout674_A net675 vssd1 vssd1 vccd1 vccd1 sky130_fd_sc_hd__diode_2
Xfanout545 net547 vssd1 vssd1 vccd1 vccd1 net545 sky130_fd_sc_hd__clkbuf_2
Xfanout556 net558 vssd1 vssd1 vccd1 vccd1 net556 sky130_fd_sc_hd__clkbuf_4
Xfanout534 net628 vssd1 vssd1 vccd1 vccd1 net534 sky130_fd_sc_hd__buf_2
XTAP_TAPCELL_ROW_109_1809 vssd1 vccd1 sky130_fd_sc_hd__tapvpwrvgnd_1
Xfanout589 net596 vssd1 vssd1 vccd1 vccd1 net589 sky130_fd_sc_hd__clkbuf_4
Xfanout578 net581 vssd1 vssd1 vccd1 vccd1 net578 sky130_fd_sc_hd__clkbuf_4
Xfanout567 net575 vssd1 vssd1 vccd1 vccd1 net567 sky130_fd_sc_hd__clkbuf_2
X_09836_ FPGA_INST.cell0.LEI0.config_data\[14\] FPGA_INST.cell0.LEI0.config_data\[15\]
+ net172 vssd1 vssd1 vccd1 vccd1 _00744_ sky130_fd_sc_hd__mux2_1
XANTENNA_fanout841_A net842 vssd1 vssd1 vccd1 vccd1 sky130_fd_sc_hd__diode_2
X_09767_ FPGA_INST.cell1.CB_0.config_dataB\[18\] FPGA_INST.cell1.CB_0.config_dataB\[17\]
+ net346 vssd1 vssd1 vccd1 vccd1 _00676_ sky130_fd_sc_hd__mux2_1
XFILLER_86_587 vssd1 vssd1 vccd1 vccd1 sky130_fd_sc_hd__fill_1
XFILLER_73_204 vssd1 vssd1 vccd1 vccd1 sky130_fd_sc_hd__fill_1
XANTENNA__06761__A0 FPGA_INST.bus3_2\[4\] vssd1 vssd1 vccd1 vccd1 sky130_fd_sc_hd__diode_2
X_06979_ net433 _02191_ _03244_ vssd1 vssd1 vccd1 vccd1 _03245_ sky130_fd_sc_hd__a21o_1
X_08718_ net395 FPGA_INST.cell3.CB_0.config_dataA\[16\] vssd1 vssd1 vccd1 vccd1 _04927_
+ sky130_fd_sc_hd__nor2_1
XANTENNA_fanout939_A net945 vssd1 vssd1 vccd1 vccd1 sky130_fd_sc_hd__diode_2
XTAP_TAPCELL_ROW_68_1241 vssd1 vccd1 sky130_fd_sc_hd__tapvpwrvgnd_1
XTAP_TAPCELL_ROW_68_1230 vssd1 vccd1 sky130_fd_sc_hd__tapvpwrvgnd_1
X_09698_ FPGA_INST.cell0.SB0.route_sel\[101\] FPGA_INST.cell0.SB0.route_sel\[102\]
+ net196 vssd1 vssd1 vccd1 vccd1 _00607_ sky130_fd_sc_hd__mux2_1
X_08649_ FPGA_INST.cell3.LEI0.config_data\[2\] _04857_ vssd1 vssd1 vccd1 vccd1 _04858_
+ sky130_fd_sc_hd__nor2_1
XANTENNA__06513__A0 FPGA_INST.bus3_2\[4\] vssd1 vssd1 vccd1 vccd1 sky130_fd_sc_hd__diode_2
XFILLER_54_473 vssd1 vssd1 vccd1 vccd1 sky130_fd_sc_hd__fill_2
XTAP_TAPCELL_ROW_1_296 vssd1 vccd1 sky130_fd_sc_hd__tapvpwrvgnd_1
X_11660_ net894 _01006_ net678 vssd1 vssd1 vccd1 vccd1 FPGA_INST.cell3.SB0.route_sel\[30\]
+ sky130_fd_sc_hd__dfstp_1
XFILLER_41_134 vssd1 vssd1 vccd1 vccd1 sky130_fd_sc_hd__fill_8
X_10611_ FPGA_INST.cell3.CB_1.config_dataA\[5\] FPGA_INST.cell3.CB_1.config_dataA\[6\]
+ net304 vssd1 vssd1 vccd1 vccd1 _01490_ sky130_fd_sc_hd__mux2_1
XANTENNA__08805__A2 net20 vssd1 vssd1 vccd1 vccd1 sky130_fd_sc_hd__diode_2
XANTENNA__08266__A0 net73 vssd1 vssd1 vccd1 vccd1 sky130_fd_sc_hd__diode_2
X_11591_ net791 _00941_ net576 vssd1 vssd1 vccd1 vccd1 FPGA_INST.cell0.CB_1.config_dataA\[10\]
+ sky130_fd_sc_hd__dfstp_1
XTAP_TAPCELL_ROW_40_836 vssd1 vccd1 sky130_fd_sc_hd__tapvpwrvgnd_1
XFILLER_50_690 vssd1 vssd1 vccd1 vccd1 sky130_fd_sc_hd__fill_1
X_10542_ FPGA_INST.cell2.SB0.route_sel\[114\] FPGA_INST.cell2.SB0.route_sel\[115\]
+ net239 vssd1 vssd1 vccd1 vccd1 _01421_ sky130_fd_sc_hd__mux2_1
XTAP_TAPCELL_ROW_40_847 vssd1 vccd1 sky130_fd_sc_hd__tapvpwrvgnd_1
XTAP_TAPCELL_ROW_20_560 vssd1 vccd1 sky130_fd_sc_hd__tapvpwrvgnd_1
X_10473_ FPGA_INST.cell2.SB0.route_sel\[45\] FPGA_INST.cell2.SB0.route_sel\[46\] net199
+ vssd1 vssd1 vccd1 vccd1 _01352_ sky130_fd_sc_hd__mux2_1
XTAP_TAPCELL_ROW_79_1392 vssd1 vccd1 sky130_fd_sc_hd__tapvpwrvgnd_1
X_12143_ net942 _01489_ net726 vssd1 vssd1 vccd1 vccd1 FPGA_INST.cell3.CB_1.config_dataA\[5\]
+ sky130_fd_sc_hd__dfstp_1
XTAP_TAPCELL_ROW_92_1570 vssd1 vccd1 sky130_fd_sc_hd__tapvpwrvgnd_1
X_12074_ net848 _01420_ net633 vssd1 vssd1 vccd1 vccd1 FPGA_INST.cell2.SB0.route_sel\[114\]
+ sky130_fd_sc_hd__dfstp_1
X_11025_ net813 _00375_ net598 vssd1 vssd1 vccd1 vccd1 FPGA_INST.cell1.LEI0.config_data\[10\]
+ sky130_fd_sc_hd__dfrtp_1
XFILLER_110_139 vssd1 vssd1 vccd1 vccd1 sky130_fd_sc_hd__fill_1
XFILLER_77_521 vssd1 vssd1 vccd1 vccd1 sky130_fd_sc_hd__fill_2
XFILLER_49_223 vssd1 vssd1 vccd1 vccd1 sky130_fd_sc_hd__fill_1
XFILLER_49_201 vssd1 vssd1 vccd1 vccd1 sky130_fd_sc_hd__fill_8
XFILLER_1_285 vssd1 vssd1 vccd1 vccd1 sky130_fd_sc_hd__fill_2
XFILLER_65_749 vssd1 vssd1 vccd1 vccd1 sky130_fd_sc_hd__fill_1
XFILLER_58_790 vssd1 vssd1 vccd1 vccd1 sky130_fd_sc_hd__fill_8
XTAP_TAPCELL_ROW_48_958 vssd1 vccd1 sky130_fd_sc_hd__tapvpwrvgnd_1
XFILLER_73_782 vssd1 vssd1 vccd1 vccd1 sky130_fd_sc_hd__fill_2
XFILLER_17_164 vssd1 vssd1 vccd1 vccd1 sky130_fd_sc_hd__fill_4
X_11927_ net944 _01273_ net728 vssd1 vssd1 vccd1 vccd1 FPGA_INST.cell3.LE_1A.config_data\[13\]
+ sky130_fd_sc_hd__dfrtp_1
XFILLER_60_421 vssd1 vssd1 vccd1 vccd1 sky130_fd_sc_hd__fill_8
XTAP_TAPCELL_ROW_28_671 vssd1 vccd1 sky130_fd_sc_hd__tapvpwrvgnd_1
X_11858_ net932 _01204_ net716 vssd1 vssd1 vccd1 vccd1 FPGA_INST.cell3.LEI0.config_data\[38\]
+ sky130_fd_sc_hd__dfrtp_1
XFILLER_60_443 vssd1 vssd1 vccd1 vccd1 sky130_fd_sc_hd__fill_1
X_10809_ net828 _00159_ net612 vssd1 vssd1 vccd1 vccd1 FPGA_INST.cell1.SB0.route_sel\[18\]
+ sky130_fd_sc_hd__dfstp_1
X_11789_ net889 _01135_ net673 vssd1 vssd1 vccd1 vccd1 FPGA_INST.io_south_oeb\[30\]
+ sky130_fd_sc_hd__dfrtp_1
XFILLER_127_740 vssd1 vssd1 vccd1 vccd1 sky130_fd_sc_hd__fill_1
X_06000_ _01794_ _02277_ _02279_ vssd1 vssd1 vccd1 vccd1 _02280_ sky130_fd_sc_hd__o21ai_1
XANTENNA__08024__A3 FPGA_INST.bus3_1\[15\] vssd1 vssd1 vccd1 vccd1 sky130_fd_sc_hd__diode_2
XFILLER_126_283 vssd1 vssd1 vccd1 vccd1 sky130_fd_sc_hd__fill_4
X_07951_ FPGA_INST.cell1.LEI0.config_data\[24\] net143 vssd1 vssd1 vccd1 vccd1 _04179_
+ sky130_fd_sc_hd__nand2_1
XFILLER_99_178 vccd1 vssd1 vccd1 vssd1 sky130_ef_sc_hd__decap_40_12
XFILLER_99_167 vssd1 vssd1 vccd1 vccd1 sky130_fd_sc_hd__fill_1
X_06902_ _03162_ _03166_ _03168_ _03169_ vssd1 vssd1 vccd1 vccd1 _03170_ sky130_fd_sc_hd__a2bb2o_1
X_07882_ FPGA_INST.cell1.LEI0.config_data\[12\] net143 vssd1 vssd1 vccd1 vccd1 _04110_
+ sky130_fd_sc_hd__nand2_1
XFILLER_101_139 vssd1 vssd1 vccd1 vccd1 sky130_fd_sc_hd__fill_2
XFILLER_95_351 vssd1 vssd1 vccd1 vccd1 sky130_fd_sc_hd__fill_4
X_09621_ FPGA_INST.cell0.SB0.route_sel\[24\] FPGA_INST.cell0.SB0.route_sel\[25\] net195
+ vssd1 vssd1 vccd1 vccd1 _00530_ sky130_fd_sc_hd__mux2_1
X_06833_ FPGA_INST.bus2_0\[6\] FPGA_INST.bus2_0\[7\] net421 vssd1 vssd1 vccd1 vccd1
+ _03101_ sky130_fd_sc_hd__mux2_1
X_09552_ FPGA_INST.cell1.LE_1A.config_data\[1\] FPGA_INST.cell1.LE_1A.config_data\[2\]
+ net212 vssd1 vssd1 vccd1 vccd1 _00461_ sky130_fd_sc_hd__mux2_1
X_06764_ net514 _02793_ _03037_ net513 vssd1 vssd1 vccd1 vccd1 _03038_ sky130_fd_sc_hd__o211a_1
X_08503_ _01601_ FPGA_INST.cell3.SB0.route_sel\[123\] vssd1 vssd1 vccd1 vccd1 _04717_
+ sky130_fd_sc_hd__nand2_1
XFILLER_71_719 vssd1 vssd1 vccd1 vccd1 sky130_fd_sc_hd__fill_8
X_05715_ _01850_ _01993_ vssd1 vssd1 vccd1 vccd1 _01995_ sky130_fd_sc_hd__or2_1
XANTENNA__07299__A1 FPGA_INST.cell1.SB0.route_sel\[31\] vssd1 vssd1 vccd1 vccd1 sky130_fd_sc_hd__diode_2
XANTENNA__07115__S _03313_ vssd1 vssd1 vccd1 vccd1 sky130_fd_sc_hd__diode_2
XFILLER_24_602 vssd1 vssd1 vccd1 vccd1 sky130_fd_sc_hd__fill_1
X_09483_ FPGA_INST.cell1.LEI0.config_data\[29\] FPGA_INST.cell1.LEI0.config_data\[30\]
+ net211 vssd1 vssd1 vccd1 vccd1 _00395_ sky130_fd_sc_hd__mux2_1
XTAP_TAPCELL_ROW_104_1739 vssd1 vccd1 sky130_fd_sc_hd__tapvpwrvgnd_1
XFILLER_63_270 vssd1 vssd1 vccd1 vccd1 sky130_fd_sc_hd__fill_1
XFILLER_62_19 vssd1 vssd1 vccd1 vccd1 sky130_fd_sc_hd__fill_2
X_06695_ _01796_ _01800_ _01801_ _01799_ net519 net520 vssd1 vssd1 vccd1 vccd1 _02969_
+ sky130_fd_sc_hd__mux4_1
XFILLER_63_292 vssd1 vssd1 vccd1 vccd1 sky130_fd_sc_hd__fill_4
X_05646_ net382 net167 net77 vssd1 vssd1 vccd1 vccd1 _01926_ sky130_fd_sc_hd__o21ai_1
X_08434_ _04652_ _01911_ vssd1 vssd1 vccd1 vccd1 FPGA_INST.bus2_0\[15\] sky130_fd_sc_hd__and2b_2
XTAP_TAPCELL_ROW_63_1171 vssd1 vccd1 sky130_fd_sc_hd__tapvpwrvgnd_1
XTAP_TAPCELL_ROW_63_1160 vssd1 vccd1 sky130_fd_sc_hd__tapvpwrvgnd_1
X_08365_ _04578_ _04580_ _04583_ _04586_ vssd1 vssd1 vccd1 vccd1 _04587_ sky130_fd_sc_hd__a22o_1
XFILLER_23_178 vssd1 vssd1 vccd1 vccd1 sky130_fd_sc_hd__fill_4
X_05577_ net485 net486 vssd1 vssd1 vccd1 vccd1 _01857_ sky130_fd_sc_hd__nand2_1
X_07316_ _03435_ _03576_ vssd1 vssd1 vccd1 vccd1 _03577_ sky130_fd_sc_hd__nand2_1
X_08296_ net445 net444 vssd1 vssd1 vccd1 vccd1 _04518_ sky130_fd_sc_hd__nor2_1
XANTENNA__07471__A1 _03716_ vssd1 vssd1 vccd1 vccd1 sky130_fd_sc_hd__diode_2
X_07247_ net150 net140 _03508_ vssd1 vssd1 vccd1 vccd1 _03509_ sky130_fd_sc_hd__mux2_1
X_07178_ _03394_ _03441_ net272 vssd1 vssd1 vccd1 vccd1 _03442_ sky130_fd_sc_hd__o21ai_1
X_06129_ _02406_ _02407_ _02408_ vssd1 vssd1 vccd1 vccd1 _02409_ sky130_fd_sc_hd__a21bo_1
XFILLER_78_307 vssd1 vssd1 vccd1 vccd1 sky130_fd_sc_hd__fill_1
XFILLER_120_415 vssd1 vssd1 vccd1 vccd1 sky130_fd_sc_hd__fill_4
Xfanout331 net332 vssd1 vssd1 vccd1 vccd1 net331 sky130_fd_sc_hd__clkbuf_2
Xfanout320 net325 vssd1 vssd1 vccd1 vccd1 net320 sky130_fd_sc_hd__clkbuf_4
Xfanout375 net377 vssd1 vssd1 vccd1 vccd1 net375 sky130_fd_sc_hd__clkbuf_4
XFILLER_101_640 vssd1 vssd1 vccd1 vccd1 sky130_fd_sc_hd__fill_2
Xfanout364 net380 vssd1 vssd1 vccd1 vccd1 net364 sky130_fd_sc_hd__clkbuf_4
Xfanout342 net349 vssd1 vssd1 vccd1 vccd1 net342 sky130_fd_sc_hd__clkbuf_4
Xfanout353 net355 vssd1 vssd1 vccd1 vccd1 net353 sky130_fd_sc_hd__clkbuf_2
XTAP_TAPCELL_ROW_6_366 vssd1 vccd1 sky130_fd_sc_hd__tapvpwrvgnd_1
XANTENNA__09505__S net344 vssd1 vssd1 vccd1 vccd1 sky130_fd_sc_hd__diode_2
Xfanout386 net387 vssd1 vssd1 vccd1 vccd1 net386 sky130_fd_sc_hd__buf_2
XANTENNA__08723__A1 net19 vssd1 vssd1 vccd1 vccd1 sky130_fd_sc_hd__diode_2
XFILLER_101_673 vssd1 vssd1 vccd1 vccd1 sky130_fd_sc_hd__fill_4
XFILLER_100_150 vssd1 vssd1 vccd1 vccd1 sky130_fd_sc_hd__fill_4
Xfanout397 FPGA_INST.cell3.CB_0.config_dataA\[10\] vssd1 vssd1 vccd1 vccd1 net397
+ sky130_fd_sc_hd__buf_2
X_09819_ net736 _03392_ vssd1 vssd1 vccd1 vccd1 _05217_ sky130_fd_sc_hd__nand2_1
XFILLER_100_194 vssd1 vssd1 vccd1 vccd1 sky130_fd_sc_hd__fill_2
XFILLER_74_568 vssd1 vssd1 vccd1 vccd1 sky130_fd_sc_hd__fill_8
XTAP_TAPCELL_ROW_45_917 vssd1 vccd1 sky130_fd_sc_hd__tapvpwrvgnd_1
XTAP_TAPCELL_ROW_45_906 vssd1 vccd1 sky130_fd_sc_hd__tapvpwrvgnd_1
XFILLER_42_421 vssd1 vssd1 vccd1 vccd1 sky130_fd_sc_hd__fill_4
X_11712_ net919 _01058_ net703 vssd1 vssd1 vccd1 vccd1 FPGA_INST.cell3.SB0.route_sel\[82\]
+ sky130_fd_sc_hd__dfstp_1
XFILLER_42_454 vssd1 vssd1 vccd1 vccd1 sky130_fd_sc_hd__fill_1
XTAP_TAPCELL_ROW_25_630 vssd1 vccd1 sky130_fd_sc_hd__tapvpwrvgnd_1
X_11643_ net855 _00989_ net640 vssd1 vssd1 vccd1 vccd1 FPGA_INST.cell3.SB0.route_sel\[13\]
+ sky130_fd_sc_hd__dfstp_1
Xinput28 gpio_in[7] vssd1 vssd1 vccd1 vccd1 net28 sky130_fd_sc_hd__buf_2
XFILLER_10_362 vssd1 vssd1 vccd1 vccd1 sky130_fd_sc_hd__fill_2
Xinput17 gpio_in[24] vssd1 vssd1 vccd1 vccd1 net17 sky130_fd_sc_hd__clkbuf_2
X_11574_ net752 _00924_ net537 vssd1 vssd1 vccd1 vccd1 FPGA_INST.cell0.CB_0.config_dataB\[18\]
+ sky130_fd_sc_hd__dfstp_1
XANTENNA__11934__RESET_B net735 vssd1 vssd1 vccd1 vccd1 sky130_fd_sc_hd__diode_2
XFILLER_109_740 vssd1 vssd1 vccd1 vccd1 sky130_fd_sc_hd__fill_1
XANTENNA__08651__Y _04860_ vssd1 vssd1 vccd1 vccd1 sky130_fd_sc_hd__diode_2
X_10525_ FPGA_INST.cell2.SB0.route_sel\[97\] FPGA_INST.cell2.SB0.route_sel\[98\] net247
+ vssd1 vssd1 vccd1 vccd1 _01404_ sky130_fd_sc_hd__mux2_1
XANTENNA__06265__A2 _01869_ vssd1 vssd1 vccd1 vccd1 sky130_fd_sc_hd__diode_2
X_10456_ FPGA_INST.cell2.SB0.route_sel\[28\] FPGA_INST.cell2.SB0.route_sel\[29\] net193
+ vssd1 vssd1 vccd1 vccd1 _01335_ sky130_fd_sc_hd__mux2_1
X_10387_ FPGA_INST.cell3.LE_1A.config_data\[5\] FPGA_INST.cell3.LE_1A.config_data\[6\]
+ net303 vssd1 vssd1 vccd1 vccd1 _01266_ sky130_fd_sc_hd__mux2_1
XFILLER_123_253 vssd1 vssd1 vccd1 vccd1 sky130_fd_sc_hd__fill_1
XANTENNA__05509__A FPGA_INST.cell3.CB_1.le_outA vssd1 vssd1 vccd1 vccd1 sky130_fd_sc_hd__diode_2
X_12126_ net938 _01472_ net722 vssd1 vssd1 vccd1 vccd1 FPGA_INST.cell3.CB_0.config_dataB\[13\]
+ sky130_fd_sc_hd__dfstp_1
XFILLER_111_459 vssd1 vssd1 vccd1 vccd1 sky130_fd_sc_hd__fill_2
X_12057_ net857 _01403_ net642 vssd1 vssd1 vccd1 vccd1 FPGA_INST.cell2.SB0.route_sel\[97\]
+ sky130_fd_sc_hd__dfstp_1
X_11008_ net888 _00358_ net672 vssd1 vssd1 vccd1 vccd1 FPGA_INST.cell2.LE_1B.config_data\[14\]
+ sky130_fd_sc_hd__dfrtp_1
X_06480_ FPGA_INST.cell2.LE_0B.config_data\[1\] FPGA_INST.cell2.LE_0B.config_data\[0\]
+ _02688_ vssd1 vssd1 vccd1 vccd1 _02758_ sky130_fd_sc_hd__mux2_1
X_05500_ FPGA_INST.cell0.CB_0.le_outA vssd1 vssd1 vccd1 vccd1 _01782_ sky130_fd_sc_hd__inv_2
XANTENNA__09003__X FPGA_INST.bus3_1\[4\] vssd1 vssd1 vccd1 vccd1 sky130_fd_sc_hd__diode_2
X_05431_ FPGA_INST.cell3.SB0.route_sel\[14\] vssd1 vssd1 vccd1 vccd1 _01713_ sky130_fd_sc_hd__inv_2
X_08150_ _04375_ _04374_ _04262_ vssd1 vssd1 vccd1 vccd1 _04376_ sky130_fd_sc_hd__mux2_1
XFILLER_20_137 vssd1 vssd1 vccd1 vccd1 sky130_fd_sc_hd__fill_2
XFILLER_119_537 vssd1 vssd1 vccd1 vccd1 sky130_fd_sc_hd__fill_1
X_05362_ FPGA_INST.cell0.SB0.route_sel\[85\] vssd1 vssd1 vccd1 vccd1 _01644_ sky130_fd_sc_hd__inv_2
X_07101_ net427 _02070_ vssd1 vssd1 vccd1 vccd1 _03367_ sky130_fd_sc_hd__nand2_1
X_08081_ net454 _03728_ vssd1 vssd1 vccd1 vccd1 _04307_ sky130_fd_sc_hd__nand2_1
X_05293_ FPGA_INST.cell2.SB0.route_sel\[93\] vssd1 vssd1 vccd1 vccd1 _01575_ sky130_fd_sc_hd__inv_2
X_07032_ net436 _02350_ vssd1 vssd1 vccd1 vccd1 _03298_ sky130_fd_sc_hd__nand2_1
XANTENNA__08402__A0 net75 vssd1 vssd1 vccd1 vccd1 sky130_fd_sc_hd__diode_2
XFILLER_115_776 vssd1 vssd1 vccd1 vccd1 sky130_fd_sc_hd__fill_8
Xteam_15_967 vssd1 vssd1 vccd1 vccd1 team_15_967/HI gpio_out[7] sky130_fd_sc_hd__conb_1
Xteam_15_956 vssd1 vssd1 vccd1 vccd1 team_15_956/HI gpio_oeb[20] sky130_fd_sc_hd__conb_1
X_08983_ FPGA_INST.cell3.SB0.route_sel\[54\] FPGA_INST.cell3.SB0.route_sel\[55\] vssd1
+ vssd1 vccd1 vccd1 _05162_ sky130_fd_sc_hd__nor2_1
XFILLER_87_115 vssd1 vssd1 vccd1 vccd1 sky130_fd_sc_hd__fill_1
X_07934_ _03421_ _04152_ _04153_ _03475_ FPGA_INST.cell1.CB_0.config_dataA\[12\] vssd1
+ vssd1 vccd1 vccd1 _04162_ sky130_fd_sc_hd__a221o_1
X_07865_ _04081_ _04085_ _04092_ vssd1 vssd1 vccd1 vccd1 _04093_ sky130_fd_sc_hd__o21ba_1
XTAP_TAPCELL_ROW_3_325 vssd1 vccd1 sky130_fd_sc_hd__tapvpwrvgnd_1
XANTENNA_fanout372_A net380 vssd1 vssd1 vccd1 vccd1 sky130_fd_sc_hd__diode_2
XFILLER_83_332 vssd1 vssd1 vccd1 vccd1 sky130_fd_sc_hd__fill_4
X_09604_ FPGA_INST.cell0.SB0.route_sel\[8\] FPGA_INST.cell0.SB0.route_sel\[7\] net321
+ vssd1 vssd1 vccd1 vccd1 _00513_ sky130_fd_sc_hd__mux2_1
XFILLER_83_376 vssd1 vssd1 vccd1 vccd1 sky130_fd_sc_hd__fill_1
XFILLER_83_354 vssd1 vssd1 vccd1 vccd1 sky130_fd_sc_hd__fill_8
X_07796_ net148 _03561_ _03926_ _04037_ _04044_ vssd1 vssd1 vccd1 vccd1 _04045_ sky130_fd_sc_hd__o311a_1
X_06816_ _03077_ _03089_ _03082_ vssd1 vssd1 vccd1 vccd1 _03090_ sky130_fd_sc_hd__a21oi_1
X_09535_ FPGA_INST.cell1.LE_0B.config_data\[7\] FPGA_INST.cell1.LE_0B.config_data\[8\]
+ net231 vssd1 vssd1 vccd1 vccd1 _00445_ sky130_fd_sc_hd__mux2_1
X_06747_ net513 net514 vssd1 vssd1 vccd1 vccd1 _03021_ sky130_fd_sc_hd__and2b_1
X_09466_ FPGA_INST.cell1.LEI0.config_data\[12\] FPGA_INST.cell1.LEI0.config_data\[13\]
+ net228 vssd1 vssd1 vccd1 vccd1 _00378_ sky130_fd_sc_hd__mux2_1
XANTENNA__11310__CLK net842 vssd1 vssd1 vccd1 vccd1 sky130_fd_sc_hd__diode_2
X_06678_ _02953_ _02952_ _02849_ vssd1 vssd1 vccd1 vccd1 _02954_ sky130_fd_sc_hd__mux2_1
XFILLER_24_443 vssd1 vssd1 vccd1 vccd1 sky130_fd_sc_hd__fill_1
XFILLER_51_273 vssd1 vssd1 vccd1 vccd1 sky130_fd_sc_hd__fill_4
X_08417_ _04605_ _04638_ _04603_ vssd1 vssd1 vccd1 vccd1 _04639_ sky130_fd_sc_hd__mux2_1
X_05629_ _01904_ _01906_ _01907_ FPGA_INST.cell2.SB0.route_sel\[121\] FPGA_INST.cell2.SB0.route_sel\[120\]
+ vssd1 vssd1 vccd1 vccd1 _01909_ sky130_fd_sc_hd__a32o_1
XANTENNA_fanout804_A net811 vssd1 vssd1 vccd1 vccd1 sky130_fd_sc_hd__diode_2
XFILLER_12_638 vssd1 vssd1 vccd1 vccd1 sky130_fd_sc_hd__fill_2
X_09397_ net487 net488 net357 vssd1 vssd1 vccd1 vccd1 _00310_ sky130_fd_sc_hd__mux2_1
X_08348_ FPGA_INST.cell0.CB_1.config_dataB\[3\] _04558_ _04568_ _04569_ FPGA_INST.cell0.CB_1.config_dataB\[4\]
+ vssd1 vssd1 vccd1 vccd1 _04570_ sky130_fd_sc_hd__a221o_1
XANTENNA_wire73_X net73 vssd1 vssd1 vccd1 vccd1 sky130_fd_sc_hd__diode_2
XTAP_TAPCELL_ROW_50_986 vssd1 vccd1 sky130_fd_sc_hd__tapvpwrvgnd_1
XFILLER_20_660 vssd1 vssd1 vccd1 vccd1 sky130_fd_sc_hd__fill_2
XTAP_TAPCELL_ROW_117_1919 vssd1 vccd1 sky130_fd_sc_hd__tapvpwrvgnd_1
X_08279_ FPGA_INST.cell0.LE_1A.config_data\[4\] FPGA_INST.cell0.LE_1A.config_data\[5\]
+ _04410_ vssd1 vssd1 vccd1 vccd1 _04503_ sky130_fd_sc_hd__mux2_1
X_10310_ FPGA_INST.cell3.LEI0.config_data\[24\] FPGA_INST.cell3.LEI0.config_data\[25\]
+ net282 vssd1 vssd1 vccd1 vccd1 _01191_ sky130_fd_sc_hd__mux2_1
XFILLER_118_570 vssd1 vssd1 vccd1 vccd1 sky130_fd_sc_hd__fill_4
X_11290_ net836 _00640_ net620 vssd1 vssd1 vccd1 vccd1 FPGA_INST.cell1.CB_0.config_dataA\[7\]
+ sky130_fd_sc_hd__dfstp_2
XFILLER_98_48 vssd1 vssd1 vccd1 vccd1 sky130_fd_sc_hd__fill_1
X_10241_ FPGA_INST.io_south_oeb\[2\] FPGA_INST.io_south_oeb\[4\] net289 vssd1 vssd1
+ vccd1 vccd1 _01122_ sky130_fd_sc_hd__mux2_1
XTAP_TAPCELL_ROW_76_1351 vssd1 vccd1 sky130_fd_sc_hd__tapvpwrvgnd_1
XTAP_TAPCELL_ROW_76_1340 vssd1 vccd1 sky130_fd_sc_hd__tapvpwrvgnd_1
XFILLER_3_347 vssd1 vssd1 vccd1 vccd1 sky130_fd_sc_hd__fill_1
XFILLER_120_201 vssd1 vssd1 vccd1 vccd1 sky130_fd_sc_hd__fill_1
X_10172_ FPGA_INST.cell3.SB0.route_sel\[77\] FPGA_INST.cell3.SB0.route_sel\[76\] net373
+ vssd1 vssd1 vccd1 vccd1 _01053_ sky130_fd_sc_hd__mux2_1
XFILLER_78_137 vssd1 vssd1 vccd1 vccd1 sky130_fd_sc_hd__fill_2
Xfanout150 FPGA_INST.cell1.CB_1.le_outA vssd1 vssd1 vccd1 vccd1 net150 sky130_fd_sc_hd__clkbuf_4
XFILLER_87_660 vssd1 vssd1 vccd1 vccd1 sky130_fd_sc_hd__fill_4
Xfanout161 _02016_ vssd1 vssd1 vccd1 vccd1 net161 sky130_fd_sc_hd__buf_2
Xfanout183 net184 vssd1 vssd1 vccd1 vccd1 net183 sky130_fd_sc_hd__clkbuf_4
Xfanout172 net173 vssd1 vssd1 vccd1 vccd1 net172 sky130_fd_sc_hd__clkbuf_4
XFILLER_101_470 vssd1 vssd1 vccd1 vccd1 sky130_fd_sc_hd__fill_4
XFILLER_86_192 vssd1 vssd1 vccd1 vccd1 sky130_fd_sc_hd__fill_1
XFILLER_74_321 vssd1 vssd1 vccd1 vccd1 sky130_fd_sc_hd__fill_4
XANTENNA__08359__B _04040_ vssd1 vssd1 vccd1 vccd1 sky130_fd_sc_hd__diode_2
XFILLER_19_215 vssd1 vssd1 vccd1 vccd1 sky130_fd_sc_hd__fill_4
Xfanout194 net202 vssd1 vssd1 vccd1 vccd1 net194 sky130_fd_sc_hd__clkbuf_4
XFILLER_74_365 vssd1 vssd1 vccd1 vccd1 sky130_fd_sc_hd__fill_1
XFILLER_15_476 vssd1 vssd1 vccd1 vccd1 sky130_fd_sc_hd__fill_2
X_11626_ net809 FPGA_INST.cfg_error_d\[0\] net595 vssd1 vssd1 vccd1 vccd1 net70 sky130_fd_sc_hd__dfstp_1
XANTENNA__08227__A3 FPGA_INST.bus1_0\[3\] vssd1 vssd1 vccd1 vccd1 sky130_fd_sc_hd__diode_2
XANTENNA__05694__B1 FPGA_INST.bus1_0\[13\] vssd1 vssd1 vccd1 vccd1 sky130_fd_sc_hd__diode_2
XFILLER_30_457 vssd1 vssd1 vccd1 vccd1 sky130_fd_sc_hd__fill_4
XFILLER_11_693 vssd1 vssd1 vccd1 vccd1 sky130_fd_sc_hd__fill_1
X_11557_ net757 _00907_ net542 vssd1 vssd1 vccd1 vccd1 FPGA_INST.cell0.CB_0.config_dataB\[1\]
+ sky130_fd_sc_hd__dfstp_1
XFILLER_10_192 vssd1 vssd1 vccd1 vccd1 sky130_fd_sc_hd__fill_4
X_10508_ FPGA_INST.cell2.SB0.route_sel\[80\] FPGA_INST.cell2.SB0.route_sel\[81\] net260
+ vssd1 vssd1 vccd1 vccd1 _01387_ sky130_fd_sc_hd__mux2_1
X_11488_ net746 _00838_ net531 vssd1 vssd1 vccd1 vccd1 FPGA_INST.cell0.LE_1A.config_data\[15\]
+ sky130_fd_sc_hd__dfrtp_1
X_10439_ FPGA_INST.cell2.SB0.route_sel\[12\] FPGA_INST.cell2.SB0.route_sel\[11\] net351
+ vssd1 vssd1 vccd1 vccd1 _01318_ sky130_fd_sc_hd__mux2_1
XFILLER_124_595 vssd1 vssd1 vccd1 vccd1 sky130_fd_sc_hd__fill_1
XFILLER_112_735 vssd1 vssd1 vccd1 vccd1 sky130_fd_sc_hd__fill_1
XFILLER_112_713 vssd1 vssd1 vccd1 vccd1 sky130_fd_sc_hd__fill_1
XANTENNA__07738__A2 _02810_ vssd1 vssd1 vccd1 vccd1 sky130_fd_sc_hd__diode_2
X_12109_ net903 _01455_ net687 vssd1 vssd1 vccd1 vccd1 FPGA_INST.cell3.CB_0.config_dataA\[21\]
+ sky130_fd_sc_hd__dfstp_1
X_05980_ net167 net159 FPGA_INST.bus1_0\[4\] vssd1 vssd1 vccd1 vccd1 _02260_ sky130_fd_sc_hd__o21ai_1
XFILLER_26_3 vssd1 vssd1 vccd1 vccd1 sky130_fd_sc_hd__fill_4
XFILLER_111_289 vssd1 vssd1 vccd1 vccd1 sky130_fd_sc_hd__fill_1
XFILLER_93_663 vssd1 vssd1 vccd1 vccd1 sky130_fd_sc_hd__fill_1
X_07650_ FPGA_INST.cell3.SB0.route_sel\[88\] FPGA_INST.cell3.SB0.route_sel\[89\] _03900_
+ _03902_ net366 vssd1 vssd1 vccd1 vccd1 _03903_ sky130_fd_sc_hd__a311o_2
XFILLER_26_708 vssd1 vssd1 vccd1 vccd1 sky130_fd_sc_hd__fill_4
X_07581_ FPGA_INST.cell1.SB0.route_sel\[80\] FPGA_INST.cell1.SB0.route_sel\[81\] vssd1
+ vssd1 vccd1 vccd1 _03835_ sky130_fd_sc_hd__nand2_1
XFILLER_53_538 vssd1 vssd1 vccd1 vccd1 sky130_fd_sc_hd__fill_1
X_06601_ FPGA_INST.cell2.LEI0.config_data\[8\] _02876_ vssd1 vssd1 vccd1 vccd1 _02877_
+ sky130_fd_sc_hd__nand2b_1
X_09320_ FPGA_INST.cell1.SB0.route_sel\[91\] FPGA_INST.cell1.SB0.route_sel\[92\] net208
+ vssd1 vssd1 vccd1 vccd1 _00233_ sky130_fd_sc_hd__mux2_1
X_06532_ FPGA_INST.cell2.SB0.route_sel\[116\] FPGA_INST.cell2.SB0.route_sel\[117\]
+ vssd1 vssd1 vccd1 vccd1 _02808_ sky130_fd_sc_hd__nor2_1
X_09251_ FPGA_INST.cell1.SB0.route_sel\[23\] FPGA_INST.cell1.SB0.route_sel\[22\] net323
+ vssd1 vssd1 vccd1 vccd1 _00164_ sky130_fd_sc_hd__mux2_1
X_08202_ _03797_ _04413_ _04414_ _03759_ _04425_ vssd1 vssd1 vccd1 vccd1 _04426_ sky130_fd_sc_hd__a221o_1
X_06463_ net6 _02728_ _02740_ _01544_ vssd1 vssd1 vccd1 vccd1 _02741_ sky130_fd_sc_hd__a211o_1
XANTENNA__08572__X _04781_ vssd1 vssd1 vccd1 vccd1 sky130_fd_sc_hd__diode_2
X_05414_ FPGA_INST.cell3.SB0.route_sel\[28\] vssd1 vssd1 vccd1 vccd1 _01696_ sky130_fd_sc_hd__inv_2
X_06394_ net497 _02092_ vssd1 vssd1 vccd1 vccd1 _02672_ sky130_fd_sc_hd__nand2_1
X_09182_ FPGA_INST.cell2.LE_0B.reset_mode FPGA_INST.cell2.LE_1A.config_data\[0\] net257
+ vssd1 vssd1 vccd1 vccd1 _00095_ sky130_fd_sc_hd__mux2_1
X_08133_ _03973_ _04335_ FPGA_INST.cell1.CB_0.config_dataB\[17\] vssd1 vssd1 vccd1
+ vccd1 _04359_ sky130_fd_sc_hd__o21ai_1
XANTENNA__08623__B1 _04831_ vssd1 vssd1 vccd1 vccd1 sky130_fd_sc_hd__diode_2
X_05345_ FPGA_INST.cell3.SB0.route_sel\[101\] vssd1 vssd1 vccd1 vccd1 _01627_ sky130_fd_sc_hd__inv_2
XANTENNA__07426__B2 _03683_ vssd1 vssd1 vccd1 vccd1 sky130_fd_sc_hd__diode_2
XANTENNA_fanout218_A net219 vssd1 vssd1 vccd1 vccd1 sky130_fd_sc_hd__diode_2
X_08064_ _03973_ _04266_ FPGA_INST.cell1.CB_0.config_dataB\[2\] vssd1 vssd1 vccd1
+ vccd1 _04290_ sky130_fd_sc_hd__o21ai_1
XANTENNA__07977__A2 FPGA_INST.bus3_1\[10\] vssd1 vssd1 vccd1 vccd1 sky130_fd_sc_hd__diode_2
XFILLER_119_389 vssd1 vssd1 vccd1 vccd1 sky130_fd_sc_hd__fill_2
XFILLER_108_25 vssd1 vssd1 vccd1 vccd1 sky130_fd_sc_hd__fill_2
X_05276_ FPGA_INST.cell2.SB0.route_sel\[40\] vssd1 vssd1 vccd1 vccd1 _01558_ sky130_fd_sc_hd__inv_2
X_07015_ net436 _01839_ _03280_ net435 vssd1 vssd1 vccd1 vccd1 _03281_ sky130_fd_sc_hd__o211a_1
XFILLER_108_69 vssd1 vssd1 vccd1 vccd1 sky130_fd_sc_hd__fill_2
XTAP_TAPCELL_ROW_112_1849 vssd1 vccd1 sky130_fd_sc_hd__tapvpwrvgnd_1
XFILLER_103_735 vssd1 vssd1 vccd1 vccd1 sky130_fd_sc_hd__fill_1
XFILLER_68_29 vssd1 vssd1 vccd1 vccd1 sky130_fd_sc_hd__fill_4
XTAP_TAPCELL_ROW_58_1092 vssd1 vccd1 sky130_fd_sc_hd__tapvpwrvgnd_1
XFILLER_102_245 vssd1 vssd1 vccd1 vccd1 sky130_fd_sc_hd__fill_1
XFILLER_88_446 vssd1 vssd1 vccd1 vccd1 sky130_fd_sc_hd__fill_4
XANTENNA_fanout587_A net588 vssd1 vssd1 vccd1 vccd1 sky130_fd_sc_hd__diode_2
XFILLER_130_587 vssd1 vssd1 vccd1 vccd1 sky130_fd_sc_hd__fill_1
XFILLER_102_256 vssd1 vssd1 vccd1 vccd1 sky130_fd_sc_hd__fill_1
X_08966_ FPGA_INST.cell3.SB0.route_sel\[64\] _01654_ _01655_ FPGA_INST.cell3.SB0.route_sel\[67\]
+ _05150_ vssd1 vssd1 vccd1 vccd1 _05151_ sky130_fd_sc_hd__a221o_1
XTAP_TAPCELL_ROW_71_1281 vssd1 vccd1 sky130_fd_sc_hd__tapvpwrvgnd_1
XTAP_TAPCELL_ROW_71_1270 vssd1 vccd1 sky130_fd_sc_hd__tapvpwrvgnd_1
XFILLER_69_660 vssd1 vssd1 vccd1 vccd1 sky130_fd_sc_hd__fill_2
XANTENNA__06679__S _02878_ vssd1 vssd1 vccd1 vccd1 sky130_fd_sc_hd__diode_2
X_07917_ FPGA_INST.cell1.CB_0.config_dataA\[3\] _04118_ FPGA_INST.cell1.CB_0.config_dataA\[2\]
+ FPGA_INST.cell1.CB_0.config_dataA\[4\] vssd1 vssd1 vccd1 vccd1 _04145_ sky130_fd_sc_hd__or4b_1
X_08897_ FPGA_INST.cell3.LE_0B.config_data\[8\] FPGA_INST.cell3.LE_0B.config_data\[9\]
+ _05032_ vssd1 vssd1 vccd1 vccd1 _05104_ sky130_fd_sc_hd__mux2_1
XFILLER_68_181 vssd1 vssd1 vccd1 vccd1 sky130_fd_sc_hd__fill_1
XANTENNA__08894__S _05032_ vssd1 vssd1 vccd1 vccd1 sky130_fd_sc_hd__diode_2
XFILLER_56_365 vssd1 vssd1 vccd1 vccd1 sky130_fd_sc_hd__fill_1
XFILLER_17_11 vssd1 vssd1 vccd1 vccd1 sky130_fd_sc_hd__fill_2
XFILLER_17_708 vssd1 vssd1 vccd1 vccd1 sky130_fd_sc_hd__fill_2
X_07848_ _02441_ _02450_ _02443_ vssd1 vssd1 vccd1 vccd1 _04078_ sky130_fd_sc_hd__o21a_1
XANTENNA__06165__A1 net135 vssd1 vssd1 vccd1 vccd1 sky130_fd_sc_hd__diode_2
XANTENNA__06704__A3 FPGA_INST.bus3_2\[3\] vssd1 vssd1 vccd1 vccd1 sky130_fd_sc_hd__diode_2
XFILLER_44_538 vssd1 vssd1 vccd1 vccd1 sky130_fd_sc_hd__fill_1
XFILLER_17_33 vssd1 vssd1 vccd1 vccd1 sky130_fd_sc_hd__fill_2
XANTENNA__05912__A1 net171 vssd1 vssd1 vccd1 vccd1 sky130_fd_sc_hd__diode_2
X_09518_ FPGA_INST.cell1.LE_0A.config_data\[13\] FPGA_INST.cell1.LE_0A.config_data\[14\]
+ net228 vssd1 vssd1 vccd1 vccd1 _00429_ sky130_fd_sc_hd__mux2_1
X_07779_ net81 _03542_ _03907_ _04026_ _04027_ vssd1 vssd1 vccd1 vccd1 _04028_ sky130_fd_sc_hd__o311a_1
XFILLER_71_335 vssd1 vssd1 vccd1 vccd1 sky130_fd_sc_hd__fill_1
X_10790_ net856 _00140_ net641 vssd1 vssd1 vccd1 vccd1 FPGA_INST.cell2.CB_1.config_dataB\[24\]
+ sky130_fd_sc_hd__dfstp_1
XFILLER_25_785 vccd1 vssd1 vccd1 vssd1 sky130_ef_sc_hd__decap_40_12
X_09449_ FPGA_INST.cell2.LE_1B.reset_val FPGA_INST.cell2.LE_1B.edge_mode net363 vssd1
+ vssd1 vccd1 vccd1 _00362_ sky130_fd_sc_hd__mux2_1
XFILLER_24_273 vssd1 vssd1 vccd1 vccd1 sky130_fd_sc_hd__fill_4
XFILLER_130_3 vccd1 vssd1 vccd1 vssd1 sky130_ef_sc_hd__decap_40_12
XFILLER_8_417 vssd1 vssd1 vccd1 vccd1 sky130_fd_sc_hd__fill_2
XFILLER_8_406 vssd1 vssd1 vccd1 vccd1 sky130_fd_sc_hd__fill_2
XANTENNA__05676__B1 net14 vssd1 vssd1 vccd1 vccd1 sky130_fd_sc_hd__diode_2
XFILLER_33_54 vssd1 vssd1 vccd1 vccd1 sky130_fd_sc_hd__fill_2
X_11411_ net741 _00761_ net526 vssd1 vssd1 vccd1 vccd1 FPGA_INST.cell0.LEI0.config_data\[32\]
+ sky130_fd_sc_hd__dfrtp_1
X_11342_ net804 _00692_ net589 vssd1 vssd1 vccd1 vccd1 FPGA_INST.cell1.CB_1.config_dataA\[9\]
+ sky130_fd_sc_hd__dfstp_1
XANTENNA__07968__A2 _03690_ vssd1 vssd1 vccd1 vccd1 sky130_fd_sc_hd__diode_2
XFILLER_125_337 vssd1 vssd1 vccd1 vccd1 sky130_fd_sc_hd__fill_1
XFILLER_106_551 vssd1 vssd1 vccd1 vccd1 sky130_fd_sc_hd__fill_1
X_11273_ net789 _00623_ net574 vssd1 vssd1 vccd1 vccd1 FPGA_INST.cell0.SB0.route_sel\[118\]
+ sky130_fd_sc_hd__dfstp_1
X_10224_ FPGA_INST.io_west_oeb\[0\] FPGA_INST.io_west_oeb\[2\] net286 vssd1 vssd1
+ vccd1 vccd1 _01105_ sky130_fd_sc_hd__mux2_1
X_10155_ FPGA_INST.cell3.SB0.route_sel\[59\] FPGA_INST.cell3.SB0.route_sel\[60\] net273
+ vssd1 vssd1 vccd1 vccd1 _01036_ sky130_fd_sc_hd__mux2_1
XANTENNA__08393__A2 _03840_ vssd1 vssd1 vccd1 vccd1 sky130_fd_sc_hd__diode_2
XFILLER_121_565 vssd1 vssd1 vccd1 vccd1 sky130_fd_sc_hd__fill_2
XTAP_TAPCELL_ROW_89_1531 vssd1 vccd1 sky130_fd_sc_hd__tapvpwrvgnd_1
XFILLER_47_321 vssd1 vssd1 vccd1 vccd1 sky130_fd_sc_hd__fill_2
X_10086_ FPGA_INST.cell0.LE_1B.config_data\[11\] FPGA_INST.cell0.LE_1B.config_data\[10\]
+ net307 vssd1 vssd1 vccd1 vccd1 _00967_ sky130_fd_sc_hd__mux2_1
XFILLER_35_505 vssd1 vssd1 vccd1 vccd1 sky130_fd_sc_hd__fill_4
XFILLER_74_50 vssd1 vssd1 vccd1 vccd1 sky130_fd_sc_hd__fill_4
XFILLER_62_346 vssd1 vssd1 vccd1 vccd1 sky130_fd_sc_hd__fill_1
XFILLER_90_688 vssd1 vssd1 vccd1 vccd1 sky130_fd_sc_hd__fill_2
X_10988_ net860 _00338_ net646 vssd1 vssd1 vccd1 vccd1 FPGA_INST.cell2.CB_1.config_dataA\[19\]
+ sky130_fd_sc_hd__dfstp_1
XTAP_TAPCELL_ROW_33_739 vssd1 vccd1 sky130_fd_sc_hd__tapvpwrvgnd_1
XANTENNA__10574__S net284 vssd1 vssd1 vccd1 vccd1 sky130_fd_sc_hd__diode_2
X_11609_ net743 _00959_ net528 vssd1 vssd1 vccd1 vccd1 FPGA_INST.cell0.LE_1B.config_data\[3\]
+ sky130_fd_sc_hd__dfrtp_1
XTAP_TAPCELL_ROW_13_463 vssd1 vccd1 sky130_fd_sc_hd__tapvpwrvgnd_1
XANTENNA__07959__A2 _03519_ vssd1 vssd1 vccd1 vccd1 sky130_fd_sc_hd__diode_2
XFILLER_112_510 vssd1 vssd1 vccd1 vccd1 sky130_fd_sc_hd__fill_1
XANTENNA__06919__A0 FPGA_INST.bus2_0\[2\] vssd1 vssd1 vccd1 vccd1 sky130_fd_sc_hd__diode_2
Xmax_cap169 _01917_ vssd1 vssd1 vccd1 vccd1 net169 sky130_fd_sc_hd__buf_1
XFILLER_124_381 vssd1 vssd1 vccd1 vccd1 sky130_fd_sc_hd__fill_8
Xfanout908 net909 vssd1 vssd1 vccd1 vccd1 net908 sky130_fd_sc_hd__buf_2
X_08820_ FPGA_INST.cell3.CB_0.config_dataB\[3\] _05011_ _05016_ _05026_ vssd1 vssd1
+ vccd1 vccd1 _05027_ sky130_fd_sc_hd__o22a_1
Xfanout919 net920 vssd1 vssd1 vccd1 vccd1 net919 sky130_fd_sc_hd__clkbuf_2
XANTENNA__07187__A3 _03447_ vssd1 vssd1 vccd1 vccd1 sky130_fd_sc_hd__diode_2
XFILLER_100_705 vssd1 vssd1 vccd1 vccd1 sky130_fd_sc_hd__fill_1
XFILLER_98_777 vssd1 vssd1 vccd1 vccd1 sky130_fd_sc_hd__fill_2
XFILLER_57_107 vssd1 vssd1 vccd1 vccd1 sky130_fd_sc_hd__fill_1
XFILLER_100_749 vssd1 vssd1 vccd1 vccd1 sky130_fd_sc_hd__fill_4
X_08751_ FPGA_INST.cell3.LE_0A.config_data\[3\] FPGA_INST.cell3.LE_0A.config_data\[2\]
+ _04860_ vssd1 vssd1 vccd1 vccd1 _04960_ sky130_fd_sc_hd__mux2_1
X_05963_ net129 _02240_ vssd1 vssd1 vccd1 vccd1 _02243_ sky130_fd_sc_hd__nand2_1
XTAP_TAPCELL_ROW_127_2067 vssd1 vccd1 sky130_fd_sc_hd__tapvpwrvgnd_1
XTAP_TAPCELL_ROW_127_2056 vssd1 vccd1 sky130_fd_sc_hd__tapvpwrvgnd_1
X_08682_ _01768_ _04890_ _04889_ _04884_ vssd1 vssd1 vccd1 vccd1 _04891_ sky130_fd_sc_hd__o211a_1
X_07702_ _03451_ _03911_ vssd1 vssd1 vccd1 vccd1 _03953_ sky130_fd_sc_hd__or2_1
XFILLER_26_505 vssd1 vssd1 vccd1 vccd1 sky130_fd_sc_hd__fill_2
X_05894_ FPGA_INST.cell0.CB_0.config_dataA\[23\] FPGA_INST.cell0.CB_0.config_dataA\[22\]
+ vssd1 vssd1 vccd1 vccd1 _02174_ sky130_fd_sc_hd__nand2b_2
XANTENNA__07895__A1 FPGA_INST.bus3_1\[5\] vssd1 vssd1 vccd1 vccd1 sky130_fd_sc_hd__diode_2
XANTENNA__07471__X _03728_ vssd1 vssd1 vccd1 vccd1 sky130_fd_sc_hd__diode_2
X_07633_ _03881_ _03885_ net329 vssd1 vssd1 vccd1 vccd1 _03886_ sky130_fd_sc_hd__a21oi_1
XFILLER_65_173 vssd1 vssd1 vccd1 vccd1 sky130_fd_sc_hd__fill_2
XANTENNA__06698__A2 _02810_ vssd1 vssd1 vccd1 vccd1 sky130_fd_sc_hd__diode_2
XFILLER_38_365 vccd1 vssd1 vccd1 vssd1 sky130_ef_sc_hd__decap_40_12
XFILLER_80_110 vssd1 vssd1 vccd1 vccd1 sky130_fd_sc_hd__fill_2
XFILLER_65_184 vccd1 vssd1 vccd1 vssd1 sky130_ef_sc_hd__decap_40_12
XFILLER_0_80 vssd1 vssd1 vccd1 vccd1 sky130_fd_sc_hd__fill_4
XFILLER_110_15 vssd1 vssd1 vccd1 vccd1 sky130_fd_sc_hd__fill_2
X_07564_ net83 _03447_ _03775_ _03814_ _03818_ vssd1 vssd1 vccd1 vccd1 _03819_ sky130_fd_sc_hd__o311a_1
XANTENNA__06528__A net352 vssd1 vssd1 vccd1 vccd1 sky130_fd_sc_hd__diode_2
XANTENNA__07123__S _03313_ vssd1 vssd1 vccd1 vccd1 sky130_fd_sc_hd__diode_2
X_07495_ _03399_ _03748_ FPGA_INST.bus3_1\[8\] vssd1 vssd1 vccd1 vccd1 _03751_ sky130_fd_sc_hd__o21ai_1
X_09303_ FPGA_INST.cell1.SB0.route_sel\[74\] FPGA_INST.cell1.SB0.route_sel\[75\] net205
+ vssd1 vssd1 vccd1 vccd1 _00216_ sky130_fd_sc_hd__mux2_1
XFILLER_80_187 vssd1 vssd1 vccd1 vccd1 sky130_fd_sc_hd__fill_2
X_06515_ FPGA_INST.cell2.SB0.route_sel\[53\] FPGA_INST.cell2.SB0.route_sel\[52\] vssd1
+ vssd1 vccd1 vccd1 _02791_ sky130_fd_sc_hd__nor2_1
XANTENNA_fanout335_A net336 vssd1 vssd1 vccd1 vccd1 sky130_fd_sc_hd__diode_2
X_09234_ FPGA_INST.cell1.SB0.route_sel\[5\] FPGA_INST.cell1.SB0.route_sel\[6\] net222
+ vssd1 vssd1 vccd1 vccd1 _00147_ sky130_fd_sc_hd__mux2_1
XPHY_EDGE_ROW_3_Right_3 vssd1 vssd1 vccd1 vccd1 sky130_fd_sc_hd__decap_3
X_06446_ FPGA_INST.cell2.LE_0B.config_data\[7\] FPGA_INST.cell2.LE_0B.config_data\[6\]
+ _02688_ vssd1 vssd1 vccd1 vccd1 _02724_ sky130_fd_sc_hd__mux2_1
X_09165_ FPGA_INST.cell2.LE_0B.config_data\[5\] FPGA_INST.cell2.LE_0B.config_data\[6\]
+ net254 vssd1 vssd1 vccd1 vccd1 _00079_ sky130_fd_sc_hd__mux2_1
X_08116_ _04340_ _04341_ FPGA_INST.cell1.CB_0.config_dataB\[17\] vssd1 vssd1 vccd1
+ vccd1 _04342_ sky130_fd_sc_hd__mux2_1
XANTENNA__09078__A1_N net89 vssd1 vssd1 vccd1 vccd1 sky130_fd_sc_hd__diode_2
X_06377_ FPGA_INST.cell2.CB_0.config_dataB\[1\] net498 vssd1 vssd1 vccd1 vccd1 _02655_
+ sky130_fd_sc_hd__and2b_2
XANTENNA__06534__Y _02810_ vssd1 vssd1 vccd1 vccd1 sky130_fd_sc_hd__diode_2
XFILLER_119_57 vssd1 vssd1 vccd1 vccd1 sky130_fd_sc_hd__fill_1
XFILLER_107_337 vssd1 vssd1 vccd1 vccd1 sky130_fd_sc_hd__fill_1
X_05328_ FPGA_INST.cell3.SB0.route_sel\[114\] vssd1 vssd1 vccd1 vccd1 _01610_ sky130_fd_sc_hd__inv_2
X_09096_ FPGA_INST.cell2.LEI0.config_data\[10\] FPGA_INST.cell2.LEI0.config_data\[11\]
+ net265 vssd1 vssd1 vccd1 vccd1 _00012_ sky130_fd_sc_hd__mux2_1
XFILLER_119_79 vssd1 vssd1 vccd1 vccd1 sky130_fd_sc_hd__fill_2
X_08047_ net460 _03728_ vssd1 vssd1 vccd1 vccd1 _04273_ sky130_fd_sc_hd__nand2_1
X_05259_ FPGA_INST.cell2.CB_0.config_dataB\[12\] vssd1 vssd1 vccd1 vccd1 _01541_ sky130_fd_sc_hd__inv_2
XFILLER_122_329 vssd1 vssd1 vccd1 vccd1 sky130_fd_sc_hd__fill_4
XTAP_TAPCELL_ROW_73_1310 vssd1 vccd1 sky130_fd_sc_hd__tapvpwrvgnd_1
XFILLER_115_381 vssd1 vssd1 vccd1 vccd1 sky130_fd_sc_hd__fill_2
XFILLER_88_210 vssd1 vssd1 vccd1 vccd1 sky130_fd_sc_hd__fill_2
XFILLER_0_125 vssd1 vssd1 vccd1 vccd1 sky130_fd_sc_hd__fill_1
X_09998_ FPGA_INST.config_bits\[10\] FPGA_INST.config_bits\[9\] _05239_ vssd1 vssd1
+ vccd1 vccd1 _05244_ sky130_fd_sc_hd__and3_1
XFILLER_88_265 vssd1 vssd1 vccd1 vccd1 sky130_fd_sc_hd__fill_1
XANTENNA__06386__A1 net5 vssd1 vssd1 vccd1 vccd1 sky130_fd_sc_hd__diode_2
X_08949_ _03866_ _05139_ vssd1 vssd1 vccd1 vccd1 FPGA_INST.bus3_1\[10\] sky130_fd_sc_hd__and2_2
XFILLER_76_438 vssd1 vssd1 vccd1 vccd1 sky130_fd_sc_hd__fill_1
XANTENNA__08127__A2 FPGA_INST.bus3_1\[10\] vssd1 vssd1 vccd1 vccd1 sky130_fd_sc_hd__diode_2
X_11960_ net856 _01306_ net641 vssd1 vssd1 vccd1 vccd1 FPGA_INST.cell2.SB0.route_sel\[0\]
+ sky130_fd_sc_hd__dfstp_1
XFILLER_91_419 vccd1 vssd1 vccd1 vssd1 sky130_ef_sc_hd__decap_40_12
X_10911_ net828 _00261_ net612 vssd1 vssd1 vccd1 vccd1 FPGA_INST.cell1.SB0.route_sel\[120\]
+ sky130_fd_sc_hd__dfstp_1
XFILLER_44_313 vssd1 vssd1 vccd1 vccd1 sky130_fd_sc_hd__fill_1
XANTENNA__07381__X _03640_ vssd1 vssd1 vccd1 vccd1 sky130_fd_sc_hd__diode_2
X_11891_ FPGA_INST.cell3.LE_1A.sel_clk _01237_ net735 vssd1 vssd1 vccd1 vccd1 FPGA_INST.cell3.LE_1A.dff1_out
+ sky130_fd_sc_hd__dfstp_1
X_10842_ net800 _00192_ net585 vssd1 vssd1 vccd1 vccd1 FPGA_INST.cell1.SB0.route_sel\[51\]
+ sky130_fd_sc_hd__dfstp_1
XTAP_TAPCELL_ROW_84_1461 vssd1 vccd1 sky130_fd_sc_hd__tapvpwrvgnd_1
XFILLER_72_699 vssd1 vssd1 vccd1 vccd1 sky130_fd_sc_hd__fill_1
XFILLER_71_165 vssd1 vssd1 vccd1 vccd1 sky130_fd_sc_hd__fill_2
XANTENNA__08835__A0 net22 vssd1 vssd1 vccd1 vccd1 sky130_fd_sc_hd__diode_2
X_10773_ net923 _00123_ net707 vssd1 vssd1 vccd1 vccd1 FPGA_INST.cell2.CB_1.config_dataB\[7\]
+ sky130_fd_sc_hd__dfstp_2
XFILLER_9_726 vssd1 vssd1 vccd1 vccd1 sky130_fd_sc_hd__fill_2
XTAP_TAPCELL_ROW_30_709 vssd1 vccd1 sky130_fd_sc_hd__tapvpwrvgnd_1
XFILLER_8_236 vssd1 vssd1 vccd1 vccd1 sky130_fd_sc_hd__fill_8
XFILLER_40_585 vssd1 vssd1 vccd1 vccd1 sky130_fd_sc_hd__fill_1
XTAP_TAPCELL_ROW_10_422 vssd1 vccd1 sky130_fd_sc_hd__tapvpwrvgnd_1
XANTENNA__09260__A0 FPGA_INST.cell1.SB0.route_sel\[32\] vssd1 vssd1 vccd1 vccd1 sky130_fd_sc_hd__diode_2
XFILLER_60_85 vssd1 vssd1 vccd1 vccd1 sky130_fd_sc_hd__fill_1
XFILLER_125_134 vssd1 vssd1 vccd1 vccd1 sky130_fd_sc_hd__fill_1
X_11325_ net838 _00675_ net622 vssd1 vssd1 vccd1 vccd1 FPGA_INST.cell1.CB_0.config_dataB\[17\]
+ sky130_fd_sc_hd__dfstp_2
XANTENNA__06613__A2 FPGA_INST.bus3_2\[6\] vssd1 vssd1 vccd1 vccd1 sky130_fd_sc_hd__diode_2
XFILLER_5_25 vssd1 vssd1 vccd1 vccd1 sky130_fd_sc_hd__fill_1
XFILLER_125_167 vssd1 vssd1 vccd1 vccd1 sky130_fd_sc_hd__fill_1
X_11256_ net781 _00606_ net566 vssd1 vssd1 vccd1 vccd1 FPGA_INST.cell0.SB0.route_sel\[101\]
+ sky130_fd_sc_hd__dfstp_1
XFILLER_4_475 vssd1 vssd1 vccd1 vccd1 sky130_fd_sc_hd__fill_1
XFILLER_4_453 vccd1 vssd1 vccd1 vssd1 sky130_ef_sc_hd__decap_40_12
X_10207_ FPGA_INST.cell3.SB0.route_sel\[112\] FPGA_INST.cell3.SB0.route_sel\[111\]
+ net364 vssd1 vssd1 vccd1 vccd1 _01088_ sky130_fd_sc_hd__mux2_1
X_11187_ net779 _00537_ net564 vssd1 vssd1 vccd1 vccd1 FPGA_INST.cell0.SB0.route_sel\[32\]
+ sky130_fd_sc_hd__dfstp_1
X_10138_ FPGA_INST.cell3.SB0.route_sel\[42\] FPGA_INST.cell3.SB0.route_sel\[43\] net277
+ vssd1 vssd1 vccd1 vccd1 _01019_ sky130_fd_sc_hd__mux2_1
XFILLER_67_449 vssd1 vssd1 vccd1 vccd1 sky130_fd_sc_hd__fill_4
X_10069_ FPGA_INST.cell0.CB_1.config_dataA\[18\] FPGA_INST.cell0.CB_1.config_dataA\[19\]
+ net208 vssd1 vssd1 vccd1 vccd1 _00950_ sky130_fd_sc_hd__mux2_1
XTAP_TAPCELL_ROW_38_809 vssd1 vccd1 sky130_fd_sc_hd__tapvpwrvgnd_1
XANTENNA__09423__S net354 vssd1 vssd1 vccd1 vccd1 sky130_fd_sc_hd__diode_2
XFILLER_47_151 vccd1 vssd1 vccd1 vssd1 sky130_ef_sc_hd__decap_40_12
XFILLER_35_313 vssd1 vssd1 vccd1 vccd1 sky130_fd_sc_hd__fill_2
XTAP_TAPCELL_ROW_18_533 vssd1 vccd1 sky130_fd_sc_hd__tapvpwrvgnd_1
XFILLER_35_335 vssd1 vssd1 vccd1 vccd1 sky130_fd_sc_hd__fill_1
XFILLER_90_463 vssd1 vssd1 vccd1 vccd1 sky130_fd_sc_hd__fill_4
XFILLER_50_349 vssd1 vssd1 vccd1 vccd1 sky130_fd_sc_hd__fill_2
XFILLER_16_582 vssd1 vssd1 vccd1 vccd1 sky130_fd_sc_hd__fill_1
XFILLER_16_593 vssd1 vssd1 vccd1 vccd1 sky130_fd_sc_hd__fill_1
XFILLER_93_3 vssd1 vssd1 vccd1 vccd1 sky130_fd_sc_hd__fill_8
X_07280_ FPGA_INST.cell3.SB0.route_sel\[24\] FPGA_INST.cell3.SB0.route_sel\[25\] vssd1
+ vssd1 vccd1 vccd1 _03541_ sky130_fd_sc_hd__and2_1
X_06300_ net501 _01914_ vssd1 vssd1 vccd1 vccd1 _02580_ sky130_fd_sc_hd__nand2_1
X_06231_ _02330_ _02505_ _02506_ _02293_ _01530_ vssd1 vssd1 vccd1 vccd1 _02511_ sky130_fd_sc_hd__a221o_1
X_06162_ _02001_ _02368_ vssd1 vssd1 vccd1 vccd1 _02442_ sky130_fd_sc_hd__or2_1
XFILLER_117_657 vssd1 vssd1 vccd1 vccd1 sky130_fd_sc_hd__fill_4
X_06093_ net236 _02365_ _02372_ vssd1 vssd1 vccd1 vccd1 _02373_ sky130_fd_sc_hd__and3_1
X_09921_ FPGA_INST.cell0.LE_1A.config_data\[3\] FPGA_INST.cell0.LE_1A.config_data\[2\]
+ net308 vssd1 vssd1 vccd1 vccd1 _00826_ sky130_fd_sc_hd__mux2_1
Xfanout705 net706 vssd1 vssd1 vccd1 vccd1 net705 sky130_fd_sc_hd__clkbuf_4
XTAP_TAPCELL_ROW_55_1051 vssd1 vccd1 sky130_fd_sc_hd__tapvpwrvgnd_1
XANTENNA__08357__A2 FPGA_INST.bus1_0\[9\] vssd1 vssd1 vccd1 vccd1 sky130_fd_sc_hd__diode_2
Xfanout738 net740 vssd1 vssd1 vccd1 vccd1 net738 sky130_fd_sc_hd__clkbuf_2
Xfanout727 net729 vssd1 vssd1 vccd1 vccd1 net727 sky130_fd_sc_hd__clkbuf_4
Xfanout716 net730 vssd1 vssd1 vccd1 vccd1 net716 sky130_fd_sc_hd__clkbuf_4
XFILLER_98_574 vssd1 vssd1 vccd1 vccd1 sky130_fd_sc_hd__fill_1
XFILLER_58_416 vssd1 vssd1 vccd1 vccd1 sky130_fd_sc_hd__fill_4
X_09852_ FPGA_INST.cell0.LEI0.config_data\[30\] FPGA_INST.cell0.LEI0.config_data\[31\]
+ net172 vssd1 vssd1 vccd1 vccd1 _00760_ sky130_fd_sc_hd__mux2_1
Xfanout749 net790 vssd1 vssd1 vccd1 vccd1 net749 sky130_fd_sc_hd__buf_2
X_09783_ FPGA_INST.cell1.CB_1.config_dataA\[8\] FPGA_INST.cell1.CB_1.config_dataA\[9\]
+ net212 vssd1 vssd1 vccd1 vccd1 _00692_ sky130_fd_sc_hd__mux2_1
X_08803_ _04843_ _05003_ _05005_ _04846_ _01773_ vssd1 vssd1 vccd1 vccd1 _05010_ sky130_fd_sc_hd__a221o_1
XANTENNA_fanout285_A net306 vssd1 vssd1 vccd1 vccd1 sky130_fd_sc_hd__diode_2
XFILLER_105_59 vssd1 vssd1 vccd1 vccd1 sky130_fd_sc_hd__fill_4
X_08734_ net394 _04785_ vssd1 vssd1 vccd1 vccd1 _04943_ sky130_fd_sc_hd__nand2_1
XFILLER_85_246 vssd1 vssd1 vccd1 vccd1 sky130_fd_sc_hd__fill_4
X_06995_ FPGA_INST.cell0.CB_0.config_dataA\[6\] _03258_ _03260_ vssd1 vssd1 vccd1
+ vccd1 _03261_ sky130_fd_sc_hd__a21o_1
XFILLER_39_641 vssd1 vssd1 vccd1 vccd1 sky130_fd_sc_hd__fill_1
X_05946_ net385 _02175_ FPGA_INST.bus2_0\[6\] vssd1 vssd1 vccd1 vccd1 _02226_ sky130_fd_sc_hd__o21bai_1
XFILLER_93_290 vssd1 vssd1 vccd1 vccd1 sky130_fd_sc_hd__fill_4
X_08665_ _04828_ _04864_ _04873_ vssd1 vssd1 vccd1 vccd1 _04874_ sky130_fd_sc_hd__o21bai_1
XFILLER_81_430 vssd1 vssd1 vccd1 vccd1 sky130_fd_sc_hd__fill_4
X_05877_ _02148_ _02150_ _02156_ vssd1 vssd1 vccd1 vccd1 _02157_ sky130_fd_sc_hd__o21bai_2
XANTENNA__10479__S net319 vssd1 vssd1 vccd1 vccd1 sky130_fd_sc_hd__diode_2
X_08596_ net401 _04018_ _04022_ _04803_ vssd1 vssd1 vccd1 vccd1 _04805_ sky130_fd_sc_hd__or4_1
X_07616_ _03546_ _03745_ vssd1 vssd1 vccd1 vccd1 _03869_ sky130_fd_sc_hd__nor2_1
X_07547_ FPGA_INST.cell1.SB0.route_sel\[72\] FPGA_INST.cell1.SB0.route_sel\[73\] vssd1
+ vssd1 vccd1 vccd1 _03802_ sky130_fd_sc_hd__nand2_1
XANTENNA_fanout240_X net240 vssd1 vssd1 vccd1 vccd1 sky130_fd_sc_hd__diode_2
XANTENNA_fanout717_A net730 vssd1 vssd1 vccd1 vccd1 sky130_fd_sc_hd__diode_2
XTAP_TAPCELL_ROW_120_1959 vssd1 vccd1 sky130_fd_sc_hd__tapvpwrvgnd_1
X_07478_ FPGA_INST.cell3.SB0.route_sel\[58\] FPGA_INST.cell3.SB0.route_sel\[59\] _03730_
+ _03734_ _03708_ vssd1 vssd1 vccd1 vccd1 _03735_ sky130_fd_sc_hd__a41o_1
X_09217_ FPGA_INST.cell2.CB_1.config_dataB\[13\] FPGA_INST.cell2.CB_1.config_dataB\[14\]
+ net275 vssd1 vssd1 vccd1 vccd1 _00130_ sky130_fd_sc_hd__mux2_1
XANTENNA__06843__A2 _01839_ vssd1 vssd1 vccd1 vccd1 sky130_fd_sc_hd__diode_2
X_06429_ net491 _02255_ _02706_ net490 vssd1 vssd1 vccd1 vccd1 _02707_ sky130_fd_sc_hd__o211a_1
XFILLER_5_217 vssd1 vssd1 vccd1 vccd1 sky130_fd_sc_hd__fill_4
X_09148_ FPGA_INST.cell2.LE_0A.config_data\[11\] FPGA_INST.cell2.LE_0A.config_data\[12\]
+ net252 vssd1 vssd1 vccd1 vccd1 _00063_ sky130_fd_sc_hd__mux2_1
X_09079_ _03485_ _04831_ _03488_ vssd1 vssd1 vccd1 vccd1 _05207_ sky130_fd_sc_hd__a21oi_1
XFILLER_107_178 vssd1 vssd1 vccd1 vccd1 sky130_fd_sc_hd__fill_2
X_11110_ net804 _00460_ net589 vssd1 vssd1 vccd1 vccd1 FPGA_INST.cell1.LE_1A.config_data\[1\]
+ sky130_fd_sc_hd__dfrtp_1
XANTENNA__05803__B1 net13 vssd1 vssd1 vccd1 vccd1 sky130_fd_sc_hd__diode_2
XFILLER_122_137 vssd1 vssd1 vccd1 vccd1 sky130_fd_sc_hd__fill_1
X_12090_ net921 _01436_ net705 vssd1 vssd1 vccd1 vccd1 FPGA_INST.cell3.CB_0.config_dataA\[2\]
+ sky130_fd_sc_hd__dfstp_1
X_11041_ net815 _00391_ net600 vssd1 vssd1 vccd1 vccd1 FPGA_INST.cell1.LEI0.config_data\[26\]
+ sky130_fd_sc_hd__dfrtp_1
XFILLER_89_552 vssd1 vssd1 vccd1 vccd1 sky130_fd_sc_hd__fill_4
XANTENNA__06359__A1 net6 vssd1 vssd1 vccd1 vccd1 sky130_fd_sc_hd__diode_2
XFILLER_77_725 vssd1 vssd1 vccd1 vccd1 sky130_fd_sc_hd__fill_2
XANTENNA__07020__A2 FPGA_INST.bus2_0\[13\] vssd1 vssd1 vccd1 vccd1 sky130_fd_sc_hd__diode_2
XFILLER_76_246 vssd1 vssd1 vccd1 vccd1 sky130_fd_sc_hd__fill_2
XFILLER_45_600 vssd1 vssd1 vccd1 vccd1 sky130_fd_sc_hd__fill_2
X_11943_ net913 _01289_ net697 vssd1 vssd1 vccd1 vccd1 FPGA_INST.cell3.CB_1.config_dataB\[8\]
+ sky130_fd_sc_hd__dfstp_1
XANTENNA__07859__A1 FPGA_INST.bus3_1\[5\] vssd1 vssd1 vccd1 vccd1 sky130_fd_sc_hd__diode_2
XFILLER_57_482 vssd1 vssd1 vccd1 vccd1 sky130_fd_sc_hd__fill_4
XANTENNA_input13_A gpio_in[20] vssd1 vssd1 vccd1 vccd1 sky130_fd_sc_hd__diode_2
X_11874_ net927 _01220_ net711 vssd1 vssd1 vccd1 vccd1 FPGA_INST.cell3.LE_0A.config_data\[4\]
+ sky130_fd_sc_hd__dfrtp_1
XFILLER_72_474 vssd1 vssd1 vccd1 vccd1 sky130_fd_sc_hd__fill_2
X_10825_ net814 _00175_ net599 vssd1 vssd1 vccd1 vccd1 FPGA_INST.cell1.SB0.route_sel\[34\]
+ sky130_fd_sc_hd__dfstp_1
XFILLER_44_187 vssd1 vssd1 vccd1 vccd1 sky130_fd_sc_hd__fill_8
XFILLER_32_338 vssd1 vssd1 vccd1 vccd1 sky130_fd_sc_hd__fill_2
XANTENNA__06819__C1 net156 vssd1 vssd1 vccd1 vccd1 sky130_fd_sc_hd__diode_2
XTAP_TAPCELL_ROW_43_878 vssd1 vccd1 sky130_fd_sc_hd__tapvpwrvgnd_1
X_10756_ net889 _00106_ net673 vssd1 vssd1 vccd1 vccd1 FPGA_INST.cell2.LE_1A.config_data\[11\]
+ sky130_fd_sc_hd__dfrtp_1
XTAP_TAPCELL_ROW_43_889 vssd1 vccd1 sky130_fd_sc_hd__tapvpwrvgnd_1
XANTENNA__11544__CLK net772 vssd1 vssd1 vccd1 vccd1 sky130_fd_sc_hd__diode_2
XFILLER_9_578 vssd1 vssd1 vccd1 vccd1 sky130_fd_sc_hd__fill_1
X_10687_ net868 _00037_ net652 vssd1 vssd1 vccd1 vccd1 FPGA_INST.cell2.LEI0.config_data\[36\]
+ sky130_fd_sc_hd__dfrtp_1
XTAP_TAPCELL_ROW_97_1641 vssd1 vccd1 sky130_fd_sc_hd__tapvpwrvgnd_1
XFILLER_5_773 vssd1 vssd1 vccd1 vccd1 sky130_fd_sc_hd__fill_4
X_11308_ net830 _00658_ net614 vssd1 vssd1 vccd1 vccd1 FPGA_INST.cell1.CB_0.config_dataB\[0\]
+ sky130_fd_sc_hd__dfstp_1
X_11239_ net768 _00589_ net553 vssd1 vssd1 vccd1 vccd1 FPGA_INST.cell0.SB0.route_sel\[84\]
+ sky130_fd_sc_hd__dfstp_1
XFILLER_67_202 vssd1 vssd1 vccd1 vccd1 sky130_fd_sc_hd__fill_1
X_05800_ _02073_ _02078_ _02079_ _01574_ _01573_ vssd1 vssd1 vccd1 vccd1 _02080_ sky130_fd_sc_hd__a311o_1
XTAP_TAPCELL_ROW_124_2015 vssd1 vccd1 sky130_fd_sc_hd__tapvpwrvgnd_1
X_06780_ _03050_ _03053_ vssd1 vssd1 vccd1 vccd1 _03054_ sky130_fd_sc_hd__nor2_1
XFILLER_67_279 vssd1 vssd1 vccd1 vccd1 sky130_fd_sc_hd__fill_1
XANTENNA__09006__X FPGA_INST.bus1_0\[3\] vssd1 vssd1 vccd1 vccd1 sky130_fd_sc_hd__diode_2
X_05731_ _01811_ _01966_ _02010_ _01810_ _01531_ vssd1 vssd1 vccd1 vccd1 _02011_ sky130_fd_sc_hd__a221o_1
X_08450_ net152 net145 net150 net141 FPGA_INST.cell1.LEI0.config_data\[42\] FPGA_INST.cell1.LEI0.config_data\[43\]
+ vssd1 vssd1 vccd1 vccd1 _04668_ sky130_fd_sc_hd__mux4_1
XFILLER_63_474 vssd1 vssd1 vccd1 vccd1 sky130_fd_sc_hd__fill_1
X_05662_ FPGA_INST.cell2.CB_1.config_dataB\[24\] FPGA_INST.cell2.CB_1.config_dataB\[21\]
+ FPGA_INST.cell2.CB_1.config_dataB\[20\] vssd1 vssd1 vccd1 vccd1 _01942_ sky130_fd_sc_hd__nor3_1
XFILLER_36_677 vssd1 vssd1 vccd1 vccd1 sky130_fd_sc_hd__fill_2
X_07401_ _03484_ _03620_ vssd1 vssd1 vccd1 vccd1 _03660_ sky130_fd_sc_hd__nor2_1
XTAP_TAPCELL_ROW_106_1770 vssd1 vccd1 sky130_fd_sc_hd__tapvpwrvgnd_1
XFILLER_91_794 vssd1 vssd1 vccd1 vccd1 sky130_fd_sc_hd__fill_4
X_08381_ _04599_ _04600_ _04602_ vssd1 vssd1 vccd1 vccd1 _04603_ sky130_fd_sc_hd__and3_1
XFILLER_23_316 vssd1 vssd1 vccd1 vccd1 sky130_fd_sc_hd__fill_1
X_07332_ _03395_ _03591_ vssd1 vssd1 vccd1 vccd1 _03592_ sky130_fd_sc_hd__nor2_1
XANTENNA__05876__A3 _02155_ vssd1 vssd1 vccd1 vccd1 sky130_fd_sc_hd__diode_2
X_05593_ FPGA_INST.cell0.CB_0.config_dataB\[24\] FPGA_INST.cell0.CB_0.config_dataB\[20\]
+ FPGA_INST.cell0.CB_0.config_dataB\[21\] vssd1 vssd1 vccd1 vccd1 _01873_ sky130_fd_sc_hd__nand3b_2
X_07263_ _01704_ _01705_ _03523_ _03524_ vssd1 vssd1 vccd1 vccd1 _03525_ sky130_fd_sc_hd__or4_1
XANTENNA__06825__A2 _02191_ vssd1 vssd1 vccd1 vccd1 sky130_fd_sc_hd__diode_2
X_09002_ FPGA_INST.cell3.SB0.route_sel\[32\] _01687_ _01688_ FPGA_INST.cell3.SB0.route_sel\[35\]
+ _05174_ vssd1 vssd1 vccd1 vccd1 _05175_ sky130_fd_sc_hd__a221o_1
X_07194_ _03456_ vssd1 vssd1 vccd1 vccd1 _03457_ sky130_fd_sc_hd__inv_2
X_06214_ net7 net8 net506 vssd1 vssd1 vccd1 vccd1 _02494_ sky130_fd_sc_hd__mux2_1
XFILLER_129_281 vssd1 vssd1 vccd1 vccd1 sky130_fd_sc_hd__fill_1
X_06145_ _02416_ _02421_ _02424_ net322 vssd1 vssd1 vccd1 vccd1 _02425_ sky130_fd_sc_hd__a211oi_1
XANTENNA_fanout200_A net201 vssd1 vssd1 vccd1 vccd1 sky130_fd_sc_hd__diode_2
XANTENNA__06589__A1 _02780_ vssd1 vssd1 vccd1 vccd1 sky130_fd_sc_hd__diode_2
XANTENNA__06589__B2 _02784_ vssd1 vssd1 vccd1 vccd1 sky130_fd_sc_hd__diode_2
X_06076_ FPGA_INST.cell2.CB_1.config_dataB\[23\] FPGA_INST.cell2.CB_1.config_dataB\[22\]
+ vssd1 vssd1 vccd1 vccd1 _02356_ sky130_fd_sc_hd__nor2_1
Xfanout524 net525 vssd1 vssd1 vccd1 vccd1 net524 sky130_fd_sc_hd__buf_4
Xfanout513 FPGA_INST.cell2.CB_1.config_dataB\[11\] vssd1 vssd1 vccd1 vccd1 net513
+ sky130_fd_sc_hd__buf_2
Xfanout502 FPGA_INST.cell2.CB_0.config_dataA\[11\] vssd1 vssd1 vccd1 vccd1 net502
+ sky130_fd_sc_hd__buf_2
X_09904_ FPGA_INST.cell0.LE_0B.config_data\[9\] FPGA_INST.cell0.LE_0B.config_data\[8\]
+ net316 vssd1 vssd1 vccd1 vccd1 _00810_ sky130_fd_sc_hd__mux2_1
XANTENNA__05800__A3 _02079_ vssd1 vssd1 vccd1 vccd1 sky130_fd_sc_hd__diode_2
XFILLER_98_371 vssd1 vssd1 vccd1 vccd1 sky130_fd_sc_hd__fill_1
XFILLER_76_29 vssd1 vssd1 vccd1 vccd1 sky130_fd_sc_hd__fill_4
XANTENNA_input5_A gpio_in[13] vssd1 vssd1 vccd1 vccd1 sky130_fd_sc_hd__diode_2
Xfanout535 net538 vssd1 vssd1 vccd1 vccd1 net535 sky130_fd_sc_hd__buf_4
X_09835_ FPGA_INST.cell0.LEI0.config_data\[13\] FPGA_INST.cell0.LEI0.config_data\[14\]
+ net172 vssd1 vssd1 vccd1 vccd1 _00743_ sky130_fd_sc_hd__mux2_1
Xfanout557 net558 vssd1 vssd1 vccd1 vccd1 net557 sky130_fd_sc_hd__clkbuf_4
Xfanout546 net547 vssd1 vssd1 vccd1 vccd1 net546 sky130_fd_sc_hd__clkbuf_4
Xfanout579 net581 vssd1 vssd1 vccd1 vccd1 net579 sky130_fd_sc_hd__clkbuf_2
XANTENNA__06210__A0 net3 vssd1 vssd1 vccd1 vccd1 sky130_fd_sc_hd__diode_2
XANTENNA_fanout667_A net675 vssd1 vssd1 vccd1 vccd1 sky130_fd_sc_hd__diode_2
Xfanout568 net569 vssd1 vssd1 vccd1 vccd1 net568 sky130_fd_sc_hd__clkbuf_4
X_09766_ FPGA_INST.cell1.CB_0.config_dataB\[17\] net450 net346 vssd1 vssd1 vccd1 vccd1
+ _00675_ sky130_fd_sc_hd__mux2_1
XANTENNA__08468__A net155 vssd1 vssd1 vccd1 vccd1 sky130_fd_sc_hd__diode_2
XANTENNA__06761__A1 FPGA_INST.bus3_2\[5\] vssd1 vssd1 vccd1 vccd1 sky130_fd_sc_hd__diode_2
X_06978_ net433 _02233_ net432 vssd1 vssd1 vccd1 vccd1 _03244_ sky130_fd_sc_hd__o21ai_1
XFILLER_39_460 vccd1 vssd1 vccd1 vssd1 sky130_ef_sc_hd__decap_40_12
X_08717_ net394 _04819_ _04925_ net393 vssd1 vssd1 vccd1 vccd1 _04926_ sky130_fd_sc_hd__o211a_1
XTAP_TAPCELL_ROW_68_1231 vssd1 vccd1 sky130_fd_sc_hd__tapvpwrvgnd_1
XFILLER_54_430 vssd1 vssd1 vccd1 vccd1 sky130_fd_sc_hd__fill_4
X_09697_ FPGA_INST.cell0.SB0.route_sel\[100\] FPGA_INST.cell0.SB0.route_sel\[101\]
+ net196 vssd1 vssd1 vccd1 vccd1 _00606_ sky130_fd_sc_hd__mux2_1
X_05929_ FPGA_INST.cell2.CB_0.config_dataA\[23\] FPGA_INST.cell2.CB_0.config_dataA\[22\]
+ vssd1 vssd1 vccd1 vccd1 _02209_ sky130_fd_sc_hd__nand2b_1
XFILLER_27_633 vssd1 vssd1 vccd1 vccd1 sky130_fd_sc_hd__fill_1
X_08648_ net89 net84 net82 _01792_ FPGA_INST.cell3.LEI0.config_data\[0\] FPGA_INST.cell3.LEI0.config_data\[1\]
+ vssd1 vssd1 vccd1 vccd1 _04857_ sky130_fd_sc_hd__mux4_1
XANTENNA__08187__B _03720_ vssd1 vssd1 vccd1 vccd1 sky130_fd_sc_hd__diode_2
XFILLER_54_463 vssd1 vssd1 vccd1 vccd1 sky130_fd_sc_hd__fill_1
XANTENNA__06513__A1 FPGA_INST.bus3_2\[5\] vssd1 vssd1 vccd1 vccd1 sky130_fd_sc_hd__diode_2
XTAP_TAPCELL_ROW_1_297 vssd1 vccd1 sky130_fd_sc_hd__tapvpwrvgnd_1
XFILLER_14_305 vssd1 vssd1 vccd1 vccd1 sky130_fd_sc_hd__fill_1
XTAP_TAPCELL_ROW_81_1420 vssd1 vccd1 sky130_fd_sc_hd__tapvpwrvgnd_1
X_08579_ _01648_ FPGA_INST.cell3.SB0.route_sel\[76\] _01649_ FPGA_INST.cell3.SB0.route_sel\[79\]
+ _04787_ vssd1 vssd1 vccd1 vccd1 _04788_ sky130_fd_sc_hd__a221o_1
X_10610_ FPGA_INST.cell3.CB_1.config_dataA\[4\] FPGA_INST.cell3.CB_1.config_dataA\[5\]
+ net304 vssd1 vssd1 vccd1 vccd1 _01489_ sky130_fd_sc_hd__mux2_1
XANTENNA__08266__A1 net95 vssd1 vssd1 vccd1 vccd1 sky130_fd_sc_hd__diode_2
X_11590_ net791 _00940_ net576 vssd1 vssd1 vccd1 vccd1 FPGA_INST.cell0.CB_1.config_dataA\[9\]
+ sky130_fd_sc_hd__dfstp_1
XANTENNA__08805__A3 net21 vssd1 vssd1 vccd1 vccd1 sky130_fd_sc_hd__diode_2
X_10541_ FPGA_INST.cell2.SB0.route_sel\[113\] FPGA_INST.cell2.SB0.route_sel\[114\]
+ net239 vssd1 vssd1 vccd1 vccd1 _01420_ sky130_fd_sc_hd__mux2_1
XTAP_TAPCELL_ROW_40_837 vssd1 vccd1 sky130_fd_sc_hd__tapvpwrvgnd_1
XTAP_TAPCELL_ROW_40_848 vssd1 vccd1 sky130_fd_sc_hd__tapvpwrvgnd_1
XFILLER_41_65 vssd1 vssd1 vccd1 vccd1 sky130_fd_sc_hd__fill_1
XFILLER_108_421 vssd1 vssd1 vccd1 vccd1 sky130_fd_sc_hd__fill_1
X_10472_ FPGA_INST.cell2.SB0.route_sel\[44\] FPGA_INST.cell2.SB0.route_sel\[45\] net245
+ vssd1 vssd1 vccd1 vccd1 _01351_ sky130_fd_sc_hd__mux2_1
XANTENNA__10935__SET_B net636 vssd1 vssd1 vccd1 vccd1 sky130_fd_sc_hd__diode_2
XTAP_TAPCELL_ROW_20_561 vssd1 vccd1 sky130_fd_sc_hd__tapvpwrvgnd_1
XTAP_TAPCELL_ROW_79_1393 vssd1 vccd1 sky130_fd_sc_hd__tapvpwrvgnd_1
XTAP_TAPCELL_ROW_79_1382 vssd1 vccd1 sky130_fd_sc_hd__tapvpwrvgnd_1
XANTENNA__07777__B1 net78 vssd1 vssd1 vccd1 vccd1 sky130_fd_sc_hd__diode_2
X_12142_ net942 _01488_ net726 vssd1 vssd1 vccd1 vccd1 FPGA_INST.cell3.CB_1.config_dataA\[4\]
+ sky130_fd_sc_hd__dfstp_1
XANTENNA__09238__S net341 vssd1 vssd1 vccd1 vccd1 sky130_fd_sc_hd__diode_2
XFILLER_2_710 vccd1 vssd1 vccd1 vssd1 sky130_ef_sc_hd__decap_40_12
XTAP_TAPCELL_ROW_92_1571 vssd1 vccd1 sky130_fd_sc_hd__tapvpwrvgnd_1
X_12073_ net848 _01419_ net633 vssd1 vssd1 vccd1 vccd1 FPGA_INST.cell2.SB0.route_sel\[113\]
+ sky130_fd_sc_hd__dfstp_1
X_11024_ net807 _00374_ net592 vssd1 vssd1 vccd1 vccd1 FPGA_INST.cell1.LEI0.config_data\[9\]
+ sky130_fd_sc_hd__dfrtp_1
XFILLER_77_533 vssd1 vssd1 vccd1 vccd1 sky130_fd_sc_hd__fill_1
XFILLER_2_798 vssd1 vssd1 vccd1 vccd1 sky130_fd_sc_hd__fill_1
XFILLER_2_26 vssd1 vssd1 vccd1 vccd1 sky130_fd_sc_hd__fill_2
XFILLER_106_80 vssd1 vssd1 vccd1 vccd1 sky130_fd_sc_hd__fill_4
XFILLER_89_393 vssd1 vssd1 vccd1 vccd1 sky130_fd_sc_hd__fill_4
XFILLER_77_555 vssd1 vssd1 vccd1 vccd1 sky130_fd_sc_hd__fill_1
XFILLER_49_268 vssd1 vssd1 vccd1 vccd1 sky130_fd_sc_hd__fill_1
XANTENNA__07282__A net81 vssd1 vssd1 vccd1 vccd1 sky130_fd_sc_hd__diode_2
XFILLER_66_73 vssd1 vssd1 vccd1 vccd1 sky130_fd_sc_hd__fill_1
XTAP_TAPCELL_ROW_48_959 vssd1 vccd1 sky130_fd_sc_hd__tapvpwrvgnd_1
XTAP_TAPCELL_ROW_48_948 vssd1 vccd1 sky130_fd_sc_hd__tapvpwrvgnd_1
XANTENNA_input16_X net16 vssd1 vssd1 vccd1 vccd1 sky130_fd_sc_hd__diode_2
X_11926_ net944 _01272_ net728 vssd1 vssd1 vccd1 vccd1 FPGA_INST.cell3.LE_1A.config_data\[12\]
+ sky130_fd_sc_hd__dfrtp_1
XFILLER_73_761 vssd1 vssd1 vccd1 vccd1 sky130_fd_sc_hd__fill_1
XTAP_TAPCELL_ROW_28_672 vssd1 vccd1 sky130_fd_sc_hd__tapvpwrvgnd_1
X_11857_ net915 _01203_ net699 vssd1 vssd1 vccd1 vccd1 FPGA_INST.cell3.LEI0.config_data\[37\]
+ sky130_fd_sc_hd__dfrtp_1
XFILLER_82_83 vssd1 vssd1 vccd1 vccd1 sky130_fd_sc_hd__fill_1
XFILLER_33_658 vssd1 vssd1 vccd1 vccd1 sky130_fd_sc_hd__fill_2
X_10808_ net828 _00158_ net612 vssd1 vssd1 vccd1 vccd1 FPGA_INST.cell1.SB0.route_sel\[17\]
+ sky130_fd_sc_hd__dfstp_1
X_11788_ net890 _01134_ net674 vssd1 vssd1 vccd1 vccd1 FPGA_INST.io_south_oeb\[28\]
+ sky130_fd_sc_hd__dfrtp_1
XANTENNA__06185__X _02465_ vssd1 vssd1 vccd1 vccd1 sky130_fd_sc_hd__diode_2
XFILLER_13_360 vssd1 vssd1 vccd1 vccd1 sky130_fd_sc_hd__fill_4
XANTENNA__06268__A0 net14 vssd1 vssd1 vccd1 vccd1 sky130_fd_sc_hd__diode_2
XFILLER_13_393 vssd1 vssd1 vccd1 vccd1 sky130_fd_sc_hd__fill_1
X_10739_ net874 _00089_ net658 vssd1 vssd1 vccd1 vccd1 FPGA_INST.cell2.LE_0B.config_data\[16\]
+ sky130_fd_sc_hd__dfrtp_1
XFILLER_127_763 vssd1 vssd1 vccd1 vccd1 sky130_fd_sc_hd__fill_1
XANTENNA__10582__S net378 vssd1 vssd1 vccd1 vccd1 sky130_fd_sc_hd__diode_2
XFILLER_56_3 vssd1 vssd1 vccd1 vccd1 sky130_fd_sc_hd__fill_8
X_07950_ net152 net145 FPGA_INST.cell1.LEI0.config_data\[24\] vssd1 vssd1 vccd1 vccd1
+ _04178_ sky130_fd_sc_hd__mux2_1
XTAP_TAPCELL_ROW_130_2096 vssd1 vccd1 sky130_fd_sc_hd__tapvpwrvgnd_1
XFILLER_68_511 vssd1 vssd1 vccd1 vccd1 sky130_fd_sc_hd__fill_4
XTAP_TAPCELL_ROW_52_1010 vssd1 vccd1 sky130_fd_sc_hd__tapvpwrvgnd_1
X_06901_ _01984_ _03163_ _03165_ _01937_ _01746_ vssd1 vssd1 vccd1 vccd1 _03169_ sky130_fd_sc_hd__a221oi_1
XANTENNA__06991__A1 FPGA_INST.bus2_0\[4\] vssd1 vssd1 vccd1 vccd1 sky130_fd_sc_hd__diode_2
XFILLER_122_490 vssd1 vssd1 vccd1 vccd1 sky130_fd_sc_hd__fill_2
X_07881_ net154 net147 FPGA_INST.cell1.LEI0.config_data\[12\] vssd1 vssd1 vccd1 vccd1
+ _04109_ sky130_fd_sc_hd__mux2_1
XANTENNA__11869__SET_B net735 vssd1 vssd1 vccd1 vccd1 sky130_fd_sc_hd__diode_2
XFILLER_95_341 vssd1 vssd1 vccd1 vccd1 sky130_fd_sc_hd__fill_1
XFILLER_68_544 vssd1 vssd1 vccd1 vccd1 sky130_fd_sc_hd__fill_4
XFILLER_56_739 vssd1 vssd1 vccd1 vccd1 sky130_fd_sc_hd__fill_1
X_09620_ FPGA_INST.cell0.SB0.route_sel\[24\] FPGA_INST.cell0.SB0.route_sel\[23\] net321
+ vssd1 vssd1 vccd1 vccd1 _00529_ sky130_fd_sc_hd__mux2_1
XANTENNA__07463__Y _03720_ vssd1 vssd1 vccd1 vccd1 sky130_fd_sc_hd__diode_2
X_06832_ _03093_ _03096_ _03098_ _03099_ vssd1 vssd1 vccd1 vccd1 _03100_ sky130_fd_sc_hd__o2bb2a_1
X_09551_ FPGA_INST.cell1.LE_1A.config_data\[1\] FPGA_INST.cell1.LE_1A.config_data\[0\]
+ net333 vssd1 vssd1 vccd1 vccd1 _00460_ sky130_fd_sc_hd__mux2_1
X_06763_ net514 _02796_ vssd1 vssd1 vccd1 vccd1 _03037_ sky130_fd_sc_hd__nand2_1
X_08502_ net155 _04716_ vssd1 vssd1 vccd1 vccd1 FPGA_INST.cell1.CB_1.le_outB sky130_fd_sc_hd__and2_1
X_05714_ _01850_ _01993_ vssd1 vssd1 vccd1 vccd1 _01994_ sky130_fd_sc_hd__nor2_1
X_09482_ FPGA_INST.cell1.LEI0.config_data\[28\] FPGA_INST.cell1.LEI0.config_data\[29\]
+ net215 vssd1 vssd1 vccd1 vccd1 _00394_ sky130_fd_sc_hd__mux2_1
X_06694_ FPGA_INST.cell2.CB_1.config_dataB\[2\] _02967_ vssd1 vssd1 vccd1 vccd1 _02968_
+ sky130_fd_sc_hd__nand2_1
XFILLER_23_113 vssd1 vssd1 vccd1 vccd1 sky130_fd_sc_hd__fill_2
XANTENNA__08735__B _04781_ vssd1 vssd1 vccd1 vccd1 sky130_fd_sc_hd__diode_2
XANTENNA_fanout150_A FPGA_INST.cell1.CB_1.le_outA vssd1 vssd1 vccd1 vccd1 sky130_fd_sc_hd__diode_2
X_05645_ net382 net167 vssd1 vssd1 vccd1 vccd1 _01925_ sky130_fd_sc_hd__nor2_1
X_08433_ _01584_ FPGA_INST.cell2.SB0.route_sel\[121\] FPGA_INST.cell2.SB0.route_sel\[126\]
+ FPGA_INST.cell2.SB0.config_data_out _04651_ vssd1 vssd1 vccd1 vccd1 _04652_ sky130_fd_sc_hd__o221a_1
XFILLER_23_124 vssd1 vssd1 vccd1 vccd1 sky130_fd_sc_hd__fill_2
XTAP_TAPCELL_ROW_63_1161 vssd1 vccd1 sky130_fd_sc_hd__tapvpwrvgnd_1
X_08364_ net441 _04584_ _04585_ vssd1 vssd1 vccd1 vccd1 _04586_ sky130_fd_sc_hd__a21oi_1
X_05576_ FPGA_INST.cell2.CB_0.config_dataB\[24\] FPGA_INST.cell2.CB_0.config_dataB\[20\]
+ FPGA_INST.cell2.CB_0.config_dataB\[21\] vssd1 vssd1 vccd1 vccd1 _01856_ sky130_fd_sc_hd__nor3b_2
X_07315_ FPGA_INST.cell3.CB_0.config_dataB\[24\] FPGA_INST.cell3.CB_0.config_dataB\[20\]
+ FPGA_INST.cell3.CB_0.config_dataB\[21\] vssd1 vssd1 vccd1 vccd1 _03576_ sky130_fd_sc_hd__and3b_1
X_08295_ net444 net445 vssd1 vssd1 vccd1 vccd1 _04517_ sky130_fd_sc_hd__and2b_1
XTAP_TAPCELL_ROW_119_1950 vssd1 vccd1 sky130_fd_sc_hd__tapvpwrvgnd_1
X_07246_ FPGA_INST.cell1.CB_1.config_dataA\[23\] FPGA_INST.cell1.CB_1.config_dataA\[22\]
+ _03507_ vssd1 vssd1 vccd1 vccd1 _03508_ sky130_fd_sc_hd__or3_1
X_07177_ _03440_ net91 _03439_ vssd1 vssd1 vccd1 vccd1 _03441_ sky130_fd_sc_hd__mux2_1
XFILLER_127_35 vssd1 vssd1 vccd1 vccd1 sky130_fd_sc_hd__fill_1
XFILLER_117_295 vssd1 vssd1 vccd1 vccd1 sky130_fd_sc_hd__fill_1
X_06128_ net135 _02406_ _02397_ vssd1 vssd1 vccd1 vccd1 _02408_ sky130_fd_sc_hd__o21a_1
XFILLER_105_446 vssd1 vssd1 vccd1 vccd1 sky130_fd_sc_hd__fill_2
X_06059_ net170 net157 FPGA_INST.bus1_0\[3\] vssd1 vssd1 vccd1 vccd1 _02339_ sky130_fd_sc_hd__o21ai_1
XANTENNA_fanout784_A net789 vssd1 vssd1 vccd1 vccd1 sky130_fd_sc_hd__diode_2
XANTENNA__08897__S _05032_ vssd1 vssd1 vccd1 vccd1 sky130_fd_sc_hd__diode_2
Xfanout332 net337 vssd1 vssd1 vccd1 vccd1 net332 sky130_fd_sc_hd__buf_2
Xfanout321 net325 vssd1 vssd1 vccd1 vccd1 net321 sky130_fd_sc_hd__clkbuf_2
Xfanout310 net315 vssd1 vssd1 vccd1 vccd1 net310 sky130_fd_sc_hd__clkbuf_4
XFILLER_98_190 vssd1 vssd1 vccd1 vccd1 sky130_fd_sc_hd__fill_2
Xfanout365 net380 vssd1 vssd1 vccd1 vccd1 net365 sky130_fd_sc_hd__buf_2
Xfanout343 net349 vssd1 vssd1 vccd1 vccd1 net343 sky130_fd_sc_hd__buf_2
Xfanout354 net355 vssd1 vssd1 vccd1 vccd1 net354 sky130_fd_sc_hd__clkbuf_4
XTAP_TAPCELL_ROW_6_367 vssd1 vccd1 sky130_fd_sc_hd__tapvpwrvgnd_1
XANTENNA_input8_X net8 vssd1 vssd1 vccd1 vccd1 sky130_fd_sc_hd__diode_2
Xfanout376 net377 vssd1 vssd1 vccd1 vccd1 net376 sky130_fd_sc_hd__clkbuf_2
X_09818_ FPGA_INST.cell1.LE_1B.reset_val FPGA_INST.cell1.LE_1B.reset_mode net228 vssd1
+ vssd1 vccd1 vccd1 _00727_ sky130_fd_sc_hd__mux2_1
Xfanout387 FPGA_INST.cell3.CB_0.config_dataB\[15\] vssd1 vssd1 vccd1 vccd1 net387
+ sky130_fd_sc_hd__buf_1
XFILLER_101_685 vssd1 vssd1 vccd1 vccd1 sky130_fd_sc_hd__fill_2
Xfanout398 FPGA_INST.cell3.CB_0.config_dataA\[6\] vssd1 vssd1 vccd1 vccd1 net398 sky130_fd_sc_hd__clkbuf_2
X_09749_ FPGA_INST.cell1.CB_0.config_dataA\[24\] net460 net226 vssd1 vssd1 vccd1 vccd1
+ _00658_ sky130_fd_sc_hd__mux2_1
XANTENNA__05615__A FPGA_INST.bus3_2\[15\] vssd1 vssd1 vccd1 vccd1 sky130_fd_sc_hd__diode_2
XTAP_TAPCELL_ROW_45_918 vssd1 vccd1 sky130_fd_sc_hd__tapvpwrvgnd_1
XTAP_TAPCELL_ROW_45_907 vssd1 vccd1 sky130_fd_sc_hd__tapvpwrvgnd_1
XFILLER_27_441 vssd1 vssd1 vccd1 vccd1 sky130_fd_sc_hd__fill_4
XFILLER_36_43 vssd1 vssd1 vccd1 vccd1 sky130_fd_sc_hd__fill_1
XFILLER_39_290 vccd1 vssd1 vccd1 vssd1 sky130_ef_sc_hd__decap_40_12
XANTENNA__05902__X _02182_ vssd1 vssd1 vccd1 vccd1 sky130_fd_sc_hd__diode_2
XFILLER_55_794 vssd1 vssd1 vccd1 vccd1 sky130_fd_sc_hd__fill_4
XFILLER_36_65 vccd1 vssd1 vccd1 vssd1 sky130_ef_sc_hd__decap_40_12
X_11711_ net921 _01057_ net705 vssd1 vssd1 vccd1 vccd1 FPGA_INST.cell3.SB0.route_sel\[81\]
+ sky130_fd_sc_hd__dfstp_1
XTAP_TAPCELL_ROW_25_631 vssd1 vccd1 sky130_fd_sc_hd__tapvpwrvgnd_1
XFILLER_70_797 vssd1 vssd1 vccd1 vccd1 sky130_fd_sc_hd__fill_2
XANTENNA__08239__A1 FPGA_INST.bus1_0\[9\] vssd1 vssd1 vccd1 vccd1 sky130_fd_sc_hd__diode_2
X_11642_ net893 _00988_ net677 vssd1 vssd1 vccd1 vccd1 FPGA_INST.cell3.SB0.route_sel\[12\]
+ sky130_fd_sc_hd__dfstp_1
XFILLER_42_477 vccd1 vssd1 vccd1 vssd1 sky130_ef_sc_hd__decap_40_12
Xinput18 gpio_in[25] vssd1 vssd1 vccd1 vccd1 net18 sky130_fd_sc_hd__buf_2
X_11573_ net752 _00923_ net537 vssd1 vssd1 vccd1 vccd1 FPGA_INST.cell0.CB_0.config_dataB\[17\]
+ sky130_fd_sc_hd__dfstp_1
Xinput29 gpio_in[8] vssd1 vssd1 vccd1 vccd1 net29 sky130_fd_sc_hd__buf_4
XANTENNA__07829__X net54 vssd1 vssd1 vccd1 vccd1 sky130_fd_sc_hd__diode_2
X_10524_ FPGA_INST.cell2.SB0.route_sel\[96\] FPGA_INST.cell2.SB0.route_sel\[97\] net246
+ vssd1 vssd1 vccd1 vccd1 _01403_ sky130_fd_sc_hd__mux2_1
XTAP_TAPCELL_ROW_94_1600 vssd1 vccd1 sky130_fd_sc_hd__tapvpwrvgnd_1
X_10455_ FPGA_INST.cell2.SB0.route_sel\[28\] FPGA_INST.cell2.SB0.route_sel\[27\] net318
+ vssd1 vssd1 vccd1 vccd1 _01334_ sky130_fd_sc_hd__mux2_1
XFILLER_123_221 vssd1 vssd1 vccd1 vccd1 sky130_fd_sc_hd__fill_2
XFILLER_109_796 vssd1 vssd1 vccd1 vccd1 sky130_fd_sc_hd__fill_2
XFILLER_108_273 vssd1 vssd1 vccd1 vccd1 sky130_fd_sc_hd__fill_1
XFILLER_124_766 vssd1 vssd1 vccd1 vccd1 sky130_fd_sc_hd__fill_4
X_10386_ FPGA_INST.cell3.LE_1A.config_data\[5\] FPGA_INST.cell3.LE_1A.config_data\[4\]
+ net376 vssd1 vssd1 vccd1 vccd1 _01265_ sky130_fd_sc_hd__mux2_1
X_12125_ net938 _01471_ net722 vssd1 vssd1 vccd1 vccd1 FPGA_INST.cell3.CB_0.config_dataB\[12\]
+ sky130_fd_sc_hd__dfstp_2
XANTENNA__06422__A0 net14 vssd1 vssd1 vccd1 vccd1 sky130_fd_sc_hd__diode_2
XANTENNA__08175__A0 net75 vssd1 vssd1 vccd1 vccd1 sky130_fd_sc_hd__diode_2
XFILLER_28_7 vssd1 vssd1 vccd1 vccd1 sky130_fd_sc_hd__fill_2
X_12056_ net857 _01402_ net642 vssd1 vssd1 vccd1 vccd1 FPGA_INST.cell2.SB0.route_sel\[96\]
+ sky130_fd_sc_hd__dfstp_1
XFILLER_65_503 vssd1 vssd1 vccd1 vccd1 sky130_fd_sc_hd__fill_1
X_11007_ net888 _00357_ net672 vssd1 vssd1 vccd1 vccd1 FPGA_INST.cell2.LE_1B.config_data\[13\]
+ sky130_fd_sc_hd__dfrtp_1
XFILLER_38_717 vssd1 vssd1 vccd1 vccd1 sky130_fd_sc_hd__fill_2
XFILLER_46_761 vssd1 vssd1 vccd1 vccd1 sky130_fd_sc_hd__fill_2
XFILLER_18_485 vssd1 vssd1 vccd1 vccd1 sky130_fd_sc_hd__fill_1
X_11909_ net940 _01255_ net724 vssd1 vssd1 vccd1 vccd1 FPGA_INST.cell3.LE_0B.edge_mode
+ sky130_fd_sc_hd__dfstp_1
XANTENNA__10577__S net284 vssd1 vssd1 vccd1 vccd1 sky130_fd_sc_hd__diode_2
X_05430_ FPGA_INST.cell3.SB0.route_sel\[13\] vssd1 vssd1 vccd1 vccd1 _01712_ sky130_fd_sc_hd__inv_2
X_05361_ FPGA_INST.cell1.SB0.route_sel\[86\] vssd1 vssd1 vccd1 vccd1 _01643_ sky130_fd_sc_hd__inv_2
XFILLER_21_639 vssd1 vssd1 vccd1 vccd1 sky130_fd_sc_hd__fill_4
X_07100_ _03362_ _03365_ _03358_ vssd1 vssd1 vccd1 vccd1 _03366_ sky130_fd_sc_hd__a21o_1
X_08080_ _04304_ _04305_ FPGA_INST.cell1.CB_0.config_dataB\[12\] vssd1 vssd1 vccd1
+ vccd1 _04306_ sky130_fd_sc_hd__mux2_1
X_05292_ FPGA_INST.cell2.SB0.route_sel\[89\] vssd1 vssd1 vccd1 vccd1 _01574_ sky130_fd_sc_hd__inv_2
XANTENNA__07458__Y _03715_ vssd1 vssd1 vccd1 vccd1 sky130_fd_sc_hd__diode_2
X_07031_ _02310_ _03283_ _03285_ _02271_ FPGA_INST.cell0.CB_0.config_dataA\[2\] vssd1
+ vssd1 vccd1 vccd1 _03297_ sky130_fd_sc_hd__o221a_1
XANTENNA__08402__A1 FPGA_INST.bus1_0\[5\] vssd1 vssd1 vccd1 vccd1 sky130_fd_sc_hd__diode_2
Xteam_15_968 vssd1 vssd1 vccd1 vccd1 team_15_968/HI gpio_out[8] sky130_fd_sc_hd__conb_1
Xteam_15_957 vssd1 vssd1 vccd1 vccd1 team_15_957/HI gpio_oeb[22] sky130_fd_sc_hd__conb_1
XTAP_TAPCELL_ROW_114_1880 vssd1 vccd1 sky130_fd_sc_hd__tapvpwrvgnd_1
X_08982_ _05161_ _02252_ vssd1 vssd1 vccd1 vccd1 FPGA_INST.bus2_0\[6\] sky130_fd_sc_hd__and2b_2
X_07933_ net467 _03519_ _04160_ FPGA_INST.cell1.CB_0.config_dataA\[11\] vssd1 vssd1
+ vccd1 vccd1 _04161_ sky130_fd_sc_hd__o211a_1
XANTENNA__09606__S net201 vssd1 vssd1 vccd1 vccd1 sky130_fd_sc_hd__diode_2
XANTENNA__08166__A0 FPGA_INST.bus1_0\[10\] vssd1 vssd1 vccd1 vccd1 sky130_fd_sc_hd__diode_2
X_07864_ FPGA_INST.cell1.CB_0.config_dataA\[7\] _04090_ _04091_ _04088_ FPGA_INST.cell1.CB_0.config_dataA\[8\]
+ vssd1 vssd1 vccd1 vccd1 _04092_ sky130_fd_sc_hd__a311o_1
XFILLER_68_374 vssd1 vssd1 vccd1 vccd1 sky130_fd_sc_hd__fill_1
XANTENNA_fanout198_A net201 vssd1 vssd1 vccd1 vccd1 sky130_fd_sc_hd__diode_2
XTAP_TAPCELL_ROW_3_326 vssd1 vccd1 sky130_fd_sc_hd__tapvpwrvgnd_1
XFILLER_113_15 vccd1 vssd1 vccd1 vssd1 sky130_ef_sc_hd__decap_40_12
X_06815_ _03085_ _03088_ _03046_ vssd1 vssd1 vccd1 vccd1 _03089_ sky130_fd_sc_hd__mux2_1
X_09603_ FPGA_INST.cell0.SB0.route_sel\[6\] FPGA_INST.cell0.SB0.route_sel\[7\] net221
+ vssd1 vssd1 vccd1 vccd1 _00512_ sky130_fd_sc_hd__mux2_1
XANTENNA_fanout365_A net380 vssd1 vssd1 vccd1 vccd1 sky130_fd_sc_hd__diode_2
X_07795_ _03561_ _03926_ net140 vssd1 vssd1 vccd1 vccd1 _04044_ sky130_fd_sc_hd__o21ai_1
XFILLER_44_709 vssd1 vssd1 vccd1 vccd1 sky130_fd_sc_hd__fill_2
X_09534_ FPGA_INST.cell1.LE_0B.config_data\[7\] FPGA_INST.cell1.LE_0B.config_data\[6\]
+ net346 vssd1 vssd1 vccd1 vccd1 _00444_ sky130_fd_sc_hd__mux2_1
XANTENNA__08469__A1 net145 vssd1 vssd1 vccd1 vccd1 sky130_fd_sc_hd__diode_2
XFILLER_71_517 vssd1 vssd1 vccd1 vccd1 sky130_fd_sc_hd__fill_1
X_06746_ FPGA_INST.cell2.LE_1B.config_data\[7\] FPGA_INST.cell2.LE_1B.config_data\[6\]
+ _02992_ vssd1 vssd1 vccd1 vccd1 _03020_ sky130_fd_sc_hd__mux2_1
XFILLER_37_783 vssd1 vssd1 vccd1 vccd1 sky130_fd_sc_hd__fill_1
XFILLER_37_794 vssd1 vssd1 vccd1 vccd1 sky130_fd_sc_hd__fill_4
X_09465_ FPGA_INST.cell1.LEI0.config_data\[12\] FPGA_INST.cell1.LEI0.config_data\[11\]
+ net335 vssd1 vssd1 vccd1 vccd1 _00377_ sky130_fd_sc_hd__mux2_1
Xwire75 FPGA_INST.bus1_0\[4\] vssd1 vssd1 vccd1 vccd1 net75 sky130_fd_sc_hd__clkbuf_2
X_06677_ FPGA_INST.cell2.LE_1A.config_data\[9\] FPGA_INST.cell2.LE_1A.config_data\[8\]
+ _02878_ vssd1 vssd1 vccd1 vccd1 _02953_ sky130_fd_sc_hd__mux2_1
XFILLER_24_433 vssd1 vssd1 vccd1 vccd1 sky130_fd_sc_hd__fill_1
XANTENNA__10487__S net351 vssd1 vssd1 vccd1 vccd1 sky130_fd_sc_hd__diode_2
XFILLER_36_282 vssd1 vssd1 vccd1 vccd1 sky130_fd_sc_hd__fill_1
X_08416_ _04636_ _04637_ _04544_ vssd1 vssd1 vccd1 vccd1 _04638_ sky130_fd_sc_hd__mux2_1
XFILLER_12_628 vssd1 vssd1 vccd1 vccd1 sky130_fd_sc_hd__fill_2
XFILLER_24_477 vssd1 vssd1 vccd1 vccd1 sky130_fd_sc_hd__fill_1
X_05628_ _01784_ _01906_ vssd1 vssd1 vccd1 vccd1 _01908_ sky130_fd_sc_hd__nor2_1
X_09396_ FPGA_INST.cell2.CB_0.config_dataB\[14\] net489 net250 vssd1 vssd1 vccd1 vccd1
+ _00309_ sky130_fd_sc_hd__mux2_1
X_08347_ _04562_ _04563_ _04566_ _04560_ vssd1 vssd1 vccd1 vccd1 _04569_ sky130_fd_sc_hd__o22a_1
XANTENNA_fanout320_X net320 vssd1 vssd1 vccd1 vccd1 sky130_fd_sc_hd__diode_2
XTAP_TAPCELL_ROW_50_976 vssd1 vccd1 sky130_fd_sc_hd__tapvpwrvgnd_1
X_05559_ _01835_ _01838_ vssd1 vssd1 vccd1 vccd1 _01839_ sky130_fd_sc_hd__and2_2
XFILLER_125_6 vccd1 vssd1 vccd1 vssd1 sky130_ef_sc_hd__decap_40_12
XANTENNA__08641__A1 net24 vssd1 vssd1 vccd1 vccd1 sky130_fd_sc_hd__diode_2
XANTENNA__08641__B2 net22 vssd1 vssd1 vccd1 vccd1 sky130_fd_sc_hd__diode_2
XTAP_TAPCELL_ROW_50_987 vssd1 vccd1 sky130_fd_sc_hd__tapvpwrvgnd_1
X_08278_ FPGA_INST.cell0.LE_1A.config_data\[6\] FPGA_INST.cell0.LE_1A.config_data\[7\]
+ _04410_ vssd1 vssd1 vccd1 vccd1 _04502_ sky130_fd_sc_hd__mux2_1
X_07229_ _03446_ _03482_ _03491_ net364 vssd1 vssd1 vccd1 vccd1 _03492_ sky130_fd_sc_hd__a211oi_2
XFILLER_106_711 vssd1 vssd1 vccd1 vccd1 sky130_fd_sc_hd__fill_1
X_10240_ FPGA_INST.io_south_oeb\[0\] FPGA_INST.io_south_oeb\[2\] net289 vssd1 vssd1
+ vccd1 vccd1 _01121_ sky130_fd_sc_hd__mux2_1
XTAP_TAPCELL_ROW_76_1352 vssd1 vccd1 sky130_fd_sc_hd__tapvpwrvgnd_1
XTAP_TAPCELL_ROW_76_1341 vssd1 vccd1 sky130_fd_sc_hd__tapvpwrvgnd_1
XFILLER_3_326 vssd1 vssd1 vccd1 vccd1 sky130_fd_sc_hd__fill_1
XFILLER_106_766 vssd1 vssd1 vccd1 vccd1 sky130_fd_sc_hd__fill_1
XFILLER_79_606 vssd1 vssd1 vccd1 vccd1 sky130_fd_sc_hd__fill_1
XFILLER_3_337 vssd1 vssd1 vccd1 vccd1 sky130_fd_sc_hd__fill_1
XFILLER_105_276 vssd1 vssd1 vccd1 vccd1 sky130_fd_sc_hd__fill_1
X_10171_ FPGA_INST.cell3.SB0.route_sel\[75\] FPGA_INST.cell3.SB0.route_sel\[76\] net286
+ vssd1 vssd1 vccd1 vccd1 _01052_ sky130_fd_sc_hd__mux2_1
XPHY_EDGE_ROW_110_Right_110 vssd1 vssd1 vccd1 vccd1 sky130_fd_sc_hd__decap_3
Xfanout140 net141 vssd1 vssd1 vccd1 vccd1 net140 sky130_fd_sc_hd__buf_2
XANTENNA__08420__S _04544_ vssd1 vssd1 vccd1 vccd1 sky130_fd_sc_hd__diode_2
Xfanout151 net152 vssd1 vssd1 vccd1 vccd1 net151 sky130_fd_sc_hd__clkbuf_2
XFILLER_93_108 vssd1 vssd1 vccd1 vccd1 sky130_fd_sc_hd__fill_1
Xfanout173 net176 vssd1 vssd1 vccd1 vccd1 net173 sky130_fd_sc_hd__clkbuf_4
Xfanout162 _02014_ vssd1 vssd1 vccd1 vccd1 net162 sky130_fd_sc_hd__clkbuf_4
Xfanout195 net196 vssd1 vssd1 vccd1 vccd1 net195 sky130_fd_sc_hd__clkbuf_4
Xfanout184 net189 vssd1 vssd1 vccd1 vccd1 net184 sky130_fd_sc_hd__clkbuf_4
XFILLER_19_238 vssd1 vssd1 vccd1 vccd1 sky130_fd_sc_hd__fill_1
XFILLER_47_97 vssd1 vssd1 vccd1 vccd1 sky130_fd_sc_hd__fill_1
XFILLER_15_444 vssd1 vssd1 vccd1 vccd1 sky130_fd_sc_hd__fill_4
XANTENNA__08943__X FPGA_INST.bus1_0\[10\] vssd1 vssd1 vccd1 vccd1 sky130_fd_sc_hd__diode_2
XANTENNA__07683__A2 _02819_ vssd1 vssd1 vccd1 vccd1 sky130_fd_sc_hd__diode_2
X_11625_ net750 _00975_ net535 vssd1 vssd1 vccd1 vccd1 FPGA_INST.cell0.LE_1B.reset_mode
+ sky130_fd_sc_hd__dfrtp_1
XANTENNA__07435__A2 _02793_ vssd1 vssd1 vccd1 vccd1 sky130_fd_sc_hd__diode_2
X_11556_ net778 _00906_ net557 vssd1 vssd1 vccd1 vccd1 FPGA_INST.cell0.CB_0.config_dataB\[0\]
+ sky130_fd_sc_hd__dfstp_1
X_10507_ FPGA_INST.cell2.SB0.route_sel\[79\] FPGA_INST.cell2.SB0.route_sel\[80\] net260
+ vssd1 vssd1 vccd1 vccd1 _01386_ sky130_fd_sc_hd__mux2_1
XANTENNA__06623__B _02814_ vssd1 vssd1 vccd1 vccd1 sky130_fd_sc_hd__diode_2
XFILLER_7_687 vssd1 vssd1 vccd1 vccd1 sky130_fd_sc_hd__fill_2
X_11487_ net746 _00837_ net531 vssd1 vssd1 vccd1 vccd1 FPGA_INST.cell0.LE_1A.config_data\[14\]
+ sky130_fd_sc_hd__dfrtp_1
XFILLER_6_197 vssd1 vssd1 vccd1 vccd1 sky130_fd_sc_hd__fill_4
X_10438_ FPGA_INST.cell2.SB0.route_sel\[10\] FPGA_INST.cell2.SB0.route_sel\[11\] net202
+ vssd1 vssd1 vccd1 vccd1 _01317_ sky130_fd_sc_hd__mux2_1
X_10369_ FPGA_INST.cell3.LE_0B.config_data\[10\] FPGA_INST.cell3.LE_0B.config_data\[11\]
+ net301 vssd1 vssd1 vccd1 vccd1 _01249_ sky130_fd_sc_hd__mux2_1
XFILLER_88_82 vssd1 vssd1 vccd1 vccd1 sky130_fd_sc_hd__fill_2
XFILLER_88_71 vssd1 vssd1 vccd1 vccd1 sky130_fd_sc_hd__fill_1
X_12108_ net917 _01454_ net701 vssd1 vssd1 vccd1 vccd1 FPGA_INST.cell3.CB_0.config_dataA\[20\]
+ sky130_fd_sc_hd__dfstp_1
XANTENNA__09426__S net354 vssd1 vssd1 vccd1 vccd1 sky130_fd_sc_hd__diode_2
XFILLER_2_381 vssd1 vssd1 vccd1 vccd1 sky130_fd_sc_hd__fill_1
XFILLER_111_279 vssd1 vssd1 vccd1 vccd1 sky130_fd_sc_hd__fill_1
XPHY_EDGE_ROW_69_Left_200 vssd1 vssd1 vccd1 vccd1 sky130_fd_sc_hd__decap_3
X_12039_ net878 _01385_ net663 vssd1 vssd1 vccd1 vccd1 FPGA_INST.cell2.SB0.route_sel\[79\]
+ sky130_fd_sc_hd__dfstp_1
XANTENNA__08699__A1 _04794_ vssd1 vssd1 vccd1 vccd1 sky130_fd_sc_hd__diode_2
XANTENNA__08699__B2 _04789_ vssd1 vssd1 vccd1 vccd1 sky130_fd_sc_hd__diode_2
XFILLER_77_160 vssd1 vssd1 vccd1 vccd1 sky130_fd_sc_hd__fill_8
XANTENNA__06159__C1 _02432_ vssd1 vssd1 vccd1 vccd1 sky130_fd_sc_hd__diode_2
XFILLER_19_3 vccd1 vssd1 vccd1 vssd1 sky130_ef_sc_hd__decap_40_12
X_07580_ net146 _03833_ _03832_ vssd1 vssd1 vccd1 vccd1 _03834_ sky130_fd_sc_hd__a21bo_1
X_06600_ net138 net127 net132 net103 FPGA_INST.cell2.LEI0.config_data\[6\] FPGA_INST.cell2.LEI0.config_data\[7\]
+ vssd1 vssd1 vccd1 vccd1 _02876_ sky130_fd_sc_hd__mux4_1
XFILLER_19_783 vssd1 vssd1 vccd1 vccd1 sky130_fd_sc_hd__fill_1
XFILLER_19_794 vssd1 vssd1 vccd1 vccd1 sky130_fd_sc_hd__fill_2
XFILLER_80_347 vssd1 vssd1 vccd1 vccd1 sky130_fd_sc_hd__fill_2
X_06531_ FPGA_INST.cell2.CB_1.config_dataA\[8\] _02787_ _02790_ _02806_ vssd1 vssd1
+ vccd1 vccd1 _02807_ sky130_fd_sc_hd__or4b_1
XFILLER_80_369 vssd1 vssd1 vccd1 vccd1 sky130_fd_sc_hd__fill_1
X_09250_ FPGA_INST.cell1.SB0.route_sel\[21\] FPGA_INST.cell1.SB0.route_sel\[22\] net224
+ vssd1 vssd1 vccd1 vccd1 _00163_ sky130_fd_sc_hd__mux2_1
XANTENNA__08320__A0 net115 vssd1 vssd1 vccd1 vccd1 sky130_fd_sc_hd__diode_2
XANTENNA__08871__A1 net24 vssd1 vssd1 vccd1 vccd1 sky130_fd_sc_hd__diode_2
X_08201_ net409 _03840_ _04424_ net408 vssd1 vssd1 vccd1 vccd1 _04425_ sky130_fd_sc_hd__o211a_1
XFILLER_61_594 vssd1 vssd1 vccd1 vccd1 sky130_fd_sc_hd__fill_4
X_06462_ net5 _02729_ _02739_ net487 vssd1 vssd1 vccd1 vccd1 _02740_ sky130_fd_sc_hd__a22o_1
XFILLER_33_285 vssd1 vssd1 vccd1 vccd1 sky130_fd_sc_hd__fill_8
X_05413_ FPGA_INST.cell3.SB0.route_sel\[26\] vssd1 vssd1 vccd1 vccd1 _01695_ sky130_fd_sc_hd__inv_2
X_09181_ FPGA_INST.cell2.LE_1B.dff1_out net524 _05212_ vssd1 vssd1 vccd1 vccd1 _00094_
+ sky130_fd_sc_hd__a21o_1
XTAP_TAPCELL_ROW_60_1120 vssd1 vccd1 sky130_fd_sc_hd__tapvpwrvgnd_1
X_06393_ _02658_ _02662_ _02670_ vssd1 vssd1 vccd1 vccd1 _02671_ sky130_fd_sc_hd__a21oi_1
XFILLER_119_335 vssd1 vssd1 vccd1 vccd1 sky130_fd_sc_hd__fill_1
XFILLER_119_313 vssd1 vssd1 vccd1 vccd1 sky130_fd_sc_hd__fill_1
X_08132_ net451 _04013_ _04357_ net450 vssd1 vssd1 vccd1 vccd1 _04358_ sky130_fd_sc_hd__o211a_1
X_05344_ FPGA_INST.cell3.SB0.route_sel\[98\] vssd1 vssd1 vccd1 vccd1 _01626_ sky130_fd_sc_hd__inv_2
X_08063_ net461 _04013_ _04288_ net459 vssd1 vssd1 vccd1 vccd1 _04289_ sky130_fd_sc_hd__o211a_1
XANTENNA__07977__A3 FPGA_INST.bus3_1\[11\] vssd1 vssd1 vccd1 vccd1 sky130_fd_sc_hd__diode_2
X_05275_ FPGA_INST.cell2.SB0.route_sel\[39\] vssd1 vssd1 vccd1 vccd1 _01557_ sky130_fd_sc_hd__inv_2
XANTENNA_fanout113_A FPGA_INST.cell0.CB_1.le_outA vssd1 vssd1 vccd1 vccd1 sky130_fd_sc_hd__diode_2
XANTENNA__09179__A2 net524 vssd1 vssd1 vccd1 vccd1 sky130_fd_sc_hd__diode_2
X_07014_ net437 _01888_ vssd1 vssd1 vccd1 vccd1 _03280_ sky130_fd_sc_hd__nand2_1
XFILLER_115_563 vssd1 vssd1 vccd1 vccd1 sky130_fd_sc_hd__fill_2
XTAP_TAPCELL_ROW_58_1093 vssd1 vccd1 sky130_fd_sc_hd__tapvpwrvgnd_1
X_08965_ FPGA_INST.cell3.SB0.route_sel\[70\] FPGA_INST.cell3.SB0.route_sel\[71\] vssd1
+ vssd1 vccd1 vccd1 _05150_ sky130_fd_sc_hd__nor2_1
XFILLER_124_47 vssd1 vssd1 vccd1 vccd1 sky130_fd_sc_hd__fill_1
X_07916_ _04134_ _04139_ _04143_ _04129_ FPGA_INST.cell1.CB_0.config_dataA\[4\] vssd1
+ vssd1 vccd1 vccd1 _04144_ sky130_fd_sc_hd__a311o_1
XFILLER_76_609 vssd1 vssd1 vccd1 vccd1 sky130_fd_sc_hd__fill_4
XTAP_TAPCELL_ROW_71_1282 vssd1 vccd1 sky130_fd_sc_hd__tapvpwrvgnd_1
XTAP_TAPCELL_ROW_71_1271 vssd1 vccd1 sky130_fd_sc_hd__tapvpwrvgnd_1
XFILLER_29_503 vssd1 vssd1 vccd1 vccd1 sky130_fd_sc_hd__fill_1
X_08896_ _05101_ _05102_ _05000_ vssd1 vssd1 vccd1 vccd1 _05103_ sky130_fd_sc_hd__mux2_1
XFILLER_84_29 vccd1 vssd1 vccd1 vssd1 sky130_ef_sc_hd__decap_40_12
X_07847_ net136 _04077_ _02406_ vssd1 vssd1 vccd1 vccd1 net46 sky130_fd_sc_hd__mux2_1
X_07778_ FPGA_INST.cell3.SB0.route_sel\[122\] FPGA_INST.cell3.SB0.route_sel\[123\]
+ vssd1 vssd1 vccd1 vccd1 _04027_ sky130_fd_sc_hd__nand2_1
XFILLER_56_377 vssd1 vssd1 vccd1 vccd1 sky130_fd_sc_hd__fill_1
X_09517_ FPGA_INST.cell1.LE_0A.config_data\[13\] FPGA_INST.cell1.LE_0A.config_data\[12\]
+ net345 vssd1 vssd1 vccd1 vccd1 _00428_ sky130_fd_sc_hd__mux2_1
XFILLER_71_347 vssd1 vssd1 vccd1 vccd1 sky130_fd_sc_hd__fill_1
X_06729_ _02840_ _02993_ _02994_ _02843_ FPGA_INST.cell2.CB_1.config_dataB\[7\] vssd1
+ vssd1 vccd1 vccd1 _03003_ sky130_fd_sc_hd__a221o_1
XANTENNA_fanout914_A net917 vssd1 vssd1 vccd1 vccd1 sky130_fd_sc_hd__diode_2
XANTENNA__08311__A0 net75 vssd1 vssd1 vccd1 vccd1 sky130_fd_sc_hd__diode_2
X_09448_ FPGA_INST.cell2.LE_1B.config_data\[16\] FPGA_INST.cell2.LE_1B.edge_mode net264
+ vssd1 vssd1 vccd1 vccd1 _00361_ sky130_fd_sc_hd__mux2_1
XFILLER_12_425 vssd1 vssd1 vccd1 vccd1 sky130_fd_sc_hd__fill_4
XFILLER_25_797 vssd1 vssd1 vccd1 vccd1 sky130_fd_sc_hd__fill_2
XTAP_TAPCELL_ROW_35_770 vssd1 vccd1 sky130_fd_sc_hd__tapvpwrvgnd_1
XFILLER_40_723 vssd1 vssd1 vccd1 vccd1 sky130_fd_sc_hd__fill_2
XANTENNA_fanout702_X net702 vssd1 vssd1 vccd1 vccd1 sky130_fd_sc_hd__diode_2
XFILLER_12_447 vccd1 vssd1 vccd1 vssd1 sky130_ef_sc_hd__decap_40_12
X_09379_ FPGA_INST.cell2.CB_0.config_dataA\[23\] FPGA_INST.cell2.CB_0.config_dataA\[22\]
+ net350 vssd1 vssd1 vccd1 vccd1 _00292_ sky130_fd_sc_hd__mux2_1
XANTENNA__08415__S _04574_ vssd1 vssd1 vccd1 vccd1 sky130_fd_sc_hd__diode_2
X_11410_ net744 _00760_ net529 vssd1 vssd1 vccd1 vccd1 FPGA_INST.cell0.LEI0.config_data\[31\]
+ sky130_fd_sc_hd__dfrtp_1
XFILLER_123_3 vccd1 vssd1 vccd1 vssd1 sky130_ef_sc_hd__decap_40_12
X_11341_ net805 _00691_ net590 vssd1 vssd1 vccd1 vccd1 FPGA_INST.cell1.CB_1.config_dataA\[8\]
+ sky130_fd_sc_hd__dfstp_1
XFILLER_106_541 vssd1 vssd1 vccd1 vccd1 sky130_fd_sc_hd__fill_1
X_11272_ net783 _00622_ net568 vssd1 vssd1 vccd1 vccd1 FPGA_INST.cell0.SB0.route_sel\[117\]
+ sky130_fd_sc_hd__dfstp_1
X_10223_ FPGA_INST.cell3.SB0.config_data_out FPGA_INST.io_west_oeb\[0\] net286 vssd1
+ vssd1 vccd1 vccd1 _01104_ sky130_fd_sc_hd__mux2_1
XFILLER_3_156 vssd1 vssd1 vccd1 vccd1 sky130_fd_sc_hd__fill_2
X_10154_ FPGA_INST.cell3.SB0.route_sel\[58\] FPGA_INST.cell3.SB0.route_sel\[59\] net273
+ vssd1 vssd1 vccd1 vccd1 _01035_ sky130_fd_sc_hd__mux2_1
XFILLER_121_588 vssd1 vssd1 vccd1 vccd1 sky130_fd_sc_hd__fill_2
XTAP_TAPCELL_ROW_89_1532 vssd1 vccd1 sky130_fd_sc_hd__tapvpwrvgnd_1
XFILLER_58_85 vssd1 vssd1 vccd1 vccd1 sky130_fd_sc_hd__fill_1
X_10085_ FPGA_INST.cell0.LE_1B.config_data\[9\] FPGA_INST.cell0.LE_1B.config_data\[10\]
+ net173 vssd1 vssd1 vccd1 vccd1 _00966_ sky130_fd_sc_hd__mux2_1
XFILLER_74_141 vssd1 vssd1 vccd1 vccd1 sky130_fd_sc_hd__fill_1
XFILLER_90_623 vssd1 vssd1 vccd1 vccd1 sky130_fd_sc_hd__fill_1
XFILLER_74_152 vssd1 vssd1 vccd1 vccd1 sky130_fd_sc_hd__fill_2
XFILLER_90_645 vssd1 vssd1 vccd1 vccd1 sky130_fd_sc_hd__fill_4
XFILLER_62_369 vssd1 vssd1 vccd1 vccd1 sky130_fd_sc_hd__fill_2
X_10987_ net860 _00337_ net646 vssd1 vssd1 vccd1 vccd1 FPGA_INST.cell2.CB_1.config_dataA\[18\]
+ sky130_fd_sc_hd__dfstp_1
XFILLER_43_561 vssd1 vssd1 vccd1 vccd1 sky130_fd_sc_hd__fill_1
XFILLER_15_252 vssd1 vssd1 vccd1 vccd1 sky130_fd_sc_hd__fill_2
X_11608_ net743 _00958_ net528 vssd1 vssd1 vccd1 vccd1 FPGA_INST.cell0.LE_1B.config_data\[2\]
+ sky130_fd_sc_hd__dfrtp_1
XTAP_TAPCELL_ROW_13_464 vssd1 vccd1 sky130_fd_sc_hd__tapvpwrvgnd_1
XFILLER_11_480 vssd1 vssd1 vccd1 vccd1 sky130_fd_sc_hd__fill_1
Xmax_cap104 _02457_ vssd1 vssd1 vccd1 vccd1 net104 sky130_fd_sc_hd__buf_1
XANTENNA__06092__A1 net135 vssd1 vssd1 vccd1 vccd1 sky130_fd_sc_hd__diode_2
X_11539_ net774 _00889_ net560 vssd1 vssd1 vccd1 vccd1 FPGA_INST.cell0.CB_0.config_dataA\[8\]
+ sky130_fd_sc_hd__dfstp_1
XANTENNA__08369__A0 net73 vssd1 vssd1 vccd1 vccd1 sky130_fd_sc_hd__diode_2
Xfanout909 net911 vssd1 vssd1 vccd1 vccd1 net909 sky130_fd_sc_hd__clkbuf_2
XANTENNA__06919__A1 FPGA_INST.bus2_0\[3\] vssd1 vssd1 vccd1 vccd1 sky130_fd_sc_hd__diode_2
XANTENNA__09009__X FPGA_INST.bus2_0\[3\] vssd1 vssd1 vccd1 vccd1 sky130_fd_sc_hd__diode_2
XFILLER_112_577 vssd1 vssd1 vccd1 vccd1 sky130_fd_sc_hd__fill_8
XFILLER_100_717 vssd1 vssd1 vccd1 vccd1 sky130_fd_sc_hd__fill_1
X_08750_ _04952_ _04958_ vssd1 vssd1 vccd1 vccd1 _04959_ sky130_fd_sc_hd__nand2_1
XFILLER_100_739 vssd1 vssd1 vccd1 vccd1 sky130_fd_sc_hd__fill_1
X_05962_ _01793_ _02239_ _02241_ vssd1 vssd1 vccd1 vccd1 _02242_ sky130_fd_sc_hd__o21ai_1
XTAP_TAPCELL_ROW_127_2057 vssd1 vccd1 sky130_fd_sc_hd__tapvpwrvgnd_1
X_08681_ FPGA_INST.cell3.CB_0.config_dataA\[8\] FPGA_INST.cell3.CB_0.config_dataA\[7\]
+ _01767_ net398 vssd1 vssd1 vccd1 vccd1 _04890_ sky130_fd_sc_hd__or4_1
X_07701_ _01996_ _03949_ _03951_ vssd1 vssd1 vccd1 vccd1 _03952_ sky130_fd_sc_hd__o21ai_1
X_05893_ FPGA_INST.cell0.CB_0.config_dataA\[23\] FPGA_INST.cell0.CB_0.config_dataA\[22\]
+ vssd1 vssd1 vccd1 vccd1 _02173_ sky130_fd_sc_hd__and2b_1
XFILLER_38_355 vssd1 vssd1 vccd1 vccd1 sky130_fd_sc_hd__fill_1
XANTENNA__07912__B _04049_ vssd1 vssd1 vccd1 vccd1 sky130_fd_sc_hd__diode_2
X_07632_ _03871_ _03882_ _03883_ vssd1 vssd1 vccd1 vccd1 _03885_ sky130_fd_sc_hd__a21o_1
XFILLER_80_100 vssd1 vssd1 vccd1 vccd1 sky130_fd_sc_hd__fill_1
XFILLER_66_697 vssd1 vssd1 vccd1 vccd1 sky130_fd_sc_hd__fill_1
XFILLER_38_377 vssd1 vssd1 vccd1 vccd1 sky130_fd_sc_hd__fill_1
XANTENNA__07895__A2 FPGA_INST.bus3_1\[6\] vssd1 vssd1 vccd1 vccd1 sky130_fd_sc_hd__diode_2
XFILLER_80_133 vssd1 vssd1 vccd1 vccd1 sky130_fd_sc_hd__fill_1
XFILLER_65_196 vssd1 vssd1 vccd1 vccd1 sky130_fd_sc_hd__fill_4
X_09302_ FPGA_INST.cell1.SB0.route_sel\[74\] FPGA_INST.cell1.SB0.route_sel\[73\] net332
+ vssd1 vssd1 vccd1 vccd1 _00215_ sky130_fd_sc_hd__mux2_1
X_07563_ _03447_ _03775_ net80 vssd1 vssd1 vccd1 vccd1 _03818_ sky130_fd_sc_hd__o21ai_1
XANTENNA__08844__B2 _04789_ vssd1 vssd1 vccd1 vccd1 sky130_fd_sc_hd__diode_2
XANTENNA__08844__A1 _04794_ vssd1 vssd1 vccd1 vccd1 sky130_fd_sc_hd__diode_2
X_07494_ _03749_ vssd1 vssd1 vccd1 vccd1 _03750_ sky130_fd_sc_hd__inv_2
XFILLER_80_177 vssd1 vssd1 vccd1 vccd1 sky130_fd_sc_hd__fill_1
X_06514_ _02788_ _02789_ FPGA_INST.cell2.CB_1.config_dataA\[7\] vssd1 vssd1 vccd1
+ vccd1 _02790_ sky130_fd_sc_hd__mux2_1
XANTENNA_fanout230_A net233 vssd1 vssd1 vccd1 vccd1 sky130_fd_sc_hd__diode_2
XTAP_TAPCELL_ROW_122_1990 vssd1 vccd1 sky130_fd_sc_hd__tapvpwrvgnd_1
X_09233_ FPGA_INST.cell1.SB0.route_sel\[4\] FPGA_INST.cell1.SB0.route_sel\[5\] net222
+ vssd1 vssd1 vccd1 vccd1 _00146_ sky130_fd_sc_hd__mux2_1
X_06445_ _02712_ _02719_ _02722_ vssd1 vssd1 vccd1 vccd1 _02723_ sky130_fd_sc_hd__o21ai_1
XFILLER_22_778 vccd1 vssd1 vccd1 vssd1 sky130_ef_sc_hd__decap_40_12
XFILLER_119_110 vssd1 vssd1 vccd1 vccd1 sky130_fd_sc_hd__fill_2
XANTENNA_fanout328_A net332 vssd1 vssd1 vccd1 vccd1 sky130_fd_sc_hd__diode_2
X_09164_ FPGA_INST.cell2.LE_0B.config_data\[5\] FPGA_INST.cell2.LE_0B.config_data\[4\]
+ net358 vssd1 vssd1 vccd1 vccd1 _00078_ sky130_fd_sc_hd__mux2_1
X_08115_ FPGA_INST.bus3_1\[4\] FPGA_INST.bus3_1\[5\] FPGA_INST.bus3_1\[6\] FPGA_INST.bus3_1\[7\]
+ net451 net450 vssd1 vssd1 vccd1 vccd1 _04341_ sky130_fd_sc_hd__mux4_1
XANTENNA__06544__A _02819_ vssd1 vssd1 vccd1 vccd1 sky130_fd_sc_hd__diode_2
XANTENNA__06607__A0 FPGA_INST.bus3_2\[0\] vssd1 vssd1 vccd1 vccd1 sky130_fd_sc_hd__diode_2
X_06376_ net498 _02376_ vssd1 vssd1 vccd1 vccd1 _02654_ sky130_fd_sc_hd__nand2_1
XFILLER_119_176 vssd1 vssd1 vccd1 vccd1 sky130_fd_sc_hd__fill_1
XFILLER_119_165 vssd1 vssd1 vccd1 vccd1 sky130_fd_sc_hd__fill_1
X_05327_ FPGA_INST.cell3.SB0.route_sel\[113\] vssd1 vssd1 vccd1 vccd1 _01609_ sky130_fd_sc_hd__inv_2
X_09095_ FPGA_INST.cell2.LEI0.config_data\[9\] FPGA_INST.cell2.LEI0.config_data\[10\]
+ net265 vssd1 vssd1 vccd1 vccd1 _00011_ sky130_fd_sc_hd__mux2_1
X_08046_ FPGA_INST.cell1.CB_0.config_dataB\[3\] _04271_ vssd1 vssd1 vccd1 vccd1 _04272_
+ sky130_fd_sc_hd__nor2_1
XANTENNA__06083__A1 net132 vssd1 vssd1 vccd1 vccd1 sky130_fd_sc_hd__diode_2
X_05258_ FPGA_INST.cell2.CB_0.config_dataB\[9\] vssd1 vssd1 vccd1 vccd1 _01540_ sky130_fd_sc_hd__inv_2
XTAP_TAPCELL_ROW_73_1311 vssd1 vccd1 sky130_fd_sc_hd__tapvpwrvgnd_1
XTAP_TAPCELL_ROW_73_1300 vssd1 vccd1 sky130_fd_sc_hd__tapvpwrvgnd_1
XFILLER_115_393 vssd1 vssd1 vccd1 vccd1 sky130_fd_sc_hd__fill_2
XFILLER_130_363 vssd1 vssd1 vccd1 vccd1 sky130_fd_sc_hd__fill_1
X_09997_ _05242_ _05243_ vssd1 vssd1 vccd1 vccd1 _00879_ sky130_fd_sc_hd__and2_1
X_08948_ FPGA_INST.cell3.SB0.route_sel\[80\] _01639_ _01640_ FPGA_INST.cell3.SB0.route_sel\[83\]
+ _05138_ vssd1 vssd1 vccd1 vccd1 _05139_ sky130_fd_sc_hd__a221o_1
X_08879_ FPGA_INST.cell3.CB_0.config_dataB\[17\] _05071_ _05075_ _05078_ _05081_ vssd1
+ vssd1 vccd1 vccd1 _05086_ sky130_fd_sc_hd__o32a_1
XANTENNA__08127__A3 FPGA_INST.bus3_1\[11\] vssd1 vssd1 vccd1 vccd1 sky130_fd_sc_hd__diode_2
XFILLER_91_409 vssd1 vssd1 vccd1 vccd1 sky130_fd_sc_hd__fill_1
XFILLER_28_33 vssd1 vssd1 vccd1 vccd1 sky130_fd_sc_hd__fill_1
XANTENNA__07335__A1 net147 vssd1 vssd1 vccd1 vccd1 sky130_fd_sc_hd__diode_2
X_10910_ net786 _00260_ net571 vssd1 vssd1 vccd1 vccd1 FPGA_INST.cell1.SB0.route_sel\[119\]
+ sky130_fd_sc_hd__dfstp_1
XFILLER_44_303 vssd1 vssd1 vccd1 vccd1 sky130_fd_sc_hd__fill_2
X_11890_ FPGA_INST.cell3.LE_0B.sel_clk _01236_ net735 vssd1 vssd1 vccd1 vccd1 FPGA_INST.cell3.LE_0B.dff0_out
+ sky130_fd_sc_hd__dfrtp_1
XFILLER_71_122 vssd1 vssd1 vccd1 vccd1 sky130_fd_sc_hd__fill_2
XANTENNA_fanout917_X net917 vssd1 vssd1 vccd1 vccd1 sky130_fd_sc_hd__diode_2
X_10841_ net802 _00191_ net587 vssd1 vssd1 vccd1 vccd1 FPGA_INST.cell1.SB0.route_sel\[50\]
+ sky130_fd_sc_hd__dfstp_1
XTAP_TAPCELL_ROW_84_1462 vssd1 vccd1 sky130_fd_sc_hd__tapvpwrvgnd_1
XANTENNA__08835__A1 net24 vssd1 vssd1 vccd1 vccd1 sky130_fd_sc_hd__diode_2
X_10772_ net923 _00122_ net707 vssd1 vssd1 vccd1 vccd1 FPGA_INST.cell2.CB_1.config_dataB\[6\]
+ sky130_fd_sc_hd__dfstp_1
XFILLER_13_723 vssd1 vssd1 vccd1 vccd1 sky130_fd_sc_hd__fill_4
XFILLER_100_71 vccd1 vssd1 vccd1 vssd1 sky130_ef_sc_hd__decap_40_12
XFILLER_60_31 vssd1 vssd1 vccd1 vccd1 sky130_fd_sc_hd__fill_1
XTAP_TAPCELL_ROW_10_423 vssd1 vccd1 sky130_fd_sc_hd__tapvpwrvgnd_1
XFILLER_125_113 vssd1 vssd1 vccd1 vccd1 sky130_fd_sc_hd__fill_1
XANTENNA__08063__A2 _04013_ vssd1 vssd1 vccd1 vccd1 sky130_fd_sc_hd__diode_2
XANTENNA__09260__A1 FPGA_INST.cell1.SB0.route_sel\[31\] vssd1 vssd1 vccd1 vccd1 sky130_fd_sc_hd__diode_2
XANTENNA__08940__Y FPGA_INST.bus3_1\[11\] vssd1 vssd1 vccd1 vccd1 sky130_fd_sc_hd__diode_2
X_11324_ net836 _00674_ net620 vssd1 vssd1 vccd1 vccd1 FPGA_INST.cell1.CB_0.config_dataB\[16\]
+ sky130_fd_sc_hd__dfstp_1
XANTENNA__06613__A3 FPGA_INST.bus3_2\[7\] vssd1 vssd1 vccd1 vccd1 sky130_fd_sc_hd__diode_2
XFILLER_5_15 vssd1 vssd1 vccd1 vccd1 sky130_fd_sc_hd__fill_8
X_11255_ net781 _00605_ net566 vssd1 vssd1 vccd1 vccd1 FPGA_INST.cell0.SB0.route_sel\[100\]
+ sky130_fd_sc_hd__dfstp_1
XFILLER_5_48 vssd1 vssd1 vccd1 vccd1 sky130_fd_sc_hd__fill_8
XFILLER_4_465 vssd1 vssd1 vccd1 vccd1 sky130_fd_sc_hd__fill_8
X_10206_ FPGA_INST.cell3.SB0.route_sel\[110\] FPGA_INST.cell3.SB0.route_sel\[111\]
+ net269 vssd1 vssd1 vccd1 vccd1 _01087_ sky130_fd_sc_hd__mux2_1
XANTENNA__08771__A0 net18 vssd1 vssd1 vccd1 vccd1 sky130_fd_sc_hd__diode_2
XFILLER_79_244 vssd1 vssd1 vccd1 vccd1 sky130_fd_sc_hd__fill_2
X_11186_ net779 _00536_ net564 vssd1 vssd1 vccd1 vccd1 FPGA_INST.cell0.SB0.route_sel\[31\]
+ sky130_fd_sc_hd__dfstp_1
XFILLER_121_374 vssd1 vssd1 vccd1 vccd1 sky130_fd_sc_hd__fill_8
X_10137_ FPGA_INST.cell3.SB0.route_sel\[41\] FPGA_INST.cell3.SB0.route_sel\[42\] net279
+ vssd1 vssd1 vccd1 vccd1 _01018_ sky130_fd_sc_hd__mux2_1
XFILLER_94_258 vssd1 vssd1 vccd1 vccd1 sky130_fd_sc_hd__fill_1
X_10068_ FPGA_INST.cell0.CB_1.config_dataA\[18\] FPGA_INST.cell0.CB_1.config_dataA\[17\]
+ net328 vssd1 vssd1 vccd1 vccd1 _00949_ sky130_fd_sc_hd__mux2_1
XPHY_EDGE_ROW_13_Right_13 vssd1 vssd1 vccd1 vccd1 sky130_fd_sc_hd__decap_3
XANTENNA__09704__S net324 vssd1 vssd1 vccd1 vccd1 sky130_fd_sc_hd__diode_2
XFILLER_48_697 vssd1 vssd1 vccd1 vccd1 sky130_fd_sc_hd__fill_2
XFILLER_47_163 vssd1 vssd1 vccd1 vccd1 sky130_fd_sc_hd__fill_4
XANTENNA__07877__A2 _04013_ vssd1 vssd1 vccd1 vccd1 sky130_fd_sc_hd__diode_2
XTAP_TAPCELL_ROW_18_534 vssd1 vccd1 sky130_fd_sc_hd__tapvpwrvgnd_1
XFILLER_35_347 vssd1 vssd1 vccd1 vccd1 sky130_fd_sc_hd__fill_2
XFILLER_90_475 vssd1 vssd1 vccd1 vccd1 sky130_fd_sc_hd__fill_1
XFILLER_62_199 vssd1 vssd1 vccd1 vccd1 sky130_fd_sc_hd__fill_1
XANTENNA__10585__S net300 vssd1 vssd1 vccd1 vccd1 sky130_fd_sc_hd__diode_2
XFILLER_43_391 vssd1 vssd1 vccd1 vccd1 sky130_fd_sc_hd__fill_1
XFILLER_86_3 vssd1 vssd1 vccd1 vccd1 sky130_fd_sc_hd__fill_2
X_06230_ net509 _02255_ _02509_ net508 vssd1 vssd1 vccd1 vccd1 _02510_ sky130_fd_sc_hd__o211a_1
XANTENNA__06301__A2 _01869_ vssd1 vssd1 vccd1 vccd1 sky130_fd_sc_hd__diode_2
XPHY_EDGE_ROW_22_Right_22 vssd1 vssd1 vccd1 vccd1 sky130_fd_sc_hd__decap_3
XFILLER_31_597 vssd1 vssd1 vccd1 vccd1 sky130_fd_sc_hd__fill_1
X_06161_ net163 _02366_ vssd1 vssd1 vccd1 vccd1 _02441_ sky130_fd_sc_hd__and2_1
XANTENNA__07262__B1 net129 vssd1 vssd1 vccd1 vccd1 sky130_fd_sc_hd__diode_2
XANTENNA__07747__X _03997_ vssd1 vssd1 vccd1 vccd1 sky130_fd_sc_hd__diode_2
X_06092_ net135 _02369_ _02371_ _02355_ vssd1 vssd1 vccd1 vccd1 _02372_ sky130_fd_sc_hd__o211ai_1
X_09920_ FPGA_INST.cell0.LE_1A.config_data\[1\] FPGA_INST.cell0.LE_1A.config_data\[2\]
+ net175 vssd1 vssd1 vccd1 vccd1 _00825_ sky130_fd_sc_hd__mux2_1
Xfanout706 net731 vssd1 vssd1 vccd1 vccd1 net706 sky130_fd_sc_hd__clkbuf_2
XTAP_TAPCELL_ROW_55_1052 vssd1 vccd1 sky130_fd_sc_hd__tapvpwrvgnd_1
Xfanout739 net740 vssd1 vssd1 vccd1 vccd1 net739 sky130_fd_sc_hd__clkbuf_1
Xfanout717 net730 vssd1 vssd1 vccd1 vccd1 net717 sky130_fd_sc_hd__clkbuf_2
Xfanout728 net729 vssd1 vssd1 vccd1 vccd1 net728 sky130_fd_sc_hd__clkbuf_2
XANTENNA__08357__A3 FPGA_INST.bus1_0\[11\] vssd1 vssd1 vccd1 vccd1 sky130_fd_sc_hd__diode_2
XANTENNA__06368__A2 net16 vssd1 vssd1 vccd1 vccd1 sky130_fd_sc_hd__diode_2
X_09851_ FPGA_INST.cell0.LEI0.config_data\[29\] FPGA_INST.cell0.LEI0.config_data\[30\]
+ net176 vssd1 vssd1 vccd1 vccd1 _00759_ sky130_fd_sc_hd__mux2_1
X_09782_ FPGA_INST.cell1.CB_1.config_dataA\[8\] FPGA_INST.cell1.CB_1.config_dataA\[7\]
+ net333 vssd1 vssd1 vccd1 vccd1 _00691_ sky130_fd_sc_hd__mux2_1
X_08802_ net392 _04835_ _05008_ vssd1 vssd1 vccd1 vccd1 _05009_ sky130_fd_sc_hd__a21oi_1
X_06994_ FPGA_INST.bus2_0\[0\] _03246_ _03247_ FPGA_INST.bus2_0\[1\] _03259_ vssd1
+ vssd1 vccd1 vccd1 _03260_ sky130_fd_sc_hd__a221o_1
XPHY_EDGE_ROW_31_Right_31 vssd1 vssd1 vccd1 vccd1 sky130_fd_sc_hd__decap_3
X_08733_ FPGA_INST.cell3.CB_0.config_dataA\[17\] _04926_ _04930_ _04937_ _04941_ vssd1
+ vssd1 vccd1 vccd1 _04942_ sky130_fd_sc_hd__o311a_1
X_05945_ FPGA_INST.cell0.SB0.route_sel\[51\] FPGA_INST.cell0.SB0.route_sel\[50\] _02222_
+ _02223_ _02224_ vssd1 vssd1 vccd1 vccd1 _02225_ sky130_fd_sc_hd__a221o_1
XANTENNA_fanout278_A net285 vssd1 vssd1 vccd1 vccd1 sky130_fd_sc_hd__diode_2
XANTENNA__08738__B _04801_ vssd1 vssd1 vccd1 vccd1 sky130_fd_sc_hd__diode_2
X_08664_ _04831_ _04865_ _04872_ net398 FPGA_INST.cell3.CB_0.config_dataA\[7\] vssd1
+ vssd1 vccd1 vccd1 _04873_ sky130_fd_sc_hd__a221o_1
XFILLER_54_645 vssd1 vssd1 vccd1 vccd1 sky130_fd_sc_hd__fill_1
XFILLER_53_111 vssd1 vssd1 vccd1 vccd1 sky130_fd_sc_hd__fill_1
X_05876_ _02149_ _02154_ _02155_ _01565_ _01564_ vssd1 vssd1 vccd1 vccd1 _02156_ sky130_fd_sc_hd__a311o_1
X_08595_ _04018_ _04022_ _04803_ vssd1 vssd1 vccd1 vccd1 _04804_ sky130_fd_sc_hd__or3_4
X_07615_ _03868_ _03866_ vssd1 vssd1 vccd1 vccd1 FPGA_INST.bus3_2\[10\] sky130_fd_sc_hd__and2b_1
XFILLER_81_453 vssd1 vssd1 vccd1 vccd1 sky130_fd_sc_hd__fill_1
X_07546_ net148 _03468_ _03762_ _03793_ _03800_ vssd1 vssd1 vccd1 vccd1 _03801_ sky130_fd_sc_hd__o311a_1
XANTENNA__06540__A2 _02810_ vssd1 vssd1 vccd1 vccd1 sky130_fd_sc_hd__diode_2
XANTENNA__06258__B _02092_ vssd1 vssd1 vccd1 vccd1 sky130_fd_sc_hd__diode_2
XANTENNA__10624__A1 FPGA_INST.cell3.CB_1.config_dataA\[19\] vssd1 vssd1 vccd1 vccd1
+ sky130_fd_sc_hd__diode_2
XANTENNA__10495__S net354 vssd1 vssd1 vccd1 vccd1 sky130_fd_sc_hd__diode_2
XANTENNA__05730__X _02010_ vssd1 vssd1 vccd1 vccd1 sky130_fd_sc_hd__diode_2
XANTENNA_fanout233_X net233 vssd1 vssd1 vccd1 vccd1 sky130_fd_sc_hd__diode_2
X_07477_ _02201_ _03731_ _03733_ vssd1 vssd1 vccd1 vccd1 _03734_ sky130_fd_sc_hd__a21bo_1
X_09216_ FPGA_INST.cell2.CB_1.config_dataB\[13\] FPGA_INST.cell2.CB_1.config_dataB\[12\]
+ net367 vssd1 vssd1 vccd1 vccd1 _00129_ sky130_fd_sc_hd__mux2_1
XANTENNA_fanout612_A net615 vssd1 vssd1 vccd1 vccd1 sky130_fd_sc_hd__diode_2
XPHY_EDGE_ROW_40_Right_40 vssd1 vssd1 vccd1 vccd1 sky130_fd_sc_hd__decap_3
XFILLER_10_737 vssd1 vssd1 vccd1 vccd1 sky130_fd_sc_hd__fill_2
X_06428_ net491 _02217_ vssd1 vssd1 vccd1 vccd1 _02706_ sky130_fd_sc_hd__nand2_1
XFILLER_107_102 vssd1 vssd1 vccd1 vccd1 sky130_fd_sc_hd__fill_1
X_09147_ FPGA_INST.cell2.LE_0A.config_data\[11\] FPGA_INST.cell2.LE_0A.config_data\[10\]
+ net356 vssd1 vssd1 vccd1 vccd1 _00062_ sky130_fd_sc_hd__mux2_1
X_06359_ net6 _02623_ _02636_ FPGA_INST.cell2.CB_0.config_dataB\[8\] vssd1 vssd1 vccd1
+ vccd1 _02637_ sky130_fd_sc_hd__a211o_1
XANTENNA__07089__B _02191_ vssd1 vssd1 vccd1 vccd1 sky130_fd_sc_hd__diode_2
XFILLER_30_23 vssd1 vssd1 vccd1 vccd1 sky130_fd_sc_hd__fill_4
XFILLER_108_669 vssd1 vssd1 vccd1 vccd1 sky130_fd_sc_hd__fill_2
X_09078_ net89 _03533_ _03534_ _05206_ vssd1 vssd1 vccd1 vccd1 net62 sky130_fd_sc_hd__a2bb2o_1
XPHY_EDGE_ROW_15_Left_146 vssd1 vssd1 vccd1 vccd1 sky130_fd_sc_hd__decap_3
XFILLER_123_617 vssd1 vssd1 vccd1 vccd1 sky130_fd_sc_hd__fill_1
X_08029_ _03932_ _04236_ _04253_ _04254_ _01728_ vssd1 vssd1 vccd1 vccd1 _04255_ sky130_fd_sc_hd__a221o_1
XFILLER_107_157 vssd1 vssd1 vccd1 vccd1 sky130_fd_sc_hd__fill_2
XANTENNA_fanout93_A net94 vssd1 vssd1 vccd1 vccd1 sky130_fd_sc_hd__diode_2
X_11040_ net815 _00390_ net600 vssd1 vssd1 vccd1 vccd1 FPGA_INST.cell1.LEI0.config_data\[25\]
+ sky130_fd_sc_hd__dfrtp_1
XFILLER_49_439 vssd1 vssd1 vccd1 vccd1 sky130_fd_sc_hd__fill_1
XANTENNA__07020__A3 FPGA_INST.bus2_0\[15\] vssd1 vssd1 vccd1 vccd1 sky130_fd_sc_hd__diode_2
XFILLER_45_612 vssd1 vssd1 vccd1 vccd1 sky130_fd_sc_hd__fill_2
XPHY_EDGE_ROW_24_Left_155 vssd1 vssd1 vccd1 vccd1 sky130_fd_sc_hd__decap_3
X_11942_ net913 _01288_ net697 vssd1 vssd1 vccd1 vccd1 FPGA_INST.cell3.CB_1.config_dataB\[7\]
+ sky130_fd_sc_hd__dfstp_1
XANTENNA__07859__A2 FPGA_INST.bus3_1\[6\] vssd1 vssd1 vccd1 vccd1 sky130_fd_sc_hd__diode_2
X_11873_ net927 _01219_ net711 vssd1 vssd1 vccd1 vccd1 FPGA_INST.cell3.LE_0A.config_data\[3\]
+ sky130_fd_sc_hd__dfrtp_1
X_10824_ net832 _00174_ net616 vssd1 vssd1 vccd1 vccd1 FPGA_INST.cell1.SB0.route_sel\[33\]
+ sky130_fd_sc_hd__dfstp_1
XFILLER_13_553 vssd1 vssd1 vccd1 vccd1 sky130_fd_sc_hd__fill_2
X_10755_ net889 _00105_ net673 vssd1 vssd1 vccd1 vccd1 FPGA_INST.cell2.LE_1A.config_data\[10\]
+ sky130_fd_sc_hd__dfrtp_1
XTAP_TAPCELL_ROW_43_879 vssd1 vccd1 sky130_fd_sc_hd__tapvpwrvgnd_1
XFILLER_9_513 vssd1 vssd1 vccd1 vccd1 sky130_fd_sc_hd__fill_1
X_10686_ net880 _00036_ net665 vssd1 vssd1 vccd1 vccd1 FPGA_INST.cell2.LEI0.config_data\[35\]
+ sky130_fd_sc_hd__dfrtp_1
XTAP_TAPCELL_ROW_97_1642 vssd1 vccd1 sky130_fd_sc_hd__tapvpwrvgnd_1
XPHY_EDGE_ROW_33_Left_164 vssd1 vssd1 vccd1 vccd1 sky130_fd_sc_hd__decap_3
X_11307_ net830 _00657_ net614 vssd1 vssd1 vccd1 vccd1 FPGA_INST.cell1.CB_0.config_dataA\[24\]
+ sky130_fd_sc_hd__dfstp_1
XFILLER_5_752 vssd1 vssd1 vccd1 vccd1 sky130_fd_sc_hd__fill_1
XFILLER_4_240 vccd1 vssd1 vccd1 vssd1 sky130_ef_sc_hd__decap_40_12
XFILLER_107_691 vssd1 vssd1 vccd1 vccd1 sky130_fd_sc_hd__fill_4
X_11238_ net766 _00588_ net551 vssd1 vssd1 vccd1 vccd1 FPGA_INST.cell0.SB0.route_sel\[83\]
+ sky130_fd_sc_hd__dfstp_1
X_11169_ net788 _00519_ net573 vssd1 vssd1 vccd1 vccd1 FPGA_INST.cell0.SB0.route_sel\[14\]
+ sky130_fd_sc_hd__dfstp_1
XFILLER_96_82 vssd1 vssd1 vccd1 vccd1 sky130_fd_sc_hd__fill_2
XFILLER_95_567 vssd1 vssd1 vccd1 vccd1 sky130_fd_sc_hd__fill_2
XPHY_EDGE_ROW_42_Left_173 vssd1 vssd1 vccd1 vccd1 sky130_fd_sc_hd__decap_3
XTAP_TAPCELL_ROW_124_2016 vssd1 vccd1 sky130_fd_sc_hd__tapvpwrvgnd_1
XFILLER_48_472 vssd1 vssd1 vccd1 vccd1 sky130_fd_sc_hd__fill_1
XFILLER_82_228 vssd1 vssd1 vccd1 vccd1 sky130_fd_sc_hd__fill_2
X_05730_ _02009_ _02007_ vssd1 vssd1 vccd1 vccd1 _02010_ sky130_fd_sc_hd__and2b_4
XFILLER_36_645 vssd1 vssd1 vccd1 vccd1 sky130_fd_sc_hd__fill_2
X_05661_ FPGA_INST.cell2.SB0.route_sel\[100\] FPGA_INST.cell2.SB0.route_sel\[101\]
+ _01940_ vssd1 vssd1 vccd1 vccd1 _01941_ sky130_fd_sc_hd__a21o_1
XTAP_TAPCELL_ROW_106_1771 vssd1 vccd1 sky130_fd_sc_hd__tapvpwrvgnd_1
XTAP_TAPCELL_ROW_106_1760 vssd1 vccd1 sky130_fd_sc_hd__tapvpwrvgnd_1
X_07400_ FPGA_INST.cell3.SB0.route_sel\[42\] FPGA_INST.cell3.SB0.route_sel\[43\] _03654_
+ _03658_ _03633_ vssd1 vssd1 vccd1 vccd1 _03659_ sky130_fd_sc_hd__a41o_1
XFILLER_51_615 vssd1 vssd1 vccd1 vccd1 sky130_fd_sc_hd__fill_1
X_08380_ FPGA_INST.cell0.LEI0.config_data\[35\] _04601_ vssd1 vssd1 vccd1 vccd1 _04602_
+ sky130_fd_sc_hd__nand2b_1
XFILLER_23_328 vssd1 vssd1 vccd1 vccd1 sky130_fd_sc_hd__fill_8
X_07331_ FPGA_INST.cell1.CB_0.config_dataA\[23\] FPGA_INST.cell1.CB_0.config_dataA\[22\]
+ vssd1 vssd1 vccd1 vccd1 _03591_ sky130_fd_sc_hd__nand2b_2
XFILLER_90_294 vssd1 vssd1 vccd1 vccd1 sky130_fd_sc_hd__fill_2
X_05592_ _01782_ _01817_ _01871_ vssd1 vssd1 vccd1 vccd1 _01872_ sky130_fd_sc_hd__or3_1
XANTENNA__08293__B _04040_ vssd1 vssd1 vccd1 vccd1 sky130_fd_sc_hd__diode_2
X_07262_ FPGA_INST.cell3.SB0.route_sel\[22\] FPGA_INST.cell3.SB0.route_sel\[23\] net129
+ _02399_ vssd1 vssd1 vccd1 vccd1 _03524_ sky130_fd_sc_hd__a22o_1
XPHY_EDGE_ROW_51_Left_182 vssd1 vssd1 vccd1 vccd1 sky130_fd_sc_hd__decap_3
X_09001_ FPGA_INST.cell3.SB0.route_sel\[38\] FPGA_INST.cell3.SB0.route_sel\[39\] vssd1
+ vssd1 vccd1 vccd1 _05174_ sky130_fd_sc_hd__nor2_1
X_07193_ net146 _03400_ _03453_ _03452_ vssd1 vssd1 vccd1 vccd1 _03456_ sky130_fd_sc_hd__a31o_1
X_06213_ FPGA_INST.cell2.CB_0.config_dataA\[6\] _02490_ _02492_ vssd1 vssd1 vccd1
+ vccd1 _02493_ sky130_fd_sc_hd__a21o_1
XANTENNA__08580__Y _04789_ vssd1 vssd1 vccd1 vccd1 sky130_fd_sc_hd__diode_2
X_06144_ _02415_ _02422_ _02423_ vssd1 vssd1 vccd1 vccd1 _02424_ sky130_fd_sc_hd__a21oi_1
XFILLER_105_617 vssd1 vssd1 vccd1 vccd1 sky130_fd_sc_hd__fill_8
XFILLER_116_15 vccd1 vssd1 vccd1 vssd1 sky130_ef_sc_hd__decap_40_12
X_06075_ FPGA_INST.cell2.SB0.route_sel\[24\] FPGA_INST.cell2.SB0.route_sel\[25\] vssd1
+ vssd1 vccd1 vccd1 _02355_ sky130_fd_sc_hd__nand2_1
XFILLER_113_650 vssd1 vssd1 vccd1 vccd1 sky130_fd_sc_hd__fill_2
XFILLER_98_350 vssd1 vssd1 vccd1 vccd1 sky130_fd_sc_hd__fill_1
Xfanout514 net515 vssd1 vssd1 vccd1 vccd1 net514 sky130_fd_sc_hd__buf_2
Xfanout503 FPGA_INST.cell2.CB_0.config_dataA\[10\] vssd1 vssd1 vccd1 vccd1 net503
+ sky130_fd_sc_hd__buf_2
X_09903_ FPGA_INST.cell0.LE_0B.config_data\[7\] FPGA_INST.cell0.LE_0B.config_data\[8\]
+ net178 vssd1 vssd1 vccd1 vccd1 _00809_ sky130_fd_sc_hd__mux2_1
Xfanout525 _01781_ vssd1 vssd1 vccd1 vccd1 net525 sky130_fd_sc_hd__clkbuf_4
XPHY_EDGE_ROW_60_Left_191 vssd1 vssd1 vccd1 vccd1 sky130_fd_sc_hd__decap_3
XFILLER_58_203 vssd1 vssd1 vccd1 vccd1 sky130_fd_sc_hd__fill_1
Xfanout536 net538 vssd1 vssd1 vccd1 vccd1 net536 sky130_fd_sc_hd__clkbuf_4
X_09834_ FPGA_INST.cell0.LEI0.config_data\[12\] FPGA_INST.cell0.LEI0.config_data\[13\]
+ net174 vssd1 vssd1 vccd1 vccd1 _00742_ sky130_fd_sc_hd__mux2_1
Xfanout547 net554 vssd1 vssd1 vccd1 vccd1 net547 sky130_fd_sc_hd__clkbuf_2
XANTENNA__06210__A1 net4 vssd1 vssd1 vccd1 vccd1 sky130_fd_sc_hd__diode_2
Xfanout558 net575 vssd1 vssd1 vccd1 vccd1 net558 sky130_fd_sc_hd__clkbuf_2
Xfanout569 net574 vssd1 vssd1 vccd1 vccd1 net569 sky130_fd_sc_hd__clkbuf_4
X_09765_ FPGA_INST.cell1.CB_0.config_dataB\[16\] net452 net346 vssd1 vssd1 vccd1 vccd1
+ _00674_ sky130_fd_sc_hd__mux2_1
XFILLER_86_589 vssd1 vssd1 vccd1 vccd1 sky130_fd_sc_hd__fill_2
XFILLER_74_729 vssd1 vssd1 vccd1 vccd1 sky130_fd_sc_hd__fill_2
XANTENNA__06761__A2 FPGA_INST.bus3_2\[6\] vssd1 vssd1 vccd1 vccd1 sky130_fd_sc_hd__diode_2
X_06977_ FPGA_INST.cell0.LE_0B.config_data\[16\] _03242_ _03243_ net155 vssd1 vssd1
+ vccd1 vccd1 FPGA_INST.cell0.CB_0.le_outB sky130_fd_sc_hd__o211a_1
XANTENNA_fanout562_A net563 vssd1 vssd1 vccd1 vccd1 sky130_fd_sc_hd__diode_2
X_08716_ net394 _04822_ vssd1 vssd1 vccd1 vccd1 _04925_ sky130_fd_sc_hd__nand2_1
XTAP_TAPCELL_ROW_68_1232 vssd1 vccd1 sky130_fd_sc_hd__tapvpwrvgnd_1
X_09696_ FPGA_INST.cell0.SB0.route_sel\[100\] FPGA_INST.cell0.SB0.route_sel\[99\]
+ net320 vssd1 vssd1 vccd1 vccd1 _00605_ sky130_fd_sc_hd__mux2_1
X_05928_ _01903_ _02207_ vssd1 vssd1 vccd1 vccd1 _02208_ sky130_fd_sc_hd__nand2_1
XFILLER_39_472 vssd1 vssd1 vccd1 vccd1 sky130_fd_sc_hd__fill_1
XFILLER_39_494 vssd1 vssd1 vccd1 vccd1 sky130_fd_sc_hd__fill_4
XFILLER_92_29 vssd1 vssd1 vccd1 vccd1 sky130_fd_sc_hd__fill_4
X_08647_ FPGA_INST.cell3.CB_0.config_dataA\[3\] _04853_ _04855_ _04815_ vssd1 vssd1
+ vccd1 vccd1 _04856_ sky130_fd_sc_hd__o211ai_2
X_05859_ net168 net162 FPGA_INST.bus2_0\[8\] vssd1 vssd1 vccd1 vccd1 _02139_ sky130_fd_sc_hd__o21ba_1
XANTENNA_fanout350_X net350 vssd1 vssd1 vccd1 vccd1 sky130_fd_sc_hd__diode_2
XTAP_TAPCELL_ROW_81_1410 vssd1 vccd1 sky130_fd_sc_hd__tapvpwrvgnd_1
XANTENNA_fanout827_A net831 vssd1 vssd1 vccd1 vccd1 sky130_fd_sc_hd__diode_2
XANTENNA__06513__A2 FPGA_INST.bus3_2\[6\] vssd1 vssd1 vccd1 vccd1 sky130_fd_sc_hd__diode_2
XFILLER_54_475 vssd1 vssd1 vccd1 vccd1 sky130_fd_sc_hd__fill_1
XTAP_TAPCELL_ROW_1_298 vssd1 vccd1 sky130_fd_sc_hd__tapvpwrvgnd_1
XFILLER_25_23 vssd1 vssd1 vccd1 vccd1 sky130_fd_sc_hd__fill_4
XTAP_TAPCELL_ROW_81_1421 vssd1 vccd1 sky130_fd_sc_hd__tapvpwrvgnd_1
X_08578_ FPGA_INST.cell3.SB0.route_sel\[74\] FPGA_INST.cell3.SB0.route_sel\[75\] vssd1
+ vssd1 vccd1 vccd1 _04787_ sky130_fd_sc_hd__nor2_1
XANTENNA__06556__X _02832_ vssd1 vssd1 vccd1 vccd1 sky130_fd_sc_hd__diode_2
X_07529_ _03783_ net92 _03782_ vssd1 vssd1 vccd1 vccd1 _03785_ sky130_fd_sc_hd__mux2_1
XANTENNA__08266__A2 FPGA_INST.bus1_0\[2\] vssd1 vssd1 vccd1 vccd1 sky130_fd_sc_hd__diode_2
XANTENNA_fanout615_X net615 vssd1 vssd1 vccd1 vccd1 sky130_fd_sc_hd__diode_2
XFILLER_41_169 vssd1 vssd1 vccd1 vccd1 sky130_fd_sc_hd__fill_2
XFILLER_22_383 vssd1 vssd1 vccd1 vccd1 sky130_fd_sc_hd__fill_2
X_10540_ FPGA_INST.cell2.SB0.route_sel\[112\] FPGA_INST.cell2.SB0.route_sel\[113\]
+ net239 vssd1 vssd1 vccd1 vccd1 _01419_ sky130_fd_sc_hd__mux2_1
XTAP_TAPCELL_ROW_40_838 vssd1 vccd1 sky130_fd_sc_hd__tapvpwrvgnd_1
XTAP_TAPCELL_ROW_40_849 vssd1 vccd1 sky130_fd_sc_hd__tapvpwrvgnd_1
XFILLER_41_22 vssd1 vssd1 vccd1 vccd1 sky130_fd_sc_hd__fill_8
X_10471_ FPGA_INST.cell2.SB0.route_sel\[44\] FPGA_INST.cell2.SB0.route_sel\[43\] net353
+ vssd1 vssd1 vccd1 vccd1 _01350_ sky130_fd_sc_hd__mux2_1
X_12210_ FPGA_INST.cfg_done vssd1 vssd1 vccd1 vccd1 net69 sky130_fd_sc_hd__clkbuf_1
XTAP_TAPCELL_ROW_20_562 vssd1 vccd1 sky130_fd_sc_hd__tapvpwrvgnd_1
XFILLER_108_477 vssd1 vssd1 vccd1 vccd1 sky130_fd_sc_hd__fill_1
XTAP_TAPCELL_ROW_79_1394 vssd1 vccd1 sky130_fd_sc_hd__tapvpwrvgnd_1
XTAP_TAPCELL_ROW_79_1383 vssd1 vccd1 sky130_fd_sc_hd__tapvpwrvgnd_1
XANTENNA__07777__A1 _03542_ vssd1 vssd1 vccd1 vccd1 sky130_fd_sc_hd__diode_2
XANTENNA__08423__S _04544_ vssd1 vssd1 vccd1 vccd1 sky130_fd_sc_hd__diode_2
X_12141_ net941 _01487_ net725 vssd1 vssd1 vccd1 vccd1 FPGA_INST.cell3.CB_1.config_dataA\[3\]
+ sky130_fd_sc_hd__dfstp_1
XFILLER_2_722 vssd1 vssd1 vccd1 vccd1 sky130_fd_sc_hd__fill_8
XFILLER_123_447 vssd1 vssd1 vccd1 vccd1 sky130_fd_sc_hd__fill_1
XTAP_TAPCELL_ROW_92_1572 vssd1 vccd1 sky130_fd_sc_hd__tapvpwrvgnd_1
X_12072_ net853 _01418_ net638 vssd1 vssd1 vccd1 vccd1 FPGA_INST.cell2.SB0.route_sel\[112\]
+ sky130_fd_sc_hd__dfstp_1
X_11023_ net807 _00373_ net592 vssd1 vssd1 vccd1 vccd1 FPGA_INST.cell1.LEI0.config_data\[8\]
+ sky130_fd_sc_hd__dfrtp_1
XFILLER_49_225 vccd1 vssd1 vccd1 vssd1 sky130_ef_sc_hd__decap_40_12
XFILLER_1_287 vssd1 vssd1 vccd1 vccd1 sky130_fd_sc_hd__fill_1
XFILLER_2_49 vssd1 vssd1 vccd1 vccd1 sky130_fd_sc_hd__fill_4
XANTENNA__06201__A1 net30 vssd1 vssd1 vccd1 vccd1 sky130_fd_sc_hd__diode_2
XFILLER_64_206 vssd1 vssd1 vccd1 vccd1 sky130_fd_sc_hd__fill_2
XTAP_TAPCELL_ROW_48_949 vssd1 vccd1 sky130_fd_sc_hd__tapvpwrvgnd_1
XFILLER_17_111 vssd1 vssd1 vccd1 vccd1 sky130_fd_sc_hd__fill_1
XANTENNA__08946__X FPGA_INST.bus2_0\[10\] vssd1 vssd1 vccd1 vccd1 sky130_fd_sc_hd__diode_2
X_11925_ net944 _01271_ net728 vssd1 vssd1 vccd1 vccd1 FPGA_INST.cell3.LE_1A.config_data\[11\]
+ sky130_fd_sc_hd__dfrtp_1
XANTENNA__11511__CLK net769 vssd1 vssd1 vccd1 vccd1 sky130_fd_sc_hd__diode_2
XFILLER_17_122 vssd1 vssd1 vccd1 vccd1 sky130_fd_sc_hd__fill_2
XFILLER_122_91 vssd1 vssd1 vccd1 vccd1 sky130_fd_sc_hd__fill_1
XTAP_TAPCELL_ROW_28_673 vssd1 vccd1 sky130_fd_sc_hd__tapvpwrvgnd_1
X_11856_ net915 _01202_ net699 vssd1 vssd1 vccd1 vccd1 FPGA_INST.cell3.LEI0.config_data\[36\]
+ sky130_fd_sc_hd__dfrtp_1
XANTENNA__05712__B1 FPGA_INST.bus3_2\[13\] vssd1 vssd1 vccd1 vccd1 sky130_fd_sc_hd__diode_2
X_10807_ net828 _00157_ net612 vssd1 vssd1 vccd1 vccd1 FPGA_INST.cell1.SB0.route_sel\[16\]
+ sky130_fd_sc_hd__dfstp_1
X_11787_ net890 _01133_ net674 vssd1 vssd1 vccd1 vccd1 FPGA_INST.io_south_oeb\[26\]
+ sky130_fd_sc_hd__dfrtp_1
XFILLER_119_709 vssd1 vssd1 vccd1 vccd1 sky130_fd_sc_hd__fill_2
XANTENNA__07465__B1 _02182_ vssd1 vssd1 vccd1 vccd1 sky130_fd_sc_hd__diode_2
XFILLER_9_343 vssd1 vssd1 vccd1 vccd1 sky130_fd_sc_hd__fill_1
X_10738_ net874 _00088_ net658 vssd1 vssd1 vccd1 vccd1 FPGA_INST.cell2.LE_0B.config_data\[15\]
+ sky130_fd_sc_hd__dfrtp_1
XTAP_TAPCELL_ROW_101_1690 vssd1 vccd1 sky130_fd_sc_hd__tapvpwrvgnd_1
XPHY_EDGE_ROW_124_Right_124 vssd1 vssd1 vccd1 vccd1 sky130_fd_sc_hd__decap_3
XANTENNA__09429__S net355 vssd1 vssd1 vccd1 vccd1 sky130_fd_sc_hd__diode_2
X_10669_ net868 _00019_ net652 vssd1 vssd1 vccd1 vccd1 FPGA_INST.cell2.LEI0.config_data\[18\]
+ sky130_fd_sc_hd__dfrtp_1
XFILLER_114_425 vssd1 vssd1 vccd1 vccd1 sky130_fd_sc_hd__fill_2
XTAP_TAPCELL_ROW_130_2097 vssd1 vccd1 sky130_fd_sc_hd__tapvpwrvgnd_1
XFILLER_68_501 vssd1 vssd1 vccd1 vccd1 sky130_fd_sc_hd__fill_1
XTAP_TAPCELL_ROW_52_1011 vssd1 vccd1 sky130_fd_sc_hd__tapvpwrvgnd_1
X_06900_ net418 _01888_ _03167_ vssd1 vssd1 vccd1 vccd1 _03168_ sky130_fd_sc_hd__a21o_1
XANTENNA__08569__A net156 vssd1 vssd1 vccd1 vccd1 sky130_fd_sc_hd__diode_2
X_07880_ _04098_ _04103_ _04107_ _04093_ FPGA_INST.cell1.CB_0.config_dataA\[9\] vssd1
+ vssd1 vccd1 vccd1 _04108_ sky130_fd_sc_hd__a311o_1
XANTENNA__05545__X _01825_ vssd1 vssd1 vccd1 vccd1 sky130_fd_sc_hd__diode_2
XANTENNA__08193__A1 _03465_ vssd1 vssd1 vccd1 vccd1 sky130_fd_sc_hd__diode_2
XANTENNA__08193__B2 _03408_ vssd1 vssd1 vccd1 vccd1 sky130_fd_sc_hd__diode_2
XANTENNA__09164__S net358 vssd1 vssd1 vccd1 vccd1 sky130_fd_sc_hd__diode_2
XTAP_TAPCELL_ROW_108_1800 vssd1 vccd1 sky130_fd_sc_hd__tapvpwrvgnd_1
XANTENNA__07904__C _03769_ vssd1 vssd1 vccd1 vccd1 sky130_fd_sc_hd__diode_2
XFILLER_95_364 vssd1 vssd1 vccd1 vccd1 sky130_fd_sc_hd__fill_1
XFILLER_55_206 vssd1 vssd1 vccd1 vccd1 sky130_fd_sc_hd__fill_2
XANTENNA__06743__A2 net132 vssd1 vssd1 vccd1 vccd1 sky130_fd_sc_hd__diode_2
X_06831_ _02465_ _03094_ _03095_ _02429_ FPGA_INST.cell0.CB_0.config_dataB\[7\] vssd1
+ vssd1 vccd1 vccd1 _03099_ sky130_fd_sc_hd__a221o_1
XFILLER_28_409 vssd1 vssd1 vccd1 vccd1 sky130_fd_sc_hd__fill_2
X_09550_ FPGA_INST.cell1.LE_0B.reset_mode FPGA_INST.cell1.LE_1A.config_data\[0\] net213
+ vssd1 vssd1 vccd1 vccd1 _00459_ sky130_fd_sc_hd__mux2_1
XFILLER_110_697 vssd1 vssd1 vccd1 vccd1 sky130_fd_sc_hd__fill_2
XANTENNA__07940__A1 _03810_ vssd1 vssd1 vccd1 vccd1 sky130_fd_sc_hd__diode_2
XFILLER_83_548 vssd1 vssd1 vccd1 vccd1 sky130_fd_sc_hd__fill_1
XANTENNA__10103__S net364 vssd1 vssd1 vccd1 vccd1 sky130_fd_sc_hd__diode_2
X_06762_ _03034_ _03035_ FPGA_INST.cell2.CB_1.config_dataB\[12\] vssd1 vssd1 vccd1
+ vccd1 _03036_ sky130_fd_sc_hd__mux2_1
XFILLER_55_217 vssd1 vssd1 vccd1 vccd1 sky130_fd_sc_hd__fill_4
X_08501_ _04715_ FPGA_INST.cell1.LE_1B.dff_out FPGA_INST.cell1.LE_1B.config_data\[16\]
+ vssd1 vssd1 vccd1 vccd1 _04716_ sky130_fd_sc_hd__mux2_1
X_09481_ FPGA_INST.cell1.LEI0.config_data\[27\] FPGA_INST.cell1.LEI0.config_data\[28\]
+ net215 vssd1 vssd1 vccd1 vccd1 _00393_ sky130_fd_sc_hd__mux2_1
X_05713_ FPGA_INST.cell2.CB_1.config_dataA\[24\] FPGA_INST.cell2.CB_1.config_dataA\[21\]
+ FPGA_INST.cell2.CB_1.config_dataA\[20\] vssd1 vssd1 vccd1 vccd1 _01993_ sky130_fd_sc_hd__or3b_2
X_06693_ FPGA_INST.bus3_2\[12\] FPGA_INST.bus3_2\[13\] FPGA_INST.bus3_2\[14\] FPGA_INST.bus3_2\[15\]
+ net520 net519 vssd1 vssd1 vccd1 vccd1 _02967_ sky130_fd_sc_hd__mux4_1
X_08432_ FPGA_INST.cell2.SB0.route_sel\[122\] FPGA_INST.cell2.SB0.route_sel\[123\]
+ vssd1 vssd1 vccd1 vccd1 _04651_ sky130_fd_sc_hd__nand2b_1
XANTENNA__11432__RESET_B net561 vssd1 vssd1 vccd1 vccd1 sky130_fd_sc_hd__diode_2
X_05644_ FPGA_INST.cell0.CB_1.config_dataB\[24\] FPGA_INST.cell0.CB_1.config_dataB\[20\]
+ FPGA_INST.cell0.CB_1.config_dataB\[21\] vssd1 vssd1 vccd1 vccd1 _01924_ sky130_fd_sc_hd__or3_1
XANTENNA__08248__A2 _03840_ vssd1 vssd1 vccd1 vccd1 sky130_fd_sc_hd__diode_2
XTAP_TAPCELL_ROW_63_1162 vssd1 vccd1 sky130_fd_sc_hd__tapvpwrvgnd_1
X_08363_ net76 _04576_ _04577_ FPGA_INST.bus1_0\[13\] _01759_ vssd1 vssd1 vccd1 vccd1
+ _04585_ sky130_fd_sc_hd__a221o_1
X_05575_ _01841_ _01843_ _01844_ _01854_ vssd1 vssd1 vccd1 vccd1 _01855_ sky130_fd_sc_hd__a211o_1
X_07314_ _03543_ _03544_ _03545_ _03570_ _03574_ vssd1 vssd1 vccd1 vccd1 _03575_ sky130_fd_sc_hd__a32o_1
X_08294_ net445 _03997_ _04515_ net444 vssd1 vssd1 vccd1 vccd1 _04516_ sky130_fd_sc_hd__o211a_1
X_07245_ FPGA_INST.cell1.CB_1.config_dataA\[24\] FPGA_INST.cell1.CB_1.config_dataA\[20\]
+ FPGA_INST.cell1.CB_1.config_dataA\[21\] vssd1 vssd1 vccd1 vccd1 _03507_ sky130_fd_sc_hd__or3b_4
XTAP_TAPCELL_ROW_119_1951 vssd1 vccd1 sky130_fd_sc_hd__tapvpwrvgnd_1
XANTENNA_fanout310_A net315 vssd1 vssd1 vccd1 vccd1 sky130_fd_sc_hd__diode_2
X_07176_ net85 net18 _03436_ vssd1 vssd1 vccd1 vccd1 _03440_ sky130_fd_sc_hd__mux2_1
XFILLER_3_519 vssd1 vssd1 vccd1 vccd1 sky130_fd_sc_hd__fill_1
XFILLER_118_797 vssd1 vssd1 vccd1 vccd1 sky130_fd_sc_hd__fill_2
XANTENNA__06271__B _02376_ vssd1 vssd1 vccd1 vccd1 sky130_fd_sc_hd__diode_2
X_06127_ net123 net3 _02405_ vssd1 vssd1 vccd1 vccd1 _02407_ sky130_fd_sc_hd__mux2_1
XFILLER_105_458 vssd1 vssd1 vccd1 vccd1 sky130_fd_sc_hd__fill_4
XFILLER_78_309 vccd1 vssd1 vccd1 vssd1 sky130_ef_sc_hd__decap_40_12
X_06058_ net170 net157 vssd1 vssd1 vccd1 vccd1 _02338_ sky130_fd_sc_hd__nor2_1
Xfanout300 net306 vssd1 vssd1 vccd1 vccd1 net300 sky130_fd_sc_hd__clkbuf_4
Xfanout322 net324 vssd1 vssd1 vccd1 vccd1 net322 sky130_fd_sc_hd__clkbuf_4
Xfanout311 net315 vssd1 vssd1 vccd1 vccd1 net311 sky130_fd_sc_hd__clkbuf_4
XANTENNA_fanout777_A net778 vssd1 vssd1 vccd1 vccd1 sky130_fd_sc_hd__diode_2
Xfanout344 net349 vssd1 vssd1 vccd1 vccd1 net344 sky130_fd_sc_hd__clkbuf_4
Xfanout333 net337 vssd1 vssd1 vccd1 vccd1 net333 sky130_fd_sc_hd__clkbuf_4
XFILLER_101_642 vssd1 vssd1 vccd1 vccd1 sky130_fd_sc_hd__fill_1
XFILLER_101_631 vssd1 vssd1 vccd1 vccd1 sky130_fd_sc_hd__fill_1
Xfanout366 net367 vssd1 vssd1 vccd1 vccd1 net366 sky130_fd_sc_hd__buf_4
Xfanout355 net381 vssd1 vssd1 vccd1 vccd1 net355 sky130_fd_sc_hd__clkbuf_4
XTAP_TAPCELL_ROW_6_368 vssd1 vccd1 sky130_fd_sc_hd__tapvpwrvgnd_1
XANTENNA_fanout944_A net945 vssd1 vssd1 vccd1 vccd1 sky130_fd_sc_hd__diode_2
Xfanout377 net378 vssd1 vssd1 vccd1 vccd1 net377 sky130_fd_sc_hd__buf_2
X_09817_ FPGA_INST.cell1.LE_1B.reset_val FPGA_INST.cell1.LE_1B.edge_mode net336 vssd1
+ vssd1 vccd1 vccd1 _00726_ sky130_fd_sc_hd__mux2_1
Xfanout388 FPGA_INST.cell3.CB_0.config_dataB\[10\] vssd1 vssd1 vccd1 vccd1 net388
+ sky130_fd_sc_hd__buf_2
XFILLER_101_653 vssd1 vssd1 vccd1 vccd1 sky130_fd_sc_hd__fill_1
Xfanout399 FPGA_INST.cell3.CB_0.config_dataA\[5\] vssd1 vssd1 vccd1 vccd1 net399 sky130_fd_sc_hd__buf_2
XANTENNA__06195__B1 _02472_ vssd1 vssd1 vccd1 vccd1 sky130_fd_sc_hd__diode_2
XFILLER_47_729 vssd1 vssd1 vccd1 vccd1 sky130_fd_sc_hd__fill_2
XANTENNA__12107__SET_B net701 vssd1 vssd1 vccd1 vccd1 sky130_fd_sc_hd__diode_2
XFILLER_101_697 vssd1 vssd1 vccd1 vccd1 sky130_fd_sc_hd__fill_2
X_09748_ FPGA_INST.cell1.CB_0.config_dataA\[24\] FPGA_INST.cell1.CB_0.config_dataA\[23\]
+ net343 vssd1 vssd1 vccd1 vccd1 _00657_ sky130_fd_sc_hd__mux2_1
XANTENNA__10013__S net319 vssd1 vssd1 vccd1 vccd1 sky130_fd_sc_hd__diode_2
XANTENNA__05942__B1 net74 vssd1 vssd1 vccd1 vccd1 sky130_fd_sc_hd__diode_2
XTAP_TAPCELL_ROW_45_919 vssd1 vccd1 sky130_fd_sc_hd__tapvpwrvgnd_1
XTAP_TAPCELL_ROW_45_908 vssd1 vccd1 sky130_fd_sc_hd__tapvpwrvgnd_1
XFILLER_27_431 vssd1 vssd1 vccd1 vccd1 sky130_fd_sc_hd__fill_4
X_11710_ net919 _01056_ net703 vssd1 vssd1 vccd1 vccd1 FPGA_INST.cell3.SB0.route_sel\[80\]
+ sky130_fd_sc_hd__dfstp_1
XFILLER_70_710 vssd1 vssd1 vccd1 vccd1 sky130_fd_sc_hd__fill_4
X_09679_ FPGA_INST.cell0.SB0.route_sel\[82\] FPGA_INST.cell0.SB0.route_sel\[83\] net187
+ vssd1 vssd1 vccd1 vccd1 _00588_ sky130_fd_sc_hd__mux2_1
XFILLER_15_615 vssd1 vssd1 vccd1 vccd1 sky130_fd_sc_hd__fill_1
XFILLER_15_626 vssd1 vssd1 vccd1 vccd1 sky130_fd_sc_hd__fill_1
XANTENNA_fanout732_X net732 vssd1 vssd1 vccd1 vccd1 sky130_fd_sc_hd__diode_2
XFILLER_36_77 vssd1 vssd1 vccd1 vccd1 sky130_fd_sc_hd__fill_4
XANTENNA__07695__B1 net78 vssd1 vssd1 vccd1 vccd1 sky130_fd_sc_hd__diode_2
XANTENNA__08418__S _04574_ vssd1 vssd1 vccd1 vccd1 sky130_fd_sc_hd__diode_2
XTAP_TAPCELL_ROW_25_632 vssd1 vccd1 sky130_fd_sc_hd__tapvpwrvgnd_1
X_11641_ net893 _00987_ net677 vssd1 vssd1 vccd1 vccd1 FPGA_INST.cell3.SB0.route_sel\[11\]
+ sky130_fd_sc_hd__dfstp_1
XFILLER_42_489 vssd1 vssd1 vccd1 vccd1 sky130_fd_sc_hd__fill_4
X_11572_ net752 _00922_ net537 vssd1 vssd1 vccd1 vccd1 FPGA_INST.cell0.CB_0.config_dataB\[16\]
+ sky130_fd_sc_hd__dfstp_1
Xinput19 gpio_in[26] vssd1 vssd1 vccd1 vccd1 net19 sky130_fd_sc_hd__buf_2
X_10523_ FPGA_INST.cell2.SB0.route_sel\[95\] FPGA_INST.cell2.SB0.route_sel\[96\] net246
+ vssd1 vssd1 vccd1 vccd1 _01402_ sky130_fd_sc_hd__mux2_1
XFILLER_109_720 vssd1 vssd1 vccd1 vccd1 sky130_fd_sc_hd__fill_4
XFILLER_6_313 vssd1 vssd1 vccd1 vccd1 sky130_fd_sc_hd__fill_1
XFILLER_124_701 vssd1 vssd1 vccd1 vccd1 sky130_fd_sc_hd__fill_4
XTAP_TAPCELL_ROW_94_1601 vssd1 vccd1 sky130_fd_sc_hd__tapvpwrvgnd_1
X_10454_ FPGA_INST.cell2.SB0.route_sel\[26\] FPGA_INST.cell2.SB0.route_sel\[27\] net192
+ vssd1 vssd1 vccd1 vccd1 _01333_ sky130_fd_sc_hd__mux2_1
XFILLER_123_211 vssd1 vssd1 vccd1 vccd1 sky130_fd_sc_hd__fill_1
X_10385_ FPGA_INST.cell3.LE_1A.config_data\[3\] FPGA_INST.cell3.LE_1A.config_data\[4\]
+ net304 vssd1 vssd1 vccd1 vccd1 _01264_ sky130_fd_sc_hd__mux2_1
X_12124_ net937 _01470_ net721 vssd1 vssd1 vccd1 vccd1 FPGA_INST.cell3.CB_0.config_dataB\[11\]
+ sky130_fd_sc_hd__dfstp_2
XANTENNA__11309__SET_B net626 vssd1 vssd1 vccd1 vccd1 sky130_fd_sc_hd__diode_2
XANTENNA__08175__A1 FPGA_INST.bus1_0\[5\] vssd1 vssd1 vccd1 vccd1 sky130_fd_sc_hd__diode_2
X_12055_ net857 _01401_ net642 vssd1 vssd1 vccd1 vccd1 FPGA_INST.cell2.SB0.route_sel\[95\]
+ sky130_fd_sc_hd__dfstp_1
X_11006_ net923 _00356_ net707 vssd1 vssd1 vccd1 vccd1 FPGA_INST.cell2.LE_1B.config_data\[12\]
+ sky130_fd_sc_hd__dfrtp_1
X_11908_ net940 _01254_ net724 vssd1 vssd1 vccd1 vccd1 FPGA_INST.cell3.LE_0B.config_data\[16\]
+ sky130_fd_sc_hd__dfrtp_1
XTAP_TAPCELL_ROW_103_1730 vssd1 vccd1 sky130_fd_sc_hd__tapvpwrvgnd_1
XFILLER_60_220 vssd1 vssd1 vccd1 vccd1 sky130_fd_sc_hd__fill_4
XANTENNA__05812__Y _02092_ vssd1 vssd1 vccd1 vccd1 sky130_fd_sc_hd__diode_2
X_11839_ net932 _01185_ net716 vssd1 vssd1 vccd1 vccd1 FPGA_INST.cell3.LEI0.config_data\[19\]
+ sky130_fd_sc_hd__dfrtp_1
XFILLER_33_478 vssd1 vssd1 vccd1 vccd1 sky130_fd_sc_hd__fill_1
X_05360_ FPGA_INST.cell1.SB0.route_sel\[85\] vssd1 vssd1 vccd1 vccd1 _01642_ sky130_fd_sc_hd__inv_2
XFILLER_61_798 vssd1 vssd1 vccd1 vccd1 sky130_fd_sc_hd__fill_1
XFILLER_20_139 vssd1 vssd1 vccd1 vccd1 sky130_fd_sc_hd__fill_1
XANTENNA__10593__S net377 vssd1 vssd1 vccd1 vccd1 sky130_fd_sc_hd__diode_2
X_05291_ FPGA_INST.cell2.SB0.route_sel\[88\] vssd1 vssd1 vccd1 vccd1 _01573_ sky130_fd_sc_hd__inv_2
XANTENNA__06661__B2 _02801_ vssd1 vssd1 vccd1 vccd1 sky130_fd_sc_hd__diode_2
XANTENNA__06661__A1 _02804_ vssd1 vssd1 vccd1 vccd1 sky130_fd_sc_hd__diode_2
XFILLER_9_195 vssd1 vssd1 vccd1 vccd1 sky130_fd_sc_hd__fill_2
X_07030_ net437 _02191_ _03295_ vssd1 vssd1 vccd1 vccd1 _03296_ sky130_fd_sc_hd__a21o_1
XFILLER_127_572 vssd1 vssd1 vccd1 vccd1 sky130_fd_sc_hd__fill_1
XANTENNA__08402__A2 net74 vssd1 vssd1 vccd1 vccd1 sky130_fd_sc_hd__diode_2
XFILLER_130_737 vssd1 vssd1 vccd1 vccd1 sky130_fd_sc_hd__fill_1
XTAP_TAPCELL_ROW_114_1881 vssd1 vccd1 sky130_fd_sc_hd__tapvpwrvgnd_1
Xteam_15_958 vssd1 vssd1 vccd1 vccd1 team_15_958/HI gpio_oeb[24] sky130_fd_sc_hd__conb_1
X_08981_ _01560_ FPGA_INST.cell2.SB0.route_sel\[49\] FPGA_INST.cell2.SB0.route_sel\[54\]
+ FPGA_INST.cell2.SB0.route_sel\[55\] _05160_ vssd1 vssd1 vccd1 vccd1 _05161_ sky130_fd_sc_hd__o221a_1
Xteam_15_969 vssd1 vssd1 vccd1 vccd1 gpio_oeb[3] team_15_969/LO sky130_fd_sc_hd__conb_1
X_07932_ net467 _03568_ vssd1 vssd1 vccd1 vccd1 _04160_ sky130_fd_sc_hd__nand2_1
XANTENNA__08166__A1 FPGA_INST.bus1_0\[11\] vssd1 vssd1 vccd1 vccd1 sky130_fd_sc_hd__diode_2
X_07863_ _03613_ _04082_ _04083_ _03652_ vssd1 vssd1 vccd1 vccd1 _04091_ sky130_fd_sc_hd__o2bb2a_1
XFILLER_95_150 vssd1 vssd1 vccd1 vccd1 sky130_fd_sc_hd__fill_4
XFILLER_68_342 vssd1 vssd1 vccd1 vccd1 sky130_fd_sc_hd__fill_1
XTAP_TAPCELL_ROW_3_327 vssd1 vccd1 sky130_fd_sc_hd__tapvpwrvgnd_1
XFILLER_3_81 vssd1 vssd1 vccd1 vccd1 sky130_fd_sc_hd__fill_1
XFILLER_29_729 vssd1 vssd1 vccd1 vccd1 sky130_fd_sc_hd__fill_4
XFILLER_113_27 vccd1 vssd1 vccd1 vssd1 sky130_ef_sc_hd__decap_40_12
XFILLER_110_472 vssd1 vssd1 vccd1 vccd1 sky130_fd_sc_hd__fill_4
X_06814_ _03086_ _03087_ _03019_ vssd1 vssd1 vccd1 vccd1 _03088_ sky130_fd_sc_hd__mux2_1
X_09602_ FPGA_INST.cell0.SB0.route_sel\[5\] FPGA_INST.cell0.SB0.route_sel\[6\] net220
+ vssd1 vssd1 vccd1 vccd1 _00511_ sky130_fd_sc_hd__mux2_1
XANTENNA__05924__A0 net133 vssd1 vssd1 vccd1 vccd1 sky130_fd_sc_hd__diode_2
XFILLER_28_206 vssd1 vssd1 vccd1 vccd1 sky130_fd_sc_hd__fill_1
X_09533_ FPGA_INST.cell1.LE_0B.config_data\[5\] FPGA_INST.cell1.LE_0B.config_data\[6\]
+ net231 vssd1 vssd1 vccd1 vccd1 _00443_ sky130_fd_sc_hd__mux2_1
XFILLER_83_345 vssd1 vssd1 vccd1 vccd1 sky130_fd_sc_hd__fill_4
X_07794_ FPGA_INST.cell1.SB0.config_data_out FPGA_INST.cell1.SB0.route_sel\[126\]
+ _01880_ _04042_ _01881_ vssd1 vssd1 vccd1 vccd1 _04043_ sky130_fd_sc_hd__a221o_1
XFILLER_71_529 vccd1 vssd1 vccd1 vssd1 sky130_ef_sc_hd__decap_40_12
X_06745_ _03006_ _03015_ _03018_ vssd1 vssd1 vccd1 vccd1 _03019_ sky130_fd_sc_hd__a21oi_2
XANTENNA_fanout358_A net363 vssd1 vssd1 vccd1 vccd1 sky130_fd_sc_hd__diode_2
X_09464_ FPGA_INST.cell1.LEI0.config_data\[10\] FPGA_INST.cell1.LEI0.config_data\[11\]
+ net217 vssd1 vssd1 vccd1 vccd1 _00376_ sky130_fd_sc_hd__mux2_1
XFILLER_52_754 vssd1 vssd1 vccd1 vccd1 sky130_fd_sc_hd__fill_2
X_06676_ FPGA_INST.cell2.LE_1A.config_data\[11\] FPGA_INST.cell2.LE_1A.config_data\[10\]
+ _02878_ vssd1 vssd1 vccd1 vccd1 _02952_ sky130_fd_sc_hd__mux2_1
X_08415_ FPGA_INST.cell0.LE_1B.config_data\[1\] FPGA_INST.cell0.LE_1B.config_data\[0\]
+ _04574_ vssd1 vssd1 vccd1 vccd1 _04637_ sky130_fd_sc_hd__mux2_1
X_09395_ FPGA_INST.cell2.CB_0.config_dataB\[13\] FPGA_INST.cell2.CB_0.config_dataB\[14\]
+ net250 vssd1 vssd1 vccd1 vccd1 _00308_ sky130_fd_sc_hd__mux2_1
X_05627_ net125 _01857_ _01903_ vssd1 vssd1 vccd1 vccd1 _01907_ sky130_fd_sc_hd__or3b_1
X_08346_ FPGA_INST.cell0.CB_1.config_dataB\[3\] _04567_ vssd1 vssd1 vccd1 vccd1 _04568_
+ sky130_fd_sc_hd__nor2_1
XTAP_TAPCELL_ROW_50_977 vssd1 vccd1 sky130_fd_sc_hd__tapvpwrvgnd_1
X_05558_ FPGA_INST.cell0.SB0.route_sel\[116\] _01613_ _01614_ FPGA_INST.cell0.SB0.route_sel\[119\]
+ _01837_ vssd1 vssd1 vccd1 vccd1 _01838_ sky130_fd_sc_hd__a221o_1
X_05489_ FPGA_INST.cell3.CB_0.config_dataA\[17\] vssd1 vssd1 vccd1 vccd1 _01771_ sky130_fd_sc_hd__inv_2
XANTENNA__06101__B1 FPGA_INST.bus1_0\[2\] vssd1 vssd1 vccd1 vccd1 sky130_fd_sc_hd__diode_2
XTAP_TAPCELL_ROW_50_988 vssd1 vccd1 sky130_fd_sc_hd__tapvpwrvgnd_1
XFILLER_22_46 vssd1 vssd1 vccd1 vccd1 sky130_fd_sc_hd__fill_4
X_08277_ _04500_ _04499_ _04440_ vssd1 vssd1 vccd1 vccd1 _04501_ sky130_fd_sc_hd__mux2_1
XFILLER_106_701 vssd1 vssd1 vccd1 vccd1 sky130_fd_sc_hd__fill_8
X_07228_ _03446_ _03490_ vssd1 vssd1 vccd1 vccd1 _03491_ sky130_fd_sc_hd__nor2_1
X_07159_ FPGA_INST.cell3.SB0.route_sel\[5\] FPGA_INST.cell3.SB0.route_sel\[4\] _03403_
+ _03422_ _03417_ vssd1 vssd1 vccd1 vccd1 _03423_ sky130_fd_sc_hd__a221o_1
XANTENNA_fanout894_A net899 vssd1 vssd1 vccd1 vccd1 sky130_fd_sc_hd__diode_2
XTAP_TAPCELL_ROW_76_1342 vssd1 vccd1 sky130_fd_sc_hd__tapvpwrvgnd_1
XTAP_TAPCELL_ROW_76_1353 vssd1 vccd1 sky130_fd_sc_hd__tapvpwrvgnd_1
XFILLER_0_6 vccd1 vssd1 vccd1 vssd1 sky130_ef_sc_hd__decap_40_12
X_10170_ FPGA_INST.cell3.SB0.route_sel\[74\] FPGA_INST.cell3.SB0.route_sel\[75\] net275
+ vssd1 vssd1 vccd1 vccd1 _01051_ sky130_fd_sc_hd__mux2_1
XANTENNA__10924__CLK net851 vssd1 vssd1 vccd1 vccd1 sky130_fd_sc_hd__diode_2
Xfanout130 _01790_ vssd1 vssd1 vccd1 vccd1 net130 sky130_fd_sc_hd__clkbuf_4
XFILLER_78_139 vssd1 vssd1 vccd1 vccd1 sky130_fd_sc_hd__fill_1
Xfanout152 FPGA_INST.cell1.CB_0.le_outA vssd1 vssd1 vccd1 vccd1 net152 sky130_fd_sc_hd__clkbuf_2
Xfanout141 FPGA_INST.cell1.CB_1.le_outB vssd1 vssd1 vccd1 vccd1 net141 sky130_fd_sc_hd__buf_2
Xfanout174 net176 vssd1 vssd1 vccd1 vccd1 net174 sky130_fd_sc_hd__clkbuf_4
XANTENNA_fanout947_X net947 vssd1 vssd1 vccd1 vccd1 sky130_fd_sc_hd__diode_2
Xfanout196 net201 vssd1 vssd1 vccd1 vccd1 net196 sky130_fd_sc_hd__clkbuf_4
Xfanout185 net189 vssd1 vssd1 vccd1 vccd1 net185 sky130_fd_sc_hd__clkbuf_4
XFILLER_74_356 vssd1 vssd1 vccd1 vccd1 sky130_fd_sc_hd__fill_8
XANTENNA__05913__X _02193_ vssd1 vssd1 vccd1 vccd1 sky130_fd_sc_hd__diode_2
XPHY_EDGE_ROW_69_Right_69 vssd1 vssd1 vccd1 vccd1 sky130_fd_sc_hd__decap_3
XFILLER_43_798 vssd1 vssd1 vccd1 vccd1 sky130_fd_sc_hd__fill_1
XFILLER_42_275 vssd1 vssd1 vccd1 vccd1 sky130_fd_sc_hd__fill_4
X_11624_ net743 _00974_ net528 vssd1 vssd1 vccd1 vccd1 FPGA_INST.cell0.LE_1B.reset_val
+ sky130_fd_sc_hd__dfrtp_1
XANTENNA__05694__A2 net165 vssd1 vssd1 vccd1 vccd1 sky130_fd_sc_hd__diode_2
XFILLER_8_48 vssd1 vssd1 vccd1 vccd1 sky130_fd_sc_hd__fill_2
XANTENNA__08093__A0 FPGA_INST.bus3_1\[12\] vssd1 vssd1 vccd1 vccd1 sky130_fd_sc_hd__diode_2
XPHY_EDGE_ROW_7_Left_138 vssd1 vssd1 vccd1 vccd1 sky130_fd_sc_hd__decap_3
XFILLER_11_673 vccd1 vssd1 vccd1 vssd1 sky130_ef_sc_hd__decap_40_12
X_11555_ net778 _00905_ net557 vssd1 vssd1 vccd1 vccd1 FPGA_INST.cell0.CB_0.config_dataA\[24\]
+ sky130_fd_sc_hd__dfstp_2
XANTENNA__06643__B2 _02840_ vssd1 vssd1 vccd1 vccd1 sky130_fd_sc_hd__diode_2
XANTENNA__06643__A1 _02843_ vssd1 vssd1 vccd1 vccd1 sky130_fd_sc_hd__diode_2
X_11486_ net759 _00836_ net544 vssd1 vssd1 vccd1 vccd1 FPGA_INST.cell0.LE_1A.config_data\[13\]
+ sky130_fd_sc_hd__dfrtp_1
X_10506_ FPGA_INST.cell2.SB0.route_sel\[78\] FPGA_INST.cell2.SB0.route_sel\[79\] net260
+ vssd1 vssd1 vccd1 vccd1 _01385_ sky130_fd_sc_hd__mux2_1
XFILLER_7_677 vssd1 vssd1 vccd1 vccd1 sky130_fd_sc_hd__fill_1
X_10437_ FPGA_INST.cell2.SB0.route_sel\[9\] FPGA_INST.cell2.SB0.route_sel\[10\] net238
+ vssd1 vssd1 vccd1 vccd1 _01316_ sky130_fd_sc_hd__mux2_1
XPHY_EDGE_ROW_78_Right_78 vssd1 vssd1 vccd1 vccd1 sky130_fd_sc_hd__decap_3
X_10368_ FPGA_INST.cell3.LE_0B.config_data\[9\] FPGA_INST.cell3.LE_0B.config_data\[10\]
+ net301 vssd1 vssd1 vccd1 vccd1 _01248_ sky130_fd_sc_hd__mux2_1
XANTENNA__11570__SET_B net558 vssd1 vssd1 vccd1 vccd1 sky130_fd_sc_hd__diode_2
X_10299_ FPGA_INST.cell3.LEI0.config_data\[13\] FPGA_INST.cell3.LEI0.config_data\[14\]
+ net296 vssd1 vssd1 vccd1 vccd1 _01180_ sky130_fd_sc_hd__mux2_1
X_12107_ net917 _01453_ net701 vssd1 vssd1 vccd1 vccd1 FPGA_INST.cell3.CB_0.config_dataA\[19\]
+ sky130_fd_sc_hd__dfstp_1
XFILLER_78_651 vssd1 vssd1 vccd1 vccd1 sky130_fd_sc_hd__fill_1
X_12038_ net878 _01384_ net663 vssd1 vssd1 vccd1 vccd1 FPGA_INST.cell2.SB0.route_sel\[78\]
+ sky130_fd_sc_hd__dfstp_1
XFILLER_120_770 vssd1 vssd1 vccd1 vccd1 sky130_fd_sc_hd__fill_8
XANTENNA__09442__S net374 vssd1 vssd1 vccd1 vccd1 sky130_fd_sc_hd__diode_2
XFILLER_19_740 vccd1 vssd1 vccd1 vssd1 sky130_ef_sc_hd__decap_40_12
XANTENNA__10588__S net377 vssd1 vssd1 vccd1 vccd1 sky130_fd_sc_hd__diode_2
XANTENNA__12153__SET_B net730 vssd1 vssd1 vccd1 vccd1 sky130_fd_sc_hd__diode_2
XFILLER_92_197 vssd1 vssd1 vccd1 vccd1 sky130_fd_sc_hd__fill_4
XPHY_EDGE_ROW_87_Right_87 vssd1 vssd1 vccd1 vccd1 sky130_fd_sc_hd__decap_3
X_06530_ net480 _02798_ _02805_ vssd1 vssd1 vccd1 vccd1 _02806_ sky130_fd_sc_hd__a21o_1
X_06461_ net7 net8 net489 vssd1 vssd1 vccd1 vccd1 _02739_ sky130_fd_sc_hd__mux2_1
XANTENNA__08320__A1 net119 vssd1 vssd1 vccd1 vccd1 sky130_fd_sc_hd__diode_2
XFILLER_34_776 vssd1 vssd1 vccd1 vccd1 sky130_fd_sc_hd__fill_1
X_05412_ FPGA_INST.cell3.SB0.route_sel\[24\] vssd1 vssd1 vccd1 vccd1 _01694_ sky130_fd_sc_hd__inv_2
X_08200_ net409 _03875_ vssd1 vssd1 vccd1 vccd1 _04424_ sky130_fd_sc_hd__nand2_1
X_09180_ net524 _03090_ vssd1 vssd1 vccd1 vccd1 _05212_ sky130_fd_sc_hd__nor2_1
XTAP_TAPCELL_ROW_60_1121 vssd1 vccd1 sky130_fd_sc_hd__tapvpwrvgnd_1
X_06392_ FPGA_INST.cell2.CB_0.config_dataB\[3\] _02664_ _02665_ _02669_ vssd1 vssd1
+ vccd1 vccd1 _02670_ sky130_fd_sc_hd__o31a_1
X_08131_ net452 _04049_ vssd1 vssd1 vccd1 vccd1 _04357_ sky130_fd_sc_hd__nand2_1
X_05343_ FPGA_INST.cell3.SB0.route_sel\[97\] vssd1 vssd1 vccd1 vccd1 _01625_ sky130_fd_sc_hd__inv_2
XANTENNA__09030__X FPGA_INST.bus3_1\[1\] vssd1 vssd1 vccd1 vccd1 sky130_fd_sc_hd__diode_2
XTAP_TAPCELL_ROW_116_1910 vssd1 vccd1 sky130_fd_sc_hd__tapvpwrvgnd_1
X_08062_ net461 _04049_ vssd1 vssd1 vccd1 vccd1 _04288_ sky130_fd_sc_hd__nand2_1
X_05274_ FPGA_INST.cell2.SB0.route_sel\[32\] vssd1 vssd1 vccd1 vccd1 _01556_ sky130_fd_sc_hd__inv_2
XPHY_EDGE_ROW_96_Right_96 vssd1 vssd1 vccd1 vccd1 sky130_fd_sc_hd__decap_3
X_07013_ _01732_ _03248_ _03259_ _03276_ _03278_ vssd1 vssd1 vccd1 vccd1 _03279_ sky130_fd_sc_hd__o311a_2
XFILLER_108_38 vssd1 vssd1 vccd1 vccd1 sky130_fd_sc_hd__fill_1
XFILLER_108_27 vssd1 vssd1 vccd1 vccd1 sky130_fd_sc_hd__fill_1
XFILLER_88_415 vssd1 vssd1 vccd1 vccd1 sky130_fd_sc_hd__fill_4
XTAP_TAPCELL_ROW_58_1094 vssd1 vccd1 sky130_fd_sc_hd__tapvpwrvgnd_1
XFILLER_88_459 vssd1 vssd1 vccd1 vccd1 sky130_fd_sc_hd__fill_4
X_08964_ _02164_ _05149_ vssd1 vssd1 vccd1 vccd1 FPGA_INST.bus2_0\[8\] sky130_fd_sc_hd__and2_4
X_07915_ _03932_ _04117_ _04141_ _04142_ vssd1 vssd1 vccd1 vccd1 _04143_ sky130_fd_sc_hd__a211o_1
XTAP_TAPCELL_ROW_71_1272 vssd1 vccd1 sky130_fd_sc_hd__tapvpwrvgnd_1
XFILLER_130_589 vssd1 vssd1 vccd1 vccd1 sky130_fd_sc_hd__fill_1
X_08895_ FPGA_INST.cell3.LE_0B.config_data\[14\] FPGA_INST.cell3.LE_0B.config_data\[15\]
+ _05032_ vssd1 vssd1 vccd1 vccd1 _05102_ sky130_fd_sc_hd__mux2_1
XTAP_TAPCELL_ROW_71_1283 vssd1 vccd1 sky130_fd_sc_hd__tapvpwrvgnd_1
XFILLER_69_673 vssd1 vssd1 vccd1 vccd1 sky130_fd_sc_hd__fill_2
XFILLER_83_142 vccd1 vssd1 vccd1 vssd1 sky130_ef_sc_hd__decap_40_12
X_07846_ net123 _02413_ _02405_ vssd1 vssd1 vccd1 vccd1 _04077_ sky130_fd_sc_hd__mux2_1
XFILLER_83_164 vssd1 vssd1 vccd1 vccd1 sky130_fd_sc_hd__fill_4
X_07777_ _03542_ _03907_ net78 vssd1 vssd1 vccd1 vccd1 _04026_ sky130_fd_sc_hd__o21ai_1
XFILLER_17_35 vssd1 vssd1 vccd1 vccd1 sky130_fd_sc_hd__fill_1
XFILLER_37_570 vssd1 vssd1 vccd1 vccd1 sky130_fd_sc_hd__fill_4
X_09516_ FPGA_INST.cell1.LE_0A.config_data\[11\] FPGA_INST.cell1.LE_0A.config_data\[12\]
+ net228 vssd1 vssd1 vccd1 vccd1 _00427_ sky130_fd_sc_hd__mux2_1
X_06728_ FPGA_INST.bus3_2\[12\] FPGA_INST.bus3_2\[13\] FPGA_INST.bus3_2\[14\] FPGA_INST.bus3_2\[15\]
+ net517 net516 vssd1 vssd1 vccd1 vccd1 _03002_ sky130_fd_sc_hd__mux4_1
XFILLER_17_57 vssd1 vssd1 vccd1 vccd1 sky130_fd_sc_hd__fill_2
X_09447_ FPGA_INST.cell2.LE_1B.config_data\[15\] FPGA_INST.cell2.LE_1B.config_data\[16\]
+ net265 vssd1 vssd1 vccd1 vccd1 _00360_ sky130_fd_sc_hd__mux2_1
XANTENNA__08311__A1 FPGA_INST.bus1_0\[5\] vssd1 vssd1 vccd1 vccd1 sky130_fd_sc_hd__diode_2
X_06659_ net475 _02793_ net474 vssd1 vssd1 vccd1 vccd1 _02935_ sky130_fd_sc_hd__o21ai_1
XTAP_TAPCELL_ROW_35_771 vssd1 vccd1 sky130_fd_sc_hd__tapvpwrvgnd_1
XFILLER_8_419 vssd1 vssd1 vccd1 vccd1 sky130_fd_sc_hd__fill_1
XFILLER_12_459 vssd1 vssd1 vccd1 vccd1 sky130_fd_sc_hd__fill_2
X_09378_ FPGA_INST.cell2.CB_0.config_dataA\[21\] FPGA_INST.cell2.CB_0.config_dataA\[22\]
+ net239 vssd1 vssd1 vccd1 vccd1 _00291_ sky130_fd_sc_hd__mux2_1
XFILLER_33_45 vssd1 vssd1 vccd1 vccd1 sky130_fd_sc_hd__fill_2
XFILLER_40_757 vssd1 vssd1 vccd1 vccd1 sky130_fd_sc_hd__fill_4
X_08329_ FPGA_INST.bus1_0\[13\] _04547_ _04548_ net77 _01757_ vssd1 vssd1 vccd1 vccd1
+ _04551_ sky130_fd_sc_hd__a221o_1
X_11340_ net805 _00690_ net590 vssd1 vssd1 vccd1 vccd1 FPGA_INST.cell1.CB_1.config_dataA\[7\]
+ sky130_fd_sc_hd__dfstp_1
XANTENNA__06625__B2 _02819_ vssd1 vssd1 vccd1 vccd1 sky130_fd_sc_hd__diode_2
XANTENNA__07822__A0 _02010_ vssd1 vssd1 vccd1 vccd1 sky130_fd_sc_hd__diode_2
XFILLER_116_3 vccd1 vssd1 vccd1 vssd1 sky130_ef_sc_hd__decap_40_12
XFILLER_3_102 vssd1 vssd1 vccd1 vccd1 sky130_fd_sc_hd__fill_8
XFILLER_106_531 vssd1 vssd1 vccd1 vccd1 sky130_fd_sc_hd__fill_1
XANTENNA__09024__C1 net341 vssd1 vssd1 vccd1 vccd1 sky130_fd_sc_hd__diode_2
X_11271_ net784 _00621_ net569 vssd1 vssd1 vccd1 vccd1 FPGA_INST.cell0.SB0.route_sel\[116\]
+ sky130_fd_sc_hd__dfstp_1
XFILLER_3_124 vccd1 vssd1 vccd1 vssd1 sky130_ef_sc_hd__decap_40_12
XFILLER_3_113 vssd1 vssd1 vccd1 vccd1 sky130_fd_sc_hd__fill_2
X_10222_ FPGA_INST.cell3.SB0.route_sel\[126\] FPGA_INST.cell3.SB0.config_data_out
+ net274 vssd1 vssd1 vccd1 vccd1 _01103_ sky130_fd_sc_hd__mux2_1
X_10153_ FPGA_INST.cell3.SB0.route_sel\[57\] FPGA_INST.cell3.SB0.route_sel\[58\] net273
+ vssd1 vssd1 vccd1 vccd1 _01034_ sky130_fd_sc_hd__mux2_1
XFILLER_121_567 vssd1 vssd1 vccd1 vccd1 sky130_fd_sc_hd__fill_1
XTAP_TAPCELL_ROW_89_1522 vssd1 vccd1 sky130_fd_sc_hd__tapvpwrvgnd_1
XFILLER_59_161 vssd1 vssd1 vccd1 vccd1 sky130_fd_sc_hd__fill_4
X_10084_ FPGA_INST.cell0.LE_1B.config_data\[9\] FPGA_INST.cell0.LE_1B.config_data\[8\]
+ net307 vssd1 vssd1 vccd1 vccd1 _00965_ sky130_fd_sc_hd__mux2_1
XTAP_TAPCELL_ROW_89_1533 vssd1 vccd1 sky130_fd_sc_hd__tapvpwrvgnd_1
XFILLER_59_194 vssd1 vssd1 vccd1 vccd1 sky130_fd_sc_hd__fill_1
XFILLER_47_323 vssd1 vssd1 vccd1 vccd1 sky130_fd_sc_hd__fill_1
XANTENNA__09262__S net336 vssd1 vssd1 vccd1 vccd1 sky130_fd_sc_hd__diode_2
XFILLER_74_175 vssd1 vssd1 vccd1 vccd1 sky130_fd_sc_hd__fill_1
XFILLER_74_85 vssd1 vssd1 vccd1 vccd1 sky130_fd_sc_hd__fill_1
XANTENNA__08302__A1 _03797_ vssd1 vssd1 vccd1 vccd1 sky130_fd_sc_hd__diode_2
XANTENNA__08302__B2 _03759_ vssd1 vssd1 vccd1 vccd1 sky130_fd_sc_hd__diode_2
X_10986_ net860 _00336_ net646 vssd1 vssd1 vccd1 vccd1 FPGA_INST.cell2.CB_1.config_dataA\[17\]
+ sky130_fd_sc_hd__dfstp_2
XANTENNA__07105__A2 _01839_ vssd1 vssd1 vccd1 vccd1 sky130_fd_sc_hd__diode_2
XFILLER_31_702 vssd1 vssd1 vccd1 vccd1 sky130_fd_sc_hd__fill_2
XFILLER_43_584 vssd1 vssd1 vccd1 vccd1 sky130_fd_sc_hd__fill_2
XFILLER_30_212 vssd1 vssd1 vccd1 vccd1 sky130_fd_sc_hd__fill_2
XFILLER_30_223 vssd1 vssd1 vccd1 vccd1 sky130_fd_sc_hd__fill_1
X_11607_ net743 _00957_ net528 vssd1 vssd1 vccd1 vccd1 FPGA_INST.cell0.LE_1B.config_data\[1\]
+ sky130_fd_sc_hd__dfrtp_1
XTAP_TAPCELL_ROW_13_465 vssd1 vccd1 sky130_fd_sc_hd__tapvpwrvgnd_1
Xmax_cap105 _02420_ vssd1 vssd1 vccd1 vccd1 net105 sky130_fd_sc_hd__buf_1
X_11538_ net776 _00888_ net562 vssd1 vssd1 vccd1 vccd1 FPGA_INST.cell0.CB_0.config_dataA\[7\]
+ sky130_fd_sc_hd__dfstp_2
XFILLER_109_391 vssd1 vssd1 vccd1 vccd1 sky130_fd_sc_hd__fill_1
XANTENNA__08369__A1 net95 vssd1 vssd1 vccd1 vccd1 sky130_fd_sc_hd__diode_2
X_11469_ net753 _00819_ net538 vssd1 vssd1 vccd1 vccd1 FPGA_INST.cell0.LE_0B.reset_val
+ sky130_fd_sc_hd__dfrtp_1
XTAP_TAPCELL_ROW_111_1840 vssd1 vccd1 sky130_fd_sc_hd__tapvpwrvgnd_1
XFILLER_97_223 vssd1 vssd1 vccd1 vccd1 sky130_fd_sc_hd__fill_1
XANTENNA__07041__A1 FPGA_INST.bus2_0\[1\] vssd1 vssd1 vccd1 vccd1 sky130_fd_sc_hd__diode_2
XFILLER_31_3 vssd1 vssd1 vccd1 vccd1 sky130_fd_sc_hd__fill_2
X_07700_ net133 _01995_ _03950_ FPGA_INST.cell3.SB0.route_sel\[108\] FPGA_INST.cell3.SB0.route_sel\[109\]
+ vssd1 vssd1 vccd1 vccd1 _03951_ sky130_fd_sc_hd__o2111a_1
X_05961_ net100 _02239_ _02240_ vssd1 vssd1 vccd1 vccd1 _02241_ sky130_fd_sc_hd__a21oi_1
XTAP_TAPCELL_ROW_127_2058 vssd1 vccd1 sky130_fd_sc_hd__tapvpwrvgnd_1
X_08680_ FPGA_INST.cell3.LEI0.config_data\[14\] _04886_ _04888_ vssd1 vssd1 vccd1
+ vccd1 _04889_ sky130_fd_sc_hd__or3_1
XANTENNA__11428__SET_B net732 vssd1 vssd1 vccd1 vccd1 sky130_fd_sc_hd__diode_2
X_05892_ _01531_ _02169_ _02171_ _01813_ vssd1 vssd1 vccd1 vccd1 _02172_ sky130_fd_sc_hd__a211oi_1
X_07631_ FPGA_INST.cell1.SB0.route_sel\[90\] FPGA_INST.cell1.SB0.route_sel\[91\] _03878_
+ _03880_ vssd1 vssd1 vccd1 vccd1 _03884_ sky130_fd_sc_hd__a31oi_2
XFILLER_65_153 vssd1 vssd1 vccd1 vccd1 sky130_fd_sc_hd__fill_2
XANTENNA__09172__S net358 vssd1 vssd1 vccd1 vccd1 sky130_fd_sc_hd__diode_2
XANTENNA__07895__A3 FPGA_INST.bus3_1\[7\] vssd1 vssd1 vccd1 vccd1 sky130_fd_sc_hd__diode_2
XANTENNA__10111__S net364 vssd1 vssd1 vccd1 vccd1 sky130_fd_sc_hd__diode_2
X_07562_ _02118_ _03815_ _03816_ vssd1 vssd1 vccd1 vccd1 _03817_ sky130_fd_sc_hd__o21bai_1
XFILLER_53_337 vssd1 vssd1 vccd1 vccd1 sky130_fd_sc_hd__fill_2
X_09301_ FPGA_INST.cell1.SB0.route_sel\[72\] FPGA_INST.cell1.SB0.route_sel\[73\] net204
+ vssd1 vssd1 vccd1 vccd1 _00214_ sky130_fd_sc_hd__mux2_1
X_06513_ FPGA_INST.bus3_2\[4\] FPGA_INST.bus3_2\[5\] FPGA_INST.bus3_2\[6\] FPGA_INST.bus3_2\[7\]
+ FPGA_INST.cell2.CB_1.config_dataA\[5\] net480 vssd1 vssd1 vccd1 vccd1 _02789_ sky130_fd_sc_hd__mux4_1
X_07493_ net147 _03398_ _03747_ _03746_ vssd1 vssd1 vccd1 vccd1 _03749_ sky130_fd_sc_hd__a31o_1
XFILLER_80_189 vssd1 vssd1 vccd1 vccd1 sky130_fd_sc_hd__fill_1
XFILLER_21_212 vssd1 vssd1 vccd1 vccd1 sky130_fd_sc_hd__fill_1
XTAP_TAPCELL_ROW_122_1991 vssd1 vccd1 sky130_fd_sc_hd__tapvpwrvgnd_1
X_09232_ FPGA_INST.cell1.SB0.route_sel\[3\] FPGA_INST.cell1.SB0.route_sel\[4\] net222
+ vssd1 vssd1 vccd1 vccd1 _00145_ sky130_fd_sc_hd__mux2_1
X_06444_ FPGA_INST.cell2.CB_0.config_dataB\[14\] _02702_ _02718_ _02721_ FPGA_INST.cell2.LEI0.config_data\[29\]
+ vssd1 vssd1 vccd1 vccd1 _02722_ sky130_fd_sc_hd__o32a_1
XTAP_TAPCELL_ROW_32_730 vssd1 vccd1 sky130_fd_sc_hd__tapvpwrvgnd_1
XANTENNA__08057__A0 FPGA_INST.bus3_1\[8\] vssd1 vssd1 vccd1 vccd1 sky130_fd_sc_hd__diode_2
X_06375_ net498 _02413_ vssd1 vssd1 vccd1 vccd1 _02653_ sky130_fd_sc_hd__or2_1
X_09163_ FPGA_INST.cell2.LE_0B.config_data\[3\] FPGA_INST.cell2.LE_0B.config_data\[4\]
+ net254 vssd1 vssd1 vccd1 vccd1 _00077_ sky130_fd_sc_hd__mux2_1
XFILLER_21_278 vssd1 vssd1 vccd1 vccd1 sky130_fd_sc_hd__fill_2
X_08114_ FPGA_INST.bus3_1\[0\] FPGA_INST.bus3_1\[1\] FPGA_INST.bus3_1\[2\] FPGA_INST.bus3_1\[3\]
+ net451 net450 vssd1 vssd1 vccd1 vccd1 _04340_ sky130_fd_sc_hd__mux4_1
XANTENNA_fanout223_A net227 vssd1 vssd1 vccd1 vccd1 sky130_fd_sc_hd__diode_2
X_05326_ FPGA_INST.cell0.SB0.config_data_out vssd1 vssd1 vccd1 vccd1 _01608_ sky130_fd_sc_hd__inv_2
XANTENNA__06607__A1 FPGA_INST.bus3_2\[1\] vssd1 vssd1 vccd1 vccd1 sky130_fd_sc_hd__diode_2
X_09094_ FPGA_INST.cell2.LEI0.config_data\[8\] FPGA_INST.cell2.LEI0.config_data\[9\]
+ net262 vssd1 vssd1 vccd1 vccd1 _00010_ sky130_fd_sc_hd__mux2_1
X_08045_ _04269_ _04270_ FPGA_INST.cell1.CB_0.config_dataB\[2\] vssd1 vssd1 vccd1
+ vccd1 _04271_ sky130_fd_sc_hd__mux2_1
X_05257_ FPGA_INST.cell2.CB_0.config_dataB\[7\] vssd1 vssd1 vccd1 vccd1 _01539_ sky130_fd_sc_hd__inv_2
XTAP_TAPCELL_ROW_73_1301 vssd1 vccd1 sky130_fd_sc_hd__tapvpwrvgnd_1
XANTENNA__09347__S net324 vssd1 vssd1 vccd1 vccd1 sky130_fd_sc_hd__diode_2
XANTENNA__06560__A net241 vssd1 vssd1 vccd1 vccd1 sky130_fd_sc_hd__diode_2
XANTENNA_fanout592_A net596 vssd1 vssd1 vccd1 vccd1 sky130_fd_sc_hd__diode_2
XFILLER_88_234 vssd1 vssd1 vccd1 vccd1 sky130_fd_sc_hd__fill_2
XFILLER_88_212 vssd1 vssd1 vccd1 vccd1 sky130_fd_sc_hd__fill_1
X_09996_ net739 FPGA_INST.config_bits\[9\] _05237_ FPGA_INST.config_bits\[10\] vssd1
+ vssd1 vccd1 vccd1 _05243_ sky130_fd_sc_hd__a31o_1
XFILLER_103_545 vssd1 vssd1 vccd1 vccd1 sky130_fd_sc_hd__fill_1
XANTENNA_fanout380_X net380 vssd1 vssd1 vccd1 vccd1 sky130_fd_sc_hd__diode_2
X_08947_ FPGA_INST.cell3.SB0.route_sel\[86\] FPGA_INST.cell3.SB0.route_sel\[87\] vssd1
+ vssd1 vccd1 vccd1 _05138_ sky130_fd_sc_hd__nor2_1
XFILLER_76_418 vssd1 vssd1 vccd1 vccd1 sky130_fd_sc_hd__fill_2
XANTENNA__11275__CLK net789 vssd1 vssd1 vccd1 vccd1 sky130_fd_sc_hd__diode_2
X_08878_ _05083_ _05084_ FPGA_INST.cell3.CB_0.config_dataB\[18\] vssd1 vssd1 vccd1
+ vccd1 _05085_ sky130_fd_sc_hd__o21ba_1
XFILLER_56_153 vssd1 vssd1 vccd1 vccd1 sky130_fd_sc_hd__fill_4
X_07829_ FPGA_INST.cell2.CB_0.le_outA _04067_ _02049_ vssd1 vssd1 vccd1 vccd1 net54
+ sky130_fd_sc_hd__mux2_1
X_10840_ net829 _00190_ net613 vssd1 vssd1 vccd1 vccd1 FPGA_INST.cell1.SB0.route_sel\[49\]
+ sky130_fd_sc_hd__dfstp_1
XFILLER_56_197 vssd1 vssd1 vccd1 vccd1 sky130_fd_sc_hd__fill_1
XANTENNA__10021__S net317 vssd1 vssd1 vccd1 vccd1 sky130_fd_sc_hd__diode_2
XPHY_EDGE_ROW_88_Left_219 vssd1 vssd1 vccd1 vccd1 sky130_fd_sc_hd__decap_3
XTAP_TAPCELL_ROW_84_1452 vssd1 vccd1 sky130_fd_sc_hd__tapvpwrvgnd_1
XFILLER_71_167 vssd1 vssd1 vccd1 vccd1 sky130_fd_sc_hd__fill_1
XANTENNA__08835__A2 net25 vssd1 vssd1 vccd1 vccd1 sky130_fd_sc_hd__diode_2
XTAP_TAPCELL_ROW_84_1463 vssd1 vccd1 sky130_fd_sc_hd__tapvpwrvgnd_1
X_10771_ net923 _00121_ net707 vssd1 vssd1 vccd1 vccd1 FPGA_INST.cell2.CB_1.config_dataB\[5\]
+ sky130_fd_sc_hd__dfstp_1
XFILLER_44_77 vssd1 vssd1 vccd1 vccd1 sky130_fd_sc_hd__fill_4
XFILLER_44_55 vssd1 vssd1 vccd1 vccd1 sky130_fd_sc_hd__fill_1
XANTENNA__07099__A1 FPGA_INST.bus2_0\[4\] vssd1 vssd1 vccd1 vccd1 sky130_fd_sc_hd__diode_2
XFILLER_13_713 vssd1 vssd1 vccd1 vccd1 sky130_fd_sc_hd__fill_1
XFILLER_40_554 vssd1 vssd1 vccd1 vccd1 sky130_fd_sc_hd__fill_4
XFILLER_100_83 vssd1 vssd1 vccd1 vccd1 sky130_fd_sc_hd__fill_1
XFILLER_60_54 vssd1 vssd1 vccd1 vccd1 sky130_fd_sc_hd__fill_1
XTAP_TAPCELL_ROW_10_424 vssd1 vccd1 sky130_fd_sc_hd__tapvpwrvgnd_1
X_11323_ net838 _00673_ net622 vssd1 vssd1 vccd1 vccd1 FPGA_INST.cell1.CB_0.config_dataB\[15\]
+ sky130_fd_sc_hd__dfstp_1
XPHY_EDGE_ROW_97_Left_228 vssd1 vssd1 vccd1 vccd1 sky130_fd_sc_hd__decap_3
XFILLER_4_411 vssd1 vssd1 vccd1 vccd1 sky130_fd_sc_hd__fill_8
XFILLER_125_169 vssd1 vssd1 vccd1 vccd1 sky130_fd_sc_hd__fill_4
XANTENNA__05821__A2 net165 vssd1 vssd1 vccd1 vccd1 sky130_fd_sc_hd__diode_2
X_11254_ net782 _00604_ net567 vssd1 vssd1 vccd1 vccd1 FPGA_INST.cell0.SB0.route_sel\[99\]
+ sky130_fd_sc_hd__dfstp_1
X_10205_ FPGA_INST.cell3.SB0.route_sel\[109\] FPGA_INST.cell3.SB0.route_sel\[110\]
+ net269 vssd1 vssd1 vccd1 vccd1 _01086_ sky130_fd_sc_hd__mux2_1
XFILLER_69_74 vssd1 vssd1 vccd1 vccd1 sky130_fd_sc_hd__fill_1
XFILLER_121_331 vssd1 vssd1 vccd1 vccd1 sky130_fd_sc_hd__fill_2
XANTENNA__08771__A1 net19 vssd1 vssd1 vccd1 vccd1 sky130_fd_sc_hd__diode_2
XANTENNA__08949__X FPGA_INST.bus3_1\[10\] vssd1 vssd1 vccd1 vccd1 sky130_fd_sc_hd__diode_2
X_11185_ net779 _00535_ net564 vssd1 vssd1 vccd1 vccd1 FPGA_INST.cell0.SB0.route_sel\[30\]
+ sky130_fd_sc_hd__dfstp_1
X_10136_ FPGA_INST.cell3.SB0.route_sel\[40\] FPGA_INST.cell3.SB0.route_sel\[41\] net279
+ vssd1 vssd1 vccd1 vccd1 _01017_ sky130_fd_sc_hd__mux2_1
XANTENNA__06782__A0 FPGA_INST.bus3_2\[12\] vssd1 vssd1 vccd1 vccd1 sky130_fd_sc_hd__diode_2
X_10067_ FPGA_INST.cell0.CB_1.config_dataA\[17\] net402 net328 vssd1 vssd1 vccd1 vccd1
+ _00948_ sky130_fd_sc_hd__mux2_1
XFILLER_85_73 vssd1 vssd1 vccd1 vccd1 sky130_fd_sc_hd__fill_2
XFILLER_90_421 vssd1 vssd1 vccd1 vccd1 sky130_fd_sc_hd__fill_4
XFILLER_35_315 vssd1 vssd1 vccd1 vccd1 sky130_fd_sc_hd__fill_1
XFILLER_35_337 vssd1 vssd1 vccd1 vccd1 sky130_fd_sc_hd__fill_1
XANTENNA__09079__A2 _04831_ vssd1 vssd1 vccd1 vccd1 sky130_fd_sc_hd__diode_2
XTAP_TAPCELL_ROW_18_535 vssd1 vccd1 sky130_fd_sc_hd__tapvpwrvgnd_1
XFILLER_90_487 vssd1 vssd1 vccd1 vccd1 sky130_fd_sc_hd__fill_4
X_10969_ net858 _00319_ net643 vssd1 vssd1 vccd1 vccd1 FPGA_INST.cell2.CB_1.config_dataA\[0\]
+ sky130_fd_sc_hd__dfstp_1
XANTENNA__05593__A_N FPGA_INST.cell0.CB_0.config_dataB\[24\] vssd1 vssd1 vccd1 vccd1
+ sky130_fd_sc_hd__diode_2
XFILLER_79_3 vccd1 vssd1 vccd1 vssd1 sky130_ef_sc_hd__decap_40_12
XANTENNA__06364__B _02092_ vssd1 vssd1 vccd1 vccd1 sky130_fd_sc_hd__diode_2
XFILLER_117_615 vssd1 vssd1 vccd1 vccd1 sky130_fd_sc_hd__fill_1
X_06160_ _02431_ _02433_ _02434_ _02439_ vssd1 vssd1 vccd1 vccd1 _02440_ sky130_fd_sc_hd__a211o_1
X_06091_ _02369_ _02370_ vssd1 vssd1 vccd1 vccd1 _02371_ sky130_fd_sc_hd__nand2_1
XFILLER_104_309 vssd1 vssd1 vccd1 vccd1 sky130_fd_sc_hd__fill_1
Xfanout718 net719 vssd1 vssd1 vccd1 vccd1 net718 sky130_fd_sc_hd__clkbuf_4
Xfanout729 net730 vssd1 vssd1 vccd1 vccd1 net729 sky130_fd_sc_hd__buf_2
XANTENNA__07763__X _04013_ vssd1 vssd1 vccd1 vccd1 sky130_fd_sc_hd__diode_2
Xfanout707 net715 vssd1 vssd1 vccd1 vccd1 net707 sky130_fd_sc_hd__clkbuf_4
XTAP_TAPCELL_ROW_55_1053 vssd1 vccd1 sky130_fd_sc_hd__tapvpwrvgnd_1
X_09850_ FPGA_INST.cell0.LEI0.config_data\[28\] FPGA_INST.cell0.LEI0.config_data\[29\]
+ net177 vssd1 vssd1 vccd1 vccd1 _00758_ sky130_fd_sc_hd__mux2_1
XANTENNA__06368__A3 net17 vssd1 vssd1 vccd1 vccd1 sky130_fd_sc_hd__diode_2
X_09781_ FPGA_INST.cell1.CB_1.config_dataA\[7\] FPGA_INST.cell1.CB_1.config_dataA\[6\]
+ net333 vssd1 vssd1 vccd1 vccd1 _00690_ sky130_fd_sc_hd__mux2_1
X_08801_ _01774_ _03703_ _04838_ _01775_ vssd1 vssd1 vccd1 vccd1 _05008_ sky130_fd_sc_hd__a31o_1
XFILLER_86_749 vssd1 vssd1 vccd1 vccd1 sky130_fd_sc_hd__fill_4
X_06993_ FPGA_INST.cell0.CB_0.config_dataA\[8\] FPGA_INST.cell0.CB_0.config_dataA\[7\]
+ vssd1 vssd1 vccd1 vccd1 _03259_ sky130_fd_sc_hd__or2_1
X_08732_ net393 _04938_ _04939_ _04940_ vssd1 vssd1 vccd1 vccd1 _04941_ sky130_fd_sc_hd__a31o_1
X_05944_ net112 _01825_ _02181_ vssd1 vssd1 vccd1 vccd1 _02224_ sky130_fd_sc_hd__nor3_1
XANTENNA__08514__A1 net84 vssd1 vssd1 vccd1 vccd1 sky130_fd_sc_hd__diode_2
X_08663_ _04819_ _04823_ FPGA_INST.cell3.CB_0.config_dataA\[5\] vssd1 vssd1 vccd1
+ vccd1 _04872_ sky130_fd_sc_hd__mux2_1
XTAP_TAPCELL_ROW_37_800 vssd1 vccd1 sky130_fd_sc_hd__tapvpwrvgnd_1
XANTENNA__07642__C _02079_ vssd1 vssd1 vccd1 vccd1 sky130_fd_sc_hd__diode_2
XFILLER_66_495 vssd1 vssd1 vccd1 vccd1 sky130_fd_sc_hd__fill_2
X_05875_ net129 _02152_ vssd1 vssd1 vccd1 vccd1 _02155_ sky130_fd_sc_hd__nand2_1
XANTENNA__06539__B _02814_ vssd1 vssd1 vccd1 vccd1 sky130_fd_sc_hd__diode_2
X_07614_ FPGA_INST.cell3.SB0.route_sel\[80\] FPGA_INST.cell3.SB0.route_sel\[81\] _01640_
+ FPGA_INST.cell3.SB0.route_sel\[83\] _03867_ vssd1 vssd1 vccd1 vccd1 _03868_ sky130_fd_sc_hd__o221a_1
X_08594_ FPGA_INST.cell3.SB0.route_sel\[114\] FPGA_INST.cell3.SB0.route_sel\[115\]
+ FPGA_INST.cell3.SB0.route_sel\[117\] _01611_ _04802_ vssd1 vssd1 vccd1 vccd1 _04803_
+ sky130_fd_sc_hd__o221a_1
XANTENNA_fanout340_A net341 vssd1 vssd1 vccd1 vccd1 sky130_fd_sc_hd__diode_2
XFILLER_81_476 vssd1 vssd1 vccd1 vccd1 sky130_fd_sc_hd__fill_2
X_07545_ _03468_ _03762_ net141 vssd1 vssd1 vccd1 vccd1 _03800_ sky130_fd_sc_hd__o21ai_1
XANTENNA__09630__S net196 vssd1 vssd1 vccd1 vccd1 sky130_fd_sc_hd__diode_2
X_07476_ net134 _02201_ _03732_ FPGA_INST.cell3.SB0.route_sel\[60\] FPGA_INST.cell3.SB0.route_sel\[61\]
+ vssd1 vssd1 vccd1 vccd1 _03733_ sky130_fd_sc_hd__o2111a_1
XANTENNA__06828__B2 _02309_ vssd1 vssd1 vccd1 vccd1 sky130_fd_sc_hd__diode_2
XFILLER_22_543 vssd1 vssd1 vccd1 vccd1 sky130_fd_sc_hd__fill_4
X_09215_ FPGA_INST.cell2.CB_1.config_dataB\[12\] FPGA_INST.cell2.CB_1.config_dataB\[11\]
+ net367 vssd1 vssd1 vccd1 vccd1 _00128_ sky130_fd_sc_hd__mux2_1
XFILLER_10_705 vssd1 vssd1 vccd1 vccd1 sky130_fd_sc_hd__fill_2
X_06427_ _02450_ _02692_ _02693_ _02487_ FPGA_INST.cell2.CB_0.config_dataB\[12\] vssd1
+ vssd1 vccd1 vccd1 _02705_ sky130_fd_sc_hd__a221o_1
XFILLER_10_749 vssd1 vssd1 vccd1 vccd1 sky130_fd_sc_hd__fill_4
XANTENNA__06274__B _02217_ vssd1 vssd1 vccd1 vccd1 sky130_fd_sc_hd__diode_2
X_09146_ FPGA_INST.cell2.LE_0A.config_data\[9\] FPGA_INST.cell2.LE_0A.config_data\[10\]
+ net252 vssd1 vssd1 vccd1 vccd1 _00061_ sky130_fd_sc_hd__mux2_1
X_06358_ net5 _02624_ _02635_ net493 _01539_ vssd1 vssd1 vccd1 vccd1 _02636_ sky130_fd_sc_hd__a221o_1
X_09077_ _03531_ _04819_ vssd1 vssd1 vccd1 vccd1 _05206_ sky130_fd_sc_hd__nand2_1
XANTENNA__08450__A0 net152 vssd1 vssd1 vccd1 vccd1 sky130_fd_sc_hd__diode_2
X_05309_ FPGA_INST.cell2.CB_1.config_dataA\[9\] vssd1 vssd1 vccd1 vccd1 _01591_ sky130_fd_sc_hd__inv_2
X_06289_ net139 net128 net131 net102 FPGA_INST.cell2.LEI0.config_data\[24\] FPGA_INST.cell2.LEI0.config_data\[25\]
+ vssd1 vssd1 vccd1 vccd1 _02569_ sky130_fd_sc_hd__mux4_1
X_08028_ net458 _04013_ net456 vssd1 vssd1 vccd1 vccd1 _04254_ sky130_fd_sc_hd__o21a_1
XFILLER_1_403 vssd1 vssd1 vccd1 vccd1 sky130_fd_sc_hd__fill_4
XANTENNA__10016__S net317 vssd1 vssd1 vccd1 vccd1 sky130_fd_sc_hd__diode_2
X_09979_ FPGA_INST.config_bits\[5\] _05221_ vssd1 vssd1 vccd1 vccd1 _05231_ sky130_fd_sc_hd__nor2_1
XFILLER_103_364 vssd1 vssd1 vccd1 vccd1 sky130_fd_sc_hd__fill_1
XANTENNA__07556__A2 _03810_ vssd1 vssd1 vccd1 vccd1 sky130_fd_sc_hd__diode_2
XFILLER_77_727 vssd1 vssd1 vccd1 vccd1 sky130_fd_sc_hd__fill_1
XANTENNA__07308__A2 _03568_ vssd1 vssd1 vccd1 vccd1 sky130_fd_sc_hd__diode_2
X_11941_ net913 _01287_ net697 vssd1 vssd1 vccd1 vccd1 FPGA_INST.cell3.CB_1.config_dataB\[6\]
+ sky130_fd_sc_hd__dfstp_1
XANTENNA__07859__A3 FPGA_INST.bus3_1\[7\] vssd1 vssd1 vccd1 vccd1 sky130_fd_sc_hd__diode_2
XFILLER_72_421 vssd1 vssd1 vccd1 vccd1 sky130_fd_sc_hd__fill_2
XFILLER_29_186 vssd1 vssd1 vccd1 vccd1 sky130_fd_sc_hd__fill_1
X_11872_ net927 _01218_ net711 vssd1 vssd1 vccd1 vccd1 FPGA_INST.cell3.LE_0A.config_data\[2\]
+ sky130_fd_sc_hd__dfrtp_1
XPHY_EDGE_ROW_105_Right_105 vssd1 vssd1 vccd1 vccd1 sky130_fd_sc_hd__decap_3
X_10823_ net824 _00173_ net608 vssd1 vssd1 vccd1 vccd1 FPGA_INST.cell1.SB0.route_sel\[32\]
+ sky130_fd_sc_hd__dfstp_1
XFILLER_72_498 vssd1 vssd1 vccd1 vccd1 sky130_fd_sc_hd__fill_1
X_10754_ net886 _00104_ net670 vssd1 vssd1 vccd1 vccd1 FPGA_INST.cell2.LE_1A.config_data\[9\]
+ sky130_fd_sc_hd__dfrtp_1
XFILLER_13_565 vssd1 vssd1 vccd1 vccd1 sky130_fd_sc_hd__fill_1
X_10685_ net880 _00035_ net665 vssd1 vssd1 vccd1 vccd1 FPGA_INST.cell2.LEI0.config_data\[34\]
+ sky130_fd_sc_hd__dfrtp_1
XTAP_TAPCELL_ROW_97_1643 vssd1 vccd1 sky130_fd_sc_hd__tapvpwrvgnd_1
XFILLER_126_467 vssd1 vssd1 vccd1 vccd1 sky130_fd_sc_hd__fill_4
X_11306_ net829 _00656_ net613 vssd1 vssd1 vccd1 vccd1 FPGA_INST.cell1.CB_0.config_dataA\[23\]
+ sky130_fd_sc_hd__dfstp_1
X_11237_ net766 _00587_ net551 vssd1 vssd1 vccd1 vccd1 FPGA_INST.cell0.SB0.route_sel\[82\]
+ sky130_fd_sc_hd__dfstp_1
X_11168_ net788 _00518_ net573 vssd1 vssd1 vccd1 vccd1 FPGA_INST.cell0.SB0.route_sel\[13\]
+ sky130_fd_sc_hd__dfstp_1
XFILLER_121_194 vssd1 vssd1 vccd1 vccd1 sky130_fd_sc_hd__fill_4
X_10119_ FPGA_INST.cell3.SB0.route_sel\[24\] FPGA_INST.cell3.SB0.route_sel\[23\] net364
+ vssd1 vssd1 vccd1 vccd1 _01000_ sky130_fd_sc_hd__mux2_1
XTAP_TAPCELL_ROW_124_2017 vssd1 vccd1 sky130_fd_sc_hd__tapvpwrvgnd_1
X_11099_ net841 _00449_ net625 vssd1 vssd1 vccd1 vccd1 FPGA_INST.cell1.LE_0B.config_data\[12\]
+ sky130_fd_sc_hd__dfrtp_1
XFILLER_76_793 vssd1 vssd1 vccd1 vccd1 sky130_fd_sc_hd__fill_4
X_05660_ FPGA_INST.cell2.SB0.route_sel\[98\] FPGA_INST.cell2.SB0.route_sel\[99\] vssd1
+ vssd1 vccd1 vccd1 _01940_ sky130_fd_sc_hd__nand2_1
XFILLER_36_679 vssd1 vssd1 vccd1 vccd1 sky130_fd_sc_hd__fill_1
XANTENNA__10596__S net300 vssd1 vssd1 vccd1 vccd1 sky130_fd_sc_hd__diode_2
XTAP_TAPCELL_ROW_106_1772 vssd1 vccd1 sky130_fd_sc_hd__tapvpwrvgnd_1
XTAP_TAPCELL_ROW_106_1761 vssd1 vccd1 sky130_fd_sc_hd__tapvpwrvgnd_1
XFILLER_90_262 vssd1 vssd1 vccd1 vccd1 sky130_fd_sc_hd__fill_4
X_05591_ FPGA_INST.cell0.CB_0.config_dataA\[24\] FPGA_INST.cell0.CB_0.config_dataA\[21\]
+ FPGA_INST.cell0.CB_0.config_dataA\[20\] vssd1 vssd1 vccd1 vccd1 _01871_ sky130_fd_sc_hd__nand3b_4
X_07330_ net82 _03428_ _03587_ _03588_ _03589_ vssd1 vssd1 vccd1 vccd1 _03590_ sky130_fd_sc_hd__o311a_1
X_07261_ _02398_ _02772_ _02400_ vssd1 vssd1 vccd1 vccd1 _03523_ sky130_fd_sc_hd__o21a_1
X_09000_ _05173_ _02289_ vssd1 vssd1 vccd1 vccd1 FPGA_INST.bus2_0\[4\] sky130_fd_sc_hd__and2b_4
X_07192_ _03400_ _03453_ vssd1 vssd1 vccd1 vccd1 _03455_ sky130_fd_sc_hd__nand2_1
X_06212_ net2 _01810_ _01811_ net30 _02491_ vssd1 vssd1 vccd1 vccd1 _02492_ sky130_fd_sc_hd__a221o_1
X_06143_ net117 _01967_ _02332_ _02416_ vssd1 vssd1 vccd1 vccd1 _02423_ sky130_fd_sc_hd__a31o_1
X_06074_ FPGA_INST.cell2.SB0.route_sel\[28\] FPGA_INST.cell2.SB0.route_sel\[29\] _02353_
+ vssd1 vssd1 vccd1 vccd1 _02354_ sky130_fd_sc_hd__a21o_1
XFILLER_116_27 vssd1 vssd1 vccd1 vccd1 sky130_fd_sc_hd__fill_1
XFILLER_104_139 vssd1 vssd1 vccd1 vccd1 sky130_fd_sc_hd__fill_1
Xfanout515 FPGA_INST.cell2.CB_1.config_dataB\[10\] vssd1 vssd1 vccd1 vccd1 net515
+ sky130_fd_sc_hd__dlymetal6s2s_1
Xfanout504 FPGA_INST.cell2.CB_0.config_dataA\[10\] vssd1 vssd1 vccd1 vccd1 net504
+ sky130_fd_sc_hd__clkbuf_2
X_09902_ FPGA_INST.cell0.LE_0B.config_data\[7\] FPGA_INST.cell0.LE_0B.config_data\[6\]
+ net309 vssd1 vssd1 vccd1 vccd1 _00808_ sky130_fd_sc_hd__mux2_1
XFILLER_113_673 vssd1 vssd1 vccd1 vccd1 sky130_fd_sc_hd__fill_1
XFILLER_98_362 vssd1 vssd1 vccd1 vccd1 sky130_fd_sc_hd__fill_2
XFILLER_59_716 vssd1 vssd1 vccd1 vccd1 sky130_fd_sc_hd__fill_4
Xfanout548 net554 vssd1 vssd1 vccd1 vccd1 net548 sky130_fd_sc_hd__clkbuf_4
XANTENNA__09625__S net320 vssd1 vssd1 vccd1 vccd1 sky130_fd_sc_hd__diode_2
Xfanout537 net538 vssd1 vssd1 vccd1 vccd1 net537 sky130_fd_sc_hd__clkbuf_2
Xfanout526 net534 vssd1 vssd1 vccd1 vccd1 net526 sky130_fd_sc_hd__clkbuf_4
X_09833_ FPGA_INST.cell0.LEI0.config_data\[12\] FPGA_INST.cell0.LEI0.config_data\[11\]
+ net308 vssd1 vssd1 vccd1 vccd1 _00741_ sky130_fd_sc_hd__mux2_1
Xfanout559 net561 vssd1 vssd1 vccd1 vccd1 net559 sky130_fd_sc_hd__clkbuf_4
X_09764_ FPGA_INST.cell1.CB_0.config_dataB\[14\] net452 net231 vssd1 vssd1 vccd1 vccd1
+ _00673_ sky130_fd_sc_hd__mux2_1
XANTENNA__06761__A3 FPGA_INST.bus3_2\[7\] vssd1 vssd1 vccd1 vccd1 sky130_fd_sc_hd__diode_2
X_06976_ _01751_ FPGA_INST.cell0.LE_0B.dff_out vssd1 vssd1 vccd1 vccd1 _03243_ sky130_fd_sc_hd__or2_1
X_08715_ _04892_ _04923_ _04891_ vssd1 vssd1 vccd1 vccd1 _04924_ sky130_fd_sc_hd__mux2_1
X_09695_ FPGA_INST.cell0.SB0.route_sel\[98\] FPGA_INST.cell0.SB0.route_sel\[99\] net196
+ vssd1 vssd1 vccd1 vccd1 _00604_ sky130_fd_sc_hd__mux2_1
XANTENNA_fanout555_A net558 vssd1 vssd1 vccd1 vccd1 sky130_fd_sc_hd__diode_2
X_05927_ net485 net486 vssd1 vssd1 vccd1 vccd1 _02207_ sky130_fd_sc_hd__and2b_1
X_08646_ _01763_ _04795_ _04816_ _04854_ vssd1 vssd1 vccd1 vccd1 _04855_ sky130_fd_sc_hd__a31oi_1
XTAP_TAPCELL_ROW_68_1233 vssd1 vccd1 sky130_fd_sc_hd__tapvpwrvgnd_1
X_05858_ FPGA_INST.cell0.SB0.route_sel\[66\] FPGA_INST.cell0.SB0.route_sel\[67\] _02135_
+ _02136_ _02137_ vssd1 vssd1 vccd1 vccd1 _02138_ sky130_fd_sc_hd__a221o_1
XANTENNA__06513__A3 FPGA_INST.bus3_2\[7\] vssd1 vssd1 vccd1 vccd1 sky130_fd_sc_hd__diode_2
XTAP_TAPCELL_ROW_1_299 vssd1 vccd1 sky130_fd_sc_hd__tapvpwrvgnd_1
XANTENNA__09360__S net240 vssd1 vssd1 vccd1 vccd1 sky130_fd_sc_hd__diode_2
XANTENNA_fanout722_A net729 vssd1 vssd1 vccd1 vccd1 sky130_fd_sc_hd__diode_2
X_08577_ _01764_ _03903_ _04784_ _04782_ net400 vssd1 vssd1 vccd1 vccd1 _04786_ sky130_fd_sc_hd__o311a_1
XTAP_TAPCELL_ROW_81_1422 vssd1 vccd1 sky130_fd_sc_hd__tapvpwrvgnd_1
XFILLER_81_295 vssd1 vssd1 vccd1 vccd1 sky130_fd_sc_hd__fill_2
XTAP_TAPCELL_ROW_81_1411 vssd1 vccd1 sky130_fd_sc_hd__tapvpwrvgnd_1
X_05789_ FPGA_INST.cell0.SB0.route_sel\[94\] _01638_ FPGA_INST.cell0.SB0.route_sel\[90\]
+ FPGA_INST.cell0.SB0.route_sel\[91\] _02068_ vssd1 vssd1 vccd1 vccd1 _02069_ sky130_fd_sc_hd__o221a_1
XFILLER_41_148 vssd1 vssd1 vccd1 vccd1 sky130_fd_sc_hd__fill_1
X_07528_ net91 _03782_ vssd1 vssd1 vccd1 vccd1 _03784_ sky130_fd_sc_hd__nand2_1
XANTENNA__08266__A3 FPGA_INST.bus1_0\[3\] vssd1 vssd1 vccd1 vccd1 sky130_fd_sc_hd__diode_2
X_07459_ _03710_ _03712_ _03714_ _03715_ vssd1 vssd1 vccd1 vccd1 _03716_ sky130_fd_sc_hd__o211a_1
XTAP_TAPCELL_ROW_40_839 vssd1 vccd1 sky130_fd_sc_hd__tapvpwrvgnd_1
X_10470_ FPGA_INST.cell2.SB0.route_sel\[42\] FPGA_INST.cell2.SB0.route_sel\[43\] net245
+ vssd1 vssd1 vccd1 vccd1 _01349_ sky130_fd_sc_hd__mux2_1
XANTENNA__07226__A1 net19 vssd1 vssd1 vccd1 vccd1 sky130_fd_sc_hd__diode_2
X_09129_ FPGA_INST.cell2.LEI0.config_data\[43\] FPGA_INST.cell2.LEI0.config_data\[44\]
+ net259 vssd1 vssd1 vccd1 vccd1 _00045_ sky130_fd_sc_hd__mux2_1
XTAP_TAPCELL_ROW_20_563 vssd1 vccd1 sky130_fd_sc_hd__tapvpwrvgnd_1
X_12140_ net941 _01486_ net725 vssd1 vssd1 vccd1 vccd1 FPGA_INST.cell3.CB_1.config_dataA\[2\]
+ sky130_fd_sc_hd__dfstp_1
XTAP_TAPCELL_ROW_79_1395 vssd1 vccd1 sky130_fd_sc_hd__tapvpwrvgnd_1
XTAP_TAPCELL_ROW_79_1384 vssd1 vccd1 sky130_fd_sc_hd__tapvpwrvgnd_1
XANTENNA__05784__B1_N FPGA_INST.bus2_0\[11\] vssd1 vssd1 vccd1 vccd1 sky130_fd_sc_hd__diode_2
XFILLER_104_640 vssd1 vssd1 vccd1 vccd1 sky130_fd_sc_hd__fill_4
XTAP_TAPCELL_ROW_92_1573 vssd1 vccd1 sky130_fd_sc_hd__tapvpwrvgnd_1
X_12071_ net853 _01417_ net638 vssd1 vssd1 vccd1 vccd1 FPGA_INST.cell2.SB0.route_sel\[111\]
+ sky130_fd_sc_hd__dfstp_1
XFILLER_9_3 vccd1 vssd1 vccd1 vssd1 sky130_ef_sc_hd__decap_40_12
XANTENNA_fanout89_X net89 vssd1 vssd1 vccd1 vccd1 sky130_fd_sc_hd__diode_2
XANTENNA__08726__B2 net24 vssd1 vssd1 vccd1 vccd1 sky130_fd_sc_hd__diode_2
XANTENNA__08726__A1 net22 vssd1 vssd1 vccd1 vccd1 sky130_fd_sc_hd__diode_2
X_11022_ net806 _00372_ net592 vssd1 vssd1 vccd1 vccd1 FPGA_INST.cell1.LEI0.config_data\[7\]
+ sky130_fd_sc_hd__dfrtp_1
XANTENNA__06737__A0 FPGA_INST.bus3_2\[2\] vssd1 vssd1 vccd1 vccd1 sky130_fd_sc_hd__diode_2
XFILLER_103_161 vssd1 vssd1 vccd1 vccd1 sky130_fd_sc_hd__fill_4
XFILLER_49_237 vssd1 vssd1 vccd1 vccd1 sky130_fd_sc_hd__fill_4
XFILLER_85_590 vssd1 vssd1 vccd1 vccd1 sky130_fd_sc_hd__fill_1
XANTENNA__07282__C _03542_ vssd1 vssd1 vccd1 vccd1 sky130_fd_sc_hd__diode_2
X_11924_ net944 _01270_ net728 vssd1 vssd1 vccd1 vccd1 FPGA_INST.cell3.LE_1A.config_data\[10\]
+ sky130_fd_sc_hd__dfrtp_1
XFILLER_17_145 vssd1 vssd1 vccd1 vccd1 sky130_fd_sc_hd__fill_4
XFILLER_18_668 vssd1 vssd1 vccd1 vccd1 sky130_fd_sc_hd__fill_1
XFILLER_122_81 vssd1 vssd1 vccd1 vccd1 sky130_fd_sc_hd__fill_2
XFILLER_82_41 vssd1 vssd1 vccd1 vccd1 sky130_fd_sc_hd__fill_4
XFILLER_73_785 vccd1 vssd1 vccd1 vssd1 sky130_ef_sc_hd__decap_40_12
XFILLER_60_413 vssd1 vssd1 vccd1 vccd1 sky130_fd_sc_hd__fill_4
XTAP_TAPCELL_ROW_28_674 vssd1 vccd1 sky130_fd_sc_hd__tapvpwrvgnd_1
X_11855_ net916 _01201_ net700 vssd1 vssd1 vccd1 vccd1 FPGA_INST.cell3.LEI0.config_data\[35\]
+ sky130_fd_sc_hd__dfrtp_1
XANTENNA__10049__A0 FPGA_INST.cell0.CB_0.config_dataB\[24\] vssd1 vssd1 vccd1 vccd1
+ sky130_fd_sc_hd__diode_2
X_10806_ net785 _00156_ net570 vssd1 vssd1 vccd1 vccd1 FPGA_INST.cell1.SB0.route_sel\[15\]
+ sky130_fd_sc_hd__dfstp_1
X_11786_ net890 _01132_ net674 vssd1 vssd1 vccd1 vccd1 FPGA_INST.io_south_oeb\[24\]
+ sky130_fd_sc_hd__dfrtp_1
XFILLER_9_322 vssd1 vssd1 vccd1 vccd1 sky130_fd_sc_hd__fill_2
XANTENNA__06268__A2 net16 vssd1 vssd1 vccd1 vccd1 sky130_fd_sc_hd__diode_2
X_10737_ net874 _00087_ net658 vssd1 vssd1 vccd1 vccd1 FPGA_INST.cell2.LE_0B.config_data\[14\]
+ sky130_fd_sc_hd__dfrtp_1
XTAP_TAPCELL_ROW_101_1691 vssd1 vccd1 sky130_fd_sc_hd__tapvpwrvgnd_1
XANTENNA__07297__Y _03558_ vssd1 vssd1 vccd1 vccd1 sky130_fd_sc_hd__diode_2
X_10668_ net868 _00018_ net652 vssd1 vssd1 vccd1 vccd1 FPGA_INST.cell2.LEI0.config_data\[17\]
+ sky130_fd_sc_hd__dfrtp_1
X_10599_ FPGA_INST.cell3.CB_0.config_dataB\[18\] FPGA_INST.cell3.CB_0.config_dataB\[19\]
+ net300 vssd1 vssd1 vccd1 vccd1 _01478_ sky130_fd_sc_hd__mux2_1
XANTENNA__10221__A0 FPGA_INST.cell3.SB0.route_sel\[125\] vssd1 vssd1 vccd1 vccd1 sky130_fd_sc_hd__diode_2
XTAP_TAPCELL_ROW_130_2098 vssd1 vccd1 sky130_fd_sc_hd__tapvpwrvgnd_1
XANTENNA__06728__A0 FPGA_INST.bus3_2\[12\] vssd1 vssd1 vccd1 vccd1 sky130_fd_sc_hd__diode_2
XTAP_TAPCELL_ROW_52_1012 vssd1 vccd1 sky130_fd_sc_hd__tapvpwrvgnd_1
XFILLER_110_643 vssd1 vssd1 vccd1 vccd1 sky130_fd_sc_hd__fill_1
X_06830_ net422 _02392_ _03097_ FPGA_INST.cell0.CB_0.config_dataB\[6\] vssd1 vssd1
+ vccd1 vccd1 _03098_ sky130_fd_sc_hd__o211a_1
XTAP_TAPCELL_ROW_108_1801 vssd1 vccd1 sky130_fd_sc_hd__tapvpwrvgnd_1
X_06761_ FPGA_INST.bus3_2\[4\] FPGA_INST.bus3_2\[5\] FPGA_INST.bus3_2\[6\] FPGA_INST.bus3_2\[7\]
+ net514 net513 vssd1 vssd1 vccd1 vccd1 _03035_ sky130_fd_sc_hd__mux4_1
XANTENNA__06743__A3 net103 vssd1 vssd1 vccd1 vccd1 sky130_fd_sc_hd__diode_2
XANTENNA__05274__A FPGA_INST.cell2.SB0.route_sel\[32\] vssd1 vssd1 vccd1 vccd1 sky130_fd_sc_hd__diode_2
X_08500_ FPGA_INST.cell1.LE_1B.dff0_out FPGA_INST.cell1.LE_1B.dff1_out FPGA_INST.cell1.LE_1B.reset_val
+ vssd1 vssd1 vccd1 vccd1 FPGA_INST.cell1.LE_1B.dff_out sky130_fd_sc_hd__mux2_1
X_09480_ FPGA_INST.cell1.LEI0.config_data\[26\] FPGA_INST.cell1.LEI0.config_data\[27\]
+ net216 vssd1 vssd1 vccd1 vccd1 _00392_ sky130_fd_sc_hd__mux2_1
X_06692_ net519 _02961_ _02962_ _02965_ vssd1 vssd1 vccd1 vccd1 _02966_ sky130_fd_sc_hd__a31o_1
X_05712_ _01847_ _01991_ FPGA_INST.bus3_2\[13\] vssd1 vssd1 vccd1 vccd1 _01992_ sky130_fd_sc_hd__o21a_1
XFILLER_102_29 vssd1 vssd1 vccd1 vccd1 sky130_fd_sc_hd__fill_4
X_08431_ _04036_ _04046_ _04650_ net225 vssd1 vssd1 vccd1 vccd1 FPGA_INST.bus1_0\[15\]
+ sky130_fd_sc_hd__o211a_4
X_05643_ FPGA_INST.cell0.SB0.route_sel\[96\] FPGA_INST.cell0.SB0.route_sel\[97\] vssd1
+ vssd1 vccd1 vccd1 _01923_ sky130_fd_sc_hd__and2_1
XFILLER_23_126 vssd1 vssd1 vccd1 vccd1 sky130_fd_sc_hd__fill_1
X_05574_ net133 _01849_ _01850_ _01853_ _01842_ vssd1 vssd1 vccd1 vccd1 _01854_ sky130_fd_sc_hd__o311a_1
XFILLER_51_457 vccd1 vssd1 vccd1 vssd1 sky130_ef_sc_hd__decap_40_12
X_08362_ FPGA_INST.bus1_0\[14\] FPGA_INST.bus1_0\[15\] net442 vssd1 vssd1 vccd1 vccd1
+ _04584_ sky130_fd_sc_hd__mux2_1
X_07313_ _03571_ _03573_ _03545_ vssd1 vssd1 vccd1 vccd1 _03574_ sky130_fd_sc_hd__a21oi_1
XTAP_TAPCELL_ROW_63_1163 vssd1 vccd1 sky130_fd_sc_hd__tapvpwrvgnd_1
X_08293_ net445 _04040_ vssd1 vssd1 vccd1 vccd1 _04515_ sky130_fd_sc_hd__nand2_1
X_07244_ FPGA_INST.cell1.SB0.route_sel\[23\] FPGA_INST.cell1.SB0.route_sel\[22\] _02382_
+ _03505_ _02383_ vssd1 vssd1 vccd1 vccd1 _03506_ sky130_fd_sc_hd__a221o_1
XANTENNA__10460__A0 FPGA_INST.cell2.SB0.route_sel\[32\] vssd1 vssd1 vccd1 vccd1 sky130_fd_sc_hd__diode_2
XFILLER_118_710 vssd1 vssd1 vccd1 vccd1 sky130_fd_sc_hd__fill_4
XTAP_TAPCELL_ROW_119_1952 vssd1 vccd1 sky130_fd_sc_hd__tapvpwrvgnd_1
XFILLER_118_754 vssd1 vssd1 vccd1 vccd1 sky130_fd_sc_hd__fill_2
X_07175_ _03437_ _03438_ vssd1 vssd1 vccd1 vccd1 _03439_ sky130_fd_sc_hd__nor2_1
XFILLER_105_426 vssd1 vssd1 vccd1 vccd1 sky130_fd_sc_hd__fill_1
X_06126_ _01859_ _02368_ vssd1 vssd1 vccd1 vccd1 _02406_ sky130_fd_sc_hd__or2_1
X_06057_ FPGA_INST.cell0.CB_1.config_dataB\[22\] FPGA_INST.cell0.CB_1.config_dataB\[23\]
+ vssd1 vssd1 vccd1 vccd1 _02337_ sky130_fd_sc_hd__or2_1
XANTENNA__08708__A1 net84 vssd1 vssd1 vccd1 vccd1 sky130_fd_sc_hd__diode_2
Xfanout301 net302 vssd1 vssd1 vccd1 vccd1 net301 sky130_fd_sc_hd__clkbuf_4
Xfanout323 net324 vssd1 vssd1 vccd1 vccd1 net323 sky130_fd_sc_hd__clkbuf_4
Xfanout312 net315 vssd1 vssd1 vccd1 vccd1 net312 sky130_fd_sc_hd__buf_2
Xfanout345 net349 vssd1 vssd1 vccd1 vccd1 net345 sky130_fd_sc_hd__clkbuf_2
Xfanout334 net337 vssd1 vssd1 vccd1 vccd1 net334 sky130_fd_sc_hd__clkbuf_2
XFILLER_98_192 vssd1 vssd1 vccd1 vccd1 sky130_fd_sc_hd__fill_1
XANTENNA_fanout672_A net675 vssd1 vssd1 vccd1 vccd1 sky130_fd_sc_hd__diode_2
Xfanout356 net357 vssd1 vssd1 vccd1 vccd1 net356 sky130_fd_sc_hd__clkbuf_4
Xfanout378 net379 vssd1 vssd1 vccd1 vccd1 net378 sky130_fd_sc_hd__clkbuf_4
X_09816_ FPGA_INST.cell1.LE_1B.config_data\[16\] FPGA_INST.cell1.LE_1B.edge_mode net217
+ vssd1 vssd1 vccd1 vccd1 _00725_ sky130_fd_sc_hd__mux2_1
Xfanout389 FPGA_INST.cell3.CB_0.config_dataB\[6\] vssd1 vssd1 vccd1 vccd1 net389 sky130_fd_sc_hd__buf_2
Xfanout367 net380 vssd1 vssd1 vccd1 vccd1 net367 sky130_fd_sc_hd__buf_2
XTAP_TAPCELL_ROW_6_369 vssd1 vccd1 sky130_fd_sc_hd__tapvpwrvgnd_1
X_09747_ FPGA_INST.cell1.CB_0.config_dataA\[23\] FPGA_INST.cell1.CB_0.config_dataA\[22\]
+ net343 vssd1 vssd1 vccd1 vccd1 _00656_ sky130_fd_sc_hd__mux2_1
XANTENNA__05942__A1 net383 vssd1 vssd1 vccd1 vccd1 sky130_fd_sc_hd__diode_2
X_06959_ net115 net119 net110 net98 FPGA_INST.cell0.LEI0.config_data\[39\] FPGA_INST.cell0.LEI0.config_data\[40\]
+ vssd1 vssd1 vccd1 vccd1 _03227_ sky130_fd_sc_hd__mux4_1
XANTENNA_fanout937_A net945 vssd1 vssd1 vccd1 vccd1 sky130_fd_sc_hd__diode_2
XFILLER_100_197 vssd1 vssd1 vccd1 vccd1 sky130_fd_sc_hd__fill_1
XTAP_TAPCELL_ROW_45_909 vssd1 vccd1 sky130_fd_sc_hd__tapvpwrvgnd_1
XANTENNA_fanout558_X net558 vssd1 vssd1 vccd1 vccd1 sky130_fd_sc_hd__diode_2
XFILLER_36_23 vssd1 vssd1 vccd1 vccd1 sky130_fd_sc_hd__fill_4
XFILLER_39_281 vssd1 vssd1 vccd1 vccd1 sky130_fd_sc_hd__fill_4
XFILLER_54_251 vssd1 vssd1 vccd1 vccd1 sky130_fd_sc_hd__fill_1
X_09678_ FPGA_INST.cell0.SB0.route_sel\[81\] FPGA_INST.cell0.SB0.route_sel\[82\] net185
+ vssd1 vssd1 vccd1 vccd1 _00587_ sky130_fd_sc_hd__mux2_1
XANTENNA__06567__X _02843_ vssd1 vssd1 vccd1 vccd1 sky130_fd_sc_hd__diode_2
X_08629_ _01673_ FPGA_INST.cell3.SB0.route_sel\[52\] _01674_ FPGA_INST.cell3.SB0.route_sel\[55\]
+ _04837_ vssd1 vssd1 vccd1 vccd1 _04838_ sky130_fd_sc_hd__a221o_2
XFILLER_82_593 vssd1 vssd1 vccd1 vccd1 sky130_fd_sc_hd__fill_2
XANTENNA__07695__A1 _03447_ vssd1 vssd1 vccd1 vccd1 sky130_fd_sc_hd__diode_2
XFILLER_70_744 vccd1 vssd1 vccd1 vssd1 sky130_ef_sc_hd__decap_40_12
XFILLER_14_115 vssd1 vssd1 vccd1 vccd1 sky130_fd_sc_hd__fill_2
XTAP_TAPCELL_ROW_25_633 vssd1 vccd1 sky130_fd_sc_hd__tapvpwrvgnd_1
XFILLER_70_766 vssd1 vssd1 vccd1 vccd1 sky130_fd_sc_hd__fill_4
X_11640_ net893 _00986_ net677 vssd1 vssd1 vccd1 vccd1 FPGA_INST.cell3.SB0.route_sel\[10\]
+ sky130_fd_sc_hd__dfstp_1
XFILLER_52_11 vssd1 vssd1 vccd1 vccd1 sky130_fd_sc_hd__fill_1
X_11571_ net770 _00921_ net555 vssd1 vssd1 vccd1 vccd1 FPGA_INST.cell0.CB_0.config_dataB\[15\]
+ sky130_fd_sc_hd__dfstp_1
XFILLER_23_671 vssd1 vssd1 vccd1 vccd1 sky130_fd_sc_hd__fill_1
XFILLER_23_682 vssd1 vssd1 vccd1 vccd1 sky130_fd_sc_hd__fill_4
X_10522_ FPGA_INST.cell2.SB0.route_sel\[94\] FPGA_INST.cell2.SB0.route_sel\[95\] net246
+ vssd1 vssd1 vccd1 vccd1 _01401_ sky130_fd_sc_hd__mux2_1
XFILLER_108_242 vssd1 vssd1 vccd1 vccd1 sky130_fd_sc_hd__fill_1
XTAP_TAPCELL_ROW_94_1602 vssd1 vccd1 sky130_fd_sc_hd__tapvpwrvgnd_1
X_10453_ FPGA_INST.cell2.SB0.route_sel\[25\] FPGA_INST.cell2.SB0.route_sel\[26\] net192
+ vssd1 vssd1 vccd1 vccd1 _01332_ sky130_fd_sc_hd__mux2_1
X_10384_ FPGA_INST.cell3.LE_1A.config_data\[3\] FPGA_INST.cell3.LE_1A.config_data\[2\]
+ net376 vssd1 vssd1 vccd1 vccd1 _01263_ sky130_fd_sc_hd__mux2_1
XFILLER_109_798 vssd1 vssd1 vccd1 vccd1 sky130_fd_sc_hd__fill_1
XFILLER_123_223 vssd1 vssd1 vccd1 vccd1 sky130_fd_sc_hd__fill_1
X_12123_ net937 _01469_ net721 vssd1 vssd1 vccd1 vccd1 FPGA_INST.cell3.CB_0.config_dataB\[10\]
+ sky130_fd_sc_hd__dfstp_1
XANTENNA__06422__A2 net16 vssd1 vssd1 vccd1 vccd1 sky130_fd_sc_hd__diode_2
XANTENNA__08411__A3 net99 vssd1 vssd1 vccd1 vccd1 sky130_fd_sc_hd__diode_2
X_12054_ net857 _01400_ net642 vssd1 vssd1 vccd1 vccd1 FPGA_INST.cell2.SB0.route_sel\[94\]
+ sky130_fd_sc_hd__dfstp_1
XANTENNA__08175__A2 net74 vssd1 vssd1 vccd1 vccd1 sky130_fd_sc_hd__diode_2
X_11005_ net923 _00355_ net707 vssd1 vssd1 vccd1 vccd1 FPGA_INST.cell2.LE_1B.config_data\[11\]
+ sky130_fd_sc_hd__dfrtp_1
XFILLER_28_9 vssd1 vssd1 vccd1 vccd1 sky130_fd_sc_hd__fill_1
XANTENNA_input21_X net21 vssd1 vssd1 vccd1 vccd1 sky130_fd_sc_hd__diode_2
XANTENNA__07922__A2 _03690_ vssd1 vssd1 vccd1 vccd1 sky130_fd_sc_hd__diode_2
Xfanout890 net891 vssd1 vssd1 vccd1 vccd1 net890 sky130_fd_sc_hd__clkbuf_2
XFILLER_65_516 vssd1 vssd1 vccd1 vccd1 sky130_fd_sc_hd__fill_2
XANTENNA__05933__A1 net135 vssd1 vssd1 vccd1 vccd1 sky130_fd_sc_hd__diode_2
XANTENNA__05822__A net112 vssd1 vssd1 vccd1 vccd1 sky130_fd_sc_hd__diode_2
XFILLER_46_763 vssd1 vssd1 vccd1 vccd1 sky130_fd_sc_hd__fill_1
XANTENNA__11912__RESET_B net735 vssd1 vssd1 vccd1 vccd1 sky130_fd_sc_hd__diode_2
X_11907_ net939 _01253_ net724 vssd1 vssd1 vccd1 vccd1 FPGA_INST.cell3.LE_0B.config_data\[15\]
+ sky130_fd_sc_hd__dfrtp_1
XTAP_TAPCELL_ROW_103_1720 vssd1 vccd1 sky130_fd_sc_hd__tapvpwrvgnd_1
XANTENNA__11530__SET_B net596 vssd1 vssd1 vccd1 vccd1 sky130_fd_sc_hd__diode_2
X_11838_ net934 _01184_ net718 vssd1 vssd1 vccd1 vccd1 FPGA_INST.cell3.LEI0.config_data\[18\]
+ sky130_fd_sc_hd__dfrtp_1
XTAP_TAPCELL_ROW_103_1731 vssd1 vccd1 sky130_fd_sc_hd__tapvpwrvgnd_1
XANTENNA__11332__Q FPGA_INST.cell1.CB_0.config_dataB\[24\] vssd1 vssd1 vccd1 vccd1
+ sky130_fd_sc_hd__diode_2
XFILLER_60_298 vssd1 vssd1 vccd1 vccd1 sky130_fd_sc_hd__fill_2
X_11769_ net925 _01115_ net709 vssd1 vssd1 vccd1 vccd1 FPGA_INST.io_west_oeb\[22\]
+ sky130_fd_sc_hd__dfrtp_1
X_05290_ FPGA_INST.cell2.SB0.route_sel\[87\] vssd1 vssd1 vccd1 vccd1 _01572_ sky130_fd_sc_hd__inv_2
XFILLER_114_212 vssd1 vssd1 vccd1 vccd1 sky130_fd_sc_hd__fill_1
XANTENNA__08402__A3 FPGA_INST.bus1_0\[7\] vssd1 vssd1 vccd1 vccd1 sky130_fd_sc_hd__diode_2
Xteam_15_948 vssd1 vssd1 vccd1 vccd1 team_15_948/HI gpio_oeb[0] sky130_fd_sc_hd__conb_1
Xteam_15_959 vssd1 vssd1 vccd1 vccd1 team_15_959/HI gpio_oeb[26] sky130_fd_sc_hd__conb_1
XFILLER_130_727 vssd1 vssd1 vccd1 vccd1 sky130_fd_sc_hd__fill_1
XTAP_TAPCELL_ROW_114_1882 vssd1 vccd1 sky130_fd_sc_hd__tapvpwrvgnd_1
X_08980_ FPGA_INST.cell2.SB0.route_sel\[50\] FPGA_INST.cell2.SB0.route_sel\[51\] vssd1
+ vssd1 vccd1 vccd1 _05160_ sky130_fd_sc_hd__nand2b_1
X_07931_ _04157_ _04158_ FPGA_INST.cell1.CB_0.config_dataA\[12\] vssd1 vssd1 vccd1
+ vccd1 _04159_ sky130_fd_sc_hd__mux2_1
X_07862_ net469 _03728_ _04089_ vssd1 vssd1 vccd1 vccd1 _04090_ sky130_fd_sc_hd__a21o_1
XANTENNA__07913__A2 _04013_ vssd1 vssd1 vccd1 vccd1 sky130_fd_sc_hd__diode_2
X_06813_ FPGA_INST.cell2.LE_1B.config_data\[9\] FPGA_INST.cell2.LE_1B.config_data\[8\]
+ _02992_ vssd1 vssd1 vccd1 vccd1 _03087_ sky130_fd_sc_hd__mux2_1
X_09601_ FPGA_INST.cell0.SB0.route_sel\[5\] FPGA_INST.cell0.SB0.route_sel\[4\] net338
+ vssd1 vssd1 vccd1 vccd1 _00510_ sky130_fd_sc_hd__mux2_1
XTAP_TAPCELL_ROW_3_328 vssd1 vccd1 sky130_fd_sc_hd__tapvpwrvgnd_1
X_09532_ FPGA_INST.cell1.LE_0B.config_data\[5\] FPGA_INST.cell1.LE_0B.config_data\[4\]
+ net347 vssd1 vssd1 vccd1 vccd1 _00442_ sky130_fd_sc_hd__mux2_1
XFILLER_113_39 vccd1 vssd1 vccd1 vssd1 sky130_ef_sc_hd__decap_40_12
XFILLER_56_549 vssd1 vssd1 vccd1 vccd1 sky130_fd_sc_hd__fill_1
X_07793_ _01877_ _01885_ _04039_ vssd1 vssd1 vccd1 vccd1 _04042_ sky130_fd_sc_hd__or3_1
X_06744_ _01595_ _03017_ _03016_ vssd1 vssd1 vccd1 vccd1 _03018_ sky130_fd_sc_hd__a21bo_1
XFILLER_36_240 vssd1 vssd1 vccd1 vccd1 sky130_fd_sc_hd__fill_2
XFILLER_36_251 vssd1 vssd1 vccd1 vccd1 sky130_fd_sc_hd__fill_1
X_09463_ FPGA_INST.cell1.LEI0.config_data\[9\] FPGA_INST.cell1.LEI0.config_data\[10\]
+ net214 vssd1 vssd1 vccd1 vccd1 _00375_ sky130_fd_sc_hd__mux2_1
XANTENNA__08868__A1_N _04828_ vssd1 vssd1 vccd1 vccd1 sky130_fd_sc_hd__diode_2
Xwire77 FPGA_INST.bus1_0\[12\] vssd1 vssd1 vccd1 vccd1 net77 sky130_fd_sc_hd__buf_2
X_06675_ _02913_ _02950_ _02911_ vssd1 vssd1 vccd1 vccd1 _02951_ sky130_fd_sc_hd__mux2_1
XFILLER_52_777 vssd1 vssd1 vccd1 vccd1 sky130_fd_sc_hd__fill_2
X_08414_ FPGA_INST.cell0.LE_1B.config_data\[3\] FPGA_INST.cell0.LE_1B.config_data\[2\]
+ _04574_ vssd1 vssd1 vccd1 vccd1 _04636_ sky130_fd_sc_hd__mux2_1
X_09394_ FPGA_INST.cell2.CB_0.config_dataB\[13\] FPGA_INST.cell2.CB_0.config_dataB\[12\]
+ net357 vssd1 vssd1 vccd1 vccd1 _00307_ sky130_fd_sc_hd__mux2_1
X_05626_ _01860_ _01905_ vssd1 vssd1 vccd1 vccd1 _01906_ sky130_fd_sc_hd__or2_1
X_08345_ _04564_ _04565_ FPGA_INST.cell0.CB_1.config_dataB\[2\] vssd1 vssd1 vccd1
+ vccd1 _04567_ sky130_fd_sc_hd__mux2_1
XFILLER_51_265 vssd1 vssd1 vccd1 vccd1 sky130_fd_sc_hd__fill_4
X_05557_ FPGA_INST.cell0.SB0.route_sel\[114\] FPGA_INST.cell0.SB0.route_sel\[115\]
+ vssd1 vssd1 vccd1 vccd1 _01837_ sky130_fd_sc_hd__nor2_1
X_05488_ FPGA_INST.cell3.CB_0.config_dataA\[13\] vssd1 vssd1 vccd1 vccd1 _01770_ sky130_fd_sc_hd__inv_2
XANTENNA__06101__A1 _01821_ vssd1 vssd1 vccd1 vccd1 sky130_fd_sc_hd__diode_2
XTAP_TAPCELL_ROW_50_989 vssd1 vccd1 sky130_fd_sc_hd__tapvpwrvgnd_1
XTAP_TAPCELL_ROW_50_978 vssd1 vccd1 sky130_fd_sc_hd__tapvpwrvgnd_1
X_08276_ FPGA_INST.cell0.LE_1A.config_data\[0\] FPGA_INST.cell0.LE_1A.config_data\[1\]
+ _04410_ vssd1 vssd1 vccd1 vccd1 _04500_ sky130_fd_sc_hd__mux2_1
XANTENNA_fanout306_X net306 vssd1 vssd1 vccd1 vccd1 sky130_fd_sc_hd__diode_2
X_07227_ _03489_ net91 _03487_ vssd1 vssd1 vccd1 vccd1 _03490_ sky130_fd_sc_hd__mux2_1
XANTENNA__11378__SET_B net732 vssd1 vssd1 vccd1 vccd1 sky130_fd_sc_hd__diode_2
X_07158_ _03421_ _03401_ vssd1 vssd1 vccd1 vccd1 _03422_ sky130_fd_sc_hd__nand2b_1
XTAP_TAPCELL_ROW_76_1343 vssd1 vccd1 sky130_fd_sc_hd__tapvpwrvgnd_1
XFILLER_106_757 vssd1 vssd1 vccd1 vccd1 sky130_fd_sc_hd__fill_2
XFILLER_105_234 vssd1 vssd1 vccd1 vccd1 sky130_fd_sc_hd__fill_1
X_06109_ _02379_ _02384_ _02387_ net322 vssd1 vssd1 vccd1 vccd1 _02389_ sky130_fd_sc_hd__a211o_1
XFILLER_105_256 vssd1 vssd1 vccd1 vccd1 sky130_fd_sc_hd__fill_2
X_07089_ net428 _02191_ vssd1 vssd1 vccd1 vccd1 _03355_ sky130_fd_sc_hd__nand2_1
XANTENNA__09085__S net358 vssd1 vssd1 vccd1 vccd1 sky130_fd_sc_hd__diode_2
XANTENNA_fanout675_X net675 vssd1 vssd1 vccd1 vccd1 sky130_fd_sc_hd__diode_2
Xfanout131 net132 vssd1 vssd1 vccd1 vccd1 net131 sky130_fd_sc_hd__clkbuf_2
Xfanout120 net121 vssd1 vssd1 vccd1 vccd1 net120 sky130_fd_sc_hd__clkbuf_4
Xfanout142 FPGA_INST.cell1.CB_1.le_outB vssd1 vssd1 vccd1 vccd1 net142 sky130_fd_sc_hd__clkbuf_2
XANTENNA__07365__A0 net22 vssd1 vssd1 vccd1 vccd1 sky130_fd_sc_hd__diode_2
Xfanout153 net154 vssd1 vssd1 vccd1 vccd1 net153 sky130_fd_sc_hd__buf_2
XANTENNA__08157__A2 _03997_ vssd1 vssd1 vccd1 vccd1 sky130_fd_sc_hd__diode_2
XFILLER_47_505 vccd1 vssd1 vccd1 vssd1 sky130_ef_sc_hd__decap_40_12
XANTENNA__10024__S net317 vssd1 vssd1 vccd1 vccd1 sky130_fd_sc_hd__diode_2
Xfanout197 net198 vssd1 vssd1 vccd1 vccd1 net197 sky130_fd_sc_hd__clkbuf_4
XFILLER_47_538 vssd1 vssd1 vccd1 vccd1 sky130_fd_sc_hd__fill_1
Xfanout186 net189 vssd1 vssd1 vccd1 vccd1 net186 sky130_fd_sc_hd__clkbuf_2
Xfanout175 net176 vssd1 vssd1 vccd1 vccd1 net175 sky130_fd_sc_hd__clkbuf_4
XANTENNA_fanout842_X net842 vssd1 vssd1 vccd1 vccd1 sky130_fd_sc_hd__diode_2
XFILLER_103_50 vssd1 vssd1 vccd1 vccd1 sky130_fd_sc_hd__fill_4
XFILLER_15_402 vssd1 vssd1 vccd1 vccd1 sky130_fd_sc_hd__fill_1
XFILLER_103_61 vssd1 vssd1 vccd1 vccd1 sky130_fd_sc_hd__fill_2
XTAP_TAPCELL_ROW_87_1494 vssd1 vccd1 sky130_fd_sc_hd__tapvpwrvgnd_1
XFILLER_43_777 vssd1 vssd1 vccd1 vccd1 sky130_fd_sc_hd__fill_2
XFILLER_70_585 vssd1 vssd1 vccd1 vccd1 sky130_fd_sc_hd__fill_1
X_11623_ net743 _00973_ net528 vssd1 vssd1 vccd1 vccd1 FPGA_INST.cell0.LE_1B.edge_mode
+ sky130_fd_sc_hd__dfstp_1
XANTENNA__08093__A1 FPGA_INST.bus3_1\[13\] vssd1 vssd1 vccd1 vccd1 sky130_fd_sc_hd__diode_2
XFILLER_11_685 vssd1 vssd1 vccd1 vccd1 sky130_fd_sc_hd__fill_8
X_11554_ net772 _00904_ net557 vssd1 vssd1 vccd1 vccd1 FPGA_INST.cell0.CB_0.config_dataA\[23\]
+ sky130_fd_sc_hd__dfstp_2
X_10505_ FPGA_INST.cell2.SB0.route_sel\[77\] FPGA_INST.cell2.SB0.route_sel\[78\] net260
+ vssd1 vssd1 vccd1 vccd1 _01384_ sky130_fd_sc_hd__mux2_1
X_11485_ net759 _00835_ net544 vssd1 vssd1 vccd1 vccd1 FPGA_INST.cell0.LE_1A.config_data\[12\]
+ sky130_fd_sc_hd__dfrtp_1
X_10436_ FPGA_INST.cell2.SB0.route_sel\[8\] FPGA_INST.cell2.SB0.route_sel\[9\] net238
+ vssd1 vssd1 vccd1 vccd1 _01315_ sky130_fd_sc_hd__mux2_1
X_10367_ FPGA_INST.cell3.LE_0B.config_data\[8\] FPGA_INST.cell3.LE_0B.config_data\[9\]
+ net293 vssd1 vssd1 vccd1 vccd1 _01247_ sky130_fd_sc_hd__mux2_1
XFILLER_124_587 vssd1 vssd1 vccd1 vccd1 sky130_fd_sc_hd__fill_1
X_10298_ FPGA_INST.cell3.LEI0.config_data\[12\] FPGA_INST.cell3.LEI0.config_data\[13\]
+ net282 vssd1 vssd1 vccd1 vccd1 _01179_ sky130_fd_sc_hd__mux2_1
X_12106_ net912 _01452_ net696 vssd1 vssd1 vccd1 vccd1 FPGA_INST.cell3.CB_0.config_dataA\[18\]
+ sky130_fd_sc_hd__dfstp_1
XANTENNA__06159__A1 net129 vssd1 vssd1 vccd1 vccd1 sky130_fd_sc_hd__diode_2
X_12037_ net879 _01383_ net664 vssd1 vssd1 vccd1 vccd1 FPGA_INST.cell2.SB0.route_sel\[77\]
+ sky130_fd_sc_hd__dfstp_1
XPHY_EDGE_ROW_108_Left_239 vssd1 vssd1 vccd1 vccd1 sky130_fd_sc_hd__decap_3
XANTENNA__08847__B _04804_ vssd1 vssd1 vccd1 vccd1 sky130_fd_sc_hd__diode_2
XFILLER_92_165 vssd1 vssd1 vccd1 vccd1 sky130_fd_sc_hd__fill_4
XANTENNA__07108__A0 FPGA_INST.bus2_0\[12\] vssd1 vssd1 vccd1 vccd1 sky130_fd_sc_hd__diode_2
XFILLER_80_349 vssd1 vssd1 vccd1 vccd1 sky130_fd_sc_hd__fill_1
XANTENNA__10868__SET_B net577 vssd1 vssd1 vccd1 vccd1 sky130_fd_sc_hd__diode_2
XFILLER_73_390 vssd1 vssd1 vccd1 vccd1 sky130_fd_sc_hd__fill_2
X_06460_ net2 _02728_ _02737_ vssd1 vssd1 vccd1 vccd1 _02738_ sky130_fd_sc_hd__a21o_1
XFILLER_34_755 vssd1 vssd1 vccd1 vccd1 sky130_fd_sc_hd__fill_1
X_05411_ FPGA_INST.cell0.SB0.route_sel\[39\] vssd1 vssd1 vccd1 vccd1 _01693_ sky130_fd_sc_hd__inv_2
X_08130_ _04355_ vssd1 vssd1 vccd1 vccd1 _04356_ sky130_fd_sc_hd__inv_2
XTAP_TAPCELL_ROW_60_1122 vssd1 vccd1 sky130_fd_sc_hd__tapvpwrvgnd_1
X_06391_ net496 _02666_ _02668_ vssd1 vssd1 vccd1 vccd1 _02669_ sky130_fd_sc_hd__a21o_1
XPHY_EDGE_ROW_117_Left_248 vssd1 vssd1 vccd1 vccd1 sky130_fd_sc_hd__decap_3
X_05342_ FPGA_INST.cell0.SB0.route_sel\[111\] vssd1 vssd1 vccd1 vccd1 _01624_ sky130_fd_sc_hd__inv_2
XTAP_TAPCELL_ROW_116_1900 vssd1 vccd1 sky130_fd_sc_hd__tapvpwrvgnd_1
X_08061_ FPGA_INST.cell1.CB_0.config_dataB\[2\] _04284_ _04286_ FPGA_INST.cell1.CB_0.config_dataB\[3\]
+ vssd1 vssd1 vccd1 vccd1 _04287_ sky130_fd_sc_hd__o211a_1
XANTENNA__10109__S net244 vssd1 vssd1 vccd1 vccd1 sky130_fd_sc_hd__diode_2
XANTENNA__09820__A2 net522 vssd1 vssd1 vccd1 vccd1 sky130_fd_sc_hd__diode_2
X_05273_ FPGA_INST.cell2.SB0.route_sel\[31\] vssd1 vssd1 vccd1 vccd1 _01555_ sky130_fd_sc_hd__inv_2
XTAP_TAPCELL_ROW_116_1911 vssd1 vccd1 sky130_fd_sc_hd__tapvpwrvgnd_1
X_07012_ FPGA_INST.cell0.LEI0.config_data\[14\] _03277_ vssd1 vssd1 vccd1 vccd1 _03278_
+ sky130_fd_sc_hd__nand2b_1
XTAP_TAPCELL_ROW_58_1095 vssd1 vccd1 sky130_fd_sc_hd__tapvpwrvgnd_1
XFILLER_103_727 vssd1 vssd1 vccd1 vccd1 sky130_fd_sc_hd__fill_1
X_08963_ FPGA_INST.cell2.SB0.route_sel\[64\] _01565_ _01567_ _01568_ _05148_ vssd1
+ vssd1 vccd1 vccd1 _05149_ sky130_fd_sc_hd__a221o_1
XPHY_EDGE_ROW_126_Left_257 vssd1 vssd1 vccd1 vccd1 sky130_fd_sc_hd__decap_3
X_07914_ _03973_ _04118_ FPGA_INST.cell1.CB_0.config_dataA\[2\] vssd1 vssd1 vccd1
+ vccd1 _04142_ sky130_fd_sc_hd__o21ai_1
XTAP_TAPCELL_ROW_71_1273 vssd1 vccd1 sky130_fd_sc_hd__tapvpwrvgnd_1
X_08894_ FPGA_INST.cell3.LE_0B.config_data\[12\] FPGA_INST.cell3.LE_0B.config_data\[13\]
+ _05032_ vssd1 vssd1 vccd1 vccd1 _05101_ sky130_fd_sc_hd__mux2_1
XANTENNA__09633__S net196 vssd1 vssd1 vccd1 vccd1 sky130_fd_sc_hd__diode_2
XFILLER_29_505 vssd1 vssd1 vccd1 vccd1 sky130_fd_sc_hd__fill_4
XANTENNA_fanout370_A net372 vssd1 vssd1 vccd1 vccd1 sky130_fd_sc_hd__diode_2
XFILLER_56_324 vssd1 vssd1 vccd1 vccd1 sky130_fd_sc_hd__fill_2
X_07845_ net136 _04076_ _02369_ vssd1 vssd1 vccd1 vccd1 net47 sky130_fd_sc_hd__mux2_1
XFILLER_84_666 vssd1 vssd1 vccd1 vccd1 sky130_fd_sc_hd__fill_2
X_07776_ _04025_ _04023_ vssd1 vssd1 vccd1 vccd1 FPGA_INST.bus3_2\[14\] sky130_fd_sc_hd__and2b_2
X_09515_ FPGA_INST.cell1.LE_0A.config_data\[11\] FPGA_INST.cell1.LE_0A.config_data\[10\]
+ net344 vssd1 vssd1 vccd1 vccd1 _00426_ sky130_fd_sc_hd__mux2_1
X_06727_ _02819_ _02993_ _02994_ _02824_ _01596_ vssd1 vssd1 vccd1 vccd1 _03001_ sky130_fd_sc_hd__a221o_1
X_09446_ FPGA_INST.cell2.LE_1B.config_data\[15\] FPGA_INST.cell2.LE_1B.config_data\[14\]
+ net361 vssd1 vssd1 vccd1 vccd1 _00359_ sky130_fd_sc_hd__mux2_1
XANTENNA__08311__A2 net74 vssd1 vssd1 vccd1 vccd1 sky130_fd_sc_hd__diode_2
XFILLER_52_541 vssd1 vssd1 vccd1 vccd1 sky130_fd_sc_hd__fill_8
XANTENNA_fanout635_A net636 vssd1 vssd1 vccd1 vccd1 sky130_fd_sc_hd__diode_2
X_06658_ _02932_ _02933_ FPGA_INST.cell2.CB_1.config_dataA\[17\] vssd1 vssd1 vccd1
+ vccd1 _02934_ sky130_fd_sc_hd__mux2_1
XTAP_TAPCELL_ROW_35_772 vssd1 vccd1 sky130_fd_sc_hd__tapvpwrvgnd_1
XFILLER_40_725 vssd1 vssd1 vccd1 vccd1 sky130_fd_sc_hd__fill_1
XANTENNA_fanout802_A net803 vssd1 vssd1 vccd1 vccd1 sky130_fd_sc_hd__diode_2
X_06589_ _02780_ _02850_ _02851_ _02784_ FPGA_INST.cell2.CB_1.config_dataA\[2\] vssd1
+ vssd1 vccd1 vccd1 _02865_ sky130_fd_sc_hd__a221o_1
X_05609_ _01819_ _01873_ _01885_ _01887_ vssd1 vssd1 vccd1 vccd1 _01889_ sky130_fd_sc_hd__o22a_1
XANTENNA__06564__Y _02840_ vssd1 vssd1 vccd1 vccd1 sky130_fd_sc_hd__diode_2
X_09377_ FPGA_INST.cell2.CB_0.config_dataA\[21\] FPGA_INST.cell2.CB_0.config_dataA\[20\]
+ net350 vssd1 vssd1 vccd1 vccd1 _00290_ sky130_fd_sc_hd__mux2_1
XANTENNA__06873__A2 _02191_ vssd1 vssd1 vccd1 vccd1 sky130_fd_sc_hd__diode_2
X_08328_ FPGA_INST.bus1_0\[14\] FPGA_INST.bus1_0\[15\] net449 vssd1 vssd1 vccd1 vccd1
+ _04550_ sky130_fd_sc_hd__mux2_1
X_08259_ net403 _03720_ vssd1 vssd1 vccd1 vccd1 _04483_ sky130_fd_sc_hd__nand2_1
XANTENNA__09808__S net336 vssd1 vssd1 vccd1 vccd1 sky130_fd_sc_hd__diode_2
XFILLER_109_3 vssd1 vssd1 vccd1 vccd1 sky130_fd_sc_hd__fill_1
XFILLER_106_521 vssd1 vssd1 vccd1 vccd1 sky130_fd_sc_hd__fill_4
X_11270_ net785 _00620_ net570 vssd1 vssd1 vccd1 vccd1 FPGA_INST.cell0.SB0.route_sel\[115\]
+ sky130_fd_sc_hd__dfstp_1
X_10221_ FPGA_INST.cell3.SB0.route_sel\[125\] FPGA_INST.cell3.SB0.route_sel\[126\]
+ net274 vssd1 vssd1 vccd1 vccd1 _01102_ sky130_fd_sc_hd__mux2_1
XFILLER_3_169 vssd1 vssd1 vccd1 vccd1 sky130_fd_sc_hd__fill_4
XFILLER_3_158 vssd1 vssd1 vccd1 vccd1 sky130_fd_sc_hd__fill_1
XFILLER_3_136 vccd1 vssd1 vccd1 vssd1 sky130_ef_sc_hd__decap_40_12
XFILLER_106_587 vssd1 vssd1 vccd1 vccd1 sky130_fd_sc_hd__fill_1
X_10152_ FPGA_INST.cell3.SB0.route_sel\[56\] FPGA_INST.cell3.SB0.route_sel\[57\] net271
+ vssd1 vssd1 vccd1 vccd1 _01033_ sky130_fd_sc_hd__mux2_1
XANTENNA__07050__A2 _02191_ vssd1 vssd1 vccd1 vccd1 sky130_fd_sc_hd__diode_2
X_10083_ FPGA_INST.cell0.LE_1B.config_data\[7\] FPGA_INST.cell0.LE_1B.config_data\[8\]
+ net173 vssd1 vssd1 vccd1 vccd1 _00964_ sky130_fd_sc_hd__mux2_1
XANTENNA__09543__S net232 vssd1 vssd1 vccd1 vccd1 sky130_fd_sc_hd__diode_2
XTAP_TAPCELL_ROW_89_1523 vssd1 vccd1 sky130_fd_sc_hd__tapvpwrvgnd_1
XANTENNA__05924__X _02204_ vssd1 vssd1 vccd1 vccd1 sky130_fd_sc_hd__diode_2
XFILLER_47_302 vssd1 vssd1 vccd1 vccd1 sky130_fd_sc_hd__fill_4
XTAP_TAPCELL_ROW_89_1534 vssd1 vccd1 sky130_fd_sc_hd__tapvpwrvgnd_1
XANTENNA_input29_A gpio_in[8] vssd1 vssd1 vccd1 vccd1 sky130_fd_sc_hd__diode_2
XFILLER_47_346 vssd1 vssd1 vccd1 vccd1 sky130_fd_sc_hd__fill_1
XFILLER_114_71 vssd1 vssd1 vccd1 vccd1 sky130_fd_sc_hd__fill_1
XFILLER_62_305 vssd1 vssd1 vccd1 vccd1 sky130_fd_sc_hd__fill_2
XFILLER_28_593 vssd1 vssd1 vccd1 vccd1 sky130_fd_sc_hd__fill_1
XFILLER_74_97 vssd1 vssd1 vccd1 vccd1 sky130_fd_sc_hd__fill_1
X_10985_ net860 _00335_ net646 vssd1 vssd1 vccd1 vccd1 FPGA_INST.cell2.CB_1.config_dataA\[16\]
+ sky130_fd_sc_hd__dfstp_1
XFILLER_16_755 vssd1 vssd1 vccd1 vccd1 sky130_fd_sc_hd__fill_1
XFILLER_130_70 vssd1 vssd1 vccd1 vccd1 sky130_fd_sc_hd__fill_1
XANTENNA__06864__A2 _01839_ vssd1 vssd1 vccd1 vccd1 sky130_fd_sc_hd__diode_2
XFILLER_30_235 vssd1 vssd1 vccd1 vccd1 sky130_fd_sc_hd__fill_2
XANTENNA__08970__X FPGA_INST.bus1_0\[7\] vssd1 vssd1 vccd1 vccd1 sky130_fd_sc_hd__diode_2
X_11606_ net750 _00956_ net535 vssd1 vssd1 vccd1 vccd1 FPGA_INST.cell0.LE_1B.config_data\[0\]
+ sky130_fd_sc_hd__dfrtp_1
XFILLER_11_460 vssd1 vssd1 vccd1 vccd1 sky130_fd_sc_hd__fill_1
XTAP_TAPCELL_ROW_13_466 vssd1 vccd1 sky130_fd_sc_hd__tapvpwrvgnd_1
X_11537_ net774 _00887_ net560 vssd1 vssd1 vccd1 vccd1 FPGA_INST.cell0.CB_0.config_dataA\[6\]
+ sky130_fd_sc_hd__dfstp_1
Xmax_cap106 _02183_ vssd1 vssd1 vccd1 vccd1 net106 sky130_fd_sc_hd__buf_1
XANTENNA__07586__X _03840_ vssd1 vssd1 vccd1 vccd1 sky130_fd_sc_hd__diode_2
X_11468_ net753 _00818_ net538 vssd1 vssd1 vccd1 vccd1 FPGA_INST.cell0.LE_0B.edge_mode
+ sky130_fd_sc_hd__dfstp_1
X_10419_ FPGA_INST.cell3.CB_1.config_dataB\[17\] FPGA_INST.cell3.CB_1.config_dataB\[16\]
+ net370 vssd1 vssd1 vccd1 vccd1 _01298_ sky130_fd_sc_hd__mux2_1
XANTENNA__07969__A1_N _03613_ vssd1 vssd1 vccd1 vccd1 sky130_fd_sc_hd__diode_2
XANTENNA__08369__A2 FPGA_INST.bus1_0\[2\] vssd1 vssd1 vccd1 vccd1 sky130_fd_sc_hd__diode_2
X_11399_ net759 _00749_ net546 vssd1 vssd1 vccd1 vccd1 FPGA_INST.cell0.LEI0.config_data\[20\]
+ sky130_fd_sc_hd__dfrtp_1
XFILLER_124_362 vssd1 vssd1 vccd1 vccd1 sky130_fd_sc_hd__fill_2
XTAP_TAPCELL_ROW_111_1830 vssd1 vccd1 sky130_fd_sc_hd__tapvpwrvgnd_1
XTAP_TAPCELL_ROW_111_1841 vssd1 vccd1 sky130_fd_sc_hd__tapvpwrvgnd_1
XANTENNA__09453__S net333 vssd1 vssd1 vccd1 vccd1 sky130_fd_sc_hd__diode_2
X_05960_ _01849_ _02200_ vssd1 vssd1 vccd1 vccd1 _02240_ sky130_fd_sc_hd__nor2_1
XANTENNA__09869__A2 net522 vssd1 vssd1 vccd1 vccd1 sky130_fd_sc_hd__diode_2
XFILLER_24_3 vssd1 vssd1 vccd1 vccd1 sky130_fd_sc_hd__fill_4
XTAP_TAPCELL_ROW_127_2059 vssd1 vccd1 sky130_fd_sc_hd__tapvpwrvgnd_1
XPHY_EDGE_ROW_119_Right_119 vssd1 vssd1 vccd1 vccd1 sky130_fd_sc_hd__decap_3
XANTENNA__10599__S net300 vssd1 vssd1 vccd1 vccd1 sky130_fd_sc_hd__diode_2
XFILLER_66_655 vssd1 vssd1 vccd1 vccd1 sky130_fd_sc_hd__fill_1
X_05891_ _01916_ _02011_ _02094_ _02170_ vssd1 vssd1 vccd1 vccd1 _02171_ sky130_fd_sc_hd__o22a_1
XANTENNA__08541__A2 FPGA_INST.cell3.CB_1.le_outA vssd1 vssd1 vccd1 vccd1 sky130_fd_sc_hd__diode_2
X_07630_ net153 _03869_ vssd1 vssd1 vccd1 vccd1 _03883_ sky130_fd_sc_hd__and2b_1
XFILLER_65_165 vssd1 vssd1 vccd1 vccd1 sky130_fd_sc_hd__fill_2
X_07561_ FPGA_INST.cell3.SB0.route_sel\[78\] FPGA_INST.cell3.SB0.route_sel\[79\] net130
+ _02117_ _03812_ vssd1 vssd1 vccd1 vccd1 _03816_ sky130_fd_sc_hd__a221o_1
XFILLER_19_571 vssd1 vssd1 vccd1 vccd1 sky130_fd_sc_hd__fill_1
XANTENNA__05282__A FPGA_INST.cell2.SB0.route_sel\[64\] vssd1 vssd1 vccd1 vccd1 sky130_fd_sc_hd__diode_2
X_09300_ FPGA_INST.cell1.SB0.route_sel\[72\] FPGA_INST.cell1.SB0.route_sel\[71\] net330
+ vssd1 vssd1 vccd1 vccd1 _00213_ sky130_fd_sc_hd__mux2_1
X_06512_ FPGA_INST.bus3_2\[0\] FPGA_INST.bus3_2\[1\] FPGA_INST.bus3_2\[2\] FPGA_INST.bus3_2\[3\]
+ FPGA_INST.cell2.CB_1.config_dataA\[5\] net480 vssd1 vssd1 vccd1 vccd1 _02788_ sky130_fd_sc_hd__mux4_1
XFILLER_0_94 vccd1 vssd1 vccd1 vssd1 sky130_ef_sc_hd__decap_40_12
XANTENNA__06097__B _02376_ vssd1 vssd1 vccd1 vccd1 sky130_fd_sc_hd__diode_2
XFILLER_34_552 vssd1 vssd1 vccd1 vccd1 sky130_fd_sc_hd__fill_1
XFILLER_110_29 vccd1 vssd1 vccd1 vssd1 sky130_ef_sc_hd__decap_40_12
X_07492_ FPGA_INST.cell1.CB_0.config_dataB\[22\] FPGA_INST.cell1.CB_0.config_dataB\[23\]
+ vssd1 vssd1 vccd1 vccd1 _03748_ sky130_fd_sc_hd__nand2b_2
XFILLER_22_725 vssd1 vssd1 vccd1 vccd1 sky130_fd_sc_hd__fill_2
XFILLER_34_574 vssd1 vssd1 vccd1 vccd1 sky130_fd_sc_hd__fill_4
XTAP_TAPCELL_ROW_122_1992 vssd1 vccd1 sky130_fd_sc_hd__tapvpwrvgnd_1
X_09231_ FPGA_INST.cell1.SB0.route_sel\[3\] FPGA_INST.cell1.SB0.route_sel\[2\] net339
+ vssd1 vssd1 vccd1 vccd1 _00144_ sky130_fd_sc_hd__mux2_1
X_06443_ _02720_ vssd1 vssd1 vccd1 vccd1 _02721_ sky130_fd_sc_hd__inv_2
XTAP_TAPCELL_ROW_32_731 vssd1 vccd1 sky130_fd_sc_hd__tapvpwrvgnd_1
XANTENNA__08057__A1 FPGA_INST.bus3_1\[9\] vssd1 vssd1 vccd1 vccd1 sky130_fd_sc_hd__diode_2
X_09162_ FPGA_INST.cell2.LE_0B.config_data\[3\] FPGA_INST.cell2.LE_0B.config_data\[2\]
+ net358 vssd1 vssd1 vccd1 vccd1 _00076_ sky130_fd_sc_hd__mux2_1
X_06374_ _01538_ _01539_ FPGA_INST.cell2.CB_0.config_dataB\[9\] _02623_ _02651_ vssd1
+ vssd1 vccd1 vccd1 _02652_ sky130_fd_sc_hd__a41o_2
X_08113_ net450 _04333_ _04334_ _04338_ vssd1 vssd1 vccd1 vccd1 _04339_ sky130_fd_sc_hd__a31o_1
XANTENNA__06607__A2 FPGA_INST.bus3_2\[2\] vssd1 vssd1 vccd1 vccd1 sky130_fd_sc_hd__diode_2
X_05325_ FPGA_INST.cell0.SB0.route_sel\[121\] vssd1 vssd1 vccd1 vccd1 _01607_ sky130_fd_sc_hd__inv_2
XANTENNA_fanout216_A net219 vssd1 vssd1 vccd1 vccd1 sky130_fd_sc_hd__diode_2
X_09093_ FPGA_INST.cell2.LEI0.config_data\[7\] FPGA_INST.cell2.LEI0.config_data\[8\]
+ net262 vssd1 vssd1 vccd1 vccd1 _00009_ sky130_fd_sc_hd__mux2_1
X_08044_ FPGA_INST.bus3_1\[4\] FPGA_INST.bus3_1\[5\] FPGA_INST.bus3_1\[6\] FPGA_INST.bus3_1\[7\]
+ net460 FPGA_INST.cell1.CB_0.config_dataB\[1\] vssd1 vssd1 vccd1 vccd1 _04270_ sky130_fd_sc_hd__mux4_1
X_05256_ FPGA_INST.cell2.CB_0.config_dataB\[8\] vssd1 vssd1 vccd1 vccd1 _01538_ sky130_fd_sc_hd__inv_2
XTAP_TAPCELL_ROW_73_1302 vssd1 vccd1 sky130_fd_sc_hd__tapvpwrvgnd_1
XANTENNA__08765__C1 net156 vssd1 vssd1 vccd1 vccd1 sky130_fd_sc_hd__diode_2
XFILLER_0_106 vssd1 vssd1 vccd1 vccd1 sky130_fd_sc_hd__fill_4
X_09995_ net739 _05241_ vssd1 vssd1 vccd1 vccd1 _05242_ sky130_fd_sc_hd__nand2_1
XFILLER_0_139 vssd1 vssd1 vccd1 vccd1 sky130_fd_sc_hd__fill_1
XFILLER_130_365 vssd1 vssd1 vccd1 vccd1 sky130_fd_sc_hd__fill_4
XANTENNA__09363__S net351 vssd1 vssd1 vccd1 vccd1 sky130_fd_sc_hd__diode_2
X_08946_ _05137_ _02053_ vssd1 vssd1 vccd1 vccd1 FPGA_INST.bus2_0\[10\] sky130_fd_sc_hd__and2b_2
X_08877_ _04843_ _05072_ _05074_ _04846_ _01779_ vssd1 vssd1 vccd1 vccd1 _05084_ sky130_fd_sc_hd__a221o_1
XFILLER_84_452 vssd1 vssd1 vccd1 vccd1 sky130_fd_sc_hd__fill_2
XFILLER_56_143 vssd1 vssd1 vccd1 vccd1 sky130_fd_sc_hd__fill_8
XFILLER_28_79 vssd1 vssd1 vccd1 vccd1 sky130_fd_sc_hd__fill_2
X_07828_ net126 _02056_ _02047_ vssd1 vssd1 vccd1 vccd1 _04067_ sky130_fd_sc_hd__mux2_1
XFILLER_29_379 vssd1 vssd1 vccd1 vccd1 sky130_fd_sc_hd__fill_1
XFILLER_84_485 vssd1 vssd1 vccd1 vccd1 sky130_fd_sc_hd__fill_2
XFILLER_71_124 vssd1 vssd1 vccd1 vccd1 sky130_fd_sc_hd__fill_1
XTAP_TAPCELL_ROW_84_1453 vssd1 vccd1 sky130_fd_sc_hd__tapvpwrvgnd_1
X_07759_ FPGA_INST.cell1.SB0.route_sel\[112\] FPGA_INST.cell1.SB0.route_sel\[113\]
+ _04001_ _04004_ _04008_ vssd1 vssd1 vccd1 vccd1 _04009_ sky130_fd_sc_hd__a41o_1
XFILLER_25_530 vssd1 vssd1 vccd1 vccd1 sky130_fd_sc_hd__fill_4
XANTENNA__08835__A3 net26 vssd1 vssd1 vccd1 vccd1 sky130_fd_sc_hd__diode_2
XTAP_TAPCELL_ROW_84_1464 vssd1 vccd1 sky130_fd_sc_hd__tapvpwrvgnd_1
X_10770_ net887 _00120_ net671 vssd1 vssd1 vccd1 vccd1 FPGA_INST.cell2.CB_1.config_dataB\[4\]
+ sky130_fd_sc_hd__dfstp_1
X_09429_ FPGA_INST.cell2.CB_1.config_dataA\[23\] FPGA_INST.cell2.CB_1.config_dataA\[22\]
+ net355 vssd1 vssd1 vccd1 vccd1 _00342_ sky130_fd_sc_hd__mux2_1
XFILLER_60_11 vssd1 vssd1 vccd1 vccd1 sky130_fd_sc_hd__fill_1
XFILLER_8_206 vssd1 vssd1 vccd1 vccd1 sky130_fd_sc_hd__fill_4
XANTENNA__06059__B1 FPGA_INST.bus1_0\[3\] vssd1 vssd1 vccd1 vccd1 sky130_fd_sc_hd__diode_2
XTAP_TAPCELL_ROW_10_425 vssd1 vccd1 sky130_fd_sc_hd__tapvpwrvgnd_1
X_11322_ net838 _00672_ net622 vssd1 vssd1 vccd1 vccd1 FPGA_INST.cell1.CB_0.config_dataB\[14\]
+ sky130_fd_sc_hd__dfstp_1
XANTENNA__11497__SET_B net577 vssd1 vssd1 vccd1 vccd1 sky130_fd_sc_hd__diode_2
X_11253_ net781 _00603_ net566 vssd1 vssd1 vccd1 vccd1 FPGA_INST.cell0.SB0.route_sel\[98\]
+ sky130_fd_sc_hd__dfstp_1
X_10204_ FPGA_INST.cell3.SB0.route_sel\[109\] FPGA_INST.cell3.SB0.route_sel\[108\]
+ net365 vssd1 vssd1 vccd1 vccd1 _01085_ sky130_fd_sc_hd__mux2_1
XFILLER_79_257 vssd1 vssd1 vccd1 vccd1 sky130_fd_sc_hd__fill_2
XFILLER_79_246 vssd1 vssd1 vccd1 vccd1 sky130_fd_sc_hd__fill_1
X_11184_ net779 _00534_ net564 vssd1 vssd1 vccd1 vccd1 FPGA_INST.cell0.SB0.route_sel\[29\]
+ sky130_fd_sc_hd__dfstp_1
X_10135_ FPGA_INST.cell3.SB0.route_sel\[40\] FPGA_INST.cell3.SB0.route_sel\[39\] net369
+ vssd1 vssd1 vccd1 vccd1 _01016_ sky130_fd_sc_hd__mux2_1
XANTENNA__08771__A2 net20 vssd1 vssd1 vccd1 vccd1 sky130_fd_sc_hd__diode_2
XFILLER_79_279 vssd1 vssd1 vccd1 vccd1 sky130_fd_sc_hd__fill_1
XANTENNA__06782__A1 FPGA_INST.bus3_2\[13\] vssd1 vssd1 vccd1 vccd1 sky130_fd_sc_hd__diode_2
XFILLER_121_398 vssd1 vssd1 vccd1 vccd1 sky130_fd_sc_hd__fill_8
XFILLER_88_791 vssd1 vssd1 vccd1 vccd1 sky130_fd_sc_hd__fill_8
X_10066_ net402 net404 net328 vssd1 vssd1 vccd1 vccd1 _00947_ sky130_fd_sc_hd__mux2_1
XFILLER_47_121 vssd1 vssd1 vccd1 vccd1 sky130_fd_sc_hd__fill_4
XFILLER_47_110 vssd1 vssd1 vccd1 vccd1 sky130_fd_sc_hd__fill_2
XANTENNA__10212__S net364 vssd1 vssd1 vccd1 vccd1 sky130_fd_sc_hd__diode_2
XFILLER_47_143 vssd1 vssd1 vccd1 vccd1 sky130_fd_sc_hd__fill_1
XFILLER_48_699 vssd1 vssd1 vccd1 vccd1 sky130_fd_sc_hd__fill_1
XFILLER_47_198 vssd1 vssd1 vccd1 vccd1 sky130_fd_sc_hd__fill_4
XFILLER_18_90 vssd1 vssd1 vccd1 vccd1 sky130_fd_sc_hd__fill_2
XTAP_TAPCELL_ROW_18_536 vssd1 vccd1 sky130_fd_sc_hd__tapvpwrvgnd_1
XFILLER_62_179 vssd1 vssd1 vccd1 vccd1 sky130_fd_sc_hd__fill_2
XFILLER_16_585 vssd1 vssd1 vccd1 vccd1 sky130_fd_sc_hd__fill_2
X_10968_ net850 _00318_ net635 vssd1 vssd1 vccd1 vccd1 FPGA_INST.cell2.CB_0.config_dataB\[24\]
+ sky130_fd_sc_hd__dfstp_2
XFILLER_16_596 vssd1 vssd1 vccd1 vccd1 sky130_fd_sc_hd__fill_1
XFILLER_86_5 vssd1 vssd1 vccd1 vccd1 sky130_fd_sc_hd__fill_1
X_10899_ net826 _00249_ net610 vssd1 vssd1 vccd1 vccd1 FPGA_INST.cell1.SB0.route_sel\[108\]
+ sky130_fd_sc_hd__dfstp_1
X_06090_ net123 net4 _02367_ vssd1 vssd1 vccd1 vccd1 _02370_ sky130_fd_sc_hd__mux2_1
XFILLER_125_671 vssd1 vssd1 vccd1 vccd1 sky130_fd_sc_hd__fill_1
Xfanout719 net730 vssd1 vssd1 vccd1 vccd1 net719 sky130_fd_sc_hd__clkbuf_4
X_08800_ _04828_ _05004_ _05005_ _04831_ vssd1 vssd1 vccd1 vccd1 _05007_ sky130_fd_sc_hd__a2bb2o_1
Xfanout708 net715 vssd1 vssd1 vccd1 vccd1 net708 sky130_fd_sc_hd__clkbuf_2
XTAP_TAPCELL_ROW_55_1054 vssd1 vccd1 sky130_fd_sc_hd__tapvpwrvgnd_1
XANTENNA__06222__B1 _02501_ vssd1 vssd1 vccd1 vccd1 sky130_fd_sc_hd__diode_2
X_09780_ FPGA_INST.cell1.CB_1.config_dataA\[5\] FPGA_INST.cell1.CB_1.config_dataA\[6\]
+ net212 vssd1 vssd1 vccd1 vccd1 _00689_ sky130_fd_sc_hd__mux2_1
XFILLER_98_599 vssd1 vssd1 vccd1 vccd1 sky130_fd_sc_hd__fill_4
XANTENNA__07565__A3 _03813_ vssd1 vssd1 vccd1 vccd1 sky130_fd_sc_hd__diode_2
XPHY_EDGE_ROW_7_Right_7 vssd1 vssd1 vccd1 vccd1 sky130_fd_sc_hd__decap_3
X_06992_ FPGA_INST.bus2_0\[2\] FPGA_INST.bus2_0\[3\] net434 vssd1 vssd1 vccd1 vccd1
+ _03258_ sky130_fd_sc_hd__mux2_1
X_08731_ _04843_ _04927_ _04929_ _04846_ _01771_ vssd1 vssd1 vccd1 vccd1 _04940_ sky130_fd_sc_hd__a221o_1
X_05943_ net96 net383 net159 _02181_ _01825_ vssd1 vssd1 vccd1 vccd1 _02223_ sky130_fd_sc_hd__o32a_1
XANTENNA__09036__X FPGA_INST.bus2_0\[0\] vssd1 vssd1 vccd1 vccd1 sky130_fd_sc_hd__diode_2
XANTENNA__09183__S net361 vssd1 vssd1 vccd1 vccd1 sky130_fd_sc_hd__diode_2
XANTENNA__08514__A2 net82 vssd1 vssd1 vccd1 vccd1 sky130_fd_sc_hd__diode_2
XFILLER_94_761 vssd1 vssd1 vccd1 vccd1 sky130_fd_sc_hd__fill_2
X_08662_ FPGA_INST.cell3.CB_0.config_dataA\[8\] _04870_ vssd1 vssd1 vccd1 vccd1 _04871_
+ sky130_fd_sc_hd__nor2_1
X_07613_ FPGA_INST.cell3.SB0.route_sel\[85\] _01641_ vssd1 vssd1 vccd1 vccd1 _03867_
+ sky130_fd_sc_hd__nand2_1
X_05874_ _01796_ _02151_ _02153_ vssd1 vssd1 vccd1 vccd1 _02154_ sky130_fd_sc_hd__o21ai_1
XTAP_TAPCELL_ROW_37_801 vssd1 vccd1 sky130_fd_sc_hd__tapvpwrvgnd_1
X_08593_ FPGA_INST.cell3.SB0.route_sel\[118\] FPGA_INST.cell3.SB0.route_sel\[119\]
+ vssd1 vssd1 vccd1 vccd1 _04802_ sky130_fd_sc_hd__nand2b_1
X_07544_ FPGA_INST.cell1.SB0.route_sel\[79\] FPGA_INST.cell1.SB0.route_sel\[78\] _02101_
+ _03798_ _02102_ vssd1 vssd1 vccd1 vccd1 _03799_ sky130_fd_sc_hd__a221o_1
XFILLER_22_500 vssd1 vssd1 vccd1 vccd1 sky130_fd_sc_hd__fill_1
X_07475_ FPGA_INST.cell3.SB0.route_sel\[62\] FPGA_INST.cell3.SB0.route_sel\[63\] vssd1
+ vssd1 vccd1 vccd1 _03732_ sky130_fd_sc_hd__nand2_1
XANTENNA__10924__SET_B net636 vssd1 vssd1 vccd1 vccd1 sky130_fd_sc_hd__diode_2
XFILLER_14_15 vccd1 vssd1 vccd1 vssd1 sky130_ef_sc_hd__decap_40_12
XFILLER_22_533 vssd1 vssd1 vccd1 vccd1 sky130_fd_sc_hd__fill_1
XANTENNA_fanout333_A net337 vssd1 vssd1 vccd1 vccd1 sky130_fd_sc_hd__diode_2
X_09214_ net514 net513 net275 vssd1 vssd1 vccd1 vccd1 _00127_ sky130_fd_sc_hd__mux2_1
XFILLER_61_190 vssd1 vssd1 vccd1 vccd1 sky130_fd_sc_hd__fill_1
XFILLER_14_37 vssd1 vssd1 vccd1 vccd1 sky130_fd_sc_hd__fill_1
X_06426_ net492 _02413_ _02703_ net490 vssd1 vssd1 vccd1 vccd1 _02704_ sky130_fd_sc_hd__o211a_1
XFILLER_10_739 vssd1 vssd1 vccd1 vccd1 sky130_fd_sc_hd__fill_1
XANTENNA_fanout219_X net219 vssd1 vssd1 vccd1 vccd1 sky130_fd_sc_hd__diode_2
X_09145_ FPGA_INST.cell2.LE_0A.config_data\[9\] FPGA_INST.cell2.LE_0A.config_data\[8\]
+ net356 vssd1 vssd1 vccd1 vccd1 _00060_ sky130_fd_sc_hd__mux2_1
X_06357_ net7 net8 net495 vssd1 vssd1 vccd1 vccd1 _02635_ sky130_fd_sc_hd__mux2_1
X_09076_ _05205_ net91 _03579_ vssd1 vssd1 vccd1 vccd1 net63 sky130_fd_sc_hd__mux2_1
XANTENNA__08450__A1 net145 vssd1 vssd1 vccd1 vccd1 sky130_fd_sc_hd__diode_2
X_05308_ FPGA_INST.cell2.CB_1.config_dataA\[7\] vssd1 vssd1 vccd1 vccd1 _01590_ sky130_fd_sc_hd__inv_2
X_06288_ _01532_ _02547_ _02550_ _02567_ _01534_ vssd1 vssd1 vccd1 vccd1 _02568_ sky130_fd_sc_hd__o311a_1
X_08027_ net458 _04049_ vssd1 vssd1 vccd1 vccd1 _04253_ sky130_fd_sc_hd__nand2_1
XANTENNA__06461__A0 net7 vssd1 vssd1 vccd1 vccd1 sky130_fd_sc_hd__diode_2
XANTENNA_fanout588_X net588 vssd1 vssd1 vccd1 vccd1 sky130_fd_sc_hd__diode_2
XANTENNA__08202__B2 _03759_ vssd1 vssd1 vccd1 vccd1 sky130_fd_sc_hd__diode_2
XANTENNA__08202__A1 _03797_ vssd1 vssd1 vccd1 vccd1 sky130_fd_sc_hd__diode_2
X_09978_ _05229_ _05230_ vssd1 vssd1 vccd1 vccd1 _00873_ sky130_fd_sc_hd__and2_1
XFILLER_89_588 vssd1 vssd1 vccd1 vccd1 sky130_fd_sc_hd__fill_1
XFILLER_49_408 vssd1 vssd1 vccd1 vccd1 sky130_fd_sc_hd__fill_1
XFILLER_130_195 vssd1 vssd1 vccd1 vccd1 sky130_fd_sc_hd__fill_1
XANTENNA_fanout79_A net80 vssd1 vssd1 vccd1 vccd1 sky130_fd_sc_hd__diode_2
X_08929_ FPGA_INST.cell3.SB0.route_sel\[102\] FPGA_INST.cell3.SB0.route_sel\[103\]
+ vssd1 vssd1 vccd1 vccd1 _05126_ sky130_fd_sc_hd__nor2_1
XFILLER_57_430 vssd1 vssd1 vccd1 vccd1 sky130_fd_sc_hd__fill_4
X_11940_ net913 _01286_ net697 vssd1 vssd1 vccd1 vccd1 FPGA_INST.cell3.CB_1.config_dataB\[5\]
+ sky130_fd_sc_hd__dfstp_1
XFILLER_91_219 vssd1 vssd1 vccd1 vccd1 sky130_fd_sc_hd__fill_4
XFILLER_85_783 vssd1 vssd1 vccd1 vccd1 sky130_fd_sc_hd__fill_1
X_11871_ net921 _01217_ net705 vssd1 vssd1 vccd1 vccd1 FPGA_INST.cell3.LE_0A.config_data\[1\]
+ sky130_fd_sc_hd__dfrtp_1
XFILLER_55_55 vssd1 vssd1 vccd1 vccd1 sky130_fd_sc_hd__fill_1
X_10822_ net821 _00172_ net605 vssd1 vssd1 vccd1 vccd1 FPGA_INST.cell1.SB0.route_sel\[31\]
+ sky130_fd_sc_hd__dfstp_1
XFILLER_32_319 vssd1 vssd1 vccd1 vccd1 sky130_fd_sc_hd__fill_1
X_10753_ net886 _00103_ net670 vssd1 vssd1 vccd1 vccd1 FPGA_INST.cell2.LE_1A.config_data\[8\]
+ sky130_fd_sc_hd__dfrtp_1
XFILLER_25_393 vssd1 vssd1 vccd1 vccd1 sky130_fd_sc_hd__fill_8
XANTENNA__06465__B _02092_ vssd1 vssd1 vccd1 vccd1 sky130_fd_sc_hd__diode_2
XFILLER_71_98 vssd1 vssd1 vccd1 vccd1 sky130_fd_sc_hd__fill_8
XFILLER_9_559 vssd1 vssd1 vccd1 vccd1 sky130_fd_sc_hd__fill_1
XFILLER_13_599 vssd1 vssd1 vccd1 vccd1 sky130_fd_sc_hd__fill_1
X_10684_ net880 _00034_ net665 vssd1 vssd1 vccd1 vccd1 FPGA_INST.cell2.LEI0.config_data\[33\]
+ sky130_fd_sc_hd__dfrtp_1
XANTENNA__07229__C1 net364 vssd1 vssd1 vccd1 vccd1 sky130_fd_sc_hd__diode_2
XTAP_TAPCELL_ROW_97_1644 vssd1 vccd1 sky130_fd_sc_hd__tapvpwrvgnd_1
XFILLER_5_721 vssd1 vssd1 vccd1 vccd1 sky130_fd_sc_hd__fill_4
X_11305_ net829 _00655_ net613 vssd1 vssd1 vccd1 vccd1 FPGA_INST.cell1.CB_0.config_dataA\[22\]
+ sky130_fd_sc_hd__dfstp_1
XANTENNA__10207__S net364 vssd1 vssd1 vccd1 vccd1 sky130_fd_sc_hd__diode_2
XFILLER_4_253 vssd1 vssd1 vccd1 vccd1 sky130_fd_sc_hd__fill_2
X_11236_ net764 _00586_ net549 vssd1 vssd1 vccd1 vccd1 FPGA_INST.cell0.SB0.route_sel\[81\]
+ sky130_fd_sc_hd__dfstp_1
X_11167_ net788 _00517_ net573 vssd1 vssd1 vccd1 vccd1 FPGA_INST.cell0.SB0.route_sel\[12\]
+ sky130_fd_sc_hd__dfstp_1
XFILLER_121_173 vssd1 vssd1 vccd1 vccd1 sky130_fd_sc_hd__fill_1
XFILLER_95_558 vssd1 vssd1 vccd1 vccd1 sky130_fd_sc_hd__fill_2
XFILLER_95_536 vssd1 vssd1 vccd1 vccd1 sky130_fd_sc_hd__fill_1
X_10118_ FPGA_INST.cell3.SB0.route_sel\[22\] FPGA_INST.cell3.SB0.route_sel\[23\] net244
+ vssd1 vssd1 vccd1 vccd1 _00999_ sky130_fd_sc_hd__mux2_1
X_11098_ net909 _00448_ net693 vssd1 vssd1 vccd1 vccd1 FPGA_INST.cell1.LE_0B.config_data\[11\]
+ sky130_fd_sc_hd__dfrtp_1
XTAP_TAPCELL_ROW_124_2018 vssd1 vccd1 sky130_fd_sc_hd__tapvpwrvgnd_1
XFILLER_95_569 vssd1 vssd1 vccd1 vccd1 sky130_fd_sc_hd__fill_1
XFILLER_76_761 vssd1 vssd1 vccd1 vccd1 sky130_fd_sc_hd__fill_2
XFILLER_48_441 vssd1 vssd1 vccd1 vccd1 sky130_fd_sc_hd__fill_4
XANTENNA__09731__S net344 vssd1 vssd1 vccd1 vccd1 sky130_fd_sc_hd__diode_2
XFILLER_63_411 vssd1 vssd1 vccd1 vccd1 sky130_fd_sc_hd__fill_1
X_10049_ FPGA_INST.cell0.CB_0.config_dataB\[24\] FPGA_INST.cell0.CB_0.config_dataB\[23\]
+ net320 vssd1 vssd1 vccd1 vccd1 _00930_ sky130_fd_sc_hd__mux2_1
XFILLER_63_444 vssd1 vssd1 vccd1 vccd1 sky130_fd_sc_hd__fill_4
XFILLER_36_647 vssd1 vssd1 vccd1 vccd1 sky130_fd_sc_hd__fill_1
XTAP_TAPCELL_ROW_106_1773 vssd1 vccd1 sky130_fd_sc_hd__tapvpwrvgnd_1
XTAP_TAPCELL_ROW_106_1762 vssd1 vccd1 sky130_fd_sc_hd__tapvpwrvgnd_1
XFILLER_23_308 vssd1 vssd1 vccd1 vccd1 sky130_fd_sc_hd__fill_8
X_05590_ FPGA_INST.cell0.CB_0.config_dataA\[24\] FPGA_INST.cell0.CB_0.config_dataA\[21\]
+ FPGA_INST.cell0.CB_0.config_dataA\[20\] vssd1 vssd1 vccd1 vccd1 _01870_ sky130_fd_sc_hd__and3b_1
XFILLER_35_157 vssd1 vssd1 vccd1 vccd1 sky130_fd_sc_hd__fill_2
XFILLER_90_296 vssd1 vssd1 vccd1 vccd1 sky130_fd_sc_hd__fill_1
XANTENNA__07468__C1 _03715_ vssd1 vssd1 vccd1 vccd1 sky130_fd_sc_hd__diode_2
XFILLER_51_639 vssd1 vssd1 vccd1 vccd1 sky130_fd_sc_hd__fill_4
XANTENNA__06375__B _02413_ vssd1 vssd1 vccd1 vccd1 sky130_fd_sc_hd__diode_2
XFILLER_31_330 vssd1 vssd1 vccd1 vccd1 sky130_fd_sc_hd__fill_4
X_07260_ FPGA_INST.cell3.SB0.route_sel\[18\] FPGA_INST.cell3.SB0.route_sel\[19\] vssd1
+ vssd1 vccd1 vccd1 _03522_ sky130_fd_sc_hd__nand2_1
XTAP_TAPCELL_ROW_42_870 vssd1 vccd1 sky130_fd_sc_hd__tapvpwrvgnd_1
XANTENNA__05905__B1_N FPGA_INST.bus2_0\[7\] vssd1 vssd1 vccd1 vccd1 sky130_fd_sc_hd__diode_2
XFILLER_117_402 vssd1 vssd1 vccd1 vccd1 sky130_fd_sc_hd__fill_2
X_07191_ FPGA_INST.cell1.CB_0.config_dataB\[24\] FPGA_INST.cell1.CB_0.config_dataB\[21\]
+ FPGA_INST.cell1.CB_0.config_dataB\[20\] vssd1 vssd1 vccd1 vccd1 _03454_ sky130_fd_sc_hd__or3b_1
X_06211_ FPGA_INST.cell2.CB_0.config_dataA\[8\] FPGA_INST.cell2.CB_0.config_dataA\[7\]
+ vssd1 vssd1 vccd1 vccd1 _02491_ sky130_fd_sc_hd__or2_1
XFILLER_129_295 vssd1 vssd1 vccd1 vccd1 sky130_fd_sc_hd__fill_1
XFILLER_117_435 vssd1 vssd1 vccd1 vccd1 sky130_fd_sc_hd__fill_2
X_06142_ _01970_ net158 FPGA_INST.bus2_0\[1\] vssd1 vssd1 vccd1 vccd1 _02422_ sky130_fd_sc_hd__o21bai_1
XANTENNA__05559__X _01839_ vssd1 vssd1 vccd1 vccd1 sky130_fd_sc_hd__diode_2
X_06073_ FPGA_INST.cell2.SB0.route_sel\[26\] FPGA_INST.cell2.SB0.route_sel\[27\] vssd1
+ vssd1 vccd1 vccd1 _02353_ sky130_fd_sc_hd__nand2_1
XANTENNA__10117__S net244 vssd1 vssd1 vccd1 vccd1 sky130_fd_sc_hd__diode_2
X_09901_ FPGA_INST.cell0.LE_0B.config_data\[5\] FPGA_INST.cell0.LE_0B.config_data\[6\]
+ net178 vssd1 vssd1 vccd1 vccd1 _00807_ sky130_fd_sc_hd__mux2_1
XANTENNA__06994__A1 FPGA_INST.bus2_0\[0\] vssd1 vssd1 vccd1 vccd1 sky130_fd_sc_hd__diode_2
XANTENNA__06994__B2 FPGA_INST.bus2_0\[1\] vssd1 vssd1 vccd1 vccd1 sky130_fd_sc_hd__diode_2
XANTENNA__08196__A0 net73 vssd1 vssd1 vccd1 vccd1 sky130_fd_sc_hd__diode_2
Xfanout505 FPGA_INST.cell2.CB_0.config_dataA\[6\] vssd1 vssd1 vccd1 vccd1 net505 sky130_fd_sc_hd__buf_2
Xfanout516 FPGA_INST.cell2.CB_1.config_dataB\[6\] vssd1 vssd1 vccd1 vccd1 net516 sky130_fd_sc_hd__buf_2
Xfanout538 net543 vssd1 vssd1 vccd1 vccd1 net538 sky130_fd_sc_hd__clkbuf_2
Xfanout527 net534 vssd1 vssd1 vccd1 vccd1 net527 sky130_fd_sc_hd__clkbuf_2
X_09832_ FPGA_INST.cell0.LEI0.config_data\[10\] FPGA_INST.cell0.LEI0.config_data\[11\]
+ net182 vssd1 vssd1 vccd1 vccd1 _00740_ sky130_fd_sc_hd__mux2_1
X_09763_ FPGA_INST.cell1.CB_0.config_dataB\[13\] FPGA_INST.cell1.CB_0.config_dataB\[14\]
+ net231 vssd1 vssd1 vccd1 vccd1 _00672_ sky130_fd_sc_hd__mux2_1
Xfanout549 net551 vssd1 vssd1 vccd1 vccd1 net549 sky130_fd_sc_hd__clkbuf_4
XANTENNA_fanout283_A net284 vssd1 vssd1 vccd1 vccd1 sky130_fd_sc_hd__diode_2
X_08714_ FPGA_INST.cell3.LE_0A.config_data\[5\] FPGA_INST.cell3.LE_0A.config_data\[4\]
+ _04860_ vssd1 vssd1 vccd1 vccd1 _04923_ sky130_fd_sc_hd__mux2_1
X_06975_ FPGA_INST.cell0.LE_0B.dff0_out FPGA_INST.cell0.LE_0B.dff1_out FPGA_INST.cell0.LE_0B.reset_val
+ vssd1 vssd1 vccd1 vccd1 FPGA_INST.cell0.LE_0B.dff_out sky130_fd_sc_hd__mux2_1
X_09694_ FPGA_INST.cell0.SB0.route_sel\[97\] FPGA_INST.cell0.SB0.route_sel\[98\] net196
+ vssd1 vssd1 vccd1 vccd1 _00603_ sky130_fd_sc_hd__mux2_1
X_05926_ _02193_ _02195_ _02205_ vssd1 vssd1 vccd1 vccd1 _02206_ sky130_fd_sc_hd__o21ai_1
X_08645_ _04849_ _04850_ _04852_ _01762_ vssd1 vssd1 vccd1 vccd1 _04854_ sky130_fd_sc_hd__o211a_1
XTAP_TAPCELL_ROW_68_1234 vssd1 vccd1 sky130_fd_sc_hd__tapvpwrvgnd_1
X_05857_ net112 _01927_ _02019_ vssd1 vssd1 vccd1 vccd1 _02137_ sky130_fd_sc_hd__nor3_1
X_08576_ _03903_ _04784_ vssd1 vssd1 vccd1 vccd1 _04785_ sky130_fd_sc_hd__nor2_2
XANTENNA_fanout548_A net554 vssd1 vssd1 vccd1 vccd1 sky130_fd_sc_hd__diode_2
XFILLER_54_477 vssd1 vssd1 vccd1 vccd1 sky130_fd_sc_hd__fill_1
X_07527_ net87 net27 _03780_ vssd1 vssd1 vccd1 vccd1 _03783_ sky130_fd_sc_hd__mux2_1
XANTENNA__07459__C1 _03715_ vssd1 vssd1 vccd1 vccd1 sky130_fd_sc_hd__diode_2
XTAP_TAPCELL_ROW_81_1423 vssd1 vccd1 sky130_fd_sc_hd__tapvpwrvgnd_1
XTAP_TAPCELL_ROW_81_1412 vssd1 vccd1 sky130_fd_sc_hd__tapvpwrvgnd_1
X_05788_ FPGA_INST.cell0.SB0.route_sel\[93\] FPGA_INST.cell0.SB0.route_sel\[92\] vssd1
+ vssd1 vccd1 vccd1 _02068_ sky130_fd_sc_hd__nand2b_1
XANTENNA_fanout336_X net336 vssd1 vssd1 vccd1 vccd1 sky130_fd_sc_hd__diode_2
XANTENNA_fanout715_A net731 vssd1 vssd1 vccd1 vccd1 sky130_fd_sc_hd__diode_2
X_07458_ FPGA_INST.cell1.SB0.route_sel\[56\] FPGA_INST.cell1.SB0.route_sel\[57\] vssd1
+ vssd1 vccd1 vccd1 _03715_ sky130_fd_sc_hd__nand2_1
XANTENNA__07474__A2 _02796_ vssd1 vssd1 vccd1 vccd1 sky130_fd_sc_hd__diode_2
X_07389_ _03634_ _03645_ _03646_ vssd1 vssd1 vccd1 vccd1 _03648_ sky130_fd_sc_hd__a21o_1
XFILLER_10_558 vssd1 vssd1 vccd1 vccd1 sky130_fd_sc_hd__fill_1
X_06409_ FPGA_INST.cell2.LEI0.config_data\[5\] _02686_ vssd1 vssd1 vccd1 vccd1 _02687_
+ sky130_fd_sc_hd__nand2b_1
XFILLER_41_57 vssd1 vssd1 vccd1 vccd1 sky130_fd_sc_hd__fill_8
X_09128_ FPGA_INST.cell2.LEI0.config_data\[42\] FPGA_INST.cell2.LEI0.config_data\[43\]
+ net261 vssd1 vssd1 vccd1 vccd1 _00044_ sky130_fd_sc_hd__mux2_1
XTAP_TAPCELL_ROW_20_564 vssd1 vccd1 sky130_fd_sc_hd__tapvpwrvgnd_1
XTAP_TAPCELL_ROW_79_1385 vssd1 vccd1 sky130_fd_sc_hd__tapvpwrvgnd_1
X_09059_ net723 FPGA_INST.cell3.LE_0B.reset_mode vssd1 vssd1 vccd1 vccd1 _09059_/X
+ sky130_fd_sc_hd__xor2_2
X_12070_ net854 _01416_ net639 vssd1 vssd1 vccd1 vccd1 FPGA_INST.cell2.SB0.route_sel\[110\]
+ sky130_fd_sc_hd__dfstp_1
XFILLER_1_234 vssd1 vssd1 vccd1 vccd1 sky130_fd_sc_hd__fill_2
XFILLER_2_757 vssd1 vssd1 vccd1 vccd1 sky130_fd_sc_hd__fill_1
X_11021_ net813 _00371_ net598 vssd1 vssd1 vccd1 vccd1 FPGA_INST.cell1.LEI0.config_data\[6\]
+ sky130_fd_sc_hd__dfrtp_1
XTAP_TAPCELL_ROW_92_1574 vssd1 vccd1 sky130_fd_sc_hd__tapvpwrvgnd_1
XFILLER_1_256 vssd1 vssd1 vccd1 vccd1 sky130_fd_sc_hd__fill_4
XFILLER_103_173 vssd1 vssd1 vccd1 vccd1 sky130_fd_sc_hd__fill_2
XANTENNA__06737__A1 FPGA_INST.bus3_2\[3\] vssd1 vssd1 vccd1 vccd1 sky130_fd_sc_hd__diode_2
XFILLER_2_18 vssd1 vssd1 vccd1 vccd1 sky130_fd_sc_hd__fill_8
XFILLER_64_208 vssd1 vssd1 vccd1 vccd1 sky130_fd_sc_hd__fill_1
X_11923_ net944 _01269_ net727 vssd1 vssd1 vccd1 vccd1 FPGA_INST.cell3.LE_1A.config_data\[9\]
+ sky130_fd_sc_hd__dfrtp_1
XANTENNA__09551__S net333 vssd1 vssd1 vccd1 vccd1 sky130_fd_sc_hd__diode_2
XANTENNA__07162__A1 net133 vssd1 vssd1 vccd1 vccd1 sky130_fd_sc_hd__diode_2
XFILLER_45_444 vssd1 vssd1 vccd1 vccd1 sky130_fd_sc_hd__fill_4
XANTENNA_input11_A gpio_in[19] vssd1 vssd1 vccd1 vccd1 sky130_fd_sc_hd__diode_2
XFILLER_17_124 vssd1 vssd1 vccd1 vccd1 sky130_fd_sc_hd__fill_1
X_11854_ net916 _01200_ net700 vssd1 vssd1 vccd1 vccd1 FPGA_INST.cell3.LEI0.config_data\[34\]
+ sky130_fd_sc_hd__dfrtp_1
XFILLER_122_71 vssd1 vssd1 vccd1 vccd1 sky130_fd_sc_hd__fill_2
XFILLER_73_797 vssd1 vssd1 vccd1 vccd1 sky130_fd_sc_hd__fill_2
XFILLER_60_403 vssd1 vssd1 vccd1 vccd1 sky130_fd_sc_hd__fill_1
XTAP_TAPCELL_ROW_28_675 vssd1 vccd1 sky130_fd_sc_hd__tapvpwrvgnd_1
XANTENNA__05380__A net27 vssd1 vssd1 vccd1 vccd1 sky130_fd_sc_hd__diode_2
X_10805_ net822 _00155_ net606 vssd1 vssd1 vccd1 vccd1 FPGA_INST.cell1.SB0.route_sel\[14\]
+ sky130_fd_sc_hd__dfstp_1
XANTENNA__10994__Q FPGA_INST.cell2.LE_1B.config_data\[0\] vssd1 vssd1 vccd1 vccd1
+ sky130_fd_sc_hd__diode_2
X_11785_ net890 _01131_ net674 vssd1 vssd1 vccd1 vccd1 FPGA_INST.io_south_oeb\[22\]
+ sky130_fd_sc_hd__dfrtp_1
XFILLER_60_458 vssd1 vssd1 vccd1 vccd1 sky130_fd_sc_hd__fill_1
XFILLER_32_149 vssd1 vssd1 vccd1 vccd1 sky130_fd_sc_hd__fill_1
XANTENNA__06268__A3 net17 vssd1 vssd1 vccd1 vccd1 sky130_fd_sc_hd__diode_2
X_10736_ net870 _00086_ net657 vssd1 vssd1 vccd1 vccd1 FPGA_INST.cell2.LE_0B.config_data\[13\]
+ sky130_fd_sc_hd__dfrtp_1
XTAP_TAPCELL_ROW_101_1692 vssd1 vccd1 sky130_fd_sc_hd__tapvpwrvgnd_1
X_10667_ net867 _00017_ net651 vssd1 vssd1 vccd1 vccd1 FPGA_INST.cell2.LEI0.config_data\[16\]
+ sky130_fd_sc_hd__dfrtp_1
X_10598_ FPGA_INST.cell3.CB_0.config_dataB\[18\] FPGA_INST.cell3.CB_0.config_dataB\[17\]
+ net378 vssd1 vssd1 vccd1 vccd1 _01477_ sky130_fd_sc_hd__mux2_1
XFILLER_126_287 vssd1 vssd1 vccd1 vccd1 sky130_fd_sc_hd__fill_1
XFILLER_114_427 vssd1 vssd1 vccd1 vccd1 sky130_fd_sc_hd__fill_1
XANTENNA__09726__S net344 vssd1 vssd1 vccd1 vccd1 sky130_fd_sc_hd__diode_2
XTAP_TAPCELL_ROW_130_2099 vssd1 vccd1 sky130_fd_sc_hd__tapvpwrvgnd_1
XANTENNA__08717__A2 _04819_ vssd1 vssd1 vccd1 vccd1 sky130_fd_sc_hd__diode_2
XTAP_TAPCELL_ROW_52_1013 vssd1 vccd1 sky130_fd_sc_hd__tapvpwrvgnd_1
X_11219_ net765 _00569_ net550 vssd1 vssd1 vccd1 vccd1 FPGA_INST.cell0.SB0.route_sel\[64\]
+ sky130_fd_sc_hd__dfstp_1
XANTENNA__06728__A1 FPGA_INST.bus3_2\[13\] vssd1 vssd1 vccd1 vccd1 sky130_fd_sc_hd__diode_2
XFILLER_110_666 vssd1 vssd1 vccd1 vccd1 sky130_fd_sc_hd__fill_4
XFILLER_95_355 vssd1 vssd1 vccd1 vccd1 sky130_fd_sc_hd__fill_1
XFILLER_49_761 vssd1 vssd1 vccd1 vccd1 sky130_fd_sc_hd__fill_1
XFILLER_110_699 vssd1 vssd1 vccd1 vccd1 sky130_fd_sc_hd__fill_1
X_06760_ FPGA_INST.bus3_2\[0\] FPGA_INST.bus3_2\[1\] FPGA_INST.bus3_2\[2\] FPGA_INST.bus3_2\[3\]
+ net514 FPGA_INST.cell2.CB_1.config_dataB\[11\] vssd1 vssd1 vccd1 vccd1 _03034_ sky130_fd_sc_hd__mux4_1
XFILLER_55_208 vssd1 vssd1 vccd1 vccd1 sky130_fd_sc_hd__fill_1
XANTENNA__07770__A net94 vssd1 vssd1 vccd1 vccd1 sky130_fd_sc_hd__diode_2
X_06691_ _02840_ _02963_ _02964_ _02843_ FPGA_INST.cell2.CB_1.config_dataB\[2\] vssd1
+ vssd1 vccd1 vccd1 _02965_ sky130_fd_sc_hd__a221o_1
X_05711_ FPGA_INST.cell2.CB_1.config_dataB\[24\] FPGA_INST.cell2.CB_1.config_dataB\[21\]
+ FPGA_INST.cell2.CB_1.config_dataB\[20\] vssd1 vssd1 vccd1 vccd1 _01991_ sky130_fd_sc_hd__or3b_1
XTAP_TAPCELL_ROW_47_940 vssd1 vccd1 sky130_fd_sc_hd__tapvpwrvgnd_1
XANTENNA__10400__S net305 vssd1 vssd1 vccd1 vccd1 sky130_fd_sc_hd__diode_2
XFILLER_91_561 vssd1 vssd1 vccd1 vccd1 sky130_fd_sc_hd__fill_4
XANTENNA__09033__Y FPGA_INST.bus1_0\[0\] vssd1 vssd1 vccd1 vccd1 sky130_fd_sc_hd__diode_2
XFILLER_64_775 vssd1 vssd1 vccd1 vccd1 sky130_fd_sc_hd__fill_4
X_08430_ FPGA_INST.cell1.SB0.route_sel\[124\] _01604_ _04649_ vssd1 vssd1 vccd1 vccd1
+ _04650_ sky130_fd_sc_hd__o21ai_1
XANTENNA__08350__A0 net115 vssd1 vssd1 vccd1 vccd1 sky130_fd_sc_hd__diode_2
X_05642_ net120 net384 net168 _01918_ _01817_ vssd1 vssd1 vccd1 vccd1 _01922_ sky130_fd_sc_hd__o32ai_1
XFILLER_23_105 vssd1 vssd1 vccd1 vccd1 sky130_fd_sc_hd__fill_4
XANTENNA__08102__A0 net152 vssd1 vssd1 vccd1 vccd1 sky130_fd_sc_hd__diode_2
X_05573_ _01798_ _01848_ _01852_ vssd1 vssd1 vccd1 vccd1 _01853_ sky130_fd_sc_hd__o21ai_1
XFILLER_51_469 vccd1 vssd1 vccd1 vssd1 sky130_ef_sc_hd__decap_40_12
X_08361_ _03923_ _04576_ _04577_ _03959_ _04582_ vssd1 vssd1 vccd1 vccd1 _04583_ sky130_fd_sc_hd__a221o_1
X_07312_ net133 _02360_ _03572_ FPGA_INST.cell3.SB0.route_sel\[28\] FPGA_INST.cell3.SB0.route_sel\[29\]
+ vssd1 vssd1 vccd1 vccd1 _03573_ sky130_fd_sc_hd__o2111a_1
XTAP_TAPCELL_ROW_63_1164 vssd1 vccd1 sky130_fd_sc_hd__tapvpwrvgnd_1
X_08292_ FPGA_INST.cell0.LE_1A.config_data\[16\] _04513_ _04514_ net155 vssd1 vssd1
+ vccd1 vccd1 FPGA_INST.cell0.CB_1.le_outA sky130_fd_sc_hd__o211a_1
X_07243_ _03501_ _03502_ _03503_ _02389_ _02380_ vssd1 vssd1 vccd1 vccd1 _03505_ sky130_fd_sc_hd__a311o_1
XTAP_TAPCELL_ROW_119_1953 vssd1 vccd1 sky130_fd_sc_hd__tapvpwrvgnd_1
XTAP_TAPCELL_ROW_119_1942 vssd1 vccd1 sky130_fd_sc_hd__tapvpwrvgnd_1
XANTENNA_fanout129_A net130 vssd1 vssd1 vccd1 vccd1 sky130_fd_sc_hd__diode_2
XFILLER_118_766 vssd1 vssd1 vccd1 vccd1 sky130_fd_sc_hd__fill_2
X_07174_ FPGA_INST.cell3.CB_0.config_dataA\[23\] FPGA_INST.cell3.CB_0.config_dataA\[22\]
+ vssd1 vssd1 vccd1 vccd1 _03438_ sky130_fd_sc_hd__or2_1
XANTENNA__05859__B1_N FPGA_INST.bus2_0\[8\] vssd1 vssd1 vccd1 vccd1 sky130_fd_sc_hd__diode_2
XFILLER_11_27 vssd1 vssd1 vccd1 vccd1 sky130_fd_sc_hd__fill_2
X_06125_ _01856_ _02366_ vssd1 vssd1 vccd1 vccd1 _02405_ sky130_fd_sc_hd__nand2_1
X_06056_ FPGA_INST.cell0.SB0.route_sel\[24\] FPGA_INST.cell0.SB0.route_sel\[25\] vssd1
+ vssd1 vccd1 vccd1 _02336_ sky130_fd_sc_hd__and2_1
XANTENNA__09636__S net314 vssd1 vssd1 vccd1 vccd1 sky130_fd_sc_hd__diode_2
XFILLER_120_419 vssd1 vssd1 vccd1 vccd1 sky130_fd_sc_hd__fill_1
Xfanout302 net305 vssd1 vssd1 vccd1 vccd1 net302 sky130_fd_sc_hd__clkbuf_4
Xfanout313 net314 vssd1 vssd1 vccd1 vccd1 net313 sky130_fd_sc_hd__clkbuf_4
Xfanout346 net348 vssd1 vssd1 vccd1 vccd1 net346 sky130_fd_sc_hd__clkbuf_4
Xfanout335 net336 vssd1 vssd1 vccd1 vccd1 net335 sky130_fd_sc_hd__clkbuf_4
X_09815_ FPGA_INST.cell1.LE_1B.config_data\[15\] FPGA_INST.cell1.LE_1B.config_data\[16\]
+ net217 vssd1 vssd1 vccd1 vccd1 _00724_ sky130_fd_sc_hd__mux2_1
XFILLER_86_300 vssd1 vssd1 vccd1 vccd1 sky130_fd_sc_hd__fill_8
Xfanout324 net325 vssd1 vssd1 vccd1 vccd1 net324 sky130_fd_sc_hd__buf_2
XFILLER_59_525 vccd1 vssd1 vccd1 vssd1 sky130_ef_sc_hd__decap_40_12
XANTENNA_input3_A gpio_in[11] vssd1 vssd1 vccd1 vccd1 sky130_fd_sc_hd__diode_2
Xfanout357 net363 vssd1 vssd1 vccd1 vccd1 net357 sky130_fd_sc_hd__clkbuf_4
Xfanout379 net380 vssd1 vssd1 vccd1 vccd1 net379 sky130_fd_sc_hd__clkbuf_4
Xfanout368 net369 vssd1 vssd1 vccd1 vccd1 net368 sky130_fd_sc_hd__clkbuf_4
XFILLER_100_121 vccd1 vssd1 vccd1 vssd1 sky130_ef_sc_hd__decap_40_12
XFILLER_101_699 vssd1 vssd1 vccd1 vccd1 sky130_fd_sc_hd__fill_1
XFILLER_101_677 vssd1 vssd1 vccd1 vccd1 sky130_fd_sc_hd__fill_2
XFILLER_100_154 vssd1 vssd1 vccd1 vccd1 sky130_fd_sc_hd__fill_2
X_09746_ FPGA_INST.cell1.CB_0.config_dataA\[21\] FPGA_INST.cell1.CB_0.config_dataA\[22\]
+ net226 vssd1 vssd1 vccd1 vccd1 _00655_ sky130_fd_sc_hd__mux2_1
X_06958_ _01748_ _03209_ _03210_ _03217_ _03225_ vssd1 vssd1 vccd1 vccd1 _03226_ sky130_fd_sc_hd__o32a_1
XANTENNA__09133__A2 net524 vssd1 vssd1 vccd1 vccd1 sky130_fd_sc_hd__diode_2
X_05909_ FPGA_INST.cell0.SB0.route_sel\[61\] FPGA_INST.cell0.SB0.route_sel\[60\] vssd1
+ vssd1 vccd1 vccd1 _02189_ sky130_fd_sc_hd__nand2b_1
XANTENNA__05752__X _02032_ vssd1 vssd1 vccd1 vccd1 sky130_fd_sc_hd__diode_2
X_09677_ FPGA_INST.cell0.SB0.route_sel\[80\] FPGA_INST.cell0.SB0.route_sel\[81\] net185
+ vssd1 vssd1 vccd1 vccd1 _00586_ sky130_fd_sc_hd__mux2_1
X_08628_ FPGA_INST.cell3.SB0.route_sel\[50\] FPGA_INST.cell3.SB0.route_sel\[51\] vssd1
+ vssd1 vccd1 vccd1 _04837_ sky130_fd_sc_hd__nor2_1
X_06889_ net114 net118 net111 net99 FPGA_INST.cell0.LEI0.config_data\[3\] FPGA_INST.cell0.LEI0.config_data\[4\]
+ vssd1 vssd1 vccd1 vccd1 _03157_ sky130_fd_sc_hd__mux4_1
XFILLER_27_455 vssd1 vssd1 vccd1 vccd1 sky130_fd_sc_hd__fill_4
XTAP_TAPCELL_ROW_25_634 vssd1 vccd1 sky130_fd_sc_hd__tapvpwrvgnd_1
XFILLER_27_488 vssd1 vssd1 vccd1 vccd1 sky130_fd_sc_hd__fill_2
X_08559_ FPGA_INST.cell3.LE_1B.config_data\[12\] FPGA_INST.cell3.LE_1B.config_data\[13\]
+ _04755_ vssd1 vssd1 vccd1 vccd1 _04770_ sky130_fd_sc_hd__mux2_1
X_11570_ net772 _00920_ net558 vssd1 vssd1 vccd1 vccd1 FPGA_INST.cell0.CB_0.config_dataB\[14\]
+ sky130_fd_sc_hd__dfstp_1
X_10521_ FPGA_INST.cell2.SB0.route_sel\[93\] FPGA_INST.cell2.SB0.route_sel\[94\] net246
+ vssd1 vssd1 vccd1 vccd1 _01400_ sky130_fd_sc_hd__mux2_1
XTAP_TAPCELL_ROW_94_1603 vssd1 vccd1 sky130_fd_sc_hd__tapvpwrvgnd_1
XANTENNA__07558__C _03812_ vssd1 vssd1 vccd1 vccd1 sky130_fd_sc_hd__diode_2
X_10452_ FPGA_INST.cell2.SB0.route_sel\[24\] FPGA_INST.cell2.SB0.route_sel\[25\] net236
+ vssd1 vssd1 vccd1 vccd1 _01331_ sky130_fd_sc_hd__mux2_1
X_10383_ FPGA_INST.cell3.LE_1A.config_data\[1\] FPGA_INST.cell3.LE_1A.config_data\[2\]
+ net304 vssd1 vssd1 vccd1 vccd1 _01262_ sky130_fd_sc_hd__mux2_1
XFILLER_124_747 vssd1 vssd1 vccd1 vccd1 sky130_fd_sc_hd__fill_2
X_12122_ net937 _01468_ net721 vssd1 vssd1 vccd1 vccd1 FPGA_INST.cell3.CB_0.config_dataB\[9\]
+ sky130_fd_sc_hd__dfstp_1
XANTENNA__06422__A3 net17 vssd1 vssd1 vccd1 vccd1 sky130_fd_sc_hd__diode_2
X_12053_ net857 _01399_ net642 vssd1 vssd1 vccd1 vccd1 FPGA_INST.cell2.SB0.route_sel\[93\]
+ sky130_fd_sc_hd__dfstp_1
XANTENNA__07907__A0 FPGA_INST.bus3_1\[12\] vssd1 vssd1 vccd1 vccd1 sky130_fd_sc_hd__diode_2
X_11004_ net923 _00354_ net707 vssd1 vssd1 vccd1 vccd1 FPGA_INST.cell2.LE_1B.config_data\[10\]
+ sky130_fd_sc_hd__dfrtp_1
XANTENNA__08175__A3 FPGA_INST.bus1_0\[7\] vssd1 vssd1 vccd1 vccd1 sky130_fd_sc_hd__diode_2
Xfanout891 net892 vssd1 vssd1 vccd1 vccd1 net891 sky130_fd_sc_hd__clkbuf_2
Xfanout880 net882 vssd1 vssd1 vccd1 vccd1 net880 sky130_fd_sc_hd__clkbuf_2
XANTENNA__07590__A net150 vssd1 vssd1 vccd1 vccd1 sky130_fd_sc_hd__diode_2
XFILLER_46_753 vssd1 vssd1 vccd1 vccd1 sky130_fd_sc_hd__fill_2
XANTENNA_input14_X net14 vssd1 vssd1 vccd1 vccd1 sky130_fd_sc_hd__diode_2
X_11906_ net939 _01252_ net723 vssd1 vssd1 vccd1 vccd1 FPGA_INST.cell3.LE_0B.config_data\[14\]
+ sky130_fd_sc_hd__dfrtp_1
XFILLER_73_561 vccd1 vssd1 vccd1 vssd1 sky130_ef_sc_hd__decap_40_12
XFILLER_46_775 vssd1 vssd1 vccd1 vccd1 sky130_fd_sc_hd__fill_4
XFILLER_18_477 vssd1 vssd1 vccd1 vccd1 sky130_fd_sc_hd__fill_8
XTAP_TAPCELL_ROW_103_1721 vssd1 vccd1 sky130_fd_sc_hd__tapvpwrvgnd_1
XANTENNA__10220__S net367 vssd1 vssd1 vccd1 vccd1 sky130_fd_sc_hd__diode_2
XANTENNA__08973__X FPGA_INST.bus2_0\[7\] vssd1 vssd1 vccd1 vccd1 sky130_fd_sc_hd__diode_2
X_11837_ net935 _01183_ net719 vssd1 vssd1 vccd1 vccd1 FPGA_INST.cell3.LEI0.config_data\[17\]
+ sky130_fd_sc_hd__dfrtp_1
XFILLER_33_447 vssd1 vssd1 vccd1 vccd1 sky130_fd_sc_hd__fill_1
X_11768_ net925 _01114_ net709 vssd1 vssd1 vccd1 vccd1 FPGA_INST.io_west_oeb\[20\]
+ sky130_fd_sc_hd__dfrtp_1
XFILLER_20_108 vssd1 vssd1 vccd1 vccd1 sky130_fd_sc_hd__fill_4
XANTENNA__06493__X FPGA_INST.cell2.CB_0.le_outB vssd1 vssd1 vccd1 vccd1 sky130_fd_sc_hd__diode_2
XANTENNA__06646__A0 FPGA_INST.bus3_2\[12\] vssd1 vssd1 vccd1 vccd1 sky130_fd_sc_hd__diode_2
X_10719_ net869 _00069_ net654 vssd1 vssd1 vccd1 vccd1 FPGA_INST.cell2.LE_0A.reset_val
+ sky130_fd_sc_hd__dfrtp_1
X_11699_ net896 _01045_ net680 vssd1 vssd1 vccd1 vccd1 FPGA_INST.cell3.SB0.route_sel\[69\]
+ sky130_fd_sc_hd__dfstp_1
XANTENNA__06653__B _02775_ vssd1 vssd1 vccd1 vccd1 sky130_fd_sc_hd__diode_2
XFILLER_9_197 vssd1 vssd1 vccd1 vccd1 sky130_fd_sc_hd__fill_1
XFILLER_54_3 vssd1 vssd1 vccd1 vccd1 sky130_fd_sc_hd__fill_1
XPHY_EDGE_ROW_39_Left_170 vssd1 vssd1 vccd1 vccd1 sky130_fd_sc_hd__decap_3
Xteam_15_949 vssd1 vssd1 vccd1 vccd1 team_15_949/HI gpio_oeb[1] sky130_fd_sc_hd__conb_1
XTAP_TAPCELL_ROW_114_1883 vssd1 vccd1 sky130_fd_sc_hd__tapvpwrvgnd_1
XTAP_TAPCELL_ROW_114_1872 vssd1 vccd1 sky130_fd_sc_hd__tapvpwrvgnd_1
X_07930_ FPGA_INST.bus3_1\[4\] FPGA_INST.bus3_1\[5\] FPGA_INST.bus3_1\[6\] FPGA_INST.bus3_1\[7\]
+ net467 FPGA_INST.cell1.CB_0.config_dataA\[11\] vssd1 vssd1 vccd1 vccd1 _04158_ sky130_fd_sc_hd__mux4_1
X_07861_ net469 _03690_ net468 vssd1 vssd1 vccd1 vccd1 _04089_ sky130_fd_sc_hd__o21ai_1
XANTENNA__07374__A1 net82 vssd1 vssd1 vccd1 vccd1 sky130_fd_sc_hd__diode_2
XTAP_TAPCELL_ROW_3_318 vssd1 vccd1 sky130_fd_sc_hd__tapvpwrvgnd_1
X_06812_ FPGA_INST.cell2.LE_1B.config_data\[11\] FPGA_INST.cell2.LE_1B.config_data\[10\]
+ _02992_ vssd1 vssd1 vccd1 vccd1 _03086_ sky130_fd_sc_hd__mux2_1
X_09600_ FPGA_INST.cell0.SB0.route_sel\[4\] FPGA_INST.cell0.SB0.route_sel\[3\] net338
+ vssd1 vssd1 vccd1 vccd1 _00509_ sky130_fd_sc_hd__mux2_1
X_07792_ _04040_ vssd1 vssd1 vccd1 vccd1 _04041_ sky130_fd_sc_hd__inv_2
XFILLER_56_528 vssd1 vssd1 vccd1 vccd1 sky130_fd_sc_hd__fill_1
XTAP_TAPCELL_ROW_3_329 vssd1 vccd1 sky130_fd_sc_hd__tapvpwrvgnd_1
X_09531_ FPGA_INST.cell1.LE_0B.config_data\[3\] FPGA_INST.cell1.LE_0B.config_data\[4\]
+ net231 vssd1 vssd1 vccd1 vccd1 _00441_ sky130_fd_sc_hd__mux2_1
XANTENNA__09191__S net361 vssd1 vssd1 vccd1 vccd1 sky130_fd_sc_hd__diode_2
X_06743_ net138 net127 net132 net103 FPGA_INST.cell2.LEI0.config_data\[21\] FPGA_INST.cell2.LEI0.config_data\[22\]
+ vssd1 vssd1 vccd1 vccd1 _03017_ sky130_fd_sc_hd__mux4_1
XFILLER_52_712 vssd1 vssd1 vccd1 vccd1 sky130_fd_sc_hd__fill_1
XFILLER_52_701 vssd1 vssd1 vccd1 vccd1 sky130_fd_sc_hd__fill_4
XFILLER_37_753 vssd1 vssd1 vccd1 vccd1 sky130_fd_sc_hd__fill_1
X_09462_ FPGA_INST.cell1.LEI0.config_data\[8\] FPGA_INST.cell1.LEI0.config_data\[9\]
+ net211 vssd1 vssd1 vccd1 vccd1 _00374_ sky130_fd_sc_hd__mux2_1
X_06674_ _02949_ _02948_ _02849_ vssd1 vssd1 vccd1 vccd1 _02950_ sky130_fd_sc_hd__mux2_1
X_09393_ FPGA_INST.cell2.CB_0.config_dataB\[12\] net490 net358 vssd1 vssd1 vccd1 vccd1
+ _00306_ sky130_fd_sc_hd__mux2_1
X_05625_ FPGA_INST.cell2.CB_0.config_dataA\[24\] FPGA_INST.cell2.CB_0.config_dataA\[21\]
+ FPGA_INST.cell2.CB_0.config_dataA\[20\] vssd1 vssd1 vccd1 vccd1 _01905_ sky130_fd_sc_hd__nand3b_1
X_08413_ FPGA_INST.cell0.CB_0.config_data_inA _04634_ _04632_ _04631_ vssd1 vssd1
+ vccd1 vccd1 _04635_ sky130_fd_sc_hd__o211a_1
X_08344_ _03465_ _04547_ _04548_ _03408_ FPGA_INST.cell0.CB_1.config_dataB\[2\] vssd1
+ vssd1 vccd1 vccd1 _04566_ sky130_fd_sc_hd__a221o_1
X_05556_ FPGA_INST.cell0.SB0.route_sel\[112\] FPGA_INST.cell0.SB0.route_sel\[113\]
+ _01829_ net322 _01834_ vssd1 vssd1 vccd1 vccd1 _01836_ sky130_fd_sc_hd__a311o_1
XFILLER_22_15 vssd1 vssd1 vccd1 vccd1 sky130_fd_sc_hd__fill_2
X_05487_ FPGA_INST.cell3.LEI0.config_data\[25\] vssd1 vssd1 vccd1 vccd1 _01769_ sky130_fd_sc_hd__inv_2
XTAP_TAPCELL_ROW_50_979 vssd1 vccd1 sky130_fd_sc_hd__tapvpwrvgnd_1
X_08275_ FPGA_INST.cell0.LE_1A.config_data\[2\] FPGA_INST.cell0.LE_1A.config_data\[3\]
+ _04410_ vssd1 vssd1 vccd1 vccd1 _04499_ sky130_fd_sc_hd__mux2_1
X_07226_ net86 net19 _03485_ vssd1 vssd1 vccd1 vccd1 _03489_ sky130_fd_sc_hd__mux2_1
XFILLER_118_585 vssd1 vssd1 vccd1 vccd1 sky130_fd_sc_hd__fill_2
XFILLER_118_574 vssd1 vssd1 vccd1 vccd1 sky130_fd_sc_hd__fill_2
X_07157_ _03415_ _03418_ _03420_ net339 vssd1 vssd1 vccd1 vccd1 _03421_ sky130_fd_sc_hd__a211o_4
XANTENNA_fanout201_X net201 vssd1 vssd1 vccd1 vccd1 sky130_fd_sc_hd__diode_2
XTAP_TAPCELL_ROW_76_1344 vssd1 vccd1 sky130_fd_sc_hd__tapvpwrvgnd_1
X_06108_ _02379_ _02384_ _02387_ net322 vssd1 vssd1 vccd1 vccd1 _02388_ sky130_fd_sc_hd__a211oi_1
XANTENNA_fanout782_A net790 vssd1 vssd1 vccd1 vccd1 sky130_fd_sc_hd__diode_2
X_07088_ _02429_ _03352_ _03353_ _02465_ FPGA_INST.cell0.CB_0.config_dataA\[17\] vssd1
+ vssd1 vccd1 vccd1 _03354_ sky130_fd_sc_hd__a221o_1
XFILLER_105_279 vssd1 vssd1 vccd1 vccd1 sky130_fd_sc_hd__fill_1
X_06039_ net100 _01990_ _02197_ _02317_ vssd1 vssd1 vccd1 vccd1 _02319_ sky130_fd_sc_hd__a31o_1
Xfanout110 net111 vssd1 vssd1 vccd1 vccd1 net110 sky130_fd_sc_hd__clkbuf_2
Xfanout121 net122 vssd1 vssd1 vccd1 vccd1 net121 sky130_fd_sc_hd__clkbuf_2
XFILLER_120_238 vssd1 vssd1 vccd1 vccd1 sky130_fd_sc_hd__fill_1
Xfanout154 FPGA_INST.cell1.CB_0.le_outA vssd1 vssd1 vccd1 vccd1 net154 sky130_fd_sc_hd__clkbuf_2
Xfanout143 FPGA_INST.cell1.CB_1.le_outB vssd1 vssd1 vccd1 vccd1 net143 sky130_fd_sc_hd__buf_1
XFILLER_101_430 vssd1 vssd1 vccd1 vccd1 sky130_fd_sc_hd__fill_4
XFILLER_87_664 vssd1 vssd1 vccd1 vccd1 sky130_fd_sc_hd__fill_2
Xfanout165 _01972_ vssd1 vssd1 vccd1 vccd1 net165 sky130_fd_sc_hd__clkbuf_4
Xfanout132 net134 vssd1 vssd1 vccd1 vccd1 net132 sky130_fd_sc_hd__buf_2
XANTENNA_input6_X net6 vssd1 vssd1 vccd1 vccd1 sky130_fd_sc_hd__diode_2
Xfanout187 net189 vssd1 vssd1 vccd1 vccd1 net187 sky130_fd_sc_hd__clkbuf_4
XFILLER_47_517 vssd1 vssd1 vccd1 vccd1 sky130_fd_sc_hd__fill_1
Xfanout198 net201 vssd1 vssd1 vccd1 vccd1 net198 sky130_fd_sc_hd__clkbuf_4
XFILLER_19_219 vssd1 vssd1 vccd1 vccd1 sky130_fd_sc_hd__fill_1
Xfanout176 net234 vssd1 vssd1 vccd1 vccd1 net176 sky130_fd_sc_hd__clkbuf_2
X_09729_ FPGA_INST.cell1.CB_0.config_dataA\[4\] net469 net230 vssd1 vssd1 vccd1 vccd1
+ _00638_ sky130_fd_sc_hd__mux2_1
XFILLER_101_485 vssd1 vssd1 vccd1 vccd1 sky130_fd_sc_hd__fill_4
XFILLER_74_325 vssd1 vssd1 vccd1 vccd1 sky130_fd_sc_hd__fill_1
XFILLER_28_731 vssd1 vssd1 vccd1 vccd1 sky130_fd_sc_hd__fill_4
XFILLER_27_252 vssd1 vssd1 vccd1 vccd1 sky130_fd_sc_hd__fill_1
XTAP_TAPCELL_ROW_87_1495 vssd1 vccd1 sky130_fd_sc_hd__tapvpwrvgnd_1
XFILLER_15_425 vssd1 vssd1 vccd1 vccd1 sky130_fd_sc_hd__fill_1
XFILLER_63_55 vssd1 vssd1 vccd1 vccd1 sky130_fd_sc_hd__fill_1
X_11622_ net744 _00972_ net529 vssd1 vssd1 vccd1 vccd1 FPGA_INST.cell0.LE_1B.config_data\[16\]
+ sky130_fd_sc_hd__dfrtp_1
XFILLER_30_417 vssd1 vssd1 vccd1 vccd1 sky130_fd_sc_hd__fill_2
XANTENNA__07202__X _03465_ vssd1 vssd1 vccd1 vccd1 sky130_fd_sc_hd__diode_2
XANTENNA__08093__A2 FPGA_INST.bus3_1\[14\] vssd1 vssd1 vccd1 vccd1 sky130_fd_sc_hd__diode_2
X_11553_ net772 _00903_ net557 vssd1 vssd1 vccd1 vccd1 FPGA_INST.cell0.CB_0.config_dataA\[22\]
+ sky130_fd_sc_hd__dfstp_2
XFILLER_10_163 vssd1 vssd1 vccd1 vccd1 sky130_fd_sc_hd__fill_1
XFILLER_7_646 vssd1 vssd1 vccd1 vccd1 sky130_fd_sc_hd__fill_1
X_11484_ net759 _00834_ net544 vssd1 vssd1 vccd1 vccd1 FPGA_INST.cell0.LE_1A.config_data\[11\]
+ sky130_fd_sc_hd__dfrtp_1
X_10504_ FPGA_INST.cell2.SB0.route_sel\[76\] FPGA_INST.cell2.SB0.route_sel\[77\] net260
+ vssd1 vssd1 vccd1 vccd1 _01383_ sky130_fd_sc_hd__mux2_1
XFILLER_12_81 vssd1 vssd1 vccd1 vccd1 sky130_fd_sc_hd__fill_1
X_10435_ FPGA_INST.cell2.SB0.route_sel\[7\] FPGA_INST.cell2.SB0.route_sel\[8\] net238
+ vssd1 vssd1 vccd1 vccd1 _01314_ sky130_fd_sc_hd__mux2_1
XFILLER_124_533 vssd1 vssd1 vccd1 vccd1 sky130_fd_sc_hd__fill_4
X_12105_ net936 _01451_ net720 vssd1 vssd1 vccd1 vccd1 FPGA_INST.cell3.CB_0.config_dataA\[17\]
+ sky130_fd_sc_hd__dfstp_2
X_10366_ FPGA_INST.cell3.LE_0B.config_data\[7\] FPGA_INST.cell3.LE_0B.config_data\[8\]
+ net293 vssd1 vssd1 vccd1 vccd1 _01246_ sky130_fd_sc_hd__mux2_1
X_10297_ FPGA_INST.cell3.LEI0.config_data\[12\] FPGA_INST.cell3.LEI0.config_data\[11\]
+ net370 vssd1 vssd1 vccd1 vccd1 _01178_ sky130_fd_sc_hd__mux2_1
XFILLER_111_227 vssd1 vssd1 vccd1 vccd1 sky130_fd_sc_hd__fill_8
XFILLER_88_85 vssd1 vssd1 vccd1 vccd1 sky130_fd_sc_hd__fill_4
XANTENNA__10215__S net367 vssd1 vssd1 vccd1 vccd1 sky130_fd_sc_hd__diode_2
X_12036_ net879 _01382_ net664 vssd1 vssd1 vccd1 vccd1 FPGA_INST.cell2.SB0.route_sel\[76\]
+ sky130_fd_sc_hd__dfstp_1
XFILLER_26_7 vssd1 vssd1 vccd1 vccd1 sky130_fd_sc_hd__fill_2
XTAP_TAPCELL_ROW_129_2090 vssd1 vccd1 sky130_fd_sc_hd__tapvpwrvgnd_1
XANTENNA__06648__B _02814_ vssd1 vssd1 vccd1 vccd1 sky130_fd_sc_hd__diode_2
XANTENNA__07108__A1 FPGA_INST.bus2_0\[14\] vssd1 vssd1 vccd1 vccd1 sky130_fd_sc_hd__diode_2
XFILLER_61_520 vssd1 vssd1 vccd1 vccd1 sky130_fd_sc_hd__fill_1
XANTENNA__08320__A3 net99 vssd1 vssd1 vccd1 vccd1 sky130_fd_sc_hd__diode_2
X_05410_ FPGA_INST.cell1.SB0.route_sel\[36\] vssd1 vssd1 vccd1 vccd1 _01692_ sky130_fd_sc_hd__inv_2
XTAP_TAPCELL_ROW_60_1123 vssd1 vccd1 sky130_fd_sc_hd__tapvpwrvgnd_1
X_06390_ net2 _02655_ _02656_ net30 _02667_ vssd1 vssd1 vccd1 vccd1 _02668_ sky130_fd_sc_hd__a221o_1
X_05341_ FPGA_INST.cell0.SB0.route_sel\[108\] vssd1 vssd1 vccd1 vccd1 _01623_ sky130_fd_sc_hd__inv_2
XTAP_TAPCELL_ROW_116_1901 vssd1 vccd1 sky130_fd_sc_hd__tapvpwrvgnd_1
X_08060_ FPGA_INST.cell1.CB_0.config_dataB\[2\] _04285_ vssd1 vssd1 vccd1 vccd1 _04286_
+ sky130_fd_sc_hd__nand2_1
X_05272_ FPGA_INST.cell2.SB0.route_sel\[24\] vssd1 vssd1 vccd1 vccd1 _01554_ sky130_fd_sc_hd__inv_2
XTAP_TAPCELL_ROW_116_1912 vssd1 vccd1 sky130_fd_sc_hd__tapvpwrvgnd_1
X_07011_ net114 net118 net110 net98 FPGA_INST.cell0.LEI0.config_data\[12\] FPGA_INST.cell0.LEI0.config_data\[13\]
+ vssd1 vssd1 vccd1 vccd1 _03277_ sky130_fd_sc_hd__mux4_1
XFILLER_127_382 vssd1 vssd1 vccd1 vccd1 sky130_fd_sc_hd__fill_1
XANTENNA__09039__X FPGA_INST.bus3_1\[0\] vssd1 vssd1 vccd1 vccd1 sky130_fd_sc_hd__diode_2
XFILLER_130_503 vssd1 vssd1 vccd1 vccd1 sky130_fd_sc_hd__fill_1
XANTENNA__06603__S _02878_ vssd1 vssd1 vccd1 vccd1 sky130_fd_sc_hd__diode_2
XANTENNA__06398__A2 _01869_ vssd1 vssd1 vccd1 vccd1 sky130_fd_sc_hd__diode_2
XFILLER_102_205 vssd1 vssd1 vccd1 vccd1 sky130_fd_sc_hd__fill_4
XTAP_TAPCELL_ROW_58_1096 vssd1 vccd1 sky130_fd_sc_hd__tapvpwrvgnd_1
X_08962_ FPGA_INST.cell2.SB0.route_sel\[66\] FPGA_INST.cell2.SB0.route_sel\[67\] vssd1
+ vssd1 vccd1 vccd1 _05148_ sky130_fd_sc_hd__and2b_1
X_07913_ net472 _04013_ _04140_ net471 vssd1 vssd1 vccd1 vccd1 _04141_ sky130_fd_sc_hd__o211a_1
X_08893_ _05034_ _05063_ _05065_ _05099_ vssd1 vssd1 vccd1 vccd1 _05100_ sky130_fd_sc_hd__a31oi_1
XANTENNA__09914__S net173 vssd1 vssd1 vccd1 vccd1 sky130_fd_sc_hd__diode_2
XFILLER_111_772 vccd1 vssd1 vccd1 vssd1 sky130_ef_sc_hd__decap_40_12
XFILLER_84_601 vssd1 vssd1 vccd1 vccd1 sky130_fd_sc_hd__fill_1
XTAP_TAPCELL_ROW_71_1274 vssd1 vccd1 sky130_fd_sc_hd__tapvpwrvgnd_1
XANTENNA_fanout196_A net201 vssd1 vssd1 vccd1 vccd1 sky130_fd_sc_hd__diode_2
X_07844_ net123 _02367_ _04075_ vssd1 vssd1 vccd1 vccd1 _04076_ sky130_fd_sc_hd__o21a_1
XFILLER_84_689 vssd1 vssd1 vccd1 vccd1 sky130_fd_sc_hd__fill_4
X_07775_ FPGA_INST.cell3.SB0.route_sel\[112\] FPGA_INST.cell3.SB0.route_sel\[113\]
+ _01610_ FPGA_INST.cell3.SB0.route_sel\[115\] _04024_ vssd1 vssd1 vccd1 vccd1 _04025_
+ sky130_fd_sc_hd__o221a_1
XANTENNA_fanout363_A net381 vssd1 vssd1 vccd1 vccd1 sky130_fd_sc_hd__diode_2
X_09514_ FPGA_INST.cell1.LE_0A.config_data\[9\] FPGA_INST.cell1.LE_0A.config_data\[10\]
+ net233 vssd1 vssd1 vccd1 vccd1 _00425_ sky130_fd_sc_hd__mux2_1
X_06726_ net518 _02810_ _02999_ net516 vssd1 vssd1 vccd1 vccd1 _03000_ sky130_fd_sc_hd__o211a_1
X_09445_ FPGA_INST.cell2.LE_1B.config_data\[13\] FPGA_INST.cell2.LE_1B.config_data\[14\]
+ net265 vssd1 vssd1 vccd1 vccd1 _00358_ sky130_fd_sc_hd__mux2_1
X_06657_ FPGA_INST.bus3_2\[4\] FPGA_INST.bus3_2\[5\] FPGA_INST.bus3_2\[6\] FPGA_INST.bus3_2\[7\]
+ net476 net474 vssd1 vssd1 vccd1 vccd1 _02933_ sky130_fd_sc_hd__mux4_1
XANTENNA__08311__A3 FPGA_INST.bus1_0\[7\] vssd1 vssd1 vccd1 vccd1 sky130_fd_sc_hd__diode_2
XFILLER_52_531 vssd1 vssd1 vccd1 vccd1 sky130_fd_sc_hd__fill_1
XFILLER_24_244 vssd1 vssd1 vccd1 vccd1 sky130_fd_sc_hd__fill_4
X_05608_ _01885_ _01887_ vssd1 vssd1 vccd1 vccd1 _01888_ sky130_fd_sc_hd__or2_4
XANTENNA_fanout628_A net31 vssd1 vssd1 vccd1 vccd1 sky130_fd_sc_hd__diode_2
XFILLER_24_277 vssd1 vssd1 vccd1 vccd1 sky130_fd_sc_hd__fill_2
XTAP_TAPCELL_ROW_35_773 vssd1 vccd1 sky130_fd_sc_hd__tapvpwrvgnd_1
X_06588_ net484 _02772_ _02863_ net482 vssd1 vssd1 vccd1 vccd1 _02864_ sky130_fd_sc_hd__o211a_1
X_09376_ FPGA_INST.cell2.CB_0.config_dataA\[19\] FPGA_INST.cell2.CB_0.config_dataA\[20\]
+ net240 vssd1 vssd1 vccd1 vccd1 _00289_ sky130_fd_sc_hd__mux2_1
X_08327_ _03959_ _04547_ _04548_ _03923_ _04546_ vssd1 vssd1 vccd1 vccd1 _04549_ sky130_fd_sc_hd__a221o_1
X_05539_ FPGA_INST.cell0.CB_0.config_dataB\[22\] FPGA_INST.cell0.CB_0.config_dataB\[23\]
+ vssd1 vssd1 vccd1 vccd1 _01819_ sky130_fd_sc_hd__nand2_1
XANTENNA__07283__B1 net78 vssd1 vssd1 vccd1 vccd1 sky130_fd_sc_hd__diode_2
X_08258_ _04475_ _04478_ _04479_ _04481_ vssd1 vssd1 vccd1 vccd1 _04482_ sky130_fd_sc_hd__a22o_1
X_07209_ _03461_ _03467_ _03471_ FPGA_INST.cell1.SB0.route_sel\[9\] FPGA_INST.cell1.SB0.route_sel\[8\]
+ vssd1 vssd1 vccd1 vccd1 _03472_ sky130_fd_sc_hd__o2111ai_4
X_10220_ FPGA_INST.cell3.SB0.route_sel\[125\] FPGA_INST.cell3.SB0.route_sel\[124\]
+ net367 vssd1 vssd1 vccd1 vccd1 _01101_ sky130_fd_sc_hd__mux2_1
X_08189_ net408 net409 vssd1 vssd1 vccd1 vccd1 _04413_ sky130_fd_sc_hd__and2b_1
XFILLER_3_148 vssd1 vssd1 vccd1 vccd1 sky130_fd_sc_hd__fill_8
XFILLER_121_514 vssd1 vssd1 vccd1 vccd1 sky130_fd_sc_hd__fill_4
XFILLER_106_577 vssd1 vssd1 vccd1 vccd1 sky130_fd_sc_hd__fill_4
X_10151_ FPGA_INST.cell3.SB0.route_sel\[56\] FPGA_INST.cell3.SB0.route_sel\[55\] net364
+ vssd1 vssd1 vccd1 vccd1 _01032_ sky130_fd_sc_hd__mux2_1
X_10082_ FPGA_INST.cell0.LE_1B.config_data\[7\] FPGA_INST.cell0.LE_1B.config_data\[6\]
+ net307 vssd1 vssd1 vccd1 vccd1 _00963_ sky130_fd_sc_hd__mux2_1
XFILLER_102_761 vssd1 vssd1 vccd1 vccd1 sky130_fd_sc_hd__fill_2
XANTENNA__07852__B _03568_ vssd1 vssd1 vccd1 vccd1 sky130_fd_sc_hd__diode_2
XFILLER_101_260 vssd1 vssd1 vccd1 vccd1 sky130_fd_sc_hd__fill_1
XTAP_TAPCELL_ROW_89_1535 vssd1 vccd1 sky130_fd_sc_hd__tapvpwrvgnd_1
XTAP_TAPCELL_ROW_89_1524 vssd1 vccd1 sky130_fd_sc_hd__tapvpwrvgnd_1
XFILLER_114_83 vssd1 vssd1 vccd1 vccd1 sky130_fd_sc_hd__fill_1
XFILLER_74_54 vssd1 vssd1 vccd1 vccd1 sky130_fd_sc_hd__fill_2
X_10984_ net887 _00334_ net671 vssd1 vssd1 vccd1 vccd1 FPGA_INST.cell2.CB_1.config_dataA\[15\]
+ sky130_fd_sc_hd__dfstp_1
XFILLER_43_520 vssd1 vssd1 vccd1 vccd1 sky130_fd_sc_hd__fill_4
XFILLER_55_391 vssd1 vssd1 vccd1 vccd1 sky130_fd_sc_hd__fill_1
XFILLER_30_214 vssd1 vssd1 vccd1 vccd1 sky130_fd_sc_hd__fill_1
X_11605_ net797 _00955_ net582 vssd1 vssd1 vccd1 vccd1 FPGA_INST.cell0.CB_1.config_dataA\[24\]
+ sky130_fd_sc_hd__dfstp_1
XTAP_TAPCELL_ROW_13_467 vssd1 vccd1 sky130_fd_sc_hd__tapvpwrvgnd_1
XANTENNA__07274__A0 net94 vssd1 vssd1 vccd1 vccd1 sky130_fd_sc_hd__diode_2
XFILLER_11_472 vssd1 vssd1 vccd1 vccd1 sky130_fd_sc_hd__fill_8
XFILLER_11_483 vssd1 vssd1 vccd1 vccd1 sky130_fd_sc_hd__fill_1
X_11536_ net777 _00886_ net563 vssd1 vssd1 vccd1 vccd1 FPGA_INST.cell0.CB_0.config_dataA\[5\]
+ sky130_fd_sc_hd__dfstp_1
Xmax_cap107 _02137_ vssd1 vssd1 vccd1 vccd1 net107 sky130_fd_sc_hd__buf_1
X_11467_ net752 _00817_ net537 vssd1 vssd1 vccd1 vccd1 FPGA_INST.cell0.LE_0B.config_data\[16\]
+ sky130_fd_sc_hd__dfrtp_1
X_10418_ FPGA_INST.cell3.CB_1.config_dataB\[15\] FPGA_INST.cell3.CB_1.config_dataB\[16\]
+ net281 vssd1 vssd1 vccd1 vccd1 _01297_ sky130_fd_sc_hd__mux2_1
XANTENNA__07577__A1 net83 vssd1 vssd1 vccd1 vccd1 sky130_fd_sc_hd__diode_2
XANTENNA__08369__A3 FPGA_INST.bus1_0\[3\] vssd1 vssd1 vccd1 vccd1 sky130_fd_sc_hd__diode_2
X_11398_ net761 _00748_ net546 vssd1 vssd1 vccd1 vccd1 FPGA_INST.cell0.LEI0.config_data\[19\]
+ sky130_fd_sc_hd__dfrtp_1
XTAP_TAPCELL_ROW_111_1831 vssd1 vccd1 sky130_fd_sc_hd__tapvpwrvgnd_1
XFILLER_97_225 vssd1 vssd1 vccd1 vccd1 sky130_fd_sc_hd__fill_1
X_10349_ FPGA_INST.cell3.LE_0A.config_data\[13\] FPGA_INST.cell3.LE_0A.config_data\[14\]
+ net292 vssd1 vssd1 vccd1 vccd1 _01230_ sky130_fd_sc_hd__mux2_1
XFILLER_3_671 vssd1 vssd1 vccd1 vccd1 sky130_fd_sc_hd__fill_1
XTAP_TAPCELL_ROW_111_1842 vssd1 vccd1 sky130_fd_sc_hd__tapvpwrvgnd_1
X_12019_ net847 _01365_ net632 vssd1 vssd1 vccd1 vccd1 FPGA_INST.cell2.SB0.route_sel\[59\]
+ sky130_fd_sc_hd__dfstp_1
X_05890_ _01810_ _02131_ _02168_ _01811_ FPGA_INST.cell2.CB_0.config_dataA\[7\] vssd1
+ vssd1 vccd1 vccd1 _02170_ sky130_fd_sc_hd__a221o_1
XFILLER_17_3 vssd1 vssd1 vccd1 vccd1 sky130_fd_sc_hd__fill_8
XFILLER_38_325 vssd1 vssd1 vccd1 vccd1 sky130_fd_sc_hd__fill_4
XANTENNA__08541__A3 net79 vssd1 vssd1 vccd1 vccd1 sky130_fd_sc_hd__diode_2
XFILLER_81_615 vssd1 vssd1 vccd1 vccd1 sky130_fd_sc_hd__fill_1
XFILLER_65_155 vssd1 vssd1 vccd1 vccd1 sky130_fd_sc_hd__fill_1
XFILLER_80_114 vssd1 vssd1 vccd1 vccd1 sky130_fd_sc_hd__fill_4
X_07560_ net164 _02036_ _02843_ vssd1 vssd1 vccd1 vccd1 _03815_ sky130_fd_sc_hd__a21oi_1
X_06511_ net480 _02777_ _02786_ vssd1 vssd1 vccd1 vccd1 _02787_ sky130_fd_sc_hd__a21oi_1
XFILLER_34_531 vssd1 vssd1 vccd1 vccd1 sky130_fd_sc_hd__fill_1
X_09230_ FPGA_INST.cell1.SB0.route_sel\[2\] FPGA_INST.cell1.SB0.route_sel\[1\] net339
+ vssd1 vssd1 vccd1 vccd1 _00143_ sky130_fd_sc_hd__mux2_1
X_07491_ FPGA_INST.cell1.CB_0.config_dataB\[22\] FPGA_INST.cell1.CB_0.config_dataB\[23\]
+ vssd1 vssd1 vccd1 vccd1 _03747_ sky130_fd_sc_hd__and2b_1
XTAP_TAPCELL_ROW_122_1993 vssd1 vccd1 sky130_fd_sc_hd__tapvpwrvgnd_1
X_06442_ net139 net128 net131 net102 FPGA_INST.cell2.LEI0.config_data\[27\] FPGA_INST.cell2.LEI0.config_data\[28\]
+ vssd1 vssd1 vccd1 vccd1 _02720_ sky130_fd_sc_hd__mux4_1
XTAP_TAPCELL_ROW_32_732 vssd1 vccd1 sky130_fd_sc_hd__tapvpwrvgnd_1
XFILLER_119_102 vssd1 vssd1 vccd1 vccd1 sky130_fd_sc_hd__fill_2
XANTENNA__08057__A2 FPGA_INST.bus3_1\[10\] vssd1 vssd1 vccd1 vccd1 sky130_fd_sc_hd__diode_2
X_06373_ _01540_ _02638_ _02649_ _02650_ _01537_ vssd1 vssd1 vccd1 vccd1 _02651_ sky130_fd_sc_hd__a32o_1
X_09161_ FPGA_INST.cell2.LE_0B.config_data\[1\] FPGA_INST.cell2.LE_0B.config_data\[2\]
+ net254 vssd1 vssd1 vccd1 vccd1 _00075_ sky130_fd_sc_hd__mux2_1
XFILLER_119_113 vssd1 vssd1 vccd1 vccd1 sky130_fd_sc_hd__fill_2
X_08112_ _03475_ _04336_ _04337_ _03421_ FPGA_INST.cell1.CB_0.config_dataB\[17\] vssd1
+ vssd1 vccd1 vccd1 _04338_ sky130_fd_sc_hd__a221o_1
XANTENNA__07265__B1 net78 vssd1 vssd1 vccd1 vccd1 sky130_fd_sc_hd__diode_2
X_05324_ FPGA_INST.cell0.SB0.route_sel\[120\] vssd1 vssd1 vccd1 vccd1 _01606_ sky130_fd_sc_hd__inv_2
X_09092_ FPGA_INST.cell2.LEI0.config_data\[6\] FPGA_INST.cell2.LEI0.config_data\[7\]
+ net262 vssd1 vssd1 vccd1 vccd1 _00008_ sky130_fd_sc_hd__mux2_1
XFILLER_9_93 vssd1 vssd1 vccd1 vccd1 sky130_fd_sc_hd__fill_2
XANTENNA__07002__B _02070_ vssd1 vssd1 vccd1 vccd1 sky130_fd_sc_hd__diode_2
X_08043_ FPGA_INST.bus3_1\[0\] FPGA_INST.bus3_1\[1\] FPGA_INST.bus3_1\[2\] FPGA_INST.bus3_1\[3\]
+ net460 FPGA_INST.cell1.CB_0.config_dataB\[1\] vssd1 vssd1 vccd1 vccd1 _04269_ sky130_fd_sc_hd__mux4_1
XANTENNA__07804__A2 _02814_ vssd1 vssd1 vccd1 vccd1 sky130_fd_sc_hd__diode_2
XANTENNA__06607__A3 FPGA_INST.bus3_2\[3\] vssd1 vssd1 vccd1 vccd1 sky130_fd_sc_hd__diode_2
XANTENNA_fanout209_A net219 vssd1 vssd1 vccd1 vccd1 sky130_fd_sc_hd__diode_2
X_05255_ FPGA_INST.cell2.LEI0.config_data\[17\] vssd1 vssd1 vccd1 vccd1 _01537_ sky130_fd_sc_hd__inv_2
XANTENNA_fanout111_A FPGA_INST.cell0.CB_1.le_outA vssd1 vssd1 vccd1 vccd1 sky130_fd_sc_hd__diode_2
XANTENNA__07568__A1 _03483_ vssd1 vssd1 vccd1 vccd1 sky130_fd_sc_hd__diode_2
XTAP_TAPCELL_ROW_73_1303 vssd1 vccd1 sky130_fd_sc_hd__tapvpwrvgnd_1
X_09994_ FPGA_INST.config_bits\[10\] FPGA_INST.config_bits\[9\] _05237_ _01529_ vssd1
+ vssd1 vccd1 vccd1 _05241_ sky130_fd_sc_hd__a31o_1
XFILLER_57_601 vssd1 vssd1 vccd1 vccd1 sky130_fd_sc_hd__fill_1
X_08945_ _01571_ FPGA_INST.cell2.SB0.route_sel\[81\] FPGA_INST.cell2.SB0.route_sel\[86\]
+ FPGA_INST.cell2.SB0.route_sel\[87\] _05136_ vssd1 vssd1 vccd1 vccd1 _05137_ sky130_fd_sc_hd__o221a_1
XANTENNA__05594__A3 _01873_ vssd1 vssd1 vccd1 vccd1 sky130_fd_sc_hd__diode_2
X_08876_ net386 _04839_ _05082_ FPGA_INST.cell3.CB_0.config_dataB\[16\] vssd1 vssd1
+ vccd1 vccd1 _05083_ sky130_fd_sc_hd__o211a_1
XFILLER_84_431 vssd1 vssd1 vccd1 vccd1 sky130_fd_sc_hd__fill_2
XFILLER_69_494 vssd1 vssd1 vccd1 vccd1 sky130_fd_sc_hd__fill_1
X_07827_ _02084_ _02085_ _04066_ _02086_ vssd1 vssd1 vccd1 vccd1 net55 sky130_fd_sc_hd__a31o_1
X_07758_ net224 _04007_ vssd1 vssd1 vccd1 vccd1 _04008_ sky130_fd_sc_hd__nand2_1
X_06709_ _02801_ _02963_ _02964_ _02804_ vssd1 vssd1 vccd1 vccd1 _02983_ sky130_fd_sc_hd__a22o_1
XFILLER_44_24 vssd1 vssd1 vccd1 vccd1 sky130_fd_sc_hd__fill_4
XANTENNA_fanout912_A net917 vssd1 vssd1 vccd1 vccd1 sky130_fd_sc_hd__diode_2
X_07689_ _03437_ _03939_ _03940_ _03433_ vssd1 vssd1 vccd1 vccd1 _03941_ sky130_fd_sc_hd__o211ai_1
XTAP_TAPCELL_ROW_84_1465 vssd1 vccd1 sky130_fd_sc_hd__tapvpwrvgnd_1
XTAP_TAPCELL_ROW_84_1454 vssd1 vccd1 sky130_fd_sc_hd__tapvpwrvgnd_1
XFILLER_71_169 vssd1 vssd1 vccd1 vccd1 sky130_fd_sc_hd__fill_1
XFILLER_52_361 vssd1 vssd1 vccd1 vccd1 sky130_fd_sc_hd__fill_2
XFILLER_25_553 vssd1 vssd1 vccd1 vccd1 sky130_fd_sc_hd__fill_1
X_09428_ FPGA_INST.cell2.CB_1.config_dataA\[21\] FPGA_INST.cell2.CB_1.config_dataA\[22\]
+ net249 vssd1 vssd1 vccd1 vccd1 _00341_ sky130_fd_sc_hd__mux2_1
XANTENNA__08048__A2 _03690_ vssd1 vssd1 vccd1 vccd1 sky130_fd_sc_hd__diode_2
X_09359_ FPGA_INST.cell2.CB_0.config_dataA\[3\] FPGA_INST.cell2.CB_0.config_dataA\[2\]
+ net356 vssd1 vssd1 vccd1 vccd1 _00272_ sky130_fd_sc_hd__mux2_1
XFILLER_12_269 vssd1 vssd1 vccd1 vccd1 sky130_fd_sc_hd__fill_1
XFILLER_100_96 vssd1 vssd1 vccd1 vccd1 sky130_fd_sc_hd__fill_4
XANTENNA__06059__A1 net170 vssd1 vssd1 vccd1 vccd1 sky130_fd_sc_hd__diode_2
X_11321_ net840 _00671_ net624 vssd1 vssd1 vccd1 vccd1 FPGA_INST.cell1.CB_0.config_dataB\[13\]
+ sky130_fd_sc_hd__dfstp_1
XTAP_TAPCELL_ROW_10_426 vssd1 vccd1 sky130_fd_sc_hd__tapvpwrvgnd_1
X_11252_ net781 _00602_ net566 vssd1 vssd1 vccd1 vccd1 FPGA_INST.cell0.SB0.route_sel\[97\]
+ sky130_fd_sc_hd__dfstp_1
XFILLER_121_300 vssd1 vssd1 vccd1 vccd1 sky130_fd_sc_hd__fill_1
XFILLER_106_363 vssd1 vssd1 vccd1 vccd1 sky130_fd_sc_hd__fill_1
X_10203_ FPGA_INST.cell3.SB0.route_sel\[107\] FPGA_INST.cell3.SB0.route_sel\[108\]
+ net271 vssd1 vssd1 vccd1 vccd1 _01084_ sky130_fd_sc_hd__mux2_1
X_11183_ net782 _00533_ net567 vssd1 vssd1 vccd1 vccd1 FPGA_INST.cell0.SB0.route_sel\[28\]
+ sky130_fd_sc_hd__dfstp_1
XFILLER_4_479 vssd1 vssd1 vccd1 vccd1 sky130_fd_sc_hd__fill_1
XFILLER_121_333 vssd1 vssd1 vccd1 vccd1 sky130_fd_sc_hd__fill_1
X_10134_ FPGA_INST.cell3.SB0.route_sel\[38\] FPGA_INST.cell3.SB0.route_sel\[39\] net278
+ vssd1 vssd1 vccd1 vccd1 _01015_ sky130_fd_sc_hd__mux2_1
XFILLER_69_87 vssd1 vssd1 vccd1 vccd1 sky130_fd_sc_hd__fill_1
XANTENNA__06231__A1 _02330_ vssd1 vssd1 vccd1 vccd1 sky130_fd_sc_hd__diode_2
XANTENNA__06231__B2 _02293_ vssd1 vssd1 vccd1 vccd1 sky130_fd_sc_hd__diode_2
XANTENNA__08678__B net80 vssd1 vssd1 vccd1 vccd1 sky130_fd_sc_hd__diode_2
XANTENNA__08771__A3 net21 vssd1 vssd1 vccd1 vccd1 sky130_fd_sc_hd__diode_2
XFILLER_88_770 vssd1 vssd1 vccd1 vccd1 sky130_fd_sc_hd__fill_1
XANTENNA__06782__A2 FPGA_INST.bus3_2\[14\] vssd1 vssd1 vccd1 vccd1 sky130_fd_sc_hd__diode_2
XFILLER_102_591 vssd1 vssd1 vccd1 vccd1 sky130_fd_sc_hd__fill_1
X_10065_ FPGA_INST.cell0.CB_1.config_dataA\[14\] net404 net203 vssd1 vssd1 vccd1 vccd1
+ _00946_ sky130_fd_sc_hd__mux2_1
XFILLER_16_531 vssd1 vssd1 vccd1 vccd1 sky130_fd_sc_hd__fill_1
XTAP_TAPCELL_ROW_18_537 vssd1 vccd1 sky130_fd_sc_hd__tapvpwrvgnd_1
XFILLER_16_575 vssd1 vssd1 vccd1 vccd1 sky130_fd_sc_hd__fill_2
X_10967_ net850 _00317_ net635 vssd1 vssd1 vccd1 vccd1 FPGA_INST.cell2.CB_0.config_dataB\[23\]
+ sky130_fd_sc_hd__dfstp_1
XANTENNA__05552__B1_N FPGA_INST.bus2_0\[14\] vssd1 vssd1 vccd1 vccd1 sky130_fd_sc_hd__diode_2
XANTENNA__07495__B1 FPGA_INST.bus3_1\[8\] vssd1 vssd1 vccd1 vccd1 sky130_fd_sc_hd__diode_2
X_10898_ net825 _00248_ net609 vssd1 vssd1 vccd1 vccd1 FPGA_INST.cell1.SB0.route_sel\[107\]
+ sky130_fd_sc_hd__dfstp_1
XFILLER_43_383 vssd1 vssd1 vccd1 vccd1 sky130_fd_sc_hd__fill_8
XANTENNA__09729__S net230 vssd1 vssd1 vccd1 vccd1 sky130_fd_sc_hd__diode_2
XANTENNA__07247__A0 net150 vssd1 vssd1 vccd1 vccd1 sky130_fd_sc_hd__diode_2
XFILLER_8_730 vssd1 vssd1 vccd1 vccd1 sky130_fd_sc_hd__fill_2
XFILLER_8_763 vccd1 vssd1 vccd1 vssd1 sky130_ef_sc_hd__decap_40_12
X_11519_ net808 _00869_ net594 vssd1 vssd1 vccd1 vccd1 FPGA_INST.config_bits\[0\]
+ sky130_fd_sc_hd__dfstp_1
XANTENNA__06470__B2 _01966_ vssd1 vssd1 vccd1 vccd1 sky130_fd_sc_hd__diode_2
XANTENNA__06470__A1 _02010_ vssd1 vssd1 vccd1 vccd1 sky130_fd_sc_hd__diode_2
Xfanout709 net710 vssd1 vssd1 vccd1 vccd1 net709 sky130_fd_sc_hd__clkbuf_4
XTAP_TAPCELL_ROW_55_1055 vssd1 vccd1 sky130_fd_sc_hd__tapvpwrvgnd_1
X_06991_ FPGA_INST.bus2_0\[4\] _03246_ _03255_ net432 vssd1 vssd1 vccd1 vccd1 _03257_
+ sky130_fd_sc_hd__a22o_1
X_08730_ net394 _04835_ vssd1 vssd1 vccd1 vccd1 _04939_ sky130_fd_sc_hd__nand2_1
XFILLER_79_781 vssd1 vssd1 vccd1 vccd1 sky130_fd_sc_hd__fill_2
X_05942_ net383 net159 net74 vssd1 vssd1 vccd1 vccd1 _02222_ sky130_fd_sc_hd__o21ai_1
XANTENNA__08514__A3 _01792_ vssd1 vssd1 vccd1 vccd1 sky130_fd_sc_hd__diode_2
X_08661_ _04868_ _04869_ FPGA_INST.cell3.CB_0.config_dataA\[7\] vssd1 vssd1 vccd1
+ vccd1 _04870_ sky130_fd_sc_hd__mux2_1
XFILLER_66_464 vssd1 vssd1 vccd1 vccd1 sky130_fd_sc_hd__fill_1
X_05873_ net101 _02151_ _02152_ vssd1 vssd1 vccd1 vccd1 _02153_ sky130_fd_sc_hd__a21oi_1
X_07612_ _03861_ _03865_ vssd1 vssd1 vccd1 vccd1 _03866_ sky130_fd_sc_hd__nor2_1
XFILLER_81_401 vssd1 vssd1 vccd1 vccd1 sky130_fd_sc_hd__fill_8
XFILLER_66_475 vssd1 vssd1 vccd1 vccd1 sky130_fd_sc_hd__fill_1
XTAP_TAPCELL_ROW_37_802 vssd1 vccd1 sky130_fd_sc_hd__tapvpwrvgnd_1
XFILLER_121_18 vccd1 vssd1 vccd1 vssd1 sky130_ef_sc_hd__decap_40_12
XFILLER_93_294 vssd1 vssd1 vccd1 vccd1 sky130_fd_sc_hd__fill_1
X_08592_ _04059_ _04800_ vssd1 vssd1 vccd1 vccd1 _04801_ sky130_fd_sc_hd__nor2_2
X_07543_ _03794_ _03795_ _03796_ _02106_ _02099_ vssd1 vssd1 vccd1 vccd1 _03798_ sky130_fd_sc_hd__a311o_1
X_07474_ _02199_ _02796_ _02202_ vssd1 vssd1 vccd1 vccd1 _03731_ sky130_fd_sc_hd__a21oi_1
XANTENNA__06328__S _02536_ vssd1 vssd1 vccd1 vccd1 sky130_fd_sc_hd__diode_2
XFILLER_14_27 vssd1 vssd1 vccd1 vccd1 sky130_fd_sc_hd__fill_1
XFILLER_22_512 vssd1 vssd1 vccd1 vccd1 sky130_fd_sc_hd__fill_4
X_09213_ FPGA_INST.cell2.CB_1.config_dataB\[9\] net515 net287 vssd1 vssd1 vccd1 vccd1
+ _00126_ sky130_fd_sc_hd__mux2_1
XFILLER_10_707 vssd1 vssd1 vccd1 vccd1 sky130_fd_sc_hd__fill_1
X_06425_ net491 _02376_ vssd1 vssd1 vccd1 vccd1 _02703_ sky130_fd_sc_hd__nand2_1
XANTENNA_fanout326_A net327 vssd1 vssd1 vccd1 vccd1 sky130_fd_sc_hd__diode_2
X_09144_ FPGA_INST.cell2.LE_0A.config_data\[7\] FPGA_INST.cell2.LE_0A.config_data\[8\]
+ net252 vssd1 vssd1 vccd1 vccd1 _00059_ sky130_fd_sc_hd__mux2_1
X_06356_ FPGA_INST.cell2.CB_0.config_dataB\[6\] _02631_ _02633_ vssd1 vssd1 vccd1
+ vccd1 _02634_ sky130_fd_sc_hd__a21o_1
XFILLER_107_127 vssd1 vssd1 vccd1 vccd1 sky130_fd_sc_hd__fill_4
X_09075_ net85 _04822_ _03577_ vssd1 vssd1 vccd1 vccd1 _05205_ sky130_fd_sc_hd__mux2_1
XANTENNA__08450__A2 net150 vssd1 vssd1 vccd1 vccd1 sky130_fd_sc_hd__diode_2
X_05307_ FPGA_INST.cell2.CB_1.config_dataA\[8\] vssd1 vssd1 vccd1 vccd1 _01589_ sky130_fd_sc_hd__inv_2
X_06287_ _02562_ _02566_ _02557_ vssd1 vssd1 vccd1 vccd1 _02567_ sky130_fd_sc_hd__a21o_1
X_08026_ _04250_ _04251_ _01728_ vssd1 vssd1 vccd1 vccd1 _04252_ sky130_fd_sc_hd__mux2_1
XANTENNA__06461__A1 net8 vssd1 vssd1 vccd1 vccd1 sky130_fd_sc_hd__diode_2
XANTENNA_fanout695_A net702 vssd1 vssd1 vccd1 vccd1 sky130_fd_sc_hd__diode_2
XFILLER_89_556 vssd1 vssd1 vccd1 vccd1 sky130_fd_sc_hd__fill_2
XFILLER_1_449 vssd1 vssd1 vccd1 vccd1 sky130_fd_sc_hd__fill_1
XANTENNA__09374__S net351 vssd1 vssd1 vccd1 vccd1 sky130_fd_sc_hd__diode_2
X_09977_ net738 FPGA_INST.config_bits\[3\] _05224_ FPGA_INST.config_bits\[4\] vssd1
+ vssd1 vccd1 vccd1 _05230_ sky130_fd_sc_hd__a31o_1
XANTENNA_fanout862_A net947 vssd1 vssd1 vccd1 vccd1 sky130_fd_sc_hd__diode_2
XANTENNA__06764__A2 _02793_ vssd1 vssd1 vccd1 vccd1 sky130_fd_sc_hd__diode_2
XFILLER_39_57 vssd1 vssd1 vccd1 vccd1 sky130_fd_sc_hd__fill_1
XFILLER_29_111 vssd1 vssd1 vccd1 vccd1 sky130_fd_sc_hd__fill_1
X_08928_ _05125_ _01963_ vssd1 vssd1 vccd1 vccd1 FPGA_INST.bus2_0\[12\] sky130_fd_sc_hd__and2b_2
XFILLER_45_604 vssd1 vssd1 vccd1 vccd1 sky130_fd_sc_hd__fill_8
X_08859_ FPGA_INST.cell3.LE_0B.config_data\[4\] FPGA_INST.cell3.LE_0B.config_data\[5\]
+ _05032_ vssd1 vssd1 vccd1 vccd1 _05066_ sky130_fd_sc_hd__mux2_1
X_11870_ net924 _01216_ net708 vssd1 vssd1 vccd1 vccd1 FPGA_INST.cell3.LE_0A.config_data\[0\]
+ sky130_fd_sc_hd__dfrtp_1
X_10821_ net821 _00171_ net605 vssd1 vssd1 vccd1 vccd1 FPGA_INST.cell1.SB0.route_sel\[30\]
+ sky130_fd_sc_hd__dfstp_1
X_10752_ net885 _00102_ net670 vssd1 vssd1 vccd1 vccd1 FPGA_INST.cell2.LE_1A.config_data\[7\]
+ sky130_fd_sc_hd__dfrtp_1
XFILLER_13_534 vssd1 vssd1 vccd1 vccd1 sky130_fd_sc_hd__fill_1
XFILLER_71_55 vssd1 vssd1 vccd1 vccd1 sky130_fd_sc_hd__fill_1
X_10683_ net880 _00033_ net667 vssd1 vssd1 vccd1 vccd1 FPGA_INST.cell2.LEI0.config_data\[32\]
+ sky130_fd_sc_hd__dfrtp_1
XTAP_TAPCELL_ROW_97_1634 vssd1 vccd1 sky130_fd_sc_hd__tapvpwrvgnd_1
XTAP_TAPCELL_ROW_97_1645 vssd1 vccd1 sky130_fd_sc_hd__tapvpwrvgnd_1
X_11304_ net829 _00654_ net613 vssd1 vssd1 vccd1 vccd1 FPGA_INST.cell1.CB_0.config_dataA\[21\]
+ sky130_fd_sc_hd__dfstp_1
XFILLER_5_744 vssd1 vssd1 vccd1 vccd1 sky130_fd_sc_hd__fill_8
XFILLER_5_733 vssd1 vssd1 vccd1 vccd1 sky130_fd_sc_hd__fill_2
XANTENNA__06452__A1 _02450_ vssd1 vssd1 vccd1 vccd1 sky130_fd_sc_hd__diode_2
XANTENNA__06452__B2 _02487_ vssd1 vssd1 vccd1 vccd1 sky130_fd_sc_hd__diode_2
XFILLER_5_777 vssd1 vssd1 vccd1 vccd1 sky130_fd_sc_hd__fill_1
XFILLER_4_265 vssd1 vssd1 vccd1 vccd1 sky130_fd_sc_hd__fill_1
X_11235_ net764 _00585_ net549 vssd1 vssd1 vccd1 vccd1 FPGA_INST.cell0.SB0.route_sel\[80\]
+ sky130_fd_sc_hd__dfstp_1
X_11166_ net785 _00516_ net570 vssd1 vssd1 vccd1 vccd1 FPGA_INST.cell0.SB0.route_sel\[11\]
+ sky130_fd_sc_hd__dfstp_1
X_11097_ net841 _00447_ net625 vssd1 vssd1 vccd1 vccd1 FPGA_INST.cell1.LE_0B.config_data\[10\]
+ sky130_fd_sc_hd__dfrtp_1
XFILLER_96_96 vssd1 vssd1 vccd1 vccd1 sky130_fd_sc_hd__fill_1
XFILLER_96_74 vssd1 vssd1 vccd1 vccd1 sky130_fd_sc_hd__fill_8
XFILLER_96_63 vssd1 vssd1 vccd1 vccd1 sky130_fd_sc_hd__fill_2
X_10117_ FPGA_INST.cell3.SB0.route_sel\[21\] FPGA_INST.cell3.SB0.route_sel\[22\] net244
+ vssd1 vssd1 vccd1 vccd1 _00998_ sky130_fd_sc_hd__mux2_1
X_10048_ FPGA_INST.cell0.CB_0.config_dataB\[22\] FPGA_INST.cell0.CB_0.config_dataB\[23\]
+ net191 vssd1 vssd1 vccd1 vccd1 _00929_ sky130_fd_sc_hd__mux2_1
XTAP_TAPCELL_ROW_124_2019 vssd1 vccd1 sky130_fd_sc_hd__tapvpwrvgnd_1
XFILLER_76_784 vssd1 vssd1 vccd1 vccd1 sky130_fd_sc_hd__fill_2
XFILLER_90_220 vssd1 vssd1 vccd1 vccd1 sky130_fd_sc_hd__fill_1
XTAP_TAPCELL_ROW_106_1763 vssd1 vccd1 sky130_fd_sc_hd__tapvpwrvgnd_1
XFILLER_91_798 vssd1 vssd1 vccd1 vccd1 sky130_fd_sc_hd__fill_1
XFILLER_90_242 vssd1 vssd1 vccd1 vccd1 sky130_fd_sc_hd__fill_2
XPHY_EDGE_ROW_11_Left_142 vssd1 vssd1 vccd1 vccd1 sky130_fd_sc_hd__decap_3
XFILLER_50_139 vssd1 vssd1 vccd1 vccd1 sky130_fd_sc_hd__fill_1
X_11999_ net852 _01345_ net637 vssd1 vssd1 vccd1 vccd1 FPGA_INST.cell2.SB0.route_sel\[39\]
+ sky130_fd_sc_hd__dfstp_1
XFILLER_44_692 vssd1 vssd1 vccd1 vccd1 sky130_fd_sc_hd__fill_2
XFILLER_84_3 vccd1 vssd1 vccd1 vssd1 sky130_ef_sc_hd__decap_40_12
XTAP_TAPCELL_ROW_42_871 vssd1 vccd1 sky130_fd_sc_hd__tapvpwrvgnd_1
X_06210_ net3 net4 net506 vssd1 vssd1 vccd1 vccd1 _02490_ sky130_fd_sc_hd__mux2_1
X_07190_ FPGA_INST.cell1.CB_0.config_dataB\[24\] FPGA_INST.cell1.CB_0.config_dataB\[21\]
+ FPGA_INST.cell1.CB_0.config_dataB\[20\] vssd1 vssd1 vccd1 vccd1 _03453_ sky130_fd_sc_hd__nor3b_2
XANTENNA__06691__B2 _02843_ vssd1 vssd1 vccd1 vccd1 sky130_fd_sc_hd__diode_2
XANTENNA__06691__A1 _02840_ vssd1 vssd1 vccd1 vccd1 sky130_fd_sc_hd__diode_2
X_06141_ FPGA_INST.cell0.SB0.route_sel\[11\] FPGA_INST.cell0.SB0.route_sel\[10\] _02418_
+ _02419_ _02420_ vssd1 vssd1 vccd1 vccd1 _02421_ sky130_fd_sc_hd__a221o_1
XPHY_EDGE_ROW_20_Left_151 vssd1 vssd1 vccd1 vccd1 sky130_fd_sc_hd__decap_3
X_06072_ _01782_ _01871_ _02333_ _02335_ _02351_ vssd1 vssd1 vccd1 vccd1 _02352_ sky130_fd_sc_hd__o32a_2
XFILLER_104_119 vccd1 vssd1 vccd1 vssd1 sky130_ef_sc_hd__decap_40_12
X_09900_ FPGA_INST.cell0.LE_0B.config_data\[5\] FPGA_INST.cell0.LE_0B.config_data\[4\]
+ net309 vssd1 vssd1 vccd1 vccd1 _00806_ sky130_fd_sc_hd__mux2_1
XFILLER_116_29 vccd1 vssd1 vccd1 vssd1 sky130_ef_sc_hd__decap_40_12
XFILLER_113_642 vssd1 vssd1 vccd1 vccd1 sky130_fd_sc_hd__fill_1
XFILLER_98_320 vssd1 vssd1 vccd1 vccd1 sky130_fd_sc_hd__fill_1
XANTENNA__08196__A1 net95 vssd1 vssd1 vccd1 vccd1 sky130_fd_sc_hd__diode_2
Xfanout506 FPGA_INST.cell2.CB_0.config_dataA\[5\] vssd1 vssd1 vccd1 vccd1 net506 sky130_fd_sc_hd__buf_2
XFILLER_112_141 vssd1 vssd1 vccd1 vccd1 sky130_fd_sc_hd__fill_4
Xfanout517 FPGA_INST.cell2.CB_1.config_dataB\[5\] vssd1 vssd1 vccd1 vccd1 net517 sky130_fd_sc_hd__clkbuf_4
Xfanout528 net534 vssd1 vssd1 vccd1 vccd1 net528 sky130_fd_sc_hd__clkbuf_4
Xfanout539 net543 vssd1 vssd1 vccd1 vccd1 net539 sky130_fd_sc_hd__clkbuf_4
X_09831_ FPGA_INST.cell0.LEI0.config_data\[9\] FPGA_INST.cell0.LEI0.config_data\[10\]
+ net182 vssd1 vssd1 vccd1 vccd1 _00739_ sky130_fd_sc_hd__mux2_1
X_09762_ FPGA_INST.cell1.CB_0.config_dataB\[13\] FPGA_INST.cell1.CB_0.config_dataB\[12\]
+ net347 vssd1 vssd1 vccd1 vccd1 _00671_ sky130_fd_sc_hd__mux2_1
XFILLER_113_686 vssd1 vssd1 vccd1 vccd1 sky130_fd_sc_hd__fill_2
X_06974_ _03241_ _03234_ _03230_ vssd1 vssd1 vccd1 vccd1 _03242_ sky130_fd_sc_hd__mux2_1
X_08713_ _04916_ _04920_ _04921_ vssd1 vssd1 vccd1 vccd1 _04922_ sky130_fd_sc_hd__and3_1
XFILLER_67_762 vssd1 vssd1 vccd1 vccd1 sky130_fd_sc_hd__fill_2
X_05925_ _02194_ _02204_ _02196_ vssd1 vssd1 vccd1 vccd1 _02205_ sky130_fd_sc_hd__a21oi_1
XANTENNA_fanout276_A net285 vssd1 vssd1 vccd1 vccd1 sky130_fd_sc_hd__diode_2
XFILLER_94_581 vssd1 vssd1 vccd1 vccd1 sky130_fd_sc_hd__fill_2
XFILLER_82_721 vssd1 vssd1 vccd1 vccd1 sky130_fd_sc_hd__fill_4
X_09693_ FPGA_INST.cell0.SB0.route_sel\[96\] FPGA_INST.cell0.SB0.route_sel\[97\] net196
+ vssd1 vssd1 vccd1 vccd1 _00602_ sky130_fd_sc_hd__mux2_1
XFILLER_27_615 vssd1 vssd1 vccd1 vccd1 sky130_fd_sc_hd__fill_1
X_08644_ FPGA_INST.cell3.CB_0.config_dataA\[2\] _04825_ _04832_ _04840_ _04847_ vssd1
+ vssd1 vccd1 vccd1 _04853_ sky130_fd_sc_hd__o32a_1
XFILLER_82_754 vssd1 vssd1 vccd1 vccd1 sky130_fd_sc_hd__fill_2
XTAP_TAPCELL_ROW_68_1235 vssd1 vccd1 sky130_fd_sc_hd__tapvpwrvgnd_1
XFILLER_66_283 vssd1 vssd1 vccd1 vccd1 sky130_fd_sc_hd__fill_2
X_05856_ net96 net167 _02016_ _02019_ _01927_ vssd1 vssd1 vccd1 vccd1 _02136_ sky130_fd_sc_hd__o32a_1
XFILLER_54_434 vssd1 vssd1 vccd1 vccd1 sky130_fd_sc_hd__fill_1
XFILLER_82_798 vssd1 vssd1 vccd1 vccd1 sky130_fd_sc_hd__fill_1
X_08575_ FPGA_INST.cell3.SB0.route_sel\[90\] FPGA_INST.cell3.SB0.route_sel\[91\] FPGA_INST.cell3.SB0.route_sel\[93\]
+ _01633_ _04783_ vssd1 vssd1 vccd1 vccd1 _04784_ sky130_fd_sc_hd__o221a_1
X_05787_ _02058_ _02063_ _02066_ net314 vssd1 vssd1 vccd1 vccd1 _02067_ sky130_fd_sc_hd__a211o_2
X_07526_ _03437_ _03781_ vssd1 vssd1 vccd1 vccd1 _03782_ sky130_fd_sc_hd__nor2_1
XTAP_TAPCELL_ROW_81_1413 vssd1 vccd1 sky130_fd_sc_hd__tapvpwrvgnd_1
XANTENNA__08120__A1 _03652_ vssd1 vssd1 vccd1 vccd1 sky130_fd_sc_hd__diode_2
XFILLER_50_651 vssd1 vssd1 vccd1 vccd1 sky130_fd_sc_hd__fill_1
XFILLER_50_640 vssd1 vssd1 vccd1 vccd1 sky130_fd_sc_hd__fill_1
X_07457_ _03713_ vssd1 vssd1 vccd1 vccd1 _03714_ sky130_fd_sc_hd__inv_2
XANTENNA__08671__A2 _04801_ vssd1 vssd1 vccd1 vccd1 sky130_fd_sc_hd__diode_2
XANTENNA_fanout610_A net615 vssd1 vssd1 vccd1 vccd1 sky130_fd_sc_hd__diode_2
X_07388_ FPGA_INST.cell1.SB0.route_sel\[43\] FPGA_INST.cell1.SB0.route_sel\[42\] _03641_
+ _03644_ vssd1 vssd1 vccd1 vccd1 _03647_ sky130_fd_sc_hd__a31oi_1
XANTENNA__09369__S net350 vssd1 vssd1 vccd1 vccd1 sky130_fd_sc_hd__diode_2
X_06408_ net138 net127 net131 net102 FPGA_INST.cell2.LEI0.config_data\[3\] FPGA_INST.cell2.LEI0.config_data\[4\]
+ vssd1 vssd1 vccd1 vccd1 _02686_ sky130_fd_sc_hd__mux4_1
X_06339_ net645 net249 vssd1 vssd1 vccd1 vccd1 _02619_ sky130_fd_sc_hd__and2_2
XTAP_TAPCELL_ROW_20_565 vssd1 vccd1 sky130_fd_sc_hd__tapvpwrvgnd_1
X_09127_ FPGA_INST.cell2.LEI0.config_data\[41\] FPGA_INST.cell2.LEI0.config_data\[42\]
+ net251 vssd1 vssd1 vccd1 vccd1 _00043_ sky130_fd_sc_hd__mux2_1
X_09058_ net927 FPGA_INST.cell3.LE_0A.edge_mode vssd1 vssd1 vccd1 vccd1 FPGA_INST.cell3.LE_0A.sel_clk
+ sky130_fd_sc_hd__xnor2_1
XTAP_TAPCELL_ROW_79_1386 vssd1 vccd1 sky130_fd_sc_hd__tapvpwrvgnd_1
XANTENNA__09893__A net736 vssd1 vssd1 vccd1 vccd1 sky130_fd_sc_hd__diode_2
X_08009_ _04234_ vssd1 vssd1 vccd1 vccd1 _04235_ sky130_fd_sc_hd__inv_2
XANTENNA__10927__CLK net851 vssd1 vssd1 vccd1 vccd1 sky130_fd_sc_hd__diode_2
XTAP_TAPCELL_ROW_92_1564 vssd1 vccd1 sky130_fd_sc_hd__tapvpwrvgnd_1
XFILLER_89_331 vssd1 vssd1 vccd1 vccd1 sky130_fd_sc_hd__fill_4
X_11020_ net813 _00370_ net598 vssd1 vssd1 vccd1 vccd1 FPGA_INST.cell1.LEI0.config_data\[5\]
+ sky130_fd_sc_hd__dfrtp_1
XFILLER_104_653 vssd1 vssd1 vccd1 vccd1 sky130_fd_sc_hd__fill_4
XTAP_TAPCELL_ROW_92_1575 vssd1 vccd1 sky130_fd_sc_hd__tapvpwrvgnd_1
XFILLER_104_686 vssd1 vssd1 vccd1 vccd1 sky130_fd_sc_hd__fill_1
XANTENNA__07934__A1 _03421_ vssd1 vssd1 vccd1 vccd1 sky130_fd_sc_hd__diode_2
XANTENNA__07934__B2 _03475_ vssd1 vssd1 vccd1 vccd1 sky130_fd_sc_hd__diode_2
XFILLER_89_397 vssd1 vssd1 vccd1 vccd1 sky130_fd_sc_hd__fill_1
XFILLER_89_375 vssd1 vssd1 vccd1 vccd1 sky130_fd_sc_hd__fill_4
XANTENNA__09136__A0 FPGA_INST.cell2.LE_0A.config_data\[0\] vssd1 vssd1 vccd1 vccd1
+ sky130_fd_sc_hd__diode_2
XFILLER_73_710 vccd1 vssd1 vccd1 vssd1 sky130_ef_sc_hd__decap_40_12
X_11922_ net943 _01268_ net727 vssd1 vssd1 vccd1 vccd1 FPGA_INST.cell3.LE_1A.config_data\[8\]
+ sky130_fd_sc_hd__dfrtp_1
XANTENNA__07698__B1 _02823_ vssd1 vssd1 vccd1 vccd1 sky130_fd_sc_hd__diode_2
X_11853_ net933 _01199_ net717 vssd1 vssd1 vccd1 vccd1 FPGA_INST.cell3.LEI0.config_data\[33\]
+ sky130_fd_sc_hd__dfrtp_1
XFILLER_122_83 vssd1 vssd1 vccd1 vccd1 sky130_fd_sc_hd__fill_1
XANTENNA__07162__A2 _02472_ vssd1 vssd1 vccd1 vccd1 sky130_fd_sc_hd__diode_2
X_10804_ net822 _00154_ net606 vssd1 vssd1 vccd1 vccd1 FPGA_INST.cell1.SB0.route_sel\[13\]
+ sky130_fd_sc_hd__dfstp_1
XTAP_TAPCELL_ROW_28_676 vssd1 vccd1 sky130_fd_sc_hd__tapvpwrvgnd_1
X_11784_ net926 _01130_ net710 vssd1 vssd1 vccd1 vccd1 FPGA_INST.io_south_oeb\[20\]
+ sky130_fd_sc_hd__dfrtp_1
XFILLER_13_331 vssd1 vssd1 vccd1 vccd1 sky130_fd_sc_hd__fill_1
XFILLER_41_673 vccd1 vssd1 vccd1 vssd1 sky130_ef_sc_hd__decap_40_12
XFILLER_9_324 vssd1 vssd1 vccd1 vccd1 sky130_fd_sc_hd__fill_1
XFILLER_13_364 vssd1 vssd1 vccd1 vccd1 sky130_fd_sc_hd__fill_1
XFILLER_13_386 vssd1 vssd1 vccd1 vccd1 sky130_fd_sc_hd__fill_1
X_10735_ net870 _00085_ net657 vssd1 vssd1 vccd1 vccd1 FPGA_INST.cell2.LE_0B.config_data\[12\]
+ sky130_fd_sc_hd__dfrtp_1
XTAP_TAPCELL_ROW_101_1693 vssd1 vccd1 sky130_fd_sc_hd__tapvpwrvgnd_1
XFILLER_9_335 vssd1 vssd1 vccd1 vccd1 sky130_fd_sc_hd__fill_1
X_10666_ net867 _00016_ net651 vssd1 vssd1 vccd1 vccd1 FPGA_INST.cell2.LEI0.config_data\[15\]
+ sky130_fd_sc_hd__dfrtp_1
XFILLER_40_194 vssd1 vssd1 vccd1 vccd1 sky130_fd_sc_hd__fill_2
X_10597_ FPGA_INST.cell3.CB_0.config_dataB\[17\] FPGA_INST.cell3.CB_0.config_dataB\[16\]
+ net378 vssd1 vssd1 vccd1 vccd1 _01476_ sky130_fd_sc_hd__mux2_1
XFILLER_114_417 vssd1 vssd1 vccd1 vccd1 sky130_fd_sc_hd__fill_2
XFILLER_99_117 vssd1 vssd1 vccd1 vccd1 sky130_fd_sc_hd__fill_2
XFILLER_49_6 vssd1 vssd1 vccd1 vccd1 sky130_fd_sc_hd__fill_2
XTAP_TAPCELL_ROW_52_1014 vssd1 vccd1 sky130_fd_sc_hd__tapvpwrvgnd_1
X_11218_ net765 _00568_ net550 vssd1 vssd1 vccd1 vccd1 FPGA_INST.cell0.SB0.route_sel\[63\]
+ sky130_fd_sc_hd__dfstp_1
X_11149_ net808 _00499_ net594 vssd1 vssd1 vccd1 vccd1 FPGA_INST.cell1.CB_1.config_dataB\[19\]
+ sky130_fd_sc_hd__dfstp_1
XFILLER_68_515 vssd1 vssd1 vccd1 vccd1 sky130_fd_sc_hd__fill_1
XANTENNA__06728__A2 FPGA_INST.bus3_2\[14\] vssd1 vssd1 vccd1 vccd1 sky130_fd_sc_hd__diode_2
XTAP_TAPCELL_ROW_8_390 vssd1 vccd1 sky130_fd_sc_hd__tapvpwrvgnd_1
XANTENNA_max_cap76_X net76 vssd1 vssd1 vccd1 vccd1 sky130_fd_sc_hd__diode_2
XFILLER_76_581 vssd1 vssd1 vccd1 vccd1 sky130_fd_sc_hd__fill_4
XFILLER_64_754 vssd1 vssd1 vccd1 vccd1 sky130_fd_sc_hd__fill_2
X_06690_ net519 net521 vssd1 vssd1 vccd1 vccd1 _02964_ sky130_fd_sc_hd__and2b_1
X_05710_ FPGA_INST.cell2.CB_1.config_dataB\[24\] FPGA_INST.cell2.CB_1.config_dataB\[21\]
+ FPGA_INST.cell2.CB_1.config_dataB\[20\] vssd1 vssd1 vccd1 vccd1 _01990_ sky130_fd_sc_hd__nor3b_1
XTAP_TAPCELL_ROW_47_941 vssd1 vccd1 sky130_fd_sc_hd__tapvpwrvgnd_1
X_05641_ net120 net384 net168 _01918_ _01817_ vssd1 vssd1 vccd1 vccd1 _01921_ sky130_fd_sc_hd__o32a_1
XANTENNA__08350__A1 net119 vssd1 vssd1 vccd1 vccd1 sky130_fd_sc_hd__diode_2
X_08360_ net442 _03997_ _04581_ net441 vssd1 vssd1 vccd1 vccd1 _04582_ sky130_fd_sc_hd__o211a_1
XANTENNA__06900__A2 _01888_ vssd1 vssd1 vccd1 vccd1 sky130_fd_sc_hd__diode_2
XFILLER_36_489 vssd1 vssd1 vccd1 vccd1 sky130_fd_sc_hd__fill_4
XANTENNA__08102__A1 net145 vssd1 vssd1 vccd1 vccd1 sky130_fd_sc_hd__diode_2
X_07311_ FPGA_INST.cell3.SB0.route_sel\[30\] FPGA_INST.cell3.SB0.route_sel\[31\] vssd1
+ vssd1 vccd1 vccd1 _03572_ sky130_fd_sc_hd__nand2_1
X_05572_ net101 _01848_ _01851_ vssd1 vssd1 vccd1 vccd1 _01852_ sky130_fd_sc_hd__a21oi_1
XTAP_TAPCELL_ROW_63_1165 vssd1 vccd1 sky130_fd_sc_hd__tapvpwrvgnd_1
X_08291_ _01756_ FPGA_INST.cell0.LE_1A.dff_out vssd1 vssd1 vccd1 vccd1 _04514_ sky130_fd_sc_hd__or2_1
X_07242_ _03501_ _03502_ _03503_ _02389_ vssd1 vssd1 vccd1 vccd1 _03504_ sky130_fd_sc_hd__a31o_4
XANTENNA__09189__S net361 vssd1 vssd1 vccd1 vccd1 sky130_fd_sc_hd__diode_2
XTAP_TAPCELL_ROW_119_1943 vssd1 vccd1 sky130_fd_sc_hd__tapvpwrvgnd_1
X_07173_ FPGA_INST.cell3.CB_0.config_dataA\[24\] FPGA_INST.cell3.CB_0.config_dataA\[21\]
+ FPGA_INST.cell3.CB_0.config_dataA\[20\] vssd1 vssd1 vccd1 vccd1 _03437_ sky130_fd_sc_hd__or3_2
XTAP_TAPCELL_ROW_119_1954 vssd1 vccd1 sky130_fd_sc_hd__tapvpwrvgnd_1
XANTENNA__06416__A1 _02131_ vssd1 vssd1 vccd1 vccd1 sky130_fd_sc_hd__diode_2
X_06124_ _02394_ _02396_ _02403_ vssd1 vssd1 vccd1 vccd1 _02404_ sky130_fd_sc_hd__a21o_1
XFILLER_117_277 vssd1 vssd1 vccd1 vccd1 sky130_fd_sc_hd__fill_1
XANTENNA__06416__B2 _02168_ vssd1 vssd1 vccd1 vccd1 sky130_fd_sc_hd__diode_2
X_06055_ net121 net171 net158 _02333_ _01871_ vssd1 vssd1 vccd1 vccd1 _02335_ sky130_fd_sc_hd__o32ai_1
Xfanout303 net304 vssd1 vssd1 vccd1 vccd1 net303 sky130_fd_sc_hd__clkbuf_4
Xfanout314 net315 vssd1 vssd1 vccd1 vccd1 net314 sky130_fd_sc_hd__clkbuf_4
Xfanout336 net337 vssd1 vssd1 vccd1 vccd1 net336 sky130_fd_sc_hd__buf_4
Xfanout347 net348 vssd1 vssd1 vccd1 vccd1 net347 sky130_fd_sc_hd__buf_2
X_09814_ FPGA_INST.cell1.LE_1B.config_data\[15\] FPGA_INST.cell1.LE_1B.config_data\[14\]
+ net335 vssd1 vssd1 vccd1 vccd1 _00723_ sky130_fd_sc_hd__mux2_1
XFILLER_100_100 vssd1 vssd1 vccd1 vccd1 sky130_fd_sc_hd__fill_1
XFILLER_59_537 vssd1 vssd1 vccd1 vccd1 sky130_fd_sc_hd__fill_1
Xfanout325 net381 vssd1 vssd1 vccd1 vccd1 net325 sky130_fd_sc_hd__clkbuf_2
Xfanout369 net372 vssd1 vssd1 vccd1 vccd1 net369 sky130_fd_sc_hd__buf_4
XFILLER_113_494 vssd1 vssd1 vccd1 vccd1 sky130_fd_sc_hd__fill_1
XFILLER_101_645 vssd1 vssd1 vccd1 vccd1 sky130_fd_sc_hd__fill_8
XFILLER_100_133 vssd1 vssd1 vccd1 vccd1 sky130_fd_sc_hd__fill_4
XFILLER_59_559 vssd1 vssd1 vccd1 vccd1 sky130_fd_sc_hd__fill_1
Xfanout358 net363 vssd1 vssd1 vccd1 vccd1 net358 sky130_fd_sc_hd__clkbuf_4
XFILLER_101_689 vssd1 vssd1 vccd1 vccd1 sky130_fd_sc_hd__fill_8
X_09745_ FPGA_INST.cell1.CB_0.config_dataA\[21\] FPGA_INST.cell1.CB_0.config_dataA\[20\]
+ net343 vssd1 vssd1 vccd1 vccd1 _00654_ sky130_fd_sc_hd__mux2_1
XANTENNA__07129__C1 net155 vssd1 vssd1 vccd1 vccd1 sky130_fd_sc_hd__diode_2
X_06957_ _03219_ _03220_ _03222_ _03224_ vssd1 vssd1 vccd1 vccd1 _03225_ sky130_fd_sc_hd__o22a_1
XANTENNA_fanout560_A net561 vssd1 vssd1 vccd1 vccd1 sky130_fd_sc_hd__diode_2
X_06888_ FPGA_INST.cell0.CB_0.config_dataB\[3\] _03135_ _03139_ _03155_ FPGA_INST.cell0.CB_0.config_dataB\[4\]
+ vssd1 vssd1 vccd1 vccd1 _03156_ sky130_fd_sc_hd__a311o_1
X_05908_ _02177_ _02184_ _02187_ net313 vssd1 vssd1 vccd1 vccd1 _02188_ sky130_fd_sc_hd__a211o_2
X_09676_ FPGA_INST.cell0.SB0.route_sel\[80\] FPGA_INST.cell0.SB0.route_sel\[79\] net313
+ vssd1 vssd1 vccd1 vccd1 _00585_ sky130_fd_sc_hd__mux2_1
X_08627_ _01764_ _03741_ _04834_ vssd1 vssd1 vccd1 vccd1 _04836_ sky130_fd_sc_hd__or3_1
XANTENNA__08341__A1 _03639_ vssd1 vssd1 vccd1 vccd1 sky130_fd_sc_hd__diode_2
XANTENNA__08341__B2 _03604_ vssd1 vssd1 vccd1 vccd1 sky130_fd_sc_hd__diode_2
X_05839_ net129 _02117_ vssd1 vssd1 vccd1 vccd1 _02119_ sky130_fd_sc_hd__nand2_1
XFILLER_27_445 vssd1 vssd1 vccd1 vccd1 sky130_fd_sc_hd__fill_2
XFILLER_55_798 vssd1 vssd1 vccd1 vccd1 sky130_fd_sc_hd__fill_1
XFILLER_42_437 vssd1 vssd1 vccd1 vccd1 sky130_fd_sc_hd__fill_4
X_08558_ _04768_ _04761_ _04759_ vssd1 vssd1 vccd1 vccd1 _04769_ sky130_fd_sc_hd__mux2_1
XTAP_TAPCELL_ROW_25_635 vssd1 vccd1 sky130_fd_sc_hd__tapvpwrvgnd_1
X_08489_ FPGA_INST.cell1.LE_1B.config_data\[0\] FPGA_INST.cell1.LE_1B.config_data\[1\]
+ _04692_ vssd1 vssd1 vccd1 vccd1 _04705_ sky130_fd_sc_hd__mux2_1
X_07509_ _03763_ _03764_ vssd1 vssd1 vccd1 vccd1 _03765_ sky130_fd_sc_hd__nand2_1
XFILLER_50_470 vssd1 vssd1 vccd1 vccd1 sky130_fd_sc_hd__fill_4
XANTENNA__12087__Q FPGA_INST.cell2.SB0.config_data_out vssd1 vssd1 vccd1 vccd1 sky130_fd_sc_hd__diode_2
XANTENNA__06655__A1 _02780_ vssd1 vssd1 vccd1 vccd1 sky130_fd_sc_hd__diode_2
XANTENNA__06655__B2 _02784_ vssd1 vssd1 vccd1 vccd1 sky130_fd_sc_hd__diode_2
XFILLER_10_334 vssd1 vssd1 vccd1 vccd1 sky130_fd_sc_hd__fill_1
X_10520_ FPGA_INST.cell2.SB0.route_sel\[92\] FPGA_INST.cell2.SB0.route_sel\[93\] net247
+ vssd1 vssd1 vccd1 vccd1 _01399_ sky130_fd_sc_hd__mux2_1
X_10451_ FPGA_INST.cell2.SB0.route_sel\[23\] FPGA_INST.cell2.SB0.route_sel\[24\] net235
+ vssd1 vssd1 vccd1 vccd1 _01330_ sky130_fd_sc_hd__mux2_1
XTAP_TAPCELL_ROW_94_1604 vssd1 vccd1 sky130_fd_sc_hd__tapvpwrvgnd_1
X_10382_ FPGA_INST.cell3.LE_1A.config_data\[1\] FPGA_INST.cell3.LE_1A.config_data\[0\]
+ net376 vssd1 vssd1 vccd1 vccd1 _01261_ sky130_fd_sc_hd__mux2_1
XFILLER_123_225 vssd1 vssd1 vccd1 vccd1 sky130_fd_sc_hd__fill_4
X_12121_ net937 _01467_ net721 vssd1 vssd1 vccd1 vccd1 FPGA_INST.cell3.CB_0.config_dataB\[8\]
+ sky130_fd_sc_hd__dfstp_1
XFILLER_117_72 vssd1 vssd1 vccd1 vccd1 sky130_fd_sc_hd__fill_2
XANTENNA_fanout94_X net94 vssd1 vssd1 vccd1 vccd1 sky130_fd_sc_hd__diode_2
X_12052_ net858 _01398_ net643 vssd1 vssd1 vccd1 vccd1 FPGA_INST.cell2.SB0.route_sel\[92\]
+ sky130_fd_sc_hd__dfstp_1
XANTENNA__07907__A1 FPGA_INST.bus3_1\[13\] vssd1 vssd1 vccd1 vccd1 sky130_fd_sc_hd__diode_2
XFILLER_77_54 vssd1 vssd1 vccd1 vccd1 sky130_fd_sc_hd__fill_2
XFILLER_77_43 vssd1 vssd1 vccd1 vccd1 sky130_fd_sc_hd__fill_1
X_11003_ net923 _00353_ net707 vssd1 vssd1 vccd1 vccd1 FPGA_INST.cell2.LE_1B.config_data\[9\]
+ sky130_fd_sc_hd__dfrtp_1
XFILLER_77_356 vssd1 vssd1 vccd1 vccd1 sky130_fd_sc_hd__fill_4
XFILLER_77_76 vssd1 vssd1 vccd1 vccd1 sky130_fd_sc_hd__fill_1
XFILLER_77_65 vssd1 vssd1 vccd1 vccd1 sky130_fd_sc_hd__fill_2
Xfanout870 net873 vssd1 vssd1 vccd1 vccd1 net870 sky130_fd_sc_hd__buf_1
XFILLER_92_315 vssd1 vssd1 vccd1 vccd1 sky130_fd_sc_hd__fill_4
XFILLER_77_389 vssd1 vssd1 vccd1 vccd1 sky130_fd_sc_hd__fill_2
XFILLER_65_518 vssd1 vssd1 vccd1 vccd1 sky130_fd_sc_hd__fill_1
Xfanout892 net947 vssd1 vssd1 vccd1 vccd1 net892 sky130_fd_sc_hd__buf_2
XANTENNA__06591__A0 FPGA_INST.bus3_2\[4\] vssd1 vssd1 vccd1 vccd1 sky130_fd_sc_hd__diode_2
Xfanout881 net882 vssd1 vssd1 vccd1 vccd1 net881 sky130_fd_sc_hd__buf_1
XFILLER_45_220 vssd1 vssd1 vccd1 vccd1 sky130_fd_sc_hd__fill_4
X_11905_ net939 _01251_ net723 vssd1 vssd1 vccd1 vccd1 FPGA_INST.cell3.LE_0B.config_data\[13\]
+ sky130_fd_sc_hd__dfrtp_1
XFILLER_92_359 vssd1 vssd1 vccd1 vccd1 sky130_fd_sc_hd__fill_1
XTAP_TAPCELL_ROW_44_900 vssd1 vccd1 sky130_fd_sc_hd__tapvpwrvgnd_1
XANTENNA__07082__S _03313_ vssd1 vssd1 vccd1 vccd1 sky130_fd_sc_hd__diode_2
X_11836_ net932 _01182_ net716 vssd1 vssd1 vccd1 vccd1 FPGA_INST.cell3.LEI0.config_data\[16\]
+ sky130_fd_sc_hd__dfrtp_1
XTAP_TAPCELL_ROW_103_1722 vssd1 vccd1 sky130_fd_sc_hd__tapvpwrvgnd_1
X_11767_ net925 _01113_ net709 vssd1 vssd1 vccd1 vccd1 FPGA_INST.io_west_oeb\[18\]
+ sky130_fd_sc_hd__dfrtp_1
XANTENNA__06646__A1 FPGA_INST.bus3_2\[13\] vssd1 vssd1 vccd1 vccd1 sky130_fd_sc_hd__diode_2
X_10718_ net869 _00068_ net654 vssd1 vssd1 vccd1 vccd1 FPGA_INST.cell2.LE_0A.edge_mode
+ sky130_fd_sc_hd__dfstp_1
XANTENNA__06934__B _01888_ vssd1 vssd1 vccd1 vccd1 sky130_fd_sc_hd__diode_2
X_11698_ net903 _01044_ net687 vssd1 vssd1 vccd1 vccd1 FPGA_INST.cell3.SB0.route_sel\[68\]
+ sky130_fd_sc_hd__dfstp_1
X_10649_ FPGA_INST.cell3.LE_1B.reset_val FPGA_INST.cell3.LE_1B.reset_mode net302 vssd1
+ vssd1 vccd1 vccd1 _01528_ sky130_fd_sc_hd__mux2_1
XANTENNA__09737__S net344 vssd1 vssd1 vccd1 vccd1 sky130_fd_sc_hd__diode_2
XFILLER_114_258 vssd1 vssd1 vccd1 vccd1 sky130_fd_sc_hd__fill_1
XTAP_TAPCELL_ROW_114_1873 vssd1 vccd1 sky130_fd_sc_hd__tapvpwrvgnd_1
XFILLER_47_3 vssd1 vssd1 vccd1 vccd1 sky130_fd_sc_hd__fill_2
XFILLER_5_393 vccd1 vssd1 vccd1 vssd1 sky130_ef_sc_hd__decap_40_12
XTAP_TAPCELL_ROW_114_1884 vssd1 vccd1 sky130_fd_sc_hd__tapvpwrvgnd_1
X_07860_ _04086_ _04087_ FPGA_INST.cell1.CB_0.config_dataA\[7\] vssd1 vssd1 vccd1
+ vccd1 _04088_ sky130_fd_sc_hd__mux2_1
XFILLER_96_643 vssd1 vssd1 vccd1 vccd1 sky130_fd_sc_hd__fill_1
XANTENNA__07374__A2 _03447_ vssd1 vssd1 vccd1 vccd1 sky130_fd_sc_hd__diode_2
XFILLER_83_304 vssd1 vssd1 vccd1 vccd1 sky130_fd_sc_hd__fill_4
X_06811_ _03083_ _03084_ _03019_ vssd1 vssd1 vccd1 vccd1 _03085_ sky130_fd_sc_hd__mux2_1
X_07791_ _01885_ _04039_ vssd1 vssd1 vccd1 vccd1 _04040_ sky130_fd_sc_hd__nor2_4
XFILLER_49_570 vccd1 vssd1 vccd1 vssd1 sky130_ef_sc_hd__decap_40_12
XTAP_TAPCELL_ROW_3_319 vssd1 vccd1 sky130_fd_sc_hd__tapvpwrvgnd_1
X_09530_ FPGA_INST.cell1.LE_0B.config_data\[3\] FPGA_INST.cell1.LE_0B.config_data\[2\]
+ net346 vssd1 vssd1 vccd1 vccd1 _00440_ sky130_fd_sc_hd__mux2_1
XFILLER_110_486 vssd1 vssd1 vccd1 vccd1 sky130_fd_sc_hd__fill_1
X_06742_ FPGA_INST.cell2.CB_1.config_dataB\[8\] _02995_ FPGA_INST.cell2.CB_1.config_dataB\[7\]
+ FPGA_INST.cell2.CB_1.config_dataB\[9\] vssd1 vssd1 vccd1 vccd1 _03016_ sky130_fd_sc_hd__or4b_1
X_09461_ FPGA_INST.cell1.LEI0.config_data\[7\] FPGA_INST.cell1.LEI0.config_data\[8\]
+ net211 vssd1 vssd1 vccd1 vccd1 _00373_ sky130_fd_sc_hd__mux2_1
XFILLER_36_242 vssd1 vssd1 vccd1 vccd1 sky130_fd_sc_hd__fill_1
XANTENNA__07531__C1 net367 vssd1 vssd1 vccd1 vccd1 sky130_fd_sc_hd__diode_2
XFILLER_64_595 vssd1 vssd1 vccd1 vccd1 sky130_fd_sc_hd__fill_1
XFILLER_37_798 vssd1 vssd1 vccd1 vccd1 sky130_fd_sc_hd__fill_1
X_06673_ FPGA_INST.cell2.LE_1A.config_data\[1\] FPGA_INST.cell2.LE_1A.config_data\[0\]
+ _02878_ vssd1 vssd1 vccd1 vccd1 _02949_ sky130_fd_sc_hd__mux2_1
X_09392_ net492 net490 net252 vssd1 vssd1 vccd1 vccd1 _00305_ sky130_fd_sc_hd__mux2_1
X_08412_ _04633_ vssd1 vssd1 vccd1 vccd1 _04634_ sky130_fd_sc_hd__inv_2
XANTENNA__06885__A1 FPGA_INST.bus2_0\[1\] vssd1 vssd1 vccd1 vccd1 sky130_fd_sc_hd__diode_2
X_05624_ net485 FPGA_INST.cell2.CB_0.config_dataB\[22\] _01903_ net17 vssd1 vssd1
+ vccd1 vccd1 _01904_ sky130_fd_sc_hd__a31o_1
XFILLER_36_297 vssd1 vssd1 vccd1 vccd1 sky130_fd_sc_hd__fill_2
X_08343_ net75 FPGA_INST.bus1_0\[5\] FPGA_INST.bus1_0\[6\] FPGA_INST.bus1_0\[7\] net449
+ net447 vssd1 vssd1 vccd1 vccd1 _04565_ sky130_fd_sc_hd__mux4_1
X_05555_ FPGA_INST.cell0.SB0.route_sel\[112\] FPGA_INST.cell0.SB0.route_sel\[113\]
+ _01829_ net322 _01834_ vssd1 vssd1 vccd1 vccd1 _01835_ sky130_fd_sc_hd__a311oi_1
X_08274_ FPGA_INST.cell0.LEI0.config_data\[44\] _04497_ _04495_ _04494_ vssd1 vssd1
+ vccd1 vccd1 _04498_ sky130_fd_sc_hd__o211a_1
XANTENNA_fanout239_A net241 vssd1 vssd1 vccd1 vccd1 sky130_fd_sc_hd__diode_2
X_07225_ net86 _03485_ vssd1 vssd1 vccd1 vccd1 _03488_ sky130_fd_sc_hd__nor2_1
X_05486_ FPGA_INST.cell3.CB_0.config_dataA\[9\] vssd1 vssd1 vccd1 vccd1 _01768_ sky130_fd_sc_hd__inv_2
XFILLER_22_27 vssd1 vssd1 vccd1 vccd1 sky130_fd_sc_hd__fill_1
XFILLER_118_542 vssd1 vssd1 vccd1 vccd1 sky130_fd_sc_hd__fill_1
XFILLER_20_698 vssd1 vssd1 vccd1 vccd1 sky130_fd_sc_hd__fill_2
X_07156_ FPGA_INST.cell1.SB0.route_sel\[3\] FPGA_INST.cell1.SB0.route_sel\[2\] _01722_
+ FPGA_INST.cell1.SB0.route_sel\[5\] _03419_ vssd1 vssd1 vccd1 vccd1 _03420_ sky130_fd_sc_hd__o221a_1
XTAP_TAPCELL_ROW_76_1345 vssd1 vccd1 sky130_fd_sc_hd__tapvpwrvgnd_1
X_07087_ net426 net427 vssd1 vssd1 vccd1 vccd1 _03353_ sky130_fd_sc_hd__nor2_1
X_06107_ _02378_ _02385_ _02386_ vssd1 vssd1 vccd1 vccd1 _02387_ sky130_fd_sc_hd__a21oi_1
XFILLER_105_258 vssd1 vssd1 vccd1 vccd1 sky130_fd_sc_hd__fill_1
X_06038_ _01993_ _02200_ vssd1 vssd1 vccd1 vccd1 _02318_ sky130_fd_sc_hd__or2_1
XFILLER_121_729 vssd1 vssd1 vccd1 vccd1 sky130_fd_sc_hd__fill_4
Xfanout100 net101 vssd1 vssd1 vccd1 vccd1 net100 sky130_fd_sc_hd__buf_2
Xfanout122 FPGA_INST.cell0.CB_0.le_outB vssd1 vssd1 vccd1 vccd1 net122 sky130_fd_sc_hd__clkbuf_2
XANTENNA_fanout775_A net778 vssd1 vssd1 vccd1 vccd1 sky130_fd_sc_hd__diode_2
Xfanout111 FPGA_INST.cell0.CB_1.le_outA vssd1 vssd1 vccd1 vccd1 net111 sky130_fd_sc_hd__buf_1
Xfanout144 net145 vssd1 vssd1 vccd1 vccd1 net144 sky130_fd_sc_hd__clkbuf_2
XFILLER_101_442 vssd1 vssd1 vccd1 vccd1 sky130_fd_sc_hd__fill_4
Xfanout133 net134 vssd1 vssd1 vccd1 vccd1 net133 sky130_fd_sc_hd__clkbuf_4
Xfanout155 _02619_ vssd1 vssd1 vccd1 vccd1 net155 sky130_fd_sc_hd__buf_6
XANTENNA_fanout942_A net945 vssd1 vssd1 vccd1 vccd1 sky130_fd_sc_hd__diode_2
XFILLER_74_304 vssd1 vssd1 vccd1 vccd1 sky130_fd_sc_hd__fill_4
Xfanout188 net189 vssd1 vssd1 vccd1 vccd1 net188 sky130_fd_sc_hd__clkbuf_2
Xfanout199 net200 vssd1 vssd1 vccd1 vccd1 net199 sky130_fd_sc_hd__clkbuf_4
XFILLER_59_389 vssd1 vssd1 vccd1 vccd1 sky130_fd_sc_hd__fill_2
XFILLER_47_35 vssd1 vssd1 vccd1 vccd1 sky130_fd_sc_hd__fill_1
Xfanout177 net181 vssd1 vssd1 vccd1 vccd1 net177 sky130_fd_sc_hd__clkbuf_4
Xfanout166 _01970_ vssd1 vssd1 vccd1 vccd1 net166 sky130_fd_sc_hd__clkbuf_4
X_09728_ FPGA_INST.cell1.CB_0.config_dataA\[3\] FPGA_INST.cell1.CB_0.config_dataA\[4\]
+ net230 vssd1 vssd1 vccd1 vccd1 _00637_ sky130_fd_sc_hd__mux2_1
X_07989_ _04213_ _04214_ _04216_ vssd1 vssd1 vccd1 vccd1 _04217_ sky130_fd_sc_hd__and3_1
XANTENNA_fanout563_X net563 vssd1 vssd1 vccd1 vccd1 sky130_fd_sc_hd__diode_2
XFILLER_28_710 vssd1 vssd1 vccd1 vccd1 sky130_fd_sc_hd__fill_1
XPHY_EDGE_ROW_29_Right_29 vssd1 vssd1 vccd1 vccd1 sky130_fd_sc_hd__decap_3
XFILLER_55_540 vssd1 vssd1 vccd1 vccd1 sky130_fd_sc_hd__fill_8
XANTENNA_fanout730_X net730 vssd1 vssd1 vccd1 vccd1 sky130_fd_sc_hd__diode_2
XTAP_TAPCELL_ROW_87_1496 vssd1 vccd1 sky130_fd_sc_hd__tapvpwrvgnd_1
XANTENNA__06100__A _01821_ vssd1 vssd1 vccd1 vccd1 sky130_fd_sc_hd__diode_2
XFILLER_28_798 vssd1 vssd1 vccd1 vccd1 sky130_fd_sc_hd__fill_1
X_09659_ FPGA_INST.cell0.SB0.route_sel\[62\] FPGA_INST.cell0.SB0.route_sel\[63\] net186
+ vssd1 vssd1 vccd1 vccd1 _00568_ sky130_fd_sc_hd__mux2_1
XANTENNA__08078__A0 FPGA_INST.bus3_1\[0\] vssd1 vssd1 vccd1 vccd1 sky130_fd_sc_hd__diode_2
XFILLER_43_779 vssd1 vssd1 vccd1 vccd1 sky130_fd_sc_hd__fill_1
X_11621_ net742 _00971_ net527 vssd1 vssd1 vccd1 vccd1 FPGA_INST.cell0.LE_1B.config_data\[15\]
+ sky130_fd_sc_hd__dfrtp_1
XANTENNA__08093__A3 FPGA_INST.bus3_1\[15\] vssd1 vssd1 vccd1 vccd1 sky130_fd_sc_hd__diode_2
XFILLER_7_625 vssd1 vssd1 vccd1 vccd1 sky130_fd_sc_hd__fill_1
X_11552_ net777 _00902_ net557 vssd1 vssd1 vccd1 vccd1 FPGA_INST.cell0.CB_0.config_dataA\[21\]
+ sky130_fd_sc_hd__dfstp_2
XPHY_EDGE_ROW_38_Right_38 vssd1 vssd1 vccd1 vccd1 sky130_fd_sc_hd__decap_3
XFILLER_128_339 vssd1 vssd1 vccd1 vccd1 sky130_fd_sc_hd__fill_1
X_10503_ FPGA_INST.cell2.SB0.route_sel\[76\] FPGA_INST.cell2.SB0.route_sel\[75\] net362
+ vssd1 vssd1 vccd1 vccd1 _01382_ sky130_fd_sc_hd__mux2_1
XFILLER_6_135 vssd1 vssd1 vccd1 vccd1 sky130_fd_sc_hd__fill_4
X_11483_ net759 _00833_ net544 vssd1 vssd1 vccd1 vccd1 FPGA_INST.cell0.LE_1A.config_data\[10\]
+ sky130_fd_sc_hd__dfrtp_1
XANTENNA__09557__S net333 vssd1 vssd1 vccd1 vccd1 sky130_fd_sc_hd__diode_2
XFILLER_10_197 vssd1 vssd1 vccd1 vccd1 sky130_fd_sc_hd__fill_1
X_10434_ FPGA_INST.cell2.SB0.route_sel\[6\] FPGA_INST.cell2.SB0.route_sel\[7\] net243
+ vssd1 vssd1 vccd1 vccd1 _01313_ sky130_fd_sc_hd__mux2_1
XFILLER_124_512 vssd1 vssd1 vccd1 vccd1 sky130_fd_sc_hd__fill_2
X_10365_ FPGA_INST.cell3.LE_0B.config_data\[6\] FPGA_INST.cell3.LE_0B.config_data\[7\]
+ net293 vssd1 vssd1 vccd1 vccd1 _01245_ sky130_fd_sc_hd__mux2_1
XFILLER_88_31 vssd1 vssd1 vccd1 vccd1 sky130_fd_sc_hd__fill_1
XFILLER_6_179 vssd1 vssd1 vccd1 vccd1 sky130_fd_sc_hd__fill_8
XFILLER_12_93 vssd1 vssd1 vccd1 vccd1 sky130_fd_sc_hd__fill_1
XANTENNA__05657__Y _01937_ vssd1 vssd1 vccd1 vccd1 sky130_fd_sc_hd__diode_2
XANTENNA__07053__B2 _02309_ vssd1 vssd1 vccd1 vccd1 sky130_fd_sc_hd__diode_2
X_12104_ net912 _01450_ net696 vssd1 vssd1 vccd1 vccd1 FPGA_INST.cell3.CB_0.config_dataA\[16\]
+ sky130_fd_sc_hd__dfstp_1
XFILLER_97_407 vssd1 vssd1 vccd1 vccd1 sky130_fd_sc_hd__fill_1
XANTENNA__05603__A2 net171 vssd1 vssd1 vccd1 vccd1 sky130_fd_sc_hd__diode_2
X_10296_ FPGA_INST.cell3.LEI0.config_data\[10\] FPGA_INST.cell3.LEI0.config_data\[11\]
+ net282 vssd1 vssd1 vccd1 vccd1 _01177_ sky130_fd_sc_hd__mux2_1
XFILLER_105_770 vssd1 vssd1 vccd1 vccd1 sky130_fd_sc_hd__fill_1
X_12035_ net879 _01381_ net664 vssd1 vssd1 vccd1 vccd1 FPGA_INST.cell2.SB0.route_sel\[75\]
+ sky130_fd_sc_hd__dfstp_1
XANTENNA__07356__A2 _02801_ vssd1 vssd1 vccd1 vccd1 sky130_fd_sc_hd__diode_2
XPHY_EDGE_ROW_47_Right_47 vssd1 vssd1 vccd1 vccd1 sky130_fd_sc_hd__decap_3
XTAP_TAPCELL_ROW_129_2091 vssd1 vccd1 sky130_fd_sc_hd__tapvpwrvgnd_1
XFILLER_65_337 vssd1 vssd1 vccd1 vccd1 sky130_fd_sc_hd__fill_4
XFILLER_19_721 vssd1 vssd1 vccd1 vccd1 sky130_fd_sc_hd__fill_4
XFILLER_80_307 vssd1 vssd1 vccd1 vccd1 sky130_fd_sc_hd__fill_1
XANTENNA__08305__A1 FPGA_INST.bus1_0\[9\] vssd1 vssd1 vccd1 vccd1 sky130_fd_sc_hd__diode_2
XANTENNA__07108__A2 FPGA_INST.bus2_0\[13\] vssd1 vssd1 vccd1 vccd1 sky130_fd_sc_hd__diode_2
XFILLER_19_765 vccd1 vssd1 vccd1 vssd1 sky130_ef_sc_hd__decap_40_12
XFILLER_73_370 vssd1 vssd1 vccd1 vccd1 sky130_fd_sc_hd__fill_1
XFILLER_18_253 vssd1 vssd1 vccd1 vccd1 sky130_fd_sc_hd__fill_1
XFILLER_61_532 vssd1 vssd1 vccd1 vccd1 sky130_fd_sc_hd__fill_1
XFILLER_34_768 vssd1 vssd1 vccd1 vccd1 sky130_fd_sc_hd__fill_8
X_11819_ FPGA_INST.cell3.LE_0A.sel_clk _01165_ net734 vssd1 vssd1 vccd1 vccd1 FPGA_INST.cell3.LE_0A.dff1_out
+ sky130_fd_sc_hd__dfstp_1
XFILLER_61_598 vssd1 vssd1 vccd1 vccd1 sky130_fd_sc_hd__fill_2
XTAP_TAPCELL_ROW_60_1124 vssd1 vccd1 sky130_fd_sc_hd__tapvpwrvgnd_1
XPHY_EDGE_ROW_56_Right_56 vssd1 vssd1 vccd1 vccd1 sky130_fd_sc_hd__decap_3
X_05340_ FPGA_INST.cell0.SB0.route_sel\[104\] vssd1 vssd1 vccd1 vccd1 _01622_ sky130_fd_sc_hd__inv_2
X_05271_ FPGA_INST.cell2.SB0.route_sel\[23\] vssd1 vssd1 vccd1 vccd1 _01553_ sky130_fd_sc_hd__inv_2
XTAP_TAPCELL_ROW_116_1913 vssd1 vccd1 sky130_fd_sc_hd__tapvpwrvgnd_1
XTAP_TAPCELL_ROW_116_1902 vssd1 vccd1 sky130_fd_sc_hd__tapvpwrvgnd_1
XFILLER_115_501 vssd1 vssd1 vccd1 vccd1 sky130_fd_sc_hd__fill_2
X_07010_ FPGA_INST.cell0.CB_0.config_dataA\[9\] _03263_ _03275_ vssd1 vssd1 vccd1
+ vccd1 _03276_ sky130_fd_sc_hd__or3b_1
XFILLER_103_729 vssd1 vssd1 vccd1 vccd1 sky130_fd_sc_hd__fill_4
X_08961_ _03754_ _03766_ _05147_ net222 vssd1 vssd1 vccd1 vccd1 FPGA_INST.bus1_0\[8\]
+ sky130_fd_sc_hd__o211a_4
XPHY_EDGE_ROW_65_Right_65 vssd1 vssd1 vccd1 vccd1 sky130_fd_sc_hd__decap_3
XTAP_TAPCELL_ROW_58_1097 vssd1 vccd1 sky130_fd_sc_hd__tapvpwrvgnd_1
XFILLER_130_559 vssd1 vssd1 vccd1 vccd1 sky130_fd_sc_hd__fill_1
XFILLER_124_29 vssd1 vssd1 vccd1 vccd1 sky130_fd_sc_hd__fill_2
X_08892_ _01778_ _05097_ _05098_ _05096_ vssd1 vssd1 vccd1 vccd1 _05099_ sky130_fd_sc_hd__a211o_1
X_07912_ net472 _04049_ vssd1 vssd1 vccd1 vccd1 _04140_ sky130_fd_sc_hd__nand2_1
XTAP_TAPCELL_ROW_71_1275 vssd1 vccd1 sky130_fd_sc_hd__tapvpwrvgnd_1
XFILLER_69_687 vssd1 vssd1 vccd1 vccd1 sky130_fd_sc_hd__fill_2
XFILLER_68_153 vssd1 vssd1 vccd1 vccd1 sky130_fd_sc_hd__fill_1
XANTENNA__11570__CLK net772 vssd1 vssd1 vccd1 vccd1 sky130_fd_sc_hd__diode_2
X_07843_ _02367_ _02376_ vssd1 vssd1 vccd1 vccd1 _04075_ sky130_fd_sc_hd__nand2_1
XFILLER_68_175 vssd1 vssd1 vccd1 vccd1 sky130_fd_sc_hd__fill_4
XANTENNA_fanout189_A net234 vssd1 vssd1 vccd1 vccd1 sky130_fd_sc_hd__diode_2
XFILLER_56_315 vssd1 vssd1 vccd1 vccd1 sky130_fd_sc_hd__fill_1
XPHY_EDGE_ROW_3_Left_134 vssd1 vssd1 vccd1 vccd1 sky130_fd_sc_hd__decap_3
XFILLER_29_529 vssd1 vssd1 vccd1 vccd1 sky130_fd_sc_hd__fill_2
X_07774_ FPGA_INST.cell3.SB0.route_sel\[117\] _01611_ vssd1 vssd1 vccd1 vccd1 _04024_
+ sky130_fd_sc_hd__nand2_1
X_09513_ FPGA_INST.cell1.LE_0A.config_data\[9\] FPGA_INST.cell1.LE_0A.config_data\[8\]
+ net345 vssd1 vssd1 vccd1 vccd1 _00424_ sky130_fd_sc_hd__mux2_1
XFILLER_83_178 vssd1 vssd1 vccd1 vccd1 sky130_fd_sc_hd__fill_1
X_06725_ net518 _02814_ vssd1 vssd1 vccd1 vccd1 _02999_ sky130_fd_sc_hd__nand2_1
XFILLER_25_702 vssd1 vssd1 vccd1 vccd1 sky130_fd_sc_hd__fill_4
X_09444_ FPGA_INST.cell2.LE_1B.config_data\[13\] FPGA_INST.cell2.LE_1B.config_data\[12\]
+ net360 vssd1 vssd1 vccd1 vccd1 _00357_ sky130_fd_sc_hd__mux2_1
X_06656_ FPGA_INST.bus3_2\[0\] FPGA_INST.bus3_2\[1\] FPGA_INST.bus3_2\[2\] FPGA_INST.bus3_2\[3\]
+ net476 FPGA_INST.cell2.CB_1.config_dataA\[16\] vssd1 vssd1 vccd1 vccd1 _02932_ sky130_fd_sc_hd__mux4_1
XANTENNA_fanout356_A net357 vssd1 vssd1 vccd1 vccd1 sky130_fd_sc_hd__diode_2
XFILLER_24_212 vccd1 vssd1 vccd1 vssd1 sky130_ef_sc_hd__decap_40_12
XPHY_EDGE_ROW_74_Right_74 vssd1 vssd1 vccd1 vccd1 sky130_fd_sc_hd__decap_3
X_05607_ FPGA_INST.cell0.SB0.route_sel\[126\] _01608_ FPGA_INST.cell0.SB0.route_sel\[122\]
+ FPGA_INST.cell0.SB0.route_sel\[123\] _01886_ vssd1 vssd1 vccd1 vccd1 _01887_ sky130_fd_sc_hd__o221a_1
XFILLER_52_587 vssd1 vssd1 vccd1 vccd1 sky130_fd_sc_hd__fill_1
XFILLER_25_779 vssd1 vssd1 vccd1 vccd1 sky130_fd_sc_hd__fill_4
XTAP_TAPCELL_ROW_35_774 vssd1 vccd1 sky130_fd_sc_hd__tapvpwrvgnd_1
XANTENNA_fanout523_A net525 vssd1 vssd1 vccd1 vccd1 sky130_fd_sc_hd__diode_2
X_06587_ net483 _02775_ vssd1 vssd1 vccd1 vccd1 _02863_ sky130_fd_sc_hd__nand2_1
X_09375_ FPGA_INST.cell2.CB_0.config_dataA\[18\] FPGA_INST.cell2.CB_0.config_dataA\[19\]
+ net240 vssd1 vssd1 vccd1 vccd1 _00288_ sky130_fd_sc_hd__mux2_1
X_08326_ net448 net447 vssd1 vssd1 vccd1 vccd1 _04548_ sky130_fd_sc_hd__nor2_1
X_05538_ FPGA_INST.cell0.CB_0.config_dataB\[24\] FPGA_INST.cell0.CB_0.config_dataB\[20\]
+ FPGA_INST.cell0.CB_0.config_dataB\[21\] vssd1 vssd1 vccd1 vccd1 _01818_ sky130_fd_sc_hd__or3b_1
X_08257_ _01755_ _04480_ vssd1 vssd1 vccd1 vccd1 _04481_ sky130_fd_sc_hd__nor2_1
X_05469_ FPGA_INST.cell0.LE_0B.config_data\[16\] vssd1 vssd1 vccd1 vccd1 _01751_ sky130_fd_sc_hd__inv_2
XFILLER_20_462 vssd1 vssd1 vccd1 vccd1 sky130_fd_sc_hd__fill_1
XFILLER_20_473 vssd1 vssd1 vccd1 vccd1 sky130_fd_sc_hd__fill_2
X_07208_ _03470_ _03461_ vssd1 vssd1 vccd1 vccd1 _03471_ sky130_fd_sc_hd__nand2b_1
X_08188_ net410 _03682_ _04411_ net408 vssd1 vssd1 vccd1 vccd1 _04412_ sky130_fd_sc_hd__o211a_1
XANTENNA__09377__S net350 vssd1 vssd1 vccd1 vccd1 sky130_fd_sc_hd__diode_2
X_07139_ _03402_ vssd1 vssd1 vccd1 vccd1 _03403_ sky130_fd_sc_hd__inv_2
XANTENNA_fanout892_A net947 vssd1 vssd1 vccd1 vccd1 sky130_fd_sc_hd__diode_2
XPHY_EDGE_ROW_83_Right_83 vssd1 vssd1 vccd1 vccd1 sky130_fd_sc_hd__decap_3
X_10150_ FPGA_INST.cell3.SB0.route_sel\[54\] FPGA_INST.cell3.SB0.route_sel\[55\] net272
+ vssd1 vssd1 vccd1 vccd1 _01031_ sky130_fd_sc_hd__mux2_1
XANTENNA__06794__A0 FPGA_INST.bus3_2\[4\] vssd1 vssd1 vccd1 vccd1 sky130_fd_sc_hd__diode_2
XFILLER_121_559 vssd1 vssd1 vccd1 vccd1 sky130_fd_sc_hd__fill_1
X_10081_ FPGA_INST.cell0.LE_1B.config_data\[5\] FPGA_INST.cell0.LE_1B.config_data\[6\]
+ net173 vssd1 vssd1 vccd1 vccd1 _00962_ sky130_fd_sc_hd__mux2_1
XANTENNA_fanout778_X net778 vssd1 vssd1 vccd1 vccd1 sky130_fd_sc_hd__diode_2
XFILLER_102_773 vssd1 vssd1 vccd1 vccd1 sky130_fd_sc_hd__fill_4
XANTENNA_fanout945_X net945 vssd1 vssd1 vccd1 vccd1 sky130_fd_sc_hd__diode_2
XTAP_TAPCELL_ROW_89_1525 vssd1 vccd1 sky130_fd_sc_hd__tapvpwrvgnd_1
XPHY_EDGE_ROW_58_Left_189 vssd1 vssd1 vccd1 vccd1 sky130_fd_sc_hd__decap_3
XFILLER_47_326 vssd1 vssd1 vccd1 vccd1 sky130_fd_sc_hd__fill_2
XFILLER_62_307 vssd1 vssd1 vccd1 vccd1 sky130_fd_sc_hd__fill_1
X_10983_ net887 _00333_ net671 vssd1 vssd1 vccd1 vccd1 FPGA_INST.cell2.CB_1.config_dataA\[14\]
+ sky130_fd_sc_hd__dfstp_1
XPHY_EDGE_ROW_92_Right_92 vssd1 vssd1 vccd1 vccd1 sky130_fd_sc_hd__decap_3
XFILLER_43_543 vssd1 vssd1 vccd1 vccd1 sky130_fd_sc_hd__fill_2
XFILLER_70_362 vssd1 vssd1 vccd1 vccd1 sky130_fd_sc_hd__fill_2
XFILLER_70_351 vssd1 vssd1 vccd1 vccd1 sky130_fd_sc_hd__fill_2
XPHY_EDGE_ROW_67_Left_198 vssd1 vssd1 vccd1 vccd1 sky130_fd_sc_hd__decap_3
X_11604_ net768 _00954_ net553 vssd1 vssd1 vccd1 vccd1 FPGA_INST.cell0.CB_1.config_dataA\[23\]
+ sky130_fd_sc_hd__dfstp_1
XTAP_TAPCELL_ROW_13_468 vssd1 vccd1 sky130_fd_sc_hd__tapvpwrvgnd_1
X_11535_ net756 _00885_ net541 vssd1 vssd1 vccd1 vccd1 FPGA_INST.cell0.CB_0.config_dataA\[4\]
+ sky130_fd_sc_hd__dfstp_1
XFILLER_23_81 vssd1 vssd1 vccd1 vccd1 sky130_fd_sc_hd__fill_2
XFILLER_116_309 vssd1 vssd1 vccd1 vccd1 sky130_fd_sc_hd__fill_1
Xmax_cap108 _02021_ vssd1 vssd1 vccd1 vccd1 net108 sky130_fd_sc_hd__clkbuf_1
XANTENNA__06771__Y _03045_ vssd1 vssd1 vccd1 vccd1 sky130_fd_sc_hd__diode_2
X_11466_ net751 _00816_ net536 vssd1 vssd1 vccd1 vccd1 FPGA_INST.cell0.LE_0B.config_data\[15\]
+ sky130_fd_sc_hd__dfrtp_1
X_10417_ FPGA_INST.cell3.CB_1.config_dataB\[14\] FPGA_INST.cell3.CB_1.config_dataB\[15\]
+ net282 vssd1 vssd1 vccd1 vccd1 _01296_ sky130_fd_sc_hd__mux2_1
XANTENNA__07577__A2 _03526_ vssd1 vssd1 vccd1 vccd1 sky130_fd_sc_hd__diode_2
X_11397_ net744 _00747_ net528 vssd1 vssd1 vccd1 vccd1 FPGA_INST.cell0.LEI0.config_data\[18\]
+ sky130_fd_sc_hd__dfrtp_1
X_10348_ FPGA_INST.cell3.LE_0A.config_data\[12\] FPGA_INST.cell3.LE_0A.config_data\[13\]
+ net292 vssd1 vssd1 vccd1 vccd1 _01229_ sky130_fd_sc_hd__mux2_1
XTAP_TAPCELL_ROW_111_1843 vssd1 vccd1 sky130_fd_sc_hd__tapvpwrvgnd_1
XTAP_TAPCELL_ROW_111_1832 vssd1 vccd1 sky130_fd_sc_hd__tapvpwrvgnd_1
X_10279_ net38 net39 net253 vssd1 vssd1 vccd1 vccd1 _01160_ sky130_fd_sc_hd__mux2_1
XANTENNA__06499__X _02775_ vssd1 vssd1 vccd1 vccd1 sky130_fd_sc_hd__diode_2
X_12018_ net776 _01364_ net562 vssd1 vssd1 vccd1 vccd1 FPGA_INST.cell2.SB0.route_sel\[58\]
+ sky130_fd_sc_hd__dfstp_1
XFILLER_38_337 vccd1 vssd1 vccd1 vssd1 sky130_ef_sc_hd__decap_40_12
XFILLER_93_443 vssd1 vssd1 vccd1 vccd1 sky130_fd_sc_hd__fill_4
XFILLER_38_359 vssd1 vssd1 vccd1 vccd1 sky130_fd_sc_hd__fill_4
XANTENNA__09750__S net232 vssd1 vssd1 vccd1 vccd1 sky130_fd_sc_hd__diode_2
XFILLER_65_167 vssd1 vssd1 vccd1 vccd1 sky130_fd_sc_hd__fill_1
X_07490_ _03395_ _03745_ vssd1 vssd1 vccd1 vccd1 _03746_ sky130_fd_sc_hd__nor2_1
X_06510_ _02780_ _02781_ _02784_ _02785_ FPGA_INST.cell2.CB_1.config_dataA\[7\] vssd1
+ vssd1 vccd1 vccd1 _02786_ sky130_fd_sc_hd__a221o_1
X_06441_ FPGA_INST.cell2.CB_0.config_dataB\[14\] _02692_ vssd1 vssd1 vccd1 vccd1 _02719_
+ sky130_fd_sc_hd__nand2_1
XTAP_TAPCELL_ROW_122_1994 vssd1 vccd1 sky130_fd_sc_hd__tapvpwrvgnd_1
XPHY_EDGE_ROW_100_Right_100 vssd1 vssd1 vccd1 vccd1 sky130_fd_sc_hd__decap_3
XANTENNA__06394__B _02092_ vssd1 vssd1 vccd1 vccd1 sky130_fd_sc_hd__diode_2
XFILLER_22_749 vssd1 vssd1 vccd1 vccd1 sky130_fd_sc_hd__fill_4
XTAP_TAPCELL_ROW_32_733 vssd1 vccd1 sky130_fd_sc_hd__tapvpwrvgnd_1
XANTENNA__08057__A3 FPGA_INST.bus3_1\[11\] vssd1 vssd1 vccd1 vccd1 sky130_fd_sc_hd__diode_2
X_09160_ FPGA_INST.cell2.LE_0B.config_data\[1\] FPGA_INST.cell2.LE_0B.config_data\[0\]
+ net359 vssd1 vssd1 vccd1 vccd1 _00074_ sky130_fd_sc_hd__mux2_1
X_06372_ net139 net128 net131 net103 FPGA_INST.cell2.LEI0.config_data\[15\] FPGA_INST.cell2.LEI0.config_data\[16\]
+ vssd1 vssd1 vccd1 vccd1 _02650_ sky130_fd_sc_hd__mux4_1
XFILLER_119_136 vccd1 vssd1 vccd1 vssd1 sky130_ef_sc_hd__decap_40_12
XFILLER_119_18 vccd1 vssd1 vccd1 vssd1 sky130_ef_sc_hd__decap_40_12
X_08111_ net450 net452 vssd1 vssd1 vccd1 vccd1 _04337_ sky130_fd_sc_hd__nor2_1
X_05323_ FPGA_INST.cell1.SB0.route_sel\[126\] vssd1 vssd1 vccd1 vccd1 _01605_ sky130_fd_sc_hd__inv_2
X_09091_ FPGA_INST.cell2.LEI0.config_data\[5\] FPGA_INST.cell2.LEI0.config_data\[6\]
+ net262 vssd1 vssd1 vccd1 vccd1 _00007_ sky130_fd_sc_hd__mux2_1
X_08042_ _03421_ _04265_ _04267_ _03475_ FPGA_INST.cell1.CB_0.config_dataB\[2\] vssd1
+ vssd1 vccd1 vccd1 _04268_ sky130_fd_sc_hd__a221o_1
XANTENNA__09197__S net361 vssd1 vssd1 vccd1 vccd1 sky130_fd_sc_hd__diode_2
X_05254_ FPGA_INST.cell2.LE_0A.config_data\[16\] vssd1 vssd1 vccd1 vccd1 _01536_ sky130_fd_sc_hd__inv_2
XTAP_TAPCELL_ROW_73_1304 vssd1 vccd1 sky130_fd_sc_hd__tapvpwrvgnd_1
X_09993_ FPGA_INST.config_bits\[9\] _05239_ _05240_ vssd1 vssd1 vccd1 vccd1 _00878_
+ sky130_fd_sc_hd__o21ba_1
X_08944_ FPGA_INST.cell2.SB0.route_sel\[82\] FPGA_INST.cell2.SB0.route_sel\[83\] vssd1
+ vssd1 vccd1 vccd1 _05136_ sky130_fd_sc_hd__nand2b_1
X_08875_ net386 _04835_ vssd1 vssd1 vccd1 vccd1 _05082_ sky130_fd_sc_hd__nand2_1
XFILLER_84_421 vssd1 vssd1 vccd1 vccd1 sky130_fd_sc_hd__fill_1
XFILLER_84_454 vssd1 vssd1 vccd1 vccd1 sky130_fd_sc_hd__fill_1
X_07826_ _02082_ _02092_ vssd1 vssd1 vccd1 vccd1 _04066_ sky130_fd_sc_hd__nand2_1
X_07757_ FPGA_INST.cell1.SB0.route_sel\[112\] FPGA_INST.cell1.SB0.route_sel\[113\]
+ _04006_ vssd1 vssd1 vccd1 vccd1 _04007_ sky130_fd_sc_hd__a21o_1
XFILLER_56_178 vssd1 vssd1 vccd1 vccd1 sky130_fd_sc_hd__fill_4
XANTENNA_fanout640_A net647 vssd1 vssd1 vccd1 vccd1 sky130_fd_sc_hd__diode_2
XFILLER_25_510 vssd1 vssd1 vccd1 vccd1 sky130_fd_sc_hd__fill_2
XANTENNA__09660__S net314 vssd1 vssd1 vccd1 vccd1 sky130_fd_sc_hd__diode_2
XANTENNA__08784__B _04801_ vssd1 vssd1 vccd1 vccd1 sky130_fd_sc_hd__diode_2
X_06708_ net520 _02793_ _02981_ FPGA_INST.cell2.CB_1.config_dataB\[1\] vssd1 vssd1
+ vccd1 vccd1 _02982_ sky130_fd_sc_hd__o211a_1
X_07688_ FPGA_INST.cell3.CB_0.config_dataB\[23\] FPGA_INST.cell3.CB_0.config_dataB\[22\]
+ net85 vssd1 vssd1 vccd1 vccd1 _03940_ sky130_fd_sc_hd__and3_1
XTAP_TAPCELL_ROW_84_1455 vssd1 vccd1 sky130_fd_sc_hd__tapvpwrvgnd_1
X_09427_ FPGA_INST.cell2.CB_1.config_dataA\[21\] FPGA_INST.cell2.CB_1.config_dataA\[20\]
+ net354 vssd1 vssd1 vccd1 vccd1 _00340_ sky130_fd_sc_hd__mux2_1
X_06639_ net475 _02836_ _02914_ net474 vssd1 vssd1 vccd1 vccd1 _02915_ sky130_fd_sc_hd__o211a_1
XFILLER_52_395 vssd1 vssd1 vccd1 vccd1 sky130_fd_sc_hd__fill_1
XFILLER_13_727 vssd1 vssd1 vccd1 vccd1 sky130_fd_sc_hd__fill_1
XFILLER_13_738 vssd1 vssd1 vccd1 vccd1 sky130_fd_sc_hd__fill_2
X_09358_ FPGA_INST.cell2.CB_0.config_dataA\[2\] net508 net356 vssd1 vssd1 vccd1 vccd1
+ _00271_ sky130_fd_sc_hd__mux2_1
X_08309_ _03465_ _04517_ _04518_ _03408_ FPGA_INST.cell0.CB_1.config_dataB\[7\] vssd1
+ vssd1 vccd1 vccd1 _04531_ sky130_fd_sc_hd__a221o_1
XTAP_TAPCELL_ROW_10_416 vssd1 vccd1 sky130_fd_sc_hd__tapvpwrvgnd_1
X_11320_ net840 _00670_ net624 vssd1 vssd1 vccd1 vccd1 FPGA_INST.cell1.CB_0.config_dataB\[12\]
+ sky130_fd_sc_hd__dfstp_2
X_09289_ FPGA_INST.cell1.SB0.route_sel\[60\] FPGA_INST.cell1.SB0.route_sel\[61\] net220
+ vssd1 vssd1 vccd1 vccd1 _00202_ sky130_fd_sc_hd__mux2_1
XTAP_TAPCELL_ROW_10_427 vssd1 vccd1 sky130_fd_sc_hd__tapvpwrvgnd_1
XFILLER_119_670 vssd1 vssd1 vccd1 vccd1 sky130_fd_sc_hd__fill_2
XFILLER_114_3 vccd1 vssd1 vccd1 vssd1 sky130_ef_sc_hd__decap_40_12
XFILLER_69_11 vssd1 vssd1 vccd1 vccd1 sky130_fd_sc_hd__fill_1
X_11251_ net781 _00601_ net566 vssd1 vssd1 vccd1 vccd1 FPGA_INST.cell0.SB0.route_sel\[96\]
+ sky130_fd_sc_hd__dfstp_1
X_10202_ FPGA_INST.cell3.SB0.route_sel\[106\] FPGA_INST.cell3.SB0.route_sel\[107\]
+ net271 vssd1 vssd1 vccd1 vccd1 _01083_ sky130_fd_sc_hd__mux2_1
X_11182_ net782 _00532_ net567 vssd1 vssd1 vccd1 vccd1 FPGA_INST.cell0.SB0.route_sel\[27\]
+ sky130_fd_sc_hd__dfstp_1
X_10133_ FPGA_INST.cell3.SB0.route_sel\[37\] FPGA_INST.cell3.SB0.route_sel\[38\] net278
+ vssd1 vssd1 vccd1 vccd1 _01014_ sky130_fd_sc_hd__mux2_1
XANTENNA__06782__A3 FPGA_INST.bus3_2\[15\] vssd1 vssd1 vccd1 vccd1 sky130_fd_sc_hd__diode_2
X_10064_ FPGA_INST.cell0.CB_1.config_dataA\[13\] FPGA_INST.cell0.CB_1.config_dataA\[14\]
+ net203 vssd1 vssd1 vccd1 vccd1 _00945_ sky130_fd_sc_hd__mux2_1
XTAP_TAPCELL_ROW_126_2050 vssd1 vccd1 sky130_fd_sc_hd__tapvpwrvgnd_1
XFILLER_75_454 vssd1 vssd1 vccd1 vccd1 sky130_fd_sc_hd__fill_4
XFILLER_75_476 vssd1 vssd1 vccd1 vccd1 sky130_fd_sc_hd__fill_2
XFILLER_47_178 vssd1 vssd1 vccd1 vccd1 sky130_fd_sc_hd__fill_2
XFILLER_47_167 vssd1 vssd1 vccd1 vccd1 sky130_fd_sc_hd__fill_1
XTAP_TAPCELL_ROW_18_538 vssd1 vccd1 sky130_fd_sc_hd__tapvpwrvgnd_1
X_10966_ net850 _00316_ net635 vssd1 vssd1 vccd1 vccd1 FPGA_INST.cell2.CB_0.config_dataB\[22\]
+ sky130_fd_sc_hd__dfstp_1
X_10897_ net823 _00247_ net607 vssd1 vssd1 vccd1 vccd1 FPGA_INST.cell1.SB0.route_sel\[106\]
+ sky130_fd_sc_hd__dfstp_1
XPHY_EDGE_ROW_75_Left_206 vssd1 vssd1 vccd1 vccd1 sky130_fd_sc_hd__decap_3
XFILLER_16_587 vssd1 vssd1 vccd1 vccd1 sky130_fd_sc_hd__fill_1
XFILLER_11_270 vssd1 vssd1 vccd1 vccd1 sky130_fd_sc_hd__fill_1
XFILLER_116_106 vssd1 vssd1 vccd1 vccd1 sky130_fd_sc_hd__fill_2
XANTENNA__05839__A net129 vssd1 vssd1 vccd1 vccd1 sky130_fd_sc_hd__diode_2
X_11518_ net780 _00868_ net565 vssd1 vssd1 vccd1 vccd1 FPGA_INST.cell0.CB_1.config_dataB\[24\]
+ sky130_fd_sc_hd__dfstp_1
X_11449_ FPGA_INST.cell0.LE_0B.sel_clk _00799_ net732 vssd1 vssd1 vccd1 vccd1 FPGA_INST.cell0.LE_0B.dff0_out
+ sky130_fd_sc_hd__dfrtp_1
XPHY_EDGE_ROW_84_Left_215 vssd1 vssd1 vccd1 vccd1 sky130_fd_sc_hd__decap_3
XFILLER_124_194 vssd1 vssd1 vccd1 vccd1 sky130_fd_sc_hd__fill_2
XTAP_TAPCELL_ROW_55_1056 vssd1 vccd1 sky130_fd_sc_hd__tapvpwrvgnd_1
XANTENNA__10554__A1 FPGA_INST.cell2.SB0.config_data_out vssd1 vssd1 vccd1 vccd1 sky130_fd_sc_hd__diode_2
XANTENNA__11536__SET_B net563 vssd1 vssd1 vccd1 vccd1 sky130_fd_sc_hd__diode_2
X_06990_ FPGA_INST.bus2_0\[5\] _03247_ FPGA_INST.cell0.CB_0.config_dataA\[7\] vssd1
+ vssd1 vccd1 vccd1 _03256_ sky130_fd_sc_hd__a21bo_1
XFILLER_66_421 vssd1 vssd1 vccd1 vccd1 sky130_fd_sc_hd__fill_8
X_05941_ net383 net159 vssd1 vssd1 vccd1 vccd1 _02221_ sky130_fd_sc_hd__nor2_1
XFILLER_39_635 vssd1 vssd1 vccd1 vccd1 sky130_fd_sc_hd__fill_4
XFILLER_94_763 vssd1 vssd1 vccd1 vccd1 sky130_fd_sc_hd__fill_1
XFILLER_94_752 vssd1 vssd1 vccd1 vccd1 sky130_fd_sc_hd__fill_4
X_08660_ net22 net24 net25 net26 FPGA_INST.cell3.CB_0.config_dataA\[5\] net398 vssd1
+ vssd1 vccd1 vccd1 _04869_ sky130_fd_sc_hd__mux4_1
X_05872_ _01946_ _02039_ vssd1 vssd1 vccd1 vccd1 _02152_ sky130_fd_sc_hd__nor2_1
XFILLER_93_273 vssd1 vssd1 vccd1 vccd1 sky130_fd_sc_hd__fill_1
X_07611_ _03828_ _03863_ _03864_ net373 vssd1 vssd1 vccd1 vccd1 _03865_ sky130_fd_sc_hd__a31o_1
XTAP_TAPCELL_ROW_37_803 vssd1 vccd1 sky130_fd_sc_hd__tapvpwrvgnd_1
X_08591_ FPGA_INST.cell3.SB0.route_sel\[122\] FPGA_INST.cell3.SB0.route_sel\[123\]
+ FPGA_INST.cell3.SB0.route_sel\[125\] _01602_ _04799_ vssd1 vssd1 vccd1 vccd1 _04800_
+ sky130_fd_sc_hd__o221a_1
XPHY_EDGE_ROW_93_Left_224 vssd1 vssd1 vccd1 vccd1 sky130_fd_sc_hd__decap_3
XFILLER_81_468 vssd1 vssd1 vccd1 vccd1 sky130_fd_sc_hd__fill_8
X_07542_ _03794_ _03795_ _03796_ _02106_ vssd1 vssd1 vccd1 vccd1 _03797_ sky130_fd_sc_hd__a31o_2
X_07473_ FPGA_INST.cell3.SB0.route_sel\[61\] FPGA_INST.cell3.SB0.route_sel\[60\] _03711_
+ _03729_ _03713_ vssd1 vssd1 vccd1 vccd1 _03730_ sky130_fd_sc_hd__a221o_1
X_09212_ FPGA_INST.cell2.CB_1.config_dataB\[8\] FPGA_INST.cell2.CB_1.config_dataB\[9\]
+ net287 vssd1 vssd1 vccd1 vccd1 _00125_ sky130_fd_sc_hd__mux2_1
X_06424_ _01541_ _02699_ _02701_ _02698_ vssd1 vssd1 vccd1 vccd1 _02702_ sky130_fd_sc_hd__a211oi_1
X_09143_ FPGA_INST.cell2.LE_0A.config_data\[7\] FPGA_INST.cell2.LE_0A.config_data\[6\]
+ net351 vssd1 vssd1 vccd1 vccd1 _00058_ sky130_fd_sc_hd__mux2_1
X_06355_ net2 _02623_ _02624_ net30 _02632_ vssd1 vssd1 vccd1 vccd1 _02633_ sky130_fd_sc_hd__a221o_1
XANTENNA_fanout221_A net227 vssd1 vssd1 vccd1 vccd1 sky130_fd_sc_hd__diode_2
X_05306_ FPGA_INST.cell2.LEI0.config_data\[20\] vssd1 vssd1 vccd1 vccd1 _01588_ sky130_fd_sc_hd__inv_2
XANTENNA_fanout319_A net325 vssd1 vssd1 vccd1 vccd1 sky130_fd_sc_hd__diode_2
X_09074_ net91 _03623_ _03624_ _05204_ vssd1 vssd1 vccd1 vccd1 net64 sky130_fd_sc_hd__a22o_1
XANTENNA__08450__A3 net141 vssd1 vssd1 vccd1 vccd1 sky130_fd_sc_hd__diode_2
X_06286_ FPGA_INST.cell2.CB_0.config_dataA\[13\] _01533_ _02564_ _02565_ vssd1 vssd1
+ vccd1 vccd1 _02566_ sky130_fd_sc_hd__or4_1
XFILLER_30_27 vssd1 vssd1 vccd1 vccd1 sky130_fd_sc_hd__fill_1
X_08025_ FPGA_INST.bus3_1\[8\] FPGA_INST.bus3_1\[9\] FPGA_INST.bus3_1\[10\] FPGA_INST.bus3_1\[11\]
+ net457 FPGA_INST.cell1.CB_0.config_dataB\[6\] vssd1 vssd1 vccd1 vccd1 _04251_ sky130_fd_sc_hd__mux4_1
XANTENNA__12114__CLK net917 vssd1 vssd1 vccd1 vccd1 sky130_fd_sc_hd__diode_2
XANTENNA__06749__A0 FPGA_INST.bus3_2\[12\] vssd1 vssd1 vccd1 vccd1 sky130_fd_sc_hd__diode_2
XANTENNA_fanout590_A net596 vssd1 vssd1 vccd1 vccd1 sky130_fd_sc_hd__diode_2
XANTENNA__08779__B _04781_ vssd1 vssd1 vccd1 vccd1 sky130_fd_sc_hd__diode_2
XANTENNA_fanout688_A net702 vssd1 vssd1 vccd1 vccd1 sky130_fd_sc_hd__diode_2
X_09976_ _01529_ _05228_ net738 vssd1 vssd1 vccd1 vccd1 _05229_ sky130_fd_sc_hd__o21ai_1
XFILLER_103_389 vssd1 vssd1 vccd1 vccd1 sky130_fd_sc_hd__fill_1
XFILLER_76_218 vssd1 vssd1 vccd1 vccd1 sky130_fd_sc_hd__fill_1
X_08927_ _01578_ FPGA_INST.cell2.SB0.route_sel\[97\] FPGA_INST.cell2.SB0.route_sel\[102\]
+ FPGA_INST.cell2.SB0.route_sel\[103\] _05124_ vssd1 vssd1 vccd1 vccd1 _05125_ sky130_fd_sc_hd__o221a_1
X_08858_ _05000_ _05064_ vssd1 vssd1 vccd1 vccd1 _05065_ sky130_fd_sc_hd__nand2_1
XFILLER_85_796 vssd1 vssd1 vccd1 vccd1 sky130_fd_sc_hd__fill_2
XFILLER_85_785 vssd1 vssd1 vccd1 vccd1 sky130_fd_sc_hd__fill_2
XFILLER_84_251 vssd1 vssd1 vccd1 vccd1 sky130_fd_sc_hd__fill_1
X_07809_ net89 _04056_ _04057_ vssd1 vssd1 vccd1 vccd1 _04058_ sky130_fd_sc_hd__o21ba_1
X_08789_ _04977_ _04981_ _04985_ _04995_ vssd1 vssd1 vccd1 vccd1 _04996_ sky130_fd_sc_hd__a31oi_1
XFILLER_45_638 vccd1 vssd1 vccd1 vssd1 sky130_ef_sc_hd__decap_40_12
X_10820_ net821 _00170_ net605 vssd1 vssd1 vccd1 vccd1 FPGA_INST.cell1.SB0.route_sel\[29\]
+ sky130_fd_sc_hd__dfstp_1
XFILLER_53_671 vssd1 vssd1 vccd1 vccd1 sky130_fd_sc_hd__fill_1
X_10751_ net885 _00101_ net669 vssd1 vssd1 vccd1 vccd1 FPGA_INST.cell2.LE_1A.config_data\[6\]
+ sky130_fd_sc_hd__dfrtp_1
XFILLER_71_45 vssd1 vssd1 vccd1 vccd1 sky130_fd_sc_hd__fill_1
XFILLER_13_557 vssd1 vssd1 vccd1 vccd1 sky130_fd_sc_hd__fill_2
XFILLER_40_332 vssd1 vssd1 vccd1 vccd1 sky130_fd_sc_hd__fill_2
XFILLER_71_67 vssd1 vssd1 vccd1 vccd1 sky130_fd_sc_hd__fill_2
X_10682_ net883 _00032_ net667 vssd1 vssd1 vccd1 vccd1 FPGA_INST.cell2.LEI0.config_data\[31\]
+ sky130_fd_sc_hd__dfrtp_1
XFILLER_40_365 vssd1 vssd1 vccd1 vccd1 sky130_fd_sc_hd__fill_1
XTAP_TAPCELL_ROW_97_1646 vssd1 vccd1 sky130_fd_sc_hd__tapvpwrvgnd_1
XTAP_TAPCELL_ROW_97_1635 vssd1 vccd1 sky130_fd_sc_hd__tapvpwrvgnd_1
XFILLER_126_448 vssd1 vssd1 vccd1 vccd1 sky130_fd_sc_hd__fill_1
X_11303_ net829 _00653_ net613 vssd1 vssd1 vccd1 vccd1 FPGA_INST.cell1.CB_0.config_dataA\[20\]
+ sky130_fd_sc_hd__dfstp_1
XFILLER_107_673 vssd1 vssd1 vccd1 vccd1 sky130_fd_sc_hd__fill_4
XFILLER_4_255 vssd1 vssd1 vccd1 vccd1 sky130_fd_sc_hd__fill_1
X_11234_ net761 _00584_ net546 vssd1 vssd1 vccd1 vccd1 FPGA_INST.cell0.SB0.route_sel\[79\]
+ sky130_fd_sc_hd__dfstp_1
XFILLER_107_695 vssd1 vssd1 vccd1 vccd1 sky130_fd_sc_hd__fill_2
XANTENNA__08322__X _04544_ vssd1 vssd1 vccd1 vccd1 sky130_fd_sc_hd__diode_2
XFILLER_106_194 vssd1 vssd1 vccd1 vccd1 sky130_fd_sc_hd__fill_2
XFILLER_95_505 vssd1 vssd1 vccd1 vccd1 sky130_fd_sc_hd__fill_1
X_11165_ net780 _00515_ net565 vssd1 vssd1 vccd1 vccd1 FPGA_INST.cell0.SB0.route_sel\[10\]
+ sky130_fd_sc_hd__dfstp_1
X_11096_ net841 _00446_ net625 vssd1 vssd1 vccd1 vccd1 FPGA_INST.cell1.LE_0B.config_data\[9\]
+ sky130_fd_sc_hd__dfrtp_1
XFILLER_95_527 vssd1 vssd1 vccd1 vccd1 sky130_fd_sc_hd__fill_1
X_10116_ FPGA_INST.cell3.SB0.route_sel\[21\] FPGA_INST.cell3.SB0.route_sel\[20\] net342
+ vssd1 vssd1 vccd1 vccd1 _00997_ sky130_fd_sc_hd__mux2_1
XANTENNA__08976__Y FPGA_INST.bus3_1\[7\] vssd1 vssd1 vccd1 vccd1 sky130_fd_sc_hd__diode_2
XFILLER_76_763 vssd1 vssd1 vccd1 vccd1 sky130_fd_sc_hd__fill_1
XFILLER_48_421 vssd1 vssd1 vccd1 vccd1 sky130_fd_sc_hd__fill_1
X_10047_ FPGA_INST.cell0.CB_0.config_dataB\[21\] FPGA_INST.cell0.CB_0.config_dataB\[22\]
+ net191 vssd1 vssd1 vccd1 vccd1 _00928_ sky130_fd_sc_hd__mux2_1
XFILLER_36_616 vssd1 vssd1 vccd1 vccd1 sky130_fd_sc_hd__fill_1
XFILLER_91_733 vssd1 vssd1 vccd1 vccd1 sky130_fd_sc_hd__fill_2
XFILLER_48_498 vssd1 vssd1 vccd1 vccd1 sky130_fd_sc_hd__fill_4
XANTENNA__06937__B _02070_ vssd1 vssd1 vccd1 vccd1 sky130_fd_sc_hd__diode_2
XANTENNA__06496__Y _02772_ vssd1 vssd1 vccd1 vccd1 sky130_fd_sc_hd__diode_2
XFILLER_29_690 vssd1 vssd1 vccd1 vccd1 sky130_fd_sc_hd__fill_1
XFILLER_36_638 vssd1 vssd1 vccd1 vccd1 sky130_fd_sc_hd__fill_4
XTAP_TAPCELL_ROW_106_1764 vssd1 vccd1 sky130_fd_sc_hd__tapvpwrvgnd_1
X_11998_ net852 _01344_ net637 vssd1 vssd1 vccd1 vccd1 FPGA_INST.cell2.SB0.route_sel\[38\]
+ sky130_fd_sc_hd__dfstp_1
X_10949_ net864 _00299_ net649 vssd1 vssd1 vccd1 vccd1 FPGA_INST.cell2.CB_0.config_dataB\[5\]
+ sky130_fd_sc_hd__dfstp_1
XFILLER_43_181 vccd1 vssd1 vccd1 vssd1 sky130_ef_sc_hd__decap_40_12
XTAP_TAPCELL_ROW_42_872 vssd1 vccd1 sky130_fd_sc_hd__tapvpwrvgnd_1
XFILLER_77_3 vccd1 vssd1 vccd1 vssd1 sky130_ef_sc_hd__decap_40_12
XFILLER_117_404 vssd1 vssd1 vccd1 vccd1 sky130_fd_sc_hd__fill_1
X_06140_ net113 _01975_ _02340_ vssd1 vssd1 vccd1 vccd1 _02420_ sky130_fd_sc_hd__nor3_1
XFILLER_117_437 vssd1 vssd1 vccd1 vccd1 sky130_fd_sc_hd__fill_1
X_06071_ net171 net158 _02347_ _02349_ vssd1 vssd1 vccd1 vccd1 _02351_ sky130_fd_sc_hd__o22a_1
XANTENNA__08196__A2 FPGA_INST.bus1_0\[2\] vssd1 vssd1 vccd1 vccd1 sky130_fd_sc_hd__diode_2
XANTENNA__10414__S net372 vssd1 vssd1 vccd1 vccd1 sky130_fd_sc_hd__diode_2
XFILLER_98_365 vssd1 vssd1 vccd1 vccd1 sky130_fd_sc_hd__fill_4
Xfanout518 FPGA_INST.cell2.CB_1.config_dataB\[5\] vssd1 vssd1 vccd1 vccd1 net518 sky130_fd_sc_hd__buf_1
Xfanout507 FPGA_INST.cell2.CB_0.config_dataA\[5\] vssd1 vssd1 vccd1 vccd1 net507 sky130_fd_sc_hd__dlymetal6s2s_1
Xfanout529 net534 vssd1 vssd1 vccd1 vccd1 net529 sky130_fd_sc_hd__clkbuf_2
X_09830_ FPGA_INST.cell0.LEI0.config_data\[8\] FPGA_INST.cell0.LEI0.config_data\[9\]
+ net183 vssd1 vssd1 vccd1 vccd1 _00738_ sky130_fd_sc_hd__mux2_1
X_09761_ FPGA_INST.cell1.CB_0.config_dataB\[12\] FPGA_INST.cell1.CB_0.config_dataB\[11\]
+ net347 vssd1 vssd1 vccd1 vccd1 _00670_ sky130_fd_sc_hd__mux2_1
XFILLER_112_186 vssd1 vssd1 vccd1 vccd1 sky130_fd_sc_hd__fill_4
XFILLER_86_538 vssd1 vssd1 vccd1 vccd1 sky130_fd_sc_hd__fill_1
X_06973_ _03240_ _03237_ _03195_ vssd1 vssd1 vccd1 vccd1 _03241_ sky130_fd_sc_hd__mux2_1
XFILLER_100_337 vssd1 vssd1 vccd1 vccd1 sky130_fd_sc_hd__fill_1
X_08712_ FPGA_INST.cell3.CB_0.config_dataA\[13\] FPGA_INST.cell3.CB_0.config_dataA\[12\]
+ FPGA_INST.cell3.CB_0.config_dataA\[14\] _04896_ vssd1 vssd1 vccd1 vccd1 _04921_
+ sky130_fd_sc_hd__or4bb_1
XFILLER_67_752 vssd1 vssd1 vccd1 vccd1 sky130_fd_sc_hd__fill_1
X_05924_ net133 _02203_ _02201_ vssd1 vssd1 vccd1 vccd1 _02204_ sky130_fd_sc_hd__mux2_1
XFILLER_39_421 vssd1 vssd1 vccd1 vccd1 sky130_fd_sc_hd__fill_2
XFILLER_67_785 vssd1 vssd1 vccd1 vccd1 sky130_fd_sc_hd__fill_1
X_09692_ FPGA_INST.cell0.SB0.route_sel\[96\] FPGA_INST.cell0.SB0.route_sel\[95\] net320
+ vssd1 vssd1 vccd1 vccd1 _00601_ sky130_fd_sc_hd__mux2_1
XFILLER_27_627 vssd1 vssd1 vccd1 vccd1 sky130_fd_sc_hd__fill_4
X_08643_ net19 _04790_ _04851_ FPGA_INST.cell3.CB_0.config_dataA\[1\] FPGA_INST.cell3.CB_0.config_dataA\[2\]
+ vssd1 vssd1 vccd1 vccd1 _04852_ sky130_fd_sc_hd__a221o_1
XTAP_TAPCELL_ROW_68_1236 vssd1 vccd1 sky130_fd_sc_hd__tapvpwrvgnd_1
X_05855_ net167 net161 FPGA_INST.bus1_0\[8\] vssd1 vssd1 vccd1 vccd1 _02135_ sky130_fd_sc_hd__o21ai_1
XANTENNA__06903__A0 FPGA_INST.bus2_0\[12\] vssd1 vssd1 vccd1 vccd1 sky130_fd_sc_hd__diode_2
XANTENNA_fanout171_A _01873_ vssd1 vssd1 vccd1 vccd1 sky130_fd_sc_hd__diode_2
XFILLER_82_777 vssd1 vssd1 vccd1 vccd1 sky130_fd_sc_hd__fill_1
XANTENNA_fanout269_A net273 vssd1 vssd1 vccd1 vccd1 sky130_fd_sc_hd__diode_2
X_08574_ FPGA_INST.cell3.SB0.route_sel\[94\] FPGA_INST.cell3.SB0.route_sel\[95\] vssd1
+ vssd1 vccd1 vccd1 _04783_ sky130_fd_sc_hd__nand2b_1
X_05786_ _02057_ _02064_ _02065_ vssd1 vssd1 vccd1 vccd1 _02066_ sky130_fd_sc_hd__o21ba_1
XFILLER_25_27 vssd1 vssd1 vccd1 vccd1 sky130_fd_sc_hd__fill_2
X_07525_ FPGA_INST.cell3.CB_0.config_dataA\[22\] FPGA_INST.cell3.CB_0.config_dataA\[23\]
+ vssd1 vssd1 vccd1 vccd1 _03781_ sky130_fd_sc_hd__nand2b_1
XTAP_TAPCELL_ROW_81_1414 vssd1 vccd1 sky130_fd_sc_hd__tapvpwrvgnd_1
XFILLER_22_332 vccd1 vssd1 vccd1 vssd1 sky130_ef_sc_hd__decap_40_12
X_07456_ net153 _03709_ vssd1 vssd1 vccd1 vccd1 _03713_ sky130_fd_sc_hd__and2b_1
XANTENNA_fanout603_A net604 vssd1 vssd1 vccd1 vccd1 sky130_fd_sc_hd__diode_2
X_07387_ net154 _03451_ _03591_ vssd1 vssd1 vccd1 vccd1 _03646_ sky130_fd_sc_hd__nor3_1
X_06407_ FPGA_INST.cell2.CB_0.config_dataB\[4\] _02655_ vssd1 vssd1 vccd1 vccd1 _02685_
+ sky130_fd_sc_hd__nand2_1
X_06338_ _02617_ _02610_ _02606_ vssd1 vssd1 vccd1 vccd1 _02618_ sky130_fd_sc_hd__mux2_1
XANTENNA__05890__B1 _02168_ vssd1 vssd1 vccd1 vccd1 sky130_fd_sc_hd__diode_2
XTAP_TAPCELL_ROW_20_566 vssd1 vccd1 sky130_fd_sc_hd__tapvpwrvgnd_1
X_09126_ FPGA_INST.cell2.LEI0.config_data\[40\] FPGA_INST.cell2.LEI0.config_data\[41\]
+ net251 vssd1 vssd1 vccd1 vccd1 _00042_ sky130_fd_sc_hd__mux2_1
X_09057_ net694 FPGA_INST.cell3.LE_0A.reset_mode vssd1 vssd1 vccd1 vccd1 _09057_/X
+ sky130_fd_sc_hd__xor2_2
X_06269_ net9 net10 net11 net13 net504 net502 vssd1 vssd1 vccd1 vccd1 _02549_ sky130_fd_sc_hd__mux4_1
X_08008_ net456 net457 vssd1 vssd1 vccd1 vccd1 _04234_ sky130_fd_sc_hd__nand2b_1
XTAP_TAPCELL_ROW_79_1387 vssd1 vccd1 sky130_fd_sc_hd__tapvpwrvgnd_1
XFILLER_116_492 vssd1 vssd1 vccd1 vccd1 sky130_fd_sc_hd__fill_1
XTAP_TAPCELL_ROW_92_1576 vssd1 vccd1 sky130_fd_sc_hd__tapvpwrvgnd_1
XTAP_TAPCELL_ROW_92_1565 vssd1 vccd1 sky130_fd_sc_hd__tapvpwrvgnd_1
XFILLER_89_354 vssd1 vssd1 vccd1 vccd1 sky130_fd_sc_hd__fill_1
XFILLER_77_505 vssd1 vssd1 vccd1 vccd1 sky130_fd_sc_hd__fill_1
X_09959_ FPGA_INST.cell0.CB_1.config_dataB\[20\] FPGA_INST.cell0.CB_1.config_dataB\[19\]
+ net314 vssd1 vssd1 vccd1 vccd1 _00864_ sky130_fd_sc_hd__mux2_1
XFILLER_92_508 vccd1 vssd1 vccd1 vssd1 sky130_ef_sc_hd__decap_40_12
XFILLER_45_402 vccd1 vssd1 vccd1 vssd1 sky130_ef_sc_hd__decap_40_12
X_11921_ net943 _01267_ net727 vssd1 vssd1 vccd1 vccd1 FPGA_INST.cell3.LE_1A.config_data\[7\]
+ sky130_fd_sc_hd__dfrtp_1
XFILLER_73_722 vssd1 vssd1 vccd1 vccd1 sky130_fd_sc_hd__fill_4
XFILLER_57_273 vssd1 vssd1 vccd1 vccd1 sky130_fd_sc_hd__fill_4
X_11852_ net933 _01198_ net717 vssd1 vssd1 vccd1 vccd1 FPGA_INST.cell3.LEI0.config_data\[32\]
+ sky130_fd_sc_hd__dfrtp_1
XFILLER_122_73 vssd1 vssd1 vccd1 vccd1 sky130_fd_sc_hd__fill_1
XFILLER_122_62 vssd1 vssd1 vccd1 vccd1 sky130_fd_sc_hd__fill_2
XFILLER_72_265 vssd1 vssd1 vccd1 vccd1 sky130_fd_sc_hd__fill_2
X_10803_ net822 _00153_ net606 vssd1 vssd1 vccd1 vccd1 FPGA_INST.cell1.SB0.route_sel\[12\]
+ sky130_fd_sc_hd__dfstp_1
XTAP_TAPCELL_ROW_0_280 vssd1 vccd1 sky130_fd_sc_hd__tapvpwrvgnd_1
XTAP_TAPCELL_ROW_28_677 vssd1 vccd1 sky130_fd_sc_hd__tapvpwrvgnd_1
X_11783_ net926 _01129_ net710 vssd1 vssd1 vccd1 vccd1 FPGA_INST.io_south_oeb\[18\]
+ sky130_fd_sc_hd__dfrtp_1
XFILLER_25_181 vssd1 vssd1 vccd1 vccd1 sky130_fd_sc_hd__fill_4
XFILLER_41_685 vssd1 vssd1 vccd1 vccd1 sky130_fd_sc_hd__fill_2
X_10734_ net870 _00084_ net654 vssd1 vssd1 vccd1 vccd1 FPGA_INST.cell2.LE_0B.config_data\[11\]
+ sky130_fd_sc_hd__dfrtp_1
XTAP_TAPCELL_ROW_101_1694 vssd1 vccd1 sky130_fd_sc_hd__tapvpwrvgnd_1
X_10665_ net874 _00015_ net658 vssd1 vssd1 vccd1 vccd1 FPGA_INST.cell2.LEI0.config_data\[14\]
+ sky130_fd_sc_hd__dfrtp_1
X_10596_ net387 FPGA_INST.cell3.CB_0.config_dataB\[16\] net300 vssd1 vssd1 vccd1 vccd1
+ _01475_ sky130_fd_sc_hd__mux2_1
Xoutput70 net70 vssd1 vssd1 vccd1 vccd1 gpio_out[5] sky130_fd_sc_hd__buf_2
XTAP_TAPCELL_ROW_52_1015 vssd1 vccd1 sky130_fd_sc_hd__tapvpwrvgnd_1
XTAP_TAPCELL_ROW_52_1004 vssd1 vccd1 sky130_fd_sc_hd__tapvpwrvgnd_1
X_11217_ net757 _00567_ net542 vssd1 vssd1 vccd1 vccd1 FPGA_INST.cell0.SB0.route_sel\[62\]
+ sky130_fd_sc_hd__dfstp_1
X_11148_ net808 _00498_ net594 vssd1 vssd1 vccd1 vccd1 FPGA_INST.cell1.CB_1.config_dataB\[18\]
+ sky130_fd_sc_hd__dfstp_1
XANTENNA__07386__B1 FPGA_INST.bus3_1\[5\] vssd1 vssd1 vccd1 vccd1 sky130_fd_sc_hd__diode_2
XANTENNA__06728__A3 FPGA_INST.bus3_2\[15\] vssd1 vssd1 vccd1 vccd1 sky130_fd_sc_hd__diode_2
XTAP_TAPCELL_ROW_8_391 vssd1 vccd1 sky130_fd_sc_hd__tapvpwrvgnd_1
XFILLER_110_635 vssd1 vssd1 vccd1 vccd1 sky130_fd_sc_hd__fill_8
X_11079_ net834 _00429_ net618 vssd1 vssd1 vccd1 vccd1 FPGA_INST.cell1.LE_0A.config_data\[14\]
+ sky130_fd_sc_hd__dfrtp_1
XFILLER_48_262 vssd1 vssd1 vccd1 vccd1 sky130_fd_sc_hd__fill_1
XTAP_TAPCELL_ROW_47_942 vssd1 vccd1 sky130_fd_sc_hd__tapvpwrvgnd_1
XANTENNA__06667__B net103 vssd1 vssd1 vccd1 vccd1 sky130_fd_sc_hd__diode_2
X_05640_ FPGA_INST.cell0.CB_0.config_dataB\[24\] FPGA_INST.cell0.CB_0.config_dataB\[20\]
+ FPGA_INST.cell0.CB_0.config_dataB\[21\] vssd1 vssd1 vccd1 vccd1 _01920_ sky130_fd_sc_hd__or3_2
XANTENNA__08350__A2 net112 vssd1 vssd1 vccd1 vccd1 sky130_fd_sc_hd__diode_2
X_05571_ _01849_ _01850_ vssd1 vssd1 vccd1 vccd1 _01851_ sky130_fd_sc_hd__nor2_1
XANTENNA__08102__A2 FPGA_INST.cell1.CB_1.le_outA vssd1 vssd1 vccd1 vccd1 sky130_fd_sc_hd__diode_2
XANTENNA__08638__B1 _04846_ vssd1 vssd1 vccd1 vccd1 sky130_fd_sc_hd__diode_2
X_07310_ _02357_ _02775_ _02361_ _02359_ vssd1 vssd1 vccd1 vccd1 _03571_ sky130_fd_sc_hd__a211o_1
XTAP_TAPCELL_ROW_63_1166 vssd1 vccd1 sky130_fd_sc_hd__tapvpwrvgnd_1
X_08290_ FPGA_INST.cell0.LE_1A.dff0_out FPGA_INST.cell0.LE_1A.dff1_out FPGA_INST.cell0.LE_1A.reset_val
+ vssd1 vssd1 vccd1 vccd1 FPGA_INST.cell0.LE_1A.dff_out sky130_fd_sc_hd__mux2_1
X_07241_ _01709_ FPGA_INST.cell0.SB0.route_sel\[23\] vssd1 vssd1 vccd1 vccd1 _03503_
+ sky130_fd_sc_hd__or2_1
XTAP_TAPCELL_ROW_119_1944 vssd1 vccd1 sky130_fd_sc_hd__tapvpwrvgnd_1
X_07172_ _03433_ _03435_ vssd1 vssd1 vccd1 vccd1 _03436_ sky130_fd_sc_hd__nand2_1
XTAP_TAPCELL_ROW_119_1955 vssd1 vccd1 sky130_fd_sc_hd__tapvpwrvgnd_1
XFILLER_117_223 vssd1 vssd1 vccd1 vccd1 sky130_fd_sc_hd__fill_1
XFILLER_11_29 vssd1 vssd1 vccd1 vccd1 sky130_fd_sc_hd__fill_1
X_06123_ _02395_ _02401_ _02402_ _02397_ vssd1 vssd1 vccd1 vccd1 _02403_ sky130_fd_sc_hd__a31o_1
XFILLER_105_418 vssd1 vssd1 vccd1 vccd1 sky130_fd_sc_hd__fill_8
XANTENNA__05624__B1 net17 vssd1 vssd1 vccd1 vccd1 sky130_fd_sc_hd__diode_2
X_06054_ FPGA_INST.cell0.CB_0.config_dataB\[22\] FPGA_INST.cell0.CB_0.config_dataB\[23\]
+ vssd1 vssd1 vccd1 vccd1 _02334_ sky130_fd_sc_hd__or2_1
Xfanout304 net305 vssd1 vssd1 vccd1 vccd1 net304 sky130_fd_sc_hd__clkbuf_4
Xfanout348 net349 vssd1 vssd1 vccd1 vccd1 net348 sky130_fd_sc_hd__buf_2
Xfanout337 net381 vssd1 vssd1 vccd1 vccd1 net337 sky130_fd_sc_hd__clkbuf_2
X_09813_ FPGA_INST.cell1.LE_1B.config_data\[13\] FPGA_INST.cell1.LE_1B.config_data\[14\]
+ net217 vssd1 vssd1 vccd1 vccd1 _00722_ sky130_fd_sc_hd__mux2_1
XANTENNA__08122__B _03889_ vssd1 vssd1 vccd1 vccd1 sky130_fd_sc_hd__diode_2
Xfanout326 net327 vssd1 vssd1 vccd1 vccd1 net326 sky130_fd_sc_hd__clkbuf_4
XANTENNA__11868__RESET_B net734 vssd1 vssd1 vccd1 vccd1 sky130_fd_sc_hd__diode_2
Xfanout315 net381 vssd1 vssd1 vccd1 vccd1 net315 sky130_fd_sc_hd__buf_2
Xfanout359 net363 vssd1 vssd1 vccd1 vccd1 net359 sky130_fd_sc_hd__clkbuf_2
X_09744_ FPGA_INST.cell1.CB_0.config_dataA\[20\] FPGA_INST.cell1.CB_0.config_dataA\[19\]
+ net343 vssd1 vssd1 vccd1 vccd1 _00653_ sky130_fd_sc_hd__mux2_1
X_06956_ FPGA_INST.bus2_0\[0\] _03198_ _03199_ FPGA_INST.bus2_0\[1\] _03223_ vssd1
+ vssd1 vccd1 vccd1 _03224_ sky130_fd_sc_hd__a221o_1
XFILLER_55_733 vssd1 vssd1 vccd1 vccd1 sky130_fd_sc_hd__fill_1
XANTENNA_fanout553_A net554 vssd1 vssd1 vccd1 vccd1 sky130_fd_sc_hd__diode_2
XFILLER_27_435 vssd1 vssd1 vccd1 vccd1 sky130_fd_sc_hd__fill_2
X_06887_ _03150_ _03154_ _03146_ vssd1 vssd1 vccd1 vccd1 _03155_ sky130_fd_sc_hd__a21oi_1
X_05907_ _02176_ _02185_ _02186_ vssd1 vssd1 vccd1 vccd1 _02187_ sky130_fd_sc_hd__o21ba_1
X_09675_ FPGA_INST.cell0.SB0.route_sel\[78\] FPGA_INST.cell0.SB0.route_sel\[79\] net184
+ vssd1 vssd1 vccd1 vccd1 _00584_ sky130_fd_sc_hd__mux2_1
X_08626_ _03741_ _04834_ vssd1 vssd1 vccd1 vccd1 _04835_ sky130_fd_sc_hd__nor2_2
X_05838_ net101 net164 _02036_ _02117_ vssd1 vssd1 vccd1 vccd1 _02118_ sky130_fd_sc_hd__a31o_1
XANTENNA__06577__B _02814_ vssd1 vssd1 vccd1 vccd1 sky130_fd_sc_hd__diode_2
XFILLER_70_714 vssd1 vssd1 vccd1 vccd1 sky130_fd_sc_hd__fill_1
XANTENNA__06352__A1 _02293_ vssd1 vssd1 vccd1 vccd1 sky130_fd_sc_hd__diode_2
X_08557_ _04767_ _04766_ _04751_ vssd1 vssd1 vccd1 vccd1 _04768_ sky130_fd_sc_hd__mux2_1
XANTENNA_fanout720_A net730 vssd1 vssd1 vccd1 vccd1 sky130_fd_sc_hd__diode_2
XANTENNA_fanout341_X net341 vssd1 vssd1 vccd1 vccd1 sky130_fd_sc_hd__diode_2
X_05769_ _01859_ _02048_ vssd1 vssd1 vccd1 vccd1 _02049_ sky130_fd_sc_hd__or2_1
XTAP_TAPCELL_ROW_25_636 vssd1 vccd1 sky130_fd_sc_hd__tapvpwrvgnd_1
X_08488_ FPGA_INST.cell1.LE_1B.config_data\[2\] FPGA_INST.cell1.LE_1B.config_data\[3\]
+ _04692_ vssd1 vssd1 vccd1 vccd1 _04704_ sky130_fd_sc_hd__mux2_1
X_07508_ net148 _03411_ _03762_ _03755_ vssd1 vssd1 vccd1 vccd1 _03764_ sky130_fd_sc_hd__o31a_1
X_07439_ _03530_ _03620_ vssd1 vssd1 vccd1 vccd1 _03697_ sky130_fd_sc_hd__nor2_1
XFILLER_10_302 vssd1 vssd1 vccd1 vccd1 sky130_fd_sc_hd__fill_1
X_10450_ FPGA_INST.cell2.SB0.route_sel\[22\] FPGA_INST.cell2.SB0.route_sel\[23\] net235
+ vssd1 vssd1 vccd1 vccd1 _01329_ sky130_fd_sc_hd__mux2_1
XTAP_TAPCELL_ROW_94_1605 vssd1 vccd1 sky130_fd_sc_hd__tapvpwrvgnd_1
X_09109_ FPGA_INST.cell2.LEI0.config_data\[24\] FPGA_INST.cell2.LEI0.config_data\[23\]
+ net359 vssd1 vssd1 vccd1 vccd1 _00025_ sky130_fd_sc_hd__mux2_1
XFILLER_124_705 vssd1 vssd1 vccd1 vccd1 sky130_fd_sc_hd__fill_1
X_10381_ FPGA_INST.cell3.LE_0B.reset_mode FPGA_INST.cell3.LE_1A.config_data\[0\] net301
+ vssd1 vssd1 vccd1 vccd1 _01260_ sky130_fd_sc_hd__mux2_1
XFILLER_124_749 vssd1 vssd1 vccd1 vccd1 sky130_fd_sc_hd__fill_1
X_12120_ net937 _01466_ net721 vssd1 vssd1 vccd1 vccd1 FPGA_INST.cell3.CB_0.config_dataB\[7\]
+ sky130_fd_sc_hd__dfstp_1
XFILLER_89_140 vssd1 vssd1 vccd1 vccd1 sky130_fd_sc_hd__fill_1
XFILLER_7_3 vssd1 vssd1 vccd1 vccd1 sky130_fd_sc_hd__fill_1
X_12051_ net858 _01397_ net643 vssd1 vssd1 vccd1 vccd1 FPGA_INST.cell2.SB0.route_sel\[91\]
+ sky130_fd_sc_hd__dfstp_1
XANTENNA__07907__A2 FPGA_INST.bus3_1\[14\] vssd1 vssd1 vccd1 vccd1 sky130_fd_sc_hd__diode_2
XFILLER_77_302 vccd1 vssd1 vccd1 vssd1 sky130_ef_sc_hd__decap_40_12
X_11002_ net926 _00352_ net710 vssd1 vssd1 vccd1 vccd1 FPGA_INST.cell2.LE_1B.config_data\[8\]
+ sky130_fd_sc_hd__dfrtp_1
XFILLER_77_335 vssd1 vssd1 vccd1 vccd1 sky130_fd_sc_hd__fill_1
Xfanout860 net861 vssd1 vssd1 vccd1 vccd1 net860 sky130_fd_sc_hd__buf_1
XANTENNA__11447__Q FPGA_INST.cell0.LE_0A.reset_val vssd1 vssd1 vccd1 vccd1 sky130_fd_sc_hd__diode_2
XANTENNA__09109__A1 FPGA_INST.cell2.LEI0.config_data\[23\] vssd1 vssd1 vccd1 vccd1
+ sky130_fd_sc_hd__diode_2
Xfanout893 net899 vssd1 vssd1 vccd1 vccd1 net893 sky130_fd_sc_hd__clkbuf_2
Xfanout882 net892 vssd1 vssd1 vccd1 vccd1 net882 sky130_fd_sc_hd__dlymetal6s2s_1
XANTENNA__06591__A1 FPGA_INST.bus3_2\[5\] vssd1 vssd1 vccd1 vccd1 sky130_fd_sc_hd__diode_2
Xfanout871 net872 vssd1 vssd1 vccd1 vccd1 net871 sky130_fd_sc_hd__clkbuf_2
XTAP_TAPCELL_ROW_5_350 vssd1 vccd1 sky130_fd_sc_hd__tapvpwrvgnd_1
X_11904_ net939 _01250_ net723 vssd1 vssd1 vccd1 vccd1 FPGA_INST.cell3.LE_0B.config_data\[12\]
+ sky130_fd_sc_hd__dfrtp_1
XFILLER_93_54 vssd1 vssd1 vccd1 vccd1 sky130_fd_sc_hd__fill_2
XANTENNA__08332__A2 _03840_ vssd1 vssd1 vccd1 vccd1 sky130_fd_sc_hd__diode_2
XFILLER_46_755 vssd1 vssd1 vccd1 vccd1 sky130_fd_sc_hd__fill_1
XTAP_TAPCELL_ROW_44_901 vssd1 vccd1 sky130_fd_sc_hd__tapvpwrvgnd_1
X_11835_ net932 _01181_ net716 vssd1 vssd1 vccd1 vccd1 FPGA_INST.cell3.LEI0.config_data\[15\]
+ sky130_fd_sc_hd__dfrtp_1
XTAP_TAPCELL_ROW_103_1723 vssd1 vccd1 sky130_fd_sc_hd__tapvpwrvgnd_1
XANTENNA__06894__A2 _02030_ vssd1 vssd1 vccd1 vccd1 sky130_fd_sc_hd__diode_2
XFILLER_26_81 vssd1 vssd1 vccd1 vccd1 sky130_fd_sc_hd__fill_2
X_11766_ net924 _01112_ net708 vssd1 vssd1 vccd1 vccd1 FPGA_INST.io_west_oeb\[16\]
+ sky130_fd_sc_hd__dfrtp_1
XANTENNA__06646__A2 FPGA_INST.bus3_2\[14\] vssd1 vssd1 vccd1 vccd1 sky130_fd_sc_hd__diode_2
XFILLER_9_111 vssd1 vssd1 vccd1 vccd1 sky130_fd_sc_hd__fill_1
X_10717_ net863 _00067_ net648 vssd1 vssd1 vccd1 vccd1 FPGA_INST.cell2.LE_0A.config_data\[16\]
+ sky130_fd_sc_hd__dfrtp_1
X_11697_ net904 _01043_ net688 vssd1 vssd1 vccd1 vccd1 FPGA_INST.cell3.SB0.route_sel\[67\]
+ sky130_fd_sc_hd__dfstp_1
XFILLER_9_166 vssd1 vssd1 vccd1 vccd1 sky130_fd_sc_hd__fill_2
X_10648_ FPGA_INST.cell3.LE_1B.reset_val FPGA_INST.cell3.LE_1B.edge_mode net368 vssd1
+ vssd1 vccd1 vccd1 _01527_ sky130_fd_sc_hd__mux2_1
XANTENNA__08399__A2 _03504_ vssd1 vssd1 vccd1 vccd1 sky130_fd_sc_hd__diode_2
X_10579_ FPGA_INST.cell3.CB_0.config_dataA\[24\] FPGA_INST.cell3.CB_0.config_dataA\[23\]
+ net371 vssd1 vssd1 vccd1 vccd1 _01458_ sky130_fd_sc_hd__mux2_1
XFILLER_5_361 vssd1 vssd1 vccd1 vccd1 sky130_fd_sc_hd__fill_2
XANTENNA__07071__A2 _01839_ vssd1 vssd1 vccd1 vccd1 sky130_fd_sc_hd__diode_2
XTAP_TAPCELL_ROW_114_1874 vssd1 vccd1 sky130_fd_sc_hd__tapvpwrvgnd_1
XTAP_TAPCELL_ROW_114_1885 vssd1 vccd1 sky130_fd_sc_hd__tapvpwrvgnd_1
XANTENNA__09753__S net232 vssd1 vssd1 vccd1 vccd1 sky130_fd_sc_hd__diode_2
XFILLER_96_699 vssd1 vssd1 vccd1 vccd1 sky130_fd_sc_hd__fill_1
X_06810_ FPGA_INST.cell2.LE_1B.config_data\[13\] FPGA_INST.cell2.LE_1B.config_data\[12\]
+ _02992_ vssd1 vssd1 vccd1 vccd1 _03084_ sky130_fd_sc_hd__mux2_1
XFILLER_56_508 vssd1 vssd1 vccd1 vccd1 sky130_fd_sc_hd__fill_1
X_07790_ FPGA_INST.cell0.SB0.route_sel\[120\] _01607_ FPGA_INST.cell0.SB0.route_sel\[124\]
+ FPGA_INST.cell0.SB0.route_sel\[125\] _04038_ vssd1 vssd1 vccd1 vccd1 _04039_ sky130_fd_sc_hd__o221a_1
XFILLER_83_349 vssd1 vssd1 vccd1 vccd1 sky130_fd_sc_hd__fill_2
XFILLER_83_316 vssd1 vssd1 vccd1 vccd1 sky130_fd_sc_hd__fill_2
X_06741_ _03008_ _03014_ FPGA_INST.cell2.CB_1.config_dataB\[9\] vssd1 vssd1 vccd1
+ vccd1 _03015_ sky130_fd_sc_hd__a21oi_1
XFILLER_49_582 vssd1 vssd1 vccd1 vccd1 sky130_fd_sc_hd__fill_8
X_09460_ FPGA_INST.cell1.LEI0.config_data\[6\] FPGA_INST.cell1.LEI0.config_data\[7\]
+ net211 vssd1 vssd1 vccd1 vccd1 _00372_ sky130_fd_sc_hd__mux2_1
XANTENNA__07358__D_N _02281_ vssd1 vssd1 vccd1 vccd1 sky130_fd_sc_hd__diode_2
XFILLER_91_371 vssd1 vssd1 vccd1 vccd1 sky130_fd_sc_hd__fill_2
XFILLER_51_202 vssd1 vssd1 vccd1 vccd1 sky130_fd_sc_hd__fill_1
X_08411_ net114 net118 net111 net99 FPGA_INST.cell0.LEI0.config_data\[45\] FPGA_INST.cell0.LEI0.config_data\[46\]
+ vssd1 vssd1 vccd1 vccd1 _04633_ sky130_fd_sc_hd__mux4_1
X_06672_ FPGA_INST.cell2.LE_1A.config_data\[3\] FPGA_INST.cell2.LE_1A.config_data\[2\]
+ _02878_ vssd1 vssd1 vccd1 vccd1 _02948_ sky130_fd_sc_hd__mux2_1
X_09391_ FPGA_INST.cell2.CB_0.config_dataB\[9\] net492 net255 vssd1 vssd1 vccd1 vccd1
+ _00304_ sky130_fd_sc_hd__mux2_1
X_05623_ FPGA_INST.cell2.CB_0.config_dataB\[24\] FPGA_INST.cell2.CB_0.config_dataB\[21\]
+ FPGA_INST.cell2.CB_0.config_dataB\[20\] vssd1 vssd1 vccd1 vccd1 _01903_ sky130_fd_sc_hd__and3b_2
X_08342_ net73 net95 FPGA_INST.bus1_0\[2\] FPGA_INST.bus1_0\[3\] net449 net447 vssd1
+ vssd1 vccd1 vccd1 _04564_ sky130_fd_sc_hd__mux4_1
XFILLER_51_279 vssd1 vssd1 vccd1 vccd1 sky130_fd_sc_hd__fill_1
X_05554_ _01820_ _01832_ _01833_ vssd1 vssd1 vccd1 vccd1 _01834_ sky130_fd_sc_hd__a21oi_1
X_05485_ net399 vssd1 vssd1 vccd1 vccd1 _01767_ sky130_fd_sc_hd__inv_2
X_08273_ _04496_ vssd1 vssd1 vccd1 vccd1 _04497_ sky130_fd_sc_hd__inv_2
X_07224_ _03438_ _03486_ vssd1 vssd1 vccd1 vccd1 _03487_ sky130_fd_sc_hd__nor2_1
XFILLER_22_17 vssd1 vssd1 vccd1 vccd1 sky130_fd_sc_hd__fill_1
XFILLER_20_688 vssd1 vssd1 vccd1 vccd1 sky130_fd_sc_hd__fill_2
X_07155_ FPGA_INST.cell1.SB0.route_sel\[6\] FPGA_INST.cell1.SB0.route_sel\[7\] vssd1
+ vssd1 vccd1 vccd1 _03419_ sky130_fd_sc_hd__nand2b_1
XFILLER_118_587 vssd1 vssd1 vccd1 vccd1 sky130_fd_sc_hd__fill_1
XTAP_TAPCELL_ROW_76_1346 vssd1 vccd1 sky130_fd_sc_hd__tapvpwrvgnd_1
X_07086_ net426 net427 vssd1 vssd1 vccd1 vccd1 _03352_ sky130_fd_sc_hd__and2b_2
X_06106_ net117 _01814_ _02332_ _02379_ vssd1 vssd1 vccd1 vccd1 _02386_ sky130_fd_sc_hd__a31o_1
X_06037_ _01993_ _02200_ vssd1 vssd1 vccd1 vccd1 _02317_ sky130_fd_sc_hd__nor2_1
XFILLER_87_611 vssd1 vssd1 vccd1 vccd1 sky130_fd_sc_hd__fill_2
Xfanout101 FPGA_INST.cell2.CB_1.le_outB vssd1 vssd1 vccd1 vccd1 net101 sky130_fd_sc_hd__dlymetal6s2s_1
Xfanout112 FPGA_INST.cell0.CB_1.le_outA vssd1 vssd1 vccd1 vccd1 net112 sky130_fd_sc_hd__buf_2
XFILLER_113_281 vssd1 vssd1 vccd1 vccd1 sky130_fd_sc_hd__fill_1
Xfanout145 FPGA_INST.cell1.CB_0.le_outB vssd1 vssd1 vccd1 vccd1 net145 sky130_fd_sc_hd__clkbuf_2
XANTENNA__08011__B2 _03613_ vssd1 vssd1 vccd1 vccd1 sky130_fd_sc_hd__diode_2
Xfanout156 _02619_ vssd1 vssd1 vccd1 vccd1 net156 sky130_fd_sc_hd__clkbuf_4
Xfanout134 FPGA_INST.cell2.CB_1.le_outA vssd1 vssd1 vccd1 vccd1 net134 sky130_fd_sc_hd__clkbuf_4
XANTENNA_fanout670_A net675 vssd1 vssd1 vccd1 vccd1 sky130_fd_sc_hd__diode_2
Xfanout123 net124 vssd1 vssd1 vccd1 vccd1 net123 sky130_fd_sc_hd__clkbuf_2
XANTENNA__10602__S net284 vssd1 vssd1 vccd1 vccd1 sky130_fd_sc_hd__diode_2
X_07988_ FPGA_INST.cell1.LEI0.config_data\[38\] _04215_ vssd1 vssd1 vccd1 vccd1 _04216_
+ sky130_fd_sc_hd__nand2b_1
Xfanout189 net234 vssd1 vssd1 vccd1 vccd1 net189 sky130_fd_sc_hd__clkbuf_2
XANTENNA_fanout768_A net769 vssd1 vssd1 vccd1 vccd1 sky130_fd_sc_hd__diode_2
Xfanout167 _01924_ vssd1 vssd1 vccd1 vccd1 net167 sky130_fd_sc_hd__buf_2
Xfanout178 net181 vssd1 vssd1 vccd1 vccd1 net178 sky130_fd_sc_hd__buf_2
XPHY_EDGE_ROW_114_Right_114 vssd1 vssd1 vccd1 vccd1 sky130_fd_sc_hd__decap_3
X_09727_ FPGA_INST.cell1.CB_0.config_dataA\[3\] FPGA_INST.cell1.CB_0.config_dataA\[2\]
+ net344 vssd1 vssd1 vccd1 vccd1 _00636_ sky130_fd_sc_hd__mux2_1
XFILLER_101_498 vssd1 vssd1 vccd1 vccd1 sky130_fd_sc_hd__fill_4
X_06939_ FPGA_INST.bus2_0\[8\] FPGA_INST.bus2_0\[9\] FPGA_INST.bus2_0\[10\] FPGA_INST.bus2_0\[11\]
+ net415 net414 vssd1 vssd1 vccd1 vccd1 _03207_ sky130_fd_sc_hd__mux4_1
XANTENNA_fanout935_A net946 vssd1 vssd1 vccd1 vccd1 sky130_fd_sc_hd__diode_2
XFILLER_28_766 vccd1 vssd1 vccd1 vssd1 sky130_ef_sc_hd__decap_40_12
XANTENNA__07522__B1 _01792_ vssd1 vssd1 vccd1 vccd1 sky130_fd_sc_hd__diode_2
XFILLER_63_24 vssd1 vssd1 vccd1 vccd1 sky130_fd_sc_hd__fill_1
X_09658_ FPGA_INST.cell0.SB0.route_sel\[61\] FPGA_INST.cell0.SB0.route_sel\[62\] net180
+ vssd1 vssd1 vccd1 vccd1 _00567_ sky130_fd_sc_hd__mux2_1
X_09589_ FPGA_INST.cell1.CB_1.config_dataB\[18\] FPGA_INST.cell1.CB_1.config_dataB\[17\]
+ net334 vssd1 vssd1 vccd1 vccd1 _00498_ sky130_fd_sc_hd__mux2_1
XTAP_TAPCELL_ROW_87_1497 vssd1 vccd1 sky130_fd_sc_hd__tapvpwrvgnd_1
X_08609_ FPGA_INST.cell3.SB0.route_sel\[18\] FPGA_INST.cell3.SB0.route_sel\[19\] FPGA_INST.cell3.SB0.route_sel\[21\]
+ _01705_ _04817_ vssd1 vssd1 vccd1 vccd1 _04818_ sky130_fd_sc_hd__o221a_1
XFILLER_55_596 vssd1 vssd1 vccd1 vccd1 sky130_fd_sc_hd__fill_1
XFILLER_43_747 vssd1 vssd1 vccd1 vccd1 sky130_fd_sc_hd__fill_1
XFILLER_15_449 vssd1 vssd1 vccd1 vccd1 sky130_fd_sc_hd__fill_1
XANTENNA__08078__A1 FPGA_INST.bus3_1\[1\] vssd1 vssd1 vccd1 vccd1 sky130_fd_sc_hd__diode_2
X_11620_ net742 _00970_ net527 vssd1 vssd1 vccd1 vccd1 FPGA_INST.cell0.LE_1B.config_data\[14\]
+ sky130_fd_sc_hd__dfrtp_1
XFILLER_30_419 vssd1 vssd1 vccd1 vccd1 sky130_fd_sc_hd__fill_1
XFILLER_51_780 vssd1 vssd1 vccd1 vccd1 sky130_fd_sc_hd__fill_4
X_11551_ net772 _00901_ net557 vssd1 vssd1 vccd1 vccd1 FPGA_INST.cell0.CB_0.config_dataA\[20\]
+ sky130_fd_sc_hd__dfstp_2
XANTENNA__08027__B _04049_ vssd1 vssd1 vccd1 vccd1 sky130_fd_sc_hd__diode_2
X_10502_ FPGA_INST.cell2.SB0.route_sel\[74\] FPGA_INST.cell2.SB0.route_sel\[75\] net260
+ vssd1 vssd1 vccd1 vccd1 _01381_ sky130_fd_sc_hd__mux2_1
XFILLER_10_143 vssd1 vssd1 vccd1 vccd1 sky130_fd_sc_hd__fill_1
XANTENNA__10049__S net320 vssd1 vssd1 vccd1 vccd1 sky130_fd_sc_hd__diode_2
XFILLER_109_510 vssd1 vssd1 vccd1 vccd1 sky130_fd_sc_hd__fill_2
XFILLER_10_176 vssd1 vssd1 vccd1 vccd1 sky130_fd_sc_hd__fill_4
X_11482_ net759 _00832_ net544 vssd1 vssd1 vccd1 vccd1 FPGA_INST.cell0.LE_1A.config_data\[9\]
+ sky130_fd_sc_hd__dfrtp_1
XANTENNA__07866__B _03889_ vssd1 vssd1 vccd1 vccd1 sky130_fd_sc_hd__diode_2
X_10433_ FPGA_INST.cell2.SB0.route_sel\[5\] FPGA_INST.cell2.SB0.route_sel\[6\] net197
+ vssd1 vssd1 vccd1 vccd1 _01312_ sky130_fd_sc_hd__mux2_1
X_10364_ FPGA_INST.cell3.LE_0B.config_data\[5\] FPGA_INST.cell3.LE_0B.config_data\[6\]
+ net293 vssd1 vssd1 vccd1 vccd1 _01244_ sky130_fd_sc_hd__mux2_1
X_12103_ net937 _01449_ net721 vssd1 vssd1 vccd1 vccd1 FPGA_INST.cell3.CB_0.config_dataA\[15\]
+ sky130_fd_sc_hd__dfstp_1
X_10295_ FPGA_INST.cell3.LEI0.config_data\[9\] FPGA_INST.cell3.LEI0.config_data\[10\]
+ net282 vssd1 vssd1 vccd1 vccd1 _01176_ sky130_fd_sc_hd__mux2_1
XFILLER_105_782 vssd1 vssd1 vccd1 vccd1 sky130_fd_sc_hd__fill_2
XFILLER_2_375 vssd1 vssd1 vccd1 vccd1 sky130_fd_sc_hd__fill_4
XFILLER_120_730 vssd1 vssd1 vccd1 vccd1 sky130_fd_sc_hd__fill_2
X_12034_ net878 _01380_ net663 vssd1 vssd1 vccd1 vccd1 FPGA_INST.cell2.SB0.route_sel\[74\]
+ sky130_fd_sc_hd__dfstp_1
XANTENNA__08697__B _04785_ vssd1 vssd1 vccd1 vccd1 sky130_fd_sc_hd__diode_2
XFILLER_26_9 vssd1 vssd1 vccd1 vccd1 sky130_fd_sc_hd__fill_1
XANTENNA__10512__S net240 vssd1 vssd1 vccd1 vccd1 sky130_fd_sc_hd__diode_2
XTAP_TAPCELL_ROW_129_2092 vssd1 vccd1 sky130_fd_sc_hd__tapvpwrvgnd_1
Xfanout690 net695 vssd1 vssd1 vccd1 vccd1 net690 sky130_fd_sc_hd__clkbuf_4
XFILLER_93_636 vssd1 vssd1 vccd1 vccd1 sky130_fd_sc_hd__fill_1
XFILLER_78_699 vssd1 vssd1 vccd1 vccd1 sky130_fd_sc_hd__fill_1
XFILLER_18_210 vssd1 vssd1 vccd1 vccd1 sky130_fd_sc_hd__fill_1
XFILLER_19_711 vssd1 vssd1 vccd1 vccd1 sky130_fd_sc_hd__fill_1
XANTENNA__10648__A0 FPGA_INST.cell3.LE_1B.reset_val vssd1 vssd1 vccd1 vccd1 sky130_fd_sc_hd__diode_2
XANTENNA__07108__A3 FPGA_INST.bus2_0\[15\] vssd1 vssd1 vccd1 vccd1 sky130_fd_sc_hd__diode_2
XFILLER_73_360 vssd1 vssd1 vccd1 vccd1 sky130_fd_sc_hd__fill_8
XANTENNA__06316__A1 net30 vssd1 vssd1 vccd1 vccd1 sky130_fd_sc_hd__diode_2
XANTENNA__06316__B2 net2 vssd1 vssd1 vccd1 vccd1 sky130_fd_sc_hd__diode_2
XFILLER_19_777 vssd1 vssd1 vccd1 vccd1 sky130_fd_sc_hd__fill_4
XFILLER_73_393 vccd1 vssd1 vccd1 vssd1 sky130_ef_sc_hd__decap_40_12
XFILLER_33_213 vssd1 vssd1 vccd1 vccd1 sky130_fd_sc_hd__fill_1
X_11818_ net873 _01164_ net657 vssd1 vssd1 vccd1 vccd1 net43 sky130_fd_sc_hd__dfrtp_1
XFILLER_21_419 vssd1 vssd1 vccd1 vccd1 sky130_fd_sc_hd__fill_4
XFILLER_33_257 vssd1 vssd1 vccd1 vccd1 sky130_fd_sc_hd__fill_1
XTAP_TAPCELL_ROW_60_1125 vssd1 vccd1 sky130_fd_sc_hd__tapvpwrvgnd_1
X_11749_ net900 _01095_ net684 vssd1 vssd1 vccd1 vccd1 FPGA_INST.cell3.SB0.route_sel\[119\]
+ sky130_fd_sc_hd__dfstp_1
X_05270_ FPGA_INST.cell2.SB0.route_sel\[16\] vssd1 vssd1 vccd1 vccd1 _01552_ sky130_fd_sc_hd__inv_2
XTAP_TAPCELL_ROW_116_1903 vssd1 vccd1 sky130_fd_sc_hd__tapvpwrvgnd_1
XFILLER_6_670 vssd1 vssd1 vccd1 vccd1 sky130_fd_sc_hd__fill_2
XFILLER_88_419 vssd1 vssd1 vccd1 vccd1 sky130_fd_sc_hd__fill_1
X_08960_ FPGA_INST.cell1.SB0.route_sel\[68\] _01659_ _05146_ vssd1 vssd1 vccd1 vccd1
+ _05147_ sky130_fd_sc_hd__o21ai_1
XTAP_TAPCELL_ROW_58_1098 vssd1 vccd1 sky130_fd_sc_hd__tapvpwrvgnd_1
X_08891_ FPGA_INST.cell3.CB_0.config_dataB\[18\] _01779_ FPGA_INST.cell3.CB_0.config_dataB\[19\]
+ _05074_ vssd1 vssd1 vccd1 vccd1 _05098_ sky130_fd_sc_hd__and4b_1
X_07911_ FPGA_INST.cell1.CB_0.config_dataA\[2\] _04138_ _04136_ FPGA_INST.cell1.CB_0.config_dataA\[3\]
+ vssd1 vssd1 vccd1 vccd1 _04139_ sky130_fd_sc_hd__o211a_1
XANTENNA__07792__A _04040_ vssd1 vssd1 vccd1 vccd1 sky130_fd_sc_hd__diode_2
XTAP_TAPCELL_ROW_71_1276 vssd1 vccd1 sky130_fd_sc_hd__tapvpwrvgnd_1
X_07842_ _04074_ net136 _02285_ vssd1 vssd1 vccd1 vccd1 net48 sky130_fd_sc_hd__mux2_1
XFILLER_111_785 vssd1 vssd1 vccd1 vccd1 sky130_fd_sc_hd__fill_1
X_09512_ FPGA_INST.cell1.LE_0A.config_data\[7\] FPGA_INST.cell1.LE_0A.config_data\[8\]
+ net229 vssd1 vssd1 vccd1 vccd1 _00423_ sky130_fd_sc_hd__mux2_1
X_07773_ _04018_ _04022_ vssd1 vssd1 vccd1 vccd1 _04023_ sky130_fd_sc_hd__nor2_1
X_06724_ net518 _02836_ _02997_ net516 vssd1 vssd1 vccd1 vccd1 _02998_ sky130_fd_sc_hd__o211a_1
XFILLER_37_574 vssd1 vssd1 vccd1 vccd1 sky130_fd_sc_hd__fill_2
X_09443_ FPGA_INST.cell2.LE_1B.config_data\[11\] FPGA_INST.cell2.LE_1B.config_data\[12\]
+ net291 vssd1 vssd1 vccd1 vccd1 _00356_ sky130_fd_sc_hd__mux2_1
X_06655_ _02780_ _02916_ _02918_ _02784_ FPGA_INST.cell2.CB_1.config_dataA\[17\] vssd1
+ vssd1 vccd1 vccd1 _02931_ sky130_fd_sc_hd__a221o_1
XFILLER_24_224 vssd1 vssd1 vccd1 vccd1 sky130_fd_sc_hd__fill_4
XANTENNA__06858__A2 _02070_ vssd1 vssd1 vccd1 vccd1 sky130_fd_sc_hd__diode_2
XANTENNA_fanout251_A net267 vssd1 vssd1 vccd1 vccd1 sky130_fd_sc_hd__diode_2
XANTENNA_fanout349_A net381 vssd1 vssd1 vccd1 vccd1 sky130_fd_sc_hd__diode_2
X_05606_ FPGA_INST.cell0.SB0.route_sel\[125\] FPGA_INST.cell0.SB0.route_sel\[124\]
+ vssd1 vssd1 vccd1 vccd1 _01886_ sky130_fd_sc_hd__nand2b_1
X_09374_ FPGA_INST.cell2.CB_0.config_dataA\[18\] FPGA_INST.cell2.CB_0.config_dataA\[17\]
+ net351 vssd1 vssd1 vccd1 vccd1 _00287_ sky130_fd_sc_hd__mux2_1
XTAP_TAPCELL_ROW_35_775 vssd1 vccd1 sky130_fd_sc_hd__tapvpwrvgnd_1
X_08325_ net447 net448 vssd1 vssd1 vccd1 vccd1 _04547_ sky130_fd_sc_hd__and2b_1
X_06586_ _02858_ _02859_ _02861_ FPGA_INST.cell2.CB_1.config_dataA\[2\] FPGA_INST.cell2.CB_1.config_dataA\[3\]
+ vssd1 vssd1 vccd1 vccd1 _02862_ sky130_fd_sc_hd__o221a_1
XFILLER_20_430 vssd1 vssd1 vccd1 vccd1 sky130_fd_sc_hd__fill_1
X_05537_ FPGA_INST.cell0.CB_0.config_dataA\[23\] FPGA_INST.cell0.CB_0.config_dataA\[22\]
+ vssd1 vssd1 vccd1 vccd1 _01817_ sky130_fd_sc_hd__nand2_2
XANTENNA__07283__A2 _03542_ vssd1 vssd1 vccd1 vccd1 sky130_fd_sc_hd__diode_2
X_08256_ net77 FPGA_INST.bus1_0\[13\] FPGA_INST.bus1_0\[14\] FPGA_INST.bus1_0\[15\]
+ net403 net402 vssd1 vssd1 vccd1 vccd1 _04480_ sky130_fd_sc_hd__mux4_1
X_05468_ FPGA_INST.cell0.CB_0.config_dataB\[19\] vssd1 vssd1 vccd1 vccd1 _01750_ sky130_fd_sc_hd__inv_2
XPHY_EDGE_ROW_104_Left_235 vssd1 vssd1 vccd1 vccd1 sky130_fd_sc_hd__decap_3
X_07207_ net150 net140 _03469_ vssd1 vssd1 vccd1 vccd1 _03470_ sky130_fd_sc_hd__mux2_1
X_08187_ net410 _03720_ vssd1 vssd1 vccd1 vccd1 _04411_ sky130_fd_sc_hd__nand2_1
XFILLER_20_496 vssd1 vssd1 vccd1 vccd1 sky130_fd_sc_hd__fill_1
XFILLER_118_362 vssd1 vssd1 vccd1 vccd1 sky130_fd_sc_hd__fill_2
X_05399_ FPGA_INST.cell3.SB0.route_sel\[45\] vssd1 vssd1 vccd1 vccd1 _01681_ sky130_fd_sc_hd__inv_2
X_07138_ net147 _03398_ _03400_ _03397_ vssd1 vssd1 vccd1 vccd1 _03402_ sky130_fd_sc_hd__a31o_1
XFILLER_106_535 vssd1 vssd1 vccd1 vccd1 sky130_fd_sc_hd__fill_4
XANTENNA__06794__A1 FPGA_INST.bus3_2\[5\] vssd1 vssd1 vccd1 vccd1 sky130_fd_sc_hd__diode_2
X_07069_ _02146_ _03317_ _03318_ _02110_ FPGA_INST.cell0.CB_0.config_dataA\[12\] vssd1
+ vssd1 vccd1 vccd1 _03335_ sky130_fd_sc_hd__a221o_1
X_10080_ FPGA_INST.cell0.LE_1B.config_data\[5\] FPGA_INST.cell0.LE_1B.config_data\[4\]
+ net307 vssd1 vssd1 vccd1 vccd1 _00961_ sky130_fd_sc_hd__mux2_1
XANTENNA__09393__S net358 vssd1 vssd1 vccd1 vccd1 sky130_fd_sc_hd__diode_2
XFILLER_102_763 vssd1 vssd1 vccd1 vccd1 sky130_fd_sc_hd__fill_1
XFILLER_59_132 vssd1 vssd1 vccd1 vccd1 sky130_fd_sc_hd__fill_1
XFILLER_114_41 vssd1 vssd1 vccd1 vccd1 sky130_fd_sc_hd__fill_2
XPHY_EDGE_ROW_113_Left_244 vssd1 vssd1 vccd1 vccd1 sky130_fd_sc_hd__decap_3
XTAP_TAPCELL_ROW_89_1526 vssd1 vccd1 sky130_fd_sc_hd__tapvpwrvgnd_1
XFILLER_59_165 vssd1 vssd1 vccd1 vccd1 sky130_fd_sc_hd__fill_1
XFILLER_114_85 vssd1 vssd1 vccd1 vccd1 sky130_fd_sc_hd__fill_2
XFILLER_74_56 vssd1 vssd1 vccd1 vccd1 sky130_fd_sc_hd__fill_1
X_10982_ net887 _00332_ net671 vssd1 vssd1 vccd1 vccd1 FPGA_INST.cell2.CB_1.config_dataA\[13\]
+ sky130_fd_sc_hd__dfstp_1
XANTENNA__10765__RESET_B net734 vssd1 vssd1 vccd1 vccd1 sky130_fd_sc_hd__diode_2
X_11603_ net767 _00953_ net552 vssd1 vssd1 vccd1 vccd1 FPGA_INST.cell0.CB_1.config_dataA\[22\]
+ sky130_fd_sc_hd__dfstp_1
XANTENNA__06257__S _02536_ vssd1 vssd1 vccd1 vccd1 sky130_fd_sc_hd__diode_2
XTAP_TAPCELL_ROW_13_458 vssd1 vccd1 sky130_fd_sc_hd__tapvpwrvgnd_1
XPHY_EDGE_ROW_122_Left_253 vssd1 vssd1 vccd1 vccd1 sky130_fd_sc_hd__decap_3
XTAP_TAPCELL_ROW_13_469 vssd1 vccd1 sky130_fd_sc_hd__tapvpwrvgnd_1
X_11534_ net756 _00884_ net541 vssd1 vssd1 vccd1 vccd1 FPGA_INST.cell0.CB_0.config_dataA\[3\]
+ sky130_fd_sc_hd__dfstp_1
X_11465_ net751 _00815_ net536 vssd1 vssd1 vccd1 vccd1 FPGA_INST.cell0.LE_0B.config_data\[14\]
+ sky130_fd_sc_hd__dfrtp_1
XFILLER_23_93 vccd1 vssd1 vccd1 vssd1 sky130_ef_sc_hd__decap_40_12
X_10416_ FPGA_INST.cell3.CB_1.config_dataB\[13\] FPGA_INST.cell3.CB_1.config_dataB\[14\]
+ net283 vssd1 vssd1 vccd1 vccd1 _01295_ sky130_fd_sc_hd__mux2_1
Xmax_cap109 _01977_ vssd1 vssd1 vccd1 vccd1 net109 sky130_fd_sc_hd__buf_1
XFILLER_7_478 vssd1 vssd1 vccd1 vccd1 sky130_fd_sc_hd__fill_4
X_11396_ net743 _00746_ net528 vssd1 vssd1 vccd1 vccd1 FPGA_INST.cell0.LEI0.config_data\[17\]
+ sky130_fd_sc_hd__dfrtp_1
XFILLER_124_365 vssd1 vssd1 vccd1 vccd1 sky130_fd_sc_hd__fill_4
X_10347_ FPGA_INST.cell3.LE_0A.config_data\[11\] FPGA_INST.cell3.LE_0A.config_data\[12\]
+ net293 vssd1 vssd1 vccd1 vccd1 _01228_ sky130_fd_sc_hd__mux2_1
XANTENNA__07577__A3 _03775_ vssd1 vssd1 vccd1 vccd1 sky130_fd_sc_hd__diode_2
XTAP_TAPCELL_ROW_111_1833 vssd1 vccd1 sky130_fd_sc_hd__tapvpwrvgnd_1
XFILLER_97_249 vssd1 vssd1 vccd1 vccd1 sky130_fd_sc_hd__fill_1
X_10278_ net37 net38 net253 vssd1 vssd1 vccd1 vccd1 _01159_ sky130_fd_sc_hd__mux2_1
XANTENNA__09723__A1 FPGA_INST.cell0.SB0.config_data_out vssd1 vssd1 vccd1 vccd1 sky130_fd_sc_hd__diode_2
X_12017_ net776 _01363_ net562 vssd1 vssd1 vccd1 vccd1 FPGA_INST.cell2.SB0.route_sel\[57\]
+ sky130_fd_sc_hd__dfstp_1
XANTENNA__07734__B1 net78 vssd1 vssd1 vccd1 vccd1 sky130_fd_sc_hd__diode_2
XFILLER_66_636 vssd1 vssd1 vccd1 vccd1 sky130_fd_sc_hd__fill_1
XFILLER_38_349 vssd1 vssd1 vccd1 vccd1 sky130_fd_sc_hd__fill_2
XFILLER_0_53 vssd1 vssd1 vccd1 vccd1 sky130_fd_sc_hd__fill_2
XFILLER_19_596 vssd1 vssd1 vccd1 vccd1 sky130_fd_sc_hd__fill_1
XFILLER_34_533 vssd1 vssd1 vccd1 vccd1 sky130_fd_sc_hd__fill_1
XFILLER_73_190 vccd1 vssd1 vccd1 vssd1 sky130_ef_sc_hd__decap_40_12
X_06440_ _02709_ _02717_ vssd1 vssd1 vccd1 vccd1 _02718_ sky130_fd_sc_hd__nor2_1
XTAP_TAPCELL_ROW_122_1984 vssd1 vccd1 sky130_fd_sc_hd__tapvpwrvgnd_1
XTAP_TAPCELL_ROW_122_1995 vssd1 vccd1 sky130_fd_sc_hd__tapvpwrvgnd_1
X_06371_ _01538_ _02645_ _02648_ vssd1 vssd1 vccd1 vccd1 _02649_ sky130_fd_sc_hd__or3_1
XTAP_TAPCELL_ROW_32_734 vssd1 vccd1 sky130_fd_sc_hd__tapvpwrvgnd_1
X_08110_ _04335_ vssd1 vssd1 vccd1 vccd1 _04336_ sky130_fd_sc_hd__inv_2
XANTENNA__07265__A2 _03526_ vssd1 vssd1 vccd1 vccd1 sky130_fd_sc_hd__diode_2
X_05322_ FPGA_INST.cell1.SB0.route_sel\[125\] vssd1 vssd1 vccd1 vccd1 _01604_ sky130_fd_sc_hd__inv_2
XANTENNA__08382__S _04574_ vssd1 vssd1 vccd1 vccd1 sky130_fd_sc_hd__diode_2
X_09090_ FPGA_INST.cell2.LEI0.config_data\[4\] FPGA_INST.cell2.LEI0.config_data\[5\]
+ net262 vssd1 vssd1 vccd1 vccd1 _00006_ sky130_fd_sc_hd__mux2_1
XFILLER_119_159 vssd1 vssd1 vccd1 vccd1 sky130_fd_sc_hd__fill_4
XFILLER_119_148 vssd1 vssd1 vccd1 vccd1 sky130_fd_sc_hd__fill_2
X_08041_ _04266_ vssd1 vssd1 vccd1 vccd1 _04267_ sky130_fd_sc_hd__inv_2
X_05253_ FPGA_INST.cell2.CB_0.config_dataA\[17\] vssd1 vssd1 vccd1 vccd1 _01535_ sky130_fd_sc_hd__inv_2
XANTENNA__06473__A0 net14 vssd1 vssd1 vccd1 vccd1 sky130_fd_sc_hd__diode_2
XFILLER_128_682 vssd1 vssd1 vccd1 vccd1 sky130_fd_sc_hd__fill_1
XFILLER_128_660 vssd1 vssd1 vccd1 vccd1 sky130_fd_sc_hd__fill_1
XTAP_TAPCELL_ROW_73_1305 vssd1 vccd1 sky130_fd_sc_hd__tapvpwrvgnd_1
X_09992_ _01529_ _05237_ FPGA_INST.config_bits\[9\] net739 vssd1 vssd1 vccd1 vccd1
+ _05240_ sky130_fd_sc_hd__o211a_1
XFILLER_103_549 vssd1 vssd1 vccd1 vccd1 sky130_fd_sc_hd__fill_2
X_08943_ _05135_ _03851_ vssd1 vssd1 vccd1 vccd1 FPGA_INST.bus1_0\[10\] sky130_fd_sc_hd__and2b_2
XANTENNA_fanout299_A net300 vssd1 vssd1 vccd1 vccd1 sky130_fd_sc_hd__diode_2
XFILLER_69_463 vssd1 vssd1 vccd1 vccd1 sky130_fd_sc_hd__fill_2
XFILLER_130_379 vssd1 vssd1 vccd1 vccd1 sky130_fd_sc_hd__fill_2
X_08874_ FPGA_INST.cell3.CB_0.config_dataB\[16\] _05079_ _05080_ vssd1 vssd1 vccd1
+ vccd1 _05081_ sky130_fd_sc_hd__a21oi_1
XANTENNA__09941__S net327 vssd1 vssd1 vccd1 vccd1 sky130_fd_sc_hd__diode_2
XFILLER_84_444 vssd1 vssd1 vccd1 vccd1 sky130_fd_sc_hd__fill_4
XFILLER_84_433 vssd1 vssd1 vccd1 vccd1 sky130_fd_sc_hd__fill_1
X_07825_ _01958_ _01959_ _04065_ _01960_ vssd1 vssd1 vccd1 vccd1 net56 sky130_fd_sc_hd__a31o_1
XFILLER_84_477 vssd1 vssd1 vccd1 vccd1 sky130_fd_sc_hd__fill_8
X_07756_ net153 _04005_ _03991_ vssd1 vssd1 vccd1 vccd1 _04006_ sky130_fd_sc_hd__mux2_1
XFILLER_25_500 vssd1 vssd1 vccd1 vccd1 sky130_fd_sc_hd__fill_4
X_06707_ net520 _02796_ vssd1 vssd1 vccd1 vccd1 _02981_ sky130_fd_sc_hd__nand2_1
X_07687_ FPGA_INST.cell3.CB_0.config_dataA\[23\] FPGA_INST.cell3.CB_0.config_dataA\[22\]
+ vssd1 vssd1 vccd1 vccd1 _03939_ sky130_fd_sc_hd__nand2_1
XTAP_TAPCELL_ROW_84_1456 vssd1 vccd1 sky130_fd_sc_hd__tapvpwrvgnd_1
X_09426_ FPGA_INST.cell2.CB_1.config_dataA\[20\] FPGA_INST.cell2.CB_1.config_dataA\[19\]
+ net354 vssd1 vssd1 vccd1 vccd1 _00339_ sky130_fd_sc_hd__mux2_1
X_06638_ net475 _02832_ vssd1 vssd1 vccd1 vccd1 _02914_ sky130_fd_sc_hd__nand2_1
XFILLER_52_374 vssd1 vssd1 vccd1 vccd1 sky130_fd_sc_hd__fill_4
XFILLER_52_363 vssd1 vssd1 vccd1 vccd1 sky130_fd_sc_hd__fill_1
X_06569_ net480 _02833_ _02837_ _02844_ vssd1 vssd1 vccd1 vccd1 _02845_ sky130_fd_sc_hd__a31o_1
X_09357_ net508 net510 net356 vssd1 vssd1 vccd1 vccd1 _00270_ sky130_fd_sc_hd__mux2_1
XFILLER_40_558 vssd1 vssd1 vccd1 vccd1 sky130_fd_sc_hd__fill_2
X_09288_ FPGA_INST.cell1.SB0.route_sel\[59\] FPGA_INST.cell1.SB0.route_sel\[60\] net220
+ vssd1 vssd1 vccd1 vccd1 _00201_ sky130_fd_sc_hd__mux2_1
XFILLER_60_25 vssd1 vssd1 vccd1 vccd1 sky130_fd_sc_hd__fill_2
X_08308_ net446 _03504_ _04529_ net444 vssd1 vssd1 vccd1 vccd1 _04530_ sky130_fd_sc_hd__o211a_1
XANTENNA__09388__S net357 vssd1 vssd1 vccd1 vccd1 sky130_fd_sc_hd__diode_2
X_08239_ FPGA_INST.bus1_0\[9\] _04443_ _04462_ vssd1 vssd1 vccd1 vccd1 _04463_ sky130_fd_sc_hd__a21oi_1
XTAP_TAPCELL_ROW_10_417 vssd1 vccd1 sky130_fd_sc_hd__tapvpwrvgnd_1
XTAP_TAPCELL_ROW_10_428 vssd1 vccd1 sky130_fd_sc_hd__tapvpwrvgnd_1
XFILLER_21_794 vssd1 vssd1 vccd1 vccd1 sky130_fd_sc_hd__fill_2
XFILLER_119_682 vssd1 vssd1 vccd1 vccd1 sky130_fd_sc_hd__fill_2
XFILLER_107_3 vssd1 vssd1 vccd1 vccd1 sky130_fd_sc_hd__fill_8
XANTENNA_fanout790_X net790 vssd1 vssd1 vccd1 vccd1 sky130_fd_sc_hd__diode_2
X_11250_ net779 _00600_ net564 vssd1 vssd1 vccd1 vccd1 FPGA_INST.cell0.SB0.route_sel\[95\]
+ sky130_fd_sc_hd__dfstp_1
XANTENNA__07964__A0 FPGA_INST.bus3_1\[0\] vssd1 vssd1 vccd1 vccd1 sky130_fd_sc_hd__diode_2
X_10201_ FPGA_INST.cell3.SB0.route_sel\[105\] FPGA_INST.cell3.SB0.route_sel\[106\]
+ net271 vssd1 vssd1 vccd1 vccd1 _01082_ sky130_fd_sc_hd__mux2_1
XFILLER_79_205 vssd1 vssd1 vccd1 vccd1 sky130_fd_sc_hd__fill_1
X_11181_ net782 _00531_ net567 vssd1 vssd1 vccd1 vccd1 FPGA_INST.cell0.SB0.route_sel\[26\]
+ sky130_fd_sc_hd__dfstp_1
X_10132_ FPGA_INST.cell3.SB0.route_sel\[37\] FPGA_INST.cell3.SB0.route_sel\[36\] net369
+ vssd1 vssd1 vccd1 vccd1 _01013_ sky130_fd_sc_hd__mux2_1
XFILLER_102_571 vssd1 vssd1 vccd1 vccd1 sky130_fd_sc_hd__fill_8
X_10063_ FPGA_INST.cell0.CB_1.config_dataA\[13\] FPGA_INST.cell0.CB_1.config_dataA\[12\]
+ net327 vssd1 vssd1 vccd1 vccd1 _00944_ sky130_fd_sc_hd__mux2_1
XANTENNA__10062__S net327 vssd1 vssd1 vccd1 vccd1 sky130_fd_sc_hd__diode_2
XTAP_TAPCELL_ROW_126_2040 vssd1 vccd1 sky130_fd_sc_hd__tapvpwrvgnd_1
XANTENNA_input27_A gpio_in[33] vssd1 vssd1 vccd1 vccd1 sky130_fd_sc_hd__diode_2
XANTENNA__09181__A2 net524 vssd1 vssd1 vccd1 vccd1 sky130_fd_sc_hd__diode_2
XTAP_TAPCELL_ROW_126_2051 vssd1 vccd1 sky130_fd_sc_hd__tapvpwrvgnd_1
XFILLER_18_60 vccd1 vssd1 vccd1 vssd1 sky130_ef_sc_hd__decap_40_12
XFILLER_90_425 vssd1 vssd1 vccd1 vccd1 sky130_fd_sc_hd__fill_2
XTAP_TAPCELL_ROW_18_528 vssd1 vccd1 sky130_fd_sc_hd__tapvpwrvgnd_1
XTAP_TAPCELL_ROW_18_539 vssd1 vccd1 sky130_fd_sc_hd__tapvpwrvgnd_1
XANTENNA__05680__A net135 vssd1 vssd1 vccd1 vccd1 sky130_fd_sc_hd__diode_2
XFILLER_90_458 vssd1 vssd1 vccd1 vccd1 sky130_fd_sc_hd__fill_2
XFILLER_71_650 vssd1 vssd1 vccd1 vccd1 sky130_fd_sc_hd__fill_1
X_10965_ net850 _00315_ net635 vssd1 vssd1 vccd1 vccd1 FPGA_INST.cell2.CB_0.config_dataB\[21\]
+ sky130_fd_sc_hd__dfstp_1
X_10896_ net823 _00246_ net607 vssd1 vssd1 vccd1 vccd1 FPGA_INST.cell1.SB0.route_sel\[105\]
+ sky130_fd_sc_hd__dfstp_1
XFILLER_70_193 vssd1 vssd1 vccd1 vccd1 sky130_fd_sc_hd__fill_2
XFILLER_129_435 vssd1 vssd1 vccd1 vccd1 sky130_fd_sc_hd__fill_1
XFILLER_12_750 vssd1 vssd1 vccd1 vccd1 sky130_fd_sc_hd__fill_4
XFILLER_34_92 vssd1 vssd1 vccd1 vccd1 sky130_fd_sc_hd__fill_2
X_11517_ net780 _00867_ net565 vssd1 vssd1 vccd1 vccd1 FPGA_INST.cell0.CB_1.config_dataB\[23\]
+ sky130_fd_sc_hd__dfstp_1
XFILLER_11_260 vssd1 vssd1 vccd1 vccd1 sky130_fd_sc_hd__fill_1
XFILLER_117_619 vccd1 vssd1 vccd1 vssd1 sky130_ef_sc_hd__decap_40_12
X_11448_ net750 _00798_ net535 vssd1 vssd1 vccd1 vccd1 FPGA_INST.cell0.LE_0A.reset_mode
+ sky130_fd_sc_hd__dfrtp_1
X_11379_ net745 _00729_ net530 vssd1 vssd1 vccd1 vccd1 FPGA_INST.cell0.LEI0.config_data\[0\]
+ sky130_fd_sc_hd__dfrtp_1
XFILLER_124_184 vssd1 vssd1 vccd1 vccd1 sky130_fd_sc_hd__fill_1
XANTENNA__06758__B2 _02784_ vssd1 vssd1 vccd1 vccd1 sky130_fd_sc_hd__diode_2
XANTENNA__06758__A1 _02780_ vssd1 vssd1 vccd1 vccd1 sky130_fd_sc_hd__diode_2
XTAP_TAPCELL_ROW_55_1057 vssd1 vccd1 sky130_fd_sc_hd__tapvpwrvgnd_1
XTAP_TAPCELL_ROW_55_1046 vssd1 vccd1 sky130_fd_sc_hd__tapvpwrvgnd_1
XFILLER_100_519 vssd1 vssd1 vccd1 vccd1 sky130_fd_sc_hd__fill_8
XFILLER_79_794 vssd1 vssd1 vccd1 vccd1 sky130_fd_sc_hd__fill_4
XFILLER_79_783 vssd1 vssd1 vccd1 vccd1 sky130_fd_sc_hd__fill_1
XFILLER_22_3 vccd1 vssd1 vccd1 vssd1 sky130_ef_sc_hd__decap_40_12
X_05940_ FPGA_INST.cell0.SB0.route_sel\[48\] FPGA_INST.cell0.SB0.route_sel\[49\] vssd1
+ vssd1 vccd1 vccd1 _02220_ sky130_fd_sc_hd__and2_1
XANTENNA__08904__C1 net156 vssd1 vssd1 vccd1 vccd1 sky130_fd_sc_hd__diode_2
X_05871_ _01943_ _02037_ vssd1 vssd1 vccd1 vccd1 _02151_ sky130_fd_sc_hd__nor2_1
XFILLER_94_797 vssd1 vssd1 vccd1 vccd1 sky130_fd_sc_hd__fill_2
X_07610_ _03530_ _03862_ _03822_ vssd1 vssd1 vccd1 vccd1 _03864_ sky130_fd_sc_hd__or3b_1
X_08590_ FPGA_INST.cell3.SB0.route_sel\[126\] FPGA_INST.cell3.SB0.config_data_out
+ vssd1 vssd1 vccd1 vccd1 _04799_ sky130_fd_sc_hd__nand2b_1
XFILLER_66_477 vssd1 vssd1 vccd1 vccd1 sky130_fd_sc_hd__fill_1
XFILLER_53_105 vssd1 vssd1 vccd1 vccd1 sky130_fd_sc_hd__fill_1
XTAP_TAPCELL_ROW_37_804 vssd1 vccd1 sky130_fd_sc_hd__tapvpwrvgnd_1
XFILLER_81_447 vssd1 vssd1 vccd1 vccd1 sky130_fd_sc_hd__fill_1
X_07541_ FPGA_INST.cell0.SB0.route_sel\[78\] _01653_ vssd1 vssd1 vccd1 vccd1 _03796_
+ sky130_fd_sc_hd__nand2_1
XFILLER_19_393 vssd1 vssd1 vccd1 vccd1 sky130_fd_sc_hd__fill_1
X_07472_ _03549_ _03594_ _03728_ vssd1 vssd1 vccd1 vccd1 _03729_ sky130_fd_sc_hd__o21ai_1
XFILLER_61_171 vssd1 vssd1 vccd1 vccd1 sky130_fd_sc_hd__fill_2
XFILLER_34_363 vssd1 vssd1 vccd1 vccd1 sky130_fd_sc_hd__fill_1
X_09211_ FPGA_INST.cell2.CB_1.config_dataB\[8\] FPGA_INST.cell2.CB_1.config_dataB\[7\]
+ net379 vssd1 vssd1 vccd1 vccd1 _00124_ sky130_fd_sc_hd__mux2_1
XFILLER_14_29 vssd1 vssd1 vccd1 vccd1 sky130_fd_sc_hd__fill_8
X_06423_ FPGA_INST.cell2.CB_0.config_dataB\[12\] _02700_ FPGA_INST.cell2.CB_0.config_dataB\[13\]
+ vssd1 vssd1 vccd1 vccd1 _02701_ sky130_fd_sc_hd__a21bo_1
X_09142_ FPGA_INST.cell2.LE_0A.config_data\[5\] FPGA_INST.cell2.LE_0A.config_data\[6\]
+ net237 vssd1 vssd1 vccd1 vccd1 _00057_ sky130_fd_sc_hd__mux2_1
X_06354_ FPGA_INST.cell2.CB_0.config_dataB\[8\] FPGA_INST.cell2.CB_0.config_dataB\[7\]
+ vssd1 vssd1 vccd1 vccd1 _02632_ sky130_fd_sc_hd__or2_1
XANTENNA__05589__X _01869_ vssd1 vssd1 vccd1 vccd1 sky130_fd_sc_hd__diode_2
X_05305_ FPGA_INST.cell2.SB0.config_data_out vssd1 vssd1 vccd1 vccd1 _01587_ sky130_fd_sc_hd__inv_2
X_09073_ _03628_ _04842_ _03621_ vssd1 vssd1 vccd1 vccd1 _05204_ sky130_fd_sc_hd__a21o_1
X_06285_ net6 _02540_ _02541_ net5 vssd1 vssd1 vccd1 vccd1 _02565_ sky130_fd_sc_hd__a22o_1
XFILLER_128_490 vssd1 vssd1 vccd1 vccd1 sky130_fd_sc_hd__fill_1
XFILLER_116_641 vssd1 vssd1 vccd1 vccd1 sky130_fd_sc_hd__fill_2
X_08024_ FPGA_INST.bus3_1\[12\] FPGA_INST.bus3_1\[13\] FPGA_INST.bus3_1\[14\] FPGA_INST.bus3_1\[15\]
+ net457 net456 vssd1 vssd1 vccd1 vccd1 _04250_ sky130_fd_sc_hd__mux4_1
XFILLER_89_503 vssd1 vssd1 vccd1 vccd1 sky130_fd_sc_hd__fill_1
XFILLER_1_407 vssd1 vssd1 vccd1 vccd1 sky130_fd_sc_hd__fill_2
XANTENNA__06749__A1 FPGA_INST.bus3_2\[13\] vssd1 vssd1 vccd1 vccd1 sky130_fd_sc_hd__diode_2
XFILLER_39_15 vssd1 vssd1 vccd1 vccd1 sky130_fd_sc_hd__fill_1
X_09975_ FPGA_INST.config_bits\[4\] FPGA_INST.config_bits\[3\] _05224_ vssd1 vssd1
+ vccd1 vccd1 _05228_ sky130_fd_sc_hd__and3_1
X_08926_ FPGA_INST.cell2.SB0.route_sel\[98\] FPGA_INST.cell2.SB0.route_sel\[99\] vssd1
+ vssd1 vccd1 vccd1 _05124_ sky130_fd_sc_hd__nand2b_1
X_08857_ FPGA_INST.cell3.LE_0B.config_data\[2\] FPGA_INST.cell3.LE_0B.config_data\[3\]
+ _05032_ vssd1 vssd1 vccd1 vccd1 _05064_ sky130_fd_sc_hd__mux2_1
XFILLER_84_263 vssd1 vssd1 vccd1 vccd1 sky130_fd_sc_hd__fill_4
X_07808_ _03576_ _03940_ _04056_ FPGA_INST.cell3.SB0.route_sel\[121\] FPGA_INST.cell3.SB0.route_sel\[120\]
+ vssd1 vssd1 vccd1 vccd1 _04057_ sky130_fd_sc_hd__a32o_1
XANTENNA_fanout848_A net849 vssd1 vssd1 vccd1 vccd1 sky130_fd_sc_hd__diode_2
X_08788_ FPGA_INST.cell3.CB_0.config_dataB\[8\] _04989_ _04990_ _04994_ FPGA_INST.cell3.CB_0.config_dataB\[9\]
+ vssd1 vssd1 vccd1 vccd1 _04995_ sky130_fd_sc_hd__a41o_1
XANTENNA__06921__A1 FPGA_INST.bus2_0\[0\] vssd1 vssd1 vccd1 vccd1 sky130_fd_sc_hd__diode_2
X_07739_ FPGA_INST.cell3.SB0.route_sel\[118\] FPGA_INST.cell3.SB0.route_sel\[119\]
+ net130 _01851_ vssd1 vssd1 vccd1 vccd1 _03989_ sky130_fd_sc_hd__a22oi_1
XANTENNA_fanout636_X net636 vssd1 vssd1 vccd1 vccd1 sky130_fd_sc_hd__diode_2
XFILLER_37_190 vssd1 vssd1 vccd1 vccd1 sky130_fd_sc_hd__fill_4
X_10750_ net885 _00100_ net669 vssd1 vssd1 vccd1 vccd1 FPGA_INST.cell2.LE_1A.config_data\[5\]
+ sky130_fd_sc_hd__dfrtp_1
XANTENNA_fanout803_X net803 vssd1 vssd1 vccd1 vccd1 sky130_fd_sc_hd__diode_2
XFILLER_71_35 vssd1 vssd1 vccd1 vccd1 sky130_fd_sc_hd__fill_1
X_09409_ FPGA_INST.cell2.CB_1.config_dataA\[3\] FPGA_INST.cell2.CB_1.config_dataA\[2\]
+ net362 vssd1 vssd1 vccd1 vccd1 _00322_ sky130_fd_sc_hd__mux2_1
X_10681_ net877 _00031_ net661 vssd1 vssd1 vccd1 vccd1 FPGA_INST.cell2.LEI0.config_data\[30\]
+ sky130_fd_sc_hd__dfrtp_1
XFILLER_71_57 vssd1 vssd1 vccd1 vccd1 sky130_fd_sc_hd__fill_1
XFILLER_40_377 vssd1 vssd1 vccd1 vccd1 sky130_fd_sc_hd__fill_1
XTAP_TAPCELL_ROW_97_1647 vssd1 vccd1 sky130_fd_sc_hd__tapvpwrvgnd_1
XTAP_TAPCELL_ROW_97_1636 vssd1 vccd1 sky130_fd_sc_hd__tapvpwrvgnd_1
XANTENNA__11542__SET_B net563 vssd1 vssd1 vccd1 vccd1 sky130_fd_sc_hd__diode_2
X_11302_ net826 _00652_ net610 vssd1 vssd1 vccd1 vccd1 FPGA_INST.cell1.CB_0.config_dataA\[19\]
+ sky130_fd_sc_hd__dfstp_1
X_11233_ net761 _00583_ net546 vssd1 vssd1 vccd1 vccd1 FPGA_INST.cell0.SB0.route_sel\[78\]
+ sky130_fd_sc_hd__dfstp_1
XFILLER_121_110 vssd1 vssd1 vccd1 vccd1 sky130_fd_sc_hd__fill_2
X_11164_ net780 _00514_ net565 vssd1 vssd1 vccd1 vccd1 FPGA_INST.cell0.SB0.route_sel\[9\]
+ sky130_fd_sc_hd__dfstp_1
X_11095_ net841 _00445_ net625 vssd1 vssd1 vccd1 vccd1 FPGA_INST.cell1.LE_0B.config_data\[8\]
+ sky130_fd_sc_hd__dfrtp_1
X_10115_ FPGA_INST.cell3.SB0.route_sel\[19\] FPGA_INST.cell3.SB0.route_sel\[20\] net270
+ vssd1 vssd1 vccd1 vccd1 _00996_ sky130_fd_sc_hd__mux2_1
XFILLER_121_198 vssd1 vssd1 vccd1 vccd1 sky130_fd_sc_hd__fill_1
XFILLER_88_591 vssd1 vssd1 vccd1 vccd1 sky130_fd_sc_hd__fill_1
X_10046_ FPGA_INST.cell0.CB_0.config_dataB\[20\] FPGA_INST.cell0.CB_0.config_dataB\[21\]
+ net180 vssd1 vssd1 vccd1 vccd1 _00927_ sky130_fd_sc_hd__mux2_1
XFILLER_91_701 vssd1 vssd1 vccd1 vccd1 sky130_fd_sc_hd__fill_2
XFILLER_76_786 vssd1 vssd1 vccd1 vccd1 sky130_fd_sc_hd__fill_1
XANTENNA__08362__A0 FPGA_INST.bus1_0\[14\] vssd1 vssd1 vccd1 vccd1 sky130_fd_sc_hd__diode_2
XFILLER_76_797 vssd1 vssd1 vccd1 vccd1 sky130_fd_sc_hd__fill_2
XANTENNA__08114__A0 FPGA_INST.bus3_1\[0\] vssd1 vssd1 vccd1 vccd1 sky130_fd_sc_hd__diode_2
XFILLER_90_244 vssd1 vssd1 vccd1 vccd1 sky130_fd_sc_hd__fill_1
X_11997_ net852 _01343_ net637 vssd1 vssd1 vccd1 vccd1 FPGA_INST.cell2.SB0.route_sel\[37\]
+ sky130_fd_sc_hd__dfstp_1
XFILLER_35_149 vssd1 vssd1 vccd1 vccd1 sky130_fd_sc_hd__fill_8
XTAP_TAPCELL_ROW_106_1765 vssd1 vccd1 sky130_fd_sc_hd__tapvpwrvgnd_1
XFILLER_90_266 vssd1 vssd1 vccd1 vccd1 sky130_fd_sc_hd__fill_2
XANTENNA__08665__A1 _04828_ vssd1 vssd1 vccd1 vccd1 sky130_fd_sc_hd__diode_2
X_10948_ net863 _00298_ net648 vssd1 vssd1 vccd1 vccd1 FPGA_INST.cell2.CB_0.config_dataB\[4\]
+ sky130_fd_sc_hd__dfstp_1
XFILLER_16_363 vssd1 vssd1 vccd1 vccd1 sky130_fd_sc_hd__fill_1
XANTENNA__10744__SET_B net734 vssd1 vssd1 vccd1 vccd1 sky130_fd_sc_hd__diode_2
X_10879_ net799 _00229_ net584 vssd1 vssd1 vccd1 vccd1 FPGA_INST.cell1.SB0.route_sel\[88\]
+ sky130_fd_sc_hd__dfstp_1
XTAP_TAPCELL_ROW_42_873 vssd1 vccd1 sky130_fd_sc_hd__tapvpwrvgnd_1
XANTENNA__09756__S net369 vssd1 vssd1 vccd1 vccd1 sky130_fd_sc_hd__diode_2
XANTENNA__07640__A2 _02832_ vssd1 vssd1 vccd1 vccd1 sky130_fd_sc_hd__diode_2
XFILLER_8_584 vssd1 vssd1 vccd1 vccd1 sky130_fd_sc_hd__fill_1
XANTENNA_1 _02467_ vssd1 vssd1 vccd1 vccd1 sky130_fd_sc_hd__diode_2
X_06070_ _02347_ _02349_ vssd1 vssd1 vccd1 vccd1 _02350_ sky130_fd_sc_hd__or2_4
XFILLER_113_600 vssd1 vssd1 vccd1 vccd1 sky130_fd_sc_hd__fill_2
XANTENNA__11327__SET_B net626 vssd1 vssd1 vccd1 vccd1 sky130_fd_sc_hd__diode_2
XANTENNA__07129__X FPGA_INST.cell0.CB_0.le_outA vssd1 vssd1 vccd1 vccd1 sky130_fd_sc_hd__diode_2
Xfanout519 FPGA_INST.cell2.CB_1.config_dataB\[1\] vssd1 vssd1 vccd1 vccd1 net519 sky130_fd_sc_hd__buf_2
XANTENNA__08196__A3 FPGA_INST.bus1_0\[3\] vssd1 vssd1 vccd1 vccd1 sky130_fd_sc_hd__diode_2
Xfanout508 FPGA_INST.cell2.CB_0.config_dataA\[1\] vssd1 vssd1 vccd1 vccd1 net508 sky130_fd_sc_hd__buf_2
X_09760_ net453 net455 net347 vssd1 vssd1 vccd1 vccd1 _00669_ sky130_fd_sc_hd__mux2_1
XFILLER_113_688 vssd1 vssd1 vccd1 vccd1 sky130_fd_sc_hd__fill_1
X_06972_ _03238_ _03239_ _03124_ vssd1 vssd1 vccd1 vccd1 _03240_ sky130_fd_sc_hd__mux2_1
X_08711_ _01769_ _04917_ _04919_ FPGA_INST.cell3.LEI0.config_data\[26\] vssd1 vssd1
+ vccd1 vccd1 _04920_ sky130_fd_sc_hd__a211o_1
XFILLER_79_591 vssd1 vssd1 vccd1 vccd1 sky130_fd_sc_hd__fill_1
X_05923_ FPGA_INST.bus3_2\[7\] _02199_ _02202_ vssd1 vssd1 vccd1 vccd1 _02203_ sky130_fd_sc_hd__a21o_1
X_09691_ FPGA_INST.cell0.SB0.route_sel\[94\] FPGA_INST.cell0.SB0.route_sel\[95\] net187
+ vssd1 vssd1 vccd1 vccd1 _00600_ sky130_fd_sc_hd__mux2_1
X_08642_ net20 net21 net401 vssd1 vssd1 vccd1 vccd1 _04851_ sky130_fd_sc_hd__mux2_1
XFILLER_67_764 vssd1 vssd1 vccd1 vccd1 sky130_fd_sc_hd__fill_1
XFILLER_27_617 vssd1 vssd1 vccd1 vccd1 sky130_fd_sc_hd__fill_1
XFILLER_94_583 vssd1 vssd1 vccd1 vccd1 sky130_fd_sc_hd__fill_1
XTAP_TAPCELL_ROW_68_1237 vssd1 vccd1 sky130_fd_sc_hd__tapvpwrvgnd_1
XFILLER_66_285 vssd1 vssd1 vccd1 vccd1 sky130_fd_sc_hd__fill_1
X_05854_ net167 net161 vssd1 vssd1 vccd1 vccd1 _02134_ sky130_fd_sc_hd__nor2_1
XANTENNA__06903__A1 FPGA_INST.bus2_0\[14\] vssd1 vssd1 vccd1 vccd1 sky130_fd_sc_hd__diode_2
X_08573_ net401 _03861_ _03865_ _04780_ vssd1 vssd1 vccd1 vccd1 _04782_ sky130_fd_sc_hd__or4_1
XFILLER_54_469 vssd1 vssd1 vccd1 vccd1 sky130_fd_sc_hd__fill_4
X_05785_ net116 _01870_ _02012_ _02058_ vssd1 vssd1 vccd1 vccd1 _02065_ sky130_fd_sc_hd__a31o_1
X_07524_ FPGA_INST.cell3.CB_0.config_dataB\[22\] _03434_ FPGA_INST.cell3.CB_0.config_dataB\[23\]
+ vssd1 vssd1 vccd1 vccd1 _03780_ sky130_fd_sc_hd__or3b_1
XTAP_TAPCELL_ROW_81_1415 vssd1 vccd1 sky130_fd_sc_hd__tapvpwrvgnd_1
X_07455_ _03549_ _03594_ FPGA_INST.bus3_1\[7\] vssd1 vssd1 vccd1 vccd1 _03712_ sky130_fd_sc_hd__o21a_1
XFILLER_34_193 vssd1 vssd1 vccd1 vccd1 sky130_fd_sc_hd__fill_1
XANTENNA_fanout331_A net332 vssd1 vssd1 vccd1 vccd1 sky130_fd_sc_hd__diode_2
X_06406_ FPGA_INST.cell2.CB_0.config_dataB\[3\] _02679_ _02683_ FPGA_INST.cell2.CB_0.config_dataB\[4\]
+ _02671_ vssd1 vssd1 vccd1 vccd1 _02684_ sky130_fd_sc_hd__a311o_1
XFILLER_22_344 vssd1 vssd1 vccd1 vccd1 sky130_fd_sc_hd__fill_4
X_07386_ _03454_ _03594_ FPGA_INST.bus3_1\[5\] vssd1 vssd1 vccd1 vccd1 _03645_ sky130_fd_sc_hd__o21ai_1
XANTENNA__09081__A1 _04828_ vssd1 vssd1 vccd1 vccd1 sky130_fd_sc_hd__diode_2
X_06337_ _02616_ _02613_ _02571_ vssd1 vssd1 vccd1 vccd1 _02617_ sky130_fd_sc_hd__mux2_1
XTAP_TAPCELL_ROW_20_556 vssd1 vccd1 sky130_fd_sc_hd__tapvpwrvgnd_1
X_09125_ FPGA_INST.cell2.LEI0.config_data\[39\] FPGA_INST.cell2.LEI0.config_data\[40\]
+ net250 vssd1 vssd1 vccd1 vccd1 _00041_ sky130_fd_sc_hd__mux2_1
X_09056_ net740 _01805_ vssd1 vssd1 vccd1 vccd1 FPGA_INST.cfg_done_d sky130_fd_sc_hd__nor2_1
X_06268_ net14 net15 net16 net17 net504 net502 vssd1 vssd1 vccd1 vccd1 _02548_ sky130_fd_sc_hd__mux4_1
XTAP_TAPCELL_ROW_20_567 vssd1 vccd1 sky130_fd_sc_hd__tapvpwrvgnd_1
X_08007_ net457 _03690_ _04232_ net456 vssd1 vssd1 vccd1 vccd1 _04233_ sky130_fd_sc_hd__o211a_1
XTAP_TAPCELL_ROW_79_1388 vssd1 vccd1 sky130_fd_sc_hd__tapvpwrvgnd_1
XFILLER_2_749 vssd1 vssd1 vccd1 vccd1 sky130_fd_sc_hd__fill_2
X_06199_ _01957_ _02368_ vssd1 vssd1 vccd1 vccd1 _02479_ sky130_fd_sc_hd__or2_1
XTAP_TAPCELL_ROW_92_1577 vssd1 vccd1 sky130_fd_sc_hd__tapvpwrvgnd_1
XTAP_TAPCELL_ROW_92_1566 vssd1 vccd1 sky130_fd_sc_hd__tapvpwrvgnd_1
XFILLER_103_165 vssd1 vssd1 vccd1 vccd1 sky130_fd_sc_hd__fill_2
XFILLER_89_388 vssd1 vssd1 vccd1 vccd1 sky130_fd_sc_hd__fill_1
XFILLER_77_517 vssd1 vssd1 vccd1 vccd1 sky130_fd_sc_hd__fill_4
X_09958_ FPGA_INST.cell0.CB_1.config_dataB\[18\] FPGA_INST.cell0.CB_1.config_dataB\[19\]
+ net187 vssd1 vssd1 vccd1 vccd1 _00863_ sky130_fd_sc_hd__mux2_1
XFILLER_66_24 vssd1 vssd1 vccd1 vccd1 sky130_fd_sc_hd__fill_1
XANTENNA__06103__B _01825_ vssd1 vssd1 vccd1 vccd1 sky130_fd_sc_hd__diode_2
X_08909_ _01582_ FPGA_INST.cell2.SB0.route_sel\[113\] FPGA_INST.cell2.SB0.route_sel\[118\]
+ FPGA_INST.cell2.SB0.route_sel\[119\] _05112_ vssd1 vssd1 vccd1 vccd1 _05113_ sky130_fd_sc_hd__o221a_1
X_09889_ FPGA_INST.cell0.LE_0A.config_data\[16\] FPGA_INST.cell0.LE_0A.edge_mode net190
+ vssd1 vssd1 vccd1 vccd1 _00796_ sky130_fd_sc_hd__mux2_1
X_11920_ net941 _01266_ net725 vssd1 vssd1 vccd1 vccd1 FPGA_INST.cell3.LE_1A.config_data\[6\]
+ sky130_fd_sc_hd__dfrtp_1
XTAP_TAPCELL_ROW_123_2010 vssd1 vccd1 sky130_fd_sc_hd__tapvpwrvgnd_1
X_11851_ net933 _01197_ net717 vssd1 vssd1 vccd1 vccd1 FPGA_INST.cell3.LEI0.config_data\[31\]
+ sky130_fd_sc_hd__dfrtp_1
XFILLER_122_52 vssd1 vssd1 vccd1 vccd1 sky130_fd_sc_hd__fill_1
XFILLER_122_85 vssd1 vssd1 vccd1 vccd1 sky130_fd_sc_hd__fill_4
XFILLER_82_45 vssd1 vssd1 vccd1 vccd1 sky130_fd_sc_hd__fill_2
X_10802_ net822 _00152_ net606 vssd1 vssd1 vccd1 vccd1 FPGA_INST.cell1.SB0.route_sel\[11\]
+ sky130_fd_sc_hd__dfstp_1
XFILLER_72_288 vssd1 vssd1 vccd1 vccd1 sky130_fd_sc_hd__fill_1
X_11782_ net926 _01128_ net710 vssd1 vssd1 vccd1 vccd1 FPGA_INST.io_south_oeb\[16\]
+ sky130_fd_sc_hd__dfrtp_1
XFILLER_60_417 vssd1 vssd1 vccd1 vccd1 sky130_fd_sc_hd__fill_2
XTAP_TAPCELL_ROW_0_270 vssd1 vccd1 sky130_fd_sc_hd__tapvpwrvgnd_1
XTAP_TAPCELL_ROW_0_281 vssd1 vccd1 sky130_fd_sc_hd__tapvpwrvgnd_1
XTAP_TAPCELL_ROW_28_678 vssd1 vccd1 sky130_fd_sc_hd__tapvpwrvgnd_1
X_10733_ net869 _00083_ net654 vssd1 vssd1 vccd1 vccd1 FPGA_INST.cell2.LE_0B.config_data\[10\]
+ sky130_fd_sc_hd__dfrtp_1
XFILLER_40_141 vssd1 vssd1 vccd1 vccd1 sky130_fd_sc_hd__fill_2
X_10664_ net867 _00014_ net651 vssd1 vssd1 vccd1 vccd1 FPGA_INST.cell2.LEI0.config_data\[13\]
+ sky130_fd_sc_hd__dfrtp_1
X_10595_ FPGA_INST.cell3.CB_0.config_dataB\[14\] net387 net300 vssd1 vssd1 vccd1 vccd1
+ _01474_ sky130_fd_sc_hd__mux2_1
XTAP_TAPCELL_ROW_101_1695 vssd1 vccd1 sky130_fd_sc_hd__tapvpwrvgnd_1
XPHY_EDGE_ROW_128_Right_128 vssd1 vssd1 vccd1 vccd1 sky130_fd_sc_hd__decap_3
XFILLER_114_419 vssd1 vssd1 vccd1 vccd1 sky130_fd_sc_hd__fill_1
XFILLER_49_8 vssd1 vssd1 vccd1 vccd1 sky130_fd_sc_hd__fill_1
Xoutput60 net60 vssd1 vssd1 vccd1 vccd1 gpio_out[25] sky130_fd_sc_hd__buf_2
XTAP_TAPCELL_ROW_52_1005 vssd1 vccd1 sky130_fd_sc_hd__tapvpwrvgnd_1
X_11216_ net757 _00566_ net542 vssd1 vssd1 vccd1 vccd1 FPGA_INST.cell0.SB0.route_sel\[61\]
+ sky130_fd_sc_hd__dfstp_1
Xoutput71 net71 vssd1 vssd1 vccd1 vccd1 gpio_out[6] sky130_fd_sc_hd__buf_2
X_11147_ net808 _00497_ net594 vssd1 vssd1 vccd1 vccd1 FPGA_INST.cell1.CB_1.config_dataB\[17\]
+ sky130_fd_sc_hd__dfstp_1
XTAP_TAPCELL_ROW_52_1016 vssd1 vccd1 sky130_fd_sc_hd__tapvpwrvgnd_1
XTAP_TAPCELL_ROW_8_392 vssd1 vccd1 sky130_fd_sc_hd__tapvpwrvgnd_1
XFILLER_0_281 vccd1 vssd1 vccd1 vssd1 sky130_ef_sc_hd__decap_40_12
XFILLER_1_782 vssd1 vssd1 vccd1 vccd1 sky130_fd_sc_hd__fill_2
X_11078_ net834 _00428_ net618 vssd1 vssd1 vccd1 vccd1 FPGA_INST.cell1.LE_0A.config_data\[13\]
+ sky130_fd_sc_hd__dfrtp_1
XANTENNA__07138__A1 net147 vssd1 vssd1 vccd1 vccd1 sky130_fd_sc_hd__diode_2
XFILLER_76_550 vssd1 vssd1 vccd1 vccd1 sky130_fd_sc_hd__fill_1
XFILLER_49_753 vssd1 vssd1 vccd1 vccd1 sky130_fd_sc_hd__fill_8
X_10029_ FPGA_INST.cell0.CB_0.config_dataB\[3\] FPGA_INST.cell0.CB_0.config_dataB\[4\]
+ net181 vssd1 vssd1 vccd1 vccd1 _00910_ sky130_fd_sc_hd__mux2_1
XTAP_TAPCELL_ROW_47_943 vssd1 vccd1 sky130_fd_sc_hd__tapvpwrvgnd_1
XFILLER_24_609 vccd1 vssd1 vccd1 vssd1 sky130_ef_sc_hd__decap_40_12
XANTENNA__08350__A3 net99 vssd1 vssd1 vccd1 vccd1 sky130_fd_sc_hd__diode_2
X_05570_ FPGA_INST.cell2.CB_1.config_dataA\[23\] FPGA_INST.cell2.CB_1.config_dataA\[22\]
+ vssd1 vssd1 vccd1 vccd1 _01850_ sky130_fd_sc_hd__nand2_1
XFILLER_51_428 vssd1 vssd1 vccd1 vccd1 sky130_fd_sc_hd__fill_1
XTAP_TAPCELL_ROW_63_1167 vssd1 vccd1 sky130_fd_sc_hd__tapvpwrvgnd_1
XANTENNA__07861__A2 _03690_ vssd1 vssd1 vccd1 vccd1 sky130_fd_sc_hd__diode_2
X_07240_ FPGA_INST.cell0.SB0.route_sel\[16\] FPGA_INST.cell0.SB0.route_sel\[17\] vssd1
+ vssd1 vccd1 vccd1 _03502_ sky130_fd_sc_hd__nand2b_1
XFILLER_118_714 vssd1 vssd1 vccd1 vccd1 sky130_fd_sc_hd__fill_1
X_07171_ FPGA_INST.cell3.CB_0.config_dataB\[23\] FPGA_INST.cell3.CB_0.config_dataB\[22\]
+ vssd1 vssd1 vccd1 vccd1 _03435_ sky130_fd_sc_hd__nor2_1
XTAP_TAPCELL_ROW_119_1945 vssd1 vccd1 sky130_fd_sc_hd__tapvpwrvgnd_1
XFILLER_117_202 vccd1 vssd1 vccd1 vssd1 sky130_ef_sc_hd__decap_40_12
X_06122_ net129 _02399_ vssd1 vssd1 vccd1 vccd1 _02402_ sky130_fd_sc_hd__nand2_1
X_06053_ FPGA_INST.cell0.CB_0.config_dataA\[23\] FPGA_INST.cell0.CB_0.config_dataA\[22\]
+ vssd1 vssd1 vccd1 vccd1 _02333_ sky130_fd_sc_hd__or2_1
Xfanout305 net306 vssd1 vssd1 vccd1 vccd1 net305 sky130_fd_sc_hd__buf_2
X_09812_ FPGA_INST.cell1.LE_1B.config_data\[13\] FPGA_INST.cell1.LE_1B.config_data\[12\]
+ net335 vssd1 vssd1 vccd1 vccd1 _00721_ sky130_fd_sc_hd__mux2_1
XFILLER_98_141 vssd1 vssd1 vccd1 vccd1 sky130_fd_sc_hd__fill_1
Xfanout327 net332 vssd1 vssd1 vccd1 vccd1 net327 sky130_fd_sc_hd__clkbuf_4
Xfanout338 net341 vssd1 vssd1 vccd1 vccd1 net338 sky130_fd_sc_hd__clkbuf_4
Xfanout316 net317 vssd1 vssd1 vccd1 vccd1 net316 sky130_fd_sc_hd__clkbuf_4
Xfanout349 net381 vssd1 vssd1 vccd1 vccd1 net349 sky130_fd_sc_hd__buf_2
XANTENNA_fanout379_A net380 vssd1 vssd1 vccd1 vccd1 sky130_fd_sc_hd__diode_2
X_09743_ FPGA_INST.cell1.CB_0.config_dataA\[18\] FPGA_INST.cell1.CB_0.config_dataA\[19\]
+ net223 vssd1 vssd1 vccd1 vccd1 _00652_ sky130_fd_sc_hd__mux2_1
X_06955_ FPGA_INST.cell0.CB_0.config_dataB\[18\] FPGA_INST.cell0.CB_0.config_dataB\[17\]
+ vssd1 vssd1 vccd1 vccd1 _03223_ sky130_fd_sc_hd__or2_1
XFILLER_39_252 vssd1 vssd1 vccd1 vccd1 sky130_fd_sc_hd__fill_2
XANTENNA__08877__A1 _04843_ vssd1 vssd1 vccd1 vccd1 sky130_fd_sc_hd__diode_2
XANTENNA__08877__B2 _04846_ vssd1 vssd1 vccd1 vccd1 sky130_fd_sc_hd__diode_2
X_09674_ FPGA_INST.cell0.SB0.route_sel\[77\] FPGA_INST.cell0.SB0.route_sel\[78\] net182
+ vssd1 vssd1 vccd1 vccd1 _00583_ sky130_fd_sc_hd__mux2_1
X_06886_ FPGA_INST.bus2_0\[0\] _03127_ _03153_ vssd1 vssd1 vccd1 vccd1 _03154_ sky130_fd_sc_hd__a21o_1
X_05906_ net116 _01870_ _02173_ _02177_ vssd1 vssd1 vccd1 vccd1 _02186_ sky130_fd_sc_hd__a31o_1
XFILLER_36_27 vssd1 vssd1 vccd1 vccd1 sky130_fd_sc_hd__fill_1
XFILLER_39_285 vssd1 vssd1 vccd1 vccd1 sky130_fd_sc_hd__fill_2
X_08625_ FPGA_INST.cell3.SB0.route_sel\[58\] FPGA_INST.cell3.SB0.route_sel\[59\] FPGA_INST.cell3.SB0.route_sel\[61\]
+ _01665_ _04833_ vssd1 vssd1 vccd1 vccd1 _04834_ sky130_fd_sc_hd__o221a_1
XFILLER_82_531 vssd1 vssd1 vccd1 vccd1 sky130_fd_sc_hd__fill_1
X_05837_ _01993_ _02039_ vssd1 vssd1 vccd1 vccd1 _02117_ sky130_fd_sc_hd__nor2_1
XFILLER_27_447 vssd1 vssd1 vccd1 vccd1 sky130_fd_sc_hd__fill_1
X_08556_ FPGA_INST.cell3.LE_1B.config_data\[6\] FPGA_INST.cell3.LE_1B.config_data\[7\]
+ _04755_ vssd1 vssd1 vccd1 vccd1 _04767_ sky130_fd_sc_hd__mux2_1
XFILLER_82_586 vssd1 vssd1 vccd1 vccd1 sky130_fd_sc_hd__fill_2
X_07507_ _03411_ _03762_ net140 vssd1 vssd1 vccd1 vccd1 _03763_ sky130_fd_sc_hd__o21ai_1
XANTENNA__07322__X _03583_ vssd1 vssd1 vccd1 vccd1 sky130_fd_sc_hd__diode_2
X_05768_ FPGA_INST.cell2.CB_0.config_dataA\[22\] FPGA_INST.cell2.CB_0.config_dataA\[23\]
+ vssd1 vssd1 vccd1 vccd1 _02048_ sky130_fd_sc_hd__nand2b_1
XTAP_TAPCELL_ROW_25_626 vssd1 vccd1 sky130_fd_sc_hd__tapvpwrvgnd_1
XTAP_TAPCELL_ROW_25_637 vssd1 vccd1 sky130_fd_sc_hd__tapvpwrvgnd_1
X_08487_ FPGA_INST.cell1.CB_0.config_data_inA _04701_ _04702_ FPGA_INST.cell1.CB_1.config_dataB\[19\]
+ vssd1 vssd1 vccd1 vccd1 _04703_ sky130_fd_sc_hd__o211a_1
X_05699_ net384 net166 FPGA_INST.bus2_0\[13\] vssd1 vssd1 vccd1 vccd1 _01979_ sky130_fd_sc_hd__o21bai_1
X_07438_ FPGA_INST.cell3.SB0.route_sel\[50\] FPGA_INST.cell3.SB0.route_sel\[51\] _03692_
+ _03695_ _03672_ vssd1 vssd1 vccd1 vccd1 _03696_ sky130_fd_sc_hd__a41o_1
XFILLER_10_314 vssd1 vssd1 vccd1 vccd1 sky130_fd_sc_hd__fill_1
XFILLER_23_686 vssd1 vssd1 vccd1 vccd1 sky130_fd_sc_hd__fill_2
XFILLER_109_703 vssd1 vssd1 vccd1 vccd1 sky130_fd_sc_hd__fill_4
X_07369_ FPGA_INST.cell3.SB0.route_sel\[32\] FPGA_INST.cell3.SB0.route_sel\[33\] vssd1
+ vssd1 vccd1 vccd1 _03629_ sky130_fd_sc_hd__or2_1
XFILLER_6_307 vssd1 vssd1 vccd1 vccd1 sky130_fd_sc_hd__fill_1
X_09108_ FPGA_INST.cell2.LEI0.config_data\[22\] FPGA_INST.cell2.LEI0.config_data\[23\]
+ net262 vssd1 vssd1 vccd1 vccd1 _00024_ sky130_fd_sc_hd__mux2_1
X_10380_ FPGA_INST.cell3.LE_1B.dff1_out net524 _05246_ vssd1 vssd1 vccd1 vccd1 _01259_
+ sky130_fd_sc_hd__a21bo_1
XANTENNA__07604__A2 _02836_ vssd1 vssd1 vccd1 vccd1 sky130_fd_sc_hd__diode_2
X_09039_ _03443_ _05199_ vssd1 vssd1 vccd1 vccd1 FPGA_INST.bus3_1\[0\] sky130_fd_sc_hd__and2_2
X_12050_ net858 _01396_ net643 vssd1 vssd1 vccd1 vccd1 FPGA_INST.cell2.SB0.route_sel\[90\]
+ sky130_fd_sc_hd__dfstp_1
XFILLER_117_74 vssd1 vssd1 vccd1 vccd1 sky130_fd_sc_hd__fill_1
XANTENNA__07907__A3 FPGA_INST.bus3_1\[15\] vssd1 vssd1 vccd1 vccd1 sky130_fd_sc_hd__diode_2
XANTENNA__11310__SET_B net626 vssd1 vssd1 vccd1 vccd1 sky130_fd_sc_hd__diode_2
X_11001_ net926 _00351_ net710 vssd1 vssd1 vccd1 vccd1 FPGA_INST.cell2.LE_1B.config_data\[7\]
+ sky130_fd_sc_hd__dfrtp_1
Xfanout861 net862 vssd1 vssd1 vccd1 vccd1 net861 sky130_fd_sc_hd__clkbuf_2
XANTENNA__06040__A1 net133 vssd1 vssd1 vccd1 vccd1 sky130_fd_sc_hd__diode_2
Xfanout850 net851 vssd1 vssd1 vccd1 vccd1 net850 sky130_fd_sc_hd__clkbuf_2
Xfanout894 net899 vssd1 vssd1 vccd1 vccd1 net894 sky130_fd_sc_hd__buf_1
XANTENNA__06591__A2 FPGA_INST.bus3_2\[6\] vssd1 vssd1 vccd1 vccd1 sky130_fd_sc_hd__diode_2
Xfanout883 net891 vssd1 vssd1 vccd1 vccd1 net883 sky130_fd_sc_hd__buf_2
XTAP_TAPCELL_ROW_5_351 vssd1 vccd1 sky130_fd_sc_hd__tapvpwrvgnd_1
Xfanout872 net873 vssd1 vssd1 vccd1 vccd1 net872 sky130_fd_sc_hd__clkbuf_2
XANTENNA__08868__B2 _04831_ vssd1 vssd1 vccd1 vccd1 sky130_fd_sc_hd__diode_2
X_11903_ net939 _01249_ net723 vssd1 vssd1 vccd1 vccd1 FPGA_INST.cell3.LE_0B.config_data\[11\]
+ sky130_fd_sc_hd__dfrtp_1
XFILLER_85_391 vssd1 vssd1 vccd1 vccd1 sky130_fd_sc_hd__fill_1
XANTENNA__06879__A0 FPGA_INST.bus2_0\[6\] vssd1 vssd1 vccd1 vccd1 sky130_fd_sc_hd__diode_2
XFILLER_60_203 vssd1 vssd1 vccd1 vccd1 sky130_fd_sc_hd__fill_1
XTAP_TAPCELL_ROW_44_902 vssd1 vccd1 sky130_fd_sc_hd__tapvpwrvgnd_1
X_11834_ net932 _01180_ net716 vssd1 vssd1 vccd1 vccd1 FPGA_INST.cell3.LEI0.config_data\[14\]
+ sky130_fd_sc_hd__dfrtp_1
XTAP_TAPCELL_ROW_103_1724 vssd1 vccd1 sky130_fd_sc_hd__tapvpwrvgnd_1
XANTENNA__07232__X FPGA_INST.bus3_2\[1\] vssd1 vssd1 vccd1 vccd1 sky130_fd_sc_hd__diode_2
XFILLER_60_236 vssd1 vssd1 vccd1 vccd1 sky130_fd_sc_hd__fill_2
X_11765_ net924 _01111_ net708 vssd1 vssd1 vccd1 vccd1 FPGA_INST.io_west_oeb\[14\]
+ sky130_fd_sc_hd__dfrtp_1
X_11696_ net904 _01042_ net688 vssd1 vssd1 vccd1 vccd1 FPGA_INST.cell3.SB0.route_sel\[66\]
+ sky130_fd_sc_hd__dfstp_1
XANTENNA__06646__A3 FPGA_INST.bus3_2\[15\] vssd1 vssd1 vccd1 vccd1 sky130_fd_sc_hd__diode_2
XFILLER_9_101 vssd1 vssd1 vccd1 vccd1 sky130_fd_sc_hd__fill_1
X_10716_ net863 _00066_ net648 vssd1 vssd1 vccd1 vccd1 FPGA_INST.cell2.LE_0A.config_data\[15\]
+ sky130_fd_sc_hd__dfrtp_1
X_10647_ FPGA_INST.cell3.LE_1B.config_data\[16\] FPGA_INST.cell3.LE_1B.edge_mode net279
+ vssd1 vssd1 vccd1 vccd1 _01526_ sky130_fd_sc_hd__mux2_1
XFILLER_127_511 vssd1 vssd1 vccd1 vccd1 sky130_fd_sc_hd__fill_1
X_10578_ FPGA_INST.cell3.CB_0.config_dataA\[23\] FPGA_INST.cell3.CB_0.config_dataA\[22\]
+ net371 vssd1 vssd1 vccd1 vccd1 _01457_ sky130_fd_sc_hd__mux2_1
XFILLER_130_709 vssd1 vssd1 vccd1 vccd1 sky130_fd_sc_hd__fill_1
XANTENNA__08005__C1 net155 vssd1 vssd1 vccd1 vccd1 sky130_fd_sc_hd__diode_2
XFILLER_123_783 vssd1 vssd1 vccd1 vccd1 sky130_fd_sc_hd__fill_1
XTAP_TAPCELL_ROW_114_1875 vssd1 vccd1 sky130_fd_sc_hd__tapvpwrvgnd_1
XANTENNA__08049__A2_N _03652_ vssd1 vssd1 vccd1 vccd1 sky130_fd_sc_hd__diode_2
X_12179_ net909 _01525_ net692 vssd1 vssd1 vccd1 vccd1 FPGA_INST.cell3.LE_1B.config_data\[16\]
+ sky130_fd_sc_hd__dfrtp_1
XANTENNA__08020__A2 _03854_ vssd1 vssd1 vccd1 vccd1 sky130_fd_sc_hd__diode_2
XANTENNA__06582__A2 _02836_ vssd1 vssd1 vccd1 vccd1 sky130_fd_sc_hd__diode_2
X_06740_ FPGA_INST.cell2.CB_1.config_dataB\[7\] _03009_ _03010_ _03013_ vssd1 vssd1
+ vccd1 vccd1 _03014_ sky130_fd_sc_hd__a22o_1
XFILLER_76_380 vssd1 vssd1 vccd1 vccd1 sky130_fd_sc_hd__fill_2
XFILLER_64_531 vssd1 vssd1 vccd1 vccd1 sky130_fd_sc_hd__fill_1
X_06671_ _02940_ _02945_ _02946_ vssd1 vssd1 vccd1 vccd1 _02947_ sky130_fd_sc_hd__and3_1
X_08410_ FPGA_INST.cell0.CB_1.config_dataB\[18\] FPGA_INST.cell0.CB_1.config_dataB\[17\]
+ FPGA_INST.cell0.CB_1.config_dataB\[19\] _04608_ vssd1 vssd1 vccd1 vccd1 _04632_
+ sky130_fd_sc_hd__or4bb_1
X_05622_ _01890_ _01891_ _01892_ _01901_ vssd1 vssd1 vccd1 vccd1 _01902_ sky130_fd_sc_hd__a211o_1
XFILLER_51_225 vssd1 vssd1 vccd1 vccd1 sky130_fd_sc_hd__fill_2
X_09390_ FPGA_INST.cell2.CB_0.config_dataB\[8\] FPGA_INST.cell2.CB_0.config_dataB\[9\]
+ net252 vssd1 vssd1 vccd1 vccd1 _00303_ sky130_fd_sc_hd__mux2_1
XFILLER_36_299 vssd1 vssd1 vccd1 vccd1 sky130_fd_sc_hd__fill_1
XANTENNA__08087__A2 _03854_ vssd1 vssd1 vccd1 vccd1 sky130_fd_sc_hd__diode_2
X_08341_ _03639_ _04547_ _04548_ _03604_ _01757_ vssd1 vssd1 vccd1 vccd1 _04563_ sky130_fd_sc_hd__a221o_1
XFILLER_51_269 vssd1 vssd1 vccd1 vccd1 sky130_fd_sc_hd__fill_2
XFILLER_32_450 vssd1 vssd1 vccd1 vccd1 sky130_fd_sc_hd__fill_4
X_05553_ net117 _01814_ _01816_ FPGA_INST.cell0.SB0.route_sel\[113\] FPGA_INST.cell0.SB0.route_sel\[112\]
+ vssd1 vssd1 vccd1 vccd1 _01833_ sky130_fd_sc_hd__a32o_1
X_05484_ FPGA_INST.cell3.CB_0.config_dataA\[7\] vssd1 vssd1 vccd1 vccd1 _01766_ sky130_fd_sc_hd__inv_2
X_08272_ net114 net119 net110 net98 FPGA_INST.cell0.LEI0.config_data\[42\] FPGA_INST.cell0.LEI0.config_data\[43\]
+ vssd1 vssd1 vccd1 vccd1 _04496_ sky130_fd_sc_hd__mux4_1
X_07223_ FPGA_INST.cell3.CB_0.config_dataA\[24\] FPGA_INST.cell3.CB_0.config_dataA\[21\]
+ FPGA_INST.cell3.CB_0.config_dataA\[20\] vssd1 vssd1 vccd1 vccd1 _03486_ sky130_fd_sc_hd__or3b_2
XFILLER_22_29 vssd1 vssd1 vccd1 vccd1 sky130_fd_sc_hd__fill_8
X_07154_ FPGA_INST.cell1.SB0.route_sel\[0\] FPGA_INST.cell1.SB0.route_sel\[1\] _03416_
+ _03417_ vssd1 vssd1 vccd1 vccd1 _03418_ sky130_fd_sc_hd__a211o_1
XANTENNA__10155__S net273 vssd1 vssd1 vccd1 vccd1 sky130_fd_sc_hd__diode_2
XTAP_TAPCELL_ROW_76_1347 vssd1 vccd1 sky130_fd_sc_hd__tapvpwrvgnd_1
X_07085_ net428 _02392_ _03350_ FPGA_INST.cell0.CB_0.config_dataA\[16\] vssd1 vssd1
+ vccd1 vccd1 _03351_ sky130_fd_sc_hd__o211a_1
X_06105_ net385 net158 FPGA_INST.bus2_0\[2\] vssd1 vssd1 vccd1 vccd1 _02385_ sky130_fd_sc_hd__o21bai_1
X_06036_ _01991_ _02198_ FPGA_INST.bus3_2\[5\] vssd1 vssd1 vccd1 vccd1 _02316_ sky130_fd_sc_hd__o21a_1
XFILLER_114_750 vssd1 vssd1 vccd1 vccd1 sky130_fd_sc_hd__fill_4
XFILLER_87_601 vssd1 vssd1 vccd1 vccd1 sky130_fd_sc_hd__fill_1
Xfanout113 FPGA_INST.cell0.CB_1.le_outA vssd1 vssd1 vccd1 vccd1 net113 sky130_fd_sc_hd__buf_2
Xfanout102 net103 vssd1 vssd1 vccd1 vccd1 net102 sky130_fd_sc_hd__clkbuf_2
Xfanout146 net147 vssd1 vssd1 vccd1 vccd1 net146 sky130_fd_sc_hd__buf_2
XANTENNA__07972__B _03889_ vssd1 vssd1 vccd1 vccd1 sky130_fd_sc_hd__diode_2
Xfanout124 net125 vssd1 vssd1 vccd1 vccd1 net124 sky130_fd_sc_hd__buf_1
Xfanout135 _01784_ vssd1 vssd1 vccd1 vccd1 net135 sky130_fd_sc_hd__buf_2
XANTENNA__05773__A net240 vssd1 vssd1 vccd1 vccd1 sky130_fd_sc_hd__diode_2
XANTENNA_input1_A gpio_in[0] vssd1 vssd1 vccd1 vccd1 sky130_fd_sc_hd__diode_2
XANTENNA_fanout284_X net284 vssd1 vssd1 vccd1 vccd1 sky130_fd_sc_hd__diode_2
XFILLER_113_293 vssd1 vssd1 vccd1 vccd1 sky130_fd_sc_hd__fill_2
X_07987_ net151 net144 net149 net142 FPGA_INST.cell1.LEI0.config_data\[36\] FPGA_INST.cell1.LEI0.config_data\[37\]
+ vssd1 vssd1 vccd1 vccd1 _04215_ sky130_fd_sc_hd__mux4_1
Xfanout157 _02337_ vssd1 vssd1 vccd1 vccd1 net157 sky130_fd_sc_hd__buf_2
Xfanout179 net180 vssd1 vssd1 vccd1 vccd1 net179 sky130_fd_sc_hd__clkbuf_4
Xfanout168 _01920_ vssd1 vssd1 vccd1 vccd1 net168 sky130_fd_sc_hd__buf_2
X_09726_ FPGA_INST.cell1.CB_0.config_dataA\[2\] net471 net344 vssd1 vssd1 vccd1 vccd1
+ _00635_ sky130_fd_sc_hd__mux2_1
XTAP_TAPCELL_ROW_2_310 vssd1 vccd1 sky130_fd_sc_hd__tapvpwrvgnd_1
X_06938_ net415 _02030_ _03205_ net414 vssd1 vssd1 vccd1 vccd1 _03206_ sky130_fd_sc_hd__o211a_1
XFILLER_103_54 vssd1 vssd1 vccd1 vccd1 sky130_fd_sc_hd__fill_2
XANTENNA_fanout830_A net831 vssd1 vssd1 vccd1 vccd1 sky130_fd_sc_hd__diode_2
X_06869_ FPGA_INST.bus2_0\[8\] FPGA_INST.bus2_0\[9\] FPGA_INST.bus2_0\[10\] FPGA_INST.bus2_0\[11\]
+ net424 net423 vssd1 vssd1 vccd1 vccd1 _03137_ sky130_fd_sc_hd__mux4_1
X_09657_ FPGA_INST.cell0.SB0.route_sel\[60\] FPGA_INST.cell0.SB0.route_sel\[61\] net180
+ vssd1 vssd1 vccd1 vccd1 _00566_ sky130_fd_sc_hd__mux2_1
X_09588_ FPGA_INST.cell1.CB_1.config_dataB\[17\] FPGA_INST.cell1.CB_1.config_dataB\[16\]
+ net334 vssd1 vssd1 vccd1 vccd1 _00497_ sky130_fd_sc_hd__mux2_1
XTAP_TAPCELL_ROW_87_1498 vssd1 vccd1 sky130_fd_sc_hd__tapvpwrvgnd_1
XFILLER_82_394 vccd1 vssd1 vccd1 vssd1 sky130_ef_sc_hd__decap_40_12
X_08608_ FPGA_INST.cell3.SB0.route_sel\[22\] FPGA_INST.cell3.SB0.route_sel\[23\] vssd1
+ vssd1 vccd1 vccd1 _04817_ sky130_fd_sc_hd__nand2b_1
X_08539_ FPGA_INST.cell3.CB_1.config_dataB\[8\] FPGA_INST.cell3.CB_1.config_dataB\[7\]
+ FPGA_INST.cell3.CB_1.config_dataB\[6\] FPGA_INST.cell3.CB_1.config_dataB\[5\] vssd1
+ vssd1 vccd1 vccd1 _04750_ sky130_fd_sc_hd__or4b_1
XANTENNA__08078__A2 FPGA_INST.bus3_1\[2\] vssd1 vssd1 vccd1 vccd1 sky130_fd_sc_hd__diode_2
XFILLER_70_589 vssd1 vssd1 vccd1 vccd1 sky130_fd_sc_hd__fill_1
X_11550_ net770 _00900_ net555 vssd1 vssd1 vccd1 vccd1 FPGA_INST.cell0.CB_0.config_dataA\[19\]
+ sky130_fd_sc_hd__dfstp_1
XFILLER_23_461 vssd1 vssd1 vccd1 vccd1 sky130_fd_sc_hd__fill_1
XFILLER_7_605 vssd1 vssd1 vccd1 vccd1 sky130_fd_sc_hd__fill_1
X_10501_ FPGA_INST.cell2.SB0.route_sel\[73\] FPGA_INST.cell2.SB0.route_sel\[74\] net260
+ vssd1 vssd1 vccd1 vccd1 _01380_ sky130_fd_sc_hd__mux2_1
X_11481_ net759 _00831_ net544 vssd1 vssd1 vccd1 vccd1 FPGA_INST.cell0.LE_1A.config_data\[8\]
+ sky130_fd_sc_hd__dfrtp_1
XFILLER_109_566 vssd1 vssd1 vccd1 vccd1 sky130_fd_sc_hd__fill_1
X_10432_ FPGA_INST.cell2.SB0.route_sel\[4\] FPGA_INST.cell2.SB0.route_sel\[5\] net197
+ vssd1 vssd1 vccd1 vccd1 _01311_ sky130_fd_sc_hd__mux2_1
X_10363_ FPGA_INST.cell3.LE_0B.config_data\[4\] FPGA_INST.cell3.LE_0B.config_data\[5\]
+ net293 vssd1 vssd1 vccd1 vccd1 _01243_ sky130_fd_sc_hd__mux2_1
X_12102_ net930 _01448_ net714 vssd1 vssd1 vccd1 vccd1 FPGA_INST.cell3.CB_0.config_dataA\[14\]
+ sky130_fd_sc_hd__dfstp_1
XANTENNA__09854__S net173 vssd1 vssd1 vccd1 vccd1 sky130_fd_sc_hd__diode_2
X_10294_ FPGA_INST.cell3.LEI0.config_data\[8\] FPGA_INST.cell3.LEI0.config_data\[9\]
+ net303 vssd1 vssd1 vccd1 vccd1 _01175_ sky130_fd_sc_hd__mux2_1
XFILLER_2_365 vssd1 vssd1 vccd1 vccd1 sky130_fd_sc_hd__fill_1
X_12033_ net878 _01379_ net663 vssd1 vssd1 vccd1 vccd1 FPGA_INST.cell2.SB0.route_sel\[73\]
+ sky130_fd_sc_hd__dfstp_1
XFILLER_78_645 vssd1 vssd1 vccd1 vccd1 sky130_fd_sc_hd__fill_4
XFILLER_77_111 vssd1 vssd1 vccd1 vccd1 sky130_fd_sc_hd__fill_1
XFILLER_77_100 vssd1 vssd1 vccd1 vccd1 sky130_fd_sc_hd__fill_4
XFILLER_120_753 vssd1 vssd1 vccd1 vccd1 sky130_fd_sc_hd__fill_2
XANTENNA__07227__X _03490_ vssd1 vssd1 vccd1 vccd1 sky130_fd_sc_hd__diode_2
XFILLER_93_604 vssd1 vssd1 vccd1 vccd1 sky130_fd_sc_hd__fill_1
XTAP_TAPCELL_ROW_129_2093 vssd1 vccd1 sky130_fd_sc_hd__tapvpwrvgnd_1
XTAP_TAPCELL_ROW_129_2082 vssd1 vccd1 sky130_fd_sc_hd__tapvpwrvgnd_1
Xfanout691 net695 vssd1 vssd1 vccd1 vccd1 net691 sky130_fd_sc_hd__clkbuf_2
Xfanout680 net682 vssd1 vssd1 vccd1 vccd1 net680 sky130_fd_sc_hd__clkbuf_4
XFILLER_46_586 vssd1 vssd1 vccd1 vccd1 sky130_fd_sc_hd__fill_2
XFILLER_18_299 vssd1 vssd1 vccd1 vccd1 sky130_fd_sc_hd__fill_1
XFILLER_33_225 vssd1 vssd1 vccd1 vccd1 sky130_fd_sc_hd__fill_1
XFILLER_33_236 vssd1 vssd1 vccd1 vccd1 sky130_fd_sc_hd__fill_1
X_11817_ net873 _01163_ net657 vssd1 vssd1 vccd1 vccd1 net42 sky130_fd_sc_hd__dfrtp_1
X_11748_ net895 _01094_ net679 vssd1 vssd1 vccd1 vccd1 FPGA_INST.cell3.SB0.route_sel\[118\]
+ sky130_fd_sc_hd__dfstp_1
XTAP_TAPCELL_ROW_60_1126 vssd1 vccd1 sky130_fd_sc_hd__tapvpwrvgnd_1
XANTENNA__06019__A net165 vssd1 vssd1 vccd1 vccd1 sky130_fd_sc_hd__diode_2
X_11679_ net905 _01025_ net689 vssd1 vssd1 vccd1 vccd1 FPGA_INST.cell3.SB0.route_sel\[49\]
+ sky130_fd_sc_hd__dfstp_1
XANTENNA__08505__Y FPGA_INST.bus3_1\[15\] vssd1 vssd1 vccd1 vccd1 sky130_fd_sc_hd__diode_2
XTAP_TAPCELL_ROW_116_1904 vssd1 vccd1 sky130_fd_sc_hd__tapvpwrvgnd_1
XANTENNA__10936__SET_B net636 vssd1 vssd1 vccd1 vccd1 sky130_fd_sc_hd__diode_2
XFILLER_115_503 vssd1 vssd1 vccd1 vccd1 sky130_fd_sc_hd__fill_1
XFILLER_52_3 vssd1 vssd1 vccd1 vccd1 sky130_fd_sc_hd__fill_8
XFILLER_6_693 vssd1 vssd1 vccd1 vccd1 sky130_fd_sc_hd__fill_1
XTAP_TAPCELL_ROW_58_1099 vssd1 vccd1 sky130_fd_sc_hd__tapvpwrvgnd_1
XTAP_TAPCELL_ROW_58_1088 vssd1 vccd1 sky130_fd_sc_hd__tapvpwrvgnd_1
XFILLER_123_591 vssd1 vssd1 vccd1 vccd1 sky130_fd_sc_hd__fill_1
X_08890_ net93 net88 FPGA_INST.cell3.CB_1.le_outA net80 FPGA_INST.cell3.LEI0.config_data\[39\]
+ FPGA_INST.cell3.LEI0.config_data\[40\] vssd1 vssd1 vccd1 vccd1 _05097_ sky130_fd_sc_hd__mux4_1
X_07910_ _04137_ vssd1 vssd1 vccd1 vccd1 _04138_ sky130_fd_sc_hd__inv_2
XFILLER_110_230 vssd1 vssd1 vccd1 vccd1 sky130_fd_sc_hd__fill_1
XTAP_TAPCELL_ROW_71_1277 vssd1 vccd1 sky130_fd_sc_hd__tapvpwrvgnd_1
X_07841_ net123 _02293_ _02284_ vssd1 vssd1 vccd1 vccd1 _04074_ sky130_fd_sc_hd__mux2_1
XFILLER_29_509 vssd1 vssd1 vccd1 vccd1 sky130_fd_sc_hd__fill_1
XFILLER_96_475 vssd1 vssd1 vccd1 vccd1 sky130_fd_sc_hd__fill_1
X_07772_ _03983_ _04020_ _04021_ net366 vssd1 vssd1 vccd1 vccd1 _04022_ sky130_fd_sc_hd__a31o_1
X_09511_ FPGA_INST.cell1.LE_0A.config_data\[7\] FPGA_INST.cell1.LE_0A.config_data\[6\]
+ net346 vssd1 vssd1 vccd1 vccd1 _00422_ sky130_fd_sc_hd__mux2_1
X_06723_ net518 _02832_ vssd1 vssd1 vccd1 vccd1 _02997_ sky130_fd_sc_hd__nand2_1
XFILLER_49_391 vssd1 vssd1 vccd1 vccd1 sky130_fd_sc_hd__fill_1
XFILLER_83_158 vssd1 vssd1 vccd1 vccd1 sky130_fd_sc_hd__fill_2
X_09442_ FPGA_INST.cell2.LE_1B.config_data\[11\] FPGA_INST.cell2.LE_1B.config_data\[10\]
+ net374 vssd1 vssd1 vccd1 vccd1 _00355_ sky130_fd_sc_hd__mux2_1
X_06654_ net475 _02772_ _02929_ net474 vssd1 vssd1 vccd1 vccd1 _02930_ sky130_fd_sc_hd__o211a_1
XFILLER_37_597 vssd1 vssd1 vccd1 vccd1 sky130_fd_sc_hd__fill_1
X_06585_ _02860_ vssd1 vssd1 vccd1 vccd1 _02861_ sky130_fd_sc_hd__inv_2
X_05605_ _01875_ _01882_ _01884_ net322 vssd1 vssd1 vccd1 vccd1 _01885_ sky130_fd_sc_hd__a211o_2
X_09373_ FPGA_INST.cell2.CB_0.config_dataA\[17\] net499 net351 vssd1 vssd1 vccd1 vccd1
+ _00286_ sky130_fd_sc_hd__mux2_1
X_08324_ net448 _03997_ _04545_ net447 vssd1 vssd1 vccd1 vccd1 _04546_ sky130_fd_sc_hd__o211a_1
XANTENNA_fanout244_A net268 vssd1 vssd1 vccd1 vccd1 sky130_fd_sc_hd__diode_2
XANTENNA__07032__B _02350_ vssd1 vssd1 vccd1 vccd1 sky130_fd_sc_hd__diode_2
X_05536_ FPGA_INST.cell0.CB_0.config_dataA\[23\] FPGA_INST.cell0.CB_0.config_dataA\[22\]
+ vssd1 vssd1 vccd1 vccd1 _01816_ sky130_fd_sc_hd__and2_1
XTAP_TAPCELL_ROW_35_776 vssd1 vccd1 sky130_fd_sc_hd__tapvpwrvgnd_1
XANTENNA__07967__B _03728_ vssd1 vssd1 vccd1 vccd1 sky130_fd_sc_hd__diode_2
X_08255_ _03923_ _03959_ _03997_ _04041_ net403 net402 vssd1 vssd1 vccd1 vccd1 _04479_
+ sky130_fd_sc_hd__mux4_1
X_05467_ FPGA_INST.cell0.CB_0.config_dataB\[17\] vssd1 vssd1 vccd1 vccd1 _01749_ sky130_fd_sc_hd__inv_2
XFILLER_20_475 vssd1 vssd1 vccd1 vccd1 sky130_fd_sc_hd__fill_1
X_05398_ FPGA_INST.cell3.SB0.route_sel\[42\] vssd1 vssd1 vccd1 vccd1 _01680_ sky130_fd_sc_hd__inv_2
X_07206_ FPGA_INST.cell1.CB_1.config_dataA\[23\] FPGA_INST.cell1.CB_1.config_dataA\[22\]
+ _03468_ vssd1 vssd1 vccd1 vccd1 _03469_ sky130_fd_sc_hd__or3_1
X_08186_ FPGA_INST.cell0.CB_1.config_dataA\[4\] _04382_ _04398_ _04409_ vssd1 vssd1
+ vccd1 vccd1 _04410_ sky130_fd_sc_hd__a31o_2
XFILLER_118_374 vssd1 vssd1 vccd1 vccd1 sky130_fd_sc_hd__fill_2
XFILLER_106_525 vssd1 vssd1 vccd1 vccd1 sky130_fd_sc_hd__fill_1
X_07137_ _03398_ _03400_ vssd1 vssd1 vccd1 vccd1 _03401_ sky130_fd_sc_hd__nand2_1
XANTENNA__08232__A2 _03997_ vssd1 vssd1 vccd1 vccd1 sky130_fd_sc_hd__diode_2
XANTENNA__06243__A1 _02131_ vssd1 vssd1 vccd1 vccd1 sky130_fd_sc_hd__diode_2
XANTENNA__06794__A2 FPGA_INST.bus3_2\[6\] vssd1 vssd1 vccd1 vccd1 sky130_fd_sc_hd__diode_2
XANTENNA__08431__X FPGA_INST.bus1_0\[15\] vssd1 vssd1 vccd1 vccd1 sky130_fd_sc_hd__diode_2
XANTENNA__06243__B2 _02168_ vssd1 vssd1 vccd1 vccd1 sky130_fd_sc_hd__diode_2
X_07068_ net430 _02030_ _03333_ net429 vssd1 vssd1 vccd1 vccd1 _03334_ sky130_fd_sc_hd__o211a_1
XFILLER_121_539 vccd1 vssd1 vccd1 vssd1 sky130_ef_sc_hd__decap_40_12
XFILLER_102_720 vccd1 vssd1 vccd1 vssd1 sky130_ef_sc_hd__decap_40_12
X_06019_ net165 net159 vssd1 vssd1 vccd1 vccd1 _02299_ sky130_fd_sc_hd__nor2_1
XFILLER_87_431 vssd1 vssd1 vccd1 vccd1 sky130_fd_sc_hd__fill_1
XANTENNA_input4_X net4 vssd1 vssd1 vccd1 vccd1 sky130_fd_sc_hd__diode_2
XANTENNA__07047__X _03313_ vssd1 vssd1 vccd1 vccd1 sky130_fd_sc_hd__diode_2
XFILLER_102_797 vssd1 vssd1 vccd1 vccd1 sky130_fd_sc_hd__fill_2
XTAP_TAPCELL_ROW_89_1527 vssd1 vccd1 sky130_fd_sc_hd__tapvpwrvgnd_1
XFILLER_75_615 vssd1 vssd1 vccd1 vccd1 sky130_fd_sc_hd__fill_1
XFILLER_47_317 vssd1 vssd1 vccd1 vccd1 sky130_fd_sc_hd__fill_4
XFILLER_47_306 vssd1 vssd1 vccd1 vccd1 sky130_fd_sc_hd__fill_1
XFILLER_75_659 vssd1 vssd1 vccd1 vccd1 sky130_fd_sc_hd__fill_4
XANTENNA__05790__X _02070_ vssd1 vssd1 vccd1 vccd1 sky130_fd_sc_hd__diode_2
XFILLER_28_531 vssd1 vssd1 vccd1 vccd1 sky130_fd_sc_hd__fill_1
X_10981_ net888 _00331_ net672 vssd1 vssd1 vccd1 vccd1 FPGA_INST.cell2.CB_1.config_dataA\[12\]
+ sky130_fd_sc_hd__dfstp_2
X_09709_ FPGA_INST.cell0.SB0.route_sel\[112\] FPGA_INST.cell0.SB0.route_sel\[113\]
+ net197 vssd1 vssd1 vccd1 vccd1 _00618_ sky130_fd_sc_hd__mux2_1
XFILLER_15_225 vssd1 vssd1 vccd1 vccd1 sky130_fd_sc_hd__fill_1
XFILLER_43_545 vssd1 vssd1 vccd1 vccd1 sky130_fd_sc_hd__fill_1
XFILLER_130_85 vssd1 vssd1 vccd1 vccd1 sky130_fd_sc_hd__fill_1
XFILLER_90_23 vssd1 vssd1 vccd1 vccd1 sky130_fd_sc_hd__fill_4
X_11602_ net767 _00952_ net552 vssd1 vssd1 vccd1 vccd1 FPGA_INST.cell0.CB_1.config_dataA\[21\]
+ sky130_fd_sc_hd__dfstp_1
XFILLER_11_420 vssd1 vssd1 vccd1 vccd1 sky130_fd_sc_hd__fill_2
XTAP_TAPCELL_ROW_13_459 vssd1 vccd1 sky130_fd_sc_hd__tapvpwrvgnd_1
X_11533_ net756 _00883_ net541 vssd1 vssd1 vccd1 vccd1 FPGA_INST.cell0.CB_0.config_dataA\[2\]
+ sky130_fd_sc_hd__dfstp_1
X_11464_ net771 _00814_ net556 vssd1 vssd1 vccd1 vccd1 FPGA_INST.cell0.LE_0B.config_data\[13\]
+ sky130_fd_sc_hd__dfrtp_1
XFILLER_11_486 vssd1 vssd1 vccd1 vccd1 sky130_fd_sc_hd__fill_1
XFILLER_23_83 vssd1 vssd1 vccd1 vccd1 sky130_fd_sc_hd__fill_1
X_10415_ FPGA_INST.cell3.CB_1.config_dataB\[13\] FPGA_INST.cell3.CB_1.config_dataB\[12\]
+ net372 vssd1 vssd1 vccd1 vccd1 _01294_ sky130_fd_sc_hd__mux2_1
XFILLER_124_311 vssd1 vssd1 vccd1 vccd1 sky130_fd_sc_hd__fill_1
XANTENNA__08223__A2 _03504_ vssd1 vssd1 vccd1 vccd1 sky130_fd_sc_hd__diode_2
X_11395_ net743 _00745_ net528 vssd1 vssd1 vccd1 vccd1 FPGA_INST.cell0.LEI0.config_data\[16\]
+ sky130_fd_sc_hd__dfrtp_1
XANTENNA__07982__A1 _03973_ vssd1 vssd1 vccd1 vccd1 sky130_fd_sc_hd__diode_2
X_10346_ FPGA_INST.cell3.LE_0A.config_data\[10\] FPGA_INST.cell3.LE_0A.config_data\[11\]
+ net292 vssd1 vssd1 vccd1 vccd1 _01227_ sky130_fd_sc_hd__mux2_1
XANTENNA__06785__A2 _02810_ vssd1 vssd1 vccd1 vccd1 sky130_fd_sc_hd__diode_2
XTAP_TAPCELL_ROW_111_1834 vssd1 vccd1 sky130_fd_sc_hd__tapvpwrvgnd_1
X_10277_ net36 net37 net253 vssd1 vssd1 vccd1 vccd1 _01158_ sky130_fd_sc_hd__mux2_1
XFILLER_31_8 vssd1 vssd1 vccd1 vccd1 sky130_fd_sc_hd__fill_2
XFILLER_78_442 vssd1 vssd1 vccd1 vccd1 sky130_fd_sc_hd__fill_1
XFILLER_24_7 vssd1 vssd1 vccd1 vccd1 sky130_fd_sc_hd__fill_1
X_12016_ net776 _01362_ net562 vssd1 vssd1 vccd1 vccd1 FPGA_INST.cell2.SB0.route_sel\[56\]
+ sky130_fd_sc_hd__dfstp_1
XFILLER_93_401 vssd1 vssd1 vccd1 vccd1 sky130_fd_sc_hd__fill_2
XANTENNA__07734__A1 _03526_ vssd1 vssd1 vccd1 vccd1 sky130_fd_sc_hd__diode_2
XFILLER_93_489 vssd1 vssd1 vccd1 vccd1 sky130_fd_sc_hd__fill_2
XFILLER_65_169 vssd1 vssd1 vccd1 vccd1 sky130_fd_sc_hd__fill_4
XTAP_TAPCELL_ROW_122_1985 vssd1 vccd1 sky130_fd_sc_hd__tapvpwrvgnd_1
XFILLER_21_206 vssd1 vssd1 vccd1 vccd1 sky130_fd_sc_hd__fill_1
XTAP_TAPCELL_ROW_32_724 vssd1 vccd1 sky130_fd_sc_hd__tapvpwrvgnd_1
XFILLER_34_578 vssd1 vssd1 vccd1 vccd1 sky130_fd_sc_hd__fill_1
XTAP_TAPCELL_ROW_122_1996 vssd1 vccd1 sky130_fd_sc_hd__tapvpwrvgnd_1
X_06370_ _02646_ _02647_ _01539_ vssd1 vssd1 vccd1 vccd1 _02648_ sky130_fd_sc_hd__mux2_1
XANTENNA__12012__SET_B net563 vssd1 vssd1 vccd1 vccd1 sky130_fd_sc_hd__diode_2
XTAP_TAPCELL_ROW_32_735 vssd1 vccd1 sky130_fd_sc_hd__tapvpwrvgnd_1
X_05321_ FPGA_INST.cell1.SB0.route_sel\[122\] vssd1 vssd1 vccd1 vccd1 _01603_ sky130_fd_sc_hd__inv_2
XFILLER_9_85 vssd1 vssd1 vccd1 vccd1 sky130_fd_sc_hd__fill_8
X_08040_ net459 net460 vssd1 vssd1 vccd1 vccd1 _04266_ sky130_fd_sc_hd__nand2b_1
X_05252_ FPGA_INST.cell2.CB_0.config_dataA\[14\] vssd1 vssd1 vccd1 vccd1 _01534_ sky130_fd_sc_hd__inv_2
XFILLER_30_795 vssd1 vssd1 vccd1 vccd1 sky130_fd_sc_hd__fill_4
XFILLER_127_193 vssd1 vssd1 vccd1 vccd1 sky130_fd_sc_hd__fill_2
XTAP_TAPCELL_ROW_73_1306 vssd1 vccd1 sky130_fd_sc_hd__tapvpwrvgnd_1
X_09991_ FPGA_INST.config_en_q net739 _05237_ vssd1 vssd1 vccd1 vccd1 _05239_ sky130_fd_sc_hd__and3_1
XFILLER_88_206 vssd1 vssd1 vccd1 vccd1 sky130_fd_sc_hd__fill_4
X_08942_ FPGA_INST.cell1.SB0.route_sel\[84\] _01642_ FPGA_INST.cell1.SB0.route_sel\[80\]
+ FPGA_INST.cell1.SB0.route_sel\[81\] _05134_ vssd1 vssd1 vccd1 vccd1 _05135_ sky130_fd_sc_hd__o221a_1
XANTENNA__06776__A2 _02836_ vssd1 vssd1 vccd1 vccd1 sky130_fd_sc_hd__diode_2
XFILLER_130_369 vssd1 vssd1 vccd1 vccd1 sky130_fd_sc_hd__fill_1
XFILLER_69_453 vssd1 vssd1 vccd1 vccd1 sky130_fd_sc_hd__fill_1
XFILLER_111_561 vssd1 vssd1 vccd1 vccd1 sky130_fd_sc_hd__fill_4
X_08873_ net18 _05072_ _05074_ net19 FPGA_INST.cell3.CB_0.config_dataB\[17\] vssd1
+ vssd1 vccd1 vccd1 _05080_ sky130_fd_sc_hd__a221o_1
XANTENNA_fanout194_A net202 vssd1 vssd1 vccd1 vccd1 sky130_fd_sc_hd__diode_2
XFILLER_56_136 vssd1 vssd1 vccd1 vccd1 sky130_fd_sc_hd__fill_1
X_07824_ net485 net486 _01954_ _01966_ vssd1 vssd1 vccd1 vccd1 _04065_ sky130_fd_sc_hd__a31o_1
X_07755_ FPGA_INST.bus3_1\[14\] net146 _03992_ vssd1 vssd1 vccd1 vccd1 _04005_ sky130_fd_sc_hd__mux2_1
XANTENNA_fanout361_A net362 vssd1 vssd1 vccd1 vccd1 sky130_fd_sc_hd__diode_2
XFILLER_44_309 vssd1 vssd1 vccd1 vccd1 sky130_fd_sc_hd__fill_4
X_07686_ FPGA_INST.cell3.SB0.route_sel\[98\] FPGA_INST.cell3.SB0.route_sel\[99\] _03934_
+ _03937_ _03910_ vssd1 vssd1 vccd1 vccd1 _03938_ sky130_fd_sc_hd__a41o_1
X_06706_ _02978_ _02979_ FPGA_INST.cell2.CB_1.config_dataB\[2\] vssd1 vssd1 vccd1
+ vccd1 _02980_ sky130_fd_sc_hd__mux2_1
XTAP_TAPCELL_ROW_84_1457 vssd1 vccd1 sky130_fd_sc_hd__tapvpwrvgnd_1
X_09425_ FPGA_INST.cell2.CB_1.config_dataA\[18\] FPGA_INST.cell2.CB_1.config_dataA\[19\]
+ net249 vssd1 vssd1 vccd1 vccd1 _00338_ sky130_fd_sc_hd__mux2_1
X_06637_ _02879_ _02912_ _02849_ vssd1 vssd1 vccd1 vccd1 _02913_ sky130_fd_sc_hd__mux2_1
XANTENNA_fanout626_A net627 vssd1 vssd1 vccd1 vccd1 sky130_fd_sc_hd__diode_2
X_06568_ _02785_ _02840_ _02843_ _02781_ FPGA_INST.cell2.CB_1.config_dataA\[7\] vssd1
+ vssd1 vccd1 vccd1 _02844_ sky130_fd_sc_hd__a221o_1
X_09356_ FPGA_INST.cell2.CB_0.config_dataA\[0\] FPGA_INST.cell2.CB_0.config_data_inA
+ net357 vssd1 vssd1 vccd1 vccd1 _00269_ sky130_fd_sc_hd__mux2_1
X_09287_ FPGA_INST.cell1.SB0.route_sel\[58\] FPGA_INST.cell1.SB0.route_sel\[59\] net208
+ vssd1 vssd1 vccd1 vccd1 _00200_ sky130_fd_sc_hd__mux2_1
X_05519_ FPGA_INST.bus3_2\[9\] vssd1 vssd1 vccd1 vccd1 _01801_ sky130_fd_sc_hd__inv_2
X_08307_ net446 _03558_ vssd1 vssd1 vccd1 vccd1 _04529_ sky130_fd_sc_hd__nand2_1
X_06499_ net236 _02365_ _02372_ _02774_ vssd1 vssd1 vccd1 vccd1 _02775_ sky130_fd_sc_hd__and4_2
XFILLER_121_6 vccd1 vssd1 vccd1 vssd1 sky130_ef_sc_hd__decap_40_12
X_08238_ FPGA_INST.bus1_0\[8\] _04444_ _04461_ net405 FPGA_INST.cell0.CB_1.config_dataA\[12\]
+ vssd1 vssd1 vccd1 vccd1 _04462_ sky130_fd_sc_hd__a221o_1
XTAP_TAPCELL_ROW_10_418 vssd1 vccd1 sky130_fd_sc_hd__tapvpwrvgnd_1
XTAP_TAPCELL_ROW_10_429 vssd1 vccd1 sky130_fd_sc_hd__tapvpwrvgnd_1
XFILLER_20_261 vssd1 vssd1 vccd1 vccd1 sky130_fd_sc_hd__fill_1
X_10200_ FPGA_INST.cell3.SB0.route_sel\[104\] FPGA_INST.cell3.SB0.route_sel\[105\]
+ net276 vssd1 vssd1 vccd1 vccd1 _01081_ sky130_fd_sc_hd__mux2_1
X_08169_ _04384_ _04386_ _04389_ _04392_ vssd1 vssd1 vccd1 vccd1 _04393_ sky130_fd_sc_hd__a22o_1
XANTENNA__06216__A1 net5 vssd1 vssd1 vccd1 vccd1 sky130_fd_sc_hd__diode_2
X_11180_ net780 _00530_ net565 vssd1 vssd1 vccd1 vccd1 FPGA_INST.cell0.SB0.route_sel\[25\]
+ sky130_fd_sc_hd__dfstp_1
X_10131_ FPGA_INST.cell3.SB0.route_sel\[35\] FPGA_INST.cell3.SB0.route_sel\[36\] net278
+ vssd1 vssd1 vccd1 vccd1 _01012_ sky130_fd_sc_hd__mux2_1
XANTENNA__07964__A1 FPGA_INST.bus3_1\[1\] vssd1 vssd1 vccd1 vccd1 sky130_fd_sc_hd__diode_2
XFILLER_125_30 vccd1 vssd1 vccd1 vssd1 sky130_ef_sc_hd__decap_40_12
X_10062_ FPGA_INST.cell0.CB_1.config_dataA\[12\] net405 net327 vssd1 vssd1 vccd1 vccd1
+ _00943_ sky130_fd_sc_hd__mux2_1
XFILLER_0_699 vssd1 vssd1 vccd1 vccd1 sky130_fd_sc_hd__fill_1
XANTENNA__06122__A net129 vssd1 vssd1 vccd1 vccd1 sky130_fd_sc_hd__diode_2
XTAP_TAPCELL_ROW_126_2041 vssd1 vccd1 sky130_fd_sc_hd__tapvpwrvgnd_1
XFILLER_85_45 vssd1 vssd1 vccd1 vccd1 sky130_fd_sc_hd__fill_2
XFILLER_47_125 vssd1 vssd1 vccd1 vccd1 sky130_fd_sc_hd__fill_2
XTAP_TAPCELL_ROW_126_2052 vssd1 vccd1 sky130_fd_sc_hd__tapvpwrvgnd_1
XFILLER_18_72 vccd1 vssd1 vccd1 vssd1 sky130_ef_sc_hd__decap_40_12
XTAP_TAPCELL_ROW_18_529 vssd1 vccd1 sky130_fd_sc_hd__tapvpwrvgnd_1
XFILLER_16_567 vssd1 vssd1 vccd1 vccd1 sky130_fd_sc_hd__fill_8
X_10964_ net866 _00314_ net653 vssd1 vssd1 vccd1 vccd1 FPGA_INST.cell2.CB_0.config_dataB\[20\]
+ sky130_fd_sc_hd__dfstp_1
X_10895_ net823 _00245_ net607 vssd1 vssd1 vccd1 vccd1 FPGA_INST.cell1.SB0.route_sel\[104\]
+ sky130_fd_sc_hd__dfstp_1
XFILLER_16_589 vssd1 vssd1 vccd1 vccd1 sky130_fd_sc_hd__fill_4
XFILLER_129_447 vssd1 vssd1 vccd1 vccd1 sky130_fd_sc_hd__fill_1
X_11516_ net780 _00866_ net565 vssd1 vssd1 vccd1 vccd1 FPGA_INST.cell0.CB_1.config_dataB\[22\]
+ sky130_fd_sc_hd__dfstp_1
XANTENNA__06455__A1 _02330_ vssd1 vssd1 vccd1 vccd1 sky130_fd_sc_hd__diode_2
XANTENNA__06455__B2 _02293_ vssd1 vssd1 vccd1 vccd1 sky130_fd_sc_hd__diode_2
XFILLER_109_182 vssd1 vssd1 vccd1 vccd1 sky130_fd_sc_hd__fill_1
X_11447_ net775 _00797_ net561 vssd1 vssd1 vccd1 vccd1 FPGA_INST.cell0.LE_0A.reset_val
+ sky130_fd_sc_hd__dfrtp_1
XFILLER_124_141 vssd1 vssd1 vccd1 vccd1 sky130_fd_sc_hd__fill_2
XANTENNA__07404__A0 net24 vssd1 vssd1 vccd1 vccd1 sky130_fd_sc_hd__diode_2
X_11378_ FPGA_INST.cell0.LE_0A.sel_clk _00728_ net732 vssd1 vssd1 vccd1 vccd1 FPGA_INST.cell0.LE_0A.dff1_out
+ sky130_fd_sc_hd__dfstp_1
X_10329_ FPGA_INST.cell3.LEI0.config_data\[43\] FPGA_INST.cell3.LEI0.config_data\[44\]
+ net298 vssd1 vssd1 vccd1 vccd1 _01210_ sky130_fd_sc_hd__mux2_1
XANTENNA__10253__S net266 vssd1 vssd1 vccd1 vccd1 sky130_fd_sc_hd__diode_2
XTAP_TAPCELL_ROW_55_1058 vssd1 vccd1 sky130_fd_sc_hd__tapvpwrvgnd_1
XTAP_TAPCELL_ROW_55_1047 vssd1 vccd1 sky130_fd_sc_hd__tapvpwrvgnd_1
XFILLER_112_336 vssd1 vssd1 vccd1 vccd1 sky130_fd_sc_hd__fill_1
XANTENNA__08231__B _04040_ vssd1 vssd1 vccd1 vccd1 sky130_fd_sc_hd__diode_2
XANTENNA__10767__SET_B net676 vssd1 vssd1 vccd1 vccd1 sky130_fd_sc_hd__diode_2
X_05870_ FPGA_INST.cell2.SB0.route_sel\[68\] FPGA_INST.cell2.SB0.route_sel\[69\] _02149_
+ vssd1 vssd1 vccd1 vccd1 _02150_ sky130_fd_sc_hd__a21o_1
XFILLER_15_3 vccd1 vssd1 vccd1 vssd1 sky130_ef_sc_hd__decap_40_12
XFILLER_66_467 vssd1 vssd1 vccd1 vccd1 sky130_fd_sc_hd__fill_8
XFILLER_66_456 vssd1 vssd1 vccd1 vccd1 sky130_fd_sc_hd__fill_2
XTAP_TAPCELL_ROW_37_805 vssd1 vccd1 sky130_fd_sc_hd__tapvpwrvgnd_1
X_07540_ FPGA_INST.cell0.SB0.route_sel\[72\] FPGA_INST.cell0.SB0.route_sel\[73\] vssd1
+ vssd1 vccd1 vccd1 _03795_ sky130_fd_sc_hd__nand2b_1
XFILLER_34_331 vssd1 vssd1 vccd1 vccd1 sky130_fd_sc_hd__fill_2
X_07471_ _03716_ _03725_ _03727_ net220 vssd1 vssd1 vccd1 vccd1 _03728_ sky130_fd_sc_hd__o211a_4
XFILLER_22_504 vssd1 vssd1 vccd1 vccd1 sky130_fd_sc_hd__fill_1
XANTENNA__09489__S net336 vssd1 vssd1 vccd1 vccd1 sky130_fd_sc_hd__diode_2
X_09210_ FPGA_INST.cell2.CB_1.config_dataB\[7\] net516 net379 vssd1 vssd1 vccd1 vccd1
+ _00123_ sky130_fd_sc_hd__mux2_1
X_06422_ net14 net15 net16 net17 net491 net490 vssd1 vssd1 vccd1 vccd1 _02700_ sky130_fd_sc_hd__mux4_1
X_09141_ FPGA_INST.cell2.LE_0A.config_data\[5\] FPGA_INST.cell2.LE_0A.config_data\[4\]
+ net350 vssd1 vssd1 vccd1 vccd1 _00056_ sky130_fd_sc_hd__mux2_1
X_06353_ net3 net4 net495 vssd1 vssd1 vccd1 vccd1 _02631_ sky130_fd_sc_hd__mux2_1
X_09072_ net89 _03661_ _03662_ _05203_ vssd1 vssd1 vccd1 vccd1 net65 sky130_fd_sc_hd__a2bb2o_1
X_05304_ FPGA_INST.cell2.SB0.route_sel\[125\] vssd1 vssd1 vccd1 vccd1 _01586_ sky130_fd_sc_hd__inv_2
X_08023_ _03810_ _04234_ _04247_ _04248_ vssd1 vssd1 vccd1 vccd1 _04249_ sky130_fd_sc_hd__o211a_1
X_06284_ net502 _02563_ vssd1 vssd1 vccd1 vccd1 _02564_ sky130_fd_sc_hd__and2_1
XFILLER_30_29 vccd1 vssd1 vccd1 vssd1 sky130_ef_sc_hd__decap_40_12
XFILLER_116_631 vssd1 vssd1 vccd1 vccd1 sky130_fd_sc_hd__fill_1
XFILLER_115_163 vssd1 vssd1 vccd1 vccd1 sky130_fd_sc_hd__fill_2
XANTENNA__07946__A1 _03932_ vssd1 vssd1 vccd1 vccd1 sky130_fd_sc_hd__diode_2
XANTENNA__06749__A2 FPGA_INST.bus3_2\[14\] vssd1 vssd1 vccd1 vccd1 sky130_fd_sc_hd__diode_2
XANTENNA__11444__RESET_B net561 vssd1 vssd1 vccd1 vccd1 sky130_fd_sc_hd__diode_2
X_09974_ FPGA_INST.config_bits\[3\] _05225_ _05227_ _05224_ vssd1 vssd1 vccd1 vccd1
+ _00872_ sky130_fd_sc_hd__a22o_1
XFILLER_97_570 vssd1 vssd1 vccd1 vccd1 sky130_fd_sc_hd__fill_1
X_08925_ _03918_ _03929_ _05123_ net340 vssd1 vssd1 vccd1 vccd1 FPGA_INST.bus1_0\[12\]
+ sky130_fd_sc_hd__a211oi_1
XANTENNA_fanout576_A net577 vssd1 vssd1 vccd1 vccd1 sky130_fd_sc_hd__diode_2
X_08856_ _05059_ _05060_ _05062_ vssd1 vssd1 vccd1 vccd1 _05063_ sky130_fd_sc_hd__and3_1
XANTENNA__07980__B _04049_ vssd1 vssd1 vccd1 vccd1 sky130_fd_sc_hd__diode_2
XFILLER_57_434 vssd1 vssd1 vccd1 vccd1 sky130_fd_sc_hd__fill_2
X_07807_ _03578_ _03939_ vssd1 vssd1 vccd1 vccd1 _04056_ sky130_fd_sc_hd__or2_1
XFILLER_29_158 vssd1 vssd1 vccd1 vccd1 sky130_fd_sc_hd__fill_1
XFILLER_29_169 vssd1 vssd1 vccd1 vccd1 sky130_fd_sc_hd__fill_4
X_08787_ net389 _04991_ _04992_ _04993_ vssd1 vssd1 vccd1 vccd1 _04994_ sky130_fd_sc_hd__a31o_1
XANTENNA_fanout364_X net364 vssd1 vssd1 vccd1 vccd1 sky130_fd_sc_hd__diode_2
XFILLER_85_798 vssd1 vssd1 vccd1 vccd1 sky130_fd_sc_hd__fill_1
X_05999_ net100 _02277_ _02278_ vssd1 vssd1 vccd1 vccd1 _02279_ sky130_fd_sc_hd__a21oi_1
XFILLER_55_59 vssd1 vssd1 vccd1 vccd1 sky130_fd_sc_hd__fill_1
X_07738_ _01848_ _02810_ _01852_ vssd1 vssd1 vccd1 vccd1 _03988_ sky130_fd_sc_hd__o21ai_1
XPHY_EDGE_ROW_9_Left_140 vssd1 vssd1 vccd1 vccd1 sky130_fd_sc_hd__decap_3
X_07669_ FPGA_INST.cell0.SB0.route_sel\[96\] FPGA_INST.cell0.SB0.route_sel\[97\] vssd1
+ vssd1 vccd1 vccd1 _03921_ sky130_fd_sc_hd__nand2b_1
X_09408_ FPGA_INST.cell2.CB_1.config_dataA\[2\] net482 net362 vssd1 vssd1 vccd1 vccd1
+ _00321_ sky130_fd_sc_hd__mux2_1
XFILLER_13_559 vssd1 vssd1 vccd1 vccd1 sky130_fd_sc_hd__fill_1
X_10680_ net874 _00030_ net658 vssd1 vssd1 vccd1 vccd1 FPGA_INST.cell2.LEI0.config_data\[29\]
+ sky130_fd_sc_hd__dfrtp_1
XANTENNA__09399__S net357 vssd1 vssd1 vccd1 vccd1 sky130_fd_sc_hd__diode_2
X_09339_ FPGA_INST.cell1.SB0.route_sel\[111\] FPGA_INST.cell1.SB0.route_sel\[110\]
+ net343 vssd1 vssd1 vccd1 vccd1 _00252_ sky130_fd_sc_hd__mux2_1
XPHY_EDGE_ROW_109_Right_109 vssd1 vssd1 vccd1 vccd1 sky130_fd_sc_hd__decap_3
XANTENNA__06437__A1 net5 vssd1 vssd1 vccd1 vccd1 sky130_fd_sc_hd__diode_2
XTAP_TAPCELL_ROW_23_598 vssd1 vccd1 sky130_fd_sc_hd__tapvpwrvgnd_1
XTAP_TAPCELL_ROW_97_1637 vssd1 vccd1 sky130_fd_sc_hd__tapvpwrvgnd_1
XANTENNA__06064__B1_N FPGA_INST.bus2_0\[3\] vssd1 vssd1 vccd1 vccd1 sky130_fd_sc_hd__diode_2
XFILLER_119_491 vssd1 vssd1 vccd1 vccd1 sky130_fd_sc_hd__fill_4
X_11301_ net826 _00651_ net610 vssd1 vssd1 vccd1 vccd1 FPGA_INST.cell1.CB_0.config_dataA\[18\]
+ sky130_fd_sc_hd__dfstp_1
XFILLER_5_725 vssd1 vssd1 vccd1 vccd1 sky130_fd_sc_hd__fill_2
XFILLER_106_141 vssd1 vssd1 vccd1 vccd1 sky130_fd_sc_hd__fill_8
X_11232_ net761 _00582_ net547 vssd1 vssd1 vccd1 vccd1 FPGA_INST.cell0.SB0.route_sel\[77\]
+ sky130_fd_sc_hd__dfstp_1
XFILLER_107_697 vssd1 vssd1 vccd1 vccd1 sky130_fd_sc_hd__fill_1
XFILLER_107_686 vssd1 vssd1 vccd1 vccd1 sky130_fd_sc_hd__fill_1
XANTENNA__07398__C1 FPGA_INST.cell3.SB0.route_sel\[44\] vssd1 vssd1 vccd1 vccd1 sky130_fd_sc_hd__diode_2
X_11163_ net780 _00513_ net565 vssd1 vssd1 vccd1 vccd1 FPGA_INST.cell0.SB0.route_sel\[8\]
+ sky130_fd_sc_hd__dfstp_1
XFILLER_20_62 vssd1 vssd1 vccd1 vccd1 sky130_fd_sc_hd__fill_1
X_10114_ FPGA_INST.cell3.SB0.route_sel\[18\] FPGA_INST.cell3.SB0.route_sel\[19\] net269
+ vssd1 vssd1 vccd1 vccd1 _00995_ sky130_fd_sc_hd__mux2_1
X_11094_ net840 _00444_ net624 vssd1 vssd1 vccd1 vccd1 FPGA_INST.cell1.LE_0B.config_data\[7\]
+ sky130_fd_sc_hd__dfrtp_1
XFILLER_76_710 vssd1 vssd1 vccd1 vccd1 sky130_fd_sc_hd__fill_4
X_10045_ FPGA_INST.cell0.CB_0.config_dataB\[20\] FPGA_INST.cell0.CB_0.config_dataB\[19\]
+ net310 vssd1 vssd1 vccd1 vccd1 _00926_ sky130_fd_sc_hd__mux2_1
XANTENNA__08362__A1 FPGA_INST.bus1_0\[15\] vssd1 vssd1 vccd1 vccd1 sky130_fd_sc_hd__diode_2
XANTENNA__07570__C1 net374 vssd1 vssd1 vccd1 vccd1 sky130_fd_sc_hd__diode_2
XANTENNA__08114__A1 FPGA_INST.bus3_1\[1\] vssd1 vssd1 vccd1 vccd1 sky130_fd_sc_hd__diode_2
X_11996_ net852 _01342_ net637 vssd1 vssd1 vccd1 vccd1 FPGA_INST.cell2.SB0.route_sel\[36\]
+ sky130_fd_sc_hd__dfstp_1
XTAP_TAPCELL_ROW_106_1766 vssd1 vccd1 sky130_fd_sc_hd__tapvpwrvgnd_1
XFILLER_45_81 vssd1 vssd1 vccd1 vccd1 sky130_fd_sc_hd__fill_2
XFILLER_44_684 vssd1 vssd1 vccd1 vccd1 sky130_fd_sc_hd__fill_8
X_10947_ net863 _00297_ net648 vssd1 vssd1 vccd1 vccd1 FPGA_INST.cell2.CB_0.config_dataB\[3\]
+ sky130_fd_sc_hd__dfstp_1
XANTENNA__07873__A0 FPGA_INST.bus3_1\[12\] vssd1 vssd1 vccd1 vccd1 sky130_fd_sc_hd__diode_2
XFILLER_31_334 vssd1 vssd1 vccd1 vccd1 sky130_fd_sc_hd__fill_2
X_10878_ net792 _00228_ net577 vssd1 vssd1 vccd1 vccd1 FPGA_INST.cell1.SB0.route_sel\[87\]
+ sky130_fd_sc_hd__dfstp_1
XTAP_TAPCELL_ROW_42_874 vssd1 vccd1 sky130_fd_sc_hd__tapvpwrvgnd_1
XFILLER_129_277 vssd1 vssd1 vccd1 vccd1 sky130_fd_sc_hd__fill_1
XANTENNA_2 _03934_ vssd1 vssd1 vccd1 vccd1 sky130_fd_sc_hd__diode_2
XFILLER_6_42 vssd1 vssd1 vccd1 vccd1 sky130_fd_sc_hd__fill_1
XFILLER_6_31 vssd1 vssd1 vccd1 vccd1 sky130_fd_sc_hd__fill_2
XANTENNA__06979__A2 _02191_ vssd1 vssd1 vccd1 vccd1 sky130_fd_sc_hd__diode_2
XANTENNA__09917__A2 net522 vssd1 vssd1 vccd1 vccd1 sky130_fd_sc_hd__diode_2
XFILLER_6_64 vssd1 vssd1 vccd1 vccd1 sky130_fd_sc_hd__fill_4
XANTENNA__09057__B FPGA_INST.cell3.LE_0A.reset_mode vssd1 vssd1 vccd1 vccd1 sky130_fd_sc_hd__diode_2
Xfanout509 FPGA_INST.cell2.CB_0.config_dataA\[0\] vssd1 vssd1 vccd1 vccd1 net509 sky130_fd_sc_hd__buf_2
X_06971_ FPGA_INST.cell0.LE_0B.config_data\[15\] FPGA_INST.cell0.LE_0B.config_data\[14\]
+ _03159_ vssd1 vssd1 vccd1 vccd1 _03239_ sky130_fd_sc_hd__mux2_1
X_08710_ FPGA_INST.cell3.LEI0.config_data\[24\] net82 _04918_ FPGA_INST.cell3.LEI0.config_data\[25\]
+ vssd1 vssd1 vccd1 vccd1 _04919_ sky130_fd_sc_hd__o211a_1
X_05922_ net100 _01893_ _02197_ vssd1 vssd1 vccd1 vccd1 _02202_ sky130_fd_sc_hd__and3_1
X_09690_ FPGA_INST.cell0.SB0.route_sel\[93\] FPGA_INST.cell0.SB0.route_sel\[94\] net187
+ vssd1 vssd1 vccd1 vccd1 _00599_ sky130_fd_sc_hd__mux2_1
XFILLER_39_434 vssd1 vssd1 vccd1 vccd1 sky130_fd_sc_hd__fill_1
XFILLER_39_423 vssd1 vssd1 vccd1 vccd1 sky130_fd_sc_hd__fill_1
XANTENNA__09550__A0 FPGA_INST.cell1.LE_0B.reset_mode vssd1 vssd1 vccd1 vccd1 sky130_fd_sc_hd__diode_2
X_08641_ net24 _04790_ _04795_ net22 _01763_ vssd1 vssd1 vccd1 vccd1 _04850_ sky130_fd_sc_hd__a221o_1
XFILLER_67_776 vssd1 vssd1 vccd1 vccd1 sky130_fd_sc_hd__fill_8
XFILLER_66_253 vssd1 vssd1 vccd1 vccd1 sky130_fd_sc_hd__fill_1
X_05853_ FPGA_INST.cell0.SB0.route_sel\[64\] FPGA_INST.cell0.SB0.route_sel\[65\] vssd1
+ vssd1 vccd1 vccd1 _02133_ sky130_fd_sc_hd__and2_1
XFILLER_81_212 vssd1 vssd1 vccd1 vccd1 sky130_fd_sc_hd__fill_2
XANTENNA__07561__C1 _03812_ vssd1 vssd1 vccd1 vccd1 sky130_fd_sc_hd__diode_2
XTAP_TAPCELL_ROW_68_1238 vssd1 vccd1 sky130_fd_sc_hd__tapvpwrvgnd_1
XFILLER_66_275 vssd1 vssd1 vccd1 vccd1 sky130_fd_sc_hd__fill_8
XANTENNA__06903__A2 FPGA_INST.bus2_0\[13\] vssd1 vssd1 vccd1 vccd1 sky130_fd_sc_hd__diode_2
X_08572_ _03861_ _03865_ _04780_ vssd1 vssd1 vccd1 vccd1 _04781_ sky130_fd_sc_hd__or3_4
XFILLER_82_757 vssd1 vssd1 vccd1 vccd1 sky130_fd_sc_hd__fill_2
XFILLER_26_139 vssd1 vssd1 vccd1 vccd1 sky130_fd_sc_hd__fill_1
X_05784_ net171 net162 FPGA_INST.bus2_0\[11\] vssd1 vssd1 vccd1 vccd1 _02064_ sky130_fd_sc_hd__o21ba_1
X_07523_ FPGA_INST.cell3.SB0.route_sel\[66\] FPGA_INST.cell3.SB0.route_sel\[67\] _03771_
+ _03774_ _03778_ vssd1 vssd1 vccd1 vccd1 _03779_ sky130_fd_sc_hd__a41o_1
XTAP_TAPCELL_ROW_81_1416 vssd1 vccd1 sky130_fd_sc_hd__tapvpwrvgnd_1
XFILLER_62_470 vssd1 vssd1 vccd1 vccd1 sky130_fd_sc_hd__fill_1
X_07454_ _03710_ vssd1 vssd1 vccd1 vccd1 _03711_ sky130_fd_sc_hd__inv_2
XANTENNA__06636__S _02878_ vssd1 vssd1 vccd1 vccd1 sky130_fd_sc_hd__diode_2
X_06405_ _02682_ vssd1 vssd1 vccd1 vccd1 _02683_ sky130_fd_sc_hd__inv_2
XFILLER_22_367 vccd1 vssd1 vccd1 vssd1 sky130_ef_sc_hd__decap_40_12
X_07385_ net148 _03468_ _03607_ _03635_ _03643_ vssd1 vssd1 vccd1 vccd1 _03644_ sky130_fd_sc_hd__o311a_1
XANTENNA_fanout324_A net325 vssd1 vssd1 vccd1 vccd1 sky130_fd_sc_hd__diode_2
XANTENNA__06419__A1 _02010_ vssd1 vssd1 vccd1 vccd1 sky130_fd_sc_hd__diode_2
XANTENNA__05890__A2 _02131_ vssd1 vssd1 vccd1 vccd1 sky130_fd_sc_hd__diode_2
X_06336_ _02615_ _02614_ _02502_ vssd1 vssd1 vccd1 vccd1 _02616_ sky130_fd_sc_hd__mux2_1
XTAP_TAPCELL_ROW_20_557 vssd1 vccd1 sky130_fd_sc_hd__tapvpwrvgnd_1
XANTENNA__06419__B2 _01966_ vssd1 vssd1 vccd1 vccd1 sky130_fd_sc_hd__diode_2
X_09124_ FPGA_INST.cell2.LEI0.config_data\[38\] FPGA_INST.cell2.LEI0.config_data\[39\]
+ net250 vssd1 vssd1 vccd1 vccd1 _00040_ sky130_fd_sc_hd__mux2_1
X_09055_ net743 FPGA_INST.cell0.LE_1B.edge_mode vssd1 vssd1 vccd1 vccd1 FPGA_INST.cell0.LE_1B.sel_clk
+ sky130_fd_sc_hd__xnor2_1
X_06267_ _02545_ _02546_ _02543_ vssd1 vssd1 vccd1 vccd1 _02547_ sky130_fd_sc_hd__o21a_1
XTAP_TAPCELL_ROW_20_568 vssd1 vccd1 sky130_fd_sc_hd__tapvpwrvgnd_1
XANTENNA_fanout112_X net112 vssd1 vssd1 vccd1 vccd1 sky130_fd_sc_hd__diode_2
X_08006_ net457 _03728_ vssd1 vssd1 vccd1 vccd1 _04232_ sky130_fd_sc_hd__nand2_1
XTAP_TAPCELL_ROW_79_1389 vssd1 vccd1 sky130_fd_sc_hd__tapvpwrvgnd_1
XANTENNA_fanout693_A net695 vssd1 vssd1 vccd1 vccd1 sky130_fd_sc_hd__diode_2
XFILLER_104_623 vssd1 vssd1 vccd1 vccd1 sky130_fd_sc_hd__fill_2
XFILLER_103_100 vssd1 vssd1 vccd1 vccd1 sky130_fd_sc_hd__fill_2
X_06198_ _01954_ _02366_ vssd1 vssd1 vccd1 vccd1 _02478_ sky130_fd_sc_hd__and2_1
XANTENNA__07395__A2 FPGA_INST.cell3.SB0.route_sel\[44\] vssd1 vssd1 vccd1 vccd1 sky130_fd_sc_hd__diode_2
XTAP_TAPCELL_ROW_92_1567 vssd1 vccd1 sky130_fd_sc_hd__tapvpwrvgnd_1
X_09957_ FPGA_INST.cell0.CB_1.config_dataB\[18\] FPGA_INST.cell0.CB_1.config_dataB\[17\]
+ net315 vssd1 vssd1 vccd1 vccd1 _00862_ sky130_fd_sc_hd__mux2_1
XFILLER_49_209 vssd1 vssd1 vccd1 vccd1 sky130_fd_sc_hd__fill_2
X_08908_ FPGA_INST.cell2.SB0.route_sel\[114\] FPGA_INST.cell2.SB0.route_sel\[115\]
+ vssd1 vssd1 vccd1 vccd1 _05112_ sky130_fd_sc_hd__nand2b_1
XANTENNA__08344__A1 _03465_ vssd1 vssd1 vccd1 vccd1 sky130_fd_sc_hd__diode_2
XANTENNA__08344__B2 _03408_ vssd1 vssd1 vccd1 vccd1 sky130_fd_sc_hd__diode_2
X_09888_ FPGA_INST.cell0.LE_0A.config_data\[15\] FPGA_INST.cell0.LE_0A.config_data\[16\]
+ net193 vssd1 vssd1 vccd1 vccd1 _00795_ sky130_fd_sc_hd__mux2_1
XTAP_TAPCELL_ROW_123_2011 vssd1 vccd1 sky130_fd_sc_hd__tapvpwrvgnd_1
XTAP_TAPCELL_ROW_123_2000 vssd1 vccd1 sky130_fd_sc_hd__tapvpwrvgnd_1
X_08839_ net388 _04839_ _05045_ FPGA_INST.cell3.CB_0.config_dataB\[11\] vssd1 vssd1
+ vccd1 vccd1 _05046_ sky130_fd_sc_hd__o211a_1
XFILLER_58_798 vssd1 vssd1 vccd1 vccd1 sky130_fd_sc_hd__fill_1
X_11850_ net934 _01196_ net718 vssd1 vssd1 vccd1 vccd1 FPGA_INST.cell3.LEI0.config_data\[30\]
+ sky130_fd_sc_hd__dfrtp_1
XFILLER_122_64 vssd1 vssd1 vccd1 vccd1 sky130_fd_sc_hd__fill_1
XFILLER_72_223 vssd1 vssd1 vccd1 vccd1 sky130_fd_sc_hd__fill_4
X_10801_ net822 _00151_ net606 vssd1 vssd1 vccd1 vccd1 FPGA_INST.cell1.SB0.route_sel\[10\]
+ sky130_fd_sc_hd__dfstp_1
X_11781_ net926 _01127_ net710 vssd1 vssd1 vccd1 vccd1 FPGA_INST.io_south_oeb\[14\]
+ sky130_fd_sc_hd__dfrtp_1
XTAP_TAPCELL_ROW_0_271 vssd1 vccd1 sky130_fd_sc_hd__tapvpwrvgnd_1
XFILLER_26_662 vssd1 vssd1 vccd1 vccd1 sky130_fd_sc_hd__fill_2
XTAP_TAPCELL_ROW_28_668 vssd1 vccd1 sky130_fd_sc_hd__tapvpwrvgnd_1
XTAP_TAPCELL_ROW_28_679 vssd1 vccd1 sky130_fd_sc_hd__tapvpwrvgnd_1
XFILLER_82_79 vssd1 vssd1 vccd1 vccd1 sky130_fd_sc_hd__fill_4
XFILLER_82_68 vssd1 vssd1 vccd1 vccd1 sky130_fd_sc_hd__fill_2
XFILLER_41_621 vssd1 vssd1 vccd1 vccd1 sky130_fd_sc_hd__fill_2
XTAP_TAPCELL_ROW_0_282 vssd1 vccd1 sky130_fd_sc_hd__tapvpwrvgnd_1
X_10732_ net869 _00082_ net654 vssd1 vssd1 vccd1 vccd1 FPGA_INST.cell2.LE_0B.config_data\[9\]
+ sky130_fd_sc_hd__dfrtp_1
XFILLER_41_687 vssd1 vssd1 vccd1 vccd1 sky130_fd_sc_hd__fill_1
X_10663_ net883 _00013_ net667 vssd1 vssd1 vccd1 vccd1 FPGA_INST.cell2.LEI0.config_data\[12\]
+ sky130_fd_sc_hd__dfrtp_1
XFILLER_40_186 vssd1 vssd1 vccd1 vccd1 sky130_fd_sc_hd__fill_8
X_10594_ FPGA_INST.cell3.CB_0.config_dataB\[13\] FPGA_INST.cell3.CB_0.config_dataB\[14\]
+ net302 vssd1 vssd1 vccd1 vccd1 _01473_ sky130_fd_sc_hd__mux2_1
XTAP_TAPCELL_ROW_101_1696 vssd1 vccd1 sky130_fd_sc_hd__tapvpwrvgnd_1
XFILLER_40_197 vssd1 vssd1 vccd1 vccd1 sky130_fd_sc_hd__fill_1
XANTENNA__06291__C1 _02570_ vssd1 vssd1 vccd1 vccd1 sky130_fd_sc_hd__diode_2
Xoutput61 net61 vssd1 vssd1 vccd1 vccd1 gpio_out[26] sky130_fd_sc_hd__buf_2
XTAP_TAPCELL_ROW_52_1006 vssd1 vccd1 sky130_fd_sc_hd__tapvpwrvgnd_1
Xoutput50 net50 vssd1 vssd1 vccd1 vccd1 gpio_out[15] sky130_fd_sc_hd__buf_2
X_11215_ net757 _00565_ net542 vssd1 vssd1 vccd1 vccd1 FPGA_INST.cell0.SB0.route_sel\[60\]
+ sky130_fd_sc_hd__dfstp_1
X_11146_ net808 _00496_ net594 vssd1 vssd1 vccd1 vccd1 FPGA_INST.cell1.CB_1.config_dataB\[16\]
+ sky130_fd_sc_hd__dfstp_1
XFILLER_68_518 vccd1 vssd1 vccd1 vssd1 sky130_ef_sc_hd__decap_40_12
XTAP_TAPCELL_ROW_52_1017 vssd1 vccd1 sky130_fd_sc_hd__tapvpwrvgnd_1
Xoutput72 net72 vssd1 vssd1 vccd1 vccd1 gpio_out[9] sky130_fd_sc_hd__buf_2
X_11077_ net834 _00427_ net618 vssd1 vssd1 vccd1 vccd1 FPGA_INST.cell1.LE_0A.config_data\[12\]
+ sky130_fd_sc_hd__dfrtp_1
XFILLER_122_486 vssd1 vssd1 vccd1 vccd1 sky130_fd_sc_hd__fill_4
XFILLER_95_337 vssd1 vssd1 vccd1 vccd1 sky130_fd_sc_hd__fill_4
XFILLER_49_732 vssd1 vssd1 vccd1 vccd1 sky130_fd_sc_hd__fill_1
XTAP_TAPCELL_ROW_8_393 vssd1 vccd1 sky130_fd_sc_hd__tapvpwrvgnd_1
XFILLER_1_794 vssd1 vssd1 vccd1 vccd1 sky130_fd_sc_hd__fill_2
XFILLER_0_293 vssd1 vssd1 vccd1 vccd1 sky130_fd_sc_hd__fill_4
X_10028_ FPGA_INST.cell0.CB_0.config_dataB\[3\] FPGA_INST.cell0.CB_0.config_dataB\[2\]
+ net310 vssd1 vssd1 vccd1 vccd1 _00909_ sky130_fd_sc_hd__mux2_1
XFILLER_76_595 vssd1 vssd1 vccd1 vccd1 sky130_fd_sc_hd__fill_2
XFILLER_49_798 vssd1 vssd1 vccd1 vccd1 sky130_fd_sc_hd__fill_1
XTAP_TAPCELL_ROW_47_944 vssd1 vccd1 sky130_fd_sc_hd__tapvpwrvgnd_1
XFILLER_23_109 vssd1 vssd1 vccd1 vccd1 sky130_fd_sc_hd__fill_2
XANTENNA__08638__A2 _04843_ vssd1 vssd1 vccd1 vccd1 sky130_fd_sc_hd__diode_2
X_11979_ net844 _01325_ net629 vssd1 vssd1 vccd1 vccd1 FPGA_INST.cell2.SB0.route_sel\[19\]
+ sky130_fd_sc_hd__dfstp_1
XTAP_TAPCELL_ROW_63_1168 vssd1 vccd1 sky130_fd_sc_hd__tapvpwrvgnd_1
XANTENNA__07310__A2 _02775_ vssd1 vssd1 vccd1 vccd1 sky130_fd_sc_hd__diode_2
XFILLER_82_3 vccd1 vssd1 vccd1 vssd1 sky130_ef_sc_hd__decap_40_12
X_07170_ FPGA_INST.cell3.CB_0.config_dataB\[21\] FPGA_INST.cell3.CB_0.config_dataB\[20\]
+ FPGA_INST.cell3.CB_0.config_dataB\[24\] vssd1 vssd1 vccd1 vccd1 _03434_ sky130_fd_sc_hd__or3_1
XTAP_TAPCELL_ROW_119_1946 vssd1 vccd1 sky130_fd_sc_hd__tapvpwrvgnd_1
XFILLER_117_225 vssd1 vssd1 vccd1 vccd1 sky130_fd_sc_hd__fill_4
X_06121_ _01795_ _02398_ _02400_ vssd1 vssd1 vccd1 vccd1 _02401_ sky130_fd_sc_hd__o21ai_1
XFILLER_117_269 vssd1 vssd1 vccd1 vccd1 sky130_fd_sc_hd__fill_8
XANTENNA__08810__A2 _04781_ vssd1 vssd1 vccd1 vccd1 sky130_fd_sc_hd__diode_2
X_06052_ FPGA_INST.cell0.CB_0.config_dataA\[23\] FPGA_INST.cell0.CB_0.config_dataA\[22\]
+ vssd1 vssd1 vccd1 vccd1 _02332_ sky130_fd_sc_hd__nor2_2
XFILLER_99_621 vssd1 vssd1 vccd1 vccd1 sky130_fd_sc_hd__fill_2
Xfanout306 _01831_ vssd1 vssd1 vccd1 vccd1 net306 sky130_fd_sc_hd__clkbuf_4
X_09811_ FPGA_INST.cell1.LE_1B.config_data\[11\] FPGA_INST.cell1.LE_1B.config_data\[12\]
+ net217 vssd1 vssd1 vccd1 vccd1 _00720_ sky130_fd_sc_hd__mux2_1
Xfanout339 net341 vssd1 vssd1 vccd1 vccd1 net339 sky130_fd_sc_hd__clkbuf_4
Xfanout328 net332 vssd1 vssd1 vccd1 vccd1 net328 sky130_fd_sc_hd__clkbuf_4
Xfanout317 net325 vssd1 vssd1 vccd1 vccd1 net317 sky130_fd_sc_hd__clkbuf_4
X_09742_ FPGA_INST.cell1.CB_0.config_dataA\[18\] FPGA_INST.cell1.CB_0.config_dataA\[17\]
+ net340 vssd1 vssd1 vccd1 vccd1 _00651_ sky130_fd_sc_hd__mux2_1
X_06954_ net414 _03221_ vssd1 vssd1 vccd1 vccd1 _03222_ sky130_fd_sc_hd__and2_1
X_09673_ FPGA_INST.cell0.SB0.route_sel\[76\] FPGA_INST.cell0.SB0.route_sel\[77\] net182
+ vssd1 vssd1 vccd1 vccd1 _00582_ sky130_fd_sc_hd__mux2_1
X_06885_ FPGA_INST.bus2_0\[1\] _03129_ _03151_ net423 _03152_ vssd1 vssd1 vccd1 vccd1
+ _03153_ sky130_fd_sc_hd__a221o_1
X_05905_ net171 _02175_ FPGA_INST.bus2_0\[7\] vssd1 vssd1 vccd1 vccd1 _02185_ sky130_fd_sc_hd__o21ba_1
X_08624_ FPGA_INST.cell3.SB0.route_sel\[62\] FPGA_INST.cell3.SB0.route_sel\[63\] vssd1
+ vssd1 vccd1 vccd1 _04833_ sky130_fd_sc_hd__nand2b_1
X_05836_ net164 _02036_ _01801_ vssd1 vssd1 vccd1 vccd1 _02116_ sky130_fd_sc_hd__a21oi_1
XFILLER_27_437 vssd1 vssd1 vccd1 vccd1 sky130_fd_sc_hd__fill_1
XFILLER_36_39 vssd1 vssd1 vccd1 vccd1 sky130_fd_sc_hd__fill_4
X_08555_ FPGA_INST.cell3.LE_1B.config_data\[4\] FPGA_INST.cell3.LE_1B.config_data\[5\]
+ _04755_ vssd1 vssd1 vccd1 vccd1 _04766_ sky130_fd_sc_hd__mux2_1
XANTENNA__07603__X _03857_ vssd1 vssd1 vccd1 vccd1 sky130_fd_sc_hd__diode_2
XFILLER_54_256 vccd1 vssd1 vccd1 vssd1 sky130_ef_sc_hd__decap_40_12
XFILLER_42_418 vssd1 vssd1 vccd1 vccd1 sky130_fd_sc_hd__fill_2
X_05767_ _01856_ _02045_ vssd1 vssd1 vccd1 vccd1 _02047_ sky130_fd_sc_hd__nand2_1
X_07506_ FPGA_INST.cell1.CB_1.config_dataA\[22\] FPGA_INST.cell1.CB_1.config_dataA\[23\]
+ vssd1 vssd1 vccd1 vccd1 _03762_ sky130_fd_sc_hd__nand2b_2
XFILLER_54_289 vccd1 vssd1 vccd1 vssd1 sky130_ef_sc_hd__decap_40_12
XTAP_TAPCELL_ROW_25_627 vssd1 vccd1 sky130_fd_sc_hd__tapvpwrvgnd_1
XTAP_TAPCELL_ROW_25_638 vssd1 vccd1 sky130_fd_sc_hd__tapvpwrvgnd_1
XFILLER_35_470 vssd1 vssd1 vccd1 vccd1 sky130_fd_sc_hd__fill_1
X_08486_ FPGA_INST.cell1.CB_1.config_dataB\[18\] FPGA_INST.cell1.CB_1.config_dataB\[17\]
+ FPGA_INST.cell1.CB_1.config_dataB\[16\] FPGA_INST.cell1.CB_1.config_dataB\[15\]
+ vssd1 vssd1 vccd1 vccd1 _04702_ sky130_fd_sc_hd__or4b_1
X_05698_ FPGA_INST.cell0.SB0.route_sel\[106\] FPGA_INST.cell0.SB0.route_sel\[107\]
+ _01974_ _01976_ _01977_ vssd1 vssd1 vccd1 vccd1 _01978_ sky130_fd_sc_hd__a221o_1
XPHY_EDGE_ROW_99_Left_230 vssd1 vssd1 vccd1 vccd1 sky130_fd_sc_hd__decap_3
X_07437_ _01673_ _03693_ _03694_ FPGA_INST.cell3.SB0.route_sel\[52\] vssd1 vssd1 vccd1
+ vccd1 _03695_ sky130_fd_sc_hd__or4b_1
XANTENNA_fanout327_X net327 vssd1 vssd1 vccd1 vccd1 sky130_fd_sc_hd__diode_2
XANTENNA_fanout706_A net731 vssd1 vssd1 vccd1 vccd1 sky130_fd_sc_hd__diode_2
XFILLER_22_164 vccd1 vssd1 vccd1 vssd1 sky130_ef_sc_hd__decap_40_12
X_07368_ _03586_ _03619_ _03627_ net371 vssd1 vssd1 vccd1 vccd1 _03628_ sky130_fd_sc_hd__a211oi_4
XANTENNA__08434__X FPGA_INST.bus2_0\[15\] vssd1 vssd1 vccd1 vccd1 sky130_fd_sc_hd__diode_2
XFILLER_22_197 vssd1 vssd1 vccd1 vccd1 sky130_fd_sc_hd__fill_8
X_09107_ FPGA_INST.cell2.LEI0.config_data\[21\] FPGA_INST.cell2.LEI0.config_data\[22\]
+ net263 vssd1 vssd1 vccd1 vccd1 _00023_ sky130_fd_sc_hd__mux2_1
X_06319_ net5 _02574_ _02598_ net499 _01535_ vssd1 vssd1 vccd1 vccd1 _02599_ sky130_fd_sc_hd__a221o_1
XANTENNA__07065__A1 FPGA_INST.bus2_0\[4\] vssd1 vssd1 vccd1 vccd1 sky130_fd_sc_hd__diode_2
XFILLER_109_759 vssd1 vssd1 vccd1 vccd1 sky130_fd_sc_hd__fill_4
X_07299_ FPGA_INST.cell1.SB0.route_sel\[31\] FPGA_INST.cell1.SB0.route_sel\[30\] _02341_
+ _03559_ _02342_ vssd1 vssd1 vccd1 vccd1 _03560_ sky130_fd_sc_hd__a221o_1
X_09038_ FPGA_INST.cell3.SB0.route_sel\[0\] _01718_ _01719_ FPGA_INST.cell3.SB0.route_sel\[3\]
+ _05198_ vssd1 vssd1 vccd1 vccd1 _05199_ sky130_fd_sc_hd__a221o_1
XFILLER_77_46 vssd1 vssd1 vccd1 vccd1 sky130_fd_sc_hd__fill_8
X_11000_ net926 _00350_ net710 vssd1 vssd1 vccd1 vccd1 FPGA_INST.cell2.LE_1B.config_data\[6\]
+ sky130_fd_sc_hd__dfrtp_1
XANTENNA__06576__A0 FPGA_INST.bus3_2\[12\] vssd1 vssd1 vccd1 vccd1 sky130_fd_sc_hd__diode_2
Xfanout840 net842 vssd1 vssd1 vccd1 vccd1 net840 sky130_fd_sc_hd__clkbuf_2
XFILLER_77_57 vssd1 vssd1 vccd1 vccd1 sky130_fd_sc_hd__fill_8
Xfanout851 net862 vssd1 vssd1 vccd1 vccd1 net851 sky130_fd_sc_hd__buf_2
Xfanout862 net947 vssd1 vssd1 vccd1 vccd1 net862 sky130_fd_sc_hd__buf_2
Xfanout884 net891 vssd1 vssd1 vccd1 vccd1 net884 sky130_fd_sc_hd__clkbuf_1
XTAP_TAPCELL_ROW_5_352 vssd1 vccd1 sky130_fd_sc_hd__tapvpwrvgnd_1
Xfanout873 net892 vssd1 vssd1 vccd1 vccd1 net873 sky130_fd_sc_hd__dlymetal6s2s_1
Xfanout895 net899 vssd1 vssd1 vccd1 vccd1 net895 sky130_fd_sc_hd__clkbuf_2
XANTENNA__06591__A3 FPGA_INST.bus3_2\[7\] vssd1 vssd1 vccd1 vccd1 sky130_fd_sc_hd__diode_2
X_11902_ net939 _01248_ net723 vssd1 vssd1 vccd1 vccd1 FPGA_INST.cell3.LE_0B.config_data\[10\]
+ sky130_fd_sc_hd__dfrtp_1
XANTENNA__08756__S _04860_ vssd1 vssd1 vccd1 vccd1 sky130_fd_sc_hd__diode_2
XFILLER_46_757 vssd1 vssd1 vccd1 vccd1 sky130_fd_sc_hd__fill_4
XANTENNA__06879__A1 FPGA_INST.bus2_0\[7\] vssd1 vssd1 vccd1 vccd1 sky130_fd_sc_hd__diode_2
X_11833_ net915 _01179_ net699 vssd1 vssd1 vccd1 vccd1 FPGA_INST.cell3.LEI0.config_data\[13\]
+ sky130_fd_sc_hd__dfrtp_1
XANTENNA__07513__X _03769_ vssd1 vssd1 vccd1 vccd1 sky130_fd_sc_hd__diode_2
XTAP_TAPCELL_ROW_44_903 vssd1 vccd1 sky130_fd_sc_hd__tapvpwrvgnd_1
XTAP_TAPCELL_ROW_103_1725 vssd1 vccd1 sky130_fd_sc_hd__tapvpwrvgnd_1
XANTENNA__06784__B _02814_ vssd1 vssd1 vccd1 vccd1 sky130_fd_sc_hd__diode_2
XFILLER_26_83 vssd1 vssd1 vccd1 vccd1 sky130_fd_sc_hd__fill_1
X_11764_ net924 _01110_ net708 vssd1 vssd1 vccd1 vccd1 FPGA_INST.io_west_oeb\[12\]
+ sky130_fd_sc_hd__dfrtp_1
XFILLER_41_451 vssd1 vssd1 vccd1 vccd1 sky130_fd_sc_hd__fill_2
XFILLER_14_643 vssd1 vssd1 vccd1 vccd1 sky130_fd_sc_hd__fill_1
XFILLER_26_94 vssd1 vssd1 vccd1 vccd1 sky130_fd_sc_hd__fill_2
X_11695_ net904 _01041_ net688 vssd1 vssd1 vccd1 vccd1 FPGA_INST.cell3.SB0.route_sel\[65\]
+ sky130_fd_sc_hd__dfstp_1
X_10715_ net863 _00065_ net648 vssd1 vssd1 vccd1 vccd1 FPGA_INST.cell2.LE_0A.config_data\[14\]
+ sky130_fd_sc_hd__dfrtp_1
X_10646_ FPGA_INST.cell3.LE_1B.config_data\[15\] FPGA_INST.cell3.LE_1B.config_data\[16\]
+ net279 vssd1 vssd1 vccd1 vccd1 _01525_ sky130_fd_sc_hd__mux2_1
XANTENNA__07056__A1 _02465_ vssd1 vssd1 vccd1 vccd1 sky130_fd_sc_hd__diode_2
X_10577_ FPGA_INST.cell3.CB_0.config_dataA\[21\] FPGA_INST.cell3.CB_0.config_dataA\[22\]
+ net284 vssd1 vssd1 vccd1 vccd1 _01456_ sky130_fd_sc_hd__mux2_1
XANTENNA__11596__CLK net803 vssd1 vssd1 vccd1 vccd1 sky130_fd_sc_hd__diode_2
XANTENNA__07056__B2 _02429_ vssd1 vssd1 vccd1 vccd1 sky130_fd_sc_hd__diode_2
XANTENNA__10823__Q FPGA_INST.cell1.SB0.route_sel\[32\] vssd1 vssd1 vccd1 vccd1 sky130_fd_sc_hd__diode_2
XTAP_TAPCELL_ROW_114_1876 vssd1 vccd1 sky130_fd_sc_hd__tapvpwrvgnd_1
X_12178_ net911 _01524_ net695 vssd1 vssd1 vccd1 vccd1 FPGA_INST.cell3.LE_1B.config_data\[15\]
+ sky130_fd_sc_hd__dfrtp_1
X_11129_ FPGA_INST.cell1.LE_1B.sel_clk _00479_ net733 vssd1 vssd1 vccd1 vccd1 FPGA_INST.cell1.LE_1B.dff0_out
+ sky130_fd_sc_hd__dfrtp_1
XANTENNA_max_cap74_X net74 vssd1 vssd1 vccd1 vccd1 sky130_fd_sc_hd__diode_2
XFILLER_95_167 vssd1 vssd1 vccd1 vccd1 sky130_fd_sc_hd__fill_1
XFILLER_37_713 vssd1 vssd1 vccd1 vccd1 sky130_fd_sc_hd__fill_2
X_06670_ FPGA_INST.cell2.CB_1.config_dataA\[18\] _02917_ FPGA_INST.cell2.CB_1.config_dataA\[17\]
+ FPGA_INST.cell2.CB_1.config_dataA\[19\] vssd1 vssd1 vccd1 vccd1 _02946_ sky130_fd_sc_hd__or4b_1
XFILLER_64_587 vssd1 vssd1 vccd1 vccd1 sky130_fd_sc_hd__fill_1
X_05621_ _01895_ _01897_ _01898_ _01900_ vssd1 vssd1 vccd1 vccd1 _01901_ sky130_fd_sc_hd__o31a_1
XFILLER_52_705 vssd1 vssd1 vccd1 vccd1 sky130_fd_sc_hd__fill_2
XFILLER_24_418 vssd1 vssd1 vccd1 vccd1 sky130_fd_sc_hd__fill_2
X_08340_ net448 _03682_ _04561_ net447 vssd1 vssd1 vccd1 vccd1 _04562_ sky130_fd_sc_hd__o211a_1
X_05552_ net385 _01819_ FPGA_INST.bus2_0\[14\] vssd1 vssd1 vccd1 vccd1 _01832_ sky130_fd_sc_hd__o21bai_1
X_05483_ FPGA_INST.cell3.CB_0.config_dataA\[4\] vssd1 vssd1 vccd1 vccd1 _01765_ sky130_fd_sc_hd__inv_2
X_08271_ FPGA_INST.cell0.CB_1.config_dataA\[18\] FPGA_INST.cell0.CB_1.config_dataA\[17\]
+ FPGA_INST.cell0.CB_1.config_dataA\[19\] _04474_ vssd1 vssd1 vccd1 vccd1 _04495_
+ sky130_fd_sc_hd__or4bb_1
X_07222_ _03435_ _03483_ vssd1 vssd1 vccd1 vccd1 _03485_ sky130_fd_sc_hd__nand2_1
X_07153_ _01787_ _03397_ vssd1 vssd1 vccd1 vccd1 _03417_ sky130_fd_sc_hd__and2_1
X_06104_ FPGA_INST.cell0.SB0.route_sel\[19\] FPGA_INST.cell0.SB0.route_sel\[18\] _02381_
+ _02382_ _02383_ vssd1 vssd1 vccd1 vccd1 _02384_ sky130_fd_sc_hd__a221o_1
XTAP_TAPCELL_ROW_30_696 vssd1 vccd1 sky130_fd_sc_hd__tapvpwrvgnd_1
XFILLER_105_206 vssd1 vssd1 vccd1 vccd1 sky130_fd_sc_hd__fill_1
XTAP_TAPCELL_ROW_76_1348 vssd1 vccd1 sky130_fd_sc_hd__tapvpwrvgnd_1
X_07084_ net428 _02350_ vssd1 vssd1 vccd1 vccd1 _03350_ sky130_fd_sc_hd__nand2_1
XANTENNA__09072__A1_N net89 vssd1 vssd1 vccd1 vccd1 sky130_fd_sc_hd__diode_2
X_06035_ FPGA_INST.cell2.SB0.route_sel\[40\] FPGA_INST.cell2.SB0.route_sel\[41\] vssd1
+ vssd1 vccd1 vccd1 _02315_ sky130_fd_sc_hd__nand2_1
Xfanout103 FPGA_INST.cell2.CB_1.le_outB vssd1 vssd1 vccd1 vccd1 net103 sky130_fd_sc_hd__buf_2
Xfanout147 FPGA_INST.cell1.CB_0.le_outB vssd1 vssd1 vccd1 vccd1 net147 sky130_fd_sc_hd__clkbuf_2
XANTENNA__10354__A1 FPGA_INST.cell3.LE_0A.reset_mode vssd1 vssd1 vccd1 vccd1 sky130_fd_sc_hd__diode_2
Xfanout114 net115 vssd1 vssd1 vccd1 vccd1 net114 sky130_fd_sc_hd__clkbuf_2
Xfanout136 net137 vssd1 vssd1 vccd1 vccd1 net136 sky130_fd_sc_hd__buf_2
Xfanout125 net126 vssd1 vssd1 vccd1 vccd1 net125 sky130_fd_sc_hd__buf_1
XFILLER_101_434 vssd1 vssd1 vccd1 vccd1 sky130_fd_sc_hd__fill_2
X_07986_ FPGA_INST.cell1.CB_0.config_dataA\[18\] _04189_ FPGA_INST.cell1.CB_0.config_dataA\[17\]
+ FPGA_INST.cell1.CB_0.config_dataA\[19\] vssd1 vssd1 vccd1 vccd1 _04214_ sky130_fd_sc_hd__or4b_1
XANTENNA__06221__Y _02501_ vssd1 vssd1 vccd1 vccd1 sky130_fd_sc_hd__diode_2
Xfanout158 _02334_ vssd1 vssd1 vccd1 vccd1 net158 sky130_fd_sc_hd__buf_2
X_09725_ net471 net473 net344 vssd1 vssd1 vccd1 vccd1 _00634_ sky130_fd_sc_hd__mux2_1
XFILLER_86_178 vccd1 vssd1 vccd1 vssd1 sky130_ef_sc_hd__decap_40_12
XTAP_TAPCELL_ROW_2_311 vssd1 vccd1 sky130_fd_sc_hd__tapvpwrvgnd_1
X_06937_ net415 _02070_ vssd1 vssd1 vccd1 vccd1 _03205_ sky130_fd_sc_hd__nand2_1
XFILLER_27_223 vssd1 vssd1 vccd1 vccd1 sky130_fd_sc_hd__fill_1
XFILLER_28_735 vssd1 vssd1 vccd1 vccd1 sky130_fd_sc_hd__fill_1
X_09656_ FPGA_INST.cell0.SB0.route_sel\[60\] FPGA_INST.cell0.SB0.route_sel\[59\] net310
+ vssd1 vssd1 vccd1 vccd1 _00565_ sky130_fd_sc_hd__mux2_1
X_08607_ net18 net27 FPGA_INST.cell3.CB_0.config_dataA\[3\] vssd1 vssd1 vccd1 vccd1
+ _04816_ sky130_fd_sc_hd__mux2_1
XFILLER_82_362 vssd1 vssd1 vccd1 vccd1 sky130_fd_sc_hd__fill_2
XFILLER_82_340 vssd1 vssd1 vccd1 vccd1 sky130_fd_sc_hd__fill_4
XFILLER_43_727 vssd1 vssd1 vccd1 vccd1 sky130_fd_sc_hd__fill_1
X_06868_ FPGA_INST.bus2_0\[12\] FPGA_INST.bus2_0\[14\] FPGA_INST.bus2_0\[13\] FPGA_INST.bus2_0\[15\]
+ net423 net425 vssd1 vssd1 vccd1 vccd1 _03136_ sky130_fd_sc_hd__mux4_1
X_09587_ FPGA_INST.cell1.CB_1.config_dataB\[16\] FPGA_INST.cell1.CB_1.config_dataB\[15\]
+ net334 vssd1 vssd1 vccd1 vccd1 _00496_ sky130_fd_sc_hd__mux2_1
XTAP_TAPCELL_ROW_87_1499 vssd1 vccd1 sky130_fd_sc_hd__tapvpwrvgnd_1
X_06799_ FPGA_INST.cell2.CB_1.config_dataB\[18\] _03069_ _03072_ _03065_ vssd1 vssd1
+ vccd1 vccd1 _03073_ sky130_fd_sc_hd__or4b_1
X_05819_ net165 net161 vssd1 vssd1 vccd1 vccd1 _02099_ sky130_fd_sc_hd__nor2_1
X_08538_ net90 net84 net82 _01792_ FPGA_INST.cell3.LEI0.config_data\[21\] FPGA_INST.cell3.LEI0.config_data\[22\]
+ vssd1 vssd1 vccd1 vccd1 _04749_ sky130_fd_sc_hd__mux4_1
XANTENNA__08078__A3 FPGA_INST.bus3_1\[3\] vssd1 vssd1 vccd1 vccd1 sky130_fd_sc_hd__diode_2
X_08469_ net151 net145 net149 net142 FPGA_INST.cell1.LEI0.config_data\[21\] FPGA_INST.cell1.LEI0.config_data\[22\]
+ vssd1 vssd1 vccd1 vccd1 _04685_ sky130_fd_sc_hd__mux4_1
XFILLER_23_473 vssd1 vssd1 vccd1 vccd1 sky130_fd_sc_hd__fill_1
XFILLER_128_309 vssd1 vssd1 vccd1 vccd1 sky130_fd_sc_hd__fill_1
XFILLER_50_292 vssd1 vssd1 vccd1 vccd1 sky130_fd_sc_hd__fill_2
X_10500_ FPGA_INST.cell2.SB0.route_sel\[72\] FPGA_INST.cell2.SB0.route_sel\[73\] net260
+ vssd1 vssd1 vccd1 vccd1 _01379_ sky130_fd_sc_hd__mux2_1
XANTENNA__07038__A1 FPGA_INST.bus2_0\[4\] vssd1 vssd1 vccd1 vccd1 sky130_fd_sc_hd__diode_2
X_11480_ net746 _00830_ net531 vssd1 vssd1 vccd1 vccd1 FPGA_INST.cell0.LE_1A.config_data\[7\]
+ sky130_fd_sc_hd__dfrtp_1
XANTENNA__09200__S net361 vssd1 vssd1 vccd1 vccd1 sky130_fd_sc_hd__diode_2
X_10431_ FPGA_INST.cell2.SB0.route_sel\[4\] FPGA_INST.cell2.SB0.route_sel\[3\] net322
+ vssd1 vssd1 vccd1 vccd1 _01310_ sky130_fd_sc_hd__mux2_1
X_10362_ FPGA_INST.cell3.LE_0B.config_data\[3\] FPGA_INST.cell3.LE_0B.config_data\[4\]
+ net301 vssd1 vssd1 vccd1 vccd1 _01242_ sky130_fd_sc_hd__mux2_1
XFILLER_12_85 vssd1 vssd1 vccd1 vccd1 sky130_fd_sc_hd__fill_8
XFILLER_124_537 vssd1 vssd1 vccd1 vccd1 sky130_fd_sc_hd__fill_2
X_10293_ FPGA_INST.cell3.LEI0.config_data\[7\] FPGA_INST.cell3.LEI0.config_data\[8\]
+ net303 vssd1 vssd1 vccd1 vccd1 _01174_ sky130_fd_sc_hd__mux2_1
X_12101_ net930 _01447_ net714 vssd1 vssd1 vccd1 vccd1 FPGA_INST.cell3.CB_0.config_dataA\[13\]
+ sky130_fd_sc_hd__dfstp_1
XFILLER_2_311 vssd1 vssd1 vccd1 vccd1 sky130_fd_sc_hd__fill_4
XANTENNA__08538__A1 net84 vssd1 vssd1 vccd1 vccd1 sky130_fd_sc_hd__diode_2
XFILLER_105_762 vssd1 vssd1 vccd1 vccd1 sky130_fd_sc_hd__fill_8
XFILLER_88_89 vssd1 vssd1 vccd1 vccd1 sky130_fd_sc_hd__fill_2
X_12032_ net858 _01378_ net643 vssd1 vssd1 vccd1 vccd1 FPGA_INST.cell2.SB0.route_sel\[72\]
+ sky130_fd_sc_hd__dfstp_1
XFILLER_120_732 vssd1 vssd1 vccd1 vccd1 sky130_fd_sc_hd__fill_1
XFILLER_105_795 vssd1 vssd1 vccd1 vccd1 sky130_fd_sc_hd__fill_4
XFILLER_104_261 vssd1 vssd1 vccd1 vccd1 sky130_fd_sc_hd__fill_4
XFILLER_104_250 vssd1 vssd1 vccd1 vccd1 sky130_fd_sc_hd__fill_2
XANTENNA__10081__S net173 vssd1 vssd1 vccd1 vccd1 sky130_fd_sc_hd__diode_2
XTAP_TAPCELL_ROW_129_2083 vssd1 vccd1 sky130_fd_sc_hd__tapvpwrvgnd_1
XFILLER_120_798 vssd1 vssd1 vccd1 vccd1 sky130_fd_sc_hd__fill_1
Xfanout692 net693 vssd1 vssd1 vccd1 vccd1 net692 sky130_fd_sc_hd__clkbuf_4
Xfanout681 net682 vssd1 vssd1 vccd1 vccd1 net681 sky130_fd_sc_hd__clkbuf_4
Xfanout670 net675 vssd1 vssd1 vccd1 vccd1 net670 sky130_fd_sc_hd__clkbuf_2
XTAP_TAPCELL_ROW_129_2094 vssd1 vccd1 sky130_fd_sc_hd__tapvpwrvgnd_1
XFILLER_92_159 vssd1 vssd1 vccd1 vccd1 sky130_fd_sc_hd__fill_4
XPHY_EDGE_ROW_16_Right_16 vssd1 vssd1 vccd1 vccd1 sky130_fd_sc_hd__decap_3
XFILLER_18_256 vssd1 vssd1 vccd1 vccd1 sky130_fd_sc_hd__fill_1
XFILLER_73_373 vssd1 vssd1 vccd1 vccd1 sky130_fd_sc_hd__fill_4
X_11816_ net872 _01162_ net656 vssd1 vssd1 vccd1 vccd1 net41 sky130_fd_sc_hd__dfrtp_1
X_11747_ net894 _01093_ net678 vssd1 vssd1 vccd1 vccd1 FPGA_INST.cell3.SB0.route_sel\[117\]
+ sky130_fd_sc_hd__dfstp_1
XTAP_TAPCELL_ROW_60_1116 vssd1 vccd1 sky130_fd_sc_hd__tapvpwrvgnd_1
XTAP_TAPCELL_ROW_60_1127 vssd1 vccd1 sky130_fd_sc_hd__tapvpwrvgnd_1
XFILLER_41_281 vssd1 vssd1 vccd1 vccd1 sky130_fd_sc_hd__fill_2
X_11678_ net905 _01024_ net689 vssd1 vssd1 vccd1 vccd1 FPGA_INST.cell3.SB0.route_sel\[48\]
+ sky130_fd_sc_hd__dfstp_1
XTAP_TAPCELL_ROW_116_1905 vssd1 vccd1 sky130_fd_sc_hd__tapvpwrvgnd_1
X_10629_ FPGA_INST.cell3.CB_1.config_dataA\[24\] FPGA_INST.cell3.CB_1.config_dataA\[23\]
+ net371 vssd1 vssd1 vccd1 vccd1 _01508_ sky130_fd_sc_hd__mux2_1
XPHY_EDGE_ROW_25_Right_25 vssd1 vssd1 vccd1 vccd1 sky130_fd_sc_hd__decap_3
XANTENNA__08777__B2 _04846_ vssd1 vssd1 vccd1 vccd1 sky130_fd_sc_hd__diode_2
XANTENNA__08777__A1 _04843_ vssd1 vssd1 vccd1 vccd1 sky130_fd_sc_hd__diode_2
XFILLER_6_672 vssd1 vssd1 vccd1 vccd1 sky130_fd_sc_hd__fill_1
XFILLER_115_559 vssd1 vssd1 vccd1 vccd1 sky130_fd_sc_hd__fill_1
XFILLER_130_507 vssd1 vssd1 vccd1 vccd1 sky130_fd_sc_hd__fill_1
XFILLER_102_209 vssd1 vssd1 vccd1 vccd1 sky130_fd_sc_hd__fill_1
XTAP_TAPCELL_ROW_58_1089 vssd1 vccd1 sky130_fd_sc_hd__tapvpwrvgnd_1
XFILLER_45_3 vssd1 vssd1 vccd1 vccd1 sky130_fd_sc_hd__fill_8
XFILLER_123_581 vssd1 vssd1 vccd1 vccd1 sky130_fd_sc_hd__fill_8
XFILLER_96_421 vssd1 vssd1 vccd1 vccd1 sky130_fd_sc_hd__fill_1
XTAP_TAPCELL_ROW_71_1278 vssd1 vccd1 sky130_fd_sc_hd__tapvpwrvgnd_1
XFILLER_69_679 vssd1 vssd1 vccd1 vccd1 sky130_fd_sc_hd__fill_8
X_07840_ _04073_ net136 _02323_ vssd1 vssd1 vccd1 vccd1 net49 sky130_fd_sc_hd__mux2_1
XFILLER_110_253 vssd1 vssd1 vccd1 vccd1 sky130_fd_sc_hd__fill_4
X_07771_ _03530_ _04019_ _03940_ vssd1 vssd1 vccd1 vccd1 _04021_ sky130_fd_sc_hd__or3b_1
XFILLER_56_307 vssd1 vssd1 vccd1 vccd1 sky130_fd_sc_hd__fill_1
X_09510_ FPGA_INST.cell1.LE_0A.config_data\[5\] FPGA_INST.cell1.LE_0A.config_data\[6\]
+ net229 vssd1 vssd1 vccd1 vccd1 _00421_ sky130_fd_sc_hd__mux2_1
XFILLER_83_137 vssd1 vssd1 vccd1 vccd1 sky130_fd_sc_hd__fill_2
XFILLER_77_690 vssd1 vssd1 vccd1 vccd1 sky130_fd_sc_hd__fill_2
X_06722_ _01796_ _01800_ _01801_ _01799_ net516 net517 vssd1 vssd1 vccd1 vccd1 _02996_
+ sky130_fd_sc_hd__mux4_1
XANTENNA__05763__A1 net134 vssd1 vssd1 vccd1 vccd1 sky130_fd_sc_hd__diode_2
XPHY_EDGE_ROW_34_Right_34 vssd1 vssd1 vccd1 vccd1 sky130_fd_sc_hd__decap_3
X_09441_ FPGA_INST.cell2.LE_1B.config_data\[9\] FPGA_INST.cell2.LE_1B.config_data\[10\]
+ net291 vssd1 vssd1 vccd1 vccd1 _00354_ sky130_fd_sc_hd__mux2_1
X_06653_ net475 _02775_ vssd1 vssd1 vccd1 vccd1 _02929_ sky130_fd_sc_hd__nand2_1
XFILLER_25_738 vccd1 vssd1 vccd1 vssd1 sky130_ef_sc_hd__decap_40_12
X_06584_ FPGA_INST.bus3_2\[8\] FPGA_INST.bus3_2\[10\] FPGA_INST.bus3_2\[9\] FPGA_INST.bus3_2\[11\]
+ net482 net484 vssd1 vssd1 vccd1 vccd1 _02860_ sky130_fd_sc_hd__mux4_1
X_05604_ _01606_ _01607_ _01874_ _01883_ _01872_ vssd1 vssd1 vccd1 vccd1 _01884_ sky130_fd_sc_hd__o221a_1
X_09372_ net499 net500 net351 vssd1 vssd1 vccd1 vccd1 _00285_ sky130_fd_sc_hd__mux2_1
XFILLER_24_248 vssd1 vssd1 vccd1 vccd1 sky130_fd_sc_hd__fill_2
XTAP_TAPCELL_ROW_35_766 vssd1 vccd1 sky130_fd_sc_hd__tapvpwrvgnd_1
X_08323_ net448 _04040_ vssd1 vssd1 vccd1 vccd1 _04545_ sky130_fd_sc_hd__nand2_1
X_05535_ FPGA_INST.cell0.CB_0.config_dataA\[24\] FPGA_INST.cell0.CB_0.config_dataA\[20\]
+ FPGA_INST.cell0.CB_0.config_dataA\[21\] vssd1 vssd1 vccd1 vccd1 _01815_ sky130_fd_sc_hd__or3b_2
XTAP_TAPCELL_ROW_35_777 vssd1 vccd1 sky130_fd_sc_hd__tapvpwrvgnd_1
XANTENNA__07600__Y _03854_ vssd1 vssd1 vccd1 vccd1 sky130_fd_sc_hd__diode_2
XANTENNA_fanout237_A net241 vssd1 vssd1 vccd1 vccd1 sky130_fd_sc_hd__diode_2
X_08254_ net402 _04476_ _04477_ vssd1 vssd1 vccd1 vccd1 _04478_ sky130_fd_sc_hd__a21oi_1
XPHY_EDGE_ROW_43_Right_43 vssd1 vssd1 vccd1 vccd1 sky130_fd_sc_hd__decap_3
XTAP_TAPCELL_ROW_15_490 vssd1 vccd1 sky130_fd_sc_hd__tapvpwrvgnd_1
X_05466_ FPGA_INST.cell0.CB_0.config_dataB\[18\] vssd1 vssd1 vccd1 vccd1 _01748_ sky130_fd_sc_hd__inv_2
X_05397_ FPGA_INST.cell3.SB0.route_sel\[41\] vssd1 vssd1 vccd1 vccd1 _01679_ sky130_fd_sc_hd__inv_2
X_07205_ FPGA_INST.cell1.CB_1.config_dataA\[24\] FPGA_INST.cell1.CB_1.config_dataA\[21\]
+ FPGA_INST.cell1.CB_1.config_dataA\[20\] vssd1 vssd1 vccd1 vccd1 _03468_ sky130_fd_sc_hd__or3b_4
X_08185_ FPGA_INST.cell0.LEI0.config_data\[8\] _04408_ _04406_ vssd1 vssd1 vccd1 vccd1
+ _04409_ sky130_fd_sc_hd__o21ai_1
X_07136_ FPGA_INST.cell1.CB_0.config_dataB\[23\] FPGA_INST.cell1.CB_0.config_dataB\[22\]
+ vssd1 vssd1 vccd1 vccd1 _03400_ sky130_fd_sc_hd__nor2_2
XPHY_EDGE_ROW_18_Left_149 vssd1 vssd1 vccd1 vccd1 sky130_fd_sc_hd__decap_3
X_07067_ net430 _02070_ vssd1 vssd1 vccd1 vccd1 _03333_ sky130_fd_sc_hd__nand2_1
X_06018_ FPGA_INST.cell0.SB0.route_sel\[40\] FPGA_INST.cell0.SB0.route_sel\[41\] vssd1
+ vssd1 vccd1 vccd1 _02298_ sky130_fd_sc_hd__nand2_1
XFILLER_87_410 vssd1 vssd1 vccd1 vccd1 sky130_fd_sc_hd__fill_8
XANTENNA__06794__A3 FPGA_INST.bus3_2\[7\] vssd1 vssd1 vccd1 vccd1 sky130_fd_sc_hd__diode_2
XFILLER_58_26 vssd1 vssd1 vccd1 vccd1 sky130_fd_sc_hd__fill_2
XFILLER_102_732 vccd1 vssd1 vccd1 vssd1 sky130_ef_sc_hd__decap_40_12
XFILLER_114_43 vssd1 vssd1 vccd1 vccd1 sky130_fd_sc_hd__fill_1
XTAP_TAPCELL_ROW_89_1528 vssd1 vccd1 sky130_fd_sc_hd__tapvpwrvgnd_1
XPHY_EDGE_ROW_52_Right_52 vssd1 vssd1 vccd1 vccd1 sky130_fd_sc_hd__decap_3
XANTENNA_fanout940_A net945 vssd1 vssd1 vccd1 vccd1 sky130_fd_sc_hd__diode_2
X_07969_ _03613_ _04188_ _04189_ _03652_ vssd1 vssd1 vccd1 vccd1 _04197_ sky130_fd_sc_hd__o2bb2a_1
XFILLER_74_25 vssd1 vssd1 vccd1 vccd1 sky130_fd_sc_hd__fill_2
XANTENNA_fanout561_X net561 vssd1 vssd1 vccd1 vccd1 sky130_fd_sc_hd__diode_2
XFILLER_28_521 vssd1 vssd1 vccd1 vccd1 sky130_fd_sc_hd__fill_2
X_09708_ FPGA_INST.cell0.SB0.route_sel\[112\] FPGA_INST.cell0.SB0.route_sel\[111\]
+ net324 vssd1 vssd1 vccd1 vccd1 _00617_ sky130_fd_sc_hd__mux2_1
X_10980_ net888 _00330_ net672 vssd1 vssd1 vccd1 vccd1 FPGA_INST.cell2.CB_1.config_dataA\[11\]
+ sky130_fd_sc_hd__dfstp_1
XFILLER_43_502 vssd1 vssd1 vccd1 vccd1 sky130_fd_sc_hd__fill_2
XFILLER_83_682 vssd1 vssd1 vccd1 vccd1 sky130_fd_sc_hd__fill_1
XFILLER_43_535 vssd1 vssd1 vccd1 vccd1 sky130_fd_sc_hd__fill_8
XFILLER_43_524 vssd1 vssd1 vccd1 vccd1 sky130_fd_sc_hd__fill_2
XPHY_EDGE_ROW_27_Left_158 vssd1 vssd1 vccd1 vccd1 sky130_fd_sc_hd__decap_3
X_09639_ FPGA_INST.cell0.SB0.route_sel\[42\] FPGA_INST.cell0.SB0.route_sel\[43\] net185
+ vssd1 vssd1 vccd1 vccd1 _00548_ sky130_fd_sc_hd__mux2_1
XFILLER_130_42 vccd1 vssd1 vccd1 vssd1 sky130_ef_sc_hd__decap_40_12
XFILLER_130_64 vssd1 vssd1 vccd1 vccd1 sky130_fd_sc_hd__fill_4
XFILLER_70_365 vssd1 vssd1 vccd1 vccd1 sky130_fd_sc_hd__fill_8
X_11601_ net797 _00951_ net582 vssd1 vssd1 vccd1 vccd1 FPGA_INST.cell0.CB_1.config_dataA\[20\]
+ sky130_fd_sc_hd__dfstp_1
XPHY_EDGE_ROW_61_Right_61 vssd1 vssd1 vccd1 vccd1 sky130_fd_sc_hd__decap_3
X_11532_ net756 _00882_ net541 vssd1 vssd1 vccd1 vccd1 FPGA_INST.cell0.CB_0.config_dataA\[1\]
+ sky130_fd_sc_hd__dfstp_1
XANTENNA__08208__A0 FPGA_INST.bus1_0\[14\] vssd1 vssd1 vccd1 vccd1 sky130_fd_sc_hd__diode_2
X_11463_ net771 _00813_ net556 vssd1 vssd1 vccd1 vccd1 FPGA_INST.cell0.LE_0B.config_data\[12\]
+ sky130_fd_sc_hd__dfrtp_1
X_10414_ FPGA_INST.cell3.CB_1.config_dataB\[12\] FPGA_INST.cell3.CB_1.config_dataB\[11\]
+ net372 vssd1 vssd1 vccd1 vccd1 _01293_ sky130_fd_sc_hd__mux2_1
XPHY_EDGE_ROW_36_Left_167 vssd1 vssd1 vccd1 vccd1 sky130_fd_sc_hd__decap_3
X_11394_ net743 _00744_ net528 vssd1 vssd1 vccd1 vccd1 FPGA_INST.cell0.LEI0.config_data\[15\]
+ sky130_fd_sc_hd__dfrtp_1
XFILLER_124_345 vssd1 vssd1 vccd1 vccd1 sky130_fd_sc_hd__fill_8
XFILLER_97_207 vssd1 vssd1 vccd1 vccd1 sky130_fd_sc_hd__fill_1
X_10345_ FPGA_INST.cell3.LE_0A.config_data\[9\] FPGA_INST.cell3.LE_0A.config_data\[10\]
+ net292 vssd1 vssd1 vccd1 vccd1 _01226_ sky130_fd_sc_hd__mux2_1
XFILLER_124_389 vssd1 vssd1 vccd1 vccd1 sky130_fd_sc_hd__fill_2
XTAP_TAPCELL_ROW_111_1835 vssd1 vccd1 sky130_fd_sc_hd__tapvpwrvgnd_1
XPHY_EDGE_ROW_70_Right_70 vssd1 vssd1 vccd1 vccd1 sky130_fd_sc_hd__decap_3
X_10276_ net35 net36 net253 vssd1 vssd1 vccd1 vccd1 _01157_ sky130_fd_sc_hd__mux2_1
XFILLER_2_141 vssd1 vssd1 vccd1 vccd1 sky130_fd_sc_hd__fill_4
X_12015_ net777 _01361_ net563 vssd1 vssd1 vccd1 vccd1 FPGA_INST.cell2.SB0.route_sel\[55\]
+ sky130_fd_sc_hd__dfstp_1
XANTENNA__12108__SET_B net701 vssd1 vssd1 vccd1 vccd1 sky130_fd_sc_hd__diode_2
XFILLER_65_104 vssd1 vssd1 vccd1 vccd1 sky130_fd_sc_hd__fill_1
XFILLER_78_498 vssd1 vssd1 vccd1 vccd1 sky130_fd_sc_hd__fill_2
XPHY_EDGE_ROW_45_Left_176 vssd1 vssd1 vccd1 vccd1 sky130_fd_sc_hd__decap_3
XFILLER_80_118 vssd1 vssd1 vccd1 vccd1 sky130_fd_sc_hd__fill_1
XFILLER_0_55 vssd1 vssd1 vccd1 vccd1 sky130_fd_sc_hd__fill_1
XTAP_TAPCELL_ROW_122_1997 vssd1 vccd1 sky130_fd_sc_hd__tapvpwrvgnd_1
XTAP_TAPCELL_ROW_122_1986 vssd1 vccd1 sky130_fd_sc_hd__tapvpwrvgnd_1
X_05320_ FPGA_INST.cell3.SB0.route_sel\[124\] vssd1 vssd1 vccd1 vccd1 _01602_ sky130_fd_sc_hd__inv_2
XFILLER_21_229 vssd1 vssd1 vccd1 vccd1 sky130_fd_sc_hd__fill_1
XTAP_TAPCELL_ROW_32_725 vssd1 vccd1 sky130_fd_sc_hd__tapvpwrvgnd_1
XTAP_TAPCELL_ROW_32_736 vssd1 vccd1 sky130_fd_sc_hd__tapvpwrvgnd_1
XFILLER_9_97 vssd1 vssd1 vccd1 vccd1 sky130_fd_sc_hd__fill_4
XPHY_EDGE_ROW_54_Left_185 vssd1 vssd1 vccd1 vccd1 sky130_fd_sc_hd__decap_3
X_05251_ FPGA_INST.cell2.CB_0.config_dataA\[12\] vssd1 vssd1 vccd1 vccd1 _01533_ sky130_fd_sc_hd__inv_2
XANTENNA__06473__A2 net16 vssd1 vssd1 vccd1 vccd1 sky130_fd_sc_hd__diode_2
XFILLER_127_172 vssd1 vssd1 vccd1 vccd1 sky130_fd_sc_hd__fill_2
X_09990_ _05236_ _05238_ vssd1 vssd1 vccd1 vccd1 _00877_ sky130_fd_sc_hd__and2_1
XTAP_TAPCELL_ROW_73_1307 vssd1 vccd1 sky130_fd_sc_hd__tapvpwrvgnd_1
XANTENNA__05875__Y _02155_ vssd1 vssd1 vccd1 vccd1 sky130_fd_sc_hd__diode_2
XANTENNA__07973__A2 _03854_ vssd1 vssd1 vccd1 vccd1 sky130_fd_sc_hd__diode_2
X_08941_ FPGA_INST.cell1.SB0.route_sel\[83\] FPGA_INST.cell1.SB0.route_sel\[82\] vssd1
+ vssd1 vccd1 vccd1 _05134_ sky130_fd_sc_hd__nand2b_1
X_08872_ net20 net21 net386 vssd1 vssd1 vccd1 vccd1 _05079_ sky130_fd_sc_hd__mux2_1
XFILLER_69_421 vssd1 vssd1 vccd1 vccd1 sky130_fd_sc_hd__fill_2
X_07823_ _04064_ net137 _02002_ vssd1 vssd1 vccd1 vccd1 net57 sky130_fd_sc_hd__mux2_1
XFILLER_28_29 vssd1 vssd1 vccd1 vccd1 sky130_fd_sc_hd__fill_4
XPHY_EDGE_ROW_63_Left_194 vssd1 vssd1 vccd1 vccd1 sky130_fd_sc_hd__decap_3
XANTENNA__06933__A0 FPGA_INST.bus2_0\[12\] vssd1 vssd1 vccd1 vccd1 sky130_fd_sc_hd__diode_2
X_07754_ net140 _04002_ _04003_ vssd1 vssd1 vccd1 vccd1 _04004_ sky130_fd_sc_hd__o21ai_1
X_07685_ FPGA_INST.cell3.SB0.route_sel\[102\] FPGA_INST.cell3.SB0.route_sel\[103\]
+ _03935_ _03936_ vssd1 vssd1 vccd1 vccd1 _03937_ sky130_fd_sc_hd__a211o_1
XFILLER_65_693 vssd1 vssd1 vccd1 vccd1 sky130_fd_sc_hd__fill_1
XFILLER_65_671 vssd1 vssd1 vccd1 vccd1 sky130_fd_sc_hd__fill_1
X_06705_ FPGA_INST.bus3_2\[4\] FPGA_INST.bus3_2\[5\] FPGA_INST.bus3_2\[6\] FPGA_INST.bus3_2\[7\]
+ net520 net519 vssd1 vssd1 vccd1 vccd1 _02979_ sky130_fd_sc_hd__mux4_1
XTAP_TAPCELL_ROW_84_1458 vssd1 vccd1 sky130_fd_sc_hd__tapvpwrvgnd_1
XANTENNA_fanout354_A net355 vssd1 vssd1 vccd1 vccd1 sky130_fd_sc_hd__diode_2
X_09424_ FPGA_INST.cell2.CB_1.config_dataA\[18\] FPGA_INST.cell2.CB_1.config_dataA\[17\]
+ net354 vssd1 vssd1 vccd1 vccd1 _00337_ sky130_fd_sc_hd__mux2_1
X_06636_ FPGA_INST.cell2.LE_1A.config_data\[7\] FPGA_INST.cell2.LE_1A.config_data\[6\]
+ _02878_ vssd1 vssd1 vccd1 vccd1 _02912_ sky130_fd_sc_hd__mux2_1
XFILLER_52_387 vssd1 vssd1 vccd1 vccd1 sky130_fd_sc_hd__fill_8
XFILLER_100_23 vssd1 vssd1 vccd1 vccd1 sky130_fd_sc_hd__fill_4
X_09355_ FPGA_INST.cell1.SB0.config_data_out FPGA_INST.cell1.SB0.route_sel\[126\]
+ net353 vssd1 vssd1 vccd1 vccd1 _00268_ sky130_fd_sc_hd__mux2_1
X_06567_ _02121_ _02127_ _02842_ vssd1 vssd1 vccd1 vccd1 _02843_ sky130_fd_sc_hd__or3b_4
X_09286_ FPGA_INST.cell1.SB0.route_sel\[58\] FPGA_INST.cell1.SB0.route_sel\[57\] net329
+ vssd1 vssd1 vccd1 vccd1 _00199_ sky130_fd_sc_hd__mux2_1
X_05518_ FPGA_INST.bus3_2\[10\] vssd1 vssd1 vccd1 vccd1 _01800_ sky130_fd_sc_hd__inv_2
XFILLER_60_27 vssd1 vssd1 vccd1 vccd1 sky130_fd_sc_hd__fill_1
XANTENNA__05779__A net170 vssd1 vssd1 vccd1 vccd1 sky130_fd_sc_hd__diode_2
X_08306_ _04519_ _04521_ _04524_ _04527_ vssd1 vssd1 vccd1 vccd1 _04528_ sky130_fd_sc_hd__a22o_1
X_06498_ _01554_ FPGA_INST.cell2.SB0.route_sel\[25\] FPGA_INST.cell2.SB0.route_sel\[30\]
+ _01555_ _02773_ vssd1 vssd1 vccd1 vccd1 _02774_ sky130_fd_sc_hd__a221o_1
X_08237_ FPGA_INST.bus1_0\[10\] FPGA_INST.bus1_0\[11\] net407 vssd1 vssd1 vccd1 vccd1
+ _04461_ sky130_fd_sc_hd__mux2_1
XTAP_TAPCELL_ROW_10_419 vssd1 vccd1 sky130_fd_sc_hd__tapvpwrvgnd_1
X_05449_ FPGA_INST.cell0.CB_0.config_dataA\[4\] vssd1 vssd1 vccd1 vccd1 _01731_ sky130_fd_sc_hd__inv_2
X_08168_ net411 _04390_ _04391_ vssd1 vssd1 vccd1 vccd1 _04392_ sky130_fd_sc_hd__a21oi_1
X_08099_ _03932_ _04300_ _04323_ _04324_ vssd1 vssd1 vccd1 vccd1 _04325_ sky130_fd_sc_hd__a211o_1
XFILLER_106_367 vssd1 vssd1 vccd1 vccd1 sky130_fd_sc_hd__fill_1
XFILLER_69_25 vssd1 vssd1 vccd1 vccd1 sky130_fd_sc_hd__fill_4
X_07119_ FPGA_INST.cell0.LE_0A.config_data\[11\] FPGA_INST.cell0.LE_0A.config_data\[10\]
+ _03313_ vssd1 vssd1 vccd1 vccd1 _03385_ sky130_fd_sc_hd__mux2_1
X_10130_ FPGA_INST.cell3.SB0.route_sel\[34\] FPGA_INST.cell3.SB0.route_sel\[35\] net278
+ vssd1 vssd1 vccd1 vccd1 _01011_ sky130_fd_sc_hd__mux2_1
XANTENNA__07964__A2 FPGA_INST.bus3_1\[2\] vssd1 vssd1 vccd1 vccd1 sky130_fd_sc_hd__diode_2
XFILLER_125_42 vccd1 vssd1 vccd1 vssd1 sky130_ef_sc_hd__decap_40_12
XFILLER_88_752 vssd1 vssd1 vccd1 vccd1 sky130_fd_sc_hd__fill_1
X_10061_ net405 net406 net327 vssd1 vssd1 vccd1 vccd1 _00942_ sky130_fd_sc_hd__mux2_1
XFILLER_0_645 vssd1 vssd1 vccd1 vccd1 sky130_fd_sc_hd__fill_1
XFILLER_48_627 vssd1 vssd1 vccd1 vccd1 sky130_fd_sc_hd__fill_1
XFILLER_85_57 vccd1 vssd1 vccd1 vssd1 sky130_ef_sc_hd__decap_40_12
XTAP_TAPCELL_ROW_126_2053 vssd1 vccd1 sky130_fd_sc_hd__tapvpwrvgnd_1
XTAP_TAPCELL_ROW_126_2042 vssd1 vccd1 sky130_fd_sc_hd__tapvpwrvgnd_1
XFILLER_75_468 vssd1 vssd1 vccd1 vccd1 sky130_fd_sc_hd__fill_8
XFILLER_90_427 vssd1 vssd1 vccd1 vccd1 sky130_fd_sc_hd__fill_1
X_10963_ net866 _00313_ net653 vssd1 vssd1 vccd1 vccd1 FPGA_INST.cell2.CB_0.config_dataB\[19\]
+ sky130_fd_sc_hd__dfstp_1
X_10894_ net822 _00244_ net606 vssd1 vssd1 vccd1 vccd1 FPGA_INST.cell1.SB0.route_sel\[103\]
+ sky130_fd_sc_hd__dfstp_1
XFILLER_70_195 vssd1 vssd1 vccd1 vccd1 sky130_fd_sc_hd__fill_1
XFILLER_8_701 vssd1 vssd1 vccd1 vccd1 sky130_fd_sc_hd__fill_4
XFILLER_12_741 vssd1 vssd1 vccd1 vccd1 sky130_fd_sc_hd__fill_2
X_11515_ net767 _00865_ net552 vssd1 vssd1 vccd1 vccd1 FPGA_INST.cell0.CB_1.config_dataB\[21\]
+ sky130_fd_sc_hd__dfstp_1
XANTENNA__09595__S net336 vssd1 vssd1 vccd1 vccd1 sky130_fd_sc_hd__diode_2
X_11446_ net770 _00796_ net555 vssd1 vssd1 vccd1 vccd1 FPGA_INST.cell0.LE_0A.edge_mode
+ sky130_fd_sc_hd__dfstp_1
XANTENNA__08352__X _04574_ vssd1 vssd1 vccd1 vccd1 sky130_fd_sc_hd__diode_2
X_11377_ net835 _00727_ net619 vssd1 vssd1 vccd1 vccd1 FPGA_INST.cell1.LE_1B.reset_mode
+ sky130_fd_sc_hd__dfrtp_2
X_10328_ FPGA_INST.cell3.LEI0.config_data\[42\] FPGA_INST.cell3.LEI0.config_data\[43\]
+ net298 vssd1 vssd1 vccd1 vccd1 _01209_ sky130_fd_sc_hd__mux2_1
XTAP_TAPCELL_ROW_55_1048 vssd1 vccd1 sky130_fd_sc_hd__tapvpwrvgnd_1
XTAP_TAPCELL_ROW_55_1059 vssd1 vccd1 sky130_fd_sc_hd__tapvpwrvgnd_1
XFILLER_78_262 vssd1 vssd1 vccd1 vccd1 sky130_fd_sc_hd__fill_1
X_10259_ FPGA_INST.io_east_oeb\[6\] FPGA_INST.io_east_oeb\[8\] net263 vssd1 vssd1
+ vccd1 vccd1 _01140_ sky130_fd_sc_hd__mux2_1
XANTENNA__06915__A0 FPGA_INST.bus2_0\[6\] vssd1 vssd1 vccd1 vccd1 sky130_fd_sc_hd__diode_2
XTAP_TAPCELL_ROW_37_806 vssd1 vccd1 sky130_fd_sc_hd__tapvpwrvgnd_1
XANTENNA__08132__A2 _04013_ vssd1 vssd1 vccd1 vccd1 sky130_fd_sc_hd__diode_2
XFILLER_46_181 vssd1 vssd1 vccd1 vccd1 sky130_fd_sc_hd__fill_1
X_07470_ FPGA_INST.cell1.SB0.route_sel\[60\] _01667_ FPGA_INST.cell1.SB0.route_sel\[63\]
+ _01668_ _03726_ vssd1 vssd1 vccd1 vccd1 _03727_ sky130_fd_sc_hd__a221o_1
XANTENNA__06983__A _02309_ vssd1 vssd1 vccd1 vccd1 sky130_fd_sc_hd__diode_2
XFILLER_61_173 vssd1 vssd1 vccd1 vccd1 sky130_fd_sc_hd__fill_1
X_06421_ net9 net10 net11 net13 net491 net490 vssd1 vssd1 vccd1 vccd1 _02699_ sky130_fd_sc_hd__mux4_1
X_09140_ FPGA_INST.cell2.LE_0A.config_data\[3\] FPGA_INST.cell2.LE_0A.config_data\[4\]
+ net237 vssd1 vssd1 vccd1 vccd1 _00055_ sky130_fd_sc_hd__mux2_1
X_06352_ _02293_ _02624_ _02629_ vssd1 vssd1 vccd1 vccd1 _02630_ sky130_fd_sc_hd__a21o_1
X_09071_ _03666_ _04845_ _03660_ vssd1 vssd1 vccd1 vccd1 _05203_ sky130_fd_sc_hd__a21o_1
X_05303_ FPGA_INST.cell2.SB0.route_sel\[124\] vssd1 vssd1 vccd1 vccd1 _01585_ sky130_fd_sc_hd__inv_2
X_06283_ net7 net8 net503 vssd1 vssd1 vccd1 vccd1 _02563_ sky130_fd_sc_hd__mux2_1
X_08022_ net456 net458 _03769_ _01728_ vssd1 vssd1 vccd1 vccd1 _04248_ sky130_fd_sc_hd__o31a_1
XFILLER_116_621 vssd1 vssd1 vccd1 vccd1 sky130_fd_sc_hd__fill_8
XFILLER_116_643 vssd1 vssd1 vccd1 vccd1 sky130_fd_sc_hd__fill_1
XANTENNA_fanout102_A net103 vssd1 vssd1 vccd1 vccd1 sky130_fd_sc_hd__diode_2
X_09973_ FPGA_INST.config_bits\[3\] _05221_ vssd1 vssd1 vccd1 vccd1 _05227_ sky130_fd_sc_hd__nor2_1
XFILLER_89_538 vssd1 vssd1 vccd1 vccd1 sky130_fd_sc_hd__fill_2
XANTENNA__06749__A3 FPGA_INST.bus3_2\[15\] vssd1 vssd1 vccd1 vccd1 sky130_fd_sc_hd__diode_2
XFILLER_1_409 vssd1 vssd1 vccd1 vccd1 sky130_fd_sc_hd__fill_1
X_08924_ FPGA_INST.cell1.SB0.route_sel\[99\] _01629_ FPGA_INST.cell1.SB0.route_sel\[97\]
+ FPGA_INST.cell1.SB0.route_sel\[96\] _05122_ vssd1 vssd1 vccd1 vccd1 _05123_ sky130_fd_sc_hd__o221a_1
XPHY_EDGE_ROW_71_Left_202 vssd1 vssd1 vccd1 vccd1 sky130_fd_sc_hd__decap_3
X_08855_ FPGA_INST.cell3.LEI0.config_data\[29\] _05061_ vssd1 vssd1 vccd1 vccd1 _05062_
+ sky130_fd_sc_hd__or2_1
XFILLER_85_733 vssd1 vssd1 vccd1 vccd1 sky130_fd_sc_hd__fill_1
X_08786_ _04809_ _04974_ _04975_ _04813_ _01776_ vssd1 vssd1 vccd1 vccd1 _04993_ sky130_fd_sc_hd__a221o_1
XFILLER_84_243 vssd1 vssd1 vccd1 vccd1 sky130_fd_sc_hd__fill_8
XANTENNA__07325__Y FPGA_INST.bus3_2\[3\] vssd1 vssd1 vccd1 vccd1 sky130_fd_sc_hd__diode_2
X_07806_ FPGA_INST.cell3.SB0.route_sel\[122\] FPGA_INST.cell3.SB0.route_sel\[123\]
+ _04052_ _04054_ _04028_ vssd1 vssd1 vccd1 vccd1 _04055_ sky130_fd_sc_hd__a41o_1
XPHY_EDGE_ROW_2_Right_2 vssd1 vssd1 vccd1 vccd1 sky130_fd_sc_hd__decap_3
XANTENNA__08659__A0 net18 vssd1 vssd1 vccd1 vccd1 sky130_fd_sc_hd__diode_2
X_07737_ _03984_ _03986_ vssd1 vssd1 vccd1 vccd1 _03987_ sky130_fd_sc_hd__nand2_1
X_05998_ _01946_ _02200_ vssd1 vssd1 vccd1 vccd1 _02278_ sky130_fd_sc_hd__nor2_1
XFILLER_38_660 vssd1 vssd1 vccd1 vccd1 sky130_fd_sc_hd__fill_1
XFILLER_38_682 vssd1 vssd1 vccd1 vccd1 sky130_fd_sc_hd__fill_4
XANTENNA__08123__A2 _03854_ vssd1 vssd1 vccd1 vccd1 sky130_fd_sc_hd__diode_2
XANTENNA_fanout736_A net28 vssd1 vssd1 vccd1 vccd1 sky130_fd_sc_hd__diode_2
XANTENNA_fanout357_X net357 vssd1 vssd1 vccd1 vccd1 sky130_fd_sc_hd__diode_2
XFILLER_37_181 vssd1 vssd1 vccd1 vccd1 sky130_fd_sc_hd__fill_4
X_07668_ FPGA_INST.cell0.SB0.route_sel\[100\] FPGA_INST.cell0.SB0.route_sel\[101\]
+ vssd1 vssd1 vccd1 vccd1 _03920_ sky130_fd_sc_hd__or2_1
XANTENNA__09871__A2 net522 vssd1 vssd1 vccd1 vccd1 sky130_fd_sc_hd__diode_2
XANTENNA_fanout524_X net524 vssd1 vssd1 vccd1 vccd1 sky130_fd_sc_hd__diode_2
X_07599_ FPGA_INST.cell1.SB0.route_sel\[84\] _01642_ FPGA_INST.cell1.SB0.route_sel\[87\]
+ _01643_ _03852_ vssd1 vssd1 vccd1 vccd1 _03853_ sky130_fd_sc_hd__a221o_2
XPHY_EDGE_ROW_80_Left_211 vssd1 vssd1 vccd1 vccd1 sky130_fd_sc_hd__decap_3
X_06619_ FPGA_INST.cell2.CB_1.config_dataA\[11\] _02892_ _02893_ _02894_ vssd1 vssd1
+ vccd1 vccd1 _02895_ sky130_fd_sc_hd__a31o_1
X_09407_ net482 net483 net362 vssd1 vssd1 vccd1 vccd1 _00320_ sky130_fd_sc_hd__mux2_1
X_09338_ FPGA_INST.cell1.SB0.route_sel\[109\] FPGA_INST.cell1.SB0.route_sel\[110\]
+ net226 vssd1 vssd1 vccd1 vccd1 _00251_ sky130_fd_sc_hd__mux2_1
XTAP_TAPCELL_ROW_23_599 vssd1 vccd1 sky130_fd_sc_hd__tapvpwrvgnd_1
XTAP_TAPCELL_ROW_97_1638 vssd1 vccd1 sky130_fd_sc_hd__tapvpwrvgnd_1
X_09269_ FPGA_INST.cell1.SB0.route_sel\[40\] FPGA_INST.cell1.SB0.route_sel\[41\] net207
+ vssd1 vssd1 vccd1 vccd1 _00182_ sky130_fd_sc_hd__mux2_1
X_11300_ net825 _00650_ net609 vssd1 vssd1 vccd1 vccd1 FPGA_INST.cell1.CB_0.config_dataA\[17\]
+ sky130_fd_sc_hd__dfstp_2
XFILLER_119_470 vssd1 vssd1 vccd1 vccd1 sky130_fd_sc_hd__fill_1
XFILLER_112_3 vccd1 vssd1 vccd1 vssd1 sky130_ef_sc_hd__decap_40_12
XANTENNA__08613__A _03583_ vssd1 vssd1 vccd1 vccd1 sky130_fd_sc_hd__diode_2
X_11231_ net761 _00581_ net546 vssd1 vssd1 vccd1 vccd1 FPGA_INST.cell0.SB0.route_sel\[76\]
+ sky130_fd_sc_hd__dfstp_1
XANTENNA__07937__A2 _03854_ vssd1 vssd1 vccd1 vccd1 sky130_fd_sc_hd__diode_2
X_11162_ net822 _00512_ net606 vssd1 vssd1 vccd1 vccd1 FPGA_INST.cell0.SB0.route_sel\[7\]
+ sky130_fd_sc_hd__dfstp_1
XFILLER_20_85 vssd1 vssd1 vccd1 vccd1 sky130_fd_sc_hd__fill_2
XFILLER_96_23 vssd1 vssd1 vccd1 vccd1 sky130_fd_sc_hd__fill_2
X_10113_ FPGA_INST.cell3.SB0.route_sel\[17\] FPGA_INST.cell3.SB0.route_sel\[18\] net269
+ vssd1 vssd1 vccd1 vccd1 _00994_ sky130_fd_sc_hd__mux2_1
X_11093_ net840 _00443_ net624 vssd1 vssd1 vccd1 vccd1 FPGA_INST.cell1.LE_0B.config_data\[6\]
+ sky130_fd_sc_hd__dfrtp_1
XANTENNA__08759__S _04860_ vssd1 vssd1 vccd1 vccd1 sky130_fd_sc_hd__diode_2
XFILLER_48_413 vssd1 vssd1 vccd1 vccd1 sky130_fd_sc_hd__fill_4
X_10044_ FPGA_INST.cell0.CB_0.config_dataB\[18\] FPGA_INST.cell0.CB_0.config_dataB\[19\]
+ net178 vssd1 vssd1 vccd1 vccd1 _00925_ sky130_fd_sc_hd__mux2_1
XFILLER_29_61 vssd1 vssd1 vccd1 vccd1 sky130_fd_sc_hd__fill_8
XFILLER_91_703 vssd1 vssd1 vccd1 vccd1 sky130_fd_sc_hd__fill_1
XFILLER_75_276 vssd1 vssd1 vccd1 vccd1 sky130_fd_sc_hd__fill_2
XFILLER_29_671 vssd1 vssd1 vccd1 vccd1 sky130_fd_sc_hd__fill_1
XFILLER_35_118 vssd1 vssd1 vccd1 vccd1 sky130_fd_sc_hd__fill_4
XFILLER_35_129 vssd1 vssd1 vccd1 vccd1 sky130_fd_sc_hd__fill_1
XPHY_EDGE_ROW_119_Left_250 vssd1 vssd1 vccd1 vccd1 sky130_fd_sc_hd__decap_3
XANTENNA__08114__A2 FPGA_INST.bus3_1\[2\] vssd1 vssd1 vccd1 vccd1 sky130_fd_sc_hd__diode_2
XFILLER_63_449 vssd1 vssd1 vccd1 vccd1 sky130_fd_sc_hd__fill_2
X_11995_ net789 _01341_ net574 vssd1 vssd1 vccd1 vccd1 FPGA_INST.cell2.SB0.route_sel\[35\]
+ sky130_fd_sc_hd__dfstp_1
XTAP_TAPCELL_ROW_106_1767 vssd1 vccd1 sky130_fd_sc_hd__tapvpwrvgnd_1
XFILLER_90_268 vssd1 vssd1 vccd1 vccd1 sky130_fd_sc_hd__fill_1
X_10946_ net863 _00296_ net648 vssd1 vssd1 vccd1 vccd1 FPGA_INST.cell2.CB_0.config_dataB\[2\]
+ sky130_fd_sc_hd__dfstp_2
XFILLER_16_365 vssd1 vssd1 vccd1 vccd1 sky130_fd_sc_hd__fill_1
XANTENNA__07873__A1 FPGA_INST.bus3_1\[13\] vssd1 vssd1 vccd1 vccd1 sky130_fd_sc_hd__diode_2
X_10877_ net792 _00227_ net577 vssd1 vssd1 vccd1 vccd1 FPGA_INST.cell1.SB0.route_sel\[86\]
+ sky130_fd_sc_hd__dfstp_1
XTAP_TAPCELL_ROW_42_864 vssd1 vccd1 sky130_fd_sc_hd__tapvpwrvgnd_1
XTAP_TAPCELL_ROW_42_875 vssd1 vccd1 sky130_fd_sc_hd__tapvpwrvgnd_1
XFILLER_8_531 vssd1 vssd1 vccd1 vccd1 sky130_fd_sc_hd__fill_1
XFILLER_129_245 vssd1 vssd1 vccd1 vccd1 sky130_fd_sc_hd__fill_2
XFILLER_8_542 vssd1 vssd1 vccd1 vccd1 sky130_fd_sc_hd__fill_1
XFILLER_12_593 vssd1 vssd1 vccd1 vccd1 sky130_fd_sc_hd__fill_1
XFILLER_6_54 vssd1 vssd1 vccd1 vccd1 sky130_fd_sc_hd__fill_1
X_11429_ net771 _00779_ net556 vssd1 vssd1 vccd1 vccd1 FPGA_INST.cell0.LE_0A.config_data\[0\]
+ sky130_fd_sc_hd__dfrtp_1
XFILLER_4_770 vssd1 vssd1 vccd1 vccd1 sky130_fd_sc_hd__fill_8
XANTENNA__05939__A1 net122 vssd1 vssd1 vccd1 vccd1 sky130_fd_sc_hd__diode_2
XFILLER_112_156 vssd1 vssd1 vccd1 vccd1 sky130_fd_sc_hd__fill_2
XFILLER_112_145 vssd1 vssd1 vccd1 vccd1 sky130_fd_sc_hd__fill_2
XANTENNA__06600__A2 net132 vssd1 vssd1 vccd1 vccd1 sky130_fd_sc_hd__diode_2
X_06970_ FPGA_INST.cell0.LE_0B.config_data\[13\] FPGA_INST.cell0.LE_0B.config_data\[12\]
+ _03159_ vssd1 vssd1 vccd1 vccd1 _03238_ sky130_fd_sc_hd__mux2_1
XFILLER_67_744 vssd1 vssd1 vccd1 vccd1 sky130_fd_sc_hd__fill_8
X_05921_ _01896_ _02200_ vssd1 vssd1 vccd1 vccd1 _02201_ sky130_fd_sc_hd__or2_1
XFILLER_39_413 vssd1 vssd1 vccd1 vccd1 sky130_fd_sc_hd__fill_8
X_08640_ net26 _01764_ net400 _04848_ vssd1 vssd1 vccd1 vccd1 _04849_ sky130_fd_sc_hd__o211a_1
XANTENNA__06697__B _02814_ vssd1 vssd1 vccd1 vccd1 sky130_fd_sc_hd__diode_2
X_05852_ net120 net168 _02014_ _02013_ _01918_ vssd1 vssd1 vccd1 vccd1 _02132_ sky130_fd_sc_hd__o32ai_2
XFILLER_82_725 vssd1 vssd1 vccd1 vccd1 sky130_fd_sc_hd__fill_2
XANTENNA__07561__B1 net130 vssd1 vssd1 vccd1 vccd1 sky130_fd_sc_hd__diode_2
XTAP_TAPCELL_ROW_68_1239 vssd1 vccd1 sky130_fd_sc_hd__tapvpwrvgnd_1
XTAP_TAPCELL_ROW_68_1228 vssd1 vccd1 sky130_fd_sc_hd__tapvpwrvgnd_1
XANTENNA__06903__A3 FPGA_INST.bus2_0\[15\] vssd1 vssd1 vccd1 vccd1 sky130_fd_sc_hd__diode_2
X_08571_ FPGA_INST.cell3.SB0.route_sel\[82\] FPGA_INST.cell3.SB0.route_sel\[83\] FPGA_INST.cell3.SB0.route_sel\[85\]
+ _01641_ _04779_ vssd1 vssd1 vccd1 vccd1 _04780_ sky130_fd_sc_hd__o221a_1
X_05783_ FPGA_INST.cell0.SB0.route_sel\[90\] FPGA_INST.cell0.SB0.route_sel\[91\] _02060_
+ _02061_ _02062_ vssd1 vssd1 vccd1 vccd1 _02063_ sky130_fd_sc_hd__a221o_1
XFILLER_35_641 vccd1 vssd1 vccd1 vssd1 sky130_ef_sc_hd__decap_40_12
X_07522_ _01655_ _01656_ _01792_ _03776_ _03777_ vssd1 vssd1 vccd1 vccd1 _03778_ sky130_fd_sc_hd__o221a_1
XFILLER_90_791 vssd1 vssd1 vccd1 vccd1 sky130_fd_sc_hd__fill_8
X_07453_ net146 _03548_ _03593_ _03709_ vssd1 vssd1 vccd1 vccd1 _03710_ sky130_fd_sc_hd__a31o_1
XTAP_TAPCELL_ROW_81_1417 vssd1 vccd1 sky130_fd_sc_hd__tapvpwrvgnd_1
XANTENNA__10439__S net351 vssd1 vssd1 vccd1 vccd1 sky130_fd_sc_hd__diode_2
X_06404_ _02680_ _02681_ FPGA_INST.cell2.CB_0.config_dataB\[2\] vssd1 vssd1 vccd1
+ vccd1 _02682_ sky130_fd_sc_hd__mux2_1
X_07384_ _03468_ _03607_ net141 vssd1 vssd1 vccd1 vccd1 _03643_ sky130_fd_sc_hd__o21ai_1
XFILLER_22_379 vssd1 vssd1 vccd1 vccd1 sky130_fd_sc_hd__fill_4
X_09123_ FPGA_INST.cell2.LEI0.config_data\[37\] FPGA_INST.cell2.LEI0.config_data\[38\]
+ net250 vssd1 vssd1 vccd1 vccd1 _00039_ sky130_fd_sc_hd__mux2_1
X_06335_ FPGA_INST.cell2.LE_0A.config_data\[11\] FPGA_INST.cell2.LE_0A.config_data\[10\]
+ _02536_ vssd1 vssd1 vccd1 vccd1 _02615_ sky130_fd_sc_hd__mux2_1
XANTENNA_fanout317_A net325 vssd1 vssd1 vccd1 vccd1 sky130_fd_sc_hd__diode_2
X_06266_ _02010_ _02540_ _02541_ _01966_ _01533_ vssd1 vssd1 vccd1 vccd1 _02546_ sky130_fd_sc_hd__a221o_1
X_09054_ net535 FPGA_INST.cell0.LE_1B.reset_mode vssd1 vssd1 vccd1 vccd1 _09054_/X
+ sky130_fd_sc_hd__xor2_2
XTAP_TAPCELL_ROW_20_558 vssd1 vccd1 sky130_fd_sc_hd__tapvpwrvgnd_1
XTAP_TAPCELL_ROW_20_569 vssd1 vccd1 sky130_fd_sc_hd__tapvpwrvgnd_1
X_08005_ _01727_ FPGA_INST.cell1.LE_0A.dff_out _04231_ net155 vssd1 vssd1 vccd1 vccd1
+ FPGA_INST.cell1.CB_0.le_outA sky130_fd_sc_hd__o211a_1
XFILLER_116_440 vssd1 vssd1 vccd1 vccd1 sky130_fd_sc_hd__fill_4
XANTENNA__09963__S net320 vssd1 vssd1 vccd1 vccd1 sky130_fd_sc_hd__diode_2
X_06197_ _02467_ _02469_ _02470_ _02476_ vssd1 vssd1 vccd1 vccd1 _02477_ sky130_fd_sc_hd__a211o_1
XFILLER_104_635 vssd1 vssd1 vccd1 vccd1 sky130_fd_sc_hd__fill_1
XTAP_TAPCELL_ROW_92_1568 vssd1 vccd1 sky130_fd_sc_hd__tapvpwrvgnd_1
XFILLER_89_335 vssd1 vssd1 vccd1 vccd1 sky130_fd_sc_hd__fill_1
XANTENNA_fanout686_A net702 vssd1 vssd1 vccd1 vccd1 sky130_fd_sc_hd__diode_2
XFILLER_103_167 vssd1 vssd1 vccd1 vccd1 sky130_fd_sc_hd__fill_1
X_09956_ FPGA_INST.cell0.CB_1.config_dataB\[17\] net438 net312 vssd1 vssd1 vccd1 vccd1
+ _00861_ sky130_fd_sc_hd__mux2_1
X_08907_ _04009_ _05111_ vssd1 vssd1 vccd1 vccd1 FPGA_INST.bus1_0\[14\] sky130_fd_sc_hd__nor2_4
XFILLER_58_733 vssd1 vssd1 vccd1 vccd1 sky130_fd_sc_hd__fill_2
X_09887_ FPGA_INST.cell0.LE_0A.config_data\[15\] FPGA_INST.cell0.LE_0A.config_data\[14\]
+ net318 vssd1 vssd1 vccd1 vccd1 _00794_ sky130_fd_sc_hd__mux2_1
X_08838_ net388 _04835_ vssd1 vssd1 vccd1 vccd1 _05045_ sky130_fd_sc_hd__nand2_1
XTAP_TAPCELL_ROW_123_2001 vssd1 vccd1 sky130_fd_sc_hd__tapvpwrvgnd_1
XANTENNA__06355__B2 net30 vssd1 vssd1 vccd1 vccd1 sky130_fd_sc_hd__diode_2
XANTENNA__06355__A1 net2 vssd1 vssd1 vccd1 vccd1 sky130_fd_sc_hd__diode_2
X_08769_ net389 _04973_ _04975_ _04831_ FPGA_INST.cell3.CB_0.config_dataB\[7\] vssd1
+ vssd1 vccd1 vccd1 _04976_ sky130_fd_sc_hd__a221oi_1
XFILLER_72_246 vssd1 vssd1 vccd1 vccd1 sky130_fd_sc_hd__fill_2
X_11780_ net931 _01126_ net715 vssd1 vssd1 vccd1 vccd1 FPGA_INST.io_south_oeb\[12\]
+ sky130_fd_sc_hd__dfrtp_1
X_10800_ net827 _00150_ net611 vssd1 vssd1 vccd1 vccd1 FPGA_INST.cell1.SB0.route_sel\[9\]
+ sky130_fd_sc_hd__dfstp_1
XFILLER_60_419 vssd1 vssd1 vccd1 vccd1 sky130_fd_sc_hd__fill_1
XTAP_TAPCELL_ROW_0_272 vssd1 vccd1 sky130_fd_sc_hd__tapvpwrvgnd_1
XTAP_TAPCELL_ROW_28_669 vssd1 vccd1 sky130_fd_sc_hd__tapvpwrvgnd_1
XTAP_TAPCELL_ROW_0_283 vssd1 vccd1 sky130_fd_sc_hd__tapvpwrvgnd_1
X_10731_ net869 _00081_ net654 vssd1 vssd1 vccd1 vccd1 FPGA_INST.cell2.LE_0B.config_data\[8\]
+ sky130_fd_sc_hd__dfrtp_1
XFILLER_40_132 vssd1 vssd1 vccd1 vccd1 sky130_fd_sc_hd__fill_8
XFILLER_40_143 vssd1 vssd1 vccd1 vccd1 sky130_fd_sc_hd__fill_1
X_10662_ net887 _00012_ net671 vssd1 vssd1 vccd1 vccd1 FPGA_INST.cell2.LEI0.config_data\[11\]
+ sky130_fd_sc_hd__dfrtp_1
XANTENNA__11995__CLK net789 vssd1 vssd1 vccd1 vccd1 sky130_fd_sc_hd__diode_2
XFILLER_9_339 vssd1 vssd1 vccd1 vccd1 sky130_fd_sc_hd__fill_4
X_10593_ FPGA_INST.cell3.CB_0.config_dataB\[13\] FPGA_INST.cell3.CB_0.config_dataB\[12\]
+ net377 vssd1 vssd1 vccd1 vccd1 _01472_ sky130_fd_sc_hd__mux2_1
XTAP_TAPCELL_ROW_101_1697 vssd1 vccd1 sky130_fd_sc_hd__tapvpwrvgnd_1
XFILLER_127_738 vssd1 vssd1 vccd1 vccd1 sky130_fd_sc_hd__fill_2
XFILLER_127_727 vssd1 vssd1 vccd1 vccd1 sky130_fd_sc_hd__fill_1
XANTENNA__08062__B _04049_ vssd1 vssd1 vccd1 vccd1 sky130_fd_sc_hd__diode_2
X_11214_ net765 _00564_ net550 vssd1 vssd1 vccd1 vccd1 FPGA_INST.cell0.SB0.route_sel\[59\]
+ sky130_fd_sc_hd__dfstp_1
XFILLER_122_421 vssd1 vssd1 vccd1 vccd1 sky130_fd_sc_hd__fill_4
Xoutput40 net40 vssd1 vssd1 vccd1 vccd1 gpio_oeb[27] sky130_fd_sc_hd__buf_2
Xoutput51 net51 vssd1 vssd1 vccd1 vccd1 gpio_out[16] sky130_fd_sc_hd__buf_2
Xoutput62 net62 vssd1 vssd1 vccd1 vccd1 gpio_out[27] sky130_fd_sc_hd__buf_2
X_11145_ net808 _00495_ net594 vssd1 vssd1 vccd1 vccd1 FPGA_INST.cell1.CB_1.config_dataB\[15\]
+ sky130_fd_sc_hd__dfstp_1
XTAP_TAPCELL_ROW_52_1007 vssd1 vccd1 sky130_fd_sc_hd__tapvpwrvgnd_1
X_11076_ net837 _00426_ net621 vssd1 vssd1 vccd1 vccd1 FPGA_INST.cell1.LE_0A.config_data\[11\]
+ sky130_fd_sc_hd__dfrtp_1
XTAP_TAPCELL_ROW_8_394 vssd1 vccd1 sky130_fd_sc_hd__tapvpwrvgnd_1
X_10027_ FPGA_INST.cell0.CB_0.config_dataB\[2\] net423 net310 vssd1 vssd1 vccd1 vccd1
+ _00908_ sky130_fd_sc_hd__mux2_1
XANTENNA__06310__B _02376_ vssd1 vssd1 vccd1 vccd1 sky130_fd_sc_hd__diode_2
XFILLER_36_405 vssd1 vssd1 vccd1 vccd1 sky130_fd_sc_hd__fill_4
XFILLER_91_544 vssd1 vssd1 vccd1 vccd1 sky130_fd_sc_hd__fill_4
XFILLER_56_81 vssd1 vssd1 vccd1 vccd1 sky130_fd_sc_hd__fill_1
XTAP_TAPCELL_ROW_47_945 vssd1 vccd1 sky130_fd_sc_hd__tapvpwrvgnd_1
XTAP_TAPCELL_ROW_47_934 vssd1 vccd1 sky130_fd_sc_hd__tapvpwrvgnd_1
XANTENNA__08099__A1 _03932_ vssd1 vssd1 vccd1 vccd1 sky130_fd_sc_hd__diode_2
XFILLER_91_588 vssd1 vssd1 vccd1 vccd1 sky130_fd_sc_hd__fill_1
XFILLER_63_279 vssd1 vssd1 vccd1 vccd1 sky130_fd_sc_hd__fill_1
X_11978_ net844 _01324_ net629 vssd1 vssd1 vccd1 vccd1 FPGA_INST.cell2.SB0.route_sel\[18\]
+ sky130_fd_sc_hd__dfstp_1
XANTENNA__06649__A2 _02810_ vssd1 vssd1 vccd1 vccd1 sky130_fd_sc_hd__diode_2
X_10929_ net846 _00279_ net631 vssd1 vssd1 vccd1 vccd1 FPGA_INST.cell2.CB_0.config_dataA\[10\]
+ sky130_fd_sc_hd__dfstp_1
XANTENNA__07846__A1 _02413_ vssd1 vssd1 vccd1 vccd1 sky130_fd_sc_hd__diode_2
XFILLER_32_622 vssd1 vssd1 vccd1 vccd1 sky130_fd_sc_hd__fill_1
XTAP_TAPCELL_ROW_63_1169 vssd1 vccd1 sky130_fd_sc_hd__tapvpwrvgnd_1
XTAP_TAPCELL_ROW_63_1158 vssd1 vccd1 sky130_fd_sc_hd__tapvpwrvgnd_1
XTAP_TAPCELL_ROW_119_1947 vssd1 vccd1 sky130_fd_sc_hd__tapvpwrvgnd_1
X_06120_ net100 _02398_ _02399_ vssd1 vssd1 vccd1 vccd1 _02400_ sky130_fd_sc_hd__a21oi_1
X_06051_ _01811_ _02293_ _02330_ _01810_ _01531_ vssd1 vssd1 vccd1 vccd1 _02331_ sky130_fd_sc_hd__a221o_1
XFILLER_125_292 vssd1 vssd1 vccd1 vccd1 sky130_fd_sc_hd__fill_4
XANTENNA__08023__A1 _03810_ vssd1 vssd1 vccd1 vccd1 sky130_fd_sc_hd__diode_2
XPHY_EDGE_ROW_99_Right_99 vssd1 vssd1 vccd1 vccd1 sky130_fd_sc_hd__decap_3
X_09810_ FPGA_INST.cell1.LE_1B.config_data\[11\] FPGA_INST.cell1.LE_1B.config_data\[10\]
+ net335 vssd1 vssd1 vccd1 vccd1 _00719_ sky130_fd_sc_hd__mux2_1
Xfanout329 net332 vssd1 vssd1 vccd1 vccd1 net329 sky130_fd_sc_hd__clkbuf_2
Xfanout307 net315 vssd1 vssd1 vccd1 vccd1 net307 sky130_fd_sc_hd__clkbuf_4
Xfanout318 net319 vssd1 vssd1 vccd1 vccd1 net318 sky130_fd_sc_hd__clkbuf_4
X_09741_ FPGA_INST.cell1.CB_0.config_dataA\[17\] net462 net339 vssd1 vssd1 vccd1 vccd1
+ _00650_ sky130_fd_sc_hd__mux2_1
X_06953_ FPGA_INST.bus2_0\[2\] FPGA_INST.bus2_0\[3\] net416 vssd1 vssd1 vccd1 vccd1
+ _03221_ sky130_fd_sc_hd__mux2_1
XFILLER_100_137 vssd1 vssd1 vccd1 vccd1 sky130_fd_sc_hd__fill_2
X_05904_ FPGA_INST.cell0.SB0.route_sel\[58\] FPGA_INST.cell0.SB0.route_sel\[59\] _02180_
+ _02182_ net106 vssd1 vssd1 vccd1 vccd1 _02184_ sky130_fd_sc_hd__a221o_1
XFILLER_54_202 vssd1 vssd1 vccd1 vccd1 sky130_fd_sc_hd__fill_2
X_09672_ FPGA_INST.cell0.SB0.route_sel\[76\] FPGA_INST.cell0.SB0.route_sel\[75\] net311
+ vssd1 vssd1 vccd1 vccd1 _00581_ sky130_fd_sc_hd__mux2_1
X_06884_ FPGA_INST.cell0.CB_0.config_dataB\[3\] FPGA_INST.cell0.CB_0.config_dataB\[2\]
+ vssd1 vssd1 vccd1 vccd1 _03152_ sky130_fd_sc_hd__or2_1
XFILLER_27_405 vssd1 vssd1 vccd1 vccd1 sky130_fd_sc_hd__fill_4
XFILLER_39_254 vssd1 vssd1 vccd1 vccd1 sky130_fd_sc_hd__fill_1
X_08623_ _04796_ _04828_ _04831_ _04790_ vssd1 vssd1 vccd1 vccd1 _04832_ sky130_fd_sc_hd__a2bb2o_1
XFILLER_36_29 vssd1 vssd1 vccd1 vccd1 sky130_fd_sc_hd__fill_1
X_05835_ FPGA_INST.cell2.SB0.route_sel\[72\] FPGA_INST.cell2.SB0.route_sel\[73\] vssd1
+ vssd1 vccd1 vccd1 _02115_ sky130_fd_sc_hd__nand2_1
X_08554_ FPGA_INST.cell3.CB_0.config_data_inA _04763_ _04764_ FPGA_INST.cell3.CB_1.config_dataB\[19\]
+ vssd1 vssd1 vccd1 vccd1 _04765_ sky130_fd_sc_hd__o211a_1
XANTENNA_fanout267_A net268 vssd1 vssd1 vccd1 vccd1 sky130_fd_sc_hd__diode_2
X_05766_ FPGA_INST.cell2.CB_0.config_dataB\[22\] FPGA_INST.cell2.CB_0.config_dataB\[23\]
+ vssd1 vssd1 vccd1 vccd1 _02046_ sky130_fd_sc_hd__nand2b_1
X_07505_ FPGA_INST.cell1.SB0.route_sel\[71\] FPGA_INST.cell1.SB0.route_sel\[70\] _02136_
+ _03760_ net107 vssd1 vssd1 vccd1 vccd1 _03761_ sky130_fd_sc_hd__a221oi_1
XANTENNA__07837__A1 _02255_ vssd1 vssd1 vccd1 vccd1 sky130_fd_sc_hd__diode_2
XTAP_TAPCELL_ROW_25_628 vssd1 vccd1 sky130_fd_sc_hd__tapvpwrvgnd_1
XTAP_TAPCELL_ROW_25_639 vssd1 vccd1 sky130_fd_sc_hd__tapvpwrvgnd_1
X_08485_ _04700_ vssd1 vssd1 vccd1 vccd1 _04701_ sky130_fd_sc_hd__inv_2
XFILLER_62_290 vssd1 vssd1 vccd1 vccd1 sky130_fd_sc_hd__fill_8
X_05697_ net113 _01826_ _01975_ vssd1 vssd1 vccd1 vccd1 _01977_ sky130_fd_sc_hd__nor3_1
X_07436_ FPGA_INST.cell3.SB0.route_sel\[54\] FPGA_INST.cell3.SB0.route_sel\[55\] net130
+ _02240_ vssd1 vssd1 vccd1 vccd1 _03694_ sky130_fd_sc_hd__a22o_1
XFILLER_22_176 vccd1 vssd1 vccd1 vssd1 sky130_ef_sc_hd__decap_40_12
XANTENNA_fanout601_A net604 vssd1 vssd1 vccd1 vccd1 sky130_fd_sc_hd__diode_2
X_07367_ _03586_ _03626_ vssd1 vssd1 vccd1 vccd1 _03627_ sky130_fd_sc_hd__nor2_1
X_09106_ FPGA_INST.cell2.LEI0.config_data\[20\] FPGA_INST.cell2.LEI0.config_data\[21\]
+ net263 vssd1 vssd1 vccd1 vccd1 _00022_ sky130_fd_sc_hd__mux2_1
X_06318_ net7 net8 net501 vssd1 vssd1 vccd1 vccd1 _02598_ sky130_fd_sc_hd__mux2_1
X_09037_ FPGA_INST.cell3.SB0.route_sel\[6\] FPGA_INST.cell3.SB0.route_sel\[7\] vssd1
+ vssd1 vccd1 vccd1 _05198_ sky130_fd_sc_hd__nor2_1
X_07298_ _02338_ _02347_ _03557_ vssd1 vssd1 vccd1 vccd1 _03559_ sky130_fd_sc_hd__or3_1
XFILLER_123_207 vssd1 vssd1 vccd1 vccd1 sky130_fd_sc_hd__fill_4
XANTENNA__09693__S net196 vssd1 vssd1 vccd1 vccd1 sky130_fd_sc_hd__diode_2
X_06249_ net14 net15 net16 net17 net509 net508 vssd1 vssd1 vccd1 vccd1 _02529_ sky130_fd_sc_hd__mux4_1
XFILLER_104_421 vssd1 vssd1 vccd1 vccd1 sky130_fd_sc_hd__fill_2
Xfanout841 net842 vssd1 vssd1 vccd1 vccd1 net841 sky130_fd_sc_hd__buf_1
XANTENNA_fanout82_A net83 vssd1 vssd1 vccd1 vccd1 sky130_fd_sc_hd__diode_2
Xfanout830 net831 vssd1 vssd1 vccd1 vccd1 net830 sky130_fd_sc_hd__clkbuf_1
XANTENNA__06576__A1 FPGA_INST.bus3_2\[13\] vssd1 vssd1 vccd1 vccd1 sky130_fd_sc_hd__diode_2
Xfanout852 net854 vssd1 vssd1 vccd1 vccd1 net852 sky130_fd_sc_hd__clkbuf_2
X_09939_ FPGA_INST.cell0.CB_1.config_dataA\[24\] FPGA_INST.cell0.CB_1.config_dataB\[0\]
+ net208 vssd1 vssd1 vccd1 vccd1 _00844_ sky130_fd_sc_hd__mux2_1
Xfanout885 net891 vssd1 vssd1 vccd1 vccd1 net885 sky130_fd_sc_hd__clkbuf_2
XTAP_TAPCELL_ROW_5_353 vssd1 vccd1 sky130_fd_sc_hd__tapvpwrvgnd_1
Xfanout863 net865 vssd1 vssd1 vccd1 vccd1 net863 sky130_fd_sc_hd__clkbuf_2
Xfanout874 net877 vssd1 vssd1 vccd1 vccd1 net874 sky130_fd_sc_hd__clkbuf_2
Xfanout896 net898 vssd1 vssd1 vccd1 vccd1 net896 sky130_fd_sc_hd__clkbuf_2
XFILLER_92_319 vssd1 vssd1 vccd1 vccd1 sky130_fd_sc_hd__fill_1
XANTENNA__06328__A1 FPGA_INST.cell2.LE_0A.config_data\[0\] vssd1 vssd1 vccd1 vccd1
+ sky130_fd_sc_hd__diode_2
X_11901_ net929 _01247_ net713 vssd1 vssd1 vccd1 vccd1 FPGA_INST.cell3.LE_0B.config_data\[9\]
+ sky130_fd_sc_hd__dfrtp_1
XFILLER_93_46 vssd1 vssd1 vccd1 vccd1 sky130_fd_sc_hd__fill_8
XFILLER_85_393 vssd1 vssd1 vccd1 vccd1 sky130_fd_sc_hd__fill_2
XFILLER_46_736 vssd1 vssd1 vccd1 vccd1 sky130_fd_sc_hd__fill_2
X_11832_ net915 _01178_ net699 vssd1 vssd1 vccd1 vccd1 FPGA_INST.cell3.LEI0.config_data\[12\]
+ sky130_fd_sc_hd__dfrtp_1
XFILLER_73_555 vssd1 vssd1 vccd1 vccd1 sky130_fd_sc_hd__fill_4
XTAP_TAPCELL_ROW_44_904 vssd1 vccd1 sky130_fd_sc_hd__tapvpwrvgnd_1
XFILLER_33_408 vssd1 vssd1 vccd1 vccd1 sky130_fd_sc_hd__fill_1
XTAP_TAPCELL_ROW_103_1726 vssd1 vccd1 sky130_fd_sc_hd__tapvpwrvgnd_1
X_11763_ net924 _01109_ net708 vssd1 vssd1 vccd1 vccd1 FPGA_INST.io_west_oeb\[10\]
+ sky130_fd_sc_hd__dfrtp_1
XANTENNA__10079__S net173 vssd1 vssd1 vccd1 vccd1 sky130_fd_sc_hd__diode_2
X_11694_ net903 _01040_ net687 vssd1 vssd1 vccd1 vccd1 FPGA_INST.cell3.SB0.route_sel\[64\]
+ sky130_fd_sc_hd__dfstp_1
XFILLER_41_474 vssd1 vssd1 vccd1 vccd1 sky130_fd_sc_hd__fill_8
X_10714_ net869 _00064_ net654 vssd1 vssd1 vccd1 vccd1 FPGA_INST.cell2.LE_0A.config_data\[13\]
+ sky130_fd_sc_hd__dfrtp_1
X_10645_ FPGA_INST.cell3.LE_1B.config_data\[15\] FPGA_INST.cell3.LE_1B.config_data\[14\]
+ net369 vssd1 vssd1 vccd1 vccd1 _01524_ sky130_fd_sc_hd__mux2_1
XFILLER_42_50 vssd1 vssd1 vccd1 vccd1 sky130_fd_sc_hd__fill_4
XANTENNA__08253__A1 FPGA_INST.bus1_0\[8\] vssd1 vssd1 vccd1 vccd1 sky130_fd_sc_hd__diode_2
XFILLER_9_169 vssd1 vssd1 vccd1 vccd1 sky130_fd_sc_hd__fill_2
XANTENNA__06292__S _02536_ vssd1 vssd1 vccd1 vccd1 sky130_fd_sc_hd__diode_2
XFILLER_127_557 vssd1 vssd1 vccd1 vccd1 sky130_fd_sc_hd__fill_1
XFILLER_127_535 vssd1 vssd1 vccd1 vccd1 sky130_fd_sc_hd__fill_1
X_10576_ FPGA_INST.cell3.CB_0.config_dataA\[21\] FPGA_INST.cell3.CB_0.config_dataA\[20\]
+ net366 vssd1 vssd1 vccd1 vccd1 _01455_ sky130_fd_sc_hd__mux2_1
XANTENNA__08253__B2 FPGA_INST.bus1_0\[9\] vssd1 vssd1 vccd1 vccd1 sky130_fd_sc_hd__diode_2
X_12177_ net911 _01523_ net693 vssd1 vssd1 vccd1 vccd1 FPGA_INST.cell3.LE_1B.config_data\[14\]
+ sky130_fd_sc_hd__dfrtp_1
XTAP_TAPCELL_ROW_114_1877 vssd1 vccd1 sky130_fd_sc_hd__tapvpwrvgnd_1
XFILLER_122_262 vssd1 vssd1 vccd1 vccd1 sky130_fd_sc_hd__fill_1
X_11128_ net806 _00478_ net591 vssd1 vssd1 vccd1 vccd1 FPGA_INST.cell1.LE_1A.reset_mode
+ sky130_fd_sc_hd__dfrtp_1
XANTENNA__07417__A net154 vssd1 vssd1 vccd1 vccd1 sky130_fd_sc_hd__diode_2
XANTENNA__08308__A2 _03504_ vssd1 vssd1 vccd1 vccd1 sky130_fd_sc_hd__diode_2
XFILLER_3_77 vssd1 vssd1 vccd1 vccd1 sky130_fd_sc_hd__fill_4
X_11059_ net796 _00409_ net581 vssd1 vssd1 vccd1 vccd1 FPGA_INST.cell1.LEI0.config_data\[44\]
+ sky130_fd_sc_hd__dfrtp_1
XFILLER_83_308 vssd1 vssd1 vccd1 vccd1 sky130_fd_sc_hd__fill_2
XANTENNA__06319__A1 net5 vssd1 vssd1 vccd1 vccd1 sky130_fd_sc_hd__diode_2
XFILLER_76_371 vssd1 vssd1 vccd1 vccd1 sky130_fd_sc_hd__fill_4
X_05620_ FPGA_INST.cell2.SB0.route_sel\[122\] FPGA_INST.cell2.SB0.route_sel\[123\]
+ _01899_ vssd1 vssd1 vccd1 vccd1 _01900_ sky130_fd_sc_hd__a21oi_1
XFILLER_17_482 vssd1 vssd1 vccd1 vccd1 sky130_fd_sc_hd__fill_2
X_05551_ FPGA_INST.cfg_done net740 vssd1 vssd1 vccd1 vccd1 _01831_ sky130_fd_sc_hd__nand2b_2
XFILLER_51_238 vssd1 vssd1 vccd1 vccd1 sky130_fd_sc_hd__fill_1
X_05482_ net401 vssd1 vssd1 vccd1 vccd1 _01764_ sky130_fd_sc_hd__inv_2
X_08270_ FPGA_INST.cell0.CB_1.config_dataA\[18\] _04482_ _04492_ _04493_ FPGA_INST.cell0.CB_1.config_dataA\[19\]
+ vssd1 vssd1 vccd1 vccd1 _04494_ sky130_fd_sc_hd__a221o_1
XFILLER_60_772 vssd1 vssd1 vccd1 vccd1 sky130_fd_sc_hd__fill_2
X_07221_ FPGA_INST.cell3.CB_0.config_dataB\[21\] FPGA_INST.cell3.CB_0.config_dataB\[24\]
+ FPGA_INST.cell3.CB_0.config_dataB\[20\] vssd1 vssd1 vccd1 vccd1 _03484_ sky130_fd_sc_hd__or3b_1
XFILLER_60_794 vssd1 vssd1 vccd1 vccd1 sky130_fd_sc_hd__fill_4
XFILLER_20_647 vssd1 vssd1 vccd1 vccd1 sky130_fd_sc_hd__fill_2
X_07152_ FPGA_INST.bus3_1\[0\] _03401_ _03402_ vssd1 vssd1 vccd1 vccd1 _03416_ sky130_fd_sc_hd__a21oi_1
X_06103_ net113 _01825_ _02340_ vssd1 vssd1 vccd1 vccd1 _02383_ sky130_fd_sc_hd__nor3_1
XTAP_TAPCELL_ROW_30_697 vssd1 vccd1 sky130_fd_sc_hd__tapvpwrvgnd_1
XANTENNA__08795__A2 _04819_ vssd1 vssd1 vccd1 vccd1 sky130_fd_sc_hd__diode_2
XTAP_TAPCELL_ROW_76_1349 vssd1 vccd1 sky130_fd_sc_hd__tapvpwrvgnd_1
X_07083_ _03348_ _03314_ _03279_ vssd1 vssd1 vccd1 vccd1 _03349_ sky130_fd_sc_hd__mux2_1
XANTENNA__08270__X _04494_ vssd1 vssd1 vccd1 vccd1 sky130_fd_sc_hd__diode_2
X_06034_ FPGA_INST.cell2.SB0.route_sel\[44\] FPGA_INST.cell2.SB0.route_sel\[45\] _02313_
+ vssd1 vssd1 vccd1 vccd1 _02314_ sky130_fd_sc_hd__a21oi_1
XANTENNA__07755__A0 FPGA_INST.bus3_1\[14\] vssd1 vssd1 vccd1 vccd1 sky130_fd_sc_hd__diode_2
Xfanout115 FPGA_INST.cell0.CB_0.le_outA vssd1 vssd1 vccd1 vccd1 net115 sky130_fd_sc_hd__clkbuf_2
Xfanout137 FPGA_INST.cell2.CB_0.le_outA vssd1 vssd1 vccd1 vccd1 net137 sky130_fd_sc_hd__dlymetal6s2s_1
Xfanout126 FPGA_INST.cell2.CB_0.le_outB vssd1 vssd1 vccd1 vccd1 net126 sky130_fd_sc_hd__buf_1
Xfanout148 _01789_ vssd1 vssd1 vccd1 vccd1 net148 sky130_fd_sc_hd__clkbuf_4
XFILLER_113_295 vssd1 vssd1 vccd1 vccd1 sky130_fd_sc_hd__fill_1
XFILLER_113_284 vssd1 vssd1 vccd1 vccd1 sky130_fd_sc_hd__fill_1
XFILLER_101_446 vssd1 vssd1 vccd1 vccd1 sky130_fd_sc_hd__fill_2
X_07985_ FPGA_INST.cell1.CB_0.config_dataA\[18\] _04207_ _04212_ FPGA_INST.cell1.CB_0.config_dataA\[19\]
+ _04199_ vssd1 vssd1 vccd1 vccd1 _04213_ sky130_fd_sc_hd__a311o_1
XFILLER_86_146 vssd1 vssd1 vccd1 vccd1 sky130_fd_sc_hd__fill_2
Xfanout159 _02178_ vssd1 vssd1 vccd1 vccd1 net159 sky130_fd_sc_hd__buf_2
X_09724_ FPGA_INST.cell1.CB_0.config_dataA\[0\] FPGA_INST.cell1.CB_0.config_data_inA
+ net336 vssd1 vssd1 vccd1 vccd1 _00633_ sky130_fd_sc_hd__mux2_1
XANTENNA__08857__S _05032_ vssd1 vssd1 vccd1 vccd1 sky130_fd_sc_hd__diode_2
XTAP_TAPCELL_ROW_2_312 vssd1 vccd1 sky130_fd_sc_hd__tapvpwrvgnd_1
X_06936_ _01937_ _03198_ _03199_ _01984_ vssd1 vssd1 vccd1 vccd1 _03204_ sky130_fd_sc_hd__a22o_1
XFILLER_67_371 vssd1 vssd1 vccd1 vccd1 sky130_fd_sc_hd__fill_4
XANTENNA__05781__A2 net170 vssd1 vssd1 vccd1 vccd1 sky130_fd_sc_hd__diode_2
X_06867_ _03126_ _03131_ _03133_ _03134_ vssd1 vssd1 vccd1 vccd1 _03135_ sky130_fd_sc_hd__a22o_1
X_09655_ FPGA_INST.cell0.SB0.route_sel\[58\] FPGA_INST.cell0.SB0.route_sel\[59\] net186
+ vssd1 vssd1 vccd1 vccd1 _00564_ sky130_fd_sc_hd__mux2_1
X_08606_ _04798_ _04814_ _01762_ vssd1 vssd1 vccd1 vccd1 _04815_ sky130_fd_sc_hd__a21o_1
XANTENNA_fanout551_A net554 vssd1 vssd1 vccd1 vccd1 sky130_fd_sc_hd__diode_2
X_05818_ FPGA_INST.cell0.SB0.route_sel\[72\] FPGA_INST.cell0.SB0.route_sel\[73\] vssd1
+ vssd1 vccd1 vccd1 _02098_ sky130_fd_sc_hd__nand2_1
X_09586_ FPGA_INST.cell1.CB_1.config_dataB\[14\] FPGA_INST.cell1.CB_1.config_dataB\[15\]
+ net213 vssd1 vssd1 vccd1 vccd1 _00495_ sky130_fd_sc_hd__mux2_1
X_06798_ FPGA_INST.cell2.CB_1.config_dataB\[16\] _03070_ _03071_ vssd1 vssd1 vccd1
+ vccd1 _03072_ sky130_fd_sc_hd__a21oi_1
XFILLER_27_279 vssd1 vssd1 vccd1 vccd1 sky130_fd_sc_hd__fill_1
X_08537_ net156 _04748_ vssd1 vssd1 vccd1 vccd1 FPGA_INST.cell3.CB_1.le_outA sky130_fd_sc_hd__and2_2
X_05749_ FPGA_INST.cell0.SB0.route_sel\[84\] _01644_ _01645_ FPGA_INST.cell0.SB0.route_sel\[87\]
+ _02028_ vssd1 vssd1 vccd1 vccd1 _02029_ sky130_fd_sc_hd__a221o_1
XANTENNA__11580__Q FPGA_INST.cell0.CB_0.config_dataB\[24\] vssd1 vssd1 vccd1 vccd1
+ sky130_fd_sc_hd__diode_2
X_08468_ net155 _04684_ vssd1 vssd1 vccd1 vccd1 FPGA_INST.cell1.CB_1.le_outA sky130_fd_sc_hd__and2_1
XANTENNA__09688__S net314 vssd1 vssd1 vccd1 vccd1 sky130_fd_sc_hd__diode_2
X_07419_ FPGA_INST.cell1.SB0.route_sel\[48\] FPGA_INST.cell1.SB0.route_sel\[49\] _03673_
+ _03674_ _03675_ vssd1 vssd1 vccd1 vccd1 _03677_ sky130_fd_sc_hd__a221o_2
XANTENNA_fanout604_X net604 vssd1 vssd1 vccd1 vccd1 sky130_fd_sc_hd__diode_2
X_08399_ net439 _03504_ _04620_ net438 vssd1 vssd1 vccd1 vccd1 _04621_ sky130_fd_sc_hd__o211a_1
X_10430_ FPGA_INST.cell2.SB0.route_sel\[2\] FPGA_INST.cell2.SB0.route_sel\[3\] net243
+ vssd1 vssd1 vccd1 vccd1 _01309_ sky130_fd_sc_hd__mux2_1
XFILLER_6_139 vssd1 vssd1 vccd1 vccd1 sky130_fd_sc_hd__fill_1
XFILLER_128_31 vssd1 vssd1 vccd1 vccd1 sky130_fd_sc_hd__fill_1
X_10361_ FPGA_INST.cell3.LE_0B.config_data\[2\] FPGA_INST.cell3.LE_0B.config_data\[3\]
+ net301 vssd1 vssd1 vccd1 vccd1 _01241_ sky130_fd_sc_hd__mux2_1
XANTENNA__06797__A1 _02784_ vssd1 vssd1 vccd1 vccd1 sky130_fd_sc_hd__diode_2
X_10292_ FPGA_INST.cell3.LEI0.config_data\[6\] FPGA_INST.cell3.LEI0.config_data\[7\]
+ net303 vssd1 vssd1 vccd1 vccd1 _01173_ sky130_fd_sc_hd__mux2_1
X_12100_ net930 _01446_ net711 vssd1 vssd1 vccd1 vccd1 FPGA_INST.cell3.CB_0.config_dataA\[12\]
+ sky130_fd_sc_hd__dfstp_2
XFILLER_88_24 vssd1 vssd1 vccd1 vccd1 sky130_fd_sc_hd__fill_4
XANTENNA__06797__B2 _02780_ vssd1 vssd1 vccd1 vccd1 sky130_fd_sc_hd__diode_2
XANTENNA__08538__A2 net82 vssd1 vssd1 vccd1 vccd1 sky130_fd_sc_hd__diode_2
XFILLER_5_3 vccd1 vssd1 vccd1 vssd1 sky130_ef_sc_hd__decap_40_12
X_12031_ net858 _01377_ net643 vssd1 vssd1 vccd1 vccd1 FPGA_INST.cell2.SB0.route_sel\[71\]
+ sky130_fd_sc_hd__dfstp_1
XFILLER_120_722 vssd1 vssd1 vccd1 vccd1 sky130_fd_sc_hd__fill_8
XFILLER_105_785 vssd1 vssd1 vccd1 vccd1 sky130_fd_sc_hd__fill_1
XANTENNA__07237__A FPGA_INST.cell1.CB_0.config_dataB\[24\] vssd1 vssd1 vccd1 vccd1
+ sky130_fd_sc_hd__diode_2
XFILLER_120_755 vssd1 vssd1 vccd1 vccd1 sky130_fd_sc_hd__fill_1
XFILLER_77_124 vssd1 vssd1 vccd1 vccd1 sky130_fd_sc_hd__fill_4
XANTENNA__11755__Q FPGA_INST.cell3.SB0.route_sel\[125\] vssd1 vssd1 vccd1 vccd1 sky130_fd_sc_hd__diode_2
Xfanout660 net661 vssd1 vssd1 vccd1 vccd1 net660 sky130_fd_sc_hd__clkbuf_4
XTAP_TAPCELL_ROW_129_2084 vssd1 vccd1 sky130_fd_sc_hd__tapvpwrvgnd_1
Xfanout693 net695 vssd1 vssd1 vccd1 vccd1 net693 sky130_fd_sc_hd__clkbuf_4
XFILLER_93_617 vssd1 vssd1 vccd1 vccd1 sky130_fd_sc_hd__fill_1
Xfanout682 net683 vssd1 vssd1 vccd1 vccd1 net682 sky130_fd_sc_hd__clkbuf_4
Xfanout671 net675 vssd1 vssd1 vccd1 vccd1 net671 sky130_fd_sc_hd__clkbuf_4
XTAP_TAPCELL_ROW_129_2095 vssd1 vccd1 sky130_fd_sc_hd__tapvpwrvgnd_1
XFILLER_19_725 vssd1 vssd1 vccd1 vccd1 sky130_fd_sc_hd__fill_2
XANTENNA__08710__A2 net82 vssd1 vssd1 vccd1 vccd1 sky130_fd_sc_hd__diode_2
XFILLER_61_503 vssd1 vssd1 vccd1 vccd1 sky130_fd_sc_hd__fill_1
XFILLER_46_555 vccd1 vssd1 vccd1 vssd1 sky130_ef_sc_hd__decap_40_12
XFILLER_27_780 vssd1 vssd1 vccd1 vccd1 sky130_fd_sc_hd__fill_4
X_11815_ net872 _01161_ net656 vssd1 vssd1 vccd1 vccd1 net40 sky130_fd_sc_hd__dfrtp_1
X_11746_ net895 _01092_ net679 vssd1 vssd1 vccd1 vccd1 FPGA_INST.cell3.SB0.route_sel\[116\]
+ sky130_fd_sc_hd__dfstp_1
XTAP_TAPCELL_ROW_60_1128 vssd1 vccd1 sky130_fd_sc_hd__tapvpwrvgnd_1
XTAP_TAPCELL_ROW_60_1117 vssd1 vccd1 sky130_fd_sc_hd__tapvpwrvgnd_1
X_11677_ net906 _01023_ net690 vssd1 vssd1 vccd1 vccd1 FPGA_INST.cell3.SB0.route_sel\[47\]
+ sky130_fd_sc_hd__dfstp_1
XTAP_TAPCELL_ROW_116_1906 vssd1 vccd1 sky130_fd_sc_hd__tapvpwrvgnd_1
X_10628_ FPGA_INST.cell3.CB_1.config_dataA\[23\] FPGA_INST.cell3.CB_1.config_dataA\[22\]
+ net369 vssd1 vssd1 vccd1 vccd1 _01507_ sky130_fd_sc_hd__mux2_1
XANTENNA__06237__A0 net7 vssd1 vssd1 vccd1 vccd1 sky130_fd_sc_hd__diode_2
XFILLER_115_505 vssd1 vssd1 vccd1 vccd1 sky130_fd_sc_hd__fill_8
X_10559_ FPGA_INST.cell3.CB_0.config_dataA\[3\] FPGA_INST.cell3.CB_0.config_dataA\[4\]
+ net288 vssd1 vssd1 vccd1 vccd1 _01438_ sky130_fd_sc_hd__mux2_1
XFILLER_111_744 vccd1 vssd1 vccd1 vssd1 sky130_ef_sc_hd__decap_40_12
XTAP_TAPCELL_ROW_71_1279 vssd1 vccd1 sky130_fd_sc_hd__tapvpwrvgnd_1
XFILLER_84_617 vssd1 vssd1 vccd1 vccd1 sky130_fd_sc_hd__fill_1
X_07770_ net94 _04019_ vssd1 vssd1 vccd1 vccd1 _04020_ sky130_fd_sc_hd__nand2_1
XFILLER_68_179 vssd1 vssd1 vccd1 vccd1 sky130_fd_sc_hd__fill_2
X_06721_ net516 net517 vssd1 vssd1 vccd1 vccd1 _02995_ sky130_fd_sc_hd__nand2b_1
XFILLER_49_393 vssd1 vssd1 vccd1 vccd1 sky130_fd_sc_hd__fill_4
XANTENNA__08701__A2 _04804_ vssd1 vssd1 vccd1 vccd1 sky130_fd_sc_hd__diode_2
X_09440_ FPGA_INST.cell2.LE_1B.config_data\[9\] FPGA_INST.cell2.LE_1B.config_data\[8\]
+ net374 vssd1 vssd1 vccd1 vccd1 _00353_ sky130_fd_sc_hd__mux2_1
XFILLER_25_706 vssd1 vssd1 vccd1 vccd1 sky130_fd_sc_hd__fill_2
X_06652_ _02920_ _02923_ _02927_ FPGA_INST.cell2.CB_1.config_dataA\[18\] vssd1 vssd1
+ vccd1 vccd1 _02928_ sky130_fd_sc_hd__and4bb_1
X_06583_ _02843_ _02850_ _02851_ _02840_ FPGA_INST.cell2.CB_1.config_dataA\[2\] vssd1
+ vssd1 vccd1 vccd1 _02859_ sky130_fd_sc_hd__a221o_1
X_05603_ net384 net171 FPGA_INST.bus2_0\[15\] vssd1 vssd1 vccd1 vccd1 _01883_ sky130_fd_sc_hd__o21ba_1
X_09371_ FPGA_INST.cell2.CB_0.config_dataA\[14\] net500 net237 vssd1 vssd1 vccd1 vccd1
+ _00284_ sky130_fd_sc_hd__mux2_1
XFILLER_24_238 vssd1 vssd1 vccd1 vccd1 sky130_fd_sc_hd__fill_4
X_08322_ _04540_ _04541_ _04543_ vssd1 vssd1 vccd1 vccd1 _04544_ sky130_fd_sc_hd__and3_2
X_05534_ FPGA_INST.cell0.CB_0.config_dataA\[24\] FPGA_INST.cell0.CB_0.config_dataA\[20\]
+ FPGA_INST.cell0.CB_0.config_dataA\[21\] vssd1 vssd1 vccd1 vccd1 _01814_ sky130_fd_sc_hd__nor3b_4
XTAP_TAPCELL_ROW_35_767 vssd1 vccd1 sky130_fd_sc_hd__tapvpwrvgnd_1
XTAP_TAPCELL_ROW_35_778 vssd1 vccd1 sky130_fd_sc_hd__tapvpwrvgnd_1
X_08253_ FPGA_INST.bus1_0\[8\] _04473_ _04474_ FPGA_INST.bus1_0\[9\] FPGA_INST.cell0.CB_1.config_dataA\[17\]
+ vssd1 vssd1 vccd1 vccd1 _04477_ sky130_fd_sc_hd__a221o_1
X_07204_ FPGA_INST.cell1.SB0.route_sel\[15\] FPGA_INST.cell1.SB0.route_sel\[14\] _02419_
+ _03466_ net105 vssd1 vssd1 vccd1 vccd1 _03467_ sky130_fd_sc_hd__a221oi_4
XANTENNA_fanout132_A net134 vssd1 vssd1 vccd1 vccd1 sky130_fd_sc_hd__diode_2
X_05465_ FPGA_INST.cell0.CB_0.config_dataB\[14\] vssd1 vssd1 vccd1 vccd1 _01747_ sky130_fd_sc_hd__inv_2
XANTENNA__10447__S net350 vssd1 vssd1 vccd1 vccd1 sky130_fd_sc_hd__diode_2
XTAP_TAPCELL_ROW_15_491 vssd1 vccd1 sky130_fd_sc_hd__tapvpwrvgnd_1
X_08184_ _04407_ vssd1 vssd1 vccd1 vccd1 _04408_ sky130_fd_sc_hd__inv_2
XFILLER_20_477 vssd1 vssd1 vccd1 vccd1 sky130_fd_sc_hd__fill_2
X_05396_ FPGA_INST.cell0.SB0.route_sel\[54\] vssd1 vssd1 vccd1 vccd1 _01678_ sky130_fd_sc_hd__inv_2
X_07135_ FPGA_INST.cell1.CB_0.config_dataB\[24\] FPGA_INST.cell1.CB_0.config_dataB\[20\]
+ FPGA_INST.cell1.CB_0.config_dataB\[21\] vssd1 vssd1 vccd1 vccd1 _03399_ sky130_fd_sc_hd__or3_2
XFILLER_118_376 vssd1 vssd1 vccd1 vccd1 sky130_fd_sc_hd__fill_1
XFILLER_109_9 vssd1 vssd1 vccd1 vccd1 sky130_fd_sc_hd__fill_4
XANTENNA__07976__A0 FPGA_INST.bus3_1\[12\] vssd1 vssd1 vccd1 vccd1 sky130_fd_sc_hd__diode_2
XANTENNA__06779__A1 _02840_ vssd1 vssd1 vccd1 vccd1 sky130_fd_sc_hd__diode_2
XANTENNA__06779__B2 _02843_ vssd1 vssd1 vccd1 vccd1 sky130_fd_sc_hd__diode_2
X_07066_ _03328_ _03331_ _03323_ vssd1 vssd1 vccd1 vccd1 _03332_ sky130_fd_sc_hd__a21o_1
XANTENNA_fanout599_A net604 vssd1 vssd1 vccd1 vccd1 sky130_fd_sc_hd__diode_2
XANTENNA__05987__C1 net320 vssd1 vssd1 vccd1 vccd1 sky130_fd_sc_hd__diode_2
X_06017_ FPGA_INST.cell0.SB0.route_sel\[40\] FPGA_INST.cell0.SB0.route_sel\[41\] vssd1
+ vssd1 vccd1 vccd1 _02297_ sky130_fd_sc_hd__and2_1
XFILLER_102_744 vssd1 vssd1 vccd1 vccd1 sky130_fd_sc_hd__fill_1
X_07968_ net463 _03690_ _04195_ FPGA_INST.cell1.CB_0.config_dataA\[16\] vssd1 vssd1
+ vccd1 vccd1 _04196_ sky130_fd_sc_hd__o211ai_1
XTAP_TAPCELL_ROW_89_1529 vssd1 vccd1 sky130_fd_sc_hd__tapvpwrvgnd_1
XANTENNA_fanout766_A net769 vssd1 vssd1 vccd1 vccd1 sky130_fd_sc_hd__diode_2
XANTENNA__07344__X _03604_ vssd1 vssd1 vccd1 vccd1 sky130_fd_sc_hd__diode_2
X_06919_ FPGA_INST.bus2_0\[2\] FPGA_INST.bus2_0\[3\] net418 vssd1 vssd1 vccd1 vccd1
+ _03187_ sky130_fd_sc_hd__mux2_1
XANTENNA__06951__A1 FPGA_INST.bus2_0\[5\] vssd1 vssd1 vccd1 vccd1 sky130_fd_sc_hd__diode_2
X_09707_ FPGA_INST.cell0.SB0.route_sel\[110\] FPGA_INST.cell0.SB0.route_sel\[111\]
+ net197 vssd1 vssd1 vccd1 vccd1 _00616_ sky130_fd_sc_hd__mux2_1
XANTENNA_fanout933_A net946 vssd1 vssd1 vccd1 vccd1 sky130_fd_sc_hd__diode_2
X_07899_ net472 _03519_ _04126_ net471 vssd1 vssd1 vccd1 vccd1 _04127_ sky130_fd_sc_hd__o211a_1
XFILLER_28_544 vssd1 vssd1 vccd1 vccd1 sky130_fd_sc_hd__fill_4
XFILLER_28_566 vccd1 vssd1 vccd1 vssd1 sky130_ef_sc_hd__decap_40_12
XANTENNA_fanout554_X net554 vssd1 vssd1 vccd1 vccd1 sky130_fd_sc_hd__diode_2
XFILLER_16_739 vssd1 vssd1 vccd1 vccd1 sky130_fd_sc_hd__fill_1
X_09638_ FPGA_INST.cell0.SB0.route_sel\[41\] FPGA_INST.cell0.SB0.route_sel\[42\] net185
+ vssd1 vssd1 vccd1 vccd1 _00547_ sky130_fd_sc_hd__mux2_1
XFILLER_130_54 vssd1 vssd1 vccd1 vccd1 sky130_fd_sc_hd__fill_2
X_09569_ FPGA_INST.cell1.LE_1A.reset_val FPGA_INST.cell1.LE_1A.reset_mode net210 vssd1
+ vssd1 vccd1 vccd1 _00478_ sky130_fd_sc_hd__mux2_1
XANTENNA__05305__A FPGA_INST.cell2.SB0.config_data_out vssd1 vssd1 vccd1 vccd1 sky130_fd_sc_hd__diode_2
X_11600_ net799 _00950_ net584 vssd1 vssd1 vccd1 vccd1 FPGA_INST.cell0.CB_1.config_dataA\[19\]
+ sky130_fd_sc_hd__dfstp_1
XFILLER_30_208 vssd1 vssd1 vccd1 vccd1 sky130_fd_sc_hd__fill_4
XANTENNA__09211__S net379 vssd1 vssd1 vccd1 vccd1 sky130_fd_sc_hd__diode_2
XFILLER_11_422 vssd1 vssd1 vccd1 vccd1 sky130_fd_sc_hd__fill_1
X_11531_ net756 _00881_ net541 vssd1 vssd1 vccd1 vccd1 FPGA_INST.cell0.CB_0.config_dataA\[0\]
+ sky130_fd_sc_hd__dfstp_1
XANTENNA__08208__A1 FPGA_INST.bus1_0\[15\] vssd1 vssd1 vccd1 vccd1 sky130_fd_sc_hd__diode_2
XFILLER_7_437 vssd1 vssd1 vccd1 vccd1 sky130_fd_sc_hd__fill_2
X_11462_ net771 _00812_ net556 vssd1 vssd1 vccd1 vccd1 FPGA_INST.cell0.LE_0B.config_data\[11\]
+ sky130_fd_sc_hd__dfrtp_1
X_10413_ FPGA_INST.cell3.CB_1.config_dataB\[10\] FPGA_INST.cell3.CB_1.config_dataB\[11\]
+ net283 vssd1 vssd1 vccd1 vccd1 _01292_ sky130_fd_sc_hd__mux2_1
XFILLER_109_365 vssd1 vssd1 vccd1 vccd1 sky130_fd_sc_hd__fill_1
XANTENNA__08054__C _03769_ vssd1 vssd1 vccd1 vccd1 sky130_fd_sc_hd__diode_2
X_11393_ net743 _00743_ net528 vssd1 vssd1 vccd1 vccd1 FPGA_INST.cell0.LEI0.config_data\[14\]
+ sky130_fd_sc_hd__dfrtp_1
XFILLER_109_387 vssd1 vssd1 vccd1 vccd1 sky130_fd_sc_hd__fill_4
X_10344_ FPGA_INST.cell3.LE_0A.config_data\[8\] FPGA_INST.cell3.LE_0A.config_data\[9\]
+ net292 vssd1 vssd1 vccd1 vccd1 _01225_ sky130_fd_sc_hd__mux2_1
XANTENNA__08622__Y _04831_ vssd1 vssd1 vccd1 vccd1 sky130_fd_sc_hd__diode_2
XTAP_TAPCELL_ROW_111_1836 vssd1 vccd1 sky130_fd_sc_hd__tapvpwrvgnd_1
X_10275_ net34 net35 net253 vssd1 vssd1 vccd1 vccd1 _01156_ sky130_fd_sc_hd__mux2_1
XANTENNA__07195__A1 FPGA_INST.bus3_1\[1\] vssd1 vssd1 vccd1 vccd1 sky130_fd_sc_hd__diode_2
XFILLER_2_197 vssd1 vssd1 vccd1 vccd1 sky130_fd_sc_hd__fill_2
X_12014_ net777 _01360_ net563 vssd1 vssd1 vccd1 vccd1 FPGA_INST.cell2.SB0.route_sel\[54\]
+ sky130_fd_sc_hd__dfstp_1
XANTENNA__10743__RESET_B net734 vssd1 vssd1 vccd1 vccd1 sky130_fd_sc_hd__diode_2
XFILLER_93_447 vssd1 vssd1 vccd1 vccd1 sky130_fd_sc_hd__fill_1
Xfanout490 FPGA_INST.cell2.CB_0.config_dataB\[11\] vssd1 vssd1 vccd1 vccd1 net490
+ sky130_fd_sc_hd__buf_2
XPHY_EDGE_ROW_100_Left_231 vssd1 vssd1 vccd1 vccd1 sky130_fd_sc_hd__decap_3
XANTENNA__08695__B2 _04846_ vssd1 vssd1 vccd1 vccd1 sky130_fd_sc_hd__diode_2
XANTENNA__08695__A1 _04843_ vssd1 vssd1 vccd1 vccd1 sky130_fd_sc_hd__diode_2
XFILLER_46_363 vssd1 vssd1 vccd1 vccd1 sky130_fd_sc_hd__fill_1
XFILLER_34_514 vssd1 vssd1 vccd1 vccd1 sky130_fd_sc_hd__fill_2
XFILLER_64_81 vssd1 vssd1 vccd1 vccd1 sky130_fd_sc_hd__fill_1
XTAP_TAPCELL_ROW_122_1987 vssd1 vccd1 sky130_fd_sc_hd__tapvpwrvgnd_1
XTAP_TAPCELL_ROW_32_726 vssd1 vccd1 sky130_fd_sc_hd__tapvpwrvgnd_1
XTAP_TAPCELL_ROW_32_737 vssd1 vccd1 sky130_fd_sc_hd__tapvpwrvgnd_1
XANTENNA__09121__S net357 vssd1 vssd1 vccd1 vccd1 sky130_fd_sc_hd__diode_2
X_11729_ net903 _01075_ net687 vssd1 vssd1 vccd1 vccd1 FPGA_INST.cell3.SB0.route_sel\[99\]
+ sky130_fd_sc_hd__dfstp_1
XANTENNA__11309__CLK net842 vssd1 vssd1 vccd1 vccd1 sky130_fd_sc_hd__diode_2
XFILLER_80_80 vssd1 vssd1 vccd1 vccd1 sky130_fd_sc_hd__fill_1
X_05250_ FPGA_INST.cell2.CB_0.config_dataA\[13\] vssd1 vssd1 vccd1 vccd1 _01532_ sky130_fd_sc_hd__inv_2
XTAP_TAPCELL_ROW_12_450 vssd1 vccd1 sky130_fd_sc_hd__tapvpwrvgnd_1
XANTENNA__06473__A3 net17 vssd1 vssd1 vccd1 vccd1 sky130_fd_sc_hd__diode_2
XANTENNA__07407__C1 net369 vssd1 vssd1 vccd1 vccd1 sky130_fd_sc_hd__diode_2
XFILLER_115_302 vssd1 vssd1 vccd1 vccd1 sky130_fd_sc_hd__fill_4
XFILLER_115_357 vssd1 vssd1 vccd1 vccd1 sky130_fd_sc_hd__fill_1
XTAP_TAPCELL_ROW_73_1308 vssd1 vccd1 sky130_fd_sc_hd__tapvpwrvgnd_1
X_08940_ _03903_ _05133_ vssd1 vssd1 vccd1 vccd1 FPGA_INST.bus3_1\[11\] sky130_fd_sc_hd__nor2_4
X_08871_ net24 _05074_ _05077_ vssd1 vssd1 vccd1 vccd1 _05078_ sky130_fd_sc_hd__a21oi_1
XANTENNA__09791__S net332 vssd1 vssd1 vccd1 vccd1 sky130_fd_sc_hd__diode_2
XFILLER_57_606 vssd1 vssd1 vccd1 vccd1 sky130_fd_sc_hd__fill_2
X_07822_ _02010_ net124 _02000_ vssd1 vssd1 vccd1 vccd1 _04064_ sky130_fd_sc_hd__mux2_1
XANTENNA__06933__A1 FPGA_INST.bus2_0\[14\] vssd1 vssd1 vccd1 vccd1 sky130_fd_sc_hd__diode_2
X_07753_ net150 _03507_ _03926_ _03999_ vssd1 vssd1 vccd1 vccd1 _04003_ sky130_fd_sc_hd__o31a_1
X_07684_ net133 _01947_ FPGA_INST.cell3.SB0.route_sel\[101\] FPGA_INST.cell3.SB0.route_sel\[100\]
+ vssd1 vssd1 vccd1 vccd1 _03936_ sky130_fd_sc_hd__o211ai_1
X_06704_ FPGA_INST.bus3_2\[0\] FPGA_INST.bus3_2\[1\] FPGA_INST.bus3_2\[2\] FPGA_INST.bus3_2\[3\]
+ net520 FPGA_INST.cell2.CB_1.config_dataB\[1\] vssd1 vssd1 vccd1 vccd1 _02978_ sky130_fd_sc_hd__mux4_1
XFILLER_37_385 vssd1 vssd1 vccd1 vccd1 sky130_fd_sc_hd__fill_1
XTAP_TAPCELL_ROW_84_1459 vssd1 vccd1 sky130_fd_sc_hd__tapvpwrvgnd_1
XFILLER_64_193 vssd1 vssd1 vccd1 vccd1 sky130_fd_sc_hd__fill_2
X_06635_ _02904_ _02909_ _02910_ vssd1 vssd1 vccd1 vccd1 _02911_ sky130_fd_sc_hd__and3_1
X_09423_ FPGA_INST.cell2.CB_1.config_dataA\[17\] net474 net354 vssd1 vssd1 vccd1 vccd1
+ _00336_ sky130_fd_sc_hd__mux2_1
XFILLER_44_29 vssd1 vssd1 vccd1 vccd1 sky130_fd_sc_hd__fill_2
XANTENNA_fanout347_A net348 vssd1 vssd1 vccd1 vccd1 sky130_fd_sc_hd__diode_2
XANTENNA__11594__SET_B net577 vssd1 vssd1 vccd1 vccd1 sky130_fd_sc_hd__diode_2
X_09354_ FPGA_INST.cell1.SB0.route_sel\[125\] FPGA_INST.cell1.SB0.route_sel\[126\]
+ net200 vssd1 vssd1 vccd1 vccd1 _00267_ sky130_fd_sc_hd__mux2_1
X_08305_ FPGA_INST.bus1_0\[9\] _04517_ _04526_ vssd1 vssd1 vccd1 vccd1 _04527_ sky130_fd_sc_hd__a21oi_1
X_06566_ _01569_ FPGA_INST.cell2.SB0.route_sel\[73\] FPGA_INST.cell2.SB0.route_sel\[78\]
+ _01570_ _02841_ vssd1 vssd1 vccd1 vccd1 _02842_ sky130_fd_sc_hd__a221o_1
X_09285_ FPGA_INST.cell1.SB0.route_sel\[56\] FPGA_INST.cell1.SB0.route_sel\[57\] net208
+ vssd1 vssd1 vccd1 vccd1 _00198_ sky130_fd_sc_hd__mux2_1
X_05517_ FPGA_INST.bus3_2\[11\] vssd1 vssd1 vccd1 vccd1 _01799_ sky130_fd_sc_hd__inv_2
X_06497_ FPGA_INST.cell2.SB0.route_sel\[28\] FPGA_INST.cell2.SB0.route_sel\[29\] vssd1
+ vssd1 vccd1 vccd1 _02773_ sky130_fd_sc_hd__nor2_1
XANTENNA_fanout135_X net135 vssd1 vssd1 vccd1 vccd1 sky130_fd_sc_hd__diode_2
X_08236_ _03759_ _03797_ _03840_ _03876_ net406 net405 vssd1 vssd1 vccd1 vccd1 _04460_
+ sky130_fd_sc_hd__mux4_1
X_05448_ FPGA_INST.cell0.CB_0.config_dataA\[2\] vssd1 vssd1 vccd1 vccd1 _01730_ sky130_fd_sc_hd__inv_2
X_08167_ FPGA_INST.bus1_0\[9\] _04382_ _04383_ FPGA_INST.bus1_0\[8\] FPGA_INST.cell0.CB_1.config_dataA\[2\]
+ vssd1 vssd1 vccd1 vccd1 _04391_ sky130_fd_sc_hd__a221o_1
XANTENNA__12114__SET_B net701 vssd1 vssd1 vccd1 vccd1 sky130_fd_sc_hd__diode_2
X_05379_ FPGA_INST.cell0.SB0.route_sel\[71\] vssd1 vssd1 vccd1 vccd1 _01661_ sky130_fd_sc_hd__inv_2
X_07118_ _03383_ _03349_ _03347_ vssd1 vssd1 vccd1 vccd1 _03384_ sky130_fd_sc_hd__mux2_1
X_08098_ _03973_ _04301_ FPGA_INST.cell1.CB_0.config_dataB\[12\] vssd1 vssd1 vccd1
+ vccd1 _04324_ sky130_fd_sc_hd__o21ai_1
XANTENNA__06621__A0 FPGA_INST.bus3_2\[12\] vssd1 vssd1 vccd1 vccd1 sky130_fd_sc_hd__diode_2
XANTENNA__07964__A3 FPGA_INST.bus3_1\[3\] vssd1 vssd1 vccd1 vccd1 sky130_fd_sc_hd__diode_2
X_07049_ net431 _02233_ net429 vssd1 vssd1 vccd1 vccd1 _03315_ sky130_fd_sc_hd__o21ai_1
X_10060_ FPGA_INST.cell0.CB_1.config_dataA\[9\] net406 net203 vssd1 vssd1 vccd1 vccd1
+ _00941_ sky130_fd_sc_hd__mux2_1
XFILLER_125_54 vssd1 vssd1 vccd1 vccd1 sky130_fd_sc_hd__fill_2
XFILLER_85_25 vccd1 vssd1 vccd1 vssd1 sky130_ef_sc_hd__decap_40_12
XANTENNA_fanout769_X net769 vssd1 vssd1 vccd1 vccd1 sky130_fd_sc_hd__diode_2
XFILLER_75_425 vssd1 vssd1 vccd1 vccd1 sky130_fd_sc_hd__fill_1
XFILLER_47_127 vssd1 vssd1 vccd1 vccd1 sky130_fd_sc_hd__fill_1
XTAP_TAPCELL_ROW_126_2043 vssd1 vccd1 sky130_fd_sc_hd__tapvpwrvgnd_1
XFILLER_85_69 vssd1 vssd1 vccd1 vccd1 sky130_fd_sc_hd__fill_4
XFILLER_75_447 vssd1 vssd1 vccd1 vccd1 sky130_fd_sc_hd__fill_1
X_10962_ net866 _00312_ net653 vssd1 vssd1 vccd1 vccd1 FPGA_INST.cell2.CB_0.config_dataB\[18\]
+ sky130_fd_sc_hd__dfstp_1
XFILLER_28_352 vccd1 vssd1 vccd1 vssd1 sky130_ef_sc_hd__decap_40_12
XFILLER_71_642 vssd1 vssd1 vccd1 vccd1 sky130_fd_sc_hd__fill_8
XFILLER_28_385 vssd1 vssd1 vccd1 vccd1 sky130_fd_sc_hd__fill_4
X_10893_ net825 _00243_ net609 vssd1 vssd1 vccd1 vccd1 FPGA_INST.cell1.SB0.route_sel\[102\]
+ sky130_fd_sc_hd__dfstp_1
XANTENNA__10087__S net173 vssd1 vssd1 vccd1 vccd1 sky130_fd_sc_hd__diode_2
XFILLER_11_241 vssd1 vssd1 vccd1 vccd1 sky130_fd_sc_hd__fill_2
X_11514_ net767 _00864_ net552 vssd1 vssd1 vccd1 vccd1 FPGA_INST.cell0.CB_1.config_dataB\[20\]
+ sky130_fd_sc_hd__dfstp_1
XFILLER_7_223 vssd1 vssd1 vccd1 vccd1 sky130_fd_sc_hd__fill_1
X_11445_ net775 _00795_ net561 vssd1 vssd1 vccd1 vccd1 FPGA_INST.cell0.LE_0A.config_data\[16\]
+ sky130_fd_sc_hd__dfrtp_1
XFILLER_124_143 vssd1 vssd1 vccd1 vccd1 sky130_fd_sc_hd__fill_1
X_11376_ net818 _00726_ net603 vssd1 vssd1 vccd1 vccd1 FPGA_INST.cell1.LE_1B.reset_val
+ sky130_fd_sc_hd__dfrtp_1
XFILLER_124_176 vssd1 vssd1 vccd1 vccd1 sky130_fd_sc_hd__fill_8
X_10327_ FPGA_INST.cell3.LEI0.config_data\[41\] FPGA_INST.cell3.LEI0.config_data\[42\]
+ net298 vssd1 vssd1 vccd1 vccd1 _01208_ sky130_fd_sc_hd__mux2_1
XTAP_TAPCELL_ROW_55_1049 vssd1 vccd1 sky130_fd_sc_hd__tapvpwrvgnd_1
XFILLER_3_462 vssd1 vssd1 vccd1 vccd1 sky130_fd_sc_hd__fill_2
XFILLER_59_70 vssd1 vssd1 vccd1 vccd1 sky130_fd_sc_hd__fill_2
X_10258_ FPGA_INST.io_east_oeb\[4\] FPGA_INST.io_east_oeb\[6\] net263 vssd1 vssd1
+ vccd1 vccd1 _01139_ sky130_fd_sc_hd__mux2_1
XFILLER_120_360 vssd1 vssd1 vccd1 vccd1 sky130_fd_sc_hd__fill_2
XFILLER_94_723 vssd1 vssd1 vccd1 vccd1 sky130_fd_sc_hd__fill_8
X_10189_ FPGA_INST.cell3.SB0.route_sel\[93\] FPGA_INST.cell3.SB0.route_sel\[94\] net274
+ vssd1 vssd1 vccd1 vccd1 _01070_ sky130_fd_sc_hd__mux2_1
XANTENNA__06915__A1 FPGA_INST.bus2_0\[7\] vssd1 vssd1 vccd1 vccd1 sky130_fd_sc_hd__diode_2
XFILLER_39_639 vssd1 vssd1 vccd1 vccd1 sky130_fd_sc_hd__fill_2
XANTENNA__12107__CLK net917 vssd1 vssd1 vccd1 vccd1 sky130_fd_sc_hd__diode_2
XTAP_TAPCELL_ROW_37_807 vssd1 vccd1 sky130_fd_sc_hd__tapvpwrvgnd_1
XANTENNA__08668__A1 _04794_ vssd1 vssd1 vccd1 vccd1 sky130_fd_sc_hd__diode_2
XFILLER_75_91 vssd1 vssd1 vccd1 vccd1 sky130_fd_sc_hd__fill_1
XFILLER_53_108 vssd1 vssd1 vccd1 vccd1 sky130_fd_sc_hd__fill_1
XFILLER_19_363 vssd1 vssd1 vccd1 vccd1 sky130_fd_sc_hd__fill_1
XANTENNA__08668__B2 _04789_ vssd1 vssd1 vccd1 vccd1 sky130_fd_sc_hd__diode_2
XTAP_TAPCELL_ROW_17_520 vssd1 vccd1 sky130_fd_sc_hd__tapvpwrvgnd_1
X_06420_ _02691_ _02694_ _02696_ _02697_ vssd1 vssd1 vccd1 vccd1 _02698_ sky130_fd_sc_hd__o22a_1
X_06351_ _02330_ _02623_ _02627_ _02628_ _01539_ vssd1 vssd1 vccd1 vccd1 _02629_ sky130_fd_sc_hd__a221o_1
X_09070_ _03698_ _03699_ _05202_ _03701_ vssd1 vssd1 vccd1 vccd1 net66 sky130_fd_sc_hd__a31o_1
X_05302_ FPGA_INST.cell2.SB0.route_sel\[120\] vssd1 vssd1 vccd1 vccd1 _01584_ sky130_fd_sc_hd__inv_2
X_06282_ net30 _02541_ _02561_ vssd1 vssd1 vccd1 vccd1 _02562_ sky130_fd_sc_hd__a21o_1
X_08021_ net458 _03889_ _04246_ vssd1 vssd1 vccd1 vccd1 _04247_ sky130_fd_sc_hd__a21o_1
XANTENNA__08840__A1 _04843_ vssd1 vssd1 vccd1 vccd1 sky130_fd_sc_hd__diode_2
XANTENNA__08840__B2 _04846_ vssd1 vssd1 vccd1 vccd1 sky130_fd_sc_hd__diode_2
XANTENNA__06851__A0 FPGA_INST.bus2_0\[8\] vssd1 vssd1 vccd1 vccd1 sky130_fd_sc_hd__diode_2
X_09972_ _05225_ _05226_ vssd1 vssd1 vccd1 vccd1 _00871_ sky130_fd_sc_hd__and2_1
XPHY_EDGE_ROW_123_Right_123 vssd1 vssd1 vccd1 vccd1 sky130_fd_sc_hd__decap_3
XFILLER_115_165 vssd1 vssd1 vccd1 vccd1 sky130_fd_sc_hd__fill_1
XFILLER_115_154 vssd1 vssd1 vccd1 vccd1 sky130_fd_sc_hd__fill_2
XFILLER_89_528 vssd1 vssd1 vccd1 vccd1 sky130_fd_sc_hd__fill_1
XFILLER_89_517 vssd1 vssd1 vccd1 vccd1 sky130_fd_sc_hd__fill_2
XFILLER_130_113 vssd1 vssd1 vccd1 vccd1 sky130_fd_sc_hd__fill_1
X_08923_ FPGA_INST.cell1.SB0.route_sel\[100\] FPGA_INST.cell1.SB0.route_sel\[101\]
+ vssd1 vssd1 vccd1 vccd1 _05122_ sky130_fd_sc_hd__nand2b_1
XANTENNA__06223__B _02376_ vssd1 vssd1 vccd1 vccd1 sky130_fd_sc_hd__diode_2
XANTENNA_fanout297_A net300 vssd1 vssd1 vccd1 vccd1 sky130_fd_sc_hd__diode_2
XANTENNA__08356__A0 _03759_ vssd1 vssd1 vccd1 vccd1 sky130_fd_sc_hd__diode_2
X_08854_ net90 _01786_ net83 _01792_ FPGA_INST.cell3.LEI0.config_data\[27\] FPGA_INST.cell3.LEI0.config_data\[28\]
+ vssd1 vssd1 vccd1 vccd1 _05061_ sky130_fd_sc_hd__mux4_1
XFILLER_97_594 vssd1 vssd1 vccd1 vccd1 sky130_fd_sc_hd__fill_1
XFILLER_57_436 vssd1 vssd1 vccd1 vccd1 sky130_fd_sc_hd__fill_1
XFILLER_57_414 vssd1 vssd1 vccd1 vccd1 sky130_fd_sc_hd__fill_4
X_08785_ FPGA_INST.cell3.CB_0.config_dataB\[5\] _04804_ vssd1 vssd1 vccd1 vccd1 _04992_
+ sky130_fd_sc_hd__or2_1
X_07805_ FPGA_INST.cell3.SB0.route_sel\[126\] FPGA_INST.cell3.SB0.config_data_out
+ _01899_ _04051_ _04053_ vssd1 vssd1 vccd1 vccd1 _04054_ sky130_fd_sc_hd__a2111o_1
X_05997_ _01943_ _02198_ vssd1 vssd1 vccd1 vccd1 _02277_ sky130_fd_sc_hd__nor2_1
XANTENNA__08659__A1 net19 vssd1 vssd1 vccd1 vccd1 sky130_fd_sc_hd__diode_2
X_07736_ net81 _03526_ _03907_ _03985_ vssd1 vssd1 vccd1 vccd1 _03986_ sky130_fd_sc_hd__o31a_1
XFILLER_72_406 vssd1 vssd1 vccd1 vccd1 sky130_fd_sc_hd__fill_2
XANTENNA__06382__A2 _02255_ vssd1 vssd1 vccd1 vccd1 sky130_fd_sc_hd__diode_2
XANTENNA__07054__B _02350_ vssd1 vssd1 vccd1 vccd1 sky130_fd_sc_hd__diode_2
XANTENNA_fanout729_A net730 vssd1 vssd1 vccd1 vccd1 sky130_fd_sc_hd__diode_2
X_07667_ FPGA_INST.cell1.SB0.route_sel\[99\] FPGA_INST.cell1.SB0.route_sel\[98\] vssd1
+ vssd1 vccd1 vccd1 _03919_ sky130_fd_sc_hd__nand2_1
XFILLER_80_461 vssd1 vssd1 vccd1 vccd1 sky130_fd_sc_hd__fill_1
XANTENNA__06893__B _02070_ vssd1 vssd1 vccd1 vccd1 sky130_fd_sc_hd__diode_2
XANTENNA__06134__A2 _02413_ vssd1 vssd1 vccd1 vccd1 sky130_fd_sc_hd__diode_2
XFILLER_111_78 vccd1 vssd1 vccd1 vssd1 sky130_ef_sc_hd__decap_40_12
X_07598_ FPGA_INST.cell1.SB0.route_sel\[82\] FPGA_INST.cell1.SB0.route_sel\[83\] vssd1
+ vssd1 vccd1 vccd1 _03852_ sky130_fd_sc_hd__nor2_1
X_06618_ _02843_ _02880_ _02882_ _02840_ FPGA_INST.cell2.CB_1.config_dataA\[12\] vssd1
+ vssd1 vccd1 vccd1 _02894_ sky130_fd_sc_hd__a221o_1
X_09406_ net483 FPGA_INST.cell2.CB_0.config_dataB\[24\] net354 vssd1 vssd1 vccd1 vccd1
+ _00319_ sky130_fd_sc_hd__mux2_1
XFILLER_25_388 vssd1 vssd1 vccd1 vccd1 sky130_fd_sc_hd__fill_4
X_09337_ FPGA_INST.cell1.SB0.route_sel\[108\] FPGA_INST.cell1.SB0.route_sel\[109\]
+ net226 vssd1 vssd1 vccd1 vccd1 _00250_ sky130_fd_sc_hd__mux2_1
X_06549_ _02785_ _02819_ _02824_ _02781_ _01590_ vssd1 vssd1 vccd1 vccd1 _02825_ sky130_fd_sc_hd__a221o_1
X_09268_ FPGA_INST.cell1.SB0.route_sel\[40\] FPGA_INST.cell1.SB0.route_sel\[39\] net331
+ vssd1 vssd1 vccd1 vccd1 _00181_ sky130_fd_sc_hd__mux2_1
XANTENNA__09696__S net320 vssd1 vssd1 vccd1 vccd1 sky130_fd_sc_hd__diode_2
XTAP_TAPCELL_ROW_97_1639 vssd1 vccd1 sky130_fd_sc_hd__tapvpwrvgnd_1
X_08219_ net405 net406 vssd1 vssd1 vccd1 vccd1 _04443_ sky130_fd_sc_hd__and2b_1
XANTENNA__08292__C1 net155 vssd1 vssd1 vccd1 vccd1 sky130_fd_sc_hd__diode_2
XANTENNA__10635__S net372 vssd1 vssd1 vccd1 vccd1 sky130_fd_sc_hd__diode_2
XANTENNA__08613__B _04821_ vssd1 vssd1 vccd1 vccd1 sky130_fd_sc_hd__diode_2
XFILLER_5_727 vssd1 vssd1 vccd1 vccd1 sky130_fd_sc_hd__fill_1
X_09199_ FPGA_INST.cell2.LE_1A.config_data\[16\] FPGA_INST.cell2.LE_1A.edge_mode net262
+ vssd1 vssd1 vccd1 vccd1 _00112_ sky130_fd_sc_hd__mux2_1
XFILLER_105_3 vssd1 vssd1 vccd1 vccd1 sky130_fd_sc_hd__fill_8
XANTENNA__07398__A1 net133 vssd1 vssd1 vccd1 vccd1 sky130_fd_sc_hd__diode_2
X_11230_ net766 _00580_ net551 vssd1 vssd1 vccd1 vccd1 FPGA_INST.cell0.SB0.route_sel\[75\]
+ sky130_fd_sc_hd__dfstp_1
XFILLER_107_677 vssd1 vssd1 vccd1 vccd1 sky130_fd_sc_hd__fill_2
X_11161_ net821 _00511_ net605 vssd1 vssd1 vccd1 vccd1 FPGA_INST.cell0.SB0.route_sel\[6\]
+ sky130_fd_sc_hd__dfstp_1
XFILLER_121_113 vssd1 vssd1 vccd1 vccd1 sky130_fd_sc_hd__fill_2
X_10112_ FPGA_INST.cell3.SB0.route_sel\[16\] FPGA_INST.cell3.SB0.route_sel\[17\] net269
+ vssd1 vssd1 vccd1 vccd1 _00993_ sky130_fd_sc_hd__mux2_1
X_11092_ net840 _00442_ net624 vssd1 vssd1 vccd1 vccd1 FPGA_INST.cell1.LE_0B.config_data\[5\]
+ sky130_fd_sc_hd__dfrtp_1
XFILLER_121_157 vssd1 vssd1 vccd1 vccd1 sky130_fd_sc_hd__fill_2
XFILLER_102_371 vssd1 vssd1 vccd1 vccd1 sky130_fd_sc_hd__fill_2
XFILLER_48_436 vssd1 vssd1 vccd1 vccd1 sky130_fd_sc_hd__fill_2
X_10043_ FPGA_INST.cell0.CB_0.config_dataB\[18\] FPGA_INST.cell0.CB_0.config_dataB\[17\]
+ net309 vssd1 vssd1 vccd1 vccd1 _00924_ sky130_fd_sc_hd__mux2_1
XANTENNA_input25_A gpio_in[31] vssd1 vssd1 vccd1 vccd1 sky130_fd_sc_hd__diode_2
XFILLER_75_222 vssd1 vssd1 vccd1 vccd1 sky130_fd_sc_hd__fill_2
XANTENNA__08114__A3 FPGA_INST.bus3_1\[3\] vssd1 vssd1 vccd1 vccd1 sky130_fd_sc_hd__diode_2
XFILLER_75_299 vssd1 vssd1 vccd1 vccd1 sky130_fd_sc_hd__fill_4
XFILLER_44_620 vssd1 vssd1 vccd1 vccd1 sky130_fd_sc_hd__fill_2
XFILLER_16_333 vssd1 vssd1 vccd1 vccd1 sky130_fd_sc_hd__fill_1
X_11994_ net783 _01340_ net568 vssd1 vssd1 vccd1 vccd1 FPGA_INST.cell2.SB0.route_sel\[34\]
+ sky130_fd_sc_hd__dfstp_1
XTAP_TAPCELL_ROW_106_1768 vssd1 vccd1 sky130_fd_sc_hd__tapvpwrvgnd_1
X_10945_ net865 _00295_ net650 vssd1 vssd1 vccd1 vccd1 FPGA_INST.cell2.CB_0.config_dataB\[1\]
+ sky130_fd_sc_hd__dfstp_1
XANTENNA__07873__A2 FPGA_INST.bus3_1\[14\] vssd1 vssd1 vccd1 vccd1 sky130_fd_sc_hd__diode_2
X_10876_ net791 _00226_ net576 vssd1 vssd1 vccd1 vccd1 FPGA_INST.cell1.SB0.route_sel\[85\]
+ sky130_fd_sc_hd__dfstp_1
XFILLER_31_314 vssd1 vssd1 vccd1 vccd1 sky130_fd_sc_hd__fill_2
XTAP_TAPCELL_ROW_42_865 vssd1 vccd1 sky130_fd_sc_hd__tapvpwrvgnd_1
XTAP_TAPCELL_ROW_42_876 vssd1 vccd1 sky130_fd_sc_hd__tapvpwrvgnd_1
XFILLER_12_572 vssd1 vssd1 vccd1 vccd1 sky130_fd_sc_hd__fill_2
XANTENNA__06833__A0 FPGA_INST.bus2_0\[6\] vssd1 vssd1 vccd1 vccd1 sky130_fd_sc_hd__diode_2
XFILLER_8_587 vssd1 vssd1 vccd1 vccd1 sky130_fd_sc_hd__fill_1
XFILLER_8_576 vssd1 vssd1 vccd1 vccd1 sky130_fd_sc_hd__fill_1
XFILLER_125_441 vssd1 vssd1 vccd1 vccd1 sky130_fd_sc_hd__fill_4
X_11428_ FPGA_INST.cell0.LE_0B.sel_clk _00778_ net732 vssd1 vssd1 vccd1 vccd1 FPGA_INST.cell0.LE_0B.dff1_out
+ sky130_fd_sc_hd__dfstp_1
XFILLER_125_463 vssd1 vssd1 vccd1 vccd1 sky130_fd_sc_hd__fill_2
X_11359_ net818 _00709_ net603 vssd1 vssd1 vccd1 vccd1 FPGA_INST.cell1.LE_1B.config_data\[1\]
+ sky130_fd_sc_hd__dfrtp_1
XFILLER_112_135 vssd1 vssd1 vccd1 vccd1 sky130_fd_sc_hd__fill_4
XFILLER_98_358 vssd1 vssd1 vccd1 vccd1 sky130_fd_sc_hd__fill_2
XANTENNA__06600__A3 net103 vssd1 vssd1 vccd1 vccd1 sky130_fd_sc_hd__diode_2
X_05920_ FPGA_INST.cell2.CB_1.config_dataA\[23\] FPGA_INST.cell2.CB_1.config_dataA\[22\]
+ vssd1 vssd1 vccd1 vccd1 _02200_ sky130_fd_sc_hd__nand2b_1
XFILLER_20_3 vccd1 vssd1 vccd1 vssd1 sky130_ef_sc_hd__decap_40_12
X_05851_ _02130_ _02128_ vssd1 vssd1 vccd1 vccd1 _02131_ sky130_fd_sc_hd__and2b_2
XFILLER_39_447 vssd1 vssd1 vccd1 vccd1 sky130_fd_sc_hd__fill_1
X_08570_ FPGA_INST.cell3.SB0.route_sel\[86\] FPGA_INST.cell3.SB0.route_sel\[87\] vssd1
+ vssd1 vccd1 vccd1 _04779_ sky130_fd_sc_hd__nand2b_1
XTAP_TAPCELL_ROW_68_1229 vssd1 vccd1 sky130_fd_sc_hd__tapvpwrvgnd_1
X_07521_ FPGA_INST.cell3.CB_1.le_outA _03776_ vssd1 vssd1 vccd1 vccd1 _03777_ sky130_fd_sc_hd__nand2_1
XFILLER_81_214 vssd1 vssd1 vccd1 vccd1 sky130_fd_sc_hd__fill_1
X_05782_ net112 _01879_ _02019_ vssd1 vssd1 vccd1 vccd1 _02062_ sky130_fd_sc_hd__nor3_1
XFILLER_19_160 vssd1 vssd1 vccd1 vccd1 sky130_fd_sc_hd__fill_8
XFILLER_35_653 vccd1 vssd1 vccd1 vssd1 sky130_ef_sc_hd__decap_40_12
XFILLER_35_675 vssd1 vssd1 vccd1 vccd1 sky130_fd_sc_hd__fill_2
X_07452_ _03546_ _03591_ vssd1 vssd1 vccd1 vccd1 _03709_ sky130_fd_sc_hd__nor2_1
XTAP_TAPCELL_ROW_81_1418 vssd1 vccd1 sky130_fd_sc_hd__tapvpwrvgnd_1
XFILLER_62_461 vssd1 vssd1 vccd1 vccd1 sky130_fd_sc_hd__fill_2
XFILLER_22_303 vssd1 vssd1 vccd1 vccd1 sky130_fd_sc_hd__fill_2
X_07383_ FPGA_INST.cell1.SB0.route_sel\[40\] FPGA_INST.cell1.SB0.route_sel\[41\] vssd1
+ vssd1 vccd1 vccd1 _03642_ sky130_fd_sc_hd__nand2_1
X_06403_ net14 net15 net16 net17 net497 net496 vssd1 vssd1 vccd1 vccd1 _02681_ sky130_fd_sc_hd__mux4_1
X_06334_ FPGA_INST.cell2.LE_0A.config_data\[9\] FPGA_INST.cell2.LE_0A.config_data\[8\]
+ _02536_ vssd1 vssd1 vccd1 vccd1 _02614_ sky130_fd_sc_hd__mux2_1
X_09122_ FPGA_INST.cell2.LEI0.config_data\[36\] FPGA_INST.cell2.LEI0.config_data\[37\]
+ net250 vssd1 vssd1 vccd1 vccd1 _00038_ sky130_fd_sc_hd__mux2_1
XANTENNA__08274__C1 _04494_ vssd1 vssd1 vccd1 vccd1 sky130_fd_sc_hd__diode_2
X_06265_ net504 _01869_ _02544_ net502 vssd1 vssd1 vccd1 vccd1 _02545_ sky130_fd_sc_hd__o211a_1
XTAP_TAPCELL_ROW_20_559 vssd1 vccd1 sky130_fd_sc_hd__tapvpwrvgnd_1
X_09053_ net745 FPGA_INST.cell0.LE_1A.edge_mode vssd1 vssd1 vccd1 vccd1 FPGA_INST.cell0.LE_1A.sel_clk
+ sky130_fd_sc_hd__xnor2_1
X_08004_ FPGA_INST.cell1.LE_0A.dff0_out FPGA_INST.cell1.LE_0A.dff1_out FPGA_INST.cell1.LE_0A.reset_val
+ vssd1 vssd1 vccd1 vccd1 FPGA_INST.cell1.LE_0A.dff_out sky130_fd_sc_hd__mux2_1
XFILLER_116_430 vssd1 vssd1 vccd1 vccd1 sky130_fd_sc_hd__fill_2
X_06196_ net132 _02472_ _02475_ _02468_ vssd1 vssd1 vccd1 vccd1 _02476_ sky130_fd_sc_hd__o211a_1
XTAP_TAPCELL_ROW_92_1569 vssd1 vccd1 sky130_fd_sc_hd__tapvpwrvgnd_1
XFILLER_89_347 vssd1 vssd1 vccd1 vccd1 sky130_fd_sc_hd__fill_2
XFILLER_103_135 vssd1 vssd1 vccd1 vccd1 sky130_fd_sc_hd__fill_4
XFILLER_89_369 vssd1 vssd1 vccd1 vccd1 sky130_fd_sc_hd__fill_4
XANTENNA_fanout581_A net588 vssd1 vssd1 vccd1 vccd1 sky130_fd_sc_hd__diode_2
X_09955_ net438 net440 net312 vssd1 vssd1 vccd1 vccd1 _00860_ sky130_fd_sc_hd__mux2_1
XFILLER_58_701 vssd1 vssd1 vccd1 vccd1 sky130_fd_sc_hd__fill_4
X_08906_ _01612_ FPGA_INST.cell1.SB0.route_sel\[115\] FPGA_INST.cell1.SB0.route_sel\[112\]
+ FPGA_INST.cell1.SB0.route_sel\[113\] _05110_ vssd1 vssd1 vccd1 vccd1 _05111_ sky130_fd_sc_hd__o221a_1
XANTENNA_fanout679_A net683 vssd1 vssd1 vccd1 vccd1 sky130_fd_sc_hd__diode_2
X_09886_ FPGA_INST.cell0.LE_0A.config_data\[13\] FPGA_INST.cell0.LE_0A.config_data\[14\]
+ net192 vssd1 vssd1 vccd1 vccd1 _00793_ sky130_fd_sc_hd__mux2_1
X_08837_ FPGA_INST.cell3.CB_0.config_dataB\[13\] _05043_ vssd1 vssd1 vccd1 vccd1 _05044_
+ sky130_fd_sc_hd__nor2_1
XFILLER_58_767 vssd1 vssd1 vccd1 vccd1 sky130_fd_sc_hd__fill_2
XTAP_TAPCELL_ROW_123_2002 vssd1 vccd1 sky130_fd_sc_hd__tapvpwrvgnd_1
XFILLER_85_564 vssd1 vssd1 vccd1 vccd1 sky130_fd_sc_hd__fill_1
XFILLER_57_277 vssd1 vssd1 vccd1 vccd1 sky130_fd_sc_hd__fill_2
XANTENNA_fanout846_A net849 vssd1 vssd1 vccd1 vccd1 sky130_fd_sc_hd__diode_2
X_08768_ net389 net390 vssd1 vssd1 vccd1 vccd1 _04975_ sky130_fd_sc_hd__and2b_1
X_08699_ _04794_ _04895_ _04896_ _04789_ FPGA_INST.cell3.CB_0.config_dataA\[12\] vssd1
+ vssd1 vccd1 vccd1 _04908_ sky130_fd_sc_hd__a221o_1
XFILLER_82_15 vccd1 vssd1 vccd1 vssd1 sky130_ef_sc_hd__decap_40_12
X_07719_ _03963_ _03969_ vssd1 vssd1 vccd1 vccd1 _03970_ sky130_fd_sc_hd__nand2_1
XTAP_TAPCELL_ROW_0_262 vssd1 vccd1 sky130_fd_sc_hd__tapvpwrvgnd_1
XFILLER_41_623 vssd1 vssd1 vccd1 vccd1 sky130_fd_sc_hd__fill_1
XFILLER_41_601 vssd1 vssd1 vccd1 vccd1 sky130_fd_sc_hd__fill_2
X_10730_ net872 _00080_ net656 vssd1 vssd1 vccd1 vccd1 FPGA_INST.cell2.LE_0B.config_data\[7\]
+ sky130_fd_sc_hd__dfrtp_1
XTAP_TAPCELL_ROW_0_273 vssd1 vccd1 sky130_fd_sc_hd__tapvpwrvgnd_1
XTAP_TAPCELL_ROW_0_284 vssd1 vccd1 sky130_fd_sc_hd__tapvpwrvgnd_1
XFILLER_25_185 vssd1 vssd1 vccd1 vccd1 sky130_fd_sc_hd__fill_2
XFILLER_80_280 vssd1 vssd1 vccd1 vccd1 sky130_fd_sc_hd__fill_8
XANTENNA__05313__A FPGA_INST.cell2.LEI0.config_data\[23\] vssd1 vssd1 vccd1 vccd1
+ sky130_fd_sc_hd__diode_2
X_10661_ net887 _00011_ net671 vssd1 vssd1 vccd1 vccd1 FPGA_INST.cell2.LEI0.config_data\[10\]
+ sky130_fd_sc_hd__dfrtp_1
XFILLER_41_645 vssd1 vssd1 vccd1 vccd1 sky130_fd_sc_hd__fill_4
XFILLER_13_347 vssd1 vssd1 vccd1 vccd1 sky130_fd_sc_hd__fill_4
XFILLER_9_318 vssd1 vssd1 vccd1 vccd1 sky130_fd_sc_hd__fill_4
X_10592_ FPGA_INST.cell3.CB_0.config_dataB\[12\] FPGA_INST.cell3.CB_0.config_dataB\[11\]
+ net377 vssd1 vssd1 vccd1 vccd1 _01471_ sky130_fd_sc_hd__mux2_1
XTAP_TAPCELL_ROW_101_1698 vssd1 vccd1 sky130_fd_sc_hd__tapvpwrvgnd_1
XFILLER_107_452 vssd1 vssd1 vccd1 vccd1 sky130_fd_sc_hd__fill_1
X_11213_ net757 _00563_ net542 vssd1 vssd1 vccd1 vccd1 FPGA_INST.cell0.SB0.route_sel\[58\]
+ sky130_fd_sc_hd__dfstp_1
Xoutput41 net41 vssd1 vssd1 vccd1 vccd1 gpio_oeb[29] sky130_fd_sc_hd__buf_2
Xoutput52 net52 vssd1 vssd1 vccd1 vccd1 gpio_out[17] sky130_fd_sc_hd__buf_2
Xoutput63 net63 vssd1 vssd1 vccd1 vccd1 gpio_out[28] sky130_fd_sc_hd__buf_2
XFILLER_122_444 vssd1 vssd1 vccd1 vccd1 sky130_fd_sc_hd__fill_1
X_11144_ net808 _00494_ net594 vssd1 vssd1 vccd1 vccd1 FPGA_INST.cell1.CB_1.config_dataB\[14\]
+ sky130_fd_sc_hd__dfstp_1
XTAP_TAPCELL_ROW_52_1008 vssd1 vccd1 sky130_fd_sc_hd__tapvpwrvgnd_1
X_11075_ net837 _00425_ net621 vssd1 vssd1 vccd1 vccd1 FPGA_INST.cell1.LE_0A.config_data\[10\]
+ sky130_fd_sc_hd__dfrtp_1
XANTENNA__06594__A2 _02796_ vssd1 vssd1 vccd1 vccd1 sky130_fd_sc_hd__diode_2
XTAP_TAPCELL_ROW_8_395 vssd1 vccd1 sky130_fd_sc_hd__tapvpwrvgnd_1
XFILLER_0_273 vssd1 vssd1 vccd1 vccd1 sky130_fd_sc_hd__fill_4
XFILLER_0_251 vssd1 vssd1 vccd1 vccd1 sky130_fd_sc_hd__fill_1
XFILLER_76_531 vssd1 vssd1 vccd1 vccd1 sky130_fd_sc_hd__fill_1
XANTENNA_input28_X net28 vssd1 vssd1 vccd1 vccd1 sky130_fd_sc_hd__diode_2
X_10026_ net423 net424 net310 vssd1 vssd1 vccd1 vccd1 _00907_ sky130_fd_sc_hd__mux2_1
XFILLER_64_737 vssd1 vssd1 vccd1 vccd1 sky130_fd_sc_hd__fill_8
XTAP_TAPCELL_ROW_47_946 vssd1 vccd1 sky130_fd_sc_hd__tapvpwrvgnd_1
XTAP_TAPCELL_ROW_47_935 vssd1 vccd1 sky130_fd_sc_hd__tapvpwrvgnd_1
X_11977_ net845 _01323_ net630 vssd1 vssd1 vccd1 vccd1 FPGA_INST.cell2.SB0.route_sel\[17\]
+ sky130_fd_sc_hd__dfstp_1
X_10928_ net851 _00278_ net636 vssd1 vssd1 vccd1 vccd1 FPGA_INST.cell2.CB_0.config_dataA\[9\]
+ sky130_fd_sc_hd__dfstp_1
XTAP_TAPCELL_ROW_63_1159 vssd1 vccd1 sky130_fd_sc_hd__tapvpwrvgnd_1
XFILLER_16_185 vssd1 vssd1 vccd1 vccd1 sky130_fd_sc_hd__fill_2
X_10859_ net801 _00209_ net586 vssd1 vssd1 vccd1 vccd1 FPGA_INST.cell1.SB0.route_sel\[68\]
+ sky130_fd_sc_hd__dfstp_1
XTAP_TAPCELL_ROW_119_1948 vssd1 vccd1 sky130_fd_sc_hd__tapvpwrvgnd_1
XFILLER_68_3 vssd1 vssd1 vccd1 vccd1 sky130_fd_sc_hd__fill_8
X_06050_ _02329_ _02327_ vssd1 vssd1 vccd1 vccd1 _02330_ sky130_fd_sc_hd__and2b_4
XANTENNA__06282__A1 net30 vssd1 vssd1 vccd1 vccd1 sky130_fd_sc_hd__diode_2
XTAP_TAPCELL_ROW_78_1380 vssd1 vccd1 sky130_fd_sc_hd__tapvpwrvgnd_1
XFILLER_99_623 vssd1 vssd1 vccd1 vccd1 sky130_fd_sc_hd__fill_1
Xfanout319 net325 vssd1 vssd1 vccd1 vccd1 net319 sky130_fd_sc_hd__clkbuf_4
Xfanout308 net315 vssd1 vssd1 vccd1 vccd1 net308 sky130_fd_sc_hd__clkbuf_4
XFILLER_101_617 vccd1 vssd1 vccd1 vssd1 sky130_ef_sc_hd__decap_40_12
X_09740_ net464 net462 net222 vssd1 vssd1 vccd1 vccd1 _00649_ sky130_fd_sc_hd__mux2_1
XFILLER_86_317 vccd1 vssd1 vccd1 vssd1 sky130_ef_sc_hd__decap_40_12
X_06952_ FPGA_INST.bus2_0\[4\] _03198_ _03218_ FPGA_INST.cell0.CB_0.config_dataB\[16\]
+ vssd1 vssd1 vccd1 vccd1 _03220_ sky130_fd_sc_hd__a22o_1
.ends
