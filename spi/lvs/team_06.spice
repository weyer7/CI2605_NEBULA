* NGSPICE file created from team_06.ext - technology: sky130A

* Black-box entry subcircuit for sky130_fd_sc_hd__fill_1 abstract view
.subckt sky130_fd_sc_hd__fill_1 VGND VNB VPB VPWR
.ends

* Black-box entry subcircuit for sky130_fd_sc_hd__tapvpwrvgnd_1 abstract view
.subckt sky130_fd_sc_hd__tapvpwrvgnd_1 VGND VPWR
.ends

* Black-box entry subcircuit for sky130_fd_sc_hd__mux2_1 abstract view
.subckt sky130_fd_sc_hd__mux2_1 A0 A1 S VGND VNB VPB VPWR X
.ends

* Black-box entry subcircuit for sky130_fd_sc_hd__xnor2_2 abstract view
.subckt sky130_fd_sc_hd__xnor2_2 A B VGND VNB VPB VPWR Y
.ends

* Black-box entry subcircuit for sky130_fd_sc_hd__diode_2 abstract view
.subckt sky130_fd_sc_hd__diode_2 DIODE VGND VNB VPB VPWR
.ends

* Black-box entry subcircuit for sky130_fd_sc_hd__fill_2 abstract view
.subckt sky130_fd_sc_hd__fill_2 VGND VNB VPB VPWR
.ends

* Black-box entry subcircuit for sky130_fd_sc_hd__dlygate4sd3_1 abstract view
.subckt sky130_fd_sc_hd__dlygate4sd3_1 A VGND VNB VPB VPWR X
.ends

* Black-box entry subcircuit for sky130_fd_sc_hd__inv_2 abstract view
.subckt sky130_fd_sc_hd__inv_2 A VGND VNB VPB VPWR Y
.ends

* Black-box entry subcircuit for sky130_fd_sc_hd__a32o_2 abstract view
.subckt sky130_fd_sc_hd__a32o_2 A1 A2 A3 B1 B2 VGND VNB VPB VPWR X
.ends

* Black-box entry subcircuit for sky130_fd_sc_hd__dfrtp_2 abstract view
.subckt sky130_fd_sc_hd__dfrtp_2 CLK D RESET_B VGND VNB VPB VPWR Q
.ends

* Black-box entry subcircuit for sky130_fd_sc_hd__a21oi_2 abstract view
.subckt sky130_fd_sc_hd__a21oi_2 A1 A2 B1 VGND VNB VPB VPWR Y
.ends

* Black-box entry subcircuit for sky130_fd_sc_hd__o22a_2 abstract view
.subckt sky130_fd_sc_hd__o22a_2 A1 A2 B1 B2 VGND VNB VPB VPWR X
.ends

* Black-box entry subcircuit for sky130_fd_sc_hd__or4_2 abstract view
.subckt sky130_fd_sc_hd__or4_2 A B C D VGND VNB VPB VPWR X
.ends

* Black-box entry subcircuit for sky130_fd_sc_hd__clkdlybuf4s25_1 abstract view
.subckt sky130_fd_sc_hd__clkdlybuf4s25_1 A VGND VNB VPB VPWR X
.ends

* Black-box entry subcircuit for sky130_fd_sc_hd__dfxtp_2 abstract view
.subckt sky130_fd_sc_hd__dfxtp_2 CLK D VGND VNB VPB VPWR Q
.ends

* Black-box entry subcircuit for sky130_fd_sc_hd__a31oi_2 abstract view
.subckt sky130_fd_sc_hd__a31oi_2 A1 A2 A3 B1 VGND VNB VPB VPWR Y
.ends

* Black-box entry subcircuit for sky130_fd_sc_hd__a22o_2 abstract view
.subckt sky130_fd_sc_hd__a22o_2 A1 A2 B1 B2 VGND VNB VPB VPWR X
.ends

* Black-box entry subcircuit for sky130_fd_sc_hd__or3_2 abstract view
.subckt sky130_fd_sc_hd__or3_2 A B C VGND VNB VPB VPWR X
.ends

* Black-box entry subcircuit for sky130_fd_sc_hd__fill_8 abstract view
.subckt sky130_fd_sc_hd__fill_8 VGND VNB VPB VPWR
.ends

* Black-box entry subcircuit for sky130_fd_sc_hd__fill_4 abstract view
.subckt sky130_fd_sc_hd__fill_4 VGND VNB VPB VPWR
.ends

* Black-box entry subcircuit for sky130_fd_sc_hd__nand2_2 abstract view
.subckt sky130_fd_sc_hd__nand2_2 A B VGND VNB VPB VPWR Y
.ends

* Black-box entry subcircuit for sky130_fd_sc_hd__o21ai_2 abstract view
.subckt sky130_fd_sc_hd__o21ai_2 A1 A2 B1 VGND VNB VPB VPWR Y
.ends

* Black-box entry subcircuit for sky130_fd_sc_hd__buf_4 abstract view
.subckt sky130_fd_sc_hd__buf_4 A VGND VNB VPB VPWR X
.ends

* Black-box entry subcircuit for sky130_fd_sc_hd__buf_2 abstract view
.subckt sky130_fd_sc_hd__buf_2 A VGND VNB VPB VPWR X
.ends

* Black-box entry subcircuit for sky130_fd_sc_hd__clkbuf_4 abstract view
.subckt sky130_fd_sc_hd__clkbuf_4 A VGND VNB VPB VPWR X
.ends

* Black-box entry subcircuit for sky130_fd_sc_hd__nor2_2 abstract view
.subckt sky130_fd_sc_hd__nor2_2 A B VGND VNB VPB VPWR Y
.ends

* Black-box entry subcircuit for sky130_fd_sc_hd__o21a_2 abstract view
.subckt sky130_fd_sc_hd__o21a_2 A1 A2 B1 VGND VNB VPB VPWR X
.ends

* Black-box entry subcircuit for sky130_fd_sc_hd__or2_2 abstract view
.subckt sky130_fd_sc_hd__or2_2 A B VGND VNB VPB VPWR X
.ends

* Black-box entry subcircuit for sky130_fd_sc_hd__and2_2 abstract view
.subckt sky130_fd_sc_hd__and2_2 A B VGND VNB VPB VPWR X
.ends

* Black-box entry subcircuit for sky130_fd_sc_hd__and3_2 abstract view
.subckt sky130_fd_sc_hd__and3_2 A B C VGND VNB VPB VPWR X
.ends

* Black-box entry subcircuit for sky130_fd_sc_hd__nand2b_2 abstract view
.subckt sky130_fd_sc_hd__nand2b_2 A_N B VGND VNB VPB VPWR Y
.ends

* Black-box entry subcircuit for sky130_fd_sc_hd__o2111a_2 abstract view
.subckt sky130_fd_sc_hd__o2111a_2 A1 A2 B1 C1 D1 VGND VNB VPB VPWR X
.ends

* Black-box entry subcircuit for sky130_fd_sc_hd__nand3_2 abstract view
.subckt sky130_fd_sc_hd__nand3_2 A B C VGND VNB VPB VPWR Y
.ends

* Black-box entry subcircuit for sky130_fd_sc_hd__conb_1 abstract view
.subckt sky130_fd_sc_hd__conb_1 VGND VNB VPB VPWR HI LO
.ends

* Black-box entry subcircuit for sky130_fd_sc_hd__and2b_2 abstract view
.subckt sky130_fd_sc_hd__and2b_2 A_N B VGND VNB VPB VPWR X
.ends

* Black-box entry subcircuit for sky130_fd_sc_hd__o211a_2 abstract view
.subckt sky130_fd_sc_hd__o211a_2 A1 A2 B1 C1 VGND VNB VPB VPWR X
.ends

* Black-box entry subcircuit for sky130_fd_sc_hd__a21o_2 abstract view
.subckt sky130_fd_sc_hd__a21o_2 A1 A2 B1 VGND VNB VPB VPWR X
.ends

* Black-box entry subcircuit for sky130_fd_sc_hd__clkbuf_16 abstract view
.subckt sky130_fd_sc_hd__clkbuf_16 A VGND VNB VPB VPWR X
.ends

* Black-box entry subcircuit for sky130_fd_sc_hd__or3b_2 abstract view
.subckt sky130_fd_sc_hd__or3b_2 A B C_N VGND VNB VPB VPWR X
.ends

* Black-box entry subcircuit for sky130_fd_sc_hd__decap_3 abstract view
.subckt sky130_fd_sc_hd__decap_3 VGND VNB VPB VPWR
.ends

* Black-box entry subcircuit for sky130_fd_sc_hd__and4_2 abstract view
.subckt sky130_fd_sc_hd__and4_2 A B C D VGND VNB VPB VPWR X
.ends

* Black-box entry subcircuit for sky130_fd_sc_hd__o221a_2 abstract view
.subckt sky130_fd_sc_hd__o221a_2 A1 A2 B1 B2 C1 VGND VNB VPB VPWR X
.ends

* Black-box entry subcircuit for sky130_fd_sc_hd__clkbuf_2 abstract view
.subckt sky130_fd_sc_hd__clkbuf_2 A VGND VNB VPB VPWR X
.ends

* Black-box entry subcircuit for sky130_fd_sc_hd__a31o_2 abstract view
.subckt sky130_fd_sc_hd__a31o_2 A1 A2 A3 B1 VGND VNB VPB VPWR X
.ends

* Black-box entry subcircuit for sky130_fd_sc_hd__a2bb2o_2 abstract view
.subckt sky130_fd_sc_hd__a2bb2o_2 A1_N A2_N B1 B2 VGND VNB VPB VPWR X
.ends

* Black-box entry subcircuit for sky130_fd_sc_hd__o32a_2 abstract view
.subckt sky130_fd_sc_hd__o32a_2 A1 A2 A3 B1 B2 VGND VNB VPB VPWR X
.ends

* Black-box entry subcircuit for sky130_fd_sc_hd__a211o_2 abstract view
.subckt sky130_fd_sc_hd__a211o_2 A1 A2 B1 C1 VGND VNB VPB VPWR X
.ends

* Black-box entry subcircuit for sky130_fd_sc_hd__nand4_2 abstract view
.subckt sky130_fd_sc_hd__nand4_2 A B C D VGND VNB VPB VPWR Y
.ends

* Black-box entry subcircuit for sky130_fd_sc_hd__a221o_2 abstract view
.subckt sky130_fd_sc_hd__a221o_2 A1 A2 B1 B2 C1 VGND VNB VPB VPWR X
.ends

* Black-box entry subcircuit for sky130_fd_sc_hd__a21bo_2 abstract view
.subckt sky130_fd_sc_hd__a21bo_2 A1 A2 B1_N VGND VNB VPB VPWR X
.ends

* Black-box entry subcircuit for sky130_fd_sc_hd__a21boi_2 abstract view
.subckt sky130_fd_sc_hd__a21boi_2 A1 A2 B1_N VGND VNB VPB VPWR Y
.ends

* Black-box entry subcircuit for sky130_fd_sc_hd__o22ai_2 abstract view
.subckt sky130_fd_sc_hd__o22ai_2 A1 A2 B1 B2 VGND VNB VPB VPWR Y
.ends

* Black-box entry subcircuit for sky130_fd_sc_hd__dfstp_2 abstract view
.subckt sky130_fd_sc_hd__dfstp_2 CLK D SET_B VGND VNB VPB VPWR Q
.ends

* Black-box entry subcircuit for sky130_fd_sc_hd__xor2_2 abstract view
.subckt sky130_fd_sc_hd__xor2_2 A B VGND VNB VPB VPWR X
.ends

* Black-box entry subcircuit for sky130_fd_sc_hd__o221ai_2 abstract view
.subckt sky130_fd_sc_hd__o221ai_2 A1 A2 B1 B2 C1 VGND VNB VPB VPWR Y
.ends

* Black-box entry subcircuit for sky130_fd_sc_hd__and3b_2 abstract view
.subckt sky130_fd_sc_hd__and3b_2 A_N B C VGND VNB VPB VPWR X
.ends

* Black-box entry subcircuit for sky130_fd_sc_hd__clkbuf_8 abstract view
.subckt sky130_fd_sc_hd__clkbuf_8 A VGND VNB VPB VPWR X
.ends

* Black-box entry subcircuit for sky130_fd_sc_hd__a211oi_2 abstract view
.subckt sky130_fd_sc_hd__a211oi_2 A1 A2 B1 C1 VGND VNB VPB VPWR Y
.ends

* Black-box entry subcircuit for sky130_fd_sc_hd__o21ba_2 abstract view
.subckt sky130_fd_sc_hd__o21ba_2 A1 A2 B1_N VGND VNB VPB VPWR X
.ends

* Black-box entry subcircuit for sky130_fd_sc_hd__o311a_2 abstract view
.subckt sky130_fd_sc_hd__o311a_2 A1 A2 A3 B1 C1 VGND VNB VPB VPWR X
.ends

* Black-box entry subcircuit for sky130_ef_sc_hd__decap_40_12 abstract view
.subckt sky130_ef_sc_hd__decap_40_12 VNB VPB VGND VPWR
.ends

* Black-box entry subcircuit for sky130_fd_sc_hd__o211ai_2 abstract view
.subckt sky130_fd_sc_hd__o211ai_2 A1 A2 B1 C1 VGND VNB VPB VPWR Y
.ends

* Black-box entry subcircuit for sky130_fd_sc_hd__and4b_2 abstract view
.subckt sky130_fd_sc_hd__and4b_2 A_N B C D VGND VNB VPB VPWR X
.ends

* Black-box entry subcircuit for sky130_fd_sc_hd__o31a_2 abstract view
.subckt sky130_fd_sc_hd__o31a_2 A1 A2 A3 B1 VGND VNB VPB VPWR X
.ends

* Black-box entry subcircuit for sky130_fd_sc_hd__o2bb2a_2 abstract view
.subckt sky130_fd_sc_hd__o2bb2a_2 A1_N A2_N B1 B2 VGND VNB VPB VPWR X
.ends

* Black-box entry subcircuit for sky130_fd_sc_hd__clkinvlp_4 abstract view
.subckt sky130_fd_sc_hd__clkinvlp_4 A VGND VNB VPB VPWR Y
.ends

* Black-box entry subcircuit for sky130_fd_sc_hd__inv_4 abstract view
.subckt sky130_fd_sc_hd__inv_4 A VGND VNB VPB VPWR Y
.ends

* Black-box entry subcircuit for sky130_fd_sc_hd__bufinv_16 abstract view
.subckt sky130_fd_sc_hd__bufinv_16 A VGND VNB VPB VPWR Y
.ends

* Black-box entry subcircuit for sky130_fd_sc_hd__nor3_2 abstract view
.subckt sky130_fd_sc_hd__nor3_2 A B C VGND VNB VPB VPWR Y
.ends

* Black-box entry subcircuit for sky130_fd_sc_hd__clkinv_2 abstract view
.subckt sky130_fd_sc_hd__clkinv_2 A VGND VNB VPB VPWR Y
.ends

* Black-box entry subcircuit for sky130_fd_sc_hd__o21bai_2 abstract view
.subckt sky130_fd_sc_hd__o21bai_2 A1 A2 B1_N VGND VNB VPB VPWR Y
.ends

* Black-box entry subcircuit for sky130_fd_sc_hd__clkbuf_1 abstract view
.subckt sky130_fd_sc_hd__clkbuf_1 A VGND VNB VPB VPWR X
.ends

* Black-box entry subcircuit for sky130_fd_sc_hd__nor4_2 abstract view
.subckt sky130_fd_sc_hd__nor4_2 A B C D VGND VNB VPB VPWR Y
.ends

* Black-box entry subcircuit for sky130_fd_sc_hd__or4b_2 abstract view
.subckt sky130_fd_sc_hd__or4b_2 A B C D_N VGND VNB VPB VPWR X
.ends

* Black-box entry subcircuit for sky130_fd_sc_hd__a2111o_2 abstract view
.subckt sky130_fd_sc_hd__a2111o_2 A1 A2 B1 C1 D1 VGND VNB VPB VPWR X
.ends

* Black-box entry subcircuit for sky130_fd_sc_hd__a22oi_2 abstract view
.subckt sky130_fd_sc_hd__a22oi_2 A1 A2 B1 B2 VGND VNB VPB VPWR Y
.ends

* Black-box entry subcircuit for sky130_fd_sc_hd__a41o_2 abstract view
.subckt sky130_fd_sc_hd__a41o_2 A1 A2 A3 A4 B1 VGND VNB VPB VPWR X
.ends

* Black-box entry subcircuit for sky130_fd_sc_hd__nor2_1 abstract view
.subckt sky130_fd_sc_hd__nor2_1 A B VGND VNB VPB VPWR Y
.ends

* Black-box entry subcircuit for sky130_fd_sc_hd__nand4b_2 abstract view
.subckt sky130_fd_sc_hd__nand4b_2 A_N B C D VGND VNB VPB VPWR Y
.ends

* Black-box entry subcircuit for sky130_fd_sc_hd__nor3_4 abstract view
.subckt sky130_fd_sc_hd__nor3_4 A B C VGND VNB VPB VPWR Y
.ends

* Black-box entry subcircuit for sky130_fd_sc_hd__o31ai_2 abstract view
.subckt sky130_fd_sc_hd__o31ai_2 A1 A2 A3 B1 VGND VNB VPB VPWR Y
.ends

* Black-box entry subcircuit for sky130_fd_sc_hd__a311o_2 abstract view
.subckt sky130_fd_sc_hd__a311o_2 A1 A2 A3 B1 C1 VGND VNB VPB VPWR X
.ends

* Black-box entry subcircuit for sky130_fd_sc_hd__nor3b_2 abstract view
.subckt sky130_fd_sc_hd__nor3b_2 A B C_N VGND VNB VPB VPWR Y
.ends

* Black-box entry subcircuit for sky130_fd_sc_hd__or4bb_2 abstract view
.subckt sky130_fd_sc_hd__or4bb_2 A B C_N D_N VGND VNB VPB VPWR X
.ends

* Black-box entry subcircuit for sky130_fd_sc_hd__and4bb_2 abstract view
.subckt sky130_fd_sc_hd__and4bb_2 A_N B_N C D VGND VNB VPB VPWR X
.ends

* Black-box entry subcircuit for sky130_fd_sc_hd__nor4_1 abstract view
.subckt sky130_fd_sc_hd__nor4_1 A B C D VGND VNB VPB VPWR Y
.ends

* Black-box entry subcircuit for sky130_fd_sc_hd__buf_1 abstract view
.subckt sky130_fd_sc_hd__buf_1 A VGND VNB VPB VPWR X
.ends

.subckt team_06 clk en gpio_in[0] gpio_in[10] gpio_in[11] gpio_in[12] gpio_in[13]
+ gpio_in[14] gpio_in[15] gpio_in[16] gpio_in[17] gpio_in[18] gpio_in[19] gpio_in[1]
+ gpio_in[20] gpio_in[21] gpio_in[22] gpio_in[23] gpio_in[24] gpio_in[25] gpio_in[26]
+ gpio_in[27] gpio_in[28] gpio_in[29] gpio_in[2] gpio_in[30] gpio_in[31] gpio_in[32]
+ gpio_in[33] gpio_in[3] gpio_in[4] gpio_in[5] gpio_in[6] gpio_in[7] gpio_in[8] gpio_in[9]
+ gpio_oeb[0] gpio_oeb[10] gpio_oeb[11] gpio_oeb[12] gpio_oeb[13] gpio_oeb[14] gpio_oeb[15]
+ gpio_oeb[16] gpio_oeb[17] gpio_oeb[18] gpio_oeb[19] gpio_oeb[1] gpio_oeb[20] gpio_oeb[21]
+ gpio_oeb[22] gpio_oeb[23] gpio_oeb[24] gpio_oeb[25] gpio_oeb[26] gpio_oeb[27] gpio_oeb[28]
+ gpio_oeb[29] gpio_oeb[2] gpio_oeb[30] gpio_oeb[31] gpio_oeb[32] gpio_oeb[33] gpio_oeb[3]
+ gpio_oeb[4] gpio_oeb[5] gpio_oeb[6] gpio_oeb[7] gpio_oeb[8] gpio_oeb[9] gpio_out[0]
+ gpio_out[10] gpio_out[11] gpio_out[12] gpio_out[13] gpio_out[14] gpio_out[15] gpio_out[16]
+ gpio_out[17] gpio_out[18] gpio_out[19] gpio_out[1] gpio_out[20] gpio_out[21] gpio_out[22]
+ gpio_out[23] gpio_out[24] gpio_out[25] gpio_out[26] gpio_out[27] gpio_out[28] gpio_out[29]
+ gpio_out[2] gpio_out[30] gpio_out[31] gpio_out[32] gpio_out[33] gpio_out[3] gpio_out[4]
+ gpio_out[5] gpio_out[6] gpio_out[7] gpio_out[8] gpio_out[9] nrst vccd1 vssd1
XFILLER_54_269 vssd1 vssd1 vccd1 vccd1 sky130_fd_sc_hd__fill_1
XTAP_TAPCELL_ROW_37_401 vssd1 vccd1 sky130_fd_sc_hd__tapvpwrvgnd_1
X_2106_ _2562_/Q _2578_/Q _2118_/S vssd1 vssd1 vccd1 vccd1 _2106_/X sky130_fd_sc_hd__mux2_1
X_2037_ _2037_/A _2037_/B vssd1 vssd1 vccd1 vccd1 _2041_/D sky130_fd_sc_hd__xnor2_2
XANTENNA_fanout162_A _1385_/B vssd1 vssd1 vccd1 vccd1 sky130_fd_sc_hd__diode_2
XFILLER_10_306 vssd1 vssd1 vccd1 vccd1 sky130_fd_sc_hd__fill_2
Xhold340 _2565_/Q vssd1 vssd1 vccd1 vccd1 hold340/X sky130_fd_sc_hd__dlygate4sd3_1
Xhold351 _1667_/X vssd1 vssd1 vccd1 vccd1 _2566_/D sky130_fd_sc_hd__dlygate4sd3_1
Xhold362 _2735_/Q vssd1 vssd1 vccd1 vccd1 hold362/X sky130_fd_sc_hd__dlygate4sd3_1
Xhold373 _2736_/Q vssd1 vssd1 vccd1 vccd1 hold373/X sky130_fd_sc_hd__dlygate4sd3_1
Xhold384 _2781_/Q vssd1 vssd1 vccd1 vccd1 hold384/X sky130_fd_sc_hd__dlygate4sd3_1
Xhold395 _2327_/X vssd1 vssd1 vccd1 vccd1 _2803_/D sky130_fd_sc_hd__dlygate4sd3_1
XANTENNA__1693__A1 _2647_/Q vssd1 vssd1 vccd1 vccd1 sky130_fd_sc_hd__diode_2
XFILLER_26_85 vssd1 vssd1 vccd1 vccd1 sky130_fd_sc_hd__fill_1
XFILLER_13_144 vssd1 vssd1 vccd1 vccd1 sky130_fd_sc_hd__fill_1
XFILLER_13_166 vssd1 vssd1 vccd1 vccd1 sky130_fd_sc_hd__fill_2
XFILLER_13_188 vssd1 vssd1 vccd1 vccd1 sky130_fd_sc_hd__fill_1
XFILLER_42_40 vssd1 vssd1 vccd1 vccd1 sky130_fd_sc_hd__fill_1
XFILLER_42_62 vssd1 vssd1 vccd1 vccd1 sky130_fd_sc_hd__fill_1
XFILLER_9_137 vssd1 vssd1 vccd1 vccd1 sky130_fd_sc_hd__fill_1
XANTENNA__1684__A1 _2638_/Q vssd1 vssd1 vccd1 vccd1 sky130_fd_sc_hd__diode_2
XFILLER_36_247 vssd1 vssd1 vccd1 vccd1 sky130_fd_sc_hd__fill_1
X_1270_ _2071_/B vssd1 vssd1 vccd1 vccd1 _1270_/Y sky130_fd_sc_hd__inv_2
X_1606_ _1624_/S _1603_/X _1604_/X _2701_/Q _1384_/B vssd1 vssd1 vccd1 vccd1 _1607_/B
+ sky130_fd_sc_hd__a32o_2
X_2724_ _2772_/CLK _2724_/D load_slew142/X vssd1 vssd1 vccd1 vccd1 _2724_/Q sky130_fd_sc_hd__dfrtp_2
X_2655_ _2689_/CLK _2655_/D fanout96/X vssd1 vssd1 vccd1 vccd1 _2655_/Q sky130_fd_sc_hd__dfrtp_2
X_1399_ _2922_/Q _2920_/Q _2816_/Q vssd1 vssd1 vccd1 vccd1 _1399_/Y sky130_fd_sc_hd__a21oi_2
X_1468_ _1415_/B _1464_/Y _1467_/X _1413_/B vssd1 vssd1 vccd1 vccd1 _1468_/X sky130_fd_sc_hd__o22a_2
X_1537_ _2839_/Q _2840_/Q _1537_/C _1537_/D vssd1 vssd1 vccd1 vccd1 _1539_/C sky130_fd_sc_hd__or4_2
Xfanout149 _1260_/Y vssd1 vssd1 vccd1 vccd1 _2156_/A sky130_fd_sc_hd__clkdlybuf4s25_1
Xfanout138 fanout144/X vssd1 vssd1 vccd1 vccd1 fanout138/X sky130_fd_sc_hd__clkdlybuf4s25_1
Xfanout105 fanout99/A vssd1 vssd1 vccd1 vccd1 fanout105/X sky130_fd_sc_hd__clkdlybuf4s25_1
X_2586_ _2689_/CLK _2586_/D vssd1 vssd1 vccd1 vccd1 _2586_/Q sky130_fd_sc_hd__dfxtp_2
XFILLER_27_225 vssd1 vssd1 vccd1 vccd1 sky130_fd_sc_hd__fill_1
XFILLER_6_107 vssd1 vssd1 vccd1 vccd1 sky130_fd_sc_hd__fill_1
XTAP_TAPCELL_ROW_40_418 vssd1 vccd1 sky130_fd_sc_hd__tapvpwrvgnd_1
XANTENNA_clkbuf_leaf_31_clk_A clkbuf_3_4__f_clk/X vssd1 vssd1 vccd1 vccd1 sky130_fd_sc_hd__diode_2
XANTENNA_fanout78_X _2293_/B1 vssd1 vssd1 vccd1 vccd1 sky130_fd_sc_hd__diode_2
XFILLER_37_62 vssd1 vssd1 vccd1 vccd1 sky130_fd_sc_hd__fill_2
XTAP_TAPCELL_ROW_5_173 vssd1 vccd1 sky130_fd_sc_hd__tapvpwrvgnd_1
X_2440_ hold332/X _2410_/A _2436_/Y _2439_/X vssd1 vssd1 vccd1 vccd1 _2837_/D sky130_fd_sc_hd__a31oi_2
X_1322_ _2732_/Q _1311_/X _1321_/Y _2733_/Q vssd1 vssd1 vccd1 vccd1 _1322_/X sky130_fd_sc_hd__a22o_2
X_2371_ _2371_/A _2371_/B _2371_/C vssd1 vssd1 vccd1 vccd1 _2371_/X sky130_fd_sc_hd__or3_2
XANTENNA__2302__A1_N _2300_/A1 vssd1 vssd1 vccd1 vccd1 sky130_fd_sc_hd__diode_2
XFILLER_24_239 vssd1 vssd1 vccd1 vccd1 sky130_fd_sc_hd__fill_1
XTAP_TAPCELL_ROW_19_275 vssd1 vccd1 sky130_fd_sc_hd__tapvpwrvgnd_1
XANTENNA_fanout125_A fanout145/X vssd1 vssd1 vccd1 vccd1 sky130_fd_sc_hd__diode_2
XTAP_TAPCELL_ROW_62_576 vssd1 vccd1 sky130_fd_sc_hd__tapvpwrvgnd_1
XANTENNA__2137__A2 _2136_/B vssd1 vssd1 vccd1 vccd1 sky130_fd_sc_hd__diode_2
X_2707_ _2772_/CLK _2707_/D load_slew142/X vssd1 vssd1 vccd1 vccd1 _2707_/Q sky130_fd_sc_hd__dfrtp_2
X_2638_ _2642_/CLK _2638_/D fanout126/X vssd1 vssd1 vccd1 vccd1 _2638_/Q sky130_fd_sc_hd__dfrtp_2
X_2569_ _2671_/CLK _2569_/D vssd1 vssd1 vccd1 vccd1 _2569_/Q sky130_fd_sc_hd__dfxtp_2
XFILLER_58_39 vssd1 vssd1 vccd1 vccd1 sky130_fd_sc_hd__fill_1
XTAP_TAPCELL_ROW_2_154 vssd1 vccd1 sky130_fd_sc_hd__tapvpwrvgnd_1
XANTENNA__2119__S _2125_/S vssd1 vssd1 vccd1 vccd1 sky130_fd_sc_hd__diode_2
XFILLER_23_261 vssd1 vssd1 vccd1 vccd1 sky130_fd_sc_hd__fill_1
XTAP_TAPCELL_ROW_53_510 vssd1 vccd1 sky130_fd_sc_hd__tapvpwrvgnd_1
XANTENNA__1693__S _1693_/S vssd1 vssd1 vccd1 vccd1 sky130_fd_sc_hd__diode_2
XANTENNA__1639__A1 _1385_/B vssd1 vssd1 vccd1 vccd1 sky130_fd_sc_hd__diode_2
XFILLER_0_57 vssd1 vssd1 vccd1 vccd1 sky130_fd_sc_hd__fill_8
XFILLER_0_79 vssd1 vssd1 vccd1 vccd1 sky130_fd_sc_hd__fill_4
X_1871_ _2637_/Q _1841_/D _1851_/Y _1870_/X vssd1 vssd1 vccd1 vccd1 _1871_/X sky130_fd_sc_hd__o22a_2
X_1940_ _1940_/A _2687_/Q vssd1 vssd1 vccd1 vccd1 _1942_/C sky130_fd_sc_hd__nand2_2
X_2423_ _2462_/B _2422_/Y _2419_/Y vssd1 vssd1 vccd1 vccd1 _2832_/D sky130_fd_sc_hd__o21ai_2
XANTENNA__2447__B _2472_/B vssd1 vssd1 vccd1 vccd1 sky130_fd_sc_hd__diode_2
X_1305_ _2803_/Q _1346_/B vssd1 vssd1 vccd1 vccd1 _1347_/A sky130_fd_sc_hd__nand2_2
X_2354_ _2862_/Q _2863_/Q _2864_/Q _2865_/Q vssd1 vssd1 vccd1 vccd1 _2371_/A sky130_fd_sc_hd__or4_2
X_2285_ _1366_/A hold422/X _2293_/B1 hold458/X vssd1 vssd1 vccd1 vccd1 _2762_/D sky130_fd_sc_hd__a22o_2
XANTENNA__1688__S _1693_/S vssd1 vssd1 vccd1 vccd1 sky130_fd_sc_hd__diode_2
XFILLER_34_52 vssd1 vssd1 vccd1 vccd1 sky130_fd_sc_hd__fill_1
XFILLER_34_85 vssd1 vssd1 vccd1 vccd1 sky130_fd_sc_hd__fill_1
XFILLER_7_202 vssd1 vssd1 vccd1 vccd1 sky130_fd_sc_hd__fill_1
XANTENNA__2349__A2 _2472_/A vssd1 vssd1 vccd1 vccd1 sky130_fd_sc_hd__diode_2
XFILLER_7_279 vssd1 vssd1 vccd1 vccd1 sky130_fd_sc_hd__fill_1
Xload_slew127 fanout126/X vssd1 vssd1 vccd1 vccd1 load_slew127/X sky130_fd_sc_hd__buf_4
Xload_slew116 fanout115/X vssd1 vssd1 vccd1 vccd1 load_slew116/X sky130_fd_sc_hd__buf_2
X_2070_ _2071_/B hold408/X _1996_/A _2069_/X vssd1 vssd1 vccd1 vccd1 _2663_/D sky130_fd_sc_hd__o22a_2
XANTENNA__2285__A1 _1366_/A vssd1 vssd1 vccd1 vccd1 sky130_fd_sc_hd__diode_2
Xload_slew85 fanout84/X vssd1 vssd1 vccd1 vccd1 _2510_/B2 sky130_fd_sc_hd__clkbuf_4
X_1785_ _1793_/C _1785_/B vssd1 vssd1 vccd1 vccd1 _1785_/Y sky130_fd_sc_hd__nor2_2
X_1854_ _2632_/Q _1823_/X _1853_/X vssd1 vssd1 vccd1 vccd1 _2632_/D sky130_fd_sc_hd__o21a_2
X_1923_ _1940_/A _2691_/Q vssd1 vssd1 vccd1 vccd1 _1926_/B sky130_fd_sc_hd__or2_2
XANTENNA_clkbuf_3_0__f_clk_X clkbuf_leaf_3_clk/A vssd1 vssd1 vccd1 vccd1 sky130_fd_sc_hd__diode_2
X_2406_ _2406_/A _2406_/B vssd1 vssd1 vccd1 vccd1 _2408_/B sky130_fd_sc_hd__and2_2
XANTENNA__1362__A _2472_/A vssd1 vssd1 vccd1 vccd1 sky130_fd_sc_hd__diode_2
XANTENNA_fanout192_A _2470_/D vssd1 vssd1 vccd1 vccd1 sky130_fd_sc_hd__diode_2
XTAP_TAPCELL_ROW_27_329 vssd1 vccd1 sky130_fd_sc_hd__tapvpwrvgnd_1
X_2337_ _2917_/Q _2916_/Q vssd1 vssd1 vccd1 vccd1 _2337_/X sky130_fd_sc_hd__or2_2
X_2268_ _2772_/Q _2726_/Q vssd1 vssd1 vccd1 vccd1 _2270_/B sky130_fd_sc_hd__nand2_2
X_2199_ _2762_/Q _2716_/Q vssd1 vssd1 vccd1 vccd1 _2200_/B sky130_fd_sc_hd__nand2_2
XTAP_TAPCELL_ROW_10_207 vssd1 vccd1 sky130_fd_sc_hd__tapvpwrvgnd_1
XTAP_TAPCELL_ROW_35_384 vssd1 vccd1 sky130_fd_sc_hd__tapvpwrvgnd_1
XANTENNA__2132__S _2134_/S vssd1 vssd1 vccd1 vccd1 sky130_fd_sc_hd__diode_2
XFILLER_20_54 vssd1 vssd1 vccd1 vccd1 sky130_fd_sc_hd__fill_2
XFILLER_61_50 vssd1 vssd1 vccd1 vccd1 sky130_fd_sc_hd__fill_1
XFILLER_3_260 vssd1 vssd1 vccd1 vccd1 sky130_fd_sc_hd__fill_2
X_1570_ _1580_/A _2642_/Q _1701_/S vssd1 vssd1 vccd1 vccd1 _1570_/X sky130_fd_sc_hd__and3_2
XFILLER_13_3 vssd1 vssd1 vccd1 vccd1 sky130_fd_sc_hd__fill_1
X_2122_ _2570_/Q _2586_/Q _2130_/S vssd1 vssd1 vccd1 vccd1 _2122_/X sky130_fd_sc_hd__mux2_1
X_2053_ _1921_/Y _2053_/B vssd1 vssd1 vccd1 vccd1 _2054_/B sky130_fd_sc_hd__nand2b_2
XFILLER_34_164 vssd1 vssd1 vccd1 vccd1 sky130_fd_sc_hd__fill_2
XTAP_TAPCELL_ROW_32_365 vssd1 vccd1 sky130_fd_sc_hd__tapvpwrvgnd_1
X_1768_ _1751_/X _1755_/X _2620_/Q _2621_/Q _2622_/Q vssd1 vssd1 vccd1 vccd1 _1783_/D
+ sky130_fd_sc_hd__o2111a_2
X_1837_ _1837_/A _1837_/B _1837_/C vssd1 vssd1 vccd1 vccd1 _1837_/Y sky130_fd_sc_hd__nand3_2
X_1906_ _2646_/Q _1903_/B _2647_/Q vssd1 vssd1 vccd1 vccd1 _1907_/B sky130_fd_sc_hd__a21oi_2
Xhold500 _2545_/Q vssd1 vssd1 vccd1 vccd1 hold500/X sky130_fd_sc_hd__dlygate4sd3_1
Xhold511 _2836_/Q vssd1 vssd1 vccd1 vccd1 hold511/X sky130_fd_sc_hd__dlygate4sd3_1
Xhold522 _2826_/Q vssd1 vssd1 vccd1 vccd1 _2402_/A sky130_fd_sc_hd__dlygate4sd3_1
Xhold533 _2554_/Q vssd1 vssd1 vccd1 vccd1 hold533/X sky130_fd_sc_hd__dlygate4sd3_1
Xhold544 _2912_/Q vssd1 vssd1 vccd1 vccd1 hold544/X sky130_fd_sc_hd__dlygate4sd3_1
X_2886_ _2916_/CLK _2886_/D load_slew108/X vssd1 vssd1 vccd1 vccd1 _2886_/Q sky130_fd_sc_hd__dfrtp_2
X_1699_ hold255/X _1593_/X _1701_/S vssd1 vssd1 vccd1 vccd1 _2597_/D sky130_fd_sc_hd__mux2_1
XANTENNA__1820__A _1863_/C vssd1 vssd1 vccd1 vccd1 sky130_fd_sc_hd__diode_2
XFILLER_21_381 vssd1 vssd1 vccd1 vccd1 sky130_fd_sc_hd__fill_1
Xoutput7 _2539_/Q vssd1 vssd1 vccd1 vccd1 gpio_out[10] sky130_fd_sc_hd__clkdlybuf4s25_1
Xoutput31 _2538_/Q vssd1 vssd1 vccd1 vccd1 gpio_out[9] sky130_fd_sc_hd__clkdlybuf4s25_1
Xoutput20 _2552_/Q vssd1 vssd1 vccd1 vccd1 gpio_out[23] sky130_fd_sc_hd__clkdlybuf4s25_1
XFILLER_0_241 vssd1 vssd1 vccd1 vccd1 sky130_fd_sc_hd__fill_2
XFILLER_0_274 vssd1 vssd1 vccd1 vccd1 sky130_fd_sc_hd__fill_4
XFILLER_56_83 vssd1 vssd1 vccd1 vccd1 sky130_fd_sc_hd__fill_1
Xteam_06_198 vssd1 vssd1 vccd1 vccd1 team_06_198/HI gpio_oeb[10] sky130_fd_sc_hd__conb_1
XFILLER_31_145 vssd1 vssd1 vccd1 vccd1 sky130_fd_sc_hd__fill_1
X_1622_ _1716_/S _2625_/Q vssd1 vssd1 vccd1 vccd1 _1622_/X sky130_fd_sc_hd__and2b_2
X_2740_ _2870_/CLK _2740_/D load_slew121/X vssd1 vssd1 vccd1 vccd1 _2740_/Q sky130_fd_sc_hd__dfrtp_2
X_2671_ _2671_/CLK _2671_/D fanout99/X vssd1 vssd1 vccd1 vccd1 _2671_/Q sky130_fd_sc_hd__dfrtp_2
X_1484_ _2915_/Q _1413_/A _1416_/A _1280_/B vssd1 vssd1 vccd1 vccd1 _1484_/X sky130_fd_sc_hd__o211a_2
X_1553_ hold294/X _1558_/B _1552_/X vssd1 vssd1 vccd1 vccd1 _2521_/D sky130_fd_sc_hd__a21o_2
XFILLER_39_289 vssd1 vssd1 vccd1 vccd1 sky130_fd_sc_hd__fill_1
XFILLER_54_226 vssd1 vssd1 vccd1 vccd1 sky130_fd_sc_hd__fill_2
XTAP_TAPCELL_ROW_37_402 vssd1 vccd1 sky130_fd_sc_hd__tapvpwrvgnd_1
X_2105_ hold450/X _2104_/X _2135_/S vssd1 vssd1 vccd1 vccd1 _2679_/D sky130_fd_sc_hd__mux2_1
X_2036_ _1979_/A _2036_/B vssd1 vssd1 vccd1 vccd1 _2037_/B sky130_fd_sc_hd__and2b_2
XANTENNA_fanout155_A _1722_/S vssd1 vssd1 vccd1 vccd1 sky130_fd_sc_hd__diode_2
XFILLER_22_123 vssd1 vssd1 vccd1 vccd1 sky130_fd_sc_hd__fill_1
Xhold330 _2731_/Q vssd1 vssd1 vccd1 vccd1 hold330/X sky130_fd_sc_hd__dlygate4sd3_1
Xhold341 _2848_/Q vssd1 vssd1 vccd1 vccd1 _2477_/A sky130_fd_sc_hd__dlygate4sd3_1
Xhold352 _2858_/Q vssd1 vssd1 vccd1 vccd1 _2502_/A sky130_fd_sc_hd__dlygate4sd3_1
Xhold363 _2776_/Q vssd1 vssd1 vccd1 vccd1 _2299_/A sky130_fd_sc_hd__dlygate4sd3_1
Xhold374 _2750_/Q vssd1 vssd1 vccd1 vccd1 hold374/X sky130_fd_sc_hd__dlygate4sd3_1
Xhold385 _2320_/X vssd1 vssd1 vccd1 vccd1 _2796_/D sky130_fd_sc_hd__dlygate4sd3_1
Xhold396 _2787_/Q vssd1 vssd1 vccd1 vccd1 hold396/X sky130_fd_sc_hd__dlygate4sd3_1
X_2869_ _2869_/CLK _2869_/D fanout120/X vssd1 vssd1 vccd1 vccd1 _2869_/Q sky130_fd_sc_hd__dfrtp_2
XANTENNA_fanout68_A _2282_/A2 vssd1 vssd1 vccd1 vccd1 sky130_fd_sc_hd__diode_2
XTAP_TAPCELL_ROW_43_438 vssd1 vccd1 sky130_fd_sc_hd__tapvpwrvgnd_1
Xclkbuf_3_6__f_clk clkbuf_0_clk/X vssd1 vssd1 vccd1 vccd1 clkbuf_3_6__f_clk/X sky130_fd_sc_hd__clkbuf_16
XANTENNA_clkbuf_leaf_5_clk_A clkbuf_leaf_5_clk/A vssd1 vssd1 vccd1 vccd1 sky130_fd_sc_hd__diode_2
XANTENNA__1905__A0 _2646_/Q vssd1 vssd1 vccd1 vccd1 sky130_fd_sc_hd__diode_2
XFILLER_3_57 vssd1 vssd1 vccd1 vccd1 sky130_fd_sc_hd__fill_8
XTAP_TAPCELL_ROW_8_193 vssd1 vccd1 sky130_fd_sc_hd__tapvpwrvgnd_1
XFILLER_51_229 vssd1 vssd1 vccd1 vccd1 sky130_fd_sc_hd__fill_1
X_2723_ _2769_/CLK _2723_/D load_slew139/X vssd1 vssd1 vccd1 vccd1 _2723_/Q sky130_fd_sc_hd__dfrtp_2
XANTENNA__2149__A0 _2707_/Q vssd1 vssd1 vccd1 vccd1 sky130_fd_sc_hd__diode_2
XFILLER_8_171 vssd1 vssd1 vccd1 vccd1 sky130_fd_sc_hd__fill_4
X_1536_ _1539_/B _1536_/B _1506_/X vssd1 vssd1 vccd1 vccd1 _1538_/B sky130_fd_sc_hd__or3b_2
X_1605_ _1384_/A _2652_/Q _2541_/Q _1589_/X vssd1 vssd1 vccd1 vccd1 _1607_/A sky130_fd_sc_hd__a22o_2
X_2654_ _2689_/CLK _2654_/D fanout99/X vssd1 vssd1 vccd1 vccd1 _2654_/Q sky130_fd_sc_hd__dfrtp_2
X_2585_ _2688_/CLK _2585_/D vssd1 vssd1 vccd1 vccd1 _2585_/Q sky130_fd_sc_hd__dfxtp_2
X_1398_ _1258_/Y _2921_/Q _2923_/Q vssd1 vssd1 vccd1 vccd1 _1400_/S sky130_fd_sc_hd__o21a_2
X_1467_ _1472_/B _1467_/B vssd1 vssd1 vccd1 vccd1 _1467_/X sky130_fd_sc_hd__or2_2
Xfanout128 wire131/A vssd1 vssd1 vccd1 vccd1 fanout128/X sky130_fd_sc_hd__clkdlybuf4s25_1
Xfanout117 fanout117/A vssd1 vssd1 vccd1 vccd1 fanout117/X sky130_fd_sc_hd__clkdlybuf4s25_1
Xfanout106 _1362_/Y vssd1 vssd1 vccd1 vccd1 fanout99/A sky130_fd_sc_hd__clkdlybuf4s25_1
XPHY_EDGE_ROW_19_Left_84 vssd1 vssd1 vccd1 vccd1 sky130_fd_sc_hd__decap_3
X_2019_ _1945_/Y _2019_/B vssd1 vssd1 vccd1 vccd1 _2020_/B sky130_fd_sc_hd__nand2b_2
XANTENNA__2702__Q _2702_/Q vssd1 vssd1 vccd1 vccd1 sky130_fd_sc_hd__diode_2
XTAP_TAPCELL_ROW_40_419 vssd1 vccd1 sky130_fd_sc_hd__tapvpwrvgnd_1
XANTENNA__2140__S _2154_/S vssd1 vssd1 vccd1 vccd1 sky130_fd_sc_hd__diode_2
XFILLER_12_99 vssd1 vssd1 vccd1 vccd1 sky130_fd_sc_hd__fill_4
XFILLER_2_347 vssd1 vssd1 vccd1 vccd1 sky130_fd_sc_hd__fill_1
XFILLER_33_218 vssd1 vssd1 vccd1 vccd1 sky130_fd_sc_hd__fill_1
XTAP_TAPCELL_ROW_56_530 vssd1 vccd1 sky130_fd_sc_hd__tapvpwrvgnd_1
XTAP_TAPCELL_ROW_5_174 vssd1 vccd1 sky130_fd_sc_hd__tapvpwrvgnd_1
XFILLER_1_391 vssd1 vssd1 vccd1 vccd1 sky130_fd_sc_hd__fill_1
X_1321_ _2794_/Q _1321_/B vssd1 vssd1 vccd1 vccd1 _1321_/Y sky130_fd_sc_hd__xnor2_2
X_2370_ _2370_/A _2370_/B _2369_/X vssd1 vssd1 vccd1 vccd1 _2371_/C sky130_fd_sc_hd__or3b_2
XFILLER_17_281 vssd1 vssd1 vccd1 vccd1 sky130_fd_sc_hd__fill_4
XTAP_TAPCELL_ROW_19_276 vssd1 vccd1 sky130_fd_sc_hd__tapvpwrvgnd_1
XFILLER_32_251 vssd1 vssd1 vccd1 vccd1 sky130_fd_sc_hd__fill_1
XTAP_TAPCELL_ROW_62_577 vssd1 vccd1 sky130_fd_sc_hd__tapvpwrvgnd_1
X_2706_ _2768_/CLK _2706_/D load_slew139/X vssd1 vssd1 vccd1 vccd1 _2706_/Q sky130_fd_sc_hd__dfrtp_2
XANTENNA__1593__A1 _2634_/Q vssd1 vssd1 vccd1 vccd1 sky130_fd_sc_hd__diode_2
XANTENNA_fanout118_A fanout145/X vssd1 vssd1 vccd1 vccd1 sky130_fd_sc_hd__diode_2
XFILLER_58_29 vssd1 vssd1 vccd1 vccd1 sky130_fd_sc_hd__fill_2
XPHY_EDGE_ROW_12_Right_12 vssd1 vssd1 vccd1 vccd1 sky130_fd_sc_hd__decap_3
X_1519_ _2819_/Q _2818_/Q _2821_/Q _2820_/Q vssd1 vssd1 vccd1 vccd1 _1519_/X sky130_fd_sc_hd__and4_2
X_2637_ clkload7/A _2637_/D load_slew127/X vssd1 vssd1 vccd1 vccd1 _2637_/Q sky130_fd_sc_hd__dfrtp_2
X_2568_ _2671_/CLK _2568_/D vssd1 vssd1 vccd1 vccd1 _2568_/Q sky130_fd_sc_hd__dfxtp_2
X_2499_ _2856_/Q _2498_/C hold322/X vssd1 vssd1 vccd1 vccd1 _2499_/Y sky130_fd_sc_hd__a21oi_2
XPHY_EDGE_ROW_21_Right_21 vssd1 vssd1 vccd1 vccd1 sky130_fd_sc_hd__decap_3
XTAP_TAPCELL_ROW_2_155 vssd1 vccd1 sky130_fd_sc_hd__tapvpwrvgnd_1
XFILLER_7_406 vssd1 vssd1 vccd1 vccd1 sky130_fd_sc_hd__fill_1
XPHY_EDGE_ROW_4_Left_69 vssd1 vssd1 vccd1 vccd1 sky130_fd_sc_hd__decap_3
XTAP_TAPCELL_ROW_53_511 vssd1 vccd1 sky130_fd_sc_hd__tapvpwrvgnd_1
XPHY_EDGE_ROW_30_Right_30 vssd1 vssd1 vccd1 vccd1 sky130_fd_sc_hd__decap_3
XFILLER_48_62 vssd1 vssd1 vccd1 vccd1 sky130_fd_sc_hd__fill_2
XFILLER_64_61 vssd1 vssd1 vccd1 vccd1 sky130_fd_sc_hd__fill_1
XFILLER_64_83 vssd1 vssd1 vccd1 vccd1 sky130_fd_sc_hd__fill_1
X_1870_ _1873_/B _1900_/C vssd1 vssd1 vccd1 vccd1 _1870_/X sky130_fd_sc_hd__and2b_2
XFILLER_43_3 vssd1 vssd1 vccd1 vccd1 sky130_fd_sc_hd__fill_2
X_2422_ _2422_/A _2426_/B vssd1 vssd1 vccd1 vccd1 _2422_/Y sky130_fd_sc_hd__nand2_2
X_2353_ _2470_/D _1389_/Y _2330_/Y _1356_/A _2352_/Y vssd1 vssd1 vccd1 vccd1 _2813_/D
+ sky130_fd_sc_hd__o221a_2
XANTENNA__1913__A _1944_/A vssd1 vssd1 vccd1 vccd1 sky130_fd_sc_hd__diode_2
X_1304_ _2802_/Q _1342_/B vssd1 vssd1 vccd1 vccd1 _1346_/B sky130_fd_sc_hd__and2_2
X_2284_ _1366_/A hold377/X _2293_/B1 hold453/X vssd1 vssd1 vccd1 vccd1 _2761_/D sky130_fd_sc_hd__a22o_2
XANTENNA_clkbuf_leaf_30_clk_A clkbuf_3_4__f_clk/X vssd1 vssd1 vccd1 vccd1 sky130_fd_sc_hd__diode_2
X_1999_ _1999_/A _2007_/B vssd1 vssd1 vccd1 vccd1 _1999_/Y sky130_fd_sc_hd__xnor2_2
XANTENNA_fanout50_A _2134_/S vssd1 vssd1 vccd1 vccd1 sky130_fd_sc_hd__diode_2
XFILLER_28_365 vssd1 vssd1 vccd1 vccd1 sky130_fd_sc_hd__fill_1
XFILLER_55_195 vssd1 vssd1 vccd1 vccd1 sky130_fd_sc_hd__fill_8
XANTENNA__2373__B _2472_/B vssd1 vssd1 vccd1 vccd1 sky130_fd_sc_hd__diode_2
XFILLER_7_225 vssd1 vssd1 vccd1 vccd1 sky130_fd_sc_hd__fill_4
XFILLER_50_85 vssd1 vssd1 vccd1 vccd1 sky130_fd_sc_hd__fill_1
Xload_slew139 fanout138/X vssd1 vssd1 vccd1 vccd1 load_slew139/X sky130_fd_sc_hd__clkbuf_2
XFILLER_46_184 vssd1 vssd1 vccd1 vccd1 sky130_fd_sc_hd__fill_2
X_1922_ _2677_/Q _1922_/B _1922_/C vssd1 vssd1 vccd1 vccd1 _2053_/B sky130_fd_sc_hd__nand3_2
Xload_slew97 fanout96/X vssd1 vssd1 vccd1 vccd1 load_slew97/X sky130_fd_sc_hd__buf_2
XANTENNA__1796__B2 _2708_/Q vssd1 vssd1 vccd1 vccd1 sky130_fd_sc_hd__diode_2
X_1784_ _2625_/Q _1780_/A _1770_/C vssd1 vssd1 vccd1 vccd1 _1785_/B sky130_fd_sc_hd__o21ai_2
X_1853_ _1863_/C _1848_/X _1849_/Y _1852_/X vssd1 vssd1 vccd1 vccd1 _1853_/X sky130_fd_sc_hd__a31o_2
XANTENNA__1720__A1 _2646_/Q vssd1 vssd1 vccd1 vccd1 sky130_fd_sc_hd__diode_2
X_2405_ _2405_/A _2405_/B vssd1 vssd1 vccd1 vccd1 _2827_/D sky130_fd_sc_hd__nor2_2
X_2336_ hold285/X _2330_/Y _2334_/Y _2345_/A vssd1 vssd1 vccd1 vccd1 _2806_/D sky130_fd_sc_hd__o211a_2
XFILLER_1_90 vssd1 vssd1 vccd1 vccd1 sky130_fd_sc_hd__fill_1
XFILLER_25_335 vssd1 vssd1 vccd1 vccd1 sky130_fd_sc_hd__fill_1
X_2267_ _2772_/Q _2726_/Q vssd1 vssd1 vccd1 vccd1 _2270_/A sky130_fd_sc_hd__or2_2
X_2198_ _2762_/Q _2716_/Q vssd1 vssd1 vccd1 vccd1 _2198_/Y sky130_fd_sc_hd__nor2_2
XTAP_TAPCELL_ROW_10_208 vssd1 vccd1 sky130_fd_sc_hd__tapvpwrvgnd_1
XTAP_TAPCELL_ROW_35_385 vssd1 vccd1 sky130_fd_sc_hd__tapvpwrvgnd_1
XANTENNA_fanout98_A fanout99/X vssd1 vssd1 vccd1 vccd1 sky130_fd_sc_hd__diode_2
XFILLER_6_24 vssd1 vssd1 vccd1 vccd1 sky130_fd_sc_hd__fill_4
XPHY_EDGE_ROW_7_Left_72 vssd1 vssd1 vccd1 vccd1 sky130_fd_sc_hd__decap_3
XANTENNA__1702__A1 _2636_/Q vssd1 vssd1 vccd1 vccd1 sky130_fd_sc_hd__diode_2
XANTENNA__2671__RESET_B fanout99/X vssd1 vssd1 vccd1 vccd1 sky130_fd_sc_hd__diode_2
X_2121_ hold442/X _2120_/X _2882_/D vssd1 vssd1 vccd1 vccd1 _2687_/D sky130_fd_sc_hd__mux2_1
X_2052_ _2051_/X _2050_/Y hold548/X _2052_/B2 vssd1 vssd1 vccd1 vccd1 _2659_/D sky130_fd_sc_hd__a2bb2o_2
XFILLER_34_187 vssd1 vssd1 vccd1 vccd1 sky130_fd_sc_hd__fill_1
XTAP_TAPCELL_ROW_32_366 vssd1 vccd1 sky130_fd_sc_hd__tapvpwrvgnd_1
X_1905_ _2646_/Q _1904_/X _1909_/S vssd1 vssd1 vccd1 vccd1 _2646_/D sky130_fd_sc_hd__mux2_1
X_2885_ _2916_/CLK _2885_/D _2335_/B1 vssd1 vssd1 vccd1 vccd1 _2885_/Q sky130_fd_sc_hd__dfrtp_2
XANTENNA_fanout100_A fanout105/X vssd1 vssd1 vccd1 vccd1 sky130_fd_sc_hd__diode_2
XPHY_EDGE_ROW_6_Right_6 vssd1 vssd1 vccd1 vccd1 sky130_fd_sc_hd__decap_3
X_1698_ hold254/X _1697_/X _1724_/S vssd1 vssd1 vccd1 vccd1 _2596_/D sky130_fd_sc_hd__mux2_1
X_1767_ _1819_/B2 _1764_/X _1766_/Y _1765_/X hold538/X vssd1 vssd1 vccd1 vccd1 _2621_/D
+ sky130_fd_sc_hd__o32a_2
X_1836_ _2636_/Q _2558_/Q vssd1 vssd1 vccd1 vccd1 _1837_/C sky130_fd_sc_hd__or2_2
Xhold501 _2668_/Q vssd1 vssd1 vccd1 vccd1 hold501/X sky130_fd_sc_hd__dlygate4sd3_1
Xhold512 _2671_/Q vssd1 vssd1 vccd1 vccd1 hold512/X sky130_fd_sc_hd__dlygate4sd3_1
Xhold523 _2665_/Q vssd1 vssd1 vccd1 vccd1 hold523/X sky130_fd_sc_hd__dlygate4sd3_1
Xhold534 _2844_/Q vssd1 vssd1 vccd1 vccd1 hold534/X sky130_fd_sc_hd__dlygate4sd3_1
Xhold545 _2823_/Q vssd1 vssd1 vccd1 vccd1 _2396_/A sky130_fd_sc_hd__dlygate4sd3_1
X_2319_ _2323_/A1 hold361/X _2323_/B1 hold392/X vssd1 vssd1 vccd1 vccd1 _2795_/D sky130_fd_sc_hd__a22o_2
XANTENNA__2705__Q _2705_/Q vssd1 vssd1 vccd1 vccd1 sky130_fd_sc_hd__diode_2
XTAP_TAPCELL_ROW_23_300 vssd1 vccd1 sky130_fd_sc_hd__tapvpwrvgnd_1
XANTENNA__2143__S _2153_/S vssd1 vssd1 vccd1 vccd1 sky130_fd_sc_hd__diode_2
XPHY_EDGE_ROW_33_Left_98 vssd1 vssd1 vccd1 vccd1 sky130_fd_sc_hd__decap_3
Xteam_06_199 vssd1 vssd1 vccd1 vccd1 team_06_199/HI gpio_oeb[11] sky130_fd_sc_hd__conb_1
Xoutput8 _2540_/Q vssd1 vssd1 vccd1 vccd1 gpio_out[11] sky130_fd_sc_hd__clkdlybuf4s25_1
Xoutput21 _2886_/Q vssd1 vssd1 vccd1 vccd1 gpio_out[24] sky130_fd_sc_hd__clkdlybuf4s25_1
Xoutput10 _2542_/Q vssd1 vssd1 vccd1 vccd1 gpio_out[13] sky130_fd_sc_hd__clkdlybuf4s25_1
XANTENNA__1696__B1 _1686_/S vssd1 vssd1 vccd1 vccd1 sky130_fd_sc_hd__diode_2
XFILLER_0_297 vssd1 vssd1 vccd1 vccd1 sky130_fd_sc_hd__fill_8
XFILLER_56_95 vssd1 vssd1 vccd1 vccd1 sky130_fd_sc_hd__fill_2
XFILLER_31_124 vssd1 vssd1 vccd1 vccd1 sky130_fd_sc_hd__fill_1
XPHY_EDGE_ROW_59_Right_59 vssd1 vssd1 vccd1 vccd1 sky130_fd_sc_hd__decap_3
X_1552_ _1582_/A _2633_/Q _1724_/S vssd1 vssd1 vccd1 vccd1 _1552_/X sky130_fd_sc_hd__and3_2
X_1621_ _2624_/Q _1586_/Y _1624_/S hold500/X _1620_/X vssd1 vssd1 vccd1 vccd1 _2545_/D
+ sky130_fd_sc_hd__o221a_2
X_2670_ _2689_/CLK _2670_/D load_slew95/X vssd1 vssd1 vccd1 vccd1 _2670_/Q sky130_fd_sc_hd__dfrtp_2
X_1483_ _1389_/B _1481_/X _1482_/X vssd1 vssd1 vccd1 vccd1 _2914_/D sky130_fd_sc_hd__o21a_2
X_2104_ _2592_/Q _2576_/Q _2134_/S vssd1 vssd1 vccd1 vccd1 _2104_/X sky130_fd_sc_hd__mux2_1
X_2035_ _2034_/X _2033_/Y hold540/X _2052_/B2 vssd1 vssd1 vccd1 vccd1 _2656_/D sky130_fd_sc_hd__a2bb2o_2
X_2868_ _2869_/CLK _2868_/D fanout125/X vssd1 vssd1 vccd1 vccd1 _2868_/Q sky130_fd_sc_hd__dfrtp_2
XANTENNA__1815__B _1816_/B vssd1 vssd1 vccd1 vccd1 sky130_fd_sc_hd__diode_2
X_1819_ hold536/X _1814_/X _1818_/X _1819_/B2 vssd1 vssd1 vccd1 vccd1 _2631_/D sky130_fd_sc_hd__o22a_2
Xhold320 _1672_/X vssd1 vssd1 vccd1 vccd1 _2571_/D sky130_fd_sc_hd__dlygate4sd3_1
Xhold331 _2859_/Q vssd1 vssd1 vccd1 vccd1 _2504_/A sky130_fd_sc_hd__dlygate4sd3_1
Xhold342 _2477_/Y vssd1 vssd1 vccd1 vccd1 _2848_/D sky130_fd_sc_hd__dlygate4sd3_1
Xhold353 _2594_/Q vssd1 vssd1 vccd1 vccd1 hold353/X sky130_fd_sc_hd__dlygate4sd3_1
Xhold364 _2593_/Q vssd1 vssd1 vccd1 vccd1 hold364/X sky130_fd_sc_hd__dlygate4sd3_1
Xhold375 _2792_/Q vssd1 vssd1 vccd1 vccd1 hold375/X sky130_fd_sc_hd__dlygate4sd3_1
Xhold386 _2782_/Q vssd1 vssd1 vccd1 vccd1 hold386/X sky130_fd_sc_hd__dlygate4sd3_1
Xhold397 _2326_/X vssd1 vssd1 vccd1 vccd1 _2802_/D sky130_fd_sc_hd__dlygate4sd3_1
X_2799_ _2801_/CLK _2799_/D load_slew123/X vssd1 vssd1 vccd1 vccd1 _2799_/Q sky130_fd_sc_hd__dfrtp_2
XFILLER_13_113 vssd1 vssd1 vccd1 vccd1 sky130_fd_sc_hd__fill_1
XTAP_TAPCELL_ROW_43_439 vssd1 vccd1 sky130_fd_sc_hd__tapvpwrvgnd_1
XANTENNA__1602__B1 _1589_/X vssd1 vssd1 vccd1 vccd1 sky130_fd_sc_hd__diode_2
XFILLER_5_301 vssd1 vssd1 vccd1 vccd1 sky130_fd_sc_hd__fill_1
XTAP_TAPCELL_ROW_51_494 vssd1 vccd1 sky130_fd_sc_hd__tapvpwrvgnd_1
XANTENNA__1725__B _2472_/A vssd1 vssd1 vccd1 vccd1 sky130_fd_sc_hd__diode_2
XTAP_TAPCELL_ROW_8_194 vssd1 vccd1 sky130_fd_sc_hd__tapvpwrvgnd_1
XTAP_TAPCELL_ROW_59_550 vssd1 vccd1 sky130_fd_sc_hd__tapvpwrvgnd_1
X_2722_ _2769_/CLK _2722_/D load_slew139/X vssd1 vssd1 vccd1 vccd1 _2722_/Q sky130_fd_sc_hd__dfrtp_2
XANTENNA__1916__A _1944_/A vssd1 vssd1 vccd1 vccd1 sky130_fd_sc_hd__diode_2
X_1535_ _2840_/Q _1502_/X _1539_/A _1534_/Y vssd1 vssd1 vccd1 vccd1 _1536_/B sky130_fd_sc_hd__o211a_2
X_1604_ _2637_/Q _1710_/S _1590_/A vssd1 vssd1 vccd1 vccd1 _1604_/X sky130_fd_sc_hd__a21o_2
Xfanout118 fanout145/X vssd1 vssd1 vccd1 vccd1 fanout118/X sky130_fd_sc_hd__clkdlybuf4s25_1
Xfanout107 fanout111/A vssd1 vssd1 vccd1 vccd1 fanout107/X sky130_fd_sc_hd__clkdlybuf4s25_1
X_2653_ _2663_/CLK _2653_/D load_slew101/X vssd1 vssd1 vccd1 vccd1 _2653_/Q sky130_fd_sc_hd__dfrtp_2
X_2584_ clkload5/A _2584_/D vssd1 vssd1 vccd1 vccd1 _2584_/Q sky130_fd_sc_hd__dfxtp_2
XFILLER_27_216 vssd1 vssd1 vccd1 vccd1 sky130_fd_sc_hd__fill_2
X_1397_ _2917_/Q _2330_/A _2348_/B _1396_/X vssd1 vssd1 vccd1 vccd1 _2917_/D sky130_fd_sc_hd__a211o_2
X_1466_ _2910_/Q _1465_/C _2911_/Q vssd1 vssd1 vccd1 vccd1 _1467_/B sky130_fd_sc_hd__a21oi_2
XFILLER_63_19 vssd1 vssd1 vccd1 vccd1 sky130_fd_sc_hd__fill_2
X_2018_ _2018_/A _2018_/B _2018_/C vssd1 vssd1 vccd1 vccd1 _2024_/A sky130_fd_sc_hd__or3_2
XANTENNA__1826__A _2635_/Q vssd1 vssd1 vccd1 vccd1 sky130_fd_sc_hd__diode_2
XFILLER_37_31 vssd1 vssd1 vccd1 vccd1 sky130_fd_sc_hd__fill_4
XFILLER_58_363 vssd1 vssd1 vccd1 vccd1 sky130_fd_sc_hd__fill_1
XTAP_TAPCELL_ROW_56_531 vssd1 vccd1 sky130_fd_sc_hd__tapvpwrvgnd_1
XTAP_TAPCELL_ROW_5_175 vssd1 vccd1 sky130_fd_sc_hd__tapvpwrvgnd_1
X_1320_ _2732_/Q _1311_/X _1314_/X _1318_/X _1319_/X vssd1 vssd1 vccd1 vccd1 _1320_/X
+ sky130_fd_sc_hd__o221a_2
XPHY_EDGE_ROW_20_Left_85 vssd1 vssd1 vccd1 vccd1 sky130_fd_sc_hd__decap_3
X_2705_ _2768_/CLK _2705_/D load_slew142/X vssd1 vssd1 vccd1 vccd1 _2705_/Q sky130_fd_sc_hd__dfrtp_2
X_2636_ clkload7/A _2636_/D load_slew127/X vssd1 vssd1 vccd1 vccd1 _2636_/Q sky130_fd_sc_hd__dfrtp_2
X_1449_ _1454_/C vssd1 vssd1 vccd1 vccd1 _1449_/Y sky130_fd_sc_hd__inv_2
X_1518_ _1490_/X _1499_/B _1517_/X _2408_/A vssd1 vssd1 vccd1 vccd1 _1518_/X sky130_fd_sc_hd__o211a_2
X_2567_ _2663_/CLK _2567_/D vssd1 vssd1 vccd1 vccd1 _2567_/Q sky130_fd_sc_hd__dfxtp_2
X_2498_ _2856_/Q _2857_/Q _2498_/C vssd1 vssd1 vccd1 vccd1 _2502_/B sky130_fd_sc_hd__and3_2
XANTENNA_clkbuf_leaf_4_clk_A clkbuf_leaf_4_clk/A vssd1 vssd1 vccd1 vccd1 sky130_fd_sc_hd__diode_2
XTAP_TAPCELL_ROW_2_156 vssd1 vccd1 sky130_fd_sc_hd__tapvpwrvgnd_1
XTAP_TAPCELL_ROW_53_512 vssd1 vccd1 sky130_fd_sc_hd__tapvpwrvgnd_1
XANTENNA__1556__A _1582_/A vssd1 vssd1 vccd1 vccd1 sky130_fd_sc_hd__diode_2
XANTENNA__2151__S _2154_/S vssd1 vssd1 vccd1 vccd1 sky130_fd_sc_hd__diode_2
XANTENNA__1291__A _2969_/A vssd1 vssd1 vccd1 vccd1 sky130_fd_sc_hd__diode_2
XANTENNA__2297__B1 _2297_/B1 vssd1 vssd1 vccd1 vccd1 sky130_fd_sc_hd__diode_2
XFILLER_48_85 vssd1 vssd1 vccd1 vccd1 sky130_fd_sc_hd__fill_1
XFILLER_0_48 vssd1 vssd1 vccd1 vccd1 sky130_fd_sc_hd__fill_2
X_1303_ _2801_/Q _2800_/Q _1339_/B vssd1 vssd1 vccd1 vccd1 _1342_/B sky130_fd_sc_hd__and3_2
X_2421_ _2831_/Q _2830_/Q _2832_/Q _2421_/D vssd1 vssd1 vccd1 vccd1 _2426_/B sky130_fd_sc_hd__nand4_2
X_2352_ _1391_/Y _2337_/X _2330_/Y vssd1 vssd1 vccd1 vccd1 _2352_/Y sky130_fd_sc_hd__o21ai_2
X_2283_ _2328_/A1 hold381/X _2156_/B hold461/X vssd1 vssd1 vccd1 vccd1 _2760_/D sky130_fd_sc_hd__a22o_2
XANTENNA__2288__B1 _2293_/B1 vssd1 vssd1 vccd1 vccd1 sky130_fd_sc_hd__diode_2
XFILLER_37_300 vssd1 vssd1 vccd1 vccd1 sky130_fd_sc_hd__fill_1
XFILLER_64_141 vssd1 vssd1 vccd1 vccd1 sky130_fd_sc_hd__fill_2
XANTENNA_fanout130_A fanout132/X vssd1 vssd1 vccd1 vccd1 sky130_fd_sc_hd__diode_2
X_1998_ _1998_/A _1998_/B vssd1 vssd1 vccd1 vccd1 _2007_/B sky130_fd_sc_hd__xnor2_2
X_2619_ clkload7/A _2619_/D fanout105/X vssd1 vssd1 vccd1 vccd1 _2619_/Q sky130_fd_sc_hd__dfrtp_2
XANTENNA__2708__Q _2708_/Q vssd1 vssd1 vccd1 vccd1 sky130_fd_sc_hd__diode_2
XFILLER_28_333 vssd1 vssd1 vccd1 vccd1 sky130_fd_sc_hd__fill_4
XANTENNA__2146__S _2153_/S vssd1 vssd1 vccd1 vccd1 sky130_fd_sc_hd__diode_2
XFILLER_55_185 vssd1 vssd1 vccd1 vccd1 sky130_fd_sc_hd__fill_2
XFILLER_11_233 vssd1 vssd1 vccd1 vccd1 sky130_fd_sc_hd__fill_1
XTAP_TAPCELL_ROW_13_228 vssd1 vccd1 sky130_fd_sc_hd__tapvpwrvgnd_1
Xload_slew129 fanout128/X vssd1 vssd1 vccd1 vccd1 load_slew129/X sky130_fd_sc_hd__buf_2
XANTENNA__2618__Q _2618_/Q vssd1 vssd1 vccd1 vccd1 sky130_fd_sc_hd__diode_2
XFILLER_46_141 vssd1 vssd1 vccd1 vccd1 sky130_fd_sc_hd__fill_2
X_1852_ _2873_/Q _2712_/Q _1822_/B _1822_/A _1851_/Y vssd1 vssd1 vccd1 vccd1 _1852_/X
+ sky130_fd_sc_hd__a221o_2
X_1921_ _1922_/B _1922_/C _2677_/Q vssd1 vssd1 vccd1 vccd1 _1921_/Y sky130_fd_sc_hd__a21oi_2
X_2970_ _2970_/A vssd1 vssd1 vccd1 vccd1 _2970_/X sky130_fd_sc_hd__buf_2
X_1783_ _2623_/Q _2624_/Q _2625_/Q _1783_/D vssd1 vssd1 vccd1 vccd1 _1793_/C sky130_fd_sc_hd__and4_2
XFILLER_57_406 vssd1 vssd1 vccd1 vccd1 sky130_fd_sc_hd__fill_1
X_2404_ _2827_/Q _2826_/Q _2406_/B vssd1 vssd1 vccd1 vccd1 _2405_/B sky130_fd_sc_hd__and3_2
X_2335_ _1293_/A _2348_/B _2335_/B1 vssd1 vssd1 vccd1 vccd1 _2345_/A sky130_fd_sc_hd__o21ai_2
X_2266_ hold484/X _2282_/A2 _2265_/X _2155_/A vssd1 vssd1 vccd1 vccd1 _2756_/D sky130_fd_sc_hd__a22o_2
XANTENNA_fanout178_A _2189_/S vssd1 vssd1 vccd1 vccd1 sky130_fd_sc_hd__diode_2
X_2197_ _1351_/A _2195_/X _2196_/Y hold377/X _2260_/A2 vssd1 vssd1 vccd1 vccd1 _2746_/D
+ sky130_fd_sc_hd__a32o_2
XTAP_TAPCELL_ROW_10_209 vssd1 vccd1 sky130_fd_sc_hd__tapvpwrvgnd_1
XTAP_TAPCELL_ROW_35_386 vssd1 vccd1 sky130_fd_sc_hd__tapvpwrvgnd_1
XFILLER_20_56 vssd1 vssd1 vccd1 vccd1 sky130_fd_sc_hd__fill_1
XPHY_EDGE_ROW_42_Left_107 vssd1 vssd1 vccd1 vccd1 sky130_fd_sc_hd__decap_3
XFILLER_16_336 vssd1 vssd1 vccd1 vccd1 sky130_fd_sc_hd__fill_1
XPHY_EDGE_ROW_51_Left_116 vssd1 vssd1 vccd1 vccd1 sky130_fd_sc_hd__decap_3
XTAP_TAPCELL_ROW_26_320 vssd1 vccd1 sky130_fd_sc_hd__tapvpwrvgnd_1
XANTENNA__1744__A _2618_/Q vssd1 vssd1 vccd1 vccd1 sky130_fd_sc_hd__diode_2
XPHY_EDGE_ROW_60_Left_125 vssd1 vssd1 vccd1 vccd1 sky130_fd_sc_hd__decap_3
X_2120_ _2569_/Q _2585_/Q _2120_/S vssd1 vssd1 vccd1 vccd1 _2120_/X sky130_fd_sc_hd__mux2_1
XFILLER_34_166 vssd1 vssd1 vccd1 vccd1 sky130_fd_sc_hd__fill_1
X_2051_ _2056_/A _2047_/X _2055_/C _2052_/B2 vssd1 vssd1 vccd1 vccd1 _2051_/X sky130_fd_sc_hd__a31o_2
XFILLER_30_350 vssd1 vssd1 vccd1 vccd1 sky130_fd_sc_hd__fill_4
XFILLER_30_383 vssd1 vssd1 vccd1 vccd1 sky130_fd_sc_hd__fill_1
XFILLER_34_199 vssd1 vssd1 vccd1 vccd1 sky130_fd_sc_hd__fill_4
XTAP_TAPCELL_ROW_32_367 vssd1 vccd1 sky130_fd_sc_hd__tapvpwrvgnd_1
X_1835_ _1834_/B _1834_/C _1834_/A vssd1 vssd1 vccd1 vccd1 _1837_/B sky130_fd_sc_hd__a21bo_2
X_1904_ _2878_/Q _1846_/Y _1903_/X _2710_/Q _1908_/A2 vssd1 vssd1 vccd1 vccd1 _1904_/X
+ sky130_fd_sc_hd__a32o_2
X_2884_ _2884_/CLK _2884_/D _2473_/A1 vssd1 vssd1 vccd1 vccd1 _2884_/Q sky130_fd_sc_hd__dfrtp_2
XANTENNA__1373__B _2154_/S vssd1 vssd1 vccd1 vccd1 sky130_fd_sc_hd__diode_2
XANTENNA__1654__A _1662_/D vssd1 vssd1 vccd1 vccd1 sky130_fd_sc_hd__diode_2
X_1697_ _2616_/Q _2633_/Q _1702_/S vssd1 vssd1 vccd1 vccd1 _1697_/X sky130_fd_sc_hd__mux2_1
X_1766_ _2621_/Q _1761_/X _1770_/C vssd1 vssd1 vccd1 vccd1 _1766_/Y sky130_fd_sc_hd__a21boi_2
Xhold502 _2672_/Q vssd1 vssd1 vccd1 vccd1 hold502/X sky130_fd_sc_hd__dlygate4sd3_1
Xhold513 _2543_/Q vssd1 vssd1 vccd1 vccd1 hold513/X sky130_fd_sc_hd__dlygate4sd3_1
Xhold524 _2841_/Q vssd1 vssd1 vccd1 vccd1 hold524/X sky130_fd_sc_hd__dlygate4sd3_1
Xhold535 _2825_/Q vssd1 vssd1 vccd1 vccd1 hold535/X sky130_fd_sc_hd__dlygate4sd3_1
Xhold546 _2695_/Q vssd1 vssd1 vccd1 vccd1 hold546/X sky130_fd_sc_hd__dlygate4sd3_1
XFILLER_57_203 vssd1 vssd1 vccd1 vccd1 sky130_fd_sc_hd__fill_8
XFILLER_57_225 vssd1 vssd1 vccd1 vccd1 sky130_fd_sc_hd__fill_1
X_2318_ _2323_/A1 hold383/X _2323_/B1 _2794_/Q vssd1 vssd1 vccd1 vccd1 _2794_/D sky130_fd_sc_hd__a22o_2
X_2249_ _2769_/Q _2723_/Q vssd1 vssd1 vccd1 vccd1 _2251_/B sky130_fd_sc_hd__nand2_2
XANTENNA__1829__A _2634_/Q vssd1 vssd1 vccd1 vccd1 sky130_fd_sc_hd__diode_2
XANTENNA__2728__RESET_B fanout132/X vssd1 vssd1 vccd1 vccd1 sky130_fd_sc_hd__diode_2
XTAP_TAPCELL_ROW_23_301 vssd1 vccd1 sky130_fd_sc_hd__tapvpwrvgnd_1
XFILLER_31_55 vssd1 vssd1 vccd1 vccd1 sky130_fd_sc_hd__fill_1
XANTENNA__1564__A _1582_/A vssd1 vssd1 vccd1 vccd1 sky130_fd_sc_hd__diode_2
XFILLER_0_221 vssd1 vssd1 vccd1 vccd1 sky130_fd_sc_hd__fill_2
XFILLER_0_243 vssd1 vssd1 vccd1 vccd1 sky130_fd_sc_hd__fill_1
Xoutput9 _2541_/Q vssd1 vssd1 vccd1 vccd1 gpio_out[12] sky130_fd_sc_hd__clkdlybuf4s25_1
Xoutput22 _2887_/Q vssd1 vssd1 vccd1 vccd1 gpio_out[25] sky130_fd_sc_hd__clkdlybuf4s25_1
Xoutput11 _2543_/Q vssd1 vssd1 vccd1 vccd1 gpio_out[14] sky130_fd_sc_hd__clkdlybuf4s25_1
XANTENNA_clkbuf_3_1__f_clk_A clkbuf_0_clk/X vssd1 vssd1 vccd1 vccd1 sky130_fd_sc_hd__diode_2
XFILLER_16_166 vssd1 vssd1 vccd1 vccd1 sky130_fd_sc_hd__fill_1
XFILLER_56_85 vssd1 vssd1 vccd1 vccd1 sky130_fd_sc_hd__fill_2
XTAP_TAPCELL_ROW_46_459 vssd1 vccd1 sky130_fd_sc_hd__tapvpwrvgnd_1
XFILLER_8_365 vssd1 vssd1 vccd1 vccd1 sky130_fd_sc_hd__fill_2
X_1482_ _2914_/Q _1416_/A _1480_/Y _1412_/Y _1280_/B vssd1 vssd1 vccd1 vccd1 _1482_/X
+ sky130_fd_sc_hd__a221o_2
X_1551_ _2805_/Q _1651_/B _1546_/X _1549_/Y vssd1 vssd1 vccd1 vccd1 _1551_/Y sky130_fd_sc_hd__o22ai_2
X_1620_ _1384_/B _2705_/Q _1586_/B _1619_/X vssd1 vssd1 vccd1 vccd1 _1620_/X sky130_fd_sc_hd__a211o_2
XANTENNA__1687__A1 _2641_/Q vssd1 vssd1 vccd1 vccd1 sky130_fd_sc_hd__diode_2
XFILLER_39_225 vssd1 vssd1 vccd1 vccd1 sky130_fd_sc_hd__fill_8
X_2103_ hold495/X _2102_/X _2125_/S vssd1 vssd1 vccd1 vccd1 _2678_/D sky130_fd_sc_hd__mux2_1
XFILLER_54_228 vssd1 vssd1 vccd1 vccd1 sky130_fd_sc_hd__fill_1
X_2034_ _2050_/A1 _2030_/X _2041_/C _2052_/B2 vssd1 vssd1 vccd1 vccd1 _2034_/X sky130_fd_sc_hd__a31o_2
XFILLER_10_309 vssd1 vssd1 vccd1 vccd1 sky130_fd_sc_hd__fill_1
X_1818_ _1756_/B _1815_/X _1816_/Y _1817_/X vssd1 vssd1 vccd1 vccd1 _1818_/X sky130_fd_sc_hd__a31o_2
Xhold310 _2717_/Q vssd1 vssd1 vccd1 vccd1 hold310/X sky130_fd_sc_hd__dlygate4sd3_1
X_2867_ _2869_/CLK _2867_/D fanout125/X vssd1 vssd1 vccd1 vccd1 _2867_/Q sky130_fd_sc_hd__dfrtp_2
X_2798_ _2801_/CLK _2798_/D load_slew123/X vssd1 vssd1 vccd1 vccd1 _2798_/Q sky130_fd_sc_hd__dfrtp_2
XANTENNA__1375__B1 _1662_/D vssd1 vssd1 vccd1 vccd1 sky130_fd_sc_hd__diode_2
X_1749_ _1734_/A _2650_/Q _1786_/B1 _2699_/Q _1819_/B2 vssd1 vssd1 vccd1 vccd1 _1749_/X
+ sky130_fd_sc_hd__a221o_2
Xhold321 _2534_/Q vssd1 vssd1 vccd1 vccd1 hold321/X sky130_fd_sc_hd__dlygate4sd3_1
Xhold332 _2837_/Q vssd1 vssd1 vccd1 vccd1 hold332/X sky130_fd_sc_hd__dlygate4sd3_1
Xhold343 _2648_/Q vssd1 vssd1 vccd1 vccd1 hold343/X sky130_fd_sc_hd__dlygate4sd3_1
Xhold354 _1695_/X vssd1 vssd1 vccd1 vccd1 _2594_/D sky130_fd_sc_hd__dlygate4sd3_1
Xhold365 _2712_/Q vssd1 vssd1 vccd1 vccd1 hold365/X sky130_fd_sc_hd__dlygate4sd3_1
Xhold376 _2752_/Q vssd1 vssd1 vccd1 vccd1 hold376/X sky130_fd_sc_hd__dlygate4sd3_1
Xhold387 _2784_/Q vssd1 vssd1 vccd1 vccd1 hold387/X sky130_fd_sc_hd__dlygate4sd3_1
Xhold398 _2775_/Q vssd1 vssd1 vccd1 vccd1 hold398/X sky130_fd_sc_hd__dlygate4sd3_1
XANTENNA__2154__S _2154_/S vssd1 vssd1 vccd1 vccd1 sky130_fd_sc_hd__diode_2
XFILLER_13_169 vssd1 vssd1 vccd1 vccd1 sky130_fd_sc_hd__fill_2
XFILLER_53_283 vssd1 vssd1 vccd1 vccd1 sky130_fd_sc_hd__fill_1
XTAP_TAPCELL_ROW_51_495 vssd1 vccd1 sky130_fd_sc_hd__tapvpwrvgnd_1
XFILLER_3_37 vssd1 vssd1 vccd1 vccd1 sky130_fd_sc_hd__fill_2
XTAP_TAPCELL_ROW_59_551 vssd1 vccd1 sky130_fd_sc_hd__tapvpwrvgnd_1
XTAP_TAPCELL_ROW_8_195 vssd1 vccd1 sky130_fd_sc_hd__tapvpwrvgnd_1
X_2721_ _2769_/CLK _2721_/D load_slew139/X vssd1 vssd1 vccd1 vccd1 _2721_/Q sky130_fd_sc_hd__dfrtp_2
X_2652_ clkload5/A _2652_/D load_slew101/X vssd1 vssd1 vccd1 vccd1 _2652_/Q sky130_fd_sc_hd__dfrtp_2
XANTENNA__1932__A _1944_/A vssd1 vssd1 vccd1 vccd1 sky130_fd_sc_hd__diode_2
X_1465_ _2910_/Q _2911_/Q _1465_/C vssd1 vssd1 vccd1 vccd1 _1472_/B sky130_fd_sc_hd__and3_2
X_1534_ _2839_/Q _2842_/Q _1537_/D vssd1 vssd1 vccd1 vccd1 _1534_/Y sky130_fd_sc_hd__nand3_2
X_1603_ _2620_/Q _2637_/Q _1710_/S vssd1 vssd1 vccd1 vccd1 _1603_/X sky130_fd_sc_hd__mux2_1
X_2583_ clkload5/A _2583_/D vssd1 vssd1 vccd1 vccd1 _2583_/Q sky130_fd_sc_hd__dfxtp_2
X_1396_ _2389_/B _1415_/B _2331_/A vssd1 vssd1 vccd1 vccd1 _1396_/X sky130_fd_sc_hd__o21a_2
X_2017_ hold438/X _2016_/Y _2071_/B vssd1 vssd1 vccd1 vccd1 _2653_/D sky130_fd_sc_hd__mux2_1
XANTENNA_fanout160_A _1863_/C vssd1 vssd1 vccd1 vccd1 sky130_fd_sc_hd__diode_2
XFILLER_50_253 vssd1 vssd1 vccd1 vccd1 sky130_fd_sc_hd__fill_1
XFILLER_50_275 vssd1 vssd1 vccd1 vccd1 sky130_fd_sc_hd__fill_1
X_2919_ _2923_/CLK _2919_/D _2331_/B vssd1 vssd1 vccd1 vccd1 _2919_/Q sky130_fd_sc_hd__dfstp_2
XANTENNA__1842__A _2640_/Q vssd1 vssd1 vccd1 vccd1 sky130_fd_sc_hd__diode_2
XANTENNA__2149__S _2153_/S vssd1 vssd1 vccd1 vccd1 sky130_fd_sc_hd__diode_2
XTAP_TAPCELL_ROW_5_176 vssd1 vccd1 sky130_fd_sc_hd__tapvpwrvgnd_1
XTAP_TAPCELL_ROW_56_532 vssd1 vccd1 sky130_fd_sc_hd__tapvpwrvgnd_1
XFILLER_53_75 vssd1 vssd1 vccd1 vccd1 sky130_fd_sc_hd__fill_4
XFILLER_5_110 vssd1 vssd1 vccd1 vccd1 sky130_fd_sc_hd__fill_2
XFILLER_20_404 vssd1 vssd1 vccd1 vccd1 sky130_fd_sc_hd__fill_2
XFILLER_32_253 vssd1 vssd1 vccd1 vccd1 sky130_fd_sc_hd__fill_1
X_2896__226 vssd1 vssd1 vccd1 vccd1 _2896__226/HI _2896_/D sky130_fd_sc_hd__conb_1
X_2704_ _2768_/CLK _2704_/D load_slew139/X vssd1 vssd1 vccd1 vccd1 _2704_/Q sky130_fd_sc_hd__dfrtp_2
X_2635_ clkload8/A _2635_/D fanout126/X vssd1 vssd1 vccd1 vccd1 _2635_/Q sky130_fd_sc_hd__dfrtp_2
X_1448_ _2906_/Q _1448_/B vssd1 vssd1 vccd1 vccd1 _1454_/C sky130_fd_sc_hd__and2_2
X_1517_ _2826_/Q _1517_/B _1517_/C _1517_/D vssd1 vssd1 vccd1 vccd1 _1517_/X sky130_fd_sc_hd__or4_2
X_2566_ _2663_/CLK _2566_/D vssd1 vssd1 vccd1 vccd1 _2566_/Q sky130_fd_sc_hd__dfxtp_2
X_2497_ _2497_/A _2498_/C vssd1 vssd1 vccd1 vccd1 _2856_/D sky130_fd_sc_hd__xor2_2
XANTENNA_fanout163_X _1385_/B vssd1 vssd1 vccd1 vccd1 sky130_fd_sc_hd__diode_2
XTAP_TAPCELL_ROW_2_157 vssd1 vccd1 sky130_fd_sc_hd__tapvpwrvgnd_1
XTAP_TAPCELL_ROW_53_513 vssd1 vccd1 sky130_fd_sc_hd__tapvpwrvgnd_1
X_1379_ _1378_/X _1661_/S vssd1 vssd1 vccd1 vccd1 _2879_/D sky130_fd_sc_hd__nand2b_2
XANTENNA__1556__B _2635_/Q vssd1 vssd1 vccd1 vccd1 sky130_fd_sc_hd__diode_2
XFILLER_48_31 vssd1 vssd1 vccd1 vccd1 sky130_fd_sc_hd__fill_2
XFILLER_48_64 vssd1 vssd1 vccd1 vccd1 sky130_fd_sc_hd__fill_1
XANTENNA__1554__C_N _1582_/A vssd1 vssd1 vccd1 vccd1 sky130_fd_sc_hd__diode_2
XFILLER_64_85 vssd1 vssd1 vccd1 vccd1 sky130_fd_sc_hd__fill_1
X_2420_ _2832_/Q _2420_/B vssd1 vssd1 vccd1 vccd1 _2422_/A sky130_fd_sc_hd__or2_2
XANTENNA__2288__A1 _1366_/A vssd1 vssd1 vccd1 vccd1 sky130_fd_sc_hd__diode_2
X_1302_ _2799_/Q _2798_/Q _2797_/Q _1330_/B vssd1 vssd1 vccd1 vccd1 _1339_/B sky130_fd_sc_hd__and4_2
X_2351_ _2332_/B _2919_/Q _2348_/Y _2470_/D hold456/X vssd1 vssd1 vccd1 vccd1 _2812_/D
+ sky130_fd_sc_hd__a32o_2
X_2282_ hold414/X _2282_/A2 _2281_/Y _1351_/A vssd1 vssd1 vccd1 vccd1 _2759_/D sky130_fd_sc_hd__a22o_2
XFILLER_64_131 vssd1 vssd1 vccd1 vccd1 sky130_fd_sc_hd__fill_1
X_1997_ _1961_/Y _1997_/B vssd1 vssd1 vccd1 vccd1 _1998_/B sky130_fd_sc_hd__nand2b_2
X_2618_ clkload7/A _2618_/D load_slew127/X vssd1 vssd1 vccd1 vccd1 _2618_/Q sky130_fd_sc_hd__dfrtp_2
X_2549_ _2647_/CLK _2549_/D load_slew129/X vssd1 vssd1 vccd1 vccd1 _2549_/Q sky130_fd_sc_hd__dfrtp_2
XFILLER_18_34 vssd1 vssd1 vccd1 vccd1 sky130_fd_sc_hd__fill_8
XTAP_TAPCELL_ROW_13_229 vssd1 vccd1 sky130_fd_sc_hd__tapvpwrvgnd_1
XANTENNA__2162__S _2168_/S vssd1 vssd1 vccd1 vccd1 sky130_fd_sc_hd__diode_2
XTAP_TAPCELL_ROW_21_284 vssd1 vccd1 sky130_fd_sc_hd__tapvpwrvgnd_1
Xload_slew119 fanout118/X vssd1 vssd1 vccd1 vccd1 fanout117/A sky130_fd_sc_hd__clkbuf_2
Xload_slew108 fanout107/X vssd1 vssd1 vccd1 vccd1 load_slew108/X sky130_fd_sc_hd__buf_2
XFILLER_46_175 vssd1 vssd1 vccd1 vccd1 sky130_fd_sc_hd__fill_1
XTAP_TAPCELL_ROW_29_340 vssd1 vccd1 sky130_fd_sc_hd__tapvpwrvgnd_1
XANTENNA__2634__Q _2634_/Q vssd1 vssd1 vccd1 vccd1 sky130_fd_sc_hd__diode_2
X_1851_ _2873_/Q _1821_/X _1382_/Y vssd1 vssd1 vccd1 vccd1 _1851_/Y sky130_fd_sc_hd__o21ai_2
X_1920_ _1940_/A _2692_/Q vssd1 vssd1 vccd1 vccd1 _1922_/C sky130_fd_sc_hd__nand2_2
XANTENNA_clkbuf_leaf_3_clk_A clkbuf_leaf_3_clk/A vssd1 vssd1 vccd1 vccd1 sky130_fd_sc_hd__diode_2
X_1782_ _2624_/Q _1814_/B2 _1780_/Y _1781_/X vssd1 vssd1 vccd1 vccd1 _2624_/D sky130_fd_sc_hd__o22a_2
X_2403_ _2826_/Q _2406_/B hold547/X vssd1 vssd1 vccd1 vccd1 _2405_/A sky130_fd_sc_hd__a21oi_2
X_2334_ _2916_/Q _2918_/Q _2332_/X _2333_/Y _2330_/Y vssd1 vssd1 vccd1 vccd1 _2334_/Y
+ sky130_fd_sc_hd__o221ai_2
X_2265_ _2265_/A _2265_/B vssd1 vssd1 vccd1 vccd1 _2265_/X sky130_fd_sc_hd__xor2_2
X_2196_ _2195_/B _2202_/A _2195_/A vssd1 vssd1 vccd1 vccd1 _2196_/Y sky130_fd_sc_hd__o21ai_2
XFILLER_37_175 vssd1 vssd1 vccd1 vccd1 sky130_fd_sc_hd__fill_1
XTAP_TAPCELL_ROW_35_387 vssd1 vccd1 sky130_fd_sc_hd__tapvpwrvgnd_1
XFILLER_16_326 vssd1 vssd1 vccd1 vccd1 sky130_fd_sc_hd__fill_1
XTAP_TAPCELL_ROW_26_321 vssd1 vccd1 sky130_fd_sc_hd__tapvpwrvgnd_1
X_2050_ _2050_/A1 _2047_/X _2055_/C vssd1 vssd1 vccd1 vccd1 _2050_/Y sky130_fd_sc_hd__a21oi_2
XFILLER_22_307 vssd1 vssd1 vccd1 vccd1 sky130_fd_sc_hd__fill_1
XFILLER_30_373 vssd1 vssd1 vccd1 vccd1 sky130_fd_sc_hd__fill_1
X_1765_ _1761_/X _1764_/X _1814_/B2 vssd1 vssd1 vccd1 vccd1 _1765_/X sky130_fd_sc_hd__o21a_2
X_1834_ _1834_/A _1834_/B _1834_/C vssd1 vssd1 vccd1 vccd1 _1834_/X sky130_fd_sc_hd__and3_2
X_1903_ _2646_/Q _1903_/B vssd1 vssd1 vccd1 vccd1 _1903_/X sky130_fd_sc_hd__or2_2
X_2883_ _2883_/CLK _2883_/D _2473_/A1 vssd1 vssd1 vccd1 vccd1 _2883_/Q sky130_fd_sc_hd__dfrtp_2
X_1696_ _1359_/B _2472_/A _1686_/S vssd1 vssd1 vccd1 vccd1 _2595_/D sky130_fd_sc_hd__a21o_2
Xhold503 _2537_/Q vssd1 vssd1 vccd1 vccd1 hold503/X sky130_fd_sc_hd__dlygate4sd3_1
Xhold514 _2831_/Q vssd1 vssd1 vccd1 vccd1 _2412_/A sky130_fd_sc_hd__dlygate4sd3_1
Xhold525 _2810_/Q vssd1 vssd1 vccd1 vccd1 hold525/X sky130_fd_sc_hd__dlygate4sd3_1
Xhold536 _2631_/Q vssd1 vssd1 vccd1 vccd1 hold536/X sky130_fd_sc_hd__dlygate4sd3_1
Xhold547 _2827_/Q vssd1 vssd1 vccd1 vccd1 hold547/X sky130_fd_sc_hd__dlygate4sd3_1
XANTENNA__2351__B1 _2470_/D vssd1 vssd1 vccd1 vccd1 sky130_fd_sc_hd__diode_2
XANTENNA_fanout190_A _1944_/A vssd1 vssd1 vccd1 vccd1 sky130_fd_sc_hd__diode_2
X_2317_ _2323_/A1 hold402/X _2323_/B1 _2793_/Q vssd1 vssd1 vccd1 vccd1 _2317_/X sky130_fd_sc_hd__a22o_2
X_2248_ _2769_/Q _2723_/Q vssd1 vssd1 vccd1 vccd1 _2251_/A sky130_fd_sc_hd__or2_2
X_2179_ hold362/X hold270/X _2180_/S vssd1 vssd1 vccd1 vccd1 _2735_/D sky130_fd_sc_hd__mux2_1
XFILLER_15_68 vssd1 vssd1 vccd1 vccd1 sky130_fd_sc_hd__fill_1
XFILLER_40_137 vssd1 vssd1 vccd1 vccd1 sky130_fd_sc_hd__fill_2
XTAP_TAPCELL_ROW_23_302 vssd1 vccd1 sky130_fd_sc_hd__tapvpwrvgnd_1
XANTENNA__1845__A _2645_/Q vssd1 vssd1 vccd1 vccd1 sky130_fd_sc_hd__diode_2
Xoutput23 _2888_/Q vssd1 vssd1 vccd1 vccd1 gpio_out[26] sky130_fd_sc_hd__clkdlybuf4s25_1
Xoutput12 _2544_/Q vssd1 vssd1 vccd1 vccd1 gpio_out[15] sky130_fd_sc_hd__clkdlybuf4s25_1
XANTENNA__1696__A2 _2472_/A vssd1 vssd1 vccd1 vccd1 sky130_fd_sc_hd__diode_2
XANTENNA__1851__Y _1851_/Y vssd1 vssd1 vccd1 vccd1 sky130_fd_sc_hd__diode_2
XFILLER_56_31 vssd1 vssd1 vccd1 vccd1 sky130_fd_sc_hd__fill_2
XFILLER_56_42 vssd1 vssd1 vccd1 vccd1 sky130_fd_sc_hd__fill_2
XANTENNA__1620__A2 _2705_/Q vssd1 vssd1 vccd1 vccd1 sky130_fd_sc_hd__diode_2
XANTENNA__1739__B _2555_/Q vssd1 vssd1 vccd1 vccd1 sky130_fd_sc_hd__diode_2
X_1481_ _1413_/A _1416_/A _1480_/Y _1413_/Y _2914_/Q vssd1 vssd1 vccd1 vccd1 _1481_/X
+ sky130_fd_sc_hd__a32o_2
X_1550_ _2805_/Q _1651_/B _1546_/X _1549_/Y vssd1 vssd1 vccd1 vccd1 _1550_/X sky130_fd_sc_hd__o22a_2
XFILLER_11_3 vssd1 vssd1 vccd1 vccd1 sky130_fd_sc_hd__fill_4
XFILLER_47_281 vssd1 vssd1 vccd1 vccd1 sky130_fd_sc_hd__fill_1
XFILLER_54_218 vssd1 vssd1 vccd1 vccd1 sky130_fd_sc_hd__fill_8
X_2102_ _2591_/Q _2575_/Q _2134_/S vssd1 vssd1 vccd1 vccd1 _2102_/X sky130_fd_sc_hd__mux2_1
X_2033_ _2050_/A1 _2030_/X _2041_/C vssd1 vssd1 vccd1 vccd1 _2033_/Y sky130_fd_sc_hd__a21oi_2
XFILLER_62_240 vssd1 vssd1 vccd1 vccd1 sky130_fd_sc_hd__fill_1
XANTENNA__1611__A2 _2703_/Q vssd1 vssd1 vccd1 vccd1 sky130_fd_sc_hd__diode_2
X_1748_ _1747_/Y _1756_/B _1748_/C vssd1 vssd1 vccd1 vccd1 _1748_/X sky130_fd_sc_hd__and3b_2
X_1817_ _2876_/Q _2712_/Q _1822_/B _2871_/Q _1643_/X vssd1 vssd1 vccd1 vccd1 _1817_/X
+ sky130_fd_sc_hd__a221o_2
Xhold300 _2525_/Q vssd1 vssd1 vccd1 vccd1 hold300/X sky130_fd_sc_hd__dlygate4sd3_1
Xhold311 _2607_/Q vssd1 vssd1 vccd1 vccd1 hold311/X sky130_fd_sc_hd__dlygate4sd3_1
Xhold322 _2857_/Q vssd1 vssd1 vccd1 vccd1 hold322/X sky130_fd_sc_hd__dlygate4sd3_1
Xhold333 _2725_/Q vssd1 vssd1 vccd1 vccd1 hold333/X sky130_fd_sc_hd__dlygate4sd3_1
Xhold344 _2716_/Q vssd1 vssd1 vccd1 vccd1 hold344/X sky130_fd_sc_hd__dlygate4sd3_1
X_2866_ _2866_/CLK _2866_/D fanout111/A vssd1 vssd1 vccd1 vccd1 _2866_/Q sky130_fd_sc_hd__dfstp_2
X_2797_ _2801_/CLK _2797_/D load_slew123/X vssd1 vssd1 vccd1 vccd1 _2797_/Q sky130_fd_sc_hd__dfrtp_2
XANTENNA__2324__B1 _2156_/B vssd1 vssd1 vccd1 vccd1 sky130_fd_sc_hd__diode_2
X_1679_ hold306/X _2633_/Q _1695_/S vssd1 vssd1 vccd1 vccd1 _2578_/D sky130_fd_sc_hd__mux2_1
Xhold355 _2522_/Q vssd1 vssd1 vccd1 vccd1 hold355/X sky130_fd_sc_hd__dlygate4sd3_1
Xhold366 _2573_/Q vssd1 vssd1 vccd1 vccd1 hold366/X sky130_fd_sc_hd__dlygate4sd3_1
Xhold377 _2746_/Q vssd1 vssd1 vccd1 vccd1 hold377/X sky130_fd_sc_hd__dlygate4sd3_1
Xhold388 _2323_/X vssd1 vssd1 vccd1 vccd1 _2799_/D sky130_fd_sc_hd__dlygate4sd3_1
Xhold399 _2881_/Q vssd1 vssd1 vccd1 vccd1 _1359_/A sky130_fd_sc_hd__dlygate4sd3_1
XANTENNA__2298__A2_N _2300_/A1 vssd1 vssd1 vccd1 vccd1 sky130_fd_sc_hd__diode_2
XANTENNA__1602__A2 _1585_/X vssd1 vssd1 vccd1 vccd1 sky130_fd_sc_hd__diode_2
XFILLER_9_119 vssd1 vssd1 vccd1 vccd1 sky130_fd_sc_hd__fill_1
XTAP_TAPCELL_ROW_51_496 vssd1 vccd1 sky130_fd_sc_hd__tapvpwrvgnd_1
XANTENNA__2170__S _2189_/S vssd1 vssd1 vccd1 vccd1 sky130_fd_sc_hd__diode_2
XTAP_TAPCELL_ROW_59_552 vssd1 vccd1 sky130_fd_sc_hd__tapvpwrvgnd_1
XTAP_TAPCELL_ROW_8_196 vssd1 vccd1 sky130_fd_sc_hd__tapvpwrvgnd_1
XANTENNA__2619__RESET_B fanout105/X vssd1 vssd1 vccd1 vccd1 sky130_fd_sc_hd__diode_2
XANTENNA__2642__Q _2642_/Q vssd1 vssd1 vccd1 vccd1 sky130_fd_sc_hd__diode_2
XFILLER_44_284 vssd1 vssd1 vccd1 vccd1 sky130_fd_sc_hd__fill_1
XFILLER_8_141 vssd1 vssd1 vccd1 vccd1 sky130_fd_sc_hd__fill_2
X_1602_ _2619_/Q _1585_/X _1589_/X hold487/X _1601_/X vssd1 vssd1 vccd1 vccd1 _2540_/D
+ sky130_fd_sc_hd__a221o_2
X_2720_ _2769_/CLK _2720_/D load_slew139/X vssd1 vssd1 vccd1 vccd1 _2720_/Q sky130_fd_sc_hd__dfrtp_2
X_2651_ clkload5/A _2651_/D load_slew95/X vssd1 vssd1 vccd1 vccd1 _2651_/Q sky130_fd_sc_hd__dfrtp_2
X_2582_ _2688_/CLK _2582_/D vssd1 vssd1 vccd1 vccd1 _2582_/Q sky130_fd_sc_hd__dfxtp_2
X_1395_ _2916_/Q _2331_/A _1389_/Y _1394_/X vssd1 vssd1 vccd1 vccd1 _2916_/D sky130_fd_sc_hd__o211a_2
X_1464_ _1273_/X _2911_/Q vssd1 vssd1 vccd1 vccd1 _1464_/Y sky130_fd_sc_hd__nand2b_2
X_1533_ _2838_/Q _1533_/B vssd1 vssd1 vccd1 vccd1 _1537_/D sky130_fd_sc_hd__and2_2
Xfanout109 fanout113/X vssd1 vssd1 vccd1 vccd1 fanout109/X sky130_fd_sc_hd__clkdlybuf4s25_1
XFILLER_27_218 vssd1 vssd1 vccd1 vccd1 sky130_fd_sc_hd__fill_1
X_2016_ _2016_/A _2018_/C vssd1 vssd1 vccd1 vccd1 _2016_/Y sky130_fd_sc_hd__xnor2_2
XANTENNA_fanout153_A _2883_/Q vssd1 vssd1 vccd1 vccd1 sky130_fd_sc_hd__diode_2
XFILLER_50_221 vssd1 vssd1 vccd1 vccd1 sky130_fd_sc_hd__fill_1
XFILLER_50_243 vssd1 vssd1 vccd1 vccd1 sky130_fd_sc_hd__fill_4
XFILLER_50_298 vssd1 vssd1 vccd1 vccd1 sky130_fd_sc_hd__fill_1
Xclkbuf_leaf_30_clk clkbuf_3_4__f_clk/X vssd1 vssd1 vccd1 vccd1 clkload9/A sky130_fd_sc_hd__clkbuf_8
X_2918_ _2923_/CLK _2918_/D _2331_/B vssd1 vssd1 vccd1 vccd1 _2918_/Q sky130_fd_sc_hd__dfstp_2
X_2849_ _2884_/CLK _2849_/D vssd1 vssd1 vccd1 vccd1 _2849_/Q sky130_fd_sc_hd__dfxtp_2
XTAP_TAPCELL_ROW_5_177 vssd1 vccd1 sky130_fd_sc_hd__tapvpwrvgnd_1
XANTENNA__2165__S _2168_/S vssd1 vssd1 vccd1 vccd1 sky130_fd_sc_hd__diode_2
XFILLER_53_54 vssd1 vssd1 vccd1 vccd1 sky130_fd_sc_hd__fill_2
XTAP_TAPCELL_ROW_56_533 vssd1 vccd1 sky130_fd_sc_hd__tapvpwrvgnd_1
Xclkbuf_leaf_21_clk clkload0/A vssd1 vssd1 vccd1 vccd1 _2804_/CLK sky130_fd_sc_hd__clkbuf_8
XANTENNA__1752__B _2558_/Q vssd1 vssd1 vccd1 vccd1 sky130_fd_sc_hd__diode_2
XANTENNA__2637__Q _2637_/Q vssd1 vssd1 vccd1 vccd1 sky130_fd_sc_hd__diode_2
Xclkbuf_leaf_12_clk clkbuf_leaf_5_clk/A vssd1 vssd1 vccd1 vccd1 _2671_/CLK sky130_fd_sc_hd__clkbuf_8
XANTENNA__1943__A _1944_/A vssd1 vssd1 vccd1 vccd1 sky130_fd_sc_hd__diode_2
X_1516_ _2818_/Q _2827_/Q _2828_/Q vssd1 vssd1 vccd1 vccd1 _1517_/D sky130_fd_sc_hd__or3_2
X_2703_ _2768_/CLK _2703_/D fanout141/X vssd1 vssd1 vccd1 vccd1 _2703_/Q sky130_fd_sc_hd__dfrtp_2
X_2634_ clkload8/A _2634_/D load_slew127/X vssd1 vssd1 vccd1 vccd1 _2634_/Q sky130_fd_sc_hd__dfrtp_2
X_2565_ _2663_/CLK _2565_/D vssd1 vssd1 vccd1 vccd1 _2565_/Q sky130_fd_sc_hd__dfxtp_2
XANTENNA__1750__A1 _2618_/Q vssd1 vssd1 vccd1 vccd1 sky130_fd_sc_hd__diode_2
XANTENNA_clkbuf_3_3__f_clk_X clkbuf_leaf_5_clk/A vssd1 vssd1 vccd1 vccd1 sky130_fd_sc_hd__diode_2
X_1378_ _1652_/A _1263_/Y _1822_/A _1863_/C vssd1 vssd1 vccd1 vccd1 _1378_/X sky130_fd_sc_hd__a31o_2
X_1447_ _2906_/Q _1448_/B vssd1 vssd1 vccd1 vccd1 _1447_/X sky130_fd_sc_hd__or2_2
X_2496_ _2498_/C _2496_/B vssd1 vssd1 vccd1 vccd1 _2855_/D sky130_fd_sc_hd__nor2_2
XTAP_TAPCELL_ROW_53_514 vssd1 vccd1 sky130_fd_sc_hd__tapvpwrvgnd_1
XANTENNA__1572__B _2643_/Q vssd1 vssd1 vccd1 vccd1 sky130_fd_sc_hd__diode_2
XFILLER_48_43 vssd1 vssd1 vccd1 vccd1 sky130_fd_sc_hd__fill_1
XANTENNA_fanout69_X _2282_/A2 vssd1 vssd1 vccd1 vccd1 sky130_fd_sc_hd__diode_2
XFILLER_58_195 vssd1 vssd1 vccd1 vccd1 sky130_fd_sc_hd__fill_1
XTAP_TAPCELL_ROW_16_249 vssd1 vccd1 sky130_fd_sc_hd__tapvpwrvgnd_1
Xfanout91 fanout93/X vssd1 vssd1 vccd1 vccd1 _1662_/C sky130_fd_sc_hd__clkdlybuf4s25_1
Xfanout80 fanout84/X vssd1 vssd1 vccd1 vccd1 _2495_/B2 sky130_fd_sc_hd__clkdlybuf4s25_1
XFILLER_37_324 vssd1 vssd1 vccd1 vccd1 sky130_fd_sc_hd__fill_1
XFILLER_49_151 vssd1 vssd1 vccd1 vccd1 sky130_fd_sc_hd__fill_2
X_1301_ _2797_/Q _1330_/B vssd1 vssd1 vccd1 vccd1 _1333_/B sky130_fd_sc_hd__nand2_2
Xclkbuf_leaf_1_clk clkbuf_leaf_3_clk/A vssd1 vssd1 vccd1 vccd1 _2865_/CLK sky130_fd_sc_hd__clkbuf_8
X_2350_ hold519/X _2472_/A _2348_/Y _2333_/B vssd1 vssd1 vccd1 vccd1 _2811_/D sky130_fd_sc_hd__a22o_2
X_2281_ _2281_/A _2281_/B vssd1 vssd1 vccd1 vccd1 _2281_/Y sky130_fd_sc_hd__xnor2_2
X_1996_ _1996_/A _2007_/A vssd1 vssd1 vccd1 vccd1 _1999_/A sky130_fd_sc_hd__nand2_2
X_2617_ clkload2/A _2617_/D fanout105/X vssd1 vssd1 vccd1 vccd1 _2617_/Q sky130_fd_sc_hd__dfrtp_2
X_2548_ _2694_/CLK _2548_/D fanout104/X vssd1 vssd1 vccd1 vccd1 _2548_/Q sky130_fd_sc_hd__dfrtp_2
XFILLER_18_68 vssd1 vssd1 vccd1 vccd1 sky130_fd_sc_hd__fill_4
XFILLER_28_324 vssd1 vssd1 vccd1 vccd1 sky130_fd_sc_hd__fill_1
X_2479_ _2847_/Q _2848_/Q wire48/X _2849_/Q vssd1 vssd1 vccd1 vccd1 _2480_/B sky130_fd_sc_hd__a31o_2
XFILLER_51_393 vssd1 vssd1 vccd1 vccd1 sky130_fd_sc_hd__fill_1
XTAP_TAPCELL_ROW_21_285 vssd1 vccd1 sky130_fd_sc_hd__tapvpwrvgnd_1
Xclkload0 clkload0/A vssd1 vssd1 vccd1 vccd1 clkload0/X sky130_fd_sc_hd__clkbuf_8
XANTENNA__1714__A1 _2643_/Q vssd1 vssd1 vccd1 vccd1 sky130_fd_sc_hd__diode_2
XFILLER_46_143 vssd1 vssd1 vccd1 vccd1 sky130_fd_sc_hd__fill_1
XTAP_TAPCELL_ROW_29_341 vssd1 vccd1 sky130_fd_sc_hd__tapvpwrvgnd_1
X_1781_ _1810_/A1 _2656_/Q _1786_/B1 _2705_/Q _1819_/B2 vssd1 vssd1 vccd1 vccd1 _1781_/X
+ sky130_fd_sc_hd__a221o_2
X_1850_ _2873_/Q _1821_/X _1382_/Y vssd1 vssd1 vccd1 vccd1 _1850_/X sky130_fd_sc_hd__o21a_2
XANTENNA__1705__A1 _2638_/Q vssd1 vssd1 vccd1 vccd1 sky130_fd_sc_hd__diode_2
XFILLER_6_261 vssd1 vssd1 vccd1 vccd1 sky130_fd_sc_hd__fill_4
X_2402_ _2402_/A _2406_/B vssd1 vssd1 vccd1 vccd1 _2826_/D sky130_fd_sc_hd__xor2_2
X_2333_ _2916_/Q _2333_/B vssd1 vssd1 vccd1 vccd1 _2333_/Y sky130_fd_sc_hd__nand2_2
X_2264_ _2254_/Y _2259_/B _2256_/B vssd1 vssd1 vccd1 vccd1 _2265_/B sky130_fd_sc_hd__o21a_2
X_2195_ _2195_/A _2195_/B _2202_/A vssd1 vssd1 vccd1 vccd1 _2195_/X sky130_fd_sc_hd__or3_2
XFILLER_52_179 vssd1 vssd1 vccd1 vccd1 sky130_fd_sc_hd__fill_1
XTAP_TAPCELL_ROW_35_388 vssd1 vccd1 sky130_fd_sc_hd__tapvpwrvgnd_1
XANTENNA__2197__A1 _1351_/A vssd1 vssd1 vccd1 vccd1 sky130_fd_sc_hd__diode_2
XANTENNA__2197__B2 _2260_/A2 vssd1 vssd1 vccd1 vccd1 sky130_fd_sc_hd__diode_2
X_1979_ _1979_/A _1979_/B vssd1 vssd1 vccd1 vccd1 _2043_/A sky130_fd_sc_hd__nor2_2
XFILLER_43_113 vssd1 vssd1 vccd1 vccd1 sky130_fd_sc_hd__fill_1
XTAP_TAPCELL_ROW_26_322 vssd1 vccd1 sky130_fd_sc_hd__tapvpwrvgnd_1
XFILLER_61_76 vssd1 vssd1 vccd1 vccd1 sky130_fd_sc_hd__fill_2
XFILLER_3_297 vssd1 vssd1 vccd1 vccd1 sky130_fd_sc_hd__fill_1
XANTENNA__1871__B1 _1851_/Y vssd1 vssd1 vccd1 vccd1 sky130_fd_sc_hd__diode_2
XANTENNA__2083__S _2882_/D vssd1 vssd1 vccd1 vccd1 sky130_fd_sc_hd__diode_2
XANTENNA__2645__Q _2645_/Q vssd1 vssd1 vccd1 vccd1 sky130_fd_sc_hd__diode_2
X_1902_ _2645_/Q _1909_/S _1900_/X _1901_/X vssd1 vssd1 vccd1 vccd1 _2645_/D sky130_fd_sc_hd__o22a_2
XANTENNA_clkbuf_0_clk_A clk vssd1 vssd1 vccd1 vccd1 sky130_fd_sc_hd__diode_2
X_1764_ _1384_/A _2653_/Q _1786_/B1 _2702_/Q vssd1 vssd1 vccd1 vccd1 _1764_/X sky130_fd_sc_hd__a22o_2
X_1833_ _1828_/Y _1830_/Y _1831_/C vssd1 vssd1 vccd1 vccd1 _1834_/C sky130_fd_sc_hd__o21ai_2
Xhold504 _2673_/Q vssd1 vssd1 vccd1 vccd1 hold504/X sky130_fd_sc_hd__dlygate4sd3_1
Xhold515 _2915_/Q vssd1 vssd1 vccd1 vccd1 hold515/X sky130_fd_sc_hd__dlygate4sd3_1
Xhold526 _2907_/Q vssd1 vssd1 vccd1 vccd1 hold526/X sky130_fd_sc_hd__dlygate4sd3_1
X_2882_ _2883_/CLK _2882_/D fanout99/A vssd1 vssd1 vccd1 vccd1 _2882_/Q sky130_fd_sc_hd__dfrtp_2
X_1695_ hold353/X _2559_/Q _1695_/S vssd1 vssd1 vccd1 vccd1 _1695_/X sky130_fd_sc_hd__mux2_1
Xhold537 _2652_/Q vssd1 vssd1 vccd1 vccd1 hold537/X sky130_fd_sc_hd__dlygate4sd3_1
Xhold548 _2659_/Q vssd1 vssd1 vccd1 vccd1 hold548/X sky130_fd_sc_hd__dlygate4sd3_1
X_2316_ _2323_/A1 hold372/X _2323_/B1 hold375/X vssd1 vssd1 vccd1 vccd1 _2792_/D sky130_fd_sc_hd__a22o_2
XANTENNA__2555__Q _2555_/Q vssd1 vssd1 vccd1 vccd1 sky130_fd_sc_hd__diode_2
XANTENNA_fanout183_A _2154_/S vssd1 vssd1 vccd1 vccd1 sky130_fd_sc_hd__diode_2
X_2247_ hold427/X _2260_/A2 _2246_/Y _2155_/A vssd1 vssd1 vccd1 vccd1 _2753_/D sky130_fd_sc_hd__a22o_2
X_2178_ hold360/X hold291/X _2180_/S vssd1 vssd1 vccd1 vccd1 _2734_/D sky130_fd_sc_hd__mux2_1
XFILLER_40_149 vssd1 vssd1 vccd1 vccd1 sky130_fd_sc_hd__fill_1
XTAP_TAPCELL_ROW_23_303 vssd1 vccd1 sky130_fd_sc_hd__tapvpwrvgnd_1
XANTENNA_fanout96_A fanout99/X vssd1 vssd1 vccd1 vccd1 sky130_fd_sc_hd__diode_2
XFILLER_31_79 vssd1 vssd1 vccd1 vccd1 sky130_fd_sc_hd__fill_2
Xoutput24 _2969_/X vssd1 vssd1 vccd1 vccd1 gpio_out[27] sky130_fd_sc_hd__clkdlybuf4s25_1
Xoutput13 _2545_/Q vssd1 vssd1 vccd1 vccd1 gpio_out[16] sky130_fd_sc_hd__clkdlybuf4s25_1
XANTENNA__1580__B _2647_/Q vssd1 vssd1 vccd1 vccd1 sky130_fd_sc_hd__diode_2
XANTENNA__2168__S _2168_/S vssd1 vssd1 vccd1 vccd1 sky130_fd_sc_hd__diode_2
XFILLER_0_223 vssd1 vssd1 vccd1 vccd1 sky130_fd_sc_hd__fill_1
XFILLER_0_278 vssd1 vssd1 vccd1 vccd1 sky130_fd_sc_hd__fill_2
XANTENNA_clkbuf_leaf_2_clk_A clkbuf_leaf_9_clk/A vssd1 vssd1 vccd1 vccd1 sky130_fd_sc_hd__diode_2
XPHY_EDGE_ROW_19_Right_19 vssd1 vssd1 vccd1 vccd1 sky130_fd_sc_hd__decap_3
XANTENNA__1908__B2 _1863_/C vssd1 vssd1 vccd1 vccd1 sky130_fd_sc_hd__diode_2
XFILLER_12_363 vssd1 vssd1 vccd1 vccd1 sky130_fd_sc_hd__fill_1
Xclkbuf_3_1__f_clk clkbuf_0_clk/X vssd1 vssd1 vccd1 vccd1 clkbuf_leaf_4_clk/A sky130_fd_sc_hd__clkbuf_16
XPHY_EDGE_ROW_28_Right_28 vssd1 vssd1 vccd1 vccd1 sky130_fd_sc_hd__decap_3
X_1480_ _1480_/A _1480_/B vssd1 vssd1 vccd1 vccd1 _1480_/Y sky130_fd_sc_hd__nor2_2
XPHY_EDGE_ROW_37_Right_37 vssd1 vssd1 vccd1 vccd1 sky130_fd_sc_hd__decap_3
X_2101_ hold505/X _2100_/X _2125_/S vssd1 vssd1 vccd1 vccd1 _2677_/D sky130_fd_sc_hd__mux2_1
X_2032_ _2032_/A _2032_/B vssd1 vssd1 vccd1 vccd1 _2041_/C sky130_fd_sc_hd__xnor2_2
X_2865_ _2865_/CLK _2865_/D vssd1 vssd1 vccd1 vccd1 _2865_/Q sky130_fd_sc_hd__dfxtp_2
XPHY_EDGE_ROW_46_Right_46 vssd1 vssd1 vccd1 vccd1 sky130_fd_sc_hd__decap_3
X_1678_ hold475/X _2631_/Q _1695_/S vssd1 vssd1 vccd1 vccd1 _1678_/X sky130_fd_sc_hd__mux2_1
X_1747_ _1739_/C _1741_/B _1744_/X _1745_/Y vssd1 vssd1 vccd1 vccd1 _1747_/Y sky130_fd_sc_hd__a211oi_2
X_1816_ _2631_/Q _1816_/B vssd1 vssd1 vccd1 vccd1 _1816_/Y sky130_fd_sc_hd__nand2_2
Xhold301 _2723_/Q vssd1 vssd1 vccd1 vccd1 hold301/X sky130_fd_sc_hd__dlygate4sd3_1
Xhold312 _2567_/Q vssd1 vssd1 vccd1 vccd1 hold312/X sky130_fd_sc_hd__dlygate4sd3_1
Xhold323 _2499_/Y vssd1 vssd1 vccd1 vccd1 _2500_/B sky130_fd_sc_hd__dlygate4sd3_1
Xhold334 _2529_/Q vssd1 vssd1 vccd1 vccd1 hold334/X sky130_fd_sc_hd__dlygate4sd3_1
Xhold345 _2572_/Q vssd1 vssd1 vccd1 vccd1 hold345/X sky130_fd_sc_hd__dlygate4sd3_1
Xhold356 _2730_/Q vssd1 vssd1 vccd1 vccd1 hold356/X sky130_fd_sc_hd__dlygate4sd3_1
Xhold367 _2733_/Q vssd1 vssd1 vccd1 vccd1 hold367/X sky130_fd_sc_hd__dlygate4sd3_1
Xhold378 _2738_/Q vssd1 vssd1 vccd1 vccd1 hold378/X sky130_fd_sc_hd__dlygate4sd3_1
X_2796_ _2902_/CLK _2796_/D fanout117/X vssd1 vssd1 vccd1 vccd1 _2796_/Q sky130_fd_sc_hd__dfrtp_2
XPHY_EDGE_ROW_55_Right_55 vssd1 vssd1 vccd1 vccd1 sky130_fd_sc_hd__decap_3
Xhold389 _2757_/Q vssd1 vssd1 vccd1 vccd1 hold389/X sky130_fd_sc_hd__dlygate4sd3_1
XFILLER_5_337 vssd1 vssd1 vccd1 vccd1 sky130_fd_sc_hd__fill_1
XPHY_EDGE_ROW_39_Left_104 vssd1 vssd1 vccd1 vccd1 sky130_fd_sc_hd__decap_3
XPHY_EDGE_ROW_64_Right_64 vssd1 vssd1 vccd1 vccd1 sky130_fd_sc_hd__decap_3
XTAP_TAPCELL_ROW_51_497 vssd1 vccd1 sky130_fd_sc_hd__tapvpwrvgnd_1
XANTENNA_fanout99_X fanout99/X vssd1 vssd1 vccd1 vccd1 sky130_fd_sc_hd__diode_2
XPHY_EDGE_ROW_48_Left_113 vssd1 vssd1 vccd1 vccd1 sky130_fd_sc_hd__decap_3
XTAP_TAPCELL_ROW_59_553 vssd1 vccd1 sky130_fd_sc_hd__tapvpwrvgnd_1
XTAP_TAPCELL_ROW_8_197 vssd1 vccd1 sky130_fd_sc_hd__tapvpwrvgnd_1
XTAP_TAPCELL_ROW_42_431 vssd1 vccd1 sky130_fd_sc_hd__tapvpwrvgnd_1
XPHY_EDGE_ROW_57_Left_122 vssd1 vssd1 vccd1 vccd1 sky130_fd_sc_hd__decap_3
X_1532_ _2442_/A _2442_/B _2442_/C vssd1 vssd1 vccd1 vccd1 _1539_/B sky130_fd_sc_hd__nand3_2
X_1601_ _2636_/Q _1702_/S _1385_/B _2700_/Q _1600_/X vssd1 vssd1 vccd1 vccd1 _1601_/X
+ sky130_fd_sc_hd__a221o_2
X_2650_ _2663_/CLK _2650_/D load_slew101/X vssd1 vssd1 vccd1 vccd1 _2650_/Q sky130_fd_sc_hd__dfrtp_2
X_2581_ clkload5/A _2581_/D vssd1 vssd1 vccd1 vccd1 _2581_/Q sky130_fd_sc_hd__dfxtp_2
X_1394_ _2814_/Q _2969_/A _2330_/A vssd1 vssd1 vccd1 vccd1 _1394_/X sky130_fd_sc_hd__a21o_2
X_1463_ _1477_/A1 _1461_/Y _1462_/X _1477_/B1 _2910_/Q vssd1 vssd1 vccd1 vccd1 _2910_/D
+ sky130_fd_sc_hd__a32o_2
XFILLER_23_403 vssd1 vssd1 vccd1 vccd1 sky130_fd_sc_hd__fill_4
XFILLER_50_211 vssd1 vssd1 vccd1 vccd1 sky130_fd_sc_hd__fill_2
XFILLER_50_233 vssd1 vssd1 vccd1 vccd1 sky130_fd_sc_hd__fill_1
X_2015_ _2015_/A _2015_/B vssd1 vssd1 vccd1 vccd1 _2018_/C sky130_fd_sc_hd__xnor2_2
XFILLER_10_108 vssd1 vssd1 vccd1 vccd1 sky130_fd_sc_hd__fill_2
XFILLER_10_119 vssd1 vssd1 vccd1 vccd1 sky130_fd_sc_hd__fill_1
XFILLER_12_37 vssd1 vssd1 vccd1 vccd1 sky130_fd_sc_hd__fill_1
X_2917_ _2923_/CLK _2917_/D fanout109/X vssd1 vssd1 vccd1 vccd1 _2917_/Q sky130_fd_sc_hd__dfstp_2
X_2848_ _2884_/CLK _2848_/D vssd1 vssd1 vccd1 vccd1 _2848_/Q sky130_fd_sc_hd__dfxtp_2
XFILLER_2_307 vssd1 vssd1 vccd1 vccd1 sky130_fd_sc_hd__fill_1
X_2779_ _2902_/CLK _2779_/D fanout117/A vssd1 vssd1 vccd1 vccd1 _2779_/Q sky130_fd_sc_hd__dfrtp_2
XTAP_TAPCELL_ROW_56_534 vssd1 vccd1 sky130_fd_sc_hd__tapvpwrvgnd_1
XTAP_TAPCELL_ROW_5_178 vssd1 vccd1 sky130_fd_sc_hd__tapvpwrvgnd_1
XANTENNA__2091__S _2882_/D vssd1 vssd1 vccd1 vccd1 sky130_fd_sc_hd__diode_2
XFILLER_20_406 vssd1 vssd1 vccd1 vccd1 sky130_fd_sc_hd__fill_1
XFILLER_32_277 vssd1 vssd1 vccd1 vccd1 sky130_fd_sc_hd__fill_2
X_2702_ _2719_/CLK _2702_/D load_slew134/X vssd1 vssd1 vccd1 vccd1 _2702_/Q sky130_fd_sc_hd__dfrtp_2
X_1515_ _1515_/A _1515_/B vssd1 vssd1 vccd1 vccd1 _2442_/A sky130_fd_sc_hd__or2_2
X_2633_ clkload8/A _2633_/D fanout126/X vssd1 vssd1 vccd1 vccd1 _2633_/Q sky130_fd_sc_hd__dfrtp_2
X_2564_ _2688_/CLK _2564_/D vssd1 vssd1 vccd1 vccd1 _2564_/Q sky130_fd_sc_hd__dfxtp_2
X_2495_ _2855_/Q _2491_/A _2410_/A _2495_/B2 vssd1 vssd1 vccd1 vccd1 _2496_/B sky130_fd_sc_hd__a2bb2o_2
X_1377_ _2812_/Q _2811_/Q _2871_/Q vssd1 vssd1 vccd1 vccd1 _1661_/S sky130_fd_sc_hd__o21ai_2
X_1446_ _1450_/A1 _1443_/X _1445_/Y _1450_/B1 hold452/X vssd1 vssd1 vccd1 vccd1 _2905_/D
+ sky130_fd_sc_hd__a32o_2
XFILLER_11_406 vssd1 vssd1 vccd1 vccd1 sky130_fd_sc_hd__fill_1
XFILLER_23_14 vssd1 vssd1 vccd1 vccd1 sky130_fd_sc_hd__fill_2
XFILLER_63_391 vssd1 vssd1 vccd1 vccd1 sky130_fd_sc_hd__fill_1
XTAP_TAPCELL_ROW_61_570 vssd1 vccd1 sky130_fd_sc_hd__tapvpwrvgnd_1
Xfanout92 fanout93/X vssd1 vssd1 vccd1 vccd1 fanout92/X sky130_fd_sc_hd__clkdlybuf4s25_1
Xfanout70 _1734_/Y vssd1 vssd1 vccd1 vccd1 _1786_/B1 sky130_fd_sc_hd__clkdlybuf4s25_1
XPHY_EDGE_ROW_24_Left_89 vssd1 vssd1 vccd1 vccd1 sky130_fd_sc_hd__decap_3
XANTENNA__1732__A2 _2555_/Q vssd1 vssd1 vccd1 vccd1 sky130_fd_sc_hd__diode_2
X_1300_ _2796_/Q _1327_/B vssd1 vssd1 vccd1 vccd1 _1330_/B sky130_fd_sc_hd__and2_2
X_2280_ _2276_/A _2276_/C _2276_/B vssd1 vssd1 vccd1 vccd1 _2281_/B sky130_fd_sc_hd__o21ba_2
X_1995_ _1992_/A _1995_/B vssd1 vssd1 vccd1 vccd1 _2007_/A sky130_fd_sc_hd__nand2b_2
X_2616_ clkload2/A _2616_/D _1662_/C vssd1 vssd1 vccd1 vccd1 _2616_/Q sky130_fd_sc_hd__dfrtp_2
XANTENNA__2558__Q _2558_/Q vssd1 vssd1 vccd1 vccd1 sky130_fd_sc_hd__diode_2
X_1429_ _2901_/Q _1437_/D vssd1 vssd1 vccd1 vccd1 _1429_/X sky130_fd_sc_hd__or2_2
X_2547_ clkload6/A _2547_/D load_slew103/X vssd1 vssd1 vccd1 vccd1 _2547_/Q sky130_fd_sc_hd__dfrtp_2
X_2478_ _2847_/Q _2848_/Q _2849_/Q wire48/X vssd1 vssd1 vccd1 vccd1 _2486_/D sky130_fd_sc_hd__and4_2
XFILLER_28_303 vssd1 vssd1 vccd1 vccd1 sky130_fd_sc_hd__fill_4
Xclkload1 clkload1/A vssd1 vssd1 vccd1 vccd1 clkload1/X sky130_fd_sc_hd__clkbuf_4
XFILLER_1_3 vssd1 vssd1 vccd1 vccd1 sky130_fd_sc_hd__fill_2
XFILLER_59_43 vssd1 vssd1 vccd1 vccd1 sky130_fd_sc_hd__fill_1
XTAP_TAPCELL_ROW_21_286 vssd1 vccd1 sky130_fd_sc_hd__tapvpwrvgnd_1
XFILLER_61_136 vssd1 vssd1 vccd1 vccd1 sky130_fd_sc_hd__fill_2
XTAP_TAPCELL_ROW_29_342 vssd1 vccd1 sky130_fd_sc_hd__tapvpwrvgnd_1
X_1780_ _1780_/A _1780_/B vssd1 vssd1 vccd1 vccd1 _1780_/Y sky130_fd_sc_hd__nor2_2
X_2401_ hold535/X _2399_/B _2406_/B vssd1 vssd1 vccd1 vccd1 _2825_/D sky130_fd_sc_hd__o21ba_2
X_2332_ _2917_/Q _2332_/B vssd1 vssd1 vccd1 vccd1 _2332_/X sky130_fd_sc_hd__or2_2
XANTENNA__1469__A1 _2969_/A vssd1 vssd1 vccd1 vccd1 sky130_fd_sc_hd__diode_2
XFILLER_25_339 vssd1 vssd1 vccd1 vccd1 sky130_fd_sc_hd__fill_1
X_2263_ _2261_/Y _2263_/B vssd1 vssd1 vccd1 vccd1 _2265_/A sky130_fd_sc_hd__nand2b_2
X_2194_ _2761_/Q _2715_/Q vssd1 vssd1 vccd1 vccd1 _2202_/A sky130_fd_sc_hd__nor2_2
X_1978_ _1937_/Y _1976_/A _1976_/B _2031_/B _2036_/B vssd1 vssd1 vccd1 vccd1 _1979_/B
+ sky130_fd_sc_hd__o311a_2
XFILLER_29_57 vssd1 vssd1 vccd1 vccd1 sky130_fd_sc_hd__fill_1
XFILLER_28_188 vssd1 vssd1 vccd1 vccd1 sky130_fd_sc_hd__fill_2
XTAP_TAPCELL_ROW_26_323 vssd1 vccd1 sky130_fd_sc_hd__tapvpwrvgnd_1
XANTENNA__1578__B _2646_/Q vssd1 vssd1 vccd1 vccd1 sky130_fd_sc_hd__diode_2
XFILLER_3_276 vssd1 vssd1 vccd1 vccd1 sky130_fd_sc_hd__fill_1
XANTENNA__1623__A1 _2642_/Q vssd1 vssd1 vccd1 vccd1 sky130_fd_sc_hd__diode_2
XANTENNA__1871__A1 _2637_/Q vssd1 vssd1 vccd1 vccd1 sky130_fd_sc_hd__diode_2
X_1832_ _1832_/A vssd1 vssd1 vccd1 vccd1 _1832_/Y sky130_fd_sc_hd__inv_2
X_1901_ _2709_/Q _1908_/A2 _1851_/Y vssd1 vssd1 vccd1 vccd1 _1901_/X sky130_fd_sc_hd__a21o_2
X_2881_ _2884_/CLK _2881_/D _2510_/B2 vssd1 vssd1 vccd1 vccd1 _2881_/Q sky130_fd_sc_hd__dfstp_2
XANTENNA__1387__B1 _2071_/B vssd1 vssd1 vccd1 vccd1 sky130_fd_sc_hd__diode_2
X_1694_ hold364/X _2632_/Q _1695_/S vssd1 vssd1 vccd1 vccd1 _2593_/D sky130_fd_sc_hd__mux2_1
X_1763_ _1819_/B2 _1759_/X _1762_/X _1760_/X hold451/X vssd1 vssd1 vccd1 vccd1 _2620_/D
+ sky130_fd_sc_hd__o32a_2
Xhold505 _2677_/Q vssd1 vssd1 vccd1 vccd1 hold505/X sky130_fd_sc_hd__dlygate4sd3_1
Xhold516 _2655_/Q vssd1 vssd1 vccd1 vccd1 hold516/X sky130_fd_sc_hd__dlygate4sd3_1
Xhold527 _2899_/Q vssd1 vssd1 vccd1 vccd1 hold527/X sky130_fd_sc_hd__dlygate4sd3_1
Xhold538 _2621_/Q vssd1 vssd1 vccd1 vccd1 hold538/X sky130_fd_sc_hd__dlygate4sd3_1
Xhold549 _2810_/Q vssd1 vssd1 vccd1 vccd1 hold549/X sky130_fd_sc_hd__dlygate4sd3_1
XPHY_EDGE_ROW_27_Left_92 vssd1 vssd1 vccd1 vccd1 sky130_fd_sc_hd__decap_3
X_2315_ _2323_/A1 _2299_/A _2323_/B1 hold445/X vssd1 vssd1 vccd1 vccd1 _2791_/D sky130_fd_sc_hd__a22o_2
X_2246_ _2246_/A _2246_/B vssd1 vssd1 vccd1 vccd1 _2246_/Y sky130_fd_sc_hd__xnor2_2
XANTENNA_fanout176_A _2870_/Q vssd1 vssd1 vccd1 vccd1 sky130_fd_sc_hd__diode_2
XPHY_EDGE_ROW_11_Left_76 vssd1 vssd1 vccd1 vccd1 sky130_fd_sc_hd__decap_3
XTAP_TAPCELL_ROW_23_304 vssd1 vccd1 sky130_fd_sc_hd__tapvpwrvgnd_1
X_2177_ hold367/X hold300/X _2180_/S vssd1 vssd1 vccd1 vccd1 _2733_/D sky130_fd_sc_hd__mux2_1
XANTENNA__1378__B1 _1863_/C vssd1 vssd1 vccd1 vccd1 sky130_fd_sc_hd__diode_2
XANTENNA__1614__A1 _2640_/Q vssd1 vssd1 vccd1 vccd1 sky130_fd_sc_hd__diode_2
XFILLER_40_139 vssd1 vssd1 vccd1 vccd1 sky130_fd_sc_hd__fill_1
Xoutput25 _2970_/X vssd1 vssd1 vccd1 vccd1 gpio_out[28] sky130_fd_sc_hd__clkdlybuf4s25_1
Xoutput14 _2546_/Q vssd1 vssd1 vccd1 vccd1 gpio_out[17] sky130_fd_sc_hd__clkdlybuf4s25_1
XANTENNA__1580__C _1723_/S vssd1 vssd1 vccd1 vccd1 sky130_fd_sc_hd__diode_2
XANTENNA__1605__B2 _1589_/X vssd1 vssd1 vccd1 vccd1 sky130_fd_sc_hd__diode_2
XANTENNA__1853__A1 _1863_/C vssd1 vssd1 vccd1 vccd1 sky130_fd_sc_hd__diode_2
XFILLER_24_191 vssd1 vssd1 vccd1 vccd1 sky130_fd_sc_hd__fill_1
X_2100_ _2590_/Q _2574_/Q _2130_/S vssd1 vssd1 vccd1 vccd1 _2100_/X sky130_fd_sc_hd__mux2_1
XFILLER_47_272 vssd1 vssd1 vccd1 vccd1 sky130_fd_sc_hd__fill_1
XFILLER_62_253 vssd1 vssd1 vccd1 vccd1 sky130_fd_sc_hd__fill_1
X_2031_ _1937_/Y _2031_/B vssd1 vssd1 vccd1 vccd1 _2032_/B sky130_fd_sc_hd__nand2b_2
XFILLER_15_180 vssd1 vssd1 vccd1 vccd1 sky130_fd_sc_hd__fill_2
X_1815_ _2631_/Q _1816_/B vssd1 vssd1 vccd1 vccd1 _1815_/X sky130_fd_sc_hd__or2_2
X_2864_ _2865_/CLK _2864_/D vssd1 vssd1 vccd1 vccd1 _2864_/Q sky130_fd_sc_hd__dfxtp_2
X_2795_ _2902_/CLK _2795_/D fanout117/X vssd1 vssd1 vccd1 vccd1 _2795_/Q sky130_fd_sc_hd__dfrtp_2
XFILLER_7_93 vssd1 vccd1 vssd1 vccd1 sky130_ef_sc_hd__decap_40_12
X_1677_ hold292/X _2630_/Q _1691_/S vssd1 vssd1 vccd1 vccd1 _2576_/D sky130_fd_sc_hd__mux2_1
X_1746_ _1744_/X _1745_/Y _1739_/C _1741_/B vssd1 vssd1 vccd1 vccd1 _1748_/C sky130_fd_sc_hd__o211ai_2
Xhold302 _2528_/Q vssd1 vssd1 vccd1 vccd1 hold302/X sky130_fd_sc_hd__dlygate4sd3_1
Xhold313 _2531_/Q vssd1 vssd1 vccd1 vccd1 hold313/X sky130_fd_sc_hd__dlygate4sd3_1
Xhold324 _2724_/Q vssd1 vssd1 vccd1 vccd1 hold324/X sky130_fd_sc_hd__dlygate4sd3_1
Xhold335 _2570_/Q vssd1 vssd1 vccd1 vccd1 hold335/X sky130_fd_sc_hd__dlygate4sd3_1
Xhold346 _2569_/Q vssd1 vssd1 vccd1 vccd1 hold346/X sky130_fd_sc_hd__dlygate4sd3_1
Xhold357 _2536_/Q vssd1 vssd1 vccd1 vccd1 hold357/X sky130_fd_sc_hd__dlygate4sd3_1
Xhold368 _2740_/Q vssd1 vssd1 vccd1 vccd1 hold368/X sky130_fd_sc_hd__dlygate4sd3_1
Xhold379 _2786_/Q vssd1 vssd1 vccd1 vccd1 hold379/X sky130_fd_sc_hd__dlygate4sd3_1
XANTENNA_fanout179_X _2168_/S vssd1 vssd1 vccd1 vccd1 sky130_fd_sc_hd__diode_2
X_2229_ _2227_/Y _2229_/B vssd1 vssd1 vccd1 vccd1 _2232_/A sky130_fd_sc_hd__and2b_2
XANTENNA__1599__B1 _1624_/S vssd1 vssd1 vccd1 vccd1 sky130_fd_sc_hd__diode_2
XFILLER_26_36 vssd1 vssd1 vccd1 vccd1 sky130_fd_sc_hd__fill_4
XFILLER_38_283 vssd1 vssd1 vccd1 vccd1 sky130_fd_sc_hd__fill_1
XFILLER_42_24 vssd1 vssd1 vccd1 vccd1 sky130_fd_sc_hd__fill_4
XFILLER_53_220 vssd1 vssd1 vccd1 vccd1 sky130_fd_sc_hd__fill_4
XFILLER_53_275 vssd1 vssd1 vccd1 vccd1 sky130_fd_sc_hd__fill_1
XFILLER_53_286 vssd1 vssd1 vccd1 vccd1 sky130_fd_sc_hd__fill_1
XTAP_TAPCELL_ROW_51_498 vssd1 vccd1 sky130_fd_sc_hd__tapvpwrvgnd_1
XTAP_TAPCELL_ROW_8_198 vssd1 vccd1 sky130_fd_sc_hd__tapvpwrvgnd_1
XFILLER_44_220 vssd1 vssd1 vccd1 vccd1 sky130_fd_sc_hd__fill_1
XFILLER_44_253 vssd1 vssd1 vccd1 vccd1 sky130_fd_sc_hd__fill_1
XTAP_TAPCELL_ROW_59_554 vssd1 vccd1 sky130_fd_sc_hd__tapvpwrvgnd_1
XTAP_TAPCELL_ROW_42_432 vssd1 vccd1 sky130_fd_sc_hd__tapvpwrvgnd_1
X_1462_ _2910_/Q _1465_/C vssd1 vssd1 vccd1 vccd1 _1462_/X sky130_fd_sc_hd__or2_2
X_1531_ _1518_/X _2389_/D _1531_/C _1531_/D vssd1 vssd1 vccd1 vccd1 _2442_/C sky130_fd_sc_hd__and4b_2
X_1600_ _1734_/A _2651_/Q vssd1 vssd1 vccd1 vccd1 _1600_/X sky130_fd_sc_hd__and2_2
X_2580_ _2883_/CLK _2580_/D vssd1 vssd1 vccd1 vccd1 _2580_/Q sky130_fd_sc_hd__dfxtp_2
XANTENNA__2089__S _2125_/S vssd1 vssd1 vccd1 vccd1 sky130_fd_sc_hd__diode_2
X_1393_ hold420/X _1392_/X _1389_/Y vssd1 vssd1 vccd1 vccd1 _2885_/D sky130_fd_sc_hd__o21a_2
X_2014_ _1973_/A _2014_/B vssd1 vssd1 vccd1 vccd1 _2015_/B sky130_fd_sc_hd__and2b_2
X_2916_ _2916_/CLK _2916_/D _2335_/B1 vssd1 vssd1 vccd1 vccd1 _2916_/Q sky130_fd_sc_hd__dfrtp_2
X_2847_ _2884_/CLK _2847_/D vssd1 vssd1 vccd1 vccd1 _2847_/Q sky130_fd_sc_hd__dfxtp_2
X_2778_ clkload9/A _2778_/D fanout118/X vssd1 vssd1 vccd1 vccd1 _2778_/Q sky130_fd_sc_hd__dfrtp_2
XANTENNA_clkbuf_leaf_1_clk_A clkbuf_leaf_3_clk/A vssd1 vssd1 vccd1 vccd1 sky130_fd_sc_hd__diode_2
XFILLER_2_319 vssd1 vssd1 vccd1 vccd1 sky130_fd_sc_hd__fill_1
X_1729_ hold267/X _1549_/B _1725_/Y _2812_/Q vssd1 vssd1 vccd1 vccd1 _1729_/X sky130_fd_sc_hd__a22o_2
XFILLER_26_253 vssd1 vssd1 vccd1 vccd1 sky130_fd_sc_hd__fill_1
XFILLER_37_35 vssd1 vssd1 vccd1 vccd1 sky130_fd_sc_hd__fill_1
XTAP_TAPCELL_ROW_56_535 vssd1 vccd1 sky130_fd_sc_hd__tapvpwrvgnd_1
XTAP_TAPCELL_ROW_64_590 vssd1 vccd1 sky130_fd_sc_hd__tapvpwrvgnd_1
XFILLER_5_113 vssd1 vssd1 vccd1 vccd1 sky130_fd_sc_hd__fill_4
XFILLER_64_3 vssd1 vssd1 vccd1 vccd1 sky130_fd_sc_hd__fill_1
X_2701_ _2765_/CLK _2701_/D load_slew136/X vssd1 vssd1 vccd1 vccd1 _2701_/Q sky130_fd_sc_hd__dfrtp_2
X_2632_ _2924_/CLK _2632_/D fanout111/X vssd1 vssd1 vccd1 vccd1 _2632_/Q sky130_fd_sc_hd__dfrtp_2
XANTENNA__1662__D _1662_/D vssd1 vssd1 vccd1 vccd1 sky130_fd_sc_hd__diode_2
X_1445_ _1448_/B vssd1 vssd1 vccd1 vccd1 _1445_/Y sky130_fd_sc_hd__inv_2
X_1514_ _1499_/A _1499_/B _1539_/A _1512_/X _1513_/X vssd1 vssd1 vccd1 vccd1 _1515_/B
+ sky130_fd_sc_hd__o2111a_2
X_2563_ clkload2/A _2563_/D vssd1 vssd1 vccd1 vccd1 _2563_/Q sky130_fd_sc_hd__dfxtp_2
X_2494_ _2853_/Q _2854_/Q _2855_/Q _2494_/D vssd1 vssd1 vccd1 vccd1 _2498_/C sky130_fd_sc_hd__and4_2
X_1376_ _2812_/Q _2811_/Q vssd1 vssd1 vccd1 vccd1 _1812_/C sky130_fd_sc_hd__nor2_2
XFILLER_23_223 vssd1 vssd1 vccd1 vccd1 sky130_fd_sc_hd__fill_1
XFILLER_2_127 vssd1 vssd1 vccd1 vccd1 sky130_fd_sc_hd__fill_2
XFILLER_14_234 vssd1 vssd1 vccd1 vccd1 sky130_fd_sc_hd__fill_1
XFILLER_58_197 vssd1 vssd1 vccd1 vccd1 sky130_fd_sc_hd__fill_2
Xfanout93 fanout99/A vssd1 vssd1 vccd1 vccd1 fanout93/X sky130_fd_sc_hd__clkdlybuf4s25_1
Xfanout82 fanout84/X vssd1 vssd1 vccd1 vccd1 fanout82/X sky130_fd_sc_hd__clkdlybuf4s25_1
Xfanout71 _1734_/Y vssd1 vssd1 vccd1 vccd1 _1810_/B1 sky130_fd_sc_hd__clkdlybuf4s25_1
Xfanout60 _1820_/Y vssd1 vssd1 vccd1 vccd1 _1908_/A2 sky130_fd_sc_hd__clkdlybuf4s25_1
XFILLER_1_171 vssd1 vssd1 vccd1 vccd1 sky130_fd_sc_hd__fill_1
XFILLER_49_164 vssd1 vssd1 vccd1 vccd1 sky130_fd_sc_hd__fill_4
X_1994_ _2069_/B1 _1992_/X _1993_/Y _1991_/X vssd1 vssd1 vccd1 vccd1 _2649_/D sky130_fd_sc_hd__o31a_2
X_2615_ _2924_/CLK _2615_/D vssd1 vssd1 vccd1 vccd1 _2615_/Q sky130_fd_sc_hd__dfxtp_2
X_1428_ _1477_/A1 _1426_/Y _1427_/X _1477_/B1 hold390/X vssd1 vssd1 vccd1 vccd1 _2900_/D
+ sky130_fd_sc_hd__a32o_2
X_2546_ clkload6/A _2546_/D load_slew103/X vssd1 vssd1 vccd1 vccd1 _2546_/Q sky130_fd_sc_hd__dfrtp_2
X_2477_ _2477_/A _2477_/B vssd1 vssd1 vccd1 vccd1 _2477_/Y sky130_fd_sc_hd__xnor2_2
XANTENNA_fanout161_X _1863_/C vssd1 vssd1 vccd1 vccd1 sky130_fd_sc_hd__diode_2
XFILLER_55_145 vssd1 vssd1 vccd1 vccd1 sky130_fd_sc_hd__fill_4
X_1359_ _1359_/A _1359_/B vssd1 vssd1 vccd1 vccd1 _2883_/D sky130_fd_sc_hd__and2_2
XTAP_TAPCELL_ROW_21_287 vssd1 vccd1 sky130_fd_sc_hd__tapvpwrvgnd_1
Xclkload2 clkload2/A vssd1 vssd1 vccd1 vccd1 clkload2/X sky130_fd_sc_hd__clkbuf_8
XANTENNA__2187__S _2189_/S vssd1 vssd1 vccd1 vccd1 sky130_fd_sc_hd__diode_2
XFILLER_46_167 vssd1 vssd1 vccd1 vccd1 sky130_fd_sc_hd__fill_8
XTAP_TAPCELL_ROW_29_343 vssd1 vccd1 sky130_fd_sc_hd__tapvpwrvgnd_1
XANTENNA_clkbuf_3_4__f_clk_A clkbuf_0_clk/X vssd1 vssd1 vccd1 vccd1 sky130_fd_sc_hd__diode_2
XFILLER_46_178 vssd1 vssd1 vccd1 vccd1 sky130_fd_sc_hd__fill_2
XFILLER_6_296 vssd1 vssd1 vccd1 vccd1 sky130_fd_sc_hd__fill_2
XTAP_TAPCELL_ROW_12_221 vssd1 vccd1 sky130_fd_sc_hd__tapvpwrvgnd_1
X_2400_ _2822_/Q _2400_/B _2400_/C vssd1 vssd1 vccd1 vccd1 _2406_/B sky130_fd_sc_hd__and3_2
XANTENNA__2097__S _2125_/S vssd1 vssd1 vccd1 vccd1 sky130_fd_sc_hd__diode_2
X_2331_ _2331_/A _2331_/B vssd1 vssd1 vccd1 vccd1 _2340_/A sky130_fd_sc_hd__nand2_2
X_2262_ _2771_/Q _2725_/Q vssd1 vssd1 vccd1 vccd1 _2263_/B sky130_fd_sc_hd__nand2_2
XFILLER_25_318 vssd1 vssd1 vccd1 vccd1 sky130_fd_sc_hd__fill_1
XFILLER_52_126 vssd1 vssd1 vccd1 vccd1 sky130_fd_sc_hd__fill_2
X_2193_ _2761_/Q _2715_/Q vssd1 vssd1 vccd1 vccd1 _2195_/B sky130_fd_sc_hd__and2_2
X_1977_ _1937_/Y _1976_/A _1976_/B _2031_/B vssd1 vssd1 vccd1 vccd1 _2037_/A sky130_fd_sc_hd__o31a_2
XFILLER_20_16 vssd1 vssd1 vccd1 vccd1 sky130_fd_sc_hd__fill_2
X_2529_ _2719_/CLK _2529_/D vssd1 vssd1 vccd1 vccd1 _2529_/Q sky130_fd_sc_hd__dfxtp_2
XANTENNA__1578__C _1723_/S vssd1 vssd1 vccd1 vccd1 sky130_fd_sc_hd__diode_2
XFILLER_45_57 vssd1 vssd1 vccd1 vccd1 sky130_fd_sc_hd__fill_2
XTAP_TAPCELL_ROW_26_324 vssd1 vccd1 sky130_fd_sc_hd__tapvpwrvgnd_1
XFILLER_10_82 vssd1 vssd1 vccd1 vccd1 sky130_fd_sc_hd__fill_2
XFILLER_19_167 vssd1 vssd1 vccd1 vccd1 sky130_fd_sc_hd__fill_1
XFILLER_19_189 vssd1 vssd1 vccd1 vccd1 sky130_fd_sc_hd__fill_2
XFILLER_59_270 vssd1 vssd1 vccd1 vccd1 sky130_fd_sc_hd__fill_1
XFILLER_30_354 vssd1 vssd1 vccd1 vccd1 sky130_fd_sc_hd__fill_1
X_1831_ _1830_/Y _1831_/B _1831_/C vssd1 vssd1 vccd1 vccd1 _1832_/A sky130_fd_sc_hd__and3b_2
X_1900_ _1903_/B _1900_/B _1900_/C vssd1 vssd1 vccd1 vccd1 _1900_/X sky130_fd_sc_hd__and3b_2
X_2880_ _2880_/CLK _2880_/D fanout92/X vssd1 vssd1 vccd1 vccd1 _2880_/Q sky130_fd_sc_hd__dfrtp_2
X_1693_ hold305/X _2647_/Q _1693_/S vssd1 vssd1 vccd1 vccd1 _2592_/D sky130_fd_sc_hd__mux2_1
X_1762_ _1761_/X _1770_/C vssd1 vssd1 vccd1 vccd1 _1762_/X sky130_fd_sc_hd__and2b_2
Xhold506 _2880_/Q vssd1 vssd1 vccd1 vccd1 _1358_/B sky130_fd_sc_hd__dlygate4sd3_1
Xhold517 _2828_/Q vssd1 vssd1 vccd1 vccd1 hold517/X sky130_fd_sc_hd__dlygate4sd3_1
Xhold528 _2658_/Q vssd1 vssd1 vccd1 vccd1 hold528/X sky130_fd_sc_hd__dlygate4sd3_1
Xhold539 _2680_/Q vssd1 vssd1 vccd1 vccd1 hold539/X sky130_fd_sc_hd__dlygate4sd3_1
X_2314_ _2323_/A1 hold398/X _2323_/B1 _2790_/Q vssd1 vssd1 vccd1 vccd1 _2790_/D sky130_fd_sc_hd__a22o_2
X_2245_ _2245_/A _2245_/B vssd1 vssd1 vccd1 vccd1 _2246_/B sky130_fd_sc_hd__or2_2
X_2176_ hold369/X hold327/X _2180_/S vssd1 vssd1 vccd1 vccd1 _2732_/D sky130_fd_sc_hd__mux2_1
XTAP_TAPCELL_ROW_31_360 vssd1 vccd1 sky130_fd_sc_hd__tapvpwrvgnd_1
XANTENNA__2327__B1 _2156_/B vssd1 vssd1 vccd1 vccd1 sky130_fd_sc_hd__diode_2
XFILLER_0_225 vssd1 vccd1 vssd1 vccd1 sky130_ef_sc_hd__decap_40_12
XPHY_EDGE_ROW_1_Right_1 vssd1 vssd1 vccd1 vccd1 sky130_fd_sc_hd__decap_3
Xoutput26 _1538_/X vssd1 vssd1 vccd1 vccd1 gpio_out[4] sky130_fd_sc_hd__clkdlybuf4s25_1
Xoutput15 _2547_/Q vssd1 vssd1 vccd1 vccd1 gpio_out[18] sky130_fd_sc_hd__clkdlybuf4s25_1
X_2030_ _2041_/A _2041_/B vssd1 vssd1 vccd1 vccd1 _2030_/X sky130_fd_sc_hd__or2_2
XTAP_TAPCELL_ROW_45_452 vssd1 vccd1 sky130_fd_sc_hd__tapvpwrvgnd_1
X_1745_ _2618_/Q _2557_/Q vssd1 vssd1 vccd1 vccd1 _1745_/Y sky130_fd_sc_hd__nor2_2
X_1814_ _2871_/Q _1822_/B _1813_/X _1814_/B2 vssd1 vssd1 vccd1 vccd1 _1814_/X sky130_fd_sc_hd__o2bb2a_2
X_2863_ _2865_/CLK _2863_/D vssd1 vssd1 vccd1 vccd1 _2863_/Q sky130_fd_sc_hd__dfxtp_2
X_2794_ _2902_/CLK _2794_/D fanout115/X vssd1 vssd1 vccd1 vccd1 _2794_/Q sky130_fd_sc_hd__dfrtp_2
X_1676_ hold281/X _2629_/Q _1693_/S vssd1 vssd1 vccd1 vccd1 _2575_/D sky130_fd_sc_hd__mux2_1
Xhold303 _2584_/Q vssd1 vssd1 vccd1 vccd1 hold303/X sky130_fd_sc_hd__dlygate4sd3_1
Xhold314 _2563_/Q vssd1 vssd1 vccd1 vccd1 hold314/X sky130_fd_sc_hd__dlygate4sd3_1
Xhold325 _2590_/Q vssd1 vssd1 vccd1 vccd1 hold325/X sky130_fd_sc_hd__dlygate4sd3_1
Xhold336 _2884_/Q vssd1 vssd1 vccd1 vccd1 hold336/X sky130_fd_sc_hd__dlygate4sd3_1
Xhold347 _2741_/Q vssd1 vssd1 vccd1 vccd1 hold347/X sky130_fd_sc_hd__dlygate4sd3_1
Xhold358 _2744_/Q vssd1 vssd1 vccd1 vccd1 hold358/X sky130_fd_sc_hd__dlygate4sd3_1
Xhold369 _2732_/Q vssd1 vssd1 vccd1 vccd1 hold369/X sky130_fd_sc_hd__dlygate4sd3_1
X_2228_ _2766_/Q _2720_/Q vssd1 vssd1 vccd1 vccd1 _2229_/B sky130_fd_sc_hd__nand2_2
X_2159_ hold279/X hold255/X _2186_/S vssd1 vssd1 vccd1 vccd1 _2715_/D sky130_fd_sc_hd__mux2_1
XANTENNA__1599__A1 _2618_/Q vssd1 vssd1 vccd1 vccd1 sky130_fd_sc_hd__diode_2
XANTENNA__2260__A2 _2260_/A2 vssd1 vssd1 vccd1 vccd1 sky130_fd_sc_hd__diode_2
Xclkbuf_leaf_33_clk clkbuf_leaf_4_clk/A vssd1 vssd1 vccd1 vccd1 _2924_/CLK sky130_fd_sc_hd__clkbuf_8
XFILLER_5_317 vssd1 vssd1 vccd1 vccd1 sky130_fd_sc_hd__fill_2
XTAP_TAPCELL_ROW_51_499 vssd1 vccd1 sky130_fd_sc_hd__tapvpwrvgnd_1
XANTENNA__1771__B2 _2703_/Q vssd1 vssd1 vccd1 vccd1 sky130_fd_sc_hd__diode_2
XTAP_TAPCELL_ROW_59_555 vssd1 vccd1 sky130_fd_sc_hd__tapvpwrvgnd_1
XTAP_TAPCELL_ROW_8_199 vssd1 vccd1 sky130_fd_sc_hd__tapvpwrvgnd_1
XFILLER_8_133 vssd1 vssd1 vccd1 vccd1 sky130_fd_sc_hd__fill_1
XTAP_TAPCELL_ROW_42_433 vssd1 vccd1 sky130_fd_sc_hd__tapvpwrvgnd_1
Xclkbuf_leaf_24_clk clkbuf_3_4__f_clk/X vssd1 vssd1 vccd1 vccd1 _2866_/CLK sky130_fd_sc_hd__clkbuf_8
X_1392_ _2916_/Q _1391_/Y _2348_/C _2331_/A vssd1 vssd1 vccd1 vccd1 _1392_/X sky130_fd_sc_hd__o211a_2
X_1461_ _2910_/Q _1465_/C vssd1 vssd1 vccd1 vccd1 _1461_/Y sky130_fd_sc_hd__nand2_2
X_1530_ _1528_/X _1529_/X _1493_/Y vssd1 vssd1 vccd1 vccd1 _1531_/D sky130_fd_sc_hd__o21ai_2
XFILLER_35_210 vssd1 vccd1 vssd1 vccd1 sky130_ef_sc_hd__decap_40_12
X_2013_ _2018_/A _2018_/B _1996_/A vssd1 vssd1 vccd1 vccd1 _2016_/A sky130_fd_sc_hd__o21ai_2
XFILLER_35_298 vssd1 vssd1 vccd1 vccd1 sky130_fd_sc_hd__fill_1
Xclkbuf_leaf_15_clk clkbuf_3_6__f_clk/X vssd1 vssd1 vccd1 vccd1 _2647_/CLK sky130_fd_sc_hd__clkbuf_8
X_2915_ clkload9/A _2915_/D fanout107/X vssd1 vssd1 vccd1 vccd1 _2915_/Q sky130_fd_sc_hd__dfrtp_2
XFILLER_2_309 vssd1 vssd1 vccd1 vccd1 sky130_fd_sc_hd__fill_1
X_1728_ hold258/X _1549_/B _1725_/Y _2811_/Q vssd1 vssd1 vccd1 vccd1 _1728_/X sky130_fd_sc_hd__a22o_2
X_2846_ _2884_/CLK _2846_/D vssd1 vssd1 vccd1 vccd1 _2846_/Q sky130_fd_sc_hd__dfxtp_2
X_2777_ _2869_/CLK _2777_/D fanout111/A vssd1 vssd1 vccd1 vccd1 _2777_/Q sky130_fd_sc_hd__dfrtp_2
XANTENNA_fanout191_X _1944_/A vssd1 vssd1 vccd1 vccd1 sky130_fd_sc_hd__diode_2
XANTENNA_input6_A nrst vssd1 vssd1 vccd1 vccd1 sky130_fd_sc_hd__diode_2
X_1659_ hold549/X hold483/X _1661_/S vssd1 vssd1 vccd1 vccd1 _2559_/D sky130_fd_sc_hd__mux2_1
XANTENNA__2233__A2 _2260_/A2 vssd1 vssd1 vccd1 vccd1 sky130_fd_sc_hd__diode_2
XTAP_TAPCELL_ROW_64_591 vssd1 vccd1 sky130_fd_sc_hd__tapvpwrvgnd_1
XFILLER_1_331 vssd1 vssd1 vccd1 vccd1 sky130_fd_sc_hd__fill_2
XFILLER_5_136 vssd1 vssd1 vccd1 vccd1 sky130_fd_sc_hd__fill_4
XFILLER_5_169 vssd1 vssd1 vccd1 vccd1 sky130_fd_sc_hd__fill_1
XFILLER_1_375 vssd1 vssd1 vccd1 vccd1 sky130_fd_sc_hd__fill_1
XFILLER_49_346 vssd1 vssd1 vccd1 vccd1 sky130_fd_sc_hd__fill_1
X_2700_ _2765_/CLK _2700_/D load_slew134/X vssd1 vssd1 vccd1 vccd1 _2700_/Q sky130_fd_sc_hd__dfrtp_2
X_2631_ clkload2/A _2631_/D fanout92/X vssd1 vssd1 vccd1 vccd1 _2631_/Q sky130_fd_sc_hd__dfrtp_2
X_2562_ clkload2/A _2562_/D vssd1 vssd1 vccd1 vccd1 _2562_/Q sky130_fd_sc_hd__dfxtp_2
XFILLER_4_73 vssd1 vssd1 vccd1 vccd1 sky130_fd_sc_hd__fill_4
X_1375_ _1382_/B _1355_/B _1358_/B _1662_/D vssd1 vssd1 vccd1 vccd1 _2880_/D sky130_fd_sc_hd__a31o_2
X_1444_ _2904_/Q _2905_/Q _1444_/C vssd1 vssd1 vccd1 vccd1 _1448_/B sky130_fd_sc_hd__and3_2
X_1513_ _2831_/Q _2830_/Q _2833_/Q _2832_/Q vssd1 vssd1 vccd1 vccd1 _1513_/X sky130_fd_sc_hd__and4_2
Xclkbuf_leaf_4_clk clkbuf_leaf_4_clk/A vssd1 vssd1 vccd1 vccd1 clkload2/A sky130_fd_sc_hd__clkbuf_8
X_2493_ _2508_/A _2493_/B _2493_/C vssd1 vssd1 vccd1 vccd1 _2854_/D sky130_fd_sc_hd__and3_2
XFILLER_55_316 vssd1 vssd1 vccd1 vccd1 sky130_fd_sc_hd__fill_1
XANTENNA_fanout151_A _2883_/Q vssd1 vssd1 vccd1 vccd1 sky130_fd_sc_hd__diode_2
XFILLER_23_16 vssd1 vssd1 vccd1 vccd1 sky130_fd_sc_hd__fill_1
X_2829_ clkload1/A _2829_/D fanout82/X vssd1 vssd1 vccd1 vccd1 _2829_/Q sky130_fd_sc_hd__dfrtp_2
XANTENNA_fanout64_A _1662_/X vssd1 vssd1 vccd1 vccd1 sky130_fd_sc_hd__diode_2
XTAP_TAPCELL_ROW_1_150 vssd1 vccd1 sky130_fd_sc_hd__tapvpwrvgnd_1
XANTENNA__2770__Q _2770_/Q vssd1 vssd1 vccd1 vccd1 sky130_fd_sc_hd__diode_2
Xfanout94 fanout99/X vssd1 vssd1 vccd1 vccd1 fanout94/X sky130_fd_sc_hd__clkdlybuf4s25_1
Xfanout61 _1662_/X vssd1 vssd1 vccd1 vccd1 _1686_/S sky130_fd_sc_hd__clkdlybuf4s25_1
Xfanout50 _2134_/S vssd1 vssd1 vccd1 vccd1 _2118_/S sky130_fd_sc_hd__clkdlybuf4s25_1
Xclkbuf_3_7__f_clk clkbuf_0_clk/X vssd1 vssd1 vccd1 vccd1 clkload0/A sky130_fd_sc_hd__clkbuf_16
XANTENNA_clkbuf_leaf_0_clk_A clkbuf_leaf_3_clk/A vssd1 vssd1 vccd1 vccd1 sky130_fd_sc_hd__diode_2
XFILLER_60_385 vssd1 vssd1 vccd1 vccd1 sky130_fd_sc_hd__fill_1
X_1993_ _1992_/A _1996_/A _1995_/B vssd1 vssd1 vccd1 vccd1 _1993_/Y sky130_fd_sc_hd__a21oi_2
X_2614_ _2924_/CLK _2614_/D vssd1 vssd1 vccd1 vccd1 _2614_/Q sky130_fd_sc_hd__dfxtp_2
X_2545_ _2642_/CLK _2545_/D load_slew129/X vssd1 vssd1 vccd1 vccd1 _2545_/Q sky130_fd_sc_hd__dfrtp_2
X_1358_ _1358_/A _1358_/B vssd1 vssd1 vccd1 vccd1 _2872_/D sky130_fd_sc_hd__and2_2
X_1427_ _2898_/Q _2897_/Q _2899_/Q _2900_/Q vssd1 vssd1 vccd1 vccd1 _1427_/X sky130_fd_sc_hd__a31o_2
X_2476_ _2477_/B _2476_/B vssd1 vssd1 vccd1 vccd1 _2847_/D sky130_fd_sc_hd__and2_2
XANTENNA_fanout154_X _2071_/B vssd1 vssd1 vccd1 vccd1 sky130_fd_sc_hd__diode_2
X_1289_ _2554_/Q _2330_/A vssd1 vssd1 vccd1 vccd1 _1364_/A sky130_fd_sc_hd__nor2_2
XTAP_TAPCELL_ROW_21_288 vssd1 vccd1 sky130_fd_sc_hd__tapvpwrvgnd_1
Xclkload3 clkload3/A vssd1 vssd1 vccd1 vccd1 clkload3/Y sky130_fd_sc_hd__clkinvlp_4
XFILLER_59_78 vssd1 vssd1 vccd1 vccd1 sky130_fd_sc_hd__fill_2
XANTENNA__1883__B1 _1851_/Y vssd1 vssd1 vccd1 vccd1 sky130_fd_sc_hd__diode_2
XTAP_TAPCELL_ROW_29_344 vssd1 vccd1 sky130_fd_sc_hd__tapvpwrvgnd_1
XTAP_TAPCELL_ROW_12_222 vssd1 vccd1 sky130_fd_sc_hd__tapvpwrvgnd_1
X_2330_ _2330_/A _2472_/A vssd1 vssd1 vccd1 vccd1 _2330_/Y sky130_fd_sc_hd__nor2_2
X_2261_ _2771_/Q _2725_/Q vssd1 vssd1 vccd1 vccd1 _2261_/Y sky130_fd_sc_hd__nor2_2
X_2192_ _1351_/A _2195_/A _2191_/X hold381/X _2313_/B1 vssd1 vssd1 vccd1 vccd1 _2745_/D
+ sky130_fd_sc_hd__a32o_2
X_1976_ _1976_/A _1976_/B vssd1 vssd1 vccd1 vccd1 _2032_/A sky130_fd_sc_hd__nor2_2
XFILLER_29_26 vssd1 vssd1 vccd1 vccd1 sky130_fd_sc_hd__fill_4
X_2528_ _2866_/CLK _2528_/D vssd1 vssd1 vccd1 vccd1 _2528_/Q sky130_fd_sc_hd__dfxtp_2
X_2459_ _2459_/A _2459_/B vssd1 vssd1 vccd1 vccd1 _2463_/A sky130_fd_sc_hd__nand2_2
XANTENNA__2290__B1 _2293_/B1 vssd1 vssd1 vccd1 vccd1 sky130_fd_sc_hd__diode_2
XFILLER_24_385 vssd1 vssd1 vccd1 vccd1 sky130_fd_sc_hd__fill_1
XTAP_TAPCELL_ROW_26_325 vssd1 vccd1 sky130_fd_sc_hd__tapvpwrvgnd_1
XTAP_TAPCELL_ROW_34_380 vssd1 vccd1 sky130_fd_sc_hd__tapvpwrvgnd_1
XFILLER_3_223 vssd1 vssd1 vccd1 vccd1 sky130_fd_sc_hd__fill_1
XFILLER_3_267 vssd1 vssd1 vccd1 vccd1 sky130_fd_sc_hd__fill_2
XANTENNA__1856__B1 _1851_/Y vssd1 vssd1 vccd1 vccd1 sky130_fd_sc_hd__diode_2
XFILLER_19_135 vssd1 vssd1 vccd1 vccd1 sky130_fd_sc_hd__fill_1
XFILLER_30_311 vssd1 vssd1 vccd1 vccd1 sky130_fd_sc_hd__fill_1
XFILLER_42_193 vssd1 vssd1 vccd1 vccd1 sky130_fd_sc_hd__fill_2
X_1761_ _1751_/X _1755_/X _2620_/Q vssd1 vssd1 vccd1 vccd1 _1761_/X sky130_fd_sc_hd__o21a_2
X_1830_ _2633_/Q _2555_/Q vssd1 vssd1 vccd1 vccd1 _1830_/Y sky130_fd_sc_hd__nand2_2
X_1692_ hold317/X _2646_/Q _1693_/S vssd1 vssd1 vccd1 vccd1 _2591_/D sky130_fd_sc_hd__mux2_1
Xhold507 _2669_/Q vssd1 vssd1 vccd1 vccd1 hold507/X sky130_fd_sc_hd__dlygate4sd3_1
Xhold518 _2818_/Q vssd1 vssd1 vccd1 vccd1 _2383_/A sky130_fd_sc_hd__dlygate4sd3_1
Xhold529 _2904_/Q vssd1 vssd1 vccd1 vccd1 hold529/X sky130_fd_sc_hd__dlygate4sd3_1
X_2313_ _2156_/A _1306_/X _2313_/B1 hold400/X vssd1 vssd1 vccd1 vccd1 _2789_/D sky130_fd_sc_hd__a2bb2o_2
X_2244_ _2231_/A _2227_/Y _2231_/B _2238_/B _2229_/B vssd1 vssd1 vccd1 vccd1 _2245_/B
+ sky130_fd_sc_hd__o311a_2
X_2175_ hold330/X hold256/X _2180_/S vssd1 vssd1 vccd1 vccd1 _2731_/D sky130_fd_sc_hd__mux2_1
X_1959_ _1963_/A _2682_/Q vssd1 vssd1 vccd1 vccd1 _1962_/B sky130_fd_sc_hd__or2_2
XFILLER_0_237 vssd1 vssd1 vccd1 vccd1 sky130_fd_sc_hd__fill_4
Xoutput27 _1541_/Y vssd1 vssd1 vccd1 vccd1 gpio_out[5] sky130_fd_sc_hd__clkdlybuf4s25_1
Xoutput16 _2548_/Q vssd1 vssd1 vccd1 vccd1 gpio_out[19] sky130_fd_sc_hd__clkdlybuf4s25_1
XFILLER_56_57 vssd1 vssd1 vccd1 vccd1 sky130_fd_sc_hd__fill_1
XFILLER_8_348 vssd1 vssd1 vccd1 vccd1 sky130_fd_sc_hd__fill_4
XFILLER_11_7 vssd1 vssd1 vccd1 vccd1 sky130_fd_sc_hd__fill_2
XFILLER_15_182 vssd1 vssd1 vccd1 vccd1 sky130_fd_sc_hd__fill_1
XTAP_TAPCELL_ROW_45_453 vssd1 vccd1 sky130_fd_sc_hd__tapvpwrvgnd_1
Xclkbuf_0_clk clk vssd1 vssd1 vccd1 vccd1 clkbuf_0_clk/X sky130_fd_sc_hd__clkbuf_16
XFILLER_30_185 vssd1 vssd1 vccd1 vccd1 sky130_fd_sc_hd__fill_2
XFILLER_7_51 vssd1 vssd1 vccd1 vccd1 sky130_fd_sc_hd__fill_4
X_1744_ _2618_/Q _2557_/Q vssd1 vssd1 vccd1 vccd1 _1744_/X sky130_fd_sc_hd__and2_2
X_1813_ _2871_/Q _1813_/B vssd1 vssd1 vccd1 vccd1 _1813_/X sky130_fd_sc_hd__and2_2
Xhold304 _2530_/Q vssd1 vssd1 vccd1 vccd1 hold304/X sky130_fd_sc_hd__dlygate4sd3_1
Xhold315 _1664_/X vssd1 vssd1 vccd1 vccd1 _2563_/D sky130_fd_sc_hd__dlygate4sd3_1
Xhold326 _2845_/Q vssd1 vssd1 vccd1 vccd1 hold326/X sky130_fd_sc_hd__dlygate4sd3_1
X_2862_ _2865_/CLK _2862_/D vssd1 vssd1 vccd1 vccd1 _2862_/Q sky130_fd_sc_hd__dfxtp_2
X_2793_ clkload9/A _2793_/D fanout118/X vssd1 vssd1 vccd1 vccd1 _2793_/Q sky130_fd_sc_hd__dfrtp_2
XPHY_EDGE_ROW_15_Right_15 vssd1 vssd1 vccd1 vccd1 sky130_fd_sc_hd__decap_3
X_1675_ hold329/X _2628_/Q _1691_/S vssd1 vssd1 vccd1 vccd1 _2574_/D sky130_fd_sc_hd__mux2_1
Xhold337 _2862_/Q vssd1 vssd1 vccd1 vccd1 _2512_/A sky130_fd_sc_hd__dlygate4sd3_1
Xhold348 _2611_/Q vssd1 vssd1 vccd1 vccd1 hold348/X sky130_fd_sc_hd__dlygate4sd3_1
Xhold359 _2552_/Q vssd1 vssd1 vccd1 vccd1 hold359/X sky130_fd_sc_hd__dlygate4sd3_1
XANTENNA_fanout181_A _1351_/A vssd1 vssd1 vccd1 vccd1 sky130_fd_sc_hd__diode_2
XFILLER_38_230 vssd1 vssd1 vccd1 vccd1 sky130_fd_sc_hd__fill_4
XFILLER_38_263 vssd1 vssd1 vccd1 vccd1 sky130_fd_sc_hd__fill_4
XFILLER_41_406 vssd1 vssd1 vccd1 vccd1 sky130_fd_sc_hd__fill_1
XFILLER_53_200 vssd1 vssd1 vccd1 vccd1 sky130_fd_sc_hd__fill_1
XFILLER_53_255 vssd1 vssd1 vccd1 vccd1 sky130_fd_sc_hd__fill_1
XPHY_EDGE_ROW_24_Right_24 vssd1 vssd1 vccd1 vccd1 sky130_fd_sc_hd__decap_3
X_2227_ _2766_/Q _2720_/Q vssd1 vssd1 vccd1 vccd1 _2227_/Y sky130_fd_sc_hd__nor2_2
X_2158_ hold287/X hold254/X _2186_/S vssd1 vssd1 vccd1 vccd1 _2714_/D sky130_fd_sc_hd__mux2_1
X_2089_ hold512/X _2088_/X _2125_/S vssd1 vssd1 vccd1 vccd1 _2671_/D sky130_fd_sc_hd__mux2_1
XFILLER_13_108 vssd1 vssd1 vccd1 vccd1 sky130_fd_sc_hd__fill_2
XFILLER_21_174 vssd1 vssd1 vccd1 vccd1 sky130_fd_sc_hd__fill_1
XANTENNA_fanout94_A fanout99/X vssd1 vssd1 vccd1 vccd1 sky130_fd_sc_hd__diode_2
XPHY_EDGE_ROW_33_Right_33 vssd1 vssd1 vccd1 vccd1 sky130_fd_sc_hd__decap_3
XTAP_TAPCELL_ROW_59_556 vssd1 vccd1 sky130_fd_sc_hd__tapvpwrvgnd_1
XFILLER_16_71 vssd1 vssd1 vccd1 vccd1 sky130_fd_sc_hd__fill_1
XPHY_EDGE_ROW_42_Right_42 vssd1 vssd1 vccd1 vccd1 sky130_fd_sc_hd__decap_3
XTAP_TAPCELL_ROW_42_434 vssd1 vccd1 sky130_fd_sc_hd__tapvpwrvgnd_1
XFILLER_12_141 vssd1 vssd1 vccd1 vccd1 sky130_fd_sc_hd__fill_1
XPHY_EDGE_ROW_51_Right_51 vssd1 vssd1 vccd1 vccd1 sky130_fd_sc_hd__decap_3
X_1391_ _2918_/Q _2919_/Q vssd1 vssd1 vccd1 vccd1 _1391_/Y sky130_fd_sc_hd__nand2_2
X_1460_ _1465_/C _1459_/Y hold542/X _1477_/B1 vssd1 vssd1 vccd1 vccd1 _2909_/D sky130_fd_sc_hd__a2bb2o_2
XFILLER_35_222 vssd1 vssd1 vccd1 vccd1 sky130_fd_sc_hd__fill_2
XPHY_EDGE_ROW_35_Left_100 vssd1 vssd1 vccd1 vccd1 sky130_fd_sc_hd__decap_3
XPHY_EDGE_ROW_60_Right_60 vssd1 vssd1 vccd1 vccd1 sky130_fd_sc_hd__decap_3
X_2012_ _2011_/X _2010_/Y hold537/X _2069_/B1 vssd1 vssd1 vccd1 vccd1 _2652_/D sky130_fd_sc_hd__a2bb2o_2
XFILLER_35_266 vssd1 vssd1 vccd1 vccd1 sky130_fd_sc_hd__fill_1
XFILLER_50_247 vssd1 vssd1 vccd1 vccd1 sky130_fd_sc_hd__fill_2
X_2914_ clkload9/A _2914_/D load_slew108/X vssd1 vssd1 vccd1 vccd1 _2914_/Q sky130_fd_sc_hd__dfrtp_2
X_2845_ _2845_/CLK _2845_/D load_slew81/X vssd1 vssd1 vccd1 vccd1 _2845_/Q sky130_fd_sc_hd__dfrtp_2
X_1658_ hold273/X _2558_/Q _1658_/S vssd1 vssd1 vccd1 vccd1 _2558_/D sky130_fd_sc_hd__mux2_1
X_1727_ hold283/X _1549_/B _1725_/Y _2810_/Q vssd1 vssd1 vccd1 vccd1 _1727_/X sky130_fd_sc_hd__a22o_2
X_2776_ _2813_/CLK _2776_/D load_slew108/X vssd1 vssd1 vccd1 vccd1 _2776_/Q sky130_fd_sc_hd__dfrtp_2
XANTENNA_fanout184_X _2154_/S vssd1 vssd1 vccd1 vccd1 sky130_fd_sc_hd__diode_2
X_1589_ _1590_/A _1590_/B vssd1 vssd1 vccd1 vccd1 _1589_/X sky130_fd_sc_hd__and2_2
XTAP_TAPCELL_ROW_64_592 vssd1 vccd1 sky130_fd_sc_hd__tapvpwrvgnd_1
XFILLER_57_380 vssd1 vssd1 vccd1 vccd1 sky130_fd_sc_hd__fill_1
XTAP_TAPCELL_ROW_4_170 vssd1 vccd1 sky130_fd_sc_hd__tapvpwrvgnd_1
XANTENNA__1680__A1 _2634_/Q vssd1 vssd1 vccd1 vccd1 sky130_fd_sc_hd__diode_2
XFILLER_32_236 vssd1 vssd1 vccd1 vccd1 sky130_fd_sc_hd__fill_1
X_1512_ _2835_/Q _2834_/Q _2837_/Q _2836_/Q vssd1 vssd1 vccd1 vccd1 _1512_/X sky130_fd_sc_hd__and4_2
X_2630_ _2647_/CLK _2630_/D load_slew129/X vssd1 vssd1 vccd1 vccd1 _2630_/Q sky130_fd_sc_hd__dfrtp_2
X_2561_ _2880_/CLK _2561_/D _1662_/C vssd1 vssd1 vccd1 vccd1 _2561_/Q sky130_fd_sc_hd__dfrtp_2
X_2492_ _2853_/Q _2494_/D _2854_/Q vssd1 vssd1 vccd1 vccd1 _2493_/C sky130_fd_sc_hd__a21o_2
XFILLER_4_63 vssd1 vssd1 vccd1 vccd1 sky130_fd_sc_hd__fill_1
XFILLER_4_85 vssd1 vssd1 vccd1 vccd1 sky130_fd_sc_hd__fill_2
X_1374_ _2300_/A1 _1351_/B _1371_/X _1269_/Y _1373_/Y vssd1 vssd1 vccd1 vccd1 _2867_/D
+ sky130_fd_sc_hd__o221ai_2
X_1443_ _2904_/Q _1444_/C _2905_/Q vssd1 vssd1 vccd1 vccd1 _1443_/X sky130_fd_sc_hd__a21o_2
XANTENNA_fanout144_A fanout145/X vssd1 vssd1 vccd1 vccd1 sky130_fd_sc_hd__diode_2
X_2828_ clkload1/A _2828_/D fanout82/X vssd1 vssd1 vccd1 vccd1 _2828_/Q sky130_fd_sc_hd__dfrtp_2
X_2759_ _2772_/CLK _2759_/D fanout140/X vssd1 vssd1 vccd1 vccd1 _2759_/Q sky130_fd_sc_hd__dfrtp_2
XFILLER_39_391 vssd1 vssd1 vccd1 vccd1 sky130_fd_sc_hd__fill_1
XFILLER_64_46 vssd1 vssd1 vccd1 vccd1 sky130_fd_sc_hd__fill_2
XFILLER_64_57 vssd1 vssd1 vccd1 vccd1 sky130_fd_sc_hd__fill_4
XFILLER_64_79 vssd1 vssd1 vccd1 vccd1 sky130_fd_sc_hd__fill_4
Xfanout62 _1662_/X vssd1 vssd1 vccd1 vccd1 _1695_/S sky130_fd_sc_hd__clkdlybuf4s25_1
Xfanout51 _2134_/S vssd1 vssd1 vccd1 vccd1 _2130_/S sky130_fd_sc_hd__clkdlybuf4s25_1
Xfanout40 _1417_/X vssd1 vssd1 vccd1 vccd1 _1477_/A1 sky130_fd_sc_hd__clkdlybuf4s25_1
Xfanout84 fanout99/A vssd1 vssd1 vccd1 vccd1 fanout84/X sky130_fd_sc_hd__clkdlybuf4s25_1
XTAP_TAPCELL_ROW_15_242 vssd1 vccd1 sky130_fd_sc_hd__tapvpwrvgnd_1
X_1992_ _1992_/A _1996_/A _1995_/B vssd1 vssd1 vccd1 vccd1 _1992_/X sky130_fd_sc_hd__and3_2
Xclkload10 _2916_/CLK vssd1 vssd1 vccd1 vccd1 clkload10/Y sky130_fd_sc_hd__inv_4
X_2613_ _2813_/CLK _2613_/D vssd1 vssd1 vccd1 vccd1 _2613_/Q sky130_fd_sc_hd__dfxtp_2
X_2544_ _2671_/CLK _2544_/D load_slew103/X vssd1 vssd1 vccd1 vccd1 _2544_/Q sky130_fd_sc_hd__dfrtp_2
X_2475_ _2847_/Q wire48/X vssd1 vssd1 vccd1 vccd1 _2476_/B sky130_fd_sc_hd__or2_2
X_1288_ _2893_/Q _2894_/Q _1294_/C vssd1 vssd1 vccd1 vccd1 _2330_/A sky130_fd_sc_hd__nand3_2
X_1357_ _2713_/Q _2876_/Q vssd1 vssd1 vccd1 vccd1 _2874_/D sky130_fd_sc_hd__and2_2
X_1426_ _1437_/D vssd1 vssd1 vccd1 vccd1 _1426_/Y sky130_fd_sc_hd__inv_2
XANTENNA__1644__A1 _1624_/S vssd1 vssd1 vccd1 vccd1 sky130_fd_sc_hd__diode_2
XFILLER_55_169 vssd1 vssd1 vccd1 vccd1 sky130_fd_sc_hd__fill_1
XTAP_TAPCELL_ROW_21_289 vssd1 vccd1 sky130_fd_sc_hd__tapvpwrvgnd_1
Xclkload4 clkload4/A vssd1 vssd1 vccd1 vccd1 clkload4/Y sky130_fd_sc_hd__clkinvlp_4
XFILLER_59_24 vssd1 vssd1 vccd1 vccd1 sky130_fd_sc_hd__fill_4
XFILLER_59_57 vssd1 vssd1 vccd1 vccd1 sky130_fd_sc_hd__fill_1
XANTENNA__1635__A1 _2646_/Q vssd1 vssd1 vccd1 vccd1 sky130_fd_sc_hd__diode_2
XFILLER_27_350 vssd1 vssd1 vccd1 vccd1 sky130_fd_sc_hd__fill_4
XFILLER_27_383 vssd1 vssd1 vccd1 vccd1 sky130_fd_sc_hd__fill_1
XTAP_TAPCELL_ROW_29_345 vssd1 vccd1 sky130_fd_sc_hd__tapvpwrvgnd_1
XTAP_TAPCELL_ROW_12_223 vssd1 vccd1 sky130_fd_sc_hd__tapvpwrvgnd_1
XFILLER_6_265 vssd1 vssd1 vccd1 vccd1 sky130_fd_sc_hd__fill_2
XFILLER_27_5 vssd1 vssd1 vccd1 vccd1 sky130_fd_sc_hd__fill_1
X_2260_ hold426/X _2260_/A2 _2259_/Y _2155_/A vssd1 vssd1 vccd1 vccd1 _2755_/D sky130_fd_sc_hd__a22o_2
X_2191_ _2760_/Q _2714_/Q vssd1 vssd1 vccd1 vccd1 _2191_/X sky130_fd_sc_hd__or2_2
XANTENNA__1626__A1 _2643_/Q vssd1 vssd1 vccd1 vccd1 sky130_fd_sc_hd__diode_2
XFILLER_37_169 vssd1 vssd1 vccd1 vccd1 sky130_fd_sc_hd__fill_4
XFILLER_52_128 vssd1 vssd1 vccd1 vccd1 sky130_fd_sc_hd__fill_1
XFILLER_20_29 vssd1 vccd1 vssd1 vccd1 sky130_ef_sc_hd__decap_40_12
X_1975_ _1945_/Y _1973_/A _1973_/B _2019_/B _2025_/B vssd1 vssd1 vccd1 vccd1 _1976_/B
+ sky130_fd_sc_hd__o311a_2
X_1409_ _2923_/Q _1403_/Y _2389_/C _1408_/X _2331_/A vssd1 vssd1 vccd1 vccd1 _1409_/X
+ sky130_fd_sc_hd__o311a_2
X_2527_ _2866_/CLK _2527_/D vssd1 vssd1 vccd1 vccd1 _2527_/Q sky130_fd_sc_hd__dfxtp_2
X_2458_ _2417_/X _2457_/Y _2842_/Q _2459_/B vssd1 vssd1 vccd1 vccd1 _2842_/D sky130_fd_sc_hd__a2bb2o_2
XANTENNA__1617__A1 _1624_/S vssd1 vssd1 vccd1 vccd1 sky130_fd_sc_hd__diode_2
XANTENNA__1865__A1 _2635_/Q vssd1 vssd1 vccd1 vccd1 sky130_fd_sc_hd__diode_2
X_2389_ _2814_/Q _2389_/B _2389_/C _2389_/D vssd1 vssd1 vccd1 vccd1 _2391_/B sky130_fd_sc_hd__nand4_2
XANTENNA__2290__A1 _1366_/A vssd1 vssd1 vccd1 vccd1 sky130_fd_sc_hd__diode_2
XTAP_TAPCELL_ROW_34_381 vssd1 vccd1 sky130_fd_sc_hd__tapvpwrvgnd_1
XANTENNA__1856__A1 _1863_/C vssd1 vssd1 vccd1 vccd1 sky130_fd_sc_hd__diode_2
XFILLER_34_139 vssd1 vssd1 vccd1 vccd1 sky130_fd_sc_hd__fill_1
XFILLER_35_70 vssd1 vssd1 vccd1 vccd1 sky130_fd_sc_hd__fill_2
X_1691_ hold325/X _2645_/Q _1691_/S vssd1 vssd1 vccd1 vccd1 _2590_/D sky130_fd_sc_hd__mux2_1
X_1760_ _1751_/X _1755_/X _1759_/X _1814_/B2 vssd1 vssd1 vccd1 vccd1 _1760_/X sky130_fd_sc_hd__o31a_2
Xhold508 _2674_/Q vssd1 vssd1 vccd1 vccd1 hold508/X sky130_fd_sc_hd__dlygate4sd3_1
Xhold519 _2811_/Q vssd1 vssd1 vccd1 vccd1 hold519/X sky130_fd_sc_hd__dlygate4sd3_1
X_2312_ _2156_/A _1347_/Y _2313_/B1 hold394/X vssd1 vssd1 vccd1 vccd1 _2788_/D sky130_fd_sc_hd__a2bb2o_2
XTAP_TAPCELL_ROW_48_473 vssd1 vccd1 sky130_fd_sc_hd__tapvpwrvgnd_1
X_2243_ _2241_/Y _2243_/B vssd1 vssd1 vccd1 vccd1 _2246_/A sky130_fd_sc_hd__and2b_2
X_2174_ hold356/X hold355/X _2180_/S vssd1 vssd1 vccd1 vccd1 _2730_/D sky130_fd_sc_hd__mux2_1
XANTENNA__2272__B2 _2282_/A2 vssd1 vssd1 vccd1 vccd1 sky130_fd_sc_hd__diode_2
X_1889_ _1892_/B _1889_/B vssd1 vssd1 vccd1 vccd1 _1889_/X sky130_fd_sc_hd__and2b_2
X_1958_ _2668_/Q _1958_/B _1958_/C vssd1 vssd1 vccd1 vccd1 _2002_/B sky130_fd_sc_hd__nand3_2
Xoutput28 _1542_/X vssd1 vssd1 vccd1 vccd1 gpio_out[6] sky130_fd_sc_hd__clkdlybuf4s25_1
Xoutput17 _2549_/Q vssd1 vssd1 vccd1 vccd1 gpio_out[20] sky130_fd_sc_hd__clkdlybuf4s25_1
XFILLER_56_220 vssd1 vssd1 vccd1 vccd1 sky130_fd_sc_hd__fill_1
XTAP_TAPCELL_ROW_45_454 vssd1 vccd1 sky130_fd_sc_hd__tapvpwrvgnd_1
X_2861_ _2865_/CLK _2861_/D vssd1 vssd1 vccd1 vccd1 _2861_/Q sky130_fd_sc_hd__dfxtp_2
XFILLER_30_197 vssd1 vssd1 vccd1 vccd1 sky130_fd_sc_hd__fill_2
X_1674_ hold366/X _2627_/Q _1691_/S vssd1 vssd1 vccd1 vccd1 _2573_/D sky130_fd_sc_hd__mux2_1
X_1743_ hold531/X _1814_/B2 _1741_/X _1742_/X vssd1 vssd1 vccd1 vccd1 _2617_/D sky130_fd_sc_hd__o22a_2
X_1812_ _2810_/Q _2554_/Q _1812_/C vssd1 vssd1 vccd1 vccd1 _1822_/B sky130_fd_sc_hd__nand3_2
Xhold305 _2592_/Q vssd1 vssd1 vccd1 vccd1 hold305/X sky130_fd_sc_hd__dlygate4sd3_1
Xhold316 _2595_/Q vssd1 vssd1 vccd1 vccd1 _1359_/B sky130_fd_sc_hd__dlygate4sd3_1
Xhold327 _2524_/Q vssd1 vssd1 vccd1 vccd1 hold327/X sky130_fd_sc_hd__dlygate4sd3_1
Xhold338 _2851_/Q vssd1 vssd1 vccd1 vccd1 _2484_/A sky130_fd_sc_hd__dlygate4sd3_1
Xhold349 _2729_/Q vssd1 vssd1 vccd1 vccd1 hold349/X sky130_fd_sc_hd__dlygate4sd3_1
X_2792_ _2813_/CLK _2792_/D fanout111/A vssd1 vssd1 vccd1 vccd1 _2792_/Q sky130_fd_sc_hd__dfrtp_2
X_2226_ _2155_/A _2224_/X _2225_/Y hold374/X _2260_/A2 vssd1 vssd1 vccd1 vccd1 _2750_/D
+ sky130_fd_sc_hd__a32o_2
XANTENNA_fanout174_A _2870_/Q vssd1 vssd1 vccd1 vccd1 sky130_fd_sc_hd__diode_2
XFILLER_53_289 vssd1 vssd1 vccd1 vccd1 sky130_fd_sc_hd__fill_1
X_2157_ _2154_/S _2713_/Q _2157_/S vssd1 vssd1 vccd1 vccd1 _2713_/D sky130_fd_sc_hd__mux2_1
X_2088_ _2584_/Q _2568_/Q _2118_/S vssd1 vssd1 vccd1 vccd1 _2088_/X sky130_fd_sc_hd__mux2_1
XFILLER_21_142 vssd1 vssd1 vccd1 vccd1 sky130_fd_sc_hd__fill_1
XFILLER_42_38 vssd1 vssd1 vccd1 vccd1 sky130_fd_sc_hd__fill_2
XANTENNA__2330__B _2472_/A vssd1 vssd1 vccd1 vccd1 sky130_fd_sc_hd__diode_2
XFILLER_17_404 vssd1 vssd1 vccd1 vccd1 sky130_fd_sc_hd__fill_2
XFILLER_44_256 vssd1 vssd1 vccd1 vccd1 sky130_fd_sc_hd__fill_1
XTAP_TAPCELL_ROW_42_435 vssd1 vccd1 sky130_fd_sc_hd__tapvpwrvgnd_1
XFILLER_32_82 vssd1 vssd1 vccd1 vccd1 sky130_fd_sc_hd__fill_2
XTAP_TAPCELL_ROW_50_490 vssd1 vccd1 sky130_fd_sc_hd__tapvpwrvgnd_1
XTAP_TAPCELL_ROW_7_190 vssd1 vccd1 sky130_fd_sc_hd__tapvpwrvgnd_1
X_1390_ _2917_/Q _2916_/Q vssd1 vssd1 vccd1 vccd1 _2348_/C sky130_fd_sc_hd__nand2_2
X_2011_ _1996_/A _2018_/A _2018_/B _2069_/B1 vssd1 vssd1 vccd1 vccd1 _2011_/X sky130_fd_sc_hd__a31o_2
X_2913_ clkload9/A _2913_/D fanout118/X vssd1 vssd1 vccd1 vccd1 _2913_/Q sky130_fd_sc_hd__dfrtp_2
X_2844_ _2845_/CLK _2844_/D load_slew81/X vssd1 vssd1 vccd1 vccd1 _2844_/Q sky130_fd_sc_hd__dfrtp_2
X_1588_ _2633_/Q _1702_/S _1385_/B _2697_/Q _1587_/X vssd1 vssd1 vccd1 vccd1 _1588_/X
+ sky130_fd_sc_hd__a221o_2
X_1657_ hold280/X _2557_/Q _1658_/S vssd1 vssd1 vccd1 vccd1 _2557_/D sky130_fd_sc_hd__mux2_1
X_1726_ hold309/X _1548_/Y _1725_/Y vssd1 vssd1 vccd1 vccd1 _2612_/D sky130_fd_sc_hd__o21ba_2
X_2775_ _2813_/CLK _2775_/D load_slew108/X vssd1 vssd1 vccd1 vccd1 _2775_/Q sky130_fd_sc_hd__dfrtp_2
XANTENNA__2874__Q _2874_/Q vssd1 vssd1 vccd1 vccd1 sky130_fd_sc_hd__diode_2
X_2209_ _2209_/A _2209_/B vssd1 vssd1 vccd1 vccd1 _2209_/X sky130_fd_sc_hd__or2_2
XFILLER_53_59 vssd1 vssd1 vccd1 vccd1 sky130_fd_sc_hd__fill_1
XTAP_TAPCELL_ROW_64_593 vssd1 vccd1 sky130_fd_sc_hd__tapvpwrvgnd_1
XANTENNA__1901__B1 _1851_/Y vssd1 vssd1 vccd1 vccd1 sky130_fd_sc_hd__diode_2
XFILLER_1_344 vssd1 vssd1 vccd1 vccd1 sky130_fd_sc_hd__fill_2
XFILLER_64_307 vssd1 vssd1 vccd1 vccd1 sky130_fd_sc_hd__fill_1
XTAP_TAPCELL_ROW_4_171 vssd1 vccd1 sky130_fd_sc_hd__tapvpwrvgnd_1
X_1442_ _1450_/A1 _1440_/X _1441_/Y _1450_/B1 hold529/X vssd1 vssd1 vccd1 vccd1 _2904_/D
+ sky130_fd_sc_hd__a32o_2
X_1511_ _1538_/A _1511_/B vssd1 vssd1 vccd1 vccd1 _1539_/A sky130_fd_sc_hd__nand2_2
X_2560_ clkload3/A _2560_/D _2473_/A1 vssd1 vssd1 vccd1 vccd1 _2560_/Q sky130_fd_sc_hd__dfrtp_2
X_2491_ _2491_/A vssd1 vssd1 vccd1 vccd1 _2493_/B sky130_fd_sc_hd__inv_2
XANTENNA__2145__A0 _2703_/Q vssd1 vssd1 vccd1 vccd1 sky130_fd_sc_hd__diode_2
X_1373_ _1373_/A _2154_/S vssd1 vssd1 vccd1 vccd1 _1373_/Y sky130_fd_sc_hd__nand2_2
XTAP_TAPCELL_ROW_53_508 vssd1 vccd1 sky130_fd_sc_hd__tapvpwrvgnd_1
XANTENNA_fanout137_A fanout144/X vssd1 vssd1 vccd1 vccd1 sky130_fd_sc_hd__diode_2
XFILLER_31_281 vssd1 vssd1 vccd1 vccd1 sky130_fd_sc_hd__fill_1
X_2827_ clkload1/A _2827_/D fanout82/X vssd1 vssd1 vccd1 vccd1 _2827_/Q sky130_fd_sc_hd__dfrtp_2
X_2758_ _2769_/CLK _2758_/D fanout140/X vssd1 vssd1 vccd1 vccd1 _2758_/Q sky130_fd_sc_hd__dfrtp_2
XPHY_EDGE_ROW_18_Left_83 vssd1 vssd1 vccd1 vccd1 sky130_fd_sc_hd__decap_3
X_1709_ hold241/X _1614_/X _1721_/S vssd1 vssd1 vccd1 vccd1 _2603_/D sky130_fd_sc_hd__mux2_1
X_2689_ _2689_/CLK _2689_/D load_slew97/X vssd1 vssd1 vccd1 vccd1 _2689_/Q sky130_fd_sc_hd__dfrtp_2
XFILLER_46_318 vssd1 vssd1 vccd1 vccd1 sky130_fd_sc_hd__fill_1
XANTENNA__1414__A2 _2969_/A vssd1 vssd1 vccd1 vccd1 sky130_fd_sc_hd__diode_2
XPHY_EDGE_ROW_54_Left_119 vssd1 vssd1 vccd1 vccd1 sky130_fd_sc_hd__decap_3
Xfanout96 fanout99/X vssd1 vssd1 vccd1 vccd1 fanout96/X sky130_fd_sc_hd__clkdlybuf4s25_1
Xfanout63 _1693_/S vssd1 vssd1 vccd1 vccd1 _1691_/S sky130_fd_sc_hd__clkdlybuf4s25_1
Xfanout52 _2075_/Y vssd1 vssd1 vccd1 vccd1 _2134_/S sky130_fd_sc_hd__clkdlybuf4s25_1
Xfanout41 _1417_/X vssd1 vssd1 vccd1 vccd1 _1450_/A1 sky130_fd_sc_hd__clkdlybuf4s25_1
XANTENNA__2071__A _2136_/B vssd1 vssd1 vccd1 vccd1 sky130_fd_sc_hd__diode_2
XFILLER_49_178 vssd1 vssd1 vccd1 vccd1 sky130_fd_sc_hd__fill_1
XPHY_EDGE_ROW_63_Left_128 vssd1 vssd1 vccd1 vccd1 sky130_fd_sc_hd__decap_3
XFILLER_60_365 vssd1 vssd1 vccd1 vccd1 sky130_fd_sc_hd__fill_1
XTAP_TAPCELL_ROW_15_243 vssd1 vccd1 sky130_fd_sc_hd__tapvpwrvgnd_1
XFILLER_20_218 vssd1 vssd1 vccd1 vccd1 sky130_fd_sc_hd__fill_1
X_1991_ _2071_/B _2649_/Q vssd1 vssd1 vccd1 vccd1 _1991_/X sky130_fd_sc_hd__or2_2
Xclkload11 _2813_/CLK vssd1 vssd1 vccd1 vccd1 clkload11/X sky130_fd_sc_hd__clkbuf_4
X_2612_ _2924_/CLK _2612_/D vssd1 vssd1 vccd1 vccd1 _2612_/Q sky130_fd_sc_hd__dfxtp_2
X_1425_ _2898_/Q _2897_/Q _2900_/Q _2899_/Q vssd1 vssd1 vccd1 vccd1 _1437_/D sky130_fd_sc_hd__and4_2
X_2543_ _2642_/CLK _2543_/D fanout128/X vssd1 vssd1 vccd1 vccd1 _2543_/Q sky130_fd_sc_hd__dfrtp_2
X_2474_ _2847_/Q wire48/X vssd1 vssd1 vccd1 vccd1 _2477_/B sky130_fd_sc_hd__nand2_2
XFILLER_18_29 vssd1 vssd1 vccd1 vccd1 sky130_fd_sc_hd__fill_1
XFILLER_28_307 vssd1 vssd1 vccd1 vccd1 sky130_fd_sc_hd__fill_1
X_1287_ _2893_/Q _2894_/Q _1294_/C vssd1 vssd1 vccd1 vccd1 _2331_/A sky130_fd_sc_hd__and3_2
X_1356_ _1356_/A _1822_/A vssd1 vssd1 vccd1 vccd1 _2875_/D sky130_fd_sc_hd__and2_2
Xclkload5 clkload5/A vssd1 vssd1 vccd1 vccd1 clkload5/Y sky130_fd_sc_hd__bufinv_16
XFILLER_19_307 vssd1 vssd1 vccd1 vccd1 sky130_fd_sc_hd__fill_2
XPHY_EDGE_ROW_3_Left_68 vssd1 vssd1 vccd1 vccd1 sky130_fd_sc_hd__decap_3
XFILLER_27_340 vssd1 vssd1 vccd1 vccd1 sky130_fd_sc_hd__fill_1
XFILLER_54_181 vssd1 vssd1 vccd1 vccd1 sky130_fd_sc_hd__fill_4
XTAP_TAPCELL_ROW_29_346 vssd1 vccd1 sky130_fd_sc_hd__tapvpwrvgnd_1
XTAP_TAPCELL_ROW_12_224 vssd1 vccd1 sky130_fd_sc_hd__tapvpwrvgnd_1
X_2190_ _2760_/Q _2714_/Q vssd1 vssd1 vccd1 vccd1 _2195_/A sky130_fd_sc_hd__nand2_2
X_1974_ _1945_/Y _1973_/A _1973_/B _2019_/B vssd1 vssd1 vccd1 vccd1 _2026_/A sky130_fd_sc_hd__o31a_2
X_1408_ _2922_/Q _1405_/Y _1406_/X _1407_/Y vssd1 vssd1 vccd1 vccd1 _1408_/X sky130_fd_sc_hd__a31o_2
X_2526_ _2866_/CLK _2526_/D vssd1 vssd1 vccd1 vccd1 _2526_/Q sky130_fd_sc_hd__dfxtp_2
X_2457_ _2842_/Q _2461_/C vssd1 vssd1 vccd1 vccd1 _2457_/Y sky130_fd_sc_hd__xnor2_2
X_2388_ _2820_/Q _2387_/B hold485/X vssd1 vssd1 vccd1 vccd1 _2388_/Y sky130_fd_sc_hd__a21oi_2
XANTENNA__2882__Q _2882_/Q vssd1 vssd1 vccd1 vccd1 sky130_fd_sc_hd__diode_2
X_1339_ _2800_/Q _1339_/B vssd1 vssd1 vccd1 vccd1 _1339_/Y sky130_fd_sc_hd__xnor2_2
XFILLER_24_365 vssd1 vssd1 vccd1 vccd1 sky130_fd_sc_hd__fill_1
XFILLER_51_184 vssd1 vssd1 vccd1 vccd1 sky130_fd_sc_hd__fill_4
XANTENNA__1664__S _1686_/S vssd1 vssd1 vccd1 vccd1 sky130_fd_sc_hd__diode_2
XFILLER_10_85 vssd1 vssd1 vccd1 vccd1 sky130_fd_sc_hd__fill_8
XFILLER_3_225 vssd1 vssd1 vccd1 vccd1 sky130_fd_sc_hd__fill_1
XANTENNA__1608__A2 _2702_/Q vssd1 vssd1 vccd1 vccd1 sky130_fd_sc_hd__diode_2
XFILLER_42_195 vssd1 vssd1 vccd1 vccd1 sky130_fd_sc_hd__fill_1
X_1690_ hold276/X _2644_/Q _1693_/S vssd1 vssd1 vccd1 vccd1 _2589_/D sky130_fd_sc_hd__mux2_1
Xhold509 _2667_/Q vssd1 vssd1 vccd1 vccd1 hold509/X sky130_fd_sc_hd__dlygate4sd3_1
X_2311_ _2156_/A _1343_/X _2313_/B1 hold396/X vssd1 vssd1 vccd1 vccd1 _2787_/D sky130_fd_sc_hd__a2bb2o_2
X_2242_ _2768_/Q _2722_/Q vssd1 vssd1 vccd1 vccd1 _2243_/B sky130_fd_sc_hd__nand2_2
XTAP_TAPCELL_ROW_48_474 vssd1 vccd1 sky130_fd_sc_hd__tapvpwrvgnd_1
X_2173_ hold349/X hold294/X _2180_/S vssd1 vssd1 vccd1 vccd1 _2729_/D sky130_fd_sc_hd__mux2_1
X_1957_ _1958_/B _1958_/C _2668_/Q vssd1 vssd1 vccd1 vccd1 _1970_/A sky130_fd_sc_hd__a21oi_2
XFILLER_0_217 vssd1 vssd1 vccd1 vccd1 sky130_fd_sc_hd__fill_4
X_1888_ _2641_/Q _2640_/Q _1881_/B _2642_/Q vssd1 vssd1 vccd1 vccd1 _1889_/B sky130_fd_sc_hd__a31o_2
Xoutput29 _1543_/Y vssd1 vssd1 vccd1 vccd1 gpio_out[7] sky130_fd_sc_hd__clkdlybuf4s25_1
Xoutput18 _2550_/Q vssd1 vssd1 vccd1 vccd1 gpio_out[21] sky130_fd_sc_hd__clkdlybuf4s25_1
X_2509_ _2861_/Q _2509_/B vssd1 vssd1 vccd1 vccd1 _2513_/C sky130_fd_sc_hd__and2_2
XFILLER_24_162 vssd1 vssd1 vccd1 vccd1 sky130_fd_sc_hd__fill_1
Xclkbuf_leaf_36_clk clkbuf_leaf_4_clk/A vssd1 vssd1 vccd1 vccd1 _2923_/CLK sky130_fd_sc_hd__clkbuf_8
XFILLER_47_221 vssd1 vssd1 vccd1 vccd1 sky130_fd_sc_hd__fill_2
XPHY_EDGE_ROW_6_Left_71 vssd1 vssd1 vccd1 vccd1 sky130_fd_sc_hd__decap_3
Xclkbuf_leaf_27_clk clkbuf_3_5__f_clk/X vssd1 vssd1 vccd1 vccd1 _2801_/CLK sky130_fd_sc_hd__clkbuf_8
XANTENNA__2254__A _2770_/Q vssd1 vssd1 vccd1 vccd1 sky130_fd_sc_hd__diode_2
XTAP_TAPCELL_ROW_45_455 vssd1 vccd1 sky130_fd_sc_hd__tapvpwrvgnd_1
X_1811_ _2630_/Q _1811_/A2 _1809_/X _1810_/X vssd1 vssd1 vccd1 vccd1 _2630_/D sky130_fd_sc_hd__o22a_2
X_2860_ _2865_/CLK _2860_/D vssd1 vssd1 vccd1 vccd1 _2860_/Q sky130_fd_sc_hd__dfxtp_2
X_2791_ clkload9/A _2791_/D fanout107/X vssd1 vssd1 vccd1 vccd1 _2791_/Q sky130_fd_sc_hd__dfrtp_2
X_1673_ hold345/X _2626_/Q _1691_/S vssd1 vssd1 vccd1 vccd1 _2572_/D sky130_fd_sc_hd__mux2_1
X_1742_ _1734_/A _2649_/Q _1786_/B1 _2698_/Q _1819_/B2 vssd1 vssd1 vccd1 vccd1 _1742_/X
+ sky130_fd_sc_hd__a221o_2
Xhold306 _2578_/Q vssd1 vssd1 vccd1 vccd1 hold306/X sky130_fd_sc_hd__dlygate4sd3_1
Xhold317 _2591_/Q vssd1 vssd1 vccd1 vccd1 hold317/X sky130_fd_sc_hd__dlygate4sd3_1
Xhold328 _2924_/Q vssd1 vssd1 vccd1 vccd1 _1373_/A sky130_fd_sc_hd__dlygate4sd3_1
Xhold339 _2484_/Y vssd1 vssd1 vccd1 vccd1 _2851_/D sky130_fd_sc_hd__dlygate4sd3_1
X_2225_ _2225_/A _2225_/B vssd1 vssd1 vccd1 vccd1 _2225_/Y sky130_fd_sc_hd__nand2_2
XANTENNA_fanout167_A _2874_/Q vssd1 vssd1 vccd1 vccd1 sky130_fd_sc_hd__diode_2
XPHY_EDGE_ROW_5_Right_5 vssd1 vssd1 vccd1 vccd1 sky130_fd_sc_hd__decap_3
Xclkbuf_leaf_18_clk clkload0/A vssd1 vssd1 vccd1 vccd1 _2772_/CLK sky130_fd_sc_hd__clkbuf_8
X_2156_ _2156_/A _2156_/B vssd1 vssd1 vccd1 vccd1 _2157_/S sky130_fd_sc_hd__nand2_2
X_2087_ hold499/X _2086_/X _2882_/D vssd1 vssd1 vccd1 vccd1 _2670_/D sky130_fd_sc_hd__mux2_1
XANTENNA__2103__S _2125_/S vssd1 vssd1 vccd1 vccd1 sky130_fd_sc_hd__diode_2
XPHY_EDGE_ROW_32_Left_97 vssd1 vssd1 vccd1 vccd1 sky130_fd_sc_hd__decap_3
XTAP_TAPCELL_ROW_42_436 vssd1 vccd1 sky130_fd_sc_hd__tapvpwrvgnd_1
XTAP_TAPCELL_ROW_50_491 vssd1 vccd1 sky130_fd_sc_hd__tapvpwrvgnd_1
XFILLER_57_80 vssd1 vssd1 vccd1 vccd1 sky130_fd_sc_hd__fill_1
XTAP_TAPCELL_ROW_7_191 vssd1 vccd1 sky130_fd_sc_hd__tapvpwrvgnd_1
X_2010_ _1996_/A _2018_/A _2018_/B vssd1 vssd1 vccd1 vccd1 _2010_/Y sky130_fd_sc_hd__a21oi_2
XFILLER_50_249 vssd1 vssd1 vccd1 vccd1 sky130_fd_sc_hd__fill_1
X_2912_ _2912_/CLK _2912_/D fanout118/X vssd1 vssd1 vccd1 vccd1 _2912_/Q sky130_fd_sc_hd__dfrtp_2
X_1725_ _2805_/Q _2472_/A _1725_/C vssd1 vssd1 vccd1 vccd1 _1725_/Y sky130_fd_sc_hd__nor3_2
X_2843_ _2845_/CLK _2843_/D load_slew81/X vssd1 vssd1 vccd1 vccd1 _2843_/Q sky130_fd_sc_hd__dfrtp_2
X_2774_ _2774_/CLK _2774_/D fanout140/X vssd1 vssd1 vccd1 vccd1 _2774_/Q sky130_fd_sc_hd__dfrtp_2
X_1587_ _1734_/A _2648_/Q vssd1 vssd1 vccd1 vccd1 _1587_/X sky130_fd_sc_hd__and2_2
X_1656_ hold296/X _2556_/Q _1658_/S vssd1 vssd1 vccd1 vccd1 _2556_/D sky130_fd_sc_hd__mux2_1
Xclkbuf_leaf_7_clk clkbuf_leaf_9_clk/A vssd1 vssd1 vccd1 vccd1 _2688_/CLK sky130_fd_sc_hd__clkbuf_8
X_2208_ _2198_/Y _2203_/B _2200_/B vssd1 vssd1 vccd1 vccd1 _2209_/B sky130_fd_sc_hd__o21a_2
X_2139_ hold440/X hold381/X _2154_/S vssd1 vssd1 vccd1 vccd1 _2697_/D sky130_fd_sc_hd__mux2_1
XANTENNA__2218__A2 _2260_/A2 vssd1 vssd1 vccd1 vccd1 sky130_fd_sc_hd__diode_2
XTAP_TAPCELL_ROW_64_594 vssd1 vccd1 sky130_fd_sc_hd__tapvpwrvgnd_1
XANTENNA_clkbuf_3_7__f_clk_A clkbuf_0_clk/X vssd1 vssd1 vccd1 vccd1 sky130_fd_sc_hd__diode_2
XFILLER_4_194 vssd1 vssd1 vccd1 vccd1 sky130_fd_sc_hd__fill_2
X_1441_ _2904_/Q _1444_/C vssd1 vssd1 vccd1 vccd1 _1441_/Y sky130_fd_sc_hd__nand2_2
X_1510_ _1510_/A _1510_/B _1511_/B vssd1 vssd1 vccd1 vccd1 _1515_/A sky130_fd_sc_hd__and3_2
X_2490_ _2853_/Q _2854_/Q _2494_/D vssd1 vssd1 vccd1 vccd1 _2491_/A sky130_fd_sc_hd__and3_2
XFILLER_4_98 vssd1 vssd1 vccd1 vccd1 sky130_fd_sc_hd__fill_2
X_1372_ _2180_/S _1371_/X _2328_/A1 vssd1 vssd1 vccd1 vccd1 _2868_/D sky130_fd_sc_hd__a21o_2
XTAP_TAPCELL_ROW_18_263 vssd1 vccd1 sky130_fd_sc_hd__tapvpwrvgnd_1
XTAP_TAPCELL_ROW_53_509 vssd1 vccd1 sky130_fd_sc_hd__tapvpwrvgnd_1
XTAP_TAPCELL_ROW_61_564 vssd1 vccd1 sky130_fd_sc_hd__tapvpwrvgnd_1
X_1708_ hold245/X _1707_/X _1721_/S vssd1 vssd1 vccd1 vccd1 _2602_/D sky130_fd_sc_hd__mux2_1
X_2826_ clkload3/A _2826_/D fanout89/X vssd1 vssd1 vccd1 vccd1 _2826_/Q sky130_fd_sc_hd__dfrtp_2
X_2757_ _2772_/CLK _2757_/D fanout140/X vssd1 vssd1 vccd1 vccd1 _2757_/Q sky130_fd_sc_hd__dfrtp_2
X_2688_ _2688_/CLK _2688_/D load_slew95/X vssd1 vssd1 vccd1 vccd1 _2688_/Q sky130_fd_sc_hd__dfrtp_2
XANTENNA__1895__B1 _2644_/Q vssd1 vssd1 vccd1 vccd1 sky130_fd_sc_hd__diode_2
XANTENNA_input4_A gpio_in[2] vssd1 vssd1 vccd1 vccd1 sky130_fd_sc_hd__diode_2
XFILLER_58_157 vssd1 vssd1 vccd1 vccd1 sky130_fd_sc_hd__fill_2
X_1639_ _1385_/B _2711_/Q _1586_/B _1638_/X vssd1 vssd1 vccd1 vccd1 _1639_/X sky130_fd_sc_hd__a211o_2
Xfanout86 _2331_/B vssd1 vssd1 vccd1 vccd1 fanout86/X sky130_fd_sc_hd__clkdlybuf4s25_1
Xfanout64 _1662_/X vssd1 vssd1 vccd1 vccd1 _1693_/S sky130_fd_sc_hd__clkdlybuf4s25_1
Xfanout53 _1850_/X vssd1 vssd1 vccd1 vccd1 _1891_/S sky130_fd_sc_hd__clkdlybuf4s25_1
Xfanout42 _1551_/Y vssd1 vssd1 vccd1 vccd1 _1558_/B sky130_fd_sc_hd__clkdlybuf4s25_1
XANTENNA__2071__B _2071_/B vssd1 vssd1 vccd1 vccd1 sky130_fd_sc_hd__diode_2
XFILLER_38_82 vssd1 vssd1 vccd1 vccd1 sky130_fd_sc_hd__fill_2
XFILLER_64_127 vssd1 vssd1 vccd1 vccd1 sky130_fd_sc_hd__fill_4
XFILLER_54_81 vssd1 vssd1 vccd1 vccd1 sky130_fd_sc_hd__fill_2
XTAP_TAPCELL_ROW_15_244 vssd1 vccd1 sky130_fd_sc_hd__tapvpwrvgnd_1
X_1990_ _1990_/A _1990_/B vssd1 vssd1 vccd1 vccd1 _1995_/B sky130_fd_sc_hd__xnor2_2
XFILLER_13_271 vssd1 vssd1 vccd1 vccd1 sky130_fd_sc_hd__fill_1
XFILLER_13_293 vssd1 vssd1 vccd1 vccd1 sky130_fd_sc_hd__fill_2
XFILLER_55_3 vssd1 vssd1 vccd1 vccd1 sky130_fd_sc_hd__fill_8
Xclkload12 _2774_/CLK vssd1 vssd1 vccd1 vccd1 clkload12/X sky130_fd_sc_hd__clkbuf_4
X_2611_ clkload8/A _2611_/D vssd1 vssd1 vccd1 vccd1 _2611_/Q sky130_fd_sc_hd__dfxtp_2
X_2542_ _2671_/CLK _2542_/D load_slew101/X vssd1 vssd1 vccd1 vccd1 _2542_/Q sky130_fd_sc_hd__dfrtp_2
X_1355_ _2713_/Q _1355_/B _2880_/Q vssd1 vssd1 vccd1 vccd1 _2877_/D sky130_fd_sc_hd__and3_2
X_1424_ _1477_/A1 _1422_/Y _1423_/X _1477_/B1 hold527/X vssd1 vssd1 vccd1 vccd1 _2899_/D
+ sky130_fd_sc_hd__a32o_2
X_2473_ _2473_/A1 _2361_/Y wire48/A _2471_/X vssd1 vssd1 vccd1 vccd1 _2846_/D sky130_fd_sc_hd__a211oi_2
XANTENNA__2156__B _2156_/B vssd1 vssd1 vccd1 vccd1 sky130_fd_sc_hd__diode_2
X_1286_ _2896_/Q _2895_/Q vssd1 vssd1 vccd1 vccd1 _1294_/C sky130_fd_sc_hd__nor2_2
XFILLER_34_29 vssd1 vssd1 vccd1 vccd1 sky130_fd_sc_hd__fill_1
Xclkload6 clkload6/A vssd1 vssd1 vccd1 vccd1 clkload6/X sky130_fd_sc_hd__clkbuf_4
XANTENNA__2111__S _2136_/B vssd1 vssd1 vccd1 vccd1 sky130_fd_sc_hd__diode_2
X_2809_ clkload3/A _2809_/D vssd1 vssd1 vccd1 vccd1 _2809_/Q sky130_fd_sc_hd__dfxtp_2
XANTENNA__1868__A0 _2636_/Q vssd1 vssd1 vccd1 vccd1 sky130_fd_sc_hd__diode_2
XANTENNA_fanout62_A _1662_/X vssd1 vssd1 vccd1 vccd1 sky130_fd_sc_hd__diode_2
XFILLER_46_138 vssd1 vssd1 vccd1 vccd1 sky130_fd_sc_hd__fill_2
XANTENNA__2293__B1 _2293_/B1 vssd1 vssd1 vccd1 vccd1 sky130_fd_sc_hd__diode_2
XFILLER_54_193 vssd1 vssd1 vccd1 vccd1 sky130_fd_sc_hd__fill_1
XTAP_TAPCELL_ROW_12_225 vssd1 vccd1 sky130_fd_sc_hd__tapvpwrvgnd_1
XTAP_TAPCELL_ROW_20_280 vssd1 vccd1 sky130_fd_sc_hd__tapvpwrvgnd_1
XANTENNA__2284__B1 _2293_/B1 vssd1 vssd1 vccd1 vccd1 sky130_fd_sc_hd__diode_2
XFILLER_33_311 vssd1 vssd1 vccd1 vccd1 sky130_fd_sc_hd__fill_1
XFILLER_60_141 vssd1 vssd1 vccd1 vccd1 sky130_fd_sc_hd__fill_1
X_1973_ _1973_/A _1973_/B vssd1 vssd1 vccd1 vccd1 _2020_/A sky130_fd_sc_hd__nor2_2
X_2525_ _2866_/CLK _2525_/D vssd1 vssd1 vccd1 vccd1 _2525_/Q sky130_fd_sc_hd__dfxtp_2
X_1338_ _2737_/Q _1333_/X _1334_/X _1332_/X _1337_/X vssd1 vssd1 vccd1 vccd1 _1338_/X
+ sky130_fd_sc_hd__o221a_2
X_1407_ _2922_/Q _2817_/Q _2923_/Q vssd1 vssd1 vccd1 vccd1 _1407_/Y sky130_fd_sc_hd__o21ai_2
X_2456_ hold524/X _2454_/B _2455_/X vssd1 vssd1 vccd1 vccd1 _2841_/D sky130_fd_sc_hd__o21a_2
X_2387_ _2387_/A _2387_/B vssd1 vssd1 vccd1 vccd1 _2820_/D sky130_fd_sc_hd__xor2_2
XANTENNA_fanout152_X _2125_/S vssd1 vssd1 vccd1 vccd1 sky130_fd_sc_hd__diode_2
X_1269_ _2180_/S vssd1 vssd1 vccd1 vccd1 _1269_/Y sky130_fd_sc_hd__inv_2
XFILLER_10_42 vssd1 vssd1 vccd1 vccd1 sky130_fd_sc_hd__fill_1
XANTENNA__1680__S _1686_/S vssd1 vssd1 vccd1 vccd1 sky130_fd_sc_hd__diode_2
XANTENNA_fanout65_X _1624_/S vssd1 vssd1 vccd1 vccd1 sky130_fd_sc_hd__diode_2
XFILLER_19_51 vssd1 vssd1 vccd1 vccd1 sky130_fd_sc_hd__fill_4
XFILLER_19_84 vssd1 vssd1 vccd1 vccd1 sky130_fd_sc_hd__fill_1
XFILLER_15_355 vssd1 vssd1 vccd1 vccd1 sky130_fd_sc_hd__fill_1
XFILLER_27_193 vssd1 vssd1 vccd1 vccd1 sky130_fd_sc_hd__fill_2
XFILLER_35_72 vssd1 vssd1 vccd1 vccd1 sky130_fd_sc_hd__fill_1
XFILLER_42_130 vssd1 vssd1 vccd1 vccd1 sky130_fd_sc_hd__fill_1
XFILLER_2_281 vssd1 vssd1 vccd1 vccd1 sky130_fd_sc_hd__fill_1
X_2310_ _2156_/A _1344_/B _2313_/B1 hold379/X vssd1 vssd1 vccd1 vccd1 _2786_/D sky130_fd_sc_hd__a2bb2o_2
X_2241_ _2768_/Q _2722_/Q vssd1 vssd1 vccd1 vccd1 _2241_/Y sky130_fd_sc_hd__nor2_2
X_2172_ hold274/X hold252/X _2189_/S vssd1 vssd1 vccd1 vccd1 _2728_/D sky130_fd_sc_hd__mux2_1
XFILLER_53_406 vssd1 vssd1 vccd1 vccd1 sky130_fd_sc_hd__fill_1
XTAP_TAPCELL_ROW_48_475 vssd1 vccd1 sky130_fd_sc_hd__tapvpwrvgnd_1
X_1887_ _2641_/Q _1886_/X _1891_/S vssd1 vssd1 vccd1 vccd1 _2641_/D sky130_fd_sc_hd__mux2_1
X_1956_ _1963_/A _2683_/Q vssd1 vssd1 vccd1 vccd1 _1958_/C sky130_fd_sc_hd__nand2_2
Xoutput19 _2551_/Q vssd1 vssd1 vccd1 vccd1 gpio_out[22] sky130_fd_sc_hd__clkdlybuf4s25_1
X_2508_ _2508_/A _2508_/B _2508_/C vssd1 vssd1 vccd1 vccd1 _2860_/D sky130_fd_sc_hd__and3_2
X_2439_ _2462_/B _2436_/B _2837_/Q vssd1 vssd1 vccd1 vccd1 _2439_/X sky130_fd_sc_hd__o21ba_2
XFILLER_8_318 vssd1 vssd1 vccd1 vccd1 sky130_fd_sc_hd__fill_1
XFILLER_21_41 vssd1 vssd1 vccd1 vccd1 sky130_fd_sc_hd__fill_4
XFILLER_47_277 vssd1 vssd1 vccd1 vccd1 sky130_fd_sc_hd__fill_1
XTAP_TAPCELL_ROW_45_456 vssd1 vccd1 sky130_fd_sc_hd__tapvpwrvgnd_1
Xmax_cap72 _1590_/B vssd1 vssd1 vccd1 vccd1 _1651_/B sky130_fd_sc_hd__clkbuf_2
XFILLER_30_122 vssd1 vssd1 vccd1 vccd1 sky130_fd_sc_hd__fill_1
XFILLER_30_199 vssd1 vssd1 vccd1 vccd1 sky130_fd_sc_hd__fill_1
X_1741_ _1756_/B _1741_/B _1741_/C vssd1 vssd1 vccd1 vccd1 _1741_/X sky130_fd_sc_hd__and3_2
X_1810_ _1810_/A1 _2662_/Q _1810_/B1 _2711_/Q _1810_/C1 vssd1 vssd1 vccd1 vccd1 _1810_/X
+ sky130_fd_sc_hd__a221o_2
X_2790_ clkload9/A _2790_/D fanout107/X vssd1 vssd1 vccd1 vccd1 _2790_/Q sky130_fd_sc_hd__dfrtp_2
X_1672_ hold319/X _2625_/Q _1691_/S vssd1 vssd1 vccd1 vccd1 _1672_/X sky130_fd_sc_hd__mux2_1
Xhold307 _2583_/Q vssd1 vssd1 vccd1 vccd1 hold307/X sky130_fd_sc_hd__dlygate4sd3_1
Xhold318 _2535_/Q vssd1 vssd1 vccd1 vccd1 hold318/X sky130_fd_sc_hd__dlygate4sd3_1
Xhold329 _2574_/Q vssd1 vssd1 vccd1 vccd1 hold329/X sky130_fd_sc_hd__dlygate4sd3_1
XFILLER_38_244 vssd1 vssd1 vccd1 vccd1 sky130_fd_sc_hd__fill_8
X_2224_ _2225_/A _2225_/B vssd1 vssd1 vccd1 vccd1 _2224_/X sky130_fd_sc_hd__or2_2
X_2155_ _2155_/A _2168_/S vssd1 vssd1 vccd1 vccd1 _2155_/Y sky130_fd_sc_hd__nor2_2
X_2086_ _2583_/Q _2567_/Q _2118_/S vssd1 vssd1 vccd1 vccd1 _2086_/X sky130_fd_sc_hd__mux2_1
X_1939_ _1940_/A _2687_/Q vssd1 vssd1 vccd1 vccd1 _1942_/B sky130_fd_sc_hd__or2_2
XANTENNA__1692__A1 _2646_/Q vssd1 vssd1 vccd1 vccd1 sky130_fd_sc_hd__diode_2
XFILLER_17_406 vssd1 vssd1 vccd1 vccd1 sky130_fd_sc_hd__fill_1
XFILLER_16_85 vssd1 vssd1 vccd1 vccd1 sky130_fd_sc_hd__fill_2
XFILLER_8_115 vssd1 vssd1 vccd1 vccd1 sky130_fd_sc_hd__fill_4
XPHY_EDGE_ROW_11_Right_11 vssd1 vssd1 vccd1 vccd1 sky130_fd_sc_hd__decap_3
XTAP_TAPCELL_ROW_42_437 vssd1 vccd1 sky130_fd_sc_hd__tapvpwrvgnd_1
XTAP_TAPCELL_ROW_50_492 vssd1 vccd1 sky130_fd_sc_hd__tapvpwrvgnd_1
XPHY_EDGE_ROW_20_Right_20 vssd1 vssd1 vccd1 vccd1 sky130_fd_sc_hd__decap_3
XTAP_TAPCELL_ROW_7_192 vssd1 vccd1 sky130_fd_sc_hd__tapvpwrvgnd_1
XANTENNA__1683__A1 _2637_/Q vssd1 vssd1 vccd1 vccd1 sky130_fd_sc_hd__diode_2
X_2911_ clkload9/A _2911_/D load_slew108/X vssd1 vssd1 vccd1 vccd1 _2911_/Q sky130_fd_sc_hd__dfrtp_2
X_1724_ hold348/X _1641_/X _1724_/S vssd1 vssd1 vccd1 vccd1 _2611_/D sky130_fd_sc_hd__mux2_1
X_2842_ _2845_/CLK _2842_/D load_slew83/X vssd1 vssd1 vccd1 vccd1 _2842_/Q sky130_fd_sc_hd__dfrtp_2
X_2773_ _2774_/CLK _2773_/D fanout132/X vssd1 vssd1 vccd1 vccd1 _2773_/Q sky130_fd_sc_hd__dfrtp_2
XANTENNA__2686__RESET_B fanout99/X vssd1 vssd1 vccd1 vccd1 sky130_fd_sc_hd__diode_2
XFILLER_58_317 vssd1 vssd1 vccd1 vccd1 sky130_fd_sc_hd__fill_1
X_1586_ _2871_/Q _1586_/B vssd1 vssd1 vccd1 vccd1 _1586_/Y sky130_fd_sc_hd__nand2_2
X_1655_ hold285/X _2555_/Q _1658_/S vssd1 vssd1 vccd1 vccd1 _2555_/D sky130_fd_sc_hd__mux2_1
XTAP_TAPCELL_ROW_56_529 vssd1 vccd1 sky130_fd_sc_hd__tapvpwrvgnd_1
X_2207_ _2216_/A _2207_/B vssd1 vssd1 vccd1 vccd1 _2209_/A sky130_fd_sc_hd__nand2b_2
X_2138_ _2577_/Q hold412/X _2138_/S vssd1 vssd1 vccd1 vccd1 _2138_/X sky130_fd_sc_hd__mux2_1
X_2069_ _1987_/A _2696_/Q _2069_/B1 vssd1 vssd1 vccd1 vccd1 _2069_/X sky130_fd_sc_hd__a21o_2
XTAP_TAPCELL_ROW_64_595 vssd1 vccd1 sky130_fd_sc_hd__tapvpwrvgnd_1
XANTENNA__1665__A1 _2618_/Q vssd1 vssd1 vccd1 vccd1 sky130_fd_sc_hd__diode_2
XFILLER_27_51 vssd1 vssd1 vccd1 vccd1 sky130_fd_sc_hd__fill_1
XFILLER_4_184 vssd1 vssd1 vccd1 vccd1 sky130_fd_sc_hd__fill_1
XFILLER_4_77 vssd1 vssd1 vccd1 vccd1 sky130_fd_sc_hd__fill_2
X_1371_ _1371_/A _1371_/B _1371_/C vssd1 vssd1 vccd1 vccd1 _1371_/X sky130_fd_sc_hd__or3_2
X_1440_ _2904_/Q _1444_/C vssd1 vssd1 vccd1 vccd1 _1440_/X sky130_fd_sc_hd__or2_2
XFILLER_0_390 vssd1 vssd1 vccd1 vccd1 sky130_fd_sc_hd__fill_2
XTAP_TAPCELL_ROW_18_264 vssd1 vccd1 sky130_fd_sc_hd__tapvpwrvgnd_1
XTAP_TAPCELL_ROW_61_565 vssd1 vccd1 sky130_fd_sc_hd__tapvpwrvgnd_1
Xclkbuf_3_2__f_clk clkbuf_0_clk/X vssd1 vssd1 vccd1 vccd1 clkbuf_leaf_9_clk/A sky130_fd_sc_hd__clkbuf_16
X_2825_ clkload3/A _2825_/D _2473_/A1 vssd1 vssd1 vccd1 vccd1 _2825_/Q sky130_fd_sc_hd__dfrtp_2
X_1638_ _2647_/Q _1716_/S _1810_/A1 _2662_/Q vssd1 vssd1 vccd1 vccd1 _1638_/X sky130_fd_sc_hd__a22o_2
X_1707_ _2622_/Q _2639_/Q _1710_/S vssd1 vssd1 vccd1 vccd1 _1707_/X sky130_fd_sc_hd__mux2_1
X_2756_ _2772_/CLK _2756_/D fanout143/X vssd1 vssd1 vccd1 vccd1 _2756_/Q sky130_fd_sc_hd__dfrtp_2
X_2687_ _2688_/CLK _2687_/D load_slew95/X vssd1 vssd1 vccd1 vccd1 _2687_/Q sky130_fd_sc_hd__dfrtp_2
XANTENNA__1895__A1 _2643_/Q vssd1 vssd1 vccd1 vccd1 sky130_fd_sc_hd__diode_2
XANTENNA_fanout182_X _1351_/A vssd1 vssd1 vccd1 vccd1 sky130_fd_sc_hd__diode_2
X_1569_ hold334/X _1581_/A2 _1568_/X vssd1 vssd1 vccd1 vccd1 _2529_/D sky130_fd_sc_hd__a21o_2
XANTENNA__2109__S _2136_/B vssd1 vssd1 vccd1 vccd1 sky130_fd_sc_hd__diode_2
XFILLER_14_206 vssd1 vssd1 vccd1 vccd1 sky130_fd_sc_hd__fill_1
XFILLER_13_42 vssd1 vssd1 vccd1 vccd1 sky130_fd_sc_hd__fill_1
XFILLER_13_75 vssd1 vssd1 vccd1 vccd1 sky130_fd_sc_hd__fill_1
Xfanout98 fanout99/X vssd1 vssd1 vccd1 vccd1 fanout98/X sky130_fd_sc_hd__clkdlybuf4s25_1
Xfanout87 fanout88/X vssd1 vssd1 vccd1 vccd1 _2331_/B sky130_fd_sc_hd__clkdlybuf4s25_1
Xfanout76 _2156_/B vssd1 vssd1 vccd1 vccd1 _2323_/B1 sky130_fd_sc_hd__clkdlybuf4s25_1
Xfanout65 _1590_/Y vssd1 vssd1 vccd1 vccd1 _1624_/S sky130_fd_sc_hd__clkdlybuf4s25_1
Xfanout54 _1850_/X vssd1 vssd1 vccd1 vccd1 _1909_/S sky130_fd_sc_hd__clkdlybuf4s25_1
Xfanout43 _1551_/Y vssd1 vssd1 vccd1 vccd1 _1581_/A2 sky130_fd_sc_hd__clkdlybuf4s25_1
Xfanout32 _2416_/X vssd1 vssd1 vccd1 vccd1 _2462_/B sky130_fd_sc_hd__clkdlybuf4s25_1
XANTENNA__1683__S _1686_/S vssd1 vssd1 vccd1 vccd1 sky130_fd_sc_hd__diode_2
Xhold490 _2771_/Q vssd1 vssd1 vccd1 vccd1 hold490/X sky130_fd_sc_hd__dlygate4sd3_1
XANTENNA__1638__A1 _2647_/Q vssd1 vssd1 vccd1 vccd1 sky130_fd_sc_hd__diode_2
XANTENNA__1886__A1 _2705_/Q vssd1 vssd1 vccd1 vccd1 sky130_fd_sc_hd__diode_2
XFILLER_38_72 vssd1 vssd1 vccd1 vccd1 sky130_fd_sc_hd__fill_1
XFILLER_38_94 vssd1 vssd1 vccd1 vccd1 sky130_fd_sc_hd__fill_4
XFILLER_49_169 vssd1 vssd1 vccd1 vccd1 sky130_fd_sc_hd__fill_4
XFILLER_9_243 vssd1 vssd1 vccd1 vccd1 sky130_fd_sc_hd__fill_1
XTAP_TAPCELL_ROW_15_245 vssd1 vccd1 sky130_fd_sc_hd__tapvpwrvgnd_1
XFILLER_9_265 vssd1 vssd1 vccd1 vccd1 sky130_fd_sc_hd__fill_4
Xclkload13 _2769_/CLK vssd1 vssd1 vccd1 vccd1 clkload13/Y sky130_fd_sc_hd__clkinv_2
X_2610_ _2647_/CLK _2610_/D vssd1 vssd1 vccd1 vccd1 _2610_/Q sky130_fd_sc_hd__dfxtp_2
X_2541_ _2671_/CLK _2541_/D load_slew101/X vssd1 vssd1 vccd1 vccd1 _2541_/Q sky130_fd_sc_hd__dfrtp_2
X_2472_ _2472_/A _2472_/B vssd1 vssd1 vccd1 vccd1 _2508_/A sky130_fd_sc_hd__or2_2
XFILLER_48_3 vssd1 vssd1 vccd1 vccd1 sky130_fd_sc_hd__fill_1
X_1285_ _2969_/A _1285_/B vssd1 vssd1 vccd1 vccd1 _1293_/A sky130_fd_sc_hd__nor2_2
X_1354_ _2873_/Q _2713_/Q vssd1 vssd1 vccd1 vccd1 _2878_/D sky130_fd_sc_hd__and2_2
X_1423_ _2898_/Q _2897_/Q _2899_/Q vssd1 vssd1 vccd1 vccd1 _1423_/X sky130_fd_sc_hd__a21o_2
XANTENNA__1629__A1 _2644_/Q vssd1 vssd1 vccd1 vccd1 sky130_fd_sc_hd__diode_2
XANTENNA__1629__B2 _2708_/Q vssd1 vssd1 vccd1 vccd1 sky130_fd_sc_hd__diode_2
Xclkload7 clkload7/A vssd1 vssd1 vccd1 vccd1 clkload7/Y sky130_fd_sc_hd__clkinv_2
X_2808_ clkload3/A _2808_/D vssd1 vssd1 vccd1 vccd1 _2808_/Q sky130_fd_sc_hd__dfxtp_2
X_2739_ _2869_/CLK _2739_/D fanout122/X vssd1 vssd1 vccd1 vccd1 _2739_/Q sky130_fd_sc_hd__dfrtp_2
XTAP_TAPCELL_ROW_12_226 vssd1 vccd1 sky130_fd_sc_hd__tapvpwrvgnd_1
XFILLER_6_279 vssd1 vssd1 vccd1 vccd1 sky130_fd_sc_hd__fill_2
XTAP_TAPCELL_ROW_20_281 vssd1 vccd1 sky130_fd_sc_hd__tapvpwrvgnd_1
XANTENNA__2520__A2 _2470_/D vssd1 vssd1 vccd1 vccd1 sky130_fd_sc_hd__diode_2
XFILLER_37_106 vssd1 vssd1 vccd1 vccd1 sky130_fd_sc_hd__fill_2
XANTENNA__2284__A1 _1366_/A vssd1 vssd1 vccd1 vccd1 sky130_fd_sc_hd__diode_2
X_1972_ _1953_/Y _1970_/A _1970_/B _2008_/B _2014_/B vssd1 vssd1 vccd1 vccd1 _1973_/B
+ sky130_fd_sc_hd__o311a_2
XPHY_EDGE_ROW_49_Right_49 vssd1 vssd1 vccd1 vccd1 sky130_fd_sc_hd__decap_3
X_2524_ _2866_/CLK _2524_/D vssd1 vssd1 vccd1 vccd1 _2524_/Q sky130_fd_sc_hd__dfxtp_2
X_2455_ _2461_/C _2416_/X _2459_/B _2841_/Q vssd1 vssd1 vccd1 vccd1 _2455_/X sky130_fd_sc_hd__a2bb2o_2
XPHY_EDGE_ROW_58_Right_58 vssd1 vssd1 vccd1 vccd1 sky130_fd_sc_hd__decap_3
X_1268_ _2846_/Q vssd1 vssd1 vccd1 vccd1 _2470_/A sky130_fd_sc_hd__inv_2
X_1337_ _2738_/Q _1337_/B vssd1 vssd1 vccd1 vccd1 _1337_/X sky130_fd_sc_hd__or2_2
X_1406_ _2920_/Q _2817_/Q _2921_/Q vssd1 vssd1 vccd1 vccd1 _1406_/X sky130_fd_sc_hd__or3b_2
X_2386_ _2386_/A _2387_/B vssd1 vssd1 vccd1 vccd1 _2819_/D sky130_fd_sc_hd__nor2_2
XANTENNA__2882__RESET_B fanout99/A vssd1 vssd1 vccd1 vccd1 sky130_fd_sc_hd__diode_2
XANTENNA_fanout145_X fanout145/X vssd1 vssd1 vccd1 vccd1 sky130_fd_sc_hd__diode_2
XFILLER_36_150 vssd1 vssd1 vccd1 vccd1 sky130_fd_sc_hd__fill_2
XFILLER_3_216 vssd1 vssd1 vccd1 vccd1 sky130_fd_sc_hd__fill_2
XFILLER_42_164 vssd1 vssd1 vccd1 vccd1 sky130_fd_sc_hd__fill_2
XFILLER_42_197 vssd1 vssd1 vccd1 vccd1 sky130_fd_sc_hd__fill_4
X_2240_ _2155_/A _2238_/Y _2239_/X hold376/X _2260_/A2 vssd1 vssd1 vccd1 vccd1 _2752_/D
+ sky130_fd_sc_hd__a32o_2
X_2171_ hold265/X hold250/X _2189_/S vssd1 vssd1 vccd1 vccd1 _2727_/D sky130_fd_sc_hd__mux2_1
XFILLER_33_197 vssd1 vssd1 vccd1 vccd1 sky130_fd_sc_hd__fill_1
XTAP_TAPCELL_ROW_48_476 vssd1 vccd1 sky130_fd_sc_hd__tapvpwrvgnd_1
XTAP_TAPCELL_ROW_31_354 vssd1 vccd1 sky130_fd_sc_hd__tapvpwrvgnd_1
X_1886_ _2705_/Q _1869_/B _1885_/X _1900_/C vssd1 vssd1 vccd1 vccd1 _1886_/X sky130_fd_sc_hd__a22o_2
X_1955_ _1963_/A _2683_/Q vssd1 vssd1 vccd1 vccd1 _1958_/B sky130_fd_sc_hd__or2_2
XANTENNA_fanout105_A fanout99/A vssd1 vssd1 vccd1 vccd1 sky130_fd_sc_hd__diode_2
X_2507_ _2858_/Q _2859_/Q _2502_/B _2860_/Q vssd1 vssd1 vccd1 vccd1 _2508_/C sky130_fd_sc_hd__a31o_2
X_2438_ hold511/X _2459_/B _2437_/X vssd1 vssd1 vccd1 vccd1 _2836_/D sky130_fd_sc_hd__a21o_2
XTAP_TAPCELL_ROW_39_410 vssd1 vccd1 sky130_fd_sc_hd__tapvpwrvgnd_1
X_2369_ _2850_/Q _2852_/Q _2860_/Q _2861_/Q vssd1 vssd1 vccd1 vccd1 _2369_/X sky130_fd_sc_hd__and4_2
XANTENNA__2117__S _2882_/D vssd1 vssd1 vccd1 vccd1 sky130_fd_sc_hd__diode_2
XFILLER_47_223 vssd1 vssd1 vccd1 vccd1 sky130_fd_sc_hd__fill_1
XFILLER_47_234 vssd1 vssd1 vccd1 vccd1 sky130_fd_sc_hd__fill_4
XTAP_TAPCELL_ROW_45_457 vssd1 vccd1 sky130_fd_sc_hd__tapvpwrvgnd_1
Xmax_cap73 _1590_/B vssd1 vssd1 vccd1 vccd1 _1725_/C sky130_fd_sc_hd__clkbuf_2
XFILLER_7_55 vssd1 vssd1 vccd1 vccd1 sky130_fd_sc_hd__fill_1
X_1671_ hold335/X _2624_/Q _1691_/S vssd1 vssd1 vccd1 vccd1 _2570_/D sky130_fd_sc_hd__mux2_1
X_1740_ _2616_/Q _2555_/Q _1739_/C _1739_/D vssd1 vssd1 vccd1 vccd1 _1741_/C sky130_fd_sc_hd__a22o_2
Xhold308 _2598_/Q vssd1 vssd1 vccd1 vccd1 hold308/X sky130_fd_sc_hd__dlygate4sd3_1
XFILLER_30_3 vssd1 vssd1 vccd1 vccd1 sky130_fd_sc_hd__fill_1
Xhold319 _2571_/Q vssd1 vssd1 vccd1 vccd1 hold319/X sky130_fd_sc_hd__dlygate4sd3_1
XFILLER_38_267 vssd1 vssd1 vccd1 vccd1 sky130_fd_sc_hd__fill_2
X_2223_ _2212_/Y _2217_/B _2214_/B vssd1 vssd1 vccd1 vccd1 _2225_/B sky130_fd_sc_hd__o21a_2
X_2154_ hold365/X hold358/X _2154_/S vssd1 vssd1 vccd1 vccd1 _2712_/D sky130_fd_sc_hd__mux2_1
X_2085_ hold507/X _2084_/X _2882_/D vssd1 vssd1 vccd1 vccd1 _2669_/D sky130_fd_sc_hd__mux2_1
XFILLER_61_270 vssd1 vssd1 vccd1 vccd1 sky130_fd_sc_hd__fill_1
X_1869_ _2701_/Q _1869_/B vssd1 vssd1 vccd1 vccd1 _1869_/X sky130_fd_sc_hd__and2_2
X_1938_ _2673_/Q _1938_/B _1938_/C vssd1 vssd1 vccd1 vccd1 _2031_/B sky130_fd_sc_hd__nand3_2
XFILLER_29_223 vssd1 vssd1 vccd1 vccd1 sky130_fd_sc_hd__fill_1
XANTENNA__1686__S _1686_/S vssd1 vssd1 vccd1 vccd1 sky130_fd_sc_hd__diode_2
XFILLER_12_134 vssd1 vssd1 vccd1 vccd1 sky130_fd_sc_hd__fill_1
XFILLER_32_85 vssd1 vssd1 vccd1 vccd1 sky130_fd_sc_hd__fill_2
XTAP_TAPCELL_ROW_50_493 vssd1 vccd1 sky130_fd_sc_hd__tapvpwrvgnd_1
XANTENNA__2157__A0 _2154_/S vssd1 vssd1 vccd1 vccd1 sky130_fd_sc_hd__diode_2
XFILLER_4_355 vssd1 vssd1 vccd1 vccd1 sky130_fd_sc_hd__fill_1
X_2910_ _2912_/CLK _2910_/D fanout117/A vssd1 vssd1 vccd1 vccd1 _2910_/Q sky130_fd_sc_hd__dfrtp_2
X_2841_ _2845_/CLK _2841_/D load_slew83/X vssd1 vssd1 vccd1 vccd1 _2841_/Q sky130_fd_sc_hd__dfrtp_2
XANTENNA__2148__A0 _2706_/Q vssd1 vssd1 vccd1 vccd1 sky130_fd_sc_hd__diode_2
X_1654_ _1662_/D _1654_/B _1653_/X vssd1 vssd1 vccd1 vccd1 _2554_/D sky130_fd_sc_hd__or3b_2
X_1723_ hold252/X _1722_/X _1723_/S vssd1 vssd1 vccd1 vccd1 _2610_/D sky130_fd_sc_hd__mux2_1
X_2772_ _2772_/CLK _2772_/D fanout143/X vssd1 vssd1 vccd1 vccd1 _2772_/Q sky130_fd_sc_hd__dfrtp_2
XFILLER_58_307 vssd1 vssd1 vccd1 vccd1 sky130_fd_sc_hd__fill_1
X_1585_ _2871_/Q _1586_/B vssd1 vssd1 vccd1 vccd1 _1585_/X sky130_fd_sc_hd__and2_2
X_2206_ _2763_/Q _2717_/Q vssd1 vssd1 vccd1 vccd1 _2207_/B sky130_fd_sc_hd__nand2_2
XTAP_TAPCELL_ROW_64_585 vssd1 vccd1 sky130_fd_sc_hd__tapvpwrvgnd_1
X_2137_ hold546/X _2136_/B _2138_/S vssd1 vssd1 vccd1 vccd1 _2695_/D sky130_fd_sc_hd__o21a_2
X_2068_ hold472/X _2067_/Y _2882_/Q vssd1 vssd1 vccd1 vccd1 _2662_/D sky130_fd_sc_hd__mux2_1
XTAP_TAPCELL_ROW_64_596 vssd1 vccd1 sky130_fd_sc_hd__tapvpwrvgnd_1
XANTENNA__1270__A _2071_/B vssd1 vssd1 vccd1 vccd1 sky130_fd_sc_hd__diode_2
XFILLER_40_251 vssd1 vssd1 vccd1 vccd1 sky130_fd_sc_hd__fill_1
XANTENNA__2040__S _2071_/B vssd1 vssd1 vccd1 vccd1 sky130_fd_sc_hd__diode_2
X_1370_ _2534_/Q _2533_/Q _2535_/Q _1370_/D vssd1 vssd1 vccd1 vccd1 _1371_/C sky130_fd_sc_hd__or4_2
XFILLER_48_373 vssd1 vssd1 vccd1 vccd1 sky130_fd_sc_hd__fill_1
XTAP_TAPCELL_ROW_18_265 vssd1 vccd1 sky130_fd_sc_hd__tapvpwrvgnd_1
XTAP_TAPCELL_ROW_61_566 vssd1 vccd1 sky130_fd_sc_hd__tapvpwrvgnd_1
X_2824_ clkload3/A _2824_/D _2473_/A1 vssd1 vssd1 vccd1 vccd1 _2824_/Q sky130_fd_sc_hd__dfrtp_2
XANTENNA__1592__A1 _2634_/Q vssd1 vssd1 vccd1 vccd1 sky130_fd_sc_hd__diode_2
X_1637_ _2629_/Q _1586_/Y _1624_/S hold492/X _1636_/X vssd1 vssd1 vccd1 vccd1 _2550_/D
+ sky130_fd_sc_hd__o221a_2
X_1706_ hold243/X _1705_/X _1721_/S vssd1 vssd1 vccd1 vccd1 _2601_/D sky130_fd_sc_hd__mux2_1
X_2755_ _2772_/CLK _2755_/D fanout143/X vssd1 vssd1 vccd1 vccd1 _2755_/Q sky130_fd_sc_hd__dfrtp_2
X_2686_ clkload5/A _2686_/D fanout99/X vssd1 vssd1 vccd1 vccd1 _2686_/Q sky130_fd_sc_hd__dfrtp_2
XANTENNA__1361__Y _2470_/D vssd1 vssd1 vccd1 vccd1 sky130_fd_sc_hd__diode_2
XANTENNA_fanout175_X _1366_/A vssd1 vssd1 vccd1 vccd1 sky130_fd_sc_hd__diode_2
XFILLER_58_159 vssd1 vssd1 vccd1 vccd1 sky130_fd_sc_hd__fill_1
X_1499_ _1499_/A _1499_/B _1510_/A vssd1 vssd1 vccd1 vccd1 _1533_/B sky130_fd_sc_hd__or3b_2
X_1568_ _1580_/A _2641_/Q _1701_/S vssd1 vssd1 vccd1 vccd1 _1568_/X sky130_fd_sc_hd__and3_2
XTAP_TAPCELL_ROW_1_144 vssd1 vccd1 sky130_fd_sc_hd__tapvpwrvgnd_1
Xfanout55 _1731_/Y vssd1 vssd1 vccd1 vccd1 _1819_/B2 sky130_fd_sc_hd__clkdlybuf4s25_1
Xfanout44 _1724_/S vssd1 vssd1 vccd1 vccd1 _1701_/S sky130_fd_sc_hd__clkdlybuf4s25_1
Xfanout33 _1996_/A vssd1 vssd1 vccd1 vccd1 _2050_/A1 sky130_fd_sc_hd__clkdlybuf4s25_1
XANTENNA__2125__S _2125_/S vssd1 vssd1 vccd1 vccd1 sky130_fd_sc_hd__diode_2
XTAP_TAPCELL_ROW_9_200 vssd1 vccd1 sky130_fd_sc_hd__tapvpwrvgnd_1
Xfanout99 fanout99/A vssd1 vssd1 vccd1 vccd1 fanout99/X sky130_fd_sc_hd__clkdlybuf4s25_1
Xfanout88 fanout99/A vssd1 vssd1 vccd1 vccd1 fanout88/X sky130_fd_sc_hd__clkdlybuf4s25_1
Xfanout77 _2297_/B1 vssd1 vssd1 vccd1 vccd1 _2156_/B sky130_fd_sc_hd__clkdlybuf4s25_1
Xfanout66 _2313_/B1 vssd1 vssd1 vccd1 vccd1 _2299_/B sky130_fd_sc_hd__clkdlybuf4s25_1
XFILLER_49_115 vssd1 vssd1 vccd1 vccd1 sky130_fd_sc_hd__fill_1
Xhold480 _2832_/Q vssd1 vssd1 vccd1 vccd1 _2419_/A sky130_fd_sc_hd__dlygate4sd3_1
Xhold491 _2660_/Q vssd1 vssd1 vccd1 vccd1 hold491/X sky130_fd_sc_hd__dlygate4sd3_1
XFILLER_45_365 vssd1 vssd1 vccd1 vccd1 sky130_fd_sc_hd__fill_1
XFILLER_64_107 vssd1 vssd1 vccd1 vccd1 sky130_fd_sc_hd__fill_1
XFILLER_13_295 vssd1 vssd1 vccd1 vccd1 sky130_fd_sc_hd__fill_1
XFILLER_54_83 vssd1 vssd1 vccd1 vccd1 sky130_fd_sc_hd__fill_1
XPHY_EDGE_ROW_41_Left_106 vssd1 vssd1 vccd1 vccd1 sky130_fd_sc_hd__decap_3
XTAP_TAPCELL_ROW_15_246 vssd1 vccd1 sky130_fd_sc_hd__tapvpwrvgnd_1
X_1422_ _2898_/Q _2897_/Q _2899_/Q vssd1 vssd1 vccd1 vccd1 _1422_/Y sky130_fd_sc_hd__nand3_2
X_2540_ clkload7/A _2540_/D load_slew127/X vssd1 vssd1 vccd1 vccd1 _2540_/Q sky130_fd_sc_hd__dfrtp_2
X_2471_ _2370_/A _2472_/A _2470_/A vssd1 vssd1 vccd1 vccd1 _2471_/X sky130_fd_sc_hd__o21a_2
XANTENNA__1903__A _2646_/Q vssd1 vssd1 vccd1 vccd1 sky130_fd_sc_hd__diode_2
XPHY_EDGE_ROW_50_Left_115 vssd1 vssd1 vccd1 vccd1 sky130_fd_sc_hd__decap_3
X_1284_ _1285_/B vssd1 vssd1 vccd1 vccd1 _1284_/Y sky130_fd_sc_hd__inv_2
X_1353_ _2866_/Q _2154_/S _1373_/A vssd1 vssd1 vccd1 vccd1 _2866_/D sky130_fd_sc_hd__o21ba_2
XFILLER_36_398 vssd1 vssd1 vccd1 vccd1 sky130_fd_sc_hd__fill_1
Xclkload8 clkload8/A vssd1 vssd1 vccd1 vccd1 clkload8/X sky130_fd_sc_hd__clkbuf_8
X_2807_ clkload3/A _2807_/D vssd1 vssd1 vccd1 vccd1 _2807_/Q sky130_fd_sc_hd__dfxtp_2
X_2738_ _2870_/CLK _2738_/D load_slew121/X vssd1 vssd1 vccd1 vccd1 _2738_/Q sky130_fd_sc_hd__dfrtp_2
X_2669_ _2688_/CLK _2669_/D load_slew95/X vssd1 vssd1 vccd1 vccd1 _2669_/Q sky130_fd_sc_hd__dfrtp_2
XFILLER_46_118 vssd1 vssd1 vccd1 vccd1 sky130_fd_sc_hd__fill_2
XFILLER_10_243 vssd1 vssd1 vccd1 vccd1 sky130_fd_sc_hd__fill_2
XFILLER_24_75 vssd1 vssd1 vccd1 vccd1 sky130_fd_sc_hd__fill_1
XTAP_TAPCELL_ROW_12_227 vssd1 vccd1 sky130_fd_sc_hd__tapvpwrvgnd_1
XFILLER_40_85 vssd1 vssd1 vccd1 vccd1 sky130_fd_sc_hd__fill_2
XTAP_TAPCELL_ROW_20_282 vssd1 vccd1 sky130_fd_sc_hd__tapvpwrvgnd_1
XFILLER_18_321 vssd1 vssd1 vccd1 vccd1 sky130_fd_sc_hd__fill_1
XFILLER_1_57 vssd1 vssd1 vccd1 vccd1 sky130_fd_sc_hd__fill_2
XFILLER_1_68 vssd1 vssd1 vccd1 vccd1 sky130_fd_sc_hd__fill_1
XFILLER_33_335 vssd1 vssd1 vccd1 vccd1 sky130_fd_sc_hd__fill_1
XFILLER_45_162 vssd1 vssd1 vccd1 vccd1 sky130_fd_sc_hd__fill_1
XFILLER_60_3 vssd1 vssd1 vccd1 vccd1 sky130_fd_sc_hd__fill_4
X_1971_ _1953_/Y _1970_/A _1970_/B _2008_/B vssd1 vssd1 vccd1 vccd1 _2015_/A sky130_fd_sc_hd__o31a_2
X_1405_ _1403_/Y _2389_/C _2921_/Q vssd1 vssd1 vccd1 vccd1 _1405_/Y sky130_fd_sc_hd__o21bai_2
X_2523_ _2866_/CLK _2523_/D vssd1 vssd1 vccd1 vccd1 _2523_/Q sky130_fd_sc_hd__dfxtp_2
X_2454_ _2841_/Q _2454_/B vssd1 vssd1 vccd1 vccd1 _2461_/C sky130_fd_sc_hd__and2_2
X_2385_ _2819_/Q _2818_/Q _2385_/C vssd1 vssd1 vccd1 vccd1 _2387_/B sky130_fd_sc_hd__and3_2
XTAP_TAPCELL_ROW_26_319 vssd1 vccd1 sky130_fd_sc_hd__tapvpwrvgnd_1
X_1267_ _2885_/Q vssd1 vssd1 vccd1 vccd1 _1267_/Y sky130_fd_sc_hd__inv_2
X_1336_ _1339_/B _1336_/B vssd1 vssd1 vccd1 vccd1 _1337_/B sky130_fd_sc_hd__nand2b_2
Xinput1 en vssd1 vssd1 vccd1 vccd1 input1/X sky130_fd_sc_hd__clkdlybuf4s25_1
XANTENNA__1786__B2 _2706_/Q vssd1 vssd1 vccd1 vccd1 sky130_fd_sc_hd__diode_2
XANTENNA__1809__A_N _1816_/B vssd1 vssd1 vccd1 vccd1 sky130_fd_sc_hd__diode_2
XANTENNA__1710__A1 _2641_/Q vssd1 vssd1 vccd1 vccd1 sky130_fd_sc_hd__diode_2
XANTENNA__1689__S _1693_/S vssd1 vssd1 vccd1 vccd1 sky130_fd_sc_hd__diode_2
XANTENNA__2266__A2 _2282_/A2 vssd1 vssd1 vccd1 vccd1 sky130_fd_sc_hd__diode_2
XFILLER_15_313 vssd1 vssd1 vccd1 vccd1 sky130_fd_sc_hd__fill_2
XFILLER_42_143 vssd1 vssd1 vccd1 vccd1 sky130_fd_sc_hd__fill_1
XFILLER_42_154 vssd1 vssd1 vccd1 vccd1 sky130_fd_sc_hd__fill_2
XTAP_TAPCELL_ROW_48_477 vssd1 vccd1 sky130_fd_sc_hd__tapvpwrvgnd_1
X_2170_ hold257/X hold242/X _2189_/S vssd1 vssd1 vccd1 vccd1 _2726_/D sky130_fd_sc_hd__mux2_1
XFILLER_33_121 vssd1 vssd1 vccd1 vccd1 sky130_fd_sc_hd__fill_1
X_1954_ _2669_/Q _1954_/B _1954_/C vssd1 vssd1 vccd1 vccd1 _2008_/B sky130_fd_sc_hd__nand3_2
XTAP_TAPCELL_ROW_31_355 vssd1 vccd1 sky130_fd_sc_hd__tapvpwrvgnd_1
X_1885_ _2641_/Q _1885_/B vssd1 vssd1 vccd1 vccd1 _1885_/X sky130_fd_sc_hd__xor2_2
X_2506_ _2509_/B vssd1 vssd1 vccd1 vccd1 _2508_/B sky130_fd_sc_hd__inv_2
X_2437_ _2836_/Q _2435_/B _2436_/Y vssd1 vssd1 vccd1 vccd1 _2437_/X sky130_fd_sc_hd__o21ba_2
X_2368_ _2851_/Q _2853_/Q _2368_/C _2368_/D vssd1 vssd1 vccd1 vccd1 _2371_/B sky130_fd_sc_hd__or4_2
XTAP_TAPCELL_ROW_39_411 vssd1 vccd1 sky130_fd_sc_hd__tapvpwrvgnd_1
X_1319_ _2731_/Q _1319_/B _1319_/C vssd1 vssd1 vccd1 vccd1 _1319_/X sky130_fd_sc_hd__or3_2
X_2299_ _2299_/A _2299_/B vssd1 vssd1 vccd1 vccd1 _2299_/Y sky130_fd_sc_hd__nand2_2
XANTENNA__1759__B2 _2701_/Q vssd1 vssd1 vccd1 vccd1 sky130_fd_sc_hd__diode_2
XTAP_TAPCELL_ROW_45_458 vssd1 vccd1 sky130_fd_sc_hd__tapvpwrvgnd_1
Xmax_cap74 wire75/X vssd1 vssd1 vccd1 vccd1 _1517_/B sky130_fd_sc_hd__clkbuf_1
XANTENNA__2773__RESET_B fanout132/X vssd1 vssd1 vccd1 vccd1 sky130_fd_sc_hd__diode_2
XFILLER_62_94 vssd1 vssd1 vccd1 vccd1 sky130_fd_sc_hd__fill_1
XFILLER_7_78 vssd1 vssd1 vccd1 vccd1 sky130_fd_sc_hd__fill_2
X_1670_ hold346/X _2623_/Q _1691_/S vssd1 vssd1 vccd1 vccd1 _2569_/D sky130_fd_sc_hd__mux2_1
Xhold309 _2612_/Q vssd1 vssd1 vccd1 vccd1 hold309/X sky130_fd_sc_hd__dlygate4sd3_1
X_2222_ _2222_/A _2222_/B vssd1 vssd1 vccd1 vccd1 _2225_/A sky130_fd_sc_hd__nand2_2
X_2153_ _2711_/Q hold414/X _2153_/S vssd1 vssd1 vccd1 vccd1 _2153_/X sky130_fd_sc_hd__mux2_1
X_2084_ _2582_/Q _2566_/Q _2120_/S vssd1 vssd1 vccd1 vccd1 _2084_/X sky130_fd_sc_hd__mux2_1
XFILLER_61_260 vssd1 vssd1 vccd1 vccd1 sky130_fd_sc_hd__fill_1
X_1937_ _1938_/B _1938_/C _2673_/Q vssd1 vssd1 vccd1 vccd1 _1937_/Y sky130_fd_sc_hd__a21oi_2
X_1799_ _2628_/Q _1798_/B _1770_/C vssd1 vssd1 vccd1 vccd1 _1800_/B sky130_fd_sc_hd__o21ai_2
X_1868_ _2636_/Q _1867_/X _1891_/S vssd1 vssd1 vccd1 vccd1 _2636_/D sky130_fd_sc_hd__mux2_1
XANTENNA__1821__A _1863_/C vssd1 vssd1 vccd1 vccd1 sky130_fd_sc_hd__diode_2
XFILLER_29_268 vssd1 vssd1 vccd1 vccd1 sky130_fd_sc_hd__fill_1
XFILLER_16_87 vssd1 vssd1 vccd1 vccd1 sky130_fd_sc_hd__fill_1
XFILLER_44_216 vssd1 vssd1 vccd1 vccd1 sky130_fd_sc_hd__fill_4
XANTENNA__1601__B1 _1385_/B vssd1 vssd1 vccd1 vccd1 sky130_fd_sc_hd__diode_2
XFILLER_12_179 vssd1 vssd1 vccd1 vccd1 sky130_fd_sc_hd__fill_2
X_2840_ clkload4/A _2840_/D load_slew83/X vssd1 vssd1 vccd1 vccd1 _2840_/Q sky130_fd_sc_hd__dfrtp_2
X_2771_ _2772_/CLK _2771_/D fanout143/X vssd1 vssd1 vccd1 vccd1 _2771_/Q sky130_fd_sc_hd__dfrtp_2
XFILLER_7_183 vssd1 vssd1 vccd1 vccd1 sky130_fd_sc_hd__fill_4
XPHY_EDGE_ROW_9_Right_9 vssd1 vssd1 vccd1 vccd1 sky130_fd_sc_hd__decap_3
X_1584_ _1822_/A _1821_/B vssd1 vssd1 vccd1 vccd1 _1586_/B sky130_fd_sc_hd__nor2_2
X_1653_ _2613_/Q _1650_/X _1658_/S _2612_/Q vssd1 vssd1 vccd1 vccd1 _1653_/X sky130_fd_sc_hd__o22a_2
X_1722_ _2630_/Q _2647_/Q _1722_/S vssd1 vssd1 vccd1 vccd1 _1722_/X sky130_fd_sc_hd__mux2_1
X_2205_ _2763_/Q _2717_/Q vssd1 vssd1 vccd1 vccd1 _2216_/A sky130_fd_sc_hd__nor2_2
XANTENNA__2472__A _2472_/A vssd1 vssd1 vccd1 vccd1 sky130_fd_sc_hd__diode_2
XANTENNA_fanout165_A _1662_/D vssd1 vssd1 vccd1 vccd1 sky130_fd_sc_hd__diode_2
XFILLER_26_216 vssd1 vccd1 vssd1 vccd1 sky130_ef_sc_hd__decap_40_12
XTAP_TAPCELL_ROW_64_586 vssd1 vccd1 sky130_fd_sc_hd__tapvpwrvgnd_1
XTAP_TAPCELL_ROW_64_597 vssd1 vccd1 sky130_fd_sc_hd__tapvpwrvgnd_1
X_2136_ _2075_/B _2136_/B vssd1 vssd1 vccd1 vccd1 _2138_/S sky130_fd_sc_hd__nand2b_2
X_2067_ _2067_/A _2067_/B vssd1 vssd1 vccd1 vccd1 _2067_/Y sky130_fd_sc_hd__xnor2_2
X_2969_ _2969_/A vssd1 vssd1 vccd1 vccd1 _2969_/X sky130_fd_sc_hd__buf_2
XANTENNA_fanout78_A _2297_/B1 vssd1 vssd1 vccd1 vccd1 sky130_fd_sc_hd__diode_2
XFILLER_27_31 vssd1 vssd1 vccd1 vccd1 sky130_fd_sc_hd__fill_2
XFILLER_40_296 vssd1 vssd1 vccd1 vccd1 sky130_fd_sc_hd__fill_1
XFILLER_4_131 vssd1 vssd1 vccd1 vccd1 sky130_fd_sc_hd__fill_1
XANTENNA__1353__A2 _2154_/S vssd1 vssd1 vccd1 vccd1 sky130_fd_sc_hd__diode_2
XFILLER_48_363 vssd1 vssd1 vccd1 vccd1 sky130_fd_sc_hd__fill_1
XTAP_TAPCELL_ROW_18_266 vssd1 vccd1 sky130_fd_sc_hd__tapvpwrvgnd_1
XFILLER_31_274 vssd1 vssd1 vccd1 vccd1 sky130_fd_sc_hd__fill_1
XTAP_TAPCELL_ROW_61_567 vssd1 vccd1 sky130_fd_sc_hd__tapvpwrvgnd_1
X_1705_ _2621_/Q _2638_/Q _1710_/S vssd1 vssd1 vccd1 vccd1 _1705_/X sky130_fd_sc_hd__mux2_1
X_2823_ _2880_/CLK _2823_/D _2473_/A1 vssd1 vssd1 vccd1 vccd1 _2823_/Q sky130_fd_sc_hd__dfrtp_2
X_2754_ _2769_/CLK _2754_/D fanout138/X vssd1 vssd1 vccd1 vccd1 _2754_/Q sky130_fd_sc_hd__dfrtp_2
X_1567_ hold302/X _1558_/B _1566_/X vssd1 vssd1 vccd1 vccd1 _2528_/D sky130_fd_sc_hd__a21o_2
X_1636_ _1385_/B _2710_/Q _1586_/B _1635_/X vssd1 vssd1 vccd1 vccd1 _1636_/X sky130_fd_sc_hd__a211o_2
X_2685_ clkload5/A _2685_/D fanout99/X vssd1 vssd1 vccd1 vccd1 _2685_/Q sky130_fd_sc_hd__dfrtp_2
XTAP_TAPCELL_ROW_1_145 vssd1 vccd1 sky130_fd_sc_hd__tapvpwrvgnd_1
X_1498_ _1498_/A _1498_/B vssd1 vssd1 vccd1 vccd1 _1510_/A sky130_fd_sc_hd__nor2_2
X_2119_ hold469/X _2118_/X _2125_/S vssd1 vssd1 vccd1 vccd1 _2686_/D sky130_fd_sc_hd__mux2_1
XTAP_TAPCELL_ROW_52_501 vssd1 vccd1 sky130_fd_sc_hd__tapvpwrvgnd_1
Xfanout89 fanout93/X vssd1 vssd1 vccd1 vccd1 fanout89/X sky130_fd_sc_hd__clkdlybuf4s25_1
Xfanout78 _2297_/B1 vssd1 vssd1 vccd1 vccd1 _2293_/B1 sky130_fd_sc_hd__clkdlybuf4s25_1
Xfanout67 _2282_/A2 vssd1 vssd1 vccd1 vccd1 _2313_/B1 sky130_fd_sc_hd__clkdlybuf4s25_1
Xfanout56 _1731_/Y vssd1 vssd1 vccd1 vccd1 _1810_/C1 sky130_fd_sc_hd__clkdlybuf4s25_1
Xfanout45 _1723_/S vssd1 vssd1 vccd1 vccd1 _1724_/S sky130_fd_sc_hd__clkdlybuf4s25_1
Xfanout34 _2056_/A vssd1 vssd1 vccd1 vccd1 _1996_/A sky130_fd_sc_hd__clkdlybuf4s25_1
XANTENNA__1546__A _1662_/D vssd1 vssd1 vccd1 vccd1 sky130_fd_sc_hd__diode_2
XANTENNA__2141__S _2154_/S vssd1 vssd1 vccd1 vccd1 sky130_fd_sc_hd__diode_2
XANTENNA__2703__Q _2703_/Q vssd1 vssd1 vccd1 vccd1 sky130_fd_sc_hd__diode_2
XTAP_TAPCELL_ROW_9_201 vssd1 vccd1 sky130_fd_sc_hd__tapvpwrvgnd_1
Xhold470 _2769_/Q vssd1 vssd1 vccd1 vccd1 hold470/X sky130_fd_sc_hd__dlygate4sd3_1
Xhold481 _2651_/Q vssd1 vssd1 vccd1 vccd1 hold481/X sky130_fd_sc_hd__dlygate4sd3_1
Xhold492 _2550_/Q vssd1 vssd1 vccd1 vccd1 hold492/X sky130_fd_sc_hd__dlygate4sd3_1
XANTENNA__2296__B1 _2297_/B1 vssd1 vssd1 vccd1 vccd1 sky130_fd_sc_hd__diode_2
XFILLER_38_85 vssd1 vssd1 vccd1 vccd1 sky130_fd_sc_hd__fill_1
XFILLER_45_355 vssd1 vssd1 vccd1 vccd1 sky130_fd_sc_hd__fill_1
XFILLER_13_263 vssd1 vssd1 vccd1 vccd1 sky130_fd_sc_hd__fill_1
XTAP_TAPCELL_ROW_15_247 vssd1 vccd1 sky130_fd_sc_hd__tapvpwrvgnd_1
X_1421_ _1477_/A1 _1419_/X _1420_/Y _1477_/B1 _2898_/Q vssd1 vssd1 vccd1 vccd1 _2898_/D
+ sky130_fd_sc_hd__a32o_2
X_2470_ _2470_/A _2969_/A _2470_/C _2470_/D vssd1 vssd1 vccd1 vccd1 wire48/A sky130_fd_sc_hd__nor4_2
XANTENNA__2287__B1 _2293_/B1 vssd1 vssd1 vccd1 vccd1 sky130_fd_sc_hd__diode_2
X_1283_ _2893_/Q _2894_/Q _2896_/Q _2895_/Q vssd1 vssd1 vccd1 vccd1 _1285_/B sky130_fd_sc_hd__or4b_2
X_1352_ _2866_/Q _1373_/A vssd1 vssd1 vccd1 vccd1 _2869_/D sky130_fd_sc_hd__and2_2
XANTENNA__1366__A _1366_/A vssd1 vssd1 vccd1 vccd1 sky130_fd_sc_hd__diode_2
Xclkload9 clkload9/A vssd1 vssd1 vccd1 vccd1 clkload9/Y sky130_fd_sc_hd__bufinv_16
X_2806_ _2813_/CLK _2806_/D vssd1 vssd1 vccd1 vccd1 _2806_/Q sky130_fd_sc_hd__dfxtp_2
X_2737_ _2869_/CLK _2737_/D load_slew121/X vssd1 vssd1 vccd1 vccd1 _2737_/Q sky130_fd_sc_hd__dfrtp_2
X_2668_ _2688_/CLK _2668_/D fanout94/X vssd1 vssd1 vccd1 vccd1 _2668_/Q sky130_fd_sc_hd__dfrtp_2
XANTENNA_input2_A gpio_in[0] vssd1 vssd1 vccd1 vccd1 sky130_fd_sc_hd__diode_2
X_1619_ _2641_/Q _1710_/S _1796_/A1 _2656_/Q vssd1 vssd1 vccd1 vccd1 _1619_/X sky130_fd_sc_hd__a22o_2
X_2599_ _2719_/CLK _2599_/D vssd1 vssd1 vccd1 vccd1 _2599_/Q sky130_fd_sc_hd__dfxtp_2
XFILLER_54_141 vssd1 vssd1 vccd1 vccd1 sky130_fd_sc_hd__fill_1
XFILLER_10_266 vssd1 vssd1 vccd1 vccd1 sky130_fd_sc_hd__fill_2
XFILLER_6_204 vssd1 vssd1 vccd1 vccd1 sky130_fd_sc_hd__fill_4
XFILLER_6_215 vssd1 vssd1 vccd1 vccd1 sky130_fd_sc_hd__fill_8
XTAP_TAPCELL_ROW_20_283 vssd1 vccd1 sky130_fd_sc_hd__tapvpwrvgnd_1
XANTENNA__1282__Y _2969_/A vssd1 vssd1 vccd1 vccd1 sky130_fd_sc_hd__diode_2
XANTENNA__2269__B1 _2263_/B vssd1 vssd1 vccd1 vccd1 sky130_fd_sc_hd__diode_2
XANTENNA__2727__RESET_B fanout132/X vssd1 vssd1 vccd1 vccd1 sky130_fd_sc_hd__diode_2
XFILLER_18_311 vssd1 vssd1 vccd1 vccd1 sky130_fd_sc_hd__fill_1
XFILLER_37_108 vssd1 vssd1 vccd1 vccd1 sky130_fd_sc_hd__fill_1
XFILLER_33_325 vssd1 vssd1 vccd1 vccd1 sky130_fd_sc_hd__fill_1
XPHY_EDGE_ROW_23_Left_88 vssd1 vssd1 vccd1 vccd1 sky130_fd_sc_hd__decap_3
X_1970_ _1970_/A _1970_/B vssd1 vssd1 vccd1 vccd1 _2009_/A sky130_fd_sc_hd__nor2_2
XFILLER_53_3 vssd1 vssd1 vccd1 vccd1 sky130_fd_sc_hd__fill_4
X_2522_ _2866_/CLK _2522_/D vssd1 vssd1 vccd1 vccd1 _2522_/Q sky130_fd_sc_hd__dfxtp_2
XANTENNA_clkbuf_3_0__f_clk_A clkbuf_0_clk/X vssd1 vssd1 vccd1 vccd1 sky130_fd_sc_hd__diode_2
XFILLER_5_281 vssd1 vssd1 vccd1 vccd1 sky130_fd_sc_hd__fill_1
X_1335_ _2798_/Q _2797_/Q _1330_/B _2799_/Q vssd1 vssd1 vccd1 vccd1 _1336_/B sky130_fd_sc_hd__a31o_2
X_1404_ _2816_/Q _2817_/Q vssd1 vssd1 vccd1 vccd1 _2389_/C sky130_fd_sc_hd__and2_2
X_2453_ _2416_/X _2452_/Y _2840_/Q _2472_/B vssd1 vssd1 vccd1 vccd1 _2840_/D sky130_fd_sc_hd__a2bb2o_2
X_2384_ _2818_/Q _2385_/C hold498/X vssd1 vssd1 vccd1 vccd1 _2386_/A sky130_fd_sc_hd__a21oi_2
XFILLER_36_152 vssd1 vssd1 vccd1 vccd1 sky130_fd_sc_hd__fill_1
XFILLER_51_111 vssd1 vssd1 vccd1 vccd1 sky130_fd_sc_hd__fill_1
X_1266_ _2919_/Q vssd1 vssd1 vccd1 vccd1 _2333_/B sky130_fd_sc_hd__inv_2
Xinput2 gpio_in[0] vssd1 vssd1 vccd1 vccd1 input2/X sky130_fd_sc_hd__clkdlybuf4s25_1
XFILLER_51_155 vssd1 vssd1 vccd1 vccd1 sky130_fd_sc_hd__fill_4
XTAP_TAPCELL_ROW_34_375 vssd1 vccd1 sky130_fd_sc_hd__tapvpwrvgnd_1
XANTENNA__1824__A _2636_/Q vssd1 vssd1 vccd1 vccd1 sky130_fd_sc_hd__diode_2
XFILLER_10_78 vssd1 vssd1 vccd1 vccd1 sky130_fd_sc_hd__fill_4
XFILLER_19_21 vssd1 vssd1 vccd1 vccd1 sky130_fd_sc_hd__fill_4
XFILLER_19_32 vssd1 vssd1 vccd1 vccd1 sky130_fd_sc_hd__fill_4
XTAP_TAPCELL_ROW_48_478 vssd1 vccd1 sky130_fd_sc_hd__tapvpwrvgnd_1
XTAP_TAPCELL_ROW_31_356 vssd1 vccd1 sky130_fd_sc_hd__tapvpwrvgnd_1
X_1884_ _2640_/Q _1891_/S _1882_/X _1883_/X vssd1 vssd1 vccd1 vccd1 _2640_/D sky130_fd_sc_hd__o22a_2
X_1953_ _1954_/B _1954_/C _2669_/Q vssd1 vssd1 vccd1 vccd1 _1953_/Y sky130_fd_sc_hd__a21oi_2
X_2505_ _2859_/Q _2860_/Q _2505_/C vssd1 vssd1 vccd1 vccd1 _2509_/B sky130_fd_sc_hd__and3_2
XFILLER_29_406 vssd1 vssd1 vccd1 vccd1 sky130_fd_sc_hd__fill_1
XTAP_TAPCELL_ROW_39_412 vssd1 vccd1 sky130_fd_sc_hd__tapvpwrvgnd_1
X_1318_ _2790_/Q _2729_/Q _1315_/X _1317_/X vssd1 vssd1 vccd1 vccd1 _1318_/X sky130_fd_sc_hd__a31o_2
X_2436_ _2462_/B _2436_/B vssd1 vssd1 vccd1 vccd1 _2436_/Y sky130_fd_sc_hd__nand2b_2
X_2367_ _2856_/Q _2857_/Q _2858_/Q _2859_/Q vssd1 vssd1 vccd1 vccd1 _2368_/D sky130_fd_sc_hd__or4_2
X_2298_ _2790_/Q _2300_/A1 hold398/X _2299_/B vssd1 vssd1 vccd1 vccd1 _2775_/D sky130_fd_sc_hd__a2bb2o_2
XANTENNA_fanout150_X _2136_/B vssd1 vssd1 vccd1 vccd1 sky130_fd_sc_hd__diode_2
XANTENNA__1554__A _2634_/Q vssd1 vssd1 vccd1 vccd1 sky130_fd_sc_hd__diode_2
XFILLER_46_96 vssd1 vssd1 vccd1 vccd1 sky130_fd_sc_hd__fill_1
XFILLER_7_365 vssd1 vssd1 vccd1 vccd1 sky130_fd_sc_hd__fill_1
XFILLER_7_57 vssd1 vccd1 vssd1 vccd1 sky130_ef_sc_hd__decap_40_12
XANTENNA__1686__A1 _2640_/Q vssd1 vssd1 vccd1 vccd1 sky130_fd_sc_hd__diode_2
XFILLER_16_3 vssd1 vssd1 vccd1 vccd1 sky130_fd_sc_hd__fill_4
X_2221_ _2765_/Q _2719_/Q vssd1 vssd1 vccd1 vccd1 _2222_/B sky130_fd_sc_hd__nand2_2
X_2152_ hold477/X hold404/X _2153_/S vssd1 vssd1 vccd1 vccd1 _2710_/D sky130_fd_sc_hd__mux2_1
XFILLER_38_269 vssd1 vssd1 vccd1 vccd1 sky130_fd_sc_hd__fill_1
X_2083_ hold501/X _2082_/X _2882_/D vssd1 vssd1 vccd1 vccd1 _2668_/D sky130_fd_sc_hd__mux2_1
XPHY_EDGE_ROW_26_Left_91 vssd1 vssd1 vccd1 vccd1 sky130_fd_sc_hd__decap_3
X_1867_ _1900_/C _1837_/Y _1866_/X _2700_/Q _1869_/B vssd1 vssd1 vccd1 vccd1 _1867_/X
+ sky130_fd_sc_hd__a32o_2
X_1936_ _1940_/A _2688_/Q vssd1 vssd1 vccd1 vccd1 _1938_/C sky130_fd_sc_hd__nand2_2
XPHY_EDGE_ROW_10_Left_75 vssd1 vssd1 vccd1 vccd1 sky130_fd_sc_hd__decap_3
X_1798_ _2628_/Q _1798_/B vssd1 vssd1 vccd1 vccd1 _1808_/C sky130_fd_sc_hd__and2_2
X_2419_ _2419_/A _2459_/B vssd1 vssd1 vccd1 vccd1 _2419_/Y sky130_fd_sc_hd__nand2_2
XANTENNA__1549__A _1582_/A vssd1 vssd1 vccd1 vccd1 sky130_fd_sc_hd__diode_2
XANTENNA__2144__S _2153_/S vssd1 vssd1 vccd1 vccd1 sky130_fd_sc_hd__diode_2
XANTENNA__2706__Q _2706_/Q vssd1 vssd1 vccd1 vccd1 sky130_fd_sc_hd__diode_2
XANTENNA__1601__A1 _2636_/Q vssd1 vssd1 vccd1 vccd1 sky130_fd_sc_hd__diode_2
XFILLER_32_65 vssd1 vssd1 vccd1 vccd1 sky130_fd_sc_hd__fill_4
XFILLER_8_129 vssd1 vssd1 vccd1 vccd1 sky130_fd_sc_hd__fill_4
X_1721_ hold250/X _1720_/X _1721_/S vssd1 vssd1 vccd1 vccd1 _2609_/D sky130_fd_sc_hd__mux2_1
X_2770_ _2772_/CLK _2770_/D fanout143/X vssd1 vssd1 vccd1 vccd1 _2770_/Q sky130_fd_sc_hd__dfrtp_2
X_1583_ hold357/X _1558_/B _1582_/X vssd1 vssd1 vccd1 vccd1 _2536_/D sky130_fd_sc_hd__a21o_2
X_1652_ _1652_/A _1725_/C vssd1 vssd1 vccd1 vccd1 _1658_/S sky130_fd_sc_hd__or2_2
XFILLER_26_228 vssd1 vssd1 vccd1 vccd1 sky130_fd_sc_hd__fill_1
X_2204_ hold422/X _2260_/A2 _2203_/Y _1351_/A vssd1 vssd1 vccd1 vccd1 _2747_/D sky130_fd_sc_hd__a22o_2
X_2135_ hold467/X _2134_/X _2135_/S vssd1 vssd1 vccd1 vccd1 _2694_/D sky130_fd_sc_hd__mux2_1
XANTENNA__2472__B _2472_/B vssd1 vssd1 vccd1 vccd1 sky130_fd_sc_hd__diode_2
XANTENNA_fanout158_A _1722_/S vssd1 vssd1 vccd1 vccd1 sky130_fd_sc_hd__diode_2
XTAP_TAPCELL_ROW_64_587 vssd1 vccd1 sky130_fd_sc_hd__tapvpwrvgnd_1
XTAP_TAPCELL_ROW_64_598 vssd1 vccd1 sky130_fd_sc_hd__tapvpwrvgnd_1
X_2066_ _2066_/A _2066_/B vssd1 vssd1 vccd1 vccd1 _2067_/B sky130_fd_sc_hd__xnor2_2
XANTENNA__1816__B _1816_/B vssd1 vssd1 vccd1 vccd1 sky130_fd_sc_hd__diode_2
X_1919_ _1940_/A _2692_/Q vssd1 vssd1 vccd1 vccd1 _1922_/B sky130_fd_sc_hd__or2_2
X_2899_ _2902_/CLK _2899_/D fanout117/X vssd1 vssd1 vccd1 vccd1 _2899_/Q sky130_fd_sc_hd__dfrtp_2
XANTENNA__1898__A1 _2644_/Q vssd1 vssd1 vccd1 vccd1 sky130_fd_sc_hd__diode_2
XANTENNA__2139__S _2154_/S vssd1 vssd1 vccd1 vccd1 sky130_fd_sc_hd__diode_2
XTAP_TAPCELL_ROW_4_165 vssd1 vccd1 sky130_fd_sc_hd__tapvpwrvgnd_1
XFILLER_25_283 vssd1 vssd1 vccd1 vccd1 sky130_fd_sc_hd__fill_1
XFILLER_4_14 vssd1 vssd1 vccd1 vccd1 sky130_fd_sc_hd__fill_2
XFILLER_4_25 vssd1 vssd1 vccd1 vccd1 sky130_fd_sc_hd__fill_2
XFILLER_4_47 vssd1 vssd1 vccd1 vccd1 sky130_fd_sc_hd__fill_2
XFILLER_0_382 vssd1 vssd1 vccd1 vccd1 sky130_fd_sc_hd__fill_1
XFILLER_63_345 vssd1 vssd1 vccd1 vccd1 sky130_fd_sc_hd__fill_1
XTAP_TAPCELL_ROW_18_267 vssd1 vccd1 sky130_fd_sc_hd__tapvpwrvgnd_1
XTAP_TAPCELL_ROW_61_568 vssd1 vccd1 sky130_fd_sc_hd__tapvpwrvgnd_1
X_1704_ hold246/X _1603_/X _1721_/S vssd1 vssd1 vccd1 vccd1 _2600_/D sky130_fd_sc_hd__mux2_1
X_2822_ clkload3/A _2822_/D fanout88/X vssd1 vssd1 vccd1 vccd1 _2822_/Q sky130_fd_sc_hd__dfrtp_2
X_2753_ _2768_/CLK _2753_/D load_slew142/X vssd1 vssd1 vccd1 vccd1 _2753_/Q sky130_fd_sc_hd__dfrtp_2
X_2684_ _2688_/CLK _2684_/D load_slew95/X vssd1 vssd1 vccd1 vccd1 _2684_/Q sky130_fd_sc_hd__dfrtp_2
X_1497_ _2831_/Q _2830_/Q _2833_/Q _2832_/Q vssd1 vssd1 vccd1 vccd1 _1498_/B sky130_fd_sc_hd__or4_2
X_1566_ _1582_/A _2640_/Q _1701_/S vssd1 vssd1 vccd1 vccd1 _1566_/X sky130_fd_sc_hd__and3_2
X_1635_ _2646_/Q _1716_/S _1810_/A1 _2661_/Q vssd1 vssd1 vccd1 vccd1 _1635_/X sky130_fd_sc_hd__a22o_2
XTAP_TAPCELL_ROW_1_146 vssd1 vccd1 sky130_fd_sc_hd__tapvpwrvgnd_1
X_2118_ _2568_/Q _2584_/Q _2118_/S vssd1 vssd1 vccd1 vccd1 _2118_/X sky130_fd_sc_hd__mux2_1
X_2049_ _2049_/A _2049_/B vssd1 vssd1 vccd1 vccd1 _2055_/C sky130_fd_sc_hd__xnor2_2
XTAP_TAPCELL_ROW_52_502 vssd1 vccd1 sky130_fd_sc_hd__tapvpwrvgnd_1
Xfanout79 _1366_/Y vssd1 vssd1 vccd1 vccd1 _2297_/B1 sky130_fd_sc_hd__clkdlybuf4s25_1
Xfanout68 _2282_/A2 vssd1 vssd1 vccd1 vccd1 _2260_/A2 sky130_fd_sc_hd__clkdlybuf4s25_1
Xfanout57 _1730_/X vssd1 vssd1 vccd1 vccd1 _1814_/B2 sky130_fd_sc_hd__clkdlybuf4s25_1
Xfanout46 _1723_/S vssd1 vssd1 vccd1 vccd1 _1721_/S sky130_fd_sc_hd__clkdlybuf4s25_1
Xfanout35 _1414_/X vssd1 vssd1 vccd1 vccd1 _1477_/B1 sky130_fd_sc_hd__clkdlybuf4s25_1
XANTENNA__1827__A _2634_/Q vssd1 vssd1 vccd1 vccd1 sky130_fd_sc_hd__diode_2
XTAP_TAPCELL_ROW_9_202 vssd1 vccd1 sky130_fd_sc_hd__tapvpwrvgnd_1
Xhold460 _2693_/Q vssd1 vssd1 vccd1 vccd1 hold460/X sky130_fd_sc_hd__dlygate4sd3_1
Xhold471 _2709_/Q vssd1 vssd1 vccd1 vccd1 hold471/X sky130_fd_sc_hd__dlygate4sd3_1
XANTENNA__1562__A _1582_/A vssd1 vssd1 vccd1 vccd1 sky130_fd_sc_hd__diode_2
Xhold482 _2763_/Q vssd1 vssd1 vccd1 vccd1 hold482/X sky130_fd_sc_hd__dlygate4sd3_1
Xhold493 _2661_/Q vssd1 vssd1 vccd1 vccd1 hold493/X sky130_fd_sc_hd__dlygate4sd3_1
XTAP_TAPCELL_ROW_15_248 vssd1 vccd1 sky130_fd_sc_hd__tapvpwrvgnd_1
X_1351_ _1351_/A _1351_/B vssd1 vssd1 vccd1 vccd1 _2870_/D sky130_fd_sc_hd__and2_2
X_1420_ _2898_/Q _2897_/Q vssd1 vssd1 vccd1 vccd1 _1420_/Y sky130_fd_sc_hd__nand2_2
XANTENNA__2287__A1 _1366_/A vssd1 vssd1 vccd1 vccd1 sky130_fd_sc_hd__diode_2
XFILLER_63_164 vssd1 vssd1 vccd1 vccd1 sky130_fd_sc_hd__fill_4
X_1282_ _1415_/B vssd1 vssd1 vccd1 vccd1 _2969_/A sky130_fd_sc_hd__inv_2
XFILLER_63_186 vssd1 vssd1 vccd1 vccd1 sky130_fd_sc_hd__fill_1
X_2805_ _2813_/CLK _2805_/D fanout111/A vssd1 vssd1 vccd1 vccd1 _2805_/Q sky130_fd_sc_hd__dfrtp_2
XANTENNA__1366__B _2168_/S vssd1 vssd1 vccd1 vccd1 sky130_fd_sc_hd__diode_2
X_1618_ _1618_/A _1618_/B vssd1 vssd1 vccd1 vccd1 _2544_/D sky130_fd_sc_hd__or2_2
X_2736_ _2869_/CLK _2736_/D load_slew121/X vssd1 vssd1 vccd1 vccd1 _2736_/Q sky130_fd_sc_hd__dfrtp_2
X_2667_ _2883_/CLK _2667_/D _2510_/B2 vssd1 vssd1 vccd1 vccd1 _2667_/Q sky130_fd_sc_hd__dfrtp_2
XANTENNA__2278__A1 _1351_/A vssd1 vssd1 vccd1 vccd1 sky130_fd_sc_hd__diode_2
XANTENNA__2278__B2 _2282_/A2 vssd1 vssd1 vccd1 vccd1 sky130_fd_sc_hd__diode_2
XANTENNA_fanout180_X _2189_/S vssd1 vssd1 vccd1 vccd1 sky130_fd_sc_hd__diode_2
X_1549_ _1582_/A _1549_/B vssd1 vssd1 vccd1 vccd1 _1549_/Y sky130_fd_sc_hd__nor2_2
X_2598_ clkload8/A _2598_/D vssd1 vssd1 vccd1 vccd1 _2598_/Q sky130_fd_sc_hd__dfxtp_2
XFILLER_24_11 vssd1 vssd1 vccd1 vccd1 sky130_fd_sc_hd__fill_2
XANTENNA__2152__S _2153_/S vssd1 vssd1 vccd1 vccd1 sky130_fd_sc_hd__diode_2
XFILLER_10_201 vssd1 vssd1 vccd1 vccd1 sky130_fd_sc_hd__fill_2
XFILLER_10_256 vssd1 vssd1 vccd1 vccd1 sky130_fd_sc_hd__fill_2
XFILLER_40_87 vssd1 vssd1 vccd1 vccd1 sky130_fd_sc_hd__fill_1
Xhold290 _2532_/Q vssd1 vssd1 vccd1 vccd1 hold290/X sky130_fd_sc_hd__dlygate4sd3_1
XANTENNA__2269__A1 _2261_/Y vssd1 vssd1 vccd1 vccd1 sky130_fd_sc_hd__diode_2
XFILLER_1_26 vssd1 vssd1 vccd1 vccd1 sky130_fd_sc_hd__fill_1
XFILLER_1_48 vssd1 vssd1 vccd1 vccd1 sky130_fd_sc_hd__fill_1
XFILLER_1_59 vssd1 vssd1 vccd1 vccd1 sky130_fd_sc_hd__fill_1
XFILLER_41_370 vssd1 vssd1 vccd1 vccd1 sky130_fd_sc_hd__fill_1
X_2521_ _2866_/CLK _2521_/D vssd1 vssd1 vccd1 vccd1 _2521_/Q sky130_fd_sc_hd__dfxtp_2
XFILLER_46_3 vssd1 vssd1 vccd1 vccd1 sky130_fd_sc_hd__fill_1
XPHY_EDGE_ROW_18_Right_18 vssd1 vssd1 vccd1 vccd1 sky130_fd_sc_hd__decap_3
X_1265_ _2918_/Q vssd1 vssd1 vccd1 vccd1 _2332_/B sky130_fd_sc_hd__inv_2
X_1334_ _2736_/Q _1331_/B _1333_/X _2737_/Q vssd1 vssd1 vccd1 vccd1 _1334_/X sky130_fd_sc_hd__a22o_2
X_1403_ _2816_/Q _2817_/Q vssd1 vssd1 vccd1 vccd1 _1403_/Y sky130_fd_sc_hd__nor2_2
X_2452_ _2454_/B _2452_/B vssd1 vssd1 vccd1 vccd1 _2452_/Y sky130_fd_sc_hd__nand2b_2
X_2383_ _2383_/A _2385_/C vssd1 vssd1 vccd1 vccd1 _2818_/D sky130_fd_sc_hd__xor2_2
XFILLER_24_348 vssd1 vssd1 vccd1 vccd1 sky130_fd_sc_hd__fill_1
XPHY_EDGE_ROW_27_Right_27 vssd1 vssd1 vccd1 vccd1 sky130_fd_sc_hd__decap_3
Xinput3 gpio_in[1] vssd1 vssd1 vccd1 vccd1 input3/X sky130_fd_sc_hd__clkdlybuf4s25_1
XANTENNA_fanout140_A fanout144/X vssd1 vssd1 vccd1 vccd1 sky130_fd_sc_hd__diode_2
XFILLER_32_381 vssd1 vssd1 vccd1 vccd1 sky130_fd_sc_hd__fill_1
XFILLER_51_167 vssd1 vssd1 vccd1 vccd1 sky130_fd_sc_hd__fill_1
XTAP_TAPCELL_ROW_34_376 vssd1 vccd1 sky130_fd_sc_hd__tapvpwrvgnd_1
XANTENNA__1824__B _2558_/Q vssd1 vssd1 vccd1 vccd1 sky130_fd_sc_hd__diode_2
XPHY_EDGE_ROW_36_Right_36 vssd1 vssd1 vccd1 vccd1 sky130_fd_sc_hd__decap_3
X_2719_ _2719_/CLK _2719_/D fanout137/X vssd1 vssd1 vccd1 vccd1 _2719_/Q sky130_fd_sc_hd__dfrtp_2
XANTENNA__1840__A _2638_/Q vssd1 vssd1 vccd1 vccd1 sky130_fd_sc_hd__diode_2
XFILLER_19_55 vssd1 vssd1 vccd1 vccd1 sky130_fd_sc_hd__fill_1
XANTENNA__2147__S _2153_/S vssd1 vssd1 vccd1 vccd1 sky130_fd_sc_hd__diode_2
XFILLER_42_189 vssd1 vssd1 vccd1 vccd1 sky130_fd_sc_hd__fill_4
XPHY_EDGE_ROW_45_Right_45 vssd1 vssd1 vccd1 vccd1 sky130_fd_sc_hd__decap_3
XPHY_EDGE_ROW_54_Right_54 vssd1 vssd1 vccd1 vccd1 sky130_fd_sc_hd__decap_3
XFILLER_18_197 vssd1 vssd1 vccd1 vccd1 sky130_fd_sc_hd__fill_1
XPHY_EDGE_ROW_38_Left_103 vssd1 vssd1 vccd1 vccd1 sky130_fd_sc_hd__decap_3
XPHY_EDGE_ROW_63_Right_63 vssd1 vssd1 vccd1 vccd1 sky130_fd_sc_hd__decap_3
XTAP_TAPCELL_ROW_48_479 vssd1 vccd1 sky130_fd_sc_hd__tapvpwrvgnd_1
XTAP_TAPCELL_ROW_31_357 vssd1 vccd1 sky130_fd_sc_hd__tapvpwrvgnd_1
X_1883_ _2704_/Q _1869_/B _1851_/Y vssd1 vssd1 vccd1 vccd1 _1883_/X sky130_fd_sc_hd__a21o_2
X_1952_ _1963_/A _2684_/Q vssd1 vssd1 vccd1 vccd1 _1954_/C sky130_fd_sc_hd__nand2_2
XPHY_EDGE_ROW_47_Left_112 vssd1 vssd1 vccd1 vccd1 sky130_fd_sc_hd__decap_3
X_2504_ _2504_/A _2505_/C vssd1 vssd1 vccd1 vccd1 _2859_/D sky130_fd_sc_hd__xor2_2
X_2435_ _2836_/Q _2435_/B vssd1 vssd1 vccd1 vccd1 _2436_/B sky130_fd_sc_hd__nand2_2
XTAP_TAPCELL_ROW_39_413 vssd1 vccd1 sky130_fd_sc_hd__tapvpwrvgnd_1
X_1317_ _1312_/B _1316_/Y _2730_/Q vssd1 vssd1 vccd1 vccd1 _1317_/X sky130_fd_sc_hd__o21a_2
X_2366_ _2847_/Q _2848_/Q _2366_/C _2366_/D vssd1 vssd1 vccd1 vccd1 _2391_/A sky130_fd_sc_hd__or4_2
X_2297_ _2297_/A1 hold414/X _2297_/B1 hold424/X vssd1 vssd1 vccd1 vccd1 _2774_/D sky130_fd_sc_hd__a22o_2
XPHY_EDGE_ROW_56_Left_121 vssd1 vssd1 vccd1 vccd1 sky130_fd_sc_hd__decap_3
XFILLER_46_31 vssd1 vssd1 vccd1 vccd1 sky130_fd_sc_hd__fill_2
XFILLER_55_281 vssd1 vssd1 vccd1 vccd1 sky130_fd_sc_hd__fill_1
XFILLER_62_218 vssd1 vssd1 vccd1 vccd1 sky130_fd_sc_hd__fill_1
XANTENNA__1852__C1 _1851_/Y vssd1 vssd1 vccd1 vccd1 sky130_fd_sc_hd__diode_2
XFILLER_7_311 vssd1 vssd1 vccd1 vccd1 sky130_fd_sc_hd__fill_4
XANTENNA__1745__A _2618_/Q vssd1 vssd1 vccd1 vccd1 sky130_fd_sc_hd__diode_2
XFILLER_7_69 vssd1 vssd1 vccd1 vccd1 sky130_fd_sc_hd__fill_2
XFILLER_23_5 vssd1 vssd1 vccd1 vccd1 sky130_fd_sc_hd__fill_2
X_2220_ _2222_/A vssd1 vssd1 vccd1 vccd1 _2231_/A sky130_fd_sc_hd__inv_2
X_2151_ hold471/X hold389/X _2154_/S vssd1 vssd1 vccd1 vccd1 _2709_/D sky130_fd_sc_hd__mux2_1
X_2082_ _2581_/Q _2565_/Q _2120_/S vssd1 vssd1 vccd1 vccd1 _2082_/X sky130_fd_sc_hd__mux2_1
XANTENNA__1610__A2 _1585_/X vssd1 vssd1 vccd1 vccd1 sky130_fd_sc_hd__diode_2
X_1797_ _2627_/Q _1811_/A2 _1795_/Y _1796_/X vssd1 vssd1 vccd1 vccd1 _2627_/D sky130_fd_sc_hd__o22a_2
X_1866_ _1837_/A _1837_/C _1837_/B vssd1 vssd1 vccd1 vccd1 _1866_/X sky130_fd_sc_hd__a21o_2
X_1935_ _1940_/A _2688_/Q vssd1 vssd1 vccd1 vccd1 _1938_/B sky130_fd_sc_hd__or2_2
XANTENNA__1374__A1 _2300_/A1 vssd1 vssd1 vccd1 vccd1 sky130_fd_sc_hd__diode_2
X_2418_ _2415_/Y _2462_/B _2412_/Y vssd1 vssd1 vccd1 vccd1 _2831_/D sky130_fd_sc_hd__o21ai_2
X_2349_ hold525/X _2472_/A _2348_/Y _2918_/Q vssd1 vssd1 vccd1 vccd1 _2810_/D sky130_fd_sc_hd__a22o_2
XFILLER_32_55 vssd1 vssd1 vccd1 vccd1 sky130_fd_sc_hd__fill_2
XFILLER_52_251 vssd1 vssd1 vccd1 vccd1 sky130_fd_sc_hd__fill_1
XFILLER_52_273 vssd1 vssd1 vccd1 vccd1 sky130_fd_sc_hd__fill_1
XFILLER_8_119 vssd1 vssd1 vccd1 vccd1 sky130_fd_sc_hd__fill_2
XPHY_EDGE_ROW_0_Right_0 vssd1 vssd1 vccd1 vccd1 sky130_fd_sc_hd__decap_3
XANTENNA_clkbuf_3_2__f_clk_X clkbuf_leaf_9_clk/A vssd1 vssd1 vccd1 vccd1 sky130_fd_sc_hd__diode_2
XFILLER_4_325 vssd1 vssd1 vccd1 vccd1 sky130_fd_sc_hd__fill_4
XFILLER_4_336 vssd1 vssd1 vccd1 vccd1 sky130_fd_sc_hd__fill_1
XFILLER_57_96 vssd1 vssd1 vccd1 vccd1 sky130_fd_sc_hd__fill_1
XFILLER_43_273 vssd1 vssd1 vccd1 vccd1 sky130_fd_sc_hd__fill_1
XTAP_TAPCELL_ROW_41_430 vssd1 vccd1 sky130_fd_sc_hd__tapvpwrvgnd_1
X_1651_ _2554_/Q _1651_/B _1651_/C vssd1 vssd1 vccd1 vccd1 _1654_/B sky130_fd_sc_hd__and3_2
X_1720_ _2629_/Q _2646_/Q _1722_/S vssd1 vssd1 vccd1 vccd1 _1720_/X sky130_fd_sc_hd__mux2_1
XFILLER_3_391 vssd1 vssd1 vccd1 vccd1 sky130_fd_sc_hd__fill_1
X_1582_ _1582_/A _2632_/Q _1724_/S vssd1 vssd1 vccd1 vccd1 _1582_/X sky130_fd_sc_hd__and3_2
XFILLER_19_281 vssd1 vssd1 vccd1 vccd1 sky130_fd_sc_hd__fill_2
X_2203_ _2203_/A _2203_/B vssd1 vssd1 vccd1 vccd1 _2203_/Y sky130_fd_sc_hd__xnor2_2
X_2134_ _2576_/Q _2592_/Q _2134_/S vssd1 vssd1 vccd1 vccd1 _2134_/X sky130_fd_sc_hd__mux2_1
X_2065_ _2065_/A _2065_/B vssd1 vssd1 vccd1 vccd1 _2066_/B sky130_fd_sc_hd__nor2_2
XTAP_TAPCELL_ROW_64_588 vssd1 vccd1 sky130_fd_sc_hd__tapvpwrvgnd_1
Xteam_06 vssd1 vssd1 vccd1 vccd1 team_06/HI gpio_oeb[4] sky130_fd_sc_hd__conb_1
XANTENNA__1595__A1 _1624_/S vssd1 vssd1 vccd1 vccd1 sky130_fd_sc_hd__diode_2
XANTENNA__1595__B2 _1385_/B vssd1 vssd1 vccd1 vccd1 sky130_fd_sc_hd__diode_2
XANTENNA_fanout106_X fanout99/A vssd1 vssd1 vccd1 vccd1 sky130_fd_sc_hd__diode_2
X_1849_ _2632_/Q _1907_/A vssd1 vssd1 vccd1 vccd1 _1849_/Y sky130_fd_sc_hd__nand2_2
X_1918_ _2678_/Q _1918_/B _1918_/C vssd1 vssd1 vccd1 vccd1 _2060_/B sky130_fd_sc_hd__nand3_2
X_2898_ _2902_/CLK _2898_/D fanout117/X vssd1 vssd1 vccd1 vccd1 _2898_/Q sky130_fd_sc_hd__dfrtp_2
XTAP_TAPCELL_ROW_4_166 vssd1 vccd1 sky130_fd_sc_hd__tapvpwrvgnd_1
XFILLER_17_207 vssd1 vssd1 vccd1 vccd1 sky130_fd_sc_hd__fill_1
XFILLER_27_33 vssd1 vssd1 vccd1 vccd1 sky130_fd_sc_hd__fill_1
XTAP_TAPCELL_ROW_55_522 vssd1 vccd1 sky130_fd_sc_hd__tapvpwrvgnd_1
Xclkbuf_leaf_20_clk clkload0/A vssd1 vssd1 vccd1 vccd1 _2765_/CLK sky130_fd_sc_hd__clkbuf_8
XFILLER_4_59 vssd1 vssd1 vccd1 vccd1 sky130_fd_sc_hd__fill_4
Xteam_06_230 vssd1 vssd1 vccd1 vccd1 gpio_oeb[3] team_06_230/LO sky130_fd_sc_hd__conb_1
XTAP_TAPCELL_ROW_18_268 vssd1 vccd1 sky130_fd_sc_hd__tapvpwrvgnd_1
XTAP_TAPCELL_ROW_61_569 vssd1 vccd1 sky130_fd_sc_hd__tapvpwrvgnd_1
X_2821_ clkload4/A _2821_/D fanout88/X vssd1 vssd1 vccd1 vccd1 _2821_/Q sky130_fd_sc_hd__dfrtp_2
X_1634_ _2628_/Q _1585_/X _1633_/X vssd1 vssd1 vccd1 vccd1 _2549_/D sky130_fd_sc_hd__a21o_2
X_1703_ hold264/X _1702_/X _1724_/S vssd1 vssd1 vccd1 vccd1 _2599_/D sky130_fd_sc_hd__mux2_1
Xclkbuf_leaf_11_clk clkbuf_leaf_5_clk/A vssd1 vssd1 vccd1 vccd1 _2694_/CLK sky130_fd_sc_hd__clkbuf_8
X_2752_ _2768_/CLK _2752_/D fanout138/X vssd1 vssd1 vccd1 vccd1 _2752_/Q sky130_fd_sc_hd__dfrtp_2
X_2683_ _2688_/CLK _2683_/D fanout94/X vssd1 vssd1 vccd1 vccd1 _2683_/Q sky130_fd_sc_hd__dfrtp_2
X_1496_ _2835_/Q _2834_/Q _2837_/Q _2836_/Q vssd1 vssd1 vccd1 vccd1 _1498_/A sky130_fd_sc_hd__or4_2
X_1565_ hold270/X _1558_/B _1564_/X vssd1 vssd1 vccd1 vccd1 _2527_/D sky130_fd_sc_hd__a21o_2
XTAP_TAPCELL_ROW_1_147 vssd1 vccd1 sky130_fd_sc_hd__tapvpwrvgnd_1
XTAP_TAPCELL_ROW_52_503 vssd1 vccd1 sky130_fd_sc_hd__tapvpwrvgnd_1
X_2117_ hold446/X _2116_/X _2882_/D vssd1 vssd1 vccd1 vccd1 _2685_/D sky130_fd_sc_hd__mux2_1
X_2048_ _1982_/A _2048_/B vssd1 vssd1 vccd1 vccd1 _2049_/B sky130_fd_sc_hd__and2b_2
Xfanout69 _2155_/Y vssd1 vssd1 vccd1 vccd1 _2282_/A2 sky130_fd_sc_hd__clkdlybuf4s25_1
Xfanout58 _1730_/X vssd1 vssd1 vccd1 vccd1 _1811_/A2 sky130_fd_sc_hd__clkdlybuf4s25_1
Xfanout47 _1550_/X vssd1 vssd1 vccd1 vccd1 _1723_/S sky130_fd_sc_hd__clkdlybuf4s25_1
Xfanout36 _1414_/X vssd1 vssd1 vccd1 vccd1 _1450_/B1 sky130_fd_sc_hd__clkdlybuf4s25_1
XANTENNA__1843__A _2642_/Q vssd1 vssd1 vccd1 vccd1 sky130_fd_sc_hd__diode_2
XTAP_TAPCELL_ROW_9_203 vssd1 vccd1 sky130_fd_sc_hd__tapvpwrvgnd_1
Xhold450 _2679_/Q vssd1 vssd1 vccd1 vccd1 hold450/X sky130_fd_sc_hd__dlygate4sd3_1
Xhold461 _2760_/Q vssd1 vssd1 vccd1 vccd1 hold461/X sky130_fd_sc_hd__dlygate4sd3_1
Xhold472 _2662_/Q vssd1 vssd1 vccd1 vccd1 hold472/X sky130_fd_sc_hd__dlygate4sd3_1
Xhold483 _2559_/Q vssd1 vssd1 vccd1 vccd1 hold483/X sky130_fd_sc_hd__dlygate4sd3_1
Xhold494 _2675_/Q vssd1 vssd1 vccd1 vccd1 hold494/X sky130_fd_sc_hd__dlygate4sd3_1
XANTENNA__1562__B _2638_/Q vssd1 vssd1 vccd1 vccd1 sky130_fd_sc_hd__diode_2
XFILLER_1_169 vssd1 vssd1 vccd1 vccd1 sky130_fd_sc_hd__fill_2
XFILLER_38_98 vssd1 vssd1 vccd1 vccd1 sky130_fd_sc_hd__fill_1
XFILLER_60_327 vssd1 vssd1 vccd1 vccd1 sky130_fd_sc_hd__fill_1
XFILLER_9_269 vssd1 vssd1 vccd1 vccd1 sky130_fd_sc_hd__fill_2
X_1281_ _2922_/Q _2920_/Q _2921_/Q _2923_/Q vssd1 vssd1 vccd1 vccd1 _1415_/B sky130_fd_sc_hd__and4_2
X_1350_ _2743_/Q _1306_/X _1348_/X _1349_/X vssd1 vssd1 vccd1 vccd1 _1351_/B sky130_fd_sc_hd__a22o_2
XFILLER_36_335 vssd1 vssd1 vccd1 vccd1 sky130_fd_sc_hd__fill_1
Xclkbuf_leaf_0_clk clkbuf_leaf_3_clk/A vssd1 vssd1 vccd1 vccd1 clkload1/A sky130_fd_sc_hd__clkbuf_8
XANTENNA__1647__B _1863_/C vssd1 vssd1 vccd1 vccd1 sky130_fd_sc_hd__diode_2
X_2804_ _2804_/CLK _2804_/D load_slew136/X vssd1 vssd1 vccd1 vccd1 _2804_/Q sky130_fd_sc_hd__dfrtp_2
XANTENNA__2211__A2 _2260_/A2 vssd1 vssd1 vccd1 vccd1 sky130_fd_sc_hd__diode_2
XFILLER_8_280 vssd1 vssd1 vccd1 vccd1 sky130_fd_sc_hd__fill_2
X_1617_ _1624_/S _1614_/X _1615_/X _2704_/Q _1384_/B vssd1 vssd1 vccd1 vccd1 _1618_/B
+ sky130_fd_sc_hd__a32o_2
X_2735_ _2902_/CLK _2735_/D load_slew121/X vssd1 vssd1 vccd1 vccd1 _2735_/Q sky130_fd_sc_hd__dfrtp_2
X_2666_ _2883_/CLK _2666_/D _2510_/B2 vssd1 vssd1 vccd1 vccd1 _2666_/Q sky130_fd_sc_hd__dfrtp_2
X_2597_ clkload8/A _2597_/D vssd1 vssd1 vccd1 vccd1 _2597_/Q sky130_fd_sc_hd__dfxtp_2
XANTENNA__1722__A1 _2647_/Q vssd1 vssd1 vccd1 vccd1 sky130_fd_sc_hd__diode_2
XFILLER_27_335 vssd1 vssd1 vccd1 vccd1 sky130_fd_sc_hd__fill_1
XFILLER_39_162 vssd1 vssd1 vccd1 vccd1 sky130_fd_sc_hd__fill_4
X_1479_ _2914_/Q _2913_/Q _1479_/C vssd1 vssd1 vccd1 vccd1 _1480_/B sky130_fd_sc_hd__and3_2
X_1548_ _1549_/B vssd1 vssd1 vccd1 vccd1 _1548_/Y sky130_fd_sc_hd__inv_2
XTAP_TAPCELL_ROW_37_396 vssd1 vccd1 sky130_fd_sc_hd__tapvpwrvgnd_1
Xhold280 _2808_/Q vssd1 vssd1 vccd1 vccd1 hold280/X sky130_fd_sc_hd__dlygate4sd3_1
Xhold291 _2526_/Q vssd1 vssd1 vccd1 vccd1 hold291/X sky130_fd_sc_hd__dlygate4sd3_1
XFILLER_45_110 vssd1 vssd1 vccd1 vccd1 sky130_fd_sc_hd__fill_2
XANTENNA__2640__Q _2640_/Q vssd1 vssd1 vccd1 vccd1 sky130_fd_sc_hd__diode_2
X_1402_ _2918_/Q _2330_/A _2348_/B _1401_/Y vssd1 vssd1 vccd1 vccd1 _2918_/D sky130_fd_sc_hd__a211o_2
X_2520_ _1373_/A _2470_/D _1548_/Y _2805_/Q _1546_/X vssd1 vssd1 vccd1 vccd1 _2924_/D
+ sky130_fd_sc_hd__a221o_2
X_2451_ _2839_/Q _2838_/Q _2450_/D _2840_/Q vssd1 vssd1 vccd1 vccd1 _2452_/B sky130_fd_sc_hd__a31o_2
X_1264_ _1963_/A vssd1 vssd1 vccd1 vccd1 _1987_/A sky130_fd_sc_hd__inv_2
X_1333_ _2798_/Q _1333_/B vssd1 vssd1 vccd1 vccd1 _1333_/X sky130_fd_sc_hd__xor2_2
Xinput4 gpio_in[2] vssd1 vssd1 vccd1 vccd1 input4/X sky130_fd_sc_hd__clkdlybuf4s25_1
X_2382_ _2382_/A _2385_/C vssd1 vssd1 vccd1 vccd1 _2817_/D sky130_fd_sc_hd__nor2_2
XFILLER_24_305 vssd1 vssd1 vccd1 vccd1 sky130_fd_sc_hd__fill_1
XTAP_TAPCELL_ROW_34_377 vssd1 vccd1 sky130_fd_sc_hd__tapvpwrvgnd_1
X_2718_ _2719_/CLK _2718_/D load_slew134/X vssd1 vssd1 vccd1 vccd1 _2718_/Q sky130_fd_sc_hd__dfrtp_2
XFILLER_10_58 vssd1 vssd1 vccd1 vccd1 sky130_fd_sc_hd__fill_2
X_2649_ clkload5/A _2649_/D load_slew95/X vssd1 vssd1 vccd1 vccd1 _2649_/Q sky130_fd_sc_hd__dfrtp_2
XANTENNA__1840__B _2637_/Q vssd1 vssd1 vccd1 vccd1 sky130_fd_sc_hd__diode_2
XANTENNA_fanout46_A _1723_/S vssd1 vssd1 vccd1 vccd1 sky130_fd_sc_hd__diode_2
XANTENNA__1631__B1 _1624_/S vssd1 vssd1 vccd1 vccd1 sky130_fd_sc_hd__diode_2
XANTENNA__2163__S _2168_/S vssd1 vssd1 vccd1 vccd1 sky130_fd_sc_hd__diode_2
XFILLER_35_55 vssd1 vssd1 vccd1 vccd1 sky130_fd_sc_hd__fill_1
XFILLER_2_253 vssd1 vssd1 vccd1 vccd1 sky130_fd_sc_hd__fill_4
XANTENNA__2635__Q _2635_/Q vssd1 vssd1 vccd1 vccd1 sky130_fd_sc_hd__diode_2
XTAP_TAPCELL_ROW_31_358 vssd1 vccd1 sky130_fd_sc_hd__tapvpwrvgnd_1
X_1882_ _1885_/B _1882_/B _1900_/C vssd1 vssd1 vccd1 vccd1 _1882_/X sky130_fd_sc_hd__and3b_2
X_1951_ _1963_/A _2684_/Q vssd1 vssd1 vccd1 vccd1 _1954_/B sky130_fd_sc_hd__or2_2
X_2503_ _2505_/C _2503_/B vssd1 vssd1 vccd1 vccd1 _2858_/D sky130_fd_sc_hd__nor2_2
X_2434_ _2417_/X _2433_/X _2835_/Q _2459_/B vssd1 vssd1 vccd1 vccd1 _2835_/D sky130_fd_sc_hd__a2bb2o_2
X_2365_ _2370_/A _2365_/B _2365_/C vssd1 vssd1 vccd1 vccd1 _2366_/D sky130_fd_sc_hd__or3_2
XTAP_TAPCELL_ROW_39_414 vssd1 vccd1 sky130_fd_sc_hd__tapvpwrvgnd_1
X_1316_ _2791_/Q _2790_/Q vssd1 vssd1 vccd1 vccd1 _1316_/Y sky130_fd_sc_hd__nor2_2
X_2296_ _2297_/A1 hold404/X _2297_/B1 hold431/X vssd1 vssd1 vccd1 vccd1 _2773_/D sky130_fd_sc_hd__a22o_2
XANTENNA__1613__B1 _1624_/S vssd1 vssd1 vccd1 vccd1 sky130_fd_sc_hd__diode_2
XANTENNA__1861__A0 _2634_/Q vssd1 vssd1 vccd1 vccd1 sky130_fd_sc_hd__diode_2
XANTENNA__1570__B _2642_/Q vssd1 vssd1 vccd1 vccd1 sky130_fd_sc_hd__diode_2
XFILLER_15_113 vssd1 vssd1 vccd1 vccd1 sky130_fd_sc_hd__fill_1
XANTENNA__1585__X _1585_/X vssd1 vssd1 vccd1 vccd1 sky130_fd_sc_hd__diode_2
XFILLER_62_31 vssd1 vssd1 vccd1 vccd1 sky130_fd_sc_hd__fill_4
XFILLER_62_75 vssd1 vssd1 vccd1 vccd1 sky130_fd_sc_hd__fill_1
XFILLER_7_26 vssd1 vssd1 vccd1 vccd1 sky130_fd_sc_hd__fill_4
XFILLER_7_323 vssd1 vssd1 vccd1 vccd1 sky130_fd_sc_hd__fill_4
XANTENNA__2068__S _2882_/Q vssd1 vssd1 vccd1 vccd1 sky130_fd_sc_hd__diode_2
X_2150_ _2708_/Q hold484/X _2154_/S vssd1 vssd1 vccd1 vccd1 _2708_/D sky130_fd_sc_hd__mux2_1
X_2081_ hold509/X _2080_/X _2136_/B vssd1 vssd1 vccd1 vccd1 _2667_/D sky130_fd_sc_hd__mux2_1
XTAP_TAPCELL_ROW_44_450 vssd1 vccd1 sky130_fd_sc_hd__tapvpwrvgnd_1
X_1934_ _2674_/Q _1934_/B _1934_/C vssd1 vssd1 vccd1 vccd1 _2036_/B sky130_fd_sc_hd__nand3_2
X_1796_ _1796_/A1 _2659_/Q _1810_/B1 _2708_/Q _1810_/C1 vssd1 vssd1 vccd1 vccd1 _1796_/X
+ sky130_fd_sc_hd__a221o_2
X_1865_ _2635_/Q _1891_/S _1863_/X _1864_/X vssd1 vssd1 vccd1 vccd1 _2635_/D sky130_fd_sc_hd__o22a_2
X_2417_ _2814_/Q _2389_/B _2378_/Y _2391_/A vssd1 vssd1 vccd1 vccd1 _2417_/X sky130_fd_sc_hd__a31o_2
X_2348_ _2472_/A _2348_/B _2348_/C vssd1 vssd1 vccd1 vccd1 _2348_/Y sky130_fd_sc_hd__nor3_2
XFILLER_16_24 vssd1 vssd1 vccd1 vccd1 sky130_fd_sc_hd__fill_4
X_2279_ _2774_/Q _2728_/Q vssd1 vssd1 vccd1 vccd1 _2281_/A sky130_fd_sc_hd__xor2_2
XANTENNA__1846__A _2646_/Q vssd1 vssd1 vccd1 vccd1 sky130_fd_sc_hd__diode_2
XTAP_TAPCELL_ROW_7_186 vssd1 vccd1 sky130_fd_sc_hd__tapvpwrvgnd_1
XFILLER_43_285 vssd1 vssd1 vccd1 vccd1 sky130_fd_sc_hd__fill_1
X_1581_ hold318/X _1581_/A2 _1580_/X vssd1 vssd1 vccd1 vccd1 _2535_/D sky130_fd_sc_hd__a21o_2
X_1650_ _1257_/Y _1812_/C _1725_/C _2614_/Q _2615_/Q vssd1 vssd1 vccd1 vccd1 _1650_/X
+ sky130_fd_sc_hd__a2111o_2
X_2202_ _2202_/A _2202_/B vssd1 vssd1 vccd1 vccd1 _2203_/B sky130_fd_sc_hd__or2_2
X_2133_ hold460/X _2132_/X _2135_/S vssd1 vssd1 vccd1 vccd1 _2693_/D sky130_fd_sc_hd__mux2_1
X_2064_ _2057_/A _2056_/B _2062_/B _2056_/A vssd1 vssd1 vccd1 vccd1 _2067_/A sky130_fd_sc_hd__o31a_2
XTAP_TAPCELL_ROW_64_589 vssd1 vccd1 sky130_fd_sc_hd__tapvpwrvgnd_1
X_1917_ _1918_/B _1918_/C _2678_/Q vssd1 vssd1 vccd1 vccd1 _1985_/A sky130_fd_sc_hd__a21oi_2
X_2897_ _2912_/CLK _2897_/D fanout117/X vssd1 vssd1 vccd1 vccd1 _2897_/Q sky130_fd_sc_hd__dfrtp_2
XANTENNA__1385__B _1385_/B vssd1 vssd1 vccd1 vccd1 sky130_fd_sc_hd__diode_2
X_1779_ _2624_/Q _1775_/A _1770_/C vssd1 vssd1 vccd1 vccd1 _1780_/B sky130_fd_sc_hd__o21ai_2
X_1848_ _2632_/Q _1907_/A vssd1 vssd1 vccd1 vccd1 _1848_/X sky130_fd_sc_hd__or2_2
XTAP_TAPCELL_ROW_4_167 vssd1 vccd1 sky130_fd_sc_hd__tapvpwrvgnd_1
XFILLER_25_241 vssd1 vssd1 vccd1 vccd1 sky130_fd_sc_hd__fill_2
XFILLER_40_211 vssd1 vssd1 vccd1 vccd1 sky130_fd_sc_hd__fill_4
XTAP_TAPCELL_ROW_55_523 vssd1 vccd1 sky130_fd_sc_hd__tapvpwrvgnd_1
XANTENNA__2171__S _2189_/S vssd1 vssd1 vccd1 vccd1 sky130_fd_sc_hd__diode_2
XFILLER_40_255 vssd1 vssd1 vccd1 vccd1 sky130_fd_sc_hd__fill_1
XFILLER_40_288 vssd1 vssd1 vccd1 vccd1 sky130_fd_sc_hd__fill_1
XFILLER_40_299 vssd1 vssd1 vccd1 vccd1 sky130_fd_sc_hd__fill_2
XFILLER_4_16 vssd1 vssd1 vccd1 vccd1 sky130_fd_sc_hd__fill_1
XFILLER_4_27 vssd1 vssd1 vccd1 vccd1 sky130_fd_sc_hd__fill_1
XFILLER_4_49 vssd1 vssd1 vccd1 vccd1 sky130_fd_sc_hd__fill_1
Xteam_06_231 vssd1 vssd1 vccd1 vccd1 gpio_oeb[29] team_06_231/LO sky130_fd_sc_hd__conb_1
Xteam_06_220 vssd1 vssd1 vccd1 vccd1 team_06_220/HI gpio_out[3] sky130_fd_sc_hd__conb_1
XANTENNA__2643__Q _2643_/Q vssd1 vssd1 vccd1 vccd1 sky130_fd_sc_hd__diode_2
XFILLER_16_285 vssd1 vssd1 vccd1 vccd1 sky130_fd_sc_hd__fill_2
XFILLER_31_277 vssd1 vssd1 vccd1 vccd1 sky130_fd_sc_hd__fill_1
XTAP_TAPCELL_ROW_18_269 vssd1 vccd1 sky130_fd_sc_hd__tapvpwrvgnd_1
X_2820_ _2923_/CLK _2820_/D _2331_/B vssd1 vssd1 vccd1 vccd1 _2820_/Q sky130_fd_sc_hd__dfrtp_2
X_2751_ _2768_/CLK _2751_/D load_slew142/X vssd1 vssd1 vccd1 vccd1 _2751_/Q sky130_fd_sc_hd__dfrtp_2
XANTENNA__2081__S _2136_/B vssd1 vssd1 vccd1 vccd1 sky130_fd_sc_hd__diode_2
X_1564_ _1582_/A _2639_/Q _1701_/S vssd1 vssd1 vccd1 vccd1 _1564_/X sky130_fd_sc_hd__and3_2
X_1633_ _2645_/Q _1716_/S _2549_/Q _1589_/X _1632_/X vssd1 vssd1 vccd1 vccd1 _1633_/X
+ sky130_fd_sc_hd__a221o_2
X_1702_ _2619_/Q _2636_/Q _1702_/S vssd1 vssd1 vccd1 vccd1 _1702_/X sky130_fd_sc_hd__mux2_1
X_2682_ _2883_/CLK _2682_/D _2510_/B2 vssd1 vssd1 vccd1 vccd1 _2682_/Q sky130_fd_sc_hd__dfrtp_2
X_1495_ _1538_/A _1495_/B _1522_/A vssd1 vssd1 vccd1 vccd1 _1499_/B sky130_fd_sc_hd__or3_2
XTAP_TAPCELL_ROW_1_148 vssd1 vccd1 sky130_fd_sc_hd__tapvpwrvgnd_1
XTAP_TAPCELL_ROW_52_504 vssd1 vccd1 sky130_fd_sc_hd__tapvpwrvgnd_1
Xfanout37 _2472_/B vssd1 vssd1 vccd1 vccd1 _2459_/B sky130_fd_sc_hd__clkdlybuf4s25_1
X_2116_ _2567_/Q _2583_/Q _2118_/S vssd1 vssd1 vccd1 vccd1 _2116_/X sky130_fd_sc_hd__mux2_1
X_2047_ _2055_/A _2055_/B vssd1 vssd1 vccd1 vccd1 _2047_/X sky130_fd_sc_hd__or2_2
Xfanout59 _1820_/Y vssd1 vssd1 vccd1 vccd1 _1869_/B sky130_fd_sc_hd__clkdlybuf4s25_1
XANTENNA__1740__A2 _2555_/Q vssd1 vssd1 vccd1 vccd1 sky130_fd_sc_hd__diode_2
XANTENNA__1843__B _2641_/Q vssd1 vssd1 vccd1 vccd1 sky130_fd_sc_hd__diode_2
XTAP_TAPCELL_ROW_9_204 vssd1 vccd1 sky130_fd_sc_hd__tapvpwrvgnd_1
Xhold440 _2697_/Q vssd1 vssd1 vccd1 vccd1 hold440/X sky130_fd_sc_hd__dlygate4sd3_1
Xhold451 _2620_/Q vssd1 vssd1 vccd1 vccd1 hold451/X sky130_fd_sc_hd__dlygate4sd3_1
Xhold462 _2682_/Q vssd1 vssd1 vccd1 vccd1 hold462/X sky130_fd_sc_hd__dlygate4sd3_1
Xhold473 _2764_/Q vssd1 vssd1 vccd1 vccd1 hold473/X sky130_fd_sc_hd__dlygate4sd3_1
Xhold484 _2756_/Q vssd1 vssd1 vccd1 vccd1 hold484/X sky130_fd_sc_hd__dlygate4sd3_1
Xhold495 _2678_/Q vssd1 vssd1 vccd1 vccd1 hold495/X sky130_fd_sc_hd__dlygate4sd3_1
XANTENNA__2166__S _2168_/S vssd1 vssd1 vccd1 vccd1 sky130_fd_sc_hd__diode_2
XANTENNA_fanout76_A _2156_/B vssd1 vssd1 vccd1 vccd1 sky130_fd_sc_hd__diode_2
XFILLER_13_222 vssd1 vssd1 vccd1 vccd1 sky130_fd_sc_hd__fill_2
XFILLER_53_391 vssd1 vssd1 vccd1 vccd1 sky130_fd_sc_hd__fill_1
XFILLER_54_54 vssd1 vssd1 vccd1 vccd1 sky130_fd_sc_hd__fill_1
XANTENNA__1753__B _2558_/Q vssd1 vssd1 vccd1 vccd1 sky130_fd_sc_hd__diode_2
XANTENNA__2638__Q _2638_/Q vssd1 vssd1 vccd1 vccd1 sky130_fd_sc_hd__diode_2
XFILLER_48_141 vssd1 vssd1 vccd1 vccd1 sky130_fd_sc_hd__fill_1
X_1280_ _1415_/A _1280_/B vssd1 vssd1 vccd1 vccd1 _1280_/Y sky130_fd_sc_hd__nor2_2
XFILLER_48_163 vssd1 vssd1 vccd1 vccd1 sky130_fd_sc_hd__fill_4
XFILLER_48_185 vssd1 vssd1 vccd1 vccd1 sky130_fd_sc_hd__fill_2
XFILLER_63_111 vssd1 vssd1 vccd1 vccd1 sky130_fd_sc_hd__fill_1
X_2803_ _2870_/CLK _2803_/D fanout124/X vssd1 vssd1 vccd1 vccd1 _2803_/Q sky130_fd_sc_hd__dfrtp_2
X_2734_ _2869_/CLK _2734_/D fanout120/X vssd1 vssd1 vccd1 vccd1 _2734_/Q sky130_fd_sc_hd__dfrtp_2
XANTENNA__1944__A _1944_/A vssd1 vssd1 vccd1 vccd1 sky130_fd_sc_hd__diode_2
XFILLER_59_406 vssd1 vssd1 vccd1 vccd1 sky130_fd_sc_hd__fill_1
XFILLER_5_81 vssd1 vssd1 vccd1 vccd1 sky130_fd_sc_hd__fill_2
X_1547_ _2472_/A _1651_/B vssd1 vssd1 vccd1 vccd1 _1549_/B sky130_fd_sc_hd__or2_2
X_1616_ _1796_/A1 _2655_/Q _2544_/Q _1589_/X vssd1 vssd1 vccd1 vccd1 _1618_/A sky130_fd_sc_hd__a22o_2
X_2665_ _2883_/CLK _2665_/D _2510_/B2 vssd1 vssd1 vccd1 vccd1 _2665_/Q sky130_fd_sc_hd__dfrtp_2
X_2596_ clkload8/A _2596_/D vssd1 vssd1 vccd1 vccd1 _2596_/Q sky130_fd_sc_hd__dfxtp_2
XFILLER_39_185 vssd1 vssd1 vccd1 vccd1 sky130_fd_sc_hd__fill_4
X_1478_ _2913_/Q _1479_/C _2914_/Q vssd1 vssd1 vccd1 vccd1 _1480_/A sky130_fd_sc_hd__a21oi_2
XANTENNA_fanout166_X _1662_/D vssd1 vssd1 vccd1 vccd1 sky130_fd_sc_hd__diode_2
XFILLER_10_203 vssd1 vssd1 vccd1 vccd1 sky130_fd_sc_hd__fill_1
XFILLER_24_13 vssd1 vssd1 vccd1 vccd1 sky130_fd_sc_hd__fill_1
XFILLER_24_35 vssd1 vssd1 vccd1 vccd1 sky130_fd_sc_hd__fill_1
XFILLER_54_199 vssd1 vssd1 vccd1 vccd1 sky130_fd_sc_hd__fill_1
XTAP_TAPCELL_ROW_37_397 vssd1 vccd1 sky130_fd_sc_hd__tapvpwrvgnd_1
XFILLER_40_56 vssd1 vssd1 vccd1 vccd1 sky130_fd_sc_hd__fill_1
XANTENNA_fanout79_X _2297_/B1 vssd1 vssd1 vccd1 vccd1 sky130_fd_sc_hd__diode_2
Xhold270 _2527_/Q vssd1 vssd1 vccd1 vccd1 hold270/X sky130_fd_sc_hd__dlygate4sd3_1
Xhold281 _2575_/Q vssd1 vssd1 vccd1 vccd1 hold281/X sky130_fd_sc_hd__dlygate4sd3_1
Xhold292 _2576_/Q vssd1 vssd1 vccd1 vccd1 hold292/X sky130_fd_sc_hd__dlygate4sd3_1
XTAP_TAPCELL_ROW_11_220 vssd1 vccd1 sky130_fd_sc_hd__tapvpwrvgnd_1
XFILLER_60_7 vssd1 vssd1 vccd1 vccd1 sky130_fd_sc_hd__fill_2
X_1401_ _2330_/A _1401_/B vssd1 vssd1 vccd1 vccd1 _1401_/Y sky130_fd_sc_hd__nor2_2
X_2450_ _2839_/Q _2838_/Q _2840_/Q _2450_/D vssd1 vssd1 vccd1 vccd1 _2454_/B sky130_fd_sc_hd__and4_2
X_2381_ _2389_/C _2381_/B vssd1 vssd1 vccd1 vccd1 _2385_/C sky130_fd_sc_hd__and2_2
X_1263_ _1263_/A vssd1 vssd1 vccd1 vccd1 _1263_/Y sky130_fd_sc_hd__inv_2
X_1332_ _2735_/Q _1328_/X _1329_/X _1326_/X _1331_/X vssd1 vssd1 vccd1 vccd1 _1332_/X
+ sky130_fd_sc_hd__o221a_2
Xinput5 gpio_in[3] vssd1 vssd1 vccd1 vccd1 input5/X sky130_fd_sc_hd__clkdlybuf4s25_1
XFILLER_36_199 vssd1 vssd1 vccd1 vccd1 sky130_fd_sc_hd__fill_2
XTAP_TAPCELL_ROW_34_378 vssd1 vccd1 sky130_fd_sc_hd__tapvpwrvgnd_1
XANTENNA_fanout126_A fanout132/X vssd1 vssd1 vccd1 vccd1 sky130_fd_sc_hd__diode_2
X_2717_ _2719_/CLK _2717_/D fanout135/X vssd1 vssd1 vccd1 vccd1 _2717_/Q sky130_fd_sc_hd__dfrtp_2
XFILLER_59_214 vssd1 vssd1 vccd1 vccd1 sky130_fd_sc_hd__fill_1
XFILLER_59_258 vssd1 vssd1 vccd1 vccd1 sky130_fd_sc_hd__fill_1
X_2648_ _2663_/CLK _2648_/D load_slew101/X vssd1 vssd1 vccd1 vccd1 _2648_/Q sky130_fd_sc_hd__dfrtp_2
X_2579_ _2883_/CLK _2579_/D vssd1 vssd1 vccd1 vccd1 _2579_/Q sky130_fd_sc_hd__dfxtp_2
XFILLER_19_57 vssd1 vssd1 vccd1 vccd1 sky130_fd_sc_hd__fill_2
XTAP_TAPCELL_ROW_25_312 vssd1 vccd1 sky130_fd_sc_hd__tapvpwrvgnd_1
XANTENNA__1568__B _2641_/Q vssd1 vssd1 vccd1 vccd1 sky130_fd_sc_hd__diode_2
XFILLER_30_309 vssd1 vssd1 vccd1 vccd1 sky130_fd_sc_hd__fill_2
XFILLER_50_180 vssd1 vssd1 vccd1 vccd1 sky130_fd_sc_hd__fill_4
XFILLER_51_44 vssd1 vssd1 vccd1 vccd1 sky130_fd_sc_hd__fill_1
XFILLER_33_169 vssd1 vssd1 vccd1 vccd1 sky130_fd_sc_hd__fill_2
X_1950_ _2670_/Q _1950_/B _1950_/C vssd1 vssd1 vccd1 vccd1 _2014_/B sky130_fd_sc_hd__nand3_2
XTAP_TAPCELL_ROW_31_359 vssd1 vccd1 sky130_fd_sc_hd__tapvpwrvgnd_1
X_1881_ _2640_/Q _1881_/B vssd1 vssd1 vccd1 vccd1 _1882_/B sky130_fd_sc_hd__or2_2
X_2502_ _2502_/A _2502_/B vssd1 vssd1 vccd1 vccd1 _2503_/B sky130_fd_sc_hd__nor2_2
XANTENNA__1689__A1 _2643_/Q vssd1 vssd1 vccd1 vccd1 sky130_fd_sc_hd__diode_2
XANTENNA__2350__A2 _2472_/A vssd1 vssd1 vccd1 vccd1 sky130_fd_sc_hd__diode_2
XFILLER_51_3 vssd1 vssd1 vccd1 vccd1 sky130_fd_sc_hd__fill_1
X_1315_ _2791_/Q _2730_/Q vssd1 vssd1 vccd1 vccd1 _1315_/X sky130_fd_sc_hd__or2_2
X_2433_ _2435_/B _2433_/B vssd1 vssd1 vccd1 vccd1 _2433_/X sky130_fd_sc_hd__or2_2
X_2364_ _2857_/Q _2364_/B _2854_/Q vssd1 vssd1 vccd1 vccd1 _2365_/C sky130_fd_sc_hd__or3b_2
XFILLER_2_71 vssd1 vssd1 vccd1 vccd1 sky130_fd_sc_hd__fill_4
XTAP_TAPCELL_ROW_39_415 vssd1 vccd1 sky130_fd_sc_hd__tapvpwrvgnd_1
XTAP_TAPCELL_ROW_47_470 vssd1 vccd1 sky130_fd_sc_hd__tapvpwrvgnd_1
X_2295_ _2297_/A1 hold389/X _2297_/B1 hold466/X vssd1 vssd1 vccd1 vccd1 _2772_/D sky130_fd_sc_hd__a22o_2
XANTENNA_hold455_A _2770_/Q vssd1 vssd1 vccd1 vccd1 sky130_fd_sc_hd__diode_2
XFILLER_47_217 vssd1 vssd1 vccd1 vccd1 sky130_fd_sc_hd__fill_4
XFILLER_15_169 vssd1 vssd1 vccd1 vccd1 sky130_fd_sc_hd__fill_2
XFILLER_46_44 vssd1 vssd1 vccd1 vccd1 sky130_fd_sc_hd__fill_1
XANTENNA__1604__A1 _2637_/Q vssd1 vssd1 vccd1 vccd1 sky130_fd_sc_hd__diode_2
XFILLER_7_346 vssd1 vssd1 vccd1 vccd1 sky130_fd_sc_hd__fill_4
XANTENNA__2646__Q _2646_/Q vssd1 vssd1 vccd1 vccd1 sky130_fd_sc_hd__diode_2
X_2080_ _2580_/Q _2564_/Q _2120_/S vssd1 vssd1 vccd1 vccd1 _2080_/X sky130_fd_sc_hd__mux2_1
XTAP_TAPCELL_ROW_44_451 vssd1 vccd1 sky130_fd_sc_hd__tapvpwrvgnd_1
X_1933_ _1934_/B _1934_/C _2674_/Q vssd1 vssd1 vccd1 vccd1 _1979_/A sky130_fd_sc_hd__a21oi_2
X_1795_ _1798_/B _1795_/B vssd1 vssd1 vccd1 vccd1 _1795_/Y sky130_fd_sc_hd__nor2_2
X_1864_ _2699_/Q _1869_/B _1851_/Y vssd1 vssd1 vccd1 vccd1 _1864_/X sky130_fd_sc_hd__a21o_2
XFILLER_29_217 vssd1 vssd1 vccd1 vccd1 sky130_fd_sc_hd__fill_4
X_2416_ _2375_/B _1543_/B _2361_/Y vssd1 vssd1 vccd1 vccd1 _2416_/X sky130_fd_sc_hd__a21bo_2
X_2347_ hold273/X _2330_/Y _2345_/A _2346_/X vssd1 vssd1 vccd1 vccd1 _2809_/D sky130_fd_sc_hd__o211a_2
X_2278_ _1351_/A _2276_/X _2277_/Y hold404/X _2282_/A2 vssd1 vssd1 vccd1 vccd1 _2758_/D
+ sky130_fd_sc_hd__a32o_2
XFILLER_37_250 vssd1 vssd1 vccd1 vccd1 sky130_fd_sc_hd__fill_1
XFILLER_52_231 vssd1 vssd1 vccd1 vccd1 sky130_fd_sc_hd__fill_1
XFILLER_4_316 vssd1 vssd1 vccd1 vccd1 sky130_fd_sc_hd__fill_1
XTAP_TAPCELL_ROW_50_487 vssd1 vccd1 sky130_fd_sc_hd__tapvpwrvgnd_1
XANTENNA__2169__S _2189_/S vssd1 vssd1 vccd1 vccd1 sky130_fd_sc_hd__diode_2
XANTENNA_fanout61_X _1686_/S vssd1 vssd1 vccd1 vccd1 sky130_fd_sc_hd__diode_2
XTAP_TAPCELL_ROW_58_543 vssd1 vccd1 sky130_fd_sc_hd__tapvpwrvgnd_1
XTAP_TAPCELL_ROW_7_187 vssd1 vccd1 sky130_fd_sc_hd__tapvpwrvgnd_1
XFILLER_28_294 vssd1 vssd1 vccd1 vccd1 sky130_fd_sc_hd__fill_2
XFILLER_7_187 vssd1 vssd1 vccd1 vccd1 sky130_fd_sc_hd__fill_1
X_1580_ _1580_/A _2647_/Q _1723_/S vssd1 vssd1 vccd1 vccd1 _1580_/X sky130_fd_sc_hd__and3_2
XANTENNA__2079__S _2136_/B vssd1 vssd1 vccd1 vccd1 sky130_fd_sc_hd__diode_2
X_2201_ _2760_/Q _2714_/Q _2761_/Q _2715_/Q vssd1 vssd1 vccd1 vccd1 _2202_/B sky130_fd_sc_hd__a22oi_2
X_2132_ _2575_/Q _2591_/Q _2134_/S vssd1 vssd1 vccd1 vccd1 _2132_/X sky130_fd_sc_hd__mux2_1
XANTENNA__1292__A2 _2969_/A vssd1 vssd1 vccd1 vccd1 sky130_fd_sc_hd__diode_2
XFILLER_19_283 vssd1 vssd1 vccd1 vccd1 sky130_fd_sc_hd__fill_1
XFILLER_34_253 vssd1 vssd1 vccd1 vccd1 sky130_fd_sc_hd__fill_1
XPHY_EDGE_ROW_14_Left_79 vssd1 vssd1 vccd1 vccd1 sky130_fd_sc_hd__decap_3
X_2063_ hold493/X _2062_/Y _2882_/Q vssd1 vssd1 vccd1 vccd1 _2661_/D sky130_fd_sc_hd__mux2_1
X_1847_ _2647_/Q _2646_/Q _1903_/B vssd1 vssd1 vccd1 vccd1 _1907_/A sky130_fd_sc_hd__and3_2
X_1916_ _1944_/A _2693_/Q vssd1 vssd1 vccd1 vccd1 _1918_/C sky130_fd_sc_hd__nand2_2
X_2896_ _2916_/CLK _2896_/D _2335_/B1 vssd1 vssd1 vccd1 vccd1 _2896_/Q sky130_fd_sc_hd__dfrtp_2
X_1778_ _2623_/Q _2624_/Q _1783_/D vssd1 vssd1 vccd1 vccd1 _1780_/A sky130_fd_sc_hd__and3_2
XTAP_TAPCELL_ROW_4_168 vssd1 vccd1 sky130_fd_sc_hd__tapvpwrvgnd_1
XTAP_TAPCELL_ROW_55_524 vssd1 vccd1 sky130_fd_sc_hd__tapvpwrvgnd_1
XFILLER_43_67 vssd1 vssd1 vccd1 vccd1 sky130_fd_sc_hd__fill_1
XANTENNA__1576__B _2645_/Q vssd1 vssd1 vccd1 vccd1 sky130_fd_sc_hd__diode_2
XFILLER_4_157 vssd1 vssd1 vccd1 vccd1 sky130_fd_sc_hd__fill_4
Xteam_06_232 vssd1 vssd1 vccd1 vccd1 gpio_oeb[30] team_06_232/LO sky130_fd_sc_hd__conb_1
Xteam_06_221 vssd1 vssd1 vccd1 vccd1 team_06_221/HI gpio_out[29] sky130_fd_sc_hd__conb_1
Xteam_06_210 vssd1 vssd1 vccd1 vccd1 team_06_210/HI gpio_oeb[22] sky130_fd_sc_hd__conb_1
XFILLER_16_242 vssd1 vssd1 vccd1 vccd1 sky130_fd_sc_hd__fill_1
X_1701_ hold308/X _1700_/X _1701_/S vssd1 vssd1 vccd1 vccd1 _2598_/D sky130_fd_sc_hd__mux2_1
X_2750_ _2765_/CLK _2750_/D fanout137/X vssd1 vssd1 vccd1 vccd1 _2750_/Q sky130_fd_sc_hd__dfrtp_2
X_2681_ _2883_/CLK _2681_/D _2510_/B2 vssd1 vssd1 vccd1 vccd1 _2681_/Q sky130_fd_sc_hd__dfrtp_2
XFILLER_3_190 vssd1 vssd1 vccd1 vccd1 sky130_fd_sc_hd__fill_2
X_1494_ _2823_/Q _2822_/Q _2825_/Q _2824_/Q vssd1 vssd1 vccd1 vccd1 _1522_/A sky130_fd_sc_hd__or4_2
X_1563_ hold291/X _1558_/B _1562_/X vssd1 vssd1 vccd1 vccd1 _2526_/D sky130_fd_sc_hd__a21o_2
X_1632_ _1384_/B _2709_/Q _2660_/Q _1796_/A1 vssd1 vssd1 vccd1 vccd1 _1632_/X sky130_fd_sc_hd__a22o_2
XANTENNA_clkbuf_3_3__f_clk_A clkbuf_0_clk/X vssd1 vssd1 vccd1 vccd1 sky130_fd_sc_hd__diode_2
XTAP_TAPCELL_ROW_1_149 vssd1 vccd1 sky130_fd_sc_hd__tapvpwrvgnd_1
X_2115_ hold436/X _2114_/X _2882_/D vssd1 vssd1 vccd1 vccd1 _2684_/D sky130_fd_sc_hd__mux2_1
XANTENNA_fanout156_A _1722_/S vssd1 vssd1 vccd1 vccd1 sky130_fd_sc_hd__diode_2
XTAP_TAPCELL_ROW_52_505 vssd1 vccd1 sky130_fd_sc_hd__tapvpwrvgnd_1
Xfanout49 _2134_/S vssd1 vssd1 vccd1 vccd1 _2120_/S sky130_fd_sc_hd__clkdlybuf4s25_1
Xfanout38 _2371_/X vssd1 vssd1 vccd1 vccd1 _2472_/B sky130_fd_sc_hd__clkdlybuf4s25_1
X_2046_ _2045_/X _2044_/Y hold528/X _2052_/B2 vssd1 vssd1 vccd1 vccd1 _2658_/D sky130_fd_sc_hd__a2bb2o_2
XFILLER_13_59 vssd1 vssd1 vccd1 vccd1 sky130_fd_sc_hd__fill_1
XFILLER_22_289 vssd1 vssd1 vccd1 vccd1 sky130_fd_sc_hd__fill_1
XTAP_TAPCELL_ROW_60_560 vssd1 vccd1 sky130_fd_sc_hd__tapvpwrvgnd_1
XTAP_TAPCELL_ROW_9_205 vssd1 vccd1 sky130_fd_sc_hd__tapvpwrvgnd_1
X_2879_ _2880_/CLK _2879_/D _1662_/C vssd1 vssd1 vccd1 vccd1 _2879_/Q sky130_fd_sc_hd__dfrtp_2
XANTENNA__1843__C _2640_/Q vssd1 vssd1 vccd1 vccd1 sky130_fd_sc_hd__diode_2
XFILLER_38_45 vssd1 vssd1 vccd1 vccd1 sky130_fd_sc_hd__fill_1
Xhold430 _2820_/Q vssd1 vssd1 vccd1 vccd1 _2387_/A sky130_fd_sc_hd__dlygate4sd3_1
Xhold441 _2683_/Q vssd1 vssd1 vccd1 vccd1 hold441/X sky130_fd_sc_hd__dlygate4sd3_1
Xhold452 _2905_/Q vssd1 vssd1 vccd1 vccd1 hold452/X sky130_fd_sc_hd__dlygate4sd3_1
Xhold463 _2689_/Q vssd1 vssd1 vccd1 vccd1 hold463/X sky130_fd_sc_hd__dlygate4sd3_1
Xhold474 _2650_/Q vssd1 vssd1 vccd1 vccd1 hold474/X sky130_fd_sc_hd__dlygate4sd3_1
Xhold485 _2821_/Q vssd1 vssd1 vccd1 vccd1 hold485/X sky130_fd_sc_hd__dlygate4sd3_1
Xhold496 _2830_/Q vssd1 vssd1 vccd1 vccd1 _2411_/A sky130_fd_sc_hd__dlygate4sd3_1
XANTENNA__2150__A0 _2708_/Q vssd1 vssd1 vccd1 vccd1 sky130_fd_sc_hd__diode_2
XFILLER_54_44 vssd1 vssd1 vccd1 vccd1 sky130_fd_sc_hd__fill_1
XFILLER_57_164 vssd1 vssd1 vccd1 vccd1 sky130_fd_sc_hd__fill_4
XANTENNA__2453__B2 _2472_/B vssd1 vssd1 vccd1 vccd1 sky130_fd_sc_hd__diode_2
XFILLER_9_205 vssd1 vssd1 vccd1 vccd1 sky130_fd_sc_hd__fill_1
XFILLER_48_9 vssd1 vssd1 vccd1 vccd1 sky130_fd_sc_hd__fill_1
XANTENNA__2141__A0 _2699_/Q vssd1 vssd1 vccd1 vccd1 sky130_fd_sc_hd__diode_2
XFILLER_63_134 vssd1 vssd1 vccd1 vccd1 sky130_fd_sc_hd__fill_2
XFILLER_63_189 vssd1 vssd1 vccd1 vccd1 sky130_fd_sc_hd__fill_1
XTAP_TAPCELL_ROW_14_240 vssd1 vccd1 sky130_fd_sc_hd__tapvpwrvgnd_1
X_2802_ _2870_/CLK _2802_/D fanout124/X vssd1 vssd1 vccd1 vccd1 _2802_/Q sky130_fd_sc_hd__dfrtp_2
X_2733_ _2869_/CLK _2733_/D fanout120/X vssd1 vssd1 vccd1 vccd1 _2733_/Q sky130_fd_sc_hd__dfrtp_2
X_2664_ clkload2/A _2664_/D _2473_/A1 vssd1 vssd1 vccd1 vccd1 _2664_/Q sky130_fd_sc_hd__dfrtp_2
X_1477_ _1477_/A1 _1475_/Y _1476_/X _1477_/B1 hold541/X vssd1 vssd1 vccd1 vccd1 _2913_/D
+ sky130_fd_sc_hd__a32o_2
X_1546_ _1662_/D _2561_/Q _1662_/C _1546_/D vssd1 vssd1 vccd1 vccd1 _1546_/X sky130_fd_sc_hd__and4_2
X_1615_ _2640_/Q _1710_/S _1590_/A vssd1 vssd1 vccd1 vccd1 _1615_/X sky130_fd_sc_hd__a21o_2
X_2595_ _2884_/CLK _2595_/D vssd1 vssd1 vccd1 vccd1 _2595_/Q sky130_fd_sc_hd__dfxtp_2
XANTENNA_fanout159_X _1722_/S vssd1 vssd1 vccd1 vccd1 sky130_fd_sc_hd__diode_2
XPHY_EDGE_ROW_17_Left_82 vssd1 vssd1 vccd1 vccd1 sky130_fd_sc_hd__decap_3
XTAP_TAPCELL_ROW_37_398 vssd1 vccd1 sky130_fd_sc_hd__tapvpwrvgnd_1
X_2029_ _2028_/X _2027_/Y hold516/X _2069_/B1 vssd1 vssd1 vccd1 vccd1 _2655_/D sky130_fd_sc_hd__a2bb2o_2
XFILLER_40_46 vssd1 vssd1 vccd1 vccd1 sky130_fd_sc_hd__fill_1
Xhold271 _2719_/Q vssd1 vssd1 vccd1 vccd1 hold271/X sky130_fd_sc_hd__dlygate4sd3_1
Xhold260 _2863_/Q vssd1 vssd1 vccd1 vccd1 hold260/X sky130_fd_sc_hd__dlygate4sd3_1
Xhold282 _2580_/Q vssd1 vssd1 vccd1 vccd1 hold282/X sky130_fd_sc_hd__dlygate4sd3_1
Xhold293 _2581_/Q vssd1 vssd1 vccd1 vccd1 hold293/X sky130_fd_sc_hd__dlygate4sd3_1
XFILLER_41_395 vssd1 vssd1 vccd1 vccd1 sky130_fd_sc_hd__fill_1
XFILLER_53_7 vssd1 vssd1 vccd1 vccd1 sky130_fd_sc_hd__fill_2
X_1331_ _2736_/Q _1331_/B vssd1 vssd1 vccd1 vccd1 _1331_/X sky130_fd_sc_hd__or2_2
X_1400_ _2816_/Q _1399_/Y _1400_/S vssd1 vssd1 vccd1 vccd1 _1401_/B sky130_fd_sc_hd__mux2_1
X_2380_ _2378_/A _2381_/B _2817_/Q vssd1 vssd1 vccd1 vccd1 _2382_/A sky130_fd_sc_hd__a21oi_2
XANTENNA__2087__S _2882_/D vssd1 vssd1 vccd1 vccd1 sky130_fd_sc_hd__diode_2
X_1262_ _2664_/Q vssd1 vssd1 vccd1 vccd1 _1355_/B sky130_fd_sc_hd__inv_2
Xinput6 nrst vssd1 vssd1 vccd1 vccd1 input6/X sky130_fd_sc_hd__clkdlybuf4s25_1
XTAP_TAPCELL_ROW_34_379 vssd1 vccd1 sky130_fd_sc_hd__tapvpwrvgnd_1
X_2716_ _2804_/CLK _2716_/D fanout135/X vssd1 vssd1 vccd1 vccd1 _2716_/Q sky130_fd_sc_hd__dfrtp_2
X_2647_ _2647_/CLK _2647_/D wire131/X vssd1 vssd1 vccd1 vccd1 _2647_/Q sky130_fd_sc_hd__dfrtp_2
XFILLER_19_36 vssd1 vssd1 vccd1 vccd1 sky130_fd_sc_hd__fill_1
XFILLER_59_248 vssd1 vssd1 vccd1 vccd1 sky130_fd_sc_hd__fill_1
X_1529_ _1538_/A _1511_/B _1526_/X _2823_/Q vssd1 vssd1 vccd1 vccd1 _1529_/X sky130_fd_sc_hd__a31o_2
X_2578_ clkload2/A _2578_/D vssd1 vssd1 vccd1 vccd1 _2578_/Q sky130_fd_sc_hd__dfxtp_2
XTAP_TAPCELL_ROW_25_313 vssd1 vccd1 sky130_fd_sc_hd__tapvpwrvgnd_1
XPHY_EDGE_ROW_14_Right_14 vssd1 vssd1 vccd1 vccd1 sky130_fd_sc_hd__decap_3
XPHY_EDGE_ROW_2_Left_67 vssd1 vssd1 vccd1 vccd1 sky130_fd_sc_hd__decap_3
Xclkbuf_3_3__f_clk clkbuf_0_clk/X vssd1 vssd1 vccd1 vccd1 clkbuf_leaf_5_clk/A sky130_fd_sc_hd__clkbuf_16
XPHY_EDGE_ROW_23_Right_23 vssd1 vssd1 vccd1 vccd1 sky130_fd_sc_hd__decap_3
XPHY_EDGE_ROW_32_Right_32 vssd1 vssd1 vccd1 vccd1 sky130_fd_sc_hd__decap_3
X_1880_ _2639_/Q _1879_/X _1891_/S vssd1 vssd1 vccd1 vccd1 _2639_/D sky130_fd_sc_hd__mux2_1
X_2501_ _2858_/Q _2502_/B vssd1 vssd1 vccd1 vccd1 _2505_/C sky130_fd_sc_hd__and2_2
XFILLER_44_3 vssd1 vssd1 vccd1 vccd1 sky130_fd_sc_hd__fill_2
XPHY_EDGE_ROW_41_Right_41 vssd1 vssd1 vccd1 vccd1 sky130_fd_sc_hd__decap_3
XTAP_TAPCELL_ROW_39_416 vssd1 vccd1 sky130_fd_sc_hd__tapvpwrvgnd_1
X_1314_ _1319_/B _1319_/C _2731_/Q vssd1 vssd1 vccd1 vccd1 _1314_/X sky130_fd_sc_hd__o21a_2
X_2432_ _2834_/Q _2431_/C _2835_/Q vssd1 vssd1 vccd1 vccd1 _2433_/B sky130_fd_sc_hd__a21oi_2
X_2363_ _2846_/Q _2849_/Q _2363_/C vssd1 vssd1 vccd1 vccd1 _2365_/B sky130_fd_sc_hd__or3_2
X_2294_ _2297_/A1 hold484/X _2297_/B1 hold490/X vssd1 vssd1 vccd1 vccd1 _2771_/D sky130_fd_sc_hd__a22o_2
XFILLER_49_281 vssd1 vssd1 vccd1 vccd1 sky130_fd_sc_hd__fill_1
XPHY_EDGE_ROW_50_Right_50 vssd1 vssd1 vccd1 vccd1 sky130_fd_sc_hd__decap_3
XTAP_TAPCELL_ROW_47_471 vssd1 vccd1 sky130_fd_sc_hd__tapvpwrvgnd_1
XANTENNA__2326__B1 _2156_/B vssd1 vssd1 vccd1 vccd1 sky130_fd_sc_hd__diode_2
XANTENNA__1624__S _1624_/S vssd1 vssd1 vccd1 vccd1 sky130_fd_sc_hd__diode_2
XANTENNA_fanout51_A _2134_/S vssd1 vssd1 vccd1 vccd1 sky130_fd_sc_hd__diode_2
XFILLER_11_310 vssd1 vssd1 vccd1 vccd1 sky130_fd_sc_hd__fill_4
XFILLER_23_181 vssd1 vssd1 vccd1 vccd1 sky130_fd_sc_hd__fill_4
XFILLER_11_92 vssd1 vssd1 vccd1 vccd1 sky130_fd_sc_hd__fill_2
XFILLER_34_402 vssd1 vssd1 vccd1 vccd1 sky130_fd_sc_hd__fill_1
XFILLER_46_240 vssd1 vssd1 vccd1 vccd1 sky130_fd_sc_hd__fill_2
X_1863_ _1834_/X _1863_/B _1863_/C vssd1 vssd1 vccd1 vccd1 _1863_/X sky130_fd_sc_hd__and3b_2
X_1932_ _1944_/A _2689_/Q vssd1 vssd1 vccd1 vccd1 _1934_/C sky130_fd_sc_hd__nand2_2
X_1794_ _2627_/Q _1790_/A _1770_/C vssd1 vssd1 vccd1 vccd1 _1795_/B sky130_fd_sc_hd__o21ai_2
X_2415_ _2420_/B _2415_/B vssd1 vssd1 vccd1 vccd1 _2415_/Y sky130_fd_sc_hd__nand2b_2
X_2346_ _2332_/B _2919_/Q _2348_/C _2337_/X _2340_/A vssd1 vssd1 vccd1 vccd1 _2346_/X
+ sky130_fd_sc_hd__a41o_2
X_2277_ _2276_/A _2276_/B _2276_/C vssd1 vssd1 vccd1 vccd1 _2277_/Y sky130_fd_sc_hd__o21ai_2
XFILLER_12_118 vssd1 vssd1 vccd1 vccd1 sky130_fd_sc_hd__fill_1
Xclkbuf_leaf_32_clk clkbuf_3_4__f_clk/X vssd1 vssd1 vccd1 vccd1 _2813_/CLK sky130_fd_sc_hd__clkbuf_8
XANTENNA__1598__A1 _2635_/Q vssd1 vssd1 vccd1 vccd1 sky130_fd_sc_hd__diode_2
XTAP_TAPCELL_ROW_50_488 vssd1 vccd1 sky130_fd_sc_hd__tapvpwrvgnd_1
XANTENNA_fanout99_A fanout99/A vssd1 vssd1 vccd1 vccd1 sky130_fd_sc_hd__diode_2
XTAP_TAPCELL_ROW_7_188 vssd1 vccd1 sky130_fd_sc_hd__tapvpwrvgnd_1
XFILLER_16_402 vssd1 vssd1 vccd1 vccd1 sky130_fd_sc_hd__fill_4
XFILLER_57_55 vssd1 vssd1 vccd1 vccd1 sky130_fd_sc_hd__fill_1
XTAP_TAPCELL_ROW_58_544 vssd1 vccd1 sky130_fd_sc_hd__tapvpwrvgnd_1
XFILLER_7_111 vssd1 vssd1 vccd1 vccd1 sky130_fd_sc_hd__fill_1
XFILLER_7_122 vssd1 vssd1 vccd1 vccd1 sky130_fd_sc_hd__fill_4
Xclkbuf_leaf_23_clk clkbuf_3_4__f_clk/X vssd1 vssd1 vccd1 vccd1 clkload8/A sky130_fd_sc_hd__clkbuf_8
XFILLER_7_144 vssd1 vssd1 vccd1 vccd1 sky130_fd_sc_hd__fill_2
XPHY_EDGE_ROW_5_Left_70 vssd1 vssd1 vccd1 vccd1 sky130_fd_sc_hd__decap_3
X_2200_ _2198_/Y _2200_/B vssd1 vssd1 vccd1 vccd1 _2203_/A sky130_fd_sc_hd__and2b_2
X_2131_ hold435/X _2130_/X _2135_/S vssd1 vssd1 vccd1 vccd1 _2692_/D sky130_fd_sc_hd__mux2_1
X_2062_ _2062_/A _2062_/B vssd1 vssd1 vccd1 vccd1 _2062_/Y sky130_fd_sc_hd__xnor2_2
XANTENNA__2095__S _2125_/S vssd1 vssd1 vccd1 vccd1 sky130_fd_sc_hd__diode_2
X_1777_ _2623_/Q _1814_/B2 _1775_/Y _1776_/X vssd1 vssd1 vccd1 vccd1 _2623_/D sky130_fd_sc_hd__o22a_2
X_1846_ _2646_/Q _1903_/B vssd1 vssd1 vccd1 vccd1 _1846_/Y sky130_fd_sc_hd__nand2_2
X_1915_ _1944_/A _2693_/Q vssd1 vssd1 vccd1 vccd1 _1918_/B sky130_fd_sc_hd__or2_2
Xclkbuf_leaf_14_clk clkbuf_3_6__f_clk/X vssd1 vssd1 vccd1 vccd1 _2642_/CLK sky130_fd_sc_hd__clkbuf_8
X_2895_ _2916_/CLK _2895_/D _2335_/B1 vssd1 vssd1 vccd1 vccd1 _2895_/Q sky130_fd_sc_hd__dfrtp_2
XPHY_EDGE_ROW_4_Right_4 vssd1 vssd1 vccd1 vccd1 sky130_fd_sc_hd__decap_3
XTAP_TAPCELL_ROW_4_169 vssd1 vccd1 sky130_fd_sc_hd__tapvpwrvgnd_1
XTAP_TAPCELL_ROW_55_525 vssd1 vccd1 sky130_fd_sc_hd__tapvpwrvgnd_1
X_2329_ _2805_/Q _2330_/A _1392_/X _1267_/Y vssd1 vssd1 vccd1 vccd1 _2805_/D sky130_fd_sc_hd__a22o_2
XTAP_TAPCELL_ROW_63_580 vssd1 vccd1 sky130_fd_sc_hd__tapvpwrvgnd_1
XANTENNA__1873__A _2638_/Q vssd1 vssd1 vccd1 vccd1 sky130_fd_sc_hd__diode_2
XANTENNA__2969__A _2969_/A vssd1 vssd1 vccd1 vccd1 sky130_fd_sc_hd__diode_2
Xteam_06_222 vssd1 vssd1 vccd1 vccd1 team_06_222/HI gpio_out[30] sky130_fd_sc_hd__conb_1
Xteam_06_211 vssd1 vssd1 vccd1 vccd1 team_06_211/HI gpio_oeb[23] sky130_fd_sc_hd__conb_1
Xteam_06_200 vssd1 vssd1 vccd1 vccd1 team_06_200/HI gpio_oeb[12] sky130_fd_sc_hd__conb_1
XPHY_EDGE_ROW_31_Left_96 vssd1 vssd1 vccd1 vccd1 sky130_fd_sc_hd__decap_3
Xteam_06_233 vssd1 vssd1 vccd1 vccd1 gpio_oeb[31] team_06_233/LO sky130_fd_sc_hd__conb_1
XANTENNA__2471__A2 _2472_/A vssd1 vssd1 vccd1 vccd1 sky130_fd_sc_hd__diode_2
XFILLER_31_246 vssd1 vssd1 vccd1 vccd1 sky130_fd_sc_hd__fill_1
X_1631_ _2627_/Q _1586_/Y _1624_/S hold468/X _1630_/X vssd1 vssd1 vccd1 vccd1 _2548_/D
+ sky130_fd_sc_hd__o221a_2
X_1700_ _2618_/Q _2635_/Q _1702_/S vssd1 vssd1 vccd1 vccd1 _1700_/X sky130_fd_sc_hd__mux2_1
X_2680_ _2883_/CLK _2680_/D _2510_/B2 vssd1 vssd1 vccd1 vccd1 _2680_/Q sky130_fd_sc_hd__dfrtp_2
X_1493_ _1538_/A _1495_/B vssd1 vssd1 vccd1 vccd1 _1493_/Y sky130_fd_sc_hd__nor2_2
X_1562_ _1582_/A _2638_/Q _1701_/S vssd1 vssd1 vccd1 vccd1 _1562_/X sky130_fd_sc_hd__and3_2
Xclkbuf_leaf_3_clk clkbuf_leaf_3_clk/A vssd1 vssd1 vccd1 vccd1 _2884_/CLK sky130_fd_sc_hd__clkbuf_8
XANTENNA__1722__S _1722_/S vssd1 vssd1 vccd1 vccd1 sky130_fd_sc_hd__diode_2
XFILLER_39_313 vssd1 vssd1 vccd1 vccd1 sky130_fd_sc_hd__fill_1
X_2114_ _2566_/Q _2582_/Q _2120_/S vssd1 vssd1 vccd1 vccd1 _2114_/X sky130_fd_sc_hd__mux2_1
X_2045_ _2050_/A1 _2055_/A _2055_/B _2052_/B2 vssd1 vssd1 vccd1 vccd1 _2045_/X sky130_fd_sc_hd__a31o_2
XTAP_TAPCELL_ROW_17_260 vssd1 vccd1 sky130_fd_sc_hd__tapvpwrvgnd_1
XTAP_TAPCELL_ROW_52_506 vssd1 vccd1 sky130_fd_sc_hd__tapvpwrvgnd_1
XTAP_TAPCELL_ROW_60_561 vssd1 vccd1 sky130_fd_sc_hd__tapvpwrvgnd_1
XTAP_TAPCELL_ROW_9_206 vssd1 vccd1 sky130_fd_sc_hd__tapvpwrvgnd_1
X_1829_ _2634_/Q _2556_/Q vssd1 vssd1 vccd1 vccd1 _1831_/B sky130_fd_sc_hd__or2_2
Xhold420 _2885_/Q vssd1 vssd1 vccd1 vccd1 hold420/X sky130_fd_sc_hd__dlygate4sd3_1
Xhold431 _2773_/Q vssd1 vssd1 vccd1 vccd1 hold431/X sky130_fd_sc_hd__dlygate4sd3_1
Xhold442 _2687_/Q vssd1 vssd1 vccd1 vccd1 hold442/X sky130_fd_sc_hd__dlygate4sd3_1
Xhold453 _2761_/Q vssd1 vssd1 vccd1 vccd1 hold453/X sky130_fd_sc_hd__dlygate4sd3_1
X_2878_ _2924_/CLK _2878_/D fanout111/X vssd1 vssd1 vccd1 vccd1 _2878_/Q sky130_fd_sc_hd__dfrtp_2
XFILLER_38_24 vssd1 vssd1 vccd1 vccd1 sky130_fd_sc_hd__fill_4
XFILLER_38_68 vssd1 vssd1 vccd1 vccd1 sky130_fd_sc_hd__fill_4
Xhold464 _2748_/Q vssd1 vssd1 vccd1 vccd1 hold464/X sky130_fd_sc_hd__dlygate4sd3_1
Xhold475 _2577_/Q vssd1 vssd1 vccd1 vccd1 hold475/X sky130_fd_sc_hd__dlygate4sd3_1
Xhold486 _2388_/Y vssd1 vssd1 vccd1 vccd1 _2392_/A sky130_fd_sc_hd__dlygate4sd3_1
Xhold497 _2681_/Q vssd1 vssd1 vccd1 vccd1 hold497/X sky130_fd_sc_hd__dlygate4sd3_1
XFILLER_9_239 vssd1 vssd1 vccd1 vccd1 sky130_fd_sc_hd__fill_4
XANTENNA__1716__A1 _2644_/Q vssd1 vssd1 vccd1 vccd1 sky130_fd_sc_hd__diode_2
XFILLER_48_187 vssd1 vssd1 vccd1 vccd1 sky130_fd_sc_hd__fill_1
XTAP_TAPCELL_ROW_14_241 vssd1 vccd1 sky130_fd_sc_hd__tapvpwrvgnd_1
X_2801_ _2801_/CLK _2801_/D fanout124/X vssd1 vssd1 vccd1 vccd1 _2801_/Q sky130_fd_sc_hd__dfrtp_2
X_1614_ _2623_/Q _2640_/Q _1710_/S vssd1 vssd1 vccd1 vccd1 _1614_/X sky130_fd_sc_hd__mux2_1
X_2732_ _2869_/CLK _2732_/D load_slew112/X vssd1 vssd1 vccd1 vccd1 _2732_/Q sky130_fd_sc_hd__dfrtp_2
X_2663_ _2663_/CLK _2663_/D load_slew101/X vssd1 vssd1 vccd1 vccd1 _2663_/Q sky130_fd_sc_hd__dfrtp_2
X_2594_ _2884_/CLK _2594_/D vssd1 vssd1 vccd1 vccd1 _2594_/Q sky130_fd_sc_hd__dfxtp_2
XFILLER_39_121 vssd1 vssd1 vccd1 vccd1 sky130_fd_sc_hd__fill_2
X_1476_ _2913_/Q _1479_/C vssd1 vssd1 vccd1 vccd1 _1476_/X sky130_fd_sc_hd__or2_2
X_1545_ _2560_/Q _2559_/Q vssd1 vssd1 vccd1 vccd1 _1546_/D sky130_fd_sc_hd__nor2_2
XANTENNA__1891__A0 _2642_/Q vssd1 vssd1 vccd1 vccd1 sky130_fd_sc_hd__diode_2
XFILLER_54_168 vssd1 vssd1 vccd1 vccd1 sky130_fd_sc_hd__fill_1
XTAP_TAPCELL_ROW_37_399 vssd1 vccd1 sky130_fd_sc_hd__tapvpwrvgnd_1
X_2028_ _2050_/A1 _2041_/A _2041_/B _2069_/B1 vssd1 vssd1 vccd1 vccd1 _2028_/X sky130_fd_sc_hd__a31o_2
XFILLER_40_69 vssd1 vssd1 vccd1 vccd1 sky130_fd_sc_hd__fill_1
XTAP_TAPCELL_ROW_20_277 vssd1 vccd1 sky130_fd_sc_hd__tapvpwrvgnd_1
Xhold272 _2893_/Q vssd1 vssd1 vccd1 vccd1 _2886_/D sky130_fd_sc_hd__dlygate4sd3_1
Xhold283 _2613_/Q vssd1 vssd1 vccd1 vccd1 hold283/X sky130_fd_sc_hd__dlygate4sd3_1
Xhold294 _2521_/Q vssd1 vssd1 vccd1 vccd1 hold294/X sky130_fd_sc_hd__dlygate4sd3_1
Xhold261 _2514_/Y vssd1 vssd1 vccd1 vccd1 _2515_/B sky130_fd_sc_hd__dlygate4sd3_1
Xhold250 _2609_/Q vssd1 vssd1 vccd1 vccd1 hold250/X sky130_fd_sc_hd__dlygate4sd3_1
XFILLER_53_190 vssd1 vssd1 vccd1 vccd1 sky130_fd_sc_hd__fill_2
XTAP_TAPCELL_ROW_28_333 vssd1 vccd1 sky130_fd_sc_hd__tapvpwrvgnd_1
XFILLER_5_297 vssd1 vssd1 vccd1 vccd1 sky130_fd_sc_hd__fill_4
X_1261_ _2713_/Q vssd1 vssd1 vccd1 vccd1 _1382_/B sky130_fd_sc_hd__inv_2
X_1330_ _2797_/Q _1330_/B vssd1 vssd1 vccd1 vccd1 _1331_/B sky130_fd_sc_hd__xnor2_2
XANTENNA__2714__RESET_B fanout132/X vssd1 vssd1 vccd1 vccd1 sky130_fd_sc_hd__diode_2
XFILLER_32_363 vssd1 vssd1 vccd1 vccd1 sky130_fd_sc_hd__fill_1
XANTENNA__2353__A1 _2470_/D vssd1 vssd1 vccd1 vccd1 sky130_fd_sc_hd__diode_2
X_2715_ clkload8/A _2715_/D fanout133/X vssd1 vssd1 vccd1 vccd1 _2715_/Q sky130_fd_sc_hd__dfrtp_2
X_2646_ _2647_/CLK _2646_/D wire131/X vssd1 vssd1 vccd1 vccd1 _2646_/Q sky130_fd_sc_hd__dfrtp_2
X_2577_ clkload2/A _2577_/D vssd1 vssd1 vccd1 vccd1 _2577_/Q sky130_fd_sc_hd__dfxtp_2
XFILLER_19_59 vssd1 vssd1 vccd1 vccd1 sky130_fd_sc_hd__fill_1
X_1459_ _2909_/Q _1458_/B _1477_/A1 vssd1 vssd1 vccd1 vccd1 _1459_/Y sky130_fd_sc_hd__o21ai_2
X_1528_ _1517_/B _1517_/C _1527_/Y _1522_/A vssd1 vssd1 vccd1 vccd1 _1528_/X sky130_fd_sc_hd__o211a_2
XANTENNA__1864__B1 _1851_/Y vssd1 vssd1 vccd1 vccd1 sky130_fd_sc_hd__diode_2
XTAP_TAPCELL_ROW_25_314 vssd1 vccd1 sky130_fd_sc_hd__tapvpwrvgnd_1
XANTENNA__1881__A _2640_/Q vssd1 vssd1 vccd1 vccd1 sky130_fd_sc_hd__diode_2
XFILLER_2_278 vssd1 vssd1 vccd1 vccd1 sky130_fd_sc_hd__fill_1
XFILLER_41_193 vssd1 vssd1 vccd1 vccd1 sky130_fd_sc_hd__fill_4
X_2500_ _2502_/B _2500_/B vssd1 vssd1 vccd1 vccd1 _2857_/D sky130_fd_sc_hd__nor2_2
X_2431_ _2835_/Q _2834_/Q _2431_/C vssd1 vssd1 vccd1 vccd1 _2435_/B sky130_fd_sc_hd__and3_2
X_1313_ _1319_/B _1319_/C vssd1 vssd1 vccd1 vccd1 _1313_/Y sky130_fd_sc_hd__nor2_2
X_2362_ _2856_/Q _2371_/A _2855_/Q vssd1 vssd1 vccd1 vccd1 _2366_/C sky130_fd_sc_hd__or3b_2
X_2293_ _2297_/A1 hold426/X _2293_/B1 hold455/X vssd1 vssd1 vccd1 vccd1 _2770_/D sky130_fd_sc_hd__a22o_2
XTAP_TAPCELL_ROW_47_472 vssd1 vccd1 sky130_fd_sc_hd__tapvpwrvgnd_1
XFILLER_32_182 vssd1 vssd1 vccd1 vccd1 sky130_fd_sc_hd__fill_4
XTAP_TAPCELL_ROW_30_350 vssd1 vccd1 sky130_fd_sc_hd__tapvpwrvgnd_1
X_2629_ _2647_/CLK _2629_/D load_slew129/X vssd1 vssd1 vccd1 vccd1 _2629_/Q sky130_fd_sc_hd__dfrtp_2
XFILLER_30_108 vssd1 vssd1 vccd1 vccd1 sky130_fd_sc_hd__fill_1
XFILLER_7_337 vssd1 vssd1 vccd1 vccd1 sky130_fd_sc_hd__fill_1
X_1793_ _2626_/Q _2627_/Q _1793_/C vssd1 vssd1 vccd1 vccd1 _1798_/B sky130_fd_sc_hd__and3_2
X_1862_ _1834_/A _1834_/B _1834_/C vssd1 vssd1 vccd1 vccd1 _1863_/B sky130_fd_sc_hd__a21o_2
X_1931_ _1944_/A _2689_/Q vssd1 vssd1 vccd1 vccd1 _1934_/B sky130_fd_sc_hd__or2_2
X_2414_ _2830_/Q _2421_/D _2831_/Q vssd1 vssd1 vccd1 vccd1 _2415_/B sky130_fd_sc_hd__a21o_2
XANTENNA_fanout179_A _2189_/S vssd1 vssd1 vccd1 vccd1 sky130_fd_sc_hd__diode_2
X_2345_ _2345_/A _2345_/B vssd1 vssd1 vccd1 vccd1 _2808_/D sky130_fd_sc_hd__and2_2
X_2276_ _2276_/A _2276_/B _2276_/C vssd1 vssd1 vccd1 vccd1 _2276_/X sky130_fd_sc_hd__or3_2
XFILLER_32_37 vssd1 vssd1 vccd1 vccd1 sky130_fd_sc_hd__fill_2
XTAP_TAPCELL_ROW_50_489 vssd1 vccd1 sky130_fd_sc_hd__tapvpwrvgnd_1
XFILLER_57_78 vssd1 vssd1 vccd1 vccd1 sky130_fd_sc_hd__fill_2
XTAP_TAPCELL_ROW_7_189 vssd1 vccd1 sky130_fd_sc_hd__tapvpwrvgnd_1
XANTENNA_fanout47_X _1723_/S vssd1 vssd1 vccd1 vccd1 sky130_fd_sc_hd__diode_2
XFILLER_31_406 vssd1 vssd1 vccd1 vccd1 sky130_fd_sc_hd__fill_1
XFILLER_43_255 vssd1 vssd1 vccd1 vccd1 sky130_fd_sc_hd__fill_1
XTAP_TAPCELL_ROW_58_545 vssd1 vccd1 sky130_fd_sc_hd__tapvpwrvgnd_1
XFILLER_11_152 vssd1 vssd1 vccd1 vccd1 sky130_fd_sc_hd__fill_2
XPHY_EDGE_ROW_44_Left_109 vssd1 vssd1 vccd1 vccd1 sky130_fd_sc_hd__decap_3
XPHY_EDGE_ROW_53_Left_118 vssd1 vssd1 vccd1 vccd1 sky130_fd_sc_hd__decap_3
X_2130_ _2574_/Q _2590_/Q _2130_/S vssd1 vssd1 vccd1 vccd1 _2130_/X sky130_fd_sc_hd__mux2_1
X_2061_ _2061_/A _2061_/B vssd1 vssd1 vccd1 vccd1 _2062_/B sky130_fd_sc_hd__xnor2_2
XFILLER_34_211 vssd1 vssd1 vccd1 vccd1 sky130_fd_sc_hd__fill_8
X_1914_ _1986_/B _1986_/C _2679_/Q vssd1 vssd1 vccd1 vccd1 _2065_/A sky130_fd_sc_hd__a21oi_2
XPHY_EDGE_ROW_62_Left_127 vssd1 vssd1 vccd1 vccd1 sky130_fd_sc_hd__decap_3
X_1776_ _1796_/A1 _2655_/Q _1786_/B1 _2704_/Q _1819_/B2 vssd1 vssd1 vccd1 vccd1 _1776_/X
+ sky130_fd_sc_hd__a221o_2
X_1845_ _2645_/Q _1899_/B vssd1 vssd1 vccd1 vccd1 _1903_/B sky130_fd_sc_hd__and2_2
X_2894_ _2916_/CLK _2894_/D _2335_/B1 vssd1 vssd1 vccd1 vccd1 _2894_/Q sky130_fd_sc_hd__dfrtp_2
X_2328_ _2328_/A1 hold400/X _2156_/B _2804_/Q vssd1 vssd1 vccd1 vccd1 _2328_/X sky130_fd_sc_hd__a22o_2
XFILLER_57_358 vssd1 vssd1 vccd1 vccd1 sky130_fd_sc_hd__fill_1
XTAP_TAPCELL_ROW_55_526 vssd1 vccd1 sky130_fd_sc_hd__tapvpwrvgnd_1
X_2259_ _2259_/A _2259_/B vssd1 vssd1 vccd1 vccd1 _2259_/Y sky130_fd_sc_hd__xnor2_2
XTAP_TAPCELL_ROW_63_581 vssd1 vccd1 sky130_fd_sc_hd__tapvpwrvgnd_1
XFILLER_4_115 vssd1 vssd1 vccd1 vccd1 sky130_fd_sc_hd__fill_1
Xteam_06_234 vssd1 vssd1 vccd1 vccd1 gpio_oeb[32] team_06_234/LO sky130_fd_sc_hd__conb_1
Xteam_06_223 vssd1 vssd1 vccd1 vccd1 team_06_223/HI gpio_out[31] sky130_fd_sc_hd__conb_1
Xteam_06_212 vssd1 vssd1 vccd1 vccd1 team_06_212/HI gpio_oeb[24] sky130_fd_sc_hd__conb_1
Xteam_06_201 vssd1 vssd1 vccd1 vccd1 team_06_201/HI gpio_oeb[13] sky130_fd_sc_hd__conb_1
XFILLER_0_365 vssd1 vssd1 vccd1 vccd1 sky130_fd_sc_hd__fill_2
XFILLER_31_225 vssd1 vssd1 vccd1 vccd1 sky130_fd_sc_hd__fill_1
X_1630_ _1796_/A1 _2659_/Q _1586_/B _1629_/X vssd1 vssd1 vccd1 vccd1 _1630_/X sky130_fd_sc_hd__a211o_2
XFILLER_3_192 vssd1 vssd1 vccd1 vccd1 sky130_fd_sc_hd__fill_1
X_1492_ _2819_/Q _2818_/Q _2821_/Q _2820_/Q vssd1 vssd1 vccd1 vccd1 _1495_/B sky130_fd_sc_hd__or4_2
X_1561_ hold300/X _1558_/B _1560_/X vssd1 vssd1 vccd1 vccd1 _2525_/D sky130_fd_sc_hd__a21o_2
XFILLER_47_391 vssd1 vssd1 vccd1 vccd1 sky130_fd_sc_hd__fill_1
XTAP_TAPCELL_ROW_52_507 vssd1 vccd1 sky130_fd_sc_hd__tapvpwrvgnd_1
X_2113_ hold441/X _2112_/X _2136_/B vssd1 vssd1 vccd1 vccd1 _2683_/D sky130_fd_sc_hd__mux2_1
X_2044_ _2050_/A1 _2055_/A _2055_/B vssd1 vssd1 vccd1 vccd1 _2044_/Y sky130_fd_sc_hd__a21oi_2
XTAP_TAPCELL_ROW_17_261 vssd1 vccd1 sky130_fd_sc_hd__tapvpwrvgnd_1
XTAP_TAPCELL_ROW_60_562 vssd1 vccd1 sky130_fd_sc_hd__tapvpwrvgnd_1
X_2877_ _2880_/CLK _2877_/D fanout92/X vssd1 vssd1 vccd1 vccd1 _2877_/Q sky130_fd_sc_hd__dfrtp_2
X_1759_ _1384_/A _2652_/Q _1786_/B1 _2701_/Q vssd1 vssd1 vccd1 vccd1 _1759_/X sky130_fd_sc_hd__a22o_2
X_1828_ _2634_/Q _2556_/Q vssd1 vssd1 vccd1 vccd1 _1828_/Y sky130_fd_sc_hd__nor2_2
Xhold410 _1661_/X vssd1 vssd1 vccd1 vccd1 _2561_/D sky130_fd_sc_hd__dlygate4sd3_1
Xhold421 _2813_/Q vssd1 vssd1 vccd1 vccd1 _1356_/A sky130_fd_sc_hd__dlygate4sd3_1
Xhold432 _2698_/Q vssd1 vssd1 vccd1 vccd1 hold432/X sky130_fd_sc_hd__dlygate4sd3_1
Xhold443 _2970_/A vssd1 vssd1 vccd1 vccd1 hold443/X sky130_fd_sc_hd__dlygate4sd3_1
Xhold454 _2688_/Q vssd1 vssd1 vccd1 vccd1 hold454/X sky130_fd_sc_hd__dlygate4sd3_1
Xhold465 _2906_/Q vssd1 vssd1 vccd1 vccd1 hold465/X sky130_fd_sc_hd__dlygate4sd3_1
Xhold476 _1678_/X vssd1 vssd1 vccd1 vccd1 _2577_/D sky130_fd_sc_hd__dlygate4sd3_1
Xhold487 _2540_/Q vssd1 vssd1 vccd1 vccd1 hold487/X sky130_fd_sc_hd__dlygate4sd3_1
Xhold498 _2819_/Q vssd1 vssd1 vccd1 vccd1 hold498/X sky130_fd_sc_hd__dlygate4sd3_1
XFILLER_13_225 vssd1 vssd1 vccd1 vccd1 sky130_fd_sc_hd__fill_4
XTAP_TAPCELL_ROW_0_140 vssd1 vccd1 sky130_fd_sc_hd__tapvpwrvgnd_1
XFILLER_0_173 vssd1 vssd1 vccd1 vccd1 sky130_fd_sc_hd__fill_2
XFILLER_48_133 vssd1 vssd1 vccd1 vccd1 sky130_fd_sc_hd__fill_4
X_2800_ _2801_/CLK _2800_/D load_slew123/X vssd1 vssd1 vccd1 vccd1 _2800_/Q sky130_fd_sc_hd__dfrtp_2
X_2731_ _2869_/CLK _2731_/D load_slew112/X vssd1 vssd1 vccd1 vccd1 _2731_/Q sky130_fd_sc_hd__dfrtp_2
XFILLER_8_251 vssd1 vssd1 vccd1 vccd1 sky130_fd_sc_hd__fill_1
X_1544_ _1822_/A _2871_/Q vssd1 vssd1 vccd1 vccd1 _1590_/B sky130_fd_sc_hd__nor2_1
X_1613_ _2622_/Q _1586_/Y _1624_/S hold513/X _1612_/X vssd1 vssd1 vccd1 vccd1 _2543_/D
+ sky130_fd_sc_hd__o221a_2
X_2662_ clkload6/A _2662_/D load_slew103/X vssd1 vssd1 vccd1 vccd1 _2662_/Q sky130_fd_sc_hd__dfrtp_2
X_2593_ clkload2/A _2593_/D vssd1 vssd1 vccd1 vccd1 _2593_/Q sky130_fd_sc_hd__dfxtp_2
XFILLER_39_166 vssd1 vssd1 vccd1 vccd1 sky130_fd_sc_hd__fill_2
X_1475_ _2913_/Q _1479_/C vssd1 vssd1 vccd1 vccd1 _1475_/Y sky130_fd_sc_hd__nand2_2
XANTENNA__1643__A1 _1385_/B vssd1 vssd1 vccd1 vccd1 sky130_fd_sc_hd__diode_2
XFILLER_24_27 vssd1 vssd1 vccd1 vccd1 sky130_fd_sc_hd__fill_1
XFILLER_54_136 vssd1 vssd1 vccd1 vccd1 sky130_fd_sc_hd__fill_4
X_2027_ _2050_/A1 _2041_/A _2041_/B vssd1 vssd1 vccd1 vccd1 _2027_/Y sky130_fd_sc_hd__a21oi_2
XFILLER_10_206 vssd1 vssd1 vccd1 vccd1 sky130_fd_sc_hd__fill_1
XFILLER_10_228 vssd1 vssd1 vccd1 vccd1 sky130_fd_sc_hd__fill_4
XFILLER_10_239 vssd1 vssd1 vccd1 vccd1 sky130_fd_sc_hd__fill_4
XTAP_TAPCELL_ROW_20_278 vssd1 vccd1 sky130_fd_sc_hd__tapvpwrvgnd_1
XFILLER_49_24 vssd1 vssd1 vccd1 vccd1 sky130_fd_sc_hd__fill_2
XFILLER_49_57 vssd1 vssd1 vccd1 vccd1 sky130_fd_sc_hd__fill_1
Xhold273 _2809_/Q vssd1 vssd1 vccd1 vccd1 hold273/X sky130_fd_sc_hd__dlygate4sd3_1
Xhold284 _1727_/X vssd1 vssd1 vccd1 vccd1 _2613_/D sky130_fd_sc_hd__dlygate4sd3_1
Xhold295 _2582_/Q vssd1 vssd1 vccd1 vccd1 hold295/X sky130_fd_sc_hd__dlygate4sd3_1
Xhold262 _2722_/Q vssd1 vssd1 vccd1 vccd1 hold262/X sky130_fd_sc_hd__dlygate4sd3_1
Xhold251 _2720_/Q vssd1 vssd1 vccd1 vccd1 hold251/X sky130_fd_sc_hd__dlygate4sd3_1
Xhold240 _2895_/Q vssd1 vssd1 vccd1 vccd1 _2888_/D sky130_fd_sc_hd__dlygate4sd3_1
XTAP_TAPCELL_ROW_28_334 vssd1 vccd1 sky130_fd_sc_hd__tapvpwrvgnd_1
XFILLER_14_82 vssd1 vssd1 vccd1 vccd1 sky130_fd_sc_hd__fill_2
X_1260_ _1351_/A vssd1 vssd1 vccd1 vccd1 _1260_/Y sky130_fd_sc_hd__inv_2
XFILLER_24_309 vssd1 vssd1 vccd1 vccd1 sky130_fd_sc_hd__fill_1
X_2714_ clkload8/A _2714_/D fanout132/X vssd1 vssd1 vccd1 vccd1 _2714_/Q sky130_fd_sc_hd__dfrtp_2
X_1527_ _2822_/Q _2825_/Q _2824_/Q _2823_/Q vssd1 vssd1 vccd1 vccd1 _1527_/Y sky130_fd_sc_hd__nand4b_2
X_2645_ _2647_/CLK _2645_/D wire131/X vssd1 vssd1 vccd1 vccd1 _2645_/Q sky130_fd_sc_hd__dfrtp_2
X_2576_ _2694_/CLK _2576_/D vssd1 vssd1 vccd1 vccd1 _2576_/Q sky130_fd_sc_hd__dfxtp_2
XANTENNA__1864__A1 _2699_/Q vssd1 vssd1 vccd1 vccd1 sky130_fd_sc_hd__diode_2
X_1389_ _1415_/A _1389_/B vssd1 vssd1 vccd1 vccd1 _1389_/Y sky130_fd_sc_hd__nand2_2
X_1458_ _2909_/Q _1458_/B vssd1 vssd1 vccd1 vccd1 _1465_/C sky130_fd_sc_hd__and2_2
XANTENNA__1616__B2 _1589_/X vssd1 vssd1 vccd1 vccd1 sky130_fd_sc_hd__diode_2
XANTENNA_fanout164_X _1582_/A vssd1 vssd1 vccd1 vccd1 sky130_fd_sc_hd__diode_2
XFILLER_35_191 vssd1 vssd1 vccd1 vccd1 sky130_fd_sc_hd__fill_2
XFILLER_42_139 vssd1 vssd1 vccd1 vccd1 sky130_fd_sc_hd__fill_1
XFILLER_50_172 vssd1 vssd1 vccd1 vccd1 sky130_fd_sc_hd__fill_2
XTAP_TAPCELL_ROW_25_315 vssd1 vccd1 sky130_fd_sc_hd__tapvpwrvgnd_1
XTAP_TAPCELL_ROW_33_370 vssd1 vccd1 sky130_fd_sc_hd__tapvpwrvgnd_1
XANTENNA_fanout77_X _2156_/B vssd1 vssd1 vccd1 vccd1 sky130_fd_sc_hd__diode_2
XFILLER_26_191 vssd1 vssd1 vccd1 vccd1 sky130_fd_sc_hd__fill_4
X_2430_ _2462_/B _2429_/Y _2834_/Q _2459_/B vssd1 vssd1 vccd1 vccd1 _2834_/D sky130_fd_sc_hd__a2bb2o_2
X_2361_ _2371_/A _2361_/B _2361_/C vssd1 vssd1 vccd1 vccd1 _2361_/Y sky130_fd_sc_hd__nor3_4
XFILLER_2_85 vssd1 vssd1 vccd1 vccd1 sky130_fd_sc_hd__fill_2
XFILLER_56_209 vssd1 vssd1 vccd1 vccd1 sky130_fd_sc_hd__fill_1
X_1312_ _2792_/Q _1312_/B vssd1 vssd1 vccd1 vccd1 _1319_/C sky130_fd_sc_hd__nor2_2
X_2292_ _1366_/A hold391/X _2293_/B1 hold470/X vssd1 vssd1 vccd1 vccd1 _2769_/D sky130_fd_sc_hd__a22o_2
XFILLER_32_150 vssd1 vssd1 vccd1 vccd1 sky130_fd_sc_hd__fill_1
XTAP_TAPCELL_ROW_30_351 vssd1 vccd1 sky130_fd_sc_hd__tapvpwrvgnd_1
X_2628_ _2694_/CLK _2628_/D fanout104/X vssd1 vssd1 vccd1 vccd1 _2628_/Q sky130_fd_sc_hd__dfrtp_2
X_2559_ _2884_/CLK _2559_/D _2473_/A1 vssd1 vssd1 vccd1 vccd1 _2559_/Q sky130_fd_sc_hd__dfrtp_2
XFILLER_46_47 vssd1 vssd1 vccd1 vccd1 sky130_fd_sc_hd__fill_1
XANTENNA_fanout37_A _2472_/B vssd1 vssd1 vccd1 vccd1 sky130_fd_sc_hd__diode_2
XANTENNA__1892__A _2643_/Q vssd1 vssd1 vccd1 vccd1 sky130_fd_sc_hd__diode_2
XFILLER_46_220 vssd1 vccd1 vssd1 vccd1 sky130_ef_sc_hd__decap_40_12
XANTENNA__2253__B2 _2260_/A2 vssd1 vssd1 vccd1 vccd1 sky130_fd_sc_hd__diode_2
XFILLER_61_212 vssd1 vssd1 vccd1 vccd1 sky130_fd_sc_hd__fill_1
X_1930_ _2675_/Q _1930_/B _1930_/C vssd1 vssd1 vccd1 vccd1 _2042_/B sky130_fd_sc_hd__nand3_2
X_1792_ _2626_/Q _1811_/A2 _1790_/Y _1791_/X vssd1 vssd1 vccd1 vccd1 _2626_/D sky130_fd_sc_hd__o22a_2
X_1861_ _2634_/Q _1860_/X _1891_/S vssd1 vssd1 vccd1 vccd1 _2634_/D sky130_fd_sc_hd__mux2_1
X_2413_ _2831_/Q _2830_/Q _2421_/D vssd1 vssd1 vccd1 vccd1 _2420_/B sky130_fd_sc_hd__and3_2
X_2344_ _2808_/Q _2340_/A _2340_/Y _2343_/X vssd1 vssd1 vccd1 vccd1 _2345_/B sky130_fd_sc_hd__a22o_2
XFILLER_52_212 vssd1 vssd1 vccd1 vccd1 sky130_fd_sc_hd__fill_1
XFILLER_52_223 vssd1 vssd1 vccd1 vccd1 sky130_fd_sc_hd__fill_2
X_2275_ _2270_/A _2270_/C _2270_/B vssd1 vssd1 vccd1 vccd1 _2276_/C sky130_fd_sc_hd__a21boi_2
XFILLER_32_27 vssd1 vssd1 vccd1 vccd1 sky130_fd_sc_hd__fill_1
XFILLER_57_57 vssd1 vssd1 vccd1 vccd1 sky130_fd_sc_hd__fill_1
XTAP_TAPCELL_ROW_58_546 vssd1 vccd1 sky130_fd_sc_hd__tapvpwrvgnd_1
XFILLER_28_264 vssd1 vssd1 vccd1 vccd1 sky130_fd_sc_hd__fill_1
XFILLER_7_113 vssd1 vssd1 vccd1 vccd1 sky130_fd_sc_hd__fill_4
XFILLER_7_146 vssd1 vssd1 vccd1 vccd1 sky130_fd_sc_hd__fill_1
XTAP_TAPCELL_ROW_41_424 vssd1 vccd1 sky130_fd_sc_hd__tapvpwrvgnd_1
XFILLER_3_374 vssd1 vssd1 vccd1 vccd1 sky130_fd_sc_hd__fill_1
X_2060_ _1985_/A _2060_/B vssd1 vssd1 vccd1 vccd1 _2061_/B sky130_fd_sc_hd__and2b_2
XANTENNA__2226__B2 _2260_/A2 vssd1 vssd1 vccd1 vccd1 sky130_fd_sc_hd__diode_2
X_1913_ _1944_/A _2694_/Q vssd1 vssd1 vccd1 vccd1 _1986_/C sky130_fd_sc_hd__nand2_2
X_2893_ _2916_/CLK _2893_/D _2335_/B1 vssd1 vssd1 vccd1 vccd1 _2893_/Q sky130_fd_sc_hd__dfrtp_2
XFILLER_8_95 vssd1 vssd1 vccd1 vccd1 sky130_fd_sc_hd__fill_4
X_1775_ _1775_/A _1775_/B vssd1 vssd1 vccd1 vccd1 _1775_/Y sky130_fd_sc_hd__nor2_2
X_1844_ _2644_/Q _2643_/Q _1892_/B vssd1 vssd1 vccd1 vccd1 _1899_/B sky130_fd_sc_hd__and3_2
X_2327_ _2328_/A1 hold394/X _2156_/B _2803_/Q vssd1 vssd1 vccd1 vccd1 _2327_/X sky130_fd_sc_hd__a22o_2
X_2258_ _2769_/Q _2723_/Q _2257_/X vssd1 vssd1 vccd1 vccd1 _2259_/B sky130_fd_sc_hd__o21bai_2
XFILLER_40_215 vssd1 vssd1 vccd1 vccd1 sky130_fd_sc_hd__fill_2
XFILLER_43_26 vssd1 vssd1 vccd1 vccd1 sky130_fd_sc_hd__fill_2
XTAP_TAPCELL_ROW_55_527 vssd1 vccd1 sky130_fd_sc_hd__tapvpwrvgnd_1
XTAP_TAPCELL_ROW_63_582 vssd1 vccd1 sky130_fd_sc_hd__tapvpwrvgnd_1
X_2189_ hold358/X _2188_/X _2189_/S vssd1 vssd1 vccd1 vccd1 _2744_/D sky130_fd_sc_hd__mux2_1
XANTENNA__2620__RESET_B fanout105/X vssd1 vssd1 vccd1 vccd1 sky130_fd_sc_hd__diode_2
Xteam_06_235 vssd1 vssd1 vccd1 vccd1 gpio_oeb[33] team_06_235/LO sky130_fd_sc_hd__conb_1
Xteam_06_224 vssd1 vssd1 vccd1 vccd1 team_06_224/HI gpio_out[32] sky130_fd_sc_hd__conb_1
Xteam_06_213 vssd1 vssd1 vccd1 vccd1 team_06_213/HI gpio_oeb[25] sky130_fd_sc_hd__conb_1
Xteam_06_202 vssd1 vssd1 vccd1 vccd1 team_06_202/HI gpio_oeb[14] sky130_fd_sc_hd__conb_1
XTAP_TAPCELL_ROW_3_160 vssd1 vccd1 sky130_fd_sc_hd__tapvpwrvgnd_1
X_1560_ _1582_/A _2637_/Q _1724_/S vssd1 vssd1 vccd1 vccd1 _1560_/X sky130_fd_sc_hd__and3_2
X_1491_ _2827_/Q _2826_/Q _2829_/Q _2828_/Q vssd1 vssd1 vccd1 vccd1 _1499_/A sky130_fd_sc_hd__or4_2
X_2112_ _2565_/Q _2581_/Q _2120_/S vssd1 vssd1 vccd1 vccd1 _2112_/X sky130_fd_sc_hd__mux2_1
XTAP_TAPCELL_ROW_17_262 vssd1 vccd1 sky130_fd_sc_hd__tapvpwrvgnd_1
X_2043_ _2043_/A _2043_/B vssd1 vssd1 vccd1 vccd1 _2055_/B sky130_fd_sc_hd__xnor2_2
XFILLER_13_18 vssd1 vssd1 vccd1 vccd1 sky130_fd_sc_hd__fill_1
XTAP_TAPCELL_ROW_60_563 vssd1 vccd1 sky130_fd_sc_hd__tapvpwrvgnd_1
X_1827_ _2634_/Q _2556_/Q vssd1 vssd1 vccd1 vccd1 _1831_/C sky130_fd_sc_hd__nand2_2
X_2876_ _2880_/CLK _2876_/D fanout92/X vssd1 vssd1 vccd1 vccd1 _2876_/Q sky130_fd_sc_hd__dfrtp_2
X_1689_ hold288/X _2643_/Q _1693_/S vssd1 vssd1 vccd1 vccd1 _2588_/D sky130_fd_sc_hd__mux2_1
X_1758_ _2619_/Q _1814_/B2 _1756_/X _1757_/X vssd1 vssd1 vccd1 vccd1 _2619_/D sky130_fd_sc_hd__o22a_2
Xhold400 _2789_/Q vssd1 vssd1 vccd1 vccd1 hold400/X sky130_fd_sc_hd__dlygate4sd3_1
Xhold411 _2856_/Q vssd1 vssd1 vccd1 vccd1 _2497_/A sky130_fd_sc_hd__dlygate4sd3_1
Xhold422 _2747_/Q vssd1 vssd1 vccd1 vccd1 hold422/X sky130_fd_sc_hd__dlygate4sd3_1
Xhold433 _2657_/Q vssd1 vssd1 vccd1 vccd1 hold433/X sky130_fd_sc_hd__dlygate4sd3_1
Xhold444 _2768_/Q vssd1 vssd1 vccd1 vccd1 hold444/X sky130_fd_sc_hd__dlygate4sd3_1
Xhold455 _2770_/Q vssd1 vssd1 vccd1 vccd1 hold455/X sky130_fd_sc_hd__dlygate4sd3_1
Xhold466 _2772_/Q vssd1 vssd1 vccd1 vccd1 hold466/X sky130_fd_sc_hd__dlygate4sd3_1
Xhold477 _2710_/Q vssd1 vssd1 vccd1 vccd1 hold477/X sky130_fd_sc_hd__dlygate4sd3_1
Xhold488 _2902_/Q vssd1 vssd1 vccd1 vccd1 hold488/X sky130_fd_sc_hd__dlygate4sd3_1
Xhold499 _2670_/Q vssd1 vssd1 vccd1 vccd1 hold499/X sky130_fd_sc_hd__dlygate4sd3_1
XTAP_TAPCELL_ROW_0_130 vssd1 vccd1 sky130_fd_sc_hd__tapvpwrvgnd_1
XTAP_TAPCELL_ROW_0_141 vssd1 vccd1 sky130_fd_sc_hd__tapvpwrvgnd_1
XTAP_TAPCELL_ROW_23_298 vssd1 vccd1 sky130_fd_sc_hd__tapvpwrvgnd_1
XANTENNA__2000__S _2071_/B vssd1 vssd1 vccd1 vccd1 sky130_fd_sc_hd__diode_2
X_2730_ _2813_/CLK _2730_/D load_slew112/X vssd1 vssd1 vccd1 vccd1 _2730_/Q sky130_fd_sc_hd__dfrtp_2
X_2661_ clkload6/A _2661_/D fanout102/X vssd1 vssd1 vccd1 vccd1 _2661_/Q sky130_fd_sc_hd__dfrtp_2
XFILLER_5_41 vssd1 vssd1 vccd1 vccd1 sky130_fd_sc_hd__fill_2
X_1474_ _1479_/C _1473_/Y hold544/X _1477_/B1 vssd1 vssd1 vccd1 vccd1 _2912_/D sky130_fd_sc_hd__a2bb2o_2
X_1543_ _2375_/B _1543_/B vssd1 vssd1 vccd1 vccd1 _1543_/Y sky130_fd_sc_hd__nand2_2
X_1612_ _2639_/Q _1710_/S _1586_/B _1611_/X vssd1 vssd1 vccd1 vccd1 _1612_/X sky130_fd_sc_hd__a211o_2
X_2592_ _2694_/CLK _2592_/D vssd1 vssd1 vccd1 vccd1 _2592_/Q sky130_fd_sc_hd__dfxtp_2
XFILLER_39_123 vssd1 vssd1 vccd1 vccd1 sky130_fd_sc_hd__fill_1
XANTENNA_fanout154_A _2882_/Q vssd1 vssd1 vccd1 vccd1 sky130_fd_sc_hd__diode_2
XFILLER_50_365 vssd1 vssd1 vccd1 vccd1 sky130_fd_sc_hd__fill_1
X_2026_ _2026_/A _2026_/B vssd1 vssd1 vccd1 vccd1 _2041_/B sky130_fd_sc_hd__xnor2_2
XFILLER_40_27 vssd1 vssd1 vccd1 vccd1 sky130_fd_sc_hd__fill_1
XTAP_TAPCELL_ROW_20_279 vssd1 vccd1 sky130_fd_sc_hd__tapvpwrvgnd_1
X_2859_ _2865_/CLK _2859_/D vssd1 vssd1 vccd1 vccd1 _2859_/Q sky130_fd_sc_hd__dfxtp_2
Xhold274 _2728_/Q vssd1 vssd1 vccd1 vccd1 hold274/X sky130_fd_sc_hd__dlygate4sd3_1
Xhold285 _2806_/Q vssd1 vssd1 vccd1 vccd1 hold285/X sky130_fd_sc_hd__dlygate4sd3_1
Xhold296 _2807_/Q vssd1 vssd1 vccd1 vccd1 hold296/X sky130_fd_sc_hd__dlygate4sd3_1
Xhold263 _2585_/Q vssd1 vssd1 vccd1 vccd1 hold263/X sky130_fd_sc_hd__dlygate4sd3_1
Xhold252 _2610_/Q vssd1 vssd1 vccd1 vccd1 hold252/X sky130_fd_sc_hd__dlygate4sd3_1
Xhold241 _2603_/Q vssd1 vssd1 vccd1 vccd1 hold241/X sky130_fd_sc_hd__dlygate4sd3_1
XANTENNA_fanout67_A _2282_/A2 vssd1 vssd1 vccd1 vccd1 sky130_fd_sc_hd__diode_2
XTAP_TAPCELL_ROW_28_335 vssd1 vccd1 sky130_fd_sc_hd__tapvpwrvgnd_1
XANTENNA__1634__A2 _1585_/X vssd1 vssd1 vccd1 vccd1 sky130_fd_sc_hd__diode_2
XTAP_TAPCELL_ROW_36_390 vssd1 vccd1 sky130_fd_sc_hd__tapvpwrvgnd_1
XFILLER_30_60 vssd1 vssd1 vccd1 vccd1 sky130_fd_sc_hd__fill_4
XFILLER_5_222 vssd1 vssd1 vccd1 vccd1 sky130_fd_sc_hd__fill_2
XFILLER_36_126 vssd1 vssd1 vccd1 vccd1 sky130_fd_sc_hd__fill_1
XANTENNA__1625__A2 _2706_/Q vssd1 vssd1 vccd1 vccd1 sky130_fd_sc_hd__diode_2
X_2713_ _2866_/CLK _2713_/D fanout111/X vssd1 vssd1 vccd1 vccd1 _2713_/Q sky130_fd_sc_hd__dfrtp_2
X_2644_ _2774_/CLK _2644_/D wire131/X vssd1 vssd1 vccd1 vccd1 _2644_/Q sky130_fd_sc_hd__dfrtp_2
X_1457_ _1477_/A1 _1455_/Y _1456_/X _1477_/B1 hold429/X vssd1 vssd1 vccd1 vccd1 _2908_/D
+ sky130_fd_sc_hd__a32o_2
X_1526_ _2825_/Q _2824_/Q _2822_/Q vssd1 vssd1 vccd1 vccd1 _1526_/X sky130_fd_sc_hd__or3b_2
X_2575_ clkload6/A _2575_/D vssd1 vssd1 vccd1 vccd1 _2575_/Q sky130_fd_sc_hd__dfxtp_2
X_1388_ _1415_/A _1389_/B vssd1 vssd1 vccd1 vccd1 _2348_/B sky130_fd_sc_hd__and2_2
XFILLER_50_184 vssd1 vssd1 vccd1 vccd1 sky130_fd_sc_hd__fill_2
XTAP_TAPCELL_ROW_25_316 vssd1 vccd1 sky130_fd_sc_hd__tapvpwrvgnd_1
XTAP_TAPCELL_ROW_33_371 vssd1 vccd1 sky130_fd_sc_hd__tapvpwrvgnd_1
X_2009_ _2009_/A _2009_/B vssd1 vssd1 vccd1 vccd1 _2018_/B sky130_fd_sc_hd__xnor2_2
XFILLER_2_214 vssd1 vssd1 vccd1 vccd1 sky130_fd_sc_hd__fill_2
XANTENNA_clkbuf_leaf_13_clk_A clkbuf_leaf_5_clk/A vssd1 vssd1 vccd1 vccd1 sky130_fd_sc_hd__diode_2
XANTENNA__1791__B2 _2707_/Q vssd1 vssd1 vccd1 vccd1 sky130_fd_sc_hd__diode_2
X_1311_ _1321_/B _1311_/B vssd1 vssd1 vccd1 vccd1 _1311_/X sky130_fd_sc_hd__or2_2
X_2360_ _2370_/A _2370_/B _2363_/C vssd1 vssd1 vccd1 vccd1 _2361_/C sky130_fd_sc_hd__or3_2
X_2291_ _1366_/A hold427/X _2293_/B1 hold444/X vssd1 vssd1 vccd1 vccd1 _2768_/D sky130_fd_sc_hd__a22o_2
XFILLER_2_75 vssd1 vssd1 vccd1 vccd1 sky130_fd_sc_hd__fill_1
XFILLER_64_221 vssd1 vssd1 vccd1 vccd1 sky130_fd_sc_hd__fill_1
XPHY_EDGE_ROW_10_Right_10 vssd1 vssd1 vccd1 vccd1 sky130_fd_sc_hd__decap_3
XFILLER_9_391 vssd1 vssd1 vccd1 vccd1 sky130_fd_sc_hd__fill_1
XTAP_TAPCELL_ROW_30_352 vssd1 vccd1 sky130_fd_sc_hd__tapvpwrvgnd_1
X_2627_ _2694_/CLK _2627_/D fanout104/X vssd1 vssd1 vccd1 vccd1 _2627_/Q sky130_fd_sc_hd__dfrtp_2
X_1509_ _2375_/A _2375_/B _2378_/A _2817_/Q vssd1 vssd1 vccd1 vccd1 _1511_/B sky130_fd_sc_hd__o31ai_2
X_2558_ _2880_/CLK _2558_/D _1662_/C vssd1 vssd1 vccd1 vccd1 _2558_/Q sky130_fd_sc_hd__dfrtp_2
X_2489_ _2489_/A _2494_/D vssd1 vssd1 vccd1 vccd1 _2853_/D sky130_fd_sc_hd__xor2_2
XFILLER_46_59 vssd1 vssd1 vccd1 vccd1 sky130_fd_sc_hd__fill_1
Xclkbuf_leaf_35_clk clkbuf_leaf_4_clk/A vssd1 vssd1 vccd1 vccd1 clkload3/A sky130_fd_sc_hd__clkbuf_8
XFILLER_11_73 vssd1 vssd1 vccd1 vccd1 sky130_fd_sc_hd__fill_4
XFILLER_46_232 vssd1 vssd1 vccd1 vccd1 sky130_fd_sc_hd__fill_8
XFILLER_36_81 vssd1 vssd1 vccd1 vccd1 sky130_fd_sc_hd__fill_2
X_1860_ _1863_/C _1832_/Y _1859_/X _2698_/Q _1869_/B vssd1 vssd1 vccd1 vccd1 _1860_/X
+ sky130_fd_sc_hd__a32o_2
Xclkbuf_leaf_26_clk clkbuf_3_5__f_clk/X vssd1 vssd1 vccd1 vccd1 _2870_/CLK sky130_fd_sc_hd__clkbuf_8
XANTENNA__1764__B2 _2702_/Q vssd1 vssd1 vccd1 vccd1 sky130_fd_sc_hd__diode_2
X_1791_ _1796_/A1 _2658_/Q _1810_/B1 _2707_/Q _1810_/C1 vssd1 vssd1 vccd1 vccd1 _1791_/X
+ sky130_fd_sc_hd__a221o_2
XANTENNA_clkbuf_3_6__f_clk_A clkbuf_0_clk/X vssd1 vssd1 vccd1 vccd1 sky130_fd_sc_hd__diode_2
X_2412_ _2412_/A _2459_/B vssd1 vssd1 vccd1 vccd1 _2412_/Y sky130_fd_sc_hd__nand2_2
X_2343_ _2918_/Q _2348_/C _2919_/Q vssd1 vssd1 vccd1 vccd1 _2343_/X sky130_fd_sc_hd__a21o_2
X_2274_ _2773_/Q _2727_/Q vssd1 vssd1 vccd1 vccd1 _2276_/B sky130_fd_sc_hd__and2_2
XFILLER_37_298 vssd1 vssd1 vccd1 vccd1 sky130_fd_sc_hd__fill_2
Xclkbuf_leaf_17_clk clkbuf_3_6__f_clk/X vssd1 vssd1 vccd1 vccd1 _2769_/CLK sky130_fd_sc_hd__clkbuf_8
XFILLER_20_143 vssd1 vssd1 vccd1 vccd1 sky130_fd_sc_hd__fill_1
XFILLER_32_39 vssd1 vssd1 vccd1 vccd1 sky130_fd_sc_hd__fill_1
X_1989_ _2666_/Q _1989_/B vssd1 vssd1 vccd1 vccd1 _1990_/B sky130_fd_sc_hd__xor2_2
XTAP_TAPCELL_ROW_58_547 vssd1 vccd1 sky130_fd_sc_hd__tapvpwrvgnd_1
XFILLER_43_202 vssd1 vssd1 vccd1 vccd1 sky130_fd_sc_hd__fill_1
XTAP_TAPCELL_ROW_41_425 vssd1 vccd1 sky130_fd_sc_hd__tapvpwrvgnd_1
XFILLER_3_320 vssd1 vssd1 vccd1 vccd1 sky130_fd_sc_hd__fill_1
XFILLER_7_169 vssd1 vssd1 vccd1 vccd1 sky130_fd_sc_hd__fill_1
XTAP_TAPCELL_ROW_6_180 vssd1 vccd1 sky130_fd_sc_hd__tapvpwrvgnd_1
XFILLER_8_63 vssd1 vssd1 vccd1 vccd1 sky130_fd_sc_hd__fill_4
XFILLER_8_85 vssd1 vssd1 vccd1 vccd1 sky130_fd_sc_hd__fill_2
X_1843_ _2642_/Q _2641_/Q _2640_/Q _1881_/B vssd1 vssd1 vccd1 vccd1 _1892_/B sky130_fd_sc_hd__and4_2
X_1912_ _1944_/A _2694_/Q vssd1 vssd1 vccd1 vccd1 _1986_/B sky130_fd_sc_hd__or2_2
X_2892_ _2923_/CLK input5/X fanout86/X vssd1 vssd1 vccd1 vccd1 _2892_/Q sky130_fd_sc_hd__dfstp_2
X_1774_ _2623_/Q _1783_/D _1770_/C vssd1 vssd1 vccd1 vccd1 _1775_/B sky130_fd_sc_hd__o21ai_2
Xclkbuf_leaf_6_clk clkbuf_leaf_9_clk/A vssd1 vssd1 vccd1 vccd1 clkload5/A sky130_fd_sc_hd__clkbuf_8
X_2326_ _2328_/A1 hold396/X _2156_/B _2802_/Q vssd1 vssd1 vccd1 vccd1 _2326_/X sky130_fd_sc_hd__a22o_2
X_2257_ _2245_/A _2241_/Y _2245_/B _2251_/B _2243_/B vssd1 vssd1 vccd1 vccd1 _2257_/X
+ sky130_fd_sc_hd__o311a_2
XFILLER_25_279 vssd1 vssd1 vccd1 vccd1 sky130_fd_sc_hd__fill_1
XFILLER_40_205 vssd1 vssd1 vccd1 vccd1 sky130_fd_sc_hd__fill_2
XTAP_TAPCELL_ROW_55_528 vssd1 vccd1 sky130_fd_sc_hd__tapvpwrvgnd_1
XTAP_TAPCELL_ROW_63_583 vssd1 vccd1 sky130_fd_sc_hd__tapvpwrvgnd_1
X_2188_ _2536_/Q _2611_/Q vssd1 vssd1 vccd1 vccd1 _2188_/X sky130_fd_sc_hd__xor2_2
XFILLER_0_323 vssd1 vssd1 vccd1 vccd1 sky130_fd_sc_hd__fill_4
Xteam_06_225 vssd1 vssd1 vccd1 vccd1 team_06_225/HI gpio_out[33] sky130_fd_sc_hd__conb_1
Xteam_06_214 vssd1 vssd1 vccd1 vccd1 team_06_214/HI gpio_oeb[26] sky130_fd_sc_hd__conb_1
Xteam_06_203 vssd1 vssd1 vccd1 vccd1 team_06_203/HI gpio_oeb[15] sky130_fd_sc_hd__conb_1
XANTENNA_fanout52_X _2134_/S vssd1 vssd1 vccd1 vccd1 sky130_fd_sc_hd__diode_2
XPHY_EDGE_ROW_9_Left_74 vssd1 vssd1 vccd1 vccd1 sky130_fd_sc_hd__decap_3
XTAP_TAPCELL_ROW_3_161 vssd1 vccd1 sky130_fd_sc_hd__tapvpwrvgnd_1
XFILLER_31_238 vssd1 vssd1 vccd1 vccd1 sky130_fd_sc_hd__fill_1
X_1490_ _2827_/Q _2826_/Q _2828_/Q vssd1 vssd1 vccd1 vccd1 _1490_/X sky130_fd_sc_hd__or3_2
X_2111_ hold462/X _2110_/X _2136_/B vssd1 vssd1 vccd1 vccd1 _2682_/D sky130_fd_sc_hd__mux2_1
X_2042_ _1929_/Y _2042_/B vssd1 vssd1 vccd1 vccd1 _2043_/B sky130_fd_sc_hd__nand2b_2
XFILLER_62_363 vssd1 vssd1 vccd1 vccd1 sky130_fd_sc_hd__fill_1
XPHY_EDGE_ROW_8_Right_8 vssd1 vssd1 vccd1 vccd1 sky130_fd_sc_hd__decap_3
X_1826_ _2635_/Q _2557_/Q vssd1 vssd1 vccd1 vccd1 _1834_/B sky130_fd_sc_hd__or2_2
Xhold401 _2328_/X vssd1 vssd1 vccd1 vccd1 _2804_/D sky130_fd_sc_hd__dlygate4sd3_1
X_2875_ _2924_/CLK _2875_/D fanout111/A vssd1 vssd1 vccd1 vccd1 _2875_/Q sky130_fd_sc_hd__dfrtp_2
XPHY_EDGE_ROW_39_Right_39 vssd1 vssd1 vccd1 vccd1 sky130_fd_sc_hd__decap_3
X_1688_ hold269/X _2642_/Q _1693_/S vssd1 vssd1 vccd1 vccd1 _2587_/D sky130_fd_sc_hd__mux2_1
X_1757_ _2700_/Q _1786_/B1 _1819_/B2 _1600_/X vssd1 vssd1 vccd1 vccd1 _1757_/X sky130_fd_sc_hd__a211o_2
Xhold412 _2696_/Q vssd1 vssd1 vccd1 vccd1 hold412/X sky130_fd_sc_hd__dlygate4sd3_1
Xhold423 _2903_/Q vssd1 vssd1 vccd1 vccd1 hold423/X sky130_fd_sc_hd__dlygate4sd3_1
Xhold434 _2690_/Q vssd1 vssd1 vccd1 vccd1 hold434/X sky130_fd_sc_hd__dlygate4sd3_1
Xhold445 _2791_/Q vssd1 vssd1 vccd1 vccd1 hold445/X sky130_fd_sc_hd__dlygate4sd3_1
Xhold456 _2812_/Q vssd1 vssd1 vccd1 vccd1 hold456/X sky130_fd_sc_hd__dlygate4sd3_1
Xhold467 _2694_/Q vssd1 vssd1 vccd1 vccd1 hold467/X sky130_fd_sc_hd__dlygate4sd3_1
Xhold478 _2560_/Q vssd1 vssd1 vccd1 vccd1 hold478/X sky130_fd_sc_hd__dlygate4sd3_1
Xhold489 _2700_/Q vssd1 vssd1 vccd1 vccd1 hold489/X sky130_fd_sc_hd__dlygate4sd3_1
XANTENNA__1894__A0 _2643_/Q vssd1 vssd1 vccd1 vccd1 sky130_fd_sc_hd__diode_2
XFILLER_53_330 vssd1 vssd1 vccd1 vccd1 sky130_fd_sc_hd__fill_1
XTAP_TAPCELL_ROW_0_131 vssd1 vccd1 sky130_fd_sc_hd__tapvpwrvgnd_1
XTAP_TAPCELL_ROW_0_142 vssd1 vccd1 sky130_fd_sc_hd__tapvpwrvgnd_1
X_2309_ _2300_/A1 _1339_/Y _2313_/B1 hold382/X vssd1 vssd1 vccd1 vccd1 _2785_/D sky130_fd_sc_hd__a2bb2o_2
XPHY_EDGE_ROW_48_Right_48 vssd1 vssd1 vccd1 vccd1 sky130_fd_sc_hd__decap_3
XPHY_EDGE_ROW_57_Right_57 vssd1 vssd1 vccd1 vccd1 sky130_fd_sc_hd__decap_3
XTAP_TAPCELL_ROW_23_299 vssd1 vccd1 sky130_fd_sc_hd__tapvpwrvgnd_1
XANTENNA__1637__B1 _1624_/S vssd1 vssd1 vccd1 vccd1 sky130_fd_sc_hd__diode_2
XFILLER_44_330 vssd1 vssd1 vccd1 vccd1 sky130_fd_sc_hd__fill_1
XFILLER_8_253 vssd1 vssd1 vccd1 vccd1 sky130_fd_sc_hd__fill_4
X_1611_ _1384_/B _2703_/Q _2654_/Q _1384_/A vssd1 vssd1 vccd1 vccd1 _1611_/X sky130_fd_sc_hd__a22o_2
X_2660_ clkload6/A _2660_/D fanout102/X vssd1 vssd1 vccd1 vccd1 _2660_/Q sky130_fd_sc_hd__dfrtp_2
X_1473_ _2912_/Q _1472_/B _1477_/A1 vssd1 vssd1 vccd1 vccd1 _1473_/Y sky130_fd_sc_hd__o21ai_2
X_1542_ _2375_/A _2378_/A _2378_/B _2375_/B vssd1 vssd1 vccd1 vccd1 _1542_/X sky130_fd_sc_hd__or4b_2
X_2591_ _2694_/CLK _2591_/D vssd1 vssd1 vccd1 vccd1 _2591_/Q sky130_fd_sc_hd__dfxtp_2
XANTENNA__1628__B1 _1589_/X vssd1 vssd1 vccd1 vccd1 sky130_fd_sc_hd__diode_2
XANTENNA__1876__A0 _2638_/Q vssd1 vssd1 vccd1 vccd1 sky130_fd_sc_hd__diode_2
X_2025_ _1976_/A _2025_/B vssd1 vssd1 vccd1 vccd1 _2026_/B sky130_fd_sc_hd__and2b_2
XFILLER_35_363 vssd1 vssd1 vccd1 vccd1 sky130_fd_sc_hd__fill_1
XPHY_EDGE_ROW_59_Left_124 vssd1 vssd1 vccd1 vccd1 sky130_fd_sc_hd__decap_3
X_1809_ _1816_/B _2874_/Q _1809_/C vssd1 vssd1 vccd1 vccd1 _1809_/X sky130_fd_sc_hd__and3b_2
Xhold253 _2605_/Q vssd1 vssd1 vccd1 vccd1 hold253/X sky130_fd_sc_hd__dlygate4sd3_1
Xhold242 _2608_/Q vssd1 vssd1 vccd1 vccd1 hold242/X sky130_fd_sc_hd__dlygate4sd3_1
X_2858_ _2865_/CLK _2858_/D vssd1 vssd1 vccd1 vccd1 _2858_/Q sky130_fd_sc_hd__dfxtp_2
X_2789_ _2804_/CLK _2789_/D load_slew136/X vssd1 vssd1 vccd1 vccd1 _2789_/Q sky130_fd_sc_hd__dfrtp_2
XANTENNA__2101__S _2125_/S vssd1 vssd1 vccd1 vccd1 sky130_fd_sc_hd__diode_2
XFILLER_49_26 vssd1 vssd1 vccd1 vccd1 sky130_fd_sc_hd__fill_1
Xhold275 _2568_/Q vssd1 vssd1 vccd1 vccd1 hold275/X sky130_fd_sc_hd__dlygate4sd3_1
Xhold286 _2562_/Q vssd1 vssd1 vccd1 vccd1 hold286/X sky130_fd_sc_hd__dlygate4sd3_1
Xhold297 _2564_/Q vssd1 vssd1 vccd1 vccd1 hold297/X sky130_fd_sc_hd__dlygate4sd3_1
Xhold264 _2599_/Q vssd1 vssd1 vccd1 vccd1 hold264/X sky130_fd_sc_hd__dlygate4sd3_1
XANTENNA__2292__B1 _2293_/B1 vssd1 vssd1 vccd1 vccd1 sky130_fd_sc_hd__diode_2
XFILLER_53_171 vssd1 vssd1 vccd1 vccd1 sky130_fd_sc_hd__fill_1
XTAP_TAPCELL_ROW_28_336 vssd1 vccd1 sky130_fd_sc_hd__tapvpwrvgnd_1
XTAP_TAPCELL_ROW_11_214 vssd1 vccd1 sky130_fd_sc_hd__tapvpwrvgnd_1
XTAP_TAPCELL_ROW_36_391 vssd1 vccd1 sky130_fd_sc_hd__tapvpwrvgnd_1
XFILLER_5_267 vssd1 vssd1 vccd1 vccd1 sky130_fd_sc_hd__fill_8
XANTENNA__2283__B1 _2156_/B vssd1 vssd1 vccd1 vccd1 sky130_fd_sc_hd__diode_2
XFILLER_44_160 vssd1 vssd1 vccd1 vccd1 sky130_fd_sc_hd__fill_2
X_2712_ _2866_/CLK _2712_/D fanout111/X vssd1 vssd1 vccd1 vccd1 _2712_/Q sky130_fd_sc_hd__dfrtp_2
X_2643_ _2774_/CLK _2643_/D wire131/X vssd1 vssd1 vccd1 vccd1 _2643_/Q sky130_fd_sc_hd__dfrtp_2
X_2574_ _2694_/CLK _2574_/D vssd1 vssd1 vccd1 vccd1 _2574_/Q sky130_fd_sc_hd__dfxtp_2
XFILLER_59_219 vssd1 vssd1 vccd1 vccd1 sky130_fd_sc_hd__fill_1
X_1387_ _1359_/B hold336/X _2071_/B vssd1 vssd1 vccd1 vccd1 _2884_/D sky130_fd_sc_hd__a21o_2
X_1456_ _2906_/Q _2907_/Q _1448_/B _2908_/Q vssd1 vssd1 vccd1 vccd1 _1456_/X sky130_fd_sc_hd__a31o_2
X_1525_ _1499_/B _1539_/A _2406_/A _2408_/A vssd1 vssd1 vccd1 vccd1 _1531_/C sky130_fd_sc_hd__a31o_2
XFILLER_35_171 vssd1 vssd1 vccd1 vccd1 sky130_fd_sc_hd__fill_4
XFILLER_35_28 vssd1 vssd1 vccd1 vccd1 sky130_fd_sc_hd__fill_1
XTAP_TAPCELL_ROW_25_317 vssd1 vccd1 sky130_fd_sc_hd__tapvpwrvgnd_1
X_2008_ _1953_/Y _2008_/B vssd1 vssd1 vccd1 vccd1 _2009_/B sky130_fd_sc_hd__nand2b_2
XFILLER_35_193 vssd1 vssd1 vccd1 vccd1 sky130_fd_sc_hd__fill_1
XFILLER_50_163 vssd1 vssd1 vccd1 vccd1 sky130_fd_sc_hd__fill_4
XTAP_TAPCELL_ROW_33_372 vssd1 vccd1 sky130_fd_sc_hd__tapvpwrvgnd_1
XFILLER_4_6 vssd1 vssd1 vccd1 vccd1 sky130_fd_sc_hd__fill_8
XFILLER_41_141 vssd1 vssd1 vccd1 vccd1 sky130_fd_sc_hd__fill_4
XFILLER_41_163 vssd1 vssd1 vccd1 vccd1 sky130_fd_sc_hd__fill_4
XFILLER_61_406 vssd1 vssd1 vccd1 vccd1 sky130_fd_sc_hd__fill_1
XFILLER_1_281 vssd1 vssd1 vccd1 vccd1 sky130_fd_sc_hd__fill_2
XPHY_EDGE_ROW_22_Left_87 vssd1 vssd1 vccd1 vccd1 sky130_fd_sc_hd__decap_3
X_1310_ _2793_/Q _1319_/B vssd1 vssd1 vccd1 vccd1 _1311_/B sky130_fd_sc_hd__nor2_2
X_2290_ _1366_/A hold376/X _2293_/B1 hold417/X vssd1 vssd1 vccd1 vccd1 _2767_/D sky130_fd_sc_hd__a22o_2
XFILLER_17_182 vssd1 vssd1 vccd1 vccd1 sky130_fd_sc_hd__fill_4
XTAP_TAPCELL_ROW_30_353 vssd1 vccd1 sky130_fd_sc_hd__tapvpwrvgnd_1
X_2626_ _2694_/CLK _2626_/D fanout104/X vssd1 vssd1 vccd1 vccd1 _2626_/Q sky130_fd_sc_hd__dfrtp_2
X_2557_ _2880_/CLK _2557_/D _1662_/C vssd1 vssd1 vccd1 vccd1 _2557_/Q sky130_fd_sc_hd__dfrtp_2
XANTENNA__2883__Q _2883_/Q vssd1 vssd1 vccd1 vccd1 sky130_fd_sc_hd__diode_2
XFILLER_55_222 vssd1 vssd1 vccd1 vccd1 sky130_fd_sc_hd__fill_2
X_1439_ _1450_/A1 _1436_/X _1438_/Y _1450_/B1 hold423/X vssd1 vssd1 vccd1 vccd1 _2903_/D
+ sky130_fd_sc_hd__a32o_2
X_1508_ _2375_/A _2375_/B _2378_/A _2817_/Q vssd1 vssd1 vccd1 vccd1 _1517_/C sky130_fd_sc_hd__o31a_2
X_2488_ _2508_/A _2488_/B _2488_/C vssd1 vssd1 vccd1 vccd1 _2852_/D sky130_fd_sc_hd__and3_2
XFILLER_11_314 vssd1 vssd1 vccd1 vccd1 sky130_fd_sc_hd__fill_1
XFILLER_43_406 vssd1 vssd1 vccd1 vccd1 sky130_fd_sc_hd__fill_1
XFILLER_62_15 vssd1 vssd1 vccd1 vccd1 sky130_fd_sc_hd__fill_4
Xmax_cap39 _2361_/Y vssd1 vssd1 vccd1 vccd1 _2410_/A sky130_fd_sc_hd__buf_2
XANTENNA__1665__S _1686_/S vssd1 vssd1 vccd1 vccd1 sky130_fd_sc_hd__diode_2
XANTENNA__2685__RESET_B fanout99/X vssd1 vssd1 vccd1 vccd1 sky130_fd_sc_hd__diode_2
XFILLER_2_3 vssd1 vssd1 vccd1 vccd1 sky130_fd_sc_hd__fill_1
XFILLER_19_403 vssd1 vssd1 vccd1 vccd1 sky130_fd_sc_hd__fill_4
XFILLER_14_141 vssd1 vssd1 vccd1 vccd1 sky130_fd_sc_hd__fill_2
XTAP_TAPCELL_ROW_44_445 vssd1 vccd1 sky130_fd_sc_hd__tapvpwrvgnd_1
X_1790_ _1790_/A _1790_/B vssd1 vssd1 vccd1 vccd1 _1790_/Y sky130_fd_sc_hd__nor2_2
X_2411_ _2411_/A _2411_/B vssd1 vssd1 vccd1 vccd1 _2830_/D sky130_fd_sc_hd__xnor2_2
X_2342_ _2345_/A _2342_/B vssd1 vssd1 vccd1 vccd1 _2807_/D sky130_fd_sc_hd__and2_2
X_2273_ _2773_/Q _2727_/Q vssd1 vssd1 vccd1 vccd1 _2276_/A sky130_fd_sc_hd__nor2_2
XFILLER_25_406 vssd1 vssd1 vccd1 vccd1 sky130_fd_sc_hd__fill_1
XFILLER_52_203 vssd1 vssd1 vccd1 vccd1 sky130_fd_sc_hd__fill_1
XANTENNA_clkbuf_leaf_12_clk_A clkbuf_leaf_5_clk/A vssd1 vssd1 vccd1 vccd1 sky130_fd_sc_hd__diode_2
X_1988_ _2065_/A _1985_/A _1985_/B _1987_/Y vssd1 vssd1 vccd1 vccd1 _2056_/A sky130_fd_sc_hd__o31a_2
X_2609_ _2774_/CLK _2609_/D vssd1 vssd1 vccd1 vccd1 _2609_/Q sky130_fd_sc_hd__dfxtp_2
XANTENNA__1691__A1 _2645_/Q vssd1 vssd1 vccd1 vccd1 sky130_fd_sc_hd__diode_2
XFILLER_16_406 vssd1 vssd1 vccd1 vccd1 sky130_fd_sc_hd__fill_1
XFILLER_28_255 vssd1 vssd1 vccd1 vccd1 sky130_fd_sc_hd__fill_1
XFILLER_43_225 vssd1 vssd1 vccd1 vccd1 sky130_fd_sc_hd__fill_2
XFILLER_57_37 vssd1 vssd1 vccd1 vccd1 sky130_fd_sc_hd__fill_2
XTAP_TAPCELL_ROW_58_548 vssd1 vccd1 sky130_fd_sc_hd__tapvpwrvgnd_1
XFILLER_11_111 vssd1 vssd1 vccd1 vccd1 sky130_fd_sc_hd__fill_1
XTAP_TAPCELL_ROW_41_426 vssd1 vccd1 sky130_fd_sc_hd__tapvpwrvgnd_1
XFILLER_7_126 vssd1 vssd1 vccd1 vccd1 sky130_fd_sc_hd__fill_1
XTAP_TAPCELL_ROW_6_181 vssd1 vccd1 sky130_fd_sc_hd__tapvpwrvgnd_1
Xfanout190 _1944_/A vssd1 vssd1 vccd1 vccd1 _1940_/A sky130_fd_sc_hd__clkdlybuf4s25_1
XANTENNA__1682__A1 _2636_/Q vssd1 vssd1 vccd1 vccd1 sky130_fd_sc_hd__diode_2
XANTENNA__2255__A _2770_/Q vssd1 vssd1 vccd1 vccd1 sky130_fd_sc_hd__diode_2
XANTENNA__2261__Y _2261_/Y vssd1 vssd1 vccd1 vccd1 sky130_fd_sc_hd__diode_2
XFILLER_8_53 vssd1 vssd1 vccd1 vccd1 sky130_fd_sc_hd__fill_4
X_1773_ _2623_/Q _1783_/D vssd1 vssd1 vccd1 vccd1 _1775_/A sky130_fd_sc_hd__and2_2
X_1842_ _2640_/Q _1881_/B vssd1 vssd1 vccd1 vccd1 _1885_/B sky130_fd_sc_hd__and2_2
X_1911_ hold343/X _1992_/A _2071_/B vssd1 vssd1 vccd1 vccd1 _2648_/D sky130_fd_sc_hd__mux2_1
X_2891_ _2923_/CLK input4/X fanout86/X vssd1 vssd1 vccd1 vccd1 _2891_/Q sky130_fd_sc_hd__dfstp_2
XFILLER_6_192 vssd1 vssd1 vccd1 vccd1 sky130_fd_sc_hd__fill_4
XFILLER_25_214 vssd1 vssd1 vccd1 vccd1 sky130_fd_sc_hd__fill_1
XPHY_EDGE_ROW_25_Left_90 vssd1 vssd1 vccd1 vccd1 sky130_fd_sc_hd__decap_3
XPHY_EDGE_ROW_40_Left_105 vssd1 vssd1 vccd1 vccd1 sky130_fd_sc_hd__decap_3
X_2325_ _2328_/A1 hold379/X _2156_/B _2801_/Q vssd1 vssd1 vccd1 vccd1 _2325_/X sky130_fd_sc_hd__a22o_2
X_2256_ _2254_/Y _2256_/B vssd1 vssd1 vccd1 vccd1 _2259_/A sky130_fd_sc_hd__and2b_2
X_2187_ hold371/X hold318/X _2189_/S vssd1 vssd1 vccd1 vccd1 _2743_/D sky130_fd_sc_hd__mux2_1
XANTENNA_fanout132_X fanout132/X vssd1 vssd1 vccd1 vccd1 sky130_fd_sc_hd__diode_2
XFILLER_25_225 vssd1 vssd1 vccd1 vccd1 sky130_fd_sc_hd__fill_4
XFILLER_25_247 vssd1 vssd1 vccd1 vccd1 sky130_fd_sc_hd__fill_1
XFILLER_43_28 vssd1 vssd1 vccd1 vccd1 sky130_fd_sc_hd__fill_1
XTAP_TAPCELL_ROW_63_584 vssd1 vccd1 sky130_fd_sc_hd__tapvpwrvgnd_1
XANTENNA__2104__S _2134_/S vssd1 vssd1 vccd1 vccd1 sky130_fd_sc_hd__diode_2
XFILLER_4_107 vssd1 vssd1 vccd1 vccd1 sky130_fd_sc_hd__fill_8
Xteam_06_204 vssd1 vssd1 vccd1 vccd1 team_06_204/HI gpio_oeb[16] sky130_fd_sc_hd__conb_1
Xteam_06_215 vssd1 vssd1 vccd1 vccd1 team_06_215/HI gpio_oeb[27] sky130_fd_sc_hd__conb_1
XFILLER_16_269 vssd1 vssd1 vccd1 vccd1 sky130_fd_sc_hd__fill_1
XFILLER_17_51 vssd1 vssd1 vccd1 vccd1 sky130_fd_sc_hd__fill_4
XTAP_TAPCELL_ROW_3_162 vssd1 vccd1 sky130_fd_sc_hd__tapvpwrvgnd_1
X_2110_ _2564_/Q _2580_/Q _2120_/S vssd1 vssd1 vccd1 vccd1 _2110_/X sky130_fd_sc_hd__mux2_1
X_2041_ _2041_/A _2041_/B _2041_/C _2041_/D vssd1 vssd1 vccd1 vccd1 _2055_/A sky130_fd_sc_hd__or4_2
XANTENNA__1655__A1 _2555_/Q vssd1 vssd1 vccd1 vccd1 sky130_fd_sc_hd__diode_2
X_1756_ _1755_/X _1756_/B _1756_/C vssd1 vssd1 vccd1 vccd1 _1756_/X sky130_fd_sc_hd__and3b_2
X_1825_ _2635_/Q _2557_/Q vssd1 vssd1 vccd1 vccd1 _1834_/A sky130_fd_sc_hd__nand2_2
Xhold402 _2778_/Q vssd1 vssd1 vccd1 vccd1 hold402/X sky130_fd_sc_hd__dlygate4sd3_1
Xhold413 _2138_/X vssd1 vssd1 vccd1 vccd1 _2696_/D sky130_fd_sc_hd__dlygate4sd3_1
Xhold424 _2774_/Q vssd1 vssd1 vccd1 vccd1 hold424/X sky130_fd_sc_hd__dlygate4sd3_1
Xhold435 _2692_/Q vssd1 vssd1 vccd1 vccd1 hold435/X sky130_fd_sc_hd__dlygate4sd3_1
X_2874_ _2880_/CLK _2874_/D fanout92/X vssd1 vssd1 vccd1 vccd1 _2874_/Q sky130_fd_sc_hd__dfrtp_2
XANTENNA__1591__B1 _1589_/X vssd1 vssd1 vccd1 vccd1 sky130_fd_sc_hd__diode_2
X_1687_ hold289/X _2641_/Q _1693_/S vssd1 vssd1 vccd1 vccd1 _2586_/D sky130_fd_sc_hd__mux2_1
Xhold446 _2685_/Q vssd1 vssd1 vccd1 vccd1 hold446/X sky130_fd_sc_hd__dlygate4sd3_1
Xhold457 _2551_/Q vssd1 vssd1 vccd1 vccd1 hold457/X sky130_fd_sc_hd__dlygate4sd3_1
Xhold468 _2548_/Q vssd1 vssd1 vccd1 vccd1 hold468/X sky130_fd_sc_hd__dlygate4sd3_1
Xhold479 _1660_/X vssd1 vssd1 vccd1 vccd1 _2560_/D sky130_fd_sc_hd__dlygate4sd3_1
X_2308_ _2300_/A1 _1337_/B _2299_/B hold387/X vssd1 vssd1 vccd1 vccd1 _2784_/D sky130_fd_sc_hd__a2bb2o_2
XTAP_TAPCELL_ROW_0_132 vssd1 vccd1 sky130_fd_sc_hd__tapvpwrvgnd_1
XTAP_TAPCELL_ROW_0_143 vssd1 vccd1 sky130_fd_sc_hd__tapvpwrvgnd_1
X_2239_ _2238_/A _2238_/B _2238_/C vssd1 vssd1 vccd1 vccd1 _2239_/X sky130_fd_sc_hd__a21o_2
XFILLER_36_309 vssd1 vssd1 vccd1 vccd1 sky130_fd_sc_hd__fill_1
XFILLER_12_261 vssd1 vssd1 vccd1 vccd1 sky130_fd_sc_hd__fill_2
XFILLER_60_70 vssd1 vssd1 vccd1 vccd1 sky130_fd_sc_hd__fill_1
X_1610_ _2621_/Q _1585_/X _1609_/X vssd1 vssd1 vccd1 vccd1 _2542_/D sky130_fd_sc_hd__a21o_2
X_2590_ _2694_/CLK _2590_/D vssd1 vssd1 vccd1 vccd1 _2590_/Q sky130_fd_sc_hd__dfxtp_2
X_1472_ _2912_/Q _1472_/B vssd1 vssd1 vccd1 vccd1 _1479_/C sky130_fd_sc_hd__and2_2
X_1541_ _2375_/B _1543_/B vssd1 vssd1 vccd1 vccd1 _1541_/Y sky130_fd_sc_hd__nand2b_2
XFILLER_35_353 vssd1 vssd1 vccd1 vccd1 sky130_fd_sc_hd__fill_1
XFILLER_39_169 vssd1 vssd1 vccd1 vccd1 sky130_fd_sc_hd__fill_8
XFILLER_47_191 vssd1 vssd1 vccd1 vccd1 sky130_fd_sc_hd__fill_2
X_2024_ _2024_/A _2024_/B vssd1 vssd1 vccd1 vccd1 _2041_/A sky130_fd_sc_hd__or2_2
XFILLER_62_161 vssd1 vssd1 vccd1 vccd1 sky130_fd_sc_hd__fill_1
X_2857_ _2865_/CLK _2857_/D vssd1 vssd1 vccd1 vccd1 _2857_/Q sky130_fd_sc_hd__dfxtp_2
XFILLER_40_29 vssd1 vssd1 vccd1 vccd1 sky130_fd_sc_hd__fill_4
X_1739_ _2616_/Q _2555_/Q _1739_/C _1739_/D vssd1 vssd1 vccd1 vccd1 _1741_/B sky130_fd_sc_hd__nand4_2
X_1808_ _2629_/Q _2630_/Q _1808_/C vssd1 vssd1 vccd1 vccd1 _1816_/B sky130_fd_sc_hd__and3_2
Xhold276 _2589_/Q vssd1 vssd1 vccd1 vccd1 hold276/X sky130_fd_sc_hd__dlygate4sd3_1
Xhold287 _2714_/Q vssd1 vssd1 vccd1 vccd1 hold287/X sky130_fd_sc_hd__dlygate4sd3_1
Xhold265 _2727_/Q vssd1 vssd1 vccd1 vccd1 hold265/X sky130_fd_sc_hd__dlygate4sd3_1
Xhold254 _2596_/Q vssd1 vssd1 vccd1 vccd1 hold254/X sky130_fd_sc_hd__dlygate4sd3_1
Xhold243 _2601_/Q vssd1 vssd1 vccd1 vccd1 hold243/X sky130_fd_sc_hd__dlygate4sd3_1
X_2788_ _2870_/CLK _2788_/D fanout124/X vssd1 vssd1 vccd1 vccd1 _2788_/Q sky130_fd_sc_hd__dfrtp_2
XANTENNA__2639__RESET_B fanout132/X vssd1 vssd1 vccd1 vccd1 sky130_fd_sc_hd__diode_2
XFILLER_18_309 vssd1 vssd1 vccd1 vccd1 sky130_fd_sc_hd__fill_2
Xhold298 _2606_/Q vssd1 vssd1 vccd1 vccd1 hold298/X sky130_fd_sc_hd__dlygate4sd3_1
XANTENNA__1619__A1 _2641_/Q vssd1 vssd1 vccd1 vccd1 sky130_fd_sc_hd__diode_2
XANTENNA__2292__A1 _1366_/A vssd1 vssd1 vccd1 vccd1 sky130_fd_sc_hd__diode_2
XFILLER_45_139 vssd1 vssd1 vccd1 vccd1 sky130_fd_sc_hd__fill_2
XTAP_TAPCELL_ROW_28_337 vssd1 vccd1 sky130_fd_sc_hd__tapvpwrvgnd_1
XTAP_TAPCELL_ROW_36_392 vssd1 vccd1 sky130_fd_sc_hd__tapvpwrvgnd_1
XFILLER_14_85 vssd1 vssd1 vccd1 vccd1 sky130_fd_sc_hd__fill_4
XFILLER_14_96 vssd1 vssd1 vccd1 vccd1 sky130_fd_sc_hd__fill_1
XTAP_TAPCELL_ROW_11_215 vssd1 vccd1 sky130_fd_sc_hd__tapvpwrvgnd_1
XFILLER_39_71 vssd1 vssd1 vccd1 vccd1 sky130_fd_sc_hd__fill_4
X_2711_ _2774_/CLK _2711_/D fanout140/X vssd1 vssd1 vccd1 vccd1 _2711_/Q sky130_fd_sc_hd__dfrtp_2
X_1524_ _2827_/Q _2826_/Q _2828_/Q vssd1 vssd1 vccd1 vccd1 _2406_/A sky130_fd_sc_hd__and3_2
X_2642_ _2642_/CLK _2642_/D wire131/X vssd1 vssd1 vccd1 vccd1 _2642_/Q sky130_fd_sc_hd__dfrtp_2
X_2573_ _2694_/CLK _2573_/D vssd1 vssd1 vccd1 vccd1 _2573_/Q sky130_fd_sc_hd__dfxtp_2
XFILLER_4_290 vssd1 vccd1 vssd1 vccd1 sky130_ef_sc_hd__decap_40_12
X_1386_ _1652_/A _2871_/Q _1812_/C _1821_/B _1756_/B vssd1 vssd1 vccd1 vccd1 _2871_/D
+ sky130_fd_sc_hd__a311o_2
X_1455_ _1458_/B vssd1 vssd1 vccd1 vccd1 _1455_/Y sky130_fd_sc_hd__inv_2
XTAP_TAPCELL_ROW_25_318 vssd1 vccd1 sky130_fd_sc_hd__tapvpwrvgnd_1
X_2007_ _2007_/A _2007_/B _2007_/C vssd1 vssd1 vccd1 vccd1 _2018_/A sky130_fd_sc_hd__or3_2
XFILLER_50_197 vssd1 vssd1 vccd1 vccd1 sky130_fd_sc_hd__fill_1
XTAP_TAPCELL_ROW_33_373 vssd1 vccd1 sky130_fd_sc_hd__tapvpwrvgnd_1
X_2909_ _2912_/CLK _2909_/D fanout117/A vssd1 vssd1 vccd1 vccd1 _2909_/Q sky130_fd_sc_hd__dfrtp_2
XFILLER_2_216 vssd1 vssd1 vccd1 vccd1 sky130_fd_sc_hd__fill_1
XANTENNA__2348__A _2472_/A vssd1 vssd1 vccd1 vccd1 sky130_fd_sc_hd__diode_2
XFILLER_25_40 vssd1 vssd1 vccd1 vccd1 sky130_fd_sc_hd__fill_1
XFILLER_41_197 vssd1 vssd1 vccd1 vccd1 sky130_fd_sc_hd__fill_1
XFILLER_2_22 vssd1 vssd1 vccd1 vccd1 sky130_fd_sc_hd__fill_1
XANTENNA__1700__A0 _2618_/Q vssd1 vssd1 vccd1 vccd1 sky130_fd_sc_hd__diode_2
XFILLER_32_186 vssd1 vssd1 vccd1 vccd1 sky130_fd_sc_hd__fill_1
X_1507_ _1499_/A _1495_/B _1522_/A wire75/X vssd1 vssd1 vccd1 vccd1 _1510_/B sky130_fd_sc_hd__o31ai_2
X_2625_ _2671_/CLK _2625_/D fanout104/X vssd1 vssd1 vccd1 vccd1 _2625_/Q sky130_fd_sc_hd__dfrtp_2
X_2556_ _2880_/CLK _2556_/D _1662_/C vssd1 vssd1 vccd1 vccd1 _2556_/Q sky130_fd_sc_hd__dfrtp_2
X_2487_ _2494_/D vssd1 vssd1 vccd1 vccd1 _2488_/C sky130_fd_sc_hd__inv_2
X_1369_ _2530_/Q _2529_/Q _2532_/Q _2531_/Q vssd1 vssd1 vccd1 vccd1 _1370_/D sky130_fd_sc_hd__or4_2
X_1438_ _1444_/C vssd1 vssd1 vccd1 vccd1 _1438_/Y sky130_fd_sc_hd__inv_2
XANTENNA__2107__S _2136_/B vssd1 vssd1 vccd1 vccd1 sky130_fd_sc_hd__diode_2
XANTENNA__2654__RESET_B fanout99/X vssd1 vssd1 vccd1 vccd1 sky130_fd_sc_hd__diode_2
XANTENNA__1681__S _1686_/S vssd1 vssd1 vccd1 vccd1 sky130_fd_sc_hd__diode_2
XFILLER_36_61 vssd1 vssd1 vccd1 vccd1 sky130_fd_sc_hd__fill_8
XFILLER_36_83 vssd1 vssd1 vccd1 vccd1 sky130_fd_sc_hd__fill_1
XTAP_TAPCELL_ROW_44_446 vssd1 vccd1 sky130_fd_sc_hd__tapvpwrvgnd_1
XANTENNA__2017__S _2071_/B vssd1 vssd1 vccd1 vccd1 sky130_fd_sc_hd__diode_2
XFILLER_6_363 vssd1 vssd1 vccd1 vccd1 sky130_fd_sc_hd__fill_1
X_2410_ _2410_/A _2421_/D vssd1 vssd1 vccd1 vccd1 _2411_/B sky130_fd_sc_hd__nand2_2
X_2341_ _2807_/Q _2340_/A _2338_/X _2340_/Y vssd1 vssd1 vccd1 vccd1 _2342_/B sky130_fd_sc_hd__a22o_2
XFILLER_37_223 vssd1 vssd1 vccd1 vccd1 sky130_fd_sc_hd__fill_1
X_2272_ _2155_/A _2270_/Y _2271_/X hold389/X _2282_/A2 vssd1 vssd1 vccd1 vccd1 _2757_/D
+ sky130_fd_sc_hd__a32o_2
X_1987_ _1987_/A _2065_/B vssd1 vssd1 vccd1 vccd1 _1987_/Y sky130_fd_sc_hd__nor2_2
X_2608_ _2647_/CLK _2608_/D vssd1 vssd1 vccd1 vccd1 _2608_/Q sky130_fd_sc_hd__dfxtp_2
X_2539_ clkload7/A _2539_/D load_slew127/X vssd1 vssd1 vccd1 vccd1 _2539_/Q sky130_fd_sc_hd__dfrtp_2
XFILLER_43_237 vssd1 vssd1 vccd1 vccd1 sky130_fd_sc_hd__fill_2
XTAP_TAPCELL_ROW_58_549 vssd1 vccd1 sky130_fd_sc_hd__tapvpwrvgnd_1
XANTENNA__1676__S _1693_/S vssd1 vssd1 vccd1 vccd1 sky130_fd_sc_hd__diode_2
XFILLER_11_101 vssd1 vssd1 vccd1 vccd1 sky130_fd_sc_hd__fill_4
XFILLER_11_167 vssd1 vssd1 vccd1 vccd1 sky130_fd_sc_hd__fill_1
XFILLER_7_105 vssd1 vssd1 vccd1 vccd1 sky130_fd_sc_hd__fill_4
XTAP_TAPCELL_ROW_41_427 vssd1 vccd1 sky130_fd_sc_hd__tapvpwrvgnd_1
XTAP_TAPCELL_ROW_6_182 vssd1 vccd1 sky130_fd_sc_hd__tapvpwrvgnd_1
Xfanout191 _2695_/Q vssd1 vssd1 vccd1 vccd1 _1944_/A sky130_fd_sc_hd__clkdlybuf4s25_1
Xfanout180 _2869_/Q vssd1 vssd1 vccd1 vccd1 _2189_/S sky130_fd_sc_hd__clkdlybuf4s25_1
XFILLER_19_278 vssd1 vssd1 vccd1 vccd1 sky130_fd_sc_hd__fill_2
X_1910_ _2680_/Q _2665_/Q vssd1 vssd1 vccd1 vccd1 _1992_/A sky130_fd_sc_hd__xor2_2
X_2890_ clkload4/A input3/X fanout86/X vssd1 vssd1 vccd1 vccd1 _2890_/Q sky130_fd_sc_hd__dfstp_2
XFILLER_8_87 vssd1 vssd1 vccd1 vccd1 sky130_fd_sc_hd__fill_1
X_1772_ _2622_/Q _1814_/B2 _1770_/X _1771_/X vssd1 vssd1 vccd1 vccd1 _2622_/D sky130_fd_sc_hd__o22a_2
X_1841_ _2639_/Q _2638_/Q _2637_/Q _1841_/D vssd1 vssd1 vccd1 vccd1 _1881_/B sky130_fd_sc_hd__and4_2
XANTENNA__2147__A0 _2705_/Q vssd1 vssd1 vccd1 vccd1 sky130_fd_sc_hd__diode_2
XFILLER_6_182 vssd1 vssd1 vccd1 vccd1 sky130_fd_sc_hd__fill_1
X_2324_ _2328_/A1 hold382/X _2156_/B _2800_/Q vssd1 vssd1 vccd1 vccd1 _2800_/D sky130_fd_sc_hd__a22o_2
XFILLER_25_237 vssd1 vssd1 vccd1 vccd1 sky130_fd_sc_hd__fill_4
X_2255_ _2770_/Q _2724_/Q vssd1 vssd1 vccd1 vccd1 _2256_/B sky130_fd_sc_hd__nand2_2
X_2186_ hold416/X hold321/X _2186_/S vssd1 vssd1 vccd1 vccd1 _2742_/D sky130_fd_sc_hd__mux2_1
XFILLER_25_259 vssd1 vssd1 vccd1 vccd1 sky130_fd_sc_hd__fill_1
XFILLER_33_292 vssd1 vssd1 vccd1 vccd1 sky130_fd_sc_hd__fill_2
Xteam_06_227 vssd1 vssd1 vccd1 vccd1 gpio_oeb[0] team_06_227/LO sky130_fd_sc_hd__conb_1
Xteam_06_216 vssd1 vssd1 vccd1 vccd1 team_06_216/HI gpio_oeb[28] sky130_fd_sc_hd__conb_1
Xteam_06_205 vssd1 vssd1 vccd1 vccd1 team_06_205/HI gpio_oeb[17] sky130_fd_sc_hd__conb_1
XANTENNA__1260__A _1351_/A vssd1 vssd1 vccd1 vccd1 sky130_fd_sc_hd__diode_2
XANTENNA_fanout38_X _2472_/B vssd1 vssd1 vccd1 vccd1 sky130_fd_sc_hd__diode_2
XTAP_TAPCELL_ROW_3_163 vssd1 vccd1 sky130_fd_sc_hd__tapvpwrvgnd_1
XFILLER_33_40 vssd1 vssd1 vccd1 vccd1 sky130_fd_sc_hd__fill_4
XFILLER_33_51 vssd1 vssd1 vccd1 vccd1 sky130_fd_sc_hd__fill_4
XFILLER_33_73 vssd1 vssd1 vccd1 vccd1 sky130_fd_sc_hd__fill_4
XANTENNA_clkbuf_leaf_11_clk_A clkbuf_leaf_5_clk/A vssd1 vssd1 vccd1 vccd1 sky130_fd_sc_hd__diode_2
XFILLER_62_332 vssd1 vssd1 vccd1 vccd1 sky130_fd_sc_hd__fill_1
X_2040_ hold433/X _2039_/Y _2071_/B vssd1 vssd1 vccd1 vccd1 _2657_/D sky130_fd_sc_hd__mux2_1
X_2873_ _2924_/CLK _2873_/D load_slew112/X vssd1 vssd1 vccd1 vccd1 _2873_/Q sky130_fd_sc_hd__dfrtp_2
X_1686_ hold263/X _2640_/Q _1686_/S vssd1 vssd1 vccd1 vccd1 _2585_/D sky130_fd_sc_hd__mux2_1
X_1755_ _1744_/X _1747_/Y _1752_/Y _1753_/X vssd1 vssd1 vccd1 vccd1 _1755_/X sky130_fd_sc_hd__o211a_2
X_1824_ _2636_/Q _2558_/Q vssd1 vssd1 vccd1 vccd1 _1837_/A sky130_fd_sc_hd__nand2_2
Xhold403 _2317_/X vssd1 vssd1 vccd1 vccd1 _2793_/D sky130_fd_sc_hd__dlygate4sd3_1
Xhold414 _2759_/Q vssd1 vssd1 vccd1 vccd1 hold414/X sky130_fd_sc_hd__dlygate4sd3_1
Xhold425 _2843_/Q vssd1 vssd1 vccd1 vccd1 _2459_/A sky130_fd_sc_hd__dlygate4sd3_1
Xhold436 _2684_/Q vssd1 vssd1 vccd1 vccd1 hold436/X sky130_fd_sc_hd__dlygate4sd3_1
Xhold447 _2766_/Q vssd1 vssd1 vccd1 vccd1 hold447/X sky130_fd_sc_hd__dlygate4sd3_1
Xhold458 _2762_/Q vssd1 vssd1 vccd1 vccd1 hold458/X sky130_fd_sc_hd__dlygate4sd3_1
Xhold469 _2686_/Q vssd1 vssd1 vccd1 vccd1 hold469/X sky130_fd_sc_hd__dlygate4sd3_1
X_2307_ _2300_/A1 _1333_/X _2299_/B hold405/X vssd1 vssd1 vccd1 vccd1 _2783_/D sky130_fd_sc_hd__a2bb2o_2
X_2238_ _2238_/A _2238_/B _2238_/C vssd1 vssd1 vccd1 vccd1 _2238_/Y sky130_fd_sc_hd__nand3_2
XFILLER_13_229 vssd1 vssd1 vccd1 vccd1 sky130_fd_sc_hd__fill_1
XTAP_TAPCELL_ROW_0_133 vssd1 vccd1 sky130_fd_sc_hd__tapvpwrvgnd_1
XTAP_TAPCELL_ROW_51_500 vssd1 vccd1 sky130_fd_sc_hd__tapvpwrvgnd_1
X_2169_ hold333/X hold311/X _2189_/S vssd1 vssd1 vccd1 vccd1 _2725_/D sky130_fd_sc_hd__mux2_1
XANTENNA__2115__S _2882_/D vssd1 vssd1 vccd1 vccd1 sky130_fd_sc_hd__diode_2
XFILLER_48_137 vssd1 vssd1 vccd1 vccd1 sky130_fd_sc_hd__fill_1
XFILLER_12_251 vssd1 vssd1 vccd1 vccd1 sky130_fd_sc_hd__fill_1
XFILLER_44_365 vssd1 vssd1 vccd1 vccd1 sky130_fd_sc_hd__fill_1
XTAP_TAPCELL_ROW_14_235 vssd1 vccd1 sky130_fd_sc_hd__tapvpwrvgnd_1
X_1540_ _2378_/A _2378_/B _2375_/A vssd1 vssd1 vccd1 vccd1 _1543_/B sky130_fd_sc_hd__nor3b_2
XFILLER_10_3 vssd1 vssd1 vccd1 vccd1 sky130_fd_sc_hd__fill_4
X_1471_ _1280_/B _1468_/X _1469_/X _1470_/Y vssd1 vssd1 vccd1 vccd1 _2911_/D sky130_fd_sc_hd__o22ai_2
XANTENNA__1628__A2 _1585_/X vssd1 vssd1 vccd1 vccd1 sky130_fd_sc_hd__diode_2
X_2023_ _2022_/X _2021_/Y hold543/X _2069_/B1 vssd1 vssd1 vccd1 vccd1 _2654_/D sky130_fd_sc_hd__a2bb2o_2
X_1807_ _2628_/Q _2629_/Q _1798_/B _2630_/Q vssd1 vssd1 vccd1 vccd1 _1809_/C sky130_fd_sc_hd__a31o_2
X_2856_ clkload1/A _2856_/D vssd1 vssd1 vccd1 vccd1 _2856_/Q sky130_fd_sc_hd__dfxtp_2
X_1669_ hold275/X _2622_/Q _1691_/S vssd1 vssd1 vccd1 vccd1 _2568_/D sky130_fd_sc_hd__mux2_1
X_1738_ _2617_/Q _2556_/Q vssd1 vssd1 vccd1 vccd1 _1739_/D sky130_fd_sc_hd__or2_2
Xhold277 _2894_/Q vssd1 vssd1 vccd1 vccd1 _2887_/D sky130_fd_sc_hd__dlygate4sd3_1
Xhold288 _2588_/Q vssd1 vssd1 vccd1 vccd1 hold288/X sky130_fd_sc_hd__dlygate4sd3_1
Xhold299 _2533_/Q vssd1 vssd1 vccd1 vccd1 hold299/X sky130_fd_sc_hd__dlygate4sd3_1
Xhold266 _2718_/Q vssd1 vssd1 vccd1 vccd1 hold266/X sky130_fd_sc_hd__dlygate4sd3_1
Xhold255 _2597_/Q vssd1 vssd1 vccd1 vccd1 hold255/X sky130_fd_sc_hd__dlygate4sd3_1
Xhold244 _2721_/Q vssd1 vssd1 vccd1 vccd1 hold244/X sky130_fd_sc_hd__dlygate4sd3_1
X_2787_ _2870_/CLK _2787_/D load_slew123/X vssd1 vssd1 vccd1 vccd1 _2787_/Q sky130_fd_sc_hd__dfrtp_2
XANTENNA_fanout192_X _2472_/A vssd1 vssd1 vccd1 vccd1 sky130_fd_sc_hd__diode_2
XTAP_TAPCELL_ROW_28_338 vssd1 vccd1 sky130_fd_sc_hd__tapvpwrvgnd_1
XFILLER_26_365 vssd1 vssd1 vccd1 vccd1 sky130_fd_sc_hd__fill_1
XTAP_TAPCELL_ROW_36_393 vssd1 vccd1 sky130_fd_sc_hd__tapvpwrvgnd_1
XANTENNA__1684__S _1686_/S vssd1 vssd1 vccd1 vccd1 sky130_fd_sc_hd__diode_2
XFILLER_5_214 vssd1 vssd1 vccd1 vccd1 sky130_fd_sc_hd__fill_8
XTAP_TAPCELL_ROW_11_216 vssd1 vccd1 sky130_fd_sc_hd__tapvpwrvgnd_1
XANTENNA__2263__B _2263_/B vssd1 vssd1 vccd1 vccd1 sky130_fd_sc_hd__diode_2
X_2710_ _2774_/CLK _2710_/D wire131/X vssd1 vssd1 vccd1 vccd1 _2710_/Q sky130_fd_sc_hd__dfrtp_2
XFILLER_58_3 vssd1 vssd1 vccd1 vccd1 sky130_fd_sc_hd__fill_4
X_1454_ _2908_/Q _2907_/Q _1454_/C vssd1 vssd1 vccd1 vccd1 _1458_/B sky130_fd_sc_hd__and3_2
X_1523_ _2822_/Q _1539_/A _2400_/B _1522_/Y _1493_/Y vssd1 vssd1 vccd1 vccd1 _2442_/B
+ sky130_fd_sc_hd__a311o_2
X_2641_ _2642_/CLK _2641_/D wire131/X vssd1 vssd1 vccd1 vccd1 _2641_/Q sky130_fd_sc_hd__dfrtp_2
X_2572_ clkload6/A _2572_/D vssd1 vssd1 vccd1 vccd1 _2572_/Q sky130_fd_sc_hd__dfxtp_2
X_1385_ _1734_/A _1385_/B vssd1 vssd1 vccd1 vccd1 _1821_/B sky130_fd_sc_hd__or2_2
XANTENNA_fanout152_A _2883_/Q vssd1 vssd1 vccd1 vccd1 sky130_fd_sc_hd__diode_2
XFILLER_23_346 vssd1 vssd1 vccd1 vccd1 sky130_fd_sc_hd__fill_1
X_2006_ _2005_/X _2004_/Y hold481/X _2069_/B1 vssd1 vssd1 vccd1 vccd1 _2651_/D sky130_fd_sc_hd__a2bb2o_2
XTAP_TAPCELL_ROW_33_374 vssd1 vccd1 sky130_fd_sc_hd__tapvpwrvgnd_1
X_2908_ _2912_/CLK _2908_/D fanout117/A vssd1 vssd1 vccd1 vccd1 _2908_/Q sky130_fd_sc_hd__dfrtp_2
X_2839_ clkload4/A _2839_/D load_slew83/X vssd1 vssd1 vccd1 vccd1 _2839_/Q sky130_fd_sc_hd__dfrtp_2
Xclkbuf_leaf_38_clk clkbuf_leaf_3_clk/A vssd1 vssd1 vccd1 vccd1 _2845_/CLK sky130_fd_sc_hd__clkbuf_8
XFILLER_26_195 vssd1 vssd1 vccd1 vccd1 sky130_fd_sc_hd__fill_1
XANTENNA__1700__A1 _2635_/Q vssd1 vssd1 vccd1 vccd1 sky130_fd_sc_hd__diode_2
XFILLER_1_283 vssd1 vssd1 vccd1 vccd1 sky130_fd_sc_hd__fill_1
XFILLER_49_221 vssd1 vssd1 vccd1 vccd1 sky130_fd_sc_hd__fill_2
XTAP_TAPCELL_ROW_47_466 vssd1 vccd1 sky130_fd_sc_hd__tapvpwrvgnd_1
Xclkbuf_leaf_29_clk clkbuf_3_5__f_clk/X vssd1 vssd1 vccd1 vccd1 _2912_/CLK sky130_fd_sc_hd__clkbuf_8
X_2624_ _2671_/CLK _2624_/D fanout128/X vssd1 vssd1 vccd1 vccd1 _2624_/Q sky130_fd_sc_hd__dfrtp_2
XANTENNA__2192__A1 _1351_/A vssd1 vssd1 vccd1 vccd1 sky130_fd_sc_hd__diode_2
X_1437_ _2901_/Q _2902_/Q _2903_/Q _1437_/D vssd1 vssd1 vccd1 vccd1 _1444_/C sky130_fd_sc_hd__and4_2
X_1506_ _2841_/Q _1505_/X _1502_/X _1504_/X vssd1 vssd1 vccd1 vccd1 _1506_/X sky130_fd_sc_hd__a2bb2o_2
X_2555_ _2813_/CLK _2555_/D _2335_/B1 vssd1 vssd1 vccd1 vccd1 _2555_/Q sky130_fd_sc_hd__dfrtp_2
X_2486_ _2850_/Q _2851_/Q _2852_/Q _2486_/D vssd1 vssd1 vccd1 vccd1 _2494_/D sky130_fd_sc_hd__and4_2
XANTENNA__2247__A2 _2260_/A2 vssd1 vssd1 vccd1 vccd1 sky130_fd_sc_hd__diode_2
XFILLER_46_18 vssd1 vssd1 vccd1 vccd1 sky130_fd_sc_hd__fill_1
X_1299_ _2795_/Q _2794_/Q _1321_/B vssd1 vssd1 vccd1 vccd1 _1327_/B sky130_fd_sc_hd__and3_2
X_1368_ _2522_/Q _2521_/Q _2524_/Q _2523_/Q vssd1 vssd1 vccd1 vccd1 _1371_/B sky130_fd_sc_hd__or4_2
XANTENNA__2263__A_N _2261_/Y vssd1 vssd1 vccd1 vccd1 sky130_fd_sc_hd__diode_2
XANTENNA__2123__S _2125_/S vssd1 vssd1 vccd1 vccd1 sky130_fd_sc_hd__diode_2
XFILLER_11_65 vssd1 vssd1 vccd1 vccd1 sky130_fd_sc_hd__fill_1
XANTENNA_fanout68_X _2260_/A2 vssd1 vssd1 vccd1 vccd1 sky130_fd_sc_hd__diode_2
XFILLER_46_246 vssd1 vssd1 vccd1 vccd1 sky130_fd_sc_hd__fill_1
XTAP_TAPCELL_ROW_44_447 vssd1 vccd1 sky130_fd_sc_hd__tapvpwrvgnd_1
XANTENNA__1749__B2 _2699_/Q vssd1 vssd1 vccd1 vccd1 sky130_fd_sc_hd__diode_2
X_2340_ _2340_/A _2340_/B vssd1 vssd1 vccd1 vccd1 _2340_/Y sky130_fd_sc_hd__nor2_2
X_2271_ _2270_/A _2270_/B _2270_/C vssd1 vssd1 vccd1 vccd1 _2271_/X sky130_fd_sc_hd__a21o_2
X_1986_ _2679_/Q _1986_/B _1986_/C vssd1 vssd1 vccd1 vccd1 _2065_/B sky130_fd_sc_hd__and3_2
XANTENNA_fanout115_A fanout145/X vssd1 vssd1 vccd1 vccd1 sky130_fd_sc_hd__diode_2
Xclkbuf_leaf_9_clk clkbuf_leaf_9_clk/A vssd1 vssd1 vccd1 vccd1 _2693_/CLK sky130_fd_sc_hd__clkbuf_8
X_2607_ _2647_/CLK _2607_/D vssd1 vssd1 vccd1 vccd1 _2607_/Q sky130_fd_sc_hd__dfxtp_2
X_2538_ _2663_/CLK _2538_/D fanout100/X vssd1 vssd1 vccd1 vccd1 _2538_/Q sky130_fd_sc_hd__dfrtp_2
X_2469_ hold326/X _2410_/A _2465_/Y _2468_/X vssd1 vssd1 vccd1 vccd1 _2845_/D sky130_fd_sc_hd__a31oi_2
XFILLER_11_113 vssd1 vssd1 vccd1 vccd1 sky130_fd_sc_hd__fill_2
XTAP_TAPCELL_ROW_41_428 vssd1 vccd1 sky130_fd_sc_hd__tapvpwrvgnd_1
XANTENNA__1692__S _1693_/S vssd1 vssd1 vccd1 vccd1 sky130_fd_sc_hd__diode_2
XFILLER_19_268 vssd1 vssd1 vccd1 vccd1 sky130_fd_sc_hd__fill_1
XTAP_TAPCELL_ROW_6_183 vssd1 vccd1 sky130_fd_sc_hd__tapvpwrvgnd_1
Xfanout192 _2470_/D vssd1 vssd1 vccd1 vccd1 _2472_/A sky130_fd_sc_hd__clkdlybuf4s25_1
Xfanout181 _1351_/A vssd1 vssd1 vccd1 vccd1 _2155_/A sky130_fd_sc_hd__clkdlybuf4s25_1
Xfanout170 _1384_/A vssd1 vssd1 vccd1 vccd1 _1810_/A1 sky130_fd_sc_hd__clkdlybuf4s25_1
X_1840_ _2638_/Q _2637_/Q _1841_/D vssd1 vssd1 vccd1 vccd1 _1877_/B sky130_fd_sc_hd__and3_2
Xclkbuf_3_4__f_clk clkbuf_0_clk/X vssd1 vssd1 vccd1 vccd1 clkbuf_3_4__f_clk/X sky130_fd_sc_hd__clkbuf_16
X_1771_ _1384_/A _2654_/Q _1786_/B1 _2703_/Q _1819_/B2 vssd1 vssd1 vccd1 vccd1 _1771_/X
+ sky130_fd_sc_hd__a221o_2
X_2323_ _2323_/A1 hold387/X _2323_/B1 _2799_/Q vssd1 vssd1 vccd1 vccd1 _2323_/X sky130_fd_sc_hd__a22o_2
X_2254_ _2770_/Q _2724_/Q vssd1 vssd1 vccd1 vccd1 _2254_/Y sky130_fd_sc_hd__nor2_2
X_2185_ hold347/X hold299/X _2186_/S vssd1 vssd1 vccd1 vccd1 _2741_/D sky130_fd_sc_hd__mux2_1
X_1969_ _1961_/Y _1967_/A _1967_/B _1997_/B _2002_/B vssd1 vssd1 vccd1 vccd1 _1970_/B
+ sky130_fd_sc_hd__o311a_2
Xteam_06_228 vssd1 vssd1 vccd1 vccd1 gpio_oeb[1] team_06_228/LO sky130_fd_sc_hd__conb_1
Xteam_06_217 vssd1 vssd1 vccd1 vccd1 team_06_217/HI gpio_out[0] sky130_fd_sc_hd__conb_1
Xteam_06_206 vssd1 vssd1 vccd1 vccd1 team_06_206/HI gpio_oeb[18] sky130_fd_sc_hd__conb_1
XANTENNA__1897__B1 _1851_/Y vssd1 vssd1 vccd1 vccd1 sky130_fd_sc_hd__diode_2
XTAP_TAPCELL_ROW_3_164 vssd1 vccd1 sky130_fd_sc_hd__tapvpwrvgnd_1
XANTENNA__1687__S _1693_/S vssd1 vssd1 vccd1 vccd1 sky130_fd_sc_hd__diode_2
XANTENNA__2372__A _2472_/B vssd1 vssd1 vccd1 vccd1 sky130_fd_sc_hd__diode_2
XFILLER_24_271 vssd1 vssd1 vccd1 vccd1 sky130_fd_sc_hd__fill_1
XFILLER_31_219 vssd1 vssd1 vccd1 vccd1 sky130_fd_sc_hd__fill_1
XTAP_TAPCELL_ROW_54_520 vssd1 vccd1 sky130_fd_sc_hd__tapvpwrvgnd_1
XANTENNA__1888__B1 _2642_/Q vssd1 vssd1 vccd1 vccd1 sky130_fd_sc_hd__diode_2
XANTENNA__2301__A1 _1351_/A vssd1 vssd1 vccd1 vccd1 sky130_fd_sc_hd__diode_2
XFILLER_47_330 vssd1 vssd1 vccd1 vccd1 sky130_fd_sc_hd__fill_1
X_1823_ _2873_/Q _1822_/A _1821_/X _1822_/Y _1382_/Y vssd1 vssd1 vccd1 vccd1 _1823_/X
+ sky130_fd_sc_hd__o311a_2
X_2872_ clkload2/A _2872_/D fanout92/X vssd1 vssd1 vccd1 vccd1 _2872_/Q sky130_fd_sc_hd__dfrtp_2
XANTENNA__1591__A2 _1585_/X vssd1 vssd1 vccd1 vccd1 sky130_fd_sc_hd__diode_2
X_1685_ hold303/X _2639_/Q _1691_/S vssd1 vssd1 vccd1 vccd1 _2584_/D sky130_fd_sc_hd__mux2_1
X_1754_ _1752_/Y _1753_/X _1744_/X _1747_/Y vssd1 vssd1 vccd1 vccd1 _1756_/C sky130_fd_sc_hd__a211o_2
Xhold404 _2758_/Q vssd1 vssd1 vccd1 vccd1 hold404/X sky130_fd_sc_hd__dlygate4sd3_1
Xhold415 _2153_/X vssd1 vssd1 vccd1 vccd1 _2711_/D sky130_fd_sc_hd__dlygate4sd3_1
Xhold426 _2755_/Q vssd1 vssd1 vccd1 vccd1 hold426/X sky130_fd_sc_hd__dlygate4sd3_1
Xhold437 _2691_/Q vssd1 vssd1 vccd1 vccd1 hold437/X sky130_fd_sc_hd__dlygate4sd3_1
Xhold448 _2765_/Q vssd1 vssd1 vccd1 vccd1 hold448/X sky130_fd_sc_hd__dlygate4sd3_1
Xhold459 _2749_/Q vssd1 vssd1 vccd1 vccd1 hold459/X sky130_fd_sc_hd__dlygate4sd3_1
XFILLER_38_363 vssd1 vssd1 vccd1 vccd1 sky130_fd_sc_hd__fill_1
X_2306_ _2300_/A1 _1331_/B _2299_/B hold386/X vssd1 vssd1 vccd1 vccd1 _2782_/D sky130_fd_sc_hd__a2bb2o_2
X_2237_ _2227_/Y _2232_/B _2229_/B vssd1 vssd1 vccd1 vccd1 _2238_/C sky130_fd_sc_hd__o21ai_2
XFILLER_38_385 vssd1 vssd1 vccd1 vccd1 sky130_fd_sc_hd__fill_1
XTAP_TAPCELL_ROW_0_134 vssd1 vccd1 sky130_fd_sc_hd__tapvpwrvgnd_1
X_2168_ hold324/X hold298/X _2168_/S vssd1 vssd1 vccd1 vccd1 _2724_/D sky130_fd_sc_hd__mux2_1
X_2099_ hold510/X _2098_/X _2125_/S vssd1 vssd1 vccd1 vccd1 _2676_/D sky130_fd_sc_hd__mux2_1
XPHY_EDGE_ROW_17_Right_17 vssd1 vssd1 vccd1 vccd1 sky130_fd_sc_hd__decap_3
XPHY_EDGE_ROW_26_Right_26 vssd1 vssd1 vccd1 vccd1 sky130_fd_sc_hd__decap_3
XANTENNA__2295__B1 _2297_/B1 vssd1 vssd1 vccd1 vccd1 sky130_fd_sc_hd__diode_2
XFILLER_28_52 vssd1 vssd1 vccd1 vccd1 sky130_fd_sc_hd__fill_4
XFILLER_44_355 vssd1 vssd1 vccd1 vccd1 sky130_fd_sc_hd__fill_1
XFILLER_56_193 vssd1 vssd1 vccd1 vccd1 sky130_fd_sc_hd__fill_2
XFILLER_12_241 vssd1 vssd1 vccd1 vccd1 sky130_fd_sc_hd__fill_8
XPHY_EDGE_ROW_35_Right_35 vssd1 vssd1 vccd1 vccd1 sky130_fd_sc_hd__decap_3
XTAP_TAPCELL_ROW_14_236 vssd1 vccd1 sky130_fd_sc_hd__tapvpwrvgnd_1
XTAP_TAPCELL_ROW_22_291 vssd1 vccd1 sky130_fd_sc_hd__tapvpwrvgnd_1
X_1470_ _2911_/Q _1413_/A _1280_/B vssd1 vssd1 vccd1 vccd1 _1470_/Y sky130_fd_sc_hd__o21ai_2
XPHY_EDGE_ROW_44_Right_44 vssd1 vssd1 vccd1 vccd1 sky130_fd_sc_hd__decap_3
XANTENNA__2286__B1 _2293_/B1 vssd1 vssd1 vccd1 vccd1 sky130_fd_sc_hd__diode_2
XFILLER_47_182 vssd1 vssd1 vccd1 vccd1 sky130_fd_sc_hd__fill_4
XFILLER_47_193 vssd1 vssd1 vccd1 vccd1 sky130_fd_sc_hd__fill_1
XFILLER_62_141 vssd1 vssd1 vccd1 vccd1 sky130_fd_sc_hd__fill_2
XPHY_EDGE_ROW_53_Right_53 vssd1 vssd1 vccd1 vccd1 sky130_fd_sc_hd__decap_3
X_2022_ _2050_/A1 _2024_/A _2024_/B _2069_/B1 vssd1 vssd1 vccd1 vccd1 _2022_/X sky130_fd_sc_hd__a31o_2
X_1806_ _2629_/Q _1811_/A2 _1804_/Y _1805_/X vssd1 vssd1 vccd1 vccd1 _2629_/D sky130_fd_sc_hd__o22a_2
X_2924_ _2924_/CLK _2924_/D vssd1 vssd1 vccd1 vccd1 _2924_/Q sky130_fd_sc_hd__dfxtp_2
X_2855_ clkload1/A _2855_/D vssd1 vssd1 vccd1 vccd1 _2855_/Q sky130_fd_sc_hd__dfxtp_2
X_2786_ _2870_/CLK _2786_/D load_slew123/X vssd1 vssd1 vccd1 vccd1 _2786_/Q sky130_fd_sc_hd__dfrtp_2
XPHY_EDGE_ROW_37_Left_102 vssd1 vssd1 vccd1 vccd1 sky130_fd_sc_hd__decap_3
XPHY_EDGE_ROW_62_Right_62 vssd1 vssd1 vccd1 vccd1 sky130_fd_sc_hd__decap_3
X_1599_ _2618_/Q _1586_/Y _1624_/S hold530/X _1598_/X vssd1 vssd1 vccd1 vccd1 _2539_/D
+ sky130_fd_sc_hd__o221a_2
X_1668_ hold312/X _2621_/Q _1695_/S vssd1 vssd1 vccd1 vccd1 _2567_/D sky130_fd_sc_hd__mux2_1
X_1737_ _2617_/Q _2556_/Q vssd1 vssd1 vccd1 vccd1 _1739_/C sky130_fd_sc_hd__nand2_2
Xhold278 _2579_/Q vssd1 vssd1 vccd1 vccd1 hold278/X sky130_fd_sc_hd__dlygate4sd3_1
Xhold289 _2586_/Q vssd1 vssd1 vccd1 vccd1 hold289/X sky130_fd_sc_hd__dlygate4sd3_1
Xhold267 _2615_/Q vssd1 vssd1 vccd1 vccd1 hold267/X sky130_fd_sc_hd__dlygate4sd3_1
Xhold256 _2523_/Q vssd1 vssd1 vccd1 vccd1 hold256/X sky130_fd_sc_hd__dlygate4sd3_1
Xhold245 _2602_/Q vssd1 vssd1 vccd1 vccd1 hold245/X sky130_fd_sc_hd__dlygate4sd3_1
XANTENNA__1362__Y _1362_/Y vssd1 vssd1 vccd1 vccd1 sky130_fd_sc_hd__diode_2
XTAP_TAPCELL_ROW_28_339 vssd1 vccd1 sky130_fd_sc_hd__tapvpwrvgnd_1
XFILLER_14_21 vssd1 vssd1 vccd1 vccd1 sky130_fd_sc_hd__fill_1
XPHY_EDGE_ROW_46_Left_111 vssd1 vssd1 vccd1 vccd1 sky130_fd_sc_hd__decap_3
XTAP_TAPCELL_ROW_11_217 vssd1 vccd1 sky130_fd_sc_hd__tapvpwrvgnd_1
XTAP_TAPCELL_ROW_36_394 vssd1 vccd1 sky130_fd_sc_hd__tapvpwrvgnd_1
XANTENNA_clkbuf_leaf_10_clk_A clkbuf_leaf_5_clk/A vssd1 vssd1 vccd1 vccd1 sky130_fd_sc_hd__diode_2
XPHY_EDGE_ROW_55_Left_120 vssd1 vssd1 vccd1 vccd1 sky130_fd_sc_hd__decap_3
XFILLER_64_406 vssd1 vssd1 vccd1 vccd1 sky130_fd_sc_hd__fill_1
XFILLER_32_303 vssd1 vssd1 vccd1 vccd1 sky130_fd_sc_hd__fill_4
XFILLER_44_141 vssd1 vssd1 vccd1 vccd1 sky130_fd_sc_hd__fill_4
X_2640_ _2642_/CLK _2640_/D fanout128/X vssd1 vssd1 vccd1 vccd1 _2640_/Q sky130_fd_sc_hd__dfrtp_2
X_1453_ _1477_/A1 _1451_/Y _1452_/X _1477_/B1 hold526/X vssd1 vssd1 vccd1 vccd1 _2907_/D
+ sky130_fd_sc_hd__a32o_2
X_1522_ _1522_/A _1539_/A vssd1 vssd1 vccd1 vccd1 _1522_/Y sky130_fd_sc_hd__nor2_2
X_2571_ clkload6/A _2571_/D vssd1 vssd1 vccd1 vccd1 _2571_/Q sky130_fd_sc_hd__dfxtp_2
X_1384_ _1384_/A _1384_/B vssd1 vssd1 vccd1 vccd1 _1590_/A sky130_fd_sc_hd__nor2_2
X_2005_ _1996_/A _2001_/X _2007_/C _2069_/B1 vssd1 vssd1 vccd1 vccd1 _2005_/X sky130_fd_sc_hd__a31o_2
XANTENNA_fanout145_A _1362_/Y vssd1 vssd1 vccd1 vccd1 sky130_fd_sc_hd__diode_2
X_2907_ _2912_/CLK _2907_/D fanout117/A vssd1 vssd1 vccd1 vccd1 _2907_/Q sky130_fd_sc_hd__dfrtp_2
XFILLER_31_391 vssd1 vssd1 vccd1 vccd1 sky130_fd_sc_hd__fill_1
X_2838_ _2845_/CLK _2838_/D load_slew83/X vssd1 vssd1 vccd1 vccd1 _2838_/Q sky130_fd_sc_hd__dfrtp_2
X_2769_ _2769_/CLK _2769_/D fanout143/X vssd1 vssd1 vccd1 vccd1 _2769_/Q sky130_fd_sc_hd__dfrtp_2
XFILLER_58_255 vssd1 vssd1 vccd1 vccd1 sky130_fd_sc_hd__fill_1
XFILLER_14_347 vssd1 vssd1 vccd1 vccd1 sky130_fd_sc_hd__fill_1
XTAP_TAPCELL_ROW_47_467 vssd1 vccd1 sky130_fd_sc_hd__tapvpwrvgnd_1
X_2623_ _2671_/CLK _2623_/D load_slew103/X vssd1 vssd1 vccd1 vccd1 _2623_/Q sky130_fd_sc_hd__dfrtp_2
X_2554_ _2924_/CLK _2554_/D load_slew112/X vssd1 vssd1 vccd1 vccd1 _2554_/Q sky130_fd_sc_hd__dfrtp_2
X_1367_ _2526_/Q _2525_/Q _2528_/Q _2527_/Q vssd1 vssd1 vccd1 vccd1 _1371_/A sky130_fd_sc_hd__or4_2
X_1436_ _2903_/Q _1436_/B vssd1 vssd1 vccd1 vccd1 _1436_/X sky130_fd_sc_hd__or2_2
X_1505_ _2843_/Q _2842_/Q _2845_/Q _2844_/Q vssd1 vssd1 vccd1 vccd1 _1505_/X sky130_fd_sc_hd__or4_2
X_2485_ _2850_/Q _2851_/Q _2486_/D _2852_/Q vssd1 vssd1 vccd1 vccd1 _2488_/B sky130_fd_sc_hd__a31o_2
XFILLER_23_111 vssd1 vssd1 vccd1 vccd1 sky130_fd_sc_hd__fill_1
XFILLER_55_225 vssd1 vssd1 vccd1 vccd1 sky130_fd_sc_hd__fill_1
X_1298_ _2793_/Q _2791_/Q _2790_/Q _2792_/Q vssd1 vssd1 vccd1 vccd1 _1321_/B sky130_fd_sc_hd__and4_2
XANTENNA_fanout148_X _2300_/A1 vssd1 vssd1 vccd1 vccd1 sky130_fd_sc_hd__diode_2
XANTENNA__2701__Q _2701_/Q vssd1 vssd1 vccd1 vccd1 sky130_fd_sc_hd__diode_2
XFILLER_11_55 vssd1 vssd1 vccd1 vccd1 sky130_fd_sc_hd__fill_1
XFILLER_11_77 vssd1 vssd1 vccd1 vccd1 sky130_fd_sc_hd__fill_2
XTAP_TAPCELL_ROW_44_448 vssd1 vccd1 sky130_fd_sc_hd__tapvpwrvgnd_1
XFILLER_6_365 vssd1 vssd1 vccd1 vccd1 sky130_fd_sc_hd__fill_1
X_2270_ _2270_/A _2270_/B _2270_/C vssd1 vssd1 vccd1 vccd1 _2270_/Y sky130_fd_sc_hd__nand3_2
XFILLER_37_225 vssd1 vssd1 vccd1 vccd1 sky130_fd_sc_hd__fill_4
X_1985_ _1985_/A _1985_/B vssd1 vssd1 vccd1 vccd1 _2066_/A sky130_fd_sc_hd__nor2_2
X_2606_ _2647_/CLK _2606_/D vssd1 vssd1 vccd1 vccd1 _2606_/Q sky130_fd_sc_hd__dfxtp_2
X_2537_ _2663_/CLK _2537_/D fanout100/X vssd1 vssd1 vccd1 vccd1 _2537_/Q sky130_fd_sc_hd__dfrtp_2
XFILLER_28_214 vssd1 vssd1 vccd1 vccd1 sky130_fd_sc_hd__fill_4
X_1419_ _2898_/Q _2897_/Q vssd1 vssd1 vccd1 vccd1 _1419_/X sky130_fd_sc_hd__or2_2
X_2468_ _2462_/B _2465_/B _2845_/Q vssd1 vssd1 vccd1 vccd1 _2468_/X sky130_fd_sc_hd__o21ba_2
X_2399_ _2399_/A _2399_/B vssd1 vssd1 vccd1 vccd1 _2824_/D sky130_fd_sc_hd__nor2_2
XTAP_TAPCELL_ROW_41_429 vssd1 vccd1 sky130_fd_sc_hd__tapvpwrvgnd_1
XANTENNA__2134__S _2134_/S vssd1 vssd1 vccd1 vccd1 sky130_fd_sc_hd__diode_2
XFILLER_11_169 vssd1 vssd1 vccd1 vccd1 sky130_fd_sc_hd__fill_4
XFILLER_51_283 vssd1 vssd1 vccd1 vccd1 sky130_fd_sc_hd__fill_1
XFILLER_0_3 vssd1 vssd1 vccd1 vccd1 sky130_fd_sc_hd__fill_2
XTAP_TAPCELL_ROW_57_540 vssd1 vccd1 sky130_fd_sc_hd__tapvpwrvgnd_1
XTAP_TAPCELL_ROW_6_184 vssd1 vccd1 sky130_fd_sc_hd__tapvpwrvgnd_1
Xfanout182 _2868_/Q vssd1 vssd1 vccd1 vccd1 _1351_/A sky130_fd_sc_hd__clkdlybuf4s25_1
Xfanout171 _1734_/A vssd1 vssd1 vccd1 vccd1 _1384_/A sky130_fd_sc_hd__clkdlybuf4s25_1
Xfanout160 _1863_/C vssd1 vssd1 vccd1 vccd1 _1900_/C sky130_fd_sc_hd__clkdlybuf4s25_1
XFILLER_8_67 vssd1 vssd1 vccd1 vccd1 sky130_fd_sc_hd__fill_2
X_1770_ _1783_/D _1770_/B _1770_/C vssd1 vssd1 vccd1 vccd1 _1770_/X sky130_fd_sc_hd__and3b_2
XANTENNA__1658__A1 _2558_/Q vssd1 vssd1 vccd1 vccd1 sky130_fd_sc_hd__diode_2
XANTENNA__1912__A _1944_/A vssd1 vssd1 vccd1 vccd1 sky130_fd_sc_hd__diode_2
X_2322_ _2323_/A1 hold405/X _2323_/B1 _2798_/Q vssd1 vssd1 vccd1 vccd1 _2798_/D sky130_fd_sc_hd__a22o_2
X_2253_ _2155_/A _2251_/Y _2252_/X hold391/X _2260_/A2 vssd1 vssd1 vccd1 vccd1 _2754_/D
+ sky130_fd_sc_hd__a32o_2
X_2184_ hold368/X hold290/X _2186_/S vssd1 vssd1 vccd1 vccd1 _2740_/D sky130_fd_sc_hd__mux2_1
X_1899_ _2645_/Q _1899_/B vssd1 vssd1 vccd1 vccd1 _1900_/B sky130_fd_sc_hd__or2_2
X_1968_ _1961_/Y _1967_/A _1967_/B _1997_/B vssd1 vssd1 vccd1 vccd1 _2003_/A sky130_fd_sc_hd__o31a_2
XANTENNA__1897__A1 _2708_/Q vssd1 vssd1 vccd1 vccd1 sky130_fd_sc_hd__diode_2
XFILLER_0_305 vssd1 vssd1 vccd1 vccd1 sky130_fd_sc_hd__fill_2
Xteam_06_229 vssd1 vssd1 vccd1 vccd1 gpio_oeb[2] team_06_229/LO sky130_fd_sc_hd__conb_1
Xteam_06_218 vssd1 vssd1 vccd1 vccd1 team_06_218/HI gpio_out[1] sky130_fd_sc_hd__conb_1
Xteam_06_207 vssd1 vssd1 vccd1 vccd1 team_06_207/HI gpio_oeb[19] sky130_fd_sc_hd__conb_1
XTAP_TAPCELL_ROW_54_521 vssd1 vccd1 sky130_fd_sc_hd__tapvpwrvgnd_1
XFILLER_24_250 vssd1 vssd1 vccd1 vccd1 sky130_fd_sc_hd__fill_2
XANTENNA__1888__A1 _2641_/Q vssd1 vssd1 vccd1 vccd1 sky130_fd_sc_hd__diode_2
XFILLER_47_364 vssd1 vssd1 vccd1 vccd1 sky130_fd_sc_hd__fill_1
XTAP_TAPCELL_ROW_17_256 vssd1 vccd1 sky130_fd_sc_hd__tapvpwrvgnd_1
XPHY_EDGE_ROW_29_Left_94 vssd1 vssd1 vccd1 vccd1 sky130_fd_sc_hd__decap_3
XTAP_TAPCELL_ROW_60_557 vssd1 vccd1 sky130_fd_sc_hd__tapvpwrvgnd_1
X_1753_ _2619_/Q _2558_/Q vssd1 vssd1 vccd1 vccd1 _1753_/X sky130_fd_sc_hd__or2_2
X_1822_ _1822_/A _1822_/B vssd1 vssd1 vccd1 vccd1 _1822_/Y sky130_fd_sc_hd__nand2_2
X_2871_ _2924_/CLK _2871_/D _1662_/C vssd1 vssd1 vccd1 vccd1 _2871_/Q sky130_fd_sc_hd__dfstp_2
XANTENNA__1879__A1 _2703_/Q vssd1 vssd1 vccd1 vccd1 sky130_fd_sc_hd__diode_2
X_1684_ hold307/X _2638_/Q _1686_/S vssd1 vssd1 vccd1 vccd1 _2583_/D sky130_fd_sc_hd__mux2_1
Xhold405 _2783_/Q vssd1 vssd1 vccd1 vccd1 hold405/X sky130_fd_sc_hd__dlygate4sd3_1
Xhold416 _2742_/Q vssd1 vssd1 vccd1 vccd1 hold416/X sky130_fd_sc_hd__dlygate4sd3_1
Xhold427 _2753_/Q vssd1 vssd1 vccd1 vccd1 hold427/X sky130_fd_sc_hd__dlygate4sd3_1
Xhold438 _2653_/Q vssd1 vssd1 vccd1 vccd1 hold438/X sky130_fd_sc_hd__dlygate4sd3_1
Xhold449 _2833_/Q vssd1 vssd1 vccd1 vccd1 _2424_/A sky130_fd_sc_hd__dlygate4sd3_1
XANTENNA_fanout175_A _2870_/Q vssd1 vssd1 vccd1 vccd1 sky130_fd_sc_hd__diode_2
XPHY_EDGE_ROW_13_Left_78 vssd1 vssd1 vccd1 vccd1 sky130_fd_sc_hd__decap_3
XTAP_TAPCELL_ROW_0_135 vssd1 vccd1 sky130_fd_sc_hd__tapvpwrvgnd_1
X_2305_ _2300_/A1 _1328_/X _2299_/B hold384/X vssd1 vssd1 vccd1 vccd1 _2781_/D sky130_fd_sc_hd__a2bb2o_2
X_2236_ _2767_/Q _2721_/Q vssd1 vssd1 vccd1 vccd1 _2238_/B sky130_fd_sc_hd__nand2_2
X_2167_ hold301/X hold253/X _2168_/S vssd1 vssd1 vccd1 vccd1 _2723_/D sky130_fd_sc_hd__mux2_1
XFILLER_21_253 vssd1 vssd1 vccd1 vccd1 sky130_fd_sc_hd__fill_1
XFILLER_53_356 vssd1 vssd1 vccd1 vccd1 sky130_fd_sc_hd__fill_1
X_2098_ _2589_/Q _2573_/Q _2130_/S vssd1 vssd1 vccd1 vccd1 _2098_/X sky130_fd_sc_hd__mux2_1
XANTENNA__1552__A _1582_/A vssd1 vssd1 vccd1 vccd1 sky130_fd_sc_hd__diode_2
XANTENNA_fanout88_A fanout99/A vssd1 vssd1 vccd1 vccd1 sky130_fd_sc_hd__diode_2
XFILLER_28_31 vssd1 vssd1 vccd1 vccd1 sky130_fd_sc_hd__fill_1
XFILLER_12_231 vssd1 vssd1 vccd1 vccd1 sky130_fd_sc_hd__fill_1
XFILLER_12_253 vssd1 vssd1 vccd1 vccd1 sky130_fd_sc_hd__fill_8
XFILLER_12_286 vssd1 vssd1 vccd1 vccd1 sky130_fd_sc_hd__fill_1
XFILLER_8_257 vssd1 vssd1 vccd1 vccd1 sky130_fd_sc_hd__fill_2
XTAP_TAPCELL_ROW_14_237 vssd1 vccd1 sky130_fd_sc_hd__tapvpwrvgnd_1
XTAP_TAPCELL_ROW_22_292 vssd1 vccd1 sky130_fd_sc_hd__tapvpwrvgnd_1
XFILLER_5_57 vssd1 vccd1 vssd1 vccd1 sky130_ef_sc_hd__decap_40_12
XANTENNA__2286__A1 _1366_/A vssd1 vssd1 vccd1 vccd1 sky130_fd_sc_hd__diode_2
X_2021_ _2050_/A1 _2024_/A _2024_/B vssd1 vssd1 vccd1 vccd1 _2021_/Y sky130_fd_sc_hd__a21oi_2
X_2923_ _2923_/CLK _2923_/D _2335_/B1 vssd1 vssd1 vccd1 vccd1 _2923_/Q sky130_fd_sc_hd__dfstp_2
X_1736_ _2616_/Q _1814_/B2 _1733_/X _1735_/X vssd1 vssd1 vccd1 vccd1 _2616_/D sky130_fd_sc_hd__o22a_2
X_1805_ _1810_/A1 _2661_/Q _1810_/B1 _2710_/Q _1810_/C1 vssd1 vssd1 vccd1 vccd1 _1805_/X
+ sky130_fd_sc_hd__a221o_2
X_2854_ clkload1/A _2854_/D vssd1 vssd1 vccd1 vccd1 _2854_/Q sky130_fd_sc_hd__dfxtp_2
X_2785_ _2801_/CLK _2785_/D load_slew123/X vssd1 vssd1 vccd1 vccd1 _2785_/Q sky130_fd_sc_hd__dfrtp_2
X_1598_ _2635_/Q _1702_/S _1586_/B _1597_/X vssd1 vssd1 vccd1 vccd1 _1598_/X sky130_fd_sc_hd__a211o_2
X_1667_ hold350/X _2620_/Q _1695_/S vssd1 vssd1 vccd1 vccd1 _1667_/X sky130_fd_sc_hd__mux2_1
Xhold279 _2715_/Q vssd1 vssd1 vccd1 vccd1 hold279/X sky130_fd_sc_hd__dlygate4sd3_1
Xhold268 _1729_/X vssd1 vssd1 vccd1 vccd1 _2615_/D sky130_fd_sc_hd__dlygate4sd3_1
Xhold257 _2726_/Q vssd1 vssd1 vccd1 vccd1 hold257/X sky130_fd_sc_hd__dlygate4sd3_1
Xhold246 _2600_/Q vssd1 vssd1 vccd1 vccd1 hold246/X sky130_fd_sc_hd__dlygate4sd3_1
X_2219_ _2765_/Q _2719_/Q vssd1 vssd1 vccd1 vccd1 _2222_/A sky130_fd_sc_hd__or2_2
XTAP_TAPCELL_ROW_11_218 vssd1 vccd1 sky130_fd_sc_hd__tapvpwrvgnd_1
XTAP_TAPCELL_ROW_36_395 vssd1 vccd1 sky130_fd_sc_hd__tapvpwrvgnd_1
XANTENNA__1547__A _2472_/A vssd1 vssd1 vccd1 vccd1 sky130_fd_sc_hd__diode_2
XANTENNA__2142__S _2153_/S vssd1 vssd1 vccd1 vccd1 sky130_fd_sc_hd__diode_2
XANTENNA__2617__RESET_B fanout105/X vssd1 vssd1 vccd1 vccd1 sky130_fd_sc_hd__diode_2
X_2570_ _2671_/CLK _2570_/D vssd1 vssd1 vccd1 vccd1 _2570_/Q sky130_fd_sc_hd__dfxtp_2
XFILLER_4_271 vssd1 vssd1 vccd1 vccd1 sky130_fd_sc_hd__fill_2
X_1383_ _2805_/Q _1263_/Y _1822_/A _2873_/Q _1382_/B vssd1 vssd1 vccd1 vccd1 _2873_/D
+ sky130_fd_sc_hd__a32o_2
X_1452_ _2907_/Q _1454_/C vssd1 vssd1 vccd1 vccd1 _1452_/X sky130_fd_sc_hd__or2_2
X_1521_ _2823_/Q _2825_/Q _2824_/Q vssd1 vssd1 vccd1 vccd1 _2400_/B sky130_fd_sc_hd__and3_2
X_2004_ _1996_/A _2001_/X _2007_/C vssd1 vssd1 vccd1 vccd1 _2004_/Y sky130_fd_sc_hd__a21oi_2
XANTENNA__2470__B _2969_/A vssd1 vssd1 vccd1 vccd1 sky130_fd_sc_hd__diode_2
XANTENNA_fanout138_A fanout144/X vssd1 vssd1 vccd1 vccd1 sky130_fd_sc_hd__diode_2
XFILLER_35_175 vssd1 vssd1 vccd1 vccd1 sky130_fd_sc_hd__fill_2
XFILLER_50_145 vssd1 vssd1 vccd1 vccd1 sky130_fd_sc_hd__fill_1
X_2906_ _2912_/CLK _2906_/D load_slew116/X vssd1 vssd1 vccd1 vccd1 _2906_/Q sky130_fd_sc_hd__dfrtp_2
X_1719_ hold242/X _1718_/X _1721_/S vssd1 vssd1 vccd1 vccd1 _2608_/D sky130_fd_sc_hd__mux2_1
X_2837_ _2845_/CLK _2837_/D load_slew81/X vssd1 vssd1 vccd1 vccd1 _2837_/Q sky130_fd_sc_hd__dfrtp_2
X_2768_ _2768_/CLK _2768_/D load_slew142/X vssd1 vssd1 vccd1 vccd1 _2768_/Q sky130_fd_sc_hd__dfrtp_2
X_2699_ _2804_/CLK _2699_/D load_slew136/X vssd1 vssd1 vccd1 vccd1 _2699_/Q sky130_fd_sc_hd__dfrtp_2
XPHY_EDGE_ROW_16_Left_81 vssd1 vssd1 vccd1 vccd1 sky130_fd_sc_hd__decap_3
XFILLER_26_197 vssd1 vssd1 vccd1 vccd1 sky130_fd_sc_hd__fill_2
XTAP_TAPCELL_ROW_24_310 vssd1 vccd1 sky130_fd_sc_hd__tapvpwrvgnd_1
XFILLER_41_167 vssd1 vssd1 vccd1 vccd1 sky130_fd_sc_hd__fill_1
XFILLER_49_223 vssd1 vssd1 vccd1 vccd1 sky130_fd_sc_hd__fill_1
XANTENNA_clkbuf_3_1__f_clk_X clkbuf_leaf_4_clk/A vssd1 vssd1 vccd1 vccd1 sky130_fd_sc_hd__diode_2
XTAP_TAPCELL_ROW_47_468 vssd1 vccd1 sky130_fd_sc_hd__tapvpwrvgnd_1
XANTENNA__1915__A _1944_/A vssd1 vssd1 vccd1 vccd1 sky130_fd_sc_hd__diode_2
X_1504_ _2841_/Q _2840_/Q _1504_/C vssd1 vssd1 vccd1 vccd1 _1504_/X sky130_fd_sc_hd__and3_2
X_2622_ clkload7/A _2622_/D load_slew127/X vssd1 vssd1 vccd1 vccd1 _2622_/Q sky130_fd_sc_hd__dfrtp_2
X_2553_ _2880_/CLK _2553_/D _1662_/C vssd1 vssd1 vccd1 vccd1 _2970_/A sky130_fd_sc_hd__dfrtp_2
X_1366_ _1366_/A _2168_/S vssd1 vssd1 vccd1 vccd1 _1366_/Y sky130_fd_sc_hd__nor2_2
X_1435_ _1450_/A1 _1432_/X _1434_/Y _1450_/B1 hold488/X vssd1 vssd1 vccd1 vccd1 _2902_/D
+ sky130_fd_sc_hd__a32o_2
X_2484_ _2484_/A _2484_/B vssd1 vssd1 vccd1 vccd1 _2484_/Y sky130_fd_sc_hd__xnor2_2
X_1297_ _2791_/Q _2790_/Q _2792_/Q vssd1 vssd1 vccd1 vccd1 _1319_/B sky130_fd_sc_hd__and3_2
XANTENNA__1809__B _2874_/Q vssd1 vssd1 vccd1 vccd1 sky130_fd_sc_hd__diode_2
XANTENNA_clkbuf_leaf_24_clk_A clkbuf_3_4__f_clk/X vssd1 vssd1 vccd1 vccd1 sky130_fd_sc_hd__diode_2
XFILLER_23_167 vssd1 vssd1 vccd1 vccd1 sky130_fd_sc_hd__fill_1
XANTENNA__1825__A _2635_/Q vssd1 vssd1 vccd1 vccd1 sky130_fd_sc_hd__diode_2
XANTENNA__1560__A _1582_/A vssd1 vssd1 vccd1 vccd1 sky130_fd_sc_hd__diode_2
XFILLER_52_85 vssd1 vssd1 vccd1 vccd1 sky130_fd_sc_hd__fill_2
XPHY_EDGE_ROW_1_Left_66 vssd1 vssd1 vccd1 vccd1 sky130_fd_sc_hd__decap_3
XTAP_TAPCELL_ROW_44_449 vssd1 vccd1 sky130_fd_sc_hd__tapvpwrvgnd_1
XANTENNA__1906__B1 _2647_/Q vssd1 vssd1 vccd1 vccd1 sky130_fd_sc_hd__diode_2
XFILLER_52_96 vssd1 vssd1 vccd1 vccd1 sky130_fd_sc_hd__fill_1
X_1984_ _1921_/Y _1982_/A _1982_/B _2053_/B _2060_/B vssd1 vssd1 vccd1 vccd1 _1985_/B
+ sky130_fd_sc_hd__o311a_2
X_2605_ _2774_/CLK _2605_/D vssd1 vssd1 vccd1 vccd1 _2605_/Q sky130_fd_sc_hd__dfxtp_2
X_2536_ clkload8/A _2536_/D vssd1 vssd1 vccd1 vccd1 _2536_/Q sky130_fd_sc_hd__dfxtp_2
X_2467_ hold534/X _2464_/B _2466_/X vssd1 vssd1 vccd1 vccd1 _2844_/D sky130_fd_sc_hd__o21a_2
X_1349_ _2743_/Q _1306_/X _1347_/Y _2742_/Q vssd1 vssd1 vccd1 vccd1 _1349_/X sky130_fd_sc_hd__o22a_2
X_1418_ _1477_/A1 _1477_/B1 _2897_/Q vssd1 vssd1 vccd1 vccd1 _2897_/D sky130_fd_sc_hd__mux2_1
X_2398_ _2823_/Q _2824_/Q _2398_/C vssd1 vssd1 vccd1 vccd1 _2399_/B sky130_fd_sc_hd__and3_2
XFILLER_11_115 vssd1 vssd1 vccd1 vccd1 sky130_fd_sc_hd__fill_1
XFILLER_43_229 vssd1 vssd1 vccd1 vccd1 sky130_fd_sc_hd__fill_4
XANTENNA__2150__S _2154_/S vssd1 vssd1 vccd1 vccd1 sky130_fd_sc_hd__diode_2
XTAP_TAPCELL_ROW_6_185 vssd1 vccd1 sky130_fd_sc_hd__tapvpwrvgnd_1
Xfanout183 _2154_/S vssd1 vssd1 vccd1 vccd1 _2153_/S sky130_fd_sc_hd__clkdlybuf4s25_1
Xfanout172 _2872_/Q vssd1 vssd1 vccd1 vccd1 _1734_/A sky130_fd_sc_hd__clkdlybuf4s25_1
Xfanout161 _2878_/Q vssd1 vssd1 vccd1 vccd1 _1863_/C sky130_fd_sc_hd__clkdlybuf4s25_1
Xfanout150 _2882_/D vssd1 vssd1 vccd1 vccd1 _2136_/B sky130_fd_sc_hd__clkdlybuf4s25_1
XFILLER_19_215 vssd1 vssd1 vccd1 vccd1 sky130_fd_sc_hd__fill_4
XFILLER_27_270 vssd1 vssd1 vccd1 vccd1 sky130_fd_sc_hd__fill_1
XFILLER_47_52 vssd1 vssd1 vccd1 vccd1 sky130_fd_sc_hd__fill_4
XTAP_TAPCELL_ROW_57_541 vssd1 vccd1 sky130_fd_sc_hd__tapvpwrvgnd_1
XFILLER_42_251 vssd1 vssd1 vccd1 vccd1 sky130_fd_sc_hd__fill_1
XFILLER_8_57 vssd1 vssd1 vccd1 vccd1 sky130_fd_sc_hd__fill_1
XFILLER_6_141 vssd1 vssd1 vccd1 vccd1 sky130_fd_sc_hd__fill_4
X_2321_ _2323_/A1 hold386/X _2323_/B1 _2797_/Q vssd1 vssd1 vccd1 vccd1 _2797_/D sky130_fd_sc_hd__a22o_2
X_2252_ _2251_/A _2251_/B _2251_/C vssd1 vssd1 vccd1 vccd1 _2252_/X sky130_fd_sc_hd__a21o_2
X_2183_ hold370/X hold313/X _2186_/S vssd1 vssd1 vccd1 vccd1 _2739_/D sky130_fd_sc_hd__mux2_1
XFILLER_25_229 vssd1 vssd1 vccd1 vccd1 sky130_fd_sc_hd__fill_2
XFILLER_33_251 vssd1 vssd1 vccd1 vccd1 sky130_fd_sc_hd__fill_1
XANTENNA__1594__B2 _1589_/X vssd1 vssd1 vccd1 vccd1 sky130_fd_sc_hd__diode_2
X_1898_ _2644_/Q _1909_/S _1896_/X _1897_/X vssd1 vssd1 vccd1 vccd1 _2644_/D sky130_fd_sc_hd__o22a_2
X_1967_ _1967_/A _1967_/B vssd1 vssd1 vccd1 vccd1 _1998_/A sky130_fd_sc_hd__nor2_2
XANTENNA__1662__X _1662_/X vssd1 vssd1 vccd1 vccd1 sky130_fd_sc_hd__diode_2
Xteam_06_219 vssd1 vssd1 vccd1 vccd1 team_06_219/HI gpio_out[2] sky130_fd_sc_hd__conb_1
Xteam_06_208 vssd1 vssd1 vccd1 vccd1 team_06_208/HI gpio_oeb[20] sky130_fd_sc_hd__conb_1
X_2519_ _2519_/A _2519_/B vssd1 vssd1 vccd1 vccd1 _2519_/Y sky130_fd_sc_hd__xnor2_2
XANTENNA__2707__Q _2707_/Q vssd1 vssd1 vccd1 vccd1 sky130_fd_sc_hd__diode_2
XFILLER_17_55 vssd1 vssd1 vccd1 vccd1 sky130_fd_sc_hd__fill_1
XANTENNA__2145__S _2153_/S vssd1 vssd1 vccd1 vccd1 sky130_fd_sc_hd__diode_2
XANTENNA__1285__A _2969_/A vssd1 vssd1 vccd1 vccd1 sky130_fd_sc_hd__diode_2
XFILLER_3_144 vssd1 vssd1 vccd1 vccd1 sky130_fd_sc_hd__fill_1
XANTENNA__1888__A2 _2640_/Q vssd1 vssd1 vccd1 vccd1 sky130_fd_sc_hd__diode_2
XFILLER_58_73 vssd1 vssd1 vccd1 vccd1 sky130_fd_sc_hd__fill_4
XTAP_TAPCELL_ROW_17_257 vssd1 vccd1 sky130_fd_sc_hd__tapvpwrvgnd_1
X_2870_ _2870_/CLK _2870_/D fanout124/X vssd1 vssd1 vccd1 vccd1 _2870_/Q sky130_fd_sc_hd__dfrtp_2
XTAP_TAPCELL_ROW_60_558 vssd1 vccd1 sky130_fd_sc_hd__tapvpwrvgnd_1
X_1683_ hold295/X _2637_/Q _1686_/S vssd1 vssd1 vccd1 vccd1 _2582_/D sky130_fd_sc_hd__mux2_1
X_1752_ _2619_/Q _2558_/Q vssd1 vssd1 vccd1 vccd1 _1752_/Y sky130_fd_sc_hd__nand2_2
X_1821_ _1863_/C _1821_/B vssd1 vssd1 vccd1 vccd1 _1821_/X sky130_fd_sc_hd__or2_2
Xhold406 _2547_/Q vssd1 vssd1 vccd1 vccd1 hold406/X sky130_fd_sc_hd__dlygate4sd3_1
Xhold417 _2767_/Q vssd1 vssd1 vccd1 vccd1 hold417/X sky130_fd_sc_hd__dlygate4sd3_1
Xclkbuf_leaf_10_clk clkbuf_leaf_5_clk/A vssd1 vssd1 vccd1 vccd1 clkload6/A sky130_fd_sc_hd__clkbuf_8
Xhold428 _2704_/Q vssd1 vssd1 vccd1 vccd1 hold428/X sky130_fd_sc_hd__dlygate4sd3_1
Xhold439 _2751_/Q vssd1 vssd1 vccd1 vccd1 hold439/X sky130_fd_sc_hd__dlygate4sd3_1
X_2304_ _1351_/A _1325_/B _2299_/B hold361/X vssd1 vssd1 vccd1 vccd1 _2780_/D sky130_fd_sc_hd__a22o_2
XANTENNA_fanout168_A _2874_/Q vssd1 vssd1 vccd1 vccd1 sky130_fd_sc_hd__diode_2
XTAP_TAPCELL_ROW_0_136 vssd1 vccd1 sky130_fd_sc_hd__tapvpwrvgnd_1
X_2235_ _2238_/A vssd1 vssd1 vccd1 vccd1 _2245_/A sky130_fd_sc_hd__inv_2
X_2166_ hold262/X hold247/X _2168_/S vssd1 vssd1 vccd1 vccd1 _2722_/D sky130_fd_sc_hd__mux2_1
X_2097_ hold494/X _2096_/X _2125_/S vssd1 vssd1 vccd1 vccd1 _2675_/D sky130_fd_sc_hd__mux2_1
XPHY_EDGE_ROW_3_Right_3 vssd1 vssd1 vccd1 vccd1 sky130_fd_sc_hd__decap_3
XFILLER_0_169 vssd1 vssd1 vccd1 vccd1 sky130_fd_sc_hd__fill_4
XFILLER_48_107 vssd1 vssd1 vccd1 vccd1 sky130_fd_sc_hd__fill_1
XFILLER_29_365 vssd1 vssd1 vccd1 vccd1 sky130_fd_sc_hd__fill_2
XFILLER_44_64 vssd1 vssd1 vccd1 vccd1 sky130_fd_sc_hd__fill_2
XFILLER_56_195 vssd1 vssd1 vccd1 vccd1 sky130_fd_sc_hd__fill_1
XFILLER_60_85 vssd1 vssd1 vccd1 vccd1 sky130_fd_sc_hd__fill_1
XPHY_EDGE_ROW_30_Left_95 vssd1 vssd1 vccd1 vccd1 sky130_fd_sc_hd__decap_3
XTAP_TAPCELL_ROW_14_238 vssd1 vccd1 sky130_fd_sc_hd__tapvpwrvgnd_1
XTAP_TAPCELL_ROW_22_293 vssd1 vccd1 sky130_fd_sc_hd__tapvpwrvgnd_1
XFILLER_5_69 vssd1 vssd1 vccd1 vccd1 sky130_fd_sc_hd__fill_4
X_2020_ _2020_/A _2020_/B vssd1 vssd1 vccd1 vccd1 _2024_/B sky130_fd_sc_hd__xnor2_2
XFILLER_62_143 vssd1 vssd1 vccd1 vccd1 sky130_fd_sc_hd__fill_1
X_2922_ _2923_/CLK _2922_/D _2331_/B vssd1 vssd1 vccd1 vccd1 _2922_/Q sky130_fd_sc_hd__dfstp_2
X_2853_ clkload1/A _2853_/D vssd1 vssd1 vccd1 vccd1 _2853_/Q sky130_fd_sc_hd__dfxtp_2
X_1666_ hold340/X _2619_/Q _1695_/S vssd1 vssd1 vccd1 vccd1 _2565_/D sky130_fd_sc_hd__mux2_1
X_1735_ _2697_/Q _1786_/B1 _1587_/X vssd1 vssd1 vccd1 vccd1 _1735_/X sky130_fd_sc_hd__a21o_2
X_1804_ _2629_/Q _1808_/C _1803_/Y vssd1 vssd1 vccd1 vccd1 _1804_/Y sky130_fd_sc_hd__a21oi_2
Xhold269 _2587_/Q vssd1 vssd1 vccd1 vccd1 hold269/X sky130_fd_sc_hd__dlygate4sd3_1
Xhold258 _2614_/Q vssd1 vssd1 vccd1 vccd1 hold258/X sky130_fd_sc_hd__dlygate4sd3_1
Xhold247 _2604_/Q vssd1 vssd1 vccd1 vccd1 hold247/X sky130_fd_sc_hd__dlygate4sd3_1
Xhold236 _2889_/Q vssd1 vssd1 vccd1 vccd1 _2920_/D sky130_fd_sc_hd__dlygate4sd3_1
X_2784_ _2801_/CLK _2784_/D load_slew123/X vssd1 vssd1 vccd1 vccd1 _2784_/Q sky130_fd_sc_hd__dfrtp_2
X_1597_ _1385_/B _2699_/Q _2650_/Q _1734_/A vssd1 vssd1 vccd1 vccd1 _1597_/X sky130_fd_sc_hd__a22o_2
XFILLER_53_187 vssd1 vssd1 vccd1 vccd1 sky130_fd_sc_hd__fill_1
X_2218_ hold459/X _2260_/A2 _2217_/Y _2155_/A vssd1 vssd1 vccd1 vccd1 _2749_/D sky130_fd_sc_hd__a22o_2
X_2149_ _2707_/Q hold426/X _2153_/S vssd1 vssd1 vccd1 vccd1 _2707_/D sky130_fd_sc_hd__mux2_1
XANTENNA__1828__A _2634_/Q vssd1 vssd1 vccd1 vccd1 sky130_fd_sc_hd__diode_2
XFILLER_14_34 vssd1 vssd1 vccd1 vccd1 sky130_fd_sc_hd__fill_1
XTAP_TAPCELL_ROW_11_219 vssd1 vccd1 sky130_fd_sc_hd__tapvpwrvgnd_1
XANTENNA__1712__A1 _2642_/Q vssd1 vssd1 vccd1 vccd1 sky130_fd_sc_hd__diode_2
XFILLER_55_52 vssd1 vssd1 vccd1 vccd1 sky130_fd_sc_hd__fill_2
XTAP_TAPCELL_ROW_27_330 vssd1 vccd1 sky130_fd_sc_hd__tapvpwrvgnd_1
X_1520_ _1495_/B _1517_/C _1519_/X _1538_/A vssd1 vssd1 vccd1 vccd1 _2389_/D sky130_fd_sc_hd__a2bb2o_2
X_1382_ _2873_/Q _1382_/B vssd1 vssd1 vccd1 vccd1 _1382_/Y sky130_fd_sc_hd__nand2_2
X_1451_ _2907_/Q _1454_/C vssd1 vssd1 vccd1 vccd1 _1451_/Y sky130_fd_sc_hd__nand2_2
XFILLER_35_187 vssd1 vssd1 vccd1 vccd1 sky130_fd_sc_hd__fill_4
X_2003_ _2003_/A _2003_/B vssd1 vssd1 vccd1 vccd1 _2007_/C sky130_fd_sc_hd__xor2_2
XANTENNA__1648__A _1662_/D vssd1 vssd1 vccd1 vccd1 sky130_fd_sc_hd__diode_2
X_2905_ _2912_/CLK _2905_/D load_slew116/X vssd1 vssd1 vccd1 vccd1 _2905_/Q sky130_fd_sc_hd__dfrtp_2
X_2836_ _2845_/CLK _2836_/D load_slew81/X vssd1 vssd1 vccd1 vccd1 _2836_/Q sky130_fd_sc_hd__dfrtp_2
X_1649_ _1821_/B hold443/X _1649_/S vssd1 vssd1 vccd1 vccd1 _2553_/D sky130_fd_sc_hd__mux2_1
X_1718_ _2628_/Q _2645_/Q _1722_/S vssd1 vssd1 vccd1 vccd1 _1718_/X sky130_fd_sc_hd__mux2_1
X_2767_ _2769_/CLK _2767_/D fanout138/X vssd1 vssd1 vccd1 vccd1 _2767_/Q sky130_fd_sc_hd__dfrtp_2
X_2698_ _2804_/CLK _2698_/D fanout133/X vssd1 vssd1 vccd1 vccd1 _2698_/Q sky130_fd_sc_hd__dfrtp_2
XANTENNA__1830__B _2555_/Q vssd1 vssd1 vccd1 vccd1 sky130_fd_sc_hd__diode_2
XANTENNA_input5_A gpio_in[3] vssd1 vssd1 vccd1 vccd1 sky130_fd_sc_hd__diode_2
XFILLER_41_113 vssd1 vssd1 vccd1 vccd1 sky130_fd_sc_hd__fill_2
XTAP_TAPCELL_ROW_24_311 vssd1 vccd1 sky130_fd_sc_hd__tapvpwrvgnd_1
XANTENNA__1558__A _2636_/Q vssd1 vssd1 vccd1 vccd1 sky130_fd_sc_hd__diode_2
XANTENNA__2153__S _2153_/S vssd1 vssd1 vccd1 vccd1 sky130_fd_sc_hd__diode_2
XFILLER_41_65 vssd1 vssd1 vccd1 vccd1 sky130_fd_sc_hd__fill_1
XFILLER_2_37 vssd1 vssd1 vccd1 vccd1 sky130_fd_sc_hd__fill_4
XFILLER_2_48 vssd1 vssd1 vccd1 vccd1 sky130_fd_sc_hd__fill_2
XTAP_TAPCELL_ROW_47_469 vssd1 vccd1 sky130_fd_sc_hd__tapvpwrvgnd_1
XANTENNA__1621__B1 _1624_/S vssd1 vssd1 vccd1 vccd1 sky130_fd_sc_hd__diode_2
XANTENNA__2063__S _2882_/Q vssd1 vssd1 vccd1 vccd1 sky130_fd_sc_hd__diode_2
XTAP_TAPCELL_ROW_30_347 vssd1 vccd1 sky130_fd_sc_hd__tapvpwrvgnd_1
X_1503_ _2843_/Q _2842_/Q _2845_/Q _2844_/Q vssd1 vssd1 vccd1 vccd1 _1504_/C sky130_fd_sc_hd__and4_2
X_2621_ _2663_/CLK _2621_/D load_slew101/X vssd1 vssd1 vccd1 vccd1 _2621_/Q sky130_fd_sc_hd__dfrtp_2
X_2552_ _2694_/CLK _2552_/D load_slew129/X vssd1 vssd1 vccd1 vccd1 _2552_/Q sky130_fd_sc_hd__dfrtp_2
X_2483_ _2508_/A _2484_/B _2483_/C vssd1 vssd1 vccd1 vccd1 _2850_/D sky130_fd_sc_hd__and3_2
XANTENNA__1931__A _1944_/A vssd1 vssd1 vccd1 vccd1 sky130_fd_sc_hd__diode_2
XTAP_TAPCELL_ROW_38_403 vssd1 vccd1 sky130_fd_sc_hd__tapvpwrvgnd_1
X_1296_ _2791_/Q _2790_/Q vssd1 vssd1 vccd1 vccd1 _1312_/B sky130_fd_sc_hd__and2_2
X_1365_ hold533/X _2331_/A _1284_/Y _1280_/Y vssd1 vssd1 vccd1 vccd1 _2895_/D sky130_fd_sc_hd__a211o_2
X_1434_ _1436_/B vssd1 vssd1 vccd1 vccd1 _1434_/Y sky130_fd_sc_hd__inv_2
XANTENNA_fanout150_A _2882_/D vssd1 vssd1 vccd1 vccd1 sky130_fd_sc_hd__diode_2
X_2819_ _2923_/CLK _2819_/D fanout86/X vssd1 vssd1 vccd1 vccd1 _2819_/Q sky130_fd_sc_hd__dfrtp_2
XANTENNA__1560__B _2637_/Q vssd1 vssd1 vccd1 vccd1 sky130_fd_sc_hd__diode_2
XANTENNA__2148__S _2153_/S vssd1 vssd1 vccd1 vccd1 sky130_fd_sc_hd__diode_2
XANTENNA_fanout63_A _1693_/S vssd1 vssd1 vccd1 vccd1 sky130_fd_sc_hd__diode_2
XFILLER_36_98 vssd1 vssd1 vccd1 vccd1 sky130_fd_sc_hd__fill_1
XFILLER_54_293 vssd1 vssd1 vccd1 vccd1 sky130_fd_sc_hd__fill_1
XANTENNA__1906__A1 _2646_/Q vssd1 vssd1 vccd1 vccd1 sky130_fd_sc_hd__diode_2
XANTENNA__2058__S _2071_/B vssd1 vssd1 vccd1 vccd1 sky130_fd_sc_hd__diode_2
X_1983_ _1921_/Y _1982_/A _1982_/B _2053_/B vssd1 vssd1 vccd1 vccd1 _2061_/A sky130_fd_sc_hd__o31a_2
X_2604_ _2769_/CLK _2604_/D vssd1 vssd1 vccd1 vccd1 _2604_/Q sky130_fd_sc_hd__dfxtp_2
X_1417_ _1280_/Y _1415_/B _1413_/A _1416_/A vssd1 vssd1 vccd1 vccd1 _1417_/X sky130_fd_sc_hd__a22o_2
X_2535_ _2719_/CLK _2535_/D vssd1 vssd1 vccd1 vccd1 _2535_/Q sky130_fd_sc_hd__dfxtp_2
X_2466_ _2844_/Q _2459_/B _2465_/Y vssd1 vssd1 vccd1 vccd1 _2466_/X sky130_fd_sc_hd__a21bo_2
X_1279_ _2894_/Q _2896_/Q _2895_/Q _2893_/Q vssd1 vssd1 vccd1 vccd1 _1280_/B sky130_fd_sc_hd__or4bb_2
X_1348_ _2741_/Q _1343_/X _1347_/Y _2742_/Q _1345_/X vssd1 vssd1 vccd1 vccd1 _1348_/X
+ sky130_fd_sc_hd__a221o_2
X_2397_ _2823_/Q _2398_/C _2824_/Q vssd1 vssd1 vccd1 vccd1 _2399_/A sky130_fd_sc_hd__a21oi_2
XFILLER_7_109 vssd1 vssd1 vccd1 vccd1 sky130_fd_sc_hd__fill_2
Xwire75 wire75/A vssd1 vssd1 vccd1 vccd1 wire75/X sky130_fd_sc_hd__clkdlybuf4s25_1
XANTENNA__1836__A _2636_/Q vssd1 vssd1 vccd1 vccd1 sky130_fd_sc_hd__diode_2
XFILLER_3_337 vssd1 vssd1 vccd1 vccd1 sky130_fd_sc_hd__fill_2
Xfanout184 _2867_/Q vssd1 vssd1 vccd1 vccd1 _2154_/S sky130_fd_sc_hd__clkdlybuf4s25_1
Xfanout173 _2328_/A1 vssd1 vssd1 vccd1 vccd1 _2323_/A1 sky130_fd_sc_hd__clkdlybuf4s25_1
Xfanout162 _1385_/B vssd1 vssd1 vccd1 vccd1 _1384_/B sky130_fd_sc_hd__clkdlybuf4s25_1
Xfanout151 _2883_/Q vssd1 vssd1 vccd1 vccd1 _2882_/D sky130_fd_sc_hd__clkdlybuf4s25_1
Xfanout140 fanout144/X vssd1 vssd1 vccd1 vccd1 fanout140/X sky130_fd_sc_hd__clkdlybuf4s25_1
XTAP_TAPCELL_ROW_57_542 vssd1 vccd1 sky130_fd_sc_hd__tapvpwrvgnd_1
XTAP_TAPCELL_ROW_40_420 vssd1 vccd1 sky130_fd_sc_hd__tapvpwrvgnd_1
X_2320_ _2323_/A1 hold384/X _2323_/B1 _2796_/Q vssd1 vssd1 vccd1 vccd1 _2320_/X sky130_fd_sc_hd__a22o_2
X_2251_ _2251_/A _2251_/B _2251_/C vssd1 vssd1 vccd1 vccd1 _2251_/Y sky130_fd_sc_hd__nand3_2
XANTENNA__2304__A1 _1351_/A vssd1 vssd1 vccd1 vccd1 sky130_fd_sc_hd__diode_2
XANTENNA_clkbuf_leaf_23_clk_A clkbuf_3_4__f_clk/X vssd1 vssd1 vccd1 vccd1 sky130_fd_sc_hd__diode_2
XANTENNA_clkbuf_leaf_38_clk_A clkbuf_leaf_3_clk/A vssd1 vssd1 vccd1 vccd1 sky130_fd_sc_hd__diode_2
XFILLER_19_3 vssd1 vssd1 vccd1 vccd1 sky130_fd_sc_hd__fill_1
X_2182_ hold378/X hold304/X _2186_/S vssd1 vssd1 vccd1 vccd1 _2738_/D sky130_fd_sc_hd__mux2_1
XTAP_TAPCELL_ROW_63_578 vssd1 vccd1 sky130_fd_sc_hd__tapvpwrvgnd_1
X_1966_ _2666_/Q _1989_/B _1990_/A vssd1 vssd1 vccd1 vccd1 _1967_/B sky130_fd_sc_hd__a21oi_2
XANTENNA_fanout113_A fanout145/X vssd1 vssd1 vccd1 vccd1 sky130_fd_sc_hd__diode_2
X_1897_ _2708_/Q _1908_/A2 _1851_/Y vssd1 vssd1 vccd1 vccd1 _1897_/X sky130_fd_sc_hd__a21o_2
Xteam_06_209 vssd1 vssd1 vccd1 vccd1 team_06_209/HI gpio_oeb[21] sky130_fd_sc_hd__conb_1
XFILLER_0_307 vssd1 vssd1 vccd1 vccd1 sky130_fd_sc_hd__fill_1
X_2518_ _2519_/B _2518_/B vssd1 vssd1 vccd1 vccd1 _2864_/D sky130_fd_sc_hd__and2_2
X_2449_ _2416_/X _2448_/X _2447_/Y vssd1 vssd1 vccd1 vccd1 _2839_/D sky130_fd_sc_hd__o21ai_2
XANTENNA__1566__A _1582_/A vssd1 vssd1 vccd1 vccd1 sky130_fd_sc_hd__diode_2
XANTENNA__2161__S _2168_/S vssd1 vssd1 vccd1 vccd1 sky130_fd_sc_hd__diode_2
XANTENNA__2309__A1_N _2300_/A1 vssd1 vssd1 vccd1 vccd1 sky130_fd_sc_hd__diode_2
XFILLER_33_44 vssd1 vssd1 vccd1 vccd1 sky130_fd_sc_hd__fill_2
XFILLER_33_55 vssd1 vssd1 vccd1 vccd1 sky130_fd_sc_hd__fill_1
XFILLER_58_85 vssd1 vssd1 vccd1 vccd1 sky130_fd_sc_hd__fill_2
XTAP_TAPCELL_ROW_17_258 vssd1 vccd1 sky130_fd_sc_hd__tapvpwrvgnd_1
XTAP_TAPCELL_ROW_60_559 vssd1 vccd1 sky130_fd_sc_hd__tapvpwrvgnd_1
X_1820_ _1863_/C _1821_/B vssd1 vssd1 vccd1 vccd1 _1820_/Y sky130_fd_sc_hd__nor2_2
X_1682_ hold293/X _2636_/Q _1686_/S vssd1 vssd1 vccd1 vccd1 _2581_/D sky130_fd_sc_hd__mux2_1
X_1751_ _2619_/Q _2558_/Q vssd1 vssd1 vccd1 vccd1 _1751_/X sky130_fd_sc_hd__and2_2
Xhold407 _2737_/Q vssd1 vssd1 vccd1 vccd1 hold407/X sky130_fd_sc_hd__dlygate4sd3_1
Xhold418 _2664_/Q vssd1 vssd1 vccd1 vccd1 _1358_/A sky130_fd_sc_hd__dlygate4sd3_1
Xhold429 _2908_/Q vssd1 vssd1 vccd1 vccd1 hold429/X sky130_fd_sc_hd__dlygate4sd3_1
XANTENNA__2289__B1 _2293_/B1 vssd1 vssd1 vccd1 vccd1 sky130_fd_sc_hd__diode_2
X_2303_ _2300_/A1 _1321_/Y _2299_/B hold383/X vssd1 vssd1 vccd1 vccd1 _2779_/D sky130_fd_sc_hd__a2bb2o_2
X_2234_ _2767_/Q _2721_/Q vssd1 vssd1 vccd1 vccd1 _2238_/A sky130_fd_sc_hd__or2_2
XTAP_TAPCELL_ROW_0_137 vssd1 vccd1 sky130_fd_sc_hd__tapvpwrvgnd_1
X_2165_ hold244/X hold241/X _2168_/S vssd1 vssd1 vccd1 vccd1 _2721_/D sky130_fd_sc_hd__mux2_1
X_2096_ _2588_/Q _2572_/Q _2130_/S vssd1 vssd1 vccd1 vccd1 _2096_/X sky130_fd_sc_hd__mux2_1
XFILLER_21_233 vssd1 vssd1 vccd1 vccd1 sky130_fd_sc_hd__fill_1
X_1949_ _1950_/B _1950_/C _2670_/Q vssd1 vssd1 vccd1 vccd1 _1973_/A sky130_fd_sc_hd__a21oi_2
XFILLER_28_11 vssd1 vssd1 vccd1 vccd1 sky130_fd_sc_hd__fill_1
XFILLER_29_300 vssd1 vssd1 vccd1 vccd1 sky130_fd_sc_hd__fill_1
XFILLER_29_344 vssd1 vssd1 vccd1 vccd1 sky130_fd_sc_hd__fill_1
XTAP_TAPCELL_ROW_14_239 vssd1 vccd1 sky130_fd_sc_hd__tapvpwrvgnd_1
XFILLER_5_26 vssd1 vssd1 vccd1 vccd1 sky130_fd_sc_hd__fill_4
XFILLER_5_37 vssd1 vssd1 vccd1 vccd1 sky130_fd_sc_hd__fill_4
XTAP_TAPCELL_ROW_22_294 vssd1 vccd1 sky130_fd_sc_hd__tapvpwrvgnd_1
XFILLER_10_7 vssd1 vssd1 vccd1 vccd1 sky130_fd_sc_hd__fill_2
XPHY_EDGE_ROW_13_Right_13 vssd1 vssd1 vccd1 vccd1 sky130_fd_sc_hd__decap_3
XPHY_EDGE_ROW_22_Right_22 vssd1 vssd1 vccd1 vccd1 sky130_fd_sc_hd__decap_3
X_1803_ _2629_/Q _1808_/C _1770_/C vssd1 vssd1 vccd1 vccd1 _1803_/Y sky130_fd_sc_hd__o21ai_2
X_2921_ _2923_/CLK _2921_/D fanout86/X vssd1 vssd1 vccd1 vccd1 _2921_/Q sky130_fd_sc_hd__dfstp_2
X_2852_ _2865_/CLK _2852_/D vssd1 vssd1 vccd1 vccd1 _2852_/Q sky130_fd_sc_hd__dfxtp_2
X_2783_ _2801_/CLK _2783_/D fanout122/X vssd1 vssd1 vccd1 vccd1 _2783_/Q sky130_fd_sc_hd__dfrtp_2
XFILLER_7_281 vssd1 vssd1 vccd1 vccd1 sky130_fd_sc_hd__fill_2
XFILLER_7_292 vssd1 vssd1 vccd1 vccd1 sky130_fd_sc_hd__fill_4
X_1596_ _1596_/A _1596_/B vssd1 vssd1 vccd1 vccd1 _2538_/D sky130_fd_sc_hd__or2_2
X_1665_ hold297/X _2618_/Q _1686_/S vssd1 vssd1 vccd1 vccd1 _2564_/D sky130_fd_sc_hd__mux2_1
X_1734_ _1734_/A _1756_/B vssd1 vssd1 vccd1 vccd1 _1734_/Y sky130_fd_sc_hd__nor2_2
Xhold259 _1728_/X vssd1 vssd1 vccd1 vccd1 _2614_/D sky130_fd_sc_hd__dlygate4sd3_1
Xhold248 _2865_/Q vssd1 vssd1 vccd1 vccd1 _2519_/A sky130_fd_sc_hd__dlygate4sd3_1
Xhold237 _2890_/Q vssd1 vssd1 vccd1 vccd1 _2921_/D sky130_fd_sc_hd__dlygate4sd3_1
XFILLER_38_141 vssd1 vssd1 vccd1 vccd1 sky130_fd_sc_hd__fill_2
XFILLER_58_406 vssd1 vssd1 vccd1 vccd1 sky130_fd_sc_hd__fill_1
XPHY_EDGE_ROW_31_Right_31 vssd1 vssd1 vccd1 vccd1 sky130_fd_sc_hd__decap_3
X_2217_ _2217_/A _2217_/B vssd1 vssd1 vccd1 vccd1 _2217_/Y sky130_fd_sc_hd__xnor2_2
X_2148_ _2706_/Q hold391/X _2153_/S vssd1 vssd1 vccd1 vccd1 _2706_/D sky130_fd_sc_hd__mux2_1
X_2079_ _2666_/Q _2078_/X _2136_/B vssd1 vssd1 vccd1 vccd1 _2666_/D sky130_fd_sc_hd__mux2_1
XFILLER_14_46 vssd1 vssd1 vccd1 vccd1 sky130_fd_sc_hd__fill_2
XPHY_EDGE_ROW_40_Right_40 vssd1 vssd1 vccd1 vccd1 sky130_fd_sc_hd__decap_3
XANTENNA__1844__A _2644_/Q vssd1 vssd1 vccd1 vccd1 sky130_fd_sc_hd__diode_2
XANTENNA_fanout93_A fanout99/A vssd1 vssd1 vccd1 vccd1 sky130_fd_sc_hd__diode_2
XTAP_TAPCELL_ROW_27_331 vssd1 vccd1 sky130_fd_sc_hd__tapvpwrvgnd_1
XFILLER_4_251 vssd1 vssd1 vccd1 vccd1 sky130_fd_sc_hd__fill_1
XFILLER_58_7 vssd1 vssd1 vccd1 vccd1 sky130_fd_sc_hd__fill_2
X_1450_ _1450_/A1 _1447_/X _1449_/Y _1450_/B1 hold465/X vssd1 vssd1 vccd1 vccd1 _2906_/D
+ sky130_fd_sc_hd__a32o_2
X_1381_ _2805_/Q _2871_/Q _1812_/C _1382_/B _2876_/Q vssd1 vssd1 vccd1 vccd1 _2876_/D
+ sky130_fd_sc_hd__a32o_2
X_2002_ _1970_/A _2002_/B vssd1 vssd1 vccd1 vccd1 _2003_/B sky130_fd_sc_hd__nand2b_2
XANTENNA__2470__D _2470_/D vssd1 vssd1 vccd1 vccd1 sky130_fd_sc_hd__diode_2
XANTENNA_clkbuf_0_clk_X clkbuf_0_clk/X vssd1 vssd1 vccd1 vccd1 sky130_fd_sc_hd__diode_2
X_2904_ _2912_/CLK _2904_/D load_slew116/X vssd1 vssd1 vccd1 vccd1 _2904_/Q sky130_fd_sc_hd__dfrtp_2
X_2835_ _2845_/CLK _2835_/D _2495_/B2 vssd1 vssd1 vccd1 vccd1 _2835_/Q sky130_fd_sc_hd__dfrtp_2
X_2766_ _2768_/CLK _2766_/D load_slew142/X vssd1 vssd1 vccd1 vccd1 _2766_/Q sky130_fd_sc_hd__dfrtp_2
X_1579_ hold321/X _1581_/A2 _1578_/X vssd1 vssd1 vccd1 vccd1 _2534_/D sky130_fd_sc_hd__a21o_2
X_1648_ _1662_/D _1648_/B _1822_/A _1651_/C vssd1 vssd1 vccd1 vccd1 _1649_/S sky130_fd_sc_hd__or4b_2
X_1717_ hold311/X _1716_/X _1721_/S vssd1 vssd1 vccd1 vccd1 _2607_/D sky130_fd_sc_hd__mux2_1
X_2697_ _2804_/CLK _2697_/D fanout133/X vssd1 vssd1 vccd1 vccd1 _2697_/Q sky130_fd_sc_hd__dfrtp_2
XANTENNA_fanout183_X _2153_/S vssd1 vssd1 vccd1 vccd1 sky130_fd_sc_hd__diode_2
XFILLER_58_236 vssd1 vssd1 vccd1 vccd1 sky130_fd_sc_hd__fill_1
XANTENNA__1839__A _2637_/Q vssd1 vssd1 vccd1 vccd1 sky130_fd_sc_hd__diode_2
XFILLER_25_34 vssd1 vssd1 vccd1 vccd1 sky130_fd_sc_hd__fill_4
XFILLER_17_111 vssd1 vssd1 vccd1 vccd1 sky130_fd_sc_hd__fill_1
XFILLER_17_166 vssd1 vssd1 vccd1 vccd1 sky130_fd_sc_hd__fill_2
XANTENNA__2641__Q _2641_/Q vssd1 vssd1 vccd1 vccd1 sky130_fd_sc_hd__diode_2
XTAP_TAPCELL_ROW_30_348 vssd1 vccd1 sky130_fd_sc_hd__tapvpwrvgnd_1
X_2620_ clkload7/A _2620_/D fanout105/X vssd1 vssd1 vccd1 vccd1 _2620_/Q sky130_fd_sc_hd__dfrtp_2
X_1433_ _2901_/Q _2902_/Q _1437_/D vssd1 vssd1 vccd1 vccd1 _1436_/B sky130_fd_sc_hd__and3_2
X_1502_ _2839_/Q _1502_/B vssd1 vssd1 vccd1 vccd1 _1502_/X sky130_fd_sc_hd__or2_2
X_2551_ _2647_/CLK _2551_/D load_slew129/X vssd1 vssd1 vccd1 vccd1 _2551_/Q sky130_fd_sc_hd__dfrtp_2
X_2482_ _2850_/Q _2486_/D vssd1 vssd1 vccd1 vccd1 _2483_/C sky130_fd_sc_hd__or2_2
XANTENNA__1688__A1 _2642_/Q vssd1 vssd1 vccd1 vccd1 sky130_fd_sc_hd__diode_2
XTAP_TAPCELL_ROW_38_404 vssd1 vccd1 sky130_fd_sc_hd__tapvpwrvgnd_1
X_1295_ _1415_/A _1413_/A _1293_/X _1280_/Y vssd1 vssd1 vccd1 vccd1 _2893_/D sky130_fd_sc_hd__a211o_2
X_1364_ _1364_/A _1413_/A _1364_/C vssd1 vssd1 vccd1 vccd1 _2894_/D sky130_fd_sc_hd__or3_2
XANTENNA__1860__A1 _1863_/C vssd1 vssd1 vccd1 vccd1 sky130_fd_sc_hd__diode_2
XANTENNA_fanout143_A fanout144/X vssd1 vssd1 vccd1 vccd1 sky130_fd_sc_hd__diode_2
X_2818_ _2923_/CLK _2818_/D fanout86/X vssd1 vssd1 vccd1 vccd1 _2818_/Q sky130_fd_sc_hd__dfrtp_2
X_2749_ _2765_/CLK _2749_/D fanout137/X vssd1 vssd1 vccd1 vccd1 _2749_/Q sky130_fd_sc_hd__dfrtp_2
XANTENNA__1841__B _2638_/Q vssd1 vssd1 vccd1 vccd1 sky130_fd_sc_hd__diode_2
XANTENNA__1603__A1 _2637_/Q vssd1 vssd1 vccd1 vccd1 sky130_fd_sc_hd__diode_2
XANTENNA__2164__S _2168_/S vssd1 vssd1 vccd1 vccd1 sky130_fd_sc_hd__diode_2
XFILLER_52_76 vssd1 vssd1 vccd1 vccd1 sky130_fd_sc_hd__fill_1
XANTENNA__1751__B _2558_/Q vssd1 vssd1 vccd1 vccd1 sky130_fd_sc_hd__diode_2
XANTENNA__2636__Q _2636_/Q vssd1 vssd1 vccd1 vccd1 sky130_fd_sc_hd__diode_2
XTAP_TAPCELL_ROW_43_440 vssd1 vccd1 sky130_fd_sc_hd__tapvpwrvgnd_1
X_1982_ _1982_/A _1982_/B vssd1 vssd1 vccd1 vccd1 _2054_/A sky130_fd_sc_hd__nor2_2
X_2603_ _2642_/CLK _2603_/D vssd1 vssd1 vccd1 vccd1 _2603_/Q sky130_fd_sc_hd__dfxtp_2
X_2534_ clkload7/A _2534_/D vssd1 vssd1 vccd1 vccd1 _2534_/Q sky130_fd_sc_hd__dfxtp_2
X_1347_ _1347_/A _1347_/B vssd1 vssd1 vccd1 vccd1 _1347_/Y sky130_fd_sc_hd__nand2_2
X_1416_ _1416_/A vssd1 vssd1 vccd1 vccd1 _1416_/Y sky130_fd_sc_hd__inv_2
X_2465_ _2462_/B _2465_/B vssd1 vssd1 vccd1 vccd1 _2465_/Y sky130_fd_sc_hd__nand2b_2
X_2396_ _2396_/A _2398_/C vssd1 vssd1 vccd1 vccd1 _2823_/D sky130_fd_sc_hd__xor2_2
X_1278_ _2894_/Q _2896_/Q _2895_/Q _2893_/Q vssd1 vssd1 vccd1 vccd1 _1389_/B sky130_fd_sc_hd__and4bb_2
XANTENNA_clkbuf_3_2__f_clk_A clkbuf_0_clk/X vssd1 vssd1 vccd1 vccd1 sky130_fd_sc_hd__diode_2
XFILLER_22_13 vssd1 vssd1 vccd1 vccd1 sky130_fd_sc_hd__fill_2
XANTENNA__1836__B _2558_/Q vssd1 vssd1 vccd1 vccd1 sky130_fd_sc_hd__diode_2
Xfanout185 _2816_/Q vssd1 vssd1 vccd1 vccd1 _2378_/A sky130_fd_sc_hd__clkdlybuf4s25_1
Xfanout174 _2870_/Q vssd1 vssd1 vccd1 vccd1 _2328_/A1 sky130_fd_sc_hd__clkdlybuf4s25_1
Xfanout163 _2877_/Q vssd1 vssd1 vccd1 vccd1 _1385_/B sky130_fd_sc_hd__clkdlybuf4s25_1
Xfanout152 _2883_/Q vssd1 vssd1 vccd1 vccd1 _2125_/S sky130_fd_sc_hd__clkdlybuf4s25_1
Xfanout141 fanout144/X vssd1 vssd1 vccd1 vccd1 fanout141/X sky130_fd_sc_hd__clkdlybuf4s25_1
Xfanout130 fanout132/X vssd1 vssd1 vccd1 vccd1 wire131/A sky130_fd_sc_hd__clkdlybuf4s25_1
XFILLER_27_283 vssd1 vssd1 vccd1 vccd1 sky130_fd_sc_hd__fill_1
XFILLER_63_53 vssd1 vssd1 vccd1 vccd1 sky130_fd_sc_hd__fill_2
XANTENNA__1588__B1 _1385_/B vssd1 vssd1 vccd1 vccd1 sky130_fd_sc_hd__diode_2
XTAP_TAPCELL_ROW_40_421 vssd1 vccd1 sky130_fd_sc_hd__tapvpwrvgnd_1
X_2250_ _2241_/Y _2246_/B _2243_/B vssd1 vssd1 vccd1 vccd1 _2251_/C sky130_fd_sc_hd__o21ai_2
X_2181_ hold407/X hold334/X _2186_/S vssd1 vssd1 vccd1 vccd1 _2737_/D sky130_fd_sc_hd__mux2_1
XTAP_TAPCELL_ROW_63_579 vssd1 vccd1 sky130_fd_sc_hd__tapvpwrvgnd_1
X_1965_ _2695_/Q _2665_/Q _2680_/Q vssd1 vssd1 vccd1 vccd1 _1990_/A sky130_fd_sc_hd__mux2_1
XANTENNA__2240__B2 _2260_/A2 vssd1 vssd1 vccd1 vccd1 sky130_fd_sc_hd__diode_2
XANTENNA_fanout106_A _1362_/Y vssd1 vssd1 vccd1 vccd1 sky130_fd_sc_hd__diode_2
X_1896_ _1899_/B _1896_/B _1900_/C vssd1 vssd1 vccd1 vccd1 _1896_/X sky130_fd_sc_hd__and3b_2
X_2517_ _2864_/Q _2517_/B vssd1 vssd1 vccd1 vccd1 _2518_/B sky130_fd_sc_hd__or2_2
X_2448_ _2839_/Q _2448_/B vssd1 vssd1 vccd1 vccd1 _2448_/X sky130_fd_sc_hd__xor2_2
X_2379_ _2378_/A _2381_/B _2377_/X vssd1 vssd1 vccd1 vccd1 _2816_/D sky130_fd_sc_hd__a21boi_2
XFILLER_17_57 vssd1 vssd1 vccd1 vccd1 sky130_fd_sc_hd__fill_1
XFILLER_24_253 vssd1 vssd1 vccd1 vccd1 sky130_fd_sc_hd__fill_2
XANTENNA__1566__B _2640_/Q vssd1 vssd1 vccd1 vccd1 sky130_fd_sc_hd__diode_2
XANTENNA__1847__A _2647_/Q vssd1 vssd1 vccd1 vccd1 sky130_fd_sc_hd__diode_2
XANTENNA__1582__A _1582_/A vssd1 vssd1 vccd1 vccd1 sky130_fd_sc_hd__diode_2
XFILLER_3_113 vssd1 vssd1 vccd1 vccd1 sky130_fd_sc_hd__fill_1
XFILLER_58_31 vssd1 vssd1 vccd1 vccd1 sky130_fd_sc_hd__fill_1
XFILLER_47_345 vssd1 vssd1 vccd1 vccd1 sky130_fd_sc_hd__fill_1
XTAP_TAPCELL_ROW_17_259 vssd1 vccd1 sky130_fd_sc_hd__tapvpwrvgnd_1
X_1750_ _2618_/Q _1814_/B2 _1748_/X _1749_/X vssd1 vssd1 vccd1 vccd1 _2618_/D sky130_fd_sc_hd__o22a_2
X_1681_ hold282/X _2635_/Q _1686_/S vssd1 vssd1 vccd1 vccd1 _2580_/D sky130_fd_sc_hd__mux2_1
Xhold408 _2663_/Q vssd1 vssd1 vccd1 vccd1 hold408/X sky130_fd_sc_hd__dlygate4sd3_1
Xhold419 _2702_/Q vssd1 vssd1 vccd1 vccd1 hold419/X sky130_fd_sc_hd__dlygate4sd3_1
XANTENNA__2289__A1 _1366_/A vssd1 vssd1 vccd1 vccd1 sky130_fd_sc_hd__diode_2
XFILLER_31_3 vssd1 vssd1 vccd1 vccd1 sky130_fd_sc_hd__fill_1
X_2302_ _2300_/A1 _1311_/X _2299_/B hold402/X vssd1 vssd1 vccd1 vccd1 _2778_/D sky130_fd_sc_hd__a2bb2o_2
X_2233_ hold439/X _2260_/A2 _2232_/Y _2155_/A vssd1 vssd1 vccd1 vccd1 _2751_/D sky130_fd_sc_hd__a22o_2
X_2164_ hold251/X hold245/X _2168_/S vssd1 vssd1 vccd1 vccd1 _2720_/D sky130_fd_sc_hd__mux2_1
XFILLER_61_370 vssd1 vssd1 vccd1 vccd1 sky130_fd_sc_hd__fill_1
XTAP_TAPCELL_ROW_0_138 vssd1 vccd1 sky130_fd_sc_hd__tapvpwrvgnd_1
X_2095_ hold508/X _2094_/X _2125_/S vssd1 vssd1 vccd1 vccd1 _2674_/D sky130_fd_sc_hd__mux2_1
X_1879_ _2703_/Q _1869_/B _1878_/Y _1900_/C vssd1 vssd1 vccd1 vccd1 _1879_/X sky130_fd_sc_hd__a22o_2
X_1948_ _1963_/A _2685_/Q vssd1 vssd1 vccd1 vccd1 _1950_/C sky130_fd_sc_hd__nand2_2
XFILLER_56_197 vssd1 vccd1 vssd1 vccd1 sky130_ef_sc_hd__decap_40_12
XANTENNA__2172__S _2189_/S vssd1 vssd1 vccd1 vccd1 sky130_fd_sc_hd__diode_2
XFILLER_12_223 vssd1 vssd1 vccd1 vccd1 sky130_fd_sc_hd__fill_1
XFILLER_44_66 vssd1 vssd1 vccd1 vccd1 sky130_fd_sc_hd__fill_1
XANTENNA__2204__B2 _1351_/A vssd1 vssd1 vccd1 vccd1 sky130_fd_sc_hd__diode_2
XANTENNA_clkbuf_leaf_37_clk_A clkbuf_leaf_4_clk/A vssd1 vssd1 vccd1 vccd1 sky130_fd_sc_hd__diode_2
XTAP_TAPCELL_ROW_22_295 vssd1 vccd1 sky130_fd_sc_hd__tapvpwrvgnd_1
XANTENNA__2644__Q _2644_/Q vssd1 vssd1 vccd1 vccd1 sky130_fd_sc_hd__diode_2
XFILLER_43_370 vssd1 vssd1 vccd1 vccd1 sky130_fd_sc_hd__fill_1
X_2920_ _2923_/CLK _2920_/D fanout86/X vssd1 vssd1 vccd1 vccd1 _2920_/Q sky130_fd_sc_hd__dfstp_2
X_1733_ _2616_/Q _2555_/Q _1819_/B2 _1732_/Y vssd1 vssd1 vccd1 vccd1 _1733_/X sky130_fd_sc_hd__o22a_2
X_1802_ _2628_/Q _1811_/A2 _1800_/Y _1801_/X vssd1 vssd1 vccd1 vccd1 _2628_/D sky130_fd_sc_hd__o22a_2
X_2851_ _2884_/CLK _2851_/D vssd1 vssd1 vccd1 vccd1 _2851_/Q sky130_fd_sc_hd__dfxtp_2
X_2782_ _2801_/CLK _2782_/D fanout115/X vssd1 vssd1 vccd1 vccd1 _2782_/Q sky130_fd_sc_hd__dfrtp_2
X_1595_ _1624_/S _1592_/X _1593_/X _2698_/Q _1385_/B vssd1 vssd1 vccd1 vccd1 _1596_/B
+ sky130_fd_sc_hd__a32o_2
X_1664_ hold314/X _2617_/Q _1686_/S vssd1 vssd1 vccd1 vccd1 _1664_/X sky130_fd_sc_hd__mux2_1
Xhold249 _2519_/Y vssd1 vssd1 vccd1 vccd1 _2865_/D sky130_fd_sc_hd__dlygate4sd3_1
Xhold238 _2892_/Q vssd1 vssd1 vccd1 vccd1 _2923_/D sky130_fd_sc_hd__dlygate4sd3_1
XANTENNA__2308__A1_N _2300_/A1 vssd1 vssd1 vccd1 vccd1 sky130_fd_sc_hd__diode_2
XFILLER_38_164 vssd1 vssd1 vccd1 vccd1 sky130_fd_sc_hd__fill_4
XFILLER_38_197 vssd1 vssd1 vccd1 vccd1 sky130_fd_sc_hd__fill_2
X_2216_ _2216_/A _2216_/B vssd1 vssd1 vccd1 vccd1 _2217_/B sky130_fd_sc_hd__or2_2
X_2147_ _2705_/Q hold427/X _2153_/S vssd1 vssd1 vccd1 vccd1 _2705_/D sky130_fd_sc_hd__mux2_1
X_2078_ _2579_/Q _2563_/Q _2120_/S vssd1 vssd1 vccd1 vccd1 _2078_/X sky130_fd_sc_hd__mux2_1
XANTENNA__1844__B _2643_/Q vssd1 vssd1 vccd1 vccd1 sky130_fd_sc_hd__diode_2
XFILLER_39_55 vssd1 vssd1 vccd1 vccd1 sky130_fd_sc_hd__fill_1
XANTENNA__2167__S _2168_/S vssd1 vssd1 vccd1 vccd1 sky130_fd_sc_hd__diode_2
XFILLER_17_337 vssd1 vssd1 vccd1 vccd1 sky130_fd_sc_hd__fill_1
XFILLER_32_307 vssd1 vssd1 vccd1 vccd1 sky130_fd_sc_hd__fill_1
XFILLER_44_145 vssd1 vssd1 vccd1 vccd1 sky130_fd_sc_hd__fill_2
XFILLER_44_178 vssd1 vssd1 vccd1 vccd1 sky130_fd_sc_hd__fill_2
XTAP_TAPCELL_ROW_27_332 vssd1 vccd1 sky130_fd_sc_hd__tapvpwrvgnd_1
XTAP_TAPCELL_ROW_10_210 vssd1 vccd1 sky130_fd_sc_hd__tapvpwrvgnd_1
X_1380_ _1382_/B _2876_/Q vssd1 vssd1 vccd1 vccd1 _1813_/B sky130_fd_sc_hd__nand2_2
XANTENNA__2077__S _2136_/B vssd1 vssd1 vccd1 vccd1 sky130_fd_sc_hd__diode_2
X_2001_ _2007_/A _2007_/B vssd1 vssd1 vccd1 vccd1 _2001_/X sky130_fd_sc_hd__or2_2
XTAP_TAPCELL_ROW_33_368 vssd1 vccd1 sky130_fd_sc_hd__tapvpwrvgnd_1
X_2903_ _2912_/CLK _2903_/D load_slew116/X vssd1 vssd1 vccd1 vccd1 _2903_/Q sky130_fd_sc_hd__dfrtp_2
X_1716_ _2627_/Q _2644_/Q _1716_/S vssd1 vssd1 vccd1 vccd1 _1716_/X sky130_fd_sc_hd__mux2_1
X_2834_ clkload1/A _2834_/D load_slew81/X vssd1 vssd1 vccd1 vccd1 _2834_/Q sky130_fd_sc_hd__dfrtp_2
X_2765_ _2765_/CLK _2765_/D fanout137/X vssd1 vssd1 vccd1 vccd1 _2765_/Q sky130_fd_sc_hd__dfrtp_2
X_2696_ clkload2/A _2696_/D fanout93/X vssd1 vssd1 vccd1 vccd1 _2696_/Q sky130_fd_sc_hd__dfrtp_2
X_1578_ _1580_/A _2646_/Q _1723_/S vssd1 vssd1 vccd1 vccd1 _1578_/X sky130_fd_sc_hd__and3_2
X_1647_ _1756_/B _1863_/C vssd1 vssd1 vccd1 vccd1 _1648_/B sky130_fd_sc_hd__or2_2
XANTENNA__1574__B _2644_/Q vssd1 vssd1 vccd1 vccd1 sky130_fd_sc_hd__diode_2
XFILLER_1_222 vssd1 vssd1 vccd1 vccd1 sky130_fd_sc_hd__fill_2
XFILLER_9_3 vssd1 vssd1 vccd1 vccd1 sky130_fd_sc_hd__fill_1
XANTENNA__1589__X _1589_/X vssd1 vssd1 vccd1 vccd1 sky130_fd_sc_hd__diode_2
XANTENNA__1909__A0 _2647_/Q vssd1 vssd1 vccd1 vccd1 sky130_fd_sc_hd__diode_2
XFILLER_63_6 vssd1 vssd1 vccd1 vccd1 sky130_fd_sc_hd__fill_1
XFILLER_9_333 vssd1 vssd1 vccd1 vccd1 sky130_fd_sc_hd__fill_2
XTAP_TAPCELL_ROW_30_349 vssd1 vccd1 sky130_fd_sc_hd__tapvpwrvgnd_1
X_2550_ _2647_/CLK _2550_/D load_slew129/X vssd1 vssd1 vccd1 vccd1 _2550_/Q sky130_fd_sc_hd__dfrtp_2
X_1363_ _1415_/B _2470_/C vssd1 vssd1 vccd1 vccd1 _1364_/C sky130_fd_sc_hd__nor2_2
X_1432_ _2901_/Q _1437_/D _2902_/Q vssd1 vssd1 vccd1 vccd1 _1432_/X sky130_fd_sc_hd__a21o_2
X_1501_ _1502_/B vssd1 vssd1 vccd1 vccd1 _1537_/C sky130_fd_sc_hd__inv_2
X_2481_ _2850_/Q _2486_/D vssd1 vssd1 vccd1 vccd1 _2484_/B sky130_fd_sc_hd__nand2_2
XPHY_EDGE_ROW_43_Left_108 vssd1 vssd1 vccd1 vccd1 sky130_fd_sc_hd__decap_3
XTAP_TAPCELL_ROW_38_405 vssd1 vccd1 sky130_fd_sc_hd__tapvpwrvgnd_1
XTAP_TAPCELL_ROW_46_460 vssd1 vccd1 sky130_fd_sc_hd__tapvpwrvgnd_1
X_1294_ _2893_/Q _2894_/Q _1294_/C vssd1 vssd1 vccd1 vccd1 _1413_/A sky130_fd_sc_hd__and3b_2
XFILLER_31_181 vssd1 vssd1 vccd1 vccd1 sky130_fd_sc_hd__fill_2
XPHY_EDGE_ROW_52_Left_117 vssd1 vssd1 vccd1 vccd1 sky130_fd_sc_hd__decap_3
X_2817_ _2923_/CLK _2817_/D fanout86/X vssd1 vssd1 vccd1 vccd1 _2817_/Q sky130_fd_sc_hd__dfrtp_2
X_2748_ _2765_/CLK _2748_/D load_slew136/X vssd1 vssd1 vccd1 vccd1 _2748_/Q sky130_fd_sc_hd__dfrtp_2
X_2679_ clkload6/A _2679_/D fanout102/X vssd1 vssd1 vccd1 vccd1 _2679_/Q sky130_fd_sc_hd__dfrtp_2
XANTENNA__1841__C _2637_/Q vssd1 vssd1 vccd1 vccd1 sky130_fd_sc_hd__diode_2
XANTENNA__2325__B1 _2156_/B vssd1 vssd1 vccd1 vccd1 sky130_fd_sc_hd__diode_2
XANTENNA_fanout49_A _2134_/S vssd1 vssd1 vccd1 vccd1 sky130_fd_sc_hd__diode_2
XFILLER_14_137 vssd1 vssd1 vccd1 vccd1 sky130_fd_sc_hd__fill_2
XPHY_EDGE_ROW_61_Left_126 vssd1 vssd1 vccd1 vccd1 sky130_fd_sc_hd__decap_3
XFILLER_20_118 vssd1 vssd1 vccd1 vccd1 sky130_fd_sc_hd__fill_1
XTAP_TAPCELL_ROW_43_441 vssd1 vccd1 sky130_fd_sc_hd__tapvpwrvgnd_1
X_1981_ _1929_/Y _1979_/A _1979_/B _2042_/B _2048_/B vssd1 vssd1 vccd1 vccd1 _1982_/B
+ sky130_fd_sc_hd__o311a_2
XFILLER_9_174 vssd1 vssd1 vccd1 vccd1 sky130_fd_sc_hd__fill_2
X_2602_ _2642_/CLK _2602_/D vssd1 vssd1 vccd1 vccd1 _2602_/Q sky130_fd_sc_hd__dfxtp_2
X_2533_ _2719_/CLK _2533_/D vssd1 vssd1 vccd1 vccd1 _2533_/Q sky130_fd_sc_hd__dfxtp_2
XFILLER_28_218 vssd1 vssd1 vccd1 vccd1 sky130_fd_sc_hd__fill_1
XFILLER_3_71 vssd1 vssd1 vccd1 vccd1 sky130_fd_sc_hd__fill_2
XFILLER_3_93 vssd1 vssd1 vccd1 vccd1 sky130_fd_sc_hd__fill_4
X_1346_ _2803_/Q _1346_/B vssd1 vssd1 vccd1 vccd1 _1347_/B sky130_fd_sc_hd__or2_2
X_1415_ _1415_/A _1415_/B vssd1 vssd1 vccd1 vccd1 _1416_/A sky130_fd_sc_hd__nor2_2
X_2464_ _2844_/Q _2464_/B vssd1 vssd1 vccd1 vccd1 _2465_/B sky130_fd_sc_hd__nand2_2
X_2395_ _2395_/A _2398_/C vssd1 vssd1 vccd1 vccd1 _2822_/D sky130_fd_sc_hd__nor2_2
XFILLER_36_262 vssd1 vssd1 vccd1 vccd1 sky130_fd_sc_hd__fill_1
X_1277_ _2911_/Q _1276_/X _1273_/X vssd1 vssd1 vccd1 vccd1 _1415_/A sky130_fd_sc_hd__o21a_2
XANTENNA__1597__A1 _1385_/B vssd1 vssd1 vccd1 vccd1 sky130_fd_sc_hd__diode_2
Xclkbuf_leaf_31_clk clkbuf_3_4__f_clk/X vssd1 vssd1 vccd1 vccd1 _2916_/CLK sky130_fd_sc_hd__clkbuf_8
XFILLER_3_339 vssd1 vssd1 vccd1 vccd1 sky130_fd_sc_hd__fill_1
Xfanout120 fanout125/X vssd1 vssd1 vccd1 vccd1 fanout120/X sky130_fd_sc_hd__clkdlybuf4s25_1
Xfanout186 _2389_/B vssd1 vssd1 vccd1 vccd1 _2375_/B sky130_fd_sc_hd__clkdlybuf4s25_1
Xfanout175 _2870_/Q vssd1 vssd1 vccd1 vccd1 _1366_/A sky130_fd_sc_hd__clkdlybuf4s25_1
Xfanout164 _1662_/D vssd1 vssd1 vccd1 vccd1 _1582_/A sky130_fd_sc_hd__clkdlybuf4s25_1
Xfanout153 _2883_/Q vssd1 vssd1 vccd1 vccd1 _2135_/S sky130_fd_sc_hd__clkdlybuf4s25_1
XFILLER_8_27 vssd1 vssd1 vccd1 vccd1 sky130_fd_sc_hd__fill_1
XTAP_TAPCELL_ROW_40_422 vssd1 vccd1 sky130_fd_sc_hd__tapvpwrvgnd_1
Xclkbuf_leaf_22_clk clkbuf_3_6__f_clk/X vssd1 vssd1 vccd1 vccd1 _2719_/CLK sky130_fd_sc_hd__clkbuf_8
XFILLER_6_122 vssd1 vssd1 vccd1 vccd1 sky130_fd_sc_hd__fill_1
XANTENNA__2647__Q _2647_/Q vssd1 vssd1 vccd1 vccd1 sky130_fd_sc_hd__diode_2
X_2180_ hold373/X hold302/X _2180_/S vssd1 vssd1 vccd1 vccd1 _2736_/D sky130_fd_sc_hd__mux2_1
XANTENNA__2085__S _2882_/D vssd1 vssd1 vccd1 vccd1 sky130_fd_sc_hd__diode_2
XFILLER_21_405 vssd1 vssd1 vccd1 vccd1 sky130_fd_sc_hd__fill_2
X_1895_ _2643_/Q _1892_/B _2644_/Q vssd1 vssd1 vccd1 vccd1 _1896_/B sky130_fd_sc_hd__a21o_2
X_1964_ _2666_/Q _1989_/B vssd1 vssd1 vccd1 vccd1 _1967_/A sky130_fd_sc_hd__nor2_2
Xclkbuf_leaf_13_clk clkbuf_leaf_5_clk/A vssd1 vssd1 vccd1 vccd1 clkload7/A sky130_fd_sc_hd__clkbuf_8
XFILLER_0_309 vssd1 vssd1 vccd1 vccd1 sky130_fd_sc_hd__fill_4
X_2516_ _2864_/Q _2517_/B vssd1 vssd1 vccd1 vccd1 _2519_/B sky130_fd_sc_hd__nand2_2
X_2447_ _2839_/Q _2472_/B vssd1 vssd1 vccd1 vccd1 _2447_/Y sky130_fd_sc_hd__nand2_2
XTAP_TAPCELL_ROW_3_158 vssd1 vccd1 sky130_fd_sc_hd__tapvpwrvgnd_1
X_1329_ _1325_/A _1325_/B _1328_/X _2735_/Q vssd1 vssd1 vccd1 vccd1 _1329_/X sky130_fd_sc_hd__a2bb2o_2
X_2378_ _2378_/A _2378_/B vssd1 vssd1 vccd1 vccd1 _2378_/Y sky130_fd_sc_hd__nor2_2
XANTENNA__1847__B _2646_/Q vssd1 vssd1 vccd1 vccd1 sky130_fd_sc_hd__diode_2
X_1680_ hold278/X _2634_/Q _1686_/S vssd1 vssd1 vccd1 vccd1 _2579_/D sky130_fd_sc_hd__mux2_1
Xhold409 _2561_/Q vssd1 vssd1 vccd1 vccd1 hold409/X sky130_fd_sc_hd__dlygate4sd3_1
X_2301_ _1351_/A _1313_/Y _2299_/B hold372/X vssd1 vssd1 vccd1 vccd1 _2777_/D sky130_fd_sc_hd__a22o_2
Xclkbuf_leaf_2_clk clkbuf_leaf_9_clk/A vssd1 vssd1 vccd1 vccd1 _2883_/CLK sky130_fd_sc_hd__clkbuf_8
X_2232_ _2232_/A _2232_/B vssd1 vssd1 vccd1 vccd1 _2232_/Y sky130_fd_sc_hd__xnor2_2
X_2163_ hold271/X hold243/X _2168_/S vssd1 vssd1 vccd1 vccd1 _2719_/D sky130_fd_sc_hd__mux2_1
XFILLER_0_83 vssd1 vssd1 vccd1 vccd1 sky130_fd_sc_hd__fill_1
XTAP_TAPCELL_ROW_0_139 vssd1 vccd1 sky130_fd_sc_hd__tapvpwrvgnd_1
X_2094_ _2587_/Q _2571_/Q _2130_/S vssd1 vssd1 vccd1 vccd1 _2094_/X sky130_fd_sc_hd__mux2_1
XFILLER_21_279 vssd1 vssd1 vccd1 vccd1 sky130_fd_sc_hd__fill_1
X_1878_ _1881_/B _1878_/B vssd1 vssd1 vccd1 vccd1 _1878_/Y sky130_fd_sc_hd__nor2_2
X_1947_ _1963_/A _2685_/Q vssd1 vssd1 vccd1 vccd1 _1950_/B sky130_fd_sc_hd__or2_2
XANTENNA__2204__A2 _2260_/A2 vssd1 vssd1 vccd1 vccd1 sky130_fd_sc_hd__diode_2
XFILLER_8_239 vssd1 vssd1 vccd1 vccd1 sky130_fd_sc_hd__fill_1
XTAP_TAPCELL_ROW_22_296 vssd1 vccd1 sky130_fd_sc_hd__tapvpwrvgnd_1
XFILLER_10_9 vssd1 vssd1 vccd1 vccd1 sky130_fd_sc_hd__fill_1
XPHY_EDGE_ROW_8_Left_73 vssd1 vssd1 vccd1 vccd1 sky130_fd_sc_hd__decap_3
XANTENNA_clkbuf_3_4__f_clk_X clkbuf_3_4__f_clk/X vssd1 vssd1 vccd1 vccd1 sky130_fd_sc_hd__diode_2
XFILLER_47_165 vssd1 vssd1 vccd1 vccd1 sky130_fd_sc_hd__fill_2
X_2850_ _2883_/CLK _2850_/D vssd1 vssd1 vccd1 vccd1 _2850_/Q sky130_fd_sc_hd__dfxtp_2
XFILLER_7_283 vssd1 vssd1 vccd1 vccd1 sky130_fd_sc_hd__fill_1
XTAP_TAPCELL_ROW_13_230 vssd1 vccd1 sky130_fd_sc_hd__tapvpwrvgnd_1
X_1663_ hold286/X _2616_/Q _1686_/S vssd1 vssd1 vccd1 vccd1 _2562_/D sky130_fd_sc_hd__mux2_1
X_1732_ _2616_/Q _2555_/Q _1756_/B vssd1 vssd1 vccd1 vccd1 _1732_/Y sky130_fd_sc_hd__a21boi_2
X_1801_ _1810_/A1 _2660_/Q _1810_/B1 _2709_/Q _1810_/C1 vssd1 vssd1 vccd1 vccd1 _1801_/X
+ sky130_fd_sc_hd__a221o_2
X_2781_ _2902_/CLK _2781_/D fanout115/X vssd1 vssd1 vccd1 vccd1 _2781_/Q sky130_fd_sc_hd__dfrtp_2
XPHY_EDGE_ROW_7_Right_7 vssd1 vssd1 vccd1 vccd1 sky130_fd_sc_hd__decap_3
X_1594_ _1734_/A _2649_/Q _2538_/Q _1589_/X vssd1 vssd1 vccd1 vccd1 _1596_/A sky130_fd_sc_hd__a22o_2
Xload_slew142 fanout141/X vssd1 vssd1 vccd1 vccd1 load_slew142/X sky130_fd_sc_hd__clkbuf_4
Xhold239 _2891_/Q vssd1 vssd1 vccd1 vccd1 _2922_/D sky130_fd_sc_hd__dlygate4sd3_1
XFILLER_19_390 vssd1 vssd1 vccd1 vccd1 sky130_fd_sc_hd__fill_2
XFILLER_38_143 vssd1 vssd1 vccd1 vccd1 sky130_fd_sc_hd__fill_1
XFILLER_53_113 vssd1 vssd1 vccd1 vccd1 sky130_fd_sc_hd__fill_4
X_2215_ _2202_/A _2198_/Y _2202_/B _2207_/B _2200_/B vssd1 vssd1 vccd1 vccd1 _2216_/B
+ sky130_fd_sc_hd__o311a_2
X_2146_ hold428/X hold376/X _2153_/S vssd1 vssd1 vccd1 vccd1 _2704_/D sky130_fd_sc_hd__mux2_1
X_2077_ hold523/X _2076_/X _2136_/B vssd1 vssd1 vccd1 vccd1 _2665_/D sky130_fd_sc_hd__mux2_1
XFILLER_55_11 vssd1 vssd1 vccd1 vccd1 sky130_fd_sc_hd__fill_2
XPHY_EDGE_ROW_34_Left_99 vssd1 vssd1 vccd1 vccd1 sky130_fd_sc_hd__decap_3
XFILLER_40_385 vssd1 vssd1 vccd1 vccd1 sky130_fd_sc_hd__fill_1
XTAP_TAPCELL_ROW_10_211 vssd1 vccd1 sky130_fd_sc_hd__tapvpwrvgnd_1
XFILLER_58_9 vssd1 vssd1 vccd1 vccd1 sky130_fd_sc_hd__fill_1
XFILLER_35_113 vssd1 vssd1 vccd1 vccd1 sky130_fd_sc_hd__fill_1
X_2000_ hold474/X _1999_/Y _2071_/B vssd1 vssd1 vccd1 vccd1 _2650_/D sky130_fd_sc_hd__mux2_1
XANTENNA__2093__S _2125_/S vssd1 vssd1 vccd1 vccd1 sky130_fd_sc_hd__diode_2
XTAP_TAPCELL_ROW_33_369 vssd1 vccd1 sky130_fd_sc_hd__tapvpwrvgnd_1
X_2902_ _2902_/CLK _2902_/D load_slew116/X vssd1 vssd1 vccd1 vccd1 _2902_/Q sky130_fd_sc_hd__dfrtp_2
X_2833_ _2845_/CLK _2833_/D _2495_/B2 vssd1 vssd1 vccd1 vccd1 _2833_/Q sky130_fd_sc_hd__dfrtp_2
XFILLER_6_93 vssd1 vssd1 vccd1 vccd1 sky130_fd_sc_hd__fill_2
X_1646_ _2873_/Q _2880_/Q _2876_/Q vssd1 vssd1 vccd1 vccd1 _1651_/C sky130_fd_sc_hd__nor3_2
X_1715_ hold298/X _1714_/X _1721_/S vssd1 vssd1 vccd1 vccd1 _2606_/D sky130_fd_sc_hd__mux2_1
X_2764_ _2765_/CLK _2764_/D fanout137/X vssd1 vssd1 vccd1 vccd1 _2764_/Q sky130_fd_sc_hd__dfrtp_2
X_2695_ _2883_/CLK _2695_/D fanout93/X vssd1 vssd1 vccd1 vccd1 _2695_/Q sky130_fd_sc_hd__dfrtp_2
X_1577_ hold299/X _1581_/A2 _1576_/X vssd1 vssd1 vccd1 vccd1 _2533_/D sky130_fd_sc_hd__a21o_2
XANTENNA_clkbuf_leaf_36_clk_A clkbuf_leaf_4_clk/A vssd1 vssd1 vccd1 vccd1 sky130_fd_sc_hd__diode_2
XTAP_TAPCELL_ROW_49_480 vssd1 vccd1 sky130_fd_sc_hd__tapvpwrvgnd_1
X_2129_ hold437/X _2128_/X _2135_/S vssd1 vssd1 vccd1 vccd1 _2691_/D sky130_fd_sc_hd__mux2_1
XANTENNA__1855__B _2555_/Q vssd1 vssd1 vccd1 vccd1 sky130_fd_sc_hd__diode_2
XANTENNA__1394__A2 _2969_/A vssd1 vssd1 vccd1 vccd1 sky130_fd_sc_hd__diode_2
XANTENNA__1606__B1 _2701_/Q vssd1 vssd1 vccd1 vccd1 sky130_fd_sc_hd__diode_2
XANTENNA__2307__A1_N _2300_/A1 vssd1 vssd1 vccd1 vccd1 sky130_fd_sc_hd__diode_2
XFILLER_56_6 vssd1 vssd1 vccd1 vccd1 sky130_fd_sc_hd__fill_2
X_1500_ _2838_/Q _1533_/B vssd1 vssd1 vccd1 vccd1 _1502_/B sky130_fd_sc_hd__or2_2
X_2480_ _2486_/D _2480_/B vssd1 vssd1 vccd1 vccd1 _2849_/D sky130_fd_sc_hd__and2b_2
X_1293_ _1293_/A _1364_/A _1292_/X vssd1 vssd1 vccd1 vccd1 _1293_/X sky130_fd_sc_hd__or3b_2
X_1362_ _2472_/A vssd1 vssd1 vccd1 vccd1 _1362_/Y sky130_fd_sc_hd__inv_2
X_1431_ _1450_/A1 _1429_/X _1430_/Y _1450_/B1 hold521/X vssd1 vssd1 vccd1 vccd1 _2901_/D
+ sky130_fd_sc_hd__a32o_2
XANTENNA__1720__S _1722_/S vssd1 vssd1 vccd1 vccd1 sky130_fd_sc_hd__diode_2
XTAP_TAPCELL_ROW_38_406 vssd1 vccd1 sky130_fd_sc_hd__tapvpwrvgnd_1
XTAP_TAPCELL_ROW_46_461 vssd1 vccd1 sky130_fd_sc_hd__tapvpwrvgnd_1
XFILLER_31_171 vssd1 vssd1 vccd1 vccd1 sky130_fd_sc_hd__fill_2
X_2816_ clkload4/A _2816_/D fanout88/X vssd1 vssd1 vccd1 vccd1 _2816_/Q sky130_fd_sc_hd__dfrtp_2
X_1629_ _2644_/Q _1716_/S _1384_/B _2708_/Q vssd1 vssd1 vccd1 vccd1 _1629_/X sky130_fd_sc_hd__a22o_2
X_2747_ _2765_/CLK _2747_/D load_slew136/X vssd1 vssd1 vccd1 vccd1 _2747_/Q sky130_fd_sc_hd__dfrtp_2
X_2678_ _2693_/CLK _2678_/D fanout98/X vssd1 vssd1 vccd1 vccd1 _2678_/Q sky130_fd_sc_hd__dfrtp_2
XANTENNA_input3_A gpio_in[1] vssd1 vssd1 vccd1 vccd1 sky130_fd_sc_hd__diode_2
XFILLER_36_35 vssd1 vssd1 vccd1 vccd1 sky130_fd_sc_hd__fill_1
XFILLER_37_219 vssd1 vssd1 vccd1 vccd1 sky130_fd_sc_hd__fill_4
XFILLER_13_171 vssd1 vssd1 vccd1 vccd1 sky130_fd_sc_hd__fill_1
XTAP_TAPCELL_ROW_43_442 vssd1 vccd1 sky130_fd_sc_hd__tapvpwrvgnd_1
X_1980_ _1929_/Y _1979_/A _1979_/B _2042_/B vssd1 vssd1 vccd1 vccd1 _2049_/A sky130_fd_sc_hd__o31a_2
XFILLER_54_3 vssd1 vssd1 vccd1 vccd1 sky130_fd_sc_hd__fill_4
XFILLER_5_370 vssd1 vssd1 vccd1 vccd1 sky130_fd_sc_hd__fill_1
XPHY_EDGE_ROW_21_Left_86 vssd1 vssd1 vccd1 vccd1 sky130_fd_sc_hd__decap_3
X_2601_ _2642_/CLK _2601_/D vssd1 vssd1 vccd1 vccd1 _2601_/Q sky130_fd_sc_hd__dfxtp_2
X_2532_ clkload8/A _2532_/D vssd1 vssd1 vccd1 vccd1 _2532_/Q sky130_fd_sc_hd__dfxtp_2
X_2463_ _2463_/A _2463_/B vssd1 vssd1 vccd1 vccd1 _2843_/D sky130_fd_sc_hd__nand2_2
X_1276_ _1274_/X _1275_/X _2910_/Q vssd1 vssd1 vccd1 vccd1 _1276_/X sky130_fd_sc_hd__o21a_2
X_1345_ _1309_/X _1341_/X _1343_/X _2741_/Q _1344_/X vssd1 vssd1 vccd1 vccd1 _1345_/X
+ sky130_fd_sc_hd__o221a_2
X_1414_ _1280_/Y _2969_/A _1413_/Y _1280_/B vssd1 vssd1 vccd1 vccd1 _1414_/X sky130_fd_sc_hd__a22o_2
X_2394_ _2822_/Q _2400_/C vssd1 vssd1 vccd1 vccd1 _2398_/C sky130_fd_sc_hd__and2_2
XANTENNA__1597__A2 _2699_/Q vssd1 vssd1 vccd1 vccd1 sky130_fd_sc_hd__diode_2
XFILLER_22_15 vssd1 vssd1 vccd1 vccd1 sky130_fd_sc_hd__fill_1
XFILLER_3_318 vssd1 vssd1 vccd1 vccd1 sky130_fd_sc_hd__fill_2
Xfanout165 _1662_/D vssd1 vssd1 vccd1 vccd1 _1580_/A sky130_fd_sc_hd__clkdlybuf4s25_1
Xfanout154 _2882_/Q vssd1 vssd1 vccd1 vccd1 _2071_/B sky130_fd_sc_hd__clkdlybuf4s25_1
Xfanout143 fanout144/X vssd1 vssd1 vccd1 vccd1 fanout143/X sky130_fd_sc_hd__clkdlybuf4s25_1
Xfanout132 fanout145/X vssd1 vssd1 vccd1 vccd1 fanout132/X sky130_fd_sc_hd__clkdlybuf4s25_1
XANTENNA_fanout61_A _1662_/X vssd1 vssd1 vccd1 vccd1 sky130_fd_sc_hd__diode_2
Xfanout187 _2815_/Q vssd1 vssd1 vccd1 vccd1 _2389_/B sky130_fd_sc_hd__clkdlybuf4s25_1
Xfanout176 _2870_/Q vssd1 vssd1 vccd1 vccd1 _2297_/A1 sky130_fd_sc_hd__clkdlybuf4s25_1
XFILLER_10_141 vssd1 vssd1 vccd1 vccd1 sky130_fd_sc_hd__fill_2
XFILLER_42_233 vssd1 vssd1 vccd1 vccd1 sky130_fd_sc_hd__fill_1
XFILLER_63_55 vssd1 vssd1 vccd1 vccd1 sky130_fd_sc_hd__fill_1
XTAP_TAPCELL_ROW_40_423 vssd1 vccd1 sky130_fd_sc_hd__tapvpwrvgnd_1
XFILLER_2_373 vssd1 vssd1 vccd1 vccd1 sky130_fd_sc_hd__fill_2
X_1894_ _2643_/Q _1893_/X _1909_/S vssd1 vssd1 vccd1 vccd1 _2643_/D sky130_fd_sc_hd__mux2_1
X_1963_ _1963_/A _2681_/Q vssd1 vssd1 vccd1 vccd1 _1989_/B sky130_fd_sc_hd__xor2_2
X_2515_ _2517_/B _2515_/B vssd1 vssd1 vccd1 vccd1 _2863_/D sky130_fd_sc_hd__nor2_2
X_2446_ _2462_/B _2445_/Y _2441_/Y vssd1 vssd1 vccd1 vccd1 _2838_/D sky130_fd_sc_hd__o21ai_2
XFILLER_17_37 vssd1 vssd1 vccd1 vccd1 sky130_fd_sc_hd__fill_1
XTAP_TAPCELL_ROW_3_159 vssd1 vccd1 sky130_fd_sc_hd__tapvpwrvgnd_1
XTAP_TAPCELL_ROW_54_515 vssd1 vccd1 sky130_fd_sc_hd__tapvpwrvgnd_1
X_1259_ _2734_/Q vssd1 vssd1 vccd1 vccd1 _1325_/A sky130_fd_sc_hd__inv_2
X_1328_ _1330_/B _1328_/B vssd1 vssd1 vccd1 vccd1 _1328_/X sky130_fd_sc_hd__or2_2
X_2377_ _2375_/A _2375_/B _2378_/B _2361_/Y _2378_/A vssd1 vssd1 vccd1 vccd1 _2377_/X
+ sky130_fd_sc_hd__a41o_2
XANTENNA_fanout151_X _2882_/D vssd1 vssd1 vccd1 vccd1 sky130_fd_sc_hd__diode_2
XANTENNA_fanout64_X _1693_/S vssd1 vssd1 vccd1 vccd1 sky130_fd_sc_hd__diode_2
XFILLER_15_200 vssd1 vssd1 vccd1 vccd1 sky130_fd_sc_hd__fill_4
XFILLER_15_288 vssd1 vssd1 vccd1 vccd1 sky130_fd_sc_hd__fill_1
XFILLER_30_214 vssd1 vssd1 vccd1 vccd1 sky130_fd_sc_hd__fill_2
XANTENNA__1733__A2 _2555_/Q vssd1 vssd1 vccd1 vccd1 sky130_fd_sc_hd__diode_2
X_2300_ _2300_/A1 _1312_/B _1316_/Y _2299_/Y vssd1 vssd1 vccd1 vccd1 _2776_/D sky130_fd_sc_hd__o31ai_2
X_2231_ _2231_/A _2231_/B vssd1 vssd1 vccd1 vccd1 _2232_/B sky130_fd_sc_hd__or2_2
X_2162_ hold266/X hold246/X _2168_/S vssd1 vssd1 vccd1 vccd1 _2718_/D sky130_fd_sc_hd__mux2_1
X_2093_ hold504/X _2092_/X _2125_/S vssd1 vssd1 vccd1 vccd1 _2673_/D sky130_fd_sc_hd__mux2_1
XTAP_TAPCELL_ROW_16_250 vssd1 vccd1 sky130_fd_sc_hd__tapvpwrvgnd_1
X_1877_ _2639_/Q _1877_/B vssd1 vssd1 vccd1 vccd1 _1878_/B sky130_fd_sc_hd__nor2_2
X_1946_ _2671_/Q _1946_/B _1946_/C vssd1 vssd1 vccd1 vccd1 _2019_/B sky130_fd_sc_hd__nand3_2
X_2429_ _2834_/Q _2431_/C vssd1 vssd1 vccd1 vccd1 _2429_/Y sky130_fd_sc_hd__xnor2_2
XTAP_TAPCELL_ROW_22_297 vssd1 vccd1 sky130_fd_sc_hd__tapvpwrvgnd_1
XFILLER_50_309 vssd1 vssd1 vccd1 vccd1 sky130_fd_sc_hd__fill_1
XTAP_TAPCELL_ROW_13_231 vssd1 vccd1 sky130_fd_sc_hd__tapvpwrvgnd_1
X_1800_ _1808_/C _1800_/B vssd1 vssd1 vccd1 vccd1 _1800_/Y sky130_fd_sc_hd__nor2_2
X_1662_ _2561_/Q _2560_/Q _1662_/C _1662_/D vssd1 vssd1 vccd1 vccd1 _1662_/X sky130_fd_sc_hd__and4b_2
X_1731_ _2876_/Q _1756_/B _1821_/B _1813_/B vssd1 vssd1 vccd1 vccd1 _1731_/Y sky130_fd_sc_hd__o31ai_2
X_2780_ _2801_/CLK _2780_/D fanout115/X vssd1 vssd1 vccd1 vccd1 _2780_/Q sky130_fd_sc_hd__dfrtp_2
XANTENNA__1723__S _1723_/S vssd1 vssd1 vccd1 vccd1 sky130_fd_sc_hd__diode_2
X_1593_ _2617_/Q _2634_/Q _1702_/S vssd1 vssd1 vccd1 vccd1 _1593_/X sky130_fd_sc_hd__mux2_1
Xload_slew121 fanout120/X vssd1 vssd1 vccd1 vccd1 load_slew121/X sky130_fd_sc_hd__buf_2
Xload_slew110 fanout109/X vssd1 vssd1 vccd1 vccd1 _2335_/B1 sky130_fd_sc_hd__buf_4
X_2214_ _2212_/Y _2214_/B vssd1 vssd1 vccd1 vccd1 _2217_/A sky130_fd_sc_hd__and2b_2
XANTENNA__1890__A1 _2706_/Q vssd1 vssd1 vccd1 vccd1 sky130_fd_sc_hd__diode_2
XFILLER_26_306 vssd1 vssd1 vccd1 vccd1 sky130_fd_sc_hd__fill_2
XFILLER_26_317 vssd1 vssd1 vccd1 vccd1 sky130_fd_sc_hd__fill_1
XFILLER_38_122 vssd1 vssd1 vccd1 vccd1 sky130_fd_sc_hd__fill_4
XFILLER_38_188 vssd1 vssd1 vccd1 vccd1 sky130_fd_sc_hd__fill_8
Xload_slew90 fanout89/X vssd1 vssd1 vccd1 vccd1 _2473_/A1 sky130_fd_sc_hd__clkbuf_4
Xclkbuf_3_5__f_clk clkbuf_0_clk/X vssd1 vssd1 vccd1 vccd1 clkbuf_3_5__f_clk/X sky130_fd_sc_hd__clkbuf_16
X_2145_ _2703_/Q hold439/X _2153_/S vssd1 vssd1 vccd1 vccd1 _2703_/D sky130_fd_sc_hd__mux2_1
X_2076_ _2578_/Q _2562_/Q _2120_/S vssd1 vssd1 vccd1 vccd1 _2076_/X sky130_fd_sc_hd__mux2_1
XFILLER_61_180 vssd1 vssd1 vccd1 vccd1 sky130_fd_sc_hd__fill_1
XTAP_TAPCELL_ROW_36_389 vssd1 vccd1 sky130_fd_sc_hd__tapvpwrvgnd_1
X_1929_ _1930_/B _1930_/C _2675_/Q vssd1 vssd1 vccd1 vccd1 _1929_/Y sky130_fd_sc_hd__a21oi_2
XFILLER_39_24 vssd1 vssd1 vccd1 vccd1 sky130_fd_sc_hd__fill_1
XFILLER_39_57 vssd1 vssd1 vccd1 vccd1 sky130_fd_sc_hd__fill_1
XANTENNA__1633__A1 _2645_/Q vssd1 vssd1 vccd1 vccd1 sky130_fd_sc_hd__diode_2
XANTENNA__1633__B2 _1589_/X vssd1 vssd1 vccd1 vccd1 sky130_fd_sc_hd__diode_2
XANTENNA__1869__A _2701_/Q vssd1 vssd1 vccd1 vccd1 sky130_fd_sc_hd__diode_2
XTAP_TAPCELL_ROW_10_212 vssd1 vccd1 sky130_fd_sc_hd__tapvpwrvgnd_1
XANTENNA__1872__A1 _2637_/Q vssd1 vssd1 vccd1 vccd1 sky130_fd_sc_hd__diode_2
X_2901_ _2912_/CLK _2901_/D load_slew116/X vssd1 vssd1 vccd1 vccd1 _2901_/Q sky130_fd_sc_hd__dfrtp_2
X_2832_ clkload1/A _2832_/D load_slew83/X vssd1 vssd1 vccd1 vccd1 _2832_/Q sky130_fd_sc_hd__dfrtp_2
X_2763_ _2765_/CLK _2763_/D fanout137/X vssd1 vssd1 vccd1 vccd1 _2763_/Q sky130_fd_sc_hd__dfrtp_2
XANTENNA__1718__S _1722_/S vssd1 vssd1 vccd1 vccd1 sky130_fd_sc_hd__diode_2
X_1576_ _1580_/A _2645_/Q _1701_/S vssd1 vssd1 vccd1 vccd1 _1576_/X sky130_fd_sc_hd__and3_2
X_1645_ hold359/X _1589_/X _1644_/X vssd1 vssd1 vccd1 vccd1 _2552_/D sky130_fd_sc_hd__a21o_2
X_1714_ _2626_/Q _2643_/Q _1716_/S vssd1 vssd1 vccd1 vccd1 _1714_/X sky130_fd_sc_hd__mux2_1
X_2694_ _2694_/CLK _2694_/D fanout102/X vssd1 vssd1 vccd1 vccd1 _2694_/Q sky130_fd_sc_hd__dfrtp_2
XANTENNA__1615__A1 _2640_/Q vssd1 vssd1 vccd1 vccd1 sky130_fd_sc_hd__diode_2
XTAP_TAPCELL_ROW_49_481 vssd1 vccd1 sky130_fd_sc_hd__tapvpwrvgnd_1
X_2128_ _2573_/Q _2589_/Q _2130_/S vssd1 vssd1 vccd1 vccd1 _2128_/X sky130_fd_sc_hd__mux2_1
X_2059_ _2057_/A _2056_/B _2056_/A vssd1 vssd1 vccd1 vccd1 _2062_/A sky130_fd_sc_hd__o21ai_2
XFILLER_1_279 vssd1 vssd1 vccd1 vccd1 sky130_fd_sc_hd__fill_1
XFILLER_17_169 vssd1 vssd1 vccd1 vccd1 sky130_fd_sc_hd__fill_4
XANTENNA__1606__A1 _1624_/S vssd1 vssd1 vccd1 vccd1 sky130_fd_sc_hd__diode_2
XFILLER_9_335 vssd1 vssd1 vccd1 vccd1 sky130_fd_sc_hd__fill_1
X_1430_ _2901_/Q _1437_/D vssd1 vssd1 vccd1 vccd1 _1430_/Y sky130_fd_sc_hd__nand2_2
XTAP_TAPCELL_ROW_38_407 vssd1 vccd1 sky130_fd_sc_hd__tapvpwrvgnd_1
X_1292_ _2893_/Q _2969_/A _2895_/Q _2896_/Q _2894_/Q vssd1 vssd1 vccd1 vccd1 _1292_/X
+ sky130_fd_sc_hd__a2111o_2
X_1361_ input6/X input1/X vssd1 vssd1 vccd1 vccd1 _2470_/D sky130_fd_sc_hd__nand2_2
XTAP_TAPCELL_ROW_46_462 vssd1 vccd1 sky130_fd_sc_hd__tapvpwrvgnd_1
XFILLER_31_183 vssd1 vssd1 vccd1 vccd1 sky130_fd_sc_hd__fill_1
XFILLER_31_194 vssd1 vssd1 vccd1 vccd1 sky130_fd_sc_hd__fill_1
X_2815_ clkload4/A _2815_/D fanout86/X vssd1 vssd1 vccd1 vccd1 _2815_/Q sky130_fd_sc_hd__dfrtp_2
X_2746_ _2804_/CLK _2746_/D load_slew134/X vssd1 vssd1 vccd1 vccd1 _2746_/Q sky130_fd_sc_hd__dfrtp_2
X_1559_ hold327/X _1724_/S _1558_/X vssd1 vssd1 vccd1 vccd1 _2524_/D sky130_fd_sc_hd__o21a_2
X_1628_ _2626_/Q _1585_/X _1589_/X hold406/X _1627_/X vssd1 vssd1 vccd1 vccd1 _2547_/D
+ sky130_fd_sc_hd__a221o_2
X_2677_ _2693_/CLK _2677_/D fanout98/X vssd1 vssd1 vccd1 vccd1 _2677_/Q sky130_fd_sc_hd__dfrtp_2
XANTENNA__1558__C_N _1582_/A vssd1 vssd1 vccd1 vccd1 sky130_fd_sc_hd__diode_2
XANTENNA__1911__S _2071_/B vssd1 vssd1 vccd1 vccd1 sky130_fd_sc_hd__diode_2
XFILLER_10_334 vssd1 vssd1 vccd1 vccd1 sky130_fd_sc_hd__fill_1
XFILLER_14_139 vssd1 vssd1 vccd1 vccd1 sky130_fd_sc_hd__fill_1
XFILLER_52_24 vssd1 vssd1 vccd1 vccd1 sky130_fd_sc_hd__fill_4
XANTENNA__2189__S _2189_/S vssd1 vssd1 vccd1 vccd1 sky130_fd_sc_hd__diode_2
Xhold390 _2900_/Q vssd1 vssd1 vccd1 vccd1 hold390/X sky130_fd_sc_hd__dlygate4sd3_1
XTAP_TAPCELL_ROW_43_443 vssd1 vccd1 sky130_fd_sc_hd__tapvpwrvgnd_1
XFILLER_9_110 vssd1 vssd1 vccd1 vccd1 sky130_fd_sc_hd__fill_2
XFILLER_9_165 vssd1 vssd1 vccd1 vccd1 sky130_fd_sc_hd__fill_2
X_2600_ _2719_/CLK _2600_/D vssd1 vssd1 vccd1 vccd1 _2600_/Q sky130_fd_sc_hd__dfxtp_2
XANTENNA__2099__S _2125_/S vssd1 vssd1 vccd1 vccd1 sky130_fd_sc_hd__diode_2
XANTENNA_clkbuf_leaf_35_clk_A clkbuf_leaf_4_clk/A vssd1 vssd1 vccd1 vccd1 sky130_fd_sc_hd__diode_2
X_1413_ _1413_/A _1413_/B vssd1 vssd1 vccd1 vccd1 _1413_/Y sky130_fd_sc_hd__nand2_2
X_2531_ _2719_/CLK _2531_/D vssd1 vssd1 vccd1 vccd1 _2531_/Q sky130_fd_sc_hd__dfxtp_2
X_2462_ _2464_/B _2462_/B _2460_/X vssd1 vssd1 vccd1 vccd1 _2463_/B sky130_fd_sc_hd__or3b_2
X_2393_ _2822_/Q _2400_/C vssd1 vssd1 vccd1 vccd1 _2395_/A sky130_fd_sc_hd__nor2_2
XFILLER_3_73 vssd1 vssd1 vccd1 vccd1 sky130_fd_sc_hd__fill_1
X_1275_ _2906_/Q _2908_/Q _2907_/Q _2909_/Q vssd1 vssd1 vccd1 vccd1 _1275_/X sky130_fd_sc_hd__or4_2
X_1344_ _2740_/Q _1344_/B vssd1 vssd1 vccd1 vccd1 _1344_/X sky130_fd_sc_hd__or2_2
XANTENNA_fanout141_A fanout144/X vssd1 vssd1 vccd1 vccd1 sky130_fd_sc_hd__diode_2
XFILLER_51_245 vssd1 vssd1 vccd1 vccd1 sky130_fd_sc_hd__fill_1
X_2729_ _2813_/CLK _2729_/D load_slew112/X vssd1 vssd1 vccd1 vccd1 _2729_/Q sky130_fd_sc_hd__dfrtp_2
XFILLER_47_24 vssd1 vssd1 vccd1 vccd1 sky130_fd_sc_hd__fill_4
XTAP_TAPCELL_ROW_6_179 vssd1 vccd1 sky130_fd_sc_hd__tapvpwrvgnd_1
Xfanout188 _2814_/Q vssd1 vssd1 vccd1 vccd1 _2375_/A sky130_fd_sc_hd__clkdlybuf4s25_1
Xfanout177 _2186_/S vssd1 vssd1 vccd1 vccd1 _2180_/S sky130_fd_sc_hd__clkdlybuf4s25_1
Xfanout166 _2875_/Q vssd1 vssd1 vccd1 vccd1 _1662_/D sky130_fd_sc_hd__clkdlybuf4s25_1
Xfanout155 _1722_/S vssd1 vssd1 vccd1 vccd1 _1822_/A sky130_fd_sc_hd__clkdlybuf4s25_1
Xfanout144 fanout145/X vssd1 vssd1 vccd1 vccd1 fanout144/X sky130_fd_sc_hd__clkdlybuf4s25_1
Xfanout133 fanout137/X vssd1 vssd1 vccd1 vccd1 fanout133/X sky130_fd_sc_hd__clkdlybuf4s25_1
Xfanout122 fanout125/X vssd1 vssd1 vccd1 vccd1 fanout122/X sky130_fd_sc_hd__clkdlybuf4s25_1
Xfanout111 fanout111/A vssd1 vssd1 vccd1 vccd1 fanout111/X sky130_fd_sc_hd__clkdlybuf4s25_1
Xfanout100 fanout105/X vssd1 vssd1 vccd1 vccd1 fanout100/X sky130_fd_sc_hd__clkdlybuf4s25_1
XANTENNA__2306__A1_N _2300_/A1 vssd1 vssd1 vccd1 vccd1 sky130_fd_sc_hd__diode_2
XFILLER_47_57 vssd1 vssd1 vccd1 vccd1 sky130_fd_sc_hd__fill_1
XPHY_EDGE_ROW_29_Right_29 vssd1 vssd1 vccd1 vccd1 sky130_fd_sc_hd__decap_3
XFILLER_6_113 vssd1 vssd1 vccd1 vccd1 sky130_fd_sc_hd__fill_2
XFILLER_8_18 vssd1 vssd1 vccd1 vccd1 sky130_fd_sc_hd__fill_1
XPHY_EDGE_ROW_38_Right_38 vssd1 vssd1 vccd1 vccd1 sky130_fd_sc_hd__decap_3
XFILLER_10_197 vssd1 vssd1 vccd1 vccd1 sky130_fd_sc_hd__fill_4
XFILLER_2_363 vssd1 vssd1 vccd1 vccd1 sky130_fd_sc_hd__fill_1
XPHY_EDGE_ROW_47_Right_47 vssd1 vssd1 vccd1 vccd1 sky130_fd_sc_hd__decap_3
XPHY_EDGE_ROW_56_Right_56 vssd1 vssd1 vccd1 vccd1 sky130_fd_sc_hd__decap_3
X_1962_ _2667_/Q _1962_/B _1962_/C vssd1 vssd1 vccd1 vccd1 _1997_/B sky130_fd_sc_hd__nand3_2
X_1893_ _2707_/Q _1908_/A2 _1892_/X _1900_/C vssd1 vssd1 vccd1 vccd1 _1893_/X sky130_fd_sc_hd__a22o_2
X_2514_ _2862_/Q _2513_/C hold260/X vssd1 vssd1 vccd1 vccd1 _2514_/Y sky130_fd_sc_hd__a21oi_2
X_2445_ _2445_/A _2448_/B vssd1 vssd1 vccd1 vccd1 _2445_/Y sky130_fd_sc_hd__nand2_2
X_2376_ _2376_/A _2381_/B vssd1 vssd1 vccd1 vccd1 _2815_/D sky130_fd_sc_hd__nor2_2
XTAP_TAPCELL_ROW_19_270 vssd1 vccd1 sky130_fd_sc_hd__tapvpwrvgnd_1
XTAP_TAPCELL_ROW_54_516 vssd1 vccd1 sky130_fd_sc_hd__tapvpwrvgnd_1
X_1258_ _2922_/Q vssd1 vssd1 vccd1 vccd1 _1258_/Y sky130_fd_sc_hd__inv_2
X_1327_ _2796_/Q _1327_/B vssd1 vssd1 vccd1 vccd1 _1328_/B sky130_fd_sc_hd__nor2_2
XANTENNA_fanout144_X fanout144/X vssd1 vssd1 vccd1 vccd1 sky130_fd_sc_hd__diode_2
XPHY_EDGE_ROW_49_Left_114 vssd1 vssd1 vccd1 vccd1 sky130_fd_sc_hd__decap_3
XTAP_TAPCELL_ROW_62_571 vssd1 vccd1 sky130_fd_sc_hd__tapvpwrvgnd_1
XANTENNA__1863__C _1863_/C vssd1 vssd1 vccd1 vccd1 sky130_fd_sc_hd__diode_2
XFILLER_59_164 vssd1 vssd1 vccd1 vccd1 sky130_fd_sc_hd__fill_4
XPHY_EDGE_ROW_58_Left_123 vssd1 vssd1 vccd1 vccd1 sky130_fd_sc_hd__decap_3
XANTENNA__2143__A0 _2701_/Q vssd1 vssd1 vccd1 vccd1 sky130_fd_sc_hd__diode_2
X_2230_ _2216_/A _2212_/Y _2216_/B _2222_/B _2214_/B vssd1 vssd1 vccd1 vccd1 _2231_/B
+ sky130_fd_sc_hd__o311a_2
XFILLER_0_85 vssd1 vssd1 vccd1 vccd1 sky130_fd_sc_hd__fill_2
X_2161_ hold310/X hold264/X _2168_/S vssd1 vssd1 vccd1 vccd1 _2717_/D sky130_fd_sc_hd__mux2_1
X_2092_ _2586_/Q _2570_/Q _2130_/S vssd1 vssd1 vccd1 vccd1 _2092_/X sky130_fd_sc_hd__mux2_1
XFILLER_9_83 vssd1 vssd1 vccd1 vccd1 sky130_fd_sc_hd__fill_1
XTAP_TAPCELL_ROW_16_251 vssd1 vccd1 sky130_fd_sc_hd__tapvpwrvgnd_1
X_1945_ _1946_/B _1946_/C _2671_/Q vssd1 vssd1 vccd1 vccd1 _1945_/Y sky130_fd_sc_hd__a21oi_2
XANTENNA_fanout104_A fanout105/X vssd1 vssd1 vccd1 vccd1 sky130_fd_sc_hd__diode_2
X_1876_ _2638_/Q _1875_/X _1891_/S vssd1 vssd1 vccd1 vccd1 _2638_/D sky130_fd_sc_hd__mux2_1
X_2428_ _2462_/B _2427_/X _2424_/Y vssd1 vssd1 vccd1 vccd1 _2833_/D sky130_fd_sc_hd__o21ai_2
X_2359_ _2851_/Q _2853_/Q _2852_/Q _2850_/Q vssd1 vssd1 vccd1 vccd1 _2363_/C sky130_fd_sc_hd__or4bb_2
XFILLER_12_215 vssd1 vssd1 vccd1 vccd1 sky130_fd_sc_hd__fill_1
XFILLER_47_167 vssd1 vssd1 vccd1 vccd1 sky130_fd_sc_hd__fill_1
XTAP_TAPCELL_ROW_13_232 vssd1 vccd1 sky130_fd_sc_hd__tapvpwrvgnd_1
X_1592_ _2634_/Q _1702_/S _1590_/A vssd1 vssd1 vccd1 vccd1 _1592_/X sky130_fd_sc_hd__a21o_2
X_1661_ _2812_/Q hold409/X _1661_/S vssd1 vssd1 vccd1 vccd1 _1661_/X sky130_fd_sc_hd__mux2_1
X_1730_ _2876_/Q _1756_/B _1821_/B _1813_/B vssd1 vssd1 vccd1 vccd1 _1730_/X sky130_fd_sc_hd__o31a_2
XFILLER_38_112 vssd1 vssd1 vccd1 vccd1 sky130_fd_sc_hd__fill_2
XFILLER_38_134 vssd1 vssd1 vccd1 vccd1 sky130_fd_sc_hd__fill_4
X_2213_ _2764_/Q _2718_/Q vssd1 vssd1 vccd1 vccd1 _2214_/B sky130_fd_sc_hd__nand2_2
X_2144_ hold419/X hold374/X _2153_/S vssd1 vssd1 vccd1 vccd1 _2702_/D sky130_fd_sc_hd__mux2_1
X_2075_ _2577_/Q _2075_/B vssd1 vssd1 vccd1 vccd1 _2075_/Y sky130_fd_sc_hd__nand2_2
XFILLER_30_27 vssd1 vssd1 vccd1 vccd1 sky130_fd_sc_hd__fill_1
X_1859_ _1831_/C _1831_/B _1830_/Y vssd1 vssd1 vccd1 vccd1 _1859_/X sky130_fd_sc_hd__a21bo_2
X_1928_ _1940_/A _2690_/Q vssd1 vssd1 vccd1 vccd1 _1930_/C sky130_fd_sc_hd__nand2_2
XFILLER_1_406 vssd1 vssd1 vccd1 vccd1 sky130_fd_sc_hd__fill_1
XFILLER_29_167 vssd1 vssd1 vccd1 vccd1 sky130_fd_sc_hd__fill_1
XFILLER_44_115 vssd1 vssd1 vccd1 vccd1 sky130_fd_sc_hd__fill_2
XFILLER_44_137 vssd1 vssd1 vccd1 vccd1 sky130_fd_sc_hd__fill_2
XFILLER_55_13 vssd1 vssd1 vccd1 vccd1 sky130_fd_sc_hd__fill_1
XFILLER_55_57 vssd1 vssd1 vccd1 vccd1 sky130_fd_sc_hd__fill_4
XANTENNA__1885__A _2641_/Q vssd1 vssd1 vccd1 vccd1 sky130_fd_sc_hd__diode_2
XTAP_TAPCELL_ROW_10_213 vssd1 vccd1 sky130_fd_sc_hd__tapvpwrvgnd_1
XFILLER_29_80 vssd1 vssd1 vccd1 vccd1 sky130_fd_sc_hd__fill_1
X_2900_ _2902_/CLK _2900_/D fanout117/X vssd1 vssd1 vccd1 vccd1 _2900_/Q sky130_fd_sc_hd__dfrtp_2
X_1713_ hold253/X _1712_/X _1721_/S vssd1 vssd1 vccd1 vccd1 _2605_/D sky130_fd_sc_hd__mux2_1
X_2831_ clkload1/A _2831_/D _2495_/B2 vssd1 vssd1 vccd1 vccd1 _2831_/Q sky130_fd_sc_hd__dfrtp_2
X_2762_ _2765_/CLK _2762_/D load_slew136/X vssd1 vssd1 vccd1 vccd1 _2762_/Q sky130_fd_sc_hd__dfrtp_2
X_1575_ hold290/X _1581_/A2 _1574_/X vssd1 vssd1 vccd1 vccd1 _2532_/D sky130_fd_sc_hd__a21o_2
X_1644_ _1624_/S _1641_/X _1642_/X _1643_/X vssd1 vssd1 vccd1 vccd1 _1644_/X sky130_fd_sc_hd__a31o_2
X_2693_ _2693_/CLK _2693_/D fanout98/X vssd1 vssd1 vccd1 vccd1 _2693_/Q sky130_fd_sc_hd__dfrtp_2
XTAP_TAPCELL_ROW_49_482 vssd1 vccd1 sky130_fd_sc_hd__tapvpwrvgnd_1
X_2127_ hold434/X _2126_/X _2135_/S vssd1 vssd1 vccd1 vccd1 _2690_/D sky130_fd_sc_hd__mux2_1
XFILLER_25_38 vssd1 vssd1 vccd1 vccd1 sky130_fd_sc_hd__fill_2
XTAP_TAPCELL_ROW_24_305 vssd1 vccd1 sky130_fd_sc_hd__tapvpwrvgnd_1
X_2058_ hold491/X _2057_/Y _2071_/B vssd1 vssd1 vccd1 vccd1 _2660_/D sky130_fd_sc_hd__mux2_1
XANTENNA__2328__B1 _2156_/B vssd1 vssd1 vccd1 vccd1 sky130_fd_sc_hd__diode_2
XANTENNA_clkbuf_3_5__f_clk_A clkbuf_0_clk/X vssd1 vssd1 vccd1 vccd1 sky130_fd_sc_hd__diode_2
XANTENNA_fanout84_A fanout99/A vssd1 vssd1 vccd1 vccd1 sky130_fd_sc_hd__diode_2
XFILLER_1_225 vssd1 vssd1 vccd1 vccd1 sky130_fd_sc_hd__fill_2
Xhold550 _2813_/Q vssd1 vssd1 vccd1 vccd1 _1263_/A sky130_fd_sc_hd__dlygate4sd3_1
XFILLER_15_82 vssd1 vssd1 vccd1 vccd1 sky130_fd_sc_hd__fill_1
XFILLER_31_81 vssd1 vssd1 vccd1 vccd1 sky130_fd_sc_hd__fill_1
XFILLER_56_8 vssd1 vssd1 vccd1 vccd1 sky130_fd_sc_hd__fill_1
X_1360_ _2881_/Q hold336/X _1359_/B vssd1 vssd1 vccd1 vccd1 _2881_/D sky130_fd_sc_hd__o21ba_2
XFILLER_63_221 vssd1 vssd1 vccd1 vccd1 sky130_fd_sc_hd__fill_1
XTAP_TAPCELL_ROW_38_408 vssd1 vccd1 sky130_fd_sc_hd__tapvpwrvgnd_1
X_1291_ _2969_/A _2470_/C vssd1 vssd1 vccd1 vccd1 _2370_/A sky130_fd_sc_hd__or2_2
Xteam_06_193 vssd1 vssd1 vccd1 vccd1 team_06_193/HI gpio_oeb[5] sky130_fd_sc_hd__conb_1
XANTENNA_clkbuf_leaf_9_clk_A clkbuf_leaf_9_clk/A vssd1 vssd1 vccd1 vccd1 sky130_fd_sc_hd__diode_2
XTAP_TAPCELL_ROW_46_463 vssd1 vccd1 sky130_fd_sc_hd__tapvpwrvgnd_1
XFILLER_31_173 vssd1 vssd1 vccd1 vccd1 sky130_fd_sc_hd__fill_1
X_2814_ clkload4/A _2814_/D fanout88/X vssd1 vssd1 vccd1 vccd1 _2814_/Q sky130_fd_sc_hd__dfrtp_2
X_2745_ _2804_/CLK _2745_/D load_slew134/X vssd1 vssd1 vccd1 vccd1 _2745_/Q sky130_fd_sc_hd__dfrtp_2
X_2676_ _2693_/CLK _2676_/D load_slew97/X vssd1 vssd1 vccd1 vccd1 _2676_/Q sky130_fd_sc_hd__dfrtp_2
XANTENNA__1781__B2 _2705_/Q vssd1 vssd1 vccd1 vccd1 sky130_fd_sc_hd__diode_2
X_1489_ _2375_/A _2375_/B _2378_/A _2817_/Q vssd1 vssd1 vccd1 vccd1 _1538_/A sky130_fd_sc_hd__or4_2
X_1558_ _2636_/Q _1558_/B _1582_/A vssd1 vssd1 vccd1 vccd1 _1558_/X sky130_fd_sc_hd__or3b_2
X_1627_ _1384_/B _2707_/Q _1626_/X vssd1 vssd1 vccd1 vccd1 _1627_/X sky130_fd_sc_hd__a21o_2
XFILLER_39_251 vssd1 vccd1 vssd1 vccd1 sky130_ef_sc_hd__decap_40_12
XFILLER_10_302 vssd1 vssd1 vccd1 vccd1 sky130_fd_sc_hd__fill_4
XFILLER_22_162 vssd1 vssd1 vccd1 vccd1 sky130_fd_sc_hd__fill_1
XFILLER_22_195 vssd1 vssd1 vccd1 vccd1 sky130_fd_sc_hd__fill_1
XFILLER_6_306 vssd1 vssd1 vccd1 vccd1 sky130_fd_sc_hd__fill_2
Xclkbuf_leaf_34_clk clkbuf_leaf_3_clk/A vssd1 vssd1 vccd1 vccd1 _2880_/CLK sky130_fd_sc_hd__clkbuf_8
Xhold380 _2325_/X vssd1 vssd1 vccd1 vccd1 _2801_/D sky130_fd_sc_hd__dlygate4sd3_1
Xhold391 _2754_/Q vssd1 vssd1 vccd1 vccd1 hold391/X sky130_fd_sc_hd__dlygate4sd3_1
XFILLER_60_246 vssd1 vssd1 vccd1 vccd1 sky130_fd_sc_hd__fill_1
XFILLER_9_100 vssd1 vssd1 vccd1 vccd1 sky130_fd_sc_hd__fill_4
XTAP_TAPCELL_ROW_43_444 vssd1 vccd1 sky130_fd_sc_hd__tapvpwrvgnd_1
Xclkbuf_leaf_25_clk clkbuf_3_5__f_clk/X vssd1 vssd1 vccd1 vccd1 _2869_/CLK sky130_fd_sc_hd__clkbuf_8
X_2530_ _2866_/CLK _2530_/D vssd1 vssd1 vccd1 vccd1 _2530_/Q sky130_fd_sc_hd__dfxtp_2
XFILLER_5_383 vssd1 vssd1 vccd1 vccd1 sky130_fd_sc_hd__fill_1
X_1343_ _1346_/B _1343_/B vssd1 vssd1 vccd1 vccd1 _1343_/X sky130_fd_sc_hd__or2_2
X_1412_ _1413_/B vssd1 vssd1 vccd1 vccd1 _1412_/Y sky130_fd_sc_hd__inv_2
X_2461_ _2843_/Q _2842_/Q _2461_/C vssd1 vssd1 vccd1 vccd1 _2464_/B sky130_fd_sc_hd__and3_2
X_2392_ _2392_/A _2400_/C vssd1 vssd1 vccd1 vccd1 _2821_/D sky130_fd_sc_hd__nor2_2
X_1274_ _2902_/Q _2903_/Q _2904_/Q _2905_/Q vssd1 vssd1 vccd1 vccd1 _1274_/X sky130_fd_sc_hd__o31a_2
Xclkbuf_leaf_16_clk clkbuf_3_6__f_clk/X vssd1 vssd1 vccd1 vccd1 _2774_/CLK sky130_fd_sc_hd__clkbuf_8
X_2728_ _2774_/CLK _2728_/D fanout132/X vssd1 vssd1 vccd1 vccd1 _2728_/Q sky130_fd_sc_hd__dfrtp_2
X_2659_ _2689_/CLK _2659_/D fanout98/X vssd1 vssd1 vccd1 vccd1 _2659_/Q sky130_fd_sc_hd__dfrtp_2
XTAP_TAPCELL_ROW_57_536 vssd1 vccd1 sky130_fd_sc_hd__tapvpwrvgnd_1
Xfanout189 _2695_/Q vssd1 vssd1 vccd1 vccd1 _1963_/A sky130_fd_sc_hd__clkdlybuf4s25_1
Xfanout178 _2189_/S vssd1 vssd1 vccd1 vccd1 _2186_/S sky130_fd_sc_hd__clkdlybuf4s25_1
Xfanout167 _2874_/Q vssd1 vssd1 vccd1 vccd1 _1770_/C sky130_fd_sc_hd__clkdlybuf4s25_1
Xfanout156 _1722_/S vssd1 vssd1 vccd1 vccd1 _1702_/S sky130_fd_sc_hd__clkdlybuf4s25_1
Xfanout145 _1362_/Y vssd1 vssd1 vccd1 vccd1 fanout145/X sky130_fd_sc_hd__clkdlybuf4s25_1
XFILLER_42_246 vssd1 vssd1 vccd1 vccd1 sky130_fd_sc_hd__fill_1
XFILLER_63_57 vssd1 vssd1 vccd1 vccd1 sky130_fd_sc_hd__fill_1
XFILLER_10_143 vssd1 vssd1 vccd1 vccd1 sky130_fd_sc_hd__fill_1
XFILLER_10_187 vssd1 vssd1 vccd1 vccd1 sky130_fd_sc_hd__fill_1
XFILLER_18_298 vssd1 vssd1 vccd1 vccd1 sky130_fd_sc_hd__fill_2
X_1892_ _2643_/Q _1892_/B vssd1 vssd1 vccd1 vccd1 _1892_/X sky130_fd_sc_hd__xor2_2
X_1961_ _1962_/B _1962_/C _2667_/Q vssd1 vssd1 vccd1 vccd1 _1961_/Y sky130_fd_sc_hd__a21oi_2
XFILLER_5_191 vssd1 vssd1 vccd1 vccd1 sky130_fd_sc_hd__fill_2
X_2513_ _2862_/Q _2863_/Q _2513_/C vssd1 vssd1 vccd1 vccd1 _2517_/B sky130_fd_sc_hd__and3_2
X_1326_ _2733_/Q _1321_/Y _1322_/X _1320_/X _1325_/Y vssd1 vssd1 vccd1 vccd1 _1326_/X
+ sky130_fd_sc_hd__o221a_2
Xclkbuf_leaf_5_clk clkbuf_leaf_5_clk/A vssd1 vssd1 vccd1 vccd1 _2663_/CLK sky130_fd_sc_hd__clkbuf_8
X_2444_ _2838_/Q _2450_/D vssd1 vssd1 vccd1 vccd1 _2448_/B sky130_fd_sc_hd__nand2_2
X_2375_ _2375_/A _2375_/B _2375_/C vssd1 vssd1 vccd1 vccd1 _2381_/B sky130_fd_sc_hd__and3_2
XTAP_TAPCELL_ROW_19_271 vssd1 vccd1 sky130_fd_sc_hd__tapvpwrvgnd_1
XTAP_TAPCELL_ROW_54_517 vssd1 vccd1 sky130_fd_sc_hd__tapvpwrvgnd_1
X_1257_ _2810_/Q vssd1 vssd1 vccd1 vccd1 _1257_/Y sky130_fd_sc_hd__inv_2
XANTENNA__2870__Q _2870_/Q vssd1 vssd1 vccd1 vccd1 sky130_fd_sc_hd__diode_2
XTAP_TAPCELL_ROW_62_572 vssd1 vccd1 sky130_fd_sc_hd__tapvpwrvgnd_1
XFILLER_3_106 vssd1 vssd1 vccd1 vccd1 sky130_fd_sc_hd__fill_1
XANTENNA_clkbuf_leaf_34_clk_A clkbuf_leaf_3_clk/A vssd1 vssd1 vccd1 vccd1 sky130_fd_sc_hd__diode_2
XFILLER_55_393 vssd1 vssd1 vccd1 vccd1 sky130_fd_sc_hd__fill_1
XANTENNA__1718__A1 _2645_/Q vssd1 vssd1 vccd1 vccd1 sky130_fd_sc_hd__diode_2
XFILLER_23_71 vssd1 vssd1 vccd1 vccd1 sky130_fd_sc_hd__fill_1
X_2160_ hold344/X hold308/X _2186_/S vssd1 vssd1 vccd1 vccd1 _2716_/D sky130_fd_sc_hd__mux2_1
X_2091_ hold502/X _2090_/X _2882_/D vssd1 vssd1 vccd1 vccd1 _2672_/D sky130_fd_sc_hd__mux2_1
XTAP_TAPCELL_ROW_16_252 vssd1 vccd1 sky130_fd_sc_hd__tapvpwrvgnd_1
X_1875_ _2702_/Q _1869_/B _1874_/Y _1900_/C vssd1 vssd1 vccd1 vccd1 _1875_/X sky130_fd_sc_hd__a22o_2
X_1944_ _1944_/A _2686_/Q vssd1 vssd1 vccd1 vccd1 _1946_/C sky130_fd_sc_hd__nand2_2
XANTENNA__2305__A1_N _2300_/A1 vssd1 vssd1 vccd1 vccd1 sky130_fd_sc_hd__diode_2
X_2427_ _2431_/C _2427_/B vssd1 vssd1 vccd1 vccd1 _2427_/X sky130_fd_sc_hd__or2_2
X_1309_ _2740_/Q _1344_/B vssd1 vssd1 vccd1 vccd1 _1309_/X sky130_fd_sc_hd__and2_2
X_2358_ _2846_/Q _2847_/Q _2848_/Q _2849_/Q vssd1 vssd1 vccd1 vccd1 _2370_/B sky130_fd_sc_hd__or4_2
X_2289_ _1366_/A hold439/X _2293_/B1 hold447/X vssd1 vssd1 vccd1 vccd1 _2766_/D sky130_fd_sc_hd__a22o_2
XFILLER_12_249 vssd1 vssd1 vccd1 vccd1 sky130_fd_sc_hd__fill_2
XFILLER_7_220 vssd1 vssd1 vccd1 vccd1 sky130_fd_sc_hd__fill_2
XTAP_TAPCELL_ROW_13_233 vssd1 vccd1 sky130_fd_sc_hd__tapvpwrvgnd_1
X_1591_ _2616_/Q _1585_/X _1589_/X hold503/X _1588_/X vssd1 vssd1 vccd1 vccd1 _2537_/D
+ sky130_fd_sc_hd__a221o_2
X_1660_ _2811_/Q hold478/X _1661_/S vssd1 vssd1 vccd1 vccd1 _1660_/X sky130_fd_sc_hd__mux2_1
Xload_slew101 fanout100/X vssd1 vssd1 vccd1 vccd1 load_slew101/X sky130_fd_sc_hd__clkbuf_4
Xload_slew112 fanout111/X vssd1 vssd1 vccd1 vccd1 load_slew112/X sky130_fd_sc_hd__buf_2
XFILLER_22_3 vssd1 vssd1 vccd1 vccd1 sky130_fd_sc_hd__fill_2
Xload_slew134 fanout133/X vssd1 vssd1 vccd1 vccd1 load_slew134/X sky130_fd_sc_hd__buf_2
Xload_slew123 fanout122/X vssd1 vssd1 vccd1 vccd1 load_slew123/X sky130_fd_sc_hd__clkbuf_4
X_2212_ _2764_/Q _2718_/Q vssd1 vssd1 vccd1 vccd1 _2212_/Y sky130_fd_sc_hd__nor2_2
X_2143_ _2701_/Q hold459/X _2153_/S vssd1 vssd1 vccd1 vccd1 _2701_/D sky130_fd_sc_hd__mux2_1
XANTENNA__2136__B _2136_/B vssd1 vssd1 vccd1 vccd1 sky130_fd_sc_hd__diode_2
Xload_slew81 _2495_/B2 vssd1 vssd1 vccd1 vccd1 load_slew81/X sky130_fd_sc_hd__buf_2
X_2074_ _2594_/Q _2074_/B vssd1 vssd1 vccd1 vccd1 _2075_/B sky130_fd_sc_hd__xnor2_2
X_1858_ _2633_/Q _1891_/S _1857_/X vssd1 vssd1 vccd1 vccd1 _2633_/D sky130_fd_sc_hd__o21a_2
X_1927_ _1940_/A _2690_/Q vssd1 vssd1 vccd1 vccd1 _1930_/B sky130_fd_sc_hd__or2_2
XANTENNA__1991__A _2071_/B vssd1 vssd1 vccd1 vccd1 sky130_fd_sc_hd__diode_2
X_1789_ _2626_/Q _1793_/C _1770_/C vssd1 vssd1 vccd1 vccd1 _1790_/B sky130_fd_sc_hd__o21ai_2
XANTENNA__2291__B1 _2293_/B1 vssd1 vssd1 vccd1 vccd1 sky130_fd_sc_hd__diode_2
XFILLER_4_278 vssd1 vssd1 vccd1 vccd1 sky130_fd_sc_hd__fill_2
XANTENNA__2882__D _2882_/D vssd1 vssd1 vccd1 vccd1 sky130_fd_sc_hd__diode_2
XFILLER_35_149 vssd1 vssd1 vccd1 vccd1 sky130_fd_sc_hd__fill_1
XFILLER_43_171 vssd1 vssd1 vccd1 vccd1 sky130_fd_sc_hd__fill_2
XFILLER_50_119 vssd1 vssd1 vccd1 vccd1 sky130_fd_sc_hd__fill_4
X_2830_ clkload1/A _2830_/D load_slew83/X vssd1 vssd1 vccd1 vccd1 _2830_/Q sky130_fd_sc_hd__dfrtp_2
XANTENNA_1 _2784_/Q vssd1 vssd1 vccd1 vccd1 sky130_fd_sc_hd__diode_2
X_1643_ _1385_/B _2712_/Q _2663_/Q _1734_/A vssd1 vssd1 vccd1 vccd1 _1643_/X sky130_fd_sc_hd__a22o_2
X_1712_ _2642_/Q _1716_/S _1622_/X vssd1 vssd1 vccd1 vccd1 _1712_/X sky130_fd_sc_hd__a21o_2
X_2761_ _2804_/CLK _2761_/D load_slew134/X vssd1 vssd1 vccd1 vccd1 _2761_/Q sky130_fd_sc_hd__dfrtp_2
X_2692_ _2693_/CLK _2692_/D fanout98/X vssd1 vssd1 vccd1 vccd1 _2692_/Q sky130_fd_sc_hd__dfrtp_2
XFILLER_6_85 vssd1 vssd1 vccd1 vccd1 sky130_fd_sc_hd__fill_2
X_1574_ _1580_/A _2644_/Q _1701_/S vssd1 vssd1 vccd1 vccd1 _1574_/X sky130_fd_sc_hd__and3_2
XANTENNA_fanout164_A _1662_/D vssd1 vssd1 vccd1 vccd1 sky130_fd_sc_hd__diode_2
XTAP_TAPCELL_ROW_49_483 vssd1 vccd1 sky130_fd_sc_hd__tapvpwrvgnd_1
X_2126_ _2572_/Q _2588_/Q _2130_/S vssd1 vssd1 vccd1 vccd1 _2126_/X sky130_fd_sc_hd__mux2_1
X_2057_ _2057_/A _2057_/B vssd1 vssd1 vccd1 vccd1 _2057_/Y sky130_fd_sc_hd__xnor2_2
XFILLER_41_38 vssd1 vssd1 vccd1 vccd1 sky130_fd_sc_hd__fill_4
XTAP_TAPCELL_ROW_24_306 vssd1 vccd1 sky130_fd_sc_hd__tapvpwrvgnd_1
XTAP_TAPCELL_ROW_32_361 vssd1 vccd1 sky130_fd_sc_hd__tapvpwrvgnd_1
Xhold540 _2656_/Q vssd1 vssd1 vccd1 vccd1 hold540/X sky130_fd_sc_hd__dlygate4sd3_1
XANTENNA_fanout77_A _2297_/B1 vssd1 vssd1 vccd1 vccd1 sky130_fd_sc_hd__diode_2
XTAP_TAPCELL_ROW_38_409 vssd1 vccd1 sky130_fd_sc_hd__tapvpwrvgnd_1
X_1290_ _2894_/Q _2896_/Q _2895_/Q _2893_/Q vssd1 vssd1 vccd1 vccd1 _2470_/C sky130_fd_sc_hd__or4b_2
Xteam_06_194 vssd1 vssd1 vccd1 vccd1 team_06_194/HI gpio_oeb[6] sky130_fd_sc_hd__conb_1
XTAP_TAPCELL_ROW_46_464 vssd1 vccd1 sky130_fd_sc_hd__tapvpwrvgnd_1
X_2813_ _2813_/CLK _2813_/D vssd1 vssd1 vccd1 vccd1 _2813_/Q sky130_fd_sc_hd__dfxtp_2
X_1626_ _2643_/Q _1716_/S _1796_/A1 _2658_/Q vssd1 vssd1 vccd1 vccd1 _1626_/X sky130_fd_sc_hd__a22o_2
X_2744_ _2866_/CLK _2744_/D fanout111/A vssd1 vssd1 vccd1 vccd1 _2744_/Q sky130_fd_sc_hd__dfrtp_2
X_2675_ _2693_/CLK _2675_/D load_slew97/X vssd1 vssd1 vccd1 vccd1 _2675_/Q sky130_fd_sc_hd__dfrtp_2
X_1488_ _2375_/A _2375_/B _2378_/A _2817_/Q vssd1 vssd1 vccd1 vccd1 wire75/A sky130_fd_sc_hd__nor4_1
X_1557_ hold256/X _1558_/B _1556_/X vssd1 vssd1 vccd1 vccd1 _2523_/D sky130_fd_sc_hd__a21o_2
XFILLER_36_49 vssd1 vssd1 vccd1 vccd1 sky130_fd_sc_hd__fill_2
XFILLER_42_406 vssd1 vssd1 vccd1 vccd1 sky130_fd_sc_hd__fill_1
X_2109_ hold497/X _2108_/X _2136_/B vssd1 vssd1 vccd1 vccd1 _2681_/D sky130_fd_sc_hd__mux2_1
Xhold370 _2739_/Q vssd1 vssd1 vccd1 vccd1 hold370/X sky130_fd_sc_hd__dlygate4sd3_1
Xhold381 _2745_/Q vssd1 vssd1 vccd1 vccd1 hold381/X sky130_fd_sc_hd__dlygate4sd3_1
Xhold392 _2795_/Q vssd1 vssd1 vccd1 vccd1 hold392/X sky130_fd_sc_hd__dlygate4sd3_1
XFILLER_9_167 vssd1 vssd1 vccd1 vccd1 sky130_fd_sc_hd__fill_1
X_2460_ _2841_/Q _2842_/Q _2454_/B _2843_/Q vssd1 vssd1 vccd1 vccd1 _2460_/X sky130_fd_sc_hd__a31o_2
XFILLER_3_97 vssd1 vssd1 vccd1 vccd1 sky130_fd_sc_hd__fill_2
X_1273_ _2912_/Q _2914_/Q _2913_/Q _2915_/Q vssd1 vssd1 vccd1 vccd1 _1273_/X sky130_fd_sc_hd__and4_2
X_1342_ _2802_/Q _1342_/B vssd1 vssd1 vccd1 vccd1 _1343_/B sky130_fd_sc_hd__nor2_2
X_1411_ _1415_/A _2969_/A vssd1 vssd1 vccd1 vccd1 _1413_/B sky130_fd_sc_hd__or2_2
X_2391_ _2391_/A _2391_/B vssd1 vssd1 vccd1 vccd1 _2400_/C sky130_fd_sc_hd__nor2_2
XFILLER_51_225 vssd1 vssd1 vccd1 vccd1 sky130_fd_sc_hd__fill_4
Xwire48 wire48/A vssd1 vssd1 vccd1 vccd1 wire48/X sky130_fd_sc_hd__buf_1
X_1609_ _2638_/Q _1710_/S _2542_/Q _1589_/X _1608_/X vssd1 vssd1 vccd1 vccd1 _1609_/X
+ sky130_fd_sc_hd__a221o_2
Xfanout113 fanout145/X vssd1 vssd1 vccd1 vccd1 fanout113/X sky130_fd_sc_hd__clkdlybuf4s25_1
Xfanout102 fanout105/X vssd1 vssd1 vccd1 vccd1 fanout102/X sky130_fd_sc_hd__clkdlybuf4s25_1
X_2727_ _2774_/CLK _2727_/D fanout132/X vssd1 vssd1 vccd1 vccd1 _2727_/Q sky130_fd_sc_hd__dfrtp_2
X_2658_ clkload6/A _2658_/D fanout96/X vssd1 vssd1 vccd1 vccd1 _2658_/Q sky130_fd_sc_hd__dfrtp_2
X_2589_ _2693_/CLK _2589_/D vssd1 vssd1 vccd1 vccd1 _2589_/Q sky130_fd_sc_hd__dfxtp_2
XANTENNA_input1_A en vssd1 vssd1 vccd1 vccd1 sky130_fd_sc_hd__diode_2
XFILLER_59_347 vssd1 vssd1 vccd1 vccd1 sky130_fd_sc_hd__fill_1
XTAP_TAPCELL_ROW_57_537 vssd1 vccd1 sky130_fd_sc_hd__tapvpwrvgnd_1
Xfanout179 _2189_/S vssd1 vssd1 vccd1 vccd1 _2168_/S sky130_fd_sc_hd__clkdlybuf4s25_1
Xfanout168 _2874_/Q vssd1 vssd1 vccd1 vccd1 _1756_/B sky130_fd_sc_hd__clkdlybuf4s25_1
Xfanout157 _1722_/S vssd1 vssd1 vccd1 vccd1 _1716_/S sky130_fd_sc_hd__clkdlybuf4s25_1
Xfanout146 _1270_/Y vssd1 vssd1 vccd1 vccd1 _2069_/B1 sky130_fd_sc_hd__clkdlybuf4s25_1
Xfanout135 fanout137/X vssd1 vssd1 vccd1 vccd1 fanout135/X sky130_fd_sc_hd__clkdlybuf4s25_1
Xfanout124 fanout125/X vssd1 vssd1 vccd1 vccd1 fanout124/X sky130_fd_sc_hd__clkdlybuf4s25_1
XANTENNA__1690__A1 _2644_/Q vssd1 vssd1 vccd1 vccd1 sky130_fd_sc_hd__diode_2
XFILLER_15_406 vssd1 vssd1 vccd1 vccd1 sky130_fd_sc_hd__fill_1
XFILLER_42_225 vssd1 vssd1 vccd1 vccd1 sky130_fd_sc_hd__fill_8
XFILLER_50_280 vssd1 vssd1 vccd1 vccd1 sky130_fd_sc_hd__fill_1
XANTENNA_clkbuf_leaf_8_clk_A clkbuf_leaf_9_clk/A vssd1 vssd1 vccd1 vccd1 sky130_fd_sc_hd__diode_2
XANTENNA__1681__A1 _2635_/Q vssd1 vssd1 vccd1 vccd1 sky130_fd_sc_hd__diode_2
X_1891_ _2642_/Q _1890_/X _1891_/S vssd1 vssd1 vccd1 vccd1 _2642_/D sky130_fd_sc_hd__mux2_1
X_1960_ _1963_/A _2682_/Q vssd1 vssd1 vccd1 vccd1 _1962_/C sky130_fd_sc_hd__nand2_2
X_2512_ _2512_/A _2513_/C vssd1 vssd1 vccd1 vccd1 _2862_/D sky130_fd_sc_hd__xor2_2
X_2443_ _2838_/Q _2450_/D vssd1 vssd1 vccd1 vccd1 _2445_/A sky130_fd_sc_hd__or2_2
X_1256_ _2805_/Q vssd1 vssd1 vccd1 vccd1 _1652_/A sky130_fd_sc_hd__inv_2
X_1325_ _1325_/A _1325_/B vssd1 vssd1 vccd1 vccd1 _1325_/Y sky130_fd_sc_hd__nand2_2
X_2374_ _2375_/A _2361_/Y _2389_/B vssd1 vssd1 vccd1 vccd1 _2376_/A sky130_fd_sc_hd__a21oi_2
XTAP_TAPCELL_ROW_19_272 vssd1 vccd1 sky130_fd_sc_hd__tapvpwrvgnd_1
XTAP_TAPCELL_ROW_54_518 vssd1 vccd1 sky130_fd_sc_hd__tapvpwrvgnd_1
XTAP_TAPCELL_ROW_62_573 vssd1 vccd1 sky130_fd_sc_hd__tapvpwrvgnd_1
XTAP_TAPCELL_ROW_2_151 vssd1 vccd1 sky130_fd_sc_hd__tapvpwrvgnd_1
XFILLER_38_317 vssd1 vssd1 vccd1 vccd1 sky130_fd_sc_hd__fill_1
X_2090_ _2585_/Q _2569_/Q _2120_/S vssd1 vssd1 vccd1 vccd1 _2090_/X sky130_fd_sc_hd__mux2_1
XFILLER_0_32 vssd1 vssd1 vccd1 vccd1 sky130_fd_sc_hd__fill_1
XFILLER_0_65 vssd1 vssd1 vccd1 vccd1 sky130_fd_sc_hd__fill_2
XFILLER_0_87 vssd1 vssd1 vccd1 vccd1 sky130_fd_sc_hd__fill_1
XTAP_TAPCELL_ROW_16_253 vssd1 vccd1 sky130_fd_sc_hd__tapvpwrvgnd_1
X_1874_ _1877_/B _1874_/B vssd1 vssd1 vccd1 vccd1 _1874_/Y sky130_fd_sc_hd__nor2_2
X_1943_ _1944_/A _2686_/Q vssd1 vssd1 vccd1 vccd1 _1946_/B sky130_fd_sc_hd__or2_2
X_2426_ _2426_/A _2426_/B vssd1 vssd1 vccd1 vccd1 _2427_/B sky130_fd_sc_hd__and2_2
XANTENNA__1893__A1 _2707_/Q vssd1 vssd1 vccd1 vccd1 sky130_fd_sc_hd__diode_2
X_1308_ _1342_/B _1308_/B vssd1 vssd1 vccd1 vccd1 _1344_/B sky130_fd_sc_hd__or2_2
X_2357_ _2856_/Q _2857_/Q _2364_/B _2368_/C vssd1 vssd1 vccd1 vccd1 _2361_/B sky130_fd_sc_hd__or4_2
X_2288_ _1366_/A hold374/X _2293_/B1 hold448/X vssd1 vssd1 vccd1 vccd1 _2765_/D sky130_fd_sc_hd__a22o_2
XANTENNA__2070__A1 _2071_/B vssd1 vssd1 vccd1 vccd1 sky130_fd_sc_hd__diode_2
XFILLER_12_206 vssd1 vssd1 vccd1 vccd1 sky130_fd_sc_hd__fill_1
XFILLER_44_27 vssd1 vssd1 vccd1 vccd1 sky130_fd_sc_hd__fill_1
XFILLER_60_26 vssd1 vssd1 vccd1 vccd1 sky130_fd_sc_hd__fill_2
XFILLER_60_37 vssd1 vssd1 vccd1 vccd1 sky130_fd_sc_hd__fill_2
XANTENNA__1663__S _1686_/S vssd1 vssd1 vccd1 vccd1 sky130_fd_sc_hd__diode_2
XANTENNA__1884__A1 _2640_/Q vssd1 vssd1 vccd1 vccd1 sky130_fd_sc_hd__diode_2
XANTENNA__1411__B _2969_/A vssd1 vssd1 vccd1 vccd1 sky130_fd_sc_hd__diode_2
XANTENNA__1636__A1 _1385_/B vssd1 vssd1 vccd1 vccd1 sky130_fd_sc_hd__diode_2
XANTENNA__1899__A _2645_/Q vssd1 vssd1 vccd1 vccd1 sky130_fd_sc_hd__diode_2
XTAP_TAPCELL_ROW_13_234 vssd1 vccd1 sky130_fd_sc_hd__tapvpwrvgnd_1
X_1590_ _1590_/A _1590_/B vssd1 vssd1 vccd1 vccd1 _1590_/Y sky130_fd_sc_hd__nand2_2
XANTENNA__1875__A1 _2702_/Q vssd1 vssd1 vccd1 vccd1 sky130_fd_sc_hd__diode_2
XFILLER_53_117 vssd1 vssd1 vccd1 vccd1 sky130_fd_sc_hd__fill_2
X_2211_ hold464/X _2260_/A2 _2209_/X _2210_/Y vssd1 vssd1 vccd1 vccd1 _2748_/D sky130_fd_sc_hd__a22o_2
X_2142_ hold489/X hold464/X _2153_/S vssd1 vssd1 vccd1 vccd1 _2700_/D sky130_fd_sc_hd__mux2_1
X_2073_ _2593_/Q _2577_/Q vssd1 vssd1 vccd1 vccd1 _2074_/B sky130_fd_sc_hd__xnor2_2
XPHY_EDGE_ROW_28_Left_93 vssd1 vssd1 vccd1 vccd1 sky130_fd_sc_hd__decap_3
XPHY_EDGE_ROW_12_Left_77 vssd1 vssd1 vccd1 vccd1 sky130_fd_sc_hd__decap_3
X_1788_ _2626_/Q _1793_/C vssd1 vssd1 vccd1 vccd1 _1790_/A sky130_fd_sc_hd__and2_2
X_1857_ _2697_/Q _1869_/B _1855_/X _1856_/X vssd1 vssd1 vccd1 vccd1 _1857_/X sky130_fd_sc_hd__a22o_2
X_1926_ _2676_/Q _1926_/B _1926_/C vssd1 vssd1 vccd1 vccd1 _2048_/B sky130_fd_sc_hd__nand3_2
XANTENNA_clkbuf_leaf_33_clk_A clkbuf_leaf_4_clk/A vssd1 vssd1 vccd1 vccd1 sky130_fd_sc_hd__diode_2
XFILLER_29_103 vssd1 vssd1 vccd1 vccd1 sky130_fd_sc_hd__fill_1
X_2409_ _2442_/B _2442_/C _2442_/D vssd1 vssd1 vccd1 vccd1 _2421_/D sky130_fd_sc_hd__and3_2
XANTENNA__2291__A1 _1366_/A vssd1 vssd1 vccd1 vccd1 sky130_fd_sc_hd__diode_2
XFILLER_29_158 vssd1 vssd1 vccd1 vccd1 sky130_fd_sc_hd__fill_1
XFILLER_44_117 vssd1 vssd1 vccd1 vccd1 sky130_fd_sc_hd__fill_1
XFILLER_44_139 vssd1 vssd1 vccd1 vccd1 sky130_fd_sc_hd__fill_1
XTAP_TAPCELL_ROW_27_326 vssd1 vccd1 sky130_fd_sc_hd__tapvpwrvgnd_1
XANTENNA_hold419_A _2702_/Q vssd1 vssd1 vccd1 vccd1 sky130_fd_sc_hd__diode_2
XFILLER_40_334 vssd1 vssd1 vccd1 vccd1 sky130_fd_sc_hd__fill_1
XANTENNA__1609__A1 _2638_/Q vssd1 vssd1 vccd1 vccd1 sky130_fd_sc_hd__diode_2
XANTENNA__1609__B2 _1589_/X vssd1 vssd1 vccd1 vccd1 sky130_fd_sc_hd__diode_2
XANTENNA__2282__B2 _1351_/A vssd1 vssd1 vccd1 vccd1 sky130_fd_sc_hd__diode_2
XFILLER_43_194 vssd1 vssd1 vccd1 vccd1 sky130_fd_sc_hd__fill_8
X_1642_ _2632_/Q _1702_/S _1590_/A vssd1 vssd1 vccd1 vccd1 _1642_/X sky130_fd_sc_hd__a21o_2
X_1711_ hold247/X _1710_/X _1721_/S vssd1 vssd1 vccd1 vccd1 _2604_/D sky130_fd_sc_hd__mux2_1
X_2760_ _2804_/CLK _2760_/D load_slew134/X vssd1 vssd1 vccd1 vccd1 _2760_/Q sky130_fd_sc_hd__dfrtp_2
X_2691_ _2693_/CLK _2691_/D load_slew97/X vssd1 vssd1 vccd1 vccd1 _2691_/Q sky130_fd_sc_hd__dfrtp_2
X_1573_ hold313/X _1581_/A2 _1572_/X vssd1 vssd1 vccd1 vccd1 _2531_/D sky130_fd_sc_hd__a21o_2
XTAP_TAPCELL_ROW_24_307 vssd1 vccd1 sky130_fd_sc_hd__tapvpwrvgnd_1
XTAP_TAPCELL_ROW_49_484 vssd1 vccd1 sky130_fd_sc_hd__tapvpwrvgnd_1
X_2125_ hold463/X _2124_/X _2125_/S vssd1 vssd1 vccd1 vccd1 _2689_/D sky130_fd_sc_hd__mux2_1
X_2056_ _2056_/A _2056_/B vssd1 vssd1 vccd1 vccd1 _2057_/B sky130_fd_sc_hd__nand2_2
XANTENNA_fanout157_A _1722_/S vssd1 vssd1 vccd1 vccd1 sky130_fd_sc_hd__diode_2
XFILLER_41_28 vssd1 vssd1 vccd1 vccd1 sky130_fd_sc_hd__fill_1
XTAP_TAPCELL_ROW_32_362 vssd1 vccd1 sky130_fd_sc_hd__tapvpwrvgnd_1
X_1909_ _2647_/Q _1908_/X _1909_/S vssd1 vssd1 vccd1 vccd1 _2647_/D sky130_fd_sc_hd__mux2_1
XANTENNA__2102__S _2134_/S vssd1 vssd1 vccd1 vccd1 sky130_fd_sc_hd__diode_2
XFILLER_1_227 vssd1 vssd1 vccd1 vccd1 sky130_fd_sc_hd__fill_1
XFILLER_1_249 vssd1 vssd1 vccd1 vccd1 sky130_fd_sc_hd__fill_1
Xhold530 _2539_/Q vssd1 vssd1 vccd1 vccd1 hold530/X sky130_fd_sc_hd__dlygate4sd3_1
Xhold541 _2913_/Q vssd1 vssd1 vccd1 vccd1 hold541/X sky130_fd_sc_hd__dlygate4sd3_1
X_2889_ clkload4/A input2/X fanout86/X vssd1 vssd1 vccd1 vccd1 _2889_/Q sky130_fd_sc_hd__dfstp_2
Xteam_06_195 vssd1 vssd1 vccd1 vccd1 team_06_195/HI gpio_oeb[7] sky130_fd_sc_hd__conb_1
XFILLER_48_253 vssd1 vssd1 vccd1 vccd1 sky130_fd_sc_hd__fill_1
XTAP_TAPCELL_ROW_46_465 vssd1 vccd1 sky130_fd_sc_hd__tapvpwrvgnd_1
X_2812_ _2880_/CLK _2812_/D vssd1 vssd1 vccd1 vccd1 _2812_/Q sky130_fd_sc_hd__dfxtp_2
X_2743_ _2804_/CLK _2743_/D fanout135/X vssd1 vssd1 vccd1 vccd1 _2743_/Q sky130_fd_sc_hd__dfrtp_2
X_1556_ _1582_/A _2635_/Q _1724_/S vssd1 vssd1 vccd1 vccd1 _1556_/X sky130_fd_sc_hd__and3_2
X_1625_ _1384_/B _2706_/Q hold433/X _1796_/A1 _1624_/X vssd1 vssd1 vccd1 vccd1 _2546_/D
+ sky130_fd_sc_hd__a221o_2
X_2674_ _2689_/CLK _2674_/D load_slew97/X vssd1 vssd1 vccd1 vccd1 _2674_/Q sky130_fd_sc_hd__dfrtp_2
XFILLER_39_220 vssd1 vssd1 vccd1 vccd1 sky130_fd_sc_hd__fill_4
X_1487_ hold515/X _1480_/B _1484_/X _1486_/X vssd1 vssd1 vccd1 vccd1 _2915_/D sky130_fd_sc_hd__o22a_2
X_2108_ _2563_/Q _2579_/Q _2118_/S vssd1 vssd1 vccd1 vccd1 _2108_/X sky130_fd_sc_hd__mux2_1
X_2039_ _2041_/D _2039_/B vssd1 vssd1 vccd1 vccd1 _2039_/Y sky130_fd_sc_hd__xnor2_2
XPHY_EDGE_ROW_15_Left_80 vssd1 vssd1 vccd1 vccd1 sky130_fd_sc_hd__decap_3
Xhold360 _2734_/Q vssd1 vssd1 vccd1 vccd1 hold360/X sky130_fd_sc_hd__dlygate4sd3_1
Xhold371 _2743_/Q vssd1 vssd1 vccd1 vccd1 hold371/X sky130_fd_sc_hd__dlygate4sd3_1
Xhold382 _2785_/Q vssd1 vssd1 vccd1 vccd1 hold382/X sky130_fd_sc_hd__dlygate4sd3_1
Xhold393 _2853_/Q vssd1 vssd1 vccd1 vccd1 _2489_/A sky130_fd_sc_hd__dlygate4sd3_1
XFILLER_54_7 vssd1 vssd1 vccd1 vccd1 sky130_fd_sc_hd__fill_1
X_1410_ _2919_/Q _2330_/A _2348_/B _1409_/X vssd1 vssd1 vccd1 vccd1 _2919_/D sky130_fd_sc_hd__a211o_2
X_1272_ _2833_/Q vssd1 vssd1 vccd1 vccd1 _2426_/A sky130_fd_sc_hd__inv_2
X_1341_ _2739_/Q _1339_/Y _1340_/X _1338_/X vssd1 vssd1 vccd1 vccd1 _1341_/X sky130_fd_sc_hd__o22a_2
X_2390_ _2391_/B vssd1 vssd1 vccd1 vccd1 _2442_/D sky130_fd_sc_hd__inv_2
X_2726_ _2774_/CLK _2726_/D wire131/X vssd1 vssd1 vccd1 vccd1 _2726_/Q sky130_fd_sc_hd__dfrtp_2
X_1539_ _1539_/A _1539_/B _1539_/C _1506_/X vssd1 vssd1 vccd1 vccd1 _2378_/B sky130_fd_sc_hd__or4b_2
X_1608_ _1384_/B _2702_/Q _2653_/Q _1384_/A vssd1 vssd1 vccd1 vccd1 _1608_/X sky130_fd_sc_hd__a22o_2
Xfanout147 _1270_/Y vssd1 vssd1 vccd1 vccd1 _2052_/B2 sky130_fd_sc_hd__clkdlybuf4s25_1
Xfanout125 fanout145/X vssd1 vssd1 vccd1 vccd1 fanout125/X sky130_fd_sc_hd__clkdlybuf4s25_1
X_2657_ clkload6/A _2657_/D fanout102/X vssd1 vssd1 vccd1 vccd1 _2657_/Q sky130_fd_sc_hd__dfrtp_2
X_2588_ _2693_/CLK _2588_/D vssd1 vssd1 vccd1 vccd1 _2588_/Q sky130_fd_sc_hd__dfxtp_2
XTAP_TAPCELL_ROW_57_538 vssd1 vccd1 sky130_fd_sc_hd__tapvpwrvgnd_1
Xfanout169 _1384_/A vssd1 vssd1 vccd1 vccd1 _1796_/A1 sky130_fd_sc_hd__clkdlybuf4s25_1
Xfanout158 _1722_/S vssd1 vssd1 vccd1 vccd1 _1710_/S sky130_fd_sc_hd__clkdlybuf4s25_1
XFILLER_42_259 vssd1 vssd1 vccd1 vccd1 sky130_fd_sc_hd__fill_1
XFILLER_12_85 vssd1 vssd1 vccd1 vccd1 sky130_fd_sc_hd__fill_1
XPHY_EDGE_ROW_0_Left_65 vssd1 vssd1 vccd1 vccd1 sky130_fd_sc_hd__decap_3
XPHY_EDGE_ROW_16_Right_16 vssd1 vssd1 vccd1 vccd1 sky130_fd_sc_hd__decap_3
XFILLER_41_281 vssd1 vssd1 vccd1 vccd1 sky130_fd_sc_hd__fill_1
XPHY_EDGE_ROW_25_Right_25 vssd1 vssd1 vccd1 vccd1 sky130_fd_sc_hd__decap_3
X_1890_ _2706_/Q _1869_/B _1889_/X _1900_/C vssd1 vssd1 vccd1 vccd1 _1890_/X sky130_fd_sc_hd__a22o_2
XFILLER_45_3 vssd1 vssd1 vccd1 vccd1 sky130_fd_sc_hd__fill_4
X_2511_ _2513_/C _2511_/B vssd1 vssd1 vccd1 vccd1 _2861_/D sky130_fd_sc_hd__nor2_2
X_2442_ _2442_/A _2442_/B _2442_/C _2442_/D vssd1 vssd1 vccd1 vccd1 _2450_/D sky130_fd_sc_hd__and4_2
X_2373_ _2375_/A _2472_/B vssd1 vssd1 vccd1 vccd1 _2814_/D sky130_fd_sc_hd__xnor2_2
XPHY_EDGE_ROW_34_Right_34 vssd1 vssd1 vccd1 vccd1 sky130_fd_sc_hd__decap_3
X_1324_ _1327_/B _1324_/B vssd1 vssd1 vccd1 vccd1 _1325_/B sky130_fd_sc_hd__nor2_2
XANTENNA__2155__B _2168_/S vssd1 vssd1 vccd1 vccd1 sky130_fd_sc_hd__diode_2
XFILLER_24_237 vssd1 vssd1 vccd1 vccd1 sky130_fd_sc_hd__fill_2
XTAP_TAPCELL_ROW_19_273 vssd1 vccd1 sky130_fd_sc_hd__tapvpwrvgnd_1
XTAP_TAPCELL_ROW_54_519 vssd1 vccd1 sky130_fd_sc_hd__tapvpwrvgnd_1
XTAP_TAPCELL_ROW_62_574 vssd1 vccd1 sky130_fd_sc_hd__tapvpwrvgnd_1
XPHY_EDGE_ROW_43_Right_43 vssd1 vssd1 vccd1 vccd1 sky130_fd_sc_hd__decap_3
X_2709_ _2772_/CLK _2709_/D fanout138/X vssd1 vssd1 vccd1 vccd1 _2709_/Q sky130_fd_sc_hd__dfrtp_2
XFILLER_58_37 vssd1 vssd1 vccd1 vccd1 sky130_fd_sc_hd__fill_2
XPHY_EDGE_ROW_52_Right_52 vssd1 vssd1 vccd1 vccd1 sky130_fd_sc_hd__decap_3
XFILLER_15_204 vssd1 vssd1 vccd1 vccd1 sky130_fd_sc_hd__fill_1
XTAP_TAPCELL_ROW_2_152 vssd1 vccd1 sky130_fd_sc_hd__tapvpwrvgnd_1
XFILLER_23_62 vssd1 vssd1 vccd1 vccd1 sky130_fd_sc_hd__fill_1
XPHY_EDGE_ROW_36_Left_101 vssd1 vssd1 vccd1 vccd1 sky130_fd_sc_hd__decap_3
XPHY_EDGE_ROW_61_Right_61 vssd1 vssd1 vccd1 vccd1 sky130_fd_sc_hd__decap_3
XFILLER_48_81 vssd1 vssd1 vccd1 vccd1 sky130_fd_sc_hd__fill_1
XPHY_EDGE_ROW_45_Left_110 vssd1 vssd1 vccd1 vccd1 sky130_fd_sc_hd__decap_3
XTAP_TAPCELL_ROW_16_254 vssd1 vccd1 sky130_fd_sc_hd__tapvpwrvgnd_1
X_1942_ _2672_/Q _1942_/B _1942_/C vssd1 vssd1 vccd1 vccd1 _2025_/B sky130_fd_sc_hd__nand3_2
XANTENNA__2262__Y _2263_/B vssd1 vssd1 vccd1 vccd1 sky130_fd_sc_hd__diode_2
XANTENNA__2699__Q _2699_/Q vssd1 vssd1 vccd1 vccd1 sky130_fd_sc_hd__diode_2
X_1873_ _2638_/Q _1873_/B vssd1 vssd1 vccd1 vccd1 _1874_/B sky130_fd_sc_hd__nor2_2
XFILLER_28_29 vssd1 vssd1 vccd1 vccd1 sky130_fd_sc_hd__fill_2
X_2425_ _2426_/A _2426_/B vssd1 vssd1 vccd1 vccd1 _2431_/C sky130_fd_sc_hd__nor2_2
X_2356_ _2854_/Q _2855_/Q vssd1 vssd1 vccd1 vccd1 _2368_/C sky130_fd_sc_hd__nand2_2
XANTENNA__1645__A2 _1589_/X vssd1 vssd1 vccd1 vccd1 sky130_fd_sc_hd__diode_2
X_1307_ _2800_/Q _1339_/B _2801_/Q vssd1 vssd1 vccd1 vccd1 _1308_/B sky130_fd_sc_hd__a21oi_2
X_2287_ _1366_/A hold459/X _2293_/B1 hold473/X vssd1 vssd1 vccd1 vccd1 _2764_/D sky130_fd_sc_hd__a22o_2
XANTENNA_clkbuf_leaf_7_clk_A clkbuf_leaf_9_clk/A vssd1 vssd1 vccd1 vccd1 sky130_fd_sc_hd__diode_2
Xclkbuf_3_0__f_clk clkbuf_0_clk/X vssd1 vssd1 vccd1 vccd1 clkbuf_leaf_3_clk/A sky130_fd_sc_hd__clkbuf_16
XFILLER_7_200 vssd1 vssd1 vccd1 vccd1 sky130_fd_sc_hd__fill_2
XFILLER_7_255 vssd1 vssd1 vccd1 vccd1 sky130_fd_sc_hd__fill_8
XTAP_TAPCELL_ROW_21_290 vssd1 vccd1 sky130_fd_sc_hd__tapvpwrvgnd_1
Xwire131 wire131/A vssd1 vssd1 vccd1 vccd1 wire131/X sky130_fd_sc_hd__clkbuf_4
XFILLER_59_80 vssd1 vssd1 vccd1 vccd1 sky130_fd_sc_hd__fill_1
Xload_slew136 fanout135/X vssd1 vssd1 vccd1 vccd1 load_slew136/X sky130_fd_sc_hd__buf_4
Xload_slew114 fanout113/X vssd1 vssd1 vccd1 vccd1 fanout111/A sky130_fd_sc_hd__clkbuf_4
Xload_slew103 fanout102/X vssd1 vssd1 vccd1 vccd1 load_slew103/X sky130_fd_sc_hd__clkbuf_2
X_2210_ _2209_/A _2209_/B _2156_/A vssd1 vssd1 vccd1 vccd1 _2210_/Y sky130_fd_sc_hd__a21oi_2
XANTENNA__1627__A2 _2707_/Q vssd1 vssd1 vccd1 vccd1 sky130_fd_sc_hd__diode_2
Xload_slew83 fanout82/X vssd1 vssd1 vccd1 vccd1 load_slew83/X sky130_fd_sc_hd__buf_4
X_2141_ _2699_/Q hold422/X _2154_/S vssd1 vssd1 vccd1 vccd1 _2699_/D sky130_fd_sc_hd__mux2_1
X_2072_ _1358_/A hold336/X _2072_/S vssd1 vssd1 vccd1 vccd1 _2664_/D sky130_fd_sc_hd__mux2_1
XFILLER_34_365 vssd1 vssd1 vccd1 vccd1 sky130_fd_sc_hd__fill_1
X_1925_ _1926_/B _1926_/C _2676_/Q vssd1 vssd1 vccd1 vccd1 _1982_/A sky130_fd_sc_hd__a21oi_2
XANTENNA_fanout102_A fanout105/X vssd1 vssd1 vccd1 vccd1 sky130_fd_sc_hd__diode_2
X_1787_ hold532/X _1811_/A2 _1785_/Y _1786_/X vssd1 vssd1 vccd1 vccd1 _2625_/D sky130_fd_sc_hd__o22a_2
X_1856_ _1863_/C _1830_/Y _1851_/Y vssd1 vssd1 vccd1 vccd1 _1856_/X sky130_fd_sc_hd__a21o_2
XPHY_EDGE_ROW_2_Right_2 vssd1 vssd1 vccd1 vccd1 sky130_fd_sc_hd__decap_3
X_2408_ _2408_/A _2408_/B vssd1 vssd1 vccd1 vccd1 _2829_/D sky130_fd_sc_hd__xnor2_2
X_2339_ _2918_/Q _2337_/X _2919_/Q vssd1 vssd1 vccd1 vccd1 _2340_/B sky130_fd_sc_hd__o21a_2
XFILLER_37_192 vssd1 vssd1 vccd1 vccd1 sky130_fd_sc_hd__fill_2
XTAP_TAPCELL_ROW_27_327 vssd1 vccd1 sky130_fd_sc_hd__tapvpwrvgnd_1
XTAP_TAPCELL_ROW_35_382 vssd1 vccd1 sky130_fd_sc_hd__tapvpwrvgnd_1
XFILLER_20_41 vssd1 vssd1 vccd1 vccd1 sky130_fd_sc_hd__fill_1
XANTENNA__2282__A2 _2282_/A2 vssd1 vssd1 vccd1 vccd1 sky130_fd_sc_hd__diode_2
XFILLER_43_173 vssd1 vssd1 vccd1 vccd1 sky130_fd_sc_hd__fill_1
XFILLER_45_82 vssd1 vssd1 vccd1 vccd1 sky130_fd_sc_hd__fill_1
XFILLER_6_87 vssd1 vssd1 vccd1 vccd1 sky130_fd_sc_hd__fill_1
X_1572_ _1580_/A _2643_/Q _1701_/S vssd1 vssd1 vccd1 vccd1 _1572_/X sky130_fd_sc_hd__and3_2
X_1641_ _2631_/Q _2632_/Q _1822_/A vssd1 vssd1 vccd1 vccd1 _1641_/X sky130_fd_sc_hd__mux2_1
X_1710_ _2624_/Q _2641_/Q _1710_/S vssd1 vssd1 vccd1 vccd1 _1710_/X sky130_fd_sc_hd__mux2_1
X_2690_ _2693_/CLK _2690_/D load_slew97/X vssd1 vssd1 vccd1 vccd1 _2690_/Q sky130_fd_sc_hd__dfrtp_2
X_2124_ _2571_/Q _2587_/Q _2130_/S vssd1 vssd1 vccd1 vccd1 _2124_/X sky130_fd_sc_hd__mux2_1
XTAP_TAPCELL_ROW_24_308 vssd1 vccd1 sky130_fd_sc_hd__tapvpwrvgnd_1
XTAP_TAPCELL_ROW_49_485 vssd1 vccd1 sky130_fd_sc_hd__tapvpwrvgnd_1
X_2055_ _2055_/A _2055_/B _2055_/C vssd1 vssd1 vccd1 vccd1 _2056_/B sky130_fd_sc_hd__or3_2
XTAP_TAPCELL_ROW_32_363 vssd1 vccd1 sky130_fd_sc_hd__tapvpwrvgnd_1
X_1839_ _2637_/Q _1841_/D vssd1 vssd1 vccd1 vccd1 _1873_/B sky130_fd_sc_hd__and2_2
X_1908_ _2711_/Q _1908_/A2 _1907_/Y _1863_/C vssd1 vssd1 vccd1 vccd1 _1908_/X sky130_fd_sc_hd__a22o_2
X_2888_ _2916_/CLK _2888_/D load_slew108/X vssd1 vssd1 vccd1 vccd1 _2888_/Q sky130_fd_sc_hd__dfrtp_2
XANTENNA_fanout105_X fanout105/X vssd1 vssd1 vccd1 vccd1 sky130_fd_sc_hd__diode_2
Xhold520 _2838_/Q vssd1 vssd1 vccd1 vccd1 _2441_/A sky130_fd_sc_hd__dlygate4sd3_1
Xhold531 _2617_/Q vssd1 vssd1 vccd1 vccd1 hold531/X sky130_fd_sc_hd__dlygate4sd3_1
Xhold542 _2909_/Q vssd1 vssd1 vccd1 vccd1 hold542/X sky130_fd_sc_hd__dlygate4sd3_1
XFILLER_57_221 vssd1 vssd1 vccd1 vccd1 sky130_fd_sc_hd__fill_1
Xclkbuf_leaf_37_clk clkbuf_leaf_4_clk/A vssd1 vssd1 vccd1 vccd1 clkload4/A sky130_fd_sc_hd__clkbuf_8
XFILLER_13_335 vssd1 vssd1 vccd1 vccd1 sky130_fd_sc_hd__fill_1
XFILLER_25_184 vssd1 vssd1 vccd1 vccd1 sky130_fd_sc_hd__fill_1
Xteam_06_196 vssd1 vssd1 vccd1 vccd1 team_06_196/HI gpio_oeb[8] sky130_fd_sc_hd__conb_1
XFILLER_56_81 vssd1 vssd1 vccd1 vccd1 sky130_fd_sc_hd__fill_2
Xclkbuf_leaf_28_clk clkbuf_3_5__f_clk/X vssd1 vssd1 vccd1 vccd1 _2902_/CLK sky130_fd_sc_hd__clkbuf_8
XANTENNA_clkbuf_leaf_32_clk_A clkbuf_3_4__f_clk/X vssd1 vssd1 vccd1 vccd1 sky130_fd_sc_hd__diode_2
XFILLER_31_165 vssd1 vssd1 vccd1 vccd1 sky130_fd_sc_hd__fill_1
XFILLER_8_361 vssd1 vssd1 vccd1 vccd1 sky130_fd_sc_hd__fill_1
X_2811_ _2813_/CLK _2811_/D vssd1 vssd1 vccd1 vccd1 _2811_/Q sky130_fd_sc_hd__dfxtp_2
X_2742_ _2870_/CLK _2742_/D load_slew121/X vssd1 vssd1 vccd1 vccd1 _2742_/Q sky130_fd_sc_hd__dfrtp_2
X_1555_ hold355/X _1724_/S _1554_/X vssd1 vssd1 vccd1 vccd1 _2522_/D sky130_fd_sc_hd__o21a_2
X_1624_ _2546_/Q _1623_/X _1624_/S vssd1 vssd1 vccd1 vccd1 _1624_/X sky130_fd_sc_hd__mux2_1
X_2673_ _2689_/CLK _2673_/D fanout96/X vssd1 vssd1 vccd1 vccd1 _2673_/Q sky130_fd_sc_hd__dfrtp_2
XTAP_TAPCELL_ROW_37_400 vssd1 vccd1 sky130_fd_sc_hd__tapvpwrvgnd_1
X_1486_ _2915_/Q _1280_/B _1413_/Y _1485_/X vssd1 vssd1 vccd1 vccd1 _1486_/X sky130_fd_sc_hd__a31o_2
Xclkbuf_leaf_19_clk clkload0/A vssd1 vssd1 vccd1 vccd1 _2768_/CLK sky130_fd_sc_hd__clkbuf_8
X_2107_ hold539/X _2106_/X _2136_/B vssd1 vssd1 vccd1 vccd1 _2680_/D sky130_fd_sc_hd__mux2_1
XFILLER_54_246 vssd1 vssd1 vccd1 vccd1 sky130_fd_sc_hd__fill_1
X_2038_ _2030_/X _2041_/C _2050_/A1 vssd1 vssd1 vccd1 vccd1 _2039_/B sky130_fd_sc_hd__o21ai_2
XANTENNA__2113__S _2136_/B vssd1 vssd1 vccd1 vccd1 sky130_fd_sc_hd__diode_2
XANTENNA__2303__A1_N _2300_/A1 vssd1 vssd1 vccd1 vccd1 sky130_fd_sc_hd__diode_2
Xhold350 _2566_/Q vssd1 vssd1 vccd1 vccd1 hold350/X sky130_fd_sc_hd__dlygate4sd3_1
Xhold361 _2780_/Q vssd1 vssd1 vccd1 vccd1 hold361/X sky130_fd_sc_hd__dlygate4sd3_1
Xhold372 _2777_/Q vssd1 vssd1 vccd1 vccd1 hold372/X sky130_fd_sc_hd__dlygate4sd3_1
Xhold383 _2779_/Q vssd1 vssd1 vccd1 vccd1 hold383/X sky130_fd_sc_hd__dlygate4sd3_1
Xhold394 _2788_/Q vssd1 vssd1 vccd1 vccd1 hold394/X sky130_fd_sc_hd__dlygate4sd3_1
XFILLER_26_40 vssd1 vssd1 vccd1 vccd1 sky130_fd_sc_hd__fill_1
XFILLER_45_279 vssd1 vssd1 vccd1 vccd1 sky130_fd_sc_hd__fill_1
XFILLER_13_198 vssd1 vssd1 vccd1 vccd1 sky130_fd_sc_hd__fill_1
XFILLER_26_95 vssd1 vssd1 vccd1 vccd1 sky130_fd_sc_hd__fill_1
XFILLER_60_249 vssd1 vssd1 vccd1 vccd1 sky130_fd_sc_hd__fill_1
XFILLER_61_9 vssd1 vssd1 vccd1 vccd1 sky130_fd_sc_hd__fill_4
X_1340_ _2738_/Q _1337_/B _1339_/Y _2739_/Q vssd1 vssd1 vccd1 vccd1 _1340_/X sky130_fd_sc_hd__a22o_2
XFILLER_36_224 vssd1 vssd1 vccd1 vccd1 sky130_fd_sc_hd__fill_4
X_1271_ _2829_/Q vssd1 vssd1 vccd1 vccd1 _2408_/A sky130_fd_sc_hd__inv_2
XANTENNA__2441__B _2472_/B vssd1 vssd1 vccd1 vccd1 sky130_fd_sc_hd__diode_2
Xclkbuf_leaf_8_clk clkbuf_leaf_9_clk/A vssd1 vssd1 vccd1 vccd1 _2689_/CLK sky130_fd_sc_hd__clkbuf_8
X_2725_ _2772_/CLK _2725_/D load_slew142/X vssd1 vssd1 vccd1 vccd1 _2725_/Q sky130_fd_sc_hd__dfrtp_2
X_2656_ _2689_/CLK _2656_/D fanout96/X vssd1 vssd1 vccd1 vccd1 _2656_/Q sky130_fd_sc_hd__dfrtp_2
X_1469_ _2969_/A _1464_/Y _1467_/X _1416_/Y _1413_/A vssd1 vssd1 vccd1 vccd1 _1469_/X
+ sky130_fd_sc_hd__o221a_2
X_1538_ _1538_/A _1538_/B vssd1 vssd1 vccd1 vccd1 _1538_/X sky130_fd_sc_hd__or2_2
X_1607_ _1607_/A _1607_/B vssd1 vssd1 vccd1 vccd1 _2541_/D sky130_fd_sc_hd__or2_2
Xfanout159 _2879_/Q vssd1 vssd1 vccd1 vccd1 _1722_/S sky130_fd_sc_hd__clkdlybuf4s25_1
Xfanout148 _1260_/Y vssd1 vssd1 vccd1 vccd1 _2300_/A1 sky130_fd_sc_hd__clkdlybuf4s25_1
Xfanout137 fanout144/X vssd1 vssd1 vccd1 vccd1 fanout137/X sky130_fd_sc_hd__clkdlybuf4s25_1
Xfanout126 fanout132/X vssd1 vssd1 vccd1 vccd1 fanout126/X sky130_fd_sc_hd__clkdlybuf4s25_1
Xfanout115 fanout145/X vssd1 vssd1 vccd1 vccd1 fanout115/X sky130_fd_sc_hd__clkdlybuf4s25_1
Xfanout104 fanout105/X vssd1 vssd1 vccd1 vccd1 fanout104/X sky130_fd_sc_hd__clkdlybuf4s25_1
X_2587_ _2689_/CLK _2587_/D vssd1 vssd1 vccd1 vccd1 _2587_/Q sky130_fd_sc_hd__dfxtp_2
XTAP_TAPCELL_ROW_57_539 vssd1 vccd1 sky130_fd_sc_hd__tapvpwrvgnd_1
XTAP_TAPCELL_ROW_40_417 vssd1 vccd1 sky130_fd_sc_hd__tapvpwrvgnd_1
XANTENNA__1682__S _1686_/S vssd1 vssd1 vccd1 vccd1 sky130_fd_sc_hd__diode_2
XFILLER_5_3 vssd1 vssd1 vccd1 vccd1 sky130_fd_sc_hd__fill_8
XANTENNA__1902__A1 _2645_/Q vssd1 vssd1 vccd1 vccd1 sky130_fd_sc_hd__diode_2
XFILLER_58_360 vssd1 vssd1 vccd1 vccd1 sky130_fd_sc_hd__fill_1
XTAP_TAPCELL_ROW_5_172 vssd1 vccd1 sky130_fd_sc_hd__tapvpwrvgnd_1
X_2510_ _2861_/Q _2509_/B _2410_/A _2510_/B2 vssd1 vssd1 vccd1 vccd1 _2511_/B sky130_fd_sc_hd__a2bb2o_2
X_1323_ _2794_/Q _1321_/B _2795_/Q vssd1 vssd1 vccd1 vccd1 _1324_/B sky130_fd_sc_hd__a21oi_2
X_2441_ _2441_/A _2472_/B vssd1 vssd1 vccd1 vccd1 _2441_/Y sky130_fd_sc_hd__nand2_2
X_2372_ _2472_/B vssd1 vssd1 vccd1 vccd1 _2375_/C sky130_fd_sc_hd__inv_2
XTAP_TAPCELL_ROW_19_274 vssd1 vccd1 sky130_fd_sc_hd__tapvpwrvgnd_1
XANTENNA_fanout132_A fanout145/X vssd1 vssd1 vccd1 vccd1 sky130_fd_sc_hd__diode_2
XTAP_TAPCELL_ROW_62_575 vssd1 vccd1 sky130_fd_sc_hd__tapvpwrvgnd_1
X_2708_ _2768_/CLK _2708_/D load_slew142/X vssd1 vssd1 vccd1 vccd1 _2708_/Q sky130_fd_sc_hd__dfrtp_2
X_2639_ _2642_/CLK _2639_/D fanout132/X vssd1 vssd1 vccd1 vccd1 _2639_/Q sky130_fd_sc_hd__dfrtp_2
XFILLER_59_146 vssd1 vssd1 vccd1 vccd1 sky130_fd_sc_hd__fill_1
XANTENNA_fanout45_A _1723_/S vssd1 vssd1 vccd1 vccd1 sky130_fd_sc_hd__diode_2
XTAP_TAPCELL_ROW_2_153 vssd1 vccd1 sky130_fd_sc_hd__tapvpwrvgnd_1
XANTENNA__1887__A0 _2641_/Q vssd1 vssd1 vccd1 vccd1 sky130_fd_sc_hd__diode_2
XFILLER_2_197 vssd1 vssd1 vccd1 vccd1 sky130_fd_sc_hd__fill_1
XANTENNA__2300__A1 _2300_/A1 vssd1 vssd1 vccd1 vccd1 sky130_fd_sc_hd__diode_2
XFILLER_0_67 vssd1 vssd1 vccd1 vccd1 sky130_fd_sc_hd__fill_1
XFILLER_46_363 vssd1 vssd1 vccd1 vccd1 sky130_fd_sc_hd__fill_1
XFILLER_46_374 vssd1 vssd1 vccd1 vccd1 sky130_fd_sc_hd__fill_1
XFILLER_61_311 vssd1 vssd1 vccd1 vccd1 sky130_fd_sc_hd__fill_1
XTAP_TAPCELL_ROW_16_255 vssd1 vccd1 sky130_fd_sc_hd__tapvpwrvgnd_1
X_1872_ _2637_/Q _1891_/S _1869_/X _1871_/X vssd1 vssd1 vccd1 vccd1 _2637_/D sky130_fd_sc_hd__o22a_2
X_1941_ _1942_/B _1942_/C _2672_/Q vssd1 vssd1 vccd1 vccd1 _1976_/A sky130_fd_sc_hd__a21oi_2
XFILLER_56_138 vssd1 vssd1 vccd1 vccd1 sky130_fd_sc_hd__fill_2
X_1306_ _2804_/Q _1347_/A vssd1 vssd1 vccd1 vccd1 _1306_/X sky130_fd_sc_hd__xor2_2
X_2424_ _2424_/A _2459_/B vssd1 vssd1 vccd1 vccd1 _2424_/Y sky130_fd_sc_hd__nand2_2
X_2355_ _2858_/Q _2859_/Q _2860_/Q _2861_/Q vssd1 vssd1 vccd1 vccd1 _2364_/B sky130_fd_sc_hd__or4bb_2
X_2286_ _1366_/A hold464/X _2293_/B1 hold482/X vssd1 vssd1 vccd1 vccd1 _2763_/D sky130_fd_sc_hd__a22o_2
XANTENNA__1351__A _1351_/A vssd1 vssd1 vccd1 vccd1 sky130_fd_sc_hd__diode_2
XFILLER_64_171 vssd1 vssd1 vccd1 vccd1 sky130_fd_sc_hd__fill_2
XFILLER_60_39 vssd1 vssd1 vccd1 vccd1 sky130_fd_sc_hd__fill_1
XANTENNA__2121__S _2882_/D vssd1 vssd1 vccd1 vccd1 sky130_fd_sc_hd__diode_2
XANTENNA__2294__B1 _2297_/B1 vssd1 vssd1 vccd1 vccd1 sky130_fd_sc_hd__diode_2
XFILLER_18_52 vssd1 vssd1 vccd1 vccd1 sky130_fd_sc_hd__fill_2
XFILLER_11_241 vssd1 vssd1 vccd1 vccd1 sky130_fd_sc_hd__fill_2
XFILLER_34_62 vssd1 vssd1 vccd1 vccd1 sky130_fd_sc_hd__fill_2
XFILLER_43_333 vssd1 vssd1 vccd1 vccd1 sky130_fd_sc_hd__fill_1
X_2140_ hold432/X hold377/X _2154_/S vssd1 vssd1 vccd1 vccd1 _2698_/D sky130_fd_sc_hd__mux2_1
XANTENNA__2285__B1 _2293_/B1 vssd1 vssd1 vccd1 vccd1 sky130_fd_sc_hd__diode_2
XFILLER_19_330 vssd1 vssd1 vccd1 vccd1 sky130_fd_sc_hd__fill_1
XFILLER_38_138 vssd1 vssd1 vccd1 vccd1 sky130_fd_sc_hd__fill_2
XFILLER_53_119 vssd1 vssd1 vccd1 vccd1 sky130_fd_sc_hd__fill_1
Xload_slew95 fanout94/X vssd1 vssd1 vccd1 vccd1 load_slew95/X sky130_fd_sc_hd__clkbuf_4
X_2071_ _2136_/B _2071_/B vssd1 vssd1 vccd1 vccd1 _2072_/S sky130_fd_sc_hd__nor2_2
X_1855_ _2633_/Q _2555_/Q vssd1 vssd1 vccd1 vccd1 _1855_/X sky130_fd_sc_hd__or2_2
X_1924_ _1940_/A _2691_/Q vssd1 vssd1 vccd1 vccd1 _1926_/C sky130_fd_sc_hd__nand2_2
X_1786_ _1796_/A1 _2657_/Q _1786_/B1 _2706_/Q _1810_/C1 vssd1 vssd1 vccd1 vccd1 _1786_/X
+ sky130_fd_sc_hd__a221o_2
X_2407_ hold517/X _2405_/B _2408_/B vssd1 vssd1 vccd1 vccd1 _2828_/D sky130_fd_sc_hd__o21ba_2
X_2338_ _2348_/C _2332_/X _2337_/X _2919_/Q vssd1 vssd1 vccd1 vccd1 _2338_/X sky130_fd_sc_hd__a31o_2
X_2269_ _2261_/Y _2265_/B _2263_/B vssd1 vssd1 vccd1 vccd1 _2270_/C sky130_fd_sc_hd__o21ai_2
XPHY_EDGE_ROW_64_Left_129 vssd1 vssd1 vccd1 vccd1 sky130_fd_sc_hd__decap_3
XTAP_TAPCELL_ROW_27_328 vssd1 vccd1 sky130_fd_sc_hd__tapvpwrvgnd_1
XTAP_TAPCELL_ROW_35_383 vssd1 vccd1 sky130_fd_sc_hd__tapvpwrvgnd_1
XANTENNA__1808__X _1816_/B vssd1 vssd1 vccd1 vccd1 sky130_fd_sc_hd__diode_2
XFILLER_4_215 vssd1 vssd1 vccd1 vccd1 sky130_fd_sc_hd__fill_4
XANTENNA__1690__S _1693_/S vssd1 vssd1 vccd1 vccd1 sky130_fd_sc_hd__diode_2
XFILLER_63_406 vssd1 vssd1 vccd1 vccd1 sky130_fd_sc_hd__fill_1
X_1571_ hold304/X _1558_/B _1570_/X vssd1 vssd1 vccd1 vccd1 _2530_/D sky130_fd_sc_hd__a21o_2
X_1640_ _2630_/Q _1586_/Y _1590_/Y hold457/X _1639_/X vssd1 vssd1 vccd1 vccd1 _2551_/D
+ sky130_fd_sc_hd__o221a_2
XANTENNA_clkbuf_leaf_6_clk_A clkbuf_leaf_9_clk/A vssd1 vssd1 vccd1 vccd1 sky130_fd_sc_hd__diode_2
X_2123_ hold454/X _2122_/X _2125_/S vssd1 vssd1 vccd1 vccd1 _2688_/D sky130_fd_sc_hd__mux2_1
XFILLER_34_185 vssd1 vssd1 vccd1 vccd1 sky130_fd_sc_hd__fill_2
XTAP_TAPCELL_ROW_24_309 vssd1 vccd1 sky130_fd_sc_hd__tapvpwrvgnd_1
XTAP_TAPCELL_ROW_49_486 vssd1 vccd1 sky130_fd_sc_hd__tapvpwrvgnd_1
X_2054_ _2054_/A _2054_/B vssd1 vssd1 vccd1 vccd1 _2057_/A sky130_fd_sc_hd__xnor2_2
XTAP_TAPCELL_ROW_32_364 vssd1 vccd1 sky130_fd_sc_hd__tapvpwrvgnd_1
X_1838_ _1837_/B _1837_/C _1837_/A vssd1 vssd1 vccd1 vccd1 _1841_/D sky130_fd_sc_hd__a21bo_2
X_1907_ _1907_/A _1907_/B vssd1 vssd1 vccd1 vccd1 _1907_/Y sky130_fd_sc_hd__nor2_2
Xhold510 _2676_/Q vssd1 vssd1 vccd1 vccd1 hold510/X sky130_fd_sc_hd__dlygate4sd3_1
X_2887_ clkload9/A _2887_/D load_slew108/X vssd1 vssd1 vccd1 vccd1 _2887_/Q sky130_fd_sc_hd__dfrtp_2
XFILLER_57_211 vssd1 vssd1 vccd1 vccd1 sky130_fd_sc_hd__fill_1
X_1769_ _2621_/Q _1761_/X _2622_/Q vssd1 vssd1 vccd1 vccd1 _1770_/B sky130_fd_sc_hd__a21o_2
Xhold521 _2901_/Q vssd1 vssd1 vccd1 vccd1 hold521/X sky130_fd_sc_hd__dlygate4sd3_1
Xhold532 _2625_/Q vssd1 vssd1 vccd1 vccd1 hold532/X sky130_fd_sc_hd__dlygate4sd3_1
Xhold543 _2654_/Q vssd1 vssd1 vccd1 vccd1 hold543/X sky130_fd_sc_hd__dlygate4sd3_1
XFILLER_21_391 vssd1 vssd1 vccd1 vccd1 sky130_fd_sc_hd__fill_1
Xoutput30 _2537_/Q vssd1 vssd1 vccd1 vccd1 gpio_out[8] sky130_fd_sc_hd__clkdlybuf4s25_1
Xteam_06_197 vssd1 vssd1 vccd1 vccd1 team_06_197/HI gpio_oeb[9] sky130_fd_sc_hd__conb_1
XFILLER_16_141 vssd1 vssd1 vccd1 vccd1 sky130_fd_sc_hd__fill_1
X_2810_ _2813_/CLK _2810_/D vssd1 vssd1 vccd1 vccd1 _2810_/Q sky130_fd_sc_hd__dfxtp_2
X_2741_ _2870_/CLK _2741_/D load_slew121/X vssd1 vssd1 vccd1 vccd1 _2741_/Q sky130_fd_sc_hd__dfrtp_2
X_2672_ _2688_/CLK _2672_/D load_slew95/X vssd1 vssd1 vccd1 vccd1 _2672_/Q sky130_fd_sc_hd__dfrtp_2
X_1485_ _2915_/Q _1415_/B _1280_/Y vssd1 vssd1 vccd1 vccd1 _1485_/X sky130_fd_sc_hd__o21a_2
X_1554_ _2634_/Q _1558_/B _1582_/A vssd1 vssd1 vccd1 vccd1 _1554_/X sky130_fd_sc_hd__or3b_2
X_1623_ _2642_/Q _1716_/S _1590_/A _1622_/X vssd1 vssd1 vccd1 vccd1 _1623_/X sky130_fd_sc_hd__a22o_2
.ends
