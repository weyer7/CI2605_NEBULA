* NGSPICE file created from team_06.ext - technology: sky130A

* Black-box entry subcircuit for sky130_fd_sc_hd__fill_1 abstract view
.subckt sky130_fd_sc_hd__fill_1 VGND VNB VPB VPWR
.ends

* Black-box entry subcircuit for sky130_fd_sc_hd__fill_8 abstract view
.subckt sky130_fd_sc_hd__fill_8 VGND VNB VPB VPWR
.ends

* Black-box entry subcircuit for sky130_fd_sc_hd__tapvpwrvgnd_1 abstract view
.subckt sky130_fd_sc_hd__tapvpwrvgnd_1 VGND VPWR
.ends

* Black-box entry subcircuit for sky130_fd_sc_hd__o2bb2a_1 abstract view
.subckt sky130_fd_sc_hd__o2bb2a_1 A1_N A2_N B1 B2 VGND VNB VPB VPWR X
.ends

* Black-box entry subcircuit for sky130_fd_sc_hd__and4_1 abstract view
.subckt sky130_fd_sc_hd__and4_1 A B C D VGND VNB VPB VPWR X
.ends

* Black-box entry subcircuit for sky130_fd_sc_hd__fill_2 abstract view
.subckt sky130_fd_sc_hd__fill_2 VGND VNB VPB VPWR
.ends

* Black-box entry subcircuit for sky130_fd_sc_hd__diode_2 abstract view
.subckt sky130_fd_sc_hd__diode_2 DIODE VGND VNB VPB VPWR
.ends

* Black-box entry subcircuit for sky130_fd_sc_hd__fill_4 abstract view
.subckt sky130_fd_sc_hd__fill_4 VGND VNB VPB VPWR
.ends

* Black-box entry subcircuit for sky130_fd_sc_hd__a21o_1 abstract view
.subckt sky130_fd_sc_hd__a21o_1 A1 A2 B1 VGND VNB VPB VPWR X
.ends

* Black-box entry subcircuit for sky130_fd_sc_hd__dfrtp_1 abstract view
.subckt sky130_fd_sc_hd__dfrtp_1 CLK D RESET_B VGND VNB VPB VPWR Q
.ends

* Black-box entry subcircuit for sky130_fd_sc_hd__nor2_1 abstract view
.subckt sky130_fd_sc_hd__nor2_1 A B VGND VNB VPB VPWR Y
.ends

* Black-box entry subcircuit for sky130_fd_sc_hd__nand2_1 abstract view
.subckt sky130_fd_sc_hd__nand2_1 A B VGND VNB VPB VPWR Y
.ends

* Black-box entry subcircuit for sky130_fd_sc_hd__a31o_1 abstract view
.subckt sky130_fd_sc_hd__a31o_1 A1 A2 A3 B1 VGND VNB VPB VPWR X
.ends

* Black-box entry subcircuit for sky130_fd_sc_hd__buf_1 abstract view
.subckt sky130_fd_sc_hd__buf_1 A VGND VNB VPB VPWR X
.ends

* Black-box entry subcircuit for sky130_fd_sc_hd__mux2_1 abstract view
.subckt sky130_fd_sc_hd__mux2_1 A0 A1 S VGND VNB VPB VPWR X
.ends

* Black-box entry subcircuit for sky130_fd_sc_hd__clkbuf_4 abstract view
.subckt sky130_fd_sc_hd__clkbuf_4 A VGND VNB VPB VPWR X
.ends

* Black-box entry subcircuit for sky130_fd_sc_hd__dfxtp_1 abstract view
.subckt sky130_fd_sc_hd__dfxtp_1 CLK D VGND VNB VPB VPWR Q
.ends

* Black-box entry subcircuit for sky130_fd_sc_hd__buf_2 abstract view
.subckt sky130_fd_sc_hd__buf_2 A VGND VNB VPB VPWR X
.ends

* Black-box entry subcircuit for sky130_ef_sc_hd__decap_40_12 abstract view
.subckt sky130_ef_sc_hd__decap_40_12 VPWR VGND VPB VNB
.ends

* Black-box entry subcircuit for sky130_fd_sc_hd__dlygate4sd3_1 abstract view
.subckt sky130_fd_sc_hd__dlygate4sd3_1 A VGND VNB VPB VPWR X
.ends

* Black-box entry subcircuit for sky130_fd_sc_hd__o21ai_1 abstract view
.subckt sky130_fd_sc_hd__o21ai_1 A1 A2 B1 VGND VNB VPB VPWR Y
.ends

* Black-box entry subcircuit for sky130_fd_sc_hd__a22o_1 abstract view
.subckt sky130_fd_sc_hd__a22o_1 A1 A2 B1 B2 VGND VNB VPB VPWR X
.ends

* Black-box entry subcircuit for sky130_fd_sc_hd__a41oi_2 abstract view
.subckt sky130_fd_sc_hd__a41oi_2 A1 A2 A3 A4 B1 VGND VNB VPB VPWR Y
.ends

* Black-box entry subcircuit for sky130_fd_sc_hd__o22a_1 abstract view
.subckt sky130_fd_sc_hd__o22a_1 A1 A2 B1 B2 VGND VNB VPB VPWR X
.ends

* Black-box entry subcircuit for sky130_fd_sc_hd__o22ai_1 abstract view
.subckt sky130_fd_sc_hd__o22ai_1 A1 A2 B1 B2 VGND VNB VPB VPWR Y
.ends

* Black-box entry subcircuit for sky130_fd_sc_hd__o21a_1 abstract view
.subckt sky130_fd_sc_hd__o21a_1 A1 A2 B1 VGND VNB VPB VPWR X
.ends

* Black-box entry subcircuit for sky130_fd_sc_hd__nand4_1 abstract view
.subckt sky130_fd_sc_hd__nand4_1 A B C D VGND VNB VPB VPWR Y
.ends

* Black-box entry subcircuit for sky130_fd_sc_hd__and2b_1 abstract view
.subckt sky130_fd_sc_hd__and2b_1 A_N B VGND VNB VPB VPWR X
.ends

* Black-box entry subcircuit for sky130_fd_sc_hd__a211o_1 abstract view
.subckt sky130_fd_sc_hd__a211o_1 A1 A2 B1 C1 VGND VNB VPB VPWR X
.ends

* Black-box entry subcircuit for sky130_fd_sc_hd__a221o_1 abstract view
.subckt sky130_fd_sc_hd__a221o_1 A1 A2 B1 B2 C1 VGND VNB VPB VPWR X
.ends

* Black-box entry subcircuit for sky130_fd_sc_hd__a2bb2o_1 abstract view
.subckt sky130_fd_sc_hd__a2bb2o_1 A1_N A2_N B1 B2 VGND VNB VPB VPWR X
.ends

* Black-box entry subcircuit for sky130_fd_sc_hd__xor2_1 abstract view
.subckt sky130_fd_sc_hd__xor2_1 A B VGND VNB VPB VPWR X
.ends

* Black-box entry subcircuit for sky130_fd_sc_hd__conb_1 abstract view
.subckt sky130_fd_sc_hd__conb_1 VGND VNB VPB VPWR HI LO
.ends

* Black-box entry subcircuit for sky130_fd_sc_hd__a21oi_1 abstract view
.subckt sky130_fd_sc_hd__a21oi_1 A1 A2 B1 VGND VNB VPB VPWR Y
.ends

* Black-box entry subcircuit for sky130_fd_sc_hd__xnor2_1 abstract view
.subckt sky130_fd_sc_hd__xnor2_1 A B VGND VNB VPB VPWR Y
.ends

* Black-box entry subcircuit for sky130_fd_sc_hd__and2_1 abstract view
.subckt sky130_fd_sc_hd__and2_1 A B VGND VNB VPB VPWR X
.ends

* Black-box entry subcircuit for sky130_fd_sc_hd__or2_1 abstract view
.subckt sky130_fd_sc_hd__or2_1 A B VGND VNB VPB VPWR X
.ends

* Black-box entry subcircuit for sky130_fd_sc_hd__clkbuf_2 abstract view
.subckt sky130_fd_sc_hd__clkbuf_2 A VGND VNB VPB VPWR X
.ends

* Black-box entry subcircuit for sky130_fd_sc_hd__decap_3 abstract view
.subckt sky130_fd_sc_hd__decap_3 VGND VNB VPB VPWR
.ends

* Black-box entry subcircuit for sky130_fd_sc_hd__dfrtp_2 abstract view
.subckt sky130_fd_sc_hd__dfrtp_2 CLK D RESET_B VGND VNB VPB VPWR Q
.ends

* Black-box entry subcircuit for sky130_fd_sc_hd__or4_1 abstract view
.subckt sky130_fd_sc_hd__or4_1 A B C D VGND VNB VPB VPWR X
.ends

* Black-box entry subcircuit for sky130_fd_sc_hd__inv_2 abstract view
.subckt sky130_fd_sc_hd__inv_2 A VGND VNB VPB VPWR Y
.ends

* Black-box entry subcircuit for sky130_fd_sc_hd__a41o_1 abstract view
.subckt sky130_fd_sc_hd__a41o_1 A1 A2 A3 A4 B1 VGND VNB VPB VPWR X
.ends

* Black-box entry subcircuit for sky130_fd_sc_hd__o311a_1 abstract view
.subckt sky130_fd_sc_hd__o311a_1 A1 A2 A3 B1 C1 VGND VNB VPB VPWR X
.ends

* Black-box entry subcircuit for sky130_fd_sc_hd__o211a_1 abstract view
.subckt sky130_fd_sc_hd__o211a_1 A1 A2 B1 C1 VGND VNB VPB VPWR X
.ends

* Black-box entry subcircuit for sky130_fd_sc_hd__nand2b_1 abstract view
.subckt sky130_fd_sc_hd__nand2b_1 A_N B VGND VNB VPB VPWR Y
.ends

* Black-box entry subcircuit for sky130_fd_sc_hd__a32o_1 abstract view
.subckt sky130_fd_sc_hd__a32o_1 A1 A2 A3 B1 B2 VGND VNB VPB VPWR X
.ends

* Black-box entry subcircuit for sky130_fd_sc_hd__nand3_1 abstract view
.subckt sky130_fd_sc_hd__nand3_1 A B C VGND VNB VPB VPWR Y
.ends

* Black-box entry subcircuit for sky130_fd_sc_hd__nand3b_2 abstract view
.subckt sky130_fd_sc_hd__nand3b_2 A_N B C VGND VNB VPB VPWR Y
.ends

* Black-box entry subcircuit for sky130_fd_sc_hd__dfrtp_4 abstract view
.subckt sky130_fd_sc_hd__dfrtp_4 CLK D RESET_B VGND VNB VPB VPWR Q
.ends

* Black-box entry subcircuit for sky130_fd_sc_hd__and3b_1 abstract view
.subckt sky130_fd_sc_hd__and3b_1 A_N B C VGND VNB VPB VPWR X
.ends

* Black-box entry subcircuit for sky130_fd_sc_hd__o32a_1 abstract view
.subckt sky130_fd_sc_hd__o32a_1 A1 A2 A3 B1 B2 VGND VNB VPB VPWR X
.ends

* Black-box entry subcircuit for sky130_fd_sc_hd__and3_1 abstract view
.subckt sky130_fd_sc_hd__and3_1 A B C VGND VNB VPB VPWR X
.ends

* Black-box entry subcircuit for sky130_fd_sc_hd__or4b_4 abstract view
.subckt sky130_fd_sc_hd__or4b_4 A B C D_N VGND VNB VPB VPWR X
.ends

* Black-box entry subcircuit for sky130_fd_sc_hd__or3b_1 abstract view
.subckt sky130_fd_sc_hd__or3b_1 A B C_N VGND VNB VPB VPWR X
.ends

* Black-box entry subcircuit for sky130_fd_sc_hd__or4b_1 abstract view
.subckt sky130_fd_sc_hd__or4b_1 A B C D_N VGND VNB VPB VPWR X
.ends

* Black-box entry subcircuit for sky130_fd_sc_hd__o21ai_4 abstract view
.subckt sky130_fd_sc_hd__o21ai_4 A1 A2 B1 VGND VNB VPB VPWR Y
.ends

* Black-box entry subcircuit for sky130_fd_sc_hd__o21ai_2 abstract view
.subckt sky130_fd_sc_hd__o21ai_2 A1 A2 B1 VGND VNB VPB VPWR Y
.ends

* Black-box entry subcircuit for sky130_fd_sc_hd__clkbuf_8 abstract view
.subckt sky130_fd_sc_hd__clkbuf_8 A VGND VNB VPB VPWR X
.ends

* Black-box entry subcircuit for sky130_fd_sc_hd__a31oi_1 abstract view
.subckt sky130_fd_sc_hd__a31oi_1 A1 A2 A3 B1 VGND VNB VPB VPWR Y
.ends

* Black-box entry subcircuit for sky130_fd_sc_hd__a21boi_1 abstract view
.subckt sky130_fd_sc_hd__a21boi_1 A1 A2 B1_N VGND VNB VPB VPWR Y
.ends

* Black-box entry subcircuit for sky130_fd_sc_hd__or4b_2 abstract view
.subckt sky130_fd_sc_hd__or4b_2 A B C D_N VGND VNB VPB VPWR X
.ends

* Black-box entry subcircuit for sky130_fd_sc_hd__nor2_2 abstract view
.subckt sky130_fd_sc_hd__nor2_2 A B VGND VNB VPB VPWR Y
.ends

* Black-box entry subcircuit for sky130_fd_sc_hd__inv_8 abstract view
.subckt sky130_fd_sc_hd__inv_8 A VGND VNB VPB VPWR Y
.ends

* Black-box entry subcircuit for sky130_fd_sc_hd__o21ba_1 abstract view
.subckt sky130_fd_sc_hd__o21ba_1 A1 A2 B1_N VGND VNB VPB VPWR X
.ends

* Black-box entry subcircuit for sky130_fd_sc_hd__or3_1 abstract view
.subckt sky130_fd_sc_hd__or3_1 A B C VGND VNB VPB VPWR X
.ends

* Black-box entry subcircuit for sky130_fd_sc_hd__o31a_1 abstract view
.subckt sky130_fd_sc_hd__o31a_1 A1 A2 A3 B1 VGND VNB VPB VPWR X
.ends

* Black-box entry subcircuit for sky130_fd_sc_hd__a21oi_2 abstract view
.subckt sky130_fd_sc_hd__a21oi_2 A1 A2 B1 VGND VNB VPB VPWR Y
.ends

* Black-box entry subcircuit for sky130_fd_sc_hd__clkinv_4 abstract view
.subckt sky130_fd_sc_hd__clkinv_4 A VGND VNB VPB VPWR Y
.ends

* Black-box entry subcircuit for sky130_fd_sc_hd__inv_6 abstract view
.subckt sky130_fd_sc_hd__inv_6 A VGND VNB VPB VPWR Y
.ends

* Black-box entry subcircuit for sky130_fd_sc_hd__nand2_2 abstract view
.subckt sky130_fd_sc_hd__nand2_2 A B VGND VNB VPB VPWR Y
.ends

* Black-box entry subcircuit for sky130_fd_sc_hd__bufinv_16 abstract view
.subckt sky130_fd_sc_hd__bufinv_16 A VGND VNB VPB VPWR Y
.ends

* Black-box entry subcircuit for sky130_fd_sc_hd__o31ai_4 abstract view
.subckt sky130_fd_sc_hd__o31ai_4 A1 A2 A3 B1 VGND VNB VPB VPWR Y
.ends

* Black-box entry subcircuit for sky130_fd_sc_hd__nor3_1 abstract view
.subckt sky130_fd_sc_hd__nor3_1 A B C VGND VNB VPB VPWR Y
.ends

* Black-box entry subcircuit for sky130_fd_sc_hd__a21bo_1 abstract view
.subckt sky130_fd_sc_hd__a21bo_1 A1 A2 B1_N VGND VNB VPB VPWR X
.ends

* Black-box entry subcircuit for sky130_fd_sc_hd__clkbuf_16 abstract view
.subckt sky130_fd_sc_hd__clkbuf_16 A VGND VNB VPB VPWR X
.ends

* Black-box entry subcircuit for sky130_fd_sc_hd__or3_2 abstract view
.subckt sky130_fd_sc_hd__or3_2 A B C VGND VNB VPB VPWR X
.ends

* Black-box entry subcircuit for sky130_fd_sc_hd__clkinv_2 abstract view
.subckt sky130_fd_sc_hd__clkinv_2 A VGND VNB VPB VPWR Y
.ends

* Black-box entry subcircuit for sky130_fd_sc_hd__o221a_1 abstract view
.subckt sky130_fd_sc_hd__o221a_1 A1 A2 B1 B2 C1 VGND VNB VPB VPWR X
.ends

* Black-box entry subcircuit for sky130_fd_sc_hd__dfstp_1 abstract view
.subckt sky130_fd_sc_hd__dfstp_1 CLK D SET_B VGND VNB VPB VPWR Q
.ends

* Black-box entry subcircuit for sky130_fd_sc_hd__nor3_4 abstract view
.subckt sky130_fd_sc_hd__nor3_4 A B C VGND VNB VPB VPWR Y
.ends

* Black-box entry subcircuit for sky130_fd_sc_hd__inv_4 abstract view
.subckt sky130_fd_sc_hd__inv_4 A VGND VNB VPB VPWR Y
.ends

* Black-box entry subcircuit for sky130_fd_sc_hd__clkbuf_1 abstract view
.subckt sky130_fd_sc_hd__clkbuf_1 A VGND VNB VPB VPWR X
.ends

* Black-box entry subcircuit for sky130_fd_sc_hd__nor4_1 abstract view
.subckt sky130_fd_sc_hd__nor4_1 A B C D VGND VNB VPB VPWR Y
.ends

* Black-box entry subcircuit for sky130_fd_sc_hd__inv_12 abstract view
.subckt sky130_fd_sc_hd__inv_12 A VGND VNB VPB VPWR Y
.ends

* Black-box entry subcircuit for sky130_fd_sc_hd__nand2_4 abstract view
.subckt sky130_fd_sc_hd__nand2_4 A B VGND VNB VPB VPWR Y
.ends

* Black-box entry subcircuit for sky130_fd_sc_hd__dlymetal6s2s_1 abstract view
.subckt sky130_fd_sc_hd__dlymetal6s2s_1 A VGND VNB VPB VPWR X
.ends

* Black-box entry subcircuit for sky130_fd_sc_hd__o21bai_1 abstract view
.subckt sky130_fd_sc_hd__o21bai_1 A1 A2 B1_N VGND VNB VPB VPWR Y
.ends

* Black-box entry subcircuit for sky130_fd_sc_hd__a22oi_2 abstract view
.subckt sky130_fd_sc_hd__a22oi_2 A1 A2 B1 B2 VGND VNB VPB VPWR Y
.ends

* Black-box entry subcircuit for sky130_fd_sc_hd__or3b_2 abstract view
.subckt sky130_fd_sc_hd__or3b_2 A B C_N VGND VNB VPB VPWR X
.ends

* Black-box entry subcircuit for sky130_fd_sc_hd__a31oi_2 abstract view
.subckt sky130_fd_sc_hd__a31oi_2 A1 A2 A3 B1 VGND VNB VPB VPWR Y
.ends

* Black-box entry subcircuit for sky130_fd_sc_hd__or4bb_1 abstract view
.subckt sky130_fd_sc_hd__or4bb_1 A B C_N D_N VGND VNB VPB VPWR X
.ends

* Black-box entry subcircuit for sky130_fd_sc_hd__and4b_1 abstract view
.subckt sky130_fd_sc_hd__and4b_1 A_N B C D VGND VNB VPB VPWR X
.ends

* Black-box entry subcircuit for sky130_fd_sc_hd__and4bb_2 abstract view
.subckt sky130_fd_sc_hd__and4bb_2 A_N B_N C D VGND VNB VPB VPWR X
.ends

* Black-box entry subcircuit for sky130_fd_sc_hd__clkinv_8 abstract view
.subckt sky130_fd_sc_hd__clkinv_8 A VGND VNB VPB VPWR Y
.ends

* Black-box entry subcircuit for sky130_fd_sc_hd__nand3b_4 abstract view
.subckt sky130_fd_sc_hd__nand3b_4 A_N B C VGND VNB VPB VPWR Y
.ends

* Black-box entry subcircuit for sky130_fd_sc_hd__a22oi_1 abstract view
.subckt sky130_fd_sc_hd__a22oi_1 A1 A2 B1 B2 VGND VNB VPB VPWR Y
.ends

* Black-box entry subcircuit for sky130_fd_sc_hd__nor3b_2 abstract view
.subckt sky130_fd_sc_hd__nor3b_2 A B C_N VGND VNB VPB VPWR Y
.ends

* Black-box entry subcircuit for sky130_fd_sc_hd__o2111a_1 abstract view
.subckt sky130_fd_sc_hd__o2111a_1 A1 A2 B1 C1 D1 VGND VNB VPB VPWR X
.ends

* Black-box entry subcircuit for sky130_fd_sc_hd__and2_2 abstract view
.subckt sky130_fd_sc_hd__and2_2 A B VGND VNB VPB VPWR X
.ends

* Black-box entry subcircuit for sky130_fd_sc_hd__and4_2 abstract view
.subckt sky130_fd_sc_hd__and4_2 A B C D VGND VNB VPB VPWR X
.ends

* Black-box entry subcircuit for sky130_fd_sc_hd__a221oi_1 abstract view
.subckt sky130_fd_sc_hd__a221oi_1 A1 A2 B1 B2 C1 VGND VNB VPB VPWR Y
.ends

* Black-box entry subcircuit for sky130_fd_sc_hd__or2_2 abstract view
.subckt sky130_fd_sc_hd__or2_2 A B VGND VNB VPB VPWR X
.ends

* Black-box entry subcircuit for sky130_fd_sc_hd__or4_2 abstract view
.subckt sky130_fd_sc_hd__or4_2 A B C D VGND VNB VPB VPWR X
.ends

* Black-box entry subcircuit for sky130_fd_sc_hd__a211oi_1 abstract view
.subckt sky130_fd_sc_hd__a211oi_1 A1 A2 B1 C1 VGND VNB VPB VPWR Y
.ends

* Black-box entry subcircuit for sky130_fd_sc_hd__or2_4 abstract view
.subckt sky130_fd_sc_hd__or2_4 A B VGND VNB VPB VPWR X
.ends

* Black-box entry subcircuit for sky130_fd_sc_hd__o2111ai_1 abstract view
.subckt sky130_fd_sc_hd__o2111ai_1 A1 A2 B1 C1 D1 VGND VNB VPB VPWR Y
.ends

* Black-box entry subcircuit for sky130_fd_sc_hd__o211ai_1 abstract view
.subckt sky130_fd_sc_hd__o211ai_1 A1 A2 B1 C1 VGND VNB VPB VPWR Y
.ends

.subckt team_06 clk en gpio_in[0] gpio_in[10] gpio_in[11] gpio_in[12] gpio_in[13]
+ gpio_in[14] gpio_in[15] gpio_in[16] gpio_in[17] gpio_in[18] gpio_in[19] gpio_in[1]
+ gpio_in[20] gpio_in[21] gpio_in[22] gpio_in[23] gpio_in[24] gpio_in[25] gpio_in[26]
+ gpio_in[27] gpio_in[28] gpio_in[29] gpio_in[2] gpio_in[30] gpio_in[31] gpio_in[32]
+ gpio_in[33] gpio_in[3] gpio_in[4] gpio_in[5] gpio_in[6] gpio_in[7] gpio_in[8] gpio_in[9]
+ gpio_oeb[0] gpio_oeb[10] gpio_oeb[11] gpio_oeb[12] gpio_oeb[13] gpio_oeb[14] gpio_oeb[15]
+ gpio_oeb[16] gpio_oeb[17] gpio_oeb[18] gpio_oeb[19] gpio_oeb[1] gpio_oeb[20] gpio_oeb[21]
+ gpio_oeb[22] gpio_oeb[23] gpio_oeb[24] gpio_oeb[25] gpio_oeb[26] gpio_oeb[27] gpio_oeb[28]
+ gpio_oeb[29] gpio_oeb[2] gpio_oeb[30] gpio_oeb[31] gpio_oeb[32] gpio_oeb[33] gpio_oeb[3]
+ gpio_oeb[4] gpio_oeb[5] gpio_oeb[6] gpio_oeb[7] gpio_oeb[8] gpio_oeb[9] gpio_out[0]
+ gpio_out[10] gpio_out[11] gpio_out[12] gpio_out[13] gpio_out[14] gpio_out[15] gpio_out[16]
+ gpio_out[17] gpio_out[18] gpio_out[19] gpio_out[1] gpio_out[20] gpio_out[21] gpio_out[22]
+ gpio_out[23] gpio_out[24] gpio_out[25] gpio_out[26] gpio_out[27] gpio_out[28] gpio_out[29]
+ gpio_out[2] gpio_out[30] gpio_out[31] gpio_out[32] gpio_out[33] gpio_out[3] gpio_out[4]
+ gpio_out[5] gpio_out[6] gpio_out[7] gpio_out[8] gpio_out[9] nrst vccd1 vssd1
XFILLER_54_203 vssd1 vssd1 vccd1 vccd1 sky130_fd_sc_hd__fill_1
XFILLER_39_255 vssd1 vssd1 vccd1 vccd1 sky130_fd_sc_hd__fill_8
XTAP_TAPCELL_ROW_37_401 vssd1 vccd1 sky130_fd_sc_hd__tapvpwrvgnd_1
X_2106_ CALC_INST.input_ctrl_inst.decoded_key\[0\] _1084_ _1153_ _1065_ vssd1 vssd1
+ vccd1 vccd1 _1154_ sky130_fd_sc_hd__o2bb2a_1
XFILLER_27_406 vssd1 vssd1 vccd1 vccd1 sky130_fd_sc_hd__fill_1
X_2037_ CALC_INST.gencon_inst.mult_calc.count.GENERATE_ADDER\[6\].thingy.in1 CALC_INST.gencon_inst.mult_calc.count.GENERATE_ADDER\[5\].thingy.in1
+ CALC_INST.gencon_inst.mult_calc.count.GENERATE_ADDER\[4\].thingy.in1 _1089_ vssd1
+ vssd1 vccd1 vccd1 _1091_ sky130_fd_sc_hd__and4_1
XFILLER_52_29 vssd1 vssd1 vccd1 vccd1 sky130_fd_sc_hd__fill_2
XANTENNA_fanout75_A _1145_ vssd1 vssd1 vccd1 vccd1 sky130_fd_sc_hd__diode_2
XFILLER_45_225 vssd1 vssd1 vccd1 vccd1 sky130_fd_sc_hd__fill_2
XFILLER_26_85 vssd1 vssd1 vccd1 vccd1 sky130_fd_sc_hd__fill_4
XFILLER_42_73 vssd1 vssd1 vccd1 vccd1 sky130_fd_sc_hd__fill_1
X_1270_ CALC_INST.gencon_inst.mult_calc.out\[13\] net55 _0627_ vssd1 vssd1 vccd1 vccd1
+ _0628_ sky130_fd_sc_hd__a21o_1
XANTENNA__1684__A1 net100 vssd1 vssd1 vccd1 vccd1 sky130_fd_sc_hd__diode_2
XANTENNA__1684__B2 net86 vssd1 vssd1 vccd1 vccd1 sky130_fd_sc_hd__diode_2
XFILLER_51_217 vssd1 vssd1 vccd1 vccd1 sky130_fd_sc_hd__fill_4
XFILLER_44_280 vssd1 vssd1 vccd1 vccd1 sky130_fd_sc_hd__fill_2
X_2724_ clknet_leaf_22_clk _0262_ net143 vssd1 vssd1 vccd1 vccd1 CALC_INST.gencon_inst.mult_calc.out\[9\]
+ sky130_fd_sc_hd__dfrtp_1
X_1606_ CALC_INST.gencon_inst.mult_calc.main.GENERATE_ADDER\[1\].thingy.in2 CALC_INST.gencon_inst.mult_calc.main.GENERATE_ADDER\[1\].thingy.in1
+ vssd1 vssd1 vccd1 vccd1 _0847_ sky130_fd_sc_hd__nor2_1
X_2655_ clknet_leaf_31_clk _0193_ net122 vssd1 vssd1 vccd1 vccd1 CALC_INST.gencon_inst.mult_calc.adderSave\[1\]
+ sky130_fd_sc_hd__dfrtp_1
X_1468_ net106 CALC_INST.gencon_inst.add_calc.main.in2\[5\] vssd1 vssd1 vccd1 vccd1
+ _0727_ sky130_fd_sc_hd__nand2_1
X_1537_ net31 _0788_ _0790_ net81 vssd1 vssd1 vccd1 vccd1 _0792_ sky130_fd_sc_hd__a31o_1
Xfanout105 net106 vssd1 vssd1 vccd1 vccd1 net105 sky130_fd_sc_hd__buf_1
X_1399_ net406 _0674_ net109 vssd1 vssd1 vccd1 vccd1 _0158_ sky130_fd_sc_hd__mux2_1
Xfanout127 net132 vssd1 vssd1 vccd1 vccd1 net127 sky130_fd_sc_hd__clkbuf_4
XFILLER_47_29 vssd1 vssd1 vccd1 vccd1 sky130_fd_sc_hd__fill_2
X_2586_ clknet_leaf_7_clk net206 vssd1 vssd1 vccd1 vccd1 CALC_INST.gencon_inst.prev_operator_input\[1\]
+ sky130_fd_sc_hd__dfxtp_1
Xfanout149 net150 vssd1 vssd1 vccd1 vccd1 net149 sky130_fd_sc_hd__clkbuf_4
Xfanout138 net139 vssd1 vssd1 vccd1 vccd1 net138 sky130_fd_sc_hd__buf_2
Xfanout116 net123 vssd1 vssd1 vccd1 vccd1 net116 sky130_fd_sc_hd__buf_2
XTAP_TAPCELL_ROW_40_418 vssd1 vccd1 sky130_fd_sc_hd__tapvpwrvgnd_1
XFILLER_6_129 vssd1 vssd1 vccd1 vccd1 sky130_fd_sc_hd__fill_4
XFILLER_12_32 vccd1 vssd1 vccd1 vssd1 sky130_ef_sc_hd__decap_40_12
Xhold181 CALC_INST.gencon_inst.add_calc.main.GENERATE_ADDER\[2\].thingy.in1 vssd1
+ vssd1 vccd1 vccd1 net377 sky130_fd_sc_hd__dlygate4sd3_1
Xhold170 CALC_INST.gencon_inst.add_calc.main.in2\[4\] vssd1 vssd1 vccd1 vccd1 net366
+ sky130_fd_sc_hd__dlygate4sd3_1
Xhold192 CALC_INST.input_ctrl_inst.scan_timer\[13\] vssd1 vssd1 vccd1 vccd1 net388
+ sky130_fd_sc_hd__dlygate4sd3_1
XFILLER_58_361 vssd1 vssd1 vccd1 vccd1 sky130_fd_sc_hd__fill_2
XTAP_TAPCELL_ROW_5_173 vssd1 vccd1 sky130_fd_sc_hd__tapvpwrvgnd_1
XANTENNA_clkbuf_leaf_31_clk_A clknet_2_0__leaf_clk vssd1 vssd1 vccd1 vccd1 sky130_fd_sc_hd__diode_2
XFILLER_53_50 vssd1 vssd1 vccd1 vccd1 sky130_fd_sc_hd__fill_1
XANTENNA__2382__X _0520_ vssd1 vssd1 vccd1 vccd1 sky130_fd_sc_hd__diode_2
XFILLER_33_206 vssd1 vssd1 vccd1 vccd1 sky130_fd_sc_hd__fill_1
X_2440_ CALC_INST.gencon_inst.operand1\[9\] _0564_ _0519_ vssd1 vssd1 vccd1 vccd1
+ _0569_ sky130_fd_sc_hd__o21ai_1
X_1322_ CALC_INST.gencon_inst.operand2\[3\] net244 net51 vssd1 vssd1 vccd1 vccd1 _0109_
+ sky130_fd_sc_hd__mux2_1
X_1253_ CALC_INST.gencon_inst.ALU_out\[8\] net69 _0615_ vssd1 vssd1 vccd1 vccd1 _0616_
+ sky130_fd_sc_hd__a21o_1
X_2371_ CALC_INST.gencon_inst.operand2\[12\] _0511_ net34 vssd1 vssd1 vccd1 vccd1
+ _0044_ sky130_fd_sc_hd__mux2_1
XANTENNA__1340__C net112 vssd1 vssd1 vccd1 vccd1 sky130_fd_sc_hd__diode_2
XTAP_TAPCELL_ROW_19_275 vssd1 vccd1 sky130_fd_sc_hd__tapvpwrvgnd_1
XTAP_TAPCELL_ROW_62_576 vssd1 vccd1 sky130_fd_sc_hd__tapvpwrvgnd_1
XANTENNA_fanout125_A net132 vssd1 vssd1 vccd1 vccd1 sky130_fd_sc_hd__diode_2
X_2638_ clknet_leaf_10_clk _0176_ net130 vssd1 vssd1 vccd1 vccd1 CALC_INST.gencon_inst.ALU_out\[2\]
+ sky130_fd_sc_hd__dfrtp_1
X_2569_ clknet_leaf_11_clk _0107_ vssd1 vssd1 vccd1 vccd1 CALC_INST.gencon_inst.ALU_in2\[1\]
+ sky130_fd_sc_hd__dfxtp_1
XANTENNA__2385__A2 net58 vssd1 vssd1 vccd1 vccd1 sky130_fd_sc_hd__diode_2
X_2707_ clknet_leaf_22_clk _0245_ net143 vssd1 vssd1 vccd1 vccd1 CALC_INST.gencon_inst.mult_calc.main.GENERATE_ADDER\[7\].thingy.in2
+ sky130_fd_sc_hd__dfrtp_1
XFILLER_59_125 vccd1 vssd1 vccd1 vssd1 sky130_ef_sc_hd__decap_40_12
XFILLER_59_147 vssd1 vssd1 vccd1 vccd1 sky130_fd_sc_hd__fill_1
XTAP_TAPCELL_ROW_2_154 vssd1 vccd1 sky130_fd_sc_hd__tapvpwrvgnd_1
XFILLER_55_353 vssd1 vssd1 vccd1 vccd1 sky130_fd_sc_hd__fill_2
XTAP_TAPCELL_ROW_53_510 vssd1 vccd1 sky130_fd_sc_hd__tapvpwrvgnd_1
XFILLER_15_217 vssd1 vssd1 vccd1 vccd1 sky130_fd_sc_hd__fill_4
XFILLER_23_75 vssd1 vssd1 vccd1 vccd1 sky130_fd_sc_hd__fill_1
XFILLER_38_309 vssd1 vssd1 vccd1 vccd1 sky130_fd_sc_hd__fill_1
XFILLER_2_187 vssd1 vssd1 vccd1 vccd1 sky130_fd_sc_hd__fill_1
XFILLER_2_132 vssd1 vssd1 vccd1 vccd1 sky130_fd_sc_hd__fill_2
XFILLER_2_110 vssd1 vssd1 vccd1 vccd1 sky130_fd_sc_hd__fill_1
XFILLER_61_301 vccd1 vssd1 vccd1 vssd1 sky130_ef_sc_hd__decap_40_12
XFILLER_48_83 vssd1 vssd1 vccd1 vccd1 sky130_fd_sc_hd__fill_1
XFILLER_0_57 vccd1 vssd1 vccd1 vssd1 sky130_ef_sc_hd__decap_40_12
XANTENNA__1272__C1 _0590_ vssd1 vssd1 vccd1 vccd1 sky130_fd_sc_hd__diode_2
X_1940_ CALC_INST.gencon_inst.operator_input\[0\] net111 CALC_INST.input_ctrl_inst.decoded_key\[2\]
+ _1020_ vssd1 vssd1 vccd1 vccd1 _0353_ sky130_fd_sc_hd__a22o_1
X_1871_ CALC_INST.input_ctrl_inst.col_index\[21\] CALC_INST.input_ctrl_inst.col_index\[20\]
+ CALC_INST.input_ctrl_inst.col_index\[22\] _0974_ _0947_ vssd1 vssd1 vccd1 vccd1
+ _0981_ sky130_fd_sc_hd__a41oi_2
XFILLER_9_11 vssd1 vssd1 vccd1 vccd1 sky130_fd_sc_hd__fill_2
XFILLER_9_66 vssd1 vssd1 vccd1 vccd1 sky130_fd_sc_hd__fill_8
XFILLER_50_3 vccd1 vssd1 vccd1 vssd1 sky130_ef_sc_hd__decap_40_12
X_2423_ CALC_INST.gencon_inst.operand1\[5\] net42 _0554_ _0555_ vssd1 vssd1 vccd1
+ vccd1 _0052_ sky130_fd_sc_hd__o22a_1
X_1305_ CALC_INST.gencon_inst.operand1\[2\] net261 net51 vssd1 vssd1 vccd1 vccd1 _0092_
+ sky130_fd_sc_hd__mux2_1
X_2354_ CALC_INST.gencon_inst.operand2\[8\] _0498_ net35 vssd1 vssd1 vccd1 vccd1 _0040_
+ sky130_fd_sc_hd__mux2_1
X_2285_ _0443_ _0445_ _0446_ CALC_INST.input_ctrl_inst.col_index\[27\] vssd1 vssd1
+ vccd1 vccd1 _0447_ sky130_fd_sc_hd__o22ai_1
XFILLER_60_29 vssd1 vssd1 vccd1 vccd1 sky130_fd_sc_hd__fill_8
XFILLER_60_18 vssd1 vssd1 vccd1 vccd1 sky130_fd_sc_hd__fill_4
XANTENNA__1869__B2 net63 vssd1 vssd1 vccd1 vccd1 sky130_fd_sc_hd__diode_2
XFILLER_62_109 vccd1 vssd1 vccd1 vssd1 sky130_ef_sc_hd__decap_40_12
XFILLER_47_117 vssd1 vssd1 vccd1 vccd1 sky130_fd_sc_hd__fill_2
XFILLER_18_75 vssd1 vssd1 vccd1 vccd1 sky130_fd_sc_hd__fill_1
XFILLER_34_52 vssd1 vssd1 vccd1 vccd1 sky130_fd_sc_hd__fill_1
XFILLER_50_40 vssd1 vssd1 vccd1 vccd1 sky130_fd_sc_hd__fill_2
XFILLER_38_139 vssd1 vssd1 vccd1 vccd1 sky130_fd_sc_hd__fill_1
XFILLER_38_128 vssd1 vssd1 vccd1 vccd1 sky130_fd_sc_hd__fill_2
X_2070_ CALC_INST.gencon_inst.mult_calc.compCount.in2\[8\] _1119_ _1123_ CALC_INST.gencon_inst.mult_calc.compCount.in2\[9\]
+ vssd1 vssd1 vccd1 vccd1 _1124_ sky130_fd_sc_hd__a22o_1
XFILLER_34_345 vssd1 vssd1 vccd1 vccd1 sky130_fd_sc_hd__fill_1
X_1923_ net111 net271 _1004_ _1007_ vssd1 vssd1 vccd1 vccd1 _0349_ sky130_fd_sc_hd__a22o_1
X_1785_ CALC_INST.gencon_inst.operand2\[9\] net48 net38 net323 vssd1 vssd1 vccd1 vccd1
+ _0295_ sky130_fd_sc_hd__a22o_1
X_1854_ CALC_INST.input_ctrl_inst.col_index\[17\] net62 _0945_ _0968_ vssd1 vssd1
+ vccd1 vccd1 _0969_ sky130_fd_sc_hd__o2bb2a_1
X_2406_ CALC_INST.gencon_inst.operand1\[2\] net42 _0540_ _0541_ vssd1 vssd1 vccd1
+ vccd1 _0049_ sky130_fd_sc_hd__o22a_1
X_2199_ net45 _1225_ CALC_INST.input_ctrl_inst.debounce_cnt\[17\] vssd1 vssd1 vccd1
+ vccd1 _1226_ sky130_fd_sc_hd__o21a_1
X_2337_ CALC_INST.gencon_inst.operand2\[5\] _0482_ vssd1 vssd1 vccd1 vccd1 _0485_
+ sky130_fd_sc_hd__nand2_1
XTAP_TAPCELL_ROW_27_329 vssd1 vccd1 sky130_fd_sc_hd__tapvpwrvgnd_1
XFILLER_25_301 vssd1 vssd1 vccd1 vccd1 sky130_fd_sc_hd__fill_2
X_2268_ CALC_INST.input_ctrl_inst.col_index\[5\] CALC_INST.input_ctrl_inst.col_index\[4\]
+ CALC_INST.input_ctrl_inst.col_index\[7\] CALC_INST.input_ctrl_inst.col_index\[6\]
+ vssd1 vssd1 vccd1 vccd1 _0430_ sky130_fd_sc_hd__nand4_1
XTAP_TAPCELL_ROW_35_384 vssd1 vccd1 sky130_fd_sc_hd__tapvpwrvgnd_1
XTAP_TAPCELL_ROW_10_207 vssd1 vccd1 sky130_fd_sc_hd__tapvpwrvgnd_1
XFILLER_20_54 vssd1 vssd1 vccd1 vccd1 sky130_fd_sc_hd__fill_2
Xhold63 CALC_INST.gencon_inst.ALU_in1\[8\] vssd1 vssd1 vccd1 vccd1 net259 sky130_fd_sc_hd__dlygate4sd3_1
Xhold74 CALC_INST.input_ctrl_inst.read_input_flag vssd1 vssd1 vccd1 vccd1 net270 sky130_fd_sc_hd__dlygate4sd3_1
Xhold30 CALC_INST.gencon_inst.mult_calc.INn1\[8\] vssd1 vssd1 vccd1 vccd1 net226 sky130_fd_sc_hd__dlygate4sd3_1
Xhold41 CALC_INST.gencon_inst.mult_calc.main.a0.in1 vssd1 vssd1 vccd1 vccd1 net237
+ sky130_fd_sc_hd__dlygate4sd3_1
Xhold52 _0342_ vssd1 vssd1 vccd1 vccd1 net248 sky130_fd_sc_hd__dlygate4sd3_1
XFILLER_31_304 vssd1 vssd1 vccd1 vccd1 sky130_fd_sc_hd__fill_2
Xhold85 CALC_INST.gencon_inst.mult_calc.countSave\[4\] vssd1 vssd1 vccd1 vccd1 net281
+ sky130_fd_sc_hd__dlygate4sd3_1
Xhold96 CALC_INST.gencon_inst.mult_calc.countSave\[12\] vssd1 vssd1 vccd1 vccd1 net292
+ sky130_fd_sc_hd__dlygate4sd3_1
XFILLER_6_34 vssd1 vssd1 vccd1 vccd1 sky130_fd_sc_hd__fill_8
X_1570_ _0704_ _0705_ vssd1 vssd1 vccd1 vccd1 _0819_ sky130_fd_sc_hd__and2b_1
X_2122_ CALC_INST.input_ctrl_inst.decoded_key\[3\] _1084_ _1148_ _1166_ vssd1 vssd1
+ vccd1 vccd1 _0030_ sky130_fd_sc_hd__a211o_1
X_2053_ CALC_INST.gencon_inst.mult_calc.compCount.in2\[3\] _1099_ _1102_ _1105_ _1106_
+ vssd1 vssd1 vccd1 vccd1 _1107_ sky130_fd_sc_hd__a221o_1
XTAP_TAPCELL_ROW_32_365 vssd1 vccd1 sky130_fd_sc_hd__tapvpwrvgnd_1
XANTENNA__1769__B1 net86 vssd1 vssd1 vccd1 vccd1 sky130_fd_sc_hd__diode_2
X_1906_ net91 net303 net75 CALC_INST.gencon_inst.mult_calc.count.GENERATE_ADDER\[3\].thingy.in1
+ vssd1 vssd1 vccd1 vccd1 _0337_ sky130_fd_sc_hd__a22o_1
X_1768_ net82 _1116_ net84 net267 vssd1 vssd1 vccd1 vccd1 _0278_ sky130_fd_sc_hd__a2bb2o_1
X_1837_ net427 _0958_ vssd1 vssd1 vccd1 vccd1 _0312_ sky130_fd_sc_hd__xor2_1
XFILLER_57_223 vssd1 vssd1 vccd1 vccd1 sky130_fd_sc_hd__fill_1
X_1699_ net379 CALC_INST.gencon_inst.mult_calc.INn2\[4\] net96 vssd1 vssd1 vccd1 vccd1
+ _0211_ sky130_fd_sc_hd__mux2_1
XFILLER_15_54 vssd1 vssd1 vccd1 vccd1 sky130_fd_sc_hd__fill_2
Xteam_06_165 vssd1 vssd1 vccd1 vccd1 team_06_165/HI gpio_out[2] sky130_fd_sc_hd__conb_1
Xoutput7 net7 vssd1 vssd1 vccd1 vccd1 gpio_out[11] sky130_fd_sc_hd__buf_2
Xteam_06_154 vssd1 vssd1 vccd1 vccd1 team_06_154/HI gpio_oeb[0] sky130_fd_sc_hd__conb_1
Xoutput20 net20 vssd1 vssd1 vccd1 vccd1 gpio_out[24] sky130_fd_sc_hd__buf_2
XFILLER_31_64 vssd1 vssd1 vccd1 vccd1 sky130_fd_sc_hd__fill_4
Xteam_06_187 vssd1 vssd1 vccd1 vccd1 gpio_oeb[19] team_06_187/LO sky130_fd_sc_hd__conb_1
Xteam_06_176 vssd1 vssd1 vccd1 vccd1 gpio_oeb[8] team_06_176/LO sky130_fd_sc_hd__conb_1
XFILLER_0_274 vssd1 vssd1 vccd1 vccd1 sky130_fd_sc_hd__fill_4
X_2740_ clknet_leaf_27_clk _0278_ net133 vssd1 vssd1 vccd1 vccd1 CALC_INST.gencon_inst.mult_calc.countSave\[7\]
+ sky130_fd_sc_hd__dfrtp_1
XFILLER_8_396 vssd1 vssd1 vccd1 vccd1 sky130_fd_sc_hd__fill_1
X_2671_ clknet_leaf_31_clk _0209_ net119 vssd1 vssd1 vccd1 vccd1 CALC_INST.gencon_inst.mult_calc.compCount.in2\[2\]
+ sky130_fd_sc_hd__dfrtp_1
X_1622_ _0858_ _0859_ net82 vssd1 vssd1 vccd1 vccd1 _0861_ sky130_fd_sc_hd__a21oi_1
X_1553_ _0755_ _0804_ vssd1 vssd1 vccd1 vccd1 _0805_ sky130_fd_sc_hd__xnor2_1
X_1484_ CALC_INST.gencon_inst.add_calc.main.GENERATE_ADDER\[1\].thingy.in1 _0742_
+ vssd1 vssd1 vccd1 vccd1 _0743_ sky130_fd_sc_hd__nor2_1
XFILLER_39_223 vssd1 vssd1 vccd1 vccd1 sky130_fd_sc_hd__fill_1
XFILLER_54_259 vssd1 vssd1 vccd1 vccd1 sky130_fd_sc_hd__fill_1
X_2105_ CALC_INST.input_ctrl_inst.key_pressed net79 vssd1 vssd1 vccd1 vccd1 _1153_
+ sky130_fd_sc_hd__nand2_1
XTAP_TAPCELL_ROW_37_402 vssd1 vccd1 sky130_fd_sc_hd__tapvpwrvgnd_1
X_2036_ CALC_INST.gencon_inst.mult_calc.count.GENERATE_ADDER\[4\].thingy.in1 _1089_
+ vssd1 vssd1 vccd1 vccd1 _1090_ sky130_fd_sc_hd__nand2_1
XFILLER_62_281 vssd1 vssd1 vccd1 vccd1 sky130_fd_sc_hd__fill_2
XFILLER_10_307 vssd1 vssd1 vccd1 vccd1 sky130_fd_sc_hd__fill_1
XANTENNA__1914__B1 net77 vssd1 vssd1 vccd1 vccd1 sky130_fd_sc_hd__diode_2
X_2869_ clknet_leaf_31_clk _0364_ vssd1 vssd1 vccd1 vccd1 CALC_INST.input_ctrl_inst.scan_timer\[7\]
+ sky130_fd_sc_hd__dfxtp_1
XANTENNA_fanout68_A net71 vssd1 vssd1 vccd1 vccd1 sky130_fd_sc_hd__diode_2
XFILLER_60_218 vssd1 vssd1 vccd1 vccd1 sky130_fd_sc_hd__fill_2
XFILLER_45_259 vssd1 vssd1 vccd1 vccd1 sky130_fd_sc_hd__fill_2
XTAP_TAPCELL_ROW_43_438 vssd1 vccd1 sky130_fd_sc_hd__tapvpwrvgnd_1
XFILLER_26_75 vssd1 vssd1 vccd1 vccd1 sky130_fd_sc_hd__fill_2
XFILLER_26_42 vssd1 vssd1 vccd1 vccd1 sky130_fd_sc_hd__fill_2
XANTENNA_clkbuf_leaf_5_clk_A clknet_2_1__leaf_clk vssd1 vssd1 vccd1 vccd1 sky130_fd_sc_hd__diode_2
XFILLER_9_127 vssd1 vssd1 vccd1 vccd1 sky130_fd_sc_hd__fill_2
XANTENNA__1905__B1 net75 vssd1 vssd1 vccd1 vccd1 sky130_fd_sc_hd__diode_2
XFILLER_5_377 vccd1 vssd1 vccd1 vssd1 sky130_ef_sc_hd__decap_40_12
XTAP_TAPCELL_ROW_8_193 vssd1 vccd1 sky130_fd_sc_hd__tapvpwrvgnd_1
XANTENNA__1725__A net82 vssd1 vssd1 vccd1 vccd1 sky130_fd_sc_hd__diode_2
XFILLER_51_207 vssd1 vssd1 vccd1 vccd1 sky130_fd_sc_hd__fill_2
XFILLER_36_248 vssd1 vssd1 vccd1 vccd1 sky130_fd_sc_hd__fill_2
XFILLER_36_204 vssd1 vssd1 vccd1 vccd1 sky130_fd_sc_hd__fill_2
XANTENNA__2397__B1 net58 vssd1 vssd1 vccd1 vccd1 sky130_fd_sc_hd__diode_2
X_2723_ clknet_leaf_22_clk _0261_ net143 vssd1 vssd1 vccd1 vccd1 CALC_INST.gencon_inst.mult_calc.out\[8\]
+ sky130_fd_sc_hd__dfrtp_1
X_1536_ net31 _0788_ _0790_ vssd1 vssd1 vccd1 vccd1 _0791_ sky130_fd_sc_hd__a21oi_1
X_2585_ clknet_leaf_7_clk _0123_ vssd1 vssd1 vccd1 vccd1 CALC_INST.gencon_inst.prev_operator_input\[0\]
+ sky130_fd_sc_hd__dfxtp_1
X_1605_ CALC_INST.gencon_inst.mult_calc.main.GENERATE_ADDER\[1\].thingy.in2 CALC_INST.gencon_inst.mult_calc.main.GENERATE_ADDER\[1\].thingy.in1
+ vssd1 vssd1 vccd1 vccd1 _0846_ sky130_fd_sc_hd__and2_1
XFILLER_8_182 vssd1 vssd1 vccd1 vccd1 sky130_fd_sc_hd__fill_8
X_2654_ clknet_leaf_31_clk _0192_ net118 vssd1 vssd1 vccd1 vccd1 CALC_INST.gencon_inst.mult_calc.adderSave\[0\]
+ sky130_fd_sc_hd__dfrtp_1
X_1467_ net106 CALC_INST.gencon_inst.add_calc.main.in2\[5\] vssd1 vssd1 vccd1 vccd1
+ _0726_ sky130_fd_sc_hd__or2_1
Xfanout106 CALC_INST.gencon_inst.add_calc.diffSign vssd1 vssd1 vccd1 vccd1 net106
+ sky130_fd_sc_hd__clkbuf_2
X_1398_ CALC_INST.gencon_inst.ALU_in2\[14\] CALC_INST.gencon_inst.ALU_in1\[14\] net66
+ vssd1 vssd1 vccd1 vccd1 _0674_ sky130_fd_sc_hd__mux2_1
Xfanout128 net131 vssd1 vssd1 vccd1 vccd1 net128 sky130_fd_sc_hd__clkbuf_4
Xfanout117 net120 vssd1 vssd1 vccd1 vccd1 net117 sky130_fd_sc_hd__clkbuf_4
Xfanout139 net153 vssd1 vssd1 vccd1 vccd1 net139 sky130_fd_sc_hd__clkbuf_2
X_2019_ _1072_ _1073_ vssd1 vssd1 vccd1 vccd1 _1075_ sky130_fd_sc_hd__and2_1
XFILLER_35_281 vssd1 vssd1 vccd1 vccd1 sky130_fd_sc_hd__fill_8
XPHY_EDGE_ROW_19_Left_84 vssd1 vssd1 vccd1 vccd1 sky130_fd_sc_hd__decap_3
XFILLER_50_273 vssd1 vssd1 vccd1 vccd1 sky130_fd_sc_hd__fill_4
XTAP_TAPCELL_ROW_40_419 vssd1 vccd1 sky130_fd_sc_hd__tapvpwrvgnd_1
XFILLER_12_44 vssd1 vssd1 vccd1 vccd1 sky130_fd_sc_hd__fill_4
Xhold182 CALC_INST.gencon_inst.add_calc.main.GENERATE_ADDER\[6\].thingy.in1 vssd1
+ vssd1 vccd1 vccd1 net378 sky130_fd_sc_hd__dlygate4sd3_1
Xhold160 CALC_INST.gencon_inst.add_calc.main.in2\[1\] vssd1 vssd1 vccd1 vccd1 net356
+ sky130_fd_sc_hd__dlygate4sd3_1
Xhold171 CALC_INST.gencon_inst.mult_calc.INn2\[8\] vssd1 vssd1 vccd1 vccd1 net367
+ sky130_fd_sc_hd__dlygate4sd3_1
XFILLER_2_325 vssd1 vssd1 vccd1 vccd1 sky130_fd_sc_hd__fill_2
Xhold193 CALC_INST.gencon_inst.mult_calc.main.GENERATE_ADDER\[6\].thingy.in2 vssd1
+ vssd1 vccd1 vccd1 net389 sky130_fd_sc_hd__dlygate4sd3_1
XTAP_TAPCELL_ROW_56_530 vssd1 vccd1 sky130_fd_sc_hd__tapvpwrvgnd_1
XFILLER_37_30 vssd1 vssd1 vccd1 vccd1 sky130_fd_sc_hd__fill_1
XTAP_TAPCELL_ROW_5_174 vssd1 vccd1 sky130_fd_sc_hd__tapvpwrvgnd_1
XANTENNA__2315__S net35 vssd1 vssd1 vccd1 vccd1 sky130_fd_sc_hd__diode_2
X_1321_ CALC_INST.gencon_inst.operand2\[2\] net253 net50 vssd1 vssd1 vccd1 vccd1 _0108_
+ sky130_fd_sc_hd__mux2_1
X_1252_ CALC_INST.gencon_inst.operand2\[8\] _0392_ net55 CALC_INST.gencon_inst.mult_calc.out\[8\]
+ _0590_ vssd1 vssd1 vccd1 vccd1 _0615_ sky130_fd_sc_hd__a221o_1
X_2370_ _0509_ _0510_ CALC_INST.gencon_inst.mult_calc.out\[12\] _0456_ vssd1 vssd1
+ vccd1 vccd1 _0511_ sky130_fd_sc_hd__a2bb2o_1
XFILLER_1_391 vssd1 vssd1 vccd1 vccd1 sky130_fd_sc_hd__fill_1
XFILLER_64_365 vssd1 vssd1 vccd1 vccd1 sky130_fd_sc_hd__fill_8
XFILLER_64_321 vccd1 vssd1 vccd1 vssd1 sky130_ef_sc_hd__decap_40_12
XTAP_TAPCELL_ROW_19_276 vssd1 vccd1 sky130_fd_sc_hd__tapvpwrvgnd_1
XFILLER_17_270 vssd1 vssd1 vccd1 vccd1 sky130_fd_sc_hd__fill_2
XFILLER_17_281 vssd1 vssd1 vccd1 vccd1 sky130_fd_sc_hd__fill_2
XTAP_TAPCELL_ROW_62_577 vssd1 vccd1 sky130_fd_sc_hd__tapvpwrvgnd_1
XFILLER_20_402 vssd1 vssd1 vccd1 vccd1 sky130_fd_sc_hd__fill_4
X_2706_ clknet_leaf_29_clk net390 net136 vssd1 vssd1 vccd1 vccd1 CALC_INST.gencon_inst.mult_calc.main.GENERATE_ADDER\[6\].thingy.in2
+ sky130_fd_sc_hd__dfrtp_1
XFILLER_59_137 vssd1 vssd1 vccd1 vccd1 sky130_fd_sc_hd__fill_8
X_1519_ net31 _0773_ _0775_ net81 vssd1 vssd1 vccd1 vccd1 _0777_ sky130_fd_sc_hd__a31o_1
X_2637_ clknet_leaf_11_clk _0175_ net130 vssd1 vssd1 vccd1 vccd1 CALC_INST.gencon_inst.ALU_out\[1\]
+ sky130_fd_sc_hd__dfrtp_1
XANTENNA__1593__A1 CALC_INST.gencon_inst.add_calc.state\[1\] vssd1 vssd1 vccd1 vccd1
+ sky130_fd_sc_hd__diode_2
X_2568_ clknet_leaf_11_clk _0106_ vssd1 vssd1 vccd1 vccd1 CALC_INST.gencon_inst.ALU_in2\[0\]
+ sky130_fd_sc_hd__dfxtp_1
X_2499_ clknet_leaf_23_clk _0041_ net142 vssd1 vssd1 vccd1 vccd1 CALC_INST.gencon_inst.operand2\[9\]
+ sky130_fd_sc_hd__dfrtp_2
XPHY_EDGE_ROW_12_Right_12 vssd1 vssd1 vccd1 vccd1 sky130_fd_sc_hd__decap_3
XFILLER_55_321 vssd1 vssd1 vccd1 vccd1 sky130_fd_sc_hd__fill_4
XFILLER_55_310 vssd1 vssd1 vccd1 vccd1 sky130_fd_sc_hd__fill_2
XPHY_EDGE_ROW_21_Right_21 vssd1 vssd1 vccd1 vccd1 sky130_fd_sc_hd__decap_3
XTAP_TAPCELL_ROW_2_155 vssd1 vccd1 sky130_fd_sc_hd__tapvpwrvgnd_1
XANTENNA__1812__B net63 vssd1 vssd1 vccd1 vccd1 sky130_fd_sc_hd__diode_2
XTAP_TAPCELL_ROW_53_511 vssd1 vccd1 sky130_fd_sc_hd__tapvpwrvgnd_1
XPHY_EDGE_ROW_4_Left_69 vssd1 vssd1 vccd1 vccd1 sky130_fd_sc_hd__decap_3
XPHY_EDGE_ROW_30_Right_30 vssd1 vssd1 vccd1 vccd1 sky130_fd_sc_hd__decap_3
XFILLER_48_95 vssd1 vssd1 vccd1 vccd1 sky130_fd_sc_hd__fill_1
XFILLER_64_83 vssd1 vssd1 vccd1 vccd1 sky130_fd_sc_hd__fill_1
XFILLER_64_72 vssd1 vssd1 vccd1 vccd1 sky130_fd_sc_hd__fill_1
XFILLER_61_335 vssd1 vssd1 vccd1 vccd1 sky130_fd_sc_hd__fill_1
XFILLER_0_69 vssd1 vssd1 vccd1 vccd1 sky130_fd_sc_hd__fill_4
X_1870_ CALC_INST.input_ctrl_inst.col_index\[21\] net28 net47 _0977_ vssd1 vssd1 vccd1
+ vccd1 _0980_ sky130_fd_sc_hd__and4_1
XFILLER_9_89 vssd1 vssd1 vccd1 vccd1 sky130_fd_sc_hd__fill_2
XFILLER_43_3 vssd1 vssd1 vccd1 vccd1 sky130_fd_sc_hd__fill_8
X_2422_ CALC_INST.gencon_inst.ALU_out\[5\] net68 net58 CALC_INST.gencon_inst.mult_calc.out\[5\]
+ vssd1 vssd1 vccd1 vccd1 _0555_ sky130_fd_sc_hd__a22o_1
X_2353_ _0496_ _0497_ CALC_INST.gencon_inst.mult_calc.out\[8\] net44 vssd1 vssd1 vccd1
+ vccd1 _0498_ sky130_fd_sc_hd__a2bb2o_1
X_1304_ CALC_INST.gencon_inst.operand1\[1\] net312 net50 vssd1 vssd1 vccd1 vccd1 _0091_
+ sky130_fd_sc_hd__mux2_1
X_2284_ CALC_INST.input_ctrl_inst.col_index\[29\] CALC_INST.input_ctrl_inst.col_index\[28\]
+ CALC_INST.input_ctrl_inst.col_index\[31\] CALC_INST.input_ctrl_inst.col_index\[30\]
+ vssd1 vssd1 vccd1 vccd1 _0446_ sky130_fd_sc_hd__or4_1
XANTENNA__2460__C1 _0524_ vssd1 vssd1 vccd1 vccd1 sky130_fd_sc_hd__diode_2
XANTENNA_clkbuf_leaf_30_clk_A clknet_2_0__leaf_clk vssd1 vssd1 vccd1 vccd1 sky130_fd_sc_hd__diode_2
X_1999_ net99 vssd1 vssd1 vccd1 vccd1 _1055_ sky130_fd_sc_hd__inv_2
XANTENNA_fanout50_A _0646_ vssd1 vssd1 vccd1 vccd1 sky130_fd_sc_hd__diode_2
XFILLER_51_390 vssd1 vssd1 vccd1 vccd1 sky130_fd_sc_hd__fill_2
XANTENNA__2451__C1 net41 vssd1 vssd1 vccd1 vccd1 sky130_fd_sc_hd__diode_2
XFILLER_50_85 vssd1 vssd1 vccd1 vccd1 sky130_fd_sc_hd__fill_2
XFILLER_61_165 vssd1 vssd1 vccd1 vccd1 sky130_fd_sc_hd__fill_2
XFILLER_46_195 vssd1 vssd1 vccd1 vccd1 sky130_fd_sc_hd__fill_1
XANTENNA__2442__C1 net41 vssd1 vssd1 vccd1 vccd1 sky130_fd_sc_hd__diode_2
XANTENNA__1245__B1 net54 vssd1 vssd1 vccd1 vccd1 sky130_fd_sc_hd__diode_2
X_1922_ CALC_INST.gencon_inst.keypad_input\[0\] _1006_ net79 vssd1 vssd1 vccd1 vccd1
+ _1007_ sky130_fd_sc_hd__mux2_1
X_1784_ CALC_INST.gencon_inst.operand2\[8\] net48 net38 net367 vssd1 vssd1 vccd1 vccd1
+ _0294_ sky130_fd_sc_hd__a22o_1
X_1853_ CALC_INST.input_ctrl_inst.col_index\[17\] CALC_INST.input_ctrl_inst.col_index\[16\]
+ _0434_ net60 vssd1 vssd1 vccd1 vccd1 _0968_ sky130_fd_sc_hd__and4_1
X_2405_ CALC_INST.gencon_inst.ALU_out\[2\] net68 net58 CALC_INST.gencon_inst.mult_calc.out\[2\]
+ net41 vssd1 vssd1 vccd1 vccd1 _0541_ sky130_fd_sc_hd__a221o_1
X_2336_ CALC_INST.gencon_inst.operand2\[4\] net35 _0481_ _0484_ vssd1 vssd1 vccd1
+ vccd1 _0036_ sky130_fd_sc_hd__o22a_1
X_2198_ net45 _1225_ _1223_ vssd1 vssd1 vccd1 vccd1 _0015_ sky130_fd_sc_hd__o21a_1
XFILLER_25_357 vssd1 vssd1 vccd1 vccd1 sky130_fd_sc_hd__fill_4
XFILLER_25_335 vssd1 vssd1 vccd1 vccd1 sky130_fd_sc_hd__fill_1
X_2267_ CALC_INST.input_ctrl_inst.col_index\[12\] CALC_INST.input_ctrl_inst.col_index\[15\]
+ CALC_INST.input_ctrl_inst.col_index\[14\] _0428_ _0423_ vssd1 vssd1 vccd1 vccd1
+ _0429_ sky130_fd_sc_hd__a41o_1
XTAP_TAPCELL_ROW_35_385 vssd1 vccd1 sky130_fd_sc_hd__tapvpwrvgnd_1
XTAP_TAPCELL_ROW_10_208 vssd1 vccd1 sky130_fd_sc_hd__tapvpwrvgnd_1
XANTENNA_fanout98_A CALC_INST.gencon_inst.mult_calc.state\[3\] vssd1 vssd1 vccd1 vccd1
+ sky130_fd_sc_hd__diode_2
Xhold53 CALC_INST.gencon_inst.ALU_in2\[8\] vssd1 vssd1 vccd1 vccd1 net249 sky130_fd_sc_hd__dlygate4sd3_1
Xhold31 CALC_INST.gencon_inst.prev_operator_input\[2\] vssd1 vssd1 vccd1 vccd1 net227
+ sky130_fd_sc_hd__dlygate4sd3_1
Xhold20 CALC_INST.gencon_inst.keypad_input\[3\] vssd1 vssd1 vccd1 vccd1 net216 sky130_fd_sc_hd__dlygate4sd3_1
Xhold64 net11 vssd1 vssd1 vccd1 vccd1 net260 sky130_fd_sc_hd__dlygate4sd3_1
Xhold75 CALC_INST.gencon_inst.keypad_input\[0\] vssd1 vssd1 vccd1 vccd1 net271 sky130_fd_sc_hd__dlygate4sd3_1
Xhold97 CALC_INST.gencon_inst.keypad_input\[1\] vssd1 vssd1 vccd1 vccd1 net293 sky130_fd_sc_hd__dlygate4sd3_1
Xhold42 CALC_INST.gencon_inst.mult_calc.INn1\[13\] vssd1 vssd1 vccd1 vccd1 net238
+ sky130_fd_sc_hd__dlygate4sd3_1
Xhold86 CALC_INST.gencon_inst.mult_calc.countSave\[5\] vssd1 vssd1 vccd1 vccd1 net282
+ sky130_fd_sc_hd__dlygate4sd3_1
XFILLER_45_85 vssd1 vssd1 vccd1 vccd1 sky130_fd_sc_hd__fill_1
XANTENNA__2384__A _0519_ vssd1 vssd1 vccd1 vccd1 sky130_fd_sc_hd__diode_2
XANTENNA__1699__S net96 vssd1 vssd1 vccd1 vccd1 sky130_fd_sc_hd__diode_2
XFILLER_61_73 vccd1 vssd1 vccd1 vssd1 sky130_ef_sc_hd__decap_40_12
XANTENNA__2323__S net35 vssd1 vssd1 vccd1 vccd1 sky130_fd_sc_hd__diode_2
XFILLER_6_13 vssd1 vssd1 vccd1 vccd1 sky130_fd_sc_hd__fill_1
XPHY_EDGE_ROW_7_Left_72 vssd1 vssd1 vccd1 vccd1 sky130_fd_sc_hd__decap_3
X_2121_ CALC_INST.input_ctrl_inst.RowSync\[3\] _1160_ _1161_ _1165_ net79 vssd1 vssd1
+ vccd1 vccd1 _1166_ sky130_fd_sc_hd__o311a_1
X_2052_ _1088_ _1100_ CALC_INST.gencon_inst.mult_calc.compCount.in2\[2\] vssd1 vssd1
+ vccd1 vccd1 _1106_ sky130_fd_sc_hd__o21a_1
XFILLER_19_162 vssd1 vssd1 vccd1 vccd1 sky130_fd_sc_hd__fill_1
XTAP_TAPCELL_ROW_32_366 vssd1 vccd1 sky130_fd_sc_hd__tapvpwrvgnd_1
XFILLER_22_349 vssd1 vssd1 vccd1 vccd1 sky130_fd_sc_hd__fill_1
X_1905_ net91 net309 net75 net316 vssd1 vssd1 vccd1 vccd1 _0336_ sky130_fd_sc_hd__a22o_1
X_1767_ net82 _1114_ net84 net274 vssd1 vssd1 vccd1 vccd1 _0277_ sky130_fd_sc_hd__a2bb2o_1
XPHY_EDGE_ROW_6_Right_6 vssd1 vssd1 vccd1 vccd1 sky130_fd_sc_hd__decap_3
X_1836_ _0957_ _0958_ vssd1 vssd1 vccd1 vccd1 _0311_ sky130_fd_sc_hd__nor2_1
X_1698_ net393 net266 net95 vssd1 vssd1 vccd1 vccd1 _0210_ sky130_fd_sc_hd__mux2_1
XANTENNA__2469__A _1234_ vssd1 vssd1 vccd1 vccd1 sky130_fd_sc_hd__diode_2
X_2319_ _0461_ _0464_ _0468_ _0469_ vssd1 vssd1 vccd1 vccd1 _0470_ sky130_fd_sc_hd__o211a_1
XFILLER_57_279 vssd1 vssd1 vccd1 vccd1 sky130_fd_sc_hd__fill_1
XFILLER_25_187 vssd1 vssd1 vccd1 vccd1 sky130_fd_sc_hd__fill_2
XTAP_TAPCELL_ROW_23_300 vssd1 vccd1 sky130_fd_sc_hd__tapvpwrvgnd_1
XFILLER_40_179 vssd1 vssd1 vccd1 vccd1 sky130_fd_sc_hd__fill_2
XFILLER_31_76 vssd1 vssd1 vccd1 vccd1 sky130_fd_sc_hd__fill_4
XFILLER_15_77 vccd1 vssd1 vccd1 vssd1 sky130_ef_sc_hd__decap_40_12
Xteam_06_155 vssd1 vssd1 vccd1 vccd1 team_06_155/HI gpio_oeb[1] sky130_fd_sc_hd__conb_1
Xteam_06_177 vssd1 vssd1 vccd1 vccd1 gpio_oeb[9] team_06_177/LO sky130_fd_sc_hd__conb_1
Xteam_06_188 vssd1 vssd1 vccd1 vccd1 gpio_oeb[20] team_06_188/LO sky130_fd_sc_hd__conb_1
Xoutput8 net8 vssd1 vssd1 vccd1 vccd1 gpio_out[12] sky130_fd_sc_hd__buf_2
Xoutput10 net10 vssd1 vssd1 vccd1 vccd1 gpio_out[14] sky130_fd_sc_hd__buf_2
Xoutput21 net21 vssd1 vssd1 vccd1 vccd1 gpio_out[25] sky130_fd_sc_hd__buf_2
XPHY_EDGE_ROW_33_Left_98 vssd1 vssd1 vccd1 vccd1 sky130_fd_sc_hd__decap_3
Xteam_06_166 vssd1 vssd1 vccd1 vccd1 team_06_166/HI gpio_out[3] sky130_fd_sc_hd__conb_1
XFILLER_0_253 vssd1 vssd1 vccd1 vccd1 sky130_fd_sc_hd__fill_1
XFILLER_48_257 vssd1 vssd1 vccd1 vccd1 sky130_fd_sc_hd__fill_1
XFILLER_48_246 vssd1 vssd1 vccd1 vccd1 sky130_fd_sc_hd__fill_4
XFILLER_48_213 vssd1 vssd1 vccd1 vccd1 sky130_fd_sc_hd__fill_4
XPHY_EDGE_ROW_59_Right_59 vssd1 vssd1 vccd1 vccd1 sky130_fd_sc_hd__decap_3
XFILLER_31_113 vssd1 vssd1 vccd1 vccd1 sky130_fd_sc_hd__fill_2
XFILLER_31_102 vssd1 vssd1 vccd1 vccd1 sky130_fd_sc_hd__fill_8
X_1552_ _0716_ _0717_ vssd1 vssd1 vccd1 vccd1 _0804_ sky130_fd_sc_hd__nand2b_1
X_2670_ clknet_leaf_32_clk _0208_ net118 vssd1 vssd1 vccd1 vccd1 CALC_INST.gencon_inst.mult_calc.compCount.in2\[1\]
+ sky130_fd_sc_hd__dfrtp_1
X_1621_ _0858_ _0859_ vssd1 vssd1 vccd1 vccd1 _0860_ sky130_fd_sc_hd__or2_1
X_1483_ CALC_INST.gencon_inst.add_calc.main.in2\[1\] net103 vssd1 vssd1 vccd1 vccd1
+ _0742_ sky130_fd_sc_hd__xor2_1
X_2104_ _1072_ _1074_ _1152_ net270 vssd1 vssd1 vccd1 vccd1 _0031_ sky130_fd_sc_hd__o22a_1
X_2035_ CALC_INST.gencon_inst.mult_calc.count.GENERATE_ADDER\[3\].thingy.in1 _1088_
+ vssd1 vssd1 vccd1 vccd1 _1089_ sky130_fd_sc_hd__and2_1
XANTENNA__2471__B _0397_ vssd1 vssd1 vccd1 vccd1 sky130_fd_sc_hd__diode_2
XANTENNA_fanout148_A net153 vssd1 vssd1 vccd1 vccd1 sky130_fd_sc_hd__diode_2
X_2868_ clknet_leaf_3_clk _0363_ vssd1 vssd1 vccd1 vccd1 CALC_INST.input_ctrl_inst.scan_timer\[6\]
+ sky130_fd_sc_hd__dfxtp_1
XANTENNA_fanout103_X net103 vssd1 vssd1 vccd1 vccd1 sky130_fd_sc_hd__diode_2
X_2799_ clknet_leaf_34_clk _0324_ net114 vssd1 vssd1 vccd1 vccd1 CALC_INST.input_ctrl_inst.col_index\[22\]
+ sky130_fd_sc_hd__dfrtp_1
X_1819_ CALC_INST.input_ctrl_inst.col_index\[1\] CALC_INST.input_ctrl_inst.col_index\[0\]
+ net90 net61 vssd1 vssd1 vccd1 vccd1 _0949_ sky130_fd_sc_hd__and4_1
XFILLER_45_238 vssd1 vssd1 vccd1 vccd1 sky130_fd_sc_hd__fill_4
XFILLER_60_208 vssd1 vssd1 vccd1 vccd1 sky130_fd_sc_hd__fill_1
XTAP_TAPCELL_ROW_43_439 vssd1 vccd1 sky130_fd_sc_hd__tapvpwrvgnd_1
XFILLER_13_146 vssd1 vssd1 vccd1 vccd1 sky130_fd_sc_hd__fill_2
XTAP_TAPCELL_ROW_51_494 vssd1 vccd1 sky130_fd_sc_hd__tapvpwrvgnd_1
XANTENNA__1905__A1 net91 vssd1 vssd1 vccd1 vccd1 sky130_fd_sc_hd__diode_2
XFILLER_5_389 vssd1 vssd1 vccd1 vccd1 sky130_fd_sc_hd__fill_2
XTAP_TAPCELL_ROW_8_194 vssd1 vccd1 sky130_fd_sc_hd__tapvpwrvgnd_1
XTAP_TAPCELL_ROW_59_550 vssd1 vccd1 sky130_fd_sc_hd__tapvpwrvgnd_1
XFILLER_44_282 vssd1 vssd1 vccd1 vccd1 sky130_fd_sc_hd__fill_1
X_2722_ clknet_leaf_21_clk _0260_ net138 vssd1 vssd1 vccd1 vccd1 CALC_INST.gencon_inst.mult_calc.out\[7\]
+ sky130_fd_sc_hd__dfrtp_1
XFILLER_8_161 vccd1 vssd1 vccd1 vssd1 sky130_ef_sc_hd__decap_40_12
X_1535_ _0750_ _0789_ vssd1 vssd1 vccd1 vccd1 _0790_ sky130_fd_sc_hd__xnor2_1
Xfanout107 CALC_INST.gencon_inst.add_calc.state\[2\] vssd1 vssd1 vccd1 vccd1 net107
+ sky130_fd_sc_hd__buf_2
Xfanout129 net131 vssd1 vssd1 vccd1 vccd1 net129 sky130_fd_sc_hd__clkbuf_4
X_2653_ clknet_leaf_11_clk _0191_ net129 vssd1 vssd1 vccd1 vccd1 CALC_INST.gencon_inst.add_calc.diffSign
+ sky130_fd_sc_hd__dfrtp_1
X_2584_ clknet_leaf_9_clk _0122_ vssd1 vssd1 vccd1 vccd1 CALC_INST.gencon_inst.add_calc.start
+ sky130_fd_sc_hd__dfxtp_1
Xfanout118 net120 vssd1 vssd1 vccd1 vccd1 net118 sky130_fd_sc_hd__clkbuf_4
X_1604_ net99 _0844_ _0845_ net337 net85 vssd1 vssd1 vccd1 vccd1 _0192_ sky130_fd_sc_hd__a32o_1
X_1466_ CALC_INST.gencon_inst.add_calc.main.GENERATE_ADDER\[6\].thingy.in1 _0722_
+ _0723_ vssd1 vssd1 vccd1 vccd1 _0725_ sky130_fd_sc_hd__nand3_1
X_1397_ net373 _0673_ net109 vssd1 vssd1 vccd1 vccd1 _0157_ sky130_fd_sc_hd__mux2_1
XFILLER_27_238 vssd1 vssd1 vccd1 vccd1 sky130_fd_sc_hd__fill_2
XANTENNA__1369__Y _0659_ vssd1 vssd1 vccd1 vccd1 sky130_fd_sc_hd__diode_2
X_2018_ CALC_INST.input_ctrl_inst.input_control_state\[1\] CALC_INST.input_ctrl_inst.input_control_state\[0\]
+ net88 vssd1 vssd1 vccd1 vccd1 _1074_ sky130_fd_sc_hd__nand3b_2
XFILLER_35_260 vssd1 vssd1 vccd1 vccd1 sky130_fd_sc_hd__fill_4
XFILLER_58_330 vssd1 vssd1 vccd1 vccd1 sky130_fd_sc_hd__fill_2
Xhold172 CALC_INST.gencon_inst.latched_operator_input\[0\] vssd1 vssd1 vccd1 vccd1
+ net368 sky130_fd_sc_hd__dlygate4sd3_1
Xhold161 CALC_INST.gencon_inst.mult_calc.compCount.in2\[12\] vssd1 vssd1 vccd1 vccd1
+ net357 sky130_fd_sc_hd__dlygate4sd3_1
Xhold183 CALC_INST.gencon_inst.mult_calc.compCount.in2\[4\] vssd1 vssd1 vccd1 vccd1
+ net379 sky130_fd_sc_hd__dlygate4sd3_1
Xhold150 CALC_INST.gencon_inst.mult_calc.main.GENERATE_ADDER\[12\].thingy.in2 vssd1
+ vssd1 vccd1 vccd1 net346 sky130_fd_sc_hd__dlygate4sd3_1
Xhold194 _0244_ vssd1 vssd1 vccd1 vccd1 net390 sky130_fd_sc_hd__dlygate4sd3_1
XFILLER_58_363 vssd1 vssd1 vccd1 vccd1 sky130_fd_sc_hd__fill_1
XTAP_TAPCELL_ROW_56_531 vssd1 vccd1 sky130_fd_sc_hd__tapvpwrvgnd_1
XTAP_TAPCELL_ROW_5_175 vssd1 vccd1 sky130_fd_sc_hd__tapvpwrvgnd_1
XFILLER_18_205 vssd1 vssd1 vccd1 vccd1 sky130_fd_sc_hd__fill_2
XFILLER_53_63 vssd1 vssd1 vccd1 vccd1 sky130_fd_sc_hd__fill_8
XANTENNA__2379__A1 _0405_ vssd1 vssd1 vccd1 vccd1 sky130_fd_sc_hd__diode_2
X_1320_ CALC_INST.gencon_inst.operand2\[1\] net313 net50 vssd1 vssd1 vccd1 vccd1 _0107_
+ sky130_fd_sc_hd__mux2_1
XANTENNA__2331__S net35 vssd1 vssd1 vccd1 vccd1 sky130_fd_sc_hd__diode_2
XFILLER_5_131 vssd1 vssd1 vccd1 vccd1 sky130_fd_sc_hd__fill_1
XFILLER_64_333 vssd1 vssd1 vccd1 vccd1 sky130_fd_sc_hd__fill_2
XANTENNA__1471__A net106 vssd1 vssd1 vccd1 vccd1 sky130_fd_sc_hd__diode_2
X_1251_ net260 _0592_ _0613_ _0614_ vssd1 vssd1 vccd1 vccd1 _0070_ sky130_fd_sc_hd__o22a_1
XFILLER_1_381 vssd1 vssd1 vccd1 vccd1 sky130_fd_sc_hd__fill_8
XFILLER_64_377 vssd1 vssd1 vccd1 vccd1 sky130_fd_sc_hd__fill_4
XPHY_EDGE_ROW_20_Left_85 vssd1 vssd1 vccd1 vccd1 sky130_fd_sc_hd__decap_3
X_2636_ clknet_leaf_11_clk _0174_ net130 vssd1 vssd1 vccd1 vccd1 CALC_INST.gencon_inst.ALU_out\[0\]
+ sky130_fd_sc_hd__dfrtp_1
X_2705_ clknet_leaf_29_clk _0243_ net138 vssd1 vssd1 vccd1 vccd1 CALC_INST.gencon_inst.mult_calc.main.GENERATE_ADDER\[5\].thingy.in2
+ sky130_fd_sc_hd__dfrtp_1
X_1518_ net31 _0773_ _0775_ vssd1 vssd1 vccd1 vccd1 _0776_ sky130_fd_sc_hd__a21oi_1
X_1449_ _0706_ _0707_ CALC_INST.gencon_inst.add_calc.main.GENERATE_ADDER\[10\].thingy.in1
+ vssd1 vssd1 vccd1 vccd1 _0708_ sky130_fd_sc_hd__a21oi_1
XANTENNA__1365__B CALC_INST.gencon_inst.add_calc.state\[1\] vssd1 vssd1 vccd1 vccd1
+ sky130_fd_sc_hd__diode_2
X_2567_ clknet_leaf_11_clk _0105_ vssd1 vssd1 vccd1 vccd1 CALC_INST.gencon_inst.ALU_in1\[15\]
+ sky130_fd_sc_hd__dfxtp_1
X_2498_ clknet_leaf_19_clk _0040_ net150 vssd1 vssd1 vccd1 vccd1 CALC_INST.gencon_inst.operand2\[8\]
+ sky130_fd_sc_hd__dfrtp_4
XFILLER_55_355 vssd1 vssd1 vccd1 vccd1 sky130_fd_sc_hd__fill_1
XTAP_TAPCELL_ROW_53_512 vssd1 vccd1 sky130_fd_sc_hd__tapvpwrvgnd_1
XANTENNA_clkbuf_leaf_4_clk_A clknet_2_1__leaf_clk vssd1 vssd1 vccd1 vccd1 sky130_fd_sc_hd__diode_2
XTAP_TAPCELL_ROW_2_156 vssd1 vccd1 sky130_fd_sc_hd__tapvpwrvgnd_1
XFILLER_23_44 vccd1 vssd1 vccd1 vssd1 sky130_ef_sc_hd__decap_40_12
XFILLER_2_134 vssd1 vssd1 vccd1 vccd1 sky130_fd_sc_hd__fill_1
XFILLER_48_85 vssd1 vssd1 vccd1 vccd1 sky130_fd_sc_hd__fill_8
XFILLER_46_333 vssd1 vssd1 vccd1 vccd1 sky130_fd_sc_hd__fill_2
XFILLER_0_26 vssd1 vssd1 vccd1 vccd1 sky130_fd_sc_hd__fill_2
XFILLER_64_62 vssd1 vssd1 vccd1 vccd1 sky130_fd_sc_hd__fill_8
XFILLER_64_51 vssd1 vssd1 vccd1 vccd1 sky130_fd_sc_hd__fill_1
XFILLER_46_344 vssd1 vssd1 vccd1 vccd1 sky130_fd_sc_hd__fill_2
XFILLER_9_13 vssd1 vssd1 vccd1 vccd1 sky130_fd_sc_hd__fill_1
XFILLER_9_46 vssd1 vssd1 vccd1 vccd1 sky130_fd_sc_hd__fill_1
X_1303_ CALC_INST.gencon_inst.operand1\[0\] net307 net50 vssd1 vssd1 vccd1 vccd1 _0090_
+ sky130_fd_sc_hd__mux2_1
X_2421_ CALC_INST.gencon_inst.operand1\[5\] _0549_ _0550_ _0553_ vssd1 vssd1 vccd1
+ vccd1 _0554_ sky130_fd_sc_hd__o22a_1
X_2352_ CALC_INST.gencon_inst.operand2\[8\] _0493_ _0404_ vssd1 vssd1 vccd1 vccd1
+ _0497_ sky130_fd_sc_hd__o21ai_1
X_2283_ CALC_INST.input_ctrl_inst.col_index\[27\] CALC_INST.input_ctrl_inst.col_index\[26\]
+ _0444_ vssd1 vssd1 vccd1 vccd1 _0445_ sky130_fd_sc_hd__nand3_1
XFILLER_64_141 vssd1 vssd1 vccd1 vccd1 sky130_fd_sc_hd__fill_2
XFILLER_52_314 vssd1 vssd1 vccd1 vccd1 sky130_fd_sc_hd__fill_2
XFILLER_49_171 vssd1 vssd1 vccd1 vccd1 sky130_fd_sc_hd__fill_1
XFILLER_52_347 vccd1 vssd1 vccd1 vssd1 sky130_ef_sc_hd__decap_40_12
XANTENNA__2460__B1 net58 vssd1 vssd1 vccd1 vccd1 sky130_fd_sc_hd__diode_2
XFILLER_20_211 vccd1 vssd1 vccd1 vssd1 sky130_ef_sc_hd__decap_40_12
X_2619_ clknet_leaf_15_clk _0157_ net146 vssd1 vssd1 vccd1 vccd1 CALC_INST.gencon_inst.add_calc.main.GENERATE_ADDER\[13\].thingy.in1
+ sky130_fd_sc_hd__dfrtp_1
X_1998_ CALC_INST.gencon_inst.mult_calc.compCount.in2\[4\] vssd1 vssd1 vccd1 vccd1
+ _1054_ sky130_fd_sc_hd__inv_2
XFILLER_20_277 vssd1 vssd1 vccd1 vccd1 sky130_fd_sc_hd__fill_8
XFILLER_18_33 vssd1 vssd1 vccd1 vccd1 sky130_fd_sc_hd__fill_2
XFILLER_43_325 vssd1 vssd1 vccd1 vccd1 sky130_fd_sc_hd__fill_1
XTAP_TAPCELL_ROW_13_228 vssd1 vccd1 sky130_fd_sc_hd__tapvpwrvgnd_1
XFILLER_46_141 vssd1 vssd1 vccd1 vccd1 sky130_fd_sc_hd__fill_2
XFILLER_61_133 vssd1 vssd1 vccd1 vccd1 sky130_fd_sc_hd__fill_2
XFILLER_61_111 vssd1 vssd1 vccd1 vccd1 sky130_fd_sc_hd__fill_1
X_1921_ CALC_INST.input_ctrl_inst.decoded_key\[0\] _1005_ _1149_ vssd1 vssd1 vccd1
+ vccd1 _1006_ sky130_fd_sc_hd__a21oi_1
X_1852_ CALC_INST.input_ctrl_inst.col_index\[17\] _0966_ vssd1 vssd1 vccd1 vccd1 _0967_
+ sky130_fd_sc_hd__nor2_1
X_1783_ CALC_INST.gencon_inst.operand2\[7\] net49 net38 net344 vssd1 vssd1 vccd1 vccd1
+ _0293_ sky130_fd_sc_hd__a22o_1
XFILLER_57_406 vssd1 vssd1 vccd1 vccd1 sky130_fd_sc_hd__fill_1
X_2404_ _0539_ _0519_ _0538_ vssd1 vssd1 vccd1 vccd1 _0540_ sky130_fd_sc_hd__and3b_1
X_2335_ CALC_INST.gencon_inst.operand2\[4\] _0474_ _0477_ _0483_ _0382_ vssd1 vssd1
+ vccd1 vccd1 _0484_ sky130_fd_sc_hd__o32a_1
X_2266_ CALC_INST.input_ctrl_inst.col_index\[11\] CALC_INST.input_ctrl_inst.col_index\[10\]
+ _0427_ vssd1 vssd1 vccd1 vccd1 _0428_ sky130_fd_sc_hd__and3_1
X_2197_ _1211_ _1224_ vssd1 vssd1 vccd1 vccd1 _1225_ sky130_fd_sc_hd__nor2_1
XFILLER_25_303 vssd1 vssd1 vccd1 vccd1 sky130_fd_sc_hd__fill_1
XFILLER_40_339 vssd1 vssd1 vccd1 vccd1 sky130_fd_sc_hd__fill_1
XTAP_TAPCELL_ROW_35_386 vssd1 vccd1 sky130_fd_sc_hd__tapvpwrvgnd_1
XANTENNA__1787__A2 net48 vssd1 vssd1 vccd1 vccd1 sky130_fd_sc_hd__diode_2
XTAP_TAPCELL_ROW_10_209 vssd1 vccd1 sky130_fd_sc_hd__tapvpwrvgnd_1
XPHY_EDGE_ROW_42_Left_107 vssd1 vssd1 vccd1 vccd1 sky130_fd_sc_hd__decap_3
XFILLER_20_56 vssd1 vssd1 vccd1 vccd1 sky130_fd_sc_hd__fill_1
Xhold54 CALC_INST.gencon_inst.ALU_in2\[14\] vssd1 vssd1 vccd1 vccd1 net250 sky130_fd_sc_hd__dlygate4sd3_1
Xhold65 CALC_INST.gencon_inst.ALU_in1\[2\] vssd1 vssd1 vccd1 vccd1 net261 sky130_fd_sc_hd__dlygate4sd3_1
Xhold76 CALC_INST.gencon_inst.ALU_in1\[11\] vssd1 vssd1 vccd1 vccd1 net272 sky130_fd_sc_hd__dlygate4sd3_1
Xhold32 _0125_ vssd1 vssd1 vccd1 vccd1 net228 sky130_fd_sc_hd__dlygate4sd3_1
Xhold10 _0124_ vssd1 vssd1 vccd1 vccd1 net206 sky130_fd_sc_hd__dlygate4sd3_1
Xhold21 CALC_INST.gencon_inst.mult_calc.INn1\[5\] vssd1 vssd1 vccd1 vccd1 net217 sky130_fd_sc_hd__dlygate4sd3_1
Xhold43 _0235_ vssd1 vssd1 vccd1 vccd1 net239 sky130_fd_sc_hd__dlygate4sd3_1
Xhold87 _0339_ vssd1 vssd1 vccd1 vccd1 net283 sky130_fd_sc_hd__dlygate4sd3_1
Xhold98 CALC_INST.gencon_inst.mult_calc.countSave\[10\] vssd1 vssd1 vccd1 vccd1 net294
+ sky130_fd_sc_hd__dlygate4sd3_1
XPHY_EDGE_ROW_51_Left_116 vssd1 vssd1 vccd1 vccd1 sky130_fd_sc_hd__decap_3
XANTENNA__1778__A2 net48 vssd1 vssd1 vccd1 vccd1 sky130_fd_sc_hd__diode_2
XFILLER_31_328 vssd1 vssd1 vccd1 vccd1 sky130_fd_sc_hd__fill_8
XTAP_TAPCELL_ROW_26_320 vssd1 vccd1 sky130_fd_sc_hd__tapvpwrvgnd_1
XFILLER_61_85 vccd1 vssd1 vccd1 vssd1 sky130_ef_sc_hd__decap_40_12
XPHY_EDGE_ROW_60_Left_125 vssd1 vssd1 vccd1 vccd1 sky130_fd_sc_hd__decap_3
X_2120_ CALC_INST.input_ctrl_inst.RowSync\[2\] _1162_ _1163_ _1164_ vssd1 vssd1 vccd1
+ vccd1 _1165_ sky130_fd_sc_hd__a31o_1
X_2051_ CALC_INST.gencon_inst.mult_calc.count.GENERATE_ADDER\[1\].thingy.cIn CALC_INST.gencon_inst.mult_calc.compCount.in2\[0\]
+ _1104_ _1103_ CALC_INST.gencon_inst.mult_calc.compCount.in2\[1\] vssd1 vssd1 vccd1
+ vccd1 _1105_ sky130_fd_sc_hd__a32o_1
XFILLER_19_141 vssd1 vssd1 vccd1 vccd1 sky130_fd_sc_hd__fill_1
XTAP_TAPCELL_ROW_32_367 vssd1 vccd1 sky130_fd_sc_hd__tapvpwrvgnd_1
X_1904_ net91 net296 net75 CALC_INST.gencon_inst.mult_calc.count.GENERATE_ADDER\[1\].thingy.in1
+ vssd1 vssd1 vccd1 vccd1 _0335_ sky130_fd_sc_hd__a22o_1
X_1835_ CALC_INST.input_ctrl_inst.col_index\[9\] CALC_INST.input_ctrl_inst.col_index\[8\]
+ _0956_ vssd1 vssd1 vccd1 vccd1 _0958_ sky130_fd_sc_hd__and3_1
XFILLER_15_391 vssd1 vssd1 vccd1 vccd1 sky130_fd_sc_hd__fill_1
X_1766_ net82 _1110_ net84 net282 vssd1 vssd1 vccd1 vccd1 _0276_ sky130_fd_sc_hd__a2bb2o_1
X_1697_ net421 net413 net95 vssd1 vssd1 vccd1 vccd1 _0209_ sky130_fd_sc_hd__mux2_1
XFILLER_57_225 vssd1 vssd1 vccd1 vccd1 sky130_fd_sc_hd__fill_2
X_2318_ CALC_INST.gencon_inst.operand2\[2\] CALC_INST.gencon_inst.latched_keypad_input\[2\]
+ vssd1 vssd1 vccd1 vccd1 _0469_ sky130_fd_sc_hd__or2_1
X_2249_ CALC_INST.input_ctrl_inst.col_index\[5\] CALC_INST.input_ctrl_inst.col_index\[4\]
+ CALC_INST.input_ctrl_inst.col_index\[7\] CALC_INST.input_ctrl_inst.col_index\[6\]
+ vssd1 vssd1 vccd1 vccd1 _0411_ sky130_fd_sc_hd__or4_1
XFILLER_40_158 vssd1 vssd1 vccd1 vccd1 sky130_fd_sc_hd__fill_4
XTAP_TAPCELL_ROW_23_301 vssd1 vccd1 sky130_fd_sc_hd__tapvpwrvgnd_1
XFILLER_15_23 vssd1 vssd1 vccd1 vccd1 sky130_fd_sc_hd__fill_1
XFILLER_15_89 vssd1 vssd1 vccd1 vccd1 sky130_fd_sc_hd__fill_2
XFILLER_31_55 vssd1 vssd1 vccd1 vccd1 sky130_fd_sc_hd__fill_1
XFILLER_31_22 vccd1 vssd1 vccd1 vssd1 sky130_ef_sc_hd__decap_40_12
Xteam_06_178 vssd1 vssd1 vccd1 vccd1 gpio_oeb[10] team_06_178/LO sky130_fd_sc_hd__conb_1
Xteam_06_156 vssd1 vssd1 vccd1 vccd1 team_06_156/HI gpio_oeb[2] sky130_fd_sc_hd__conb_1
Xteam_06_167 vssd1 vssd1 vccd1 vccd1 team_06_167/HI gpio_out[29] sky130_fd_sc_hd__conb_1
Xteam_06_189 vssd1 vssd1 vccd1 vccd1 gpio_oeb[21] team_06_189/LO sky130_fd_sc_hd__conb_1
Xoutput22 net22 vssd1 vssd1 vccd1 vccd1 gpio_out[26] sky130_fd_sc_hd__buf_2
Xoutput11 net11 vssd1 vssd1 vccd1 vccd1 gpio_out[15] sky130_fd_sc_hd__buf_2
Xoutput9 net9 vssd1 vssd1 vccd1 vccd1 gpio_out[13] sky130_fd_sc_hd__buf_2
XFILLER_0_221 vssd1 vssd1 vccd1 vccd1 sky130_fd_sc_hd__fill_1
XFILLER_0_243 vssd1 vssd1 vccd1 vccd1 sky130_fd_sc_hd__fill_8
XTAP_TAPCELL_ROW_46_459 vssd1 vccd1 sky130_fd_sc_hd__tapvpwrvgnd_1
XFILLER_16_199 vssd1 vssd1 vccd1 vccd1 sky130_fd_sc_hd__fill_1
X_1551_ _0798_ _0800_ vssd1 vssd1 vccd1 vccd1 _0803_ sky130_fd_sc_hd__or2_1
X_1482_ CALC_INST.gencon_inst.add_calc.main.GENERATE_ADDER\[2\].thingy.in1 _0738_
+ _0739_ vssd1 vssd1 vccd1 vccd1 _0741_ sky130_fd_sc_hd__nand3_1
X_1620_ _0850_ _0854_ _0851_ vssd1 vssd1 vccd1 vccd1 _0859_ sky130_fd_sc_hd__o21a_1
XFILLER_39_225 vssd1 vssd1 vccd1 vccd1 sky130_fd_sc_hd__fill_1
X_2103_ net79 _1150_ _1151_ vssd1 vssd1 vccd1 vccd1 _1152_ sky130_fd_sc_hd__and3_1
X_2034_ CALC_INST.gencon_inst.mult_calc.count.GENERATE_ADDER\[1\].thingy.in1 CALC_INST.gencon_inst.mult_calc.count.GENERATE_ADDER\[1\].thingy.cIn
+ CALC_INST.gencon_inst.mult_calc.count.GENERATE_ADDER\[2\].thingy.in1 vssd1 vssd1
+ vccd1 vccd1 _1088_ sky130_fd_sc_hd__and3_1
X_2867_ clknet_leaf_3_clk _0362_ vssd1 vssd1 vccd1 vccd1 CALC_INST.input_ctrl_inst.scan_timer\[5\]
+ sky130_fd_sc_hd__dfxtp_1
X_2798_ clknet_leaf_34_clk _0323_ net114 vssd1 vssd1 vccd1 vccd1 CALC_INST.input_ctrl_inst.col_index\[21\]
+ sky130_fd_sc_hd__dfrtp_2
X_1818_ _0455_ _0947_ vssd1 vssd1 vccd1 vccd1 _0948_ sky130_fd_sc_hd__nor2_1
X_1749_ CALC_INST.gencon_inst.mult_calc.out\[7\] net318 net102 vssd1 vssd1 vccd1 vccd1
+ _0260_ sky130_fd_sc_hd__mux2_1
XFILLER_26_44 vssd1 vssd1 vccd1 vccd1 sky130_fd_sc_hd__fill_1
XANTENNA__1678__B2 net100 vssd1 vssd1 vccd1 vccd1 sky130_fd_sc_hd__diode_2
XTAP_TAPCELL_ROW_51_495 vssd1 vccd1 sky130_fd_sc_hd__tapvpwrvgnd_1
XFILLER_9_129 vssd1 vssd1 vccd1 vccd1 sky130_fd_sc_hd__fill_1
XFILLER_5_335 vssd1 vssd1 vccd1 vccd1 sky130_fd_sc_hd__fill_1
XTAP_TAPCELL_ROW_59_551 vssd1 vccd1 sky130_fd_sc_hd__tapvpwrvgnd_1
XFILLER_3_26 vssd1 vssd1 vccd1 vccd1 sky130_fd_sc_hd__fill_1
XTAP_TAPCELL_ROW_8_195 vssd1 vccd1 sky130_fd_sc_hd__tapvpwrvgnd_1
XFILLER_36_239 vssd1 vssd1 vccd1 vccd1 sky130_fd_sc_hd__fill_2
XFILLER_29_291 vssd1 vssd1 vccd1 vccd1 sky130_fd_sc_hd__fill_1
X_2652_ clknet_leaf_4_clk _0190_ net121 vssd1 vssd1 vccd1 vccd1 CALC_INST.gencon_inst.operand2\[15\]
+ sky130_fd_sc_hd__dfrtp_2
X_2721_ clknet_leaf_29_clk _0259_ net138 vssd1 vssd1 vccd1 vccd1 CALC_INST.gencon_inst.mult_calc.out\[6\]
+ sky130_fd_sc_hd__dfrtp_1
XFILLER_8_173 vssd1 vssd1 vccd1 vccd1 sky130_fd_sc_hd__fill_1
Xfanout108 CALC_INST.gencon_inst.add_calc.state\[2\] vssd1 vssd1 vccd1 vccd1 net108
+ sky130_fd_sc_hd__buf_2
X_1465_ _0722_ _0723_ CALC_INST.gencon_inst.add_calc.main.GENERATE_ADDER\[6\].thingy.in1
+ vssd1 vssd1 vccd1 vccd1 _0724_ sky130_fd_sc_hd__a21oi_1
X_1534_ _0728_ _0729_ vssd1 vssd1 vccd1 vccd1 _0789_ sky130_fd_sc_hd__and2b_1
X_2583_ clknet_leaf_9_clk _0121_ vssd1 vssd1 vccd1 vccd1 CALC_INST.gencon_inst.ALU_in2\[15\]
+ sky130_fd_sc_hd__dfxtp_1
Xfanout119 net120 vssd1 vssd1 vccd1 vccd1 net119 sky130_fd_sc_hd__clkbuf_2
X_1603_ CALC_INST.gencon_inst.mult_calc.main.a0.in2 CALC_INST.gencon_inst.mult_calc.main.a0.in1
+ vssd1 vssd1 vccd1 vccd1 _0845_ sky130_fd_sc_hd__or2_1
X_1396_ CALC_INST.gencon_inst.ALU_in2\[13\] CALC_INST.gencon_inst.ALU_in1\[13\] net66
+ vssd1 vssd1 vccd1 vccd1 _0673_ sky130_fd_sc_hd__mux2_1
X_2017_ CALC_INST.input_ctrl_inst.input_control_state\[1\] CALC_INST.input_ctrl_inst.input_control_state\[0\]
+ CALC_INST.input_ctrl_inst.input_control_state\[2\] vssd1 vssd1 vccd1 vccd1 _1073_
+ sky130_fd_sc_hd__and3b_1
XFILLER_50_231 vssd1 vssd1 vccd1 vccd1 sky130_fd_sc_hd__fill_4
XFILLER_35_272 vssd1 vssd1 vccd1 vccd1 sky130_fd_sc_hd__fill_2
Xhold140 CALC_INST.gencon_inst.add_calc.main.in2\[2\] vssd1 vssd1 vccd1 vccd1 net336
+ sky130_fd_sc_hd__dlygate4sd3_1
Xhold162 CALC_INST.gencon_inst.mult_calc.INn2\[14\] vssd1 vssd1 vccd1 vccd1 net358
+ sky130_fd_sc_hd__dlygate4sd3_1
XFILLER_2_305 vssd1 vssd1 vccd1 vccd1 sky130_fd_sc_hd__fill_1
Xhold151 _0250_ vssd1 vssd1 vccd1 vccd1 net347 sky130_fd_sc_hd__dlygate4sd3_1
Xhold195 CALC_INST.gencon_inst.add_calc.main.in2\[3\] vssd1 vssd1 vccd1 vccd1 net391
+ sky130_fd_sc_hd__dlygate4sd3_1
Xhold173 CALC_INST.gencon_inst.add_calc.main.GENERATE_ADDER\[3\].thingy.in1 vssd1
+ vssd1 vccd1 vccd1 net369 sky130_fd_sc_hd__dlygate4sd3_1
XFILLER_58_353 vssd1 vssd1 vccd1 vccd1 sky130_fd_sc_hd__fill_8
XANTENNA_fanout73_A _0393_ vssd1 vssd1 vccd1 vccd1 sky130_fd_sc_hd__diode_2
XTAP_TAPCELL_ROW_5_176 vssd1 vccd1 sky130_fd_sc_hd__tapvpwrvgnd_1
Xhold184 _0211_ vssd1 vssd1 vccd1 vccd1 net380 sky130_fd_sc_hd__dlygate4sd3_1
XTAP_TAPCELL_ROW_56_532 vssd1 vccd1 sky130_fd_sc_hd__tapvpwrvgnd_1
XFILLER_26_250 vssd1 vssd1 vccd1 vccd1 sky130_fd_sc_hd__fill_2
XFILLER_5_187 vssd1 vssd1 vccd1 vccd1 sky130_fd_sc_hd__fill_1
X_1250_ CALC_INST.gencon_inst.ALU_out\[7\] net70 net54 CALC_INST.gencon_inst.mult_calc.out\[7\]
+ net57 vssd1 vssd1 vccd1 vccd1 _0614_ sky130_fd_sc_hd__a221o_1
XFILLER_1_393 vssd1 vssd1 vccd1 vccd1 sky130_fd_sc_hd__fill_8
XFILLER_17_283 vssd1 vssd1 vccd1 vccd1 sky130_fd_sc_hd__fill_1
X_2635_ clknet_leaf_13_clk _0173_ net146 vssd1 vssd1 vccd1 vccd1 CALC_INST.gencon_inst.add_calc.main.in2\[14\]
+ sky130_fd_sc_hd__dfrtp_1
X_2704_ clknet_leaf_28_clk net410 net134 vssd1 vssd1 vccd1 vccd1 CALC_INST.gencon_inst.mult_calc.main.GENERATE_ADDER\[4\].thingy.in2
+ sky130_fd_sc_hd__dfrtp_1
X_1517_ _0746_ _0774_ vssd1 vssd1 vccd1 vccd1 _0775_ sky130_fd_sc_hd__xnor2_1
X_1448_ net105 CALC_INST.gencon_inst.add_calc.main.in2\[10\] vssd1 vssd1 vccd1 vccd1
+ _0707_ sky130_fd_sc_hd__nand2_1
X_2566_ clknet_leaf_13_clk _0104_ vssd1 vssd1 vccd1 vccd1 CALC_INST.gencon_inst.ALU_in1\[14\]
+ sky130_fd_sc_hd__dfxtp_1
X_2497_ clknet_leaf_20_clk _0039_ net145 vssd1 vssd1 vccd1 vccd1 CALC_INST.gencon_inst.operand2\[7\]
+ sky130_fd_sc_hd__dfrtp_2
XFILLER_4_91 vccd1 vssd1 vccd1 vssd1 sky130_ef_sc_hd__decap_40_12
XFILLER_55_312 vssd1 vssd1 vccd1 vccd1 sky130_fd_sc_hd__fill_1
XTAP_TAPCELL_ROW_53_513 vssd1 vccd1 sky130_fd_sc_hd__tapvpwrvgnd_1
X_1379_ net383 _0664_ net108 vssd1 vssd1 vccd1 vccd1 _0148_ sky130_fd_sc_hd__mux2_1
XANTENNA__1266__C1 _0590_ vssd1 vssd1 vccd1 vccd1 sky130_fd_sc_hd__diode_2
XTAP_TAPCELL_ROW_2_157 vssd1 vccd1 sky130_fd_sc_hd__tapvpwrvgnd_1
XANTENNA__1281__A2 _0519_ vssd1 vssd1 vccd1 vccd1 sky130_fd_sc_hd__diode_2
XFILLER_23_253 vssd1 vssd1 vccd1 vccd1 sky130_fd_sc_hd__fill_2
XANTENNA__1741__B1 net77 vssd1 vssd1 vccd1 vccd1 sky130_fd_sc_hd__diode_2
XFILLER_58_150 vssd1 vssd1 vccd1 vccd1 sky130_fd_sc_hd__fill_2
XFILLER_48_75 vssd1 vssd1 vccd1 vccd1 sky130_fd_sc_hd__fill_8
XFILLER_64_85 vssd1 vssd1 vccd1 vccd1 sky130_fd_sc_hd__fill_2
XFILLER_64_41 vssd1 vssd1 vccd1 vccd1 sky130_fd_sc_hd__fill_8
XFILLER_61_337 vssd1 vssd1 vccd1 vccd1 sky130_fd_sc_hd__fill_4
XANTENNA__1257__C1 net57 vssd1 vssd1 vccd1 vccd1 sky130_fd_sc_hd__diode_2
XANTENNA__1272__A2 _0392_ vssd1 vssd1 vccd1 vccd1 sky130_fd_sc_hd__diode_2
X_2420_ CALC_INST.gencon_inst.operand1\[5\] _0520_ vssd1 vssd1 vccd1 vccd1 _0553_
+ sky130_fd_sc_hd__nor2_1
Xfanout90 CALC_INST.input_ctrl_inst.col_index\[2\] vssd1 vssd1 vccd1 vccd1 net90 sky130_fd_sc_hd__buf_2
X_1302_ CALC_INST.gencon_inst.latched_operator_input\[2\] net112 _0387_ CALC_INST.gencon_inst.latched_operator_input\[1\]
+ vssd1 vssd1 vccd1 vccd1 _0646_ sky130_fd_sc_hd__or4b_4
X_2351_ CALC_INST.gencon_inst.operand2\[8\] CALC_INST.gencon_inst.operand2\[7\] _0489_
+ vssd1 vssd1 vccd1 vccd1 _0496_ sky130_fd_sc_hd__and3_1
X_2282_ CALC_INST.input_ctrl_inst.col_index\[29\] CALC_INST.input_ctrl_inst.col_index\[28\]
+ CALC_INST.input_ctrl_inst.col_index\[31\] CALC_INST.input_ctrl_inst.col_index\[30\]
+ vssd1 vssd1 vccd1 vccd1 _0444_ sky130_fd_sc_hd__and4_1
XFILLER_64_197 vssd1 vssd1 vccd1 vccd1 sky130_fd_sc_hd__fill_8
XFILLER_52_359 vssd1 vssd1 vccd1 vccd1 sky130_fd_sc_hd__fill_1
XFILLER_52_337 vssd1 vssd1 vccd1 vccd1 sky130_fd_sc_hd__fill_1
X_1997_ CALC_INST.input_ctrl_inst.RowSync\[2\] vssd1 vssd1 vccd1 vccd1 _1053_ sky130_fd_sc_hd__inv_2
XANTENNA_fanout123_A net5 vssd1 vssd1 vccd1 vccd1 sky130_fd_sc_hd__diode_2
XFILLER_20_223 vssd1 vssd1 vccd1 vccd1 sky130_fd_sc_hd__fill_4
X_2618_ clknet_leaf_15_clk _0156_ net151 vssd1 vssd1 vccd1 vccd1 CALC_INST.gencon_inst.add_calc.main.GENERATE_ADDER\[12\].thingy.in1
+ sky130_fd_sc_hd__dfrtp_1
X_2549_ clknet_leaf_7_clk _0087_ net125 vssd1 vssd1 vccd1 vccd1 CALC_INST.gencon_inst.latched_operator_input\[1\]
+ sky130_fd_sc_hd__dfrtp_1
XFILLER_43_304 vssd1 vssd1 vccd1 vccd1 sky130_fd_sc_hd__fill_1
XANTENNA__1254__A2 _0397_ vssd1 vssd1 vccd1 vccd1 sky130_fd_sc_hd__diode_2
XTAP_TAPCELL_ROW_13_229 vssd1 vccd1 sky130_fd_sc_hd__tapvpwrvgnd_1
XFILLER_18_89 vssd1 vssd1 vccd1 vccd1 sky130_fd_sc_hd__fill_1
XFILLER_50_87 vssd1 vssd1 vccd1 vccd1 sky130_fd_sc_hd__fill_1
XFILLER_50_54 vssd1 vssd1 vccd1 vccd1 sky130_fd_sc_hd__fill_1
XTAP_TAPCELL_ROW_21_284 vssd1 vccd1 sky130_fd_sc_hd__tapvpwrvgnd_1
XFILLER_46_197 vccd1 vssd1 vccd1 vssd1 sky130_ef_sc_hd__decap_40_12
XFILLER_46_120 vssd1 vssd1 vccd1 vccd1 sky130_fd_sc_hd__fill_4
XANTENNA__1241__S _0393_ vssd1 vssd1 vccd1 vccd1 sky130_fd_sc_hd__diode_2
XTAP_TAPCELL_ROW_29_340 vssd1 vccd1 sky130_fd_sc_hd__tapvpwrvgnd_1
XFILLER_61_167 vssd1 vssd1 vccd1 vccd1 sky130_fd_sc_hd__fill_1
X_1920_ CALC_INST.input_ctrl_inst.decoded_key\[1\] CALC_INST.input_ctrl_inst.decoded_key\[3\]
+ CALC_INST.input_ctrl_inst.decoded_key\[2\] vssd1 vssd1 vccd1 vccd1 _1005_ sky130_fd_sc_hd__or3b_1
X_1851_ CALC_INST.input_ctrl_inst.col_index\[16\] _0434_ net60 vssd1 vssd1 vccd1 vccd1
+ _0966_ sky130_fd_sc_hd__and3_1
X_2403_ _0529_ _0531_ _0535_ _0537_ vssd1 vssd1 vccd1 vccd1 _0539_ sky130_fd_sc_hd__o211a_1
X_1782_ CALC_INST.gencon_inst.operand2\[6\] net49 net37 net365 vssd1 vssd1 vccd1 vccd1
+ _0292_ sky130_fd_sc_hd__a22o_1
XANTENNA_clkbuf_leaf_3_clk_A clknet_2_0__leaf_clk vssd1 vssd1 vccd1 vccd1 sky130_fd_sc_hd__diode_2
X_2196_ CALC_INST.input_ctrl_inst.debounce_cnt\[15\] CALC_INST.input_ctrl_inst.debounce_cnt\[16\]
+ _1218_ vssd1 vssd1 vccd1 vccd1 _1224_ sky130_fd_sc_hd__and3_1
X_2334_ _0405_ _0482_ vssd1 vssd1 vccd1 vccd1 _0483_ sky130_fd_sc_hd__nor2_1
XFILLER_29_109 vssd1 vssd1 vccd1 vccd1 sky130_fd_sc_hd__fill_2
X_2265_ CALC_INST.input_ctrl_inst.col_index\[4\] CALC_INST.input_ctrl_inst.col_index\[9\]
+ CALC_INST.input_ctrl_inst.col_index\[8\] CALC_INST.input_ctrl_inst.col_index\[13\]
+ vssd1 vssd1 vccd1 vccd1 _0427_ sky130_fd_sc_hd__and4_1
XTAP_TAPCELL_ROW_35_387 vssd1 vccd1 sky130_fd_sc_hd__tapvpwrvgnd_1
Xhold22 CALC_INST.gencon_inst.mult_calc.INn1\[3\] vssd1 vssd1 vccd1 vccd1 net218 sky130_fd_sc_hd__dlygate4sd3_1
Xhold11 CALC_INST.gencon_inst.mult_calc.INn1\[7\] vssd1 vssd1 vccd1 vccd1 net207 sky130_fd_sc_hd__dlygate4sd3_1
Xhold44 CALC_INST.gencon_inst.ALU_in2\[10\] vssd1 vssd1 vccd1 vccd1 net240 sky130_fd_sc_hd__dlygate4sd3_1
Xhold55 CALC_INST.gencon_inst.ALU_in1\[12\] vssd1 vssd1 vccd1 vccd1 net251 sky130_fd_sc_hd__dlygate4sd3_1
XFILLER_45_54 vssd1 vssd1 vccd1 vccd1 sky130_fd_sc_hd__fill_2
Xhold88 net15 vssd1 vssd1 vccd1 vccd1 net284 sky130_fd_sc_hd__dlygate4sd3_1
XFILLER_29_99 vssd1 vssd1 vccd1 vccd1 sky130_fd_sc_hd__fill_1
Xhold66 CALC_INST.gencon_inst.mult_calc.diffSign vssd1 vssd1 vccd1 vccd1 net262 sky130_fd_sc_hd__dlygate4sd3_1
XTAP_TAPCELL_ROW_26_321 vssd1 vccd1 sky130_fd_sc_hd__tapvpwrvgnd_1
Xhold33 CALC_INST.gencon_inst.mult_calc.main.GENERATE_ADDER\[2\].thingy.in1 vssd1
+ vssd1 vccd1 vccd1 net229 sky130_fd_sc_hd__dlygate4sd3_1
Xhold99 _0344_ vssd1 vssd1 vccd1 vccd1 net295 sky130_fd_sc_hd__dlygate4sd3_1
XFILLER_16_315 vssd1 vssd1 vccd1 vccd1 sky130_fd_sc_hd__fill_2
XFILLER_16_337 vssd1 vssd1 vccd1 vccd1 sky130_fd_sc_hd__fill_2
Xhold77 CALC_INST.gencon_inst.mult_calc.main.GENERATE_ADDER\[11\].thingy.in1 vssd1
+ vssd1 vccd1 vccd1 net273 sky130_fd_sc_hd__dlygate4sd3_1
XFILLER_61_53 vssd1 vssd1 vccd1 vccd1 sky130_fd_sc_hd__fill_2
XFILLER_61_42 vssd1 vssd1 vccd1 vccd1 sky130_fd_sc_hd__fill_1
XFILLER_61_97 vccd1 vssd1 vccd1 vssd1 sky130_ef_sc_hd__decap_40_12
X_2050_ CALC_INST.gencon_inst.mult_calc.count.GENERATE_ADDER\[1\].thingy.in1 CALC_INST.gencon_inst.mult_calc.compCount.in2\[1\]
+ vssd1 vssd1 vccd1 vccd1 _1104_ sky130_fd_sc_hd__or2_1
XFILLER_22_307 vssd1 vssd1 vccd1 vccd1 sky130_fd_sc_hd__fill_1
X_1765_ net99 _1108_ net84 net281 vssd1 vssd1 vccd1 vccd1 _0275_ sky130_fd_sc_hd__a22o_1
X_1903_ net91 net290 net75 CALC_INST.gencon_inst.mult_calc.count.GENERATE_ADDER\[1\].thingy.cIn
+ vssd1 vssd1 vccd1 vccd1 _0334_ sky130_fd_sc_hd__a22o_1
X_1834_ CALC_INST.input_ctrl_inst.col_index\[8\] _0956_ net469 vssd1 vssd1 vccd1 vccd1
+ _0957_ sky130_fd_sc_hd__a21oi_1
XANTENNA__2469__C _0397_ vssd1 vssd1 vccd1 vccd1 sky130_fd_sc_hd__diode_2
X_1696_ net405 net263 net95 vssd1 vssd1 vccd1 vccd1 _0208_ sky130_fd_sc_hd__mux2_1
X_2179_ _1208_ _1210_ net467 net45 vssd1 vssd1 vccd1 vccd1 _0011_ sky130_fd_sc_hd__a2bb2o_1
X_2317_ CALC_INST.gencon_inst.operand2\[2\] CALC_INST.gencon_inst.latched_keypad_input\[2\]
+ vssd1 vssd1 vccd1 vccd1 _0468_ sky130_fd_sc_hd__nand2_1
X_2248_ CALC_INST.input_ctrl_inst.col_index\[9\] CALC_INST.input_ctrl_inst.col_index\[8\]
+ CALC_INST.input_ctrl_inst.col_index\[11\] CALC_INST.input_ctrl_inst.col_index\[10\]
+ vssd1 vssd1 vccd1 vccd1 _0410_ sky130_fd_sc_hd__or4_1
XFILLER_25_167 vssd1 vssd1 vccd1 vccd1 sky130_fd_sc_hd__fill_1
XTAP_TAPCELL_ROW_23_302 vssd1 vccd1 sky130_fd_sc_hd__tapvpwrvgnd_1
XFILLER_15_46 vssd1 vssd1 vccd1 vccd1 sky130_fd_sc_hd__fill_1
Xoutput23 net23 vssd1 vssd1 vccd1 vccd1 gpio_out[27] sky130_fd_sc_hd__buf_2
Xoutput12 net12 vssd1 vssd1 vccd1 vccd1 gpio_out[16] sky130_fd_sc_hd__buf_2
XANTENNA__1917__B1 net77 vssd1 vssd1 vccd1 vccd1 sky130_fd_sc_hd__diode_2
Xteam_06_157 vssd1 vssd1 vccd1 vccd1 team_06_157/HI gpio_oeb[3] sky130_fd_sc_hd__conb_1
Xteam_06_168 vssd1 vssd1 vccd1 vccd1 team_06_168/HI gpio_out[30] sky130_fd_sc_hd__conb_1
Xteam_06_179 vssd1 vssd1 vccd1 vccd1 gpio_oeb[11] team_06_179/LO sky130_fd_sc_hd__conb_1
XANTENNA_clkbuf_2_0__f_clk_X clknet_2_0__leaf_clk vssd1 vssd1 vccd1 vccd1 sky130_fd_sc_hd__diode_2
XFILLER_16_134 vssd1 vssd1 vccd1 vccd1 sky130_fd_sc_hd__fill_4
X_1550_ _0802_ _0801_ CALC_INST.gencon_inst.ALU_out\[7\] net80 vssd1 vssd1 vccd1 vccd1
+ _0181_ sky130_fd_sc_hd__a2bb2o_1
X_1481_ _0738_ _0739_ CALC_INST.gencon_inst.add_calc.main.GENERATE_ADDER\[2\].thingy.in1
+ vssd1 vssd1 vccd1 vccd1 _0740_ sky130_fd_sc_hd__a21oi_1
XANTENNA__1908__B1 net75 vssd1 vssd1 vccd1 vccd1 sky130_fd_sc_hd__diode_2
XFILLER_47_281 vssd1 vssd1 vccd1 vccd1 sky130_fd_sc_hd__fill_2
XFILLER_47_270 vssd1 vssd1 vccd1 vccd1 sky130_fd_sc_hd__fill_1
X_2033_ _1075_ _1085_ _1087_ _1079_ vssd1 vssd1 vccd1 vccd1 CALC_INST.input_ctrl_inst.next_state\[0\]
+ sky130_fd_sc_hd__or4b_1
X_2102_ CALC_INST.input_ctrl_inst.decoded_key\[1\] CALC_INST.input_ctrl_inst.decoded_key\[0\]
+ vssd1 vssd1 vccd1 vccd1 _1151_ sky130_fd_sc_hd__nand2_1
XFILLER_11_3 vssd1 vssd1 vccd1 vccd1 sky130_fd_sc_hd__fill_8
XFILLER_62_251 vssd1 vssd1 vccd1 vccd1 sky130_fd_sc_hd__fill_1
XFILLER_22_126 vccd1 vssd1 vccd1 vssd1 sky130_ef_sc_hd__decap_40_12
X_2866_ clknet_leaf_3_clk _0361_ vssd1 vssd1 vccd1 vccd1 CALC_INST.input_ctrl_inst.scan_timer\[4\]
+ sky130_fd_sc_hd__dfxtp_1
X_1748_ CALC_INST.gencon_inst.mult_calc.out\[6\] net431 net102 vssd1 vssd1 vccd1 vccd1
+ _0259_ sky130_fd_sc_hd__mux2_1
X_2797_ clknet_leaf_33_clk _0322_ net114 vssd1 vssd1 vccd1 vccd1 CALC_INST.input_ctrl_inst.col_index\[20\]
+ sky130_fd_sc_hd__dfrtp_1
X_1817_ _0455_ _0946_ _0936_ vssd1 vssd1 vccd1 vccd1 _0947_ sky130_fd_sc_hd__o21ai_4
X_1679_ CALC_INST.gencon_inst.mult_calc.main.GENERATE_ADDER\[12\].thingy.in2 CALC_INST.gencon_inst.mult_calc.main.GENERATE_ADDER\[12\].thingy.in1
+ vssd1 vssd1 vccd1 vccd1 _0909_ sky130_fd_sc_hd__or2_1
XFILLER_41_402 vssd1 vssd1 vccd1 vccd1 sky130_fd_sc_hd__fill_1
XFILLER_26_89 vssd1 vssd1 vccd1 vccd1 sky130_fd_sc_hd__fill_1
XTAP_TAPCELL_ROW_51_496 vssd1 vccd1 sky130_fd_sc_hd__tapvpwrvgnd_1
XTAP_TAPCELL_ROW_59_552 vssd1 vccd1 sky130_fd_sc_hd__tapvpwrvgnd_1
XTAP_TAPCELL_ROW_8_196 vssd1 vccd1 sky130_fd_sc_hd__tapvpwrvgnd_1
XFILLER_44_251 vssd1 vssd1 vccd1 vccd1 sky130_fd_sc_hd__fill_1
X_2651_ clknet_leaf_10_clk _0189_ net130 vssd1 vssd1 vccd1 vccd1 CALC_INST.gencon_inst.ALU_out\[15\]
+ sky130_fd_sc_hd__dfrtp_1
X_2582_ clknet_leaf_13_clk _0120_ vssd1 vssd1 vccd1 vccd1 CALC_INST.gencon_inst.ALU_in2\[14\]
+ sky130_fd_sc_hd__dfxtp_1
X_2720_ clknet_leaf_29_clk _0258_ net137 vssd1 vssd1 vccd1 vccd1 CALC_INST.gencon_inst.mult_calc.out\[5\]
+ sky130_fd_sc_hd__dfrtp_1
X_1602_ CALC_INST.gencon_inst.mult_calc.main.a0.in2 CALC_INST.gencon_inst.mult_calc.main.a0.in1
+ vssd1 vssd1 vccd1 vccd1 _0844_ sky130_fd_sc_hd__nand2_1
Xfanout109 CALC_INST.gencon_inst.add_calc.state\[2\] vssd1 vssd1 vccd1 vccd1 net109
+ sky130_fd_sc_hd__clkbuf_4
X_1464_ net104 CALC_INST.gencon_inst.add_calc.main.in2\[6\] vssd1 vssd1 vccd1 vccd1
+ _0723_ sky130_fd_sc_hd__nand2_1
X_1533_ _0783_ _0785_ vssd1 vssd1 vccd1 vccd1 _0788_ sky130_fd_sc_hd__or2_1
X_1395_ net397 _0672_ net109 vssd1 vssd1 vccd1 vccd1 _0156_ sky130_fd_sc_hd__mux2_1
X_2016_ CALC_INST.input_ctrl_inst.debounce_cnt\[14\] _1071_ _1068_ vssd1 vssd1 vccd1
+ vccd1 _1072_ sky130_fd_sc_hd__o21ai_2
XFILLER_35_240 vssd1 vssd1 vccd1 vccd1 sky130_fd_sc_hd__fill_8
XANTENNA__2242__C1 _0405_ vssd1 vssd1 vccd1 vccd1 sky130_fd_sc_hd__diode_2
Xclkbuf_leaf_30_clk clknet_2_0__leaf_clk vssd1 vssd1 vccd1 vccd1 clknet_leaf_30_clk
+ sky130_fd_sc_hd__clkbuf_8
XANTENNA_fanout153_A net5 vssd1 vssd1 vccd1 vccd1 sky130_fd_sc_hd__diode_2
Xhold163 CALC_INST.gencon_inst.add_calc.main.in2\[6\] vssd1 vssd1 vccd1 vccd1 net359
+ sky130_fd_sc_hd__dlygate4sd3_1
X_2849_ clknet_leaf_8_clk _0009_ net126 vssd1 vssd1 vccd1 vccd1 CALC_INST.input_ctrl_inst.debounce_cnt\[10\]
+ sky130_fd_sc_hd__dfrtp_1
Xhold185 CALC_INST.gencon_inst.add_calc.main.GENERATE_ADDER\[10\].thingy.in1 vssd1
+ vssd1 vccd1 vccd1 net381 sky130_fd_sc_hd__dlygate4sd3_1
Xhold174 CALC_INST.equal_input vssd1 vssd1 vccd1 vccd1 net370 sky130_fd_sc_hd__dlygate4sd3_1
Xhold152 CALC_INST.gencon_inst.mult_calc.INn2\[10\] vssd1 vssd1 vccd1 vccd1 net348
+ sky130_fd_sc_hd__dlygate4sd3_1
Xhold130 CALC_INST.input_ctrl_inst.col_index\[15\] vssd1 vssd1 vccd1 vccd1 net326
+ sky130_fd_sc_hd__dlygate4sd3_1
Xhold141 CALC_INST.gencon_inst.mult_calc.adderSave\[0\] vssd1 vssd1 vccd1 vccd1 net337
+ sky130_fd_sc_hd__dlygate4sd3_1
Xhold196 CALC_INST.gencon_inst.add_calc.main.in2\[7\] vssd1 vssd1 vccd1 vccd1 net392
+ sky130_fd_sc_hd__dlygate4sd3_1
XFILLER_58_365 vssd1 vssd1 vccd1 vccd1 sky130_fd_sc_hd__fill_4
XFILLER_58_332 vssd1 vssd1 vccd1 vccd1 sky130_fd_sc_hd__fill_1
XANTENNA_fanout66_A _0659_ vssd1 vssd1 vccd1 vccd1 sky130_fd_sc_hd__diode_2
XTAP_TAPCELL_ROW_5_177 vssd1 vccd1 sky130_fd_sc_hd__tapvpwrvgnd_1
XFILLER_18_207 vssd1 vssd1 vccd1 vccd1 sky130_fd_sc_hd__fill_1
XTAP_TAPCELL_ROW_56_533 vssd1 vccd1 sky130_fd_sc_hd__tapvpwrvgnd_1
XANTENNA__1289__B net56 vssd1 vssd1 vccd1 vccd1 sky130_fd_sc_hd__diode_2
XFILLER_37_88 vssd1 vssd1 vccd1 vccd1 sky130_fd_sc_hd__fill_2
Xclkbuf_leaf_21_clk clknet_2_2__leaf_clk vssd1 vssd1 vccd1 vccd1 clknet_leaf_21_clk
+ sky130_fd_sc_hd__clkbuf_8
XFILLER_5_111 vssd1 vssd1 vccd1 vccd1 sky130_fd_sc_hd__fill_1
XANTENNA__1244__S _0393_ vssd1 vssd1 vccd1 vccd1 sky130_fd_sc_hd__diode_2
XFILLER_64_335 vssd1 vssd1 vccd1 vccd1 sky130_fd_sc_hd__fill_1
Xclkbuf_leaf_12_clk clknet_2_3__leaf_clk vssd1 vssd1 vccd1 vccd1 clknet_leaf_12_clk
+ sky130_fd_sc_hd__clkbuf_8
X_1516_ _0740_ _0741_ vssd1 vssd1 vccd1 vccd1 _0774_ sky130_fd_sc_hd__nand2b_1
X_2634_ clknet_leaf_13_clk _0172_ net146 vssd1 vssd1 vccd1 vccd1 CALC_INST.gencon_inst.add_calc.main.in2\[13\]
+ sky130_fd_sc_hd__dfrtp_1
X_2565_ clknet_leaf_18_clk _0103_ vssd1 vssd1 vccd1 vccd1 CALC_INST.gencon_inst.ALU_in1\[13\]
+ sky130_fd_sc_hd__dfxtp_1
X_2703_ clknet_leaf_29_clk net363 net137 vssd1 vssd1 vccd1 vccd1 CALC_INST.gencon_inst.mult_calc.main.GENERATE_ADDER\[3\].thingy.in2
+ sky130_fd_sc_hd__dfrtp_1
X_1447_ net105 CALC_INST.gencon_inst.add_calc.main.in2\[10\] vssd1 vssd1 vccd1 vccd1
+ _0706_ sky130_fd_sc_hd__or2_1
X_1378_ CALC_INST.gencon_inst.ALU_in2\[4\] CALC_INST.gencon_inst.ALU_in1\[4\] net64
+ vssd1 vssd1 vccd1 vccd1 _0664_ sky130_fd_sc_hd__mux2_1
X_2496_ clknet_leaf_21_clk _0038_ net145 vssd1 vssd1 vccd1 vccd1 CALC_INST.gencon_inst.operand2\[6\]
+ sky130_fd_sc_hd__dfrtp_2
XFILLER_55_335 vssd1 vssd1 vccd1 vccd1 sky130_fd_sc_hd__fill_1
XTAP_TAPCELL_ROW_53_514 vssd1 vccd1 sky130_fd_sc_hd__tapvpwrvgnd_1
XANTENNA__1266__B1 net54 vssd1 vssd1 vccd1 vccd1 sky130_fd_sc_hd__diode_2
XFILLER_23_276 vssd1 vssd1 vccd1 vccd1 sky130_fd_sc_hd__fill_4
XFILLER_23_57 vccd1 vssd1 vccd1 vssd1 sky130_ef_sc_hd__decap_40_12
XANTENNA__1741__A1 net94 vssd1 vssd1 vccd1 vccd1 sky130_fd_sc_hd__diode_2
XFILLER_58_195 vssd1 vssd1 vccd1 vccd1 sky130_fd_sc_hd__fill_1
Xfanout80 _1061_ vssd1 vssd1 vccd1 vccd1 net80 sky130_fd_sc_hd__clkbuf_2
XANTENNA__1257__B1 net54 vssd1 vssd1 vccd1 vccd1 sky130_fd_sc_hd__diode_2
Xfanout91 net94 vssd1 vssd1 vccd1 vccd1 net91 sky130_fd_sc_hd__buf_2
XTAP_TAPCELL_ROW_16_249 vssd1 vccd1 sky130_fd_sc_hd__tapvpwrvgnd_1
XFILLER_64_110 vssd1 vssd1 vccd1 vccd1 sky130_fd_sc_hd__fill_2
X_1301_ CALC_INST.gencon_inst.read_input net213 _0644_ vssd1 vssd1 vccd1 vccd1 _0089_
+ sky130_fd_sc_hd__mux2_1
XFILLER_37_324 vssd1 vssd1 vccd1 vccd1 sky130_fd_sc_hd__fill_2
X_2350_ CALC_INST.gencon_inst.operand2\[7\] _0495_ net34 vssd1 vssd1 vccd1 vccd1 _0039_
+ sky130_fd_sc_hd__mux2_1
X_2281_ CALC_INST.input_ctrl_inst.col_index\[25\] _0442_ vssd1 vssd1 vccd1 vccd1 _0443_
+ sky130_fd_sc_hd__nor2_1
Xclkbuf_leaf_1_clk clknet_2_0__leaf_clk vssd1 vssd1 vccd1 vccd1 clknet_leaf_1_clk
+ sky130_fd_sc_hd__clkbuf_8
XFILLER_64_121 vssd1 vssd1 vccd1 vccd1 sky130_fd_sc_hd__fill_1
XFILLER_45_390 vssd1 vssd1 vccd1 vccd1 sky130_fd_sc_hd__fill_2
XFILLER_37_357 vssd1 vssd1 vccd1 vccd1 sky130_fd_sc_hd__fill_1
XANTENNA__1702__S net96 vssd1 vssd1 vccd1 vccd1 sky130_fd_sc_hd__diode_2
X_1996_ CALC_INST.input_ctrl_inst.debounce_cnt\[17\] vssd1 vssd1 vccd1 vccd1 _1052_
+ sky130_fd_sc_hd__inv_2
X_2617_ clknet_leaf_17_clk _0155_ net152 vssd1 vssd1 vccd1 vccd1 CALC_INST.gencon_inst.add_calc.main.GENERATE_ADDER\[11\].thingy.in1
+ sky130_fd_sc_hd__dfrtp_1
X_2548_ clknet_leaf_7_clk _0086_ net127 vssd1 vssd1 vccd1 vccd1 CALC_INST.gencon_inst.latched_operator_input\[0\]
+ sky130_fd_sc_hd__dfrtp_1
XANTENNA_fanout116_A net123 vssd1 vssd1 vccd1 vccd1 sky130_fd_sc_hd__diode_2
X_2479_ CALC_INST.gencon_inst.operand2\[2\] CALC_INST.gencon_inst.operand1\[2\] net72
+ vssd1 vssd1 vccd1 vccd1 _0599_ sky130_fd_sc_hd__mux2_1
XFILLER_28_335 vssd1 vssd1 vccd1 vccd1 sky130_fd_sc_hd__fill_4
XFILLER_18_35 vssd1 vssd1 vccd1 vccd1 sky130_fd_sc_hd__fill_1
XANTENNA__1239__B1 net54 vssd1 vssd1 vccd1 vccd1 sky130_fd_sc_hd__diode_2
Xclkload0 clknet_2_1__leaf_clk vssd1 vssd1 vccd1 vccd1 clkload0/X sky130_fd_sc_hd__clkbuf_8
XTAP_TAPCELL_ROW_21_285 vssd1 vccd1 sky130_fd_sc_hd__tapvpwrvgnd_1
XFILLER_61_135 vssd1 vssd1 vccd1 vccd1 sky130_fd_sc_hd__fill_1
XFILLER_61_113 vccd1 vssd1 vccd1 vssd1 sky130_ef_sc_hd__decap_40_12
XANTENNA__2427__C1 net41 vssd1 vssd1 vccd1 vccd1 sky130_fd_sc_hd__diode_2
XTAP_TAPCELL_ROW_29_341 vssd1 vccd1 sky130_fd_sc_hd__tapvpwrvgnd_1
XFILLER_19_346 vssd1 vssd1 vccd1 vccd1 sky130_fd_sc_hd__fill_4
X_1781_ CALC_INST.gencon_inst.operand2\[5\] net49 net40 net382 vssd1 vssd1 vccd1 vccd1
+ _0291_ sky130_fd_sc_hd__a22o_1
X_1850_ net462 _0965_ vssd1 vssd1 vccd1 vccd1 _0318_ sky130_fd_sc_hd__xnor2_1
X_2402_ _0535_ _0537_ _0529_ _0531_ vssd1 vssd1 vccd1 vccd1 _0538_ sky130_fd_sc_hd__a211o_1
X_2333_ _0474_ _0477_ CALC_INST.gencon_inst.operand2\[4\] vssd1 vssd1 vccd1 vccd1
+ _0482_ sky130_fd_sc_hd__o21a_1
XFILLER_6_294 vssd1 vssd1 vccd1 vccd1 sky130_fd_sc_hd__fill_1
X_2195_ CALC_INST.input_ctrl_inst.debounce_cnt\[15\] net36 _1218_ CALC_INST.input_ctrl_inst.debounce_cnt\[16\]
+ vssd1 vssd1 vccd1 vccd1 _1223_ sky130_fd_sc_hd__a31o_1
XFILLER_37_143 vssd1 vssd1 vccd1 vccd1 sky130_fd_sc_hd__fill_4
X_2264_ _0420_ _0421_ _0425_ vssd1 vssd1 vccd1 vccd1 _0426_ sky130_fd_sc_hd__and3_1
XTAP_TAPCELL_ROW_35_388 vssd1 vccd1 sky130_fd_sc_hd__tapvpwrvgnd_1
XFILLER_33_393 vssd1 vssd1 vccd1 vccd1 sky130_fd_sc_hd__fill_1
X_1979_ CALC_INST.input_ctrl_inst.scan_timer\[13\] CALC_INST.input_ctrl_inst.scan_timer\[14\]
+ _1039_ vssd1 vssd1 vccd1 vccd1 _1042_ sky130_fd_sc_hd__and3_1
Xhold56 CALC_INST.gencon_inst.ALU_in2\[13\] vssd1 vssd1 vccd1 vccd1 net252 sky130_fd_sc_hd__dlygate4sd3_1
Xhold45 CALC_INST.gencon_inst.ALU_in2\[4\] vssd1 vssd1 vccd1 vccd1 net241 sky130_fd_sc_hd__dlygate4sd3_1
Xhold12 CALC_INST.gencon_inst.mult_calc.INn1\[4\] vssd1 vssd1 vccd1 vccd1 net208 sky130_fd_sc_hd__dlygate4sd3_1
Xhold23 CALC_INST.gencon_inst.mult_calc.main.GENERATE_ADDER\[6\].thingy.in1 vssd1
+ vssd1 vccd1 vccd1 net219 sky130_fd_sc_hd__dlygate4sd3_1
Xhold34 CALC_INST.gencon_inst.mult_calc.main.GENERATE_ADDER\[5\].thingy.in1 vssd1
+ vssd1 vccd1 vccd1 net230 sky130_fd_sc_hd__dlygate4sd3_1
Xhold67 CALC_INST.gencon_inst.mult_calc.INn2\[1\] vssd1 vssd1 vccd1 vccd1 net263 sky130_fd_sc_hd__dlygate4sd3_1
XTAP_TAPCELL_ROW_26_322 vssd1 vccd1 sky130_fd_sc_hd__tapvpwrvgnd_1
Xhold89 CALC_INST.gencon_inst.mult_calc.countSave\[11\] vssd1 vssd1 vccd1 vccd1 net285
+ sky130_fd_sc_hd__dlygate4sd3_1
Xhold78 CALC_INST.gencon_inst.mult_calc.countSave\[6\] vssd1 vssd1 vccd1 vccd1 net274
+ sky130_fd_sc_hd__dlygate4sd3_1
XFILLER_3_264 vssd1 vssd1 vccd1 vccd1 sky130_fd_sc_hd__fill_2
XFILLER_3_242 vssd1 vssd1 vccd1 vccd1 sky130_fd_sc_hd__fill_1
XFILLER_6_49 vccd1 vssd1 vccd1 vssd1 sky130_ef_sc_hd__decap_40_12
XFILLER_34_135 vssd1 vssd1 vccd1 vccd1 sky130_fd_sc_hd__fill_4
X_1902_ net232 net47 _1000_ _1002_ vssd1 vssd1 vccd1 vccd1 _0333_ sky130_fd_sc_hd__a31oi_1
XANTENNA_clkbuf_0_clk_A clk vssd1 vssd1 vccd1 vccd1 sky130_fd_sc_hd__diode_2
XFILLER_30_374 vssd1 vssd1 vccd1 vccd1 sky130_fd_sc_hd__fill_2
X_2882_ clknet_leaf_3_clk _0377_ vssd1 vssd1 vccd1 vccd1 CALC_INST.gencon_inst.mult_calc.start
+ sky130_fd_sc_hd__dfxtp_1
X_1764_ net82 _1099_ net84 net303 vssd1 vssd1 vccd1 vccd1 _0274_ sky130_fd_sc_hd__a2bb2o_1
X_1833_ net418 _0956_ vssd1 vssd1 vccd1 vccd1 _0310_ sky130_fd_sc_hd__xor2_1
XANTENNA__1427__S net109 vssd1 vssd1 vccd1 vccd1 sky130_fd_sc_hd__diode_2
X_2316_ CALC_INST.gencon_inst.operand2\[2\] CALC_INST.gencon_inst.latched_keypad_input\[2\]
+ vssd1 vssd1 vccd1 vccd1 _0467_ sky130_fd_sc_hd__and2_1
X_1695_ net310 CALC_INST.gencon_inst.mult_calc.INn2\[0\] net95 vssd1 vssd1 vccd1 vccd1
+ _0207_ sky130_fd_sc_hd__mux2_1
XFILLER_57_238 vssd1 vssd1 vccd1 vccd1 sky130_fd_sc_hd__fill_4
X_2178_ CALC_INST.input_ctrl_inst.debounce_cnt\[12\] _1204_ _1209_ _1175_ vssd1 vssd1
+ vccd1 vccd1 _1210_ sky130_fd_sc_hd__a2bb2o_1
X_2247_ CALC_INST.input_ctrl_inst.col_index\[13\] CALC_INST.input_ctrl_inst.col_index\[12\]
+ CALC_INST.input_ctrl_inst.col_index\[15\] CALC_INST.input_ctrl_inst.col_index\[14\]
+ vssd1 vssd1 vccd1 vccd1 _0409_ sky130_fd_sc_hd__or4_1
XFILLER_31_13 vssd1 vssd1 vccd1 vccd1 sky130_fd_sc_hd__fill_1
XTAP_TAPCELL_ROW_23_303 vssd1 vccd1 sky130_fd_sc_hd__tapvpwrvgnd_1
Xoutput24 net24 vssd1 vssd1 vccd1 vccd1 gpio_out[28] sky130_fd_sc_hd__buf_2
Xoutput13 net13 vssd1 vssd1 vccd1 vccd1 gpio_out[17] sky130_fd_sc_hd__buf_2
XFILLER_31_68 vssd1 vssd1 vccd1 vccd1 sky130_fd_sc_hd__fill_1
XANTENNA_fanout96_A CALC_INST.gencon_inst.mult_calc.state\[3\] vssd1 vssd1 vccd1 vccd1
+ sky130_fd_sc_hd__diode_2
Xteam_06_169 vssd1 vssd1 vccd1 vccd1 team_06_169/HI gpio_out[31] sky130_fd_sc_hd__conb_1
XFILLER_0_278 vssd1 vssd1 vccd1 vccd1 sky130_fd_sc_hd__fill_2
Xteam_06_158 vssd1 vssd1 vccd1 vccd1 team_06_158/HI gpio_oeb[29] sky130_fd_sc_hd__conb_1
XFILLER_56_271 vssd1 vssd1 vccd1 vccd1 sky130_fd_sc_hd__fill_8
XANTENNA_clkbuf_leaf_2_clk_A clknet_2_0__leaf_clk vssd1 vssd1 vccd1 vccd1 sky130_fd_sc_hd__diode_2
XPHY_EDGE_ROW_19_Right_19 vssd1 vssd1 vccd1 vccd1 sky130_fd_sc_hd__decap_3
XANTENNA__1908__A1 net91 vssd1 vssd1 vccd1 vccd1 sky130_fd_sc_hd__diode_2
X_1480_ net103 CALC_INST.gencon_inst.add_calc.main.in2\[2\] vssd1 vssd1 vccd1 vccd1
+ _0739_ sky130_fd_sc_hd__nand2_1
XPHY_EDGE_ROW_28_Right_28 vssd1 vssd1 vccd1 vccd1 sky130_fd_sc_hd__decap_3
X_2032_ net88 CALC_INST.input_ctrl_inst.key_pressed _1086_ vssd1 vssd1 vccd1 vccd1
+ _1087_ sky130_fd_sc_hd__a21boi_1
XPHY_EDGE_ROW_37_Right_37 vssd1 vssd1 vccd1 vccd1 sky130_fd_sc_hd__decap_3
X_2101_ CALC_INST.input_ctrl_inst.decoded_key\[3\] _1149_ vssd1 vssd1 vccd1 vccd1
+ _1150_ sky130_fd_sc_hd__nand2_1
X_2865_ clknet_leaf_3_clk _0360_ vssd1 vssd1 vccd1 vccd1 CALC_INST.input_ctrl_inst.scan_timer\[3\]
+ sky130_fd_sc_hd__dfxtp_1
XFILLER_22_138 vssd1 vssd1 vccd1 vccd1 sky130_fd_sc_hd__fill_2
XPHY_EDGE_ROW_46_Right_46 vssd1 vssd1 vccd1 vccd1 sky130_fd_sc_hd__decap_3
X_1747_ CALC_INST.gencon_inst.mult_calc.out\[5\] net314 net101 vssd1 vssd1 vccd1 vccd1
+ _0258_ sky130_fd_sc_hd__mux2_1
X_2796_ clknet_leaf_32_clk _0321_ net117 vssd1 vssd1 vccd1 vccd1 CALC_INST.input_ctrl_inst.col_index\[19\]
+ sky130_fd_sc_hd__dfrtp_1
X_1816_ net90 _0424_ _0450_ _0453_ vssd1 vssd1 vccd1 vccd1 _0946_ sky130_fd_sc_hd__or4b_2
X_1678_ net428 net87 _0908_ net100 vssd1 vssd1 vccd1 vccd1 _0203_ sky130_fd_sc_hd__a22o_1
XPHY_EDGE_ROW_55_Right_55 vssd1 vssd1 vccd1 vccd1 sky130_fd_sc_hd__decap_3
XFILLER_26_24 vssd1 vssd1 vccd1 vccd1 sky130_fd_sc_hd__fill_4
XPHY_EDGE_ROW_64_Right_64 vssd1 vssd1 vccd1 vccd1 sky130_fd_sc_hd__decap_3
XTAP_TAPCELL_ROW_51_497 vssd1 vccd1 sky130_fd_sc_hd__tapvpwrvgnd_1
XPHY_EDGE_ROW_39_Left_104 vssd1 vssd1 vccd1 vccd1 sky130_fd_sc_hd__decap_3
XANTENNA__1768__A1_N net82 vssd1 vssd1 vccd1 vccd1 sky130_fd_sc_hd__diode_2
XTAP_TAPCELL_ROW_59_553 vssd1 vccd1 sky130_fd_sc_hd__tapvpwrvgnd_1
XPHY_EDGE_ROW_48_Left_113 vssd1 vssd1 vccd1 vccd1 sky130_fd_sc_hd__decap_3
XTAP_TAPCELL_ROW_8_197 vssd1 vccd1 sky130_fd_sc_hd__tapvpwrvgnd_1
XTAP_TAPCELL_ROW_42_431 vssd1 vccd1 sky130_fd_sc_hd__tapvpwrvgnd_1
XFILLER_8_120 vccd1 vssd1 vccd1 vssd1 sky130_ef_sc_hd__decap_40_12
XPHY_EDGE_ROW_57_Left_122 vssd1 vssd1 vccd1 vccd1 sky130_fd_sc_hd__decap_3
X_2650_ clknet_leaf_15_clk _0188_ net146 vssd1 vssd1 vccd1 vccd1 CALC_INST.gencon_inst.ALU_out\[14\]
+ sky130_fd_sc_hd__dfrtp_1
X_1532_ _0787_ _0786_ net464 net81 vssd1 vssd1 vccd1 vccd1 _0178_ sky130_fd_sc_hd__a2bb2o_1
X_2581_ clknet_leaf_13_clk _0119_ vssd1 vssd1 vccd1 vccd1 CALC_INST.gencon_inst.ALU_in2\[13\]
+ sky130_fd_sc_hd__dfxtp_1
X_1601_ net95 net99 vssd1 vssd1 vccd1 vccd1 _0843_ sky130_fd_sc_hd__nor2_2
X_1463_ net104 CALC_INST.gencon_inst.add_calc.main.in2\[6\] vssd1 vssd1 vccd1 vccd1
+ _0722_ sky130_fd_sc_hd__or2_1
X_1394_ CALC_INST.gencon_inst.ALU_in2\[12\] CALC_INST.gencon_inst.ALU_in1\[12\] net66
+ vssd1 vssd1 vccd1 vccd1 _0672_ sky130_fd_sc_hd__mux2_1
X_2015_ _1069_ _1070_ CALC_INST.input_ctrl_inst.debounce_cnt\[13\] vssd1 vssd1 vccd1
+ vccd1 _1071_ sky130_fd_sc_hd__o21a_1
X_2848_ clknet_leaf_8_clk _0026_ net126 vssd1 vssd1 vccd1 vccd1 CALC_INST.input_ctrl_inst.debounce_cnt\[9\]
+ sky130_fd_sc_hd__dfrtp_1
XFILLER_12_26 vssd1 vssd1 vccd1 vccd1 sky130_fd_sc_hd__fill_2
Xhold175 CALC_INST.input_ctrl_inst.input_control_state\[1\] vssd1 vssd1 vccd1 vccd1
+ net371 sky130_fd_sc_hd__dlygate4sd3_1
Xhold186 CALC_INST.gencon_inst.mult_calc.INn2\[5\] vssd1 vssd1 vccd1 vccd1 net382
+ sky130_fd_sc_hd__dlygate4sd3_1
Xhold153 CALC_INST.gencon_inst.mult_calc.INn2\[12\] vssd1 vssd1 vccd1 vccd1 net349
+ sky130_fd_sc_hd__dlygate4sd3_1
Xhold142 CALC_INST.gencon_inst.mult_calc.count.GENERATE_ADDER\[13\].thingy.in1 vssd1
+ vssd1 vccd1 vccd1 net338 sky130_fd_sc_hd__dlygate4sd3_1
Xhold120 CALC_INST.gencon_inst.mult_calc.count.GENERATE_ADDER\[2\].thingy.in1 vssd1
+ vssd1 vccd1 vccd1 net316 sky130_fd_sc_hd__dlygate4sd3_1
Xhold197 CALC_INST.gencon_inst.mult_calc.compCount.in2\[3\] vssd1 vssd1 vccd1 vccd1
+ net393 sky130_fd_sc_hd__dlygate4sd3_1
X_2779_ clknet_leaf_0_clk _0304_ net113 vssd1 vssd1 vccd1 vccd1 CALC_INST.input_ctrl_inst.col_index\[2\]
+ sky130_fd_sc_hd__dfrtp_1
Xhold131 CALC_INST.gencon_inst.mult_calc.main.GENERATE_ADDER\[12\].thingy.in1 vssd1
+ vssd1 vccd1 vccd1 net327 sky130_fd_sc_hd__dlygate4sd3_1
Xhold164 CALC_INST.input_ctrl_inst.scan_timer\[11\] vssd1 vssd1 vccd1 vccd1 net360
+ sky130_fd_sc_hd__dlygate4sd3_1
XTAP_TAPCELL_ROW_56_534 vssd1 vccd1 sky130_fd_sc_hd__tapvpwrvgnd_1
XTAP_TAPCELL_ROW_5_178 vssd1 vccd1 sky130_fd_sc_hd__tapvpwrvgnd_1
XFILLER_53_55 vssd1 vssd1 vccd1 vccd1 sky130_fd_sc_hd__fill_1
XANTENNA__2481__B1 net54 vssd1 vssd1 vccd1 vccd1 sky130_fd_sc_hd__diode_2
XFILLER_5_101 vssd1 vssd1 vccd1 vccd1 sky130_fd_sc_hd__fill_2
X_2702_ clknet_leaf_30_clk net396 net122 vssd1 vssd1 vccd1 vccd1 CALC_INST.gencon_inst.mult_calc.main.GENERATE_ADDER\[2\].thingy.in2
+ sky130_fd_sc_hd__dfrtp_1
XFILLER_20_406 vssd1 vssd1 vccd1 vccd1 sky130_fd_sc_hd__fill_1
X_1515_ _0690_ _0769_ vssd1 vssd1 vccd1 vccd1 _0773_ sky130_fd_sc_hd__nand2b_1
X_2633_ clknet_leaf_18_clk _0171_ net151 vssd1 vssd1 vccd1 vccd1 CALC_INST.gencon_inst.add_calc.main.in2\[12\]
+ sky130_fd_sc_hd__dfrtp_1
X_2564_ clknet_leaf_18_clk _0102_ vssd1 vssd1 vccd1 vccd1 CALC_INST.gencon_inst.ALU_in1\[12\]
+ sky130_fd_sc_hd__dfxtp_1
X_2495_ clknet_leaf_21_clk _0037_ net145 vssd1 vssd1 vccd1 vccd1 CALC_INST.gencon_inst.operand2\[5\]
+ sky130_fd_sc_hd__dfrtp_2
X_1377_ net369 _0663_ net108 vssd1 vssd1 vccd1 vccd1 _0147_ sky130_fd_sc_hd__mux2_1
XFILLER_55_325 vssd1 vssd1 vccd1 vccd1 sky130_fd_sc_hd__fill_2
X_1446_ CALC_INST.gencon_inst.add_calc.main.GENERATE_ADDER\[11\].thingy.in1 _0702_
+ _0703_ vssd1 vssd1 vccd1 vccd1 _0705_ sky130_fd_sc_hd__nand3_1
XFILLER_63_391 vssd1 vssd1 vccd1 vccd1 sky130_fd_sc_hd__fill_1
XTAP_TAPCELL_ROW_61_570 vssd1 vccd1 sky130_fd_sc_hd__tapvpwrvgnd_1
XFILLER_23_255 vssd1 vssd1 vccd1 vccd1 sky130_fd_sc_hd__fill_1
XFILLER_11_406 vssd1 vssd1 vccd1 vccd1 sky130_fd_sc_hd__fill_1
XFILLER_23_69 vssd1 vssd1 vccd1 vccd1 sky130_fd_sc_hd__fill_4
XFILLER_2_104 vssd1 vssd1 vccd1 vccd1 sky130_fd_sc_hd__fill_4
XFILLER_64_76 vssd1 vssd1 vccd1 vccd1 sky130_fd_sc_hd__fill_4
XFILLER_58_174 vssd1 vssd1 vccd1 vccd1 sky130_fd_sc_hd__fill_2
Xfanout81 _1061_ vssd1 vssd1 vccd1 vccd1 net81 sky130_fd_sc_hd__clkbuf_2
Xfanout70 net71 vssd1 vssd1 vccd1 vccd1 net70 sky130_fd_sc_hd__buf_2
XFILLER_14_266 vssd1 vssd1 vccd1 vccd1 sky130_fd_sc_hd__fill_4
Xfanout92 net94 vssd1 vssd1 vccd1 vccd1 net92 sky130_fd_sc_hd__buf_2
XANTENNA__1255__S net73 vssd1 vssd1 vccd1 vccd1 sky130_fd_sc_hd__diode_2
XPHY_EDGE_ROW_24_Left_89 vssd1 vssd1 vccd1 vccd1 sky130_fd_sc_hd__decap_3
XFILLER_13_91 vssd1 vssd1 vccd1 vccd1 sky130_fd_sc_hd__fill_1
XFILLER_49_174 vssd1 vssd1 vccd1 vccd1 sky130_fd_sc_hd__fill_1
X_1300_ CALC_INST.gencon_inst.read_input _0644_ vssd1 vssd1 vccd1 vccd1 _0645_ sky130_fd_sc_hd__nor2_1
X_2280_ CALC_INST.input_ctrl_inst.col_index\[23\] CALC_INST.input_ctrl_inst.col_index\[24\]
+ _0413_ _0417_ vssd1 vssd1 vccd1 vccd1 _0442_ sky130_fd_sc_hd__or4_1
XFILLER_64_166 vssd1 vssd1 vccd1 vccd1 sky130_fd_sc_hd__fill_2
X_2616_ clknet_leaf_17_clk _0154_ net152 vssd1 vssd1 vccd1 vccd1 CALC_INST.gencon_inst.add_calc.main.GENERATE_ADDER\[10\].thingy.in1
+ sky130_fd_sc_hd__dfrtp_1
X_1995_ CALC_INST.input_ctrl_inst.debounce_cnt\[13\] vssd1 vssd1 vccd1 vccd1 _1051_
+ sky130_fd_sc_hd__inv_2
XANTENNA_fanout109_A CALC_INST.gencon_inst.add_calc.state\[2\] vssd1 vssd1 vccd1 vccd1
+ sky130_fd_sc_hd__diode_2
X_1429_ net351 _0689_ net109 vssd1 vssd1 vccd1 vccd1 _0173_ sky130_fd_sc_hd__mux2_1
X_2478_ net453 net57 net56 _0597_ _0598_ vssd1 vssd1 vccd1 vccd1 _0064_ sky130_fd_sc_hd__a221o_1
X_2547_ clknet_leaf_5_clk _0085_ net125 vssd1 vssd1 vccd1 vccd1 CALC_INST.gencon_inst.latched_keypad_input\[3\]
+ sky130_fd_sc_hd__dfrtp_2
XFILLER_55_166 vssd1 vssd1 vccd1 vccd1 sky130_fd_sc_hd__fill_2
XFILLER_11_247 vssd1 vssd1 vccd1 vccd1 sky130_fd_sc_hd__fill_1
Xclkload1 clknet_leaf_0_clk vssd1 vssd1 vccd1 vccd1 clkload1/Y sky130_fd_sc_hd__inv_8
XTAP_TAPCELL_ROW_21_286 vssd1 vccd1 sky130_fd_sc_hd__tapvpwrvgnd_1
XFILLER_59_54 vssd1 vssd1 vccd1 vccd1 sky130_fd_sc_hd__fill_2
XFILLER_61_125 vssd1 vssd1 vccd1 vccd1 sky130_fd_sc_hd__fill_8
XTAP_TAPCELL_ROW_29_342 vssd1 vccd1 sky130_fd_sc_hd__tapvpwrvgnd_1
X_1780_ CALC_INST.gencon_inst.operand2\[4\] net48 net40 net439 vssd1 vssd1 vccd1 vccd1
+ _0290_ sky130_fd_sc_hd__a22o_1
X_2401_ CALC_INST.gencon_inst.operand1\[2\] CALC_INST.gencon_inst.latched_keypad_input\[2\]
+ vssd1 vssd1 vccd1 vccd1 _0537_ sky130_fd_sc_hd__or2_1
X_2332_ CALC_INST.gencon_inst.mult_calc.out\[4\] _1234_ _0405_ vssd1 vssd1 vccd1 vccd1
+ _0481_ sky130_fd_sc_hd__and3_1
X_2194_ net45 _1221_ _1222_ vssd1 vssd1 vccd1 vccd1 _0014_ sky130_fd_sc_hd__o21a_1
XANTENNA__2855__RESET_B net132 vssd1 vssd1 vccd1 vccd1 sky130_fd_sc_hd__diode_2
XANTENNA__2418__B1 net58 vssd1 vssd1 vccd1 vccd1 sky130_fd_sc_hd__diode_2
XFILLER_37_188 vssd1 vssd1 vccd1 vccd1 sky130_fd_sc_hd__fill_4
XFILLER_37_155 vssd1 vssd1 vccd1 vccd1 sky130_fd_sc_hd__fill_1
XANTENNA__1713__S net96 vssd1 vssd1 vccd1 vccd1 sky130_fd_sc_hd__diode_2
X_2263_ CALC_INST.input_ctrl_inst.col_index\[19\] CALC_INST.input_ctrl_inst.col_index\[18\]
+ net74 _0422_ vssd1 vssd1 vccd1 vccd1 _0425_ sky130_fd_sc_hd__or4_1
X_1978_ CALC_INST.input_ctrl_inst.scan_timer\[13\] CALC_INST.input_ctrl_inst.scan_timer\[12\]
+ _1037_ CALC_INST.input_ctrl_inst.scan_timer\[14\] vssd1 vssd1 vccd1 vccd1 _1041_
+ sky130_fd_sc_hd__a31o_1
Xhold57 CALC_INST.gencon_inst.ALU_in2\[2\] vssd1 vssd1 vccd1 vccd1 net253 sky130_fd_sc_hd__dlygate4sd3_1
Xhold46 CALC_INST.gencon_inst.ALU_in2\[5\] vssd1 vssd1 vccd1 vccd1 net242 sky130_fd_sc_hd__dlygate4sd3_1
Xhold68 CALC_INST.gencon_inst.ALU_in1\[10\] vssd1 vssd1 vccd1 vccd1 net264 sky130_fd_sc_hd__dlygate4sd3_1
Xhold13 CALC_INST.gencon_inst.mult_calc.INn1\[6\] vssd1 vssd1 vccd1 vccd1 net209 sky130_fd_sc_hd__dlygate4sd3_1
Xhold79 CALC_INST.gencon_inst.mult_calc.INn1\[15\] vssd1 vssd1 vccd1 vccd1 net275
+ sky130_fd_sc_hd__dlygate4sd3_1
XFILLER_28_111 vssd1 vssd1 vccd1 vccd1 sky130_fd_sc_hd__fill_1
Xhold35 CALC_INST.gencon_inst.mult_calc.main.GENERATE_ADDER\[3\].thingy.in1 vssd1
+ vssd1 vccd1 vccd1 net231 sky130_fd_sc_hd__dlygate4sd3_1
Xhold24 CALC_INST.gencon_inst.mult_calc.main.GENERATE_ADDER\[7\].thingy.in1 vssd1
+ vssd1 vccd1 vccd1 net220 sky130_fd_sc_hd__dlygate4sd3_1
XANTENNA_fanout41_A _0524_ vssd1 vssd1 vccd1 vccd1 sky130_fd_sc_hd__diode_2
XFILLER_28_199 vssd1 vssd1 vccd1 vccd1 sky130_fd_sc_hd__fill_1
XTAP_TAPCELL_ROW_26_323 vssd1 vccd1 sky130_fd_sc_hd__tapvpwrvgnd_1
XFILLER_16_306 vssd1 vssd1 vccd1 vccd1 sky130_fd_sc_hd__fill_2
XFILLER_61_55 vssd1 vssd1 vccd1 vccd1 sky130_fd_sc_hd__fill_1
XANTENNA__2751__Q CALC_INST.gencon_inst.mult_calc.state\[3\] vssd1 vssd1 vccd1 vccd1
+ sky130_fd_sc_hd__diode_2
XFILLER_10_70 vssd1 vssd1 vccd1 vccd1 sky130_fd_sc_hd__fill_8
X_1901_ _0945_ _0999_ CALC_INST.input_ctrl_inst.col_index\[31\] vssd1 vssd1 vccd1
+ vccd1 _1002_ sky130_fd_sc_hd__o21ba_1
X_1832_ net415 _0953_ _0956_ vssd1 vssd1 vccd1 vccd1 _0309_ sky130_fd_sc_hd__o21ba_1
X_2881_ clknet_leaf_1_clk net204 vssd1 vssd1 vccd1 vccd1 CALC_INST.input_ctrl_inst.scan_timer\[19\]
+ sky130_fd_sc_hd__dfxtp_1
X_1763_ net99 _1101_ net84 net309 vssd1 vssd1 vccd1 vccd1 _0273_ sky130_fd_sc_hd__a22o_1
X_1694_ net433 net87 _0921_ net100 vssd1 vssd1 vccd1 vccd1 _0206_ sky130_fd_sc_hd__a22o_1
X_2246_ CALC_INST.gencon_inst.mult_calc.finish net384 _0389_ vssd1 vssd1 vccd1 vccd1
+ CALC_INST.gencon_inst.next_state\[3\] sky130_fd_sc_hd__o21ba_1
X_2315_ CALC_INST.gencon_inst.operand2\[1\] _0466_ net35 vssd1 vssd1 vccd1 vccd1 _0033_
+ sky130_fd_sc_hd__mux2_1
XPHY_EDGE_ROW_27_Left_92 vssd1 vssd1 vccd1 vccd1 sky130_fd_sc_hd__decap_3
X_2177_ CALC_INST.input_ctrl_inst.debounce_cnt\[12\] _1077_ _1197_ vssd1 vssd1 vccd1
+ vccd1 _1209_ sky130_fd_sc_hd__o21ai_1
XFILLER_40_106 vssd1 vssd1 vccd1 vccd1 sky130_fd_sc_hd__fill_1
XTAP_TAPCELL_ROW_23_304 vssd1 vccd1 sky130_fd_sc_hd__tapvpwrvgnd_1
XPHY_EDGE_ROW_11_Left_76 vssd1 vssd1 vccd1 vccd1 sky130_fd_sc_hd__decap_3
XFILLER_15_26 vccd1 vssd1 vccd1 vssd1 sky130_ef_sc_hd__decap_40_12
XFILLER_31_47 vssd1 vssd1 vccd1 vccd1 sky130_fd_sc_hd__fill_8
Xoutput14 net14 vssd1 vssd1 vccd1 vccd1 gpio_out[18] sky130_fd_sc_hd__buf_2
Xteam_06_159 vssd1 vssd1 vccd1 vccd1 team_06_159/HI gpio_oeb[30] sky130_fd_sc_hd__conb_1
Xoutput25 net25 vssd1 vssd1 vccd1 vccd1 gpio_out[4] sky130_fd_sc_hd__buf_2
XFILLER_56_250 vssd1 vssd1 vccd1 vccd1 sky130_fd_sc_hd__fill_2
XFILLER_48_217 vssd1 vssd1 vccd1 vccd1 sky130_fd_sc_hd__fill_2
XFILLER_44_401 vssd1 vssd1 vccd1 vccd1 sky130_fd_sc_hd__fill_2
XANTENNA__1353__S net73 vssd1 vssd1 vccd1 vccd1 sky130_fd_sc_hd__diode_2
X_2100_ CALC_INST.input_ctrl_inst.decoded_key\[0\] CALC_INST.input_ctrl_inst.decoded_key\[2\]
+ vssd1 vssd1 vccd1 vccd1 _1149_ sky130_fd_sc_hd__and2b_1
XFILLER_47_283 vssd1 vssd1 vccd1 vccd1 sky130_fd_sc_hd__fill_1
X_2031_ CALC_INST.input_ctrl_inst.input_control_state\[1\] CALC_INST.input_ctrl_inst.input_control_state\[0\]
+ vssd1 vssd1 vccd1 vccd1 _1086_ sky130_fd_sc_hd__nor2_1
X_2864_ clknet_leaf_3_clk _0359_ vssd1 vssd1 vccd1 vccd1 CALC_INST.input_ctrl_inst.scan_timer\[2\]
+ sky130_fd_sc_hd__dfxtp_1
X_1815_ net28 net47 vssd1 vssd1 vccd1 vccd1 _0945_ sky130_fd_sc_hd__nand2_1
X_2795_ clknet_leaf_32_clk _0320_ net117 vssd1 vssd1 vccd1 vccd1 CALC_INST.input_ctrl_inst.col_index\[18\]
+ sky130_fd_sc_hd__dfrtp_2
X_1746_ CALC_INST.gencon_inst.mult_calc.out\[4\] net460 net101 vssd1 vssd1 vccd1 vccd1
+ _0257_ sky130_fd_sc_hd__mux2_1
X_1677_ _0906_ _0907_ vssd1 vssd1 vccd1 vccd1 _0908_ sky130_fd_sc_hd__xor2_1
X_2229_ CALC_INST.gencon_inst.gencon_state\[0\] CALC_INST.gencon_inst.gencon_state\[1\]
+ CALC_INST.gencon_inst.gencon_state\[2\] vssd1 vssd1 vccd1 vccd1 _0395_ sky130_fd_sc_hd__or3_1
XFILLER_53_220 vssd1 vssd1 vccd1 vccd1 sky130_fd_sc_hd__fill_1
XTAP_TAPCELL_ROW_51_498 vssd1 vccd1 sky130_fd_sc_hd__tapvpwrvgnd_1
XFILLER_21_161 vssd1 vssd1 vccd1 vccd1 sky130_fd_sc_hd__fill_2
XANTENNA__1856__B net63 vssd1 vssd1 vccd1 vccd1 sky130_fd_sc_hd__diode_2
XANTENNA__1771__B1 net86 vssd1 vssd1 vccd1 vccd1 sky130_fd_sc_hd__diode_2
XTAP_TAPCELL_ROW_8_198 vssd1 vccd1 sky130_fd_sc_hd__tapvpwrvgnd_1
XTAP_TAPCELL_ROW_59_554 vssd1 vccd1 sky130_fd_sc_hd__tapvpwrvgnd_1
XTAP_TAPCELL_ROW_42_432 vssd1 vccd1 sky130_fd_sc_hd__tapvpwrvgnd_1
XFILLER_8_132 vssd1 vssd1 vccd1 vccd1 sky130_fd_sc_hd__fill_8
XFILLER_16_80 vssd1 vssd1 vccd1 vccd1 sky130_fd_sc_hd__fill_1
X_1462_ CALC_INST.gencon_inst.add_calc.main.GENERATE_ADDER\[7\].thingy.in1 _0718_
+ _0719_ vssd1 vssd1 vccd1 vccd1 _0721_ sky130_fd_sc_hd__nand3_1
X_1531_ _0767_ _0783_ _0785_ net81 vssd1 vssd1 vccd1 vccd1 _0787_ sky130_fd_sc_hd__a31o_1
X_1600_ net107 net103 _0842_ vssd1 vssd1 vccd1 vccd1 _0191_ sky130_fd_sc_hd__o21a_1
X_2580_ clknet_leaf_18_clk _0118_ vssd1 vssd1 vccd1 vccd1 CALC_INST.gencon_inst.ALU_in2\[12\]
+ sky130_fd_sc_hd__dfxtp_1
XANTENNA__1762__B1 net84 vssd1 vssd1 vccd1 vccd1 sky130_fd_sc_hd__diode_2
XFILLER_8_176 vssd1 vssd1 vccd1 vccd1 sky130_fd_sc_hd__fill_4
X_1393_ net450 _0671_ net110 vssd1 vssd1 vccd1 vccd1 _0155_ sky130_fd_sc_hd__mux2_1
X_2014_ CALC_INST.input_ctrl_inst.debounce_cnt\[9\] CALC_INST.input_ctrl_inst.debounce_cnt\[11\]
+ CALC_INST.input_ctrl_inst.debounce_cnt\[10\] CALC_INST.input_ctrl_inst.debounce_cnt\[12\]
+ vssd1 vssd1 vccd1 vccd1 _1070_ sky130_fd_sc_hd__or4_1
XFILLER_35_264 vssd1 vssd1 vccd1 vccd1 sky130_fd_sc_hd__fill_2
X_2847_ clknet_leaf_8_clk _0025_ net126 vssd1 vssd1 vccd1 vccd1 CALC_INST.input_ctrl_inst.debounce_cnt\[8\]
+ sky130_fd_sc_hd__dfrtp_1
XANTENNA_clkbuf_2_1__f_clk_A clknet_0_clk vssd1 vssd1 vccd1 vccd1 sky130_fd_sc_hd__diode_2
Xhold110 CALC_INST.gencon_inst.mult_calc.INn1\[12\] vssd1 vssd1 vccd1 vccd1 net306
+ sky130_fd_sc_hd__dlygate4sd3_1
XANTENNA_fanout139_A net153 vssd1 vssd1 vccd1 vccd1 sky130_fd_sc_hd__diode_2
X_2778_ clknet_leaf_0_clk _0303_ net113 vssd1 vssd1 vccd1 vccd1 CALC_INST.input_ctrl_inst.col_index\[1\]
+ sky130_fd_sc_hd__dfrtp_4
Xhold176 CALC_INST.gencon_inst.add_calc.main.in2\[10\] vssd1 vssd1 vccd1 vccd1 net372
+ sky130_fd_sc_hd__dlygate4sd3_1
Xhold187 CALC_INST.gencon_inst.add_calc.main.GENERATE_ADDER\[4\].thingy.in1 vssd1
+ vssd1 vccd1 vccd1 net383 sky130_fd_sc_hd__dlygate4sd3_1
Xhold121 CALC_INST.complete vssd1 vssd1 vccd1 vccd1 net317 sky130_fd_sc_hd__dlygate4sd3_1
Xhold198 net12 vssd1 vssd1 vccd1 vccd1 net394 sky130_fd_sc_hd__dlygate4sd3_1
Xhold154 CALC_INST.gencon_inst.ALU_in1\[7\] vssd1 vssd1 vccd1 vccd1 net350 sky130_fd_sc_hd__dlygate4sd3_1
Xhold132 CALC_INST.gencon_inst.ALU_in1\[9\] vssd1 vssd1 vccd1 vccd1 net328 sky130_fd_sc_hd__dlygate4sd3_1
Xhold165 CALC_INST.gencon_inst.mult_calc.adderSave\[9\] vssd1 vssd1 vccd1 vccd1 net361
+ sky130_fd_sc_hd__dlygate4sd3_1
XANTENNA_clkbuf_leaf_1_clk_A clknet_2_0__leaf_clk vssd1 vssd1 vccd1 vccd1 sky130_fd_sc_hd__diode_2
Xhold143 CALC_INST.gencon_inst.mult_calc.adderSave\[1\] vssd1 vssd1 vccd1 vccd1 net339
+ sky130_fd_sc_hd__dlygate4sd3_1
X_1729_ net92 CALC_INST.gencon_inst.mult_calc.adderSave\[2\] net75 net395 vssd1 vssd1
+ vccd1 vccd1 _0240_ sky130_fd_sc_hd__a22o_1
XTAP_TAPCELL_ROW_56_535 vssd1 vccd1 sky130_fd_sc_hd__tapvpwrvgnd_1
XANTENNA__1269__C1 _0590_ vssd1 vssd1 vccd1 vccd1 sky130_fd_sc_hd__diode_2
XFILLER_26_253 vssd1 vssd1 vccd1 vccd1 sky130_fd_sc_hd__fill_4
XTAP_TAPCELL_ROW_64_590 vssd1 vccd1 sky130_fd_sc_hd__tapvpwrvgnd_1
XANTENNA__2233__A1 _0392_ vssd1 vssd1 vccd1 vccd1 sky130_fd_sc_hd__diode_2
XFILLER_41_223 vssd1 vssd1 vccd1 vccd1 sky130_fd_sc_hd__fill_1
XFILLER_5_113 vccd1 vssd1 vccd1 vssd1 sky130_ef_sc_hd__decap_40_12
XFILLER_49_334 vssd1 vssd1 vccd1 vccd1 sky130_fd_sc_hd__fill_2
XFILLER_64_337 vccd1 vssd1 vccd1 vssd1 sky130_ef_sc_hd__decap_40_12
XANTENNA__2209__Y _1234_ vssd1 vssd1 vccd1 vccd1 sky130_fd_sc_hd__diode_2
XFILLER_17_286 vssd1 vssd1 vccd1 vccd1 sky130_fd_sc_hd__fill_2
X_2632_ clknet_leaf_17_clk _0170_ net152 vssd1 vssd1 vccd1 vccd1 CALC_INST.gencon_inst.add_calc.main.in2\[11\]
+ sky130_fd_sc_hd__dfrtp_1
XFILLER_32_289 vssd1 vssd1 vccd1 vccd1 sky130_fd_sc_hd__fill_1
X_2701_ clknet_leaf_31_clk _0239_ net121 vssd1 vssd1 vccd1 vccd1 CALC_INST.gencon_inst.mult_calc.main.GENERATE_ADDER\[1\].thingy.in2
+ sky130_fd_sc_hd__dfrtp_1
X_1514_ net81 _0771_ _0772_ _0770_ vssd1 vssd1 vccd1 vccd1 _0175_ sky130_fd_sc_hd__o31a_1
X_1445_ _0702_ _0703_ CALC_INST.gencon_inst.add_calc.main.GENERATE_ADDER\[11\].thingy.in1
+ vssd1 vssd1 vccd1 vccd1 _0704_ sky130_fd_sc_hd__a21oi_2
X_2563_ clknet_leaf_18_clk _0101_ vssd1 vssd1 vccd1 vccd1 CALC_INST.gencon_inst.ALU_in1\[11\]
+ sky130_fd_sc_hd__dfxtp_1
X_2494_ clknet_leaf_12_clk _0036_ net145 vssd1 vssd1 vccd1 vccd1 CALC_INST.gencon_inst.operand2\[4\]
+ sky130_fd_sc_hd__dfrtp_2
XFILLER_55_337 vccd1 vssd1 vccd1 vssd1 sky130_ef_sc_hd__decap_40_12
X_1376_ CALC_INST.gencon_inst.ALU_in2\[3\] CALC_INST.gencon_inst.ALU_in1\[3\] net64
+ vssd1 vssd1 vccd1 vccd1 _0663_ sky130_fd_sc_hd__mux2_1
XANTENNA__1266__A2 _0392_ vssd1 vssd1 vccd1 vccd1 sky130_fd_sc_hd__diode_2
XFILLER_23_223 vssd1 vssd1 vccd1 vccd1 sky130_fd_sc_hd__fill_1
XANTENNA__1767__A1_N net82 vssd1 vssd1 vccd1 vccd1 sky130_fd_sc_hd__diode_2
XFILLER_58_120 vccd1 vssd1 vccd1 vssd1 sky130_ef_sc_hd__decap_40_12
XFILLER_64_55 vssd1 vssd1 vccd1 vccd1 sky130_fd_sc_hd__fill_1
XANTENNA__1257__A2 net71 vssd1 vssd1 vccd1 vccd1 sky130_fd_sc_hd__diode_2
Xfanout71 _0521_ vssd1 vssd1 vccd1 vccd1 net71 sky130_fd_sc_hd__clkbuf_2
Xfanout93 net94 vssd1 vssd1 vccd1 vccd1 net93 sky130_fd_sc_hd__clkbuf_4
XFILLER_9_39 vssd1 vssd1 vccd1 vccd1 sky130_fd_sc_hd__fill_2
XFILLER_13_70 vssd1 vssd1 vccd1 vccd1 sky130_fd_sc_hd__fill_4
XFILLER_13_81 vssd1 vssd1 vccd1 vccd1 sky130_fd_sc_hd__fill_8
Xfanout82 _1055_ vssd1 vssd1 vccd1 vccd1 net82 sky130_fd_sc_hd__buf_2
XANTENNA__2390__B1 net58 vssd1 vssd1 vccd1 vccd1 sky130_fd_sc_hd__diode_2
XFILLER_52_307 vssd1 vssd1 vccd1 vccd1 sky130_fd_sc_hd__fill_1
XFILLER_37_326 vssd1 vssd1 vccd1 vccd1 sky130_fd_sc_hd__fill_1
XFILLER_64_189 vssd1 vssd1 vccd1 vccd1 sky130_fd_sc_hd__fill_2
X_1994_ CALC_INST.gencon_inst.operator_input\[0\] vssd1 vssd1 vccd1 vccd1 _1050_ sky130_fd_sc_hd__inv_2
X_2615_ clknet_leaf_17_clk _0153_ net151 vssd1 vssd1 vccd1 vccd1 CALC_INST.gencon_inst.add_calc.main.GENERATE_ADDER\[9\].thingy.in1
+ sky130_fd_sc_hd__dfrtp_1
Xclkload30 clknet_leaf_19_clk vssd1 vssd1 vccd1 vccd1 clkload30/Y sky130_fd_sc_hd__clkinv_4
X_1428_ CALC_INST.gencon_inst.ALU_in1\[14\] CALC_INST.gencon_inst.ALU_in2\[14\] net65
+ vssd1 vssd1 vccd1 vccd1 _0689_ sky130_fd_sc_hd__mux2_1
X_2477_ CALC_INST.gencon_inst.ALU_out\[1\] net68 net54 CALC_INST.gencon_inst.mult_calc.out\[1\]
+ vssd1 vssd1 vccd1 vccd1 _0598_ sky130_fd_sc_hd__a22o_1
X_2546_ clknet_leaf_5_clk _0084_ net128 vssd1 vssd1 vccd1 vccd1 CALC_INST.gencon_inst.latched_keypad_input\[2\]
+ sky130_fd_sc_hd__dfrtp_1
XFILLER_28_304 vssd1 vssd1 vccd1 vccd1 sky130_fd_sc_hd__fill_2
XFILLER_18_26 vssd1 vssd1 vccd1 vccd1 sky130_fd_sc_hd__fill_2
X_1359_ _0653_ net306 net39 vssd1 vssd1 vccd1 vccd1 _0139_ sky130_fd_sc_hd__mux2_1
XFILLER_50_46 vssd1 vssd1 vccd1 vccd1 sky130_fd_sc_hd__fill_8
XTAP_TAPCELL_ROW_21_287 vssd1 vccd1 sky130_fd_sc_hd__tapvpwrvgnd_1
Xclkload2 clknet_leaf_1_clk vssd1 vssd1 vccd1 vccd1 clkload2/Y sky130_fd_sc_hd__inv_6
XFILLER_46_134 vssd1 vssd1 vccd1 vccd1 sky130_fd_sc_hd__fill_4
XTAP_TAPCELL_ROW_29_343 vssd1 vccd1 sky130_fd_sc_hd__tapvpwrvgnd_1
XFILLER_19_359 vssd1 vssd1 vccd1 vccd1 sky130_fd_sc_hd__fill_1
XFILLER_42_362 vssd1 vssd1 vccd1 vccd1 sky130_fd_sc_hd__fill_2
X_2400_ _0535_ vssd1 vssd1 vccd1 vccd1 _0536_ sky130_fd_sc_hd__inv_2
XTAP_TAPCELL_ROW_12_221 vssd1 vccd1 sky130_fd_sc_hd__tapvpwrvgnd_1
X_2331_ CALC_INST.gencon_inst.operand2\[3\] _0480_ net35 vssd1 vssd1 vccd1 vccd1 _0035_
+ sky130_fd_sc_hd__mux2_1
XFILLER_27_3 vssd1 vssd1 vccd1 vccd1 sky130_fd_sc_hd__fill_4
X_2262_ _0415_ _0423_ vssd1 vssd1 vccd1 vccd1 _0424_ sky130_fd_sc_hd__nand2_1
X_2193_ net36 _1218_ CALC_INST.input_ctrl_inst.debounce_cnt\[15\] vssd1 vssd1 vccd1
+ vccd1 _1222_ sky130_fd_sc_hd__a21o_1
X_1977_ net388 _1039_ vssd1 vssd1 vccd1 vccd1 _0370_ sky130_fd_sc_hd__xor2_1
XANTENNA_fanout121_A net123 vssd1 vssd1 vccd1 vccd1 sky130_fd_sc_hd__diode_2
X_2529_ clknet_leaf_13_clk _0067_ net148 vssd1 vssd1 vccd1 vccd1 net8 sky130_fd_sc_hd__dfrtp_1
Xhold47 CALC_INST.gencon_inst.ALU_in2\[9\] vssd1 vssd1 vccd1 vccd1 net243 sky130_fd_sc_hd__dlygate4sd3_1
Xhold58 CALC_INST.gencon_inst.ALU_in2\[11\] vssd1 vssd1 vccd1 vccd1 net254 sky130_fd_sc_hd__dlygate4sd3_1
Xhold69 CALC_INST.gencon_inst.ALU_in1\[13\] vssd1 vssd1 vccd1 vccd1 net265 sky130_fd_sc_hd__dlygate4sd3_1
Xhold14 CALC_INST.gencon_inst.mult_calc.main.GENERATE_ADDER\[4\].thingy.in1 vssd1
+ vssd1 vccd1 vccd1 net210 sky130_fd_sc_hd__dlygate4sd3_1
Xhold25 CALC_INST.gencon_inst.mult_calc.INn1\[0\] vssd1 vssd1 vccd1 vccd1 net221 sky130_fd_sc_hd__dlygate4sd3_1
Xhold36 CALC_INST.input_ctrl_inst.col_index\[31\] vssd1 vssd1 vccd1 vccd1 net232 sky130_fd_sc_hd__dlygate4sd3_1
XANTENNA_fanout34_A net35 vssd1 vssd1 vccd1 vccd1 sky130_fd_sc_hd__diode_2
XTAP_TAPCELL_ROW_26_324 vssd1 vccd1 sky130_fd_sc_hd__tapvpwrvgnd_1
XANTENNA__1859__B net63 vssd1 vssd1 vccd1 vccd1 sky130_fd_sc_hd__diode_2
XFILLER_3_299 vssd1 vssd1 vccd1 vccd1 sky130_fd_sc_hd__fill_1
XFILLER_3_266 vssd1 vssd1 vccd1 vccd1 sky130_fd_sc_hd__fill_1
XFILLER_10_82 vssd1 vssd1 vccd1 vccd1 sky130_fd_sc_hd__fill_2
XFILLER_34_115 vssd1 vssd1 vccd1 vccd1 sky130_fd_sc_hd__fill_1
X_1900_ net452 net62 _1001_ vssd1 vssd1 vccd1 vccd1 _0332_ sky130_fd_sc_hd__a21o_1
X_1831_ _0936_ net60 vssd1 vssd1 vccd1 vccd1 _0956_ sky130_fd_sc_hd__and2_1
X_2880_ clknet_leaf_0_clk _0375_ vssd1 vssd1 vccd1 vccd1 CALC_INST.input_ctrl_inst.scan_timer\[18\]
+ sky130_fd_sc_hd__dfxtp_1
X_1762_ net82 _1103_ net84 net296 vssd1 vssd1 vccd1 vccd1 _0272_ sky130_fd_sc_hd__a2bb2o_1
X_1693_ _0919_ _0920_ vssd1 vssd1 vccd1 vccd1 _0921_ sky130_fd_sc_hd__xnor2_1
X_2176_ CALC_INST.input_ctrl_inst.debounce_cnt\[12\] _1204_ vssd1 vssd1 vccd1 vccd1
+ _1208_ sky130_fd_sc_hd__and2_1
X_2245_ _0379_ _0403_ _0408_ vssd1 vssd1 vccd1 vccd1 CALC_INST.gencon_inst.next_state\[2\]
+ sky130_fd_sc_hd__or3_1
X_2314_ _0404_ _0463_ _0465_ net44 CALC_INST.gencon_inst.mult_calc.out\[1\] vssd1
+ vssd1 vccd1 vccd1 _0466_ sky130_fd_sc_hd__a32o_1
XFILLER_40_129 vssd1 vssd1 vccd1 vccd1 sky130_fd_sc_hd__fill_4
XFILLER_15_38 vssd1 vssd1 vccd1 vccd1 sky130_fd_sc_hd__fill_8
XANTENNA__2303__B _0404_ vssd1 vssd1 vccd1 vccd1 sky130_fd_sc_hd__diode_2
XTAP_TAPCELL_ROW_31_360 vssd1 vccd1 sky130_fd_sc_hd__tapvpwrvgnd_1
XFILLER_21_332 vssd1 vssd1 vccd1 vccd1 sky130_fd_sc_hd__fill_4
Xoutput15 net15 vssd1 vssd1 vccd1 vccd1 gpio_out[19] sky130_fd_sc_hd__buf_2
XPHY_EDGE_ROW_1_Right_1 vssd1 vssd1 vccd1 vccd1 sky130_fd_sc_hd__decap_3
XFILLER_0_225 vssd1 vssd1 vccd1 vccd1 sky130_fd_sc_hd__fill_1
Xoutput26 net26 vssd1 vssd1 vccd1 vccd1 gpio_out[5] sky130_fd_sc_hd__buf_2
X_2030_ CALC_INST.gencon_inst.key_read _1084_ _1082_ vssd1 vssd1 vccd1 vccd1 _1085_
+ sky130_fd_sc_hd__o21ai_1
XFILLER_50_405 vssd1 vssd1 vccd1 vccd1 sky130_fd_sc_hd__fill_2
XTAP_TAPCELL_ROW_45_452 vssd1 vccd1 sky130_fd_sc_hd__tapvpwrvgnd_1
X_2863_ clknet_leaf_2_clk _0358_ vssd1 vssd1 vccd1 vccd1 CALC_INST.input_ctrl_inst.scan_timer\[1\]
+ sky130_fd_sc_hd__dfxtp_1
X_1745_ CALC_INST.gencon_inst.mult_calc.out\[3\] net441 net101 vssd1 vssd1 vccd1 vccd1
+ _0256_ sky130_fd_sc_hd__mux2_1
X_2794_ clknet_leaf_32_clk _0319_ net117 vssd1 vssd1 vccd1 vccd1 CALC_INST.input_ctrl_inst.col_index\[17\]
+ sky130_fd_sc_hd__dfrtp_1
X_1814_ CALC_INST.input_ctrl_inst.col_index\[1\] _0944_ vssd1 vssd1 vccd1 vccd1 _0303_
+ sky130_fd_sc_hd__xor2_1
X_1676_ _0898_ _0902_ _0899_ vssd1 vssd1 vccd1 vccd1 _0907_ sky130_fd_sc_hd__o21a_1
X_2159_ CALC_INST.input_ctrl_inst.debounce_cnt\[7\] CALC_INST.input_ctrl_inst.debounce_cnt\[8\]
+ _1190_ vssd1 vssd1 vccd1 vccd1 _1195_ sky130_fd_sc_hd__and3_1
X_2228_ CALC_INST.gencon_inst.read_input CALC_INST.equal_input vssd1 vssd1 vccd1 vccd1
+ _0394_ sky130_fd_sc_hd__nor2_1
XFILLER_53_298 vssd1 vssd1 vccd1 vccd1 sky130_fd_sc_hd__fill_1
XFILLER_53_287 vssd1 vssd1 vccd1 vccd1 sky130_fd_sc_hd__fill_2
Xclkbuf_leaf_33_clk clknet_2_0__leaf_clk vssd1 vssd1 vccd1 vccd1 clknet_leaf_33_clk
+ sky130_fd_sc_hd__clkbuf_8
XTAP_TAPCELL_ROW_51_499 vssd1 vccd1 sky130_fd_sc_hd__tapvpwrvgnd_1
XTAP_TAPCELL_ROW_59_555 vssd1 vccd1 sky130_fd_sc_hd__tapvpwrvgnd_1
XTAP_TAPCELL_ROW_8_199 vssd1 vccd1 sky130_fd_sc_hd__tapvpwrvgnd_1
XFILLER_16_70 vssd1 vssd1 vccd1 vccd1 sky130_fd_sc_hd__fill_1
XTAP_TAPCELL_ROW_42_433 vssd1 vccd1 sky130_fd_sc_hd__tapvpwrvgnd_1
Xclkbuf_leaf_24_clk clknet_2_2__leaf_clk vssd1 vssd1 vccd1 vccd1 clknet_leaf_24_clk
+ sky130_fd_sc_hd__clkbuf_8
X_1461_ _0718_ _0719_ CALC_INST.gencon_inst.add_calc.main.GENERATE_ADDER\[7\].thingy.in1
+ vssd1 vssd1 vccd1 vccd1 _0720_ sky130_fd_sc_hd__a21oi_2
XFILLER_59_6 vccd1 vssd1 vccd1 vssd1 sky130_ef_sc_hd__decap_40_12
X_1530_ net31 _0783_ _0785_ vssd1 vssd1 vccd1 vccd1 _0786_ sky130_fd_sc_hd__a21oi_1
X_1392_ CALC_INST.gencon_inst.ALU_in2\[11\] CALC_INST.gencon_inst.ALU_in1\[11\] net67
+ vssd1 vssd1 vccd1 vccd1 _0671_ sky130_fd_sc_hd__mux2_1
X_2013_ CALC_INST.input_ctrl_inst.debounce_cnt\[5\] CALC_INST.input_ctrl_inst.debounce_cnt\[7\]
+ CALC_INST.input_ctrl_inst.debounce_cnt\[6\] CALC_INST.input_ctrl_inst.debounce_cnt\[8\]
+ vssd1 vssd1 vccd1 vccd1 _1069_ sky130_fd_sc_hd__o31a_1
XANTENNA__1278__B1 net56 vssd1 vssd1 vccd1 vccd1 sky130_fd_sc_hd__diode_2
Xclkbuf_leaf_15_clk clknet_2_3__leaf_clk vssd1 vssd1 vccd1 vccd1 clknet_leaf_15_clk
+ sky130_fd_sc_hd__clkbuf_8
XFILLER_50_235 vssd1 vssd1 vccd1 vccd1 sky130_fd_sc_hd__fill_2
XFILLER_35_276 vssd1 vssd1 vccd1 vccd1 sky130_fd_sc_hd__fill_4
XFILLER_23_405 vssd1 vssd1 vccd1 vccd1 sky130_fd_sc_hd__fill_2
X_2846_ clknet_leaf_8_clk _0024_ net126 vssd1 vssd1 vccd1 vccd1 CALC_INST.input_ctrl_inst.debounce_cnt\[7\]
+ sky130_fd_sc_hd__dfrtp_1
Xhold111 CALC_INST.gencon_inst.ALU_in1\[0\] vssd1 vssd1 vccd1 vccd1 net307 sky130_fd_sc_hd__dlygate4sd3_1
Xhold144 CALC_INST.gencon_inst.mult_calc.INn2\[11\] vssd1 vssd1 vccd1 vccd1 net340
+ sky130_fd_sc_hd__dlygate4sd3_1
Xhold133 CALC_INST.gencon_inst.mult_calc.INn2\[0\] vssd1 vssd1 vccd1 vccd1 net329
+ sky130_fd_sc_hd__dlygate4sd3_1
Xhold100 CALC_INST.gencon_inst.mult_calc.countSave\[1\] vssd1 vssd1 vccd1 vccd1 net296
+ sky130_fd_sc_hd__dlygate4sd3_1
X_2777_ clknet_leaf_0_clk _0302_ net113 vssd1 vssd1 vccd1 vccd1 CALC_INST.input_ctrl_inst.col_index\[0\]
+ sky130_fd_sc_hd__dfrtp_4
Xhold122 CALC_INST.gencon_inst.mult_calc.adderSave\[7\] vssd1 vssd1 vccd1 vccd1 net318
+ sky130_fd_sc_hd__dlygate4sd3_1
X_1728_ net92 net339 net75 net448 vssd1 vssd1 vccd1 vccd1 _0239_ sky130_fd_sc_hd__a22o_1
Xhold177 CALC_INST.gencon_inst.add_calc.main.GENERATE_ADDER\[13\].thingy.in1 vssd1
+ vssd1 vccd1 vccd1 net373 sky130_fd_sc_hd__dlygate4sd3_1
Xhold155 CALC_INST.gencon_inst.add_calc.main.in2\[14\] vssd1 vssd1 vccd1 vccd1 net351
+ sky130_fd_sc_hd__dlygate4sd3_1
Xhold188 CALC_INST.gencon_inst.ALU_finish vssd1 vssd1 vccd1 vccd1 net384 sky130_fd_sc_hd__dlygate4sd3_1
Xhold199 CALC_INST.gencon_inst.mult_calc.main.GENERATE_ADDER\[2\].thingy.in2 vssd1
+ vssd1 vccd1 vccd1 net395 sky130_fd_sc_hd__dlygate4sd3_1
X_1659_ net403 net87 _0892_ net100 vssd1 vssd1 vccd1 vccd1 _0200_ sky130_fd_sc_hd__a22o_1
Xhold166 CALC_INST.gencon_inst.mult_calc.main.GENERATE_ADDER\[3\].thingy.in2 vssd1
+ vssd1 vccd1 vccd1 net362 sky130_fd_sc_hd__dlygate4sd3_1
XANTENNA__2481__A2 net57 vssd1 vssd1 vccd1 vccd1 sky130_fd_sc_hd__diode_2
XTAP_TAPCELL_ROW_64_591 vssd1 vccd1 sky130_fd_sc_hd__tapvpwrvgnd_1
XFILLER_5_103 vssd1 vssd1 vccd1 vccd1 sky130_fd_sc_hd__fill_1
XFILLER_5_125 vssd1 vssd1 vccd1 vccd1 sky130_fd_sc_hd__fill_4
XFILLER_5_158 vssd1 vssd1 vccd1 vccd1 sky130_fd_sc_hd__fill_1
XFILLER_64_349 vccd1 vssd1 vccd1 vssd1 sky130_ef_sc_hd__decap_40_12
XFILLER_64_305 vssd1 vssd1 vccd1 vccd1 sky130_fd_sc_hd__fill_2
XANTENNA__2487__Q CALC_INST.gencon_inst.add_calc.state\[1\] vssd1 vssd1 vccd1 vccd1
+ sky130_fd_sc_hd__diode_2
XFILLER_32_257 vssd1 vssd1 vccd1 vccd1 sky130_fd_sc_hd__fill_1
XFILLER_32_246 vssd1 vssd1 vccd1 vccd1 sky130_fd_sc_hd__fill_1
XFILLER_32_202 vssd1 vssd1 vccd1 vccd1 sky130_fd_sc_hd__fill_1
XFILLER_17_298 vssd1 vssd1 vccd1 vccd1 sky130_fd_sc_hd__fill_1
X_2631_ clknet_leaf_17_clk _0169_ net152 vssd1 vssd1 vccd1 vccd1 CALC_INST.gencon_inst.add_calc.main.in2\[10\]
+ sky130_fd_sc_hd__dfrtp_1
X_2562_ clknet_leaf_18_clk _0100_ vssd1 vssd1 vccd1 vccd1 CALC_INST.gencon_inst.ALU_in1\[10\]
+ sky130_fd_sc_hd__dfxtp_1
X_2700_ clknet_leaf_31_clk _0238_ net119 vssd1 vssd1 vccd1 vccd1 CALC_INST.gencon_inst.mult_calc.main.a0.in2
+ sky130_fd_sc_hd__dfrtp_1
X_1375_ net377 _0662_ net107 vssd1 vssd1 vccd1 vccd1 _0146_ sky130_fd_sc_hd__mux2_1
X_1513_ _0690_ net31 _0769_ vssd1 vssd1 vccd1 vccd1 _0772_ sky130_fd_sc_hd__a21oi_1
X_1444_ net104 CALC_INST.gencon_inst.add_calc.main.in2\[11\] vssd1 vssd1 vccd1 vccd1
+ _0703_ sky130_fd_sc_hd__nand2_1
X_2493_ clknet_leaf_12_clk _0035_ net137 vssd1 vssd1 vccd1 vccd1 CALC_INST.gencon_inst.operand2\[3\]
+ sky130_fd_sc_hd__dfrtp_2
Xclkbuf_leaf_4_clk clknet_2_1__leaf_clk vssd1 vssd1 vccd1 vccd1 clknet_leaf_4_clk
+ sky130_fd_sc_hd__clkbuf_8
XFILLER_4_62 vssd1 vssd1 vccd1 vccd1 sky130_fd_sc_hd__fill_2
XFILLER_4_51 vssd1 vssd1 vccd1 vccd1 sky130_fd_sc_hd__fill_4
XFILLER_55_349 vssd1 vssd1 vccd1 vccd1 sky130_fd_sc_hd__fill_4
XFILLER_55_327 vssd1 vssd1 vccd1 vccd1 sky130_fd_sc_hd__fill_1
XFILLER_63_393 vccd1 vssd1 vccd1 vssd1 sky130_ef_sc_hd__decap_40_12
XANTENNA_fanout151_A net153 vssd1 vssd1 vccd1 vccd1 sky130_fd_sc_hd__diode_2
XFILLER_23_16 vssd1 vssd1 vccd1 vccd1 sky130_fd_sc_hd__fill_1
X_2829_ clknet_leaf_2_clk _0350_ vssd1 vssd1 vccd1 vccd1 CALC_INST.gencon_inst.keypad_input\[1\]
+ sky130_fd_sc_hd__dfxtp_1
XFILLER_64_12 vccd1 vssd1 vccd1 vssd1 sky130_ef_sc_hd__decap_40_12
XFILLER_58_176 vssd1 vssd1 vccd1 vccd1 sky130_fd_sc_hd__fill_1
XFILLER_58_165 vssd1 vssd1 vccd1 vccd1 sky130_fd_sc_hd__fill_2
XFILLER_58_154 vssd1 vssd1 vccd1 vccd1 sky130_fd_sc_hd__fill_2
XANTENNA_fanout64_A _0659_ vssd1 vssd1 vccd1 vccd1 sky130_fd_sc_hd__diode_2
XFILLER_48_24 vssd1 vssd1 vccd1 vccd1 sky130_fd_sc_hd__fill_4
XFILLER_64_34 vssd1 vssd1 vccd1 vccd1 sky130_fd_sc_hd__fill_4
XTAP_TAPCELL_ROW_1_150 vssd1 vccd1 sky130_fd_sc_hd__tapvpwrvgnd_1
XFILLER_14_213 vssd1 vssd1 vccd1 vccd1 sky130_fd_sc_hd__fill_1
Xfanout50 _0646_ vssd1 vssd1 vccd1 vccd1 net50 sky130_fd_sc_hd__clkbuf_4
Xfanout72 net73 vssd1 vssd1 vccd1 vccd1 net72 sky130_fd_sc_hd__clkbuf_4
Xfanout83 _1055_ vssd1 vssd1 vccd1 vccd1 net83 sky130_fd_sc_hd__buf_1
XFILLER_6_401 vssd1 vssd1 vccd1 vccd1 sky130_fd_sc_hd__fill_2
Xfanout94 CALC_INST.gencon_inst.mult_calc.state\[4\] vssd1 vssd1 vccd1 vccd1 net94
+ sky130_fd_sc_hd__buf_2
XFILLER_64_146 vccd1 vssd1 vccd1 vssd1 sky130_ef_sc_hd__decap_40_12
XFILLER_64_113 vssd1 vssd1 vccd1 vccd1 sky130_fd_sc_hd__fill_8
XFILLER_64_102 vssd1 vssd1 vccd1 vccd1 sky130_fd_sc_hd__fill_8
XFILLER_60_374 vccd1 vssd1 vccd1 vssd1 sky130_ef_sc_hd__decap_40_12
XFILLER_60_363 vssd1 vssd1 vccd1 vccd1 sky130_fd_sc_hd__fill_1
XFILLER_60_330 vssd1 vssd1 vccd1 vccd1 sky130_fd_sc_hd__fill_2
X_1993_ net430 net112 _0651_ vssd1 vssd1 vccd1 vccd1 _0377_ sky130_fd_sc_hd__a21o_1
XANTENNA_clkbuf_leaf_0_clk_A clknet_2_0__leaf_clk vssd1 vssd1 vccd1 vccd1 sky130_fd_sc_hd__diode_2
XFILLER_20_227 vssd1 vssd1 vccd1 vccd1 sky130_fd_sc_hd__fill_2
X_2614_ clknet_leaf_16_clk _0152_ net151 vssd1 vssd1 vccd1 vccd1 CALC_INST.gencon_inst.add_calc.main.GENERATE_ADDER\[8\].thingy.in1
+ sky130_fd_sc_hd__dfrtp_1
Xclkload31 clknet_leaf_20_clk vssd1 vssd1 vccd1 vccd1 clkload31/Y sky130_fd_sc_hd__inv_8
X_2545_ clknet_leaf_3_clk _0083_ net116 vssd1 vssd1 vccd1 vccd1 CALC_INST.gencon_inst.latched_keypad_input\[1\]
+ sky130_fd_sc_hd__dfrtp_1
Xclkload20 clknet_leaf_26_clk vssd1 vssd1 vccd1 vccd1 clkload20/X sky130_fd_sc_hd__clkbuf_4
XFILLER_55_113 vssd1 vssd1 vccd1 vccd1 sky130_fd_sc_hd__fill_1
X_1427_ net341 _0688_ net109 vssd1 vssd1 vccd1 vccd1 _0172_ sky130_fd_sc_hd__mux2_1
X_2476_ CALC_INST.gencon_inst.operand2\[1\] CALC_INST.gencon_inst.operand1\[1\] net73
+ vssd1 vssd1 vccd1 vccd1 _0597_ sky130_fd_sc_hd__mux2_1
X_1358_ CALC_INST.gencon_inst.operand2\[12\] CALC_INST.gencon_inst.operand1\[12\]
+ net73 vssd1 vssd1 vccd1 vccd1 _0653_ sky130_fd_sc_hd__mux2_1
X_1289_ CALC_INST.gencon_inst.read_input net56 vssd1 vssd1 vccd1 vccd1 _0642_ sky130_fd_sc_hd__nand2_2
XFILLER_50_36 vssd1 vssd1 vccd1 vccd1 sky130_fd_sc_hd__fill_4
Xclkload3 clknet_leaf_2_clk vssd1 vssd1 vccd1 vccd1 clkload3/Y sky130_fd_sc_hd__bufinv_16
XTAP_TAPCELL_ROW_21_288 vssd1 vccd1 sky130_fd_sc_hd__tapvpwrvgnd_1
XFILLER_7_209 vssd1 vssd1 vccd1 vccd1 sky130_fd_sc_hd__fill_4
XFILLER_59_67 vssd1 vssd1 vccd1 vccd1 sky130_fd_sc_hd__fill_2
XFILLER_46_124 vssd1 vssd1 vccd1 vccd1 sky130_fd_sc_hd__fill_1
XTAP_TAPCELL_ROW_29_344 vssd1 vccd1 sky130_fd_sc_hd__tapvpwrvgnd_1
XFILLER_27_360 vssd1 vssd1 vccd1 vccd1 sky130_fd_sc_hd__fill_2
XANTENNA_clkbuf_2_3__f_clk_X clknet_2_3__leaf_clk vssd1 vssd1 vccd1 vccd1 sky130_fd_sc_hd__diode_2
XTAP_TAPCELL_ROW_12_222 vssd1 vccd1 sky130_fd_sc_hd__tapvpwrvgnd_1
XFILLER_6_253 vssd1 vssd1 vccd1 vccd1 sky130_fd_sc_hd__fill_4
X_2192_ CALC_INST.input_ctrl_inst.debounce_cnt\[15\] _1218_ _1211_ vssd1 vssd1 vccd1
+ vccd1 _1221_ sky130_fd_sc_hd__a21oi_1
X_2330_ CALC_INST.gencon_inst.mult_calc.out\[3\] net44 _0478_ _0479_ vssd1 vssd1 vccd1
+ vccd1 _0480_ sky130_fd_sc_hd__a22o_1
XANTENNA__1766__A1_N net82 vssd1 vssd1 vccd1 vccd1 sky130_fd_sc_hd__diode_2
X_2261_ CALC_INST.input_ctrl_inst.col_index\[1\] CALC_INST.input_ctrl_inst.col_index\[0\]
+ net90 net89 vssd1 vssd1 vccd1 vccd1 _0423_ sky130_fd_sc_hd__o31ai_4
XANTENNA__2418__A2 net71 vssd1 vssd1 vccd1 vccd1 sky130_fd_sc_hd__diode_2
XFILLER_18_371 vssd1 vssd1 vccd1 vccd1 sky130_fd_sc_hd__fill_4
X_1976_ _1039_ _1040_ vssd1 vssd1 vccd1 vccd1 _0369_ sky130_fd_sc_hd__nor2_1
X_2528_ clknet_leaf_12_clk _0066_ net145 vssd1 vssd1 vccd1 vccd1 net7 sky130_fd_sc_hd__dfrtp_1
XFILLER_29_26 vssd1 vssd1 vccd1 vccd1 sky130_fd_sc_hd__fill_1
XANTENNA_fanout114_A net123 vssd1 vssd1 vccd1 vccd1 sky130_fd_sc_hd__diode_2
Xhold48 CALC_INST.gencon_inst.ALU_in2\[3\] vssd1 vssd1 vccd1 vccd1 net244 sky130_fd_sc_hd__dlygate4sd3_1
Xhold59 CALC_INST.gencon_inst.ALU_in1\[14\] vssd1 vssd1 vccd1 vccd1 net255 sky130_fd_sc_hd__dlygate4sd3_1
X_2459_ CALC_INST.gencon_inst.operand1\[13\] _0579_ _0583_ vssd1 vssd1 vccd1 vccd1
+ _0584_ sky130_fd_sc_hd__o21a_1
Xhold15 CALC_INST.gencon_inst.mult_calc.INn1\[10\] vssd1 vssd1 vccd1 vccd1 net211
+ sky130_fd_sc_hd__dlygate4sd3_1
Xhold37 CALC_INST.gencon_inst.mult_calc.INn1\[14\] vssd1 vssd1 vccd1 vccd1 net233
+ sky130_fd_sc_hd__dlygate4sd3_1
Xhold26 CALC_INST.gencon_inst.mult_calc.main.GENERATE_ADDER\[9\].thingy.in1 vssd1
+ vssd1 vccd1 vccd1 net222 sky130_fd_sc_hd__dlygate4sd3_1
XFILLER_61_57 vssd1 vssd1 vccd1 vccd1 sky130_fd_sc_hd__fill_4
XTAP_TAPCELL_ROW_34_380 vssd1 vccd1 sky130_fd_sc_hd__tapvpwrvgnd_1
XTAP_TAPCELL_ROW_26_325 vssd1 vccd1 sky130_fd_sc_hd__tapvpwrvgnd_1
XFILLER_24_374 vssd1 vssd1 vccd1 vccd1 sky130_fd_sc_hd__fill_8
XFILLER_24_363 vssd1 vssd1 vccd1 vccd1 sky130_fd_sc_hd__fill_1
XFILLER_3_223 vssd1 vssd1 vccd1 vccd1 sky130_fd_sc_hd__fill_1
XFILLER_19_113 vssd1 vssd1 vccd1 vccd1 sky130_fd_sc_hd__fill_1
XFILLER_35_91 vssd1 vssd1 vccd1 vccd1 sky130_fd_sc_hd__fill_1
X_1761_ CALC_INST.gencon_inst.mult_calc.count.GENERATE_ADDER\[1\].thingy.cIn net82
+ net290 net84 vssd1 vssd1 vccd1 vccd1 _0271_ sky130_fd_sc_hd__a2bb2o_1
X_1830_ _0431_ _0455_ _0954_ vssd1 vssd1 vccd1 vccd1 _0955_ sky130_fd_sc_hd__nor3_1
X_2313_ _0464_ vssd1 vssd1 vccd1 vccd1 _0465_ sky130_fd_sc_hd__inv_2
X_1692_ _0914_ _0916_ _0915_ vssd1 vssd1 vccd1 vccd1 _0920_ sky130_fd_sc_hd__o21ba_1
XFILLER_57_219 vssd1 vssd1 vccd1 vccd1 sky130_fd_sc_hd__fill_4
X_2175_ net458 net46 _1207_ vssd1 vssd1 vccd1 vccd1 _0010_ sky130_fd_sc_hd__a21bo_1
X_2244_ net72 _0394_ vssd1 vssd1 vccd1 vccd1 _0408_ sky130_fd_sc_hd__nor2_1
X_1959_ net426 _1030_ vssd1 vssd1 vccd1 vccd1 _0362_ sky130_fd_sc_hd__xnor2_1
XFILLER_48_219 vssd1 vssd1 vccd1 vccd1 sky130_fd_sc_hd__fill_1
Xoutput16 net16 vssd1 vssd1 vccd1 vccd1 gpio_out[20] sky130_fd_sc_hd__buf_2
Xoutput27 net27 vssd1 vssd1 vccd1 vccd1 gpio_out[6] sky130_fd_sc_hd__buf_2
XFILLER_16_138 vssd1 vssd1 vccd1 vccd1 sky130_fd_sc_hd__fill_2
XFILLER_39_219 vssd1 vssd1 vccd1 vccd1 sky130_fd_sc_hd__fill_4
XTAP_TAPCELL_ROW_45_453 vssd1 vccd1 sky130_fd_sc_hd__tapvpwrvgnd_1
Xclkbuf_0_clk clk vssd1 vssd1 vccd1 vccd1 clknet_0_clk sky130_fd_sc_hd__clkbuf_16
XANTENNA__2404__B _0519_ vssd1 vssd1 vccd1 vccd1 sky130_fd_sc_hd__diode_2
X_2862_ clknet_leaf_2_clk _0357_ vssd1 vssd1 vccd1 vccd1 CALC_INST.input_ctrl_inst.scan_timer\[0\]
+ sky130_fd_sc_hd__dfxtp_1
X_1744_ CALC_INST.gencon_inst.mult_calc.out\[2\] net422 net101 vssd1 vssd1 vccd1 vccd1
+ _0255_ sky130_fd_sc_hd__mux2_1
X_2793_ clknet_leaf_33_clk _0318_ net114 vssd1 vssd1 vccd1 vccd1 CALC_INST.input_ctrl_inst.col_index\[16\]
+ sky130_fd_sc_hd__dfrtp_1
X_1813_ _0943_ _0944_ vssd1 vssd1 vccd1 vccd1 _0302_ sky130_fd_sc_hd__nor2_1
XANTENNA__1780__A2 net48 vssd1 vssd1 vccd1 vccd1 sky130_fd_sc_hd__diode_2
X_1675_ _0904_ _0905_ vssd1 vssd1 vccd1 vccd1 _0906_ sky130_fd_sc_hd__nand2b_1
XPHY_EDGE_ROW_15_Right_15 vssd1 vssd1 vccd1 vccd1 sky130_fd_sc_hd__decap_3
X_2158_ CALC_INST.input_ctrl_inst.debounce_cnt\[7\] _1190_ CALC_INST.input_ctrl_inst.debounce_cnt\[8\]
+ vssd1 vssd1 vccd1 vccd1 _1194_ sky130_fd_sc_hd__a21o_1
X_2227_ CALC_INST.gencon_inst.gencon_state\[2\] CALC_INST.gencon_inst.gencon_state\[3\]
+ _0388_ vssd1 vssd1 vccd1 vccd1 _0393_ sky130_fd_sc_hd__or3_2
XFILLER_38_263 vssd1 vssd1 vccd1 vccd1 sky130_fd_sc_hd__fill_2
XPHY_EDGE_ROW_24_Right_24 vssd1 vssd1 vccd1 vccd1 sky130_fd_sc_hd__decap_3
X_2089_ CALC_INST.gencon_inst.mult_calc.INn2\[2\] _1140_ _1142_ vssd1 vssd1 vccd1
+ vccd1 _1143_ sky130_fd_sc_hd__nor3_1
XFILLER_21_152 vssd1 vssd1 vccd1 vccd1 sky130_fd_sc_hd__fill_1
XPHY_EDGE_ROW_33_Right_33 vssd1 vssd1 vccd1 vccd1 sky130_fd_sc_hd__decap_3
XTAP_TAPCELL_ROW_59_556 vssd1 vccd1 sky130_fd_sc_hd__tapvpwrvgnd_1
XANTENNA__2476__S net73 vssd1 vssd1 vccd1 vccd1 sky130_fd_sc_hd__diode_2
XFILLER_44_244 vssd1 vssd1 vccd1 vccd1 sky130_fd_sc_hd__fill_1
XPHY_EDGE_ROW_42_Right_42 vssd1 vssd1 vccd1 vccd1 sky130_fd_sc_hd__decap_3
XANTENNA__2484__B1 net56 vssd1 vssd1 vccd1 vccd1 sky130_fd_sc_hd__diode_2
XTAP_TAPCELL_ROW_42_434 vssd1 vccd1 sky130_fd_sc_hd__tapvpwrvgnd_1
XFILLER_16_60 vssd1 vssd1 vccd1 vccd1 sky130_fd_sc_hd__fill_8
XPHY_EDGE_ROW_51_Right_51 vssd1 vssd1 vccd1 vccd1 sky130_fd_sc_hd__decap_3
XFILLER_32_81 vssd1 vssd1 vccd1 vccd1 sky130_fd_sc_hd__fill_2
X_1460_ net104 CALC_INST.gencon_inst.add_calc.main.in2\[7\] vssd1 vssd1 vccd1 vccd1
+ _0719_ sky130_fd_sc_hd__nand2_1
X_1391_ net381 _0670_ net110 vssd1 vssd1 vccd1 vccd1 _0154_ sky130_fd_sc_hd__mux2_1
XFILLER_4_373 vccd1 vssd1 vccd1 vssd1 sky130_ef_sc_hd__decap_40_12
XPHY_EDGE_ROW_60_Right_60 vssd1 vssd1 vccd1 vccd1 sky130_fd_sc_hd__decap_3
X_2012_ CALC_INST.input_ctrl_inst.debounce_cnt\[15\] CALC_INST.input_ctrl_inst.debounce_cnt\[17\]
+ CALC_INST.input_ctrl_inst.debounce_cnt\[16\] CALC_INST.input_ctrl_inst.debounce_cnt\[18\]
+ vssd1 vssd1 vccd1 vccd1 _1068_ sky130_fd_sc_hd__and4_1
XANTENNA__2475__B1 net56 vssd1 vssd1 vccd1 vccd1 sky130_fd_sc_hd__diode_2
XPHY_EDGE_ROW_35_Left_100 vssd1 vssd1 vccd1 vccd1 sky130_fd_sc_hd__decap_3
XANTENNA__2239__X _0404_ vssd1 vssd1 vccd1 vccd1 sky130_fd_sc_hd__diode_2
X_2845_ clknet_leaf_8_clk _0023_ net127 vssd1 vssd1 vccd1 vccd1 CALC_INST.input_ctrl_inst.debounce_cnt\[6\]
+ sky130_fd_sc_hd__dfrtp_1
XFILLER_35_299 vssd1 vssd1 vccd1 vccd1 sky130_fd_sc_hd__fill_2
Xhold123 CALC_INST.input_ctrl_inst.debounce_cnt\[3\] vssd1 vssd1 vccd1 vccd1 net319
+ sky130_fd_sc_hd__dlygate4sd3_1
Xhold145 CALC_INST.gencon_inst.add_calc.main.in2\[13\] vssd1 vssd1 vccd1 vccd1 net341
+ sky130_fd_sc_hd__dlygate4sd3_1
Xhold112 CALC_INST.gencon_inst.latched_operator_input\[2\] vssd1 vssd1 vccd1 vccd1
+ net308 sky130_fd_sc_hd__dlygate4sd3_1
X_2776_ clknet_leaf_6_clk net88 net125 vssd1 vssd1 vccd1 vccd1 net22 sky130_fd_sc_hd__dfrtp_1
Xhold134 CALC_INST.gencon_inst.keypad_input\[2\] vssd1 vssd1 vccd1 vccd1 net330 sky130_fd_sc_hd__dlygate4sd3_1
X_1658_ _0889_ _0891_ vssd1 vssd1 vccd1 vccd1 _0892_ sky130_fd_sc_hd__xnor2_1
Xhold101 CALC_INST.gencon_inst.mult_calc.countSave\[13\] vssd1 vssd1 vccd1 vccd1 net297
+ sky130_fd_sc_hd__dlygate4sd3_1
Xhold156 CALC_INST.gencon_inst.mult_calc.main.GENERATE_ADDER\[14\].thingy.in2 vssd1
+ vssd1 vccd1 vccd1 net352 sky130_fd_sc_hd__dlygate4sd3_1
X_1727_ net92 net337 net76 net440 vssd1 vssd1 vccd1 vccd1 _0238_ sky130_fd_sc_hd__a22o_1
Xhold167 _0241_ vssd1 vssd1 vccd1 vccd1 net363 sky130_fd_sc_hd__dlygate4sd3_1
XFILLER_58_369 vssd1 vssd1 vccd1 vccd1 sky130_fd_sc_hd__fill_1
X_1589_ _0832_ _0834_ vssd1 vssd1 vccd1 vccd1 _0835_ sky130_fd_sc_hd__nand2_1
Xhold189 CALC_INST.gencon_inst.ALU_out\[15\] vssd1 vssd1 vccd1 vccd1 net385 sky130_fd_sc_hd__dlygate4sd3_1
Xhold178 CALC_INST.gencon_inst.mult_calc.main.GENERATE_ADDER\[11\].thingy.in2 vssd1
+ vssd1 vccd1 vccd1 net374 sky130_fd_sc_hd__dlygate4sd3_1
XTAP_TAPCELL_ROW_64_592 vssd1 vccd1 sky130_fd_sc_hd__tapvpwrvgnd_1
XANTENNA__2325__A CALC_INST.gencon_inst.operand2\[3\] vssd1 vssd1 vccd1 vccd1 sky130_fd_sc_hd__diode_2
XFILLER_27_70 vssd1 vssd1 vccd1 vccd1 sky130_fd_sc_hd__fill_1
XTAP_TAPCELL_ROW_4_170 vssd1 vccd1 sky130_fd_sc_hd__tapvpwrvgnd_1
XFILLER_17_222 vssd1 vssd1 vccd1 vccd1 sky130_fd_sc_hd__fill_2
X_2630_ clknet_leaf_17_clk _0168_ net152 vssd1 vssd1 vccd1 vccd1 CALC_INST.gencon_inst.add_calc.main.in2\[9\]
+ sky130_fd_sc_hd__dfrtp_1
X_1512_ _0690_ net31 _0769_ vssd1 vssd1 vccd1 vccd1 _0771_ sky130_fd_sc_hd__and3_1
X_2561_ clknet_leaf_18_clk _0099_ vssd1 vssd1 vccd1 vccd1 CALC_INST.gencon_inst.ALU_in1\[9\]
+ sky130_fd_sc_hd__dfxtp_1
X_2492_ clknet_leaf_4_clk _0034_ net128 vssd1 vssd1 vccd1 vccd1 CALC_INST.gencon_inst.operand2\[2\]
+ sky130_fd_sc_hd__dfrtp_2
X_1443_ net104 CALC_INST.gencon_inst.add_calc.main.in2\[11\] vssd1 vssd1 vccd1 vccd1
+ _0702_ sky130_fd_sc_hd__or2_1
X_1374_ CALC_INST.gencon_inst.ALU_in2\[2\] CALC_INST.gencon_inst.ALU_in1\[2\] net64
+ vssd1 vssd1 vccd1 vccd1 _0662_ sky130_fd_sc_hd__mux2_1
XFILLER_23_225 vssd1 vssd1 vccd1 vccd1 sky130_fd_sc_hd__fill_8
X_2828_ clknet_leaf_2_clk _0349_ vssd1 vssd1 vccd1 vccd1 CALC_INST.gencon_inst.keypad_input\[0\]
+ sky130_fd_sc_hd__dfxtp_1
XANTENNA_fanout144_A net153 vssd1 vssd1 vccd1 vccd1 sky130_fd_sc_hd__diode_2
X_2759_ clknet_leaf_30_clk net414 vssd1 vssd1 vccd1 vccd1 CALC_INST.gencon_inst.mult_calc.INn2\[2\]
+ sky130_fd_sc_hd__dfxtp_1
XFILLER_58_111 vssd1 vssd1 vccd1 vccd1 sky130_fd_sc_hd__fill_1
XANTENNA_fanout57_A _0591_ vssd1 vssd1 vccd1 vccd1 sky130_fd_sc_hd__diode_2
XFILLER_39_391 vssd1 vssd1 vccd1 vccd1 sky130_fd_sc_hd__fill_1
XFILLER_64_57 vssd1 vssd1 vccd1 vccd1 sky130_fd_sc_hd__fill_2
XFILLER_54_361 vssd1 vssd1 vccd1 vccd1 sky130_fd_sc_hd__fill_2
Xfanout51 _0646_ vssd1 vssd1 vccd1 vccd1 net51 sky130_fd_sc_hd__clkbuf_2
Xfanout73 _0393_ vssd1 vssd1 vccd1 vccd1 net73 sky130_fd_sc_hd__clkbuf_4
Xfanout40 _0650_ vssd1 vssd1 vccd1 vccd1 net40 sky130_fd_sc_hd__clkbuf_2
Xfanout62 net63 vssd1 vssd1 vccd1 vccd1 net62 sky130_fd_sc_hd__buf_2
XFILLER_14_247 vssd1 vssd1 vccd1 vccd1 sky130_fd_sc_hd__fill_2
Xfanout84 _0843_ vssd1 vssd1 vccd1 vccd1 net84 sky130_fd_sc_hd__buf_2
Xfanout95 net96 vssd1 vssd1 vccd1 vccd1 net95 sky130_fd_sc_hd__clkbuf_4
XFILLER_64_169 vccd1 vssd1 vccd1 vssd1 sky130_ef_sc_hd__decap_40_12
XFILLER_64_158 vssd1 vssd1 vccd1 vccd1 sky130_fd_sc_hd__fill_8
XFILLER_64_125 vccd1 vssd1 vccd1 vssd1 sky130_ef_sc_hd__decap_40_12
XFILLER_38_80 vssd1 vssd1 vccd1 vccd1 sky130_fd_sc_hd__fill_1
XFILLER_60_386 vccd1 vssd1 vccd1 vssd1 sky130_ef_sc_hd__decap_40_12
Xclkload10 clknet_leaf_5_clk vssd1 vssd1 vccd1 vccd1 clkload10/Y sky130_fd_sc_hd__clkinv_2
XFILLER_9_262 vssd1 vssd1 vccd1 vccd1 sky130_fd_sc_hd__fill_1
XTAP_TAPCELL_ROW_15_242 vssd1 vccd1 sky130_fd_sc_hd__tapvpwrvgnd_1
X_1992_ net203 _1048_ vssd1 vssd1 vccd1 vccd1 _0376_ sky130_fd_sc_hd__xnor2_1
X_2613_ clknet_leaf_15_clk _0151_ net146 vssd1 vssd1 vccd1 vccd1 CALC_INST.gencon_inst.add_calc.main.GENERATE_ADDER\[7\].thingy.in1
+ sky130_fd_sc_hd__dfrtp_1
X_2475_ net451 net57 net56 _0594_ _0596_ vssd1 vssd1 vccd1 vccd1 _0063_ sky130_fd_sc_hd__a221o_1
X_2544_ clknet_leaf_3_clk _0082_ net116 vssd1 vssd1 vccd1 vccd1 CALC_INST.gencon_inst.latched_keypad_input\[0\]
+ sky130_fd_sc_hd__dfrtp_2
Xclkload21 clknet_leaf_27_clk vssd1 vssd1 vccd1 vccd1 clkload21/Y sky130_fd_sc_hd__inv_6
X_1426_ CALC_INST.gencon_inst.ALU_in1\[13\] CALC_INST.gencon_inst.ALU_in2\[13\] net66
+ vssd1 vssd1 vccd1 vccd1 _0688_ sky130_fd_sc_hd__mux2_1
X_1288_ _1050_ _0398_ CALC_INST.gencon_inst.prev_operator_input\[2\] CALC_INST.gencon_inst.prev_operator_input\[0\]
+ vssd1 vssd1 vccd1 vccd1 _0641_ sky130_fd_sc_hd__a211o_1
X_1357_ _0622_ net256 net39 vssd1 vssd1 vccd1 vccd1 _0138_ sky130_fd_sc_hd__mux2_1
XFILLER_28_339 vssd1 vssd1 vccd1 vccd1 sky130_fd_sc_hd__fill_2
XFILLER_55_169 vssd1 vssd1 vccd1 vccd1 sky130_fd_sc_hd__fill_2
XFILLER_43_309 vssd1 vssd1 vccd1 vccd1 sky130_fd_sc_hd__fill_1
XFILLER_34_38 vccd1 vssd1 vccd1 vssd1 sky130_ef_sc_hd__decap_40_12
XFILLER_34_27 vssd1 vssd1 vccd1 vccd1 sky130_fd_sc_hd__fill_1
XFILLER_11_217 vssd1 vssd1 vccd1 vccd1 sky130_fd_sc_hd__fill_1
XFILLER_50_15 vssd1 vssd1 vccd1 vccd1 sky130_fd_sc_hd__fill_2
Xclkload4 clknet_leaf_3_clk vssd1 vssd1 vccd1 vccd1 clkload4/Y sky130_fd_sc_hd__bufinv_16
XTAP_TAPCELL_ROW_21_289 vssd1 vccd1 sky130_fd_sc_hd__tapvpwrvgnd_1
XFILLER_3_405 vssd1 vssd1 vccd1 vccd1 sky130_fd_sc_hd__fill_2
XFILLER_59_46 vssd1 vssd1 vccd1 vccd1 sky130_fd_sc_hd__fill_8
XTAP_TAPCELL_ROW_29_345 vssd1 vccd1 sky130_fd_sc_hd__tapvpwrvgnd_1
XTAP_TAPCELL_ROW_12_223 vssd1 vccd1 sky130_fd_sc_hd__tapvpwrvgnd_1
XFILLER_41_7 vssd1 vssd1 vccd1 vccd1 sky130_fd_sc_hd__fill_2
XFILLER_6_232 vccd1 vssd1 vccd1 vssd1 sky130_ef_sc_hd__decap_40_12
X_2191_ _1214_ _1216_ _1220_ vssd1 vssd1 vccd1 vccd1 _0013_ sky130_fd_sc_hd__or3b_1
XFILLER_37_125 vssd1 vssd1 vccd1 vccd1 sky130_fd_sc_hd__fill_1
X_2260_ CALC_INST.input_ctrl_inst.col_index\[1\] CALC_INST.input_ctrl_inst.col_index\[0\]
+ net90 net89 vssd1 vssd1 vccd1 vccd1 _0422_ sky130_fd_sc_hd__o31a_1
XFILLER_60_172 vssd1 vssd1 vccd1 vccd1 sky130_fd_sc_hd__fill_8
XFILLER_52_128 vssd1 vssd1 vccd1 vccd1 sky130_fd_sc_hd__fill_1
X_1975_ net437 _1037_ vssd1 vssd1 vccd1 vccd1 _1040_ sky130_fd_sc_hd__nor2_1
XANTENNA_fanout107_A CALC_INST.gencon_inst.add_calc.state\[2\] vssd1 vssd1 vccd1 vccd1
+ sky130_fd_sc_hd__diode_2
X_1409_ net366 _0679_ net108 vssd1 vssd1 vccd1 vccd1 _0163_ sky130_fd_sc_hd__mux2_1
X_2527_ clknet_leaf_11_clk _0065_ net131 vssd1 vssd1 vccd1 vccd1 net6 sky130_fd_sc_hd__dfrtp_1
X_2458_ CALC_INST.gencon_inst.operand1\[13\] _0579_ _0520_ vssd1 vssd1 vccd1 vccd1
+ _0583_ sky130_fd_sc_hd__a21oi_1
Xhold38 CALC_INST.gencon_inst.mult_calc.INn2\[15\] vssd1 vssd1 vccd1 vccd1 net234
+ sky130_fd_sc_hd__dlygate4sd3_1
Xhold16 CALC_INST.gencon_inst.mult_calc.INn1\[9\] vssd1 vssd1 vccd1 vccd1 net212 sky130_fd_sc_hd__dlygate4sd3_1
Xhold27 CALC_INST.input_ctrl_inst.scan_timer\[17\] vssd1 vssd1 vccd1 vccd1 net223
+ sky130_fd_sc_hd__dlygate4sd3_1
Xhold49 CALC_INST.gencon_inst.ALU_in1\[4\] vssd1 vssd1 vccd1 vccd1 net245 sky130_fd_sc_hd__dlygate4sd3_1
XFILLER_45_26 vssd1 vssd1 vccd1 vccd1 sky130_fd_sc_hd__fill_2
X_2389_ CALC_INST.gencon_inst.operand1\[0\] CALC_INST.gencon_inst.latched_keypad_input\[0\]
+ net41 _0526_ vssd1 vssd1 vccd1 vccd1 _0527_ sky130_fd_sc_hd__o22a_1
XFILLER_36_180 vccd1 vssd1 vccd1 vssd1 sky130_ef_sc_hd__decap_40_12
XFILLER_28_169 vssd1 vssd1 vccd1 vccd1 sky130_fd_sc_hd__fill_1
XFILLER_28_103 vssd1 vssd1 vccd1 vccd1 sky130_fd_sc_hd__fill_8
XTAP_TAPCELL_ROW_34_381 vssd1 vccd1 sky130_fd_sc_hd__tapvpwrvgnd_1
XANTENNA__1383__S net109 vssd1 vssd1 vccd1 vccd1 sky130_fd_sc_hd__diode_2
XANTENNA__1250__C1 net57 vssd1 vssd1 vccd1 vccd1 sky130_fd_sc_hd__diode_2
XFILLER_59_250 vccd1 vssd1 vccd1 vssd1 sky130_ef_sc_hd__decap_40_12
XFILLER_3_279 vssd1 vssd1 vccd1 vccd1 sky130_fd_sc_hd__fill_1
XFILLER_34_139 vssd1 vssd1 vccd1 vccd1 sky130_fd_sc_hd__fill_1
XFILLER_34_106 vssd1 vssd1 vccd1 vccd1 sky130_fd_sc_hd__fill_1
XFILLER_19_169 vssd1 vssd1 vccd1 vccd1 sky130_fd_sc_hd__fill_1
X_1760_ CALC_INST.gencon_inst.ALU_in1\[15\] net333 _0842_ vssd1 vssd1 vccd1 vccd1
+ _0270_ sky130_fd_sc_hd__mux2_1
X_1691_ CALC_INST.gencon_inst.mult_calc.main.GENERATE_ADDER\[14\].thingy.in2 CALC_INST.gencon_inst.mult_calc.main.GENERATE_ADDER\[14\].thingy.in1
+ vssd1 vssd1 vccd1 vccd1 _0919_ sky130_fd_sc_hd__xor2_1
XANTENNA__2336__A2 net35 vssd1 vssd1 vccd1 vccd1 sky130_fd_sc_hd__diode_2
X_2312_ CALC_INST.gencon_inst.operand2\[0\] CALC_INST.gencon_inst.latched_keypad_input\[0\]
+ _0460_ _0462_ vssd1 vssd1 vccd1 vccd1 _0464_ sky130_fd_sc_hd__and4_1
X_2174_ _1175_ _1205_ _1206_ _1204_ vssd1 vssd1 vccd1 vccd1 _1207_ sky130_fd_sc_hd__a211o_1
XTAP_TAPCELL_ROW_48_473 vssd1 vccd1 sky130_fd_sc_hd__tapvpwrvgnd_1
X_2243_ _0402_ _0403_ _0407_ vssd1 vssd1 vccd1 vccd1 CALC_INST.gencon_inst.next_state\[1\]
+ sky130_fd_sc_hd__or3b_1
Xoutput17 net17 vssd1 vssd1 vccd1 vccd1 gpio_out[21] sky130_fd_sc_hd__buf_2
X_1958_ net112 net63 _1028_ CALC_INST.input_ctrl_inst.scan_timer\[4\] _1030_ vssd1
+ vssd1 vccd1 vccd1 _0361_ sky130_fd_sc_hd__o221a_1
X_1889_ CALC_INST.input_ctrl_inst.col_index\[28\] _0991_ vssd1 vssd1 vccd1 vccd1 _0993_
+ sky130_fd_sc_hd__and2_1
Xoutput28 net28 vssd1 vssd1 vccd1 vccd1 gpio_out[7] sky130_fd_sc_hd__buf_2
XFILLER_56_25 vssd1 vssd1 vccd1 vccd1 sky130_fd_sc_hd__fill_2
XFILLER_8_305 vssd1 vssd1 vccd1 vccd1 sky130_fd_sc_hd__fill_2
XFILLER_12_356 vssd1 vssd1 vccd1 vccd1 sky130_fd_sc_hd__fill_1
XANTENNA__1774__B1 net86 vssd1 vssd1 vccd1 vccd1 sky130_fd_sc_hd__diode_2
XTAP_TAPCELL_ROW_45_454 vssd1 vccd1 sky130_fd_sc_hd__tapvpwrvgnd_1
X_2861_ clknet_leaf_2_clk _0030_ net116 vssd1 vssd1 vccd1 vccd1 CALC_INST.input_ctrl_inst.decoded_key\[3\]
+ sky130_fd_sc_hd__dfstp_1
XFILLER_15_172 vssd1 vssd1 vccd1 vccd1 sky130_fd_sc_hd__fill_1
XFILLER_30_197 vssd1 vssd1 vccd1 vccd1 sky130_fd_sc_hd__fill_2
X_1743_ CALC_INST.gencon_inst.mult_calc.out\[1\] net339 net101 vssd1 vssd1 vccd1 vccd1
+ _0254_ sky130_fd_sc_hd__mux2_1
XANTENNA__1765__B1 net84 vssd1 vssd1 vccd1 vccd1 sky130_fd_sc_hd__diode_2
X_2792_ clknet_leaf_32_clk _0317_ net117 vssd1 vssd1 vccd1 vccd1 CALC_INST.input_ctrl_inst.col_index\[15\]
+ sky130_fd_sc_hd__dfrtp_1
XFILLER_7_393 vssd1 vssd1 vccd1 vccd1 sky130_fd_sc_hd__fill_8
X_1674_ CALC_INST.gencon_inst.mult_calc.main.GENERATE_ADDER\[11\].thingy.in2 CALC_INST.gencon_inst.mult_calc.main.GENERATE_ADDER\[11\].thingy.in1
+ vssd1 vssd1 vccd1 vccd1 _0905_ sky130_fd_sc_hd__nand2_1
X_1812_ _1065_ net63 vssd1 vssd1 vccd1 vccd1 _0944_ sky130_fd_sc_hd__nor2_1
X_2226_ CALC_INST.gencon_inst.gencon_state\[2\] CALC_INST.gencon_inst.gencon_state\[3\]
+ _0388_ vssd1 vssd1 vccd1 vccd1 _0392_ sky130_fd_sc_hd__nor3_4
XANTENNA__2420__B _0520_ vssd1 vssd1 vccd1 vccd1 sky130_fd_sc_hd__diode_2
X_2157_ _1176_ _1192_ _1193_ net46 CALC_INST.input_ctrl_inst.debounce_cnt\[7\] vssd1
+ vssd1 vccd1 vccd1 _0024_ sky130_fd_sc_hd__a32o_1
XFILLER_53_289 vssd1 vssd1 vccd1 vccd1 sky130_fd_sc_hd__fill_1
XFILLER_53_201 vssd1 vssd1 vccd1 vccd1 sky130_fd_sc_hd__fill_1
XFILLER_38_231 vccd1 vssd1 vccd1 vssd1 sky130_ef_sc_hd__decap_40_12
X_2088_ CALC_INST.gencon_inst.mult_calc.INn2\[13\] CALC_INST.gencon_inst.mult_calc.INn2\[12\]
+ CALC_INST.gencon_inst.mult_calc.INn2\[14\] _1141_ vssd1 vssd1 vccd1 vccd1 _1142_
+ sky130_fd_sc_hd__or4_1
XANTENNA_fanout87_A _0843_ vssd1 vssd1 vccd1 vccd1 sky130_fd_sc_hd__diode_2
XTAP_TAPCELL_ROW_42_435 vssd1 vccd1 sky130_fd_sc_hd__tapvpwrvgnd_1
XFILLER_12_120 vssd1 vssd1 vccd1 vccd1 sky130_fd_sc_hd__fill_8
XTAP_TAPCELL_ROW_50_490 vssd1 vccd1 sky130_fd_sc_hd__tapvpwrvgnd_1
XFILLER_32_93 vssd1 vssd1 vccd1 vccd1 sky130_fd_sc_hd__fill_4
X_1390_ CALC_INST.gencon_inst.ALU_in2\[10\] CALC_INST.gencon_inst.ALU_in1\[10\] net66
+ vssd1 vssd1 vccd1 vccd1 _0670_ sky130_fd_sc_hd__mux2_1
XFILLER_4_385 vccd1 vssd1 vccd1 vssd1 sky130_ef_sc_hd__decap_40_12
XFILLER_4_363 vssd1 vssd1 vccd1 vccd1 sky130_fd_sc_hd__fill_1
XTAP_TAPCELL_ROW_7_190 vssd1 vccd1 sky130_fd_sc_hd__tapvpwrvgnd_1
XFILLER_35_289 vssd1 vssd1 vccd1 vccd1 sky130_fd_sc_hd__fill_2
XANTENNA__1278__A2 net57 vssd1 vssd1 vccd1 vccd1 sky130_fd_sc_hd__diode_2
X_2011_ CALC_INST.input_ctrl_inst.col_index\[26\] vssd1 vssd1 vccd1 vccd1 _1067_ sky130_fd_sc_hd__inv_2
X_2844_ clknet_leaf_8_clk _0022_ net126 vssd1 vssd1 vccd1 vccd1 CALC_INST.input_ctrl_inst.debounce_cnt\[5\]
+ sky130_fd_sc_hd__dfrtp_1
Xhold168 CALC_INST.gencon_inst.add_calc.main.GENERATE_ADDER\[5\].thingy.in1 vssd1
+ vssd1 vccd1 vccd1 net364 sky130_fd_sc_hd__dlygate4sd3_1
Xhold135 CALC_INST.gencon_inst.add_calc.main.in2\[9\] vssd1 vssd1 vccd1 vccd1 net331
+ sky130_fd_sc_hd__dlygate4sd3_1
X_1588_ _0764_ _0833_ vssd1 vssd1 vccd1 vccd1 _0834_ sky130_fd_sc_hd__xnor2_1
Xhold124 CALC_INST.input_ctrl_inst.input_control_state\[0\] vssd1 vssd1 vccd1 vccd1
+ net320 sky130_fd_sc_hd__dlygate4sd3_1
X_2775_ clknet_leaf_6_clk net371 net124 vssd1 vssd1 vccd1 vccd1 net21 sky130_fd_sc_hd__dfrtp_1
X_1657_ _0882_ _0890_ vssd1 vssd1 vccd1 vccd1 _0891_ sky130_fd_sc_hd__or2_1
Xhold102 CALC_INST.gencon_inst.mult_calc.count.GENERATE_ADDER\[9\].thingy.in1 vssd1
+ vssd1 vccd1 vccd1 net298 sky130_fd_sc_hd__dlygate4sd3_1
Xhold113 CALC_INST.gencon_inst.mult_calc.countSave\[2\] vssd1 vssd1 vccd1 vccd1 net309
+ sky130_fd_sc_hd__dlygate4sd3_1
Xhold157 _0252_ vssd1 vssd1 vccd1 vccd1 net353 sky130_fd_sc_hd__dlygate4sd3_1
Xhold179 _0249_ vssd1 vssd1 vccd1 vccd1 net375 sky130_fd_sc_hd__dlygate4sd3_1
X_1726_ net101 CALC_INST.gencon_inst.mult_calc.finish _0922_ vssd1 vssd1 vccd1 vccd1
+ _0237_ sky130_fd_sc_hd__mux2_1
Xhold146 CALC_INST.gencon_inst.mult_calc.main.GENERATE_ADDER\[7\].thingy.in2 vssd1
+ vssd1 vccd1 vccd1 net342 sky130_fd_sc_hd__dlygate4sd3_1
XANTENNA__1269__A2 _0392_ vssd1 vssd1 vccd1 vccd1 sky130_fd_sc_hd__diode_2
X_2209_ CALC_INST.gencon_inst.gencon_state\[3\] _1232_ vssd1 vssd1 vccd1 vccd1 _1234_
+ sky130_fd_sc_hd__nand2_2
XANTENNA__1910__B1 net75 vssd1 vssd1 vccd1 vccd1 sky130_fd_sc_hd__diode_2
XTAP_TAPCELL_ROW_64_593 vssd1 vccd1 sky130_fd_sc_hd__tapvpwrvgnd_1
XFILLER_53_26 vssd1 vssd1 vccd1 vccd1 sky130_fd_sc_hd__fill_2
XFILLER_53_15 vssd1 vssd1 vccd1 vccd1 sky130_fd_sc_hd__fill_2
XFILLER_41_204 vccd1 vssd1 vccd1 vssd1 sky130_ef_sc_hd__decap_40_12
XANTENNA__1729__B1 net75 vssd1 vssd1 vccd1 vccd1 sky130_fd_sc_hd__diode_2
XFILLER_1_322 vssd1 vssd1 vccd1 vccd1 sky130_fd_sc_hd__fill_4
XFILLER_64_307 vssd1 vssd1 vccd1 vccd1 sky130_fd_sc_hd__fill_1
Xclkbuf_2_0__f_clk clknet_0_clk vssd1 vssd1 vccd1 vccd1 clknet_2_0__leaf_clk sky130_fd_sc_hd__clkbuf_16
XTAP_TAPCELL_ROW_4_171 vssd1 vccd1 sky130_fd_sc_hd__tapvpwrvgnd_1
X_1511_ CALC_INST.gencon_inst.add_calc.state\[1\] CALC_INST.gencon_inst.ALU_out\[1\]
+ vssd1 vssd1 vccd1 vccd1 _0770_ sky130_fd_sc_hd__or2_1
X_1442_ CALC_INST.gencon_inst.add_calc.main.GENERATE_ADDER\[12\].thingy.in1 _0698_
+ _0699_ vssd1 vssd1 vccd1 vccd1 _0701_ sky130_fd_sc_hd__nand3_1
X_2560_ clknet_leaf_18_clk _0098_ vssd1 vssd1 vccd1 vccd1 CALC_INST.gencon_inst.ALU_in1\[8\]
+ sky130_fd_sc_hd__dfxtp_1
X_2491_ clknet_leaf_4_clk _0033_ net121 vssd1 vssd1 vccd1 vccd1 CALC_INST.gencon_inst.operand2\[1\]
+ sky130_fd_sc_hd__dfrtp_1
XFILLER_4_193 vssd1 vssd1 vccd1 vccd1 sky130_fd_sc_hd__fill_2
X_1373_ CALC_INST.gencon_inst.add_calc.main.GENERATE_ADDER\[1\].thingy.in1 _0661_
+ net107 vssd1 vssd1 vccd1 vccd1 _0145_ sky130_fd_sc_hd__mux2_1
XTAP_TAPCELL_ROW_53_508 vssd1 vccd1 sky130_fd_sc_hd__tapvpwrvgnd_1
XANTENNA__1601__Y _0843_ vssd1 vssd1 vccd1 vccd1 sky130_fd_sc_hd__diode_2
XFILLER_31_270 vssd1 vssd1 vccd1 vccd1 sky130_fd_sc_hd__fill_1
X_2758_ clknet_leaf_30_clk _0287_ vssd1 vssd1 vccd1 vccd1 CALC_INST.gencon_inst.mult_calc.INn2\[1\]
+ sky130_fd_sc_hd__dfxtp_1
X_2827_ clknet_leaf_25_clk _0348_ net144 vssd1 vssd1 vccd1 vccd1 CALC_INST.gencon_inst.mult_calc.count.GENERATE_ADDER\[14\].thingy.in1
+ sky130_fd_sc_hd__dfrtp_1
X_2689_ clknet_leaf_21_clk _0227_ net137 vssd1 vssd1 vccd1 vccd1 CALC_INST.gencon_inst.mult_calc.main.GENERATE_ADDER\[5\].thingy.in1
+ sky130_fd_sc_hd__dfrtp_1
XFILLER_2_108 vssd1 vssd1 vccd1 vccd1 sky130_fd_sc_hd__fill_2
X_1709_ net412 net358 net97 vssd1 vssd1 vccd1 vccd1 _0221_ sky130_fd_sc_hd__mux2_1
XPHY_EDGE_ROW_18_Left_83 vssd1 vssd1 vccd1 vccd1 sky130_fd_sc_hd__decap_3
XFILLER_46_307 vssd1 vssd1 vccd1 vccd1 sky130_fd_sc_hd__fill_1
XPHY_EDGE_ROW_54_Left_119 vssd1 vssd1 vccd1 vccd1 sky130_fd_sc_hd__decap_3
Xfanout52 _0646_ vssd1 vssd1 vccd1 vccd1 net52 sky130_fd_sc_hd__clkbuf_4
Xfanout41 _0524_ vssd1 vssd1 vccd1 vccd1 net41 sky130_fd_sc_hd__buf_2
Xfanout96 CALC_INST.gencon_inst.mult_calc.state\[3\] vssd1 vssd1 vccd1 vccd1 net96
+ sky130_fd_sc_hd__clkbuf_4
Xfanout63 _0935_ vssd1 vssd1 vccd1 vccd1 net63 sky130_fd_sc_hd__buf_2
Xfanout85 _0843_ vssd1 vssd1 vccd1 vccd1 net85 sky130_fd_sc_hd__clkbuf_2
XFILLER_6_403 vssd1 vssd1 vccd1 vccd1 sky130_fd_sc_hd__fill_1
XPHY_EDGE_ROW_63_Left_128 vssd1 vssd1 vccd1 vccd1 sky130_fd_sc_hd__decap_3
XFILLER_64_137 vssd1 vssd1 vccd1 vccd1 sky130_fd_sc_hd__fill_2
XFILLER_60_332 vssd1 vssd1 vccd1 vccd1 sky130_fd_sc_hd__fill_1
XTAP_TAPCELL_ROW_15_243 vssd1 vccd1 sky130_fd_sc_hd__tapvpwrvgnd_1
X_2612_ clknet_leaf_14_clk _0150_ net146 vssd1 vssd1 vccd1 vccd1 CALC_INST.gencon_inst.add_calc.main.GENERATE_ADDER\[6\].thingy.in1
+ sky130_fd_sc_hd__dfrtp_1
XFILLER_60_398 vssd1 vssd1 vccd1 vccd1 sky130_fd_sc_hd__fill_1
XANTENNA__2412__C _0519_ vssd1 vssd1 vccd1 vccd1 sky130_fd_sc_hd__diode_2
Xclkload11 clknet_leaf_6_clk vssd1 vssd1 vccd1 vccd1 clkload11/Y sky130_fd_sc_hd__inv_4
XFILLER_9_274 vssd1 vssd1 vccd1 vccd1 sky130_fd_sc_hd__fill_4
X_1991_ _1048_ _1049_ vssd1 vssd1 vccd1 vccd1 _0375_ sky130_fd_sc_hd__and2_1
Xclkload22 clknet_leaf_28_clk vssd1 vssd1 vccd1 vccd1 clkload22/Y sky130_fd_sc_hd__inv_6
XFILLER_20_229 vssd1 vssd1 vccd1 vccd1 sky130_fd_sc_hd__fill_1
X_1425_ net322 _0687_ net110 vssd1 vssd1 vccd1 vccd1 _0171_ sky130_fd_sc_hd__mux2_1
X_2543_ clknet_leaf_5_clk _0081_ net125 vssd1 vssd1 vccd1 vccd1 CALC_INST.gencon_inst.key_read
+ sky130_fd_sc_hd__dfrtp_2
X_2474_ CALC_INST.gencon_inst.ALU_out\[0\] net68 net54 CALC_INST.gencon_inst.mult_calc.out\[0\]
+ vssd1 vssd1 vccd1 vccd1 _0596_ sky130_fd_sc_hd__a22o_1
X_1287_ _0379_ net56 _0639_ vssd1 vssd1 vccd1 vccd1 _0640_ sky130_fd_sc_hd__or3b_1
X_1356_ _0620_ net211 net39 vssd1 vssd1 vccd1 vccd1 _0137_ sky130_fd_sc_hd__mux2_1
Xclkload5 clknet_leaf_30_clk vssd1 vssd1 vccd1 vccd1 clkload5/Y sky130_fd_sc_hd__inv_6
XFILLER_11_207 vssd1 vssd1 vccd1 vccd1 sky130_fd_sc_hd__fill_2
XFILLER_59_69 vssd1 vssd1 vccd1 vccd1 sky130_fd_sc_hd__fill_1
XPHY_EDGE_ROW_3_Left_68 vssd1 vssd1 vccd1 vccd1 sky130_fd_sc_hd__decap_3
XFILLER_42_354 vssd1 vssd1 vccd1 vccd1 sky130_fd_sc_hd__fill_8
XTAP_TAPCELL_ROW_29_346 vssd1 vccd1 sky130_fd_sc_hd__tapvpwrvgnd_1
XFILLER_27_362 vssd1 vssd1 vccd1 vccd1 sky130_fd_sc_hd__fill_1
XFILLER_42_398 vssd1 vssd1 vccd1 vccd1 sky130_fd_sc_hd__fill_1
XFILLER_42_365 vssd1 vssd1 vccd1 vccd1 sky130_fd_sc_hd__fill_1
XFILLER_6_244 vssd1 vssd1 vccd1 vccd1 sky130_fd_sc_hd__fill_1
XFILLER_10_251 vssd1 vssd1 vccd1 vccd1 sky130_fd_sc_hd__fill_1
XTAP_TAPCELL_ROW_12_224 vssd1 vccd1 sky130_fd_sc_hd__tapvpwrvgnd_1
XFILLER_34_7 vccd1 vssd1 vccd1 vssd1 sky130_ef_sc_hd__decap_40_12
X_2190_ _1175_ _1219_ _1218_ _1217_ vssd1 vssd1 vccd1 vccd1 _1220_ sky130_fd_sc_hd__a211o_1
XFILLER_49_91 vssd1 vssd1 vccd1 vccd1 sky130_fd_sc_hd__fill_1
XFILLER_18_351 vssd1 vssd1 vccd1 vccd1 sky130_fd_sc_hd__fill_2
XFILLER_18_362 vssd1 vssd1 vccd1 vccd1 sky130_fd_sc_hd__fill_2
XFILLER_60_195 vssd1 vssd1 vccd1 vccd1 sky130_fd_sc_hd__fill_1
XFILLER_60_184 vssd1 vssd1 vccd1 vccd1 sky130_fd_sc_hd__fill_1
XFILLER_18_384 vssd1 vssd1 vccd1 vccd1 sky130_fd_sc_hd__fill_2
X_1974_ CALC_INST.input_ctrl_inst.scan_timer\[12\] _1037_ vssd1 vssd1 vccd1 vccd1
+ _1039_ sky130_fd_sc_hd__and2_1
X_1408_ CALC_INST.gencon_inst.ALU_in1\[4\] CALC_INST.gencon_inst.ALU_in2\[4\] net64
+ vssd1 vssd1 vccd1 vccd1 _0679_ sky130_fd_sc_hd__mux2_1
X_2526_ clknet_leaf_11_clk _0064_ net131 vssd1 vssd1 vccd1 vccd1 net30 sky130_fd_sc_hd__dfrtp_1
Xhold17 CALC_INST.gencon_inst.prev_read_input vssd1 vssd1 vccd1 vccd1 net213 sky130_fd_sc_hd__dlygate4sd3_1
X_2457_ CALC_INST.gencon_inst.operand1\[12\] net43 _0581_ _0582_ vssd1 vssd1 vccd1
+ vccd1 _0059_ sky130_fd_sc_hd__o22a_1
X_2388_ _0519_ _0525_ vssd1 vssd1 vccd1 vccd1 _0526_ sky130_fd_sc_hd__and2_1
Xhold39 _0301_ vssd1 vssd1 vccd1 vccd1 net235 sky130_fd_sc_hd__dlygate4sd3_1
Xhold28 _1047_ vssd1 vssd1 vccd1 vccd1 net224 sky130_fd_sc_hd__dlygate4sd3_1
X_1339_ CALC_INST.gencon_inst.latched_operator_input\[0\] net279 net50 vssd1 vssd1
+ vccd1 vccd1 _0126_ sky130_fd_sc_hd__mux2_1
XFILLER_36_192 vssd1 vssd1 vccd1 vccd1 sky130_fd_sc_hd__fill_4
XFILLER_28_137 vssd1 vssd1 vccd1 vccd1 sky130_fd_sc_hd__fill_2
XANTENNA__1250__B1 net54 vssd1 vssd1 vccd1 vccd1 sky130_fd_sc_hd__diode_2
XFILLER_10_85 vssd1 vssd1 vccd1 vccd1 sky130_fd_sc_hd__fill_4
XFILLER_59_262 vssd1 vssd1 vccd1 vccd1 sky130_fd_sc_hd__fill_4
XFILLER_19_137 vssd1 vssd1 vccd1 vccd1 sky130_fd_sc_hd__fill_4
XFILLER_35_60 vccd1 vssd1 vccd1 vssd1 sky130_ef_sc_hd__decap_40_12
X_1690_ net100 _0917_ _0918_ net325 net86 vssd1 vssd1 vccd1 vccd1 _0205_ sky130_fd_sc_hd__a32o_1
X_2242_ _1059_ _0384_ net72 _0406_ _0405_ vssd1 vssd1 vccd1 vccd1 _0407_ sky130_fd_sc_hd__o221a_1
X_2311_ CALC_INST.gencon_inst.operand2\[0\] CALC_INST.gencon_inst.latched_keypad_input\[0\]
+ _0460_ _0462_ vssd1 vssd1 vccd1 vccd1 _0463_ sky130_fd_sc_hd__a22o_1
X_2173_ CALC_INST.input_ctrl_inst.debounce_cnt\[10\] _1199_ CALC_INST.input_ctrl_inst.debounce_cnt\[11\]
+ vssd1 vssd1 vccd1 vccd1 _1206_ sky130_fd_sc_hd__a21oi_1
XTAP_TAPCELL_ROW_48_474 vssd1 vccd1 sky130_fd_sc_hd__tapvpwrvgnd_1
XFILLER_25_129 vssd1 vssd1 vccd1 vccd1 sky130_fd_sc_hd__fill_2
XFILLER_15_19 vssd1 vssd1 vccd1 vccd1 sky130_fd_sc_hd__fill_4
XFILLER_33_173 vssd1 vssd1 vccd1 vccd1 sky130_fd_sc_hd__fill_2
X_1957_ CALC_INST.input_ctrl_inst.scan_timer\[4\] _1028_ vssd1 vssd1 vccd1 vccd1 _1030_
+ sky130_fd_sc_hd__nand2_1
X_2509_ clknet_leaf_12_clk _0051_ net145 vssd1 vssd1 vccd1 vccd1 CALC_INST.gencon_inst.operand1\[4\]
+ sky130_fd_sc_hd__dfrtp_1
Xoutput29 net29 vssd1 vssd1 vccd1 vccd1 gpio_out[8] sky130_fd_sc_hd__buf_2
Xoutput18 net18 vssd1 vssd1 vccd1 vccd1 gpio_out[22] sky130_fd_sc_hd__buf_2
XFILLER_0_217 vssd1 vssd1 vccd1 vccd1 sky130_fd_sc_hd__fill_4
X_1888_ _0990_ _0992_ vssd1 vssd1 vccd1 vccd1 _0329_ sky130_fd_sc_hd__nor2_1
XFILLER_56_221 vssd1 vssd1 vccd1 vccd1 sky130_fd_sc_hd__fill_1
XFILLER_46_81 vssd1 vssd1 vccd1 vccd1 sky130_fd_sc_hd__fill_2
Xclkbuf_leaf_27_clk clknet_2_2__leaf_clk vssd1 vssd1 vccd1 vccd1 clknet_leaf_27_clk
+ sky130_fd_sc_hd__clkbuf_8
XPHY_EDGE_ROW_6_Left_71 vssd1 vssd1 vccd1 vccd1 sky130_fd_sc_hd__decap_3
Xmax_cap60 _0955_ vssd1 vssd1 vccd1 vccd1 net60 sky130_fd_sc_hd__clkbuf_1
XTAP_TAPCELL_ROW_45_455 vssd1 vccd1 sky130_fd_sc_hd__tapvpwrvgnd_1
X_2860_ clknet_leaf_6_clk _0029_ net124 vssd1 vssd1 vccd1 vccd1 CALC_INST.input_ctrl_inst.decoded_key\[2\]
+ sky130_fd_sc_hd__dfstp_1
X_2791_ clknet_leaf_32_clk _0316_ net117 vssd1 vssd1 vccd1 vccd1 CALC_INST.input_ctrl_inst.col_index\[14\]
+ sky130_fd_sc_hd__dfrtp_1
X_1811_ CALC_INST.input_ctrl_inst.col_index\[0\] net61 vssd1 vssd1 vccd1 vccd1 _0943_
+ sky130_fd_sc_hd__nor2_1
X_1673_ CALC_INST.gencon_inst.mult_calc.main.GENERATE_ADDER\[11\].thingy.in2 CALC_INST.gencon_inst.mult_calc.main.GENERATE_ADDER\[11\].thingy.in1
+ vssd1 vssd1 vccd1 vccd1 _0904_ sky130_fd_sc_hd__nor2_1
X_1742_ CALC_INST.gencon_inst.mult_calc.out\[0\] net337 net101 vssd1 vssd1 vccd1 vccd1
+ _0253_ sky130_fd_sc_hd__mux2_1
X_2225_ _0382_ _0386_ _0387_ _0390_ CALC_INST.gencon_inst.gencon_state\[3\] vssd1
+ vssd1 vccd1 vccd1 _0391_ sky130_fd_sc_hd__a41o_1
XFILLER_38_243 vssd1 vssd1 vccd1 vccd1 sky130_fd_sc_hd__fill_2
X_2156_ CALC_INST.input_ctrl_inst.debounce_cnt\[7\] _1190_ vssd1 vssd1 vccd1 vccd1
+ _1193_ sky130_fd_sc_hd__nand2_1
Xclkbuf_leaf_18_clk clknet_2_3__leaf_clk vssd1 vssd1 vccd1 vccd1 clknet_leaf_18_clk
+ sky130_fd_sc_hd__clkbuf_8
XFILLER_38_265 vssd1 vssd1 vccd1 vccd1 sky130_fd_sc_hd__fill_1
XPHY_EDGE_ROW_5_Right_5 vssd1 vssd1 vccd1 vccd1 sky130_fd_sc_hd__decap_3
X_2087_ CALC_INST.gencon_inst.mult_calc.INn2\[9\] CALC_INST.gencon_inst.mult_calc.INn2\[8\]
+ CALC_INST.gencon_inst.mult_calc.INn2\[11\] CALC_INST.gencon_inst.mult_calc.INn2\[10\]
+ vssd1 vssd1 vccd1 vccd1 _1141_ sky130_fd_sc_hd__or4_1
XFILLER_17_405 vssd1 vssd1 vccd1 vccd1 sky130_fd_sc_hd__fill_2
XANTENNA__1389__S net109 vssd1 vssd1 vccd1 vccd1 sky130_fd_sc_hd__diode_2
XFILLER_44_268 vssd1 vssd1 vccd1 vccd1 sky130_fd_sc_hd__fill_1
XTAP_TAPCELL_ROW_42_436 vssd1 vccd1 sky130_fd_sc_hd__tapvpwrvgnd_1
XANTENNA_fanout35_X net35 vssd1 vssd1 vccd1 vccd1 sky130_fd_sc_hd__diode_2
XPHY_EDGE_ROW_32_Left_97 vssd1 vssd1 vccd1 vccd1 sky130_fd_sc_hd__decap_3
XTAP_TAPCELL_ROW_50_491 vssd1 vccd1 sky130_fd_sc_hd__tapvpwrvgnd_1
XFILLER_32_83 vssd1 vssd1 vccd1 vccd1 sky130_fd_sc_hd__fill_1
XFILLER_4_397 vssd1 vssd1 vccd1 vccd1 sky130_fd_sc_hd__fill_4
X_2010_ CALC_INST.input_ctrl_inst.col_index\[23\] vssd1 vssd1 vccd1 vccd1 _1066_ sky130_fd_sc_hd__inv_2
XTAP_TAPCELL_ROW_7_191 vssd1 vccd1 sky130_fd_sc_hd__tapvpwrvgnd_1
XANTENNA__2475__A2 net57 vssd1 vssd1 vccd1 vccd1 sky130_fd_sc_hd__diode_2
XFILLER_35_268 vssd1 vssd1 vccd1 vccd1 sky130_fd_sc_hd__fill_4
X_2843_ clknet_leaf_8_clk _0021_ net127 vssd1 vssd1 vccd1 vccd1 CALC_INST.input_ctrl_inst.debounce_cnt\[4\]
+ sky130_fd_sc_hd__dfrtp_1
X_2774_ clknet_leaf_6_clk net320 net124 vssd1 vssd1 vccd1 vccd1 net20 sky130_fd_sc_hd__dfrtp_1
X_1725_ net82 net76 vssd1 vssd1 vccd1 vccd1 _0922_ sky130_fd_sc_hd__nand2_1
XFILLER_58_305 vssd1 vssd1 vccd1 vccd1 sky130_fd_sc_hd__fill_2
Xhold136 CALC_INST.gencon_inst.add_calc.state\[0\] vssd1 vssd1 vccd1 vccd1 net332
+ sky130_fd_sc_hd__dlygate4sd3_1
X_1587_ _0693_ _0765_ vssd1 vssd1 vccd1 vccd1 _0833_ sky130_fd_sc_hd__nor2_1
Xclkbuf_leaf_7_clk clknet_2_1__leaf_clk vssd1 vssd1 vccd1 vccd1 clknet_leaf_7_clk
+ sky130_fd_sc_hd__clkbuf_8
Xhold125 CALC_INST.gencon_inst.ALU_in2\[7\] vssd1 vssd1 vccd1 vccd1 net321 sky130_fd_sc_hd__dlygate4sd3_1
Xhold169 CALC_INST.gencon_inst.mult_calc.INn2\[6\] vssd1 vssd1 vccd1 vccd1 net365
+ sky130_fd_sc_hd__dlygate4sd3_1
Xhold103 CALC_INST.input_ctrl_inst.scan_timer\[16\] vssd1 vssd1 vccd1 vccd1 net299
+ sky130_fd_sc_hd__dlygate4sd3_1
XFILLER_7_180 vssd1 vssd1 vccd1 vccd1 sky130_fd_sc_hd__fill_1
Xhold158 CALC_INST.gencon_inst.mult_calc.count.GENERATE_ADDER\[14\].thingy.in1 vssd1
+ vssd1 vccd1 vccd1 net354 sky130_fd_sc_hd__dlygate4sd3_1
Xhold114 CALC_INST.gencon_inst.mult_calc.compCount.in2\[0\] vssd1 vssd1 vccd1 vccd1
+ net310 sky130_fd_sc_hd__dlygate4sd3_1
Xhold147 CALC_INST.input_ctrl_inst.scan_timer\[9\] vssd1 vssd1 vccd1 vccd1 net343
+ sky130_fd_sc_hd__dlygate4sd3_1
X_1656_ _0869_ _0875_ _0878_ _0883_ _0876_ vssd1 vssd1 vccd1 vccd1 _0890_ sky130_fd_sc_hd__o311a_1
X_2139_ net36 _1179_ _1180_ net45 net466 vssd1 vssd1 vccd1 vccd1 _0019_ sky130_fd_sc_hd__a32o_1
X_2208_ CALC_INST.gencon_inst.gencon_state\[3\] _1232_ vssd1 vssd1 vccd1 vccd1 _1233_
+ sky130_fd_sc_hd__and2_1
XFILLER_26_246 vssd1 vssd1 vccd1 vccd1 sky130_fd_sc_hd__fill_4
XANTENNA__1764__A1_N net82 vssd1 vssd1 vccd1 vccd1 sky130_fd_sc_hd__diode_2
XANTENNA__1910__A1 net91 vssd1 vssd1 vccd1 vccd1 sky130_fd_sc_hd__diode_2
XTAP_TAPCELL_ROW_64_594 vssd1 vccd1 sky130_fd_sc_hd__tapvpwrvgnd_1
XFILLER_53_38 vccd1 vssd1 vccd1 vssd1 sky130_ef_sc_hd__decap_40_12
XFILLER_26_257 vssd1 vssd1 vccd1 vccd1 sky130_fd_sc_hd__fill_1
XFILLER_1_301 vssd1 vssd1 vccd1 vccd1 sky130_fd_sc_hd__fill_1
XFILLER_49_305 vssd1 vssd1 vccd1 vccd1 sky130_fd_sc_hd__fill_1
XFILLER_1_389 vssd1 vssd1 vccd1 vccd1 sky130_fd_sc_hd__fill_2
X_1510_ _0744_ _0768_ vssd1 vssd1 vccd1 vccd1 _0769_ sky130_fd_sc_hd__xnor2_1
XFILLER_57_6 vssd1 vssd1 vccd1 vccd1 sky130_fd_sc_hd__fill_4
X_1441_ _0698_ _0699_ CALC_INST.gencon_inst.add_calc.main.GENERATE_ADDER\[12\].thingy.in1
+ vssd1 vssd1 vccd1 vccd1 _0700_ sky130_fd_sc_hd__a21oi_1
X_2490_ clknet_leaf_4_clk _0032_ net121 vssd1 vssd1 vccd1 vccd1 CALC_INST.gencon_inst.operand2\[0\]
+ sky130_fd_sc_hd__dfrtp_2
XFILLER_4_43 vssd1 vssd1 vccd1 vccd1 sky130_fd_sc_hd__fill_1
X_1372_ CALC_INST.gencon_inst.ALU_in2\[1\] CALC_INST.gencon_inst.ALU_in1\[1\] net64
+ vssd1 vssd1 vccd1 vccd1 _0661_ sky130_fd_sc_hd__mux2_1
XTAP_TAPCELL_ROW_61_564 vssd1 vccd1 sky130_fd_sc_hd__tapvpwrvgnd_1
XTAP_TAPCELL_ROW_53_509 vssd1 vccd1 sky130_fd_sc_hd__tapvpwrvgnd_1
XTAP_TAPCELL_ROW_18_263 vssd1 vccd1 sky130_fd_sc_hd__tapvpwrvgnd_1
X_2757_ clknet_leaf_4_clk _0286_ vssd1 vssd1 vccd1 vccd1 CALC_INST.gencon_inst.mult_calc.INn2\[0\]
+ sky130_fd_sc_hd__dfxtp_1
X_2688_ clknet_leaf_30_clk _0226_ net137 vssd1 vssd1 vccd1 vccd1 CALC_INST.gencon_inst.mult_calc.main.GENERATE_ADDER\[4\].thingy.in1
+ sky130_fd_sc_hd__dfrtp_1
X_2826_ clknet_leaf_25_clk _0347_ net144 vssd1 vssd1 vccd1 vccd1 CALC_INST.gencon_inst.mult_calc.count.GENERATE_ADDER\[13\].thingy.in1
+ sky130_fd_sc_hd__dfrtp_1
X_1708_ net429 net424 net97 vssd1 vssd1 vccd1 vccd1 _0220_ sky130_fd_sc_hd__mux2_1
XANTENNA_input4_A gpio_in[3] vssd1 vssd1 vccd1 vccd1 sky130_fd_sc_hd__diode_2
X_1639_ CALC_INST.gencon_inst.mult_calc.main.GENERATE_ADDER\[6\].thingy.in2 CALC_INST.gencon_inst.mult_calc.main.GENERATE_ADDER\[6\].thingy.in1
+ vssd1 vssd1 vccd1 vccd1 _0875_ sky130_fd_sc_hd__nor2_1
XFILLER_54_363 vssd1 vssd1 vccd1 vccd1 sky130_fd_sc_hd__fill_1
XFILLER_39_371 vssd1 vssd1 vccd1 vccd1 sky130_fd_sc_hd__fill_1
XFILLER_14_238 vssd1 vssd1 vccd1 vccd1 sky130_fd_sc_hd__fill_1
Xfanout31 _0767_ vssd1 vssd1 vccd1 vccd1 net31 sky130_fd_sc_hd__buf_2
Xfanout64 _0659_ vssd1 vssd1 vccd1 vccd1 net64 sky130_fd_sc_hd__clkbuf_4
Xfanout53 _0646_ vssd1 vssd1 vccd1 vccd1 net53 sky130_fd_sc_hd__buf_2
Xfanout42 _0523_ vssd1 vssd1 vccd1 vccd1 net42 sky130_fd_sc_hd__clkbuf_4
XFILLER_22_271 vssd1 vssd1 vccd1 vccd1 sky130_fd_sc_hd__fill_4
Xfanout75 _1145_ vssd1 vssd1 vccd1 vccd1 net75 sky130_fd_sc_hd__clkbuf_4
Xfanout86 _0843_ vssd1 vssd1 vccd1 vccd1 net86 sky130_fd_sc_hd__buf_2
XFILLER_13_52 vssd1 vssd1 vccd1 vccd1 sky130_fd_sc_hd__fill_4
XFILLER_14_249 vssd1 vssd1 vccd1 vccd1 sky130_fd_sc_hd__fill_1
Xfanout97 CALC_INST.gencon_inst.mult_calc.state\[3\] vssd1 vssd1 vccd1 vccd1 net97
+ sky130_fd_sc_hd__clkbuf_4
XFILLER_60_322 vssd1 vssd1 vccd1 vccd1 sky130_fd_sc_hd__fill_8
XTAP_TAPCELL_ROW_15_244 vssd1 vccd1 sky130_fd_sc_hd__tapvpwrvgnd_1
X_1990_ CALC_INST.input_ctrl_inst.scan_timer\[18\] _1046_ vssd1 vssd1 vccd1 vccd1
+ _1049_ sky130_fd_sc_hd__or2_1
X_2611_ clknet_leaf_14_clk _0149_ net147 vssd1 vssd1 vccd1 vccd1 CALC_INST.gencon_inst.add_calc.main.GENERATE_ADDER\[5\].thingy.in1
+ sky130_fd_sc_hd__dfrtp_1
Xclkload12 clknet_leaf_7_clk vssd1 vssd1 vccd1 vccd1 clkload12/Y sky130_fd_sc_hd__clkinv_4
X_2542_ clknet_leaf_11_clk _0080_ net128 vssd1 vssd1 vccd1 vccd1 CALC_INST.gencon_inst.operand1\[15\]
+ sky130_fd_sc_hd__dfrtp_1
XANTENNA__2366__A1 _0405_ vssd1 vssd1 vccd1 vccd1 sky130_fd_sc_hd__diode_2
XFILLER_13_271 vssd1 vssd1 vccd1 vccd1 sky130_fd_sc_hd__fill_1
Xclkload23 clknet_leaf_29_clk vssd1 vssd1 vccd1 vccd1 clkload23/Y sky130_fd_sc_hd__inv_6
X_1424_ CALC_INST.gencon_inst.ALU_in1\[12\] CALC_INST.gencon_inst.ALU_in2\[12\] net66
+ vssd1 vssd1 vccd1 vccd1 _0687_ sky130_fd_sc_hd__mux2_1
X_2473_ _1058_ _0383_ vssd1 vssd1 vccd1 vccd1 _0595_ sky130_fd_sc_hd__nor2_1
X_1355_ _0617_ net212 net39 vssd1 vssd1 vccd1 vccd1 _0136_ sky130_fd_sc_hd__mux2_1
X_1286_ CALC_INST.gencon_inst.key_read _0384_ _0389_ vssd1 vssd1 vccd1 vccd1 _0639_
+ sky130_fd_sc_hd__and3_1
XFILLER_50_17 vssd1 vssd1 vccd1 vccd1 sky130_fd_sc_hd__fill_1
XFILLER_34_29 vssd1 vssd1 vccd1 vccd1 sky130_fd_sc_hd__fill_1
Xclkload6 clknet_leaf_31_clk vssd1 vssd1 vccd1 vccd1 clkload6/X sky130_fd_sc_hd__clkbuf_8
XFILLER_59_59 vssd1 vssd1 vccd1 vccd1 sky130_fd_sc_hd__fill_8
X_2809_ clknet_leaf_2_clk net1 net115 vssd1 vssd1 vccd1 vccd1 CALC_INST.input_ctrl_inst.RowMid\[0\]
+ sky130_fd_sc_hd__dfstp_1
XFILLER_46_138 vssd1 vssd1 vccd1 vccd1 sky130_fd_sc_hd__fill_2
XANTENNA_fanout62_A net63 vssd1 vssd1 vccd1 vccd1 sky130_fd_sc_hd__diode_2
XANTENNA__1397__S net109 vssd1 vssd1 vccd1 vccd1 sky130_fd_sc_hd__diode_2
XFILLER_40_72 vssd1 vssd1 vccd1 vccd1 sky130_fd_sc_hd__fill_2
XTAP_TAPCELL_ROW_12_225 vssd1 vccd1 sky130_fd_sc_hd__tapvpwrvgnd_1
XTAP_TAPCELL_ROW_20_280 vssd1 vccd1 sky130_fd_sc_hd__tapvpwrvgnd_1
XFILLER_40_83 vssd1 vssd1 vccd1 vccd1 sky130_fd_sc_hd__fill_1
XFILLER_27_7 vssd1 vssd1 vccd1 vccd1 sky130_fd_sc_hd__fill_1
XFILLER_1_55 vssd1 vssd1 vccd1 vccd1 sky130_fd_sc_hd__fill_1
XFILLER_60_141 vssd1 vssd1 vccd1 vccd1 sky130_fd_sc_hd__fill_8
X_1973_ _1037_ _1038_ vssd1 vssd1 vccd1 vccd1 _0368_ sky130_fd_sc_hd__nor2_1
X_2525_ clknet_leaf_4_clk _0063_ net128 vssd1 vssd1 vccd1 vccd1 net29 sky130_fd_sc_hd__dfrtp_1
XANTENNA__2339__A1 _0404_ vssd1 vssd1 vccd1 vccd1 sky130_fd_sc_hd__diode_2
X_1407_ net391 _0678_ net108 vssd1 vssd1 vccd1 vccd1 _0162_ sky130_fd_sc_hd__mux2_1
X_1338_ net227 _0644_ _0645_ CALC_INST.gencon_inst.operator_input\[2\] vssd1 vssd1
+ vccd1 vccd1 _0125_ sky130_fd_sc_hd__a22o_1
X_2456_ CALC_INST.gencon_inst.ALU_out\[12\] net69 net59 CALC_INST.gencon_inst.mult_calc.out\[12\]
+ _0524_ vssd1 vssd1 vccd1 vccd1 _0582_ sky130_fd_sc_hd__a221o_1
X_2387_ CALC_INST.gencon_inst.operand1\[0\] CALC_INST.gencon_inst.latched_keypad_input\[0\]
+ vssd1 vssd1 vccd1 vccd1 _0525_ sky130_fd_sc_hd__nand2_1
Xhold18 CALC_INST.gencon_inst.mult_calc.INn1\[2\] vssd1 vssd1 vccd1 vccd1 net214 sky130_fd_sc_hd__dlygate4sd3_1
Xhold29 CALC_INST.gencon_inst.mult_calc.main.GENERATE_ADDER\[10\].thingy.in1 vssd1
+ vssd1 vccd1 vccd1 net225 sky130_fd_sc_hd__dlygate4sd3_1
XFILLER_43_108 vssd1 vssd1 vccd1 vccd1 sky130_fd_sc_hd__fill_4
X_1269_ CALC_INST.gencon_inst.operand2\[13\] _0392_ net69 CALC_INST.gencon_inst.ALU_out\[13\]
+ _0590_ vssd1 vssd1 vccd1 vccd1 _0627_ sky130_fd_sc_hd__a221o_1
XFILLER_10_53 vssd1 vssd1 vccd1 vccd1 sky130_fd_sc_hd__fill_4
XFILLER_59_285 vssd1 vssd1 vccd1 vccd1 sky130_fd_sc_hd__fill_4
XFILLER_42_130 vssd1 vssd1 vccd1 vccd1 sky130_fd_sc_hd__fill_1
XFILLER_35_72 vssd1 vssd1 vccd1 vccd1 sky130_fd_sc_hd__fill_1
X_2172_ CALC_INST.input_ctrl_inst.debounce_cnt\[11\] _1077_ _1197_ vssd1 vssd1 vccd1
+ vccd1 _1205_ sky130_fd_sc_hd__o21ai_1
X_2241_ CALC_INST.equal_input CALC_INST.gencon_inst.read_input vssd1 vssd1 vccd1 vccd1
+ _0406_ sky130_fd_sc_hd__and2b_1
X_2310_ CALC_INST.gencon_inst.operand2\[1\] CALC_INST.gencon_inst.latched_keypad_input\[1\]
+ vssd1 vssd1 vccd1 vccd1 _0462_ sky130_fd_sc_hd__or2_1
XFILLER_18_3 vssd1 vssd1 vccd1 vccd1 sky130_fd_sc_hd__fill_4
XFILLER_53_406 vssd1 vssd1 vccd1 vccd1 sky130_fd_sc_hd__fill_1
XTAP_TAPCELL_ROW_48_475 vssd1 vccd1 sky130_fd_sc_hd__tapvpwrvgnd_1
X_1956_ _1028_ _1029_ vssd1 vssd1 vccd1 vccd1 _0360_ sky130_fd_sc_hd__and2b_1
X_1887_ CALC_INST.input_ctrl_inst.col_index\[27\] net62 _0945_ _0991_ vssd1 vssd1
+ vccd1 vccd1 _0992_ sky130_fd_sc_hd__o2bb2a_1
Xoutput19 net19 vssd1 vssd1 vccd1 vccd1 gpio_out[23] sky130_fd_sc_hd__buf_2
X_2508_ clknet_leaf_12_clk _0050_ net145 vssd1 vssd1 vccd1 vccd1 CALC_INST.gencon_inst.operand1\[3\]
+ sky130_fd_sc_hd__dfrtp_1
XFILLER_56_27 vssd1 vssd1 vccd1 vccd1 sky130_fd_sc_hd__fill_1
X_2439_ CALC_INST.gencon_inst.operand1\[7\] CALC_INST.gencon_inst.operand1\[8\] CALC_INST.gencon_inst.operand1\[9\]
+ _0556_ vssd1 vssd1 vccd1 vccd1 _0568_ sky130_fd_sc_hd__and4_1
XFILLER_24_174 vssd1 vssd1 vccd1 vccd1 sky130_fd_sc_hd__fill_2
XFILLER_8_307 vssd1 vssd1 vccd1 vccd1 sky130_fd_sc_hd__fill_1
XANTENNA__2360__A CALC_INST.gencon_inst.operand2\[10\] vssd1 vssd1 vccd1 vccd1 sky130_fd_sc_hd__diode_2
XFILLER_62_269 vssd1 vssd1 vccd1 vccd1 sky130_fd_sc_hd__fill_2
XFILLER_46_60 vssd1 vssd1 vccd1 vccd1 sky130_fd_sc_hd__fill_1
XTAP_TAPCELL_ROW_45_456 vssd1 vccd1 sky130_fd_sc_hd__tapvpwrvgnd_1
XFILLER_15_130 vccd1 vssd1 vccd1 vssd1 sky130_ef_sc_hd__decap_40_12
XFILLER_62_70 vccd1 vssd1 vccd1 vssd1 sky130_ef_sc_hd__decap_40_12
XANTENNA__1585__S CALC_INST.gencon_inst.add_calc.state\[1\] vssd1 vssd1 vccd1 vccd1
+ sky130_fd_sc_hd__diode_2
XFILLER_30_199 vssd1 vssd1 vccd1 vccd1 sky130_fd_sc_hd__fill_1
X_1810_ _1082_ _0939_ _0940_ _0941_ vssd1 vssd1 vccd1 vccd1 _0942_ sky130_fd_sc_hd__nor4_1
X_2790_ clknet_leaf_32_clk _0315_ net117 vssd1 vssd1 vccd1 vccd1 CALC_INST.input_ctrl_inst.col_index\[13\]
+ sky130_fd_sc_hd__dfrtp_1
XFILLER_7_32 vccd1 vssd1 vccd1 vssd1 sky130_ef_sc_hd__decap_40_12
X_1741_ net94 CALC_INST.gencon_inst.mult_calc.adderSave\[14\] net77 net352 vssd1 vssd1
+ vccd1 vccd1 _0252_ sky130_fd_sc_hd__a22o_1
X_1672_ net432 net87 _0903_ net100 vssd1 vssd1 vccd1 vccd1 _0202_ sky130_fd_sc_hd__a22o_1
XFILLER_7_373 vssd1 vssd1 vccd1 vccd1 sky130_fd_sc_hd__fill_2
X_2155_ CALC_INST.input_ctrl_inst.debounce_cnt\[7\] _1190_ vssd1 vssd1 vccd1 vccd1
+ _1192_ sky130_fd_sc_hd__or2_1
XANTENNA__2478__B1 net56 vssd1 vssd1 vccd1 vccd1 sky130_fd_sc_hd__diode_2
X_2224_ CALC_INST.gencon_inst.ALU_finish _0389_ vssd1 vssd1 vccd1 vccd1 _0390_ sky130_fd_sc_hd__or2_1
XFILLER_38_255 vssd1 vssd1 vccd1 vccd1 sky130_fd_sc_hd__fill_2
XFILLER_53_225 vssd1 vssd1 vccd1 vccd1 sky130_fd_sc_hd__fill_1
X_2086_ CALC_INST.gencon_inst.mult_calc.INn2\[1\] CALC_INST.gencon_inst.mult_calc.INn2\[0\]
+ CALC_INST.gencon_inst.mult_calc.INn2\[3\] _1139_ vssd1 vssd1 vccd1 vccd1 _1140_
+ sky130_fd_sc_hd__or4_1
X_1939_ _1151_ _1003_ vssd1 vssd1 vccd1 vccd1 _1020_ sky130_fd_sc_hd__nor2_1
XFILLER_44_236 vssd1 vssd1 vccd1 vccd1 sky130_fd_sc_hd__fill_1
XANTENNA__2355__A CALC_INST.gencon_inst.operand2\[9\] vssd1 vssd1 vccd1 vccd1 sky130_fd_sc_hd__diode_2
XFILLER_29_277 vssd1 vssd1 vccd1 vccd1 sky130_fd_sc_hd__fill_2
XFILLER_29_233 vssd1 vssd1 vccd1 vccd1 sky130_fd_sc_hd__fill_1
XFILLER_29_222 vssd1 vssd1 vccd1 vccd1 sky130_fd_sc_hd__fill_2
XTAP_TAPCELL_ROW_50_492 vssd1 vccd1 sky130_fd_sc_hd__tapvpwrvgnd_1
XTAP_TAPCELL_ROW_42_437 vssd1 vccd1 sky130_fd_sc_hd__tapvpwrvgnd_1
XFILLER_32_40 vssd1 vssd1 vccd1 vccd1 sky130_fd_sc_hd__fill_1
XPHY_EDGE_ROW_11_Right_11 vssd1 vssd1 vccd1 vccd1 sky130_fd_sc_hd__decap_3
XPHY_EDGE_ROW_20_Right_20 vssd1 vssd1 vccd1 vccd1 sky130_fd_sc_hd__decap_3
XFILLER_57_92 vccd1 vssd1 vccd1 vssd1 sky130_ef_sc_hd__decap_40_12
XTAP_TAPCELL_ROW_7_192 vssd1 vccd1 sky130_fd_sc_hd__tapvpwrvgnd_1
XFILLER_43_291 vssd1 vssd1 vccd1 vccd1 sky130_fd_sc_hd__fill_2
X_2842_ clknet_leaf_8_clk _0020_ net127 vssd1 vssd1 vccd1 vccd1 CALC_INST.input_ctrl_inst.debounce_cnt\[3\]
+ sky130_fd_sc_hd__dfrtp_1
Xhold126 CALC_INST.gencon_inst.add_calc.main.in2\[12\] vssd1 vssd1 vccd1 vccd1 net322
+ sky130_fd_sc_hd__dlygate4sd3_1
X_2773_ clknet_leaf_6_clk _0031_ net124 vssd1 vssd1 vccd1 vccd1 CALC_INST.input_ctrl_inst.read_input_flag
+ sky130_fd_sc_hd__dfrtp_1
Xhold104 CALC_INST.gencon_inst.mult_calc.out\[15\] vssd1 vssd1 vccd1 vccd1 net300
+ sky130_fd_sc_hd__dlygate4sd3_1
Xhold115 _0207_ vssd1 vssd1 vccd1 vccd1 net311 sky130_fd_sc_hd__dlygate4sd3_1
X_1724_ net276 net233 net97 vssd1 vssd1 vccd1 vccd1 _0236_ sky130_fd_sc_hd__mux2_1
X_1586_ _0823_ _0826_ _0829_ net32 vssd1 vssd1 vccd1 vccd1 _0832_ sky130_fd_sc_hd__o31a_1
Xhold137 CALC_INST.gencon_inst.add_calc.sameSignVal vssd1 vssd1 vccd1 vccd1 net333
+ sky130_fd_sc_hd__dlygate4sd3_1
Xhold148 CALC_INST.gencon_inst.mult_calc.INn2\[7\] vssd1 vssd1 vccd1 vccd1 net344
+ sky130_fd_sc_hd__dlygate4sd3_1
X_1655_ _0887_ _0888_ vssd1 vssd1 vccd1 vccd1 _0889_ sky130_fd_sc_hd__and2b_1
Xhold159 CALC_INST.gencon_inst.mult_calc.count.GENERATE_ADDER\[12\].thingy.in1 vssd1
+ vssd1 vccd1 vccd1 net355 sky130_fd_sc_hd__dlygate4sd3_1
X_2138_ CALC_INST.input_ctrl_inst.debounce_cnt\[0\] CALC_INST.input_ctrl_inst.debounce_cnt\[1\]
+ CALC_INST.input_ctrl_inst.debounce_cnt\[2\] vssd1 vssd1 vccd1 vccd1 _1180_ sky130_fd_sc_hd__a21o_1
XTAP_TAPCELL_ROW_56_529 vssd1 vccd1 sky130_fd_sc_hd__tapvpwrvgnd_1
XFILLER_53_17 vssd1 vssd1 vccd1 vccd1 sky130_fd_sc_hd__fill_1
X_2207_ CALC_INST.gencon_inst.gencon_state\[1\] CALC_INST.gencon_inst.gencon_state\[2\]
+ vssd1 vssd1 vccd1 vccd1 _1232_ sky130_fd_sc_hd__nor2_1
X_2069_ _1093_ _1122_ vssd1 vssd1 vccd1 vccd1 _1123_ sky130_fd_sc_hd__or2_1
XTAP_TAPCELL_ROW_64_595 vssd1 vccd1 sky130_fd_sc_hd__tapvpwrvgnd_1
XFILLER_53_28 vssd1 vssd1 vccd1 vccd1 sky130_fd_sc_hd__fill_1
XFILLER_5_129 vssd1 vssd1 vccd1 vccd1 sky130_fd_sc_hd__fill_2
XANTENNA_fanout92_A net94 vssd1 vssd1 vccd1 vccd1 sky130_fd_sc_hd__diode_2
XFILLER_64_309 vccd1 vssd1 vccd1 vssd1 sky130_ef_sc_hd__decap_40_12
XFILLER_1_357 vccd1 vssd1 vccd1 vssd1 sky130_ef_sc_hd__decap_40_12
XFILLER_1_335 vssd1 vssd1 vccd1 vccd1 sky130_fd_sc_hd__fill_1
XANTENNA__1665__B2 net86 vssd1 vssd1 vccd1 vccd1 sky130_fd_sc_hd__diode_2
XANTENNA__1665__A1 net100 vssd1 vssd1 vccd1 vccd1 sky130_fd_sc_hd__diode_2
XFILLER_40_261 vssd1 vssd1 vccd1 vccd1 sky130_fd_sc_hd__fill_2
X_1371_ net445 _0660_ net107 vssd1 vssd1 vccd1 vccd1 _0144_ sky130_fd_sc_hd__mux2_1
X_1440_ net104 CALC_INST.gencon_inst.add_calc.main.in2\[12\] vssd1 vssd1 vccd1 vccd1
+ _0699_ sky130_fd_sc_hd__nand2_1
XFILLER_4_195 vssd1 vssd1 vccd1 vccd1 sky130_fd_sc_hd__fill_1
XFILLER_4_55 vssd1 vssd1 vccd1 vccd1 sky130_fd_sc_hd__fill_1
XFILLER_63_331 vssd1 vssd1 vccd1 vccd1 sky130_fd_sc_hd__fill_4
XFILLER_48_383 vssd1 vssd1 vccd1 vccd1 sky130_fd_sc_hd__fill_2
XTAP_TAPCELL_ROW_61_565 vssd1 vccd1 sky130_fd_sc_hd__tapvpwrvgnd_1
XANTENNA__2426__C _0519_ vssd1 vssd1 vccd1 vccd1 sky130_fd_sc_hd__diode_2
XFILLER_31_261 vssd1 vssd1 vccd1 vccd1 sky130_fd_sc_hd__fill_1
X_2825_ clknet_leaf_25_clk _0346_ net140 vssd1 vssd1 vccd1 vccd1 CALC_INST.gencon_inst.mult_calc.count.GENERATE_ADDER\[12\].thingy.in1
+ sky130_fd_sc_hd__dfrtp_1
XTAP_TAPCELL_ROW_18_264 vssd1 vccd1 sky130_fd_sc_hd__tapvpwrvgnd_1
X_2756_ clknet_leaf_2_clk net198 net115 vssd1 vssd1 vccd1 vccd1 CALC_INST.input_ctrl_inst.RowSync\[3\]
+ sky130_fd_sc_hd__dfstp_1
X_2687_ clknet_leaf_30_clk _0225_ net137 vssd1 vssd1 vccd1 vccd1 CALC_INST.gencon_inst.mult_calc.main.GENERATE_ADDER\[3\].thingy.in1
+ sky130_fd_sc_hd__dfrtp_1
X_1707_ net357 net349 net97 vssd1 vssd1 vccd1 vccd1 _0219_ sky130_fd_sc_hd__mux2_1
X_1638_ net99 _0873_ _0874_ net314 net84 vssd1 vssd1 vccd1 vccd1 _0197_ sky130_fd_sc_hd__a32o_1
X_1569_ _0813_ _0815_ vssd1 vssd1 vccd1 vccd1 _0818_ sky130_fd_sc_hd__or2_1
XFILLER_46_309 vssd1 vssd1 vccd1 vccd1 sky130_fd_sc_hd__fill_8
XFILLER_64_49 vssd1 vssd1 vccd1 vccd1 sky130_fd_sc_hd__fill_2
XFILLER_64_27 vssd1 vssd1 vccd1 vccd1 sky130_fd_sc_hd__fill_1
Xfanout32 net33 vssd1 vssd1 vccd1 vccd1 net32 sky130_fd_sc_hd__buf_2
Xfanout65 _0659_ vssd1 vssd1 vccd1 vccd1 net65 sky130_fd_sc_hd__clkbuf_2
Xfanout54 _0595_ vssd1 vssd1 vccd1 vccd1 net54 sky130_fd_sc_hd__clkbuf_4
Xfanout43 _0523_ vssd1 vssd1 vccd1 vccd1 net43 sky130_fd_sc_hd__clkbuf_2
XANTENNA__1249__A _1234_ vssd1 vssd1 vccd1 vccd1 sky130_fd_sc_hd__diode_2
XFILLER_22_261 vssd1 vssd1 vccd1 vccd1 sky130_fd_sc_hd__fill_1
XFILLER_13_31 vssd1 vssd1 vccd1 vccd1 sky130_fd_sc_hd__fill_1
Xfanout76 _1145_ vssd1 vssd1 vccd1 vccd1 net76 sky130_fd_sc_hd__clkbuf_2
Xfanout87 _0843_ vssd1 vssd1 vccd1 vccd1 net87 sky130_fd_sc_hd__clkbuf_2
Xfanout98 CALC_INST.gencon_inst.mult_calc.state\[3\] vssd1 vssd1 vccd1 vccd1 net98
+ sky130_fd_sc_hd__clkbuf_2
XFILLER_64_139 vssd1 vssd1 vccd1 vccd1 sky130_fd_sc_hd__fill_1
XFILLER_49_169 vssd1 vssd1 vccd1 vccd1 sky130_fd_sc_hd__fill_2
XANTENNA__1638__B2 net84 vssd1 vssd1 vccd1 vccd1 sky130_fd_sc_hd__diode_2
XFILLER_54_82 vssd1 vssd1 vccd1 vccd1 sky130_fd_sc_hd__fill_2
XFILLER_45_386 vssd1 vssd1 vccd1 vccd1 sky130_fd_sc_hd__fill_4
XTAP_TAPCELL_ROW_15_245 vssd1 vccd1 sky130_fd_sc_hd__tapvpwrvgnd_1
Xclkload13 clknet_leaf_8_clk vssd1 vssd1 vccd1 vccd1 clkload13/Y sky130_fd_sc_hd__bufinv_16
X_2610_ clknet_leaf_14_clk _0148_ net147 vssd1 vssd1 vccd1 vccd1 CALC_INST.gencon_inst.add_calc.main.GENERATE_ADDER\[4\].thingy.in1
+ sky130_fd_sc_hd__dfrtp_1
X_2541_ clknet_leaf_5_clk _0079_ net128 vssd1 vssd1 vccd1 vccd1 CALC_INST.complete
+ sky130_fd_sc_hd__dfrtp_1
Xclkload24 clknet_leaf_12_clk vssd1 vssd1 vccd1 vccd1 clkload24/Y sky130_fd_sc_hd__inv_6
X_2472_ CALC_INST.gencon_inst.operand2\[0\] CALC_INST.gencon_inst.operand1\[0\] net72
+ vssd1 vssd1 vccd1 vccd1 _0594_ sky130_fd_sc_hd__mux2_1
X_1423_ net376 _0686_ net110 vssd1 vssd1 vccd1 vccd1 _0170_ sky130_fd_sc_hd__mux2_1
X_1285_ CALC_INST.gencon_inst.operand1\[15\] _0635_ _0637_ _0638_ vssd1 vssd1 vccd1
+ vccd1 _0080_ sky130_fd_sc_hd__o22a_1
X_1354_ _0652_ net226 net39 vssd1 vssd1 vccd1 vccd1 _0135_ sky130_fd_sc_hd__mux2_1
XFILLER_34_19 vssd1 vssd1 vccd1 vccd1 sky130_fd_sc_hd__fill_8
X_2808_ clknet_leaf_34_clk _0333_ net113 vssd1 vssd1 vccd1 vccd1 CALC_INST.input_ctrl_inst.col_index\[31\]
+ sky130_fd_sc_hd__dfrtp_1
Xclkload7 clknet_leaf_33_clk vssd1 vssd1 vccd1 vccd1 clkload7/Y sky130_fd_sc_hd__inv_12
X_2739_ clknet_leaf_27_clk _0277_ net135 vssd1 vssd1 vccd1 vccd1 CALC_INST.gencon_inst.mult_calc.countSave\[6\]
+ sky130_fd_sc_hd__dfrtp_1
XANTENNA_fanout55_A _0595_ vssd1 vssd1 vccd1 vccd1 sky130_fd_sc_hd__diode_2
XFILLER_61_109 vssd1 vssd1 vccd1 vccd1 sky130_fd_sc_hd__fill_2
XFILLER_24_74 vssd1 vssd1 vccd1 vccd1 sky130_fd_sc_hd__fill_2
XTAP_TAPCELL_ROW_12_226 vssd1 vccd1 sky130_fd_sc_hd__tapvpwrvgnd_1
XTAP_TAPCELL_ROW_20_281 vssd1 vccd1 sky130_fd_sc_hd__tapvpwrvgnd_1
XFILLER_60_197 vssd1 vssd1 vccd1 vccd1 sky130_fd_sc_hd__fill_4
X_1972_ CALC_INST.input_ctrl_inst.scan_timer\[10\] _1036_ net360 vssd1 vssd1 vccd1
+ vccd1 _1038_ sky130_fd_sc_hd__a21oi_1
XPHY_EDGE_ROW_49_Right_49 vssd1 vssd1 vccd1 vccd1 sky130_fd_sc_hd__decap_3
X_2524_ clknet_leaf_5_clk CALC_INST.gencon_inst.next_state\[3\] net128 vssd1 vssd1
+ vccd1 vccd1 CALC_INST.gencon_inst.gencon_state\[3\] sky130_fd_sc_hd__dfrtp_4
X_2455_ CALC_INST.gencon_inst.operand1\[12\] _0576_ _0580_ vssd1 vssd1 vccd1 vccd1
+ _0581_ sky130_fd_sc_hd__o21a_1
XPHY_EDGE_ROW_58_Right_58 vssd1 vssd1 vccd1 vccd1 sky130_fd_sc_hd__decap_3
XFILLER_56_404 vssd1 vssd1 vccd1 vccd1 sky130_fd_sc_hd__fill_2
X_1406_ CALC_INST.gencon_inst.ALU_in1\[3\] CALC_INST.gencon_inst.ALU_in2\[3\] net64
+ vssd1 vssd1 vccd1 vccd1 _0678_ sky130_fd_sc_hd__mux2_1
Xhold19 CALC_INST.gencon_inst.prev_operator_input\[0\] vssd1 vssd1 vccd1 vccd1 net215
+ sky130_fd_sc_hd__dlygate4sd3_1
X_1337_ net205 _0644_ _0645_ CALC_INST.gencon_inst.operator_input\[1\] vssd1 vssd1
+ vccd1 vccd1 _0124_ sky130_fd_sc_hd__a22o_1
X_2386_ _0383_ net58 _0385_ vssd1 vssd1 vccd1 vccd1 _0524_ sky130_fd_sc_hd__a21o_1
X_1268_ CALC_INST.gencon_inst.operand1\[12\] _0397_ _0592_ net423 _0626_ vssd1 vssd1
+ vccd1 vccd1 _0075_ sky130_fd_sc_hd__o221a_1
XFILLER_28_139 vssd1 vssd1 vccd1 vccd1 sky130_fd_sc_hd__fill_1
XFILLER_51_164 vssd1 vssd1 vccd1 vccd1 sky130_fd_sc_hd__fill_4
XFILLER_47_404 vssd1 vssd1 vccd1 vccd1 sky130_fd_sc_hd__fill_2
XANTENNA_fanout58_X net58 vssd1 vssd1 vccd1 vccd1 sky130_fd_sc_hd__diode_2
XFILLER_19_85 vssd1 vssd1 vccd1 vccd1 sky130_fd_sc_hd__fill_2
X_2171_ CALC_INST.input_ctrl_inst.debounce_cnt\[11\] CALC_INST.input_ctrl_inst.debounce_cnt\[10\]
+ _1199_ vssd1 vssd1 vccd1 vccd1 _1204_ sky130_fd_sc_hd__and3_1
X_2240_ CALC_INST.gencon_inst.gencon_state\[0\] _1236_ vssd1 vssd1 vccd1 vccd1 _0405_
+ sky130_fd_sc_hd__nand2_4
XTAP_TAPCELL_ROW_48_476 vssd1 vccd1 sky130_fd_sc_hd__tapvpwrvgnd_1
XFILLER_33_175 vssd1 vssd1 vccd1 vccd1 sky130_fd_sc_hd__fill_1
XANTENNA__2450__B _0519_ vssd1 vssd1 vccd1 vccd1 sky130_fd_sc_hd__diode_2
XTAP_TAPCELL_ROW_31_354 vssd1 vccd1 sky130_fd_sc_hd__tapvpwrvgnd_1
X_1955_ CALC_INST.input_ctrl_inst.scan_timer\[1\] CALC_INST.input_ctrl_inst.scan_timer\[2\]
+ _1023_ CALC_INST.input_ctrl_inst.scan_timer\[3\] vssd1 vssd1 vccd1 vccd1 _1029_
+ sky130_fd_sc_hd__a31o_1
X_1886_ CALC_INST.input_ctrl_inst.col_index\[27\] CALC_INST.input_ctrl_inst.col_index\[26\]
+ _0987_ vssd1 vssd1 vccd1 vccd1 _0991_ sky130_fd_sc_hd__and3_1
XANTENNA__1768__B1 net84 vssd1 vssd1 vccd1 vccd1 sky130_fd_sc_hd__diode_2
XANTENNA_fanout105_A net106 vssd1 vssd1 vccd1 vccd1 sky130_fd_sc_hd__diode_2
X_2438_ CALC_INST.gencon_inst.operand1\[8\] net43 _0566_ _0567_ vssd1 vssd1 vccd1
+ vccd1 _0055_ sky130_fd_sc_hd__o22a_1
X_2507_ clknet_leaf_11_clk _0049_ net131 vssd1 vssd1 vccd1 vccd1 CALC_INST.gencon_inst.operand1\[2\]
+ sky130_fd_sc_hd__dfrtp_1
XTAP_TAPCELL_ROW_39_410 vssd1 vccd1 sky130_fd_sc_hd__tapvpwrvgnd_1
X_2369_ CALC_INST.gencon_inst.operand2\[12\] _0505_ _0404_ vssd1 vssd1 vccd1 vccd1
+ _0510_ sky130_fd_sc_hd__o21ai_1
XFILLER_24_197 vssd1 vssd1 vccd1 vccd1 sky130_fd_sc_hd__fill_1
XFILLER_21_86 vssd1 vssd1 vccd1 vccd1 sky130_fd_sc_hd__fill_4
XFILLER_47_256 vssd1 vssd1 vccd1 vccd1 sky130_fd_sc_hd__fill_1
XFILLER_47_234 vssd1 vssd1 vccd1 vccd1 sky130_fd_sc_hd__fill_4
XFILLER_62_226 vssd1 vssd1 vccd1 vccd1 sky130_fd_sc_hd__fill_2
XFILLER_46_83 vssd1 vssd1 vccd1 vccd1 sky130_fd_sc_hd__fill_1
XTAP_TAPCELL_ROW_45_457 vssd1 vccd1 sky130_fd_sc_hd__tapvpwrvgnd_1
XFILLER_62_82 vssd1 vssd1 vccd1 vccd1 sky130_fd_sc_hd__fill_2
XFILLER_7_44 vssd1 vssd1 vccd1 vccd1 sky130_fd_sc_hd__fill_1
XFILLER_7_55 vssd1 vssd1 vccd1 vccd1 sky130_fd_sc_hd__fill_1
XFILLER_7_77 vssd1 vssd1 vccd1 vccd1 sky130_fd_sc_hd__fill_2
X_1740_ net94 net325 net78 net335 vssd1 vssd1 vccd1 vccd1 _0251_ sky130_fd_sc_hd__a22o_1
X_1671_ _0900_ _0902_ vssd1 vssd1 vccd1 vccd1 _0903_ sky130_fd_sc_hd__xnor2_1
X_2154_ _1176_ _1189_ _1191_ net46 net425 vssd1 vssd1 vccd1 vccd1 _0023_ sky130_fd_sc_hd__a32o_1
X_2223_ _1235_ _0388_ vssd1 vssd1 vccd1 vccd1 _0389_ sky130_fd_sc_hd__or2_1
X_2085_ CALC_INST.gencon_inst.mult_calc.INn2\[5\] CALC_INST.gencon_inst.mult_calc.INn2\[4\]
+ CALC_INST.gencon_inst.mult_calc.INn2\[7\] CALC_INST.gencon_inst.mult_calc.INn2\[6\]
+ vssd1 vssd1 vccd1 vccd1 _1139_ sky130_fd_sc_hd__or4_1
X_1938_ _1004_ _1018_ _1019_ net216 net111 vssd1 vssd1 vccd1 vccd1 _0352_ sky130_fd_sc_hd__a32o_1
X_1869_ _0947_ _0979_ CALC_INST.input_ctrl_inst.col_index\[21\] net63 vssd1 vssd1
+ vccd1 vccd1 _0323_ sky130_fd_sc_hd__a2bb2o_1
XANTENNA__1913__B1 net77 vssd1 vssd1 vccd1 vccd1 sky130_fd_sc_hd__diode_2
XFILLER_29_289 vssd1 vssd1 vccd1 vccd1 sky130_fd_sc_hd__fill_2
XTAP_TAPCELL_ROW_50_493 vssd1 vccd1 sky130_fd_sc_hd__tapvpwrvgnd_1
XFILLER_32_52 vssd1 vssd1 vccd1 vccd1 sky130_fd_sc_hd__fill_2
XFILLER_8_149 vccd1 vssd1 vccd1 vssd1 sky130_ef_sc_hd__decap_40_12
XANTENNA__1904__B1 net75 vssd1 vssd1 vccd1 vccd1 sky130_fd_sc_hd__diode_2
XANTENNA_clkload0_A clknet_2_1__leaf_clk vssd1 vssd1 vccd1 vccd1 sky130_fd_sc_hd__diode_2
X_2841_ clknet_leaf_8_clk _0019_ net127 vssd1 vssd1 vccd1 vccd1 CALC_INST.input_ctrl_inst.debounce_cnt\[2\]
+ sky130_fd_sc_hd__dfrtp_1
XFILLER_35_248 vssd1 vssd1 vccd1 vccd1 sky130_fd_sc_hd__fill_1
Xhold138 CALC_INST.gencon_inst.add_calc.main.in2\[8\] vssd1 vssd1 vccd1 vccd1 net334
+ sky130_fd_sc_hd__dlygate4sd3_1
Xhold105 CALC_INST.gencon_inst.add_calc.start vssd1 vssd1 vccd1 vccd1 net301 sky130_fd_sc_hd__dlygate4sd3_1
Xhold116 CALC_INST.gencon_inst.ALU_in1\[1\] vssd1 vssd1 vccd1 vccd1 net312 sky130_fd_sc_hd__dlygate4sd3_1
Xhold149 _0293_ vssd1 vssd1 vccd1 vccd1 net345 sky130_fd_sc_hd__dlygate4sd3_1
X_2772_ clknet_leaf_3_clk net235 vssd1 vssd1 vccd1 vccd1 CALC_INST.gencon_inst.mult_calc.INn2\[15\]
+ sky130_fd_sc_hd__dfxtp_1
Xhold127 CALC_INST.gencon_inst.mult_calc.INn2\[9\] vssd1 vssd1 vccd1 vccd1 net323
+ sky130_fd_sc_hd__dlygate4sd3_1
X_1654_ CALC_INST.gencon_inst.mult_calc.main.GENERATE_ADDER\[8\].thingy.in2 CALC_INST.gencon_inst.mult_calc.main.GENERATE_ADDER\[8\].thingy.in1
+ vssd1 vssd1 vccd1 vccd1 _0888_ sky130_fd_sc_hd__nand2_1
X_1723_ CALC_INST.gencon_inst.mult_calc.main.GENERATE_ADDER\[13\].thingy.in1 net238
+ net98 vssd1 vssd1 vccd1 vccd1 _0235_ sky130_fd_sc_hd__mux2_1
XFILLER_58_307 vssd1 vssd1 vccd1 vccd1 sky130_fd_sc_hd__fill_1
X_1585_ net461 _0831_ CALC_INST.gencon_inst.add_calc.state\[1\] vssd1 vssd1 vccd1
+ vccd1 _0187_ sky130_fd_sc_hd__mux2_1
X_2206_ _1073_ _1229_ _1231_ vssd1 vssd1 vccd1 vccd1 _0017_ sky130_fd_sc_hd__a21oi_1
XTAP_TAPCELL_ROW_64_585 vssd1 vccd1 sky130_fd_sc_hd__tapvpwrvgnd_1
X_2137_ CALC_INST.input_ctrl_inst.debounce_cnt\[2\] CALC_INST.input_ctrl_inst.debounce_cnt\[0\]
+ CALC_INST.input_ctrl_inst.debounce_cnt\[1\] vssd1 vssd1 vccd1 vccd1 _1179_ sky130_fd_sc_hd__nand3_1
X_2068_ CALC_INST.gencon_inst.mult_calc.count.GENERATE_ADDER\[9\].thingy.in1 _1092_
+ vssd1 vssd1 vccd1 vccd1 _1122_ sky130_fd_sc_hd__nor2_1
XTAP_TAPCELL_ROW_64_596 vssd1 vccd1 sky130_fd_sc_hd__tapvpwrvgnd_1
XFILLER_1_369 vccd1 vssd1 vccd1 vssd1 sky130_ef_sc_hd__decap_40_12
XANTENNA_fanout85_A _0843_ vssd1 vssd1 vccd1 vccd1 sky130_fd_sc_hd__diode_2
XFILLER_40_251 vssd1 vssd1 vccd1 vccd1 sky130_fd_sc_hd__fill_1
XFILLER_25_281 vssd1 vssd1 vccd1 vccd1 sky130_fd_sc_hd__fill_4
X_1370_ CALC_INST.gencon_inst.ALU_in2\[0\] CALC_INST.gencon_inst.ALU_in1\[0\] net64
+ vssd1 vssd1 vccd1 vccd1 _0660_ sky130_fd_sc_hd__mux2_1
XTAP_TAPCELL_ROW_18_265 vssd1 vccd1 sky130_fd_sc_hd__tapvpwrvgnd_1
XTAP_TAPCELL_ROW_61_566 vssd1 vccd1 sky130_fd_sc_hd__tapvpwrvgnd_1
XANTENNA__2369__B1 _0404_ vssd1 vssd1 vccd1 vccd1 sky130_fd_sc_hd__diode_2
X_2824_ clknet_leaf_26_clk _0345_ net140 vssd1 vssd1 vccd1 vccd1 CALC_INST.gencon_inst.mult_calc.count.GENERATE_ADDER\[11\].thingy.in1
+ sky130_fd_sc_hd__dfrtp_1
X_2755_ clknet_leaf_2_clk net199 net115 vssd1 vssd1 vccd1 vccd1 CALC_INST.input_ctrl_inst.RowSync\[2\]
+ sky130_fd_sc_hd__dfstp_1
X_2686_ clknet_leaf_30_clk _0224_ net122 vssd1 vssd1 vccd1 vccd1 CALC_INST.gencon_inst.mult_calc.main.GENERATE_ADDER\[2\].thingy.in1
+ sky130_fd_sc_hd__dfrtp_1
X_1706_ net420 net340 net97 vssd1 vssd1 vccd1 vccd1 _0218_ sky130_fd_sc_hd__mux2_1
X_1637_ _0871_ _0872_ vssd1 vssd1 vccd1 vccd1 _0874_ sky130_fd_sc_hd__nand2_1
X_1499_ _0712_ _0757_ vssd1 vssd1 vccd1 vccd1 _0758_ sky130_fd_sc_hd__nor2_1
X_1568_ _0817_ _0816_ net476 net80 vssd1 vssd1 vccd1 vccd1 _0184_ sky130_fd_sc_hd__a2bb2o_1
XFILLER_48_29 vssd1 vssd1 vccd1 vccd1 sky130_fd_sc_hd__fill_1
XFILLER_39_340 vssd1 vssd1 vccd1 vccd1 sky130_fd_sc_hd__fill_1
Xfanout33 _0767_ vssd1 vssd1 vccd1 vccd1 net33 sky130_fd_sc_hd__clkbuf_2
XFILLER_54_365 vssd1 vssd1 vccd1 vccd1 sky130_fd_sc_hd__fill_1
Xfanout55 _0595_ vssd1 vssd1 vccd1 vccd1 net55 sky130_fd_sc_hd__dlymetal6s2s_1
Xfanout44 _0456_ vssd1 vssd1 vccd1 vccd1 net44 sky130_fd_sc_hd__buf_2
XTAP_TAPCELL_ROW_1_144 vssd1 vccd1 sky130_fd_sc_hd__tapvpwrvgnd_1
Xfanout66 _0659_ vssd1 vssd1 vccd1 vccd1 net66 sky130_fd_sc_hd__clkbuf_4
XANTENNA__1280__B1 _0397_ vssd1 vssd1 vccd1 vccd1 sky130_fd_sc_hd__diode_2
Xfanout88 CALC_INST.input_ctrl_inst.input_control_state\[2\] vssd1 vssd1 vccd1 vccd1
+ net88 sky130_fd_sc_hd__buf_2
XTAP_TAPCELL_ROW_9_200 vssd1 vccd1 sky130_fd_sc_hd__tapvpwrvgnd_1
Xfanout99 net100 vssd1 vssd1 vccd1 vccd1 net99 sky130_fd_sc_hd__clkbuf_4
Xfanout77 _1145_ vssd1 vssd1 vccd1 vccd1 net77 sky130_fd_sc_hd__clkbuf_4
XANTENNA__1335__A1 net112 vssd1 vssd1 vccd1 vccd1 sky130_fd_sc_hd__diode_2
XFILLER_8_3 vccd1 vssd1 vccd1 vssd1 sky130_ef_sc_hd__decap_40_12
XFILLER_57_181 vssd1 vssd1 vccd1 vccd1 sky130_fd_sc_hd__fill_2
XFILLER_45_321 vssd1 vssd1 vccd1 vccd1 sky130_fd_sc_hd__fill_1
XFILLER_60_346 vssd1 vssd1 vccd1 vccd1 sky130_fd_sc_hd__fill_4
XFILLER_54_94 vssd1 vssd1 vccd1 vccd1 sky130_fd_sc_hd__fill_2
XFILLER_54_61 vssd1 vssd1 vccd1 vccd1 sky130_fd_sc_hd__fill_8
XPHY_EDGE_ROW_41_Left_106 vssd1 vssd1 vccd1 vccd1 sky130_fd_sc_hd__decap_3
XTAP_TAPCELL_ROW_15_246 vssd1 vccd1 sky130_fd_sc_hd__tapvpwrvgnd_1
XFILLER_62_6 vccd1 vssd1 vccd1 vssd1 sky130_ef_sc_hd__decap_40_12
Xclkload14 clknet_leaf_9_clk vssd1 vssd1 vccd1 vccd1 clkload14/Y sky130_fd_sc_hd__bufinv_16
X_1422_ CALC_INST.gencon_inst.ALU_in1\[11\] CALC_INST.gencon_inst.ALU_in2\[11\] net67
+ vssd1 vssd1 vccd1 vccd1 _0686_ sky130_fd_sc_hd__mux2_1
Xclkload25 clknet_leaf_13_clk vssd1 vssd1 vccd1 vccd1 clkload25/Y sky130_fd_sc_hd__clkinv_2
X_2471_ net72 _0397_ vssd1 vssd1 vccd1 vccd1 _0593_ sky130_fd_sc_hd__nand2_2
X_2540_ clknet_leaf_4_clk _0078_ net125 vssd1 vssd1 vccd1 vccd1 net19 sky130_fd_sc_hd__dfrtp_1
XPHY_EDGE_ROW_50_Left_115 vssd1 vssd1 vccd1 vccd1 sky130_fd_sc_hd__decap_3
X_1284_ net41 _0631_ _0634_ vssd1 vssd1 vccd1 vccd1 _0638_ sky130_fd_sc_hd__or3b_1
X_1353_ CALC_INST.gencon_inst.operand2\[8\] CALC_INST.gencon_inst.operand1\[8\] net73
+ vssd1 vssd1 vccd1 vccd1 _0652_ sky130_fd_sc_hd__mux2_1
XFILLER_51_357 vssd1 vssd1 vccd1 vccd1 sky130_fd_sc_hd__fill_8
XFILLER_51_346 vssd1 vssd1 vccd1 vccd1 sky130_fd_sc_hd__fill_2
XFILLER_51_335 vssd1 vssd1 vccd1 vccd1 sky130_fd_sc_hd__fill_1
X_2738_ clknet_leaf_27_clk _0276_ net133 vssd1 vssd1 vccd1 vccd1 CALC_INST.gencon_inst.mult_calc.countSave\[5\]
+ sky130_fd_sc_hd__dfrtp_1
Xclkload8 clknet_leaf_34_clk vssd1 vssd1 vccd1 vccd1 clkload8/Y sky130_fd_sc_hd__inv_12
X_2807_ clknet_leaf_34_clk _0332_ net113 vssd1 vssd1 vccd1 vccd1 CALC_INST.input_ctrl_inst.col_index\[30\]
+ sky130_fd_sc_hd__dfrtp_1
XFILLER_59_402 vssd1 vssd1 vccd1 vccd1 sky130_fd_sc_hd__fill_2
X_2669_ clknet_leaf_31_clk net311 net118 vssd1 vssd1 vccd1 vccd1 CALC_INST.gencon_inst.mult_calc.compCount.in2\[0\]
+ sky130_fd_sc_hd__dfrtp_1
XANTENNA_fanout48_A _0648_ vssd1 vssd1 vccd1 vccd1 sky130_fd_sc_hd__diode_2
XFILLER_54_195 vssd1 vssd1 vccd1 vccd1 sky130_fd_sc_hd__fill_1
XANTENNA__2363__B CALC_INST.gencon_inst.operand2\[10\] vssd1 vssd1 vccd1 vccd1 sky130_fd_sc_hd__diode_2
XTAP_TAPCELL_ROW_12_227 vssd1 vccd1 sky130_fd_sc_hd__tapvpwrvgnd_1
XTAP_TAPCELL_ROW_20_282 vssd1 vccd1 sky130_fd_sc_hd__tapvpwrvgnd_1
XFILLER_10_265 vssd1 vssd1 vccd1 vccd1 sky130_fd_sc_hd__fill_2
XFILLER_60_110 vccd1 vssd1 vccd1 vssd1 sky130_ef_sc_hd__decap_40_12
XFILLER_18_321 vssd1 vssd1 vccd1 vccd1 sky130_fd_sc_hd__fill_8
X_1971_ CALC_INST.input_ctrl_inst.scan_timer\[11\] CALC_INST.input_ctrl_inst.scan_timer\[10\]
+ _1036_ vssd1 vssd1 vccd1 vccd1 _1037_ sky130_fd_sc_hd__and3_1
X_1405_ net336 _0677_ net107 vssd1 vssd1 vccd1 vccd1 _0161_ sky130_fd_sc_hd__mux2_1
X_2385_ _0383_ net58 _0385_ vssd1 vssd1 vccd1 vccd1 _0523_ sky130_fd_sc_hd__a21oi_1
X_2523_ clknet_leaf_5_clk CALC_INST.gencon_inst.next_state\[2\] net128 vssd1 vssd1
+ vccd1 vccd1 CALC_INST.gencon_inst.gencon_state\[2\] sky130_fd_sc_hd__dfrtp_4
X_2454_ _0520_ _0579_ vssd1 vssd1 vccd1 vccd1 _0580_ sky130_fd_sc_hd__nor2_1
X_1336_ net215 _0644_ _0645_ CALC_INST.gencon_inst.operator_input\[0\] vssd1 vssd1
+ vccd1 vccd1 _0123_ sky130_fd_sc_hd__a22o_1
X_1267_ CALC_INST.gencon_inst.ALU_out\[12\] net69 _0625_ vssd1 vssd1 vccd1 vccd1 _0626_
+ sky130_fd_sc_hd__a21o_1
XTAP_TAPCELL_ROW_26_319 vssd1 vccd1 sky130_fd_sc_hd__tapvpwrvgnd_1
Xinput1 gpio_in[0] vssd1 vssd1 vccd1 vccd1 net1 sky130_fd_sc_hd__clkbuf_1
XFILLER_61_18 vssd1 vssd1 vccd1 vccd1 sky130_fd_sc_hd__fill_1
XANTENNA__2432__C1 net41 vssd1 vssd1 vccd1 vccd1 sky130_fd_sc_hd__diode_2
XANTENNA__1786__A1 CALC_INST.gencon_inst.operand2\[10\] vssd1 vssd1 vccd1 vccd1 sky130_fd_sc_hd__diode_2
XANTENNA__1762__A1_N net82 vssd1 vssd1 vccd1 vccd1 sky130_fd_sc_hd__diode_2
XFILLER_15_335 vssd1 vssd1 vccd1 vccd1 sky130_fd_sc_hd__fill_1
XFILLER_15_346 vssd1 vssd1 vccd1 vccd1 sky130_fd_sc_hd__fill_1
XFILLER_51_40 vssd1 vssd1 vccd1 vccd1 sky130_fd_sc_hd__fill_8
X_2170_ _1202_ _1203_ CALC_INST.input_ctrl_inst.debounce_cnt\[10\] net45 vssd1 vssd1
+ vccd1 vccd1 _0009_ sky130_fd_sc_hd__a2bb2o_1
XTAP_TAPCELL_ROW_48_477 vssd1 vccd1 sky130_fd_sc_hd__tapvpwrvgnd_1
X_1954_ CALC_INST.input_ctrl_inst.scan_timer\[1\] CALC_INST.input_ctrl_inst.scan_timer\[3\]
+ CALC_INST.input_ctrl_inst.scan_timer\[2\] _1023_ vssd1 vssd1 vccd1 vccd1 _1028_
+ sky130_fd_sc_hd__and4_1
XTAP_TAPCELL_ROW_31_355 vssd1 vccd1 sky130_fd_sc_hd__tapvpwrvgnd_1
X_1885_ CALC_INST.input_ctrl_inst.col_index\[26\] _0987_ CALC_INST.input_ctrl_inst.col_index\[27\]
+ vssd1 vssd1 vccd1 vccd1 _0990_ sky130_fd_sc_hd__a21oi_1
X_2506_ clknet_leaf_11_clk _0048_ net131 vssd1 vssd1 vccd1 vccd1 CALC_INST.gencon_inst.operand1\[1\]
+ sky130_fd_sc_hd__dfrtp_1
X_2437_ CALC_INST.gencon_inst.ALU_out\[8\] net69 net59 CALC_INST.gencon_inst.mult_calc.out\[8\]
+ net41 vssd1 vssd1 vccd1 vccd1 _0567_ sky130_fd_sc_hd__a221o_1
X_2368_ CALC_INST.gencon_inst.operand2\[12\] _0505_ vssd1 vssd1 vccd1 vccd1 _0509_
+ sky130_fd_sc_hd__and2_1
XFILLER_56_279 vssd1 vssd1 vccd1 vccd1 sky130_fd_sc_hd__fill_2
X_1319_ CALC_INST.gencon_inst.operand2\[0\] net291 net50 vssd1 vssd1 vccd1 vccd1 _0106_
+ sky130_fd_sc_hd__mux2_1
XTAP_TAPCELL_ROW_39_411 vssd1 vccd1 sky130_fd_sc_hd__tapvpwrvgnd_1
X_2299_ net82 _1138_ vssd1 vssd1 vccd1 vccd1 _0004_ sky130_fd_sc_hd__nor2_1
XANTENNA__2405__C1 net41 vssd1 vssd1 vccd1 vccd1 sky130_fd_sc_hd__diode_2
XFILLER_12_338 vccd1 vssd1 vccd1 vssd1 sky130_ef_sc_hd__decap_40_12
XFILLER_21_54 vssd1 vssd1 vccd1 vccd1 sky130_fd_sc_hd__fill_2
XFILLER_47_279 vssd1 vssd1 vccd1 vccd1 sky130_fd_sc_hd__fill_1
XFILLER_46_40 vccd1 vssd1 vccd1 vssd1 sky130_ef_sc_hd__decap_40_12
XFILLER_62_238 vssd1 vssd1 vccd1 vccd1 sky130_fd_sc_hd__fill_1
XTAP_TAPCELL_ROW_45_458 vssd1 vccd1 sky130_fd_sc_hd__tapvpwrvgnd_1
Xmax_cap74 _0414_ vssd1 vssd1 vccd1 vccd1 net74 sky130_fd_sc_hd__buf_1
XFILLER_30_179 vssd1 vssd1 vccd1 vccd1 sky130_fd_sc_hd__fill_1
X_1670_ CALC_INST.gencon_inst.mult_calc.main.GENERATE_ADDER\[9\].thingy.in2 CALC_INST.gencon_inst.mult_calc.main.GENERATE_ADDER\[9\].thingy.in1
+ _0901_ vssd1 vssd1 vccd1 vccd1 _0902_ sky130_fd_sc_hd__o21bai_1
XFILLER_7_89 vssd1 vssd1 vccd1 vccd1 sky130_fd_sc_hd__fill_2
XANTENNA__2478__A2 net57 vssd1 vssd1 vccd1 vccd1 sky130_fd_sc_hd__diode_2
X_2222_ CALC_INST.gencon_inst.gencon_state\[0\] CALC_INST.gencon_inst.gencon_state\[1\]
+ vssd1 vssd1 vccd1 vccd1 _0388_ sky130_fd_sc_hd__nand2_1
XFILLER_38_202 vssd1 vssd1 vccd1 vccd1 sky130_fd_sc_hd__fill_2
X_2153_ _1190_ vssd1 vssd1 vccd1 vccd1 _1191_ sky130_fd_sc_hd__inv_2
X_2084_ CALC_INST.gencon_inst.mult_calc.compCount.in2\[14\] _1097_ _1136_ _1137_ vssd1
+ vssd1 vccd1 vccd1 _1138_ sky130_fd_sc_hd__a22oi_2
X_1937_ CALC_INST.gencon_inst.keypad_input\[3\] net79 vssd1 vssd1 vccd1 vccd1 _1019_
+ sky130_fd_sc_hd__or2_1
X_1799_ CALC_INST.input_ctrl_inst.scan_timer\[1\] CALC_INST.input_ctrl_inst.scan_timer\[0\]
+ CALC_INST.input_ctrl_inst.scan_timer\[3\] vssd1 vssd1 vccd1 vccd1 _0931_ sky130_fd_sc_hd__or3_1
X_1868_ CALC_INST.input_ctrl_inst.col_index\[21\] _0977_ vssd1 vssd1 vccd1 vccd1 _0979_
+ sky130_fd_sc_hd__xnor2_1
XFILLER_44_205 vssd1 vssd1 vccd1 vccd1 sky130_fd_sc_hd__fill_1
XFILLER_29_279 vssd1 vssd1 vccd1 vccd1 sky130_fd_sc_hd__fill_1
XFILLER_32_97 vssd1 vssd1 vccd1 vccd1 sky130_fd_sc_hd__fill_2
XANTENNA_clkbuf_leaf_19_clk_A clknet_2_3__leaf_clk vssd1 vssd1 vccd1 vccd1 sky130_fd_sc_hd__diode_2
XANTENNA__1904__A1 net91 vssd1 vssd1 vccd1 vccd1 sky130_fd_sc_hd__diode_2
XANTENNA__2386__X _0524_ vssd1 vssd1 vccd1 vccd1 sky130_fd_sc_hd__diode_2
XFILLER_35_216 vssd1 vssd1 vccd1 vccd1 sky130_fd_sc_hd__fill_1
X_2840_ clknet_leaf_8_clk _0018_ net127 vssd1 vssd1 vccd1 vccd1 CALC_INST.input_ctrl_inst.debounce_cnt\[1\]
+ sky130_fd_sc_hd__dfrtp_2
XFILLER_43_293 vssd1 vssd1 vccd1 vccd1 sky130_fd_sc_hd__fill_1
X_2771_ clknet_leaf_22_clk _0300_ vssd1 vssd1 vccd1 vccd1 CALC_INST.gencon_inst.mult_calc.INn2\[14\]
+ sky130_fd_sc_hd__dfxtp_1
X_1584_ _0829_ _0830_ vssd1 vssd1 vccd1 vccd1 _0831_ sky130_fd_sc_hd__xnor2_1
Xhold117 CALC_INST.gencon_inst.ALU_in2\[1\] vssd1 vssd1 vccd1 vccd1 net313 sky130_fd_sc_hd__dlygate4sd3_1
Xhold106 net14 vssd1 vssd1 vccd1 vccd1 net302 sky130_fd_sc_hd__dlygate4sd3_1
X_1653_ CALC_INST.gencon_inst.mult_calc.main.GENERATE_ADDER\[8\].thingy.in2 CALC_INST.gencon_inst.mult_calc.main.GENERATE_ADDER\[8\].thingy.in1
+ vssd1 vssd1 vccd1 vccd1 _0887_ sky130_fd_sc_hd__nor2_1
Xhold128 CALC_INST.gencon_inst.mult_calc.main.GENERATE_ADDER\[5\].thingy.in2 vssd1
+ vssd1 vccd1 vccd1 net324 sky130_fd_sc_hd__dlygate4sd3_1
XFILLER_7_161 vssd1 vssd1 vccd1 vccd1 sky130_fd_sc_hd__fill_4
XFILLER_7_194 vssd1 vssd1 vccd1 vccd1 sky130_fd_sc_hd__fill_4
XPHY_EDGE_ROW_9_Right_9 vssd1 vssd1 vccd1 vccd1 sky130_fd_sc_hd__decap_3
X_1722_ net327 net306 net98 vssd1 vssd1 vccd1 vccd1 _0234_ sky130_fd_sc_hd__mux2_1
Xhold139 CALC_INST.gencon_inst.mult_calc.main.GENERATE_ADDER\[13\].thingy.in2 vssd1
+ vssd1 vccd1 vccd1 net335 sky130_fd_sc_hd__dlygate4sd3_1
X_2205_ _1174_ _1228_ _1230_ _1074_ vssd1 vssd1 vccd1 vccd1 _1231_ sky130_fd_sc_hd__o211a_1
XTAP_TAPCELL_ROW_64_597 vssd1 vccd1 sky130_fd_sc_hd__tapvpwrvgnd_1
XTAP_TAPCELL_ROW_64_586 vssd1 vccd1 sky130_fd_sc_hd__tapvpwrvgnd_1
X_2136_ net36 _1177_ _1178_ net45 net472 vssd1 vssd1 vccd1 vccd1 _0018_ sky130_fd_sc_hd__a32o_1
X_2067_ CALC_INST.gencon_inst.mult_calc.compCount.in2\[7\] _1116_ _1117_ _1115_ _1120_
+ vssd1 vssd1 vccd1 vccd1 _1121_ sky130_fd_sc_hd__o221a_1
XFILLER_1_326 vssd1 vssd1 vccd1 vccd1 sky130_fd_sc_hd__fill_1
XANTENNA_fanout78_A _1145_ vssd1 vssd1 vccd1 vccd1 sky130_fd_sc_hd__diode_2
XFILLER_40_230 vssd1 vssd1 vccd1 vccd1 sky130_fd_sc_hd__fill_2
XFILLER_4_197 vssd1 vssd1 vccd1 vccd1 sky130_fd_sc_hd__fill_4
XFILLER_63_377 vccd1 vssd1 vccd1 vssd1 sky130_ef_sc_hd__decap_40_12
XFILLER_48_363 vssd1 vssd1 vccd1 vccd1 sky130_fd_sc_hd__fill_1
XFILLER_23_219 vssd1 vssd1 vccd1 vccd1 sky130_fd_sc_hd__fill_4
XTAP_TAPCELL_ROW_18_266 vssd1 vccd1 sky130_fd_sc_hd__tapvpwrvgnd_1
XTAP_TAPCELL_ROW_61_567 vssd1 vccd1 sky130_fd_sc_hd__tapvpwrvgnd_1
XFILLER_31_296 vssd1 vssd1 vccd1 vccd1 sky130_fd_sc_hd__fill_1
XFILLER_31_241 vssd1 vssd1 vccd1 vccd1 sky130_fd_sc_hd__fill_4
X_2754_ clknet_leaf_2_clk net197 net115 vssd1 vssd1 vccd1 vccd1 CALC_INST.input_ctrl_inst.RowSync\[1\]
+ sky130_fd_sc_hd__dfstp_1
X_2823_ clknet_leaf_26_clk net295 net140 vssd1 vssd1 vccd1 vccd1 CALC_INST.gencon_inst.mult_calc.count.GENERATE_ADDER\[10\].thingy.in1
+ sky130_fd_sc_hd__dfrtp_1
X_1705_ net407 net348 net97 vssd1 vssd1 vccd1 vccd1 _0217_ sky130_fd_sc_hd__mux2_1
X_1567_ net32 _0813_ _0815_ net80 vssd1 vssd1 vccd1 vccd1 _0817_ sky130_fd_sc_hd__a31o_1
X_2685_ clknet_leaf_31_clk net202 net122 vssd1 vssd1 vccd1 vccd1 CALC_INST.gencon_inst.mult_calc.main.GENERATE_ADDER\[1\].thingy.in1
+ sky130_fd_sc_hd__dfrtp_1
X_1636_ _0871_ _0872_ vssd1 vssd1 vccd1 vccd1 _0873_ sky130_fd_sc_hd__or2_1
XFILLER_64_29 vssd1 vssd1 vccd1 vccd1 sky130_fd_sc_hd__fill_2
X_1498_ _0716_ _0720_ _0754_ _0717_ _0713_ vssd1 vssd1 vccd1 vccd1 _0757_ sky130_fd_sc_hd__o311a_1
X_2119_ CALC_INST.input_ctrl_inst.RowSync\[2\] CALC_INST.input_ctrl_inst.col_index\[3\]
+ CALC_INST.input_ctrl_inst.RowSync\[3\] vssd1 vssd1 vccd1 vccd1 _1164_ sky130_fd_sc_hd__o21ai_1
XTAP_TAPCELL_ROW_1_145 vssd1 vccd1 sky130_fd_sc_hd__tapvpwrvgnd_1
Xfanout45 _1173_ vssd1 vssd1 vccd1 vccd1 net45 sky130_fd_sc_hd__buf_2
XTAP_TAPCELL_ROW_52_501 vssd1 vccd1 sky130_fd_sc_hd__tapvpwrvgnd_1
Xfanout67 _0659_ vssd1 vssd1 vccd1 vccd1 net67 sky130_fd_sc_hd__clkbuf_2
XANTENNA__2473__Y _0595_ vssd1 vssd1 vccd1 vccd1 sky130_fd_sc_hd__diode_2
Xfanout34 net35 vssd1 vssd1 vccd1 vccd1 net34 sky130_fd_sc_hd__buf_2
Xfanout56 _0593_ vssd1 vssd1 vccd1 vccd1 net56 sky130_fd_sc_hd__clkbuf_4
Xfanout78 _1145_ vssd1 vssd1 vccd1 vccd1 net78 sky130_fd_sc_hd__clkbuf_2
Xfanout89 CALC_INST.input_ctrl_inst.col_index\[3\] vssd1 vssd1 vccd1 vccd1 net89 sky130_fd_sc_hd__buf_2
XTAP_TAPCELL_ROW_9_201 vssd1 vccd1 sky130_fd_sc_hd__tapvpwrvgnd_1
XFILLER_38_52 vssd1 vssd1 vccd1 vccd1 sky130_fd_sc_hd__fill_1
XFILLER_1_134 vssd1 vssd1 vccd1 vccd1 sky130_fd_sc_hd__fill_4
XFILLER_57_193 vssd1 vssd1 vccd1 vccd1 sky130_fd_sc_hd__fill_1
XFILLER_45_333 vssd1 vssd1 vccd1 vccd1 sky130_fd_sc_hd__fill_2
XFILLER_60_358 vssd1 vssd1 vccd1 vccd1 sky130_fd_sc_hd__fill_1
Xclkload26 clknet_leaf_14_clk vssd1 vssd1 vccd1 vccd1 clkload26/Y sky130_fd_sc_hd__inv_6
Xclkload15 clknet_leaf_10_clk vssd1 vssd1 vccd1 vccd1 clkload15/Y sky130_fd_sc_hd__inv_8
XFILLER_9_278 vssd1 vssd1 vccd1 vccd1 sky130_fd_sc_hd__fill_2
XTAP_TAPCELL_ROW_15_247 vssd1 vccd1 sky130_fd_sc_hd__tapvpwrvgnd_1
XFILLER_55_6 vssd1 vssd1 vccd1 vccd1 sky130_fd_sc_hd__fill_2
X_1421_ net372 _0685_ net110 vssd1 vssd1 vccd1 vccd1 _0169_ sky130_fd_sc_hd__mux2_1
X_2470_ _0397_ _0590_ vssd1 vssd1 vccd1 vccd1 _0592_ sky130_fd_sc_hd__nand2_2
X_1283_ CALC_INST.gencon_inst.operand1\[15\] _0587_ _0636_ vssd1 vssd1 vccd1 vccd1
+ _0637_ sky130_fd_sc_hd__o21a_1
X_1352_ _0612_ net207 net38 vssd1 vssd1 vccd1 vccd1 _0134_ sky130_fd_sc_hd__mux2_1
Xclkload9 clknet_leaf_4_clk vssd1 vssd1 vccd1 vccd1 clkload9/Y sky130_fd_sc_hd__inv_6
X_2806_ clknet_leaf_34_clk _0331_ net113 vssd1 vssd1 vccd1 vccd1 CALC_INST.input_ctrl_inst.col_index\[29\]
+ sky130_fd_sc_hd__dfrtp_1
X_2737_ clknet_leaf_32_clk _0275_ net133 vssd1 vssd1 vccd1 vccd1 CALC_INST.gencon_inst.mult_calc.countSave\[4\]
+ sky130_fd_sc_hd__dfrtp_1
X_2668_ clknet_leaf_24_clk _0206_ net140 vssd1 vssd1 vccd1 vccd1 CALC_INST.gencon_inst.mult_calc.adderSave\[14\]
+ sky130_fd_sc_hd__dfrtp_1
XANTENNA__2468__Y _0590_ vssd1 vssd1 vccd1 vccd1 sky130_fd_sc_hd__diode_2
X_2599_ clknet_leaf_23_clk _0137_ vssd1 vssd1 vccd1 vccd1 CALC_INST.gencon_inst.mult_calc.INn1\[10\]
+ sky130_fd_sc_hd__dfxtp_1
XANTENNA_input2_A gpio_in[1] vssd1 vssd1 vccd1 vccd1 sky130_fd_sc_hd__diode_2
X_1619_ _0856_ _0857_ vssd1 vssd1 vccd1 vccd1 _0858_ sky130_fd_sc_hd__nand2b_1
XFILLER_54_141 vssd1 vssd1 vccd1 vccd1 sky130_fd_sc_hd__fill_1
XFILLER_24_76 vssd1 vssd1 vccd1 vccd1 sky130_fd_sc_hd__fill_1
XFILLER_40_31 vssd1 vssd1 vccd1 vccd1 sky130_fd_sc_hd__fill_1
XTAP_TAPCELL_ROW_20_283 vssd1 vccd1 sky130_fd_sc_hd__tapvpwrvgnd_1
XFILLER_60_122 vccd1 vssd1 vccd1 vssd1 sky130_ef_sc_hd__decap_40_12
XFILLER_33_369 vssd1 vssd1 vccd1 vccd1 sky130_fd_sc_hd__fill_1
XPHY_EDGE_ROW_23_Left_88 vssd1 vssd1 vccd1 vccd1 sky130_fd_sc_hd__decap_3
X_1970_ net457 _1036_ vssd1 vssd1 vccd1 vccd1 _0367_ sky130_fd_sc_hd__xor2_1
XFILLER_53_3 vccd1 vssd1 vccd1 vssd1 sky130_ef_sc_hd__decap_40_12
X_2522_ clknet_leaf_5_clk CALC_INST.gencon_inst.next_state\[1\] net128 vssd1 vssd1
+ vccd1 vccd1 CALC_INST.gencon_inst.gencon_state\[1\] sky130_fd_sc_hd__dfrtp_1
X_1404_ CALC_INST.gencon_inst.ALU_in1\[2\] CALC_INST.gencon_inst.ALU_in2\[2\] net64
+ vssd1 vssd1 vccd1 vccd1 _0677_ sky130_fd_sc_hd__mux2_1
X_1335_ net112 net301 net50 vssd1 vssd1 vccd1 vccd1 _0122_ sky130_fd_sc_hd__a21bo_1
X_2384_ _0519_ net70 vssd1 vssd1 vccd1 vccd1 _0522_ sky130_fd_sc_hd__nor2_1
X_2453_ CALC_INST.gencon_inst.operand1\[12\] _0576_ vssd1 vssd1 vccd1 vccd1 _0579_
+ sky130_fd_sc_hd__and2_1
XFILLER_56_406 vssd1 vssd1 vccd1 vccd1 sky130_fd_sc_hd__fill_1
XANTENNA__2464__B _0519_ vssd1 vssd1 vccd1 vccd1 sky130_fd_sc_hd__diode_2
X_1266_ CALC_INST.gencon_inst.operand2\[12\] _0392_ net54 CALC_INST.gencon_inst.mult_calc.out\[12\]
+ _0590_ vssd1 vssd1 vccd1 vccd1 _0625_ sky130_fd_sc_hd__a221o_1
XFILLER_36_152 vssd1 vssd1 vccd1 vccd1 sky130_fd_sc_hd__fill_2
Xinput2 gpio_in[1] vssd1 vssd1 vccd1 vccd1 net2 sky130_fd_sc_hd__clkbuf_1
XTAP_TAPCELL_ROW_34_375 vssd1 vccd1 sky130_fd_sc_hd__tapvpwrvgnd_1
XANTENNA__1786__A2 net48 vssd1 vssd1 vccd1 vccd1 sky130_fd_sc_hd__diode_2
XFILLER_10_23 vssd1 vssd1 vccd1 vccd1 sky130_fd_sc_hd__fill_4
XFILLER_10_78 vssd1 vssd1 vccd1 vccd1 sky130_fd_sc_hd__fill_1
XFILLER_59_277 vssd1 vssd1 vccd1 vccd1 sky130_fd_sc_hd__fill_2
XFILLER_47_406 vssd1 vssd1 vccd1 vccd1 sky130_fd_sc_hd__fill_1
XFILLER_10_89 vssd1 vssd1 vccd1 vccd1 sky130_fd_sc_hd__fill_1
XANTENNA_input5_X net5 vssd1 vssd1 vccd1 vccd1 sky130_fd_sc_hd__diode_2
XFILLER_30_317 vssd1 vssd1 vccd1 vccd1 sky130_fd_sc_hd__fill_1
XFILLER_2_251 vssd1 vssd1 vccd1 vccd1 sky130_fd_sc_hd__fill_1
XTAP_TAPCELL_ROW_48_478 vssd1 vccd1 sky130_fd_sc_hd__tapvpwrvgnd_1
XFILLER_33_111 vssd1 vssd1 vccd1 vccd1 sky130_fd_sc_hd__fill_1
XFILLER_18_141 vssd1 vssd1 vccd1 vccd1 sky130_fd_sc_hd__fill_4
XFILLER_33_133 vssd1 vssd1 vccd1 vccd1 sky130_fd_sc_hd__fill_2
XFILLER_33_122 vssd1 vssd1 vccd1 vccd1 sky130_fd_sc_hd__fill_4
XTAP_TAPCELL_ROW_31_356 vssd1 vccd1 sky130_fd_sc_hd__tapvpwrvgnd_1
X_1953_ net459 _1026_ vssd1 vssd1 vccd1 vccd1 _0359_ sky130_fd_sc_hd__xnor2_1
XFILLER_21_306 vssd1 vssd1 vccd1 vccd1 sky130_fd_sc_hd__fill_2
X_1884_ _0947_ _0989_ CALC_INST.input_ctrl_inst.col_index\[26\] net62 vssd1 vssd1
+ vccd1 vccd1 _0328_ sky130_fd_sc_hd__a2bb2o_1
X_2505_ clknet_leaf_4_clk _0047_ net128 vssd1 vssd1 vccd1 vccd1 CALC_INST.gencon_inst.operand1\[0\]
+ sky130_fd_sc_hd__dfrtp_1
X_1318_ CALC_INST.gencon_inst.operand1\[15\] CALC_INST.gencon_inst.ALU_in1\[15\] net50
+ vssd1 vssd1 vccd1 vccd1 _0105_ sky130_fd_sc_hd__mux2_1
X_2436_ CALC_INST.gencon_inst.operand1\[8\] _0560_ _0565_ vssd1 vssd1 vccd1 vccd1
+ _0566_ sky130_fd_sc_hd__o21a_1
XTAP_TAPCELL_ROW_39_412 vssd1 vccd1 sky130_fd_sc_hd__tapvpwrvgnd_1
X_2367_ _0507_ _0508_ CALC_INST.gencon_inst.operand2\[11\] net34 vssd1 vssd1 vccd1
+ vccd1 _0043_ sky130_fd_sc_hd__o2bb2a_1
XFILLER_29_406 vssd1 vssd1 vccd1 vccd1 sky130_fd_sc_hd__fill_1
X_2298_ net430 net446 vssd1 vssd1 vccd1 vccd1 _0003_ sky130_fd_sc_hd__and2_1
X_1249_ _1234_ _0612_ vssd1 vssd1 vccd1 vccd1 _0613_ sky130_fd_sc_hd__and2_1
XFILLER_24_122 vssd1 vssd1 vccd1 vccd1 sky130_fd_sc_hd__fill_2
XFILLER_24_111 vssd1 vssd1 vccd1 vccd1 sky130_fd_sc_hd__fill_1
XANTENNA__2405__B1 net58 vssd1 vssd1 vccd1 vccd1 sky130_fd_sc_hd__diode_2
XFILLER_21_77 vssd1 vssd1 vccd1 vccd1 sky130_fd_sc_hd__fill_2
XFILLER_62_228 vssd1 vssd1 vccd1 vccd1 sky130_fd_sc_hd__fill_1
XFILLER_46_52 vssd1 vssd1 vccd1 vccd1 sky130_fd_sc_hd__fill_8
XANTENNA_fanout63_X net63 vssd1 vssd1 vccd1 vccd1 sky130_fd_sc_hd__diode_2
XFILLER_30_158 vssd1 vssd1 vccd1 vccd1 sky130_fd_sc_hd__fill_1
XFILLER_7_57 vccd1 vssd1 vccd1 vssd1 sky130_ef_sc_hd__decap_40_12
XFILLER_7_365 vssd1 vssd1 vccd1 vccd1 sky130_fd_sc_hd__fill_8
X_2152_ CALC_INST.input_ctrl_inst.debounce_cnt\[4\] CALC_INST.input_ctrl_inst.debounce_cnt\[5\]
+ CALC_INST.input_ctrl_inst.debounce_cnt\[6\] _1181_ vssd1 vssd1 vccd1 vccd1 _1190_
+ sky130_fd_sc_hd__and4_1
X_2221_ _1235_ CALC_INST.gencon_inst.gencon_state\[0\] CALC_INST.gencon_inst.gencon_state\[1\]
+ vssd1 vssd1 vccd1 vccd1 _0387_ sky130_fd_sc_hd__or3b_2
XFILLER_30_5 vssd1 vssd1 vccd1 vccd1 sky130_fd_sc_hd__fill_2
XFILLER_16_3 vssd1 vssd1 vccd1 vccd1 sky130_fd_sc_hd__fill_4
X_2083_ CALC_INST.gencon_inst.mult_calc.compCount.in2\[14\] _1097_ _1135_ CALC_INST.gencon_inst.mult_calc.compCount.in2\[13\]
+ vssd1 vssd1 vccd1 vccd1 _1137_ sky130_fd_sc_hd__o22a_1
X_1936_ _1151_ _1008_ _1009_ _1084_ vssd1 vssd1 vccd1 vccd1 _1018_ sky130_fd_sc_hd__a31o_1
XPHY_EDGE_ROW_26_Left_91 vssd1 vssd1 vccd1 vccd1 sky130_fd_sc_hd__decap_3
X_1867_ _0976_ _0978_ vssd1 vssd1 vccd1 vccd1 _0322_ sky130_fd_sc_hd__nor2_1
XANTENNA_fanout110_A CALC_INST.gencon_inst.add_calc.state\[2\] vssd1 vssd1 vccd1 vccd1
+ sky130_fd_sc_hd__diode_2
X_1798_ _1082_ _0927_ _0928_ _0929_ vssd1 vssd1 vccd1 vccd1 _0930_ sky130_fd_sc_hd__nor4_1
XPHY_EDGE_ROW_10_Left_75 vssd1 vssd1 vccd1 vccd1 sky130_fd_sc_hd__decap_3
X_2419_ CALC_INST.gencon_inst.operand1\[4\] net42 _0551_ _0552_ vssd1 vssd1 vccd1
+ vccd1 _0051_ sky130_fd_sc_hd__o22a_1
XFILLER_52_250 vssd1 vssd1 vccd1 vccd1 sky130_fd_sc_hd__fill_2
XFILLER_12_136 vssd1 vssd1 vccd1 vccd1 sky130_fd_sc_hd__fill_4
XFILLER_16_55 vssd1 vssd1 vccd1 vccd1 sky130_fd_sc_hd__fill_2
XFILLER_32_65 vssd1 vssd1 vccd1 vccd1 sky130_fd_sc_hd__fill_4
XANTENNA__1284__A net41 vssd1 vssd1 vccd1 vccd1 sky130_fd_sc_hd__diode_2
X_2770_ clknet_leaf_22_clk _0299_ vssd1 vssd1 vccd1 vccd1 CALC_INST.gencon_inst.mult_calc.INn2\[13\]
+ sky130_fd_sc_hd__dfxtp_1
X_1721_ net273 net256 net98 vssd1 vssd1 vccd1 vccd1 _0233_ sky130_fd_sc_hd__mux2_1
X_1583_ _0823_ _0826_ net32 vssd1 vssd1 vccd1 vccd1 _0830_ sky130_fd_sc_hd__o21ai_1
Xhold107 CALC_INST.gencon_inst.mult_calc.countSave\[3\] vssd1 vssd1 vccd1 vccd1 net303
+ sky130_fd_sc_hd__dlygate4sd3_1
Xhold129 CALC_INST.gencon_inst.mult_calc.adderSave\[13\] vssd1 vssd1 vccd1 vccd1 net325
+ sky130_fd_sc_hd__dlygate4sd3_1
X_1652_ net100 _0885_ _0886_ net318 net87 vssd1 vssd1 vccd1 vccd1 _0199_ sky130_fd_sc_hd__a32o_1
Xhold118 CALC_INST.gencon_inst.mult_calc.adderSave\[5\] vssd1 vssd1 vccd1 vccd1 net314
+ sky130_fd_sc_hd__dlygate4sd3_1
XFILLER_58_309 vssd1 vssd1 vccd1 vccd1 sky130_fd_sc_hd__fill_1
X_2135_ CALC_INST.input_ctrl_inst.debounce_cnt\[0\] CALC_INST.input_ctrl_inst.debounce_cnt\[1\]
+ vssd1 vssd1 vccd1 vccd1 _1178_ sky130_fd_sc_hd__nand2_1
X_2204_ _1078_ _1170_ CALC_INST.input_ctrl_inst.debounce_cnt\[18\] vssd1 vssd1 vccd1
+ vccd1 _1230_ sky130_fd_sc_hd__o21ai_1
XANTENNA__1659__B2 net100 vssd1 vssd1 vccd1 vccd1 sky130_fd_sc_hd__diode_2
XTAP_TAPCELL_ROW_64_598 vssd1 vccd1 sky130_fd_sc_hd__tapvpwrvgnd_1
XTAP_TAPCELL_ROW_64_587 vssd1 vccd1 sky130_fd_sc_hd__tapvpwrvgnd_1
XFILLER_34_250 vssd1 vssd1 vccd1 vccd1 sky130_fd_sc_hd__fill_2
X_2066_ CALC_INST.gencon_inst.mult_calc.compCount.in2\[8\] _1119_ vssd1 vssd1 vccd1
+ vccd1 _1120_ sky130_fd_sc_hd__or2_1
X_1919_ net88 _1080_ _1086_ _1003_ vssd1 vssd1 vccd1 vccd1 _1004_ sky130_fd_sc_hd__a31oi_2
XTAP_TAPCELL_ROW_4_165 vssd1 vccd1 sky130_fd_sc_hd__tapvpwrvgnd_1
XFILLER_43_97 vssd1 vssd1 vccd1 vccd1 sky130_fd_sc_hd__fill_4
XFILLER_43_31 vssd1 vssd1 vccd1 vccd1 sky130_fd_sc_hd__fill_2
XFILLER_4_176 vssd1 vssd1 vccd1 vccd1 sky130_fd_sc_hd__fill_8
XFILLER_4_58 vssd1 vssd1 vccd1 vccd1 sky130_fd_sc_hd__fill_4
XFILLER_0_393 vssd1 vssd1 vccd1 vccd1 sky130_fd_sc_hd__fill_4
XFILLER_63_389 vssd1 vssd1 vccd1 vccd1 sky130_fd_sc_hd__fill_2
XTAP_TAPCELL_ROW_61_568 vssd1 vccd1 sky130_fd_sc_hd__tapvpwrvgnd_1
XTAP_TAPCELL_ROW_18_267 vssd1 vccd1 sky130_fd_sc_hd__tapvpwrvgnd_1
X_2753_ clknet_leaf_2_clk net200 net115 vssd1 vssd1 vccd1 vccd1 CALC_INST.input_ctrl_inst.RowSync\[0\]
+ sky130_fd_sc_hd__dfstp_1
X_2684_ clknet_leaf_3_clk _0222_ net121 vssd1 vssd1 vccd1 vccd1 CALC_INST.gencon_inst.mult_calc.main.a0.in1
+ sky130_fd_sc_hd__dfrtp_1
X_2822_ clknet_leaf_26_clk _0343_ net135 vssd1 vssd1 vccd1 vccd1 CALC_INST.gencon_inst.mult_calc.count.GENERATE_ADDER\[9\].thingy.in1
+ sky130_fd_sc_hd__dfrtp_1
X_1704_ net419 net323 net97 vssd1 vssd1 vccd1 vccd1 _0216_ sky130_fd_sc_hd__mux2_1
X_1497_ _0716_ _0720_ _0754_ _0717_ vssd1 vssd1 vccd1 vccd1 _0756_ sky130_fd_sc_hd__o31a_1
X_1566_ net32 _0813_ _0815_ vssd1 vssd1 vccd1 vccd1 _0816_ sky130_fd_sc_hd__a21oi_1
XANTENNA__1329__A0 CALC_INST.gencon_inst.operand2\[10\] vssd1 vssd1 vccd1 vccd1 sky130_fd_sc_hd__diode_2
X_1635_ _0862_ _0866_ _0863_ vssd1 vssd1 vccd1 vccd1 _0872_ sky130_fd_sc_hd__o21a_1
XFILLER_54_345 vccd1 vssd1 vccd1 vssd1 sky130_ef_sc_hd__decap_40_12
X_2118_ CALC_INST.input_ctrl_inst.RowSync\[0\] net89 CALC_INST.input_ctrl_inst.RowSync\[1\]
+ vssd1 vssd1 vccd1 vccd1 _1163_ sky130_fd_sc_hd__or3b_1
XTAP_TAPCELL_ROW_1_146 vssd1 vccd1 sky130_fd_sc_hd__tapvpwrvgnd_1
X_2049_ CALC_INST.gencon_inst.mult_calc.count.GENERATE_ADDER\[1\].thingy.in1 CALC_INST.gencon_inst.mult_calc.count.GENERATE_ADDER\[1\].thingy.cIn
+ vssd1 vssd1 vccd1 vccd1 _1103_ sky130_fd_sc_hd__xnor2_1
Xfanout46 _1173_ vssd1 vssd1 vccd1 vccd1 net46 sky130_fd_sc_hd__clkbuf_2
XTAP_TAPCELL_ROW_52_502 vssd1 vccd1 sky130_fd_sc_hd__tapvpwrvgnd_1
XANTENNA_clkbuf_leaf_18_clk_A clknet_2_3__leaf_clk vssd1 vssd1 vccd1 vccd1 sky130_fd_sc_hd__diode_2
Xfanout68 net71 vssd1 vssd1 vccd1 vccd1 net68 sky130_fd_sc_hd__buf_2
Xfanout57 _0591_ vssd1 vssd1 vccd1 vccd1 net57 sky130_fd_sc_hd__clkbuf_4
Xfanout79 _1083_ vssd1 vssd1 vccd1 vccd1 net79 sky130_fd_sc_hd__buf_2
Xfanout35 _0381_ vssd1 vssd1 vccd1 vccd1 net35 sky130_fd_sc_hd__clkbuf_4
XFILLER_22_275 vssd1 vssd1 vccd1 vccd1 sky130_fd_sc_hd__fill_1
XTAP_TAPCELL_ROW_9_202 vssd1 vccd1 sky130_fd_sc_hd__tapvpwrvgnd_1
XFILLER_13_89 vssd1 vssd1 vccd1 vccd1 sky130_fd_sc_hd__fill_2
XFILLER_57_183 vssd1 vssd1 vccd1 vccd1 sky130_fd_sc_hd__fill_1
XFILLER_54_85 vssd1 vssd1 vccd1 vccd1 sky130_fd_sc_hd__fill_1
XFILLER_45_345 vssd1 vssd1 vccd1 vccd1 sky130_fd_sc_hd__fill_1
XTAP_TAPCELL_ROW_15_248 vssd1 vccd1 sky130_fd_sc_hd__tapvpwrvgnd_1
Xclkload27 clknet_leaf_15_clk vssd1 vssd1 vccd1 vccd1 clkload27/Y sky130_fd_sc_hd__inv_8
XANTENNA__1271__A2 _0397_ vssd1 vssd1 vccd1 vccd1 sky130_fd_sc_hd__diode_2
Xclkload16 clknet_leaf_22_clk vssd1 vssd1 vccd1 vccd1 clkload16/Y sky130_fd_sc_hd__bufinv_16
XANTENNA__1472__A net106 vssd1 vssd1 vccd1 vccd1 sky130_fd_sc_hd__diode_2
X_1420_ CALC_INST.gencon_inst.ALU_in1\[10\] CALC_INST.gencon_inst.ALU_in2\[10\] net67
+ vssd1 vssd1 vccd1 vccd1 _0685_ sky130_fd_sc_hd__mux2_1
X_1351_ _0609_ net209 net38 vssd1 vssd1 vccd1 vccd1 _0133_ sky130_fd_sc_hd__mux2_1
XFILLER_48_161 vssd1 vssd1 vccd1 vccd1 sky130_fd_sc_hd__fill_1
X_1282_ CALC_INST.gencon_inst.operand1\[15\] _0587_ _0520_ vssd1 vssd1 vccd1 vccd1
+ _0636_ sky130_fd_sc_hd__a21oi_1
XFILLER_51_348 vssd1 vssd1 vccd1 vccd1 sky130_fd_sc_hd__fill_1
X_2805_ clknet_leaf_0_clk _0330_ net113 vssd1 vssd1 vccd1 vccd1 CALC_INST.input_ctrl_inst.col_index\[28\]
+ sky130_fd_sc_hd__dfrtp_4
X_2736_ clknet_leaf_32_clk _0274_ net118 vssd1 vssd1 vccd1 vccd1 CALC_INST.gencon_inst.mult_calc.countSave\[3\]
+ sky130_fd_sc_hd__dfrtp_1
X_2667_ clknet_leaf_24_clk _0205_ net140 vssd1 vssd1 vccd1 vccd1 CALC_INST.gencon_inst.mult_calc.adderSave\[13\]
+ sky130_fd_sc_hd__dfrtp_1
X_1618_ CALC_INST.gencon_inst.mult_calc.main.GENERATE_ADDER\[3\].thingy.in2 CALC_INST.gencon_inst.mult_calc.main.GENERATE_ADDER\[3\].thingy.in1
+ vssd1 vssd1 vccd1 vccd1 _0857_ sky130_fd_sc_hd__nand2_1
X_1549_ net32 _0798_ _0800_ net80 vssd1 vssd1 vccd1 vccd1 _0802_ sky130_fd_sc_hd__a31o_1
X_2598_ clknet_leaf_23_clk _0136_ vssd1 vssd1 vccd1 vccd1 CALC_INST.gencon_inst.mult_calc.INn1\[9\]
+ sky130_fd_sc_hd__dfxtp_1
XFILLER_54_197 vssd1 vssd1 vccd1 vccd1 sky130_fd_sc_hd__fill_4
XANTENNA__2388__A _0519_ vssd1 vssd1 vccd1 vccd1 sky130_fd_sc_hd__diode_2
XFILLER_45_142 vssd1 vssd1 vccd1 vccd1 sky130_fd_sc_hd__fill_2
XFILLER_1_26 vssd1 vssd1 vccd1 vccd1 sky130_fd_sc_hd__fill_1
XFILLER_60_167 vssd1 vssd1 vccd1 vccd1 sky130_fd_sc_hd__fill_2
XFILLER_60_134 vssd1 vssd1 vccd1 vccd1 sky130_fd_sc_hd__fill_4
XANTENNA__1467__A net106 vssd1 vssd1 vccd1 vccd1 sky130_fd_sc_hd__diode_2
X_2521_ clknet_leaf_5_clk CALC_INST.gencon_inst.next_state\[0\] net128 vssd1 vssd1
+ vccd1 vccd1 CALC_INST.gencon_inst.gencon_state\[0\] sky130_fd_sc_hd__dfrtp_4
X_1403_ net356 _0676_ net107 vssd1 vssd1 vccd1 vccd1 _0160_ sky130_fd_sc_hd__mux2_1
X_1334_ CALC_INST.gencon_inst.operand2\[15\] net269 net50 vssd1 vssd1 vccd1 vccd1
+ _0121_ sky130_fd_sc_hd__mux2_1
X_2383_ _1058_ _0395_ vssd1 vssd1 vccd1 vccd1 _0521_ sky130_fd_sc_hd__nor2_1
X_2452_ CALC_INST.gencon_inst.operand1\[11\] net43 _0577_ _0578_ vssd1 vssd1 vccd1
+ vccd1 _0058_ sky130_fd_sc_hd__o22a_1
X_1265_ net284 _0592_ _0623_ _0624_ vssd1 vssd1 vccd1 vccd1 _0074_ sky130_fd_sc_hd__o22a_1
XPHY_EDGE_ROW_18_Right_18 vssd1 vssd1 vccd1 vccd1 sky130_fd_sc_hd__decap_3
XFILLER_36_197 vssd1 vssd1 vccd1 vccd1 sky130_fd_sc_hd__fill_4
XPHY_EDGE_ROW_27_Right_27 vssd1 vssd1 vccd1 vccd1 sky130_fd_sc_hd__decap_3
Xinput3 gpio_in[2] vssd1 vssd1 vccd1 vccd1 net3 sky130_fd_sc_hd__clkbuf_1
XFILLER_51_189 vssd1 vssd1 vccd1 vccd1 sky130_fd_sc_hd__fill_2
XTAP_TAPCELL_ROW_34_376 vssd1 vccd1 sky130_fd_sc_hd__tapvpwrvgnd_1
XPHY_EDGE_ROW_36_Right_36 vssd1 vssd1 vccd1 vccd1 sky130_fd_sc_hd__decap_3
X_2719_ clknet_leaf_29_clk _0257_ net137 vssd1 vssd1 vccd1 vccd1 CALC_INST.gencon_inst.mult_calc.out\[4\]
+ sky130_fd_sc_hd__dfrtp_1
XANTENNA_fanout53_A _0646_ vssd1 vssd1 vccd1 vccd1 sky130_fd_sc_hd__diode_2
XPHY_EDGE_ROW_45_Right_45 vssd1 vssd1 vccd1 vccd1 sky130_fd_sc_hd__decap_3
XFILLER_35_87 vssd1 vssd1 vccd1 vccd1 sky130_fd_sc_hd__fill_4
XPHY_EDGE_ROW_54_Right_54 vssd1 vssd1 vccd1 vccd1 sky130_fd_sc_hd__decap_3
XFILLER_25_8 vssd1 vssd1 vccd1 vccd1 sky130_fd_sc_hd__fill_8
XPHY_EDGE_ROW_63_Right_63 vssd1 vssd1 vccd1 vccd1 sky130_fd_sc_hd__decap_3
XTAP_TAPCELL_ROW_48_479 vssd1 vccd1 sky130_fd_sc_hd__tapvpwrvgnd_1
XPHY_EDGE_ROW_38_Left_103 vssd1 vssd1 vccd1 vccd1 sky130_fd_sc_hd__decap_3
XFILLER_18_7 vssd1 vssd1 vccd1 vccd1 sky130_fd_sc_hd__fill_2
XTAP_TAPCELL_ROW_31_357 vssd1 vccd1 sky130_fd_sc_hd__tapvpwrvgnd_1
X_1952_ _1026_ _1027_ vssd1 vssd1 vccd1 vccd1 _0358_ sky130_fd_sc_hd__and2_1
X_1883_ CALC_INST.input_ctrl_inst.col_index\[26\] _0987_ vssd1 vssd1 vccd1 vccd1 _0989_
+ sky130_fd_sc_hd__xnor2_1
XPHY_EDGE_ROW_47_Left_112 vssd1 vssd1 vccd1 vccd1 sky130_fd_sc_hd__decap_3
X_2435_ _0520_ _0564_ vssd1 vssd1 vccd1 vccd1 _0565_ sky130_fd_sc_hd__nor2_1
X_2504_ clknet_leaf_21_clk _0046_ net137 vssd1 vssd1 vccd1 vccd1 CALC_INST.gencon_inst.operand2\[14\]
+ sky130_fd_sc_hd__dfrtp_2
X_1317_ CALC_INST.gencon_inst.operand1\[14\] net255 net52 vssd1 vssd1 vccd1 vccd1
+ _0104_ sky130_fd_sc_hd__mux2_1
X_1248_ CALC_INST.gencon_inst.operand2\[7\] CALC_INST.gencon_inst.operand1\[7\] _0393_
+ vssd1 vssd1 vccd1 vccd1 _0612_ sky130_fd_sc_hd__mux2_1
XTAP_TAPCELL_ROW_39_413 vssd1 vccd1 sky130_fd_sc_hd__tapvpwrvgnd_1
X_2366_ _0405_ _0505_ _0506_ net34 vssd1 vssd1 vccd1 vccd1 _0508_ sky130_fd_sc_hd__o31a_1
X_2297_ _0454_ _0455_ vssd1 vssd1 vccd1 vccd1 net28 sky130_fd_sc_hd__or2_1
XFILLER_64_281 vccd1 vssd1 vccd1 vssd1 sky130_ef_sc_hd__decap_40_12
XFILLER_64_270 vssd1 vssd1 vccd1 vccd1 sky130_fd_sc_hd__fill_1
XPHY_EDGE_ROW_56_Left_121 vssd1 vssd1 vccd1 vccd1 sky130_fd_sc_hd__decap_3
XFILLER_24_101 vssd1 vssd1 vccd1 vccd1 sky130_fd_sc_hd__fill_8
XANTENNA__1916__B1 net77 vssd1 vssd1 vccd1 vccd1 sky130_fd_sc_hd__diode_2
XFILLER_47_204 vssd1 vssd1 vccd1 vccd1 sky130_fd_sc_hd__fill_4
XANTENNA_fanout56_X net56 vssd1 vssd1 vccd1 vccd1 sky130_fd_sc_hd__diode_2
XFILLER_62_85 vccd1 vssd1 vccd1 vssd1 sky130_ef_sc_hd__decap_40_12
XFILLER_7_333 vssd1 vssd1 vccd1 vccd1 sky130_fd_sc_hd__fill_2
XFILLER_11_362 vssd1 vssd1 vccd1 vccd1 sky130_fd_sc_hd__fill_1
XANTENNA__2340__S net35 vssd1 vssd1 vccd1 vccd1 sky130_fd_sc_hd__diode_2
XFILLER_7_69 vssd1 vssd1 vccd1 vccd1 sky130_fd_sc_hd__fill_1
XANTENNA__1907__B1 net75 vssd1 vssd1 vccd1 vccd1 sky130_fd_sc_hd__diode_2
XFILLER_7_388 vssd1 vssd1 vccd1 vccd1 sky130_fd_sc_hd__fill_4
XANTENNA__1480__A net103 vssd1 vssd1 vccd1 vccd1 sky130_fd_sc_hd__diode_2
X_2151_ CALC_INST.input_ctrl_inst.debounce_cnt\[6\] _1187_ vssd1 vssd1 vccd1 vccd1
+ _1189_ sky130_fd_sc_hd__or2_1
X_2220_ CALC_INST.gencon_inst.mult_calc.finish _0384_ vssd1 vssd1 vccd1 vccd1 _0386_
+ sky130_fd_sc_hd__or2_1
XFILLER_38_259 vssd1 vssd1 vccd1 vccd1 sky130_fd_sc_hd__fill_4
X_2082_ CALC_INST.gencon_inst.mult_calc.compCount.in2\[12\] _1131_ _1135_ CALC_INST.gencon_inst.mult_calc.compCount.in2\[13\]
+ _1133_ vssd1 vssd1 vccd1 vccd1 _1136_ sky130_fd_sc_hd__a221o_1
X_1935_ net111 net330 _1004_ _1017_ vssd1 vssd1 vccd1 vccd1 _0351_ sky130_fd_sc_hd__a22o_1
X_1797_ CALC_INST.input_ctrl_inst.scan_timer\[1\] CALC_INST.input_ctrl_inst.scan_timer\[0\]
+ CALC_INST.input_ctrl_inst.scan_timer\[3\] CALC_INST.input_ctrl_inst.scan_timer\[2\]
+ vssd1 vssd1 vccd1 vccd1 _0929_ sky130_fd_sc_hd__or4_1
XFILLER_21_148 vssd1 vssd1 vccd1 vccd1 sky130_fd_sc_hd__fill_4
X_1866_ CALC_INST.input_ctrl_inst.col_index\[20\] net62 _0945_ _0977_ vssd1 vssd1
+ vccd1 vccd1 _0978_ sky130_fd_sc_hd__o2bb2a_1
XANTENNA_fanout103_A net106 vssd1 vssd1 vccd1 vccd1 sky130_fd_sc_hd__diode_2
X_2418_ CALC_INST.gencon_inst.ALU_out\[4\] net71 net58 CALC_INST.gencon_inst.mult_calc.out\[4\]
+ vssd1 vssd1 vccd1 vccd1 _0552_ sky130_fd_sc_hd__a22o_1
XFILLER_37_292 vssd1 vssd1 vccd1 vccd1 sky130_fd_sc_hd__fill_1
X_2349_ CALC_INST.gencon_inst.mult_calc.out\[7\] net44 _0492_ _0494_ vssd1 vssd1 vccd1
+ vccd1 _0495_ sky130_fd_sc_hd__a22o_1
XFILLER_16_34 vccd1 vssd1 vccd1 vssd1 sky130_ef_sc_hd__decap_40_12
XFILLER_52_262 vssd1 vssd1 vccd1 vccd1 sky130_fd_sc_hd__fill_1
XPHY_EDGE_ROW_0_Right_0 vssd1 vssd1 vccd1 vccd1 sky130_fd_sc_hd__decap_3
XFILLER_16_78 vssd1 vssd1 vccd1 vccd1 sky130_fd_sc_hd__fill_2
XFILLER_32_77 vssd1 vssd1 vccd1 vccd1 sky130_fd_sc_hd__fill_4
XFILLER_20_170 vssd1 vssd1 vccd1 vccd1 sky130_fd_sc_hd__fill_1
XFILLER_20_181 vssd1 vssd1 vccd1 vccd1 sky130_fd_sc_hd__fill_1
XTAP_TAPCELL_ROW_41_430 vssd1 vccd1 sky130_fd_sc_hd__tapvpwrvgnd_1
X_1720_ net225 net211 net98 vssd1 vssd1 vccd1 vccd1 _0232_ sky130_fd_sc_hd__mux2_1
Xhold108 _0337_ vssd1 vssd1 vccd1 vccd1 net304 sky130_fd_sc_hd__dlygate4sd3_1
X_1651_ _0881_ _0883_ _0884_ vssd1 vssd1 vccd1 vccd1 _0886_ sky130_fd_sc_hd__a21o_1
XANTENNA__1475__A net103 vssd1 vssd1 vccd1 vccd1 sky130_fd_sc_hd__diode_2
X_1582_ _0762_ _0828_ vssd1 vssd1 vccd1 vccd1 _0829_ sky130_fd_sc_hd__xnor2_1
Xhold119 CALC_INST.gencon_inst.ALU_in1\[6\] vssd1 vssd1 vccd1 vccd1 net315 sky130_fd_sc_hd__dlygate4sd3_1
XFILLER_3_391 vssd1 vssd1 vccd1 vccd1 sky130_fd_sc_hd__fill_1
X_2134_ CALC_INST.input_ctrl_inst.debounce_cnt\[0\] CALC_INST.input_ctrl_inst.debounce_cnt\[1\]
+ vssd1 vssd1 vccd1 vccd1 _1177_ sky130_fd_sc_hd__or2_1
X_2203_ CALC_INST.input_ctrl_inst.debounce_cnt\[18\] _1072_ _1171_ _1228_ vssd1 vssd1
+ vccd1 vccd1 _1229_ sky130_fd_sc_hd__o2bb2a_1
XANTENNA__2305__B1 _0405_ vssd1 vssd1 vccd1 vccd1 sky130_fd_sc_hd__diode_2
X_2065_ _1092_ _1118_ vssd1 vssd1 vccd1 vccd1 _1119_ sky130_fd_sc_hd__or2_1
XTAP_TAPCELL_ROW_64_588 vssd1 vccd1 sky130_fd_sc_hd__tapvpwrvgnd_1
XANTENNA_fanout106_X net106 vssd1 vssd1 vccd1 vccd1 sky130_fd_sc_hd__diode_2
X_1918_ net111 _1148_ vssd1 vssd1 vccd1 vccd1 _1003_ sky130_fd_sc_hd__or2_1
X_1849_ _0434_ _0956_ vssd1 vssd1 vccd1 vccd1 _0965_ sky130_fd_sc_hd__nand2_1
XFILLER_57_310 vssd1 vssd1 vccd1 vccd1 sky130_fd_sc_hd__fill_8
XTAP_TAPCELL_ROW_4_166 vssd1 vccd1 sky130_fd_sc_hd__tapvpwrvgnd_1
XTAP_TAPCELL_ROW_55_522 vssd1 vccd1 sky130_fd_sc_hd__tapvpwrvgnd_1
XFILLER_27_66 vssd1 vssd1 vccd1 vccd1 sky130_fd_sc_hd__fill_4
XFILLER_17_218 vssd1 vssd1 vccd1 vccd1 sky130_fd_sc_hd__fill_4
XFILLER_43_54 vssd1 vssd1 vccd1 vccd1 sky130_fd_sc_hd__fill_2
Xclkbuf_leaf_20_clk clknet_2_3__leaf_clk vssd1 vssd1 vccd1 vccd1 clknet_leaf_20_clk
+ sky130_fd_sc_hd__clkbuf_8
XFILLER_40_232 vssd1 vssd1 vccd1 vccd1 sky130_fd_sc_hd__fill_1
XFILLER_4_144 vccd1 vssd1 vccd1 vssd1 sky130_ef_sc_hd__decap_40_12
XFILLER_4_15 vssd1 vssd1 vccd1 vccd1 sky130_fd_sc_hd__fill_8
XFILLER_63_335 vssd1 vssd1 vccd1 vccd1 sky130_fd_sc_hd__fill_1
XFILLER_0_361 vssd1 vssd1 vccd1 vccd1 sky130_fd_sc_hd__fill_2
XTAP_TAPCELL_ROW_61_569 vssd1 vccd1 sky130_fd_sc_hd__tapvpwrvgnd_1
X_2821_ clknet_leaf_26_clk net248 net135 vssd1 vssd1 vccd1 vccd1 CALC_INST.gencon_inst.mult_calc.count.GENERATE_ADDER\[8\].thingy.in1
+ sky130_fd_sc_hd__dfrtp_1
XTAP_TAPCELL_ROW_18_268 vssd1 vccd1 sky130_fd_sc_hd__tapvpwrvgnd_1
Xclkbuf_leaf_11_clk clknet_2_1__leaf_clk vssd1 vssd1 vccd1 vccd1 clknet_leaf_11_clk
+ sky130_fd_sc_hd__clkbuf_8
X_1703_ net398 net367 net97 vssd1 vssd1 vccd1 vccd1 _0215_ sky130_fd_sc_hd__mux2_1
X_2752_ clknet_leaf_28_clk _0004_ net136 vssd1 vssd1 vccd1 vccd1 CALC_INST.gencon_inst.mult_calc.state\[4\]
+ sky130_fd_sc_hd__dfrtp_1
X_2683_ clknet_leaf_26_clk _0221_ net141 vssd1 vssd1 vccd1 vccd1 CALC_INST.gencon_inst.mult_calc.compCount.in2\[14\]
+ sky130_fd_sc_hd__dfrtp_1
X_1634_ _0868_ _0870_ vssd1 vssd1 vccd1 vccd1 _0871_ sky130_fd_sc_hd__nand2_1
X_1496_ _0720_ _0754_ vssd1 vssd1 vccd1 vccd1 _0755_ sky130_fd_sc_hd__nor2_1
X_1565_ _0758_ _0814_ vssd1 vssd1 vccd1 vccd1 _0815_ sky130_fd_sc_hd__xnor2_1
XFILLER_54_357 vssd1 vssd1 vccd1 vccd1 sky130_fd_sc_hd__fill_4
XTAP_TAPCELL_ROW_52_503 vssd1 vccd1 sky130_fd_sc_hd__tapvpwrvgnd_1
X_2117_ _1160_ _1161_ CALC_INST.input_ctrl_inst.RowSync\[1\] vssd1 vssd1 vccd1 vccd1
+ _1162_ sky130_fd_sc_hd__o21bai_1
XTAP_TAPCELL_ROW_1_147 vssd1 vccd1 sky130_fd_sc_hd__tapvpwrvgnd_1
X_2048_ CALC_INST.gencon_inst.mult_calc.compCount.in2\[2\] _1088_ _1100_ vssd1 vssd1
+ vccd1 vccd1 _1102_ sky130_fd_sc_hd__or3_1
Xfanout36 _1176_ vssd1 vssd1 vccd1 vccd1 net36 sky130_fd_sc_hd__buf_2
Xfanout69 net70 vssd1 vssd1 vccd1 vccd1 net69 sky130_fd_sc_hd__buf_2
Xfanout58 _0522_ vssd1 vssd1 vccd1 vccd1 net58 sky130_fd_sc_hd__buf_2
XFILLER_1_147 vssd1 vssd1 vccd1 vccd1 sky130_fd_sc_hd__fill_1
XTAP_TAPCELL_ROW_9_203 vssd1 vccd1 sky130_fd_sc_hd__tapvpwrvgnd_1
XFILLER_45_335 vssd1 vssd1 vccd1 vccd1 sky130_fd_sc_hd__fill_1
XFILLER_38_76 vssd1 vssd1 vccd1 vccd1 sky130_fd_sc_hd__fill_4
XANTENNA__1740__A1 net94 vssd1 vssd1 vccd1 vccd1 sky130_fd_sc_hd__diode_2
Xclkload28 clknet_leaf_16_clk vssd1 vssd1 vccd1 vccd1 clkload28/Y sky130_fd_sc_hd__inv_8
XFILLER_55_8 vssd1 vssd1 vccd1 vccd1 sky130_fd_sc_hd__fill_1
Xclkload17 clknet_leaf_23_clk vssd1 vssd1 vccd1 vccd1 clkload17/X sky130_fd_sc_hd__clkbuf_8
XFILLER_9_236 vssd1 vssd1 vccd1 vccd1 sky130_fd_sc_hd__fill_1
X_1281_ _1232_ _0519_ _0634_ _0386_ vssd1 vssd1 vccd1 vccd1 _0635_ sky130_fd_sc_hd__o211a_1
X_1350_ _0607_ net217 net40 vssd1 vssd1 vccd1 vccd1 _0132_ sky130_fd_sc_hd__mux2_1
Xclkbuf_leaf_0_clk clknet_2_0__leaf_clk vssd1 vssd1 vccd1 vccd1 clknet_leaf_0_clk
+ sky130_fd_sc_hd__clkbuf_8
X_2804_ clknet_leaf_0_clk _0329_ net113 vssd1 vssd1 vccd1 vccd1 CALC_INST.input_ctrl_inst.col_index\[27\]
+ sky130_fd_sc_hd__dfrtp_1
X_2597_ clknet_leaf_23_clk _0135_ vssd1 vssd1 vccd1 vccd1 CALC_INST.gencon_inst.mult_calc.INn1\[8\]
+ sky130_fd_sc_hd__dfxtp_1
X_2735_ clknet_leaf_32_clk _0273_ net118 vssd1 vssd1 vccd1 vccd1 CALC_INST.gencon_inst.mult_calc.countSave\[2\]
+ sky130_fd_sc_hd__dfrtp_1
X_2666_ clknet_leaf_25_clk _0204_ net141 vssd1 vssd1 vccd1 vccd1 CALC_INST.gencon_inst.mult_calc.adderSave\[12\]
+ sky130_fd_sc_hd__dfrtp_1
X_1617_ CALC_INST.gencon_inst.mult_calc.main.GENERATE_ADDER\[3\].thingy.in2 CALC_INST.gencon_inst.mult_calc.main.GENERATE_ADDER\[3\].thingy.in1
+ vssd1 vssd1 vccd1 vccd1 _0856_ sky130_fd_sc_hd__nor2_1
X_1548_ net33 _0798_ _0800_ vssd1 vssd1 vccd1 vccd1 _0801_ sky130_fd_sc_hd__a21oi_1
X_1479_ net103 CALC_INST.gencon_inst.add_calc.main.in2\[2\] vssd1 vssd1 vccd1 vccd1
+ _0738_ sky130_fd_sc_hd__or2_1
XFILLER_54_187 vssd1 vssd1 vccd1 vccd1 sky130_fd_sc_hd__fill_8
XTAP_TAPCELL_ROW_37_396 vssd1 vccd1 sky130_fd_sc_hd__tapvpwrvgnd_1
XFILLER_50_382 vssd1 vssd1 vccd1 vccd1 sky130_fd_sc_hd__fill_2
XFILLER_6_217 vssd1 vssd1 vccd1 vccd1 sky130_fd_sc_hd__fill_2
Xhold280 CALC_INST.gencon_inst.ALU_out\[10\] vssd1 vssd1 vccd1 vccd1 net476 sky130_fd_sc_hd__dlygate4sd3_1
XFILLER_49_64 vssd1 vssd1 vccd1 vccd1 sky130_fd_sc_hd__fill_1
XFILLER_2_401 vssd1 vssd1 vccd1 vccd1 sky130_fd_sc_hd__fill_2
XANTENNA_fanout86_X net86 vssd1 vssd1 vccd1 vccd1 sky130_fd_sc_hd__diode_2
XFILLER_6_3 vssd1 vssd1 vccd1 vccd1 sky130_fd_sc_hd__fill_8
XFILLER_41_371 vssd1 vssd1 vccd1 vccd1 sky130_fd_sc_hd__fill_1
XFILLER_60_6 vccd1 vssd1 vccd1 vssd1 sky130_ef_sc_hd__decap_40_12
X_1402_ CALC_INST.gencon_inst.ALU_in1\[1\] CALC_INST.gencon_inst.ALU_in2\[1\] net64
+ vssd1 vssd1 vccd1 vccd1 _0676_ sky130_fd_sc_hd__mux2_1
X_2451_ CALC_INST.gencon_inst.ALU_out\[11\] net69 net59 CALC_INST.gencon_inst.mult_calc.out\[11\]
+ net41 vssd1 vssd1 vccd1 vccd1 _0578_ sky130_fd_sc_hd__a221o_1
X_2520_ clknet_leaf_6_clk _0062_ net124 vssd1 vssd1 vccd1 vccd1 CALC_INST.gencon_inst.read_input
+ sky130_fd_sc_hd__dfrtp_2
XFILLER_5_250 vccd1 vssd1 vccd1 vssd1 sky130_ef_sc_hd__decap_40_12
XANTENNA_clkbuf_leaf_17_clk_A clknet_2_3__leaf_clk vssd1 vssd1 vccd1 vccd1 sky130_fd_sc_hd__diode_2
X_1333_ CALC_INST.gencon_inst.operand2\[14\] net250 net52 vssd1 vssd1 vccd1 vccd1
+ _0120_ sky130_fd_sc_hd__mux2_1
X_2382_ CALC_INST.gencon_inst.gencon_state\[0\] CALC_INST.gencon_inst.gencon_state\[2\]
+ CALC_INST.gencon_inst.gencon_state\[3\] CALC_INST.gencon_inst.gencon_state\[1\]
+ vssd1 vssd1 vccd1 vccd1 _0520_ sky130_fd_sc_hd__or4b_4
X_1264_ CALC_INST.gencon_inst.ALU_out\[11\] net69 net55 CALC_INST.gencon_inst.mult_calc.out\[11\]
+ _0591_ vssd1 vssd1 vccd1 vccd1 _0624_ sky130_fd_sc_hd__a221o_1
Xinput4 gpio_in[3] vssd1 vssd1 vccd1 vccd1 net4 sky130_fd_sc_hd__clkbuf_1
XFILLER_51_179 vssd1 vssd1 vccd1 vccd1 sky130_fd_sc_hd__fill_1
Xclkbuf_2_1__f_clk clknet_0_clk vssd1 vssd1 vccd1 vccd1 clknet_2_1__leaf_clk sky130_fd_sc_hd__clkbuf_16
XTAP_TAPCELL_ROW_34_377 vssd1 vccd1 sky130_fd_sc_hd__tapvpwrvgnd_1
X_2718_ clknet_leaf_29_clk _0256_ net137 vssd1 vssd1 vccd1 vccd1 CALC_INST.gencon_inst.mult_calc.out\[3\]
+ sky130_fd_sc_hd__dfrtp_1
X_2649_ clknet_leaf_18_clk _0187_ net151 vssd1 vssd1 vccd1 vccd1 CALC_INST.gencon_inst.ALU_out\[13\]
+ sky130_fd_sc_hd__dfrtp_1
XFILLER_59_279 vssd1 vssd1 vccd1 vccd1 sky130_fd_sc_hd__fill_1
XFILLER_15_327 vssd1 vssd1 vccd1 vccd1 sky130_fd_sc_hd__fill_8
XFILLER_51_54 vssd1 vssd1 vccd1 vccd1 sky130_fd_sc_hd__fill_2
XFILLER_42_124 vssd1 vssd1 vccd1 vccd1 sky130_fd_sc_hd__fill_4
XFILLER_23_393 vssd1 vssd1 vccd1 vccd1 sky130_fd_sc_hd__fill_1
XANTENNA__1287__B net56 vssd1 vssd1 vccd1 vccd1 sky130_fd_sc_hd__diode_2
XFILLER_33_135 vssd1 vssd1 vccd1 vccd1 sky130_fd_sc_hd__fill_1
XFILLER_21_308 vssd1 vssd1 vccd1 vccd1 sky130_fd_sc_hd__fill_1
XFILLER_18_154 vssd1 vssd1 vccd1 vccd1 sky130_fd_sc_hd__fill_2
XTAP_TAPCELL_ROW_31_358 vssd1 vccd1 sky130_fd_sc_hd__tapvpwrvgnd_1
X_1951_ CALC_INST.input_ctrl_inst.scan_timer\[1\] _1023_ vssd1 vssd1 vccd1 vccd1 _1027_
+ sky130_fd_sc_hd__or2_1
X_1882_ _0947_ _0988_ CALC_INST.input_ctrl_inst.col_index\[25\] net62 vssd1 vssd1
+ vccd1 vccd1 _0327_ sky130_fd_sc_hd__a2bb2o_1
XANTENNA__1622__B1 net82 vssd1 vssd1 vccd1 vccd1 sky130_fd_sc_hd__diode_2
X_2434_ CALC_INST.gencon_inst.operand1\[7\] CALC_INST.gencon_inst.operand1\[8\] _0556_
+ vssd1 vssd1 vccd1 vccd1 _0564_ sky130_fd_sc_hd__and3_1
X_2365_ CALC_INST.gencon_inst.mult_calc.out\[11\] net44 vssd1 vssd1 vccd1 vccd1 _0507_
+ sky130_fd_sc_hd__nand2_1
X_2503_ clknet_leaf_23_clk _0045_ net143 vssd1 vssd1 vccd1 vccd1 CALC_INST.gencon_inst.operand2\[13\]
+ sky130_fd_sc_hd__dfrtp_4
X_1316_ CALC_INST.gencon_inst.operand1\[13\] net265 net52 vssd1 vssd1 vccd1 vccd1
+ _0103_ sky130_fd_sc_hd__mux2_1
X_1247_ _0610_ _0611_ vssd1 vssd1 vccd1 vccd1 _0069_ sky130_fd_sc_hd__or2_1
XTAP_TAPCELL_ROW_39_414 vssd1 vccd1 sky130_fd_sc_hd__tapvpwrvgnd_1
XFILLER_2_92 vssd1 vssd1 vccd1 vccd1 sky130_fd_sc_hd__fill_1
X_2296_ CALC_INST.input_ctrl_inst.col_index\[0\] _0454_ CALC_INST.input_ctrl_inst.col_index\[1\]
+ vssd1 vssd1 vccd1 vccd1 net27 sky130_fd_sc_hd__or3b_1
XFILLER_64_293 vccd1 vssd1 vccd1 vssd1 sky130_ef_sc_hd__decap_40_12
XFILLER_12_319 vssd1 vssd1 vccd1 vccd1 sky130_fd_sc_hd__fill_2
XFILLER_21_79 vssd1 vssd1 vccd1 vccd1 sky130_fd_sc_hd__fill_1
XFILLER_21_57 vccd1 vssd1 vccd1 vssd1 sky130_ef_sc_hd__decap_40_12
XFILLER_55_260 vccd1 vssd1 vccd1 vssd1 sky130_ef_sc_hd__decap_40_12
XFILLER_47_238 vssd1 vssd1 vccd1 vccd1 sky130_fd_sc_hd__fill_1
XFILLER_15_113 vssd1 vssd1 vccd1 vccd1 sky130_fd_sc_hd__fill_2
XFILLER_62_97 vccd1 vssd1 vccd1 vssd1 sky130_ef_sc_hd__decap_40_12
XFILLER_7_345 vssd1 vssd1 vccd1 vccd1 sky130_fd_sc_hd__fill_2
XANTENNA__1907__A1 net91 vssd1 vssd1 vccd1 vccd1 sky130_fd_sc_hd__diode_2
X_2150_ net36 _1186_ _1188_ net46 CALC_INST.input_ctrl_inst.debounce_cnt\[5\] vssd1
+ vssd1 vccd1 vccd1 _0022_ sky130_fd_sc_hd__a32o_1
X_2081_ _1096_ _1134_ vssd1 vssd1 vccd1 vccd1 _1135_ sky130_fd_sc_hd__nand2_1
XTAP_TAPCELL_ROW_44_450 vssd1 vccd1 sky130_fd_sc_hd__tapvpwrvgnd_1
X_1934_ CALC_INST.gencon_inst.keypad_input\[2\] _1083_ _1015_ _1016_ vssd1 vssd1 vccd1
+ vccd1 _1017_ sky130_fd_sc_hd__o22a_1
XANTENNA__1700__S net96 vssd1 vssd1 vccd1 vccd1 sky130_fd_sc_hd__diode_2
X_1796_ CALC_INST.input_ctrl_inst.scan_timer\[5\] CALC_INST.input_ctrl_inst.scan_timer\[7\]
+ CALC_INST.input_ctrl_inst.scan_timer\[6\] CALC_INST.input_ctrl_inst.scan_timer\[4\]
+ vssd1 vssd1 vccd1 vccd1 _0928_ sky130_fd_sc_hd__or4bb_1
X_1865_ CALC_INST.input_ctrl_inst.col_index\[19\] CALC_INST.input_ctrl_inst.col_index\[18\]
+ CALC_INST.input_ctrl_inst.col_index\[20\] _0968_ vssd1 vssd1 vccd1 vccd1 _0977_
+ sky130_fd_sc_hd__and4_1
X_2417_ CALC_INST.gencon_inst.operand1\[4\] _0542_ _0545_ _0550_ vssd1 vssd1 vccd1
+ vccd1 _0551_ sky130_fd_sc_hd__o31a_1
X_2348_ _0405_ _0493_ vssd1 vssd1 vccd1 vccd1 _0494_ sky130_fd_sc_hd__nor2_1
XFILLER_52_230 vssd1 vssd1 vccd1 vccd1 sky130_fd_sc_hd__fill_2
XFILLER_37_271 vssd1 vssd1 vccd1 vccd1 sky130_fd_sc_hd__fill_1
X_2279_ _0426_ _0434_ _0439_ _0440_ vssd1 vssd1 vccd1 vccd1 _0441_ sky130_fd_sc_hd__and4b_1
XFILLER_16_46 vssd1 vssd1 vccd1 vccd1 sky130_fd_sc_hd__fill_4
XFILLER_16_68 vssd1 vssd1 vccd1 vccd1 sky130_fd_sc_hd__fill_2
XFILLER_32_23 vssd1 vssd1 vccd1 vccd1 sky130_fd_sc_hd__fill_4
XFILLER_12_149 vccd1 vssd1 vccd1 vssd1 sky130_ef_sc_hd__decap_40_12
XFILLER_4_359 vssd1 vssd1 vccd1 vccd1 sky130_fd_sc_hd__fill_4
XFILLER_4_348 vssd1 vssd1 vccd1 vccd1 sky130_fd_sc_hd__fill_1
XANTENNA__2314__A1 _0404_ vssd1 vssd1 vccd1 vccd1 sky130_fd_sc_hd__diode_2
XTAP_TAPCELL_ROW_7_186 vssd1 vccd1 sky130_fd_sc_hd__tapvpwrvgnd_1
XFILLER_43_274 vssd1 vssd1 vccd1 vccd1 sky130_fd_sc_hd__fill_4
Xhold109 CALC_INST.gencon_inst.add_calc.next_finish vssd1 vssd1 vccd1 vccd1 net305
+ sky130_fd_sc_hd__dlygate4sd3_1
X_1581_ _0696_ _0697_ vssd1 vssd1 vccd1 vccd1 _0828_ sky130_fd_sc_hd__and2b_1
XFILLER_11_160 vssd1 vssd1 vccd1 vccd1 sky130_fd_sc_hd__fill_8
X_1650_ _0881_ _0883_ _0884_ vssd1 vssd1 vccd1 vccd1 _0885_ sky130_fd_sc_hd__nand3_1
X_2202_ _1068_ _1218_ _1227_ vssd1 vssd1 vccd1 vccd1 _1228_ sky130_fd_sc_hd__a21o_1
X_2133_ _1174_ _1175_ vssd1 vssd1 vccd1 vccd1 _1176_ sky130_fd_sc_hd__nand2_1
XFILLER_34_230 vssd1 vssd1 vccd1 vccd1 sky130_fd_sc_hd__fill_1
X_2064_ CALC_INST.gencon_inst.mult_calc.count.GENERATE_ADDER\[7\].thingy.in1 _1091_
+ CALC_INST.gencon_inst.mult_calc.count.GENERATE_ADDER\[8\].thingy.in1 vssd1 vssd1
+ vccd1 vccd1 _1118_ sky130_fd_sc_hd__a21oi_1
XTAP_TAPCELL_ROW_64_589 vssd1 vccd1 sky130_fd_sc_hd__tapvpwrvgnd_1
X_1917_ net93 net289 net77 net354 vssd1 vssd1 vccd1 vccd1 _0348_ sky130_fd_sc_hd__a22o_1
X_1779_ CALC_INST.gencon_inst.operand2\[3\] _0649_ _0651_ net266 vssd1 vssd1 vccd1
+ vccd1 _0289_ sky130_fd_sc_hd__o22a_1
X_1848_ net326 _0964_ vssd1 vssd1 vccd1 vccd1 _0317_ sky130_fd_sc_hd__xnor2_1
XTAP_TAPCELL_ROW_4_167 vssd1 vccd1 sky130_fd_sc_hd__tapvpwrvgnd_1
XTAP_TAPCELL_ROW_55_523 vssd1 vccd1 sky130_fd_sc_hd__tapvpwrvgnd_1
XFILLER_43_11 vssd1 vssd1 vccd1 vccd1 sky130_fd_sc_hd__fill_1
XANTENNA__2480__B1 net56 vssd1 vssd1 vccd1 vccd1 sky130_fd_sc_hd__diode_2
XFILLER_40_222 vssd1 vssd1 vccd1 vccd1 sky130_fd_sc_hd__fill_8
XFILLER_25_263 vssd1 vssd1 vccd1 vccd1 sky130_fd_sc_hd__fill_1
XFILLER_63_303 vssd1 vssd1 vccd1 vccd1 sky130_fd_sc_hd__fill_2
XFILLER_0_384 vssd1 vssd1 vccd1 vccd1 sky130_fd_sc_hd__fill_8
X_2820_ clknet_leaf_27_clk _0341_ net135 vssd1 vssd1 vccd1 vccd1 CALC_INST.gencon_inst.mult_calc.count.GENERATE_ADDER\[7\].thingy.in1
+ sky130_fd_sc_hd__dfrtp_1
X_2751_ clknet_leaf_31_clk _0003_ net119 vssd1 vssd1 vccd1 vccd1 CALC_INST.gencon_inst.mult_calc.state\[3\]
+ sky130_fd_sc_hd__dfrtp_1
XTAP_TAPCELL_ROW_18_269 vssd1 vccd1 sky130_fd_sc_hd__tapvpwrvgnd_1
X_1564_ _0708_ _0709_ vssd1 vssd1 vccd1 vccd1 _0814_ sky130_fd_sc_hd__nand2b_1
X_1702_ net434 net344 net96 vssd1 vssd1 vccd1 vccd1 _0214_ sky130_fd_sc_hd__mux2_1
X_2682_ clknet_leaf_26_clk _0220_ net141 vssd1 vssd1 vccd1 vccd1 CALC_INST.gencon_inst.mult_calc.compCount.in2\[13\]
+ sky130_fd_sc_hd__dfrtp_1
X_1633_ CALC_INST.gencon_inst.mult_calc.main.GENERATE_ADDER\[5\].thingy.in2 CALC_INST.gencon_inst.mult_calc.main.GENERATE_ADDER\[5\].thingy.in1
+ vssd1 vssd1 vccd1 vccd1 _0870_ sky130_fd_sc_hd__nand2_1
X_1495_ _0724_ _0728_ _0751_ _0725_ _0721_ vssd1 vssd1 vccd1 vccd1 _0754_ sky130_fd_sc_hd__o311a_1
XFILLER_54_369 vssd1 vssd1 vccd1 vccd1 sky130_fd_sc_hd__fill_2
XTAP_TAPCELL_ROW_52_504 vssd1 vccd1 sky130_fd_sc_hd__tapvpwrvgnd_1
Xfanout37 net40 vssd1 vssd1 vccd1 vccd1 net37 sky130_fd_sc_hd__clkbuf_4
XTAP_TAPCELL_ROW_1_148 vssd1 vccd1 sky130_fd_sc_hd__tapvpwrvgnd_1
X_2047_ _1088_ _1100_ vssd1 vssd1 vccd1 vccd1 _1101_ sky130_fd_sc_hd__nor2_1
X_2116_ net89 net90 vssd1 vssd1 vccd1 vccd1 _1161_ sky130_fd_sc_hd__and2_1
Xfanout59 _0522_ vssd1 vssd1 vccd1 vccd1 net59 sky130_fd_sc_hd__clkbuf_2
Xfanout48 _0648_ vssd1 vssd1 vccd1 vccd1 net48 sky130_fd_sc_hd__clkbuf_4
XFILLER_22_255 vssd1 vssd1 vccd1 vccd1 sky130_fd_sc_hd__fill_4
XTAP_TAPCELL_ROW_9_204 vssd1 vccd1 sky130_fd_sc_hd__tapvpwrvgnd_1
XFILLER_57_163 vssd1 vssd1 vccd1 vccd1 sky130_fd_sc_hd__fill_4
XFILLER_38_22 vssd1 vssd1 vccd1 vccd1 sky130_fd_sc_hd__fill_1
XANTENNA_fanout76_A _1145_ vssd1 vssd1 vccd1 vccd1 sky130_fd_sc_hd__diode_2
XFILLER_60_317 vssd1 vssd1 vccd1 vccd1 sky130_fd_sc_hd__fill_2
XFILLER_9_248 vssd1 vssd1 vccd1 vccd1 sky130_fd_sc_hd__fill_1
Xclkload29 clknet_leaf_17_clk vssd1 vssd1 vccd1 vccd1 clkload29/Y sky130_fd_sc_hd__inv_6
Xclkload18 clknet_leaf_24_clk vssd1 vssd1 vccd1 vccd1 clkload18/Y sky130_fd_sc_hd__bufinv_16
X_1280_ CALC_INST.gencon_inst.operator_input\[0\] CALC_INST.gencon_inst.key_read _0398_
+ _0397_ vssd1 vssd1 vccd1 vccd1 _0634_ sky130_fd_sc_hd__a31o_1
XFILLER_63_166 vssd1 vssd1 vccd1 vccd1 sky130_fd_sc_hd__fill_2
XFILLER_63_111 vssd1 vssd1 vccd1 vccd1 sky130_fd_sc_hd__fill_1
XFILLER_51_317 vssd1 vssd1 vccd1 vccd1 sky130_fd_sc_hd__fill_1
XANTENNA__2444__B1 _0520_ vssd1 vssd1 vccd1 vccd1 sky130_fd_sc_hd__diode_2
XFILLER_36_303 vssd1 vssd1 vccd1 vccd1 sky130_fd_sc_hd__fill_4
X_2734_ clknet_leaf_32_clk _0272_ net118 vssd1 vssd1 vccd1 vccd1 CALC_INST.gencon_inst.mult_calc.countSave\[1\]
+ sky130_fd_sc_hd__dfrtp_1
X_2803_ clknet_leaf_0_clk _0328_ net113 vssd1 vssd1 vccd1 vccd1 CALC_INST.input_ctrl_inst.col_index\[26\]
+ sky130_fd_sc_hd__dfrtp_2
X_1547_ _0753_ _0799_ vssd1 vssd1 vccd1 vccd1 _0800_ sky130_fd_sc_hd__xnor2_1
X_2596_ clknet_leaf_22_clk _0134_ vssd1 vssd1 vccd1 vccd1 CALC_INST.gencon_inst.mult_calc.INn1\[7\]
+ sky130_fd_sc_hd__dfxtp_1
X_2665_ clknet_leaf_24_clk _0203_ net142 vssd1 vssd1 vccd1 vccd1 CALC_INST.gencon_inst.mult_calc.adderSave\[11\]
+ sky130_fd_sc_hd__dfrtp_1
X_1616_ net422 net85 _0855_ net99 vssd1 vssd1 vccd1 vccd1 _0194_ sky130_fd_sc_hd__a22o_1
X_1478_ CALC_INST.gencon_inst.add_calc.main.GENERATE_ADDER\[3\].thingy.in1 _0734_
+ _0735_ vssd1 vssd1 vccd1 vccd1 _0737_ sky130_fd_sc_hd__nand3_1
XTAP_TAPCELL_ROW_37_397 vssd1 vccd1 sky130_fd_sc_hd__tapvpwrvgnd_1
XFILLER_24_24 vssd1 vssd1 vccd1 vccd1 sky130_fd_sc_hd__fill_4
Xhold270 CALC_INST.input_ctrl_inst.debounce_cnt\[2\] vssd1 vssd1 vccd1 vccd1 net466
+ sky130_fd_sc_hd__dlygate4sd3_1
XFILLER_49_87 vssd1 vssd1 vccd1 vccd1 sky130_fd_sc_hd__fill_4
Xhold281 net9 vssd1 vssd1 vccd1 vccd1 net477 sky130_fd_sc_hd__dlygate4sd3_1
XFILLER_45_144 vssd1 vssd1 vccd1 vccd1 sky130_fd_sc_hd__fill_1
XTAP_TAPCELL_ROW_11_220 vssd1 vccd1 sky130_fd_sc_hd__tapvpwrvgnd_1
XANTENNA__1483__B net103 vssd1 vssd1 vccd1 vccd1 sky130_fd_sc_hd__diode_2
X_1401_ CALC_INST.gencon_inst.add_calc.main.in2\[0\] _0675_ net107 vssd1 vssd1 vccd1
+ vccd1 _0159_ sky130_fd_sc_hd__mux2_1
X_2381_ CALC_INST.gencon_inst.gencon_state\[0\] CALC_INST.gencon_inst.gencon_state\[2\]
+ _1058_ CALC_INST.gencon_inst.gencon_state\[1\] vssd1 vssd1 vccd1 vccd1 _0519_ sky130_fd_sc_hd__and4bb_2
X_2450_ _0576_ _0519_ _0575_ vssd1 vssd1 vccd1 vccd1 _0577_ sky130_fd_sc_hd__and3b_1
XFILLER_5_262 vssd1 vssd1 vccd1 vccd1 sky130_fd_sc_hd__fill_2
X_1332_ CALC_INST.gencon_inst.operand2\[13\] net252 net52 vssd1 vssd1 vccd1 vccd1
+ _0119_ sky130_fd_sc_hd__mux2_1
X_1263_ _1234_ _0622_ vssd1 vssd1 vccd1 vccd1 _0623_ sky130_fd_sc_hd__and2_1
Xinput5 nrst vssd1 vssd1 vccd1 vccd1 net5 sky130_fd_sc_hd__clkbuf_2
XFILLER_51_169 vssd1 vssd1 vccd1 vccd1 sky130_fd_sc_hd__fill_2
XFILLER_36_177 vssd1 vssd1 vccd1 vccd1 sky130_fd_sc_hd__fill_1
XTAP_TAPCELL_ROW_34_378 vssd1 vccd1 sky130_fd_sc_hd__tapvpwrvgnd_1
XFILLER_17_391 vssd1 vssd1 vccd1 vccd1 sky130_fd_sc_hd__fill_1
X_2717_ clknet_leaf_30_clk _0255_ net122 vssd1 vssd1 vccd1 vccd1 CALC_INST.gencon_inst.mult_calc.out\[2\]
+ sky130_fd_sc_hd__dfrtp_1
X_2648_ clknet_leaf_16_clk _0186_ net151 vssd1 vssd1 vccd1 vccd1 CALC_INST.gencon_inst.ALU_out\[12\]
+ sky130_fd_sc_hd__dfrtp_1
X_2579_ clknet_leaf_18_clk _0117_ vssd1 vssd1 vccd1 vccd1 CALC_INST.gencon_inst.ALU_in2\[11\]
+ sky130_fd_sc_hd__dfxtp_1
XFILLER_35_23 vssd1 vssd1 vccd1 vccd1 sky130_fd_sc_hd__fill_2
XFILLER_27_111 vssd1 vssd1 vccd1 vccd1 sky130_fd_sc_hd__fill_1
XTAP_TAPCELL_ROW_25_312 vssd1 vccd1 sky130_fd_sc_hd__tapvpwrvgnd_1
XFILLER_35_78 vssd1 vssd1 vccd1 vccd1 sky130_fd_sc_hd__fill_1
XFILLER_23_383 vssd1 vssd1 vccd1 vccd1 sky130_fd_sc_hd__fill_1
XFILLER_18_9 vssd1 vssd1 vccd1 vccd1 sky130_fd_sc_hd__fill_1
XFILLER_33_103 vssd1 vssd1 vccd1 vccd1 sky130_fd_sc_hd__fill_8
XANTENNA__2354__S net35 vssd1 vssd1 vccd1 vccd1 sky130_fd_sc_hd__diode_2
X_1950_ CALC_INST.input_ctrl_inst.scan_timer\[1\] _1023_ vssd1 vssd1 vccd1 vccd1 _1026_
+ sky130_fd_sc_hd__nand2_1
XTAP_TAPCELL_ROW_31_359 vssd1 vccd1 sky130_fd_sc_hd__tapvpwrvgnd_1
X_2502_ clknet_leaf_23_clk _0044_ net142 vssd1 vssd1 vccd1 vccd1 CALC_INST.gencon_inst.operand2\[12\]
+ sky130_fd_sc_hd__dfrtp_2
X_1881_ _0986_ _0987_ vssd1 vssd1 vccd1 vccd1 _0988_ sky130_fd_sc_hd__or2_1
X_1315_ CALC_INST.gencon_inst.operand1\[12\] net251 net52 vssd1 vssd1 vccd1 vccd1
+ _0102_ sky130_fd_sc_hd__mux2_1
X_2433_ CALC_INST.gencon_inst.operand1\[7\] net43 _0562_ _0563_ vssd1 vssd1 vccd1
+ vccd1 _0054_ sky130_fd_sc_hd__o22a_1
X_2364_ CALC_INST.gencon_inst.operand2\[10\] _0499_ CALC_INST.gencon_inst.operand2\[11\]
+ vssd1 vssd1 vccd1 vccd1 _0506_ sky130_fd_sc_hd__a21oi_1
XTAP_TAPCELL_ROW_47_470 vssd1 vccd1 sky130_fd_sc_hd__tapvpwrvgnd_1
X_1246_ net10 net57 _0593_ _0609_ vssd1 vssd1 vccd1 vccd1 _0611_ sky130_fd_sc_hd__a22o_1
XTAP_TAPCELL_ROW_39_415 vssd1 vccd1 sky130_fd_sc_hd__tapvpwrvgnd_1
XFILLER_24_114 vssd1 vssd1 vccd1 vccd1 sky130_fd_sc_hd__fill_8
XFILLER_2_82 vssd1 vssd1 vccd1 vccd1 sky130_fd_sc_hd__fill_2
X_2295_ CALC_INST.input_ctrl_inst.col_index\[1\] _1065_ _0454_ vssd1 vssd1 vccd1 vccd1
+ net26 sky130_fd_sc_hd__or3_1
XFILLER_20_353 vssd1 vssd1 vccd1 vccd1 sky130_fd_sc_hd__fill_1
XFILLER_21_69 vssd1 vssd1 vccd1 vccd1 sky130_fd_sc_hd__fill_8
XFILLER_21_25 vssd1 vssd1 vccd1 vccd1 sky130_fd_sc_hd__fill_4
XFILLER_55_272 vssd1 vssd1 vccd1 vccd1 sky130_fd_sc_hd__fill_8
XFILLER_46_77 vssd1 vssd1 vccd1 vccd1 sky130_fd_sc_hd__fill_4
XANTENNA_clkbuf_2_0__f_clk_A clknet_0_clk vssd1 vssd1 vccd1 vccd1 sky130_fd_sc_hd__diode_2
XANTENNA_clkbuf_leaf_16_clk_A clknet_2_3__leaf_clk vssd1 vssd1 vccd1 vccd1 sky130_fd_sc_hd__diode_2
XFILLER_7_335 vssd1 vssd1 vccd1 vccd1 sky130_fd_sc_hd__fill_1
XFILLER_46_261 vssd1 vssd1 vccd1 vccd1 sky130_fd_sc_hd__fill_1
X_2080_ CALC_INST.gencon_inst.mult_calc.count.GENERATE_ADDER\[13\].thingy.in1 _1095_
+ vssd1 vssd1 vccd1 vccd1 _1134_ sky130_fd_sc_hd__or2_1
XTAP_TAPCELL_ROW_44_451 vssd1 vccd1 sky130_fd_sc_hd__tapvpwrvgnd_1
X_1933_ _1083_ _1010_ vssd1 vssd1 vccd1 vccd1 _1016_ sky130_fd_sc_hd__nand2_1
X_1864_ CALC_INST.input_ctrl_inst.col_index\[20\] _0974_ vssd1 vssd1 vccd1 vccd1 _0976_
+ sky130_fd_sc_hd__nor2_1
X_1795_ _0924_ _0925_ _0926_ vssd1 vssd1 vccd1 vccd1 _0927_ sky130_fd_sc_hd__or3_1
X_2416_ _0520_ _0549_ net42 vssd1 vssd1 vccd1 vccd1 _0550_ sky130_fd_sc_hd__o21ai_1
X_2347_ CALC_INST.gencon_inst.operand2\[7\] _0489_ vssd1 vssd1 vccd1 vccd1 _0493_
+ sky130_fd_sc_hd__and2_1
X_2278_ _1066_ net74 _0422_ vssd1 vssd1 vccd1 vccd1 _0440_ sky130_fd_sc_hd__or3_1
XFILLER_37_283 vssd1 vssd1 vccd1 vccd1 sky130_fd_sc_hd__fill_1
XTAP_TAPCELL_ROW_50_487 vssd1 vccd1 sky130_fd_sc_hd__tapvpwrvgnd_1
XFILLER_4_316 vssd1 vssd1 vccd1 vccd1 sky130_fd_sc_hd__fill_2
XFILLER_12_128 vssd1 vssd1 vccd1 vccd1 sky130_fd_sc_hd__fill_1
XFILLER_57_10 vssd1 vssd1 vccd1 vccd1 sky130_fd_sc_hd__fill_1
XANTENNA__1770__B1 net86 vssd1 vssd1 vccd1 vccd1 sky130_fd_sc_hd__diode_2
XTAP_TAPCELL_ROW_58_543 vssd1 vccd1 sky130_fd_sc_hd__tapvpwrvgnd_1
XTAP_TAPCELL_ROW_7_187 vssd1 vccd1 sky130_fd_sc_hd__tapvpwrvgnd_1
XFILLER_43_253 vssd1 vssd1 vccd1 vccd1 sky130_fd_sc_hd__fill_1
X_1580_ CALC_INST.gencon_inst.ALU_out\[12\] _0827_ CALC_INST.gencon_inst.add_calc.state\[1\]
+ vssd1 vssd1 vccd1 vccd1 _0186_ sky130_fd_sc_hd__mux2_1
XANTENNA__1248__S _0393_ vssd1 vssd1 vccd1 vccd1 sky130_fd_sc_hd__diode_2
XFILLER_22_90 vssd1 vssd1 vccd1 vccd1 sky130_fd_sc_hd__fill_8
XFILLER_7_165 vssd1 vssd1 vccd1 vccd1 sky130_fd_sc_hd__fill_2
XFILLER_7_198 vssd1 vssd1 vccd1 vccd1 sky130_fd_sc_hd__fill_2
X_2201_ CALC_INST.input_ctrl_inst.debounce_cnt\[17\] _1224_ CALC_INST.input_ctrl_inst.debounce_cnt\[18\]
+ vssd1 vssd1 vccd1 vccd1 _1227_ sky130_fd_sc_hd__a21oi_1
X_2132_ _1075_ _1080_ vssd1 vssd1 vccd1 vccd1 _1175_ sky130_fd_sc_hd__nand2_2
XFILLER_3_393 vccd1 vssd1 vccd1 vssd1 sky130_ef_sc_hd__decap_40_12
X_2063_ CALC_INST.gencon_inst.mult_calc.compCount.in2\[6\] _1114_ _1116_ CALC_INST.gencon_inst.mult_calc.compCount.in2\[7\]
+ vssd1 vssd1 vccd1 vccd1 _1117_ sky130_fd_sc_hd__a22o_1
XPHY_EDGE_ROW_14_Left_79 vssd1 vssd1 vccd1 vccd1 sky130_fd_sc_hd__decap_3
X_1916_ net93 net297 net77 net338 vssd1 vssd1 vccd1 vccd1 _0347_ sky130_fd_sc_hd__a22o_1
X_1847_ _0963_ _0964_ vssd1 vssd1 vccd1 vccd1 _0316_ sky130_fd_sc_hd__and2_1
X_1778_ CALC_INST.gencon_inst.operand2\[2\] net48 net37 net413 vssd1 vssd1 vccd1 vccd1
+ _0288_ sky130_fd_sc_hd__a22o_1
XFILLER_57_345 vssd1 vssd1 vccd1 vccd1 sky130_fd_sc_hd__fill_8
XTAP_TAPCELL_ROW_55_524 vssd1 vccd1 sky130_fd_sc_hd__tapvpwrvgnd_1
XFILLER_27_57 vssd1 vssd1 vccd1 vccd1 sky130_fd_sc_hd__fill_2
XTAP_TAPCELL_ROW_4_168 vssd1 vccd1 sky130_fd_sc_hd__tapvpwrvgnd_1
XFILLER_4_39 vssd1 vssd1 vccd1 vccd1 sky130_fd_sc_hd__fill_4
XFILLER_0_363 vssd1 vssd1 vccd1 vccd1 sky130_fd_sc_hd__fill_1
XFILLER_48_345 vssd1 vssd1 vccd1 vccd1 sky130_fd_sc_hd__fill_2
XANTENNA__1274__A2 _0397_ vssd1 vssd1 vccd1 vccd1 sky130_fd_sc_hd__diode_2
XFILLER_16_220 vssd1 vssd1 vccd1 vccd1 sky130_fd_sc_hd__fill_4
XFILLER_16_231 vssd1 vssd1 vccd1 vccd1 sky130_fd_sc_hd__fill_1
XFILLER_16_275 vssd1 vssd1 vccd1 vccd1 sky130_fd_sc_hd__fill_2
XANTENNA__2362__S net35 vssd1 vssd1 vccd1 vccd1 sky130_fd_sc_hd__diode_2
X_2681_ clknet_leaf_26_clk _0219_ net140 vssd1 vssd1 vccd1 vccd1 CALC_INST.gencon_inst.mult_calc.compCount.in2\[12\]
+ sky130_fd_sc_hd__dfrtp_1
X_1701_ net387 net365 net96 vssd1 vssd1 vccd1 vccd1 _0213_ sky130_fd_sc_hd__mux2_1
X_2750_ clknet_leaf_31_clk _0007_ net134 vssd1 vssd1 vccd1 vccd1 CALC_INST.gencon_inst.mult_calc.state\[2\]
+ sky130_fd_sc_hd__dfrtp_1
X_1494_ _0724_ _0728_ _0751_ _0725_ vssd1 vssd1 vccd1 vccd1 _0753_ sky130_fd_sc_hd__o31a_1
X_1563_ _0798_ _0800_ _0805_ _0810_ vssd1 vssd1 vccd1 vccd1 _0813_ sky130_fd_sc_hd__or4_1
XANTENNA__1734__B1 net77 vssd1 vssd1 vccd1 vccd1 sky130_fd_sc_hd__diode_2
X_1632_ _0868_ vssd1 vssd1 vccd1 vccd1 _0869_ sky130_fd_sc_hd__inv_2
XFILLER_58_109 vssd1 vssd1 vccd1 vccd1 sky130_fd_sc_hd__fill_2
XFILLER_39_389 vssd1 vssd1 vccd1 vccd1 sky130_fd_sc_hd__fill_2
X_2115_ net89 net90 vssd1 vssd1 vccd1 vccd1 _1160_ sky130_fd_sc_hd__nor2_1
XTAP_TAPCELL_ROW_1_149 vssd1 vccd1 sky130_fd_sc_hd__tapvpwrvgnd_1
XTAP_TAPCELL_ROW_52_505 vssd1 vccd1 sky130_fd_sc_hd__tapvpwrvgnd_1
Xfanout49 _0648_ vssd1 vssd1 vccd1 vccd1 net49 sky130_fd_sc_hd__dlymetal6s2s_1
Xfanout38 net39 vssd1 vssd1 vccd1 vccd1 net38 sky130_fd_sc_hd__buf_2
X_2046_ CALC_INST.gencon_inst.mult_calc.count.GENERATE_ADDER\[1\].thingy.in1 CALC_INST.gencon_inst.mult_calc.count.GENERATE_ADDER\[1\].thingy.cIn
+ CALC_INST.gencon_inst.mult_calc.count.GENERATE_ADDER\[2\].thingy.in1 vssd1 vssd1
+ vccd1 vccd1 _1100_ sky130_fd_sc_hd__a21oi_1
XTAP_TAPCELL_ROW_60_560 vssd1 vccd1 sky130_fd_sc_hd__tapvpwrvgnd_1
XTAP_TAPCELL_ROW_9_205 vssd1 vccd1 sky130_fd_sc_hd__tapvpwrvgnd_1
X_2879_ clknet_leaf_1_clk _0374_ vssd1 vssd1 vccd1 vccd1 CALC_INST.input_ctrl_inst.scan_timer\[17\]
+ sky130_fd_sc_hd__dfxtp_1
XFILLER_1_138 vssd1 vssd1 vccd1 vccd1 sky130_fd_sc_hd__fill_2
XFILLER_13_223 vssd1 vssd1 vccd1 vccd1 sky130_fd_sc_hd__fill_1
Xclkload19 clknet_leaf_25_clk vssd1 vssd1 vccd1 vccd1 clkload19/Y sky130_fd_sc_hd__clkinv_8
XFILLER_48_175 vssd1 vssd1 vccd1 vccd1 sky130_fd_sc_hd__fill_4
XFILLER_63_189 vssd1 vssd1 vccd1 vccd1 sky130_fd_sc_hd__fill_4
X_2664_ clknet_leaf_24_clk _0202_ net142 vssd1 vssd1 vccd1 vccd1 CALC_INST.gencon_inst.mult_calc.adderSave\[10\]
+ sky130_fd_sc_hd__dfrtp_1
X_2733_ clknet_leaf_32_clk _0271_ net118 vssd1 vssd1 vccd1 vccd1 CALC_INST.gencon_inst.mult_calc.countSave\[0\]
+ sky130_fd_sc_hd__dfrtp_1
X_2802_ clknet_leaf_0_clk _0327_ net114 vssd1 vssd1 vccd1 vccd1 CALC_INST.input_ctrl_inst.col_index\[25\]
+ sky130_fd_sc_hd__dfrtp_1
XTAP_TAPCELL_ROW_14_240 vssd1 vccd1 sky130_fd_sc_hd__tapvpwrvgnd_1
X_1546_ _0720_ _0721_ vssd1 vssd1 vccd1 vccd1 _0799_ sky130_fd_sc_hd__and2b_1
X_1477_ _0734_ _0735_ CALC_INST.gencon_inst.add_calc.main.GENERATE_ADDER\[3\].thingy.in1
+ vssd1 vssd1 vccd1 vccd1 _0736_ sky130_fd_sc_hd__a21oi_1
X_2595_ clknet_leaf_21_clk _0133_ vssd1 vssd1 vccd1 vccd1 CALC_INST.gencon_inst.mult_calc.INn1\[6\]
+ sky130_fd_sc_hd__dfxtp_1
X_1615_ _0852_ _0854_ vssd1 vssd1 vccd1 vccd1 _0855_ sky130_fd_sc_hd__xnor2_1
XFILLER_42_307 vssd1 vssd1 vccd1 vccd1 sky130_fd_sc_hd__fill_1
XFILLER_50_384 vssd1 vssd1 vccd1 vccd1 sky130_fd_sc_hd__fill_1
X_2029_ net88 CALC_INST.input_ctrl_inst.input_control_state\[1\] CALC_INST.input_ctrl_inst.input_control_state\[0\]
+ vssd1 vssd1 vccd1 vccd1 _1084_ sky130_fd_sc_hd__nand3b_4
XTAP_TAPCELL_ROW_37_398 vssd1 vccd1 sky130_fd_sc_hd__tapvpwrvgnd_1
XPHY_EDGE_ROW_17_Left_82 vssd1 vssd1 vccd1 vccd1 sky130_fd_sc_hd__decap_3
Xhold271 CALC_INST.input_ctrl_inst.debounce_cnt\[12\] vssd1 vssd1 vccd1 vccd1 net467
+ sky130_fd_sc_hd__dlygate4sd3_1
XFILLER_40_68 vssd1 vssd1 vccd1 vccd1 sky130_fd_sc_hd__fill_4
Xhold260 CALC_INST.gencon_inst.operator_input\[2\] vssd1 vssd1 vccd1 vccd1 net456
+ sky130_fd_sc_hd__dlygate4sd3_1
XFILLER_40_46 vssd1 vssd1 vccd1 vccd1 sky130_fd_sc_hd__fill_1
XFILLER_2_403 vssd1 vssd1 vccd1 vccd1 sky130_fd_sc_hd__fill_1
Xhold282 CALC_INST.input_ctrl_inst.debounce_cnt\[4\] vssd1 vssd1 vccd1 vccd1 net478
+ sky130_fd_sc_hd__dlygate4sd3_1
XFILLER_49_33 vssd1 vssd1 vccd1 vccd1 sky130_fd_sc_hd__fill_1
XFILLER_60_159 vssd1 vssd1 vccd1 vccd1 sky130_fd_sc_hd__fill_8
XFILLER_45_167 vssd1 vssd1 vccd1 vccd1 sky130_fd_sc_hd__fill_1
XFILLER_41_340 vssd1 vssd1 vccd1 vccd1 sky130_fd_sc_hd__fill_1
X_1400_ CALC_INST.gencon_inst.ALU_in1\[0\] CALC_INST.gencon_inst.ALU_in2\[0\] net64
+ vssd1 vssd1 vccd1 vccd1 _0675_ sky130_fd_sc_hd__mux2_1
X_1331_ CALC_INST.gencon_inst.operand2\[12\] net246 net52 vssd1 vssd1 vccd1 vccd1
+ _0118_ sky130_fd_sc_hd__mux2_1
XANTENNA__2362__A0 CALC_INST.gencon_inst.operand2\[10\] vssd1 vssd1 vccd1 vccd1 sky130_fd_sc_hd__diode_2
X_2380_ _0517_ _0518_ CALC_INST.gencon_inst.operand2\[14\] net34 vssd1 vssd1 vccd1
+ vccd1 _0046_ sky130_fd_sc_hd__o2bb2a_1
X_1262_ CALC_INST.gencon_inst.operand2\[11\] CALC_INST.gencon_inst.operand1\[11\]
+ net73 vssd1 vssd1 vccd1 vccd1 _0622_ sky130_fd_sc_hd__mux2_1
XTAP_TAPCELL_ROW_34_379 vssd1 vccd1 sky130_fd_sc_hd__tapvpwrvgnd_1
XFILLER_32_373 vssd1 vssd1 vccd1 vccd1 sky130_fd_sc_hd__fill_2
XFILLER_32_351 vccd1 vssd1 vccd1 vssd1 sky130_ef_sc_hd__decap_40_12
X_2647_ clknet_leaf_16_clk _0185_ net151 vssd1 vssd1 vccd1 vccd1 CALC_INST.gencon_inst.ALU_out\[11\]
+ sky130_fd_sc_hd__dfrtp_1
X_2716_ clknet_leaf_3_clk _0254_ net122 vssd1 vssd1 vccd1 vccd1 CALC_INST.gencon_inst.mult_calc.out\[1\]
+ sky130_fd_sc_hd__dfrtp_1
XFILLER_10_27 vssd1 vssd1 vccd1 vccd1 sky130_fd_sc_hd__fill_1
X_1529_ _0749_ _0784_ vssd1 vssd1 vccd1 vccd1 _0785_ sky130_fd_sc_hd__xnor2_1
XFILLER_59_204 vssd1 vssd1 vccd1 vccd1 sky130_fd_sc_hd__fill_2
X_2578_ clknet_leaf_17_clk _0116_ vssd1 vssd1 vccd1 vccd1 CALC_INST.gencon_inst.ALU_in2\[10\]
+ sky130_fd_sc_hd__dfxtp_1
XTAP_TAPCELL_ROW_25_313 vssd1 vccd1 sky130_fd_sc_hd__tapvpwrvgnd_1
XFILLER_50_181 vssd1 vssd1 vccd1 vccd1 sky130_fd_sc_hd__fill_1
XPHY_EDGE_ROW_2_Left_67 vssd1 vssd1 vccd1 vccd1 sky130_fd_sc_hd__decap_3
XPHY_EDGE_ROW_14_Right_14 vssd1 vssd1 vccd1 vccd1 sky130_fd_sc_hd__decap_3
XPHY_EDGE_ROW_23_Right_23 vssd1 vssd1 vccd1 vccd1 sky130_fd_sc_hd__decap_3
XFILLER_2_277 vssd1 vssd1 vccd1 vccd1 sky130_fd_sc_hd__fill_2
XANTENNA_fanout91_X net91 vssd1 vssd1 vccd1 vccd1 sky130_fd_sc_hd__diode_2
XFILLER_33_126 vssd1 vssd1 vccd1 vccd1 sky130_fd_sc_hd__fill_1
XPHY_EDGE_ROW_32_Right_32 vssd1 vssd1 vccd1 vccd1 sky130_fd_sc_hd__decap_3
X_1880_ CALC_INST.input_ctrl_inst.col_index\[25\] _0984_ vssd1 vssd1 vccd1 vccd1 _0987_
+ sky130_fd_sc_hd__and2_1
X_2501_ clknet_leaf_23_clk _0043_ net142 vssd1 vssd1 vccd1 vccd1 CALC_INST.gencon_inst.operand2\[11\]
+ sky130_fd_sc_hd__dfrtp_2
X_1314_ CALC_INST.gencon_inst.operand1\[11\] net272 net53 vssd1 vssd1 vccd1 vccd1
+ _0101_ sky130_fd_sc_hd__mux2_1
XPHY_EDGE_ROW_41_Right_41 vssd1 vssd1 vccd1 vccd1 sky130_fd_sc_hd__decap_3
XTAP_TAPCELL_ROW_39_416 vssd1 vccd1 sky130_fd_sc_hd__tapvpwrvgnd_1
X_2432_ CALC_INST.gencon_inst.ALU_out\[7\] net70 net59 CALC_INST.gencon_inst.mult_calc.out\[7\]
+ net41 vssd1 vssd1 vccd1 vccd1 _0563_ sky130_fd_sc_hd__a221o_1
X_2363_ CALC_INST.gencon_inst.operand2\[11\] CALC_INST.gencon_inst.operand2\[10\]
+ _0499_ vssd1 vssd1 vccd1 vccd1 _0505_ sky130_fd_sc_hd__and3_1
XANTENNA__1714__S net96 vssd1 vssd1 vccd1 vccd1 sky130_fd_sc_hd__diode_2
X_2294_ CALC_INST.input_ctrl_inst.col_index\[1\] CALC_INST.input_ctrl_inst.col_index\[0\]
+ vssd1 vssd1 vccd1 vccd1 _0455_ sky130_fd_sc_hd__nand2_2
XFILLER_64_251 vssd1 vssd1 vccd1 vccd1 sky130_fd_sc_hd__fill_1
XPHY_EDGE_ROW_50_Right_50 vssd1 vssd1 vccd1 vccd1 sky130_fd_sc_hd__decap_3
XTAP_TAPCELL_ROW_47_471 vssd1 vccd1 sky130_fd_sc_hd__tapvpwrvgnd_1
XANTENNA__1302__X _0646_ vssd1 vssd1 vccd1 vccd1 sky130_fd_sc_hd__diode_2
X_1245_ CALC_INST.gencon_inst.ALU_out\[6\] net70 net54 CALC_INST.gencon_inst.mult_calc.out\[6\]
+ vssd1 vssd1 vccd1 vccd1 _0610_ sky130_fd_sc_hd__a22o_1
XANTENNA_fanout51_A _0646_ vssd1 vssd1 vccd1 vccd1 sky130_fd_sc_hd__diode_2
XFILLER_7_347 vssd1 vssd1 vccd1 vccd1 sky130_fd_sc_hd__fill_1
XFILLER_11_354 vssd1 vssd1 vccd1 vccd1 sky130_fd_sc_hd__fill_2
XFILLER_23_8 vssd1 vssd1 vccd1 vccd1 sky130_fd_sc_hd__fill_8
X_1932_ CALC_INST.input_ctrl_inst.decoded_key\[2\] _1062_ _1151_ vssd1 vssd1 vccd1
+ vccd1 _1015_ sky130_fd_sc_hd__and3_1
X_1863_ _0947_ _0975_ _0972_ vssd1 vssd1 vccd1 vccd1 _0321_ sky130_fd_sc_hd__o21ai_1
X_2415_ _0542_ _0545_ CALC_INST.gencon_inst.operand1\[4\] vssd1 vssd1 vccd1 vccd1
+ _0549_ sky130_fd_sc_hd__o21a_1
X_1794_ _1060_ CALC_INST.input_ctrl_inst.scan_timer\[11\] CALC_INST.input_ctrl_inst.scan_timer\[10\]
+ CALC_INST.input_ctrl_inst.scan_timer\[8\] vssd1 vssd1 vccd1 vccd1 _0926_ sky130_fd_sc_hd__or4b_1
X_2346_ CALC_INST.gencon_inst.operand2\[7\] _0489_ vssd1 vssd1 vccd1 vccd1 _0492_
+ sky130_fd_sc_hd__or2_1
XFILLER_29_218 vssd1 vssd1 vccd1 vccd1 sky130_fd_sc_hd__fill_4
X_2277_ _0419_ _0424_ _0438_ _0436_ vssd1 vssd1 vccd1 vccd1 _0439_ sky130_fd_sc_hd__a31o_1
XFILLER_52_287 vssd1 vssd1 vccd1 vccd1 sky130_fd_sc_hd__fill_1
XFILLER_52_232 vssd1 vssd1 vccd1 vccd1 sky130_fd_sc_hd__fill_1
XFILLER_25_402 vssd1 vssd1 vccd1 vccd1 sky130_fd_sc_hd__fill_4
Xclkbuf_leaf_32_clk clknet_2_0__leaf_clk vssd1 vssd1 vccd1 vccd1 clknet_leaf_32_clk
+ sky130_fd_sc_hd__clkbuf_8
XTAP_TAPCELL_ROW_50_488 vssd1 vccd1 sky130_fd_sc_hd__tapvpwrvgnd_1
XFILLER_32_69 vssd1 vssd1 vccd1 vccd1 sky130_fd_sc_hd__fill_1
XFILLER_32_36 vssd1 vssd1 vccd1 vccd1 sky130_fd_sc_hd__fill_4
XFILLER_4_328 vssd1 vssd1 vccd1 vccd1 sky130_fd_sc_hd__fill_1
XFILLER_20_195 vssd1 vssd1 vccd1 vccd1 sky130_fd_sc_hd__fill_1
XTAP_TAPCELL_ROW_7_188 vssd1 vccd1 sky130_fd_sc_hd__tapvpwrvgnd_1
XANTENNA_fanout99_A net100 vssd1 vssd1 vccd1 vccd1 sky130_fd_sc_hd__diode_2
XTAP_TAPCELL_ROW_58_544 vssd1 vccd1 sky130_fd_sc_hd__tapvpwrvgnd_1
XFILLER_57_55 vssd1 vssd1 vccd1 vccd1 sky130_fd_sc_hd__fill_1
XANTENNA_fanout54_X net54 vssd1 vssd1 vccd1 vccd1 sky130_fd_sc_hd__diode_2
Xclkbuf_leaf_23_clk clknet_2_2__leaf_clk vssd1 vssd1 vccd1 vccd1 clknet_leaf_23_clk
+ sky130_fd_sc_hd__clkbuf_8
XPHY_EDGE_ROW_5_Left_70 vssd1 vssd1 vccd1 vccd1 sky130_fd_sc_hd__decap_3
XANTENNA__1761__B2 net84 vssd1 vssd1 vccd1 vccd1 sky130_fd_sc_hd__diode_2
X_2200_ _1052_ net36 _1224_ _1226_ vssd1 vssd1 vccd1 vccd1 _0016_ sky130_fd_sc_hd__a31o_1
X_2131_ _1078_ _1172_ vssd1 vssd1 vccd1 vccd1 _1174_ sky130_fd_sc_hd__or2_1
X_2062_ CALC_INST.gencon_inst.mult_calc.count.GENERATE_ADDER\[7\].thingy.in1 _1091_
+ vssd1 vssd1 vccd1 vccd1 _1116_ sky130_fd_sc_hd__xnor2_1
Xclkbuf_leaf_14_clk clknet_2_3__leaf_clk vssd1 vssd1 vccd1 vccd1 clknet_leaf_14_clk
+ sky130_fd_sc_hd__clkbuf_8
X_1777_ CALC_INST.gencon_inst.operand2\[1\] _0649_ _0651_ net263 vssd1 vssd1 vccd1
+ vccd1 _0287_ sky130_fd_sc_hd__o22a_1
X_1846_ CALC_INST.input_ctrl_inst.col_index\[14\] _0962_ vssd1 vssd1 vccd1 vccd1 _0964_
+ sky130_fd_sc_hd__nand2_1
X_1915_ net93 net292 net77 net355 vssd1 vssd1 vccd1 vccd1 _0346_ sky130_fd_sc_hd__a22o_1
XANTENNA_clkbuf_leaf_15_clk_A clknet_2_3__leaf_clk vssd1 vssd1 vccd1 vccd1 sky130_fd_sc_hd__diode_2
XPHY_EDGE_ROW_4_Right_4 vssd1 vssd1 vccd1 vccd1 sky130_fd_sc_hd__decap_3
XFILLER_57_368 vssd1 vssd1 vccd1 vccd1 sky130_fd_sc_hd__fill_4
XFILLER_57_335 vssd1 vssd1 vccd1 vccd1 sky130_fd_sc_hd__fill_1
XTAP_TAPCELL_ROW_55_525 vssd1 vccd1 sky130_fd_sc_hd__tapvpwrvgnd_1
XANTENNA__2465__C1 _0524_ vssd1 vssd1 vccd1 vccd1 sky130_fd_sc_hd__diode_2
X_2329_ _0405_ _0477_ vssd1 vssd1 vccd1 vccd1 _0479_ sky130_fd_sc_hd__nor2_1
XTAP_TAPCELL_ROW_4_169 vssd1 vccd1 sky130_fd_sc_hd__tapvpwrvgnd_1
XTAP_TAPCELL_ROW_63_580 vssd1 vccd1 sky130_fd_sc_hd__tapvpwrvgnd_1
XFILLER_43_57 vssd1 vssd1 vccd1 vccd1 sky130_fd_sc_hd__fill_2
XFILLER_43_46 vssd1 vssd1 vccd1 vccd1 sky130_fd_sc_hd__fill_8
XFILLER_4_103 vccd1 vssd1 vccd1 vssd1 sky130_ef_sc_hd__decap_40_12
XPHY_EDGE_ROW_31_Left_96 vssd1 vssd1 vccd1 vccd1 sky130_fd_sc_hd__decap_3
XFILLER_0_397 vssd1 vssd1 vccd1 vccd1 sky130_fd_sc_hd__fill_1
XFILLER_0_331 vssd1 vssd1 vccd1 vccd1 sky130_fd_sc_hd__fill_4
XFILLER_63_305 vssd1 vssd1 vccd1 vccd1 sky130_fd_sc_hd__fill_1
XANTENNA__1259__A0 CALC_INST.gencon_inst.operand2\[10\] vssd1 vssd1 vccd1 vccd1 sky130_fd_sc_hd__diode_2
XANTENNA__2456__C1 _0524_ vssd1 vssd1 vccd1 vccd1 sky130_fd_sc_hd__diode_2
XFILLER_16_243 vssd1 vssd1 vccd1 vccd1 sky130_fd_sc_hd__fill_1
XFILLER_16_298 vssd1 vssd1 vccd1 vccd1 sky130_fd_sc_hd__fill_8
XANTENNA__1259__S net73 vssd1 vssd1 vccd1 vccd1 sky130_fd_sc_hd__diode_2
XFILLER_31_279 vssd1 vssd1 vccd1 vccd1 sky130_fd_sc_hd__fill_1
X_2680_ clknet_leaf_26_clk _0218_ net140 vssd1 vssd1 vccd1 vccd1 CALC_INST.gencon_inst.mult_calc.compCount.in2\[11\]
+ sky130_fd_sc_hd__dfrtp_1
X_1700_ net435 net382 net96 vssd1 vssd1 vccd1 vccd1 _0212_ sky130_fd_sc_hd__mux2_1
X_1631_ CALC_INST.gencon_inst.mult_calc.main.GENERATE_ADDER\[5\].thingy.in2 CALC_INST.gencon_inst.mult_calc.main.GENERATE_ADDER\[5\].thingy.in1
+ vssd1 vssd1 vccd1 vccd1 _0868_ sky130_fd_sc_hd__or2_1
X_1562_ _0812_ _0811_ CALC_INST.gencon_inst.ALU_out\[9\] _1061_ vssd1 vssd1 vccd1
+ vccd1 _0183_ sky130_fd_sc_hd__a2bb2o_1
X_1493_ _0728_ _0751_ vssd1 vssd1 vccd1 vccd1 _0752_ sky130_fd_sc_hd__nor2_1
XANTENNA__2231__X _0397_ vssd1 vssd1 vccd1 vccd1 sky130_fd_sc_hd__diode_2
Xclkbuf_leaf_3_clk clknet_2_0__leaf_clk vssd1 vssd1 vccd1 vccd1 clknet_leaf_3_clk
+ sky130_fd_sc_hd__clkbuf_8
X_2114_ CALC_INST.input_ctrl_inst.decoded_key\[2\] _1084_ _1148_ _1159_ vssd1 vssd1
+ vccd1 vccd1 _0029_ sky130_fd_sc_hd__a211o_1
XANTENNA_clkbuf_2_2__f_clk_X clknet_2_2__leaf_clk vssd1 vssd1 vccd1 vccd1 sky130_fd_sc_hd__diode_2
X_2045_ _1089_ _1098_ vssd1 vssd1 vccd1 vccd1 _1099_ sky130_fd_sc_hd__or2_1
XTAP_TAPCELL_ROW_60_561 vssd1 vccd1 sky130_fd_sc_hd__tapvpwrvgnd_1
XTAP_TAPCELL_ROW_52_506 vssd1 vccd1 sky130_fd_sc_hd__tapvpwrvgnd_1
Xfanout39 net40 vssd1 vssd1 vccd1 vccd1 net39 sky130_fd_sc_hd__buf_2
XTAP_TAPCELL_ROW_17_260 vssd1 vccd1 sky130_fd_sc_hd__tapvpwrvgnd_1
XFILLER_1_106 vssd1 vssd1 vccd1 vccd1 sky130_fd_sc_hd__fill_2
XTAP_TAPCELL_ROW_9_206 vssd1 vccd1 sky130_fd_sc_hd__tapvpwrvgnd_1
X_1829_ CALC_INST.input_ctrl_inst.col_index\[4\] _1161_ vssd1 vssd1 vccd1 vccd1 _0954_
+ sky130_fd_sc_hd__nand2_1
X_2878_ clknet_leaf_1_clk _0373_ vssd1 vssd1 vccd1 vccd1 CALC_INST.input_ctrl_inst.scan_timer\[16\]
+ sky130_fd_sc_hd__dfxtp_1
XFILLER_45_316 vssd1 vssd1 vccd1 vccd1 sky130_fd_sc_hd__fill_2
XFILLER_5_401 vssd1 vssd1 vccd1 vccd1 sky130_fd_sc_hd__fill_2
XFILLER_63_113 vccd1 vssd1 vccd1 vssd1 sky130_ef_sc_hd__decap_40_12
XFILLER_36_316 vssd1 vssd1 vccd1 vccd1 sky130_fd_sc_hd__fill_8
XFILLER_63_157 vssd1 vssd1 vccd1 vccd1 sky130_fd_sc_hd__fill_1
X_2801_ clknet_leaf_0_clk _0326_ net113 vssd1 vssd1 vccd1 vccd1 CALC_INST.input_ctrl_inst.col_index\[24\]
+ sky130_fd_sc_hd__dfrtp_1
XTAP_TAPCELL_ROW_14_241 vssd1 vccd1 sky130_fd_sc_hd__tapvpwrvgnd_1
X_2732_ clknet_leaf_9_clk _0270_ net129 vssd1 vssd1 vccd1 vccd1 CALC_INST.gencon_inst.add_calc.sameSignVal
+ sky130_fd_sc_hd__dfrtp_1
X_2594_ clknet_leaf_21_clk _0132_ vssd1 vssd1 vccd1 vccd1 CALC_INST.gencon_inst.mult_calc.INn1\[5\]
+ sky130_fd_sc_hd__dfxtp_1
X_2663_ clknet_leaf_23_clk _0201_ net142 vssd1 vssd1 vccd1 vccd1 CALC_INST.gencon_inst.mult_calc.adderSave\[9\]
+ sky130_fd_sc_hd__dfrtp_1
X_1614_ _0847_ _0853_ vssd1 vssd1 vccd1 vccd1 _0854_ sky130_fd_sc_hd__or2_1
X_1476_ net103 CALC_INST.gencon_inst.add_calc.main.in2\[3\] vssd1 vssd1 vccd1 vccd1
+ _0735_ sky130_fd_sc_hd__nand2_1
X_1545_ _0793_ _0795_ vssd1 vssd1 vccd1 vccd1 _0798_ sky130_fd_sc_hd__or2_1
X_2028_ net88 CALC_INST.input_ctrl_inst.input_control_state\[1\] CALC_INST.input_ctrl_inst.input_control_state\[0\]
+ vssd1 vssd1 vccd1 vccd1 _1083_ sky130_fd_sc_hd__and3b_1
XTAP_TAPCELL_ROW_37_399 vssd1 vccd1 sky130_fd_sc_hd__tapvpwrvgnd_1
XFILLER_24_59 vssd1 vssd1 vccd1 vccd1 sky130_fd_sc_hd__fill_1
XFILLER_6_209 vssd1 vssd1 vccd1 vccd1 sky130_fd_sc_hd__fill_8
Xhold283 CALC_INST.gencon_inst.ALU_out\[6\] vssd1 vssd1 vccd1 vccd1 net479 sky130_fd_sc_hd__dlygate4sd3_1
Xhold272 net8 vssd1 vssd1 vccd1 vccd1 net468 sky130_fd_sc_hd__dlygate4sd3_1
Xhold250 CALC_INST.gencon_inst.mult_calc.state\[0\] vssd1 vssd1 vccd1 vccd1 net446
+ sky130_fd_sc_hd__dlygate4sd3_1
Xhold261 CALC_INST.input_ctrl_inst.scan_timer\[10\] vssd1 vssd1 vccd1 vccd1 net457
+ sky130_fd_sc_hd__dlygate4sd3_1
XTAP_TAPCELL_ROW_20_277 vssd1 vccd1 sky130_fd_sc_hd__tapvpwrvgnd_1
XANTENNA__1362__S net73 vssd1 vssd1 vccd1 vccd1 sky130_fd_sc_hd__diode_2
XFILLER_60_138 vssd1 vssd1 vccd1 vccd1 sky130_fd_sc_hd__fill_2
XFILLER_60_149 vssd1 vssd1 vccd1 vccd1 sky130_fd_sc_hd__fill_1
XTAP_TAPCELL_ROW_28_333 vssd1 vccd1 sky130_fd_sc_hd__tapvpwrvgnd_1
X_1330_ CALC_INST.gencon_inst.operand2\[11\] net254 net53 vssd1 vssd1 vccd1 vccd1
+ _0117_ sky130_fd_sc_hd__mux2_1
X_1261_ net302 _0591_ net56 _0620_ _0621_ vssd1 vssd1 vccd1 vccd1 _0073_ sky130_fd_sc_hd__a221o_1
XFILLER_51_105 vssd1 vssd1 vccd1 vccd1 sky130_fd_sc_hd__fill_1
XFILLER_32_363 vssd1 vssd1 vccd1 vccd1 sky130_fd_sc_hd__fill_1
X_2646_ clknet_leaf_16_clk _0184_ net151 vssd1 vssd1 vccd1 vccd1 CALC_INST.gencon_inst.ALU_out\[10\]
+ sky130_fd_sc_hd__dfrtp_1
X_2577_ clknet_leaf_17_clk _0115_ vssd1 vssd1 vccd1 vccd1 CALC_INST.gencon_inst.ALU_in2\[9\]
+ sky130_fd_sc_hd__dfxtp_1
X_2715_ clknet_leaf_31_clk _0253_ net121 vssd1 vssd1 vccd1 vccd1 CALC_INST.gencon_inst.mult_calc.out\[0\]
+ sky130_fd_sc_hd__dfrtp_1
X_1459_ net104 CALC_INST.gencon_inst.add_calc.main.in2\[7\] vssd1 vssd1 vccd1 vccd1
+ _0718_ sky130_fd_sc_hd__or2_1
X_1528_ _0732_ _0733_ vssd1 vssd1 vccd1 vccd1 _0784_ sky130_fd_sc_hd__nand2b_1
XFILLER_19_37 vssd1 vssd1 vccd1 vccd1 sky130_fd_sc_hd__fill_1
XFILLER_42_138 vssd1 vssd1 vccd1 vccd1 sky130_fd_sc_hd__fill_2
XFILLER_35_36 vssd1 vssd1 vccd1 vccd1 sky130_fd_sc_hd__fill_1
XTAP_TAPCELL_ROW_25_314 vssd1 vccd1 sky130_fd_sc_hd__tapvpwrvgnd_1
XFILLER_51_57 vssd1 vssd1 vccd1 vccd1 sky130_fd_sc_hd__fill_2
XANTENNA__2344__A1 _0405_ vssd1 vssd1 vccd1 vccd1 sky130_fd_sc_hd__diode_2
XFILLER_4_3 vccd1 vssd1 vccd1 vssd1 sky130_ef_sc_hd__decap_40_12
XFILLER_2_245 vssd1 vssd1 vccd1 vccd1 sky130_fd_sc_hd__fill_2
XANTENNA_fanout84_X net84 vssd1 vssd1 vccd1 vccd1 sky130_fd_sc_hd__diode_2
XFILLER_58_271 vssd1 vssd1 vccd1 vccd1 sky130_fd_sc_hd__fill_2
XFILLER_18_124 vccd1 vssd1 vccd1 vssd1 sky130_ef_sc_hd__decap_40_12
XFILLER_41_182 vssd1 vssd1 vccd1 vccd1 sky130_fd_sc_hd__fill_2
X_2431_ _0560_ _0561_ vssd1 vssd1 vccd1 vccd1 _0562_ sky130_fd_sc_hd__nor2_1
X_2500_ clknet_leaf_19_clk _0042_ net149 vssd1 vssd1 vccd1 vccd1 CALC_INST.gencon_inst.operand2\[10\]
+ sky130_fd_sc_hd__dfrtp_2
X_1313_ CALC_INST.gencon_inst.operand1\[10\] net264 net53 vssd1 vssd1 vccd1 vccd1
+ _0100_ sky130_fd_sc_hd__mux2_1
X_1244_ CALC_INST.gencon_inst.operand2\[6\] CALC_INST.gencon_inst.operand1\[6\] _0393_
+ vssd1 vssd1 vccd1 vccd1 _0609_ sky130_fd_sc_hd__mux2_1
XFILLER_37_3 vssd1 vssd1 vccd1 vccd1 sky130_fd_sc_hd__fill_2
X_2362_ CALC_INST.gencon_inst.operand2\[10\] _0504_ net35 vssd1 vssd1 vccd1 vccd1
+ _0042_ sky130_fd_sc_hd__mux2_1
X_2293_ net90 _0424_ _0450_ vssd1 vssd1 vccd1 vccd1 _0454_ sky130_fd_sc_hd__or3_1
XTAP_TAPCELL_ROW_47_472 vssd1 vccd1 sky130_fd_sc_hd__tapvpwrvgnd_1
XANTENNA_fanout131_A net132 vssd1 vssd1 vccd1 vccd1 sky130_fd_sc_hd__diode_2
XTAP_TAPCELL_ROW_30_350 vssd1 vccd1 sky130_fd_sc_hd__tapvpwrvgnd_1
XFILLER_21_16 vssd1 vssd1 vccd1 vccd1 sky130_fd_sc_hd__fill_1
X_2629_ clknet_leaf_16_clk _0167_ net152 vssd1 vssd1 vccd1 vccd1 CALC_INST.gencon_inst.add_calc.main.in2\[8\]
+ sky130_fd_sc_hd__dfrtp_1
XFILLER_7_304 vssd1 vssd1 vccd1 vccd1 sky130_fd_sc_hd__fill_1
XFILLER_7_337 vssd1 vssd1 vccd1 vccd1 sky130_fd_sc_hd__fill_8
XFILLER_11_82 vssd1 vssd1 vccd1 vccd1 sky130_fd_sc_hd__fill_4
X_1931_ net111 net293 _1004_ _1014_ vssd1 vssd1 vccd1 vccd1 _0350_ sky130_fd_sc_hd__a22o_1
X_1862_ _0973_ _0974_ vssd1 vssd1 vccd1 vccd1 _0975_ sky130_fd_sc_hd__or2_1
X_1793_ CALC_INST.input_ctrl_inst.scan_timer\[13\] CALC_INST.input_ctrl_inst.scan_timer\[12\]
+ CALC_INST.input_ctrl_inst.scan_timer\[15\] CALC_INST.input_ctrl_inst.scan_timer\[14\]
+ vssd1 vssd1 vccd1 vccd1 _0925_ sky130_fd_sc_hd__or4bb_1
X_2414_ CALC_INST.gencon_inst.operand1\[3\] net42 _0547_ _0548_ vssd1 vssd1 vccd1
+ vccd1 _0050_ sky130_fd_sc_hd__o22a_1
X_2345_ _0490_ _0491_ CALC_INST.gencon_inst.operand2\[6\] net34 vssd1 vssd1 vccd1
+ vccd1 _0038_ sky130_fd_sc_hd__o2bb2a_1
X_2276_ CALC_INST.input_ctrl_inst.col_index\[16\] CALC_INST.input_ctrl_inst.col_index\[19\]
+ CALC_INST.input_ctrl_inst.col_index\[20\] _0437_ vssd1 vssd1 vccd1 vccd1 _0438_
+ sky130_fd_sc_hd__and4_1
XFILLER_52_277 vssd1 vssd1 vccd1 vccd1 sky130_fd_sc_hd__fill_2
XTAP_TAPCELL_ROW_50_489 vssd1 vccd1 sky130_fd_sc_hd__tapvpwrvgnd_1
XANTENNA__2304__B _1234_ vssd1 vssd1 vccd1 vccd1 sky130_fd_sc_hd__diode_2
XFILLER_32_48 vssd1 vssd1 vccd1 vccd1 sky130_fd_sc_hd__fill_4
XTAP_TAPCELL_ROW_7_189 vssd1 vccd1 sky130_fd_sc_hd__tapvpwrvgnd_1
XTAP_TAPCELL_ROW_58_545 vssd1 vccd1 sky130_fd_sc_hd__tapvpwrvgnd_1
XANTENNA__2483__A0 CALC_INST.gencon_inst.operand2\[3\] vssd1 vssd1 vccd1 vccd1 sky130_fd_sc_hd__diode_2
XPHY_EDGE_ROW_44_Left_109 vssd1 vssd1 vccd1 vccd1 sky130_fd_sc_hd__decap_3
XFILLER_7_167 vssd1 vssd1 vccd1 vccd1 sky130_fd_sc_hd__fill_1
XPHY_EDGE_ROW_53_Left_118 vssd1 vssd1 vccd1 vccd1 sky130_fd_sc_hd__decap_3
X_2130_ _1073_ _1172_ _1078_ _1170_ vssd1 vssd1 vccd1 vccd1 _1173_ sky130_fd_sc_hd__o2bb2a_1
X_2061_ CALC_INST.gencon_inst.mult_calc.compCount.in2\[5\] _1110_ _1114_ CALC_INST.gencon_inst.mult_calc.compCount.in2\[6\]
+ _1112_ vssd1 vssd1 vccd1 vccd1 _1115_ sky130_fd_sc_hd__o221a_1
XFILLER_19_263 vssd1 vssd1 vccd1 vccd1 sky130_fd_sc_hd__fill_1
XANTENNA__2474__B1 net54 vssd1 vssd1 vccd1 vccd1 sky130_fd_sc_hd__diode_2
X_1914_ net93 net285 net77 net287 vssd1 vssd1 vccd1 vccd1 _0345_ sky130_fd_sc_hd__a22o_1
XFILLER_19_285 vssd1 vssd1 vccd1 vccd1 sky130_fd_sc_hd__fill_8
XPHY_EDGE_ROW_62_Left_127 vssd1 vssd1 vccd1 vccd1 sky130_fd_sc_hd__decap_3
X_1776_ CALC_INST.gencon_inst.operand2\[0\] net48 net37 net329 vssd1 vssd1 vccd1 vccd1
+ _0286_ sky130_fd_sc_hd__a22o_1
X_1845_ CALC_INST.input_ctrl_inst.col_index\[14\] _0962_ vssd1 vssd1 vccd1 vccd1 _0963_
+ sky130_fd_sc_hd__or2_1
X_2328_ _0475_ _0476_ _0467_ _0470_ vssd1 vssd1 vccd1 vccd1 _0478_ sky130_fd_sc_hd__a211o_1
XTAP_TAPCELL_ROW_55_526 vssd1 vccd1 sky130_fd_sc_hd__tapvpwrvgnd_1
XANTENNA__2465__B1 net58 vssd1 vssd1 vccd1 vccd1 sky130_fd_sc_hd__diode_2
XFILLER_25_222 vssd1 vssd1 vccd1 vccd1 sky130_fd_sc_hd__fill_2
X_2259_ _0413_ _0417_ CALC_INST.input_ctrl_inst.col_index\[23\] vssd1 vssd1 vccd1
+ vccd1 _0421_ sky130_fd_sc_hd__o21ai_1
XFILLER_13_406 vssd1 vssd1 vccd1 vccd1 sky130_fd_sc_hd__fill_1
XTAP_TAPCELL_ROW_63_581 vssd1 vccd1 sky130_fd_sc_hd__tapvpwrvgnd_1
XFILLER_4_115 vccd1 vssd1 vccd1 vssd1 sky130_ef_sc_hd__decap_40_12
XFILLER_0_365 vccd1 vssd1 vccd1 vssd1 sky130_ef_sc_hd__decap_40_12
XANTENNA__2493__Q CALC_INST.gencon_inst.operand2\[3\] vssd1 vssd1 vccd1 vccd1 sky130_fd_sc_hd__diode_2
X_1630_ net460 net84 _0867_ net99 vssd1 vssd1 vccd1 vccd1 _0196_ sky130_fd_sc_hd__a22o_1
X_1561_ net32 _0808_ _0810_ net80 vssd1 vssd1 vccd1 vccd1 _0812_ sky130_fd_sc_hd__a31o_1
X_1492_ _0732_ _0736_ _0748_ _0733_ _0729_ vssd1 vssd1 vccd1 vccd1 _0751_ sky130_fd_sc_hd__o311a_1
XFILLER_39_325 vssd1 vssd1 vccd1 vccd1 sky130_fd_sc_hd__fill_2
XTAP_TAPCELL_ROW_52_507 vssd1 vccd1 sky130_fd_sc_hd__tapvpwrvgnd_1
X_2113_ _1084_ _1158_ vssd1 vssd1 vccd1 vccd1 _1159_ sky130_fd_sc_hd__nor2_1
X_2044_ CALC_INST.gencon_inst.mult_calc.count.GENERATE_ADDER\[3\].thingy.in1 _1088_
+ vssd1 vssd1 vccd1 vccd1 _1098_ sky130_fd_sc_hd__nor2_1
XFILLER_62_383 vccd1 vssd1 vccd1 vssd1 sky130_ef_sc_hd__decap_40_12
XTAP_TAPCELL_ROW_60_562 vssd1 vccd1 sky130_fd_sc_hd__tapvpwrvgnd_1
XFILLER_22_225 vccd1 vssd1 vccd1 vssd1 sky130_ef_sc_hd__decap_40_12
X_2877_ clknet_leaf_2_clk _0372_ vssd1 vssd1 vccd1 vccd1 CALC_INST.input_ctrl_inst.scan_timer\[15\]
+ sky130_fd_sc_hd__dfxtp_1
XTAP_TAPCELL_ROW_17_261 vssd1 vccd1 sky130_fd_sc_hd__tapvpwrvgnd_1
X_1759_ net262 _0923_ net96 vssd1 vssd1 vccd1 vccd1 _0269_ sky130_fd_sc_hd__mux2_1
X_1828_ _0952_ _0953_ vssd1 vssd1 vccd1 vccd1 _0308_ sky130_fd_sc_hd__nor2_1
XFILLER_57_111 vssd1 vssd1 vccd1 vccd1 sky130_fd_sc_hd__fill_1
XFILLER_60_309 vssd1 vssd1 vccd1 vccd1 sky130_fd_sc_hd__fill_8
XTAP_TAPCELL_ROW_0_140 vssd1 vccd1 sky130_fd_sc_hd__tapvpwrvgnd_1
XANTENNA__2488__Q CALC_INST.gencon_inst.add_calc.state\[2\] vssd1 vssd1 vccd1 vccd1
+ sky130_fd_sc_hd__diode_2
XFILLER_63_125 vccd1 vssd1 vccd1 vssd1 sky130_ef_sc_hd__decap_40_12
XANTENNA_clkbuf_leaf_14_clk_A clknet_2_3__leaf_clk vssd1 vssd1 vccd1 vccd1 sky130_fd_sc_hd__diode_2
XFILLER_44_383 vssd1 vssd1 vccd1 vccd1 sky130_fd_sc_hd__fill_2
XANTENNA__2226__Y _0392_ vssd1 vssd1 vccd1 vccd1 sky130_fd_sc_hd__diode_2
X_2731_ clknet_leaf_3_clk _0269_ net121 vssd1 vssd1 vccd1 vccd1 CALC_INST.gencon_inst.mult_calc.diffSign
+ sky130_fd_sc_hd__dfrtp_1
X_2800_ clknet_leaf_33_clk _0325_ net114 vssd1 vssd1 vccd1 vccd1 CALC_INST.input_ctrl_inst.col_index\[23\]
+ sky130_fd_sc_hd__dfrtp_1
XANTENNA__1652__A1 net100 vssd1 vssd1 vccd1 vccd1 sky130_fd_sc_hd__diode_2
X_1544_ _0797_ _0796_ net479 net80 vssd1 vssd1 vccd1 vccd1 _0180_ sky130_fd_sc_hd__a2bb2o_1
X_2593_ clknet_leaf_21_clk _0131_ vssd1 vssd1 vccd1 vccd1 CALC_INST.gencon_inst.mult_calc.INn1\[4\]
+ sky130_fd_sc_hd__dfxtp_1
XANTENNA_clkbuf_leaf_29_clk_A clknet_2_2__leaf_clk vssd1 vssd1 vccd1 vccd1 sky130_fd_sc_hd__diode_2
X_2662_ clknet_leaf_22_clk _0200_ net143 vssd1 vssd1 vccd1 vccd1 CALC_INST.gencon_inst.mult_calc.adderSave\[8\]
+ sky130_fd_sc_hd__dfrtp_1
XFILLER_8_251 vssd1 vssd1 vccd1 vccd1 sky130_fd_sc_hd__fill_1
X_1613_ CALC_INST.gencon_inst.mult_calc.main.a0.in2 CALC_INST.gencon_inst.mult_calc.main.a0.in1
+ CALC_INST.gencon_inst.mult_calc.main.GENERATE_ADDER\[1\].thingy.in2 CALC_INST.gencon_inst.mult_calc.main.GENERATE_ADDER\[1\].thingy.in1
+ vssd1 vssd1 vccd1 vccd1 _0853_ sky130_fd_sc_hd__a22oi_1
X_1475_ net103 CALC_INST.gencon_inst.add_calc.main.in2\[3\] vssd1 vssd1 vccd1 vccd1
+ _0734_ sky130_fd_sc_hd__or2_1
X_2027_ _1080_ _1081_ vssd1 vssd1 vccd1 vccd1 _1082_ sky130_fd_sc_hd__nand2_1
XFILLER_40_26 vssd1 vssd1 vccd1 vccd1 sky130_fd_sc_hd__fill_2
XTAP_TAPCELL_ROW_20_278 vssd1 vccd1 sky130_fd_sc_hd__tapvpwrvgnd_1
Xhold240 CALC_INST.input_ctrl_inst.debounce_cnt\[8\] vssd1 vssd1 vccd1 vccd1 net436
+ sky130_fd_sc_hd__dlygate4sd3_1
Xhold262 CALC_INST.input_ctrl_inst.debounce_cnt\[11\] vssd1 vssd1 vccd1 vccd1 net458
+ sky130_fd_sc_hd__dlygate4sd3_1
XFILLER_49_24 vssd1 vssd1 vccd1 vccd1 sky130_fd_sc_hd__fill_2
Xhold284 CALC_INST.input_ctrl_inst.read_input_flag vssd1 vssd1 vccd1 vccd1 net480
+ sky130_fd_sc_hd__dlygate4sd3_1
Xhold251 CALC_INST.gencon_inst.operator_input\[1\] vssd1 vssd1 vccd1 vccd1 net447
+ sky130_fd_sc_hd__dlygate4sd3_1
Xhold273 CALC_INST.input_ctrl_inst.col_index\[9\] vssd1 vssd1 vccd1 vccd1 net469 sky130_fd_sc_hd__dlygate4sd3_1
XFILLER_45_169 vssd1 vssd1 vccd1 vccd1 sky130_fd_sc_hd__fill_1
XTAP_TAPCELL_ROW_28_334 vssd1 vccd1 sky130_fd_sc_hd__tapvpwrvgnd_1
XFILLER_18_306 vssd1 vssd1 vccd1 vccd1 sky130_fd_sc_hd__fill_2
XFILLER_14_71 vssd1 vssd1 vccd1 vccd1 sky130_fd_sc_hd__fill_1
XFILLER_64_401 vssd1 vssd1 vccd1 vccd1 sky130_fd_sc_hd__fill_2
XANTENNA__1322__A0 CALC_INST.gencon_inst.operand2\[3\] vssd1 vssd1 vccd1 vccd1 sky130_fd_sc_hd__diode_2
X_1260_ CALC_INST.gencon_inst.ALU_out\[10\] net69 net55 CALC_INST.gencon_inst.mult_calc.out\[10\]
+ vssd1 vssd1 vccd1 vccd1 _0621_ sky130_fd_sc_hd__a22o_1
XFILLER_32_320 vssd1 vssd1 vccd1 vccd1 sky130_fd_sc_hd__fill_4
XFILLER_24_309 vssd1 vssd1 vccd1 vccd1 sky130_fd_sc_hd__fill_4
XANTENNA__1873__A1 net63 vssd1 vssd1 vccd1 vccd1 sky130_fd_sc_hd__diode_2
X_2714_ clknet_leaf_28_clk net353 net136 vssd1 vssd1 vccd1 vccd1 CALC_INST.gencon_inst.mult_calc.main.GENERATE_ADDER\[14\].thingy.in2
+ sky130_fd_sc_hd__dfrtp_1
X_2645_ clknet_leaf_16_clk _0183_ net151 vssd1 vssd1 vccd1 vccd1 CALC_INST.gencon_inst.ALU_out\[9\]
+ sky130_fd_sc_hd__dfrtp_1
XFILLER_59_217 vssd1 vssd1 vccd1 vccd1 sky130_fd_sc_hd__fill_2
XFILLER_59_206 vssd1 vssd1 vccd1 vccd1 sky130_fd_sc_hd__fill_1
X_1527_ _0773_ _0775_ _0780_ vssd1 vssd1 vccd1 vccd1 _0783_ sky130_fd_sc_hd__or3_1
X_2576_ clknet_leaf_18_clk _0114_ vssd1 vssd1 vccd1 vccd1 CALC_INST.gencon_inst.ALU_in2\[8\]
+ sky130_fd_sc_hd__dfxtp_1
X_1389_ net408 _0669_ net109 vssd1 vssd1 vccd1 vccd1 _0153_ sky130_fd_sc_hd__mux2_1
X_1458_ CALC_INST.gencon_inst.add_calc.main.GENERATE_ADDER\[8\].thingy.in1 _0714_
+ _0715_ vssd1 vssd1 vccd1 vccd1 _0717_ sky130_fd_sc_hd__nand3_1
XFILLER_42_128 vssd1 vssd1 vccd1 vccd1 sky130_fd_sc_hd__fill_2
XFILLER_35_191 vssd1 vssd1 vccd1 vccd1 sky130_fd_sc_hd__fill_1
XFILLER_35_48 vssd1 vssd1 vccd1 vccd1 sky130_fd_sc_hd__fill_8
XTAP_TAPCELL_ROW_33_370 vssd1 vccd1 sky130_fd_sc_hd__tapvpwrvgnd_1
XFILLER_27_169 vssd1 vssd1 vccd1 vccd1 sky130_fd_sc_hd__fill_4
XTAP_TAPCELL_ROW_25_315 vssd1 vccd1 sky130_fd_sc_hd__tapvpwrvgnd_1
XFILLER_2_279 vssd1 vssd1 vccd1 vccd1 sky130_fd_sc_hd__fill_1
XANTENNA_fanout77_X net77 vssd1 vssd1 vccd1 vccd1 sky130_fd_sc_hd__diode_2
XFILLER_58_261 vssd1 vssd1 vccd1 vccd1 sky130_fd_sc_hd__fill_2
XFILLER_18_136 vssd1 vssd1 vccd1 vccd1 sky130_fd_sc_hd__fill_4
XFILLER_25_92 vssd1 vssd1 vccd1 vccd1 sky130_fd_sc_hd__fill_4
XFILLER_14_342 vssd1 vssd1 vccd1 vccd1 sky130_fd_sc_hd__fill_2
X_2430_ CALC_INST.gencon_inst.operand1\[7\] _0556_ _0519_ vssd1 vssd1 vccd1 vccd1
+ _0561_ sky130_fd_sc_hd__o21ai_1
X_2361_ _0404_ _0502_ _0503_ net44 CALC_INST.gencon_inst.mult_calc.out\[10\] vssd1
+ vssd1 vccd1 vccd1 _0504_ sky130_fd_sc_hd__a32o_1
X_1312_ CALC_INST.gencon_inst.operand1\[9\] net328 net53 vssd1 vssd1 vccd1 vccd1 _0099_
+ sky130_fd_sc_hd__mux2_1
X_1243_ net477 net57 _0593_ _0607_ _0608_ vssd1 vssd1 vccd1 vccd1 _0068_ sky130_fd_sc_hd__a221o_1
X_2292_ _0415_ _0450_ _0452_ vssd1 vssd1 vccd1 vccd1 net25 sky130_fd_sc_hd__or3b_1
XFILLER_64_275 vssd1 vssd1 vccd1 vccd1 sky130_fd_sc_hd__fill_4
XFILLER_64_264 vssd1 vssd1 vccd1 vccd1 sky130_fd_sc_hd__fill_4
XFILLER_64_253 vssd1 vssd1 vccd1 vccd1 sky130_fd_sc_hd__fill_1
XFILLER_24_139 vssd1 vssd1 vccd1 vccd1 sky130_fd_sc_hd__fill_1
XTAP_TAPCELL_ROW_30_351 vssd1 vccd1 sky130_fd_sc_hd__tapvpwrvgnd_1
X_2628_ clknet_leaf_15_clk _0166_ net146 vssd1 vssd1 vccd1 vccd1 CALC_INST.gencon_inst.add_calc.main.in2\[7\]
+ sky130_fd_sc_hd__dfrtp_1
X_2559_ clknet_leaf_20_clk _0097_ vssd1 vssd1 vccd1 vccd1 CALC_INST.gencon_inst.ALU_in1\[7\]
+ sky130_fd_sc_hd__dfxtp_1
XFILLER_46_14 vccd1 vssd1 vccd1 vssd1 sky130_ef_sc_hd__decap_40_12
XFILLER_7_327 vssd1 vssd1 vccd1 vccd1 sky130_fd_sc_hd__fill_1
XFILLER_11_345 vssd1 vssd1 vccd1 vccd1 sky130_fd_sc_hd__fill_2
XANTENNA__1773__B1 net86 vssd1 vssd1 vccd1 vccd1 sky130_fd_sc_hd__diode_2
XFILLER_61_289 vssd1 vssd1 vccd1 vccd1 sky130_fd_sc_hd__fill_2
XFILLER_61_278 vssd1 vssd1 vccd1 vccd1 sky130_fd_sc_hd__fill_2
XFILLER_61_223 vssd1 vssd1 vccd1 vccd1 sky130_fd_sc_hd__fill_1
X_1930_ net79 _1005_ _1012_ _1013_ vssd1 vssd1 vccd1 vccd1 _1014_ sky130_fd_sc_hd__a31o_1
XFILLER_52_90 vssd1 vssd1 vccd1 vccd1 sky130_fd_sc_hd__fill_1
XANTENNA__1764__B1 net84 vssd1 vssd1 vccd1 vccd1 sky130_fd_sc_hd__diode_2
X_1861_ CALC_INST.input_ctrl_inst.col_index\[17\] CALC_INST.input_ctrl_inst.col_index\[19\]
+ CALC_INST.input_ctrl_inst.col_index\[18\] _0966_ vssd1 vssd1 vccd1 vccd1 _0974_
+ sky130_fd_sc_hd__and4_1
XFILLER_6_360 vssd1 vssd1 vccd1 vccd1 sky130_fd_sc_hd__fill_4
X_1792_ CALC_INST.input_ctrl_inst.scan_timer\[17\] CALC_INST.input_ctrl_inst.scan_timer\[16\]
+ CALC_INST.input_ctrl_inst.scan_timer\[19\] CALC_INST.input_ctrl_inst.scan_timer\[18\]
+ vssd1 vssd1 vccd1 vccd1 _0924_ sky130_fd_sc_hd__or4_1
X_2413_ CALC_INST.gencon_inst.ALU_out\[3\] net71 net58 CALC_INST.gencon_inst.mult_calc.out\[3\]
+ net41 vssd1 vssd1 vccd1 vccd1 _0548_ sky130_fd_sc_hd__a221o_1
X_2344_ _0405_ _0488_ _0489_ net34 vssd1 vssd1 vccd1 vccd1 _0491_ sky130_fd_sc_hd__o31a_1
X_2275_ CALC_INST.input_ctrl_inst.col_index\[17\] CALC_INST.input_ctrl_inst.col_index\[18\]
+ CALC_INST.input_ctrl_inst.col_index\[21\] CALC_INST.input_ctrl_inst.col_index\[22\]
+ vssd1 vssd1 vccd1 vccd1 _0437_ sky130_fd_sc_hd__and4_1
XFILLER_32_27 vssd1 vssd1 vccd1 vccd1 sky130_fd_sc_hd__fill_1
XANTENNA__2304__C _0405_ vssd1 vssd1 vccd1 vccd1 sky130_fd_sc_hd__diode_2
XTAP_TAPCELL_ROW_58_546 vssd1 vccd1 sky130_fd_sc_hd__tapvpwrvgnd_1
XFILLER_43_278 vssd1 vssd1 vccd1 vccd1 sky130_fd_sc_hd__fill_2
XFILLER_28_253 vssd1 vssd1 vccd1 vccd1 sky130_fd_sc_hd__fill_4
XTAP_TAPCELL_ROW_41_424 vssd1 vccd1 sky130_fd_sc_hd__tapvpwrvgnd_1
XFILLER_22_82 vssd1 vssd1 vccd1 vccd1 sky130_fd_sc_hd__fill_2
XFILLER_7_102 vssd1 vssd1 vccd1 vccd1 sky130_fd_sc_hd__fill_2
XFILLER_7_113 vssd1 vssd1 vccd1 vccd1 sky130_fd_sc_hd__fill_1
XFILLER_11_186 vssd1 vssd1 vccd1 vccd1 sky130_fd_sc_hd__fill_1
X_2060_ _1091_ _1113_ vssd1 vssd1 vccd1 vccd1 _1114_ sky130_fd_sc_hd__nand2b_1
X_1913_ net93 net294 net77 CALC_INST.gencon_inst.mult_calc.count.GENERATE_ADDER\[10\].thingy.in1
+ vssd1 vssd1 vccd1 vccd1 _0344_ sky130_fd_sc_hd__a22o_1
XFILLER_8_40 vssd1 vssd1 vccd1 vccd1 sky130_fd_sc_hd__fill_2
X_1844_ _0961_ _0962_ vssd1 vssd1 vccd1 vccd1 _0315_ sky130_fd_sc_hd__nor2_1
X_1775_ net83 _1097_ net86 net289 vssd1 vssd1 vccd1 vccd1 _0285_ sky130_fd_sc_hd__a2bb2o_1
XFILLER_57_326 vssd1 vssd1 vccd1 vccd1 sky130_fd_sc_hd__fill_1
X_2327_ _0467_ _0470_ _0475_ _0476_ vssd1 vssd1 vccd1 vccd1 _0477_ sky130_fd_sc_hd__o211a_1
X_2258_ CALC_INST.input_ctrl_inst.col_index\[23\] _0413_ _0417_ vssd1 vssd1 vccd1
+ vccd1 _0420_ sky130_fd_sc_hd__or3_1
XTAP_TAPCELL_ROW_63_582 vssd1 vccd1 sky130_fd_sc_hd__tapvpwrvgnd_1
XTAP_TAPCELL_ROW_55_527 vssd1 vccd1 sky130_fd_sc_hd__tapvpwrvgnd_1
X_2189_ CALC_INST.input_ctrl_inst.debounce_cnt\[14\] _1077_ _1197_ vssd1 vssd1 vccd1
+ vccd1 _1219_ sky130_fd_sc_hd__o21ai_1
XANTENNA__1268__A2 _0397_ vssd1 vssd1 vccd1 vccd1 sky130_fd_sc_hd__diode_2
XFILLER_25_234 vssd1 vssd1 vccd1 vccd1 sky130_fd_sc_hd__fill_4
XFILLER_43_59 vssd1 vssd1 vccd1 vccd1 sky130_fd_sc_hd__fill_1
XFILLER_4_127 vccd1 vssd1 vccd1 vssd1 sky130_ef_sc_hd__decap_40_12
XANTENNA__1728__B1 net75 vssd1 vssd1 vccd1 vccd1 sky130_fd_sc_hd__diode_2
XTAP_TAPCELL_ROW_3_160 vssd1 vccd1 sky130_fd_sc_hd__tapvpwrvgnd_1
XFILLER_0_377 vssd1 vssd1 vccd1 vccd1 sky130_fd_sc_hd__fill_4
XFILLER_17_93 vssd1 vssd1 vccd1 vccd1 sky130_fd_sc_hd__fill_2
X_1560_ net32 _0808_ _0810_ vssd1 vssd1 vccd1 vccd1 _0811_ sky130_fd_sc_hd__a21oi_1
X_1491_ _0732_ _0736_ _0748_ _0733_ vssd1 vssd1 vccd1 vccd1 _0750_ sky130_fd_sc_hd__o31a_1
XFILLER_39_337 vssd1 vssd1 vccd1 vccd1 sky130_fd_sc_hd__fill_1
X_2112_ CALC_INST.input_ctrl_inst.col_index\[2\] _1157_ _1156_ vssd1 vssd1 vccd1 vccd1
+ _1158_ sky130_fd_sc_hd__mux2_1
XFILLER_3_160 vssd1 vssd1 vccd1 vccd1 sky130_fd_sc_hd__fill_4
XFILLER_62_351 vssd1 vssd1 vccd1 vccd1 sky130_fd_sc_hd__fill_1
X_2043_ CALC_INST.gencon_inst.mult_calc.count.GENERATE_ADDER\[14\].thingy.in1 _1096_
+ vssd1 vssd1 vccd1 vccd1 _1097_ sky130_fd_sc_hd__xor2_1
XTAP_TAPCELL_ROW_17_262 vssd1 vccd1 sky130_fd_sc_hd__tapvpwrvgnd_1
XFILLER_62_395 vssd1 vssd1 vccd1 vccd1 sky130_fd_sc_hd__fill_4
XTAP_TAPCELL_ROW_60_563 vssd1 vccd1 sky130_fd_sc_hd__tapvpwrvgnd_1
XFILLER_22_259 vssd1 vssd1 vccd1 vccd1 sky130_fd_sc_hd__fill_2
XFILLER_22_248 vssd1 vssd1 vccd1 vccd1 sky130_fd_sc_hd__fill_4
XFILLER_22_237 vssd1 vssd1 vccd1 vccd1 sky130_fd_sc_hd__fill_2
X_2876_ clknet_leaf_1_clk _0371_ vssd1 vssd1 vccd1 vccd1 CALC_INST.input_ctrl_inst.scan_timer\[14\]
+ sky130_fd_sc_hd__dfxtp_1
X_1827_ CALC_INST.input_ctrl_inst.col_index\[5\] CALC_INST.input_ctrl_inst.col_index\[6\]
+ _0951_ vssd1 vssd1 vccd1 vccd1 _0953_ sky130_fd_sc_hd__and3_1
X_1758_ CALC_INST.gencon_inst.mult_calc.INn2\[15\] CALC_INST.gencon_inst.mult_calc.INn1\[15\]
+ vssd1 vssd1 vccd1 vccd1 _0923_ sky130_fd_sc_hd__xor2_1
X_1689_ _0914_ _0915_ _0916_ vssd1 vssd1 vccd1 vccd1 _0918_ sky130_fd_sc_hd__o21ai_1
XFILLER_57_167 vssd1 vssd1 vccd1 vccd1 sky130_fd_sc_hd__fill_1
XFILLER_45_318 vssd1 vssd1 vccd1 vccd1 sky130_fd_sc_hd__fill_1
XFILLER_54_69 vssd1 vssd1 vccd1 vccd1 sky130_fd_sc_hd__fill_2
XANTENNA__2326__A CALC_INST.gencon_inst.operand2\[3\] vssd1 vssd1 vccd1 vccd1 sky130_fd_sc_hd__diode_2
XTAP_TAPCELL_ROW_0_141 vssd1 vccd1 sky130_fd_sc_hd__tapvpwrvgnd_1
XTAP_TAPCELL_ROW_0_130 vssd1 vccd1 sky130_fd_sc_hd__tapvpwrvgnd_1
XTAP_TAPCELL_ROW_23_298 vssd1 vccd1 sky130_fd_sc_hd__tapvpwrvgnd_1
XFILLER_21_281 vssd1 vssd1 vccd1 vccd1 sky130_fd_sc_hd__fill_4
XFILLER_5_403 vssd1 vssd1 vccd1 vccd1 sky130_fd_sc_hd__fill_1
XFILLER_0_130 vssd1 vssd1 vccd1 vccd1 sky130_fd_sc_hd__fill_8
XFILLER_63_137 vccd1 vssd1 vccd1 vssd1 sky130_ef_sc_hd__decap_40_12
XANTENNA__2236__A _0397_ vssd1 vssd1 vccd1 vccd1 sky130_fd_sc_hd__diode_2
XFILLER_36_307 vssd1 vssd1 vccd1 vccd1 sky130_fd_sc_hd__fill_1
X_2730_ clknet_leaf_4_clk _0268_ net121 vssd1 vssd1 vccd1 vccd1 CALC_INST.gencon_inst.mult_calc.out\[15\]
+ sky130_fd_sc_hd__dfrtp_1
X_2661_ clknet_leaf_29_clk _0199_ net138 vssd1 vssd1 vccd1 vccd1 CALC_INST.gencon_inst.mult_calc.adderSave\[7\]
+ sky130_fd_sc_hd__dfrtp_1
X_1543_ net33 _0793_ _0795_ net80 vssd1 vssd1 vccd1 vccd1 _0797_ sky130_fd_sc_hd__a31o_1
X_1474_ CALC_INST.gencon_inst.add_calc.main.GENERATE_ADDER\[4\].thingy.in1 _0730_
+ _0731_ vssd1 vssd1 vccd1 vccd1 _0733_ sky130_fd_sc_hd__nand3_1
X_2592_ clknet_leaf_30_clk _0130_ vssd1 vssd1 vccd1 vccd1 CALC_INST.gencon_inst.mult_calc.INn1\[3\]
+ sky130_fd_sc_hd__dfxtp_1
X_1612_ _0850_ _0851_ vssd1 vssd1 vccd1 vccd1 _0852_ sky130_fd_sc_hd__and2b_1
XFILLER_39_167 vssd1 vssd1 vccd1 vccd1 sky130_fd_sc_hd__fill_1
XFILLER_54_159 vssd1 vssd1 vccd1 vccd1 sky130_fd_sc_hd__fill_1
X_2026_ net88 CALC_INST.input_ctrl_inst.input_control_state\[1\] CALC_INST.input_ctrl_inst.input_control_state\[0\]
+ vssd1 vssd1 vccd1 vccd1 _1081_ sky130_fd_sc_hd__nor3b_2
XFILLER_35_373 vssd1 vssd1 vccd1 vccd1 sky130_fd_sc_hd__fill_2
XFILLER_10_207 vssd1 vssd1 vccd1 vccd1 sky130_fd_sc_hd__fill_2
XANTENNA__2356__B1 _0404_ vssd1 vssd1 vccd1 vccd1 sky130_fd_sc_hd__diode_2
X_2859_ clknet_leaf_2_clk _0028_ net116 vssd1 vssd1 vccd1 vccd1 CALC_INST.input_ctrl_inst.decoded_key\[1\]
+ sky130_fd_sc_hd__dfstp_1
XTAP_TAPCELL_ROW_20_279 vssd1 vccd1 sky130_fd_sc_hd__tapvpwrvgnd_1
Xhold274 CALC_INST.gencon_inst.ALU_out\[0\] vssd1 vssd1 vccd1 vccd1 net470 sky130_fd_sc_hd__dlygate4sd3_1
Xhold263 CALC_INST.input_ctrl_inst.scan_timer\[2\] vssd1 vssd1 vccd1 vccd1 net459
+ sky130_fd_sc_hd__dlygate4sd3_1
Xhold230 CALC_INST.input_ctrl_inst.scan_timer\[5\] vssd1 vssd1 vccd1 vccd1 net426
+ sky130_fd_sc_hd__dlygate4sd3_1
Xhold252 CALC_INST.gencon_inst.mult_calc.main.GENERATE_ADDER\[1\].thingy.in2 vssd1
+ vssd1 vccd1 vccd1 net448 sky130_fd_sc_hd__dlygate4sd3_1
Xhold241 CALC_INST.input_ctrl_inst.scan_timer\[12\] vssd1 vssd1 vccd1 vccd1 net437
+ sky130_fd_sc_hd__dlygate4sd3_1
XANTENNA_fanout67_A _0659_ vssd1 vssd1 vccd1 vccd1 sky130_fd_sc_hd__diode_2
XTAP_TAPCELL_ROW_28_335 vssd1 vccd1 sky130_fd_sc_hd__tapvpwrvgnd_1
XFILLER_18_329 vssd1 vssd1 vccd1 vccd1 sky130_fd_sc_hd__fill_2
XANTENNA_clkbuf_2_3__f_clk_A clknet_0_clk vssd1 vssd1 vccd1 vccd1 sky130_fd_sc_hd__diode_2
XTAP_TAPCELL_ROW_36_390 vssd1 vccd1 sky130_fd_sc_hd__tapvpwrvgnd_1
XANTENNA__2499__Q CALC_INST.gencon_inst.operand2\[9\] vssd1 vssd1 vccd1 vccd1 sky130_fd_sc_hd__diode_2
XFILLER_51_129 vssd1 vssd1 vccd1 vccd1 sky130_fd_sc_hd__fill_1
XFILLER_32_365 vssd1 vssd1 vccd1 vccd1 sky130_fd_sc_hd__fill_8
X_2644_ clknet_leaf_16_clk _0182_ net151 vssd1 vssd1 vccd1 vccd1 CALC_INST.gencon_inst.ALU_out\[8\]
+ sky130_fd_sc_hd__dfrtp_1
X_2713_ clknet_leaf_24_clk _0251_ net141 vssd1 vssd1 vccd1 vccd1 CALC_INST.gencon_inst.mult_calc.main.GENERATE_ADDER\[13\].thingy.in2
+ sky130_fd_sc_hd__dfrtp_1
X_1457_ _0714_ _0715_ CALC_INST.gencon_inst.add_calc.main.GENERATE_ADDER\[8\].thingy.in1
+ vssd1 vssd1 vccd1 vccd1 _0716_ sky130_fd_sc_hd__a21oi_1
X_1526_ _0782_ _0781_ net465 net81 vssd1 vssd1 vccd1 vccd1 _0177_ sky130_fd_sc_hd__a2bb2o_1
X_2575_ clknet_leaf_13_clk _0113_ vssd1 vssd1 vccd1 vccd1 CALC_INST.gencon_inst.ALU_in2\[7\]
+ sky130_fd_sc_hd__dfxtp_1
X_1388_ CALC_INST.gencon_inst.ALU_in2\[9\] CALC_INST.gencon_inst.ALU_in1\[9\] net66
+ vssd1 vssd1 vccd1 vccd1 _0669_ sky130_fd_sc_hd__mux2_1
XFILLER_50_195 vssd1 vssd1 vccd1 vccd1 sky130_fd_sc_hd__fill_1
XTAP_TAPCELL_ROW_33_371 vssd1 vccd1 sky130_fd_sc_hd__tapvpwrvgnd_1
XTAP_TAPCELL_ROW_25_316 vssd1 vccd1 sky130_fd_sc_hd__tapvpwrvgnd_1
X_2009_ CALC_INST.input_ctrl_inst.col_index\[0\] vssd1 vssd1 vccd1 vccd1 _1065_ sky130_fd_sc_hd__inv_2
XFILLER_2_214 vssd1 vssd1 vccd1 vccd1 sky130_fd_sc_hd__fill_1
XFILLER_58_251 vssd1 vssd1 vccd1 vccd1 sky130_fd_sc_hd__fill_1
XANTENNA_clkbuf_leaf_13_clk_A clknet_2_3__leaf_clk vssd1 vssd1 vccd1 vccd1 sky130_fd_sc_hd__diode_2
XANTENNA_clkbuf_leaf_28_clk_A clknet_2_2__leaf_clk vssd1 vssd1 vccd1 vccd1 sky130_fd_sc_hd__diode_2
XFILLER_14_321 vssd1 vssd1 vccd1 vccd1 sky130_fd_sc_hd__fill_1
XANTENNA__1240__B1 _0593_ vssd1 vssd1 vccd1 vccd1 sky130_fd_sc_hd__diode_2
X_1311_ CALC_INST.gencon_inst.operand1\[8\] net259 net53 vssd1 vssd1 vccd1 vccd1 _0098_
+ sky130_fd_sc_hd__mux2_1
XFILLER_37_5 vssd1 vssd1 vccd1 vccd1 sky130_fd_sc_hd__fill_1
X_2360_ CALC_INST.gencon_inst.operand2\[10\] _0499_ vssd1 vssd1 vccd1 vccd1 _0503_
+ sky130_fd_sc_hd__or2_1
X_2291_ _0415_ _0423_ _0443_ _1067_ CALC_INST.input_ctrl_inst.col_index\[28\] vssd1
+ vssd1 vccd1 vccd1 _0453_ sky130_fd_sc_hd__a221o_1
XFILLER_64_210 vssd1 vssd1 vccd1 vccd1 sky130_fd_sc_hd__fill_1
X_1242_ CALC_INST.gencon_inst.ALU_out\[5\] net70 net54 CALC_INST.gencon_inst.mult_calc.out\[5\]
+ vssd1 vssd1 vccd1 vccd1 _0608_ sky130_fd_sc_hd__a22o_1
XPHY_EDGE_ROW_10_Right_10 vssd1 vssd1 vccd1 vccd1 sky130_fd_sc_hd__decap_3
XFILLER_32_195 vssd1 vssd1 vccd1 vccd1 sky130_fd_sc_hd__fill_1
XFILLER_20_302 vssd1 vssd1 vccd1 vccd1 sky130_fd_sc_hd__fill_1
X_2627_ clknet_leaf_14_clk _0165_ net146 vssd1 vssd1 vccd1 vccd1 CALC_INST.gencon_inst.add_calc.main.in2\[6\]
+ sky130_fd_sc_hd__dfrtp_1
XTAP_TAPCELL_ROW_30_352 vssd1 vccd1 sky130_fd_sc_hd__tapvpwrvgnd_1
XFILLER_21_29 vssd1 vssd1 vccd1 vccd1 sky130_fd_sc_hd__fill_1
X_1509_ CALC_INST.gencon_inst.add_calc.main.GENERATE_ADDER\[1\].thingy.in1 _0742_
+ vssd1 vssd1 vccd1 vccd1 _0768_ sky130_fd_sc_hd__xor2_1
X_2489_ clknet_leaf_9_clk _0005_ net127 vssd1 vssd1 vccd1 vccd1 CALC_INST.gencon_inst.add_calc.next_finish
+ sky130_fd_sc_hd__dfrtp_1
X_2558_ clknet_leaf_13_clk _0096_ vssd1 vssd1 vccd1 vccd1 CALC_INST.gencon_inst.ALU_in1\[6\]
+ sky130_fd_sc_hd__dfxtp_1
XFILLER_46_26 vssd1 vssd1 vccd1 vccd1 sky130_fd_sc_hd__fill_2
XFILLER_62_58 vssd1 vssd1 vccd1 vccd1 sky130_fd_sc_hd__fill_1
XANTENNA__2334__A _0405_ vssd1 vssd1 vccd1 vccd1 sky130_fd_sc_hd__diode_2
XFILLER_23_195 vssd1 vssd1 vccd1 vccd1 sky130_fd_sc_hd__fill_1
XFILLER_11_73 vssd1 vssd1 vccd1 vccd1 sky130_fd_sc_hd__fill_4
XFILLER_46_287 vssd1 vssd1 vccd1 vccd1 sky130_fd_sc_hd__fill_2
XFILLER_36_81 vssd1 vssd1 vccd1 vccd1 sky130_fd_sc_hd__fill_2
X_1860_ CALC_INST.input_ctrl_inst.col_index\[18\] _0968_ CALC_INST.input_ctrl_inst.col_index\[19\]
+ vssd1 vssd1 vccd1 vccd1 _0973_ sky130_fd_sc_hd__a21oi_1
Xclkbuf_leaf_26_clk clknet_2_2__leaf_clk vssd1 vssd1 vccd1 vccd1 clknet_leaf_26_clk
+ sky130_fd_sc_hd__clkbuf_8
XFILLER_14_162 vssd1 vssd1 vccd1 vccd1 sky130_fd_sc_hd__fill_1
X_1791_ CALC_INST.gencon_inst.operand2\[15\] net48 net37 net234 vssd1 vssd1 vccd1
+ vccd1 _0301_ sky130_fd_sc_hd__a22o_1
X_2412_ _0545_ _0546_ _0519_ vssd1 vssd1 vccd1 vccd1 _0547_ sky130_fd_sc_hd__and3b_1
X_2343_ CALC_INST.gencon_inst.mult_calc.out\[6\] _0456_ vssd1 vssd1 vccd1 vccd1 _0490_
+ sky130_fd_sc_hd__nand2_1
X_2274_ _0413_ net74 _0435_ vssd1 vssd1 vccd1 vccd1 _0436_ sky130_fd_sc_hd__a21oi_1
Xclkbuf_leaf_17_clk clknet_2_3__leaf_clk vssd1 vssd1 vccd1 vccd1 clknet_leaf_17_clk
+ sky130_fd_sc_hd__clkbuf_8
X_1989_ net471 _1046_ vssd1 vssd1 vccd1 vccd1 _1048_ sky130_fd_sc_hd__nand2_1
XTAP_TAPCELL_ROW_58_547 vssd1 vccd1 sky130_fd_sc_hd__tapvpwrvgnd_1
XANTENNA__2329__A _0405_ vssd1 vssd1 vccd1 vccd1 sky130_fd_sc_hd__diode_2
XFILLER_28_232 vssd1 vssd1 vccd1 vccd1 sky130_fd_sc_hd__fill_4
XTAP_TAPCELL_ROW_41_425 vssd1 vccd1 sky130_fd_sc_hd__tapvpwrvgnd_1
XFILLER_21_8 vssd1 vssd1 vccd1 vccd1 sky130_fd_sc_hd__fill_8
XFILLER_47_80 vssd1 vssd1 vccd1 vccd1 sky130_fd_sc_hd__fill_1
XTAP_TAPCELL_ROW_6_180 vssd1 vccd1 sky130_fd_sc_hd__tapvpwrvgnd_1
XFILLER_14_7 vssd1 vssd1 vccd1 vccd1 sky130_fd_sc_hd__fill_4
XFILLER_19_221 vssd1 vssd1 vccd1 vccd1 sky130_fd_sc_hd__fill_2
XFILLER_42_290 vssd1 vssd1 vccd1 vccd1 sky130_fd_sc_hd__fill_1
X_1912_ net93 net286 net77 net298 vssd1 vssd1 vccd1 vccd1 _0343_ sky130_fd_sc_hd__a22o_1
X_1843_ CALC_INST.input_ctrl_inst.col_index\[13\] CALC_INST.input_ctrl_inst.col_index\[12\]
+ _0960_ vssd1 vssd1 vccd1 vccd1 _0962_ sky130_fd_sc_hd__and3_1
XFILLER_8_85 vssd1 vssd1 vccd1 vccd1 sky130_fd_sc_hd__fill_4
Xclkbuf_leaf_6_clk clknet_2_1__leaf_clk vssd1 vssd1 vccd1 vccd1 clknet_leaf_6_clk
+ sky130_fd_sc_hd__clkbuf_8
X_1774_ net83 _1135_ net86 net297 vssd1 vssd1 vccd1 vccd1 _0284_ sky130_fd_sc_hd__a2bb2o_1
XFILLER_8_96 vssd1 vssd1 vccd1 vccd1 sky130_fd_sc_hd__fill_1
XANTENNA__1737__A1 net94 vssd1 vssd1 vccd1 vccd1 sky130_fd_sc_hd__diode_2
X_2326_ CALC_INST.gencon_inst.operand2\[3\] CALC_INST.gencon_inst.latched_keypad_input\[3\]
+ vssd1 vssd1 vccd1 vccd1 _0476_ sky130_fd_sc_hd__or2_1
X_2257_ _0411_ _0418_ vssd1 vssd1 vccd1 vccd1 _0419_ sky130_fd_sc_hd__or2_1
XTAP_TAPCELL_ROW_63_583 vssd1 vccd1 sky130_fd_sc_hd__tapvpwrvgnd_1
XTAP_TAPCELL_ROW_55_528 vssd1 vccd1 sky130_fd_sc_hd__tapvpwrvgnd_1
X_2188_ CALC_INST.input_ctrl_inst.debounce_cnt\[13\] CALC_INST.input_ctrl_inst.debounce_cnt\[14\]
+ _1208_ vssd1 vssd1 vccd1 vccd1 _1218_ sky130_fd_sc_hd__and3_1
XFILLER_43_27 vssd1 vssd1 vccd1 vccd1 sky130_fd_sc_hd__fill_4
XFILLER_4_139 vssd1 vssd1 vccd1 vccd1 sky130_fd_sc_hd__fill_1
XANTENNA_fanout97_A CALC_INST.gencon_inst.mult_calc.state\[3\] vssd1 vssd1 vccd1 vccd1
+ sky130_fd_sc_hd__diode_2
XTAP_TAPCELL_ROW_3_161 vssd1 vccd1 sky130_fd_sc_hd__tapvpwrvgnd_1
XPHY_EDGE_ROW_9_Left_74 vssd1 vssd1 vccd1 vccd1 sky130_fd_sc_hd__decap_3
XFILLER_16_224 vssd1 vssd1 vccd1 vccd1 sky130_fd_sc_hd__fill_1
XFILLER_8_401 vssd1 vssd1 vccd1 vccd1 sky130_fd_sc_hd__fill_4
X_1490_ _0736_ _0748_ vssd1 vssd1 vccd1 vccd1 _0749_ sky130_fd_sc_hd__nor2_1
XFILLER_39_327 vssd1 vssd1 vccd1 vccd1 sky130_fd_sc_hd__fill_1
X_2111_ CALC_INST.input_ctrl_inst.RowSync\[2\] CALC_INST.input_ctrl_inst.RowSync\[0\]
+ CALC_INST.input_ctrl_inst.col_index\[2\] vssd1 vssd1 vccd1 vccd1 _1157_ sky130_fd_sc_hd__a21oi_1
Xhold1 CALC_INST.input_ctrl_inst.RowMid\[1\] vssd1 vssd1 vccd1 vccd1 net197 sky130_fd_sc_hd__dlygate4sd3_1
X_2042_ CALC_INST.gencon_inst.mult_calc.count.GENERATE_ADDER\[13\].thingy.in1 _1095_
+ vssd1 vssd1 vccd1 vccd1 _1096_ sky130_fd_sc_hd__nand2_1
XFILLER_62_363 vssd1 vssd1 vccd1 vccd1 sky130_fd_sc_hd__fill_1
XPHY_EDGE_ROW_8_Right_8 vssd1 vssd1 vccd1 vccd1 sky130_fd_sc_hd__decap_3
XANTENNA__1958__A1 net112 vssd1 vssd1 vccd1 vccd1 sky130_fd_sc_hd__diode_2
X_1826_ CALC_INST.input_ctrl_inst.col_index\[5\] _0951_ net474 vssd1 vssd1 vccd1 vccd1
+ _0952_ sky130_fd_sc_hd__a21oi_1
X_2875_ clknet_leaf_1_clk _0370_ vssd1 vssd1 vccd1 vccd1 CALC_INST.input_ctrl_inst.scan_timer\[13\]
+ sky130_fd_sc_hd__dfxtp_1
XPHY_EDGE_ROW_39_Right_39 vssd1 vssd1 vccd1 vccd1 sky130_fd_sc_hd__decap_3
X_1757_ net300 net262 net101 vssd1 vssd1 vccd1 vccd1 _0268_ sky130_fd_sc_hd__mux2_1
X_1688_ _0914_ _0915_ _0916_ vssd1 vssd1 vccd1 vccd1 _0917_ sky130_fd_sc_hd__or3_1
XANTENNA__1511__A CALC_INST.gencon_inst.add_calc.state\[1\] vssd1 vssd1 vccd1 vccd1
+ sky130_fd_sc_hd__diode_2
XFILLER_54_37 vccd1 vssd1 vccd1 vssd1 sky130_ef_sc_hd__decap_40_12
XFILLER_45_308 vssd1 vssd1 vccd1 vccd1 sky130_fd_sc_hd__fill_8
X_2309_ _0460_ vssd1 vssd1 vccd1 vccd1 _0461_ sky130_fd_sc_hd__inv_2
XTAP_TAPCELL_ROW_0_142 vssd1 vccd1 sky130_fd_sc_hd__tapvpwrvgnd_1
XTAP_TAPCELL_ROW_0_131 vssd1 vccd1 sky130_fd_sc_hd__tapvpwrvgnd_1
XPHY_EDGE_ROW_48_Right_48 vssd1 vssd1 vccd1 vccd1 sky130_fd_sc_hd__decap_3
XFILLER_13_227 vssd1 vssd1 vccd1 vccd1 sky130_fd_sc_hd__fill_1
XPHY_EDGE_ROW_57_Right_57 vssd1 vssd1 vccd1 vccd1 sky130_fd_sc_hd__decap_3
XANTENNA__2374__A1 _0404_ vssd1 vssd1 vccd1 vccd1 sky130_fd_sc_hd__diode_2
XTAP_TAPCELL_ROW_23_299 vssd1 vccd1 sky130_fd_sc_hd__tapvpwrvgnd_1
XFILLER_48_157 vssd1 vssd1 vccd1 vccd1 sky130_fd_sc_hd__fill_4
XFILLER_63_149 vssd1 vssd1 vccd1 vccd1 sky130_fd_sc_hd__fill_8
XFILLER_48_179 vssd1 vssd1 vccd1 vccd1 sky130_fd_sc_hd__fill_1
XFILLER_44_363 vssd1 vssd1 vccd1 vccd1 sky130_fd_sc_hd__fill_1
XFILLER_28_93 vssd1 vssd1 vccd1 vccd1 sky130_fd_sc_hd__fill_2
XFILLER_8_253 vssd1 vssd1 vccd1 vccd1 sky130_fd_sc_hd__fill_1
X_2660_ clknet_leaf_29_clk _0198_ net138 vssd1 vssd1 vccd1 vccd1 CALC_INST.gencon_inst.mult_calc.adderSave\[6\]
+ sky130_fd_sc_hd__dfrtp_1
X_1611_ CALC_INST.gencon_inst.mult_calc.main.GENERATE_ADDER\[2\].thingy.in2 CALC_INST.gencon_inst.mult_calc.main.GENERATE_ADDER\[2\].thingy.in1
+ vssd1 vssd1 vccd1 vccd1 _0851_ sky130_fd_sc_hd__nand2_1
X_1542_ net33 _0793_ _0795_ vssd1 vssd1 vccd1 vccd1 _0796_ sky130_fd_sc_hd__a21oi_1
X_1473_ _0730_ _0731_ CALC_INST.gencon_inst.add_calc.main.GENERATE_ADDER\[4\].thingy.in1
+ vssd1 vssd1 vccd1 vccd1 _0732_ sky130_fd_sc_hd__a21oi_1
X_2591_ clknet_leaf_30_clk _0129_ vssd1 vssd1 vccd1 vccd1 CALC_INST.gencon_inst.mult_calc.INn1\[2\]
+ sky130_fd_sc_hd__dfxtp_1
XFILLER_5_42 vssd1 vssd1 vccd1 vccd1 sky130_fd_sc_hd__fill_1
XFILLER_54_116 vssd1 vssd1 vccd1 vccd1 sky130_fd_sc_hd__fill_1
X_2025_ _1080_ vssd1 vssd1 vccd1 vccd1 CALC_INST.input_ctrl_inst.key_pressed sky130_fd_sc_hd__inv_2
XFILLER_62_193 vssd1 vssd1 vccd1 vccd1 sky130_fd_sc_hd__fill_2
XPHY_EDGE_ROW_59_Left_124 vssd1 vssd1 vccd1 vccd1 sky130_fd_sc_hd__decap_3
X_2927_ CALC_INST.complete vssd1 vssd1 vccd1 vccd1 net24 sky130_fd_sc_hd__buf_1
Xhold253 CALC_INST.gencon_inst.add_calc.main.GENERATE_ADDER\[7\].thingy.in1 vssd1
+ vssd1 vccd1 vccd1 net449 sky130_fd_sc_hd__dlygate4sd3_1
Xhold220 CALC_INST.gencon_inst.add_calc.main.in2\[5\] vssd1 vssd1 vccd1 vccd1 net416
+ sky130_fd_sc_hd__dlygate4sd3_1
XANTENNA__2356__A1 CALC_INST.gencon_inst.operand2\[9\] vssd1 vssd1 vccd1 vccd1 sky130_fd_sc_hd__diode_2
X_2858_ clknet_leaf_6_clk _0027_ net115 vssd1 vssd1 vccd1 vccd1 CALC_INST.input_ctrl_inst.decoded_key\[0\]
+ sky130_fd_sc_hd__dfrtp_1
X_1809_ CALC_INST.input_ctrl_inst.scan_timer\[1\] CALC_INST.input_ctrl_inst.scan_timer\[0\]
+ CALC_INST.input_ctrl_inst.scan_timer\[15\] CALC_INST.input_ctrl_inst.scan_timer\[14\]
+ vssd1 vssd1 vccd1 vccd1 _0941_ sky130_fd_sc_hd__or4bb_1
X_2789_ clknet_leaf_32_clk _0314_ net117 vssd1 vssd1 vccd1 vccd1 CALC_INST.input_ctrl_inst.col_index\[12\]
+ sky130_fd_sc_hd__dfrtp_1
Xhold231 CALC_INST.input_ctrl_inst.col_index\[10\] vssd1 vssd1 vccd1 vccd1 net427
+ sky130_fd_sc_hd__dlygate4sd3_1
Xhold242 CALC_INST.input_ctrl_inst.col_index\[5\] vssd1 vssd1 vccd1 vccd1 net438 sky130_fd_sc_hd__dlygate4sd3_1
XFILLER_49_15 vssd1 vssd1 vccd1 vccd1 sky130_fd_sc_hd__fill_1
Xhold264 CALC_INST.gencon_inst.mult_calc.adderSave\[4\] vssd1 vssd1 vccd1 vccd1 net460
+ sky130_fd_sc_hd__dlygate4sd3_1
Xhold275 CALC_INST.input_ctrl_inst.scan_timer\[18\] vssd1 vssd1 vccd1 vccd1 net471
+ sky130_fd_sc_hd__dlygate4sd3_1
XTAP_TAPCELL_ROW_28_336 vssd1 vccd1 sky130_fd_sc_hd__tapvpwrvgnd_1
XFILLER_26_385 vssd1 vssd1 vccd1 vccd1 sky130_fd_sc_hd__fill_2
XANTENNA__1387__S net109 vssd1 vssd1 vccd1 vccd1 sky130_fd_sc_hd__diode_2
XFILLER_41_355 vssd1 vssd1 vccd1 vccd1 sky130_fd_sc_hd__fill_4
XTAP_TAPCELL_ROW_36_391 vssd1 vccd1 sky130_fd_sc_hd__tapvpwrvgnd_1
XTAP_TAPCELL_ROW_11_214 vssd1 vccd1 sky130_fd_sc_hd__tapvpwrvgnd_1
XFILLER_30_50 vssd1 vssd1 vccd1 vccd1 sky130_fd_sc_hd__fill_2
XFILLER_64_403 vssd1 vssd1 vccd1 vccd1 sky130_fd_sc_hd__fill_1
XFILLER_32_311 vssd1 vssd1 vccd1 vccd1 sky130_fd_sc_hd__fill_2
XFILLER_32_300 vssd1 vssd1 vccd1 vccd1 sky130_fd_sc_hd__fill_1
X_2643_ clknet_leaf_15_clk _0181_ net147 vssd1 vssd1 vccd1 vccd1 CALC_INST.gencon_inst.ALU_out\[7\]
+ sky130_fd_sc_hd__dfrtp_1
X_2574_ clknet_leaf_13_clk _0112_ vssd1 vssd1 vccd1 vccd1 CALC_INST.gencon_inst.ALU_in2\[6\]
+ sky130_fd_sc_hd__dfxtp_1
X_2712_ clknet_leaf_25_clk net347 net141 vssd1 vssd1 vccd1 vccd1 CALC_INST.gencon_inst.mult_calc.main.GENERATE_ADDER\[12\].thingy.in2
+ sky130_fd_sc_hd__dfrtp_1
X_1456_ net105 CALC_INST.gencon_inst.add_calc.main.in2\[8\] vssd1 vssd1 vccd1 vccd1
+ _0715_ sky130_fd_sc_hd__nand2_1
X_1387_ net411 _0668_ net109 vssd1 vssd1 vccd1 vccd1 _0152_ sky130_fd_sc_hd__mux2_1
X_1525_ net31 _0778_ _0780_ net81 vssd1 vssd1 vccd1 vccd1 _0782_ sky130_fd_sc_hd__a31o_1
XANTENNA__1770__A1_N net82 vssd1 vssd1 vccd1 vccd1 sky130_fd_sc_hd__diode_2
X_2008_ net103 vssd1 vssd1 vccd1 vccd1 _1064_ sky130_fd_sc_hd__inv_2
XTAP_TAPCELL_ROW_25_317 vssd1 vccd1 sky130_fd_sc_hd__tapvpwrvgnd_1
XTAP_TAPCELL_ROW_33_372 vssd1 vccd1 sky130_fd_sc_hd__tapvpwrvgnd_1
XFILLER_46_403 vssd1 vssd1 vccd1 vccd1 sky130_fd_sc_hd__fill_4
XFILLER_25_61 vssd1 vssd1 vccd1 vccd1 sky130_fd_sc_hd__fill_1
XANTENNA__1791__A2 net48 vssd1 vssd1 vccd1 vccd1 sky130_fd_sc_hd__diode_2
XANTENNA__1580__S CALC_INST.gencon_inst.add_calc.state\[1\] vssd1 vssd1 vccd1 vccd1
+ sky130_fd_sc_hd__diode_2
X_1310_ CALC_INST.gencon_inst.operand1\[7\] net350 net52 vssd1 vssd1 vccd1 vccd1 _0097_
+ sky130_fd_sc_hd__mux2_1
XFILLER_44_7 vccd1 vssd1 vccd1 vssd1 sky130_ef_sc_hd__decap_40_12
X_1241_ CALC_INST.gencon_inst.operand2\[5\] CALC_INST.gencon_inst.operand1\[5\] _0393_
+ vssd1 vssd1 vccd1 vccd1 _0607_ sky130_fd_sc_hd__mux2_1
XPHY_EDGE_ROW_22_Left_87 vssd1 vssd1 vccd1 vccd1 sky130_fd_sc_hd__decap_3
X_2290_ CALC_INST.input_ctrl_inst.col_index\[25\] CALC_INST.input_ctrl_inst.col_index\[24\]
+ CALC_INST.input_ctrl_inst.col_index\[28\] _0420_ _0451_ vssd1 vssd1 vccd1 vccd1
+ _0452_ sky130_fd_sc_hd__a41o_1
XTAP_TAPCELL_ROW_30_353 vssd1 vccd1 sky130_fd_sc_hd__tapvpwrvgnd_1
X_2626_ clknet_leaf_14_clk _0164_ net147 vssd1 vssd1 vccd1 vccd1 CALC_INST.gencon_inst.add_calc.main.in2\[5\]
+ sky130_fd_sc_hd__dfrtp_1
X_2557_ clknet_leaf_13_clk _0095_ vssd1 vssd1 vccd1 vccd1 CALC_INST.gencon_inst.ALU_in1\[5\]
+ sky130_fd_sc_hd__dfxtp_1
XFILLER_9_381 vssd1 vssd1 vccd1 vccd1 sky130_fd_sc_hd__fill_4
X_2488_ clknet_leaf_9_clk _0001_ net129 vssd1 vssd1 vccd1 vccd1 CALC_INST.gencon_inst.add_calc.state\[2\]
+ sky130_fd_sc_hd__dfrtp_2
X_1508_ _0693_ _0696_ _0763_ _0766_ vssd1 vssd1 vccd1 vccd1 _0767_ sky130_fd_sc_hd__o31a_1
X_1439_ net104 CALC_INST.gencon_inst.add_calc.main.in2\[12\] vssd1 vssd1 vccd1 vccd1
+ _0698_ sky130_fd_sc_hd__or2_1
XFILLER_43_406 vssd1 vssd1 vccd1 vccd1 sky130_fd_sc_hd__fill_1
XFILLER_23_185 vssd1 vssd1 vccd1 vccd1 sky130_fd_sc_hd__fill_1
XFILLER_11_41 vssd1 vssd1 vccd1 vccd1 sky130_fd_sc_hd__fill_8
XANTENNA_fanout82_X net82 vssd1 vssd1 vccd1 vccd1 sky130_fd_sc_hd__diode_2
XFILLER_61_225 vssd1 vssd1 vccd1 vccd1 sky130_fd_sc_hd__fill_1
XFILLER_52_81 vssd1 vssd1 vccd1 vccd1 sky130_fd_sc_hd__fill_2
XTAP_TAPCELL_ROW_44_445 vssd1 vccd1 sky130_fd_sc_hd__tapvpwrvgnd_1
X_1790_ CALC_INST.gencon_inst.operand2\[14\] net49 net38 net358 vssd1 vssd1 vccd1
+ vccd1 _0300_ sky130_fd_sc_hd__a22o_1
X_2411_ _0543_ _0544_ _0536_ _0539_ vssd1 vssd1 vccd1 vccd1 _0546_ sky130_fd_sc_hd__a211o_1
XFILLER_6_351 vssd1 vssd1 vccd1 vccd1 sky130_fd_sc_hd__fill_1
XANTENNA__2477__B1 net54 vssd1 vssd1 vccd1 vccd1 sky130_fd_sc_hd__diode_2
X_2342_ _0474_ _0477_ CALC_INST.gencon_inst.operand2\[6\] CALC_INST.gencon_inst.operand2\[5\]
+ CALC_INST.gencon_inst.operand2\[4\] vssd1 vssd1 vccd1 vccd1 _0489_ sky130_fd_sc_hd__o2111a_1
X_2273_ CALC_INST.input_ctrl_inst.col_index\[17\] CALC_INST.input_ctrl_inst.col_index\[16\]
+ _0416_ _0422_ vssd1 vssd1 vccd1 vccd1 _0435_ sky130_fd_sc_hd__or4_1
XANTENNA__2435__A _0520_ vssd1 vssd1 vccd1 vccd1 sky130_fd_sc_hd__diode_2
XFILLER_25_406 vssd1 vssd1 vccd1 vccd1 sky130_fd_sc_hd__fill_1
XANTENNA_clkbuf_leaf_12_clk_A clknet_2_3__leaf_clk vssd1 vssd1 vccd1 vccd1 sky130_fd_sc_hd__diode_2
X_1988_ _1046_ net224 vssd1 vssd1 vccd1 vccd1 _0374_ sky130_fd_sc_hd__nor2_1
X_2609_ clknet_leaf_10_clk _0147_ net147 vssd1 vssd1 vccd1 vccd1 CALC_INST.gencon_inst.add_calc.main.GENERATE_ADDER\[3\].thingy.in1
+ sky130_fd_sc_hd__dfrtp_1
XANTENNA_clkbuf_leaf_27_clk_A clknet_2_2__leaf_clk vssd1 vssd1 vccd1 vccd1 sky130_fd_sc_hd__diode_2
XTAP_TAPCELL_ROW_58_548 vssd1 vccd1 sky130_fd_sc_hd__tapvpwrvgnd_1
Xclkbuf_2_2__f_clk clknet_0_clk vssd1 vssd1 vccd1 vccd1 clknet_2_2__leaf_clk sky130_fd_sc_hd__clkbuf_16
XTAP_TAPCELL_ROW_41_426 vssd1 vccd1 sky130_fd_sc_hd__tapvpwrvgnd_1
XFILLER_11_111 vssd1 vssd1 vccd1 vccd1 sky130_fd_sc_hd__fill_1
XANTENNA__1395__S net109 vssd1 vssd1 vccd1 vccd1 sky130_fd_sc_hd__diode_2
XFILLER_3_310 vssd1 vssd1 vccd1 vccd1 sky130_fd_sc_hd__fill_4
XTAP_TAPCELL_ROW_6_181 vssd1 vccd1 sky130_fd_sc_hd__tapvpwrvgnd_1
XFILLER_47_70 vssd1 vssd1 vccd1 vccd1 sky130_fd_sc_hd__fill_8
X_1773_ net83 _1131_ net86 net292 vssd1 vssd1 vccd1 vccd1 _0283_ sky130_fd_sc_hd__a2bb2o_1
X_1911_ net91 net247 net77 CALC_INST.gencon_inst.mult_calc.count.GENERATE_ADDER\[8\].thingy.in1
+ vssd1 vssd1 vccd1 vccd1 _0342_ sky130_fd_sc_hd__a22o_1
X_1842_ CALC_INST.input_ctrl_inst.col_index\[12\] _0960_ net475 vssd1 vssd1 vccd1
+ vccd1 _0961_ sky130_fd_sc_hd__a21oi_1
XFILLER_8_42 vssd1 vssd1 vccd1 vccd1 sky130_fd_sc_hd__fill_1
X_2187_ CALC_INST.input_ctrl_inst.debounce_cnt\[13\] _1208_ CALC_INST.input_ctrl_inst.debounce_cnt\[14\]
+ vssd1 vssd1 vccd1 vccd1 _1217_ sky130_fd_sc_hd__a21oi_1
XPHY_EDGE_ROW_40_Left_105 vssd1 vssd1 vccd1 vccd1 sky130_fd_sc_hd__decap_3
X_2325_ CALC_INST.gencon_inst.operand2\[3\] CALC_INST.gencon_inst.latched_keypad_input\[3\]
+ vssd1 vssd1 vccd1 vccd1 _0475_ sky130_fd_sc_hd__nand2_1
XPHY_EDGE_ROW_25_Left_90 vssd1 vssd1 vccd1 vccd1 sky130_fd_sc_hd__decap_3
X_2256_ _0409_ _0410_ _0415_ vssd1 vssd1 vccd1 vccd1 _0418_ sky130_fd_sc_hd__or3_1
XTAP_TAPCELL_ROW_63_584 vssd1 vccd1 sky130_fd_sc_hd__tapvpwrvgnd_1
XANTENNA_fanout132_X net132 vssd1 vssd1 vccd1 vccd1 sky130_fd_sc_hd__diode_2
XFILLER_0_335 vssd1 vssd1 vccd1 vccd1 sky130_fd_sc_hd__fill_1
XFILLER_56_372 vssd1 vssd1 vccd1 vccd1 sky130_fd_sc_hd__fill_8
XFILLER_56_361 vssd1 vssd1 vccd1 vccd1 sky130_fd_sc_hd__fill_2
XFILLER_56_350 vssd1 vssd1 vccd1 vccd1 sky130_fd_sc_hd__fill_4
XTAP_TAPCELL_ROW_3_162 vssd1 vccd1 sky130_fd_sc_hd__tapvpwrvgnd_1
XFILLER_3_151 vssd1 vssd1 vccd1 vccd1 sky130_fd_sc_hd__fill_1
Xhold2 CALC_INST.input_ctrl_inst.RowMid\[3\] vssd1 vssd1 vccd1 vccd1 net198 sky130_fd_sc_hd__dlygate4sd3_1
X_2110_ _1053_ CALC_INST.input_ctrl_inst.RowSync\[1\] CALC_INST.input_ctrl_inst.RowSync\[3\]
+ vssd1 vssd1 vccd1 vccd1 _1156_ sky130_fd_sc_hd__o21a_1
X_2041_ CALC_INST.gencon_inst.mult_calc.count.GENERATE_ADDER\[12\].thingy.in1 _1094_
+ vssd1 vssd1 vccd1 vccd1 _1095_ sky130_fd_sc_hd__and2_1
XANTENNA__1958__A2 net63 vssd1 vssd1 vccd1 vccd1 sky130_fd_sc_hd__diode_2
X_1825_ net438 _0951_ vssd1 vssd1 vccd1 vccd1 _0307_ sky130_fd_sc_hd__xor2_1
X_1756_ CALC_INST.gencon_inst.mult_calc.out\[14\] net433 net102 vssd1 vssd1 vccd1
+ vccd1 _0267_ sky130_fd_sc_hd__mux2_1
X_2874_ clknet_leaf_1_clk _0369_ vssd1 vssd1 vccd1 vccd1 CALC_INST.input_ctrl_inst.scan_timer\[12\]
+ sky130_fd_sc_hd__dfxtp_1
XANTENNA__1591__B1 CALC_INST.gencon_inst.add_calc.state\[1\] vssd1 vssd1 vccd1 vccd1
+ sky130_fd_sc_hd__diode_2
X_2308_ CALC_INST.gencon_inst.operand2\[1\] CALC_INST.gencon_inst.latched_keypad_input\[1\]
+ vssd1 vssd1 vccd1 vccd1 _0460_ sky130_fd_sc_hd__nand2_1
X_1687_ _0909_ _0911_ _0910_ vssd1 vssd1 vccd1 vccd1 _0916_ sky130_fd_sc_hd__a21boi_1
XFILLER_57_169 vccd1 vssd1 vccd1 vssd1 sky130_ef_sc_hd__decap_40_12
XFILLER_54_49 vccd1 vssd1 vccd1 vssd1 sky130_ef_sc_hd__decap_40_12
X_2239_ CALC_INST.gencon_inst.gencon_state\[0\] _1236_ vssd1 vssd1 vccd1 vccd1 _0404_
+ sky130_fd_sc_hd__and2_2
XTAP_TAPCELL_ROW_0_143 vssd1 vccd1 sky130_fd_sc_hd__tapvpwrvgnd_1
XTAP_TAPCELL_ROW_0_132 vssd1 vccd1 sky130_fd_sc_hd__tapvpwrvgnd_1
XFILLER_48_125 vccd1 vssd1 vccd1 vssd1 sky130_ef_sc_hd__decap_40_12
XFILLER_29_350 vssd1 vssd1 vccd1 vccd1 sky130_fd_sc_hd__fill_2
XFILLER_28_83 vssd1 vssd1 vccd1 vccd1 sky130_fd_sc_hd__fill_1
XFILLER_28_50 vssd1 vssd1 vccd1 vccd1 sky130_fd_sc_hd__fill_4
X_2590_ clknet_leaf_4_clk _0128_ vssd1 vssd1 vccd1 vccd1 CALC_INST.gencon_inst.mult_calc.INn1\[1\]
+ sky130_fd_sc_hd__dfxtp_1
XFILLER_8_221 vssd1 vssd1 vccd1 vccd1 sky130_fd_sc_hd__fill_1
X_1610_ CALC_INST.gencon_inst.mult_calc.main.GENERATE_ADDER\[2\].thingy.in2 CALC_INST.gencon_inst.mult_calc.main.GENERATE_ADDER\[2\].thingy.in1
+ vssd1 vssd1 vccd1 vccd1 _0850_ sky130_fd_sc_hd__nor2_1
X_1541_ _0752_ _0794_ vssd1 vssd1 vccd1 vccd1 _0795_ sky130_fd_sc_hd__xnor2_1
X_1472_ net106 CALC_INST.gencon_inst.add_calc.main.in2\[4\] vssd1 vssd1 vccd1 vccd1
+ _0731_ sky130_fd_sc_hd__nand2_1
XFILLER_47_180 vssd1 vssd1 vccd1 vccd1 sky130_fd_sc_hd__fill_2
XFILLER_39_169 vssd1 vssd1 vccd1 vccd1 sky130_fd_sc_hd__fill_4
X_2024_ CALC_INST.input_ctrl_inst.RowSync\[2\] CALC_INST.input_ctrl_inst.RowSync\[0\]
+ CALC_INST.input_ctrl_inst.RowSync\[1\] CALC_INST.input_ctrl_inst.RowSync\[3\] vssd1
+ vssd1 vccd1 vccd1 _1080_ sky130_fd_sc_hd__and4_2
X_2857_ clknet_leaf_7_clk _0017_ net126 vssd1 vssd1 vccd1 vccd1 CALC_INST.input_ctrl_inst.debounce_cnt\[18\]
+ sky130_fd_sc_hd__dfrtp_1
X_2926_ CALC_INST.input_ctrl_inst.key_pressed vssd1 vssd1 vccd1 vccd1 net23 sky130_fd_sc_hd__clkbuf_1
Xhold276 CALC_INST.input_ctrl_inst.debounce_cnt\[1\] vssd1 vssd1 vccd1 vccd1 net472
+ sky130_fd_sc_hd__dlygate4sd3_1
Xhold254 CALC_INST.gencon_inst.add_calc.main.GENERATE_ADDER\[11\].thingy.in1 vssd1
+ vssd1 vccd1 vccd1 net450 sky130_fd_sc_hd__dlygate4sd3_1
Xhold210 CALC_INST.gencon_inst.add_calc.main.GENERATE_ADDER\[14\].thingy.in1 vssd1
+ vssd1 vccd1 vccd1 net406 sky130_fd_sc_hd__dlygate4sd3_1
Xhold265 CALC_INST.gencon_inst.ALU_out\[13\] vssd1 vssd1 vccd1 vccd1 net461 sky130_fd_sc_hd__dlygate4sd3_1
XFILLER_40_29 vssd1 vssd1 vccd1 vccd1 sky130_fd_sc_hd__fill_2
Xhold221 net18 vssd1 vssd1 vccd1 vccd1 net417 sky130_fd_sc_hd__dlygate4sd3_1
Xhold243 CALC_INST.gencon_inst.mult_calc.INn2\[4\] vssd1 vssd1 vccd1 vccd1 net439
+ sky130_fd_sc_hd__dlygate4sd3_1
X_1808_ CALC_INST.input_ctrl_inst.scan_timer\[3\] CALC_INST.input_ctrl_inst.scan_timer\[2\]
+ CALC_INST.input_ctrl_inst.scan_timer\[5\] CALC_INST.input_ctrl_inst.scan_timer\[4\]
+ vssd1 vssd1 vccd1 vccd1 _0940_ sky130_fd_sc_hd__or4b_1
X_2788_ clknet_leaf_32_clk _0313_ net119 vssd1 vssd1 vccd1 vccd1 CALC_INST.input_ctrl_inst.col_index\[11\]
+ sky130_fd_sc_hd__dfrtp_1
X_1739_ net93 CALC_INST.gencon_inst.mult_calc.adderSave\[12\] net77 net346 vssd1 vssd1
+ vccd1 vccd1 _0250_ sky130_fd_sc_hd__a22o_1
Xhold232 CALC_INST.gencon_inst.mult_calc.adderSave\[11\] vssd1 vssd1 vccd1 vccd1 net428
+ sky130_fd_sc_hd__dlygate4sd3_1
XFILLER_38_191 vssd1 vssd1 vccd1 vccd1 sky130_fd_sc_hd__fill_2
XTAP_TAPCELL_ROW_36_392 vssd1 vccd1 sky130_fd_sc_hd__tapvpwrvgnd_1
XTAP_TAPCELL_ROW_28_337 vssd1 vccd1 sky130_fd_sc_hd__tapvpwrvgnd_1
XANTENNA__1252__C1 _0590_ vssd1 vssd1 vccd1 vccd1 sky130_fd_sc_hd__diode_2
XFILLER_5_202 vssd1 vssd1 vccd1 vccd1 sky130_fd_sc_hd__fill_2
XTAP_TAPCELL_ROW_11_215 vssd1 vccd1 sky130_fd_sc_hd__tapvpwrvgnd_1
XFILLER_14_63 vssd1 vssd1 vccd1 vccd1 sky130_fd_sc_hd__fill_8
XANTENNA__1432__A net103 vssd1 vssd1 vccd1 vccd1 sky130_fd_sc_hd__diode_2
XFILLER_17_331 vssd1 vssd1 vccd1 vccd1 sky130_fd_sc_hd__fill_4
X_2711_ clknet_leaf_24_clk net375 net141 vssd1 vssd1 vccd1 vccd1 CALC_INST.gencon_inst.mult_calc.main.GENERATE_ADDER\[11\].thingy.in2
+ sky130_fd_sc_hd__dfrtp_1
XFILLER_17_386 vssd1 vssd1 vccd1 vccd1 sky130_fd_sc_hd__fill_1
X_1524_ net31 _0778_ _0780_ vssd1 vssd1 vccd1 vccd1 _0781_ sky130_fd_sc_hd__a21oi_1
X_2642_ clknet_leaf_14_clk _0180_ net146 vssd1 vssd1 vccd1 vccd1 CALC_INST.gencon_inst.ALU_out\[6\]
+ sky130_fd_sc_hd__dfrtp_1
X_2573_ clknet_leaf_13_clk _0111_ vssd1 vssd1 vccd1 vccd1 CALC_INST.gencon_inst.ALU_in2\[5\]
+ sky130_fd_sc_hd__dfxtp_1
X_1455_ net105 CALC_INST.gencon_inst.add_calc.main.in2\[8\] vssd1 vssd1 vccd1 vccd1
+ _0714_ sky130_fd_sc_hd__or2_1
XFILLER_59_209 vssd1 vssd1 vccd1 vccd1 sky130_fd_sc_hd__fill_8
X_1386_ CALC_INST.gencon_inst.ALU_in2\[8\] CALC_INST.gencon_inst.ALU_in1\[8\] net66
+ vssd1 vssd1 vccd1 vccd1 _0668_ sky130_fd_sc_hd__mux2_1
X_2007_ net480 vssd1 vssd1 vccd1 vccd1 _1063_ sky130_fd_sc_hd__inv_2
XFILLER_35_29 vssd1 vssd1 vccd1 vccd1 sky130_fd_sc_hd__fill_1
XANTENNA__1342__A net48 vssd1 vssd1 vccd1 vccd1 sky130_fd_sc_hd__diode_2
XTAP_TAPCELL_ROW_25_318 vssd1 vccd1 sky130_fd_sc_hd__tapvpwrvgnd_1
XTAP_TAPCELL_ROW_33_373 vssd1 vccd1 sky130_fd_sc_hd__tapvpwrvgnd_1
XFILLER_58_220 vssd1 vssd1 vccd1 vccd1 sky130_fd_sc_hd__fill_8
XANTENNA_fanout72_A net73 vssd1 vssd1 vccd1 vccd1 sky130_fd_sc_hd__diode_2
XANTENNA__2348__A _0405_ vssd1 vssd1 vccd1 vccd1 sky130_fd_sc_hd__diode_2
XFILLER_18_106 vssd1 vssd1 vccd1 vccd1 sky130_fd_sc_hd__fill_2
XANTENNA__1240__A2 net57 vssd1 vssd1 vccd1 vccd1 sky130_fd_sc_hd__diode_2
X_1240_ net468 net57 _0593_ _0605_ _0606_ vssd1 vssd1 vccd1 vccd1 _0067_ sky130_fd_sc_hd__a221o_1
XFILLER_24_109 vssd1 vssd1 vccd1 vccd1 sky130_fd_sc_hd__fill_2
XANTENNA__1767__B1 net84 vssd1 vssd1 vccd1 vccd1 sky130_fd_sc_hd__diode_2
X_2487_ clknet_leaf_9_clk net107 net129 vssd1 vssd1 vccd1 vccd1 CALC_INST.gencon_inst.add_calc.state\[1\]
+ sky130_fd_sc_hd__dfrtp_4
X_1507_ _1064_ _0765_ vssd1 vssd1 vccd1 vccd1 _0766_ sky130_fd_sc_hd__nor2_1
X_2625_ clknet_leaf_11_clk _0163_ net147 vssd1 vssd1 vccd1 vccd1 CALC_INST.gencon_inst.add_calc.main.in2\[4\]
+ sky130_fd_sc_hd__dfrtp_1
X_2556_ clknet_leaf_12_clk _0094_ vssd1 vssd1 vccd1 vccd1 CALC_INST.gencon_inst.ALU_in1\[4\]
+ sky130_fd_sc_hd__dfxtp_1
X_1438_ CALC_INST.gencon_inst.add_calc.main.GENERATE_ADDER\[13\].thingy.in1 _0694_
+ _0695_ vssd1 vssd1 vccd1 vccd1 _0697_ sky130_fd_sc_hd__nand3_1
X_1369_ CALC_INST.gencon_inst.ALU_in1\[15\] _0658_ vssd1 vssd1 vccd1 vccd1 _0659_
+ sky130_fd_sc_hd__nand2_2
XFILLER_23_120 vssd1 vssd1 vccd1 vccd1 sky130_fd_sc_hd__fill_4
XFILLER_11_315 vssd1 vssd1 vccd1 vccd1 sky130_fd_sc_hd__fill_1
XANTENNA_fanout75_X net75 vssd1 vssd1 vccd1 vccd1 sky130_fd_sc_hd__diode_2
XFILLER_11_86 vssd1 vssd1 vccd1 vccd1 sky130_fd_sc_hd__fill_1
XFILLER_46_289 vssd1 vssd1 vccd1 vccd1 sky130_fd_sc_hd__fill_1
XTAP_TAPCELL_ROW_44_446 vssd1 vccd1 sky130_fd_sc_hd__tapvpwrvgnd_1
XFILLER_36_83 vssd1 vssd1 vccd1 vccd1 sky130_fd_sc_hd__fill_1
X_2410_ _0536_ _0539_ _0543_ _0544_ vssd1 vssd1 vccd1 vccd1 _0545_ sky130_fd_sc_hd__o211a_1
X_2341_ CALC_INST.gencon_inst.operand2\[5\] _0482_ CALC_INST.gencon_inst.operand2\[6\]
+ vssd1 vssd1 vccd1 vccd1 _0488_ sky130_fd_sc_hd__a21oi_1
XFILLER_37_223 vssd1 vssd1 vccd1 vccd1 sky130_fd_sc_hd__fill_1
X_2272_ _0429_ _0433_ _0419_ vssd1 vssd1 vccd1 vccd1 _0434_ sky130_fd_sc_hd__a21bo_1
XFILLER_60_270 vssd1 vssd1 vccd1 vccd1 sky130_fd_sc_hd__fill_2
XFILLER_37_267 vssd1 vssd1 vccd1 vccd1 sky130_fd_sc_hd__fill_4
XANTENNA_fanout122_A net123 vssd1 vssd1 vccd1 vccd1 sky130_fd_sc_hd__diode_2
XFILLER_9_190 vssd1 vssd1 vccd1 vccd1 sky130_fd_sc_hd__fill_2
X_1987_ CALC_INST.input_ctrl_inst.scan_timer\[16\] _1044_ net223 vssd1 vssd1 vccd1
+ vccd1 _1047_ sky130_fd_sc_hd__a21oi_1
X_2608_ clknet_leaf_10_clk _0146_ net129 vssd1 vssd1 vccd1 vccd1 CALC_INST.gencon_inst.add_calc.main.GENERATE_ADDER\[2\].thingy.in1
+ sky130_fd_sc_hd__dfrtp_1
XFILLER_57_27 vssd1 vssd1 vccd1 vccd1 sky130_fd_sc_hd__fill_2
X_2539_ clknet_leaf_19_clk _0077_ net149 vssd1 vssd1 vccd1 vccd1 net18 sky130_fd_sc_hd__dfrtp_1
XANTENNA__1912__B1 net77 vssd1 vssd1 vccd1 vccd1 sky130_fd_sc_hd__diode_2
XTAP_TAPCELL_ROW_58_549 vssd1 vccd1 sky130_fd_sc_hd__tapvpwrvgnd_1
XFILLER_51_281 vssd1 vssd1 vccd1 vccd1 sky130_fd_sc_hd__fill_1
XTAP_TAPCELL_ROW_41_427 vssd1 vccd1 sky130_fd_sc_hd__tapvpwrvgnd_1
XFILLER_7_127 vssd1 vssd1 vccd1 vccd1 sky130_fd_sc_hd__fill_1
XFILLER_3_355 vccd1 vssd1 vccd1 vssd1 sky130_ef_sc_hd__decap_40_12
XFILLER_59_370 vssd1 vssd1 vccd1 vccd1 sky130_fd_sc_hd__fill_2
XANTENNA__1903__B1 net75 vssd1 vssd1 vccd1 vccd1 sky130_fd_sc_hd__diode_2
XTAP_TAPCELL_ROW_6_182 vssd1 vccd1 sky130_fd_sc_hd__tapvpwrvgnd_1
XFILLER_19_223 vssd1 vssd1 vccd1 vccd1 sky130_fd_sc_hd__fill_1
X_1910_ net91 net267 net75 CALC_INST.gencon_inst.mult_calc.count.GENERATE_ADDER\[7\].thingy.in1
+ vssd1 vssd1 vccd1 vccd1 _0341_ sky130_fd_sc_hd__a22o_1
XANTENNA__2395__B1 _0520_ vssd1 vssd1 vccd1 vccd1 sky130_fd_sc_hd__diode_2
X_1772_ net83 _1129_ net86 net285 vssd1 vssd1 vccd1 vccd1 _0282_ sky130_fd_sc_hd__a2bb2o_1
X_1841_ net443 _0960_ vssd1 vssd1 vccd1 vccd1 _0314_ sky130_fd_sc_hd__xor2_1
X_2324_ CALC_INST.gencon_inst.operand2\[3\] CALC_INST.gencon_inst.latched_keypad_input\[3\]
+ vssd1 vssd1 vccd1 vccd1 _0474_ sky130_fd_sc_hd__and2_1
XFILLER_6_193 vssd1 vssd1 vccd1 vccd1 sky130_fd_sc_hd__fill_2
X_2186_ _1078_ _1215_ CALC_INST.input_ctrl_inst.debounce_cnt\[14\] _1074_ vssd1 vssd1
+ vccd1 vccd1 _1216_ sky130_fd_sc_hd__o211a_1
X_2255_ CALC_INST.input_ctrl_inst.col_index\[17\] CALC_INST.input_ctrl_inst.col_index\[16\]
+ _0415_ _0416_ vssd1 vssd1 vccd1 vccd1 _0417_ sky130_fd_sc_hd__or4_1
XFILLER_33_281 vssd1 vssd1 vccd1 vccd1 sky130_fd_sc_hd__fill_1
XFILLER_25_259 vssd1 vssd1 vccd1 vccd1 sky130_fd_sc_hd__fill_4
XFILLER_0_303 vssd1 vssd1 vccd1 vccd1 sky130_fd_sc_hd__fill_4
XTAP_TAPCELL_ROW_3_163 vssd1 vccd1 sky130_fd_sc_hd__tapvpwrvgnd_1
XFILLER_3_141 vssd1 vssd1 vccd1 vccd1 sky130_fd_sc_hd__fill_2
XANTENNA_clkbuf_leaf_11_clk_A clknet_2_1__leaf_clk vssd1 vssd1 vccd1 vccd1 sky130_fd_sc_hd__diode_2
Xhold3 CALC_INST.input_ctrl_inst.RowMid\[2\] vssd1 vssd1 vccd1 vccd1 net199 sky130_fd_sc_hd__dlygate4sd3_1
X_2040_ CALC_INST.gencon_inst.mult_calc.count.GENERATE_ADDER\[11\].thingy.in1 CALC_INST.gencon_inst.mult_calc.count.GENERATE_ADDER\[10\].thingy.in1
+ _1093_ vssd1 vssd1 vccd1 vccd1 _1094_ sky130_fd_sc_hd__and3_1
XFILLER_62_365 vssd1 vssd1 vccd1 vccd1 sky130_fd_sc_hd__fill_2
XFILLER_30_251 vssd1 vssd1 vccd1 vccd1 sky130_fd_sc_hd__fill_1
XANTENNA_clkbuf_leaf_26_clk_A clknet_2_2__leaf_clk vssd1 vssd1 vccd1 vccd1 sky130_fd_sc_hd__diode_2
X_2873_ clknet_leaf_1_clk _0368_ vssd1 vssd1 vccd1 vccd1 CALC_INST.input_ctrl_inst.scan_timer\[11\]
+ sky130_fd_sc_hd__dfxtp_1
X_1686_ CALC_INST.gencon_inst.mult_calc.main.GENERATE_ADDER\[13\].thingy.in2 CALC_INST.gencon_inst.mult_calc.main.GENERATE_ADDER\[13\].thingy.in1
+ vssd1 vssd1 vccd1 vccd1 _0915_ sky130_fd_sc_hd__and2_1
X_1824_ _0950_ _0951_ vssd1 vssd1 vccd1 vccd1 _0306_ sky130_fd_sc_hd__nor2_1
X_1755_ CALC_INST.gencon_inst.mult_calc.out\[13\] net325 net102 vssd1 vssd1 vccd1
+ vccd1 _0266_ sky130_fd_sc_hd__mux2_1
XFILLER_57_104 vssd1 vssd1 vccd1 vccd1 sky130_fd_sc_hd__fill_2
X_2238_ CALC_INST.gencon_inst.mult_calc.finish _0390_ _0387_ vssd1 vssd1 vccd1 vccd1
+ _0403_ sky130_fd_sc_hd__o21ai_1
X_2307_ CALC_INST.gencon_inst.operand2\[0\] net35 _0457_ _0459_ vssd1 vssd1 vccd1
+ vccd1 _0032_ sky130_fd_sc_hd__o22a_1
X_2169_ CALC_INST.input_ctrl_inst.debounce_cnt\[10\] _1199_ _1201_ _1175_ vssd1 vssd1
+ vccd1 vccd1 _1203_ sky130_fd_sc_hd__a22o_1
XTAP_TAPCELL_ROW_51_500 vssd1 vccd1 sky130_fd_sc_hd__tapvpwrvgnd_1
XTAP_TAPCELL_ROW_0_133 vssd1 vccd1 sky130_fd_sc_hd__tapvpwrvgnd_1
XANTENNA__1290__C_N net56 vssd1 vssd1 vccd1 vccd1 sky130_fd_sc_hd__diode_2
XFILLER_21_273 vssd1 vssd1 vccd1 vccd1 sky130_fd_sc_hd__fill_4
XFILLER_48_137 vssd1 vssd1 vccd1 vccd1 sky130_fd_sc_hd__fill_2
XFILLER_48_104 vssd1 vssd1 vccd1 vccd1 sky130_fd_sc_hd__fill_4
XFILLER_29_373 vssd1 vssd1 vccd1 vccd1 sky130_fd_sc_hd__fill_2
XFILLER_28_73 vssd1 vssd1 vccd1 vccd1 sky130_fd_sc_hd__fill_2
XFILLER_44_83 vssd1 vssd1 vccd1 vccd1 sky130_fd_sc_hd__fill_1
XTAP_TAPCELL_ROW_14_235 vssd1 vccd1 sky130_fd_sc_hd__tapvpwrvgnd_1
XANTENNA__2092__Y _1145_ vssd1 vssd1 vccd1 vccd1 sky130_fd_sc_hd__diode_2
X_1540_ _0724_ _0725_ vssd1 vssd1 vccd1 vccd1 _0794_ sky130_fd_sc_hd__nand2b_1
XFILLER_5_55 vssd1 vssd1 vccd1 vccd1 sky130_fd_sc_hd__fill_1
XFILLER_5_11 vssd1 vssd1 vccd1 vccd1 sky130_fd_sc_hd__fill_2
X_1471_ net106 CALC_INST.gencon_inst.add_calc.main.in2\[4\] vssd1 vssd1 vccd1 vccd1
+ _0730_ sky130_fd_sc_hd__or2_1
X_2023_ _1072_ _1078_ vssd1 vssd1 vccd1 vccd1 _1079_ sky130_fd_sc_hd__or2_1
XFILLER_62_195 vssd1 vssd1 vccd1 vccd1 sky130_fd_sc_hd__fill_1
XFILLER_50_357 vssd1 vssd1 vccd1 vccd1 sky130_fd_sc_hd__fill_1
X_2856_ clknet_leaf_7_clk _0016_ net132 vssd1 vssd1 vccd1 vccd1 CALC_INST.input_ctrl_inst.debounce_cnt\[17\]
+ sky130_fd_sc_hd__dfrtp_1
XANTENNA__1261__B1 net56 vssd1 vssd1 vccd1 vccd1 sky130_fd_sc_hd__diode_2
X_1807_ _0924_ _0937_ _0938_ vssd1 vssd1 vccd1 vccd1 _0939_ sky130_fd_sc_hd__or3b_1
Xhold277 CALC_INST.input_ctrl_inst.debounce_cnt\[9\] vssd1 vssd1 vccd1 vccd1 net473
+ sky130_fd_sc_hd__dlygate4sd3_1
Xhold255 net29 vssd1 vssd1 vccd1 vccd1 net451 sky130_fd_sc_hd__dlygate4sd3_1
X_1669_ _0882_ _0887_ _0890_ _0894_ _0888_ vssd1 vssd1 vccd1 vccd1 _0901_ sky130_fd_sc_hd__o311a_1
Xhold200 _0240_ vssd1 vssd1 vccd1 vccd1 net396 sky130_fd_sc_hd__dlygate4sd3_1
Xhold266 CALC_INST.input_ctrl_inst.col_index\[16\] vssd1 vssd1 vccd1 vccd1 net462
+ sky130_fd_sc_hd__dlygate4sd3_1
X_2787_ clknet_leaf_31_clk _0312_ net119 vssd1 vssd1 vccd1 vccd1 CALC_INST.input_ctrl_inst.col_index\[10\]
+ sky130_fd_sc_hd__dfrtp_1
Xhold222 CALC_INST.input_ctrl_inst.col_index\[8\] vssd1 vssd1 vccd1 vccd1 net418 sky130_fd_sc_hd__dlygate4sd3_1
Xhold211 CALC_INST.gencon_inst.mult_calc.compCount.in2\[10\] vssd1 vssd1 vccd1 vccd1
+ net407 sky130_fd_sc_hd__dlygate4sd3_1
Xhold233 CALC_INST.gencon_inst.mult_calc.compCount.in2\[13\] vssd1 vssd1 vccd1 vccd1
+ net429 sky130_fd_sc_hd__dlygate4sd3_1
Xhold244 CALC_INST.gencon_inst.mult_calc.main.a0.in2 vssd1 vssd1 vccd1 vccd1 net440
+ sky130_fd_sc_hd__dlygate4sd3_1
X_1738_ net93 CALC_INST.gencon_inst.mult_calc.adderSave\[11\] net78 net374 vssd1 vssd1
+ vccd1 vccd1 _0249_ sky130_fd_sc_hd__a22o_1
XTAP_TAPCELL_ROW_28_338 vssd1 vccd1 sky130_fd_sc_hd__tapvpwrvgnd_1
XFILLER_53_195 vssd1 vssd1 vccd1 vccd1 sky130_fd_sc_hd__fill_4
XTAP_TAPCELL_ROW_36_393 vssd1 vccd1 sky130_fd_sc_hd__tapvpwrvgnd_1
XTAP_TAPCELL_ROW_11_216 vssd1 vccd1 sky130_fd_sc_hd__tapvpwrvgnd_1
XFILLER_39_61 vssd1 vssd1 vccd1 vccd1 sky130_fd_sc_hd__fill_4
XFILLER_30_85 vssd1 vssd1 vccd1 vccd1 sky130_fd_sc_hd__fill_2
XFILLER_55_60 vssd1 vssd1 vccd1 vccd1 sky130_fd_sc_hd__fill_4
XFILLER_32_313 vssd1 vssd1 vccd1 vccd1 sky130_fd_sc_hd__fill_1
XANTENNA__1243__B1 _0593_ vssd1 vssd1 vccd1 vccd1 sky130_fd_sc_hd__diode_2
XFILLER_32_324 vssd1 vssd1 vccd1 vccd1 sky130_fd_sc_hd__fill_2
X_2710_ clknet_leaf_23_clk net402 net142 vssd1 vssd1 vccd1 vccd1 CALC_INST.gencon_inst.mult_calc.main.GENERATE_ADDER\[10\].thingy.in2
+ sky130_fd_sc_hd__dfrtp_1
X_1454_ CALC_INST.gencon_inst.add_calc.main.GENERATE_ADDER\[9\].thingy.in1 _0710_
+ _0711_ vssd1 vssd1 vccd1 vccd1 _0713_ sky130_fd_sc_hd__nand3_1
X_1523_ _0747_ _0779_ vssd1 vssd1 vccd1 vccd1 _0780_ sky130_fd_sc_hd__xor2_1
X_2641_ clknet_leaf_14_clk _0179_ net147 vssd1 vssd1 vccd1 vccd1 CALC_INST.gencon_inst.ALU_out\[5\]
+ sky130_fd_sc_hd__dfrtp_1
X_2572_ clknet_leaf_12_clk _0110_ vssd1 vssd1 vccd1 vccd1 CALC_INST.gencon_inst.ALU_in2\[4\]
+ sky130_fd_sc_hd__dfxtp_1
X_1385_ net449 _0667_ net109 vssd1 vssd1 vccd1 vccd1 _0151_ sky130_fd_sc_hd__mux2_1
XANTENNA_fanout152_A net153 vssd1 vssd1 vccd1 vccd1 sky130_fd_sc_hd__diode_2
XANTENNA__2454__A _0520_ vssd1 vssd1 vccd1 vccd1 sky130_fd_sc_hd__diode_2
X_2006_ CALC_INST.input_ctrl_inst.decoded_key\[3\] vssd1 vssd1 vccd1 vccd1 _1062_
+ sky130_fd_sc_hd__inv_2
XFILLER_23_335 vssd1 vssd1 vccd1 vccd1 sky130_fd_sc_hd__fill_1
X_2839_ clknet_leaf_6_clk _0008_ net125 vssd1 vssd1 vccd1 vccd1 CALC_INST.input_ctrl_inst.debounce_cnt\[0\]
+ sky130_fd_sc_hd__dfrtp_4
XTAP_TAPCELL_ROW_33_374 vssd1 vccd1 sky130_fd_sc_hd__tapvpwrvgnd_1
XANTENNA__1785__A1 CALC_INST.gencon_inst.operand2\[9\] vssd1 vssd1 vccd1 vccd1 sky130_fd_sc_hd__diode_2
XANTENNA_fanout65_A _0659_ vssd1 vssd1 vccd1 vccd1 sky130_fd_sc_hd__diode_2
XFILLER_41_110 vssd1 vssd1 vccd1 vccd1 sky130_fd_sc_hd__fill_2
XFILLER_25_96 vssd1 vssd1 vccd1 vccd1 sky130_fd_sc_hd__fill_2
XFILLER_49_210 vssd1 vssd1 vccd1 vccd1 sky130_fd_sc_hd__fill_2
XFILLER_64_279 vssd1 vssd1 vccd1 vccd1 sky130_fd_sc_hd__fill_1
XFILLER_64_268 vssd1 vssd1 vccd1 vccd1 sky130_fd_sc_hd__fill_2
XTAP_TAPCELL_ROW_47_466 vssd1 vccd1 sky130_fd_sc_hd__tapvpwrvgnd_1
Xclkbuf_leaf_29_clk clknet_2_2__leaf_clk vssd1 vssd1 vccd1 vccd1 clknet_leaf_29_clk
+ sky130_fd_sc_hd__clkbuf_8
X_2624_ clknet_leaf_14_clk _0162_ net130 vssd1 vssd1 vccd1 vccd1 CALC_INST.gencon_inst.add_calc.main.in2\[3\]
+ sky130_fd_sc_hd__dfrtp_1
XANTENNA__2413__C1 net41 vssd1 vssd1 vccd1 vccd1 sky130_fd_sc_hd__diode_2
X_2486_ clknet_leaf_8_clk _0000_ net127 vssd1 vssd1 vccd1 vccd1 CALC_INST.gencon_inst.add_calc.state\[0\]
+ sky130_fd_sc_hd__dfstp_1
X_1437_ _0694_ _0695_ CALC_INST.gencon_inst.add_calc.main.GENERATE_ADDER\[13\].thingy.in1
+ vssd1 vssd1 vccd1 vccd1 _0696_ sky130_fd_sc_hd__a21oi_1
X_1506_ CALC_INST.gencon_inst.add_calc.main.GENERATE_ADDER\[14\].thingy.in1 _0691_
+ _0692_ vssd1 vssd1 vccd1 vccd1 _0765_ sky130_fd_sc_hd__and3_1
X_2555_ clknet_leaf_11_clk _0093_ vssd1 vssd1 vccd1 vccd1 CALC_INST.gencon_inst.ALU_in1\[3\]
+ sky130_fd_sc_hd__dfxtp_1
XFILLER_55_235 vssd1 vssd1 vccd1 vccd1 sky130_fd_sc_hd__fill_4
XFILLER_55_213 vssd1 vssd1 vccd1 vccd1 sky130_fd_sc_hd__fill_2
X_1368_ CALC_INST.gencon_inst.addOrSub _0657_ vssd1 vssd1 vccd1 vccd1 _0658_ sky130_fd_sc_hd__xnor2_1
XFILLER_46_29 vssd1 vssd1 vccd1 vccd1 sky130_fd_sc_hd__fill_8
X_1299_ net125 net56 vssd1 vssd1 vccd1 vccd1 _0644_ sky130_fd_sc_hd__nand2_1
XANTENNA__1263__A _1234_ vssd1 vssd1 vccd1 vccd1 sky130_fd_sc_hd__diode_2
XANTENNA__2359__A CALC_INST.gencon_inst.operand2\[10\] vssd1 vssd1 vccd1 vccd1 sky130_fd_sc_hd__diode_2
XTAP_TAPCELL_ROW_44_447 vssd1 vccd1 sky130_fd_sc_hd__tapvpwrvgnd_1
XFILLER_52_83 vssd1 vssd1 vccd1 vccd1 sky130_fd_sc_hd__fill_1
XANTENNA__2381__X _0519_ vssd1 vssd1 vccd1 vccd1 sky130_fd_sc_hd__diode_2
X_2340_ CALC_INST.gencon_inst.operand2\[5\] _0487_ net35 vssd1 vssd1 vccd1 vccd1 _0037_
+ sky130_fd_sc_hd__mux2_1
X_2271_ _0431_ _0432_ vssd1 vssd1 vccd1 vccd1 _0433_ sky130_fd_sc_hd__nor2_1
X_1986_ CALC_INST.input_ctrl_inst.scan_timer\[17\] CALC_INST.input_ctrl_inst.scan_timer\[16\]
+ _1044_ vssd1 vssd1 vccd1 vccd1 _1046_ sky130_fd_sc_hd__and3_1
X_2607_ clknet_leaf_9_clk _0145_ net129 vssd1 vssd1 vccd1 vccd1 CALC_INST.gencon_inst.add_calc.main.GENERATE_ADDER\[1\].thingy.in1
+ sky130_fd_sc_hd__dfrtp_1
Xclkbuf_leaf_9_clk clknet_2_1__leaf_clk vssd1 vssd1 vccd1 vccd1 clknet_leaf_9_clk
+ sky130_fd_sc_hd__clkbuf_8
X_2538_ clknet_leaf_19_clk _0076_ net149 vssd1 vssd1 vccd1 vccd1 net17 sky130_fd_sc_hd__dfrtp_1
X_2469_ _1234_ net72 _0397_ vssd1 vssd1 vccd1 vccd1 _0591_ sky130_fd_sc_hd__and3_1
Xwire61 _0942_ vssd1 vssd1 vccd1 vccd1 net61 sky130_fd_sc_hd__clkbuf_1
XTAP_TAPCELL_ROW_41_428 vssd1 vccd1 sky130_fd_sc_hd__tapvpwrvgnd_1
XFILLER_3_367 vccd1 vssd1 vccd1 vssd1 sky130_ef_sc_hd__decap_40_12
XANTENNA__1903__A1 net91 vssd1 vssd1 vccd1 vccd1 sky130_fd_sc_hd__diode_2
XTAP_TAPCELL_ROW_6_183 vssd1 vccd1 sky130_fd_sc_hd__tapvpwrvgnd_1
XFILLER_8_33 vssd1 vssd1 vccd1 vccd1 sky130_fd_sc_hd__fill_2
X_1840_ _0959_ _0960_ vssd1 vssd1 vccd1 vccd1 _0313_ sky130_fd_sc_hd__nor2_1
X_1771_ net83 _1125_ net86 net294 vssd1 vssd1 vccd1 vccd1 _0281_ sky130_fd_sc_hd__a2bb2o_1
X_2323_ CALC_INST.gencon_inst.operand2\[2\] _0473_ net35 vssd1 vssd1 vccd1 vccd1 _0034_
+ sky130_fd_sc_hd__mux2_1
X_2254_ CALC_INST.input_ctrl_inst.col_index\[21\] CALC_INST.input_ctrl_inst.col_index\[20\]
+ CALC_INST.input_ctrl_inst.col_index\[22\] vssd1 vssd1 vccd1 vccd1 _0416_ sky130_fd_sc_hd__or3_1
X_2185_ _1068_ CALC_INST.input_ctrl_inst.key_pressed vssd1 vssd1 vccd1 vccd1 _1215_
+ sky130_fd_sc_hd__nor2_1
XFILLER_25_238 vssd1 vssd1 vccd1 vccd1 sky130_fd_sc_hd__fill_1
X_1969_ net116 _0936_ _1035_ _1060_ _1036_ vssd1 vssd1 vccd1 vccd1 _0366_ sky130_fd_sc_hd__a221oi_1
XFILLER_0_337 vccd1 vssd1 vccd1 vssd1 sky130_ef_sc_hd__decap_40_12
XFILLER_56_363 vssd1 vssd1 vccd1 vccd1 sky130_fd_sc_hd__fill_1
XTAP_TAPCELL_ROW_3_164 vssd1 vccd1 sky130_fd_sc_hd__tapvpwrvgnd_1
XTAP_TAPCELL_ROW_54_520 vssd1 vccd1 sky130_fd_sc_hd__tapvpwrvgnd_1
XFILLER_17_53 vssd1 vssd1 vccd1 vccd1 sky130_fd_sc_hd__fill_2
XFILLER_17_97 vssd1 vssd1 vccd1 vccd1 sky130_fd_sc_hd__fill_8
XFILLER_58_71 vccd1 vssd1 vccd1 vssd1 sky130_ef_sc_hd__decap_40_12
XFILLER_39_319 vssd1 vssd1 vccd1 vccd1 sky130_fd_sc_hd__fill_1
Xhold4 CALC_INST.input_ctrl_inst.RowMid\[0\] vssd1 vssd1 vccd1 vccd1 net200 sky130_fd_sc_hd__dlygate4sd3_1
XFILLER_3_164 vssd1 vssd1 vccd1 vccd1 sky130_fd_sc_hd__fill_2
XFILLER_62_399 vssd1 vssd1 vccd1 vccd1 sky130_fd_sc_hd__fill_2
XFILLER_30_274 vssd1 vssd1 vccd1 vccd1 sky130_fd_sc_hd__fill_2
X_1823_ net89 CALC_INST.input_ctrl_inst.col_index\[4\] _0949_ vssd1 vssd1 vccd1 vccd1
+ _0951_ sky130_fd_sc_hd__and3_1
X_2872_ clknet_leaf_1_clk _0367_ vssd1 vssd1 vccd1 vccd1 CALC_INST.input_ctrl_inst.scan_timer\[10\]
+ sky130_fd_sc_hd__dfxtp_1
X_1685_ CALC_INST.gencon_inst.mult_calc.main.GENERATE_ADDER\[13\].thingy.in2 CALC_INST.gencon_inst.mult_calc.main.GENERATE_ADDER\[13\].thingy.in1
+ vssd1 vssd1 vccd1 vccd1 _0914_ sky130_fd_sc_hd__nor2_1
X_1754_ CALC_INST.gencon_inst.mult_calc.out\[12\] net404 net102 vssd1 vssd1 vccd1
+ vccd1 _0265_ sky130_fd_sc_hd__mux2_1
X_2237_ _0399_ _0402_ _0391_ vssd1 vssd1 vccd1 vccd1 CALC_INST.gencon_inst.next_state\[0\]
+ sky130_fd_sc_hd__or3b_1
X_2306_ CALC_INST.gencon_inst.operand2\[0\] CALC_INST.gencon_inst.latched_keypad_input\[0\]
+ _0382_ _0458_ vssd1 vssd1 vccd1 vccd1 _0459_ sky130_fd_sc_hd__o22a_1
X_2168_ CALC_INST.input_ctrl_inst.debounce_cnt\[10\] _1199_ vssd1 vssd1 vccd1 vccd1
+ _1202_ sky130_fd_sc_hd__nor2_1
XFILLER_53_333 vssd1 vssd1 vccd1 vccd1 sky130_fd_sc_hd__fill_2
X_2099_ _1072_ _1074_ vssd1 vssd1 vccd1 vccd1 _1148_ sky130_fd_sc_hd__nor2_2
XTAP_TAPCELL_ROW_0_134 vssd1 vccd1 sky130_fd_sc_hd__tapvpwrvgnd_1
XFILLER_21_285 vssd1 vssd1 vccd1 vccd1 sky130_fd_sc_hd__fill_1
XPHY_EDGE_ROW_17_Right_17 vssd1 vssd1 vccd1 vccd1 sky130_fd_sc_hd__decap_3
XPHY_EDGE_ROW_26_Right_26 vssd1 vssd1 vccd1 vccd1 sky130_fd_sc_hd__decap_3
XFILLER_0_101 vssd1 vssd1 vccd1 vccd1 sky130_fd_sc_hd__fill_4
XANTENNA_fanout95_A net96 vssd1 vssd1 vccd1 vccd1 sky130_fd_sc_hd__diode_2
XFILLER_28_85 vssd1 vssd1 vccd1 vccd1 sky130_fd_sc_hd__fill_8
XPHY_EDGE_ROW_35_Right_35 vssd1 vssd1 vccd1 vccd1 sky130_fd_sc_hd__decap_3
XFILLER_8_234 vssd1 vssd1 vccd1 vccd1 sky130_fd_sc_hd__fill_1
XTAP_TAPCELL_ROW_14_236 vssd1 vccd1 sky130_fd_sc_hd__tapvpwrvgnd_1
X_1470_ CALC_INST.gencon_inst.add_calc.main.GENERATE_ADDER\[5\].thingy.in1 _0726_
+ _0727_ vssd1 vssd1 vccd1 vccd1 _0729_ sky130_fd_sc_hd__nand3_1
XFILLER_60_83 vssd1 vssd1 vccd1 vccd1 sky130_fd_sc_hd__fill_1
XTAP_TAPCELL_ROW_22_291 vssd1 vccd1 sky130_fd_sc_hd__tapvpwrvgnd_1
XPHY_EDGE_ROW_44_Right_44 vssd1 vssd1 vccd1 vccd1 sky130_fd_sc_hd__decap_3
XFILLER_62_141 vccd1 vssd1 vccd1 vssd1 sky130_ef_sc_hd__decap_40_12
XPHY_EDGE_ROW_53_Right_53 vssd1 vssd1 vccd1 vccd1 sky130_fd_sc_hd__decap_3
XFILLER_47_182 vssd1 vssd1 vccd1 vccd1 sky130_fd_sc_hd__fill_1
X_2022_ CALC_INST.input_ctrl_inst.input_control_state\[2\] _1076_ vssd1 vssd1 vccd1
+ vccd1 _1078_ sky130_fd_sc_hd__or2_2
X_2855_ clknet_leaf_9_clk _0015_ net132 vssd1 vssd1 vccd1 vccd1 CALC_INST.input_ctrl_inst.debounce_cnt\[16\]
+ sky130_fd_sc_hd__dfrtp_1
Xhold201 CALC_INST.gencon_inst.add_calc.main.GENERATE_ADDER\[12\].thingy.in1 vssd1
+ vssd1 vccd1 vccd1 net397 sky130_fd_sc_hd__dlygate4sd3_1
X_2786_ clknet_leaf_33_clk _0311_ net120 vssd1 vssd1 vccd1 vccd1 CALC_INST.input_ctrl_inst.col_index\[9\]
+ sky130_fd_sc_hd__dfrtp_1
X_1806_ CALC_INST.input_ctrl_inst.scan_timer\[7\] CALC_INST.input_ctrl_inst.scan_timer\[6\]
+ CALC_INST.input_ctrl_inst.scan_timer\[9\] CALC_INST.input_ctrl_inst.scan_timer\[8\]
+ vssd1 vssd1 vccd1 vccd1 _0938_ sky130_fd_sc_hd__and4b_1
XPHY_EDGE_ROW_62_Right_62 vssd1 vssd1 vccd1 vccd1 sky130_fd_sc_hd__decap_3
Xhold212 CALC_INST.gencon_inst.add_calc.main.GENERATE_ADDER\[9\].thingy.in1 vssd1
+ vssd1 vccd1 vccd1 net408 sky130_fd_sc_hd__dlygate4sd3_1
Xhold267 CALC_INST.gencon_inst.ALU_out\[2\] vssd1 vssd1 vccd1 vccd1 net463 sky130_fd_sc_hd__dlygate4sd3_1
X_1599_ _0658_ net107 vssd1 vssd1 vccd1 vccd1 _0842_ sky130_fd_sc_hd__nand2b_1
XPHY_EDGE_ROW_37_Left_102 vssd1 vssd1 vccd1 vccd1 sky130_fd_sc_hd__decap_3
Xhold234 CALC_INST.gencon_inst.mult_calc.start vssd1 vssd1 vccd1 vccd1 net430 sky130_fd_sc_hd__dlygate4sd3_1
X_1668_ _0898_ _0899_ vssd1 vssd1 vccd1 vccd1 _0900_ sky130_fd_sc_hd__and2b_1
X_1737_ net94 CALC_INST.gencon_inst.mult_calc.adderSave\[10\] net78 net401 vssd1 vssd1
+ vccd1 vccd1 _0248_ sky130_fd_sc_hd__a22o_1
Xhold256 CALC_INST.input_ctrl_inst.col_index\[30\] vssd1 vssd1 vccd1 vccd1 net452
+ sky130_fd_sc_hd__dlygate4sd3_1
Xhold223 CALC_INST.gencon_inst.mult_calc.compCount.in2\[9\] vssd1 vssd1 vccd1 vccd1
+ net419 sky130_fd_sc_hd__dlygate4sd3_1
Xhold278 CALC_INST.input_ctrl_inst.col_index\[6\] vssd1 vssd1 vccd1 vccd1 net474 sky130_fd_sc_hd__dlygate4sd3_1
Xhold245 CALC_INST.gencon_inst.mult_calc.adderSave\[3\] vssd1 vssd1 vccd1 vccd1 net441
+ sky130_fd_sc_hd__dlygate4sd3_1
XTAP_TAPCELL_ROW_28_339 vssd1 vccd1 sky130_fd_sc_hd__tapvpwrvgnd_1
XFILLER_26_355 vssd1 vssd1 vccd1 vccd1 sky130_fd_sc_hd__fill_1
XPHY_EDGE_ROW_46_Left_111 vssd1 vssd1 vccd1 vccd1 sky130_fd_sc_hd__decap_3
XTAP_TAPCELL_ROW_36_394 vssd1 vccd1 sky130_fd_sc_hd__tapvpwrvgnd_1
XTAP_TAPCELL_ROW_11_217 vssd1 vccd1 sky130_fd_sc_hd__tapvpwrvgnd_1
XANTENNA_clkbuf_leaf_10_clk_A clknet_2_1__leaf_clk vssd1 vssd1 vccd1 vccd1 sky130_fd_sc_hd__diode_2
XPHY_EDGE_ROW_55_Left_120 vssd1 vssd1 vccd1 vccd1 sky130_fd_sc_hd__decap_3
XANTENNA_clkbuf_leaf_25_clk_A clknet_2_2__leaf_clk vssd1 vssd1 vccd1 vccd1 sky130_fd_sc_hd__diode_2
XFILLER_44_141 vssd1 vssd1 vccd1 vccd1 sky130_fd_sc_hd__fill_1
X_2640_ clknet_leaf_14_clk _0178_ net147 vssd1 vssd1 vccd1 vccd1 CALC_INST.gencon_inst.ALU_out\[4\]
+ sky130_fd_sc_hd__dfrtp_1
XANTENNA__2440__B1 _0519_ vssd1 vssd1 vccd1 vccd1 sky130_fd_sc_hd__diode_2
X_1453_ _0710_ _0711_ CALC_INST.gencon_inst.add_calc.main.GENERATE_ADDER\[9\].thingy.in1
+ vssd1 vssd1 vccd1 vccd1 _0712_ sky130_fd_sc_hd__a21oi_1
X_1522_ _0736_ _0737_ vssd1 vssd1 vccd1 vccd1 _0779_ sky130_fd_sc_hd__nand2b_1
X_2571_ clknet_leaf_10_clk _0109_ vssd1 vssd1 vccd1 vccd1 CALC_INST.gencon_inst.ALU_in2\[3\]
+ sky130_fd_sc_hd__dfxtp_1
X_1384_ CALC_INST.gencon_inst.ALU_in2\[7\] CALC_INST.gencon_inst.ALU_in1\[7\] net66
+ vssd1 vssd1 vccd1 vccd1 _0667_ sky130_fd_sc_hd__mux2_1
X_2005_ CALC_INST.gencon_inst.add_calc.state\[1\] vssd1 vssd1 vccd1 vccd1 _1061_ sky130_fd_sc_hd__inv_2
XFILLER_50_199 vssd1 vssd1 vccd1 vccd1 sky130_fd_sc_hd__fill_4
XFILLER_35_163 vssd1 vssd1 vccd1 vccd1 sky130_fd_sc_hd__fill_4
XANTENNA__2470__A _0397_ vssd1 vssd1 vccd1 vccd1 sky130_fd_sc_hd__diode_2
X_2838_ clknet_leaf_6_clk _0356_ vssd1 vssd1 vccd1 vccd1 CALC_INST.equal_input sky130_fd_sc_hd__dfxtp_1
XFILLER_31_391 vssd1 vssd1 vccd1 vccd1 sky130_fd_sc_hd__fill_1
XANTENNA__1785__A2 net48 vssd1 vssd1 vccd1 vccd1 sky130_fd_sc_hd__diode_2
X_2769_ clknet_leaf_22_clk _0298_ vssd1 vssd1 vccd1 vccd1 CALC_INST.gencon_inst.mult_calc.INn2\[12\]
+ sky130_fd_sc_hd__dfxtp_1
XANTENNA_fanout100_X net100 vssd1 vssd1 vccd1 vccd1 sky130_fd_sc_hd__diode_2
XANTENNA__2469__X _0591_ vssd1 vssd1 vccd1 vccd1 sky130_fd_sc_hd__diode_2
XFILLER_41_133 vssd1 vssd1 vccd1 vccd1 sky130_fd_sc_hd__fill_2
XANTENNA__2422__B1 net58 vssd1 vssd1 vccd1 vccd1 sky130_fd_sc_hd__diode_2
XANTENNA__1776__A2 net48 vssd1 vssd1 vccd1 vccd1 sky130_fd_sc_hd__diode_2
XFILLER_49_277 vssd1 vssd1 vccd1 vccd1 sky130_fd_sc_hd__fill_1
XFILLER_49_222 vssd1 vssd1 vccd1 vccd1 sky130_fd_sc_hd__fill_2
XFILLER_49_200 vssd1 vssd1 vccd1 vccd1 sky130_fd_sc_hd__fill_1
XTAP_TAPCELL_ROW_47_467 vssd1 vccd1 sky130_fd_sc_hd__tapvpwrvgnd_1
XANTENNA__2413__B1 net58 vssd1 vssd1 vccd1 vccd1 sky130_fd_sc_hd__diode_2
X_2623_ clknet_leaf_10_clk _0161_ net130 vssd1 vssd1 vccd1 vccd1 CALC_INST.gencon_inst.add_calc.main.in2\[2\]
+ sky130_fd_sc_hd__dfrtp_1
X_2554_ clknet_leaf_11_clk _0092_ vssd1 vssd1 vccd1 vccd1 CALC_INST.gencon_inst.ALU_in1\[2\]
+ sky130_fd_sc_hd__dfxtp_1
X_1505_ _0696_ _0763_ vssd1 vssd1 vccd1 vccd1 _0764_ sky130_fd_sc_hd__nor2_1
X_1436_ net104 CALC_INST.gencon_inst.add_calc.main.in2\[13\] vssd1 vssd1 vccd1 vccd1
+ _0695_ sky130_fd_sc_hd__nand2_1
X_1367_ CALC_INST.gencon_inst.ALU_in2\[15\] CALC_INST.gencon_inst.ALU_in1\[15\] vssd1
+ vssd1 vccd1 vccd1 _0657_ sky130_fd_sc_hd__xnor2_1
X_2485_ net7 net57 net54 CALC_INST.gencon_inst.mult_calc.out\[3\] vssd1 vssd1 vccd1
+ vccd1 _0604_ sky130_fd_sc_hd__a22o_1
XFILLER_62_18 vssd1 vssd1 vccd1 vccd1 sky130_fd_sc_hd__fill_2
XFILLER_55_225 vssd1 vssd1 vccd1 vccd1 sky130_fd_sc_hd__fill_2
XFILLER_55_203 vssd1 vssd1 vccd1 vccd1 sky130_fd_sc_hd__fill_2
X_1298_ net308 _0400_ _0401_ vssd1 vssd1 vccd1 vccd1 _0088_ sky130_fd_sc_hd__a21bo_1
XFILLER_62_29 vssd1 vssd1 vccd1 vccd1 sky130_fd_sc_hd__fill_2
XANTENNA__2471__Y _0593_ vssd1 vssd1 vccd1 vccd1 sky130_fd_sc_hd__diode_2
XFILLER_2_6 vssd1 vssd1 vccd1 vccd1 sky130_fd_sc_hd__fill_8
XFILLER_11_11 vssd1 vssd1 vccd1 vccd1 sky130_fd_sc_hd__fill_2
XFILLER_11_77 vssd1 vssd1 vccd1 vccd1 sky130_fd_sc_hd__fill_2
XANTENNA__1694__B2 net100 vssd1 vssd1 vccd1 vccd1 sky130_fd_sc_hd__diode_2
XTAP_TAPCELL_ROW_44_448 vssd1 vccd1 sky130_fd_sc_hd__tapvpwrvgnd_1
XFILLER_36_85 vssd1 vssd1 vccd1 vccd1 sky130_fd_sc_hd__fill_4
XFILLER_52_73 vssd1 vssd1 vccd1 vccd1 sky130_fd_sc_hd__fill_8
XFILLER_6_365 vccd1 vssd1 vccd1 vssd1 sky130_ef_sc_hd__decap_40_12
X_2270_ CALC_INST.input_ctrl_inst.col_index\[4\] _0409_ _0410_ _0423_ vssd1 vssd1
+ vccd1 vccd1 _0432_ sky130_fd_sc_hd__o31a_1
XFILLER_37_258 vssd1 vssd1 vccd1 vccd1 sky130_fd_sc_hd__fill_1
XFILLER_60_283 vssd1 vssd1 vccd1 vccd1 sky130_fd_sc_hd__fill_4
XFILLER_60_272 vssd1 vssd1 vccd1 vccd1 sky130_fd_sc_hd__fill_1
XFILLER_60_250 vssd1 vssd1 vccd1 vccd1 sky130_fd_sc_hd__fill_2
X_1985_ net299 _1044_ vssd1 vssd1 vccd1 vccd1 _0373_ sky130_fd_sc_hd__xor2_1
XANTENNA_fanout108_A CALC_INST.gencon_inst.add_calc.state\[2\] vssd1 vssd1 vccd1 vccd1
+ sky130_fd_sc_hd__diode_2
X_2606_ clknet_leaf_9_clk _0144_ net129 vssd1 vssd1 vccd1 vccd1 CALC_INST.gencon_inst.add_calc.main.a0.in1
+ sky130_fd_sc_hd__dfrtp_1
X_2537_ clknet_leaf_18_clk _0075_ net149 vssd1 vssd1 vccd1 vccd1 net16 sky130_fd_sc_hd__dfrtp_1
X_1419_ net331 _0684_ net110 vssd1 vssd1 vccd1 vccd1 _0168_ sky130_fd_sc_hd__mux2_1
X_2468_ _1233_ _0392_ vssd1 vssd1 vccd1 vccd1 _0590_ sky130_fd_sc_hd__nor2_2
X_2399_ CALC_INST.gencon_inst.operand1\[2\] CALC_INST.gencon_inst.latched_keypad_input\[2\]
+ vssd1 vssd1 vccd1 vccd1 _0535_ sky130_fd_sc_hd__nand2_1
XTAP_TAPCELL_ROW_41_429 vssd1 vccd1 sky130_fd_sc_hd__tapvpwrvgnd_1
XFILLER_36_280 vssd1 vssd1 vccd1 vccd1 sky130_fd_sc_hd__fill_2
XFILLER_22_98 vssd1 vssd1 vccd1 vccd1 sky130_fd_sc_hd__fill_1
XFILLER_22_76 vssd1 vssd1 vccd1 vccd1 sky130_fd_sc_hd__fill_1
XFILLER_11_136 vssd1 vssd1 vccd1 vccd1 sky130_fd_sc_hd__fill_2
XFILLER_3_379 vccd1 vssd1 vccd1 vssd1 sky130_ef_sc_hd__decap_40_12
XFILLER_3_335 vssd1 vssd1 vccd1 vccd1 sky130_fd_sc_hd__fill_1
XTAP_TAPCELL_ROW_57_540 vssd1 vccd1 sky130_fd_sc_hd__tapvpwrvgnd_1
XTAP_TAPCELL_ROW_6_184 vssd1 vccd1 sky130_fd_sc_hd__tapvpwrvgnd_1
XFILLER_19_225 vssd1 vssd1 vccd1 vccd1 sky130_fd_sc_hd__fill_4
XFILLER_42_261 vssd1 vssd1 vccd1 vccd1 sky130_fd_sc_hd__fill_1
XFILLER_30_401 vssd1 vssd1 vccd1 vccd1 sky130_fd_sc_hd__fill_2
X_1770_ net82 _1123_ net86 net286 vssd1 vssd1 vccd1 vccd1 _0280_ sky130_fd_sc_hd__a2bb2o_1
XFILLER_8_23 vssd1 vssd1 vccd1 vccd1 sky130_fd_sc_hd__fill_4
XFILLER_6_195 vssd1 vssd1 vccd1 vccd1 sky130_fd_sc_hd__fill_1
X_2184_ _1068_ _1073_ CALC_INST.input_ctrl_inst.key_pressed CALC_INST.input_ctrl_inst.debounce_cnt\[14\]
+ vssd1 vssd1 vccd1 vccd1 _1214_ sky130_fd_sc_hd__and4b_1
X_2322_ _0404_ _0471_ _0472_ net44 CALC_INST.gencon_inst.mult_calc.out\[2\] vssd1
+ vssd1 vccd1 vccd1 _0473_ sky130_fd_sc_hd__a32o_1
XFILLER_33_3 vssd1 vssd1 vccd1 vccd1 sky130_fd_sc_hd__fill_8
X_2253_ CALC_INST.input_ctrl_inst.col_index\[1\] CALC_INST.input_ctrl_inst.col_index\[0\]
+ net89 net90 vssd1 vssd1 vccd1 vccd1 _0415_ sky130_fd_sc_hd__or4_2
XANTENNA__2386__A2 net58 vssd1 vssd1 vccd1 vccd1 sky130_fd_sc_hd__diode_2
X_1899_ CALC_INST.input_ctrl_inst.col_index\[30\] _0997_ _1000_ vssd1 vssd1 vccd1
+ vccd1 _1001_ sky130_fd_sc_hd__o21ba_1
X_1968_ CALC_INST.input_ctrl_inst.scan_timer\[7\] CALC_INST.input_ctrl_inst.scan_timer\[9\]
+ CALC_INST.input_ctrl_inst.scan_timer\[8\] _1032_ vssd1 vssd1 vccd1 vccd1 _1036_
+ sky130_fd_sc_hd__and4_1
XFILLER_0_349 vccd1 vssd1 vccd1 vssd1 sky130_ef_sc_hd__decap_40_12
XTAP_TAPCELL_ROW_54_521 vssd1 vccd1 sky130_fd_sc_hd__tapvpwrvgnd_1
XFILLER_58_83 vssd1 vssd1 vccd1 vccd1 sky130_fd_sc_hd__fill_1
Xhold5 CALC_INST.gencon_inst.mult_calc.INn1\[1\] vssd1 vssd1 vccd1 vccd1 net201 sky130_fd_sc_hd__dlygate4sd3_1
XTAP_TAPCELL_ROW_17_256 vssd1 vccd1 sky130_fd_sc_hd__tapvpwrvgnd_1
XTAP_TAPCELL_ROW_60_557 vssd1 vccd1 sky130_fd_sc_hd__tapvpwrvgnd_1
XFILLER_30_297 vssd1 vssd1 vccd1 vccd1 sky130_fd_sc_hd__fill_2
XFILLER_30_253 vssd1 vssd1 vccd1 vccd1 sky130_fd_sc_hd__fill_4
XPHY_EDGE_ROW_29_Left_94 vssd1 vssd1 vccd1 vccd1 sky130_fd_sc_hd__decap_3
X_1822_ net89 _0949_ CALC_INST.input_ctrl_inst.col_index\[4\] vssd1 vssd1 vccd1 vccd1
+ _0950_ sky130_fd_sc_hd__a21oi_1
X_1753_ CALC_INST.gencon_inst.mult_calc.out\[11\] net428 net102 vssd1 vssd1 vccd1
+ vccd1 _0264_ sky130_fd_sc_hd__mux2_1
X_2871_ clknet_leaf_3_clk _0366_ vssd1 vssd1 vccd1 vccd1 CALC_INST.input_ctrl_inst.scan_timer\[9\]
+ sky130_fd_sc_hd__dfxtp_1
XANTENNA__1328__A0 CALC_INST.gencon_inst.operand2\[9\] vssd1 vssd1 vccd1 vccd1 sky130_fd_sc_hd__diode_2
X_1684_ net100 _0912_ _0913_ net404 net86 vssd1 vssd1 vccd1 vccd1 _0204_ sky130_fd_sc_hd__a32o_1
X_2167_ CALC_INST.input_ctrl_inst.debounce_cnt\[10\] _1077_ _1197_ vssd1 vssd1 vccd1
+ vccd1 _1201_ sky130_fd_sc_hd__o21ai_1
X_2236_ _0397_ _0398_ vssd1 vssd1 vccd1 vccd1 _0402_ sky130_fd_sc_hd__nor2_1
X_2305_ CALC_INST.gencon_inst.operand2\[0\] CALC_INST.gencon_inst.latched_keypad_input\[0\]
+ _0405_ vssd1 vssd1 vccd1 vccd1 _0458_ sky130_fd_sc_hd__a21oi_1
XTAP_TAPCELL_ROW_0_135 vssd1 vccd1 sky130_fd_sc_hd__tapvpwrvgnd_1
XPHY_EDGE_ROW_13_Left_78 vssd1 vssd1 vccd1 vccd1 sky130_fd_sc_hd__decap_3
X_2098_ net301 net305 CALC_INST.gencon_inst.add_calc.state\[1\] vssd1 vssd1 vccd1
+ vccd1 _0005_ sky130_fd_sc_hd__a21o_1
XANTENNA__1264__C1 _0591_ vssd1 vssd1 vccd1 vccd1 sky130_fd_sc_hd__diode_2
XFILLER_48_139 vssd1 vssd1 vccd1 vccd1 sky130_fd_sc_hd__fill_1
XFILLER_63_109 vssd1 vssd1 vccd1 vccd1 sky130_fd_sc_hd__fill_2
XFILLER_44_41 vssd1 vssd1 vccd1 vccd1 sky130_fd_sc_hd__fill_1
XFILLER_29_375 vssd1 vssd1 vccd1 vccd1 sky130_fd_sc_hd__fill_1
XFILLER_44_85 vssd1 vssd1 vccd1 vccd1 sky130_fd_sc_hd__fill_1
XTAP_TAPCELL_ROW_22_292 vssd1 vccd1 sky130_fd_sc_hd__tapvpwrvgnd_1
XFILLER_12_242 vssd1 vssd1 vccd1 vccd1 sky130_fd_sc_hd__fill_1
XFILLER_12_297 vssd1 vssd1 vccd1 vccd1 sky130_fd_sc_hd__fill_1
XTAP_TAPCELL_ROW_14_237 vssd1 vccd1 sky130_fd_sc_hd__tapvpwrvgnd_1
XFILLER_5_13 vssd1 vssd1 vccd1 vccd1 sky130_fd_sc_hd__fill_1
X_2021_ net88 _1076_ vssd1 vssd1 vccd1 vccd1 _1077_ sky130_fd_sc_hd__nor2_1
XFILLER_35_301 vssd1 vssd1 vccd1 vccd1 sky130_fd_sc_hd__fill_1
XFILLER_62_153 vssd1 vssd1 vccd1 vccd1 sky130_fd_sc_hd__fill_2
X_2854_ clknet_leaf_7_clk _0014_ net126 vssd1 vssd1 vccd1 vccd1 CALC_INST.input_ctrl_inst.debounce_cnt\[15\]
+ sky130_fd_sc_hd__dfrtp_1
XANTENNA__1261__A2 _0591_ vssd1 vssd1 vccd1 vccd1 sky130_fd_sc_hd__diode_2
X_1736_ net94 net361 net78 net442 vssd1 vssd1 vccd1 vccd1 _0247_ sky130_fd_sc_hd__a22o_1
Xhold224 CALC_INST.gencon_inst.mult_calc.compCount.in2\[11\] vssd1 vssd1 vccd1 vccd1
+ net420 sky130_fd_sc_hd__dlygate4sd3_1
Xhold202 CALC_INST.gencon_inst.mult_calc.compCount.in2\[8\] vssd1 vssd1 vccd1 vccd1
+ net398 sky130_fd_sc_hd__dlygate4sd3_1
X_2785_ clknet_leaf_31_clk _0310_ net120 vssd1 vssd1 vccd1 vccd1 CALC_INST.input_ctrl_inst.col_index\[8\]
+ sky130_fd_sc_hd__dfrtp_1
Xhold213 CALC_INST.gencon_inst.mult_calc.main.GENERATE_ADDER\[4\].thingy.in2 vssd1
+ vssd1 vccd1 vccd1 net409 sky130_fd_sc_hd__dlygate4sd3_1
Xhold235 CALC_INST.gencon_inst.mult_calc.adderSave\[6\] vssd1 vssd1 vccd1 vccd1 net431
+ sky130_fd_sc_hd__dlygate4sd3_1
X_1805_ CALC_INST.input_ctrl_inst.scan_timer\[11\] CALC_INST.input_ctrl_inst.scan_timer\[10\]
+ CALC_INST.input_ctrl_inst.scan_timer\[13\] CALC_INST.input_ctrl_inst.scan_timer\[12\]
+ vssd1 vssd1 vccd1 vccd1 _0937_ sky130_fd_sc_hd__or4_1
Xhold268 CALC_INST.gencon_inst.ALU_out\[4\] vssd1 vssd1 vccd1 vccd1 net464 sky130_fd_sc_hd__dlygate4sd3_1
Xhold257 net30 vssd1 vssd1 vccd1 vccd1 net453 sky130_fd_sc_hd__dlygate4sd3_1
X_1598_ CALC_INST.gencon_inst.operand2\[15\] _0839_ _0841_ vssd1 vssd1 vccd1 vccd1
+ _0190_ sky130_fd_sc_hd__o21a_1
X_1667_ CALC_INST.gencon_inst.mult_calc.main.GENERATE_ADDER\[10\].thingy.in2 CALC_INST.gencon_inst.mult_calc.main.GENERATE_ADDER\[10\].thingy.in1
+ vssd1 vssd1 vccd1 vccd1 _0899_ sky130_fd_sc_hd__nand2_1
Xhold246 CALC_INST.gencon_inst.mult_calc.main.GENERATE_ADDER\[9\].thingy.in2 vssd1
+ vssd1 vccd1 vccd1 net442 sky130_fd_sc_hd__dlygate4sd3_1
Xhold279 CALC_INST.input_ctrl_inst.col_index\[13\] vssd1 vssd1 vccd1 vccd1 net475
+ sky130_fd_sc_hd__dlygate4sd3_1
X_2219_ CALC_INST.gencon_inst.mult_calc.finish _0384_ vssd1 vssd1 vccd1 vccd1 _0385_
+ sky130_fd_sc_hd__nor2_1
XFILLER_38_183 vssd1 vssd1 vccd1 vccd1 sky130_fd_sc_hd__fill_8
XFILLER_41_359 vssd1 vssd1 vccd1 vccd1 sky130_fd_sc_hd__fill_1
XANTENNA__1252__A2 _0392_ vssd1 vssd1 vccd1 vccd1 sky130_fd_sc_hd__diode_2
XTAP_TAPCELL_ROW_36_395 vssd1 vccd1 sky130_fd_sc_hd__tapvpwrvgnd_1
XTAP_TAPCELL_ROW_11_218 vssd1 vccd1 sky130_fd_sc_hd__tapvpwrvgnd_1
XFILLER_14_11 vssd1 vssd1 vccd1 vccd1 sky130_fd_sc_hd__fill_2
XFILLER_39_74 vssd1 vssd1 vccd1 vccd1 sky130_fd_sc_hd__fill_4
XFILLER_55_84 vssd1 vssd1 vccd1 vccd1 sky130_fd_sc_hd__fill_1
XFILLER_32_337 vssd1 vssd1 vccd1 vccd1 sky130_fd_sc_hd__fill_1
X_2570_ clknet_leaf_11_clk _0108_ vssd1 vssd1 vccd1 vccd1 CALC_INST.gencon_inst.ALU_in2\[2\]
+ sky130_fd_sc_hd__dfxtp_1
XFILLER_40_381 vssd1 vssd1 vccd1 vccd1 sky130_fd_sc_hd__fill_1
XANTENNA__1243__A2 net57 vssd1 vssd1 vccd1 vccd1 sky130_fd_sc_hd__diode_2
X_1383_ net378 _0666_ net109 vssd1 vssd1 vccd1 vccd1 _0150_ sky130_fd_sc_hd__mux2_1
X_1452_ net105 CALC_INST.gencon_inst.add_calc.main.in2\[9\] vssd1 vssd1 vccd1 vccd1
+ _0711_ sky130_fd_sc_hd__nand2_1
X_1521_ _0773_ _0775_ vssd1 vssd1 vccd1 vccd1 _0778_ sky130_fd_sc_hd__or2_1
X_2004_ net343 vssd1 vssd1 vccd1 vccd1 _1060_ sky130_fd_sc_hd__inv_2
XANTENNA__2470__B _0590_ vssd1 vssd1 vccd1 vccd1 sky130_fd_sc_hd__diode_2
X_2837_ clknet_leaf_6_clk CALC_INST.input_ctrl_inst.next_state\[2\] net124 vssd1 vssd1
+ vccd1 vccd1 CALC_INST.input_ctrl_inst.input_control_state\[2\] sky130_fd_sc_hd__dfrtp_1
X_2768_ clknet_leaf_22_clk _0297_ vssd1 vssd1 vccd1 vccd1 CALC_INST.gencon_inst.mult_calc.INn2\[11\]
+ sky130_fd_sc_hd__dfxtp_1
X_1719_ net222 net212 net98 vssd1 vssd1 vccd1 vccd1 _0231_ sky130_fd_sc_hd__mux2_1
X_2699_ clknet_leaf_31_clk _0237_ net121 vssd1 vssd1 vccd1 vccd1 CALC_INST.gencon_inst.mult_calc.finish
+ sky130_fd_sc_hd__dfrtp_4
XPHY_EDGE_ROW_16_Left_81 vssd1 vssd1 vccd1 vccd1 sky130_fd_sc_hd__decap_3
XFILLER_41_101 vssd1 vssd1 vccd1 vccd1 sky130_fd_sc_hd__fill_4
XTAP_TAPCELL_ROW_24_310 vssd1 vccd1 sky130_fd_sc_hd__tapvpwrvgnd_1
XFILLER_41_167 vssd1 vssd1 vccd1 vccd1 sky130_fd_sc_hd__fill_1
XFILLER_49_212 vssd1 vssd1 vccd1 vccd1 sky130_fd_sc_hd__fill_1
XFILLER_2_14 vssd1 vssd1 vccd1 vccd1 sky130_fd_sc_hd__fill_1
XTAP_TAPCELL_ROW_47_468 vssd1 vccd1 sky130_fd_sc_hd__tapvpwrvgnd_1
X_2622_ clknet_leaf_9_clk _0160_ net129 vssd1 vssd1 vccd1 vccd1 CALC_INST.gencon_inst.add_calc.main.in2\[1\]
+ sky130_fd_sc_hd__dfrtp_1
X_1504_ _0700_ _0704_ _0760_ _0701_ _0697_ vssd1 vssd1 vccd1 vccd1 _0763_ sky130_fd_sc_hd__o311a_1
X_2553_ clknet_leaf_11_clk _0091_ vssd1 vssd1 vccd1 vccd1 CALC_INST.gencon_inst.ALU_in1\[1\]
+ sky130_fd_sc_hd__dfxtp_1
XFILLER_9_385 vssd1 vssd1 vccd1 vccd1 sky130_fd_sc_hd__fill_1
XFILLER_55_215 vssd1 vssd1 vccd1 vccd1 sky130_fd_sc_hd__fill_1
X_1435_ net104 CALC_INST.gencon_inst.add_calc.main.in2\[13\] vssd1 vssd1 vccd1 vccd1
+ _0694_ sky130_fd_sc_hd__or2_1
X_1366_ net305 net384 _0656_ vssd1 vssd1 vccd1 vccd1 _0143_ sky130_fd_sc_hd__mux2_1
X_2484_ CALC_INST.gencon_inst.ALU_out\[3\] net68 net56 _0602_ vssd1 vssd1 vccd1 vccd1
+ _0603_ sky130_fd_sc_hd__a22o_1
XFILLER_63_281 vssd1 vssd1 vccd1 vccd1 sky130_fd_sc_hd__fill_2
X_1297_ net288 _0401_ _0400_ vssd1 vssd1 vccd1 vccd1 _0087_ sky130_fd_sc_hd__a21bo_1
XANTENNA_clkbuf_leaf_24_clk_A clknet_2_2__leaf_clk vssd1 vssd1 vccd1 vccd1 sky130_fd_sc_hd__diode_2
XANTENNA__1915__B1 net77 vssd1 vssd1 vccd1 vccd1 sky130_fd_sc_hd__diode_2
XANTENNA_fanout70_A net71 vssd1 vssd1 vccd1 vccd1 sky130_fd_sc_hd__diode_2
XFILLER_52_63 vssd1 vssd1 vccd1 vccd1 sky130_fd_sc_hd__fill_4
XFILLER_52_41 vssd1 vssd1 vccd1 vccd1 sky130_fd_sc_hd__fill_2
XTAP_TAPCELL_ROW_44_449 vssd1 vccd1 sky130_fd_sc_hd__tapvpwrvgnd_1
XPHY_EDGE_ROW_1_Left_66 vssd1 vssd1 vccd1 vccd1 sky130_fd_sc_hd__decap_3
XANTENNA__1906__B1 net75 vssd1 vssd1 vccd1 vccd1 sky130_fd_sc_hd__diode_2
XFILLER_6_377 vccd1 vssd1 vccd1 vssd1 sky130_ef_sc_hd__decap_40_12
XANTENNA__2331__A0 CALC_INST.gencon_inst.operand2\[3\] vssd1 vssd1 vccd1 vccd1 sky130_fd_sc_hd__diode_2
XFILLER_45_281 vssd1 vssd1 vccd1 vccd1 sky130_fd_sc_hd__fill_2
XFILLER_60_262 vssd1 vssd1 vccd1 vccd1 sky130_fd_sc_hd__fill_1
X_1984_ _1044_ _1045_ vssd1 vssd1 vccd1 vccd1 _0372_ sky130_fd_sc_hd__nor2_1
X_2605_ clknet_leaf_9_clk _0143_ net129 vssd1 vssd1 vccd1 vccd1 CALC_INST.gencon_inst.ALU_finish
+ sky130_fd_sc_hd__dfrtp_1
X_2467_ CALC_INST.gencon_inst.read_input _1084_ _1152_ _1063_ vssd1 vssd1 vccd1 vccd1
+ _0062_ sky130_fd_sc_hd__a22o_1
X_2536_ clknet_leaf_19_clk _0074_ net149 vssd1 vssd1 vccd1 vccd1 net15 sky130_fd_sc_hd__dfrtp_1
X_1418_ CALC_INST.gencon_inst.ALU_in1\[9\] CALC_INST.gencon_inst.ALU_in2\[9\] net67
+ vssd1 vssd1 vccd1 vccd1 _0684_ sky130_fd_sc_hd__mux2_1
X_2398_ CALC_INST.gencon_inst.operand1\[1\] _0534_ net42 vssd1 vssd1 vccd1 vccd1 _0048_
+ sky130_fd_sc_hd__mux2_1
X_1349_ _0605_ net208 net37 vssd1 vssd1 vccd1 vccd1 _0131_ sky130_fd_sc_hd__mux2_1
XANTENNA__2389__B1 net41 vssd1 vssd1 vccd1 vccd1 sky130_fd_sc_hd__diode_2
XANTENNA__1600__A2 net103 vssd1 vssd1 vccd1 vccd1 sky130_fd_sc_hd__diode_2
XFILLER_22_33 vssd1 vssd1 vccd1 vccd1 sky130_fd_sc_hd__fill_1
XFILLER_7_119 vssd1 vssd1 vccd1 vccd1 sky130_fd_sc_hd__fill_8
XANTENNA_fanout73_X net73 vssd1 vssd1 vccd1 vccd1 sky130_fd_sc_hd__diode_2
Xfanout150 net153 vssd1 vssd1 vccd1 vccd1 net150 sky130_fd_sc_hd__buf_2
XTAP_TAPCELL_ROW_6_185 vssd1 vccd1 sky130_fd_sc_hd__tapvpwrvgnd_1
XFILLER_59_384 vssd1 vssd1 vccd1 vccd1 sky130_fd_sc_hd__fill_4
XTAP_TAPCELL_ROW_57_541 vssd1 vccd1 sky130_fd_sc_hd__tapvpwrvgnd_1
XFILLER_47_52 vssd1 vssd1 vccd1 vccd1 sky130_fd_sc_hd__fill_4
XFILLER_42_251 vssd1 vssd1 vccd1 vccd1 sky130_fd_sc_hd__fill_1
X_2321_ _0468_ _0469_ _0461_ _0464_ vssd1 vssd1 vccd1 vccd1 _0472_ sky130_fd_sc_hd__a211o_1
X_2183_ _1051_ net36 _1208_ _1213_ vssd1 vssd1 vccd1 vccd1 _0012_ sky130_fd_sc_hd__a31o_1
X_2252_ CALC_INST.input_ctrl_inst.col_index\[1\] CALC_INST.input_ctrl_inst.col_index\[0\]
+ net89 net90 vssd1 vssd1 vccd1 vccd1 _0414_ sky130_fd_sc_hd__nor4_1
XFILLER_25_218 vssd1 vssd1 vccd1 vccd1 sky130_fd_sc_hd__fill_4
X_1898_ _0945_ _0999_ vssd1 vssd1 vccd1 vccd1 _1000_ sky130_fd_sc_hd__nand2b_1
XANTENNA_fanout120_A net123 vssd1 vssd1 vccd1 vccd1 sky130_fd_sc_hd__diode_2
X_1967_ _1025_ _1034_ _1035_ vssd1 vssd1 vccd1 vccd1 _0365_ sky130_fd_sc_hd__and3_1
X_2519_ clknet_leaf_20_clk _0061_ net148 vssd1 vssd1 vccd1 vccd1 CALC_INST.gencon_inst.operand1\[14\]
+ sky130_fd_sc_hd__dfrtp_2
XFILLER_17_55 vssd1 vssd1 vccd1 vccd1 sky130_fd_sc_hd__fill_1
XANTENNA__1282__B1 _0520_ vssd1 vssd1 vccd1 vccd1 sky130_fd_sc_hd__diode_2
XFILLER_33_76 vssd1 vssd1 vccd1 vccd1 sky130_fd_sc_hd__fill_2
XFILLER_3_133 vssd1 vssd1 vccd1 vccd1 sky130_fd_sc_hd__fill_8
Xhold6 _0223_ vssd1 vssd1 vccd1 vccd1 net202 sky130_fd_sc_hd__dlygate4sd3_1
XTAP_TAPCELL_ROW_17_257 vssd1 vccd1 sky130_fd_sc_hd__tapvpwrvgnd_1
X_2870_ clknet_leaf_31_clk _0365_ vssd1 vssd1 vccd1 vccd1 CALC_INST.input_ctrl_inst.scan_timer\[8\]
+ sky130_fd_sc_hd__dfxtp_1
XTAP_TAPCELL_ROW_60_558 vssd1 vccd1 sky130_fd_sc_hd__tapvpwrvgnd_1
Xclkbuf_leaf_10_clk clknet_2_1__leaf_clk vssd1 vssd1 vccd1 vccd1 clknet_leaf_10_clk
+ sky130_fd_sc_hd__clkbuf_8
X_1752_ CALC_INST.gencon_inst.mult_calc.out\[10\] net432 net102 vssd1 vssd1 vccd1
+ vccd1 _0263_ sky130_fd_sc_hd__mux2_1
X_1683_ _0909_ _0910_ _0911_ vssd1 vssd1 vccd1 vccd1 _0913_ sky130_fd_sc_hd__a21o_1
X_1821_ net89 _0949_ vssd1 vssd1 vccd1 vccd1 _0305_ sky130_fd_sc_hd__xor2_1
X_2304_ CALC_INST.gencon_inst.mult_calc.out\[0\] _1234_ _0405_ vssd1 vssd1 vccd1 vccd1
+ _0457_ sky130_fd_sc_hd__and3_1
X_2166_ _1199_ _1200_ net473 net46 vssd1 vssd1 vccd1 vccd1 _0026_ sky130_fd_sc_hd__a2bb2o_1
XFILLER_53_357 vssd1 vssd1 vccd1 vccd1 sky130_fd_sc_hd__fill_2
XFILLER_53_335 vssd1 vssd1 vccd1 vccd1 sky130_fd_sc_hd__fill_1
X_2235_ CALC_INST.gencon_inst.operator_input\[2\] _0396_ vssd1 vssd1 vccd1 vccd1 _0401_
+ sky130_fd_sc_hd__nand2_1
X_2097_ CALC_INST.gencon_inst.key_read net79 _1086_ net88 _1075_ vssd1 vssd1 vccd1
+ vccd1 CALC_INST.input_ctrl_inst.next_state\[2\] sky130_fd_sc_hd__a221o_1
XTAP_TAPCELL_ROW_0_136 vssd1 vccd1 sky130_fd_sc_hd__tapvpwrvgnd_1
XPHY_EDGE_ROW_3_Right_3 vssd1 vssd1 vccd1 vccd1 sky130_fd_sc_hd__decap_3
XANTENNA_fanout123_X net123 vssd1 vssd1 vccd1 vccd1 sky130_fd_sc_hd__diode_2
XFILLER_28_65 vssd1 vssd1 vccd1 vccd1 sky130_fd_sc_hd__fill_8
XFILLER_28_54 vssd1 vssd1 vccd1 vccd1 sky130_fd_sc_hd__fill_2
XANTENNA__1255__A0 CALC_INST.gencon_inst.operand2\[9\] vssd1 vssd1 vccd1 vccd1 sky130_fd_sc_hd__diode_2
XPHY_EDGE_ROW_30_Left_95 vssd1 vssd1 vccd1 vccd1 sky130_fd_sc_hd__decap_3
XTAP_TAPCELL_ROW_22_293 vssd1 vccd1 sky130_fd_sc_hd__tapvpwrvgnd_1
XFILLER_8_225 vssd1 vssd1 vccd1 vccd1 sky130_fd_sc_hd__fill_1
XFILLER_8_247 vssd1 vssd1 vccd1 vccd1 sky130_fd_sc_hd__fill_4
XTAP_TAPCELL_ROW_14_238 vssd1 vccd1 sky130_fd_sc_hd__tapvpwrvgnd_1
XFILLER_5_47 vssd1 vssd1 vccd1 vccd1 sky130_fd_sc_hd__fill_8
XFILLER_62_121 vccd1 vssd1 vccd1 vssd1 sky130_ef_sc_hd__decap_40_12
X_2020_ CALC_INST.input_ctrl_inst.input_control_state\[0\] CALC_INST.input_ctrl_inst.input_control_state\[1\]
+ vssd1 vssd1 vccd1 vccd1 _1076_ sky130_fd_sc_hd__nand2b_1
X_2853_ clknet_leaf_7_clk _0013_ net126 vssd1 vssd1 vccd1 vccd1 CALC_INST.input_ctrl_inst.debounce_cnt\[14\]
+ sky130_fd_sc_hd__dfrtp_2
XANTENNA__1246__B1 _0593_ vssd1 vssd1 vccd1 vccd1 sky130_fd_sc_hd__diode_2
Xhold269 CALC_INST.gencon_inst.ALU_out\[3\] vssd1 vssd1 vccd1 vccd1 net465 sky130_fd_sc_hd__dlygate4sd3_1
X_1666_ CALC_INST.gencon_inst.mult_calc.main.GENERATE_ADDER\[10\].thingy.in2 CALC_INST.gencon_inst.mult_calc.main.GENERATE_ADDER\[10\].thingy.in1
+ vssd1 vssd1 vccd1 vccd1 _0898_ sky130_fd_sc_hd__nor2_1
Xhold203 CALC_INST.gencon_inst.mult_calc.main.GENERATE_ADDER\[8\].thingy.in2 vssd1
+ vssd1 vccd1 vccd1 net399 sky130_fd_sc_hd__dlygate4sd3_1
Xhold236 CALC_INST.gencon_inst.mult_calc.adderSave\[10\] vssd1 vssd1 vccd1 vccd1 net432
+ sky130_fd_sc_hd__dlygate4sd3_1
X_1735_ net93 CALC_INST.gencon_inst.mult_calc.adderSave\[8\] net78 net399 vssd1 vssd1
+ vccd1 vccd1 _0246_ sky130_fd_sc_hd__a22o_1
Xhold247 CALC_INST.input_ctrl_inst.col_index\[12\] vssd1 vssd1 vccd1 vccd1 net443
+ sky130_fd_sc_hd__dlygate4sd3_1
Xhold225 CALC_INST.gencon_inst.mult_calc.compCount.in2\[2\] vssd1 vssd1 vccd1 vccd1
+ net421 sky130_fd_sc_hd__dlygate4sd3_1
X_2784_ clknet_leaf_33_clk _0309_ net120 vssd1 vssd1 vccd1 vccd1 CALC_INST.input_ctrl_inst.col_index\[7\]
+ sky130_fd_sc_hd__dfrtp_1
Xhold214 _0242_ vssd1 vssd1 vccd1 vccd1 net410 sky130_fd_sc_hd__dlygate4sd3_1
X_1804_ net63 vssd1 vssd1 vccd1 vccd1 _0936_ sky130_fd_sc_hd__inv_2
Xhold258 CALC_INST.input_ctrl_inst.scan_timer\[7\] vssd1 vssd1 vccd1 vccd1 net454
+ sky130_fd_sc_hd__dlygate4sd3_1
XANTENNA__2468__B _0392_ vssd1 vssd1 vccd1 vccd1 sky130_fd_sc_hd__diode_2
X_1597_ CALC_INST.gencon_inst.mult_calc.out\[15\] _0379_ _0404_ _0840_ _0382_ vssd1
+ vssd1 vccd1 vccd1 _0841_ sky130_fd_sc_hd__a221o_1
X_2149_ _1187_ vssd1 vssd1 vccd1 vccd1 _1188_ sky130_fd_sc_hd__inv_2
XANTENNA__1485__A0 net103 vssd1 vssd1 vccd1 vccd1 sky130_fd_sc_hd__diode_2
X_2218_ CALC_INST.gencon_inst.gencon_state\[3\] _0383_ vssd1 vssd1 vccd1 vccd1 _0384_
+ sky130_fd_sc_hd__or2_1
XFILLER_26_302 vssd1 vssd1 vccd1 vccd1 sky130_fd_sc_hd__fill_4
XTAP_TAPCELL_ROW_11_219 vssd1 vccd1 sky130_fd_sc_hd__tapvpwrvgnd_1
XFILLER_17_335 vssd1 vssd1 vccd1 vccd1 sky130_fd_sc_hd__fill_1
XTAP_TAPCELL_ROW_27_330 vssd1 vccd1 sky130_fd_sc_hd__tapvpwrvgnd_1
XANTENNA__1779__A1 CALC_INST.gencon_inst.operand2\[3\] vssd1 vssd1 vccd1 vccd1 sky130_fd_sc_hd__diode_2
X_1520_ _0777_ _0776_ net463 net81 vssd1 vssd1 vccd1 vccd1 _0176_ sky130_fd_sc_hd__a2bb2o_1
X_1451_ net105 CALC_INST.gencon_inst.add_calc.main.in2\[9\] vssd1 vssd1 vccd1 vccd1
+ _0710_ sky130_fd_sc_hd__or2_1
X_1382_ CALC_INST.gencon_inst.ALU_in2\[6\] CALC_INST.gencon_inst.ALU_in1\[6\] net65
+ vssd1 vssd1 vccd1 vccd1 _0666_ sky130_fd_sc_hd__mux2_1
X_2003_ CALC_INST.gencon_inst.mult_calc.finish vssd1 vssd1 vccd1 vccd1 _1059_ sky130_fd_sc_hd__inv_2
X_2836_ clknet_leaf_6_clk CALC_INST.input_ctrl_inst.next_state\[1\] net124 vssd1 vssd1
+ vccd1 vccd1 CALC_INST.input_ctrl_inst.input_control_state\[1\] sky130_fd_sc_hd__dfrtp_4
X_2767_ clknet_leaf_22_clk _0296_ vssd1 vssd1 vccd1 vccd1 CALC_INST.gencon_inst.mult_calc.INn2\[10\]
+ sky130_fd_sc_hd__dfxtp_1
X_1718_ net236 net226 net98 vssd1 vssd1 vccd1 vccd1 _0230_ sky130_fd_sc_hd__mux2_1
X_2698_ clknet_leaf_28_clk _0236_ net136 vssd1 vssd1 vccd1 vccd1 CALC_INST.gencon_inst.mult_calc.main.GENERATE_ADDER\[14\].thingy.in1
+ sky130_fd_sc_hd__dfrtp_1
X_1649_ _0875_ _0879_ _0876_ vssd1 vssd1 vccd1 vccd1 _0884_ sky130_fd_sc_hd__o21ai_1
XFILLER_58_257 vssd1 vssd1 vccd1 vccd1 sky130_fd_sc_hd__fill_4
XANTENNA_input5_A nrst vssd1 vssd1 vccd1 vccd1 sky130_fd_sc_hd__diode_2
XFILLER_41_124 vssd1 vssd1 vccd1 vccd1 sky130_fd_sc_hd__fill_1
XFILLER_26_165 vssd1 vssd1 vccd1 vccd1 sky130_fd_sc_hd__fill_4
XTAP_TAPCELL_ROW_24_311 vssd1 vccd1 sky130_fd_sc_hd__tapvpwrvgnd_1
XFILLER_41_43 vssd1 vssd1 vccd1 vccd1 sky130_fd_sc_hd__fill_1
XFILLER_64_227 vccd1 vssd1 vccd1 vssd1 sky130_ef_sc_hd__decap_40_12
XFILLER_64_205 vssd1 vssd1 vccd1 vccd1 sky130_fd_sc_hd__fill_1
XTAP_TAPCELL_ROW_47_469 vssd1 vccd1 sky130_fd_sc_hd__tapvpwrvgnd_1
XANTENNA__1468__A net106 vssd1 vssd1 vccd1 vccd1 sky130_fd_sc_hd__diode_2
XANTENNA__2413__A2 net71 vssd1 vssd1 vccd1 vccd1 sky130_fd_sc_hd__diode_2
XFILLER_32_168 vssd1 vssd1 vccd1 vccd1 sky130_fd_sc_hd__fill_2
XTAP_TAPCELL_ROW_30_347 vssd1 vccd1 sky130_fd_sc_hd__tapvpwrvgnd_1
XFILLER_9_320 vssd1 vssd1 vccd1 vccd1 sky130_fd_sc_hd__fill_2
XFILLER_9_331 vssd1 vssd1 vccd1 vccd1 sky130_fd_sc_hd__fill_4
X_2621_ clknet_leaf_9_clk _0159_ net129 vssd1 vssd1 vccd1 vccd1 CALC_INST.gencon_inst.add_calc.main.in2\[0\]
+ sky130_fd_sc_hd__dfrtp_1
X_1503_ _0700_ _0704_ _0760_ _0701_ vssd1 vssd1 vccd1 vccd1 _0762_ sky130_fd_sc_hd__o31a_1
X_2552_ clknet_leaf_11_clk _0090_ vssd1 vssd1 vccd1 vccd1 CALC_INST.gencon_inst.ALU_in1\[0\]
+ sky130_fd_sc_hd__dfxtp_1
X_2483_ CALC_INST.gencon_inst.operand2\[3\] CALC_INST.gencon_inst.operand1\[3\] net73
+ vssd1 vssd1 vccd1 vccd1 _0602_ sky130_fd_sc_hd__mux2_1
XANTENNA__2299__A net82 vssd1 vssd1 vccd1 vccd1 sky130_fd_sc_hd__diode_2
X_1434_ _0691_ _0692_ CALC_INST.gencon_inst.add_calc.main.GENERATE_ADDER\[14\].thingy.in1
+ vssd1 vssd1 vccd1 vccd1 _0693_ sky130_fd_sc_hd__a21oi_1
X_1365_ net107 CALC_INST.gencon_inst.add_calc.state\[1\] vssd1 vssd1 vccd1 vccd1 _0656_
+ sky130_fd_sc_hd__or2_1
X_1296_ net368 CALC_INST.gencon_inst.operator_input\[0\] _0402_ vssd1 vssd1 vccd1
+ vccd1 _0086_ sky130_fd_sc_hd__mux2_1
XTAP_TAPCELL_ROW_38_403 vssd1 vccd1 sky130_fd_sc_hd__tapvpwrvgnd_1
XFILLER_48_290 vssd1 vssd1 vccd1 vccd1 sky130_fd_sc_hd__fill_1
XANTENNA_fanout150_A net153 vssd1 vssd1 vccd1 vccd1 sky130_fd_sc_hd__diode_2
XFILLER_23_124 vssd1 vssd1 vccd1 vccd1 sky130_fd_sc_hd__fill_1
XFILLER_23_102 vssd1 vssd1 vccd1 vccd1 sky130_fd_sc_hd__fill_4
X_2819_ clknet_leaf_27_clk _0340_ net135 vssd1 vssd1 vccd1 vccd1 CALC_INST.gencon_inst.mult_calc.count.GENERATE_ADDER\[6\].thingy.in1
+ sky130_fd_sc_hd__dfrtp_1
XFILLER_11_13 vssd1 vssd1 vccd1 vccd1 sky130_fd_sc_hd__fill_1
XFILLER_11_57 vssd1 vssd1 vccd1 vccd1 sky130_fd_sc_hd__fill_1
XFILLER_14_124 vccd1 vssd1 vccd1 vssd1 sky130_ef_sc_hd__decap_40_12
XANTENNA__1906__A1 net91 vssd1 vssd1 vccd1 vccd1 sky130_fd_sc_hd__diode_2
XFILLER_6_389 vccd1 vssd1 vccd1 vssd1 sky130_ef_sc_hd__decap_40_12
XFILLER_10_363 vssd1 vssd1 vccd1 vccd1 sky130_fd_sc_hd__fill_1
XFILLER_37_227 vssd1 vssd1 vccd1 vccd1 sky130_fd_sc_hd__fill_8
XFILLER_52_208 vssd1 vssd1 vccd1 vccd1 sky130_fd_sc_hd__fill_2
X_2604_ clknet_leaf_3_clk _0142_ vssd1 vssd1 vccd1 vccd1 CALC_INST.gencon_inst.mult_calc.INn1\[15\]
+ sky130_fd_sc_hd__dfxtp_1
X_1983_ net444 _1042_ _1025_ vssd1 vssd1 vccd1 vccd1 _1045_ sky130_fd_sc_hd__o21ai_1
XFILLER_20_127 vccd1 vssd1 vccd1 vssd1 sky130_ef_sc_hd__decap_40_12
X_1417_ net334 _0683_ net110 vssd1 vssd1 vccd1 vccd1 _0167_ sky130_fd_sc_hd__mux2_1
X_2535_ clknet_leaf_18_clk _0073_ net150 vssd1 vssd1 vccd1 vccd1 net14 sky130_fd_sc_hd__dfrtp_1
X_2466_ CALC_INST.gencon_inst.operand1\[14\] net42 _0588_ _0589_ vssd1 vssd1 vccd1
+ vccd1 _0061_ sky130_fd_sc_hd__o22a_1
X_1279_ _1058_ net317 _0395_ _1233_ vssd1 vssd1 vccd1 vccd1 _0079_ sky130_fd_sc_hd__a31o_1
X_2397_ CALC_INST.gencon_inst.ALU_out\[1\] net68 net58 CALC_INST.gencon_inst.mult_calc.out\[1\]
+ _0533_ vssd1 vssd1 vccd1 vccd1 _0534_ sky130_fd_sc_hd__a221o_1
XANTENNA__2322__A1 _0404_ vssd1 vssd1 vccd1 vccd1 sky130_fd_sc_hd__diode_2
X_1348_ _0602_ net218 net40 vssd1 vssd1 vccd1 vccd1 _0130_ sky130_fd_sc_hd__mux2_1
XANTENNA_fanout153_X net153 vssd1 vssd1 vccd1 vccd1 sky130_fd_sc_hd__diode_2
XFILLER_11_116 vccd1 vssd1 vccd1 vssd1 sky130_ef_sc_hd__decap_40_12
Xfanout151 net153 vssd1 vssd1 vccd1 vccd1 net151 sky130_fd_sc_hd__clkbuf_4
XFILLER_47_31 vssd1 vssd1 vccd1 vccd1 sky130_fd_sc_hd__fill_1
Xfanout140 net141 vssd1 vssd1 vccd1 vccd1 net140 sky130_fd_sc_hd__clkbuf_4
XFILLER_63_85 vccd1 vssd1 vccd1 vssd1 sky130_ef_sc_hd__decap_40_12
XTAP_TAPCELL_ROW_57_542 vssd1 vccd1 sky130_fd_sc_hd__tapvpwrvgnd_1
XTAP_TAPCELL_ROW_40_420 vssd1 vccd1 sky130_fd_sc_hd__tapvpwrvgnd_1
X_2320_ _0470_ vssd1 vssd1 vccd1 vccd1 _0471_ sky130_fd_sc_hd__inv_2
XFILLER_6_197 vssd1 vssd1 vccd1 vccd1 sky130_fd_sc_hd__fill_1
X_2251_ _0409_ _0410_ _0411_ _0412_ vssd1 vssd1 vccd1 vccd1 _0413_ sky130_fd_sc_hd__or4_1
X_2182_ net45 _1212_ CALC_INST.input_ctrl_inst.debounce_cnt\[13\] vssd1 vssd1 vccd1
+ vccd1 _1213_ sky130_fd_sc_hd__o21a_1
XANTENNA_clkbuf_leaf_23_clk_A clknet_2_2__leaf_clk vssd1 vssd1 vccd1 vccd1 sky130_fd_sc_hd__diode_2
XFILLER_19_3 vssd1 vssd1 vccd1 vccd1 sky130_fd_sc_hd__fill_4
XTAP_TAPCELL_ROW_63_578 vssd1 vccd1 sky130_fd_sc_hd__tapvpwrvgnd_1
X_1966_ CALC_INST.input_ctrl_inst.scan_timer\[7\] CALC_INST.input_ctrl_inst.scan_timer\[8\]
+ _1032_ vssd1 vssd1 vccd1 vccd1 _1035_ sky130_fd_sc_hd__nand3_1
X_1897_ CALC_INST.input_ctrl_inst.col_index\[29\] CALC_INST.input_ctrl_inst.col_index\[28\]
+ CALC_INST.input_ctrl_inst.col_index\[30\] _0991_ vssd1 vssd1 vccd1 vccd1 _0999_
+ sky130_fd_sc_hd__nand4_1
X_2449_ CALC_INST.gencon_inst.operand1\[10\] CALC_INST.gencon_inst.operand1\[11\]
+ _0568_ vssd1 vssd1 vccd1 vccd1 _0576_ sky130_fd_sc_hd__and3_1
X_2518_ clknet_leaf_20_clk _0060_ net150 vssd1 vssd1 vccd1 vccd1 CALC_INST.gencon_inst.operand1\[13\]
+ sky130_fd_sc_hd__dfrtp_2
XFILLER_0_307 vssd1 vssd1 vccd1 vccd1 sky130_fd_sc_hd__fill_1
XFILLER_33_11 vssd1 vssd1 vccd1 vccd1 sky130_fd_sc_hd__fill_2
XFILLER_58_85 vccd1 vssd1 vccd1 vssd1 sky130_ef_sc_hd__decap_40_12
XFILLER_47_366 vssd1 vssd1 vccd1 vccd1 sky130_fd_sc_hd__fill_1
Xhold7 CALC_INST.input_ctrl_inst.scan_timer\[19\] vssd1 vssd1 vccd1 vccd1 net203 sky130_fd_sc_hd__dlygate4sd3_1
XFILLER_62_347 vssd1 vssd1 vccd1 vccd1 sky130_fd_sc_hd__fill_4
XTAP_TAPCELL_ROW_60_559 vssd1 vccd1 sky130_fd_sc_hd__tapvpwrvgnd_1
X_1820_ net90 _0948_ _0949_ vssd1 vssd1 vccd1 vccd1 _0304_ sky130_fd_sc_hd__o21ba_1
XTAP_TAPCELL_ROW_17_258 vssd1 vccd1 sky130_fd_sc_hd__tapvpwrvgnd_1
XANTENNA__1476__A net103 vssd1 vssd1 vccd1 vccd1 sky130_fd_sc_hd__diode_2
X_1751_ CALC_INST.gencon_inst.mult_calc.out\[9\] net361 net102 vssd1 vssd1 vccd1 vccd1
+ _0262_ sky130_fd_sc_hd__mux2_1
X_1682_ _0909_ _0910_ _0911_ vssd1 vssd1 vccd1 vccd1 _0912_ sky130_fd_sc_hd__nand3_1
XANTENNA__1415__S net109 vssd1 vssd1 vccd1 vccd1 sky130_fd_sc_hd__diode_2
X_2234_ CALC_INST.gencon_inst.operator_input\[1\] _0396_ vssd1 vssd1 vccd1 vccd1 _0400_
+ sky130_fd_sc_hd__nand2_1
X_2303_ _1233_ _0404_ vssd1 vssd1 vccd1 vccd1 _0456_ sky130_fd_sc_hd__nor2_1
X_2165_ CALC_INST.input_ctrl_inst.debounce_cnt\[9\] _1195_ _1198_ _1175_ vssd1 vssd1
+ vccd1 vccd1 _1200_ sky130_fd_sc_hd__a2bb2o_1
XFILLER_53_325 vssd1 vssd1 vccd1 vccd1 sky130_fd_sc_hd__fill_4
X_2096_ net88 CALC_INST.input_ctrl_inst.input_control_state\[1\] _1147_ vssd1 vssd1
+ vccd1 vccd1 CALC_INST.input_ctrl_inst.next_state\[1\] sky130_fd_sc_hd__a21oi_1
XFILLER_38_333 vssd1 vssd1 vccd1 vccd1 sky130_fd_sc_hd__fill_1
XTAP_TAPCELL_ROW_0_137 vssd1 vccd1 sky130_fd_sc_hd__tapvpwrvgnd_1
XFILLER_61_391 vssd1 vssd1 vccd1 vccd1 sky130_fd_sc_hd__fill_1
X_1949_ _1023_ _1024_ _1025_ vssd1 vssd1 vccd1 vccd1 _0357_ sky130_fd_sc_hd__and3b_1
XFILLER_21_277 vssd1 vssd1 vccd1 vccd1 sky130_fd_sc_hd__fill_2
XFILLER_21_222 vssd1 vssd1 vccd1 vccd1 sky130_fd_sc_hd__fill_2
XFILLER_48_108 vssd1 vssd1 vccd1 vccd1 sky130_fd_sc_hd__fill_1
XFILLER_29_333 vssd1 vssd1 vccd1 vccd1 sky130_fd_sc_hd__fill_2
XFILLER_56_185 vssd1 vssd1 vccd1 vccd1 sky130_fd_sc_hd__fill_2
XFILLER_44_65 vssd1 vssd1 vccd1 vccd1 sky130_fd_sc_hd__fill_2
XTAP_TAPCELL_ROW_14_239 vssd1 vccd1 sky130_fd_sc_hd__tapvpwrvgnd_1
XTAP_TAPCELL_ROW_22_294 vssd1 vccd1 sky130_fd_sc_hd__tapvpwrvgnd_1
XFILLER_8_215 vssd1 vssd1 vccd1 vccd1 sky130_fd_sc_hd__fill_4
XFILLER_8_237 vssd1 vssd1 vccd1 vccd1 sky130_fd_sc_hd__fill_1
XFILLER_12_266 vssd1 vssd1 vccd1 vccd1 sky130_fd_sc_hd__fill_1
XFILLER_62_155 vssd1 vssd1 vccd1 vccd1 sky130_fd_sc_hd__fill_1
XFILLER_62_133 vssd1 vssd1 vccd1 vccd1 sky130_fd_sc_hd__fill_4
XFILLER_50_306 vssd1 vssd1 vccd1 vccd1 sky130_fd_sc_hd__fill_2
XFILLER_47_185 vssd1 vssd1 vccd1 vccd1 sky130_fd_sc_hd__fill_2
XPHY_EDGE_ROW_13_Right_13 vssd1 vssd1 vccd1 vccd1 sky130_fd_sc_hd__decap_3
X_2852_ clknet_leaf_7_clk _0012_ net126 vssd1 vssd1 vccd1 vccd1 CALC_INST.input_ctrl_inst.debounce_cnt\[13\]
+ sky130_fd_sc_hd__dfrtp_1
XFILLER_43_391 vssd1 vssd1 vccd1 vccd1 sky130_fd_sc_hd__fill_1
XPHY_EDGE_ROW_22_Right_22 vssd1 vssd1 vccd1 vccd1 sky130_fd_sc_hd__decap_3
X_1803_ _1082_ _0932_ _0933_ _0934_ vssd1 vssd1 vccd1 vccd1 _0935_ sky130_fd_sc_hd__or4_1
X_2783_ clknet_leaf_1_clk _0308_ net117 vssd1 vssd1 vccd1 vccd1 CALC_INST.input_ctrl_inst.col_index\[6\]
+ sky130_fd_sc_hd__dfrtp_1
Xhold215 CALC_INST.gencon_inst.add_calc.main.GENERATE_ADDER\[8\].thingy.in1 vssd1
+ vssd1 vccd1 vccd1 net411 sky130_fd_sc_hd__dlygate4sd3_1
Xhold259 net19 vssd1 vssd1 vccd1 vccd1 net455 sky130_fd_sc_hd__dlygate4sd3_1
X_1596_ CALC_INST.gencon_inst.operand2\[15\] _0515_ vssd1 vssd1 vccd1 vccd1 _0840_
+ sky130_fd_sc_hd__xor2_1
X_1665_ net100 _0896_ _0897_ net361 net86 vssd1 vssd1 vccd1 vccd1 _0201_ sky130_fd_sc_hd__a32o_1
Xhold248 CALC_INST.input_ctrl_inst.scan_timer\[15\] vssd1 vssd1 vccd1 vccd1 net444
+ sky130_fd_sc_hd__dlygate4sd3_1
Xhold204 _0246_ vssd1 vssd1 vccd1 vccd1 net400 sky130_fd_sc_hd__dlygate4sd3_1
X_1734_ net93 net318 net77 net342 vssd1 vssd1 vccd1 vccd1 _0245_ sky130_fd_sc_hd__a22o_1
Xhold237 CALC_INST.gencon_inst.mult_calc.adderSave\[14\] vssd1 vssd1 vccd1 vccd1 net433
+ sky130_fd_sc_hd__dlygate4sd3_1
Xhold226 CALC_INST.gencon_inst.mult_calc.adderSave\[2\] vssd1 vssd1 vccd1 vccd1 net422
+ sky130_fd_sc_hd__dlygate4sd3_1
XFILLER_58_406 vssd1 vssd1 vccd1 vccd1 sky130_fd_sc_hd__fill_1
X_2217_ CALC_INST.gencon_inst.gencon_state\[0\] _1232_ vssd1 vssd1 vccd1 vccd1 _0383_
+ sky130_fd_sc_hd__nand2_1
XFILLER_38_130 vssd1 vssd1 vccd1 vccd1 sky130_fd_sc_hd__fill_1
XPHY_EDGE_ROW_31_Right_31 vssd1 vssd1 vccd1 vccd1 sky130_fd_sc_hd__decap_3
X_2148_ CALC_INST.input_ctrl_inst.debounce_cnt\[4\] CALC_INST.input_ctrl_inst.debounce_cnt\[5\]
+ _1181_ vssd1 vssd1 vccd1 vccd1 _1187_ sky130_fd_sc_hd__and3_1
XFILLER_53_199 vssd1 vssd1 vccd1 vccd1 sky130_fd_sc_hd__fill_2
XFILLER_41_306 vssd1 vssd1 vccd1 vccd1 sky130_fd_sc_hd__fill_1
XFILLER_38_174 vssd1 vssd1 vccd1 vccd1 sky130_fd_sc_hd__fill_1
XANTENNA__1788__A2 net48 vssd1 vssd1 vccd1 vccd1 sky130_fd_sc_hd__diode_2
XFILLER_26_347 vssd1 vssd1 vccd1 vccd1 sky130_fd_sc_hd__fill_8
XFILLER_26_325 vssd1 vssd1 vccd1 vccd1 sky130_fd_sc_hd__fill_4
X_2079_ CALC_INST.gencon_inst.mult_calc.compCount.in2\[11\] _1129_ _1130_ _1127_ _1132_
+ vssd1 vssd1 vccd1 vccd1 _1133_ sky130_fd_sc_hd__o221a_1
XFILLER_14_13 vssd1 vssd1 vccd1 vccd1 sky130_fd_sc_hd__fill_1
XANTENNA__2005__A CALC_INST.gencon_inst.add_calc.state\[1\] vssd1 vssd1 vccd1 vccd1
+ sky130_fd_sc_hd__diode_2
XPHY_EDGE_ROW_40_Right_40 vssd1 vssd1 vccd1 vccd1 sky130_fd_sc_hd__decap_3
XFILLER_49_406 vssd1 vssd1 vccd1 vccd1 sky130_fd_sc_hd__fill_1
XFILLER_39_65 vssd1 vssd1 vccd1 vccd1 sky130_fd_sc_hd__fill_1
XANTENNA_fanout93_A net94 vssd1 vssd1 vccd1 vccd1 sky130_fd_sc_hd__diode_2
XTAP_TAPCELL_ROW_27_331 vssd1 vccd1 sky130_fd_sc_hd__tapvpwrvgnd_1
XFILLER_40_361 vssd1 vssd1 vccd1 vccd1 sky130_fd_sc_hd__fill_2
XFILLER_40_372 vssd1 vssd1 vccd1 vccd1 sky130_fd_sc_hd__fill_1
X_1450_ CALC_INST.gencon_inst.add_calc.main.GENERATE_ADDER\[10\].thingy.in1 _0706_
+ _0707_ vssd1 vssd1 vccd1 vccd1 _0709_ sky130_fd_sc_hd__nand3_1
X_1381_ net364 _0665_ net108 vssd1 vssd1 vccd1 vccd1 _0149_ sky130_fd_sc_hd__mux2_1
X_2002_ CALC_INST.gencon_inst.gencon_state\[3\] vssd1 vssd1 vccd1 vccd1 _1058_ sky130_fd_sc_hd__inv_2
X_2835_ clknet_leaf_6_clk CALC_INST.input_ctrl_inst.next_state\[0\] net125 vssd1 vssd1
+ vccd1 vccd1 CALC_INST.input_ctrl_inst.input_control_state\[0\] sky130_fd_sc_hd__dfrtp_4
XANTENNA_clkbuf_0_clk_X clknet_0_clk vssd1 vssd1 vccd1 vccd1 sky130_fd_sc_hd__diode_2
X_2766_ clknet_leaf_21_clk _0295_ vssd1 vssd1 vccd1 vccd1 CALC_INST.gencon_inst.mult_calc.INn2\[9\]
+ sky130_fd_sc_hd__dfxtp_1
X_1579_ _0824_ _0826_ vssd1 vssd1 vccd1 vccd1 _0827_ sky130_fd_sc_hd__xnor2_1
X_1717_ net220 net207 net97 vssd1 vssd1 vccd1 vccd1 _0229_ sky130_fd_sc_hd__mux2_1
X_1648_ CALC_INST.gencon_inst.mult_calc.main.GENERATE_ADDER\[7\].thingy.in2 CALC_INST.gencon_inst.mult_calc.main.GENERATE_ADDER\[7\].thingy.in1
+ vssd1 vssd1 vccd1 vccd1 _0883_ sky130_fd_sc_hd__nand2_1
X_2697_ clknet_leaf_24_clk net239 net142 vssd1 vssd1 vccd1 vccd1 CALC_INST.gencon_inst.mult_calc.main.GENERATE_ADDER\[13\].thingy.in1
+ sky130_fd_sc_hd__dfrtp_1
XFILLER_26_155 vssd1 vssd1 vccd1 vccd1 sky130_fd_sc_hd__fill_1
XFILLER_25_78 vssd1 vssd1 vccd1 vccd1 sky130_fd_sc_hd__fill_1
XFILLER_14_317 vssd1 vssd1 vccd1 vccd1 sky130_fd_sc_hd__fill_4
XFILLER_41_55 vssd1 vssd1 vccd1 vccd1 sky130_fd_sc_hd__fill_1
XFILLER_49_247 vssd1 vssd1 vccd1 vccd1 sky130_fd_sc_hd__fill_1
XFILLER_49_225 vssd1 vssd1 vccd1 vccd1 sky130_fd_sc_hd__fill_4
XANTENNA_fanout96_X net96 vssd1 vssd1 vccd1 vccd1 sky130_fd_sc_hd__diode_2
XFILLER_64_239 vccd1 vssd1 vccd1 vssd1 sky130_ef_sc_hd__decap_40_12
XFILLER_64_217 vssd1 vssd1 vccd1 vccd1 sky130_fd_sc_hd__fill_2
XFILLER_17_177 vssd1 vssd1 vccd1 vccd1 sky130_fd_sc_hd__fill_1
X_2620_ clknet_leaf_13_clk _0158_ net146 vssd1 vssd1 vccd1 vccd1 CALC_INST.gencon_inst.add_calc.main.GENERATE_ADDER\[14\].thingy.in1
+ sky130_fd_sc_hd__dfrtp_1
XTAP_TAPCELL_ROW_30_348 vssd1 vccd1 sky130_fd_sc_hd__tapvpwrvgnd_1
X_1502_ _0704_ _0760_ vssd1 vssd1 vccd1 vccd1 _0761_ sky130_fd_sc_hd__nor2_1
X_1433_ net103 CALC_INST.gencon_inst.add_calc.main.in2\[14\] vssd1 vssd1 vccd1 vccd1
+ _0692_ sky130_fd_sc_hd__nand2_1
XFILLER_49_3 vccd1 vssd1 vccd1 vssd1 sky130_ef_sc_hd__decap_40_12
X_2482_ _0600_ _0601_ vssd1 vssd1 vccd1 vccd1 _0065_ sky130_fd_sc_hd__or2_1
X_2551_ clknet_leaf_5_clk _0089_ vssd1 vssd1 vccd1 vccd1 CALC_INST.gencon_inst.prev_read_input
+ sky130_fd_sc_hd__dfxtp_1
XFILLER_55_239 vssd1 vssd1 vccd1 vccd1 sky130_fd_sc_hd__fill_1
XTAP_TAPCELL_ROW_38_404 vssd1 vccd1 sky130_fd_sc_hd__tapvpwrvgnd_1
X_1295_ net216 CALC_INST.gencon_inst.latched_keypad_input\[3\] _0642_ vssd1 vssd1
+ vccd1 vccd1 _0085_ sky130_fd_sc_hd__mux2_1
X_1364_ _0633_ net275 net37 vssd1 vssd1 vccd1 vccd1 _0142_ sky130_fd_sc_hd__mux2_1
XFILLER_23_147 vssd1 vssd1 vccd1 vccd1 sky130_fd_sc_hd__fill_1
X_2818_ clknet_leaf_27_clk net283 net133 vssd1 vssd1 vccd1 vccd1 CALC_INST.gencon_inst.mult_calc.count.GENERATE_ADDER\[5\].thingy.in1
+ sky130_fd_sc_hd__dfrtp_1
X_2749_ clknet_leaf_28_clk _0006_ net134 vssd1 vssd1 vccd1 vccd1 CALC_INST.gencon_inst.mult_calc.next_finish
+ sky130_fd_sc_hd__dfrtp_1
XFILLER_61_209 vssd1 vssd1 vccd1 vccd1 sky130_fd_sc_hd__fill_2
XFILLER_54_250 vssd1 vssd1 vccd1 vccd1 sky130_fd_sc_hd__fill_2
XFILLER_46_217 vssd1 vssd1 vccd1 vccd1 sky130_fd_sc_hd__fill_2
XANTENNA_fanout56_A _0593_ vssd1 vssd1 vccd1 vccd1 sky130_fd_sc_hd__diode_2
XFILLER_14_136 vssd1 vssd1 vccd1 vccd1 sky130_fd_sc_hd__fill_4
XFILLER_6_335 vssd1 vssd1 vccd1 vccd1 sky130_fd_sc_hd__fill_1
XFILLER_10_320 vssd1 vssd1 vccd1 vccd1 sky130_fd_sc_hd__fill_1
XANTENNA__1479__A net103 vssd1 vssd1 vccd1 vccd1 sky130_fd_sc_hd__diode_2
XFILLER_45_283 vssd1 vssd1 vccd1 vccd1 sky130_fd_sc_hd__fill_1
XTAP_TAPCELL_ROW_43_440 vssd1 vccd1 sky130_fd_sc_hd__tapvpwrvgnd_1
X_1982_ CALC_INST.input_ctrl_inst.scan_timer\[15\] _1042_ vssd1 vssd1 vccd1 vccd1
+ _1044_ sky130_fd_sc_hd__and2_1
XFILLER_20_139 vssd1 vssd1 vccd1 vccd1 sky130_fd_sc_hd__fill_1
X_2534_ clknet_leaf_19_clk _0072_ net149 vssd1 vssd1 vccd1 vccd1 net13 sky130_fd_sc_hd__dfrtp_1
X_2603_ clknet_leaf_21_clk _0141_ vssd1 vssd1 vccd1 vccd1 CALC_INST.gencon_inst.mult_calc.INn1\[14\]
+ sky130_fd_sc_hd__dfxtp_1
X_1416_ CALC_INST.gencon_inst.ALU_in1\[8\] CALC_INST.gencon_inst.ALU_in2\[8\] net67
+ vssd1 vssd1 vccd1 vccd1 _0683_ sky130_fd_sc_hd__mux2_1
X_2396_ _0531_ _0532_ vssd1 vssd1 vccd1 vccd1 _0533_ sky130_fd_sc_hd__nor2_1
X_2465_ CALC_INST.gencon_inst.ALU_out\[14\] net70 net58 CALC_INST.gencon_inst.mult_calc.out\[14\]
+ _0524_ vssd1 vssd1 vccd1 vccd1 _0589_ sky130_fd_sc_hd__a221o_1
X_1347_ _0599_ net214 net37 vssd1 vssd1 vccd1 vccd1 _0129_ sky130_fd_sc_hd__mux2_1
XFILLER_3_70 vssd1 vssd1 vccd1 vccd1 sky130_fd_sc_hd__fill_4
XFILLER_43_209 vssd1 vssd1 vccd1 vccd1 sky130_fd_sc_hd__fill_1
XFILLER_36_294 vssd1 vssd1 vccd1 vccd1 sky130_fd_sc_hd__fill_1
X_1278_ net455 net57 net56 _0633_ _0632_ vssd1 vssd1 vccd1 vccd1 _0078_ sky130_fd_sc_hd__a221o_1
XANTENNA__1597__B1 _0404_ vssd1 vssd1 vccd1 vccd1 sky130_fd_sc_hd__diode_2
XFILLER_22_24 vssd1 vssd1 vccd1 vccd1 sky130_fd_sc_hd__fill_4
XFILLER_11_128 vssd1 vssd1 vccd1 vccd1 sky130_fd_sc_hd__fill_4
XFILLER_0_6 vccd1 vssd1 vccd1 vssd1 sky130_ef_sc_hd__decap_40_12
XFILLER_59_353 vssd1 vssd1 vccd1 vccd1 sky130_fd_sc_hd__fill_2
Xfanout130 net131 vssd1 vssd1 vccd1 vccd1 net130 sky130_fd_sc_hd__clkbuf_2
Xfanout152 net153 vssd1 vssd1 vccd1 vccd1 net152 sky130_fd_sc_hd__clkbuf_2
Xfanout141 net144 vssd1 vssd1 vccd1 vccd1 net141 sky130_fd_sc_hd__clkbuf_4
XFILLER_19_239 vssd1 vssd1 vccd1 vccd1 sky130_fd_sc_hd__fill_2
XFILLER_63_97 vccd1 vssd1 vccd1 vssd1 sky130_ef_sc_hd__decap_40_12
XFILLER_63_53 vssd1 vssd1 vccd1 vccd1 sky130_fd_sc_hd__fill_2
XFILLER_8_15 vssd1 vssd1 vccd1 vccd1 sky130_fd_sc_hd__fill_2
XTAP_TAPCELL_ROW_40_421 vssd1 vccd1 sky130_fd_sc_hd__tapvpwrvgnd_1
X_2250_ CALC_INST.input_ctrl_inst.col_index\[19\] CALC_INST.input_ctrl_inst.col_index\[18\]
+ vssd1 vssd1 vccd1 vccd1 _0412_ sky130_fd_sc_hd__or2_1
X_2181_ _1208_ _1211_ vssd1 vssd1 vccd1 vccd1 _1212_ sky130_fd_sc_hd__nor2_1
XANTENNA__1701__S net96 vssd1 vssd1 vccd1 vccd1 sky130_fd_sc_hd__diode_2
XFILLER_18_250 vssd1 vssd1 vccd1 vccd1 sky130_fd_sc_hd__fill_2
XTAP_TAPCELL_ROW_63_579 vssd1 vccd1 sky130_fd_sc_hd__tapvpwrvgnd_1
X_1965_ CALC_INST.input_ctrl_inst.scan_timer\[7\] _1032_ CALC_INST.input_ctrl_inst.scan_timer\[8\]
+ vssd1 vssd1 vccd1 vccd1 _1034_ sky130_fd_sc_hd__a21o_1
X_2517_ clknet_leaf_19_clk _0059_ net150 vssd1 vssd1 vccd1 vccd1 CALC_INST.gencon_inst.operand1\[12\]
+ sky130_fd_sc_hd__dfrtp_2
X_1896_ CALC_INST.input_ctrl_inst.col_index\[29\] net62 _0998_ vssd1 vssd1 vccd1 vccd1
+ _0331_ sky130_fd_sc_hd__a21bo_1
X_2448_ CALC_INST.gencon_inst.operand1\[10\] _0568_ CALC_INST.gencon_inst.operand1\[11\]
+ vssd1 vssd1 vccd1 vccd1 _0575_ sky130_fd_sc_hd__a21o_1
X_2379_ _0405_ _0515_ _0516_ net34 vssd1 vssd1 vccd1 vccd1 _0518_ sky130_fd_sc_hd__o31a_1
XANTENNA__2008__A net103 vssd1 vssd1 vccd1 vccd1 sky130_fd_sc_hd__diode_2
XFILLER_17_57 vssd1 vssd1 vccd1 vccd1 sky130_fd_sc_hd__fill_4
XFILLER_58_42 vssd1 vssd1 vccd1 vccd1 sky130_fd_sc_hd__fill_2
XFILLER_58_97 vccd1 vssd1 vccd1 vssd1 sky130_ef_sc_hd__decap_40_12
Xhold8 _0376_ vssd1 vssd1 vccd1 vccd1 net204 sky130_fd_sc_hd__dlygate4sd3_1
X_1750_ CALC_INST.gencon_inst.mult_calc.out\[8\] net403 net102 vssd1 vssd1 vccd1 vccd1
+ _0261_ sky130_fd_sc_hd__mux2_1
XTAP_TAPCELL_ROW_17_259 vssd1 vccd1 sky130_fd_sc_hd__tapvpwrvgnd_1
X_1681_ _0904_ _0907_ _0905_ vssd1 vssd1 vccd1 vccd1 _0911_ sky130_fd_sc_hd__o21ai_1
X_2164_ CALC_INST.input_ctrl_inst.debounce_cnt\[9\] _1195_ vssd1 vssd1 vccd1 vccd1
+ _1199_ sky130_fd_sc_hd__and2_1
X_2233_ _0392_ _0394_ _0396_ CALC_INST.gencon_inst.read_input vssd1 vssd1 vccd1 vccd1
+ _0399_ sky130_fd_sc_hd__a22o_1
XFILLER_31_3 vssd1 vssd1 vccd1 vccd1 sky130_fd_sc_hd__fill_4
X_2302_ net101 net446 net430 vssd1 vssd1 vccd1 vccd1 _0002_ sky130_fd_sc_hd__o21ba_1
XANTENNA__1431__S CALC_INST.gencon_inst.add_calc.state\[1\] vssd1 vssd1 vccd1 vccd1
+ sky130_fd_sc_hd__diode_2
XFILLER_53_359 vssd1 vssd1 vccd1 vccd1 sky130_fd_sc_hd__fill_1
X_2095_ CALC_INST.gencon_inst.key_read _1084_ _1146_ _1076_ vssd1 vssd1 vccd1 vccd1
+ _1147_ sky130_fd_sc_hd__o211a_1
XTAP_TAPCELL_ROW_0_138 vssd1 vccd1 sky130_fd_sc_hd__tapvpwrvgnd_1
X_1948_ net111 net63 vssd1 vssd1 vccd1 vccd1 _1025_ sky130_fd_sc_hd__or2_1
X_1879_ CALC_INST.input_ctrl_inst.col_index\[25\] _0984_ vssd1 vssd1 vccd1 vccd1 _0986_
+ sky130_fd_sc_hd__nor2_1
XANTENNA_fanout109_X net109 vssd1 vssd1 vccd1 vccd1 sky130_fd_sc_hd__diode_2
XFILLER_0_138 vssd1 vssd1 vccd1 vccd1 sky130_fd_sc_hd__fill_2
XANTENNA_clkbuf_leaf_22_clk_A clknet_2_2__leaf_clk vssd1 vssd1 vccd1 vccd1 sky130_fd_sc_hd__diode_2
XFILLER_12_212 vssd1 vssd1 vccd1 vccd1 sky130_fd_sc_hd__fill_1
XFILLER_60_98 vccd1 vssd1 vccd1 vssd1 sky130_ef_sc_hd__decap_40_12
XFILLER_60_43 vssd1 vssd1 vccd1 vccd1 sky130_fd_sc_hd__fill_4
XTAP_TAPCELL_ROW_22_295 vssd1 vccd1 sky130_fd_sc_hd__tapvpwrvgnd_1
Xclkbuf_2_3__f_clk clknet_0_clk vssd1 vssd1 vccd1 vccd1 clknet_2_3__leaf_clk sky130_fd_sc_hd__clkbuf_16
XANTENNA__1246__A2 net57 vssd1 vssd1 vccd1 vccd1 sky130_fd_sc_hd__diode_2
XFILLER_35_337 vssd1 vssd1 vccd1 vccd1 sky130_fd_sc_hd__fill_2
XFILLER_35_304 vccd1 vssd1 vccd1 vssd1 sky130_ef_sc_hd__decap_40_12
X_2851_ clknet_leaf_8_clk _0011_ net126 vssd1 vssd1 vccd1 vccd1 CALC_INST.input_ctrl_inst.debounce_cnt\[12\]
+ sky130_fd_sc_hd__dfrtp_1
X_1733_ net91 CALC_INST.gencon_inst.mult_calc.adderSave\[6\] net76 net389 vssd1 vssd1
+ vccd1 vccd1 _0244_ sky130_fd_sc_hd__a22o_1
X_2782_ clknet_leaf_31_clk _0307_ net117 vssd1 vssd1 vccd1 vccd1 CALC_INST.input_ctrl_inst.col_index\[5\]
+ sky130_fd_sc_hd__dfrtp_1
X_1802_ CALC_INST.input_ctrl_inst.scan_timer\[11\] _0924_ CALC_INST.input_ctrl_inst.scan_timer\[8\]
+ vssd1 vssd1 vccd1 vccd1 _0934_ sky130_fd_sc_hd__or3b_1
Xhold249 CALC_INST.gencon_inst.add_calc.main.a0.in1 vssd1 vssd1 vccd1 vccd1 net445
+ sky130_fd_sc_hd__dlygate4sd3_1
Xhold227 net16 vssd1 vssd1 vccd1 vccd1 net423 sky130_fd_sc_hd__dlygate4sd3_1
X_1595_ _0378_ net72 _0838_ _0380_ vssd1 vssd1 vccd1 vccd1 _0839_ sky130_fd_sc_hd__a211oi_1
X_1664_ _0893_ _0894_ _0895_ vssd1 vssd1 vccd1 vccd1 _0897_ sky130_fd_sc_hd__a21o_1
Xhold205 CALC_INST.gencon_inst.mult_calc.main.GENERATE_ADDER\[10\].thingy.in2 vssd1
+ vssd1 vccd1 vccd1 net401 sky130_fd_sc_hd__dlygate4sd3_1
XFILLER_7_293 vssd1 vssd1 vccd1 vccd1 sky130_fd_sc_hd__fill_1
Xhold216 CALC_INST.gencon_inst.mult_calc.compCount.in2\[14\] vssd1 vssd1 vccd1 vccd1
+ net412 sky130_fd_sc_hd__dlygate4sd3_1
Xhold238 CALC_INST.gencon_inst.mult_calc.compCount.in2\[7\] vssd1 vssd1 vccd1 vccd1
+ net434 sky130_fd_sc_hd__dlygate4sd3_1
X_2147_ CALC_INST.input_ctrl_inst.debounce_cnt\[4\] _1181_ CALC_INST.input_ctrl_inst.debounce_cnt\[5\]
+ vssd1 vssd1 vccd1 vccd1 _1186_ sky130_fd_sc_hd__a21o_1
X_2216_ _0378_ _0380_ vssd1 vssd1 vccd1 vccd1 _0382_ sky130_fd_sc_hd__or2_2
XFILLER_53_189 vssd1 vssd1 vccd1 vccd1 sky130_fd_sc_hd__fill_1
XFILLER_41_329 vssd1 vssd1 vccd1 vccd1 sky130_fd_sc_hd__fill_1
X_2078_ CALC_INST.gencon_inst.mult_calc.compCount.in2\[12\] _1131_ vssd1 vssd1 vccd1
+ vccd1 _1132_ sky130_fd_sc_hd__or2_1
XFILLER_30_46 vssd1 vssd1 vccd1 vccd1 sky130_fd_sc_hd__fill_4
XFILLER_39_11 vssd1 vssd1 vccd1 vccd1 sky130_fd_sc_hd__fill_1
XANTENNA_fanout86_A _0843_ vssd1 vssd1 vccd1 vccd1 sky130_fd_sc_hd__diode_2
XFILLER_44_112 vssd1 vssd1 vccd1 vccd1 sky130_fd_sc_hd__fill_8
XANTENNA_fanout41_X net41 vssd1 vssd1 vccd1 vccd1 sky130_fd_sc_hd__diode_2
XTAP_TAPCELL_ROW_27_332 vssd1 vccd1 sky130_fd_sc_hd__tapvpwrvgnd_1
XTAP_TAPCELL_ROW_10_210 vssd1 vccd1 sky130_fd_sc_hd__tapvpwrvgnd_1
X_1380_ CALC_INST.gencon_inst.ALU_in2\[5\] CALC_INST.gencon_inst.ALU_in1\[5\] net65
+ vssd1 vssd1 vccd1 vccd1 _0665_ sky130_fd_sc_hd__mux2_1
X_2001_ net121 vssd1 vssd1 vccd1 vccd1 _1057_ sky130_fd_sc_hd__inv_2
XANTENNA__2416__A1 _0520_ vssd1 vssd1 vccd1 vccd1 sky130_fd_sc_hd__diode_2
XFILLER_35_189 vssd1 vssd1 vccd1 vccd1 sky130_fd_sc_hd__fill_2
XFILLER_35_167 vssd1 vssd1 vccd1 vccd1 sky130_fd_sc_hd__fill_1
XTAP_TAPCELL_ROW_33_368 vssd1 vccd1 sky130_fd_sc_hd__tapvpwrvgnd_1
X_2834_ clknet_leaf_5_clk _0355_ vssd1 vssd1 vccd1 vccd1 CALC_INST.gencon_inst.operator_input\[2\]
+ sky130_fd_sc_hd__dfxtp_1
X_1716_ net219 net209 net97 vssd1 vssd1 vccd1 vccd1 _0228_ sky130_fd_sc_hd__mux2_1
X_2765_ clknet_leaf_21_clk _0294_ vssd1 vssd1 vccd1 vccd1 CALC_INST.gencon_inst.mult_calc.INn2\[8\]
+ sky130_fd_sc_hd__dfxtp_1
X_2696_ clknet_leaf_24_clk _0234_ net141 vssd1 vssd1 vccd1 vccd1 CALC_INST.gencon_inst.mult_calc.main.GENERATE_ADDER\[12\].thingy.in1
+ sky130_fd_sc_hd__dfrtp_1
X_1578_ _0761_ _0825_ vssd1 vssd1 vccd1 vccd1 _0826_ sky130_fd_sc_hd__xnor2_1
XANTENNA__2352__B1 _0404_ vssd1 vssd1 vccd1 vccd1 sky130_fd_sc_hd__diode_2
X_1647_ _0881_ vssd1 vssd1 vccd1 vccd1 _0882_ sky130_fd_sc_hd__inv_2
XFILLER_41_23 vccd1 vssd1 vccd1 vssd1 sky130_ef_sc_hd__decap_40_12
XFILLER_41_12 vssd1 vssd1 vccd1 vccd1 sky130_fd_sc_hd__fill_2
XFILLER_22_373 vssd1 vssd1 vccd1 vccd1 sky130_fd_sc_hd__fill_1
XANTENNA__1630__A2 net84 vssd1 vssd1 vccd1 vccd1 sky130_fd_sc_hd__diode_2
XFILLER_17_167 vssd1 vssd1 vccd1 vccd1 sky130_fd_sc_hd__fill_1
X_2550_ clknet_leaf_7_clk _0088_ net125 vssd1 vssd1 vccd1 vccd1 CALC_INST.gencon_inst.latched_operator_input\[2\]
+ sky130_fd_sc_hd__dfrtp_1
XTAP_TAPCELL_ROW_30_349 vssd1 vccd1 sky130_fd_sc_hd__tapvpwrvgnd_1
XANTENNA__1909__B1 net75 vssd1 vssd1 vccd1 vccd1 sky130_fd_sc_hd__diode_2
X_1501_ _0708_ _0712_ _0757_ _0709_ _0705_ vssd1 vssd1 vccd1 vccd1 _0760_ sky130_fd_sc_hd__o311a_1
X_1432_ net103 CALC_INST.gencon_inst.add_calc.main.in2\[14\] vssd1 vssd1 vccd1 vccd1
+ _0691_ sky130_fd_sc_hd__or2_1
X_2481_ net6 net57 net54 CALC_INST.gencon_inst.mult_calc.out\[2\] vssd1 vssd1 vccd1
+ vccd1 _0601_ sky130_fd_sc_hd__a22o_1
X_1363_ _0655_ net233 net38 vssd1 vssd1 vccd1 vccd1 _0141_ sky130_fd_sc_hd__mux2_1
Xteam_06_190 vssd1 vssd1 vccd1 vccd1 gpio_oeb[22] team_06_190/LO sky130_fd_sc_hd__conb_1
XFILLER_51_402 vssd1 vssd1 vccd1 vccd1 sky130_fd_sc_hd__fill_4
XTAP_TAPCELL_ROW_46_460 vssd1 vccd1 sky130_fd_sc_hd__tapvpwrvgnd_1
XPHY_EDGE_ROW_43_Left_108 vssd1 vssd1 vccd1 vccd1 sky130_fd_sc_hd__decap_3
XTAP_TAPCELL_ROW_38_405 vssd1 vccd1 sky130_fd_sc_hd__tapvpwrvgnd_1
X_1294_ net330 CALC_INST.gencon_inst.latched_keypad_input\[2\] _0642_ vssd1 vssd1
+ vccd1 vccd1 _0084_ sky130_fd_sc_hd__mux2_1
XPHY_EDGE_ROW_52_Left_117 vssd1 vssd1 vccd1 vccd1 sky130_fd_sc_hd__decap_3
X_2817_ clknet_leaf_27_clk _0338_ net133 vssd1 vssd1 vccd1 vccd1 CALC_INST.gencon_inst.mult_calc.count.GENERATE_ADDER\[4\].thingy.in1
+ sky130_fd_sc_hd__dfrtp_1
X_2679_ clknet_leaf_26_clk _0217_ net136 vssd1 vssd1 vccd1 vccd1 CALC_INST.gencon_inst.mult_calc.compCount.in2\[10\]
+ sky130_fd_sc_hd__dfrtp_1
X_2748_ clknet_leaf_31_clk _0002_ net117 vssd1 vssd1 vccd1 vccd1 CALC_INST.gencon_inst.mult_calc.state\[0\]
+ sky130_fd_sc_hd__dfstp_1
XPHY_EDGE_ROW_61_Left_126 vssd1 vssd1 vccd1 vccd1 sky130_fd_sc_hd__decap_3
XFILLER_54_295 vssd1 vssd1 vccd1 vccd1 sky130_fd_sc_hd__fill_4
XFILLER_39_281 vssd1 vssd1 vccd1 vccd1 sky130_fd_sc_hd__fill_1
XFILLER_36_89 vssd1 vssd1 vccd1 vccd1 sky130_fd_sc_hd__fill_2
XFILLER_36_45 vssd1 vssd1 vccd1 vccd1 sky130_fd_sc_hd__fill_4
XANTENNA_fanout49_A _0648_ vssd1 vssd1 vccd1 vccd1 sky130_fd_sc_hd__diode_2
XFILLER_60_287 vssd1 vssd1 vccd1 vccd1 sky130_fd_sc_hd__fill_2
XTAP_TAPCELL_ROW_43_441 vssd1 vccd1 sky130_fd_sc_hd__tapvpwrvgnd_1
X_1981_ _1025_ _1041_ _1043_ vssd1 vssd1 vccd1 vccd1 _0371_ sky130_fd_sc_hd__and3_1
XFILLER_20_107 vssd1 vssd1 vccd1 vccd1 sky130_fd_sc_hd__fill_1
X_2533_ clknet_leaf_18_clk _0071_ net150 vssd1 vssd1 vccd1 vccd1 net12 sky130_fd_sc_hd__dfrtp_1
X_2602_ clknet_leaf_22_clk _0140_ vssd1 vssd1 vccd1 vccd1 CALC_INST.gencon_inst.mult_calc.INn1\[13\]
+ sky130_fd_sc_hd__dfxtp_1
XFILLER_5_391 vssd1 vssd1 vccd1 vccd1 sky130_fd_sc_hd__fill_1
X_1415_ net392 _0682_ net109 vssd1 vssd1 vccd1 vccd1 _0166_ sky130_fd_sc_hd__mux2_1
X_2464_ _0587_ _0519_ _0586_ vssd1 vssd1 vccd1 vccd1 _0588_ sky130_fd_sc_hd__and3b_1
X_2395_ _0525_ _0530_ _0520_ vssd1 vssd1 vccd1 vccd1 _0532_ sky130_fd_sc_hd__a21o_1
X_1346_ _0597_ net201 net37 vssd1 vssd1 vccd1 vccd1 _0128_ sky130_fd_sc_hd__mux2_1
XFILLER_3_93 vssd1 vssd1 vccd1 vccd1 sky130_fd_sc_hd__fill_2
XFILLER_51_221 vssd1 vssd1 vccd1 vccd1 sky130_fd_sc_hd__fill_2
X_1277_ CALC_INST.gencon_inst.operand2\[15\] CALC_INST.gencon_inst.operand1\[15\]
+ net72 vssd1 vssd1 vccd1 vccd1 _0633_ sky130_fd_sc_hd__mux2_1
XFILLER_24_402 vssd1 vssd1 vccd1 vccd1 sky130_fd_sc_hd__fill_4
XFILLER_11_107 vssd1 vssd1 vccd1 vccd1 sky130_fd_sc_hd__fill_4
Xclkbuf_leaf_31_clk clknet_2_0__leaf_clk vssd1 vssd1 vccd1 vccd1 clknet_leaf_31_clk
+ sky130_fd_sc_hd__clkbuf_8
XANTENNA_clkbuf_2_1__f_clk_X clknet_2_1__leaf_clk vssd1 vssd1 vccd1 vccd1 sky130_fd_sc_hd__diode_2
Xfanout131 net132 vssd1 vssd1 vccd1 vccd1 net131 sky130_fd_sc_hd__clkbuf_2
Xfanout120 net123 vssd1 vssd1 vccd1 vccd1 net120 sky130_fd_sc_hd__clkbuf_2
XFILLER_59_376 vssd1 vssd1 vccd1 vccd1 sky130_fd_sc_hd__fill_4
Xfanout153 net5 vssd1 vssd1 vccd1 vccd1 net153 sky130_fd_sc_hd__buf_2
Xfanout142 net143 vssd1 vssd1 vccd1 vccd1 net142 sky130_fd_sc_hd__clkbuf_4
XFILLER_19_229 vssd1 vssd1 vccd1 vccd1 sky130_fd_sc_hd__fill_2
XFILLER_63_21 vccd1 vssd1 vccd1 vssd1 sky130_ef_sc_hd__decap_40_12
XFILLER_42_232 vssd1 vssd1 vccd1 vccd1 sky130_fd_sc_hd__fill_1
XANTENNA__1299__B net56 vssd1 vssd1 vccd1 vccd1 sky130_fd_sc_hd__diode_2
XTAP_TAPCELL_ROW_40_422 vssd1 vccd1 sky130_fd_sc_hd__tapvpwrvgnd_1
Xclkbuf_leaf_22_clk clknet_2_2__leaf_clk vssd1 vssd1 vccd1 vccd1 clknet_leaf_22_clk
+ sky130_fd_sc_hd__clkbuf_8
XFILLER_8_27 vssd1 vssd1 vccd1 vccd1 sky130_fd_sc_hd__fill_1
XFILLER_6_133 vssd1 vssd1 vccd1 vccd1 sky130_fd_sc_hd__fill_2
XFILLER_10_195 vssd1 vssd1 vccd1 vccd1 sky130_fd_sc_hd__fill_1
X_2180_ net36 _1197_ vssd1 vssd1 vccd1 vccd1 _1211_ sky130_fd_sc_hd__nor2_1
XFILLER_33_254 vssd1 vssd1 vccd1 vccd1 sky130_fd_sc_hd__fill_1
XFILLER_33_232 vssd1 vssd1 vccd1 vccd1 sky130_fd_sc_hd__fill_1
XFILLER_33_221 vssd1 vssd1 vccd1 vccd1 sky130_fd_sc_hd__fill_1
XANTENNA__1429__S net109 vssd1 vssd1 vccd1 vccd1 sky130_fd_sc_hd__diode_2
Xclkbuf_leaf_13_clk clknet_2_3__leaf_clk vssd1 vssd1 vccd1 vccd1 clknet_leaf_13_clk
+ sky130_fd_sc_hd__clkbuf_8
X_1895_ _0947_ _0996_ _0997_ vssd1 vssd1 vccd1 vccd1 _0998_ sky130_fd_sc_hd__or3_1
X_1964_ net454 _1032_ vssd1 vssd1 vccd1 vccd1 _0364_ sky130_fd_sc_hd__xor2_1
X_2447_ CALC_INST.gencon_inst.operand1\[10\] net43 _0573_ _0574_ vssd1 vssd1 vccd1
+ vccd1 _0057_ sky130_fd_sc_hd__o22a_1
X_2516_ clknet_leaf_19_clk _0058_ net149 vssd1 vssd1 vccd1 vccd1 CALC_INST.gencon_inst.operand1\[11\]
+ sky130_fd_sc_hd__dfrtp_1
XFILLER_0_309 vssd1 vssd1 vccd1 vccd1 sky130_fd_sc_hd__fill_2
X_1329_ CALC_INST.gencon_inst.operand2\[10\] net240 net53 vssd1 vssd1 vccd1 vccd1
+ _0116_ sky130_fd_sc_hd__mux2_1
X_2378_ CALC_INST.gencon_inst.mult_calc.out\[14\] net44 vssd1 vssd1 vccd1 vccd1 _0517_
+ sky130_fd_sc_hd__nand2_1
XTAP_TAPCELL_ROW_3_158 vssd1 vccd1 sky130_fd_sc_hd__tapvpwrvgnd_1
XFILLER_33_35 vssd1 vssd1 vccd1 vccd1 sky130_fd_sc_hd__fill_1
XFILLER_33_13 vssd1 vssd1 vccd1 vccd1 sky130_fd_sc_hd__fill_1
XANTENNA_fanout71_X net71 vssd1 vssd1 vccd1 vccd1 sky130_fd_sc_hd__diode_2
Xhold9 CALC_INST.gencon_inst.prev_operator_input\[1\] vssd1 vssd1 vccd1 vccd1 net205
+ sky130_fd_sc_hd__dlygate4sd3_1
XFILLER_62_305 vssd1 vssd1 vccd1 vccd1 sky130_fd_sc_hd__fill_2
XFILLER_15_221 vssd1 vssd1 vccd1 vccd1 sky130_fd_sc_hd__fill_2
XFILLER_30_257 vssd1 vssd1 vccd1 vccd1 sky130_fd_sc_hd__fill_1
X_2301_ net301 net332 vssd1 vssd1 vccd1 vccd1 _0001_ sky130_fd_sc_hd__and2_1
X_1680_ CALC_INST.gencon_inst.mult_calc.main.GENERATE_ADDER\[12\].thingy.in2 CALC_INST.gencon_inst.mult_calc.main.GENERATE_ADDER\[12\].thingy.in1
+ vssd1 vssd1 vccd1 vccd1 _0910_ sky130_fd_sc_hd__nand2_1
XANTENNA__1733__A1 net91 vssd1 vssd1 vccd1 vccd1 sky130_fd_sc_hd__diode_2
X_2163_ CALC_INST.input_ctrl_inst.debounce_cnt\[9\] _1077_ _1197_ vssd1 vssd1 vccd1
+ vccd1 _1198_ sky130_fd_sc_hd__o21ai_1
X_2232_ CALC_INST.gencon_inst.operator_input\[2\] CALC_INST.gencon_inst.operator_input\[1\]
+ vssd1 vssd1 vccd1 vccd1 _0398_ sky130_fd_sc_hd__nor2_1
Xclkbuf_leaf_2_clk clknet_2_0__leaf_clk vssd1 vssd1 vccd1 vccd1 clknet_leaf_2_clk
+ sky130_fd_sc_hd__clkbuf_8
XFILLER_61_393 vssd1 vssd1 vccd1 vccd1 sky130_fd_sc_hd__fill_2
XANTENNA__2446__C1 net41 vssd1 vssd1 vccd1 vccd1 sky130_fd_sc_hd__diode_2
X_2094_ CALC_INST.input_ctrl_inst.key_pressed _1081_ vssd1 vssd1 vccd1 vccd1 _1146_
+ sky130_fd_sc_hd__nand2_1
XFILLER_0_83 vssd1 vssd1 vccd1 vccd1 sky130_fd_sc_hd__fill_1
XTAP_TAPCELL_ROW_0_139 vssd1 vccd1 sky130_fd_sc_hd__tapvpwrvgnd_1
X_1947_ net116 _1080_ _1081_ CALC_INST.input_ctrl_inst.scan_timer\[0\] vssd1 vssd1
+ vccd1 vccd1 _1024_ sky130_fd_sc_hd__a31o_1
XFILLER_21_279 vssd1 vssd1 vccd1 vccd1 sky130_fd_sc_hd__fill_1
X_1878_ _0947_ _0985_ CALC_INST.input_ctrl_inst.col_index\[24\] net62 vssd1 vssd1
+ vccd1 vccd1 _0326_ sky130_fd_sc_hd__a2bb2o_1
XFILLER_56_187 vssd1 vssd1 vccd1 vccd1 sky130_fd_sc_hd__fill_1
XANTENNA__2437__C1 net41 vssd1 vssd1 vccd1 vccd1 sky130_fd_sc_hd__diode_2
XFILLER_29_346 vssd1 vssd1 vccd1 vccd1 sky130_fd_sc_hd__fill_4
XFILLER_29_335 vssd1 vssd1 vccd1 vccd1 sky130_fd_sc_hd__fill_1
XFILLER_28_24 vssd1 vssd1 vccd1 vccd1 sky130_fd_sc_hd__fill_4
XFILLER_60_22 vssd1 vssd1 vccd1 vccd1 sky130_fd_sc_hd__fill_2
XFILLER_8_206 vssd1 vssd1 vccd1 vccd1 sky130_fd_sc_hd__fill_1
XTAP_TAPCELL_ROW_22_296 vssd1 vccd1 sky130_fd_sc_hd__tapvpwrvgnd_1
XFILLER_4_401 vssd1 vssd1 vccd1 vccd1 sky130_fd_sc_hd__fill_2
XFILLER_47_110 vssd1 vssd1 vccd1 vccd1 sky130_fd_sc_hd__fill_2
XPHY_EDGE_ROW_8_Left_73 vssd1 vssd1 vccd1 vccd1 sky130_fd_sc_hd__decap_3
X_2850_ clknet_leaf_8_clk _0010_ net127 vssd1 vssd1 vccd1 vccd1 CALC_INST.input_ctrl_inst.debounce_cnt\[11\]
+ sky130_fd_sc_hd__dfrtp_1
XFILLER_35_316 vccd1 vssd1 vccd1 vssd1 sky130_ef_sc_hd__decap_40_12
Xhold217 CALC_INST.gencon_inst.mult_calc.INn2\[2\] vssd1 vssd1 vccd1 vccd1 net413
+ sky130_fd_sc_hd__dlygate4sd3_1
Xhold206 _0248_ vssd1 vssd1 vccd1 vccd1 net402 sky130_fd_sc_hd__dlygate4sd3_1
X_1663_ _0893_ _0894_ _0895_ vssd1 vssd1 vccd1 vccd1 _0896_ sky130_fd_sc_hd__nand3_1
XFILLER_7_283 vssd1 vssd1 vccd1 vccd1 sky130_fd_sc_hd__fill_1
X_2781_ clknet_leaf_1_clk _0306_ net114 vssd1 vssd1 vccd1 vccd1 CALC_INST.input_ctrl_inst.col_index\[4\]
+ sky130_fd_sc_hd__dfrtp_2
XTAP_TAPCELL_ROW_13_230 vssd1 vccd1 sky130_fd_sc_hd__tapvpwrvgnd_1
X_1801_ _1060_ CALC_INST.input_ctrl_inst.scan_timer\[10\] _0925_ vssd1 vssd1 vccd1
+ vccd1 _0933_ sky130_fd_sc_hd__or3_1
X_1732_ net92 net314 net76 net324 vssd1 vssd1 vccd1 vccd1 _0243_ sky130_fd_sc_hd__a22o_1
X_1594_ CALC_INST.gencon_inst.operator_input\[0\] CALC_INST.gencon_inst.key_read _0398_
+ net72 vssd1 vssd1 vccd1 vccd1 _0838_ sky130_fd_sc_hd__a31oi_1
Xhold228 CALC_INST.gencon_inst.mult_calc.INn2\[13\] vssd1 vssd1 vccd1 vccd1 net424
+ sky130_fd_sc_hd__dlygate4sd3_1
XPHY_EDGE_ROW_7_Right_7 vssd1 vssd1 vccd1 vccd1 sky130_fd_sc_hd__decap_3
Xhold239 CALC_INST.gencon_inst.mult_calc.compCount.in2\[5\] vssd1 vssd1 vccd1 vccd1
+ net435 sky130_fd_sc_hd__dlygate4sd3_1
X_2146_ net36 _1184_ _1185_ net45 net478 vssd1 vssd1 vccd1 vccd1 _0021_ sky130_fd_sc_hd__a32o_1
XFILLER_53_113 vssd1 vssd1 vccd1 vccd1 sky130_fd_sc_hd__fill_1
XFILLER_38_143 vssd1 vssd1 vccd1 vccd1 sky130_fd_sc_hd__fill_1
X_2215_ _0378_ _0380_ vssd1 vssd1 vccd1 vccd1 _0381_ sky130_fd_sc_hd__nor2_1
X_2077_ CALC_INST.gencon_inst.mult_calc.count.GENERATE_ADDER\[12\].thingy.in1 _1094_
+ vssd1 vssd1 vccd1 vccd1 _1131_ sky130_fd_sc_hd__xnor2_1
XFILLER_39_78 vssd1 vssd1 vccd1 vccd1 sky130_fd_sc_hd__fill_2
XPHY_EDGE_ROW_34_Left_99 vssd1 vssd1 vccd1 vccd1 sky130_fd_sc_hd__decap_3
XFILLER_40_363 vssd1 vssd1 vccd1 vccd1 sky130_fd_sc_hd__fill_1
XTAP_TAPCELL_ROW_10_211 vssd1 vccd1 sky130_fd_sc_hd__tapvpwrvgnd_1
XANTENNA__2361__A1 _0404_ vssd1 vssd1 vccd1 vccd1 sky130_fd_sc_hd__diode_2
XANTENNA__1262__S net73 vssd1 vssd1 vccd1 vccd1 sky130_fd_sc_hd__diode_2
X_2000_ net92 vssd1 vssd1 vccd1 vccd1 _1056_ sky130_fd_sc_hd__inv_2
X_2833_ clknet_leaf_5_clk _0354_ vssd1 vssd1 vccd1 vccd1 CALC_INST.gencon_inst.operator_input\[1\]
+ sky130_fd_sc_hd__dfxtp_1
XFILLER_35_157 vssd1 vssd1 vccd1 vccd1 sky130_fd_sc_hd__fill_4
XTAP_TAPCELL_ROW_33_369 vssd1 vccd1 sky130_fd_sc_hd__tapvpwrvgnd_1
X_2764_ clknet_leaf_21_clk net345 vssd1 vssd1 vccd1 vccd1 CALC_INST.gencon_inst.mult_calc.INn2\[7\]
+ sky130_fd_sc_hd__dfxtp_1
X_1715_ net230 net217 net96 vssd1 vssd1 vccd1 vccd1 _0227_ sky130_fd_sc_hd__mux2_1
X_1646_ CALC_INST.gencon_inst.mult_calc.main.GENERATE_ADDER\[7\].thingy.in2 CALC_INST.gencon_inst.mult_calc.main.GENERATE_ADDER\[7\].thingy.in1
+ vssd1 vssd1 vccd1 vccd1 _0881_ sky130_fd_sc_hd__or2_1
XFILLER_6_82 vssd1 vssd1 vccd1 vccd1 sky130_fd_sc_hd__fill_2
X_2695_ clknet_leaf_24_clk _0233_ net142 vssd1 vssd1 vccd1 vccd1 CALC_INST.gencon_inst.mult_calc.main.GENERATE_ADDER\[11\].thingy.in1
+ sky130_fd_sc_hd__dfrtp_1
X_1577_ _0700_ _0701_ vssd1 vssd1 vccd1 vccd1 _0825_ sky130_fd_sc_hd__nand2b_1
XANTENNA_clkbuf_leaf_21_clk_A clknet_2_2__leaf_clk vssd1 vssd1 vccd1 vccd1 sky130_fd_sc_hd__diode_2
XTAP_TAPCELL_ROW_49_480 vssd1 vccd1 sky130_fd_sc_hd__tapvpwrvgnd_1
X_2129_ _1072_ CALC_INST.input_ctrl_inst.key_pressed vssd1 vssd1 vccd1 vccd1 _1172_
+ sky130_fd_sc_hd__nand2_1
XFILLER_41_57 vssd1 vssd1 vccd1 vccd1 sky130_fd_sc_hd__fill_8
XFILLER_41_35 vssd1 vssd1 vccd1 vccd1 sky130_fd_sc_hd__fill_1
XFILLER_64_219 vssd1 vssd1 vccd1 vccd1 sky130_fd_sc_hd__fill_1
XFILLER_2_29 vssd1 vssd1 vccd1 vccd1 sky130_fd_sc_hd__fill_1
XFILLER_17_113 vccd1 vssd1 vccd1 vssd1 sky130_ef_sc_hd__decap_40_12
XFILLER_15_91 vssd1 vssd1 vccd1 vccd1 sky130_fd_sc_hd__fill_1
X_1500_ _0708_ _0712_ _0757_ _0709_ vssd1 vssd1 vccd1 vccd1 _0759_ sky130_fd_sc_hd__o31a_1
XFILLER_56_6 vssd1 vssd1 vccd1 vccd1 sky130_fd_sc_hd__fill_8
X_2480_ CALC_INST.gencon_inst.ALU_out\[2\] net68 net56 _0599_ vssd1 vssd1 vccd1 vccd1
+ _0600_ sky130_fd_sc_hd__a22o_1
XFILLER_31_90 vccd1 vssd1 vccd1 vssd1 sky130_ef_sc_hd__decap_40_12
XANTENNA__1909__A1 net91 vssd1 vssd1 vccd1 vccd1 sky130_fd_sc_hd__diode_2
Xteam_06_191 vssd1 vssd1 vccd1 vccd1 gpio_oeb[23] team_06_191/LO sky130_fd_sc_hd__conb_1
X_1431_ net470 _0690_ CALC_INST.gencon_inst.add_calc.state\[1\] vssd1 vssd1 vccd1
+ vccd1 _0174_ sky130_fd_sc_hd__mux2_1
X_1362_ CALC_INST.gencon_inst.operand2\[14\] CALC_INST.gencon_inst.operand1\[14\]
+ net73 vssd1 vssd1 vccd1 vccd1 _0655_ sky130_fd_sc_hd__mux2_1
X_1293_ net293 CALC_INST.gencon_inst.latched_keypad_input\[1\] _0642_ vssd1 vssd1
+ vccd1 vccd1 _0083_ sky130_fd_sc_hd__mux2_1
Xteam_06_180 vssd1 vssd1 vccd1 vccd1 gpio_oeb[12] team_06_180/LO sky130_fd_sc_hd__conb_1
XANTENNA__2098__B1 CALC_INST.gencon_inst.add_calc.state\[1\] vssd1 vssd1 vccd1 vccd1
+ sky130_fd_sc_hd__diode_2
XTAP_TAPCELL_ROW_46_461 vssd1 vccd1 sky130_fd_sc_hd__tapvpwrvgnd_1
XTAP_TAPCELL_ROW_38_406 vssd1 vccd1 sky130_fd_sc_hd__tapvpwrvgnd_1
X_2816_ clknet_leaf_32_clk net304 net133 vssd1 vssd1 vccd1 vccd1 CALC_INST.gencon_inst.mult_calc.count.GENERATE_ADDER\[3\].thingy.in1
+ sky130_fd_sc_hd__dfrtp_1
X_2678_ clknet_leaf_26_clk _0216_ net135 vssd1 vssd1 vccd1 vccd1 CALC_INST.gencon_inst.mult_calc.compCount.in2\[9\]
+ sky130_fd_sc_hd__dfrtp_1
X_2747_ clknet_leaf_26_clk _0285_ net141 vssd1 vssd1 vccd1 vccd1 CALC_INST.gencon_inst.mult_calc.countSave\[14\]
+ sky130_fd_sc_hd__dfrtp_1
XFILLER_11_27 vssd1 vssd1 vccd1 vccd1 sky130_fd_sc_hd__fill_8
X_1629_ _0864_ _0866_ vssd1 vssd1 vccd1 vccd1 _0867_ sky130_fd_sc_hd__xnor2_1
XFILLER_46_219 vssd1 vssd1 vccd1 vccd1 sky130_fd_sc_hd__fill_1
XANTENNA_input3_A gpio_in[2] vssd1 vssd1 vccd1 vccd1 sky130_fd_sc_hd__diode_2
XFILLER_54_241 vssd1 vssd1 vccd1 vccd1 sky130_fd_sc_hd__fill_1
XFILLER_36_57 vssd1 vssd1 vccd1 vccd1 sky130_fd_sc_hd__fill_1
XFILLER_60_266 vssd1 vssd1 vccd1 vccd1 sky130_fd_sc_hd__fill_4
XTAP_TAPCELL_ROW_43_442 vssd1 vccd1 sky130_fd_sc_hd__tapvpwrvgnd_1
X_1980_ _1042_ vssd1 vssd1 vccd1 vccd1 _1043_ sky130_fd_sc_hd__inv_2
XFILLER_9_164 vssd1 vssd1 vccd1 vccd1 sky130_fd_sc_hd__fill_4
X_2463_ CALC_INST.gencon_inst.operand1\[13\] CALC_INST.gencon_inst.operand1\[14\]
+ _0579_ vssd1 vssd1 vccd1 vccd1 _0587_ sky130_fd_sc_hd__and3_1
X_2532_ clknet_leaf_19_clk _0070_ net149 vssd1 vssd1 vccd1 vccd1 net11 sky130_fd_sc_hd__dfrtp_1
X_2601_ clknet_leaf_23_clk _0139_ vssd1 vssd1 vccd1 vccd1 CALC_INST.gencon_inst.mult_calc.INn1\[12\]
+ sky130_fd_sc_hd__dfxtp_1
XANTENNA__1715__S net96 vssd1 vssd1 vccd1 vccd1 sky130_fd_sc_hd__diode_2
XPHY_EDGE_ROW_21_Left_86 vssd1 vssd1 vccd1 vccd1 sky130_fd_sc_hd__decap_3
X_1414_ CALC_INST.gencon_inst.ALU_in1\[7\] CALC_INST.gencon_inst.ALU_in2\[7\] net66
+ vssd1 vssd1 vccd1 vccd1 _0682_ sky130_fd_sc_hd__mux2_1
X_2394_ _0525_ _0530_ vssd1 vssd1 vccd1 vccd1 _0531_ sky130_fd_sc_hd__nor2_1
X_1276_ _0590_ _0631_ vssd1 vssd1 vccd1 vccd1 _0632_ sky130_fd_sc_hd__and2b_1
X_1345_ _0594_ net221 net37 vssd1 vssd1 vccd1 vccd1 _0127_ sky130_fd_sc_hd__mux2_1
XFILLER_59_355 vssd1 vssd1 vccd1 vccd1 sky130_fd_sc_hd__fill_1
Xfanout110 CALC_INST.gencon_inst.add_calc.state\[2\] vssd1 vssd1 vccd1 vccd1 net110
+ sky130_fd_sc_hd__buf_2
Xfanout132 net5 vssd1 vssd1 vccd1 vccd1 net132 sky130_fd_sc_hd__clkbuf_2
Xfanout143 net144 vssd1 vssd1 vccd1 vccd1 net143 sky130_fd_sc_hd__clkbuf_4
Xfanout121 net123 vssd1 vssd1 vccd1 vccd1 net121 sky130_fd_sc_hd__clkbuf_4
XFILLER_59_388 vssd1 vssd1 vccd1 vccd1 sky130_fd_sc_hd__fill_2
XFILLER_59_366 vssd1 vssd1 vccd1 vccd1 sky130_fd_sc_hd__fill_4
XFILLER_47_78 vssd1 vssd1 vccd1 vccd1 sky130_fd_sc_hd__fill_2
XANTENNA__1360__S net73 vssd1 vssd1 vccd1 vccd1 sky130_fd_sc_hd__diode_2
XFILLER_27_296 vssd1 vssd1 vccd1 vccd1 sky130_fd_sc_hd__fill_1
XFILLER_63_55 vssd1 vssd1 vccd1 vccd1 sky130_fd_sc_hd__fill_1
XTAP_TAPCELL_ROW_40_423 vssd1 vccd1 sky130_fd_sc_hd__tapvpwrvgnd_1
XFILLER_8_17 vssd1 vssd1 vccd1 vccd1 sky130_fd_sc_hd__fill_1
XFILLER_10_141 vssd1 vssd1 vccd1 vccd1 sky130_fd_sc_hd__fill_1
XFILLER_12_70 vssd1 vssd1 vccd1 vccd1 sky130_fd_sc_hd__fill_1
XFILLER_12_92 vssd1 vssd1 vccd1 vccd1 sky130_fd_sc_hd__fill_2
XFILLER_18_285 vssd1 vssd1 vccd1 vccd1 sky130_fd_sc_hd__fill_1
X_1963_ _1025_ _1031_ _1033_ vssd1 vssd1 vccd1 vccd1 _0363_ sky130_fd_sc_hd__and3_1
X_1894_ CALC_INST.input_ctrl_inst.col_index\[29\] CALC_INST.input_ctrl_inst.col_index\[28\]
+ _0991_ vssd1 vssd1 vccd1 vccd1 _0997_ sky130_fd_sc_hd__and3_1
X_2515_ clknet_leaf_18_clk _0057_ net150 vssd1 vssd1 vccd1 vccd1 CALC_INST.gencon_inst.operand1\[10\]
+ sky130_fd_sc_hd__dfrtp_2
X_2446_ CALC_INST.gencon_inst.ALU_out\[10\] net69 net59 CALC_INST.gencon_inst.mult_calc.out\[10\]
+ net41 vssd1 vssd1 vccd1 vccd1 _0574_ sky130_fd_sc_hd__a221o_1
X_1328_ CALC_INST.gencon_inst.operand2\[9\] net243 net53 vssd1 vssd1 vccd1 vccd1 _0115_
+ sky130_fd_sc_hd__mux2_1
XTAP_TAPCELL_ROW_54_515 vssd1 vccd1 sky130_fd_sc_hd__tapvpwrvgnd_1
X_1259_ CALC_INST.gencon_inst.operand2\[10\] CALC_INST.gencon_inst.operand1\[10\]
+ net73 vssd1 vssd1 vccd1 vccd1 _0620_ sky130_fd_sc_hd__mux2_1
X_2377_ CALC_INST.gencon_inst.operand2\[13\] _0509_ CALC_INST.gencon_inst.operand2\[14\]
+ vssd1 vssd1 vccd1 vccd1 _0516_ sky130_fd_sc_hd__a21oi_1
XTAP_TAPCELL_ROW_3_159 vssd1 vccd1 sky130_fd_sc_hd__tapvpwrvgnd_1
XFILLER_33_47 vssd1 vssd1 vccd1 vccd1 sky130_fd_sc_hd__fill_1
X_2300_ net305 net332 net301 vssd1 vssd1 vccd1 vccd1 _0000_ sky130_fd_sc_hd__o21ba_1
X_2231_ CALC_INST.gencon_inst.gencon_state\[3\] _0395_ vssd1 vssd1 vccd1 vccd1 _0397_
+ sky130_fd_sc_hd__or2_4
X_2162_ _1073_ _1172_ vssd1 vssd1 vccd1 vccd1 _1197_ sky130_fd_sc_hd__nor2_1
X_2093_ _1056_ _1143_ net76 vssd1 vssd1 vccd1 vccd1 _0007_ sky130_fd_sc_hd__a21oi_1
XFILLER_61_361 vssd1 vssd1 vccd1 vccd1 sky130_fd_sc_hd__fill_2
XANTENNA__1948__B net63 vssd1 vssd1 vccd1 vccd1 sky130_fd_sc_hd__diode_2
XTAP_TAPCELL_ROW_16_250 vssd1 vccd1 sky130_fd_sc_hd__tapvpwrvgnd_1
XANTENNA_fanout111_A net112 vssd1 vssd1 vccd1 vccd1 sky130_fd_sc_hd__diode_2
X_1946_ net115 CALC_INST.input_ctrl_inst.scan_timer\[0\] _1080_ _1081_ vssd1 vssd1
+ vccd1 vccd1 _1023_ sky130_fd_sc_hd__and4_1
XANTENNA__1761__A2_N net82 vssd1 vssd1 vccd1 vccd1 sky130_fd_sc_hd__diode_2
X_1877_ _0983_ _0984_ vssd1 vssd1 vccd1 vccd1 _0985_ sky130_fd_sc_hd__or2_1
X_2429_ CALC_INST.gencon_inst.operand1\[7\] _0556_ vssd1 vssd1 vccd1 vccd1 _0560_
+ sky130_fd_sc_hd__and2_1
XFILLER_0_118 vccd1 vssd1 vccd1 vssd1 sky130_ef_sc_hd__decap_40_12
XFILLER_44_339 vssd1 vssd1 vccd1 vccd1 sky130_fd_sc_hd__fill_1
XFILLER_44_35 vssd1 vssd1 vccd1 vccd1 sky130_fd_sc_hd__fill_1
XFILLER_44_24 vssd1 vssd1 vccd1 vccd1 sky130_fd_sc_hd__fill_4
XTAP_TAPCELL_ROW_22_297 vssd1 vccd1 sky130_fd_sc_hd__tapvpwrvgnd_1
XFILLER_35_328 vssd1 vssd1 vccd1 vccd1 sky130_fd_sc_hd__fill_8
X_1800_ CALC_INST.input_ctrl_inst.scan_timer\[2\] _0928_ _0931_ vssd1 vssd1 vccd1
+ vccd1 _0932_ sky130_fd_sc_hd__or3_1
XTAP_TAPCELL_ROW_13_231 vssd1 vccd1 sky130_fd_sc_hd__tapvpwrvgnd_1
Xhold229 CALC_INST.input_ctrl_inst.debounce_cnt\[6\] vssd1 vssd1 vccd1 vccd1 net425
+ sky130_fd_sc_hd__dlygate4sd3_1
Xhold218 _0288_ vssd1 vssd1 vccd1 vccd1 net414 sky130_fd_sc_hd__dlygate4sd3_1
X_1662_ _0887_ _0891_ _0888_ vssd1 vssd1 vccd1 vccd1 _0895_ sky130_fd_sc_hd__o21ai_1
Xhold207 CALC_INST.gencon_inst.mult_calc.adderSave\[8\] vssd1 vssd1 vccd1 vccd1 net403
+ sky130_fd_sc_hd__dlygate4sd3_1
X_1731_ net92 CALC_INST.gencon_inst.mult_calc.adderSave\[4\] net76 net409 vssd1 vssd1
+ vccd1 vccd1 _0242_ sky130_fd_sc_hd__a22o_1
X_2780_ clknet_leaf_1_clk _0305_ net114 vssd1 vssd1 vccd1 vccd1 CALC_INST.input_ctrl_inst.col_index\[3\]
+ sky130_fd_sc_hd__dfrtp_1
X_1593_ CALC_INST.gencon_inst.add_calc.state\[1\] net385 net31 _0837_ vssd1 vssd1
+ vccd1 vccd1 _0189_ sky130_fd_sc_hd__o22a_1
X_2214_ _1059_ _0379_ vssd1 vssd1 vccd1 vccd1 _0380_ sky130_fd_sc_hd__and2_1
X_2145_ CALC_INST.input_ctrl_inst.debounce_cnt\[4\] _1181_ vssd1 vssd1 vccd1 vccd1
+ _1185_ sky130_fd_sc_hd__nand2_1
XFILLER_26_306 vssd1 vssd1 vccd1 vccd1 sky130_fd_sc_hd__fill_2
XFILLER_19_391 vssd1 vssd1 vccd1 vccd1 sky130_fd_sc_hd__fill_1
X_2076_ CALC_INST.gencon_inst.mult_calc.compCount.in2\[10\] _1125_ _1129_ CALC_INST.gencon_inst.mult_calc.compCount.in2\[11\]
+ vssd1 vssd1 vccd1 vccd1 _1130_ sky130_fd_sc_hd__a22o_1
XTAP_TAPCELL_ROW_36_389 vssd1 vccd1 sky130_fd_sc_hd__tapvpwrvgnd_1
X_1929_ CALC_INST.gencon_inst.keypad_input\[1\] _1084_ vssd1 vssd1 vccd1 vccd1 _1013_
+ sky130_fd_sc_hd__and2_1
XFILLER_14_27 vssd1 vssd1 vccd1 vccd1 sky130_fd_sc_hd__fill_1
XFILLER_30_37 vssd1 vssd1 vccd1 vccd1 sky130_fd_sc_hd__fill_2
XFILLER_29_111 vssd1 vssd1 vccd1 vccd1 sky130_fd_sc_hd__fill_1
XFILLER_25_361 vssd1 vssd1 vccd1 vccd1 sky130_fd_sc_hd__fill_2
XTAP_TAPCELL_ROW_10_212 vssd1 vccd1 sky130_fd_sc_hd__tapvpwrvgnd_1
XANTENNA__2227__X _0393_ vssd1 vssd1 vccd1 vccd1 sky130_fd_sc_hd__diode_2
Xhold90 CALC_INST.gencon_inst.mult_calc.countSave\[9\] vssd1 vssd1 vccd1 vccd1 net286
+ sky130_fd_sc_hd__dlygate4sd3_1
XFILLER_16_350 vssd1 vssd1 vccd1 vccd1 sky130_fd_sc_hd__fill_1
XFILLER_50_139 vssd1 vssd1 vccd1 vccd1 sky130_fd_sc_hd__fill_1
X_2832_ clknet_leaf_5_clk _0353_ vssd1 vssd1 vccd1 vccd1 CALC_INST.gencon_inst.operator_input\[0\]
+ sky130_fd_sc_hd__dfxtp_1
XFILLER_31_353 vssd1 vssd1 vccd1 vccd1 sky130_fd_sc_hd__fill_2
X_2763_ clknet_leaf_21_clk _0292_ vssd1 vssd1 vccd1 vccd1 CALC_INST.gencon_inst.mult_calc.INn2\[6\]
+ sky130_fd_sc_hd__dfxtp_1
X_1576_ net32 _0823_ vssd1 vssd1 vccd1 vccd1 _0824_ sky130_fd_sc_hd__nand2_1
X_2694_ clknet_leaf_23_clk _0232_ net144 vssd1 vssd1 vccd1 vccd1 CALC_INST.gencon_inst.mult_calc.main.GENERATE_ADDER\[10\].thingy.in1
+ sky130_fd_sc_hd__dfrtp_1
X_1714_ net210 net208 net96 vssd1 vssd1 vccd1 vccd1 _0226_ sky130_fd_sc_hd__mux2_1
XFILLER_6_61 vccd1 vssd1 vccd1 vssd1 sky130_ef_sc_hd__decap_40_12
X_1645_ net431 net85 _0880_ net100 vssd1 vssd1 vccd1 vccd1 _0198_ sky130_fd_sc_hd__a22o_1
XTAP_TAPCELL_ROW_49_481 vssd1 vccd1 sky130_fd_sc_hd__tapvpwrvgnd_1
X_2128_ _1170_ vssd1 vssd1 vccd1 vccd1 _1171_ sky130_fd_sc_hd__inv_2
XFILLER_26_169 vssd1 vssd1 vccd1 vccd1 sky130_fd_sc_hd__fill_2
X_2059_ CALC_INST.gencon_inst.mult_calc.count.GENERATE_ADDER\[5\].thingy.in1 CALC_INST.gencon_inst.mult_calc.count.GENERATE_ADDER\[4\].thingy.in1
+ _1089_ CALC_INST.gencon_inst.mult_calc.count.GENERATE_ADDER\[6\].thingy.in1 vssd1
+ vssd1 vccd1 vccd1 _1113_ sky130_fd_sc_hd__a31o_1
XFILLER_22_397 vssd1 vssd1 vccd1 vccd1 sky130_fd_sc_hd__fill_2
XFILLER_1_279 vssd1 vssd1 vccd1 vccd1 sky130_fd_sc_hd__fill_1
XANTENNA_fanout91_A net94 vssd1 vssd1 vccd1 vccd1 sky130_fd_sc_hd__diode_2
XFILLER_17_125 vssd1 vssd1 vccd1 vccd1 sky130_fd_sc_hd__fill_8
XANTENNA__2856__RESET_B net132 vssd1 vssd1 vccd1 vccd1 sky130_fd_sc_hd__diode_2
XFILLER_9_335 vssd1 vssd1 vccd1 vccd1 sky130_fd_sc_hd__fill_1
X_1430_ CALC_INST.gencon_inst.add_calc.main.a0.in1 CALC_INST.gencon_inst.add_calc.main.in2\[0\]
+ vssd1 vssd1 vccd1 vccd1 _0690_ sky130_fd_sc_hd__xor2_1
XFILLER_31_80 vssd1 vssd1 vccd1 vccd1 sky130_fd_sc_hd__fill_2
Xteam_06_170 vssd1 vssd1 vccd1 vccd1 team_06_170/HI gpio_out[32] sky130_fd_sc_hd__conb_1
Xteam_06_181 vssd1 vssd1 vccd1 vccd1 gpio_oeb[13] team_06_181/LO sky130_fd_sc_hd__conb_1
Xteam_06_192 vssd1 vssd1 vccd1 vccd1 gpio_oeb[24] team_06_192/LO sky130_fd_sc_hd__conb_1
XFILLER_48_250 vssd1 vssd1 vccd1 vccd1 sky130_fd_sc_hd__fill_2
XTAP_TAPCELL_ROW_38_407 vssd1 vccd1 sky130_fd_sc_hd__tapvpwrvgnd_1
X_1292_ net271 CALC_INST.gencon_inst.latched_keypad_input\[0\] _0642_ vssd1 vssd1
+ vccd1 vccd1 _0082_ sky130_fd_sc_hd__mux2_1
X_1361_ _0654_ net238 net39 vssd1 vssd1 vccd1 vccd1 _0140_ sky130_fd_sc_hd__mux2_1
XTAP_TAPCELL_ROW_46_462 vssd1 vccd1 sky130_fd_sc_hd__tapvpwrvgnd_1
XFILLER_23_106 vssd1 vssd1 vccd1 vccd1 sky130_fd_sc_hd__fill_2
X_2815_ clknet_leaf_32_clk _0336_ net118 vssd1 vssd1 vccd1 vccd1 CALC_INST.gencon_inst.mult_calc.count.GENERATE_ADDER\[2\].thingy.in1
+ sky130_fd_sc_hd__dfrtp_1
X_2746_ clknet_leaf_26_clk _0284_ net140 vssd1 vssd1 vccd1 vccd1 CALC_INST.gencon_inst.mult_calc.countSave\[13\]
+ sky130_fd_sc_hd__dfrtp_1
XFILLER_8_390 vssd1 vssd1 vccd1 vccd1 sky130_fd_sc_hd__fill_4
X_1559_ _0756_ _0809_ vssd1 vssd1 vccd1 vccd1 _0810_ sky130_fd_sc_hd__xnor2_1
X_2677_ clknet_leaf_26_clk _0215_ net136 vssd1 vssd1 vccd1 vccd1 CALC_INST.gencon_inst.mult_calc.compCount.in2\[8\]
+ sky130_fd_sc_hd__dfrtp_1
X_1628_ _0856_ _0865_ vssd1 vssd1 vccd1 vccd1 _0866_ sky130_fd_sc_hd__or2_1
XFILLER_54_253 vssd1 vssd1 vccd1 vccd1 sky130_fd_sc_hd__fill_4
XFILLER_46_209 vssd1 vssd1 vccd1 vccd1 sky130_fd_sc_hd__fill_8
XFILLER_54_275 vssd1 vssd1 vccd1 vccd1 sky130_fd_sc_hd__fill_2
XFILLER_52_35 vssd1 vssd1 vccd1 vccd1 sky130_fd_sc_hd__fill_2
XFILLER_14_106 vssd1 vssd1 vccd1 vccd1 sky130_fd_sc_hd__fill_2
XANTENNA__1358__S net73 vssd1 vssd1 vccd1 vccd1 sky130_fd_sc_hd__diode_2
XANTENNA__1772__B1 net86 vssd1 vssd1 vccd1 vccd1 sky130_fd_sc_hd__diode_2
XFILLER_6_349 vssd1 vssd1 vccd1 vccd1 sky130_fd_sc_hd__fill_2
XANTENNA_fanout94_X net94 vssd1 vssd1 vccd1 vccd1 sky130_fd_sc_hd__diode_2
XFILLER_60_201 vssd1 vssd1 vccd1 vccd1 sky130_fd_sc_hd__fill_2
XFILLER_45_242 vssd1 vssd1 vccd1 vccd1 sky130_fd_sc_hd__fill_1
XTAP_TAPCELL_ROW_43_443 vssd1 vccd1 sky130_fd_sc_hd__tapvpwrvgnd_1
XANTENNA_clkbuf_leaf_20_clk_A clknet_2_3__leaf_clk vssd1 vssd1 vccd1 vccd1 sky130_fd_sc_hd__diode_2
X_2600_ clknet_leaf_23_clk _0138_ vssd1 vssd1 vccd1 vccd1 CALC_INST.gencon_inst.mult_calc.INn1\[11\]
+ sky130_fd_sc_hd__dfxtp_1
XFILLER_9_154 vssd1 vssd1 vccd1 vccd1 sky130_fd_sc_hd__fill_2
X_1413_ net359 _0681_ net108 vssd1 vssd1 vccd1 vccd1 _0165_ sky130_fd_sc_hd__mux2_1
XFILLER_47_3 vssd1 vssd1 vccd1 vccd1 sky130_fd_sc_hd__fill_8
X_2393_ CALC_INST.gencon_inst.operand1\[1\] CALC_INST.gencon_inst.latched_keypad_input\[1\]
+ vssd1 vssd1 vccd1 vccd1 _0530_ sky130_fd_sc_hd__xnor2_1
X_2531_ clknet_leaf_19_clk _0069_ net149 vssd1 vssd1 vccd1 vccd1 net10 sky130_fd_sc_hd__dfrtp_1
X_2462_ CALC_INST.gencon_inst.operand1\[12\] CALC_INST.gencon_inst.operand1\[13\]
+ _0576_ CALC_INST.gencon_inst.operand1\[14\] vssd1 vssd1 vccd1 vccd1 _0586_ sky130_fd_sc_hd__a31o_1
XANTENNA__2307__A2 net35 vssd1 vssd1 vccd1 vccd1 sky130_fd_sc_hd__diode_2
XANTENNA__1763__B1 net84 vssd1 vssd1 vccd1 vccd1 sky130_fd_sc_hd__diode_2
XFILLER_5_393 vssd1 vssd1 vccd1 vccd1 sky130_fd_sc_hd__fill_8
X_1275_ CALC_INST.gencon_inst.gencon_state\[0\] CALC_INST.gencon_inst.mult_calc.out\[15\]
+ _1232_ net68 CALC_INST.gencon_inst.ALU_out\[15\] vssd1 vssd1 vccd1 vccd1 _0631_
+ sky130_fd_sc_hd__a32o_1
X_1344_ net37 vssd1 vssd1 vccd1 vccd1 _0651_ sky130_fd_sc_hd__inv_2
XFILLER_3_95 vssd1 vssd1 vccd1 vccd1 sky130_fd_sc_hd__fill_1
XFILLER_51_278 vssd1 vssd1 vccd1 vccd1 sky130_fd_sc_hd__fill_2
XFILLER_51_234 vssd1 vssd1 vccd1 vccd1 sky130_fd_sc_hd__fill_2
XFILLER_51_223 vssd1 vssd1 vccd1 vccd1 sky130_fd_sc_hd__fill_1
X_2729_ clknet_leaf_28_clk _0267_ net136 vssd1 vssd1 vccd1 vccd1 CALC_INST.gencon_inst.mult_calc.out\[14\]
+ sky130_fd_sc_hd__dfrtp_1
XFILLER_59_334 vssd1 vssd1 vccd1 vccd1 sky130_fd_sc_hd__fill_2
XFILLER_47_35 vssd1 vssd1 vccd1 vccd1 sky130_fd_sc_hd__fill_4
Xfanout111 net112 vssd1 vssd1 vccd1 vccd1 net111 sky130_fd_sc_hd__buf_2
Xfanout122 net123 vssd1 vssd1 vccd1 vccd1 net122 sky130_fd_sc_hd__buf_2
XTAP_TAPCELL_ROW_6_179 vssd1 vccd1 sky130_fd_sc_hd__tapvpwrvgnd_1
Xfanout133 net139 vssd1 vssd1 vccd1 vccd1 net133 sky130_fd_sc_hd__clkbuf_4
Xfanout144 net153 vssd1 vssd1 vccd1 vccd1 net144 sky130_fd_sc_hd__buf_2
Xfanout100 CALC_INST.gencon_inst.mult_calc.state\[2\] vssd1 vssd1 vccd1 vccd1 net100
+ sky130_fd_sc_hd__clkbuf_4
XANTENNA_fanout54_A _0595_ vssd1 vssd1 vccd1 vccd1 sky130_fd_sc_hd__diode_2
XPHY_EDGE_ROW_29_Right_29 vssd1 vssd1 vccd1 vccd1 sky130_fd_sc_hd__decap_3
XPHY_EDGE_ROW_38_Right_38 vssd1 vssd1 vccd1 vccd1 sky130_fd_sc_hd__decap_3
XFILLER_8_29 vssd1 vssd1 vccd1 vccd1 sky130_fd_sc_hd__fill_4
XFILLER_10_197 vssd1 vssd1 vccd1 vccd1 sky130_fd_sc_hd__fill_1
XPHY_EDGE_ROW_47_Right_47 vssd1 vssd1 vccd1 vccd1 sky130_fd_sc_hd__decap_3
XPHY_EDGE_ROW_56_Right_56 vssd1 vssd1 vccd1 vccd1 sky130_fd_sc_hd__decap_3
XFILLER_37_90 vssd1 vssd1 vccd1 vccd1 sky130_fd_sc_hd__fill_1
X_1962_ _1032_ vssd1 vssd1 vccd1 vccd1 _1033_ sky130_fd_sc_hd__inv_2
X_1893_ CALC_INST.input_ctrl_inst.col_index\[29\] _0993_ vssd1 vssd1 vccd1 vccd1 _0996_
+ sky130_fd_sc_hd__nor2_1
X_2514_ clknet_leaf_18_clk _0056_ net149 vssd1 vssd1 vccd1 vccd1 CALC_INST.gencon_inst.operand1\[9\]
+ sky130_fd_sc_hd__dfrtp_1
X_2445_ CALC_INST.gencon_inst.operand1\[10\] _0568_ _0572_ vssd1 vssd1 vccd1 vccd1
+ _0573_ sky130_fd_sc_hd__o21a_1
X_2376_ CALC_INST.gencon_inst.operand2\[14\] CALC_INST.gencon_inst.operand2\[13\]
+ _0509_ vssd1 vssd1 vccd1 vccd1 _0515_ sky130_fd_sc_hd__and3_1
XFILLER_56_326 vssd1 vssd1 vccd1 vccd1 sky130_fd_sc_hd__fill_2
XTAP_TAPCELL_ROW_54_516 vssd1 vccd1 sky130_fd_sc_hd__tapvpwrvgnd_1
X_1327_ CALC_INST.gencon_inst.operand2\[8\] net249 net53 vssd1 vssd1 vccd1 vccd1 _0114_
+ sky130_fd_sc_hd__mux2_1
X_1258_ net257 _0592_ _0618_ _0619_ vssd1 vssd1 vccd1 vccd1 _0072_ sky130_fd_sc_hd__o22a_1
XTAP_TAPCELL_ROW_19_270 vssd1 vccd1 sky130_fd_sc_hd__tapvpwrvgnd_1
XTAP_TAPCELL_ROW_62_571 vssd1 vccd1 sky130_fd_sc_hd__tapvpwrvgnd_1
XPHY_EDGE_ROW_49_Left_114 vssd1 vssd1 vccd1 vccd1 sky130_fd_sc_hd__decap_3
XPHY_EDGE_ROW_58_Left_123 vssd1 vssd1 vccd1 vccd1 sky130_fd_sc_hd__decap_3
XFILLER_58_23 vssd1 vssd1 vccd1 vccd1 sky130_fd_sc_hd__fill_1
XFILLER_47_326 vssd1 vssd1 vccd1 vccd1 sky130_fd_sc_hd__fill_2
XANTENNA_fanout57_X net57 vssd1 vssd1 vccd1 vccd1 sky130_fd_sc_hd__diode_2
XFILLER_62_307 vssd1 vssd1 vccd1 vccd1 sky130_fd_sc_hd__fill_1
XFILLER_55_370 vssd1 vssd1 vccd1 vccd1 sky130_fd_sc_hd__fill_1
XFILLER_30_237 vssd1 vssd1 vccd1 vccd1 sky130_fd_sc_hd__fill_2
XFILLER_15_223 vssd1 vssd1 vccd1 vccd1 sky130_fd_sc_hd__fill_1
X_2230_ CALC_INST.gencon_inst.gencon_state\[3\] _0395_ vssd1 vssd1 vccd1 vccd1 _0396_
+ sky130_fd_sc_hd__nor2_1
X_2161_ _1176_ _1194_ _1196_ net46 net436 vssd1 vssd1 vccd1 vccd1 _0025_ sky130_fd_sc_hd__a32o_1
XANTENNA_clkbuf_2_2__f_clk_A clknet_0_clk vssd1 vssd1 vccd1 vccd1 sky130_fd_sc_hd__diode_2
X_2092_ net95 net92 vssd1 vssd1 vccd1 vccd1 _1145_ sky130_fd_sc_hd__nor2_2
XFILLER_61_395 vssd1 vssd1 vccd1 vccd1 sky130_fd_sc_hd__fill_1
X_1945_ net124 _1148_ _1021_ _1022_ vssd1 vssd1 vccd1 vccd1 _0356_ sky130_fd_sc_hd__a211oi_1
XTAP_TAPCELL_ROW_16_251 vssd1 vccd1 sky130_fd_sc_hd__tapvpwrvgnd_1
XANTENNA_fanout104_A net106 vssd1 vssd1 vccd1 vccd1 sky130_fd_sc_hd__diode_2
X_1876_ CALC_INST.input_ctrl_inst.col_index\[24\] _0441_ _0955_ vssd1 vssd1 vccd1
+ vccd1 _0984_ sky130_fd_sc_hd__and3_1
X_2428_ CALC_INST.gencon_inst.operand1\[6\] net42 _0558_ _0559_ vssd1 vssd1 vccd1
+ vccd1 _0053_ sky130_fd_sc_hd__o22a_1
X_2359_ CALC_INST.gencon_inst.operand2\[10\] _0499_ vssd1 vssd1 vccd1 vccd1 _0502_
+ sky130_fd_sc_hd__nand2_1
XFILLER_4_403 vssd1 vssd1 vccd1 vccd1 sky130_fd_sc_hd__fill_1
XFILLER_8_219 vssd1 vssd1 vccd1 vccd1 sky130_fd_sc_hd__fill_2
XFILLER_20_270 vssd1 vssd1 vccd1 vccd1 sky130_fd_sc_hd__fill_1
XFILLER_62_137 vssd1 vssd1 vccd1 vccd1 sky130_fd_sc_hd__fill_2
XFILLER_28_381 vssd1 vssd1 vccd1 vccd1 sky130_fd_sc_hd__fill_1
XFILLER_43_373 vssd1 vssd1 vccd1 vccd1 sky130_fd_sc_hd__fill_4
XTAP_TAPCELL_ROW_13_232 vssd1 vccd1 sky130_fd_sc_hd__tapvpwrvgnd_1
X_1592_ _1064_ CALC_INST.gencon_inst.add_calc.sameSignVal net81 vssd1 vssd1 vccd1
+ vccd1 _0837_ sky130_fd_sc_hd__a21o_1
X_1661_ CALC_INST.gencon_inst.mult_calc.main.GENERATE_ADDER\[9\].thingy.in2 CALC_INST.gencon_inst.mult_calc.main.GENERATE_ADDER\[9\].thingy.in1
+ vssd1 vssd1 vccd1 vccd1 _0894_ sky130_fd_sc_hd__nand2_1
Xhold208 CALC_INST.gencon_inst.mult_calc.adderSave\[12\] vssd1 vssd1 vccd1 vccd1 net404
+ sky130_fd_sc_hd__dlygate4sd3_1
Xhold219 CALC_INST.input_ctrl_inst.col_index\[7\] vssd1 vssd1 vccd1 vccd1 net415 sky130_fd_sc_hd__dlygate4sd3_1
X_1730_ net92 CALC_INST.gencon_inst.mult_calc.adderSave\[3\] net76 net362 vssd1 vssd1
+ vccd1 vccd1 _0241_ sky130_fd_sc_hd__a22o_1
X_2144_ CALC_INST.input_ctrl_inst.debounce_cnt\[4\] _1181_ vssd1 vssd1 vccd1 vccd1
+ _1184_ sky130_fd_sc_hd__or2_1
X_2213_ CALC_INST.gencon_inst.gencon_state\[0\] _1236_ vssd1 vssd1 vccd1 vccd1 _0379_
+ sky130_fd_sc_hd__and2b_1
XFILLER_26_329 vssd1 vssd1 vccd1 vccd1 sky130_fd_sc_hd__fill_1
X_2075_ _1094_ _1128_ vssd1 vssd1 vccd1 vccd1 _1129_ sky130_fd_sc_hd__or2_1
X_1928_ CALC_INST.input_ctrl_inst.decoded_key\[3\] _1011_ _1010_ vssd1 vssd1 vccd1
+ vccd1 _1012_ sky130_fd_sc_hd__o21ai_1
X_1859_ CALC_INST.input_ctrl_inst.col_index\[19\] net63 vssd1 vssd1 vccd1 vccd1 _0972_
+ sky130_fd_sc_hd__nand2_1
XFILLER_55_35 vssd1 vssd1 vccd1 vccd1 sky130_fd_sc_hd__fill_1
XFILLER_44_104 vssd1 vssd1 vccd1 vccd1 sky130_fd_sc_hd__fill_2
XFILLER_29_189 vssd1 vssd1 vccd1 vccd1 sky130_fd_sc_hd__fill_2
XFILLER_40_365 vssd1 vssd1 vccd1 vccd1 sky130_fd_sc_hd__fill_4
XFILLER_4_255 vssd1 vssd1 vccd1 vccd1 sky130_fd_sc_hd__fill_2
XTAP_TAPCELL_ROW_10_213 vssd1 vccd1 sky130_fd_sc_hd__tapvpwrvgnd_1
Xhold91 CALC_INST.gencon_inst.mult_calc.count.GENERATE_ADDER\[11\].thingy.in1 vssd1
+ vssd1 vccd1 vccd1 net287 sky130_fd_sc_hd__dlygate4sd3_1
Xhold80 CALC_INST.gencon_inst.mult_calc.main.GENERATE_ADDER\[14\].thingy.in1 vssd1
+ vssd1 vccd1 vccd1 net276 sky130_fd_sc_hd__dlygate4sd3_1
XFILLER_43_192 vssd1 vssd1 vccd1 vccd1 sky130_fd_sc_hd__fill_1
X_2831_ clknet_leaf_5_clk _0352_ vssd1 vssd1 vccd1 vccd1 CALC_INST.gencon_inst.keypad_input\[3\]
+ sky130_fd_sc_hd__dfxtp_1
X_2762_ clknet_leaf_21_clk _0291_ vssd1 vssd1 vccd1 vccd1 CALC_INST.gencon_inst.mult_calc.INn2\[5\]
+ sky130_fd_sc_hd__dfxtp_1
X_1713_ net231 net218 net96 vssd1 vssd1 vccd1 vccd1 _0225_ sky130_fd_sc_hd__mux2_1
X_1575_ _0813_ _0815_ _0820_ vssd1 vssd1 vccd1 vccd1 _0823_ sky130_fd_sc_hd__or3_1
X_2693_ clknet_leaf_23_clk _0231_ net144 vssd1 vssd1 vccd1 vccd1 CALC_INST.gencon_inst.mult_calc.main.GENERATE_ADDER\[9\].thingy.in1
+ sky130_fd_sc_hd__dfrtp_1
XFILLER_6_73 vssd1 vssd1 vccd1 vccd1 sky130_fd_sc_hd__fill_2
X_1644_ _0877_ _0879_ vssd1 vssd1 vccd1 vccd1 _0880_ sky130_fd_sc_hd__xnor2_1
XTAP_TAPCELL_ROW_49_482 vssd1 vccd1 sky130_fd_sc_hd__tapvpwrvgnd_1
X_2127_ _1072_ _1080_ vssd1 vssd1 vccd1 vccd1 _1170_ sky130_fd_sc_hd__and2_1
XFILLER_25_16 vssd1 vssd1 vccd1 vccd1 sky130_fd_sc_hd__fill_2
XTAP_TAPCELL_ROW_24_305 vssd1 vccd1 sky130_fd_sc_hd__tapvpwrvgnd_1
X_2058_ _1107_ _1109_ _1110_ CALC_INST.gencon_inst.mult_calc.compCount.in2\[5\] _1111_
+ vssd1 vssd1 vccd1 vccd1 _1112_ sky130_fd_sc_hd__a221o_1
XFILLER_49_229 vssd1 vssd1 vccd1 vccd1 sky130_fd_sc_hd__fill_2
XANTENNA_fanout84_A _0843_ vssd1 vssd1 vccd1 vccd1 sky130_fd_sc_hd__diode_2
XFILLER_45_402 vssd1 vssd1 vccd1 vccd1 sky130_fd_sc_hd__fill_1
XFILLER_40_184 vccd1 vssd1 vccd1 vssd1 sky130_ef_sc_hd__decap_40_12
XFILLER_63_9 vccd1 vssd1 vccd1 vssd1 sky130_ef_sc_hd__decap_40_12
X_1360_ CALC_INST.gencon_inst.operand2\[13\] CALC_INST.gencon_inst.operand1\[13\]
+ net73 vssd1 vssd1 vccd1 vccd1 _0654_ sky130_fd_sc_hd__mux2_1
Xteam_06_193 vssd1 vssd1 vccd1 vccd1 gpio_oeb[25] team_06_193/LO sky130_fd_sc_hd__conb_1
Xteam_06_182 vssd1 vssd1 vccd1 vccd1 gpio_oeb[14] team_06_182/LO sky130_fd_sc_hd__conb_1
Xteam_06_160 vssd1 vssd1 vccd1 vccd1 team_06_160/HI gpio_oeb[31] sky130_fd_sc_hd__conb_1
X_1291_ net213 _0642_ _0643_ _0387_ _0640_ vssd1 vssd1 vccd1 vccd1 _0081_ sky130_fd_sc_hd__o2111ai_1
XTAP_TAPCELL_ROW_38_408 vssd1 vccd1 sky130_fd_sc_hd__tapvpwrvgnd_1
Xteam_06_171 vssd1 vssd1 vccd1 vccd1 team_06_171/HI gpio_out[33] sky130_fd_sc_hd__conb_1
XANTENNA_clkbuf_leaf_9_clk_A clknet_2_1__leaf_clk vssd1 vssd1 vccd1 vccd1 sky130_fd_sc_hd__diode_2
XTAP_TAPCELL_ROW_46_463 vssd1 vccd1 sky130_fd_sc_hd__tapvpwrvgnd_1
XANTENNA__1302__B net112 vssd1 vssd1 vccd1 vccd1 sky130_fd_sc_hd__diode_2
XFILLER_31_162 vssd1 vssd1 vccd1 vccd1 sky130_fd_sc_hd__fill_1
X_2745_ clknet_leaf_26_clk _0283_ net140 vssd1 vssd1 vccd1 vccd1 CALC_INST.gencon_inst.mult_calc.countSave\[12\]
+ sky130_fd_sc_hd__dfrtp_1
X_2814_ clknet_leaf_32_clk _0335_ net118 vssd1 vssd1 vccd1 vccd1 CALC_INST.gencon_inst.mult_calc.count.GENERATE_ADDER\[1\].thingy.in1
+ sky130_fd_sc_hd__dfrtp_1
X_2676_ clknet_leaf_28_clk _0214_ net135 vssd1 vssd1 vccd1 vccd1 CALC_INST.gencon_inst.mult_calc.compCount.in2\[7\]
+ sky130_fd_sc_hd__dfrtp_1
X_1558_ _0712_ _0713_ vssd1 vssd1 vccd1 vccd1 _0809_ sky130_fd_sc_hd__and2b_1
X_1489_ _0740_ _0743_ _0745_ _0741_ _0737_ vssd1 vssd1 vccd1 vccd1 _0748_ sky130_fd_sc_hd__o311a_1
X_1627_ _0847_ _0850_ _0853_ _0857_ _0851_ vssd1 vssd1 vccd1 vccd1 _0865_ sky130_fd_sc_hd__o311a_1
XFILLER_36_26 vssd1 vssd1 vccd1 vccd1 sky130_fd_sc_hd__fill_2
XFILLER_27_402 vssd1 vssd1 vccd1 vccd1 sky130_fd_sc_hd__fill_4
XANTENNA__2324__A CALC_INST.gencon_inst.operand2\[3\] vssd1 vssd1 vccd1 vccd1 sky130_fd_sc_hd__diode_2
XFILLER_22_173 vssd1 vssd1 vccd1 vccd1 sky130_fd_sc_hd__fill_2
Xclkbuf_leaf_34_clk clknet_2_0__leaf_clk vssd1 vssd1 vccd1 vccd1 clknet_leaf_34_clk
+ sky130_fd_sc_hd__clkbuf_8
XFILLER_45_210 vccd1 vssd1 vccd1 vssd1 sky130_ef_sc_hd__decap_40_12
XTAP_TAPCELL_ROW_43_444 vssd1 vccd1 sky130_fd_sc_hd__tapvpwrvgnd_1
Xclkbuf_leaf_25_clk clknet_2_2__leaf_clk vssd1 vssd1 vccd1 vccd1 clknet_leaf_25_clk
+ sky130_fd_sc_hd__clkbuf_8
XFILLER_61_6 vccd1 vssd1 vccd1 vssd1 sky130_ef_sc_hd__decap_40_12
X_2530_ clknet_leaf_21_clk _0068_ net148 vssd1 vssd1 vccd1 vccd1 net9 sky130_fd_sc_hd__dfrtp_1
X_1412_ CALC_INST.gencon_inst.ALU_in1\[6\] CALC_INST.gencon_inst.ALU_in2\[6\] net65
+ vssd1 vssd1 vccd1 vccd1 _0681_ sky130_fd_sc_hd__mux2_1
X_2392_ CALC_INST.gencon_inst.operand1\[1\] CALC_INST.gencon_inst.latched_keypad_input\[1\]
+ vssd1 vssd1 vccd1 vccd1 _0529_ sky130_fd_sc_hd__and2_1
X_2461_ CALC_INST.gencon_inst.operand1\[13\] net42 _0584_ _0585_ vssd1 vssd1 vccd1
+ vccd1 _0060_ sky130_fd_sc_hd__o22a_1
XANTENNA__2240__Y _0405_ vssd1 vssd1 vccd1 vccd1 sky130_fd_sc_hd__diode_2
X_1343_ net111 _0642_ _0649_ vssd1 vssd1 vccd1 vccd1 _0650_ sky130_fd_sc_hd__o21a_1
X_1274_ CALC_INST.gencon_inst.operand1\[14\] _0397_ _0592_ net417 _0630_ vssd1 vssd1
+ vccd1 vccd1 _0077_ sky130_fd_sc_hd__o221a_1
Xwire47 _0930_ vssd1 vssd1 vccd1 vccd1 net47 sky130_fd_sc_hd__buf_1
Xclkbuf_leaf_16_clk clknet_2_3__leaf_clk vssd1 vssd1 vccd1 vccd1 clknet_leaf_16_clk
+ sky130_fd_sc_hd__clkbuf_8
X_2659_ clknet_leaf_29_clk _0197_ net137 vssd1 vssd1 vccd1 vccd1 CALC_INST.gencon_inst.mult_calc.adderSave\[5\]
+ sky130_fd_sc_hd__dfrtp_1
X_2728_ clknet_leaf_24_clk _0266_ net141 vssd1 vssd1 vccd1 vccd1 CALC_INST.gencon_inst.mult_calc.out\[13\]
+ sky130_fd_sc_hd__dfrtp_1
XTAP_TAPCELL_ROW_57_536 vssd1 vccd1 sky130_fd_sc_hd__tapvpwrvgnd_1
Xfanout145 net148 vssd1 vssd1 vccd1 vccd1 net145 sky130_fd_sc_hd__clkbuf_4
Xfanout112 _1057_ vssd1 vssd1 vccd1 vccd1 net112 sky130_fd_sc_hd__clkbuf_2
Xfanout123 net5 vssd1 vssd1 vccd1 vccd1 net123 sky130_fd_sc_hd__clkbuf_2
Xfanout134 net139 vssd1 vssd1 vccd1 vccd1 net134 sky130_fd_sc_hd__clkbuf_2
Xfanout101 CALC_INST.gencon_inst.mult_calc.next_finish vssd1 vssd1 vccd1 vccd1 net101
+ sky130_fd_sc_hd__clkbuf_4
XFILLER_27_276 vssd1 vssd1 vccd1 vccd1 sky130_fd_sc_hd__fill_2
XFILLER_12_94 vssd1 vssd1 vccd1 vccd1 sky130_fd_sc_hd__fill_1
X_1961_ CALC_INST.input_ctrl_inst.scan_timer\[5\] CALC_INST.input_ctrl_inst.scan_timer\[4\]
+ CALC_INST.input_ctrl_inst.scan_timer\[6\] _1028_ vssd1 vssd1 vccd1 vccd1 _1032_
+ sky130_fd_sc_hd__and4_2
X_1892_ CALC_INST.input_ctrl_inst.col_index\[28\] net62 _0995_ vssd1 vssd1 vccd1 vccd1
+ _0330_ sky130_fd_sc_hd__a21bo_1
X_2513_ clknet_leaf_20_clk _0055_ net150 vssd1 vssd1 vccd1 vccd1 CALC_INST.gencon_inst.operand1\[8\]
+ sky130_fd_sc_hd__dfrtp_2
XANTENNA__1736__A1 net94 vssd1 vssd1 vccd1 vccd1 sky130_fd_sc_hd__diode_2
XFILLER_56_338 vccd1 vssd1 vccd1 vssd1 sky130_ef_sc_hd__decap_40_12
XFILLER_56_305 vssd1 vssd1 vccd1 vccd1 sky130_fd_sc_hd__fill_2
X_1326_ CALC_INST.gencon_inst.operand2\[7\] net321 net52 vssd1 vssd1 vccd1 vccd1 _0113_
+ sky130_fd_sc_hd__mux2_1
X_2444_ CALC_INST.gencon_inst.operand1\[10\] _0568_ _0520_ vssd1 vssd1 vccd1 vccd1
+ _0572_ sky130_fd_sc_hd__a21oi_1
Xclkbuf_leaf_5_clk clknet_2_1__leaf_clk vssd1 vssd1 vccd1 vccd1 clknet_leaf_5_clk
+ sky130_fd_sc_hd__clkbuf_8
X_2375_ CALC_INST.gencon_inst.operand2\[13\] _0514_ net34 vssd1 vssd1 vccd1 vccd1
+ _0045_ sky130_fd_sc_hd__mux2_1
XFILLER_64_393 vssd1 vssd1 vccd1 vccd1 sky130_fd_sc_hd__fill_8
XTAP_TAPCELL_ROW_54_517 vssd1 vccd1 sky130_fd_sc_hd__tapvpwrvgnd_1
XFILLER_49_390 vssd1 vssd1 vccd1 vccd1 sky130_fd_sc_hd__fill_2
X_1257_ CALC_INST.gencon_inst.ALU_out\[9\] net71 net54 CALC_INST.gencon_inst.mult_calc.out\[9\]
+ net57 vssd1 vssd1 vccd1 vccd1 _0619_ sky130_fd_sc_hd__a221o_1
XTAP_TAPCELL_ROW_19_271 vssd1 vccd1 sky130_fd_sc_hd__tapvpwrvgnd_1
XTAP_TAPCELL_ROW_62_572 vssd1 vccd1 sky130_fd_sc_hd__tapvpwrvgnd_1
XFILLER_24_279 vccd1 vssd1 vccd1 vssd1 sky130_ef_sc_hd__decap_40_12
XFILLER_59_110 vssd1 vssd1 vccd1 vccd1 sky130_fd_sc_hd__fill_2
XANTENNA__2483__S net73 vssd1 vssd1 vccd1 vccd1 sky130_fd_sc_hd__diode_2
XFILLER_30_227 vssd1 vssd1 vccd1 vccd1 sky130_fd_sc_hd__fill_2
XANTENNA_clkbuf_leaf_34_clk_A clknet_2_0__leaf_clk vssd1 vssd1 vccd1 vccd1 sky130_fd_sc_hd__diode_2
XFILLER_7_401 vssd1 vssd1 vccd1 vccd1 sky130_fd_sc_hd__fill_2
X_2160_ _1195_ vssd1 vssd1 vccd1 vccd1 _1196_ sky130_fd_sc_hd__inv_2
XFILLER_38_316 vssd1 vssd1 vccd1 vccd1 sky130_fd_sc_hd__fill_1
XFILLER_31_7 vssd1 vssd1 vccd1 vccd1 sky130_fd_sc_hd__fill_2
XFILLER_2_161 vssd1 vssd1 vccd1 vccd1 sky130_fd_sc_hd__fill_2
XFILLER_61_341 vssd1 vssd1 vccd1 vccd1 sky130_fd_sc_hd__fill_1
X_2091_ net99 _1138_ _1144_ vssd1 vssd1 vccd1 vccd1 _0006_ sky130_fd_sc_hd__a21o_1
X_1944_ net124 net79 net370 vssd1 vssd1 vccd1 vccd1 _1022_ sky130_fd_sc_hd__a21oi_1
X_1875_ _0441_ _0955_ CALC_INST.input_ctrl_inst.col_index\[24\] vssd1 vssd1 vccd1
+ vccd1 _0983_ sky130_fd_sc_hd__a21oi_1
XTAP_TAPCELL_ROW_16_252 vssd1 vccd1 sky130_fd_sc_hd__tapvpwrvgnd_1
X_2427_ CALC_INST.gencon_inst.ALU_out\[6\] net70 net59 CALC_INST.gencon_inst.mult_calc.out\[6\]
+ net41 vssd1 vssd1 vccd1 vccd1 _0559_ sky130_fd_sc_hd__a221o_1
X_1309_ CALC_INST.gencon_inst.operand1\[6\] net315 net52 vssd1 vssd1 vccd1 vccd1 _0096_
+ sky130_fd_sc_hd__mux2_1
X_2358_ CALC_INST.gencon_inst.operand2\[9\] _0501_ net34 vssd1 vssd1 vccd1 vccd1 _0041_
+ sky130_fd_sc_hd__mux2_1
X_2289_ _1067_ CALC_INST.input_ctrl_inst.col_index\[28\] _0443_ vssd1 vssd1 vccd1
+ vccd1 _0451_ sky130_fd_sc_hd__o21a_1
XFILLER_52_385 vssd1 vssd1 vccd1 vccd1 sky130_fd_sc_hd__fill_2
XFILLER_52_330 vssd1 vssd1 vccd1 vccd1 sky130_fd_sc_hd__fill_2
XFILLER_60_47 vssd1 vssd1 vccd1 vccd1 sky130_fd_sc_hd__fill_2
XFILLER_47_113 vssd1 vssd1 vccd1 vccd1 sky130_fd_sc_hd__fill_4
XFILLER_47_135 vssd1 vssd1 vccd1 vccd1 sky130_fd_sc_hd__fill_1
XFILLER_43_352 vssd1 vssd1 vccd1 vccd1 sky130_fd_sc_hd__fill_1
XTAP_TAPCELL_ROW_13_233 vssd1 vccd1 sky130_fd_sc_hd__tapvpwrvgnd_1
X_1591_ _0835_ _0836_ CALC_INST.gencon_inst.add_calc.state\[1\] CALC_INST.gencon_inst.ALU_out\[14\]
+ vssd1 vssd1 vccd1 vccd1 _0188_ sky130_fd_sc_hd__o2bb2a_1
XFILLER_50_80 vssd1 vssd1 vccd1 vccd1 sky130_fd_sc_hd__fill_4
XANTENNA__2364__A1 CALC_INST.gencon_inst.operand2\[10\] vssd1 vssd1 vccd1 vccd1 sky130_fd_sc_hd__diode_2
X_1660_ CALC_INST.gencon_inst.mult_calc.main.GENERATE_ADDER\[9\].thingy.in2 CALC_INST.gencon_inst.mult_calc.main.GENERATE_ADDER\[9\].thingy.in1
+ vssd1 vssd1 vccd1 vccd1 _0893_ sky130_fd_sc_hd__or2_1
XFILLER_7_275 vssd1 vssd1 vccd1 vccd1 sky130_fd_sc_hd__fill_1
Xhold209 CALC_INST.gencon_inst.mult_calc.compCount.in2\[1\] vssd1 vssd1 vccd1 vccd1
+ net405 sky130_fd_sc_hd__dlygate4sd3_1
X_2143_ net36 _1182_ _1183_ net45 net319 vssd1 vssd1 vccd1 vccd1 _0020_ sky130_fd_sc_hd__a32o_1
X_2212_ _1233_ _1236_ vssd1 vssd1 vccd1 vccd1 _0378_ sky130_fd_sc_hd__nor2_1
X_2074_ CALC_INST.gencon_inst.mult_calc.count.GENERATE_ADDER\[10\].thingy.in1 _1093_
+ CALC_INST.gencon_inst.mult_calc.count.GENERATE_ADDER\[11\].thingy.in1 vssd1 vssd1
+ vccd1 vccd1 _1128_ sky130_fd_sc_hd__a21oi_1
X_1927_ _1151_ _1008_ vssd1 vssd1 vccd1 vccd1 _1011_ sky130_fd_sc_hd__nand2_1
X_1858_ _0947_ _0971_ _0970_ vssd1 vssd1 vccd1 vccd1 _0320_ sky130_fd_sc_hd__o21ai_1
X_1789_ CALC_INST.gencon_inst.operand2\[13\] net49 net39 net424 vssd1 vssd1 vccd1
+ vccd1 _0299_ sky130_fd_sc_hd__a22o_1
XFILLER_29_113 vssd1 vssd1 vccd1 vccd1 sky130_fd_sc_hd__fill_4
XFILLER_17_319 vccd1 vssd1 vccd1 vssd1 sky130_ef_sc_hd__decap_40_12
XFILLER_25_363 vssd1 vssd1 vccd1 vccd1 sky130_fd_sc_hd__fill_1
XFILLER_4_201 vssd1 vssd1 vccd1 vccd1 sky130_fd_sc_hd__fill_1
XFILLER_20_83 vssd1 vssd1 vccd1 vccd1 sky130_fd_sc_hd__fill_1
Xhold81 CALC_INST.gencon_inst.ALU_in1\[3\] vssd1 vssd1 vccd1 vccd1 net277 sky130_fd_sc_hd__dlygate4sd3_1
Xhold92 CALC_INST.gencon_inst.latched_operator_input\[1\] vssd1 vssd1 vccd1 vccd1
+ net288 sky130_fd_sc_hd__dlygate4sd3_1
Xhold70 CALC_INST.gencon_inst.mult_calc.INn2\[3\] vssd1 vssd1 vccd1 vccd1 net266 sky130_fd_sc_hd__dlygate4sd3_1
X_2830_ clknet_leaf_5_clk _0351_ vssd1 vssd1 vccd1 vccd1 CALC_INST.gencon_inst.keypad_input\[2\]
+ sky130_fd_sc_hd__dfxtp_1
XFILLER_16_385 vssd1 vssd1 vccd1 vccd1 sky130_fd_sc_hd__fill_2
X_2761_ clknet_leaf_21_clk _0290_ vssd1 vssd1 vccd1 vccd1 CALC_INST.gencon_inst.mult_calc.INn2\[4\]
+ sky130_fd_sc_hd__dfxtp_1
X_2692_ clknet_leaf_23_clk _0230_ net144 vssd1 vssd1 vccd1 vccd1 CALC_INST.gencon_inst.mult_calc.main.GENERATE_ADDER\[8\].thingy.in1
+ sky130_fd_sc_hd__dfrtp_1
X_1712_ net229 net214 net95 vssd1 vssd1 vccd1 vccd1 _0224_ sky130_fd_sc_hd__mux2_1
X_1643_ _0869_ _0878_ vssd1 vssd1 vccd1 vccd1 _0879_ sky130_fd_sc_hd__or2_1
XFILLER_58_208 vccd1 vssd1 vccd1 vssd1 sky130_ef_sc_hd__decap_40_12
X_1574_ _0822_ _0821_ CALC_INST.gencon_inst.ALU_out\[11\] net80 vssd1 vssd1 vccd1
+ vccd1 _0185_ sky130_fd_sc_hd__a2bb2o_1
XFILLER_6_96 vssd1 vssd1 vccd1 vccd1 sky130_fd_sc_hd__fill_2
XTAP_TAPCELL_ROW_49_483 vssd1 vccd1 sky130_fd_sc_hd__tapvpwrvgnd_1
X_2126_ _1075_ _1167_ _1169_ _1079_ vssd1 vssd1 vccd1 vccd1 _0008_ sky130_fd_sc_hd__a22o_1
X_2057_ _1054_ _1108_ vssd1 vssd1 vccd1 vccd1 _1111_ sky130_fd_sc_hd__nor2_1
XTAP_TAPCELL_ROW_32_361 vssd1 vccd1 sky130_fd_sc_hd__tapvpwrvgnd_1
XFILLER_25_39 vssd1 vssd1 vccd1 vccd1 sky130_fd_sc_hd__fill_2
XTAP_TAPCELL_ROW_24_306 vssd1 vccd1 sky130_fd_sc_hd__tapvpwrvgnd_1
XFILLER_9_7 vssd1 vssd1 vccd1 vccd1 sky130_fd_sc_hd__fill_4
XANTENNA_fanout77_A _1145_ vssd1 vssd1 vccd1 vccd1 sky130_fd_sc_hd__diode_2
XFILLER_17_105 vssd1 vssd1 vccd1 vccd1 sky130_fd_sc_hd__fill_2
XFILLER_40_174 vssd1 vssd1 vccd1 vccd1 sky130_fd_sc_hd__fill_2
XFILLER_40_152 vssd1 vssd1 vccd1 vccd1 sky130_fd_sc_hd__fill_1
XFILLER_9_337 vssd1 vssd1 vccd1 vccd1 sky130_fd_sc_hd__fill_4
Xteam_06_183 vssd1 vssd1 vccd1 vccd1 gpio_oeb[15] team_06_183/LO sky130_fd_sc_hd__conb_1
Xteam_06_172 vssd1 vssd1 vccd1 vccd1 gpio_oeb[4] team_06_172/LO sky130_fd_sc_hd__conb_1
Xteam_06_161 vssd1 vssd1 vccd1 vccd1 team_06_161/HI gpio_oeb[32] sky130_fd_sc_hd__conb_1
Xteam_06_194 vssd1 vssd1 vccd1 vccd1 gpio_oeb[26] team_06_194/LO sky130_fd_sc_hd__conb_1
X_1290_ net205 _0641_ net56 vssd1 vssd1 vccd1 vccd1 _0643_ sky130_fd_sc_hd__or3b_1
XTAP_TAPCELL_ROW_38_409 vssd1 vccd1 sky130_fd_sc_hd__tapvpwrvgnd_1
XFILLER_0_281 vssd1 vssd1 vccd1 vccd1 sky130_fd_sc_hd__fill_2
XFILLER_51_406 vssd1 vssd1 vccd1 vccd1 sky130_fd_sc_hd__fill_1
XTAP_TAPCELL_ROW_46_464 vssd1 vccd1 sky130_fd_sc_hd__tapvpwrvgnd_1
XFILLER_23_108 vssd1 vssd1 vccd1 vccd1 sky130_fd_sc_hd__fill_1
X_2813_ clknet_leaf_32_clk _0334_ net118 vssd1 vssd1 vccd1 vccd1 CALC_INST.gencon_inst.mult_calc.count.GENERATE_ADDER\[1\].thingy.cIn
+ sky130_fd_sc_hd__dfrtp_2
X_2744_ clknet_leaf_26_clk _0282_ net140 vssd1 vssd1 vccd1 vccd1 CALC_INST.gencon_inst.mult_calc.countSave\[11\]
+ sky130_fd_sc_hd__dfrtp_1
X_2675_ clknet_leaf_27_clk _0213_ net134 vssd1 vssd1 vccd1 vccd1 CALC_INST.gencon_inst.mult_calc.compCount.in2\[6\]
+ sky130_fd_sc_hd__dfrtp_1
X_1626_ _0862_ _0863_ vssd1 vssd1 vccd1 vccd1 _0864_ sky130_fd_sc_hd__and2b_1
X_1557_ _0803_ _0805_ vssd1 vssd1 vccd1 vccd1 _0808_ sky130_fd_sc_hd__or2_1
X_1488_ _0740_ _0743_ _0745_ _0741_ vssd1 vssd1 vccd1 vccd1 _0747_ sky130_fd_sc_hd__o31a_1
XFILLER_54_299 vssd1 vssd1 vccd1 vccd1 sky130_fd_sc_hd__fill_2
XFILLER_54_233 vssd1 vssd1 vccd1 vccd1 sky130_fd_sc_hd__fill_8
XFILLER_52_15 vssd1 vssd1 vccd1 vccd1 sky130_fd_sc_hd__fill_4
XFILLER_39_263 vssd1 vssd1 vccd1 vccd1 sky130_fd_sc_hd__fill_2
X_2109_ _1148_ _1155_ vssd1 vssd1 vccd1 vccd1 _0028_ sky130_fd_sc_hd__or2_1
XFILLER_45_222 vssd1 vssd1 vccd1 vccd1 sky130_fd_sc_hd__fill_2
XANTENNA__2485__B1 net54 vssd1 vssd1 vccd1 vccd1 sky130_fd_sc_hd__diode_2
XFILLER_45_277 vssd1 vssd1 vccd1 vccd1 sky130_fd_sc_hd__fill_2
XFILLER_26_82 vssd1 vssd1 vccd1 vccd1 sky130_fd_sc_hd__fill_2
X_2460_ CALC_INST.gencon_inst.ALU_out\[13\] net69 net58 CALC_INST.gencon_inst.mult_calc.out\[13\]
+ _0524_ vssd1 vssd1 vccd1 vccd1 _0585_ sky130_fd_sc_hd__a221o_1
XFILLER_13_196 vssd1 vssd1 vccd1 vccd1 sky130_fd_sc_hd__fill_2
X_1411_ net416 _0680_ net108 vssd1 vssd1 vccd1 vccd1 _0164_ sky130_fd_sc_hd__mux2_1
X_1273_ CALC_INST.gencon_inst.mult_calc.out\[14\] net55 _0629_ vssd1 vssd1 vccd1 vccd1
+ _0630_ sky130_fd_sc_hd__a21o_1
X_2391_ CALC_INST.gencon_inst.operand1\[0\] net42 _0527_ _0528_ vssd1 vssd1 vccd1
+ vccd1 _0047_ sky130_fd_sc_hd__o22a_1
X_1342_ net48 vssd1 vssd1 vccd1 vccd1 _0649_ sky130_fd_sc_hd__inv_2
XFILLER_51_236 vssd1 vssd1 vccd1 vccd1 sky130_fd_sc_hd__fill_1
XFILLER_24_406 vssd1 vssd1 vccd1 vccd1 sky130_fd_sc_hd__fill_1
XANTENNA_fanout127_A net132 vssd1 vssd1 vccd1 vccd1 sky130_fd_sc_hd__diode_2
XFILLER_22_29 vssd1 vssd1 vccd1 vccd1 sky130_fd_sc_hd__fill_4
X_2589_ clknet_leaf_3_clk _0127_ vssd1 vssd1 vccd1 vccd1 CALC_INST.gencon_inst.mult_calc.INn1\[0\]
+ sky130_fd_sc_hd__dfxtp_1
Xfanout113 net114 vssd1 vssd1 vccd1 vccd1 net113 sky130_fd_sc_hd__clkbuf_4
X_2658_ clknet_leaf_28_clk _0196_ net133 vssd1 vssd1 vccd1 vccd1 CALC_INST.gencon_inst.mult_calc.adderSave\[4\]
+ sky130_fd_sc_hd__dfrtp_1
Xfanout102 CALC_INST.gencon_inst.mult_calc.next_finish vssd1 vssd1 vccd1 vccd1 net102
+ sky130_fd_sc_hd__clkbuf_4
X_2727_ clknet_leaf_24_clk _0265_ net143 vssd1 vssd1 vccd1 vccd1 CALC_INST.gencon_inst.mult_calc.out\[12\]
+ sky130_fd_sc_hd__dfrtp_1
X_1609_ net99 _0848_ _0849_ net339 net85 vssd1 vssd1 vccd1 vccd1 _0193_ sky130_fd_sc_hd__a32o_1
XTAP_TAPCELL_ROW_57_537 vssd1 vccd1 sky130_fd_sc_hd__tapvpwrvgnd_1
Xfanout146 net147 vssd1 vssd1 vccd1 vccd1 net146 sky130_fd_sc_hd__clkbuf_4
Xfanout124 net125 vssd1 vssd1 vccd1 vccd1 net124 sky130_fd_sc_hd__clkbuf_4
XANTENNA_input1_A gpio_in[0] vssd1 vssd1 vccd1 vccd1 sky130_fd_sc_hd__diode_2
Xfanout135 net139 vssd1 vssd1 vccd1 vccd1 net135 sky130_fd_sc_hd__clkbuf_4
XANTENNA__1690__B2 net86 vssd1 vssd1 vccd1 vccd1 sky130_fd_sc_hd__diode_2
XANTENNA__1690__A1 net100 vssd1 vssd1 vccd1 vccd1 sky130_fd_sc_hd__diode_2
XANTENNA__1385__S net109 vssd1 vssd1 vccd1 vccd1 sky130_fd_sc_hd__diode_2
XANTENNA__1993__A2 net112 vssd1 vssd1 vccd1 vccd1 sky130_fd_sc_hd__diode_2
XANTENNA_clkbuf_leaf_8_clk_A clknet_2_1__leaf_clk vssd1 vssd1 vccd1 vccd1 sky130_fd_sc_hd__diode_2
XFILLER_2_365 vccd1 vssd1 vccd1 vssd1 sky130_ef_sc_hd__decap_40_12
XANTENNA__2458__B1 _0520_ vssd1 vssd1 vccd1 vccd1 sky130_fd_sc_hd__diode_2
XFILLER_33_225 vssd1 vssd1 vccd1 vccd1 sky130_fd_sc_hd__fill_2
X_1960_ CALC_INST.input_ctrl_inst.scan_timer\[5\] CALC_INST.input_ctrl_inst.scan_timer\[4\]
+ _1028_ CALC_INST.input_ctrl_inst.scan_timer\[6\] vssd1 vssd1 vccd1 vccd1 _1031_
+ sky130_fd_sc_hd__a31o_1
X_1891_ _0945_ _0993_ _0994_ vssd1 vssd1 vccd1 vccd1 _0995_ sky130_fd_sc_hd__or3_1
XFILLER_52_3 vccd1 vssd1 vccd1 vssd1 sky130_ef_sc_hd__decap_40_12
X_2443_ CALC_INST.gencon_inst.operand1\[9\] net43 _0570_ _0571_ vssd1 vssd1 vccd1
+ vccd1 _0056_ sky130_fd_sc_hd__o22a_1
X_2512_ clknet_leaf_20_clk _0054_ net145 vssd1 vssd1 vccd1 vccd1 CALC_INST.gencon_inst.operand1\[7\]
+ sky130_fd_sc_hd__dfrtp_1
XFILLER_56_328 vssd1 vssd1 vccd1 vccd1 sky130_fd_sc_hd__fill_1
X_1325_ CALC_INST.gencon_inst.operand2\[6\] net258 net52 vssd1 vssd1 vccd1 vccd1 _0112_
+ sky130_fd_sc_hd__mux2_1
X_1256_ _1234_ _0617_ vssd1 vssd1 vccd1 vccd1 _0618_ sky130_fd_sc_hd__and2_1
X_2374_ _0404_ _0512_ _0513_ _0456_ CALC_INST.gencon_inst.mult_calc.out\[13\] vssd1
+ vssd1 vccd1 vccd1 _0514_ sky130_fd_sc_hd__a32o_1
XFILLER_64_361 vssd1 vssd1 vccd1 vccd1 sky130_fd_sc_hd__fill_2
XTAP_TAPCELL_ROW_62_573 vssd1 vccd1 sky130_fd_sc_hd__tapvpwrvgnd_1
XTAP_TAPCELL_ROW_54_518 vssd1 vccd1 sky130_fd_sc_hd__tapvpwrvgnd_1
XANTENNA__1672__B2 net100 vssd1 vssd1 vccd1 vccd1 sky130_fd_sc_hd__diode_2
XTAP_TAPCELL_ROW_19_272 vssd1 vccd1 sky130_fd_sc_hd__tapvpwrvgnd_1
XFILLER_32_280 vssd1 vssd1 vccd1 vccd1 sky130_fd_sc_hd__fill_1
XFILLER_55_383 vssd1 vssd1 vccd1 vccd1 sky130_fd_sc_hd__fill_1
XTAP_TAPCELL_ROW_2_151 vssd1 vccd1 sky130_fd_sc_hd__tapvpwrvgnd_1
X_2090_ CALC_INST.gencon_inst.mult_calc.start net101 _1143_ net95 vssd1 vssd1 vccd1
+ vccd1 _1144_ sky130_fd_sc_hd__a22o_1
XFILLER_64_90 vccd1 vssd1 vccd1 vssd1 sky130_ef_sc_hd__decap_40_12
XFILLER_61_331 vssd1 vssd1 vccd1 vccd1 sky130_fd_sc_hd__fill_4
XFILLER_0_32 vccd1 vssd1 vccd1 vssd1 sky130_ef_sc_hd__decap_40_12
XFILLER_9_30 vssd1 vssd1 vccd1 vccd1 sky130_fd_sc_hd__fill_1
XTAP_TAPCELL_ROW_16_253 vssd1 vccd1 sky130_fd_sc_hd__tapvpwrvgnd_1
X_1943_ CALC_INST.input_ctrl_inst.decoded_key\[1\] _1150_ net79 net124 vssd1 vssd1
+ vccd1 vccd1 _1021_ sky130_fd_sc_hd__o211a_1
X_1874_ _1066_ CALC_INST.input_ctrl_inst.col_index\[22\] _0980_ _0982_ vssd1 vssd1
+ vccd1 vccd1 _0325_ sky130_fd_sc_hd__a31o_1
XFILLER_9_74 vssd1 vssd1 vccd1 vccd1 sky130_fd_sc_hd__fill_1
XANTENNA__1590__B1 CALC_INST.gencon_inst.add_calc.state\[1\] vssd1 vssd1 vccd1 vccd1
+ sky130_fd_sc_hd__diode_2
X_2426_ _0556_ _0557_ _0519_ vssd1 vssd1 vccd1 vccd1 _0558_ sky130_fd_sc_hd__and3b_1
XFILLER_52_320 vssd1 vssd1 vccd1 vccd1 sky130_fd_sc_hd__fill_2
X_1308_ CALC_INST.gencon_inst.operand1\[5\] net268 net50 vssd1 vssd1 vccd1 vccd1 _0095_
+ sky130_fd_sc_hd__mux2_1
X_1239_ CALC_INST.gencon_inst.ALU_out\[4\] net68 net54 CALC_INST.gencon_inst.mult_calc.out\[4\]
+ vssd1 vssd1 vccd1 vccd1 _0606_ sky130_fd_sc_hd__a22o_1
X_2357_ _0499_ _0500_ CALC_INST.gencon_inst.mult_calc.out\[9\] net44 vssd1 vssd1 vccd1
+ vccd1 _0501_ sky130_fd_sc_hd__a2bb2o_1
X_2288_ _0424_ _0449_ _0447_ _0441_ vssd1 vssd1 vccd1 vccd1 _0450_ sky130_fd_sc_hd__o211ai_1
XFILLER_64_191 vssd1 vssd1 vccd1 vccd1 sky130_fd_sc_hd__fill_1
XFILLER_60_37 vssd1 vssd1 vccd1 vccd1 sky130_fd_sc_hd__fill_1
XANTENNA__1645__B2 net100 vssd1 vssd1 vccd1 vccd1 sky130_fd_sc_hd__diode_2
XANTENNA__2332__B _1234_ vssd1 vssd1 vccd1 vccd1 sky130_fd_sc_hd__diode_2
XFILLER_62_139 vssd1 vssd1 vccd1 vccd1 sky130_fd_sc_hd__fill_1
XFILLER_43_320 vssd1 vssd1 vccd1 vccd1 sky130_fd_sc_hd__fill_1
XFILLER_34_60 vssd1 vssd1 vccd1 vccd1 sky130_fd_sc_hd__fill_8
XTAP_TAPCELL_ROW_13_234 vssd1 vccd1 sky130_fd_sc_hd__tapvpwrvgnd_1
X_1590_ _0832_ _0834_ CALC_INST.gencon_inst.add_calc.state\[1\] vssd1 vssd1 vccd1
+ vccd1 _0836_ sky130_fd_sc_hd__o21a_1
XFILLER_59_90 vccd1 vssd1 vccd1 vssd1 sky130_ef_sc_hd__decap_40_12
X_2142_ CALC_INST.input_ctrl_inst.debounce_cnt\[2\] CALC_INST.input_ctrl_inst.debounce_cnt\[0\]
+ CALC_INST.input_ctrl_inst.debounce_cnt\[1\] CALC_INST.input_ctrl_inst.debounce_cnt\[3\]
+ vssd1 vssd1 vccd1 vccd1 _1183_ sky130_fd_sc_hd__a31o_1
X_2211_ CALC_INST.gencon_inst.gencon_state\[1\] _1235_ vssd1 vssd1 vccd1 vccd1 _1236_
+ sky130_fd_sc_hd__nor2_1
XFILLER_19_350 vssd1 vssd1 vccd1 vccd1 sky130_fd_sc_hd__fill_1
X_2073_ CALC_INST.gencon_inst.mult_calc.compCount.in2\[9\] _1123_ _1124_ _1121_ _1126_
+ vssd1 vssd1 vccd1 vccd1 _1127_ sky130_fd_sc_hd__o221a_1
XPHY_EDGE_ROW_28_Left_93 vssd1 vssd1 vccd1 vccd1 sky130_fd_sc_hd__decap_3
X_1926_ CALC_INST.input_ctrl_inst.decoded_key\[2\] _1062_ _1008_ vssd1 vssd1 vccd1
+ vccd1 _1010_ sky130_fd_sc_hd__or3_1
XFILLER_30_29 vssd1 vssd1 vccd1 vccd1 sky130_fd_sc_hd__fill_8
X_1788_ CALC_INST.gencon_inst.operand2\[12\] net48 net38 net349 vssd1 vssd1 vccd1
+ vccd1 _0298_ sky130_fd_sc_hd__a22o_1
X_1857_ CALC_INST.input_ctrl_inst.col_index\[18\] _0968_ vssd1 vssd1 vccd1 vccd1 _0971_
+ sky130_fd_sc_hd__xnor2_1
XPHY_EDGE_ROW_12_Left_77 vssd1 vssd1 vccd1 vccd1 sky130_fd_sc_hd__decap_3
X_2409_ CALC_INST.gencon_inst.operand1\[3\] CALC_INST.gencon_inst.latched_keypad_input\[3\]
+ vssd1 vssd1 vccd1 vccd1 _0544_ sky130_fd_sc_hd__or2_1
XANTENNA_clkbuf_leaf_33_clk_A clknet_2_0__leaf_clk vssd1 vssd1 vccd1 vccd1 sky130_fd_sc_hd__diode_2
XFILLER_44_106 vssd1 vssd1 vccd1 vccd1 sky130_fd_sc_hd__fill_1
XFILLER_29_169 vssd1 vssd1 vccd1 vccd1 sky130_fd_sc_hd__fill_4
XTAP_TAPCELL_ROW_27_326 vssd1 vccd1 sky130_fd_sc_hd__tapvpwrvgnd_1
XFILLER_52_194 vssd1 vssd1 vccd1 vccd1 sky130_fd_sc_hd__fill_2
XFILLER_4_257 vssd1 vssd1 vccd1 vccd1 sky130_fd_sc_hd__fill_1
Xhold60 CALC_INST.gencon_inst.mult_calc.INn1\[11\] vssd1 vssd1 vccd1 vccd1 net256
+ sky130_fd_sc_hd__dlygate4sd3_1
Xhold82 CALC_INST.gencon_inst.mult_calc.count.GENERATE_ADDER\[6\].thingy.in1 vssd1
+ vssd1 vccd1 vccd1 net278 sky130_fd_sc_hd__dlygate4sd3_1
Xhold71 CALC_INST.gencon_inst.mult_calc.countSave\[7\] vssd1 vssd1 vccd1 vccd1 net267
+ sky130_fd_sc_hd__dlygate4sd3_1
Xhold93 CALC_INST.gencon_inst.mult_calc.countSave\[14\] vssd1 vssd1 vccd1 vccd1 net289
+ sky130_fd_sc_hd__dlygate4sd3_1
XFILLER_45_81 vssd1 vssd1 vccd1 vccd1 sky130_fd_sc_hd__fill_4
XFILLER_31_345 vssd1 vssd1 vccd1 vccd1 sky130_fd_sc_hd__fill_8
X_2760_ clknet_leaf_30_clk _0289_ vssd1 vssd1 vccd1 vccd1 CALC_INST.gencon_inst.mult_calc.INn2\[3\]
+ sky130_fd_sc_hd__dfxtp_1
X_1711_ CALC_INST.gencon_inst.mult_calc.main.GENERATE_ADDER\[1\].thingy.in1 net201
+ net95 vssd1 vssd1 vccd1 vccd1 _0223_ sky130_fd_sc_hd__mux2_1
X_2691_ clknet_leaf_22_clk _0229_ net138 vssd1 vssd1 vccd1 vccd1 CALC_INST.gencon_inst.mult_calc.main.GENERATE_ADDER\[7\].thingy.in1
+ sky130_fd_sc_hd__dfrtp_1
XFILLER_6_42 vssd1 vssd1 vccd1 vccd1 sky130_fd_sc_hd__fill_2
X_1642_ _0856_ _0862_ _0865_ _0870_ _0863_ vssd1 vssd1 vccd1 vccd1 _0878_ sky130_fd_sc_hd__o311a_1
X_1573_ net33 _0818_ _0820_ net80 vssd1 vssd1 vccd1 vccd1 _0822_ sky130_fd_sc_hd__a31o_1
XTAP_TAPCELL_ROW_49_484 vssd1 vccd1 sky130_fd_sc_hd__tapvpwrvgnd_1
X_2125_ CALC_INST.input_ctrl_inst.debounce_cnt\[0\] _1074_ _1078_ _1168_ vssd1 vssd1
+ vccd1 vccd1 _1169_ sky130_fd_sc_hd__a31o_1
XTAP_TAPCELL_ROW_24_307 vssd1 vccd1 sky130_fd_sc_hd__tapvpwrvgnd_1
X_2056_ CALC_INST.gencon_inst.mult_calc.count.GENERATE_ADDER\[5\].thingy.in1 _1090_
+ vssd1 vssd1 vccd1 vccd1 _1110_ sky130_fd_sc_hd__xor2_1
XFILLER_34_172 vssd1 vssd1 vccd1 vccd1 sky130_fd_sc_hd__fill_8
XTAP_TAPCELL_ROW_32_362 vssd1 vccd1 sky130_fd_sc_hd__tapvpwrvgnd_1
X_1909_ net91 net274 net75 net278 vssd1 vssd1 vccd1 vccd1 _0340_ sky130_fd_sc_hd__a22o_1
XANTENNA_fanout112_X net112 vssd1 vssd1 vccd1 vccd1 sky130_fd_sc_hd__diode_2
XFILLER_1_227 vssd1 vssd1 vccd1 vccd1 sky130_fd_sc_hd__fill_1
XFILLER_57_242 vssd1 vssd1 vccd1 vccd1 sky130_fd_sc_hd__fill_1
XFILLER_9_316 vssd1 vssd1 vccd1 vccd1 sky130_fd_sc_hd__fill_4
XFILLER_40_164 vssd1 vssd1 vccd1 vccd1 sky130_fd_sc_hd__fill_8
XANTENNA__1775__B1 net86 vssd1 vssd1 vccd1 vccd1 sky130_fd_sc_hd__diode_2
Xteam_06_173 vssd1 vssd1 vccd1 vccd1 gpio_oeb[5] team_06_173/LO sky130_fd_sc_hd__conb_1
Xteam_06_195 vssd1 vssd1 vccd1 vccd1 gpio_oeb[27] team_06_195/LO sky130_fd_sc_hd__conb_1
Xteam_06_184 vssd1 vssd1 vccd1 vccd1 gpio_oeb[16] team_06_184/LO sky130_fd_sc_hd__conb_1
Xteam_06_162 vssd1 vssd1 vccd1 vccd1 team_06_162/HI gpio_oeb[33] sky130_fd_sc_hd__conb_1
XFILLER_63_245 vssd1 vssd1 vccd1 vccd1 sky130_fd_sc_hd__fill_2
XFILLER_48_286 vssd1 vssd1 vccd1 vccd1 sky130_fd_sc_hd__fill_2
XTAP_TAPCELL_ROW_46_465 vssd1 vccd1 sky130_fd_sc_hd__tapvpwrvgnd_1
X_2812_ clknet_leaf_2_clk net4 net115 vssd1 vssd1 vccd1 vccd1 CALC_INST.input_ctrl_inst.RowMid\[3\]
+ sky130_fd_sc_hd__dfstp_1
X_2743_ clknet_leaf_26_clk _0281_ net135 vssd1 vssd1 vccd1 vccd1 CALC_INST.gencon_inst.mult_calc.countSave\[10\]
+ sky130_fd_sc_hd__dfrtp_1
X_1556_ _0807_ _0806_ CALC_INST.gencon_inst.ALU_out\[8\] _1061_ vssd1 vssd1 vccd1
+ vccd1 _0182_ sky130_fd_sc_hd__a2bb2o_1
XANTENNA__1766__B1 net84 vssd1 vssd1 vccd1 vccd1 sky130_fd_sc_hd__diode_2
XFILLER_8_360 vssd1 vssd1 vccd1 vccd1 sky130_fd_sc_hd__fill_4
X_2674_ clknet_leaf_28_clk _0212_ net134 vssd1 vssd1 vccd1 vccd1 CALC_INST.gencon_inst.mult_calc.compCount.in2\[5\]
+ sky130_fd_sc_hd__dfrtp_1
X_1625_ CALC_INST.gencon_inst.mult_calc.main.GENERATE_ADDER\[4\].thingy.in2 CALC_INST.gencon_inst.mult_calc.main.GENERATE_ADDER\[4\].thingy.in1
+ vssd1 vssd1 vccd1 vccd1 _0863_ sky130_fd_sc_hd__nand2_1
X_1487_ _0743_ _0745_ vssd1 vssd1 vccd1 vccd1 _0746_ sky130_fd_sc_hd__nor2_1
XFILLER_54_212 vssd1 vssd1 vccd1 vccd1 sky130_fd_sc_hd__fill_4
XFILLER_54_201 vssd1 vssd1 vccd1 vccd1 sky130_fd_sc_hd__fill_2
XFILLER_39_231 vccd1 vssd1 vccd1 vssd1 sky130_ef_sc_hd__decap_40_12
XFILLER_52_27 vssd1 vssd1 vccd1 vccd1 sky130_fd_sc_hd__fill_1
X_2108_ CALC_INST.input_ctrl_inst.decoded_key\[1\] net79 _1153_ CALC_INST.input_ctrl_inst.col_index\[1\]
+ vssd1 vssd1 vccd1 vccd1 _1155_ sky130_fd_sc_hd__o22a_1
X_2039_ CALC_INST.gencon_inst.mult_calc.count.GENERATE_ADDER\[9\].thingy.in1 _1092_
+ vssd1 vssd1 vccd1 vccd1 _1093_ sky130_fd_sc_hd__and2_1
XFILLER_22_175 vssd1 vssd1 vccd1 vccd1 sky130_fd_sc_hd__fill_1
XPHY_EDGE_ROW_15_Left_80 vssd1 vssd1 vccd1 vccd1 sky130_fd_sc_hd__decap_3
X_1410_ CALC_INST.gencon_inst.ALU_in1\[5\] CALC_INST.gencon_inst.ALU_in2\[5\] net65
+ vssd1 vssd1 vccd1 vccd1 _0680_ sky130_fd_sc_hd__mux2_1
XFILLER_42_82 vssd1 vssd1 vccd1 vccd1 sky130_fd_sc_hd__fill_2
X_1341_ _0387_ _0647_ vssd1 vssd1 vccd1 vccd1 _0648_ sky130_fd_sc_hd__nor2_1
X_1272_ CALC_INST.gencon_inst.operand2\[14\] _0392_ net70 CALC_INST.gencon_inst.ALU_out\[14\]
+ _0590_ vssd1 vssd1 vccd1 vccd1 _0629_ sky130_fd_sc_hd__a221o_1
XFILLER_36_201 vssd1 vssd1 vccd1 vccd1 sky130_fd_sc_hd__fill_1
X_2390_ CALC_INST.gencon_inst.ALU_out\[0\] net68 net58 CALC_INST.gencon_inst.mult_calc.out\[0\]
+ vssd1 vssd1 vccd1 vccd1 _0528_ sky130_fd_sc_hd__a22o_1
XFILLER_8_190 vssd1 vssd1 vccd1 vccd1 sky130_fd_sc_hd__fill_2
XANTENNA__1739__B1 net77 vssd1 vssd1 vccd1 vccd1 sky130_fd_sc_hd__diode_2
X_2726_ clknet_leaf_24_clk _0264_ net143 vssd1 vssd1 vccd1 vccd1 CALC_INST.gencon_inst.mult_calc.out\[11\]
+ sky130_fd_sc_hd__dfrtp_1
X_1539_ _0783_ _0785_ _0790_ vssd1 vssd1 vccd1 vccd1 _0793_ sky130_fd_sc_hd__or3_1
Xfanout103 net106 vssd1 vssd1 vccd1 vccd1 net103 sky130_fd_sc_hd__buf_2
Xfanout147 net148 vssd1 vssd1 vccd1 vccd1 net147 sky130_fd_sc_hd__clkbuf_4
X_2588_ clknet_leaf_9_clk net280 vssd1 vssd1 vccd1 vccd1 CALC_INST.gencon_inst.addOrSub
+ sky130_fd_sc_hd__dfxtp_1
Xfanout125 net132 vssd1 vssd1 vccd1 vccd1 net125 sky130_fd_sc_hd__clkbuf_4
X_1608_ _0846_ _0847_ _0844_ vssd1 vssd1 vccd1 vccd1 _0849_ sky130_fd_sc_hd__o21ai_1
XANTENNA__1911__B1 net77 vssd1 vssd1 vccd1 vccd1 sky130_fd_sc_hd__diode_2
Xfanout114 net123 vssd1 vssd1 vccd1 vccd1 net114 sky130_fd_sc_hd__clkbuf_4
Xfanout136 net139 vssd1 vssd1 vccd1 vccd1 net136 sky130_fd_sc_hd__buf_2
X_2657_ clknet_leaf_30_clk _0195_ net133 vssd1 vssd1 vccd1 vccd1 CALC_INST.gencon_inst.mult_calc.adderSave\[3\]
+ sky130_fd_sc_hd__dfrtp_1
XTAP_TAPCELL_ROW_57_538 vssd1 vccd1 sky130_fd_sc_hd__tapvpwrvgnd_1
XFILLER_27_234 vssd1 vssd1 vccd1 vccd1 sky130_fd_sc_hd__fill_4
XFILLER_27_212 vssd1 vssd1 vccd1 vccd1 sky130_fd_sc_hd__fill_1
Xhold190 net17 vssd1 vssd1 vccd1 vccd1 net386 sky130_fd_sc_hd__dlygate4sd3_1
XFILLER_2_377 vccd1 vssd1 vccd1 vssd1 sky130_ef_sc_hd__decap_40_12
XPHY_EDGE_ROW_0_Left_65 vssd1 vssd1 vccd1 vccd1 sky130_fd_sc_hd__decap_3
XPHY_EDGE_ROW_16_Right_16 vssd1 vssd1 vccd1 vccd1 sky130_fd_sc_hd__decap_3
XFILLER_41_281 vssd1 vssd1 vccd1 vccd1 sky130_fd_sc_hd__fill_1
XPHY_EDGE_ROW_25_Right_25 vssd1 vssd1 vccd1 vccd1 sky130_fd_sc_hd__decap_3
X_1890_ CALC_INST.input_ctrl_inst.col_index\[28\] _0991_ vssd1 vssd1 vccd1 vccd1 _0994_
+ sky130_fd_sc_hd__nor2_1
X_2442_ CALC_INST.gencon_inst.ALU_out\[9\] net70 net59 CALC_INST.gencon_inst.mult_calc.out\[9\]
+ net41 vssd1 vssd1 vccd1 vccd1 _0571_ sky130_fd_sc_hd__a221o_1
X_2511_ clknet_leaf_13_clk _0053_ net145 vssd1 vssd1 vccd1 vccd1 CALC_INST.gencon_inst.operand1\[6\]
+ sky130_fd_sc_hd__dfrtp_1
X_2373_ CALC_INST.gencon_inst.operand2\[13\] _0509_ vssd1 vssd1 vccd1 vccd1 _0513_
+ sky130_fd_sc_hd__or2_1
XFILLER_56_318 vssd1 vssd1 vccd1 vccd1 sky130_fd_sc_hd__fill_8
XFILLER_56_307 vssd1 vssd1 vccd1 vccd1 sky130_fd_sc_hd__fill_1
X_1324_ CALC_INST.gencon_inst.operand2\[5\] net242 net51 vssd1 vssd1 vccd1 vccd1 _0111_
+ sky130_fd_sc_hd__mux2_1
X_1255_ CALC_INST.gencon_inst.operand2\[9\] CALC_INST.gencon_inst.operand1\[9\] net73
+ vssd1 vssd1 vccd1 vccd1 _0617_ sky130_fd_sc_hd__mux2_1
XPHY_EDGE_ROW_34_Right_34 vssd1 vssd1 vccd1 vccd1 sky130_fd_sc_hd__decap_3
XFILLER_64_384 vssd1 vssd1 vccd1 vccd1 sky130_fd_sc_hd__fill_8
XFILLER_64_373 vssd1 vssd1 vccd1 vccd1 sky130_fd_sc_hd__fill_1
XTAP_TAPCELL_ROW_62_574 vssd1 vccd1 sky130_fd_sc_hd__tapvpwrvgnd_1
XTAP_TAPCELL_ROW_54_519 vssd1 vccd1 sky130_fd_sc_hd__tapvpwrvgnd_1
XTAP_TAPCELL_ROW_19_273 vssd1 vccd1 sky130_fd_sc_hd__tapvpwrvgnd_1
XPHY_EDGE_ROW_43_Right_43 vssd1 vssd1 vccd1 vccd1 sky130_fd_sc_hd__decap_3
X_2709_ clknet_leaf_23_clk _0247_ net142 vssd1 vssd1 vccd1 vccd1 CALC_INST.gencon_inst.mult_calc.main.GENERATE_ADDER\[9\].thingy.in2
+ sky130_fd_sc_hd__dfrtp_1
XFILLER_59_145 vssd1 vssd1 vccd1 vccd1 sky130_fd_sc_hd__fill_2
XPHY_EDGE_ROW_52_Right_52 vssd1 vssd1 vccd1 vccd1 sky130_fd_sc_hd__decap_3
XANTENNA_fanout52_A _0646_ vssd1 vssd1 vccd1 vccd1 sky130_fd_sc_hd__diode_2
XTAP_TAPCELL_ROW_2_152 vssd1 vccd1 sky130_fd_sc_hd__tapvpwrvgnd_1
XPHY_EDGE_ROW_61_Right_61 vssd1 vssd1 vccd1 vccd1 sky130_fd_sc_hd__decap_3
XPHY_EDGE_ROW_36_Left_101 vssd1 vssd1 vccd1 vccd1 sky130_fd_sc_hd__decap_3
XFILLER_23_281 vssd1 vssd1 vccd1 vccd1 sky130_fd_sc_hd__fill_2
XFILLER_23_73 vssd1 vssd1 vccd1 vccd1 sky130_fd_sc_hd__fill_2
XFILLER_7_403 vssd1 vssd1 vccd1 vccd1 sky130_fd_sc_hd__fill_1
XFILLER_31_9 vssd1 vssd1 vccd1 vccd1 sky130_fd_sc_hd__fill_1
XPHY_EDGE_ROW_45_Left_110 vssd1 vssd1 vccd1 vccd1 sky130_fd_sc_hd__decap_3
XFILLER_2_185 vssd1 vssd1 vccd1 vccd1 sky130_fd_sc_hd__fill_2
XFILLER_0_44 vccd1 vssd1 vccd1 vssd1 sky130_ef_sc_hd__decap_40_12
X_1942_ net456 net111 _1009_ _1020_ vssd1 vssd1 vccd1 vccd1 _0355_ sky130_fd_sc_hd__a22o_1
XFILLER_21_218 vssd1 vssd1 vccd1 vccd1 sky130_fd_sc_hd__fill_4
XFILLER_14_270 vssd1 vssd1 vccd1 vccd1 sky130_fd_sc_hd__fill_1
XTAP_TAPCELL_ROW_16_254 vssd1 vccd1 sky130_fd_sc_hd__tapvpwrvgnd_1
X_1873_ net63 _0981_ CALC_INST.input_ctrl_inst.col_index\[23\] vssd1 vssd1 vccd1 vccd1
+ _0982_ sky130_fd_sc_hd__o21a_1
X_2425_ CALC_INST.gencon_inst.operand1\[5\] _0549_ CALC_INST.gencon_inst.operand1\[6\]
+ vssd1 vssd1 vccd1 vccd1 _0557_ sky130_fd_sc_hd__a21o_1
X_2356_ CALC_INST.gencon_inst.operand2\[9\] _0496_ _0404_ vssd1 vssd1 vccd1 vccd1
+ _0500_ sky130_fd_sc_hd__o21ai_1
XFILLER_64_181 vssd1 vssd1 vccd1 vccd1 sky130_fd_sc_hd__fill_8
XFILLER_52_332 vssd1 vssd1 vccd1 vccd1 sky130_fd_sc_hd__fill_1
X_1307_ CALC_INST.gencon_inst.operand1\[4\] net245 net51 vssd1 vssd1 vccd1 vccd1 _0094_
+ sky130_fd_sc_hd__mux2_1
XANTENNA__1341__Y _0648_ vssd1 vssd1 vccd1 vccd1 sky130_fd_sc_hd__diode_2
X_1238_ CALC_INST.gencon_inst.operand2\[4\] CALC_INST.gencon_inst.operand1\[4\] net72
+ vssd1 vssd1 vccd1 vccd1 _0605_ sky130_fd_sc_hd__mux2_1
XFILLER_29_329 vssd1 vssd1 vccd1 vccd1 sky130_fd_sc_hd__fill_4
X_2287_ CALC_INST.input_ctrl_inst.col_index\[25\] _1067_ _0442_ _0448_ vssd1 vssd1
+ vccd1 vccd1 _0449_ sky130_fd_sc_hd__and4b_1
XFILLER_60_49 vssd1 vssd1 vccd1 vccd1 sky130_fd_sc_hd__fill_1
XANTENNA_clkbuf_leaf_7_clk_A clknet_2_1__leaf_clk vssd1 vssd1 vccd1 vccd1 sky130_fd_sc_hd__diode_2
XFILLER_20_251 vssd1 vssd1 vccd1 vccd1 sky130_fd_sc_hd__fill_1
XANTENNA__2332__C _0405_ vssd1 vssd1 vccd1 vccd1 sky130_fd_sc_hd__diode_2
XANTENNA__2358__A0 CALC_INST.gencon_inst.operand2\[9\] vssd1 vssd1 vccd1 vccd1 sky130_fd_sc_hd__diode_2
XANTENNA__1276__A_N _0590_ vssd1 vssd1 vccd1 vccd1 sky130_fd_sc_hd__diode_2
XFILLER_34_50 vssd1 vssd1 vccd1 vccd1 sky130_fd_sc_hd__fill_2
XFILLER_28_362 vssd1 vssd1 vccd1 vccd1 sky130_fd_sc_hd__fill_2
XTAP_TAPCELL_ROW_21_290 vssd1 vccd1 sky130_fd_sc_hd__tapvpwrvgnd_1
XFILLER_7_200 vssd1 vssd1 vccd1 vccd1 sky130_fd_sc_hd__fill_1
XFILLER_7_233 vssd1 vssd1 vccd1 vccd1 sky130_fd_sc_hd__fill_8
X_2210_ CALC_INST.gencon_inst.gencon_state\[2\] _1058_ vssd1 vssd1 vccd1 vccd1 _1235_
+ sky130_fd_sc_hd__nand2_1
X_2141_ _1181_ vssd1 vssd1 vccd1 vccd1 _1182_ sky130_fd_sc_hd__inv_2
X_2072_ CALC_INST.gencon_inst.mult_calc.compCount.in2\[10\] _1125_ vssd1 vssd1 vccd1
+ vccd1 _1126_ sky130_fd_sc_hd__or2_1
X_1925_ CALC_INST.input_ctrl_inst.decoded_key\[2\] _1062_ vssd1 vssd1 vccd1 vccd1
+ _1009_ sky130_fd_sc_hd__nor2_1
X_1787_ CALC_INST.gencon_inst.operand2\[11\] net48 net38 net340 vssd1 vssd1 vccd1
+ vccd1 _0297_ sky130_fd_sc_hd__a22o_1
X_1856_ CALC_INST.input_ctrl_inst.col_index\[18\] net63 vssd1 vssd1 vccd1 vccd1 _0970_
+ sky130_fd_sc_hd__nand2_1
XFILLER_57_402 vssd1 vssd1 vccd1 vccd1 sky130_fd_sc_hd__fill_4
X_2408_ CALC_INST.gencon_inst.operand1\[3\] CALC_INST.gencon_inst.latched_keypad_input\[3\]
+ vssd1 vssd1 vccd1 vccd1 _0543_ sky130_fd_sc_hd__nand2_1
X_2339_ _0404_ _0485_ _0486_ net44 CALC_INST.gencon_inst.mult_calc.out\[5\] vssd1
+ vssd1 vccd1 vccd1 _0487_ sky130_fd_sc_hd__a32o_1
XPHY_EDGE_ROW_2_Right_2 vssd1 vssd1 vccd1 vccd1 sky130_fd_sc_hd__decap_3
XFILLER_37_192 vssd1 vssd1 vccd1 vccd1 sky130_fd_sc_hd__fill_2
XTAP_TAPCELL_ROW_35_382 vssd1 vccd1 sky130_fd_sc_hd__tapvpwrvgnd_1
XTAP_TAPCELL_ROW_27_327 vssd1 vccd1 sky130_fd_sc_hd__tapvpwrvgnd_1
XFILLER_63_405 vssd1 vssd1 vccd1 vccd1 sky130_fd_sc_hd__fill_2
Xhold83 CALC_INST.gencon_inst.addOrSub vssd1 vssd1 vccd1 vccd1 net279 sky130_fd_sc_hd__dlygate4sd3_1
Xhold50 CALC_INST.gencon_inst.ALU_in2\[12\] vssd1 vssd1 vccd1 vccd1 net246 sky130_fd_sc_hd__dlygate4sd3_1
Xhold72 CALC_INST.gencon_inst.ALU_in1\[5\] vssd1 vssd1 vccd1 vccd1 net268 sky130_fd_sc_hd__dlygate4sd3_1
Xhold61 net13 vssd1 vssd1 vccd1 vccd1 net257 sky130_fd_sc_hd__dlygate4sd3_1
Xhold94 CALC_INST.gencon_inst.mult_calc.countSave\[0\] vssd1 vssd1 vccd1 vccd1 net290
+ sky130_fd_sc_hd__dlygate4sd3_1
XFILLER_16_376 vssd1 vssd1 vccd1 vccd1 sky130_fd_sc_hd__fill_1
X_1572_ net33 _0818_ _0820_ vssd1 vssd1 vccd1 vccd1 _0821_ sky130_fd_sc_hd__a21oi_1
XANTENNA__1242__B1 net54 vssd1 vssd1 vccd1 vccd1 sky130_fd_sc_hd__diode_2
X_2690_ clknet_leaf_21_clk _0228_ net138 vssd1 vssd1 vccd1 vccd1 CALC_INST.gencon_inst.mult_calc.main.GENERATE_ADDER\[6\].thingy.in1
+ sky130_fd_sc_hd__dfrtp_1
XFILLER_6_87 vssd1 vssd1 vccd1 vccd1 sky130_fd_sc_hd__fill_2
X_1710_ net237 net221 net95 vssd1 vssd1 vccd1 vccd1 _0222_ sky130_fd_sc_hd__mux2_1
X_1641_ _0875_ _0876_ vssd1 vssd1 vccd1 vccd1 _0877_ sky130_fd_sc_hd__and2b_1
X_2124_ _1078_ _1167_ vssd1 vssd1 vccd1 vccd1 _1168_ sky130_fd_sc_hd__nor2_1
XFILLER_3_291 vssd1 vssd1 vccd1 vccd1 sky130_fd_sc_hd__fill_1
XTAP_TAPCELL_ROW_49_485 vssd1 vccd1 sky130_fd_sc_hd__tapvpwrvgnd_1
XFILLER_34_151 vssd1 vssd1 vccd1 vccd1 sky130_fd_sc_hd__fill_1
XANTENNA__1759__S net96 vssd1 vssd1 vccd1 vccd1 sky130_fd_sc_hd__diode_2
XTAP_TAPCELL_ROW_24_308 vssd1 vccd1 sky130_fd_sc_hd__tapvpwrvgnd_1
X_2055_ _1054_ _1108_ CALC_INST.gencon_inst.mult_calc.compCount.in2\[3\] _1099_ vssd1
+ vssd1 vccd1 vccd1 _1109_ sky130_fd_sc_hd__o2bb2a_1
XTAP_TAPCELL_ROW_32_363 vssd1 vccd1 sky130_fd_sc_hd__tapvpwrvgnd_1
X_1908_ net91 net282 net75 CALC_INST.gencon_inst.mult_calc.count.GENERATE_ADDER\[5\].thingy.in1
+ vssd1 vssd1 vccd1 vccd1 _0339_ sky130_fd_sc_hd__a22o_1
X_1839_ CALC_INST.input_ctrl_inst.col_index\[11\] CALC_INST.input_ctrl_inst.col_index\[10\]
+ _0958_ vssd1 vssd1 vccd1 vccd1 _0960_ sky130_fd_sc_hd__and3_1
XFILLER_17_107 vssd1 vssd1 vccd1 vccd1 sky130_fd_sc_hd__fill_1
XFILLER_13_335 vssd1 vssd1 vccd1 vccd1 sky130_fd_sc_hd__fill_1
Xteam_06_174 vssd1 vssd1 vccd1 vccd1 gpio_oeb[6] team_06_174/LO sky130_fd_sc_hd__conb_1
Xteam_06_163 vssd1 vssd1 vccd1 vccd1 team_06_163/HI gpio_out[0] sky130_fd_sc_hd__conb_1
Xteam_06_185 vssd1 vssd1 vccd1 vccd1 gpio_oeb[17] team_06_185/LO sky130_fd_sc_hd__conb_1
XANTENNA__1433__A net103 vssd1 vssd1 vccd1 vccd1 sky130_fd_sc_hd__diode_2
Xteam_06_196 vssd1 vssd1 vccd1 vccd1 gpio_oeb[28] team_06_196/LO sky130_fd_sc_hd__conb_1
XFILLER_63_279 vssd1 vssd1 vccd1 vccd1 sky130_fd_sc_hd__fill_1
XFILLER_31_110 vssd1 vssd1 vccd1 vccd1 sky130_fd_sc_hd__fill_2
Xclkbuf_leaf_28_clk clknet_2_2__leaf_clk vssd1 vssd1 vccd1 vccd1 clknet_leaf_28_clk
+ sky130_fd_sc_hd__clkbuf_8
X_2811_ clknet_leaf_2_clk net3 net115 vssd1 vssd1 vccd1 vccd1 CALC_INST.input_ctrl_inst.RowMid\[2\]
+ sky130_fd_sc_hd__dfstp_1
XANTENNA_clkbuf_leaf_32_clk_A clknet_2_0__leaf_clk vssd1 vssd1 vccd1 vccd1 sky130_fd_sc_hd__diode_2
X_2742_ clknet_leaf_26_clk _0280_ net135 vssd1 vssd1 vccd1 vccd1 CALC_INST.gencon_inst.mult_calc.countSave\[9\]
+ sky130_fd_sc_hd__dfrtp_1
X_1555_ net32 _0803_ _0805_ net80 vssd1 vssd1 vccd1 vccd1 _0807_ sky130_fd_sc_hd__a31o_1
XANTENNA__2500__Q CALC_INST.gencon_inst.operand2\[10\] vssd1 vssd1 vccd1 vccd1 sky130_fd_sc_hd__diode_2
XFILLER_8_394 vssd1 vssd1 vccd1 vccd1 sky130_fd_sc_hd__fill_2
X_2673_ clknet_leaf_28_clk net380 net133 vssd1 vssd1 vccd1 vccd1 CALC_INST.gencon_inst.mult_calc.compCount.in2\[4\]
+ sky130_fd_sc_hd__dfrtp_1
X_1624_ CALC_INST.gencon_inst.mult_calc.main.GENERATE_ADDER\[4\].thingy.in2 CALC_INST.gencon_inst.mult_calc.main.GENERATE_ADDER\[4\].thingy.in1
+ vssd1 vssd1 vccd1 vccd1 _0862_ sky130_fd_sc_hd__nor2_1
X_1486_ CALC_INST.gencon_inst.add_calc.main.GENERATE_ADDER\[1\].thingy.in1 _0742_
+ _0744_ vssd1 vssd1 vccd1 vccd1 _0745_ sky130_fd_sc_hd__a21oi_1
XFILLER_39_276 vssd1 vssd1 vccd1 vccd1 sky130_fd_sc_hd__fill_2
XTAP_TAPCELL_ROW_37_400 vssd1 vccd1 sky130_fd_sc_hd__tapvpwrvgnd_1
Xclkbuf_leaf_19_clk clknet_2_3__leaf_clk vssd1 vssd1 vccd1 vccd1 clknet_leaf_19_clk
+ sky130_fd_sc_hd__clkbuf_8
X_2107_ _1148_ _1154_ vssd1 vssd1 vccd1 vccd1 _0027_ sky130_fd_sc_hd__nor2_1
XFILLER_54_257 vssd1 vssd1 vccd1 vccd1 sky130_fd_sc_hd__fill_2
XFILLER_22_143 vssd1 vssd1 vccd1 vccd1 sky130_fd_sc_hd__fill_2
X_2038_ CALC_INST.gencon_inst.mult_calc.count.GENERATE_ADDER\[8\].thingy.in1 CALC_INST.gencon_inst.mult_calc.count.GENERATE_ADDER\[7\].thingy.in1
+ _1091_ vssd1 vssd1 vccd1 vccd1 _1092_ sky130_fd_sc_hd__and3_1
XFILLER_6_309 vssd1 vssd1 vccd1 vccd1 sky130_fd_sc_hd__fill_2
XANTENNA__1399__S net109 vssd1 vssd1 vccd1 vccd1 sky130_fd_sc_hd__diode_2
XFILLER_45_279 vssd1 vssd1 vccd1 vccd1 sky130_fd_sc_hd__fill_1
XANTENNA__2485__A2 net57 vssd1 vssd1 vccd1 vccd1 sky130_fd_sc_hd__diode_2
XFILLER_9_169 vssd1 vssd1 vccd1 vccd1 sky130_fd_sc_hd__fill_1
XFILLER_13_198 vssd1 vssd1 vccd1 vccd1 sky130_fd_sc_hd__fill_1
X_1340_ CALC_INST.gencon_inst.latched_operator_input\[1\] CALC_INST.gencon_inst.latched_operator_input\[0\]
+ net112 CALC_INST.gencon_inst.latched_operator_input\[2\] vssd1 vssd1 vccd1 vccd1
+ _0647_ sky130_fd_sc_hd__or4b_1
XFILLER_5_331 vssd1 vssd1 vccd1 vccd1 sky130_fd_sc_hd__fill_4
X_1271_ CALC_INST.gencon_inst.operand1\[13\] _0397_ _0592_ net386 _0628_ vssd1 vssd1
+ vccd1 vccd1 _0076_ sky130_fd_sc_hd__o221a_1
XFILLER_36_235 vssd1 vssd1 vccd1 vccd1 sky130_fd_sc_hd__fill_4
XFILLER_3_88 vssd1 vssd1 vccd1 vccd1 sky130_fd_sc_hd__fill_2
XFILLER_3_44 vssd1 vssd1 vccd1 vccd1 sky130_fd_sc_hd__fill_1
Xclkbuf_leaf_8_clk clknet_2_1__leaf_clk vssd1 vssd1 vccd1 vccd1 clknet_leaf_8_clk
+ sky130_fd_sc_hd__clkbuf_8
X_2656_ clknet_leaf_30_clk _0194_ net122 vssd1 vssd1 vccd1 vccd1 CALC_INST.gencon_inst.mult_calc.adderSave\[2\]
+ sky130_fd_sc_hd__dfrtp_1
X_2725_ clknet_leaf_24_clk _0263_ net143 vssd1 vssd1 vccd1 vccd1 CALC_INST.gencon_inst.mult_calc.out\[10\]
+ sky130_fd_sc_hd__dfrtp_1
X_1469_ _0726_ _0727_ CALC_INST.gencon_inst.add_calc.main.GENERATE_ADDER\[5\].thingy.in1
+ vssd1 vssd1 vccd1 vccd1 _0728_ sky130_fd_sc_hd__a21oi_1
XFILLER_59_316 vssd1 vssd1 vccd1 vccd1 sky130_fd_sc_hd__fill_2
X_1538_ _0792_ _0791_ CALC_INST.gencon_inst.ALU_out\[5\] net81 vssd1 vssd1 vccd1 vccd1
+ _0179_ sky130_fd_sc_hd__a2bb2o_1
Xfanout104 net106 vssd1 vssd1 vccd1 vccd1 net104 sky130_fd_sc_hd__clkbuf_2
Xfanout126 net127 vssd1 vssd1 vccd1 vccd1 net126 sky130_fd_sc_hd__clkbuf_4
X_2587_ clknet_leaf_7_clk net228 vssd1 vssd1 vccd1 vccd1 CALC_INST.gencon_inst.prev_operator_input\[2\]
+ sky130_fd_sc_hd__dfxtp_1
Xfanout148 net153 vssd1 vssd1 vccd1 vccd1 net148 sky130_fd_sc_hd__clkbuf_2
Xfanout115 net116 vssd1 vssd1 vccd1 vccd1 net115 sky130_fd_sc_hd__clkbuf_4
XANTENNA__1911__A1 net91 vssd1 vssd1 vccd1 vccd1 sky130_fd_sc_hd__diode_2
Xfanout137 net139 vssd1 vssd1 vccd1 vccd1 net137 sky130_fd_sc_hd__clkbuf_4
X_1607_ _0844_ _0846_ _0847_ vssd1 vssd1 vccd1 vccd1 _0848_ sky130_fd_sc_hd__or3_1
XTAP_TAPCELL_ROW_57_539 vssd1 vccd1 sky130_fd_sc_hd__tapvpwrvgnd_1
XFILLER_47_39 vssd1 vssd1 vccd1 vccd1 sky130_fd_sc_hd__fill_2
XTAP_TAPCELL_ROW_40_417 vssd1 vccd1 sky130_fd_sc_hd__tapvpwrvgnd_1
Xhold180 CALC_INST.gencon_inst.add_calc.main.in2\[11\] vssd1 vssd1 vccd1 vccd1 net376
+ sky130_fd_sc_hd__dlygate4sd3_1
XFILLER_5_3 vssd1 vssd1 vccd1 vccd1 sky130_fd_sc_hd__fill_8
XTAP_TAPCELL_ROW_5_172 vssd1 vccd1 sky130_fd_sc_hd__tapvpwrvgnd_1
XFILLER_2_389 vccd1 vssd1 vccd1 vssd1 sky130_ef_sc_hd__decap_40_12
Xhold191 CALC_INST.gencon_inst.mult_calc.compCount.in2\[6\] vssd1 vssd1 vccd1 vccd1
+ net387 sky130_fd_sc_hd__dlygate4sd3_1
XFILLER_53_71 vssd1 vssd1 vccd1 vccd1 sky130_fd_sc_hd__fill_1
XFILLER_33_216 vssd1 vssd1 vccd1 vccd1 sky130_fd_sc_hd__fill_1
XFILLER_53_93 vssd1 vssd1 vccd1 vccd1 sky130_fd_sc_hd__fill_2
X_2510_ clknet_leaf_12_clk _0052_ net145 vssd1 vssd1 vccd1 vccd1 CALC_INST.gencon_inst.operand1\[5\]
+ sky130_fd_sc_hd__dfrtp_2
X_1323_ CALC_INST.gencon_inst.operand2\[4\] net241 net51 vssd1 vssd1 vccd1 vccd1 _0110_
+ sky130_fd_sc_hd__mux2_1
X_2441_ _0568_ _0569_ vssd1 vssd1 vccd1 vccd1 _0570_ sky130_fd_sc_hd__nor2_1
XFILLER_38_3 vssd1 vssd1 vccd1 vccd1 sky130_fd_sc_hd__fill_2
X_2372_ CALC_INST.gencon_inst.operand2\[13\] _0509_ vssd1 vssd1 vccd1 vccd1 _0512_
+ sky130_fd_sc_hd__nand2_1
XFILLER_64_363 vssd1 vssd1 vccd1 vccd1 sky130_fd_sc_hd__fill_1
XFILLER_49_371 vssd1 vssd1 vccd1 vccd1 sky130_fd_sc_hd__fill_1
X_1254_ CALC_INST.gencon_inst.operand1\[8\] _0397_ _0592_ net394 _0616_ vssd1 vssd1
+ vccd1 vccd1 _0071_ sky130_fd_sc_hd__o221a_1
XTAP_TAPCELL_ROW_19_274 vssd1 vccd1 sky130_fd_sc_hd__tapvpwrvgnd_1
XTAP_TAPCELL_ROW_62_575 vssd1 vccd1 sky130_fd_sc_hd__tapvpwrvgnd_1
XANTENNA_fanout132_A net5 vssd1 vssd1 vccd1 vccd1 sky130_fd_sc_hd__diode_2
XFILLER_24_238 vccd1 vssd1 vccd1 vssd1 sky130_ef_sc_hd__decap_40_12
X_2639_ clknet_leaf_10_clk _0177_ net147 vssd1 vssd1 vccd1 vccd1 CALC_INST.gencon_inst.ALU_out\[3\]
+ sky130_fd_sc_hd__dfrtp_1
X_2708_ clknet_leaf_22_clk net400 net143 vssd1 vssd1 vccd1 vccd1 CALC_INST.gencon_inst.mult_calc.main.GENERATE_ADDER\[8\].thingy.in2
+ sky130_fd_sc_hd__dfrtp_1
XFILLER_59_113 vccd1 vssd1 vccd1 vssd1 sky130_ef_sc_hd__decap_40_12
XFILLER_59_102 vssd1 vssd1 vccd1 vccd1 sky130_fd_sc_hd__fill_8
XTAP_TAPCELL_ROW_2_153 vssd1 vccd1 sky130_fd_sc_hd__tapvpwrvgnd_1
XFILLER_15_205 vccd1 vssd1 vccd1 vssd1 sky130_ef_sc_hd__decap_40_12
XFILLER_2_197 vssd1 vssd1 vccd1 vccd1 sky130_fd_sc_hd__fill_4
XFILLER_2_120 vccd1 vssd1 vccd1 vssd1 sky130_ef_sc_hd__decap_40_12
XFILLER_48_93 vssd1 vssd1 vccd1 vccd1 sky130_fd_sc_hd__fill_2
XFILLER_46_385 vssd1 vssd1 vccd1 vccd1 sky130_fd_sc_hd__fill_2
XFILLER_64_70 vssd1 vssd1 vccd1 vccd1 sky130_fd_sc_hd__fill_2
X_1941_ net447 net111 _1062_ _1020_ vssd1 vssd1 vccd1 vccd1 _0354_ sky130_fd_sc_hd__a22o_1
X_1872_ CALC_INST.input_ctrl_inst.col_index\[22\] _0980_ _0981_ net62 vssd1 vssd1
+ vccd1 vccd1 _0324_ sky130_fd_sc_hd__o22a_1
XFILLER_0_89 vccd1 vssd1 vccd1 vssd1 sky130_ef_sc_hd__decap_40_12
XTAP_TAPCELL_ROW_16_255 vssd1 vccd1 sky130_fd_sc_hd__tapvpwrvgnd_1
XFILLER_56_116 vssd1 vssd1 vccd1 vccd1 sky130_fd_sc_hd__fill_4
X_1306_ CALC_INST.gencon_inst.operand1\[3\] net277 net51 vssd1 vssd1 vccd1 vccd1 _0093_
+ sky130_fd_sc_hd__mux2_1
X_2424_ _0542_ _0545_ CALC_INST.gencon_inst.operand1\[4\] CALC_INST.gencon_inst.operand1\[5\]
+ CALC_INST.gencon_inst.operand1\[6\] vssd1 vssd1 vccd1 vccd1 _0556_ sky130_fd_sc_hd__o2111a_1
X_2355_ CALC_INST.gencon_inst.operand2\[9\] CALC_INST.gencon_inst.operand2\[8\] CALC_INST.gencon_inst.operand2\[7\]
+ _0489_ vssd1 vssd1 vccd1 vccd1 _0499_ sky130_fd_sc_hd__and4_1
X_2286_ CALC_INST.input_ctrl_inst.col_index\[24\] _0420_ vssd1 vssd1 vccd1 vccd1 _0448_
+ sky130_fd_sc_hd__nand2_1
XFILLER_44_29 vssd1 vssd1 vccd1 vccd1 sky130_fd_sc_hd__fill_1
X_1237_ _0603_ _0604_ vssd1 vssd1 vccd1 vccd1 _0066_ sky130_fd_sc_hd__or2_1
XFILLER_20_285 vssd1 vssd1 vccd1 vccd1 sky130_fd_sc_hd__fill_1
XANTENNA_fanout48_X net48 vssd1 vssd1 vccd1 vccd1 sky130_fd_sc_hd__diode_2
X_2140_ CALC_INST.input_ctrl_inst.debounce_cnt\[3\] CALC_INST.input_ctrl_inst.debounce_cnt\[2\]
+ CALC_INST.input_ctrl_inst.debounce_cnt\[0\] CALC_INST.input_ctrl_inst.debounce_cnt\[1\]
+ vssd1 vssd1 vccd1 vccd1 _1181_ sky130_fd_sc_hd__and4_1
XFILLER_46_193 vssd1 vssd1 vccd1 vccd1 sky130_fd_sc_hd__fill_2
X_2071_ CALC_INST.gencon_inst.mult_calc.count.GENERATE_ADDER\[10\].thingy.in1 _1093_
+ vssd1 vssd1 vccd1 vccd1 _1125_ sky130_fd_sc_hd__xnor2_1
X_1924_ CALC_INST.input_ctrl_inst.decoded_key\[1\] CALC_INST.input_ctrl_inst.decoded_key\[0\]
+ vssd1 vssd1 vccd1 vccd1 _1008_ sky130_fd_sc_hd__or2_1
X_1855_ _0967_ _0969_ vssd1 vssd1 vccd1 vccd1 _0319_ sky130_fd_sc_hd__nor2_1
X_1786_ CALC_INST.gencon_inst.operand2\[10\] net48 net38 net348 vssd1 vssd1 vccd1
+ vccd1 _0296_ sky130_fd_sc_hd__a22o_1
X_2407_ CALC_INST.gencon_inst.operand1\[3\] CALC_INST.gencon_inst.latched_keypad_input\[3\]
+ vssd1 vssd1 vccd1 vccd1 _0542_ sky130_fd_sc_hd__and2_1
X_2338_ CALC_INST.gencon_inst.operand2\[5\] _0482_ vssd1 vssd1 vccd1 vccd1 _0486_
+ sky130_fd_sc_hd__or2_1
X_2269_ _0411_ _0430_ _0414_ vssd1 vssd1 vccd1 vccd1 _0431_ sky130_fd_sc_hd__a21o_1
XPHY_EDGE_ROW_64_Left_129 vssd1 vssd1 vccd1 vccd1 sky130_fd_sc_hd__decap_3
XFILLER_52_185 vssd1 vssd1 vccd1 vccd1 sky130_fd_sc_hd__fill_1
XFILLER_40_369 vssd1 vssd1 vccd1 vccd1 sky130_fd_sc_hd__fill_1
XFILLER_40_314 vssd1 vssd1 vccd1 vccd1 sky130_fd_sc_hd__fill_1
XTAP_TAPCELL_ROW_35_383 vssd1 vccd1 sky130_fd_sc_hd__tapvpwrvgnd_1
XTAP_TAPCELL_ROW_27_328 vssd1 vccd1 sky130_fd_sc_hd__tapvpwrvgnd_1
XFILLER_25_333 vssd1 vssd1 vccd1 vccd1 sky130_fd_sc_hd__fill_2
XFILLER_48_403 vssd1 vssd1 vccd1 vccd1 sky130_fd_sc_hd__fill_4
XANTENNA__1256__A _1234_ vssd1 vssd1 vccd1 vccd1 sky130_fd_sc_hd__diode_2
XFILLER_29_62 vssd1 vssd1 vccd1 vccd1 sky130_fd_sc_hd__fill_4
Xhold40 CALC_INST.gencon_inst.mult_calc.main.GENERATE_ADDER\[8\].thingy.in1 vssd1
+ vssd1 vccd1 vccd1 net236 sky130_fd_sc_hd__dlygate4sd3_1
XFILLER_20_75 vssd1 vssd1 vccd1 vccd1 sky130_fd_sc_hd__fill_1
Xhold62 CALC_INST.gencon_inst.ALU_in2\[6\] vssd1 vssd1 vccd1 vccd1 net258 sky130_fd_sc_hd__dlygate4sd3_1
Xhold95 CALC_INST.gencon_inst.ALU_in2\[0\] vssd1 vssd1 vccd1 vccd1 net291 sky130_fd_sc_hd__dlygate4sd3_1
Xhold73 CALC_INST.gencon_inst.ALU_in2\[15\] vssd1 vssd1 vccd1 vccd1 net269 sky130_fd_sc_hd__dlygate4sd3_1
Xhold84 _0126_ vssd1 vssd1 vccd1 vccd1 net280 sky130_fd_sc_hd__dlygate4sd3_1
Xhold51 CALC_INST.gencon_inst.mult_calc.countSave\[8\] vssd1 vssd1 vccd1 vccd1 net247
+ sky130_fd_sc_hd__dlygate4sd3_1
XFILLER_43_163 vssd1 vssd1 vccd1 vccd1 sky130_fd_sc_hd__fill_1
X_1571_ _0759_ _0819_ vssd1 vssd1 vccd1 vccd1 _0820_ sky130_fd_sc_hd__xnor2_1
XFILLER_6_11 vssd1 vssd1 vccd1 vccd1 sky130_fd_sc_hd__fill_2
X_1640_ CALC_INST.gencon_inst.mult_calc.main.GENERATE_ADDER\[6\].thingy.in2 CALC_INST.gencon_inst.mult_calc.main.GENERATE_ADDER\[6\].thingy.in1
+ vssd1 vssd1 vccd1 vccd1 _0876_ sky130_fd_sc_hd__nand2_1
X_2123_ CALC_INST.input_ctrl_inst.debounce_cnt\[0\] CALC_INST.input_ctrl_inst.key_pressed
+ vssd1 vssd1 vccd1 vccd1 _1167_ sky130_fd_sc_hd__xnor2_1
XANTENNA_clkbuf_leaf_6_clk_A clknet_2_1__leaf_clk vssd1 vssd1 vccd1 vccd1 sky130_fd_sc_hd__diode_2
XFILLER_20_3 vssd1 vssd1 vccd1 vccd1 sky130_fd_sc_hd__fill_2
XTAP_TAPCELL_ROW_49_486 vssd1 vccd1 sky130_fd_sc_hd__tapvpwrvgnd_1
XTAP_TAPCELL_ROW_24_309 vssd1 vccd1 sky130_fd_sc_hd__tapvpwrvgnd_1
X_2054_ CALC_INST.gencon_inst.mult_calc.count.GENERATE_ADDER\[4\].thingy.in1 _1089_
+ vssd1 vssd1 vccd1 vccd1 _1108_ sky130_fd_sc_hd__xor2_1
XANTENNA__2430__B1 _0519_ vssd1 vssd1 vccd1 vccd1 sky130_fd_sc_hd__diode_2
XTAP_TAPCELL_ROW_32_364 vssd1 vccd1 sky130_fd_sc_hd__tapvpwrvgnd_1
XANTENNA__1784__A2 net48 vssd1 vssd1 vccd1 vccd1 sky130_fd_sc_hd__diode_2
X_1907_ net91 net281 net75 CALC_INST.gencon_inst.mult_calc.count.GENERATE_ADDER\[4\].thingy.in1
+ vssd1 vssd1 vccd1 vccd1 _0338_ sky130_fd_sc_hd__a22o_1
X_1838_ CALC_INST.input_ctrl_inst.col_index\[10\] _0958_ CALC_INST.input_ctrl_inst.col_index\[11\]
+ vssd1 vssd1 vccd1 vccd1 _0959_ sky130_fd_sc_hd__a21oi_1
X_1769_ net83 _1119_ net86 net247 vssd1 vssd1 vccd1 vccd1 _0279_ sky130_fd_sc_hd__a2bb2o_1
XANTENNA__1804__A net63 vssd1 vssd1 vccd1 vccd1 sky130_fd_sc_hd__diode_2
XFILLER_57_277 vssd1 vssd1 vccd1 vccd1 sky130_fd_sc_hd__fill_2
XFILLER_57_255 vssd1 vssd1 vccd1 vccd1 sky130_fd_sc_hd__fill_2
XFILLER_40_133 vssd1 vssd1 vccd1 vccd1 sky130_fd_sc_hd__fill_2
XFILLER_25_163 vssd1 vssd1 vccd1 vccd1 sky130_fd_sc_hd__fill_4
XFILLER_13_314 vssd1 vssd1 vccd1 vccd1 sky130_fd_sc_hd__fill_1
Xoutput6 net6 vssd1 vssd1 vccd1 vccd1 gpio_out[10] sky130_fd_sc_hd__buf_2
Xoutput30 net30 vssd1 vssd1 vccd1 vccd1 gpio_out[9] sky130_fd_sc_hd__buf_2
Xteam_06_186 vssd1 vssd1 vccd1 vccd1 gpio_oeb[18] team_06_186/LO sky130_fd_sc_hd__conb_1
Xteam_06_175 vssd1 vssd1 vccd1 vccd1 gpio_oeb[7] team_06_175/LO sky130_fd_sc_hd__conb_1
Xteam_06_164 vssd1 vssd1 vccd1 vccd1 team_06_164/HI gpio_out[1] sky130_fd_sc_hd__conb_1
XFILLER_0_251 vssd1 vssd1 vccd1 vccd1 sky130_fd_sc_hd__fill_1
XFILLER_56_93 vssd1 vssd1 vccd1 vccd1 sky130_fd_sc_hd__fill_2
XFILLER_31_199 vssd1 vssd1 vccd1 vccd1 sky130_fd_sc_hd__fill_1
X_2810_ clknet_leaf_2_clk net2 net115 vssd1 vssd1 vccd1 vccd1 CALC_INST.input_ctrl_inst.RowMid\[1\]
+ sky130_fd_sc_hd__dfstp_1
X_2741_ clknet_leaf_27_clk _0279_ net135 vssd1 vssd1 vccd1 vccd1 CALC_INST.gencon_inst.mult_calc.countSave\[8\]
+ sky130_fd_sc_hd__dfrtp_1
XFILLER_8_373 vssd1 vssd1 vccd1 vccd1 sky130_fd_sc_hd__fill_4
X_2672_ clknet_leaf_32_clk _0210_ net133 vssd1 vssd1 vccd1 vccd1 CALC_INST.gencon_inst.mult_calc.compCount.in2\[3\]
+ sky130_fd_sc_hd__dfrtp_1
X_1554_ net32 _0803_ _0805_ vssd1 vssd1 vccd1 vccd1 _0806_ sky130_fd_sc_hd__a21oi_1
X_1485_ net103 CALC_INST.gencon_inst.add_calc.main.a0.in1 CALC_INST.gencon_inst.add_calc.main.in2\[0\]
+ vssd1 vssd1 vccd1 vccd1 _0744_ sky130_fd_sc_hd__mux2_1
X_1623_ net441 net85 _0860_ _0861_ vssd1 vssd1 vccd1 vccd1 _0195_ sky130_fd_sc_hd__a22o_1
.ends
