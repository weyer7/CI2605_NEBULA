* NGSPICE file created from team_06.ext - technology: sky130A

* Black-box entry subcircuit for sky130_fd_sc_hd__xnor2_1 abstract view
.subckt sky130_fd_sc_hd__xnor2_1 A B VGND VNB VPB VPWR Y
.ends

* Black-box entry subcircuit for sky130_fd_sc_hd__fill_2 abstract view
.subckt sky130_fd_sc_hd__fill_2 VGND VNB VPB VPWR
.ends

* Black-box entry subcircuit for sky130_fd_sc_hd__tapvpwrvgnd_1 abstract view
.subckt sky130_fd_sc_hd__tapvpwrvgnd_1 VGND VPWR
.ends

* Black-box entry subcircuit for sky130_fd_sc_hd__fill_1 abstract view
.subckt sky130_fd_sc_hd__fill_1 VGND VNB VPB VPWR
.ends

* Black-box entry subcircuit for sky130_fd_sc_hd__a22o_1 abstract view
.subckt sky130_fd_sc_hd__a22o_1 A1 A2 B1 B2 VGND VNB VPB VPWR X
.ends

* Black-box entry subcircuit for sky130_ef_sc_hd__decap_40_12 abstract view
.subckt sky130_ef_sc_hd__decap_40_12 VPWR VGND VPB VNB
.ends

* Black-box entry subcircuit for sky130_fd_sc_hd__fill_4 abstract view
.subckt sky130_fd_sc_hd__fill_4 VGND VNB VPB VPWR
.ends

* Black-box entry subcircuit for sky130_fd_sc_hd__mux2_1 abstract view
.subckt sky130_fd_sc_hd__mux2_1 A0 A1 S VGND VNB VPB VPWR X
.ends

* Black-box entry subcircuit for sky130_fd_sc_hd__dfrtp_1 abstract view
.subckt sky130_fd_sc_hd__dfrtp_1 CLK D RESET_B VGND VNB VPB VPWR Q
.ends

* Black-box entry subcircuit for sky130_fd_sc_hd__clkbuf_2 abstract view
.subckt sky130_fd_sc_hd__clkbuf_2 A VGND VNB VPB VPWR X
.ends

* Black-box entry subcircuit for sky130_fd_sc_hd__dfxtp_1 abstract view
.subckt sky130_fd_sc_hd__dfxtp_1 CLK D VGND VNB VPB VPWR Q
.ends

* Black-box entry subcircuit for sky130_fd_sc_hd__clkbuf_4 abstract view
.subckt sky130_fd_sc_hd__clkbuf_4 A VGND VNB VPB VPWR X
.ends

* Black-box entry subcircuit for sky130_fd_sc_hd__nor2_1 abstract view
.subckt sky130_fd_sc_hd__nor2_1 A B VGND VNB VPB VPWR Y
.ends

* Black-box entry subcircuit for sky130_fd_sc_hd__buf_2 abstract view
.subckt sky130_fd_sc_hd__buf_2 A VGND VNB VPB VPWR X
.ends

* Black-box entry subcircuit for sky130_fd_sc_hd__nand2_1 abstract view
.subckt sky130_fd_sc_hd__nand2_1 A B VGND VNB VPB VPWR Y
.ends

* Black-box entry subcircuit for sky130_fd_sc_hd__dlygate4sd3_1 abstract view
.subckt sky130_fd_sc_hd__dlygate4sd3_1 A VGND VNB VPB VPWR X
.ends

* Black-box entry subcircuit for sky130_fd_sc_hd__diode_2 abstract view
.subckt sky130_fd_sc_hd__diode_2 DIODE VGND VNB VPB VPWR
.ends

* Black-box entry subcircuit for sky130_fd_sc_hd__o21ba_1 abstract view
.subckt sky130_fd_sc_hd__o21ba_1 A1 A2 B1_N VGND VNB VPB VPWR X
.ends

* Black-box entry subcircuit for sky130_fd_sc_hd__and2_1 abstract view
.subckt sky130_fd_sc_hd__and2_1 A B VGND VNB VPB VPWR X
.ends

* Black-box entry subcircuit for sky130_fd_sc_hd__o21a_1 abstract view
.subckt sky130_fd_sc_hd__o21a_1 A1 A2 B1 VGND VNB VPB VPWR X
.ends

* Black-box entry subcircuit for sky130_fd_sc_hd__a32o_1 abstract view
.subckt sky130_fd_sc_hd__a32o_1 A1 A2 A3 B1 B2 VGND VNB VPB VPWR X
.ends

* Black-box entry subcircuit for sky130_fd_sc_hd__nand3_1 abstract view
.subckt sky130_fd_sc_hd__nand3_1 A B C VGND VNB VPB VPWR Y
.ends

* Black-box entry subcircuit for sky130_fd_sc_hd__or4_1 abstract view
.subckt sky130_fd_sc_hd__or4_1 A B C D VGND VNB VPB VPWR X
.ends

* Black-box entry subcircuit for sky130_fd_sc_hd__nor3_1 abstract view
.subckt sky130_fd_sc_hd__nor3_1 A B C VGND VNB VPB VPWR Y
.ends

* Black-box entry subcircuit for sky130_fd_sc_hd__fill_8 abstract view
.subckt sky130_fd_sc_hd__fill_8 VGND VNB VPB VPWR
.ends

* Black-box entry subcircuit for sky130_fd_sc_hd__a2bb2o_1 abstract view
.subckt sky130_fd_sc_hd__a2bb2o_1 A1_N A2_N B1 B2 VGND VNB VPB VPWR X
.ends

* Black-box entry subcircuit for sky130_fd_sc_hd__a21oi_1 abstract view
.subckt sky130_fd_sc_hd__a21oi_1 A1 A2 B1 VGND VNB VPB VPWR Y
.ends

* Black-box entry subcircuit for sky130_fd_sc_hd__and2b_1 abstract view
.subckt sky130_fd_sc_hd__and2b_1 A_N B VGND VNB VPB VPWR X
.ends

* Black-box entry subcircuit for sky130_fd_sc_hd__nor4_1 abstract view
.subckt sky130_fd_sc_hd__nor4_1 A B C D VGND VNB VPB VPWR Y
.ends

* Black-box entry subcircuit for sky130_fd_sc_hd__inv_2 abstract view
.subckt sky130_fd_sc_hd__inv_2 A VGND VNB VPB VPWR Y
.ends

* Black-box entry subcircuit for sky130_fd_sc_hd__or2_1 abstract view
.subckt sky130_fd_sc_hd__or2_1 A B VGND VNB VPB VPWR X
.ends

* Black-box entry subcircuit for sky130_fd_sc_hd__o221a_1 abstract view
.subckt sky130_fd_sc_hd__o221a_1 A1 A2 B1 B2 C1 VGND VNB VPB VPWR X
.ends

* Black-box entry subcircuit for sky130_fd_sc_hd__o21ai_1 abstract view
.subckt sky130_fd_sc_hd__o21ai_1 A1 A2 B1 VGND VNB VPB VPWR Y
.ends

* Black-box entry subcircuit for sky130_fd_sc_hd__a31o_1 abstract view
.subckt sky130_fd_sc_hd__a31o_1 A1 A2 A3 B1 VGND VNB VPB VPWR X
.ends

* Black-box entry subcircuit for sky130_fd_sc_hd__conb_1 abstract view
.subckt sky130_fd_sc_hd__conb_1 VGND VNB VPB VPWR HI LO
.ends

* Black-box entry subcircuit for sky130_fd_sc_hd__nand2b_1 abstract view
.subckt sky130_fd_sc_hd__nand2b_1 A_N B VGND VNB VPB VPWR Y
.ends

* Black-box entry subcircuit for sky130_fd_sc_hd__a21bo_1 abstract view
.subckt sky130_fd_sc_hd__a21bo_1 A1 A2 B1_N VGND VNB VPB VPWR X
.ends

* Black-box entry subcircuit for sky130_fd_sc_hd__or3_2 abstract view
.subckt sky130_fd_sc_hd__or3_2 A B C VGND VNB VPB VPWR X
.ends

* Black-box entry subcircuit for sky130_fd_sc_hd__o31a_1 abstract view
.subckt sky130_fd_sc_hd__o31a_1 A1 A2 A3 B1 VGND VNB VPB VPWR X
.ends

* Black-box entry subcircuit for sky130_fd_sc_hd__dlymetal6s2s_1 abstract view
.subckt sky130_fd_sc_hd__dlymetal6s2s_1 A VGND VNB VPB VPWR X
.ends

* Black-box entry subcircuit for sky130_fd_sc_hd__decap_3 abstract view
.subckt sky130_fd_sc_hd__decap_3 VGND VNB VPB VPWR
.ends

* Black-box entry subcircuit for sky130_fd_sc_hd__o22a_1 abstract view
.subckt sky130_fd_sc_hd__o22a_1 A1 A2 B1 B2 VGND VNB VPB VPWR X
.ends

* Black-box entry subcircuit for sky130_fd_sc_hd__a221o_1 abstract view
.subckt sky130_fd_sc_hd__a221o_1 A1 A2 B1 B2 C1 VGND VNB VPB VPWR X
.ends

* Black-box entry subcircuit for sky130_fd_sc_hd__o211a_1 abstract view
.subckt sky130_fd_sc_hd__o211a_1 A1 A2 B1 C1 VGND VNB VPB VPWR X
.ends

* Black-box entry subcircuit for sky130_fd_sc_hd__a31oi_2 abstract view
.subckt sky130_fd_sc_hd__a31oi_2 A1 A2 A3 B1 VGND VNB VPB VPWR Y
.ends

* Black-box entry subcircuit for sky130_fd_sc_hd__a211o_1 abstract view
.subckt sky130_fd_sc_hd__a211o_1 A1 A2 B1 C1 VGND VNB VPB VPWR X
.ends

* Black-box entry subcircuit for sky130_fd_sc_hd__and3_1 abstract view
.subckt sky130_fd_sc_hd__and3_1 A B C VGND VNB VPB VPWR X
.ends

* Black-box entry subcircuit for sky130_fd_sc_hd__or3_1 abstract view
.subckt sky130_fd_sc_hd__or3_1 A B C VGND VNB VPB VPWR X
.ends

* Black-box entry subcircuit for sky130_fd_sc_hd__or4bb_4 abstract view
.subckt sky130_fd_sc_hd__or4bb_4 A B C_N D_N VGND VNB VPB VPWR X
.ends

* Black-box entry subcircuit for sky130_fd_sc_hd__dfrtp_2 abstract view
.subckt sky130_fd_sc_hd__dfrtp_2 CLK D RESET_B VGND VNB VPB VPWR Q
.ends

* Black-box entry subcircuit for sky130_fd_sc_hd__a211oi_2 abstract view
.subckt sky130_fd_sc_hd__a211oi_2 A1 A2 B1 C1 VGND VNB VPB VPWR Y
.ends

* Black-box entry subcircuit for sky130_fd_sc_hd__and4_1 abstract view
.subckt sky130_fd_sc_hd__and4_1 A B C D VGND VNB VPB VPWR X
.ends

* Black-box entry subcircuit for sky130_fd_sc_hd__xor2_1 abstract view
.subckt sky130_fd_sc_hd__xor2_1 A B VGND VNB VPB VPWR X
.ends

* Black-box entry subcircuit for sky130_fd_sc_hd__a21o_1 abstract view
.subckt sky130_fd_sc_hd__a21o_1 A1 A2 B1 VGND VNB VPB VPWR X
.ends

* Black-box entry subcircuit for sky130_fd_sc_hd__or4bb_1 abstract view
.subckt sky130_fd_sc_hd__or4bb_1 A B C_N D_N VGND VNB VPB VPWR X
.ends

* Black-box entry subcircuit for sky130_fd_sc_hd__clkbuf_8 abstract view
.subckt sky130_fd_sc_hd__clkbuf_8 A VGND VNB VPB VPWR X
.ends

* Black-box entry subcircuit for sky130_fd_sc_hd__dfrtp_4 abstract view
.subckt sky130_fd_sc_hd__dfrtp_4 CLK D RESET_B VGND VNB VPB VPWR Q
.ends

* Black-box entry subcircuit for sky130_fd_sc_hd__inv_8 abstract view
.subckt sky130_fd_sc_hd__inv_8 A VGND VNB VPB VPWR Y
.ends

* Black-box entry subcircuit for sky130_fd_sc_hd__or4b_1 abstract view
.subckt sky130_fd_sc_hd__or4b_1 A B C D_N VGND VNB VPB VPWR X
.ends

* Black-box entry subcircuit for sky130_fd_sc_hd__a22oi_2 abstract view
.subckt sky130_fd_sc_hd__a22oi_2 A1 A2 B1 B2 VGND VNB VPB VPWR Y
.ends

* Black-box entry subcircuit for sky130_fd_sc_hd__inv_6 abstract view
.subckt sky130_fd_sc_hd__inv_6 A VGND VNB VPB VPWR Y
.ends

* Black-box entry subcircuit for sky130_fd_sc_hd__o311a_1 abstract view
.subckt sky130_fd_sc_hd__o311a_1 A1 A2 A3 B1 C1 VGND VNB VPB VPWR X
.ends

* Black-box entry subcircuit for sky130_fd_sc_hd__or3b_1 abstract view
.subckt sky130_fd_sc_hd__or3b_1 A B C_N VGND VNB VPB VPWR X
.ends

* Black-box entry subcircuit for sky130_fd_sc_hd__and3b_1 abstract view
.subckt sky130_fd_sc_hd__and3b_1 A_N B C VGND VNB VPB VPWR X
.ends

* Black-box entry subcircuit for sky130_fd_sc_hd__bufinv_16 abstract view
.subckt sky130_fd_sc_hd__bufinv_16 A VGND VNB VPB VPWR Y
.ends

* Black-box entry subcircuit for sky130_fd_sc_hd__a21boi_1 abstract view
.subckt sky130_fd_sc_hd__a21boi_1 A1 A2 B1_N VGND VNB VPB VPWR Y
.ends

* Black-box entry subcircuit for sky130_fd_sc_hd__o21bai_2 abstract view
.subckt sky130_fd_sc_hd__o21bai_2 A1 A2 B1_N VGND VNB VPB VPWR Y
.ends

* Black-box entry subcircuit for sky130_fd_sc_hd__and4b_1 abstract view
.subckt sky130_fd_sc_hd__and4b_1 A_N B C D VGND VNB VPB VPWR X
.ends

* Black-box entry subcircuit for sky130_fd_sc_hd__o2bb2a_1 abstract view
.subckt sky130_fd_sc_hd__o2bb2a_1 A1_N A2_N B1 B2 VGND VNB VPB VPWR X
.ends

* Black-box entry subcircuit for sky130_fd_sc_hd__nand2_4 abstract view
.subckt sky130_fd_sc_hd__nand2_4 A B VGND VNB VPB VPWR Y
.ends

* Black-box entry subcircuit for sky130_fd_sc_hd__clkbuf_16 abstract view
.subckt sky130_fd_sc_hd__clkbuf_16 A VGND VNB VPB VPWR X
.ends

* Black-box entry subcircuit for sky130_fd_sc_hd__clkbuf_1 abstract view
.subckt sky130_fd_sc_hd__clkbuf_1 A VGND VNB VPB VPWR X
.ends

* Black-box entry subcircuit for sky130_fd_sc_hd__dfstp_1 abstract view
.subckt sky130_fd_sc_hd__dfstp_1 CLK D SET_B VGND VNB VPB VPWR Q
.ends

* Black-box entry subcircuit for sky130_fd_sc_hd__nor2_4 abstract view
.subckt sky130_fd_sc_hd__nor2_4 A B VGND VNB VPB VPWR Y
.ends

* Black-box entry subcircuit for sky130_fd_sc_hd__clkinv_2 abstract view
.subckt sky130_fd_sc_hd__clkinv_2 A VGND VNB VPB VPWR Y
.ends

* Black-box entry subcircuit for sky130_fd_sc_hd__clkinv_4 abstract view
.subckt sky130_fd_sc_hd__clkinv_4 A VGND VNB VPB VPWR Y
.ends

* Black-box entry subcircuit for sky130_fd_sc_hd__clkinv_1 abstract view
.subckt sky130_fd_sc_hd__clkinv_1 A VGND VNB VPB VPWR Y
.ends

* Black-box entry subcircuit for sky130_fd_sc_hd__or4b_2 abstract view
.subckt sky130_fd_sc_hd__or4b_2 A B C D_N VGND VNB VPB VPWR X
.ends

* Black-box entry subcircuit for sky130_fd_sc_hd__dfstp_2 abstract view
.subckt sky130_fd_sc_hd__dfstp_2 CLK D SET_B VGND VNB VPB VPWR Q
.ends

* Black-box entry subcircuit for sky130_fd_sc_hd__and4bb_1 abstract view
.subckt sky130_fd_sc_hd__and4bb_1 A_N B_N C D VGND VNB VPB VPWR X
.ends

* Black-box entry subcircuit for sky130_fd_sc_hd__buf_1 abstract view
.subckt sky130_fd_sc_hd__buf_1 A VGND VNB VPB VPWR X
.ends

* Black-box entry subcircuit for sky130_fd_sc_hd__and4b_2 abstract view
.subckt sky130_fd_sc_hd__and4b_2 A_N B C D VGND VNB VPB VPWR X
.ends

* Black-box entry subcircuit for sky130_fd_sc_hd__inv_12 abstract view
.subckt sky130_fd_sc_hd__inv_12 A VGND VNB VPB VPWR Y
.ends

* Black-box entry subcircuit for sky130_fd_sc_hd__o32a_1 abstract view
.subckt sky130_fd_sc_hd__o32a_1 A1 A2 A3 B1 B2 VGND VNB VPB VPWR X
.ends

* Black-box entry subcircuit for sky130_fd_sc_hd__nand2_2 abstract view
.subckt sky130_fd_sc_hd__nand2_2 A B VGND VNB VPB VPWR Y
.ends

* Black-box entry subcircuit for sky130_fd_sc_hd__and4_2 abstract view
.subckt sky130_fd_sc_hd__and4_2 A B C D VGND VNB VPB VPWR X
.ends

* Black-box entry subcircuit for sky130_fd_sc_hd__clkinv_8 abstract view
.subckt sky130_fd_sc_hd__clkinv_8 A VGND VNB VPB VPWR Y
.ends

* Black-box entry subcircuit for sky130_fd_sc_hd__o221ai_1 abstract view
.subckt sky130_fd_sc_hd__o221ai_1 A1 A2 B1 B2 C1 VGND VNB VPB VPWR Y
.ends

* Black-box entry subcircuit for sky130_fd_sc_hd__clkinvlp_4 abstract view
.subckt sky130_fd_sc_hd__clkinvlp_4 A VGND VNB VPB VPWR Y
.ends

* Black-box entry subcircuit for sky130_fd_sc_hd__nand4_2 abstract view
.subckt sky130_fd_sc_hd__nand4_2 A B C D VGND VNB VPB VPWR Y
.ends

* Black-box entry subcircuit for sky130_fd_sc_hd__xnor2_2 abstract view
.subckt sky130_fd_sc_hd__xnor2_2 A B VGND VNB VPB VPWR Y
.ends

* Black-box entry subcircuit for sky130_fd_sc_hd__nor2_2 abstract view
.subckt sky130_fd_sc_hd__nor2_2 A B VGND VNB VPB VPWR Y
.ends

* Black-box entry subcircuit for sky130_fd_sc_hd__o2111ai_2 abstract view
.subckt sky130_fd_sc_hd__o2111ai_2 A1 A2 B1 C1 D1 VGND VNB VPB VPWR Y
.ends

* Black-box entry subcircuit for sky130_fd_sc_hd__o31ai_1 abstract view
.subckt sky130_fd_sc_hd__o31ai_1 A1 A2 A3 B1 VGND VNB VPB VPWR Y
.ends

* Black-box entry subcircuit for sky130_fd_sc_hd__nand4_1 abstract view
.subckt sky130_fd_sc_hd__nand4_1 A B C D VGND VNB VPB VPWR Y
.ends

* Black-box entry subcircuit for sky130_fd_sc_hd__a22oi_1 abstract view
.subckt sky130_fd_sc_hd__a22oi_1 A1 A2 B1 B2 VGND VNB VPB VPWR Y
.ends

* Black-box entry subcircuit for sky130_fd_sc_hd__or2_4 abstract view
.subckt sky130_fd_sc_hd__or2_4 A B VGND VNB VPB VPWR X
.ends

* Black-box entry subcircuit for sky130_fd_sc_hd__nand3_4 abstract view
.subckt sky130_fd_sc_hd__nand3_4 A B C VGND VNB VPB VPWR Y
.ends

* Black-box entry subcircuit for sky130_fd_sc_hd__and3_2 abstract view
.subckt sky130_fd_sc_hd__and3_2 A B C VGND VNB VPB VPWR X
.ends

* Black-box entry subcircuit for sky130_fd_sc_hd__or4b_4 abstract view
.subckt sky130_fd_sc_hd__or4b_4 A B C D_N VGND VNB VPB VPWR X
.ends

* Black-box entry subcircuit for sky130_fd_sc_hd__a311oi_1 abstract view
.subckt sky130_fd_sc_hd__a311oi_1 A1 A2 A3 B1 C1 VGND VNB VPB VPWR Y
.ends

* Black-box entry subcircuit for sky130_fd_sc_hd__and3b_2 abstract view
.subckt sky130_fd_sc_hd__and3b_2 A_N B C VGND VNB VPB VPWR X
.ends

* Black-box entry subcircuit for sky130_fd_sc_hd__a31oi_1 abstract view
.subckt sky130_fd_sc_hd__a31oi_1 A1 A2 A3 B1 VGND VNB VPB VPWR Y
.ends

* Black-box entry subcircuit for sky130_fd_sc_hd__or2_2 abstract view
.subckt sky130_fd_sc_hd__or2_2 A B VGND VNB VPB VPWR X
.ends

* Black-box entry subcircuit for sky130_fd_sc_hd__or3_4 abstract view
.subckt sky130_fd_sc_hd__or3_4 A B C VGND VNB VPB VPWR X
.ends

* Black-box entry subcircuit for sky130_fd_sc_hd__a21oi_2 abstract view
.subckt sky130_fd_sc_hd__a21oi_2 A1 A2 B1 VGND VNB VPB VPWR Y
.ends

* Black-box entry subcircuit for sky130_fd_sc_hd__nor3_2 abstract view
.subckt sky130_fd_sc_hd__nor3_2 A B C VGND VNB VPB VPWR Y
.ends

* Black-box entry subcircuit for sky130_fd_sc_hd__o2111a_1 abstract view
.subckt sky130_fd_sc_hd__o2111a_1 A1 A2 B1 C1 D1 VGND VNB VPB VPWR X
.ends

* Black-box entry subcircuit for sky130_fd_sc_hd__a41o_1 abstract view
.subckt sky130_fd_sc_hd__a41o_1 A1 A2 A3 A4 B1 VGND VNB VPB VPWR X
.ends

.subckt team_06 clk en gpio_in[0] gpio_in[10] gpio_in[11] gpio_in[12] gpio_in[13]
+ gpio_in[14] gpio_in[15] gpio_in[16] gpio_in[17] gpio_in[18] gpio_in[19] gpio_in[1]
+ gpio_in[20] gpio_in[21] gpio_in[22] gpio_in[23] gpio_in[24] gpio_in[25] gpio_in[26]
+ gpio_in[27] gpio_in[28] gpio_in[29] gpio_in[2] gpio_in[30] gpio_in[31] gpio_in[32]
+ gpio_in[33] gpio_in[3] gpio_in[4] gpio_in[5] gpio_in[6] gpio_in[7] gpio_in[8] gpio_in[9]
+ gpio_oeb[0] gpio_oeb[10] gpio_oeb[11] gpio_oeb[12] gpio_oeb[13] gpio_oeb[14] gpio_oeb[15]
+ gpio_oeb[16] gpio_oeb[17] gpio_oeb[18] gpio_oeb[19] gpio_oeb[1] gpio_oeb[20] gpio_oeb[21]
+ gpio_oeb[22] gpio_oeb[23] gpio_oeb[24] gpio_oeb[25] gpio_oeb[26] gpio_oeb[27] gpio_oeb[28]
+ gpio_oeb[29] gpio_oeb[2] gpio_oeb[30] gpio_oeb[31] gpio_oeb[32] gpio_oeb[33] gpio_oeb[3]
+ gpio_oeb[4] gpio_oeb[5] gpio_oeb[6] gpio_oeb[7] gpio_oeb[8] gpio_oeb[9] gpio_out[0]
+ gpio_out[10] gpio_out[11] gpio_out[12] gpio_out[13] gpio_out[14] gpio_out[15] gpio_out[16]
+ gpio_out[17] gpio_out[18] gpio_out[19] gpio_out[1] gpio_out[20] gpio_out[21] gpio_out[22]
+ gpio_out[23] gpio_out[24] gpio_out[25] gpio_out[26] gpio_out[27] gpio_out[28] gpio_out[29]
+ gpio_out[2] gpio_out[30] gpio_out[31] gpio_out[32] gpio_out[33] gpio_out[3] gpio_out[4]
+ gpio_out[5] gpio_out[6] gpio_out[7] gpio_out[8] gpio_out[9] nrst vccd1 vssd1
X_2037_ _0924_ _0978_ vssd1 vssd1 vccd1 vccd1 _0979_ sky130_fd_sc_hd__xnor2_1
XFILLER_39_266 vssd1 vssd1 vccd1 vccd1 sky130_fd_sc_hd__fill_2
XTAP_TAPCELL_ROW_37_401 vssd1 vccd1 sky130_fd_sc_hd__tapvpwrvgnd_1
XFILLER_27_406 vssd1 vssd1 vccd1 vccd1 sky130_fd_sc_hd__fill_1
X_2106_ net135 net288 net124 net294 vssd1 vssd1 vccd1 vccd1 _0345_ sky130_fd_sc_hd__a22o_1
XFILLER_62_280 vccd1 vssd1 vccd1 vssd1 sky130_ef_sc_hd__decap_40_12
XFILLER_52_29 vccd1 vssd1 vccd1 vssd1 sky130_ef_sc_hd__decap_40_12
XFILLER_26_85 vssd1 vssd1 vccd1 vccd1 sky130_fd_sc_hd__fill_2
XFILLER_13_122 vssd1 vssd1 vccd1 vccd1 sky130_fd_sc_hd__fill_4
X_1270_ CALC_INST.gencon_inst.operand2\[10\] _0467_ vssd1 vssd1 vccd1 vccd1 _0470_
+ sky130_fd_sc_hd__xnor2_1
XFILLER_3_67 vssd1 vssd1 vccd1 vccd1 sky130_fd_sc_hd__fill_1
XFILLER_44_280 vssd1 vssd1 vccd1 vccd1 sky130_fd_sc_hd__fill_2
X_1606_ CALC_INST.gencon_inst.operand1\[1\] net306 net63 vssd1 vssd1 vccd1 vccd1 _0123_
+ sky130_fd_sc_hd__mux2_1
X_2655_ clknet_leaf_32_clk _0214_ net89 vssd1 vssd1 vccd1 vccd1 CALC_INST.gencon_inst.mult_calc.adderSave\[2\]
+ sky130_fd_sc_hd__dfrtp_1
X_2724_ clknet_leaf_26_clk _0283_ net108 vssd1 vssd1 vccd1 vccd1 CALC_INST.gencon_inst.mult_calc.out\[10\]
+ sky130_fd_sc_hd__dfrtp_1
Xfanout116 net121 vssd1 vssd1 vccd1 vccd1 net116 sky130_fd_sc_hd__clkbuf_2
X_2586_ clknet_leaf_15_clk _0145_ vssd1 vssd1 vccd1 vccd1 CALC_INST.gencon_inst.ALU_in2\[7\]
+ sky130_fd_sc_hd__dfxtp_1
X_1537_ CALC_INST.gencon_inst.ALU_out\[6\] net76 net67 CALC_INST.gencon_inst.mult_calc.out\[6\]
+ vssd1 vssd1 vccd1 vccd1 _0678_ sky130_fd_sc_hd__a22o_1
Xfanout149 CALC_INST.gencon_inst.gencon_state\[0\] vssd1 vssd1 vccd1 vccd1 net149
+ sky130_fd_sc_hd__clkbuf_2
Xfanout105 net112 vssd1 vssd1 vccd1 vccd1 net105 sky130_fd_sc_hd__clkbuf_4
X_1399_ CALC_INST.input_ctrl_inst.col_index\[0\] net51 vssd1 vssd1 vccd1 vccd1 _0579_
+ sky130_fd_sc_hd__nor2_1
Xfanout127 _1052_ vssd1 vssd1 vccd1 vccd1 net127 sky130_fd_sc_hd__buf_2
X_1468_ net474 _0578_ vssd1 vssd1 vccd1 vccd1 _0624_ sky130_fd_sc_hd__nand2_1
Xfanout138 CALC_INST.gencon_inst.mult_calc.state\[3\] vssd1 vssd1 vccd1 vccd1 net138
+ sky130_fd_sc_hd__buf_2
XTAP_TAPCELL_ROW_40_418 vssd1 vccd1 sky130_fd_sc_hd__tapvpwrvgnd_1
Xhold181 CALC_INST.input_ctrl_inst.scan_timer\[5\] vssd1 vssd1 vccd1 vccd1 net380
+ sky130_fd_sc_hd__dlygate4sd3_1
XFILLER_2_379 vccd1 vssd1 vccd1 vssd1 sky130_ef_sc_hd__decap_40_12
XFILLER_2_357 vssd1 vssd1 vccd1 vccd1 sky130_fd_sc_hd__fill_4
XFILLER_12_87 vssd1 vssd1 vccd1 vccd1 sky130_fd_sc_hd__fill_1
Xhold170 CALC_INST.gencon_inst.mult_calc.compCount.in2\[2\] vssd1 vssd1 vccd1 vccd1
+ net369 sky130_fd_sc_hd__dlygate4sd3_1
Xhold192 CALC_INST.gencon_inst.mult_calc.compCount.in2\[4\] vssd1 vssd1 vccd1 vccd1
+ net391 sky130_fd_sc_hd__dlygate4sd3_1
XFILLER_58_372 vssd1 vssd1 vccd1 vccd1 sky130_fd_sc_hd__fill_2
XANTENNA_clkbuf_leaf_31_clk_A clknet_2_2__leaf_clk vssd1 vssd1 vccd1 vccd1 sky130_fd_sc_hd__diode_2
XTAP_TAPCELL_ROW_5_173 vssd1 vccd1 sky130_fd_sc_hd__tapvpwrvgnd_1
X_2440_ net317 net334 net277 vssd1 vssd1 vccd1 vccd1 _0000_ sky130_fd_sc_hd__o21ba_1
XFILLER_52_6 vssd1 vssd1 vccd1 vccd1 sky130_fd_sc_hd__fill_2
X_1322_ CALC_INST.gencon_inst.operand1\[3\] CALC_INST.gencon_inst.latched_keypad_input\[3\]
+ vssd1 vssd1 vccd1 vccd1 _0514_ sky130_fd_sc_hd__and2_1
X_1253_ CALC_INST.gencon_inst.operand2\[5\] net36 _0457_ vssd1 vssd1 vccd1 vccd1 _0037_
+ sky130_fd_sc_hd__o21a_1
X_2371_ net39 _1203_ _1204_ net41 net470 vssd1 vssd1 vccd1 vccd1 _0012_ sky130_fd_sc_hd__a32o_1
XFILLER_64_397 vssd1 vssd1 vccd1 vccd1 sky130_fd_sc_hd__fill_1
XTAP_TAPCELL_ROW_19_275 vssd1 vccd1 sky130_fd_sc_hd__tapvpwrvgnd_1
XTAP_TAPCELL_ROW_62_576 vssd1 vccd1 sky130_fd_sc_hd__tapvpwrvgnd_1
X_2638_ clknet_leaf_15_clk _0197_ net115 vssd1 vssd1 vccd1 vccd1 CALC_INST.gencon_inst.add_calc.main.in2\[6\]
+ sky130_fd_sc_hd__dfrtp_1
X_2569_ clknet_leaf_15_clk _0128_ vssd1 vssd1 vccd1 vccd1 CALC_INST.gencon_inst.ALU_in1\[6\]
+ sky130_fd_sc_hd__dfxtp_1
X_2707_ clknet_leaf_24_clk _0266_ net109 vssd1 vssd1 vccd1 vccd1 CALC_INST.gencon_inst.mult_calc.main.GENERATE_ADDER\[8\].thingy.in2
+ sky130_fd_sc_hd__dfrtp_1
XFILLER_59_169 vssd1 vssd1 vccd1 vccd1 sky130_fd_sc_hd__fill_4
XTAP_TAPCELL_ROW_2_154 vssd1 vccd1 sky130_fd_sc_hd__tapvpwrvgnd_1
XFILLER_55_364 vssd1 vssd1 vccd1 vccd1 sky130_fd_sc_hd__fill_1
XTAP_TAPCELL_ROW_53_510 vssd1 vccd1 sky130_fd_sc_hd__tapvpwrvgnd_1
XFILLER_23_53 vssd1 vssd1 vccd1 vccd1 sky130_fd_sc_hd__fill_2
XFILLER_2_143 vssd1 vssd1 vccd1 vccd1 sky130_fd_sc_hd__fill_1
XFILLER_61_301 vssd1 vssd1 vccd1 vccd1 sky130_fd_sc_hd__fill_1
XFILLER_48_94 vssd1 vssd1 vccd1 vccd1 sky130_fd_sc_hd__fill_4
XFILLER_46_386 vssd1 vssd1 vccd1 vccd1 sky130_fd_sc_hd__fill_1
XFILLER_0_57 vccd1 vssd1 vccd1 vssd1 sky130_ef_sc_hd__decap_40_12
XFILLER_61_367 vssd1 vssd1 vccd1 vccd1 sky130_fd_sc_hd__fill_4
X_1940_ CALC_INST.gencon_inst.add_calc.main.GENERATE_ADDER\[6\].thingy.in1 _0888_
+ _0889_ vssd1 vssd1 vccd1 vccd1 _0891_ sky130_fd_sc_hd__nand3_1
XANTENNA__2064__A1 net154 vssd1 vssd1 vccd1 vccd1 sky130_fd_sc_hd__diode_2
XFILLER_9_55 vssd1 vssd1 vccd1 vccd1 sky130_fd_sc_hd__fill_1
XFILLER_14_261 vssd1 vssd1 vccd1 vccd1 sky130_fd_sc_hd__fill_1
X_1871_ net134 net344 net123 net451 vssd1 vssd1 vccd1 vccd1 _0258_ sky130_fd_sc_hd__a22o_1
X_2423_ CALC_INST.input_ctrl_inst.col_index\[29\] CALC_INST.input_ctrl_inst.col_index\[28\]
+ CALC_INST.input_ctrl_inst.col_index\[31\] CALC_INST.input_ctrl_inst.col_index\[30\]
+ vssd1 vssd1 vccd1 vccd1 _0403_ sky130_fd_sc_hd__or4_1
XFILLER_49_180 vssd1 vssd1 vccd1 vccd1 sky130_fd_sc_hd__fill_1
X_1305_ CALC_INST.gencon_inst.ALU_out\[0\] net75 net69 CALC_INST.gencon_inst.mult_calc.out\[0\]
+ vssd1 vssd1 vccd1 vccd1 _0500_ sky130_fd_sc_hd__a22o_1
X_1236_ CALC_INST.gencon_inst.operand2\[3\] CALC_INST.gencon_inst.latched_keypad_input\[3\]
+ vssd1 vssd1 vccd1 vccd1 _0443_ sky130_fd_sc_hd__and2_1
X_2354_ net39 _1190_ _1192_ net41 net475 vssd1 vssd1 vccd1 vccd1 _0025_ sky130_fd_sc_hd__a32o_1
X_2285_ _1139_ _1140_ _1142_ vssd1 vssd1 vccd1 vccd1 _1143_ sky130_fd_sc_hd__nor3_1
XANTENNA__1878__A1 net133 vssd1 vssd1 vccd1 vccd1 sky130_fd_sc_hd__diode_2
XFILLER_64_194 vssd1 vssd1 vccd1 vccd1 sky130_fd_sc_hd__fill_2
XFILLER_37_353 vssd1 vssd1 vccd1 vccd1 sky130_fd_sc_hd__fill_1
XFILLER_60_29 vssd1 vssd1 vccd1 vccd1 sky130_fd_sc_hd__fill_8
XFILLER_60_18 vssd1 vssd1 vccd1 vccd1 sky130_fd_sc_hd__fill_8
XFILLER_20_253 vssd1 vssd1 vccd1 vccd1 sky130_fd_sc_hd__fill_4
XFILLER_62_109 vssd1 vssd1 vccd1 vccd1 sky130_fd_sc_hd__fill_1
XFILLER_18_53 vssd1 vssd1 vccd1 vccd1 sky130_fd_sc_hd__fill_8
XFILLER_34_85 vssd1 vssd1 vccd1 vccd1 sky130_fd_sc_hd__fill_4
XFILLER_34_63 vssd1 vssd1 vccd1 vccd1 sky130_fd_sc_hd__fill_1
XFILLER_11_242 vssd1 vssd1 vccd1 vccd1 sky130_fd_sc_hd__fill_1
XFILLER_7_279 vssd1 vssd1 vccd1 vccd1 sky130_fd_sc_hd__fill_1
XFILLER_59_93 vccd1 vssd1 vccd1 vssd1 sky130_ef_sc_hd__decap_40_12
XFILLER_38_139 vssd1 vssd1 vccd1 vccd1 sky130_fd_sc_hd__fill_1
XFILLER_22_7 vssd1 vssd1 vccd1 vccd1 sky130_fd_sc_hd__fill_8
X_2070_ net127 _1109_ net129 net307 vssd1 vssd1 vccd1 vccd1 _0311_ sky130_fd_sc_hd__a2bb2o_1
XFILLER_53_109 vssd1 vssd1 vccd1 vccd1 sky130_fd_sc_hd__fill_2
XFILLER_34_356 vssd1 vssd1 vccd1 vccd1 sky130_fd_sc_hd__fill_8
X_1923_ _0872_ _0873_ CALC_INST.gencon_inst.add_calc.main.GENERATE_ADDER\[10\].thingy.in1
+ vssd1 vssd1 vccd1 vccd1 _0874_ sky130_fd_sc_hd__a21oi_1
XANTENNA__1260__A2 net49 vssd1 vssd1 vccd1 vccd1 sky130_fd_sc_hd__diode_2
X_1854_ net228 net212 net137 vssd1 vssd1 vccd1 vccd1 _0242_ sky130_fd_sc_hd__mux2_1
X_1785_ _0807_ _0808_ vssd1 vssd1 vccd1 vccd1 _0809_ sky130_fd_sc_hd__and2b_1
X_2406_ CALC_INST.input_ctrl_inst.col_index\[5\] CALC_INST.input_ctrl_inst.col_index\[4\]
+ CALC_INST.input_ctrl_inst.col_index\[7\] CALC_INST.input_ctrl_inst.col_index\[6\]
+ vssd1 vssd1 vccd1 vccd1 _0386_ sky130_fd_sc_hd__nor4_1
X_2199_ net146 vssd1 vssd1 vccd1 vccd1 _1059_ sky130_fd_sc_hd__inv_2
XANTENNA__2538__RESET_B net100 vssd1 vssd1 vccd1 vccd1 sky130_fd_sc_hd__diode_2
XTAP_TAPCELL_ROW_27_329 vssd1 vccd1 sky130_fd_sc_hd__tapvpwrvgnd_1
XFILLER_25_334 vssd1 vssd1 vccd1 vccd1 sky130_fd_sc_hd__fill_2
X_2337_ CALC_INST.input_ctrl_inst.debounce_cnt\[4\] _1177_ vssd1 vssd1 vccd1 vccd1
+ _1180_ sky130_fd_sc_hd__or2_1
X_2268_ CALC_INST.gencon_inst.mult_calc.compCount.in2\[9\] _1122_ _1123_ _1120_ _1125_
+ vssd1 vssd1 vccd1 vccd1 _1126_ sky130_fd_sc_hd__o221a_1
XFILLER_52_186 vssd1 vssd1 vccd1 vccd1 sky130_fd_sc_hd__fill_1
XTAP_TAPCELL_ROW_35_384 vssd1 vccd1 sky130_fd_sc_hd__tapvpwrvgnd_1
XTAP_TAPCELL_ROW_10_207 vssd1 vccd1 sky130_fd_sc_hd__tapvpwrvgnd_1
XANTENNA__1539__B1 _0660_ vssd1 vssd1 vccd1 vccd1 sky130_fd_sc_hd__diode_2
Xhold52 CALC_INST.gencon_inst.ALU_in1\[2\] vssd1 vssd1 vccd1 vccd1 net251 sky130_fd_sc_hd__dlygate4sd3_1
Xhold74 CALC_INST.gencon_inst.ALU_in1\[7\] vssd1 vssd1 vccd1 vccd1 net273 sky130_fd_sc_hd__dlygate4sd3_1
Xhold63 CALC_INST.gencon_inst.mult_calc.main.GENERATE_ADDER\[12\].thingy.in1 vssd1
+ vssd1 vccd1 vccd1 net262 sky130_fd_sc_hd__dlygate4sd3_1
Xhold30 CALC_INST.gencon_inst.mult_calc.main.GENERATE_ADDER\[8\].thingy.in1 vssd1
+ vssd1 vccd1 vccd1 net229 sky130_fd_sc_hd__dlygate4sd3_1
Xhold41 CALC_INST.gencon_inst.mult_calc.countSave\[3\] vssd1 vssd1 vccd1 vccd1 net240
+ sky130_fd_sc_hd__dlygate4sd3_1
Xhold96 net17 vssd1 vssd1 vccd1 vccd1 net295 sky130_fd_sc_hd__dlygate4sd3_1
XFILLER_35_109 vssd1 vssd1 vccd1 vccd1 sky130_fd_sc_hd__fill_2
Xhold85 CALC_INST.gencon_inst.mult_calc.countSave\[4\] vssd1 vssd1 vccd1 vccd1 net284
+ sky130_fd_sc_hd__dlygate4sd3_1
XFILLER_31_337 vssd1 vssd1 vccd1 vccd1 sky130_fd_sc_hd__fill_1
X_1570_ net286 _0660_ _0702_ vssd1 vssd1 vccd1 vccd1 _0109_ sky130_fd_sc_hd__o21a_1
X_2053_ _0988_ _0989_ _0933_ vssd1 vssd1 vccd1 vccd1 _0992_ sky130_fd_sc_hd__o21ai_1
X_2122_ _1150_ _1006_ _1009_ CALC_INST.input_ctrl_inst.decoded_key\[3\] vssd1 vssd1
+ vccd1 vccd1 _1010_ sky130_fd_sc_hd__a31o_1
XFILLER_34_197 vssd1 vssd1 vccd1 vccd1 sky130_fd_sc_hd__fill_2
XTAP_TAPCELL_ROW_32_365 vssd1 vccd1 sky130_fd_sc_hd__tapvpwrvgnd_1
XFILLER_22_348 vssd1 vssd1 vccd1 vccd1 sky130_fd_sc_hd__fill_1
X_1906_ net146 CALC_INST.gencon_inst.add_calc.main.in2\[14\] vssd1 vssd1 vccd1 vccd1
+ _0857_ sky130_fd_sc_hd__or2_1
X_1837_ _0851_ _0852_ vssd1 vssd1 vccd1 vccd1 _0853_ sky130_fd_sc_hd__xnor2_1
X_1768_ CALC_INST.gencon_inst.mult_calc.main.GENERATE_ADDER\[4\].thingy.in2 CALC_INST.gencon_inst.mult_calc.main.GENERATE_ADDER\[4\].thingy.in1
+ vssd1 vssd1 vccd1 vccd1 _0794_ sky130_fd_sc_hd__nor2_1
XFILLER_57_223 vssd1 vssd1 vccd1 vccd1 sky130_fd_sc_hd__fill_1
X_1699_ net489 _0749_ net150 vssd1 vssd1 vccd1 vccd1 _0191_ sky130_fd_sc_hd__mux2_1
XFILLER_57_278 vssd1 vssd1 vccd1 vccd1 sky130_fd_sc_hd__fill_2
XFILLER_40_178 vssd1 vssd1 vccd1 vccd1 sky130_fd_sc_hd__fill_1
XFILLER_15_87 vssd1 vssd1 vccd1 vccd1 sky130_fd_sc_hd__fill_4
Xoutput7 net7 vssd1 vssd1 vccd1 vccd1 gpio_out[10] sky130_fd_sc_hd__buf_2
Xoutput31 net31 vssd1 vssd1 vccd1 vccd1 gpio_out[9] sky130_fd_sc_hd__buf_2
Xoutput20 net20 vssd1 vssd1 vccd1 vccd1 gpio_out[23] sky130_fd_sc_hd__buf_2
Xteam_06_165 vssd1 vssd1 vccd1 vccd1 team_06_165/HI gpio_oeb[13] sky130_fd_sc_hd__conb_1
XANTENNA__2072__A1_N net127 vssd1 vssd1 vccd1 vccd1 sky130_fd_sc_hd__diode_2
Xteam_06_176 vssd1 vssd1 vccd1 vccd1 team_06_176/HI gpio_oeb[24] sky130_fd_sc_hd__conb_1
Xteam_06_198 vssd1 vssd1 vccd1 vccd1 gpio_oeb[32] team_06_198/LO sky130_fd_sc_hd__conb_1
XFILLER_56_61 vssd1 vssd1 vccd1 vccd1 sky130_fd_sc_hd__fill_2
Xteam_06_187 vssd1 vssd1 vccd1 vccd1 team_06_187/HI gpio_out[31] sky130_fd_sc_hd__conb_1
XFILLER_48_278 vssd1 vssd1 vccd1 vccd1 sky130_fd_sc_hd__fill_1
XANTENNA__1999__B1 net126 vssd1 vssd1 vccd1 vccd1 sky130_fd_sc_hd__diode_2
X_2740_ clknet_leaf_17_clk _0299_ net119 vssd1 vssd1 vccd1 vccd1 CALC_INST.gencon_inst.ALU_out\[9\]
+ sky130_fd_sc_hd__dfrtp_1
X_1622_ CALC_INST.gencon_inst.operand2\[1\] net291 net63 vssd1 vssd1 vccd1 vccd1 _0139_
+ sky130_fd_sc_hd__mux2_1
XFILLER_8_396 vssd1 vssd1 vccd1 vccd1 sky130_fd_sc_hd__fill_8
X_2671_ clknet_leaf_29_clk _0230_ net101 vssd1 vssd1 vccd1 vccd1 CALC_INST.gencon_inst.mult_calc.compCount.in2\[3\]
+ sky130_fd_sc_hd__dfrtp_1
XFILLER_12_370 vssd1 vssd1 vccd1 vccd1 sky130_fd_sc_hd__fill_2
X_1553_ CALC_INST.gencon_inst.operand2\[10\] CALC_INST.gencon_inst.operand1\[10\]
+ net74 vssd1 vssd1 vccd1 vccd1 _0690_ sky130_fd_sc_hd__mux2_1
X_1484_ _0634_ _0635_ vssd1 vssd1 vccd1 vccd1 _0636_ sky130_fd_sc_hd__nor2_1
X_2036_ _0874_ _0875_ vssd1 vssd1 vccd1 vccd1 _0978_ sky130_fd_sc_hd__nand2b_1
XFILLER_39_256 vssd1 vssd1 vccd1 vccd1 sky130_fd_sc_hd__fill_1
XTAP_TAPCELL_ROW_37_402 vssd1 vccd1 sky130_fd_sc_hd__tapvpwrvgnd_1
X_2105_ net133 net289 net122 CALC_INST.gencon_inst.mult_calc.count.GENERATE_ADDER\[7\].thingy.in1
+ vssd1 vssd1 vccd1 vccd1 _0344_ sky130_fd_sc_hd__a22o_1
XANTENNA__2100__B1 net122 vssd1 vssd1 vccd1 vccd1 sky130_fd_sc_hd__diode_2
XFILLER_10_307 vssd1 vssd1 vccd1 vccd1 sky130_fd_sc_hd__fill_1
XFILLER_10_318 vssd1 vssd1 vccd1 vccd1 sky130_fd_sc_hd__fill_4
XANTENNA__2553__RESET_B net99 vssd1 vssd1 vccd1 vccd1 sky130_fd_sc_hd__diode_2
XANTENNA_fanout68_A _0662_ vssd1 vssd1 vccd1 vccd1 sky130_fd_sc_hd__diode_2
XFILLER_53_270 vssd1 vssd1 vccd1 vccd1 sky130_fd_sc_hd__fill_4
XTAP_TAPCELL_ROW_43_438 vssd1 vccd1 sky130_fd_sc_hd__tapvpwrvgnd_1
XFILLER_42_96 vssd1 vssd1 vccd1 vccd1 sky130_fd_sc_hd__fill_1
XFILLER_42_85 vssd1 vssd1 vccd1 vccd1 sky130_fd_sc_hd__fill_4
XANTENNA_clkbuf_leaf_5_clk_A clknet_2_1__leaf_clk vssd1 vssd1 vccd1 vccd1 sky130_fd_sc_hd__diode_2
XFILLER_9_138 vssd1 vssd1 vccd1 vccd1 sky130_fd_sc_hd__fill_4
XFILLER_47_9 vssd1 vssd1 vccd1 vccd1 sky130_fd_sc_hd__fill_4
XTAP_TAPCELL_ROW_8_193 vssd1 vccd1 sky130_fd_sc_hd__tapvpwrvgnd_1
XFILLER_51_207 vssd1 vssd1 vccd1 vccd1 sky130_fd_sc_hd__fill_1
XANTENNA__2291__A net155 vssd1 vssd1 vccd1 vccd1 sky130_fd_sc_hd__diode_2
X_2723_ clknet_leaf_24_clk _0282_ net111 vssd1 vssd1 vccd1 vccd1 CALC_INST.gencon_inst.mult_calc.out\[9\]
+ sky130_fd_sc_hd__dfrtp_1
X_1605_ CALC_INST.gencon_inst.operand1\[0\] net248 net63 vssd1 vssd1 vccd1 vccd1 _0122_
+ sky130_fd_sc_hd__mux2_1
X_2585_ clknet_leaf_15_clk _0144_ vssd1 vssd1 vccd1 vccd1 CALC_INST.gencon_inst.ALU_in2\[6\]
+ sky130_fd_sc_hd__dfxtp_1
X_1536_ CALC_INST.gencon_inst.operand2\[6\] _0645_ _0647_ vssd1 vssd1 vccd1 vccd1
+ _0677_ sky130_fd_sc_hd__a21bo_1
X_2654_ clknet_leaf_32_clk _0213_ net91 vssd1 vssd1 vccd1 vccd1 CALC_INST.gencon_inst.mult_calc.adderSave\[1\]
+ sky130_fd_sc_hd__dfrtp_1
X_1398_ _1082_ _0573_ _0576_ vssd1 vssd1 vccd1 vccd1 _0578_ sky130_fd_sc_hd__or3_2
Xfanout117 net118 vssd1 vssd1 vccd1 vccd1 net117 sky130_fd_sc_hd__clkbuf_4
Xfanout106 net112 vssd1 vssd1 vccd1 vccd1 net106 sky130_fd_sc_hd__clkbuf_2
X_1467_ _1062_ _0578_ _0621_ _0623_ vssd1 vssd1 vccd1 vccd1 _0085_ sky130_fd_sc_hd__o31a_1
Xfanout128 _1052_ vssd1 vssd1 vccd1 vccd1 net128 sky130_fd_sc_hd__dlymetal6s2s_1
Xfanout139 CALC_INST.gencon_inst.mult_calc.state\[3\] vssd1 vssd1 vccd1 vccd1 net139
+ sky130_fd_sc_hd__clkbuf_4
XFILLER_63_29 vssd1 vssd1 vccd1 vccd1 sky130_fd_sc_hd__fill_2
X_2019_ _0919_ _0963_ vssd1 vssd1 vccd1 vccd1 _0964_ sky130_fd_sc_hd__xnor2_1
XFILLER_50_240 vssd1 vssd1 vccd1 vccd1 sky130_fd_sc_hd__fill_1
XFILLER_27_259 vssd1 vssd1 vccd1 vccd1 sky130_fd_sc_hd__fill_1
XPHY_EDGE_ROW_19_Left_84 vssd1 vssd1 vccd1 vccd1 sky130_fd_sc_hd__decap_3
XFILLER_50_262 vssd1 vssd1 vccd1 vccd1 sky130_fd_sc_hd__fill_1
XTAP_TAPCELL_ROW_40_419 vssd1 vccd1 sky130_fd_sc_hd__tapvpwrvgnd_1
XFILLER_6_119 vssd1 vssd1 vccd1 vccd1 sky130_fd_sc_hd__fill_1
XFILLER_10_137 vssd1 vssd1 vccd1 vccd1 sky130_fd_sc_hd__fill_2
XFILLER_12_77 vssd1 vssd1 vccd1 vccd1 sky130_fd_sc_hd__fill_1
Xhold160 CALC_INST.input_ctrl_inst.col_index\[16\] vssd1 vssd1 vccd1 vccd1 net359
+ sky130_fd_sc_hd__dlygate4sd3_1
Xhold171 _0229_ vssd1 vssd1 vccd1 vccd1 net370 sky130_fd_sc_hd__dlygate4sd3_1
Xhold193 _0231_ vssd1 vssd1 vccd1 vccd1 net392 sky130_fd_sc_hd__dlygate4sd3_1
Xhold182 CALC_INST.gencon_inst.mult_calc.main.GENERATE_ADDER\[11\].thingy.in2 vssd1
+ vssd1 vccd1 vccd1 net381 sky130_fd_sc_hd__dlygate4sd3_1
XFILLER_58_384 vssd1 vssd1 vccd1 vccd1 sky130_fd_sc_hd__fill_1
XTAP_TAPCELL_ROW_56_530 vssd1 vccd1 sky130_fd_sc_hd__tapvpwrvgnd_1
XFILLER_37_63 vssd1 vssd1 vccd1 vccd1 sky130_fd_sc_hd__fill_1
XTAP_TAPCELL_ROW_5_174 vssd1 vccd1 sky130_fd_sc_hd__tapvpwrvgnd_1
XFILLER_18_237 vssd1 vssd1 vccd1 vccd1 sky130_fd_sc_hd__fill_1
XANTENNA__2091__A2 net42 vssd1 vssd1 vccd1 vccd1 sky130_fd_sc_hd__diode_2
XFILLER_26_270 vssd1 vssd1 vccd1 vccd1 sky130_fd_sc_hd__fill_1
XANTENNA__2475__RESET_B net99 vssd1 vssd1 vccd1 vccd1 sky130_fd_sc_hd__diode_2
X_1321_ CALC_INST.gencon_inst.operand1\[2\] net47 _0512_ _0513_ vssd1 vssd1 vccd1
+ vccd1 _0049_ sky130_fd_sc_hd__o22a_1
X_1252_ CALC_INST.gencon_inst.mult_calc.out\[5\] net49 _0456_ net54 _0422_ vssd1 vssd1
+ vccd1 vccd1 _0457_ sky130_fd_sc_hd__a221o_1
XFILLER_1_391 vssd1 vssd1 vccd1 vccd1 sky130_fd_sc_hd__fill_1
X_2370_ CALC_INST.input_ctrl_inst.debounce_cnt\[13\] _1201_ vssd1 vssd1 vccd1 vccd1
+ _1204_ sky130_fd_sc_hd__or2_1
XFILLER_64_365 vccd1 vssd1 vccd1 vssd1 sky130_ef_sc_hd__decap_40_12
XTAP_TAPCELL_ROW_19_276 vssd1 vccd1 sky130_fd_sc_hd__tapvpwrvgnd_1
XTAP_TAPCELL_ROW_62_577 vssd1 vccd1 sky130_fd_sc_hd__tapvpwrvgnd_1
XFILLER_32_273 vssd1 vssd1 vccd1 vccd1 sky130_fd_sc_hd__fill_2
XANTENNA__2082__A2 net42 vssd1 vssd1 vccd1 vccd1 sky130_fd_sc_hd__diode_2
X_2706_ clknet_leaf_24_clk _0265_ net106 vssd1 vssd1 vccd1 vccd1 CALC_INST.gencon_inst.mult_calc.main.GENERATE_ADDER\[7\].thingy.in2
+ sky130_fd_sc_hd__dfrtp_1
XFILLER_59_115 vssd1 vssd1 vccd1 vccd1 sky130_fd_sc_hd__fill_1
XFILLER_58_29 vssd1 vssd1 vccd1 vccd1 sky130_fd_sc_hd__fill_2
X_2637_ clknet_leaf_16_clk _0196_ net115 vssd1 vssd1 vccd1 vccd1 CALC_INST.gencon_inst.add_calc.main.in2\[5\]
+ sky130_fd_sc_hd__dfrtp_1
X_2568_ clknet_leaf_15_clk _0127_ vssd1 vssd1 vccd1 vccd1 CALC_INST.gencon_inst.ALU_in1\[5\]
+ sky130_fd_sc_hd__dfxtp_1
X_1519_ net31 _0660_ _0664_ net71 vssd1 vssd1 vccd1 vccd1 _0665_ sky130_fd_sc_hd__o211a_1
XANTENNA_fanout118_A net121 vssd1 vssd1 vccd1 vccd1 sky130_fd_sc_hd__diode_2
X_2499_ clknet_leaf_21_clk _0058_ net118 vssd1 vssd1 vccd1 vccd1 CALC_INST.gencon_inst.operand1\[11\]
+ sky130_fd_sc_hd__dfrtp_1
XPHY_EDGE_ROW_12_Right_12 vssd1 vssd1 vccd1 vccd1 sky130_fd_sc_hd__decap_3
XFILLER_55_332 vssd1 vssd1 vccd1 vccd1 sky130_fd_sc_hd__fill_1
XANTENNA__2196__A net154 vssd1 vssd1 vccd1 vccd1 sky130_fd_sc_hd__diode_2
XPHY_EDGE_ROW_21_Right_21 vssd1 vssd1 vccd1 vccd1 sky130_fd_sc_hd__decap_3
XTAP_TAPCELL_ROW_2_155 vssd1 vccd1 sky130_fd_sc_hd__tapvpwrvgnd_1
XTAP_TAPCELL_ROW_53_511 vssd1 vccd1 sky130_fd_sc_hd__tapvpwrvgnd_1
XPHY_EDGE_ROW_4_Left_69 vssd1 vssd1 vccd1 vccd1 sky130_fd_sc_hd__decap_3
XFILLER_15_229 vssd1 vssd1 vccd1 vccd1 sky130_fd_sc_hd__fill_2
XPHY_EDGE_ROW_30_Right_30 vssd1 vssd1 vccd1 vccd1 sky130_fd_sc_hd__decap_3
XFILLER_61_335 vssd1 vssd1 vccd1 vccd1 sky130_fd_sc_hd__fill_1
XFILLER_61_324 vssd1 vssd1 vccd1 vccd1 sky130_fd_sc_hd__fill_1
XFILLER_58_170 vssd1 vssd1 vccd1 vccd1 sky130_fd_sc_hd__fill_1
XFILLER_0_14 vssd1 vssd1 vccd1 vccd1 sky130_fd_sc_hd__fill_2
XFILLER_0_69 vccd1 vssd1 vccd1 vssd1 sky130_ef_sc_hd__decap_40_12
XFILLER_14_251 vssd1 vssd1 vccd1 vccd1 sky130_fd_sc_hd__fill_1
X_1870_ net143 CALC_INST.gencon_inst.mult_calc.finish _0854_ vssd1 vssd1 vccd1 vccd1
+ _0257_ sky130_fd_sc_hd__mux2_1
X_2353_ _1191_ vssd1 vssd1 vccd1 vccd1 _1192_ sky130_fd_sc_hd__inv_2
X_2422_ _1225_ net72 _0400_ _0391_ vssd1 vssd1 vccd1 vccd1 _0402_ sky130_fd_sc_hd__a31oi_2
XFILLER_64_151 vssd1 vssd1 vccd1 vccd1 sky130_fd_sc_hd__fill_1
X_1304_ CALC_INST.gencon_inst.operand1\[0\] CALC_INST.gencon_inst.latched_keypad_input\[0\]
+ net45 _0498_ vssd1 vssd1 vccd1 vccd1 _0499_ sky130_fd_sc_hd__o22a_1
X_1235_ CALC_INST.gencon_inst.operand2\[2\] _0442_ net36 vssd1 vssd1 vccd1 vccd1 _0034_
+ sky130_fd_sc_hd__mux2_1
X_2284_ CALC_INST.gencon_inst.mult_calc.INn2\[13\] CALC_INST.gencon_inst.mult_calc.INn2\[12\]
+ CALC_INST.gencon_inst.mult_calc.INn2\[14\] _1141_ vssd1 vssd1 vccd1 vccd1 _1142_
+ sky130_fd_sc_hd__or4_1
XFILLER_64_184 vssd1 vssd1 vccd1 vccd1 sky130_fd_sc_hd__fill_1
XFILLER_37_387 vssd1 vssd1 vccd1 vccd1 sky130_fd_sc_hd__fill_2
X_1999_ net33 _0944_ _0946_ net126 vssd1 vssd1 vccd1 vccd1 _0948_ sky130_fd_sc_hd__a31o_1
XANTENNA_clkbuf_leaf_30_clk_A clknet_2_2__leaf_clk vssd1 vssd1 vccd1 vccd1 sky130_fd_sc_hd__diode_2
XFILLER_55_195 vssd1 vssd1 vccd1 vccd1 sky130_fd_sc_hd__fill_2
XFILLER_55_151 vssd1 vssd1 vccd1 vccd1 sky130_fd_sc_hd__fill_1
XFILLER_28_365 vssd1 vssd1 vccd1 vccd1 sky130_fd_sc_hd__fill_1
XFILLER_18_32 vssd1 vssd1 vccd1 vccd1 sky130_fd_sc_hd__fill_1
XFILLER_18_43 vssd1 vssd1 vccd1 vccd1 sky130_fd_sc_hd__fill_2
X_1922_ net147 CALC_INST.gencon_inst.add_calc.main.in2\[10\] vssd1 vssd1 vccd1 vccd1
+ _0873_ sky130_fd_sc_hd__nand2_1
XFILLER_61_110 vssd1 vssd1 vccd1 vccd1 sky130_fd_sc_hd__fill_2
XANTENNA__2490__RESET_B net99 vssd1 vssd1 vccd1 vccd1 sky130_fd_sc_hd__diode_2
XFILLER_34_346 vssd1 vssd1 vccd1 vccd1 sky130_fd_sc_hd__fill_1
XANTENNA__1796__B2 net132 vssd1 vssd1 vccd1 vccd1 sky130_fd_sc_hd__diode_2
XANTENNA__1796__A1 net141 vssd1 vssd1 vccd1 vccd1 sky130_fd_sc_hd__diode_2
X_1853_ net472 net404 net140 vssd1 vssd1 vccd1 vccd1 _0241_ sky130_fd_sc_hd__mux2_1
X_1784_ CALC_INST.gencon_inst.mult_calc.main.GENERATE_ADDER\[6\].thingy.in2 CALC_INST.gencon_inst.mult_calc.main.GENERATE_ADDER\[6\].thingy.in1
+ vssd1 vssd1 vccd1 vccd1 _0808_ sky130_fd_sc_hd__nand2_1
X_2336_ net38 _1178_ _1179_ net40 net326 vssd1 vssd1 vccd1 vccd1 _0020_ sky130_fd_sc_hd__a32o_1
X_2405_ _1225_ _1229_ _0384_ vssd1 vssd1 vccd1 vccd1 _0385_ sky130_fd_sc_hd__a21oi_1
X_2198_ net504 vssd1 vssd1 vccd1 vccd1 _1058_ sky130_fd_sc_hd__inv_2
XFILLER_29_129 vssd1 vssd1 vccd1 vccd1 sky130_fd_sc_hd__fill_2
X_2267_ CALC_INST.gencon_inst.mult_calc.compCount.in2\[10\] _1124_ vssd1 vssd1 vccd1
+ vccd1 _1125_ sky130_fd_sc_hd__or2_1
XTAP_TAPCELL_ROW_35_385 vssd1 vccd1 sky130_fd_sc_hd__tapvpwrvgnd_1
XFILLER_33_390 vssd1 vssd1 vccd1 vccd1 sky130_fd_sc_hd__fill_2
XTAP_TAPCELL_ROW_10_208 vssd1 vccd1 sky130_fd_sc_hd__tapvpwrvgnd_1
XANTENNA_fanout98_A net99 vssd1 vssd1 vccd1 vccd1 sky130_fd_sc_hd__diode_2
Xhold97 CALC_INST.input_ctrl_inst.scan_timer\[16\] vssd1 vssd1 vccd1 vccd1 net296
+ sky130_fd_sc_hd__dlygate4sd3_1
Xhold53 CALC_INST.gencon_inst.ALU_in2\[3\] vssd1 vssd1 vccd1 vccd1 net252 sky130_fd_sc_hd__dlygate4sd3_1
Xhold64 CALC_INST.gencon_inst.ALU_in2\[8\] vssd1 vssd1 vccd1 vccd1 net263 sky130_fd_sc_hd__dlygate4sd3_1
Xhold86 CALC_INST.gencon_inst.ALU_in1\[8\] vssd1 vssd1 vccd1 vccd1 net285 sky130_fd_sc_hd__dlygate4sd3_1
Xhold75 CALC_INST.gencon_inst.mult_calc.INn2\[15\] vssd1 vssd1 vccd1 vccd1 net274
+ sky130_fd_sc_hd__dlygate4sd3_1
Xhold31 CALC_INST.gencon_inst.keypad_input\[2\] vssd1 vssd1 vccd1 vccd1 net230 sky130_fd_sc_hd__dlygate4sd3_1
Xhold20 CALC_INST.gencon_inst.mult_calc.INn1\[14\] vssd1 vssd1 vccd1 vccd1 net219
+ sky130_fd_sc_hd__dlygate4sd3_1
Xhold42 _0340_ vssd1 vssd1 vccd1 vccd1 net241 sky130_fd_sc_hd__dlygate4sd3_1
XANTENNA_fanout53_X net53 vssd1 vssd1 vccd1 vccd1 sky130_fd_sc_hd__diode_2
XFILLER_43_165 vssd1 vssd1 vccd1 vccd1 sky130_fd_sc_hd__fill_1
XFILLER_43_143 vssd1 vssd1 vccd1 vccd1 sky130_fd_sc_hd__fill_4
XFILLER_16_313 vssd1 vssd1 vccd1 vccd1 sky130_fd_sc_hd__fill_1
XPHY_EDGE_ROW_7_Left_72 vssd1 vssd1 vccd1 vccd1 sky130_fd_sc_hd__decap_3
XFILLER_6_13 vssd1 vssd1 vccd1 vccd1 sky130_fd_sc_hd__fill_1
X_2052_ net463 _0991_ CALC_INST.gencon_inst.add_calc.state\[1\] vssd1 vssd1 vccd1
+ vccd1 _0302_ sky130_fd_sc_hd__mux2_1
X_2121_ CALC_INST.input_ctrl_inst.decoded_key\[1\] CALC_INST.input_ctrl_inst.decoded_key\[0\]
+ vssd1 vssd1 vccd1 vccd1 _1009_ sky130_fd_sc_hd__or2_1
XFILLER_19_184 vssd1 vssd1 vccd1 vccd1 sky130_fd_sc_hd__fill_4
X_1905_ net452 _0856_ net154 vssd1 vssd1 vccd1 vccd1 _0290_ sky130_fd_sc_hd__mux2_1
XTAP_TAPCELL_ROW_32_366 vssd1 vccd1 sky130_fd_sc_hd__tapvpwrvgnd_1
XFILLER_30_360 vssd1 vssd1 vccd1 vccd1 sky130_fd_sc_hd__fill_2
X_1698_ CALC_INST.gencon_inst.ALU_in1\[0\] CALC_INST.gencon_inst.ALU_in2\[0\] net59
+ vssd1 vssd1 vccd1 vccd1 _0749_ sky130_fd_sc_hd__mux2_1
XANTENNA_fanout100_A CALC_INST.gencon_inst.add_calc.nRST vssd1 vssd1 vccd1 vccd1 sky130_fd_sc_hd__diode_2
XANTENNA__1644__Y _0727_ vssd1 vssd1 vccd1 vccd1 sky130_fd_sc_hd__diode_2
X_1836_ _0846_ _0848_ _0847_ vssd1 vssd1 vccd1 vccd1 _0852_ sky130_fd_sc_hd__o21ba_1
XPHY_EDGE_ROW_6_Right_6 vssd1 vssd1 vccd1 vccd1 sky130_fd_sc_hd__decap_3
X_1767_ net447 net132 _0792_ _0793_ vssd1 vssd1 vccd1 vccd1 _0215_ sky130_fd_sc_hd__a22o_1
X_2319_ CALC_INST.input_ctrl_inst.decoded_key\[3\] _1078_ _1148_ _1166_ vssd1 vssd1
+ vccd1 vccd1 _0030_ sky130_fd_sc_hd__a211o_1
XANTENNA__2759__RESET_B net112 vssd1 vssd1 vccd1 vccd1 sky130_fd_sc_hd__diode_2
XTAP_TAPCELL_ROW_23_300 vssd1 vccd1 sky130_fd_sc_hd__tapvpwrvgnd_1
XFILLER_13_305 vssd1 vssd1 vccd1 vccd1 sky130_fd_sc_hd__fill_1
XFILLER_21_393 vssd1 vssd1 vccd1 vccd1 sky130_fd_sc_hd__fill_1
Xteam_06_166 vssd1 vssd1 vccd1 vccd1 team_06_166/HI gpio_oeb[14] sky130_fd_sc_hd__conb_1
Xoutput8 net8 vssd1 vssd1 vccd1 vccd1 gpio_out[11] sky130_fd_sc_hd__buf_2
Xteam_06_199 vssd1 vssd1 vccd1 vccd1 gpio_oeb[33] team_06_199/LO sky130_fd_sc_hd__conb_1
Xoutput10 net10 vssd1 vssd1 vccd1 vccd1 gpio_out[13] sky130_fd_sc_hd__buf_2
Xteam_06_177 vssd1 vssd1 vccd1 vccd1 team_06_177/HI gpio_oeb[25] sky130_fd_sc_hd__conb_1
XPHY_EDGE_ROW_33_Left_98 vssd1 vssd1 vccd1 vccd1 sky130_fd_sc_hd__decap_3
Xoutput21 net21 vssd1 vssd1 vccd1 vccd1 gpio_out[24] sky130_fd_sc_hd__buf_2
XFILLER_0_253 vccd1 vssd1 vccd1 vssd1 sky130_ef_sc_hd__decap_40_12
Xteam_06_188 vssd1 vssd1 vccd1 vccd1 team_06_188/HI gpio_out[32] sky130_fd_sc_hd__conb_1
XFILLER_63_238 vssd1 vssd1 vccd1 vccd1 sky130_fd_sc_hd__fill_2
XFILLER_48_268 vssd1 vssd1 vccd1 vccd1 sky130_fd_sc_hd__fill_1
XPHY_EDGE_ROW_59_Right_59 vssd1 vssd1 vccd1 vccd1 sky130_fd_sc_hd__decap_3
XFILLER_31_113 vssd1 vssd1 vccd1 vccd1 sky130_fd_sc_hd__fill_2
X_1621_ CALC_INST.gencon_inst.operand2\[0\] net254 net63 vssd1 vssd1 vccd1 vccd1 _0138_
+ sky130_fd_sc_hd__mux2_1
X_1552_ CALC_INST.gencon_inst.ALU_out\[10\] net77 net68 CALC_INST.gencon_inst.mult_calc.out\[10\]
+ vssd1 vssd1 vccd1 vccd1 _0689_ sky130_fd_sc_hd__a22o_1
XFILLER_8_331 vssd1 vssd1 vccd1 vccd1 sky130_fd_sc_hd__fill_1
XFILLER_8_342 vssd1 vssd1 vccd1 vccd1 sky130_fd_sc_hd__fill_8
X_2670_ clknet_leaf_32_clk net370 net104 vssd1 vssd1 vccd1 vccd1 CALC_INST.gencon_inst.mult_calc.compCount.in2\[2\]
+ sky130_fd_sc_hd__dfrtp_1
XANTENNA__1892__S net143 vssd1 vssd1 vccd1 vccd1 sky130_fd_sc_hd__diode_2
XFILLER_39_268 vssd1 vssd1 vccd1 vccd1 sky130_fd_sc_hd__fill_1
XFILLER_39_213 vssd1 vssd1 vccd1 vccd1 sky130_fd_sc_hd__fill_4
X_2104_ net133 net315 net122 net323 vssd1 vssd1 vccd1 vccd1 _0343_ sky130_fd_sc_hd__a22o_1
X_1483_ CALC_INST.input_ctrl_inst.col_index\[27\] CALC_INST.input_ctrl_inst.col_index\[28\]
+ _0630_ vssd1 vssd1 vccd1 vccd1 _0635_ sky130_fd_sc_hd__and3_1
X_2035_ _0968_ _0969_ _0974_ vssd1 vssd1 vccd1 vccd1 _0977_ sky130_fd_sc_hd__or3_1
XANTENNA__2100__A1 net133 vssd1 vssd1 vccd1 vccd1 sky130_fd_sc_hd__diode_2
X_2799_ clknet_leaf_28_clk _0345_ net102 vssd1 vssd1 vccd1 vccd1 CALC_INST.gencon_inst.mult_calc.count.GENERATE_ADDER\[8\].thingy.in1
+ sky130_fd_sc_hd__dfrtp_1
X_1819_ _0836_ _0837_ vssd1 vssd1 vccd1 vccd1 _0838_ sky130_fd_sc_hd__nand2b_1
XTAP_TAPCELL_ROW_43_439 vssd1 vccd1 sky130_fd_sc_hd__tapvpwrvgnd_1
XFILLER_26_87 vssd1 vssd1 vccd1 vccd1 sky130_fd_sc_hd__fill_1
XTAP_TAPCELL_ROW_51_494 vssd1 vccd1 sky130_fd_sc_hd__tapvpwrvgnd_1
XFILLER_5_323 vssd1 vssd1 vccd1 vccd1 sky130_fd_sc_hd__fill_2
XFILLER_5_334 vssd1 vssd1 vccd1 vccd1 sky130_fd_sc_hd__fill_2
XFILLER_5_378 vccd1 vssd1 vccd1 vssd1 sky130_ef_sc_hd__decap_40_12
XTAP_TAPCELL_ROW_8_194 vssd1 vccd1 sky130_fd_sc_hd__tapvpwrvgnd_1
XTAP_TAPCELL_ROW_59_550 vssd1 vccd1 sky130_fd_sc_hd__tapvpwrvgnd_1
XFILLER_44_282 vssd1 vssd1 vccd1 vccd1 sky130_fd_sc_hd__fill_1
XFILLER_36_216 vssd1 vssd1 vccd1 vccd1 sky130_fd_sc_hd__fill_1
XANTENNA__2094__B1 net34 vssd1 vssd1 vccd1 vccd1 sky130_fd_sc_hd__diode_2
XANTENNA__1887__S net143 vssd1 vssd1 vccd1 vccd1 sky130_fd_sc_hd__diode_2
X_2722_ clknet_leaf_24_clk _0281_ net106 vssd1 vssd1 vccd1 vccd1 CALC_INST.gencon_inst.mult_calc.out\[8\]
+ sky130_fd_sc_hd__dfrtp_1
X_2584_ clknet_leaf_15_clk _0143_ vssd1 vssd1 vccd1 vccd1 CALC_INST.gencon_inst.ALU_in2\[5\]
+ sky130_fd_sc_hd__dfxtp_1
X_1604_ CALC_INST.gencon_inst.latched_operator_input\[2\] _1146_ _0715_ CALC_INST.gencon_inst.latched_operator_input\[1\]
+ vssd1 vssd1 vccd1 vccd1 _0724_ sky130_fd_sc_hd__or4bb_4
Xfanout118 net121 vssd1 vssd1 vccd1 vccd1 net118 sky130_fd_sc_hd__clkbuf_4
X_1535_ _0675_ _0676_ vssd1 vssd1 vccd1 vccd1 _0100_ sky130_fd_sc_hd__or2_1
Xfanout129 net132 vssd1 vssd1 vccd1 vccd1 net129 sky130_fd_sc_hd__buf_2
Xfanout107 net108 vssd1 vssd1 vccd1 vccd1 net107 sky130_fd_sc_hd__clkbuf_4
X_2653_ clknet_leaf_32_clk _0212_ net92 vssd1 vssd1 vccd1 vccd1 CALC_INST.gencon_inst.mult_calc.adderSave\[0\]
+ sky130_fd_sc_hd__dfrtp_1
X_1397_ _1082_ _0573_ _0576_ vssd1 vssd1 vccd1 vccd1 _0577_ sky130_fd_sc_hd__nor3_1
XFILLER_27_227 vssd1 vssd1 vccd1 vccd1 sky130_fd_sc_hd__fill_2
X_1466_ CALC_INST.input_ctrl_inst.col_index\[22\] _0585_ _0619_ CALC_INST.input_ctrl_inst.col_index\[23\]
+ vssd1 vssd1 vccd1 vccd1 _0623_ sky130_fd_sc_hd__a31o_1
X_2018_ _0886_ _0887_ vssd1 vssd1 vccd1 vccd1 _0963_ sky130_fd_sc_hd__and2b_1
XANTENNA__2071__A1_N net127 vssd1 vssd1 vccd1 vccd1 sky130_fd_sc_hd__diode_2
XFILLER_12_67 vssd1 vssd1 vccd1 vccd1 sky130_fd_sc_hd__fill_2
Xhold172 CALC_INST.gencon_inst.add_calc.main.GENERATE_ADDER\[11\].thingy.in1 vssd1
+ vssd1 vccd1 vccd1 net371 sky130_fd_sc_hd__dlygate4sd3_1
XANTENNA__1363__A2 net47 vssd1 vssd1 vccd1 vccd1 sky130_fd_sc_hd__diode_2
Xhold194 CALC_INST.input_ctrl_inst.debounce_cnt\[9\] vssd1 vssd1 vccd1 vccd1 net393
+ sky130_fd_sc_hd__dlygate4sd3_1
Xhold161 CALC_INST.gencon_inst.mult_calc.compCount.in2\[10\] vssd1 vssd1 vccd1 vccd1
+ net360 sky130_fd_sc_hd__dlygate4sd3_1
Xhold183 _0269_ vssd1 vssd1 vccd1 vccd1 net382 sky130_fd_sc_hd__dlygate4sd3_1
Xhold150 CALC_INST.input_ctrl_inst.col_index\[14\] vssd1 vssd1 vccd1 vccd1 net349
+ sky130_fd_sc_hd__dlygate4sd3_1
XTAP_TAPCELL_ROW_56_531 vssd1 vccd1 sky130_fd_sc_hd__tapvpwrvgnd_1
XFILLER_37_97 vssd1 vssd1 vccd1 vccd1 sky130_fd_sc_hd__fill_2
XANTENNA__2076__B1 net130 vssd1 vssd1 vccd1 vccd1 sky130_fd_sc_hd__diode_2
XTAP_TAPCELL_ROW_5_175 vssd1 vccd1 sky130_fd_sc_hd__tapvpwrvgnd_1
XFILLER_52_8 vssd1 vssd1 vccd1 vccd1 sky130_fd_sc_hd__fill_1
X_1320_ CALC_INST.gencon_inst.ALU_out\[2\] net75 net69 CALC_INST.gencon_inst.mult_calc.out\[2\]
+ net45 vssd1 vssd1 vccd1 vccd1 _0513_ sky130_fd_sc_hd__a221o_1
XANTENNA__1354__A2 net47 vssd1 vssd1 vccd1 vccd1 sky130_fd_sc_hd__diode_2
XANTENNA__1295__X _0490_ vssd1 vssd1 vccd1 vccd1 sky130_fd_sc_hd__diode_2
X_1251_ _0454_ _0455_ vssd1 vssd1 vccd1 vccd1 _0456_ sky130_fd_sc_hd__nor2_1
XFILLER_64_377 vccd1 vssd1 vccd1 vssd1 sky130_ef_sc_hd__decap_40_12
XFILLER_32_241 vssd1 vssd1 vccd1 vccd1 sky130_fd_sc_hd__fill_1
XPHY_EDGE_ROW_20_Left_85 vssd1 vssd1 vccd1 vccd1 sky130_fd_sc_hd__decap_3
X_2636_ clknet_leaf_12_clk _0195_ net98 vssd1 vssd1 vccd1 vccd1 CALC_INST.gencon_inst.add_calc.main.in2\[4\]
+ sky130_fd_sc_hd__dfrtp_1
X_2705_ clknet_leaf_30_clk net416 net102 vssd1 vssd1 vccd1 vccd1 CALC_INST.gencon_inst.mult_calc.main.GENERATE_ADDER\[6\].thingy.in2
+ sky130_fd_sc_hd__dfrtp_1
XFILLER_58_19 vssd1 vssd1 vccd1 vccd1 sky130_fd_sc_hd__fill_1
X_2567_ clknet_leaf_15_clk _0126_ vssd1 vssd1 vccd1 vccd1 CALC_INST.gencon_inst.ALU_in1\[4\]
+ sky130_fd_sc_hd__dfxtp_1
X_1518_ _0655_ _0663_ vssd1 vssd1 vccd1 vccd1 _0664_ sky130_fd_sc_hd__or2_1
X_2498_ clknet_leaf_22_clk _0057_ net117 vssd1 vssd1 vccd1 vccd1 CALC_INST.gencon_inst.operand1\[10\]
+ sky130_fd_sc_hd__dfrtp_2
XFILLER_4_90 vssd1 vssd1 vccd1 vccd1 sky130_fd_sc_hd__fill_4
X_1449_ net462 net52 _0611_ vssd1 vssd1 vccd1 vccd1 _0079_ sky130_fd_sc_hd__a21bo_1
XTAP_TAPCELL_ROW_53_512 vssd1 vccd1 sky130_fd_sc_hd__tapvpwrvgnd_1
XANTENNA_clkbuf_leaf_4_clk_A clknet_2_0__leaf_clk vssd1 vssd1 vccd1 vccd1 sky130_fd_sc_hd__diode_2
XTAP_TAPCELL_ROW_2_156 vssd1 vccd1 sky130_fd_sc_hd__tapvpwrvgnd_1
XANTENNA__1569__C1 _0659_ vssd1 vssd1 vccd1 vccd1 sky130_fd_sc_hd__diode_2
XFILLER_23_274 vssd1 vssd1 vccd1 vccd1 sky130_fd_sc_hd__fill_4
XFILLER_23_77 vssd1 vssd1 vccd1 vccd1 sky130_fd_sc_hd__fill_4
XFILLER_23_55 vssd1 vssd1 vccd1 vccd1 sky130_fd_sc_hd__fill_1
XFILLER_11_403 vssd1 vssd1 vccd1 vccd1 sky130_fd_sc_hd__fill_4
XFILLER_3_3 vssd1 vssd1 vccd1 vccd1 sky130_fd_sc_hd__fill_2
XFILLER_0_26 vssd1 vssd1 vccd1 vccd1 sky130_fd_sc_hd__fill_2
X_1303_ _0490_ _0497_ vssd1 vssd1 vccd1 vccd1 _0498_ sky130_fd_sc_hd__and2_1
X_2821__190 vssd1 vssd1 vccd1 vccd1 _2821__190/HI net190 sky130_fd_sc_hd__conb_1
X_2352_ CALC_INST.input_ctrl_inst.debounce_cnt\[7\] CALC_INST.input_ctrl_inst.debounce_cnt\[8\]
+ _1186_ vssd1 vssd1 vccd1 vccd1 _1191_ sky130_fd_sc_hd__and3_1
X_2421_ _0395_ _0399_ _0385_ _0389_ vssd1 vssd1 vccd1 vccd1 _0401_ sky130_fd_sc_hd__a211oi_2
X_2283_ CALC_INST.gencon_inst.mult_calc.INn2\[9\] CALC_INST.gencon_inst.mult_calc.INn2\[8\]
+ CALC_INST.gencon_inst.mult_calc.INn2\[11\] CALC_INST.gencon_inst.mult_calc.INn2\[10\]
+ vssd1 vssd1 vccd1 vccd1 _1141_ sky130_fd_sc_hd__or4_1
XFILLER_64_141 vssd1 vssd1 vccd1 vccd1 sky130_fd_sc_hd__fill_8
X_1234_ net54 _0440_ _0441_ net49 CALC_INST.gencon_inst.mult_calc.out\[2\] vssd1 vssd1
+ vccd1 vccd1 _0442_ sky130_fd_sc_hd__a32o_1
XFILLER_52_336 vssd1 vssd1 vccd1 vccd1 sky130_fd_sc_hd__fill_4
XANTENNA_fanout130_A net132 vssd1 vssd1 vccd1 vccd1 sky130_fd_sc_hd__diode_2
X_2619_ clknet_leaf_12_clk _0178_ net97 vssd1 vssd1 vccd1 vccd1 CALC_INST.gencon_inst.add_calc.main.GENERATE_ADDER\[2\].thingy.in1
+ sky130_fd_sc_hd__dfrtp_1
X_1998_ net33 _0944_ _0946_ vssd1 vssd1 vccd1 vccd1 _0947_ sky130_fd_sc_hd__a21oi_1
XANTENNA_fanout43_A net44 vssd1 vssd1 vccd1 vccd1 sky130_fd_sc_hd__diode_2
XFILLER_28_355 vssd1 vssd1 vccd1 vccd1 sky130_fd_sc_hd__fill_8
XFILLER_11_222 vssd1 vssd1 vccd1 vccd1 sky130_fd_sc_hd__fill_2
XFILLER_11_233 vssd1 vssd1 vccd1 vccd1 sky130_fd_sc_hd__fill_1
XTAP_TAPCELL_ROW_13_228 vssd1 vccd1 sky130_fd_sc_hd__tapvpwrvgnd_1
X_1921_ net147 CALC_INST.gencon_inst.add_calc.main.in2\[10\] vssd1 vssd1 vccd1 vccd1
+ _0872_ sky130_fd_sc_hd__or2_1
XFILLER_34_369 vssd1 vssd1 vccd1 vccd1 sky130_fd_sc_hd__fill_1
X_1852_ net450 net398 net140 vssd1 vssd1 vccd1 vccd1 _0240_ sky130_fd_sc_hd__mux2_1
X_1783_ CALC_INST.gencon_inst.mult_calc.main.GENERATE_ADDER\[6\].thingy.in2 CALC_INST.gencon_inst.mult_calc.main.GENERATE_ADDER\[6\].thingy.in1
+ vssd1 vssd1 vccd1 vccd1 _0807_ sky130_fd_sc_hd__nor2_1
XFILLER_57_406 vssd1 vssd1 vccd1 vccd1 sky130_fd_sc_hd__fill_1
XFILLER_29_108 vssd1 vssd1 vccd1 vccd1 sky130_fd_sc_hd__fill_4
X_2335_ CALC_INST.input_ctrl_inst.debounce_cnt\[2\] CALC_INST.input_ctrl_inst.debounce_cnt\[0\]
+ CALC_INST.input_ctrl_inst.debounce_cnt\[1\] CALC_INST.input_ctrl_inst.debounce_cnt\[3\]
+ vssd1 vssd1 vccd1 vccd1 _1179_ sky130_fd_sc_hd__a31o_1
X_2266_ CALC_INST.gencon_inst.mult_calc.count.GENERATE_ADDER\[10\].thingy.in1 _1093_
+ vssd1 vssd1 vccd1 vccd1 _1124_ sky130_fd_sc_hd__xnor2_1
X_2404_ CALC_INST.input_ctrl_inst.col_index\[4\] _1228_ _0382_ _0383_ vssd1 vssd1
+ vccd1 vccd1 _0384_ sky130_fd_sc_hd__and4_1
XFILLER_37_141 vssd1 vssd1 vccd1 vccd1 sky130_fd_sc_hd__fill_1
X_2197_ CALC_INST.input_ctrl_inst.decoded_key\[3\] vssd1 vssd1 vccd1 vccd1 _1057_
+ sky130_fd_sc_hd__inv_2
XFILLER_1_80 vccd1 vssd1 vccd1 vssd1 sky130_ef_sc_hd__decap_40_12
XTAP_TAPCELL_ROW_35_386 vssd1 vccd1 sky130_fd_sc_hd__tapvpwrvgnd_1
XTAP_TAPCELL_ROW_10_209 vssd1 vccd1 sky130_fd_sc_hd__tapvpwrvgnd_1
XANTENNA_fanout133_X net133 vssd1 vssd1 vccd1 vccd1 sky130_fd_sc_hd__diode_2
XPHY_EDGE_ROW_42_Left_107 vssd1 vssd1 vccd1 vccd1 sky130_fd_sc_hd__decap_3
XFILLER_20_67 vssd1 vssd1 vccd1 vccd1 sky130_fd_sc_hd__fill_1
XFILLER_20_89 vssd1 vssd1 vccd1 vccd1 sky130_fd_sc_hd__fill_1
Xhold65 CALC_INST.gencon_inst.ALU_in1\[6\] vssd1 vssd1 vccd1 vccd1 net264 sky130_fd_sc_hd__dlygate4sd3_1
Xhold54 CALC_INST.gencon_inst.ALU_in2\[13\] vssd1 vssd1 vccd1 vccd1 net253 sky130_fd_sc_hd__dlygate4sd3_1
XFILLER_45_20 vssd1 vssd1 vccd1 vccd1 sky130_fd_sc_hd__fill_4
Xhold87 net19 vssd1 vssd1 vccd1 vccd1 net286 sky130_fd_sc_hd__dlygate4sd3_1
Xhold76 _0336_ vssd1 vssd1 vccd1 vccd1 net275 sky130_fd_sc_hd__dlygate4sd3_1
Xhold21 CALC_INST.gencon_inst.mult_calc.INn1\[7\] vssd1 vssd1 vccd1 vccd1 net220 sky130_fd_sc_hd__dlygate4sd3_1
Xhold43 CALC_INST.gencon_inst.mult_calc.main.GENERATE_ADDER\[7\].thingy.in1 vssd1
+ vssd1 vccd1 vccd1 net242 sky130_fd_sc_hd__dlygate4sd3_1
XFILLER_28_163 vssd1 vssd1 vccd1 vccd1 sky130_fd_sc_hd__fill_1
Xhold32 CALC_INST.gencon_inst.mult_calc.main.GENERATE_ADDER\[3\].thingy.in1 vssd1
+ vssd1 vccd1 vccd1 net231 sky130_fd_sc_hd__dlygate4sd3_1
Xhold10 CALC_INST.gencon_inst.mult_calc.INn1\[2\] vssd1 vssd1 vccd1 vccd1 net209 sky130_fd_sc_hd__dlygate4sd3_1
Xhold98 CALC_INST.gencon_inst.mult_calc.compCount.in2\[0\] vssd1 vssd1 vccd1 vccd1
+ net297 sky130_fd_sc_hd__dlygate4sd3_1
XPHY_EDGE_ROW_51_Left_116 vssd1 vssd1 vccd1 vccd1 sky130_fd_sc_hd__decap_3
XFILLER_45_53 vssd1 vssd1 vccd1 vccd1 sky130_fd_sc_hd__fill_1
XFILLER_45_42 vssd1 vssd1 vccd1 vccd1 sky130_fd_sc_hd__fill_2
XFILLER_43_111 vssd1 vssd1 vccd1 vccd1 sky130_fd_sc_hd__fill_1
XTAP_TAPCELL_ROW_26_320 vssd1 vccd1 sky130_fd_sc_hd__tapvpwrvgnd_1
XFILLER_61_74 vccd1 vssd1 vccd1 vssd1 sky130_ef_sc_hd__decap_40_12
XPHY_EDGE_ROW_60_Left_125 vssd1 vssd1 vccd1 vccd1 sky130_fd_sc_hd__decap_3
X_2120_ net232 _1004_ _1008_ _1003_ vssd1 vssd1 vccd1 vccd1 _0353_ sky130_fd_sc_hd__o211a_1
X_2051_ _0988_ _0990_ vssd1 vssd1 vccd1 vccd1 _0991_ sky130_fd_sc_hd__xnor2_1
X_1904_ CALC_INST.gencon_inst.add_calc.main.a0.in1 CALC_INST.gencon_inst.add_calc.main.in2\[0\]
+ vssd1 vssd1 vccd1 vccd1 _0856_ sky130_fd_sc_hd__xor2_1
XTAP_TAPCELL_ROW_32_367 vssd1 vccd1 sky130_fd_sc_hd__tapvpwrvgnd_1
X_1835_ CALC_INST.gencon_inst.mult_calc.main.GENERATE_ADDER\[14\].thingy.in2 CALC_INST.gencon_inst.mult_calc.main.GENERATE_ADDER\[14\].thingy.in1
+ vssd1 vssd1 vccd1 vccd1 _0851_ sky130_fd_sc_hd__xor2_1
X_1697_ net385 _0748_ net152 vssd1 vssd1 vccd1 vccd1 _0190_ sky130_fd_sc_hd__mux2_1
X_1766_ _0790_ _0791_ net127 vssd1 vssd1 vccd1 vccd1 _0793_ sky130_fd_sc_hd__a21oi_1
XFILLER_57_247 vssd1 vssd1 vccd1 vccd1 sky130_fd_sc_hd__fill_4
X_2318_ CALC_INST.input_ctrl_inst.RowSync\[3\] _1161_ _1165_ _1077_ vssd1 vssd1 vccd1
+ vccd1 _1166_ sky130_fd_sc_hd__o211a_1
X_2249_ CALC_INST.gencon_inst.mult_calc.count.GENERATE_ADDER\[4\].thingy.in1 _1089_
+ vssd1 vssd1 vccd1 vccd1 _1107_ sky130_fd_sc_hd__xnor2_1
XFILLER_40_158 vssd1 vssd1 vccd1 vccd1 sky130_fd_sc_hd__fill_2
XFILLER_25_100 vssd1 vssd1 vccd1 vccd1 sky130_fd_sc_hd__fill_1
XTAP_TAPCELL_ROW_23_301 vssd1 vccd1 sky130_fd_sc_hd__tapvpwrvgnd_1
XFILLER_15_23 vssd1 vssd1 vccd1 vccd1 sky130_fd_sc_hd__fill_1
XFILLER_15_34 vssd1 vssd1 vccd1 vccd1 sky130_fd_sc_hd__fill_8
XFILLER_31_11 vssd1 vssd1 vccd1 vccd1 sky130_fd_sc_hd__fill_4
Xteam_06_167 vssd1 vssd1 vccd1 vccd1 team_06_167/HI gpio_oeb[15] sky130_fd_sc_hd__conb_1
Xoutput9 net9 vssd1 vssd1 vccd1 vccd1 gpio_out[12] sky130_fd_sc_hd__buf_2
Xoutput11 net11 vssd1 vssd1 vccd1 vccd1 gpio_out[14] sky130_fd_sc_hd__buf_2
Xteam_06_178 vssd1 vssd1 vccd1 vccd1 team_06_178/HI gpio_oeb[26] sky130_fd_sc_hd__conb_1
Xteam_06_156 vssd1 vssd1 vccd1 vccd1 team_06_156/HI gpio_oeb[4] sky130_fd_sc_hd__conb_1
XANTENNA__1564__A _0655_ vssd1 vssd1 vccd1 vccd1 sky130_fd_sc_hd__diode_2
Xoutput22 net22 vssd1 vssd1 vccd1 vccd1 gpio_out[25] sky130_fd_sc_hd__buf_2
Xteam_06_189 vssd1 vssd1 vccd1 vccd1 team_06_189/HI gpio_out[33] sky130_fd_sc_hd__conb_1
XFILLER_0_221 vssd1 vssd1 vccd1 vccd1 sky130_fd_sc_hd__fill_2
XFILLER_0_265 vccd1 vssd1 vccd1 vssd1 sky130_ef_sc_hd__decap_40_12
XTAP_TAPCELL_ROW_46_459 vssd1 vccd1 sky130_fd_sc_hd__tapvpwrvgnd_1
XFILLER_8_321 vssd1 vssd1 vccd1 vccd1 sky130_fd_sc_hd__fill_2
XFILLER_12_372 vssd1 vssd1 vccd1 vccd1 sky130_fd_sc_hd__fill_1
X_1620_ CALC_INST.gencon_inst.operand1\[15\] net480 net63 vssd1 vssd1 vccd1 vccd1
+ _0137_ sky130_fd_sc_hd__mux2_1
X_1551_ _0687_ _0688_ vssd1 vssd1 vccd1 vccd1 _0104_ sky130_fd_sc_hd__or2_1
X_1482_ CALC_INST.input_ctrl_inst.col_index\[27\] _0630_ CALC_INST.input_ctrl_inst.col_index\[28\]
+ vssd1 vssd1 vccd1 vccd1 _0634_ sky130_fd_sc_hd__a21oi_1
XFILLER_39_203 vssd1 vssd1 vccd1 vccd1 sky130_fd_sc_hd__fill_2
X_2103_ net133 net307 net122 CALC_INST.gencon_inst.mult_calc.count.GENERATE_ADDER\[5\].thingy.in1
+ vssd1 vssd1 vccd1 vccd1 _0342_ sky130_fd_sc_hd__a22o_1
X_2034_ _0976_ _0975_ CALC_INST.gencon_inst.ALU_out\[9\] net126 vssd1 vssd1 vccd1
+ vccd1 _0299_ sky130_fd_sc_hd__a2bb2o_1
X_1818_ CALC_INST.gencon_inst.mult_calc.main.GENERATE_ADDER\[11\].thingy.in2 CALC_INST.gencon_inst.mult_calc.main.GENERATE_ADDER\[11\].thingy.in1
+ vssd1 vssd1 vccd1 vccd1 _0837_ sky130_fd_sc_hd__nand2_1
X_2798_ clknet_leaf_28_clk net290 net102 vssd1 vssd1 vccd1 vccd1 CALC_INST.gencon_inst.mult_calc.count.GENERATE_ADDER\[7\].thingy.in1
+ sky130_fd_sc_hd__dfrtp_1
X_1749_ CALC_INST.gencon_inst.mult_calc.main.GENERATE_ADDER\[1\].thingy.in2 CALC_INST.gencon_inst.mult_calc.main.GENERATE_ADDER\[1\].thingy.in1
+ vssd1 vssd1 vccd1 vccd1 _0778_ sky130_fd_sc_hd__and2_1
XTAP_TAPCELL_ROW_51_495 vssd1 vccd1 sky130_fd_sc_hd__tapvpwrvgnd_1
XFILLER_26_77 vssd1 vssd1 vccd1 vccd1 sky130_fd_sc_hd__fill_1
XFILLER_21_191 vssd1 vssd1 vccd1 vccd1 sky130_fd_sc_hd__fill_1
XFILLER_5_346 vssd1 vssd1 vccd1 vccd1 sky130_fd_sc_hd__fill_2
XTAP_TAPCELL_ROW_59_551 vssd1 vccd1 sky130_fd_sc_hd__tapvpwrvgnd_1
XTAP_TAPCELL_ROW_8_195 vssd1 vccd1 sky130_fd_sc_hd__tapvpwrvgnd_1
XFILLER_44_261 vssd1 vssd1 vccd1 vccd1 sky130_fd_sc_hd__fill_8
XFILLER_36_239 vssd1 vssd1 vccd1 vccd1 sky130_fd_sc_hd__fill_1
X_2652_ clknet_leaf_10_clk _0211_ net97 vssd1 vssd1 vccd1 vccd1 CALC_INST.gencon_inst.add_calc.diffSign
+ sky130_fd_sc_hd__dfrtp_1
X_2721_ clknet_leaf_23_clk _0280_ net106 vssd1 vssd1 vccd1 vccd1 CALC_INST.gencon_inst.mult_calc.out\[7\]
+ sky130_fd_sc_hd__dfrtp_1
XFILLER_8_195 vssd1 vssd1 vccd1 vccd1 sky130_fd_sc_hd__fill_1
Xfanout119 net121 vssd1 vssd1 vccd1 vccd1 net119 sky130_fd_sc_hd__clkbuf_4
X_2583_ clknet_leaf_15_clk _0142_ vssd1 vssd1 vccd1 vccd1 CALC_INST.gencon_inst.ALU_in2\[4\]
+ sky130_fd_sc_hd__dfxtp_1
X_1534_ net10 _0659_ _0674_ _0656_ vssd1 vssd1 vccd1 vccd1 _0676_ sky130_fd_sc_hd__a22o_1
X_1603_ CALC_INST.gencon_inst.read_input net217 _0722_ vssd1 vssd1 vccd1 vccd1 _0121_
+ sky130_fd_sc_hd__mux2_1
X_1465_ CALC_INST.input_ctrl_inst.col_index\[22\] net52 _0622_ vssd1 vssd1 vccd1 vccd1
+ _0084_ sky130_fd_sc_hd__a21o_1
Xfanout108 net112 vssd1 vssd1 vccd1 vccd1 net108 sky130_fd_sc_hd__clkbuf_4
X_2017_ net492 _0962_ net154 vssd1 vssd1 vccd1 vccd1 _0296_ sky130_fd_sc_hd__mux2_1
X_1396_ _0574_ _0575_ vssd1 vssd1 vccd1 vccd1 _0576_ sky130_fd_sc_hd__or2_1
XFILLER_35_250 vssd1 vssd1 vccd1 vccd1 sky130_fd_sc_hd__fill_1
XFILLER_10_139 vssd1 vssd1 vccd1 vccd1 sky130_fd_sc_hd__fill_1
Xhold151 CALC_INST.gencon_inst.add_calc.main.in2\[9\] vssd1 vssd1 vccd1 vccd1 net350
+ sky130_fd_sc_hd__dlygate4sd3_1
Xhold140 CALC_INST.gencon_inst.mult_calc.adderSave\[12\] vssd1 vssd1 vccd1 vccd1 net339
+ sky130_fd_sc_hd__dlygate4sd3_1
Xhold162 CALC_INST.gencon_inst.mult_calc.compCount.in2\[12\] vssd1 vssd1 vccd1 vccd1
+ net361 sky130_fd_sc_hd__dlygate4sd3_1
Xhold173 CALC_INST.gencon_inst.add_calc.main.GENERATE_ADDER\[5\].thingy.in1 vssd1
+ vssd1 vccd1 vccd1 net372 sky130_fd_sc_hd__dlygate4sd3_1
Xhold195 CALC_INST.gencon_inst.add_calc.main.in2\[6\] vssd1 vssd1 vccd1 vccd1 net394
+ sky130_fd_sc_hd__dlygate4sd3_1
XANTENNA_fanout73_A net74 vssd1 vssd1 vccd1 vccd1 sky130_fd_sc_hd__diode_2
XTAP_TAPCELL_ROW_5_176 vssd1 vccd1 sky130_fd_sc_hd__tapvpwrvgnd_1
Xhold184 CALC_INST.gencon_inst.mult_calc.main.GENERATE_ADDER\[3\].thingy.in2 vssd1
+ vssd1 vccd1 vccd1 net383 sky130_fd_sc_hd__dlygate4sd3_1
XTAP_TAPCELL_ROW_56_532 vssd1 vccd1 sky130_fd_sc_hd__tapvpwrvgnd_1
XFILLER_53_20 vssd1 vssd1 vccd1 vccd1 sky130_fd_sc_hd__fill_8
XANTENNA__1520__B1 net67 vssd1 vssd1 vccd1 vccd1 sky130_fd_sc_hd__diode_2
XFILLER_37_54 vssd1 vssd1 vccd1 vccd1 sky130_fd_sc_hd__fill_2
XFILLER_26_250 vssd1 vssd1 vccd1 vccd1 sky130_fd_sc_hd__fill_2
XFILLER_18_228 vssd1 vssd1 vccd1 vccd1 sky130_fd_sc_hd__fill_4
XANTENNA__2000__B2 net126 vssd1 vssd1 vccd1 vccd1 sky130_fd_sc_hd__diode_2
XFILLER_64_345 vssd1 vssd1 vccd1 vccd1 sky130_fd_sc_hd__fill_8
XFILLER_64_334 vssd1 vssd1 vccd1 vccd1 sky130_fd_sc_hd__fill_2
XFILLER_49_331 vssd1 vssd1 vccd1 vccd1 sky130_fd_sc_hd__fill_4
X_1250_ _0443_ _0447_ CALC_INST.gencon_inst.operand2\[5\] CALC_INST.gencon_inst.operand2\[4\]
+ vssd1 vssd1 vccd1 vccd1 _0455_ sky130_fd_sc_hd__o211a_1
XFILLER_1_393 vssd1 vssd1 vccd1 vccd1 sky130_fd_sc_hd__fill_8
XFILLER_64_389 vssd1 vssd1 vccd1 vccd1 sky130_fd_sc_hd__fill_2
XANTENNA__2067__A1 net141 vssd1 vssd1 vccd1 vccd1 sky130_fd_sc_hd__diode_2
X_2635_ clknet_leaf_12_clk _0194_ net98 vssd1 vssd1 vccd1 vccd1 CALC_INST.gencon_inst.add_calc.main.in2\[3\]
+ sky130_fd_sc_hd__dfrtp_1
XANTENNA__1578__B1 _0491_ vssd1 vssd1 vccd1 vccd1 sky130_fd_sc_hd__diode_2
X_2704_ clknet_leaf_30_clk _0263_ net104 vssd1 vssd1 vccd1 vccd1 CALC_INST.gencon_inst.mult_calc.main.GENERATE_ADDER\[5\].thingy.in2
+ sky130_fd_sc_hd__dfrtp_1
XFILLER_59_128 vssd1 vssd1 vccd1 vccd1 sky130_fd_sc_hd__fill_4
X_2566_ clknet_leaf_13_clk _0125_ vssd1 vssd1 vccd1 vccd1 CALC_INST.gencon_inst.ALU_in1\[3\]
+ sky130_fd_sc_hd__dfxtp_1
X_2497_ clknet_leaf_22_clk _0056_ net118 vssd1 vssd1 vccd1 vccd1 CALC_INST.gencon_inst.operand1\[9\]
+ sky130_fd_sc_hd__dfrtp_1
X_1517_ CALC_INST.gencon_inst.operand2\[1\] CALC_INST.gencon_inst.operand1\[1\] net74
+ vssd1 vssd1 vccd1 vccd1 _0663_ sky130_fd_sc_hd__mux2_1
X_1448_ _0584_ _0609_ _0610_ vssd1 vssd1 vccd1 vccd1 _0611_ sky130_fd_sc_hd__or3_1
XTAP_TAPCELL_ROW_53_513 vssd1 vccd1 sky130_fd_sc_hd__tapvpwrvgnd_1
X_1379_ CALC_INST.gencon_inst.operand1\[13\] CALC_INST.gencon_inst.operand1\[14\]
+ _0552_ vssd1 vssd1 vccd1 vccd1 _0560_ sky130_fd_sc_hd__and3_1
XTAP_TAPCELL_ROW_2_157 vssd1 vccd1 sky130_fd_sc_hd__tapvpwrvgnd_1
XFILLER_23_23 vccd1 vssd1 vccd1 vssd1 sky130_ef_sc_hd__decap_40_12
XFILLER_48_75 vssd1 vssd1 vccd1 vccd1 sky130_fd_sc_hd__fill_1
XFILLER_0_16 vssd1 vssd1 vccd1 vccd1 sky130_fd_sc_hd__fill_1
XFILLER_64_85 vccd1 vssd1 vccd1 vssd1 sky130_ef_sc_hd__decap_40_12
XFILLER_61_337 vccd1 vssd1 vccd1 vssd1 sky130_ef_sc_hd__decap_40_12
XFILLER_9_47 vssd1 vssd1 vccd1 vccd1 sky130_fd_sc_hd__fill_8
XFILLER_14_220 vssd1 vssd1 vccd1 vccd1 sky130_fd_sc_hd__fill_4
X_2420_ _1062_ net79 _0398_ vssd1 vssd1 vccd1 vccd1 _0400_ sky130_fd_sc_hd__and3_1
Xfanout90 net93 vssd1 vssd1 vccd1 vccd1 net90 sky130_fd_sc_hd__clkbuf_2
X_1302_ CALC_INST.gencon_inst.operand1\[0\] CALC_INST.gencon_inst.latched_keypad_input\[0\]
+ vssd1 vssd1 vccd1 vccd1 _0497_ sky130_fd_sc_hd__nand2_1
X_1233_ _0436_ _0438_ _0430_ _0432_ vssd1 vssd1 vccd1 vccd1 _0441_ sky130_fd_sc_hd__a211o_1
X_2351_ CALC_INST.input_ctrl_inst.debounce_cnt\[7\] _1186_ CALC_INST.input_ctrl_inst.debounce_cnt\[8\]
+ vssd1 vssd1 vccd1 vccd1 _1190_ sky130_fd_sc_hd__a21o_1
XANTENNA__2070__A1_N net127 vssd1 vssd1 vccd1 vccd1 sky130_fd_sc_hd__diode_2
X_2282_ CALC_INST.gencon_inst.mult_calc.INn2\[1\] CALC_INST.gencon_inst.mult_calc.INn2\[0\]
+ CALC_INST.gencon_inst.mult_calc.INn2\[3\] CALC_INST.gencon_inst.mult_calc.INn2\[2\]
+ vssd1 vssd1 vccd1 vccd1 _1140_ sky130_fd_sc_hd__or4_1
XFILLER_64_175 vssd1 vssd1 vccd1 vccd1 sky130_fd_sc_hd__fill_2
XFILLER_52_359 vssd1 vssd1 vccd1 vccd1 sky130_fd_sc_hd__fill_4
XFILLER_37_389 vssd1 vssd1 vccd1 vccd1 sky130_fd_sc_hd__fill_1
X_1997_ _0913_ _0945_ vssd1 vssd1 vccd1 vccd1 _0946_ sky130_fd_sc_hd__xor2_1
XANTENNA_fanout123_A net125 vssd1 vssd1 vccd1 vccd1 sky130_fd_sc_hd__diode_2
X_2618_ clknet_leaf_11_clk _0177_ net97 vssd1 vssd1 vccd1 vccd1 CALC_INST.gencon_inst.add_calc.main.GENERATE_ADDER\[1\].thingy.in1
+ sky130_fd_sc_hd__dfrtp_1
X_2549_ clknet_leaf_20_clk _0108_ net118 vssd1 vssd1 vccd1 vccd1 net18 sky130_fd_sc_hd__dfrtp_1
XANTENNA__2451__A1 net71 vssd1 vssd1 vccd1 vccd1 sky130_fd_sc_hd__diode_2
XFILLER_34_77 vssd1 vssd1 vccd1 vccd1 sky130_fd_sc_hd__fill_4
XTAP_TAPCELL_ROW_13_229 vssd1 vccd1 sky130_fd_sc_hd__tapvpwrvgnd_1
XFILLER_50_98 vssd1 vssd1 vccd1 vccd1 sky130_fd_sc_hd__fill_1
XTAP_TAPCELL_ROW_21_284 vssd1 vccd1 sky130_fd_sc_hd__tapvpwrvgnd_1
XFILLER_11_278 vssd1 vssd1 vccd1 vccd1 sky130_fd_sc_hd__fill_2
XFILLER_34_304 vssd1 vssd1 vccd1 vccd1 sky130_fd_sc_hd__fill_4
XTAP_TAPCELL_ROW_29_340 vssd1 vccd1 sky130_fd_sc_hd__tapvpwrvgnd_1
XFILLER_19_345 vssd1 vssd1 vccd1 vccd1 sky130_fd_sc_hd__fill_2
XFILLER_61_189 vssd1 vssd1 vccd1 vccd1 sky130_fd_sc_hd__fill_4
X_1920_ CALC_INST.gencon_inst.add_calc.main.GENERATE_ADDER\[11\].thingy.in1 _0868_
+ _0869_ vssd1 vssd1 vccd1 vccd1 _0871_ sky130_fd_sc_hd__nand3_1
X_1851_ net361 CALC_INST.gencon_inst.mult_calc.INn2\[12\] net140 vssd1 vssd1 vccd1
+ vccd1 _0239_ sky130_fd_sc_hd__mux2_1
XANTENNA__2442__A1 net143 vssd1 vssd1 vccd1 vccd1 sky130_fd_sc_hd__diode_2
XANTENNA_clkbuf_leaf_3_clk_A clknet_2_0__leaf_clk vssd1 vssd1 vccd1 vccd1 sky130_fd_sc_hd__diode_2
X_2403_ CALC_INST.input_ctrl_inst.col_index\[9\] CALC_INST.input_ctrl_inst.col_index\[8\]
+ CALC_INST.input_ctrl_inst.col_index\[13\] CALC_INST.input_ctrl_inst.col_index\[14\]
+ vssd1 vssd1 vccd1 vccd1 _0383_ sky130_fd_sc_hd__and4_1
X_1782_ net141 _0805_ _0806_ net337 net132 vssd1 vssd1 vccd1 vccd1 _0217_ sky130_fd_sc_hd__a32o_1
X_2196_ net154 vssd1 vssd1 vccd1 vccd1 _1056_ sky130_fd_sc_hd__inv_2
X_2334_ _1177_ vssd1 vssd1 vccd1 vccd1 _1178_ sky130_fd_sc_hd__inv_2
X_2265_ CALC_INST.gencon_inst.mult_calc.compCount.in2\[8\] _1118_ _1122_ CALC_INST.gencon_inst.mult_calc.compCount.in2\[9\]
+ vssd1 vssd1 vccd1 vccd1 _1123_ sky130_fd_sc_hd__a22o_1
XFILLER_52_123 vssd1 vssd1 vccd1 vccd1 sky130_fd_sc_hd__fill_1
XFILLER_37_197 vssd1 vssd1 vccd1 vccd1 sky130_fd_sc_hd__fill_2
XTAP_TAPCELL_ROW_35_387 vssd1 vccd1 sky130_fd_sc_hd__tapvpwrvgnd_1
XFILLER_25_337 vssd1 vssd1 vccd1 vccd1 sky130_fd_sc_hd__fill_2
XANTENNA_fanout126_X net126 vssd1 vssd1 vccd1 vccd1 sky130_fd_sc_hd__diode_2
XFILLER_4_219 vssd1 vssd1 vccd1 vccd1 sky130_fd_sc_hd__fill_2
Xhold11 CALC_INST.gencon_inst.mult_calc.INn1\[1\] vssd1 vssd1 vccd1 vccd1 net210 sky130_fd_sc_hd__dlygate4sd3_1
Xhold22 CALC_INST.gencon_inst.mult_calc.INn1\[6\] vssd1 vssd1 vccd1 vccd1 net221 sky130_fd_sc_hd__dlygate4sd3_1
XFILLER_20_35 vssd1 vssd1 vccd1 vccd1 sky130_fd_sc_hd__fill_4
Xhold55 CALC_INST.gencon_inst.ALU_in2\[0\] vssd1 vssd1 vccd1 vccd1 net254 sky130_fd_sc_hd__dlygate4sd3_1
Xhold66 CALC_INST.gencon_inst.addOrSub vssd1 vssd1 vccd1 vccd1 net265 sky130_fd_sc_hd__dlygate4sd3_1
Xhold77 CALC_INST.gencon_inst.ALU_in2\[9\] vssd1 vssd1 vccd1 vccd1 net276 sky130_fd_sc_hd__dlygate4sd3_1
Xhold88 CALC_INST.gencon_inst.ALU_in2\[6\] vssd1 vssd1 vccd1 vccd1 net287 sky130_fd_sc_hd__dlygate4sd3_1
XFILLER_43_101 vssd1 vssd1 vccd1 vccd1 sky130_fd_sc_hd__fill_1
Xhold33 CALC_INST.gencon_inst.keypad_input\[0\] vssd1 vssd1 vccd1 vccd1 net232 sky130_fd_sc_hd__dlygate4sd3_1
XTAP_TAPCELL_ROW_26_321 vssd1 vccd1 sky130_fd_sc_hd__tapvpwrvgnd_1
Xhold44 CALC_INST.gencon_inst.mult_calc.INn1\[9\] vssd1 vssd1 vccd1 vccd1 net243 sky130_fd_sc_hd__dlygate4sd3_1
Xhold99 _0227_ vssd1 vssd1 vccd1 vccd1 net298 sky130_fd_sc_hd__dlygate4sd3_1
XFILLER_61_86 vccd1 vssd1 vccd1 vssd1 sky130_ef_sc_hd__decap_40_12
XFILLER_43_178 vssd1 vssd1 vccd1 vccd1 sky130_fd_sc_hd__fill_2
XFILLER_31_318 vssd1 vssd1 vccd1 vccd1 sky130_fd_sc_hd__fill_1
XFILLER_6_37 vssd1 vssd1 vccd1 vccd1 sky130_fd_sc_hd__fill_2
X_2050_ net32 _0989_ vssd1 vssd1 vccd1 vccd1 _0990_ sky130_fd_sc_hd__nand2_1
XFILLER_20_7 vssd1 vssd1 vccd1 vccd1 sky130_fd_sc_hd__fill_2
X_1903_ net272 _0855_ net137 vssd1 vssd1 vccd1 vccd1 _0289_ sky130_fd_sc_hd__mux2_1
X_1834_ net142 _0849_ _0850_ net332 net131 vssd1 vssd1 vccd1 vccd1 _0225_ sky130_fd_sc_hd__a32o_1
X_1765_ _0790_ _0791_ vssd1 vssd1 vccd1 vccd1 _0792_ sky130_fd_sc_hd__or2_1
X_1696_ CALC_INST.gencon_inst.ALU_in2\[14\] CALC_INST.gencon_inst.ALU_in1\[14\] net60
+ vssd1 vssd1 vccd1 vccd1 _0748_ sky130_fd_sc_hd__mux2_1
X_2179_ net444 _1041_ _1044_ _1022_ vssd1 vssd1 vccd1 vccd1 _0376_ sky130_fd_sc_hd__o211a_1
X_2317_ CALC_INST.input_ctrl_inst.RowSync\[2\] _1162_ _1163_ _1164_ vssd1 vssd1 vccd1
+ vccd1 _1165_ sky130_fd_sc_hd__a31o_1
XANTENNA__2103__B1 net122 vssd1 vssd1 vccd1 vccd1 sky130_fd_sc_hd__diode_2
X_2248_ _1102_ _1103_ _1105_ CALC_INST.gencon_inst.mult_calc.compCount.in2\[3\] vssd1
+ vssd1 vccd1 vccd1 _1106_ sky130_fd_sc_hd__a22o_1
XFILLER_25_156 vssd1 vssd1 vccd1 vccd1 sky130_fd_sc_hd__fill_1
XTAP_TAPCELL_ROW_23_302 vssd1 vccd1 sky130_fd_sc_hd__tapvpwrvgnd_1
XFILLER_15_57 vssd1 vssd1 vccd1 vccd1 sky130_fd_sc_hd__fill_2
Xoutput12 net12 vssd1 vssd1 vccd1 vccd1 gpio_out[15] sky130_fd_sc_hd__buf_2
Xoutput23 net23 vssd1 vssd1 vccd1 vccd1 gpio_out[26] sky130_fd_sc_hd__buf_2
Xteam_06_157 vssd1 vssd1 vccd1 vccd1 team_06_157/HI gpio_oeb[5] sky130_fd_sc_hd__conb_1
Xteam_06_179 vssd1 vssd1 vccd1 vccd1 team_06_179/HI gpio_oeb[27] sky130_fd_sc_hd__conb_1
XFILLER_48_248 vssd1 vssd1 vccd1 vccd1 sky130_fd_sc_hd__fill_2
XFILLER_0_277 vssd1 vssd1 vccd1 vccd1 sky130_fd_sc_hd__fill_2
Xteam_06_168 vssd1 vssd1 vccd1 vccd1 team_06_168/HI gpio_oeb[16] sky130_fd_sc_hd__conb_1
XFILLER_31_115 vssd1 vssd1 vccd1 vccd1 sky130_fd_sc_hd__fill_1
XANTENNA_clkbuf_2_0__f_clk_X clknet_2_0__leaf_clk vssd1 vssd1 vccd1 vccd1 sky130_fd_sc_hd__diode_2
XFILLER_8_355 vssd1 vssd1 vccd1 vccd1 sky130_fd_sc_hd__fill_4
XFILLER_12_351 vccd1 vssd1 vccd1 vssd1 sky130_ef_sc_hd__decap_40_12
X_1550_ net14 _0659_ _0686_ _0656_ vssd1 vssd1 vccd1 vccd1 _0688_ sky130_fd_sc_hd__a22o_1
X_1481_ CALC_INST.input_ctrl_inst.col_index\[27\] net52 _0633_ vssd1 vssd1 vccd1 vccd1
+ _0089_ sky130_fd_sc_hd__a21o_1
X_2033_ net32 _0972_ _0974_ net126 vssd1 vssd1 vccd1 vccd1 _0976_ sky130_fd_sc_hd__a31o_1
XFILLER_47_281 vssd1 vssd1 vccd1 vccd1 sky130_fd_sc_hd__fill_2
X_2102_ net133 net284 net122 CALC_INST.gencon_inst.mult_calc.count.GENERATE_ADDER\[4\].thingy.in1
+ vssd1 vssd1 vccd1 vccd1 _0341_ sky130_fd_sc_hd__a22o_1
XFILLER_11_3 vssd1 vssd1 vccd1 vccd1 sky130_fd_sc_hd__fill_8
X_2866_ clknet_leaf_3_clk _0381_ vssd1 vssd1 vccd1 vccd1 CALC_INST.gencon_inst.mult_calc.start
+ sky130_fd_sc_hd__dfxtp_1
X_1817_ CALC_INST.gencon_inst.mult_calc.main.GENERATE_ADDER\[11\].thingy.in2 CALC_INST.gencon_inst.mult_calc.main.GENERATE_ADDER\[11\].thingy.in1
+ vssd1 vssd1 vccd1 vccd1 _0836_ sky130_fd_sc_hd__nor2_1
X_2797_ clknet_leaf_28_clk _0343_ net102 vssd1 vssd1 vccd1 vccd1 CALC_INST.gencon_inst.mult_calc.count.GENERATE_ADDER\[6\].thingy.in1
+ sky130_fd_sc_hd__dfrtp_1
Xhold300 CALC_INST.input_ctrl_inst.col_index\[28\] vssd1 vssd1 vccd1 vccd1 net499
+ sky130_fd_sc_hd__dlygate4sd3_1
X_1748_ net141 _0776_ _0777_ net344 net129 vssd1 vssd1 vccd1 vccd1 _0212_ sky130_fd_sc_hd__a32o_1
X_1679_ net372 _0739_ net151 vssd1 vssd1 vccd1 vccd1 _0181_ sky130_fd_sc_hd__mux2_1
XTAP_TAPCELL_ROW_51_496 vssd1 vccd1 sky130_fd_sc_hd__tapvpwrvgnd_1
XFILLER_13_126 vssd1 vssd1 vccd1 vccd1 sky130_fd_sc_hd__fill_2
XTAP_TAPCELL_ROW_59_552 vssd1 vccd1 sky130_fd_sc_hd__tapvpwrvgnd_1
XTAP_TAPCELL_ROW_8_196 vssd1 vccd1 sky130_fd_sc_hd__tapvpwrvgnd_1
XFILLER_44_251 vssd1 vssd1 vccd1 vccd1 sky130_fd_sc_hd__fill_1
XANTENNA__2094__A2 net42 vssd1 vssd1 vccd1 vccd1 sky130_fd_sc_hd__diode_2
X_2582_ clknet_leaf_13_clk _0141_ vssd1 vssd1 vccd1 vccd1 CALC_INST.gencon_inst.ALU_in2\[3\]
+ sky130_fd_sc_hd__dfxtp_1
X_2651_ clknet_leaf_10_clk net397 net96 vssd1 vssd1 vccd1 vccd1 CALC_INST.gencon_inst.add_calc.sameSignVal
+ sky130_fd_sc_hd__dfrtp_1
X_1602_ CALC_INST.gencon_inst.read_input _0722_ vssd1 vssd1 vccd1 vccd1 _0723_ sky130_fd_sc_hd__nor2_1
X_2720_ clknet_leaf_29_clk _0279_ net101 vssd1 vssd1 vccd1 vccd1 CALC_INST.gencon_inst.mult_calc.out\[6\]
+ sky130_fd_sc_hd__dfrtp_1
X_1395_ CALC_INST.input_ctrl_inst.scan_timer\[1\] CALC_INST.input_ctrl_inst.scan_timer\[0\]
+ CALC_INST.input_ctrl_inst.scan_timer\[15\] CALC_INST.input_ctrl_inst.scan_timer\[14\]
+ vssd1 vssd1 vccd1 vccd1 _0575_ sky130_fd_sc_hd__or4bb_1
X_1533_ CALC_INST.gencon_inst.ALU_out\[5\] net76 net67 CALC_INST.gencon_inst.mult_calc.out\[5\]
+ vssd1 vssd1 vccd1 vccd1 _0675_ sky130_fd_sc_hd__a22o_1
Xfanout109 net111 vssd1 vssd1 vccd1 vccd1 net109 sky130_fd_sc_hd__clkbuf_4
X_1464_ CALC_INST.input_ctrl_inst.col_index\[22\] _0619_ _0621_ vssd1 vssd1 vccd1
+ vccd1 _0622_ sky130_fd_sc_hd__o21a_1
X_2016_ _0959_ _0961_ vssd1 vssd1 vccd1 vccd1 _0962_ sky130_fd_sc_hd__xnor2_1
XFILLER_35_240 vssd1 vssd1 vccd1 vccd1 sky130_fd_sc_hd__fill_1
XANTENNA_fanout153_A CALC_INST.gencon_inst.add_calc.state\[2\] vssd1 vssd1 vccd1 vccd1
+ sky130_fd_sc_hd__diode_2
XFILLER_50_298 vssd1 vssd1 vccd1 vccd1 sky130_fd_sc_hd__fill_8
XFILLER_50_221 vssd1 vssd1 vccd1 vccd1 sky130_fd_sc_hd__fill_2
XFILLER_12_25 vssd1 vssd1 vccd1 vccd1 sky130_fd_sc_hd__fill_2
Xclkbuf_leaf_30_clk clknet_2_2__leaf_clk vssd1 vssd1 vccd1 vccd1 clknet_leaf_30_clk
+ sky130_fd_sc_hd__clkbuf_8
Xhold174 CALC_INST.gencon_inst.add_calc.main.GENERATE_ADDER\[10\].thingy.in1 vssd1
+ vssd1 vccd1 vccd1 net373 sky130_fd_sc_hd__dlygate4sd3_1
Xhold141 CALC_INST.gencon_inst.add_calc.main.in2\[13\] vssd1 vssd1 vccd1 vccd1 net340
+ sky130_fd_sc_hd__dlygate4sd3_1
Xhold130 CALC_INST.gencon_inst.ALU_in2\[10\] vssd1 vssd1 vccd1 vccd1 net329 sky130_fd_sc_hd__dlygate4sd3_1
X_2849_ clknet_leaf_7_clk _0364_ vssd1 vssd1 vccd1 vccd1 CALC_INST.input_ctrl_inst.scan_timer\[3\]
+ sky130_fd_sc_hd__dfxtp_1
Xhold152 CALC_INST.gencon_inst.mult_calc.INn2\[10\] vssd1 vssd1 vccd1 vccd1 net351
+ sky130_fd_sc_hd__dlygate4sd3_1
XFILLER_12_69 vssd1 vssd1 vccd1 vccd1 sky130_fd_sc_hd__fill_1
Xhold163 _0239_ vssd1 vssd1 vccd1 vccd1 net362 sky130_fd_sc_hd__dlygate4sd3_1
Xhold185 _0261_ vssd1 vssd1 vccd1 vccd1 net384 sky130_fd_sc_hd__dlygate4sd3_1
XANTENNA_fanout66_A _0724_ vssd1 vssd1 vccd1 vccd1 sky130_fd_sc_hd__diode_2
XFILLER_37_22 vssd1 vssd1 vccd1 vccd1 sky130_fd_sc_hd__fill_1
XFILLER_37_11 vssd1 vssd1 vccd1 vccd1 sky130_fd_sc_hd__fill_1
Xhold196 CALC_INST.gencon_inst.mult_calc.INn2\[2\] vssd1 vssd1 vccd1 vccd1 net395
+ sky130_fd_sc_hd__dlygate4sd3_1
XTAP_TAPCELL_ROW_5_177 vssd1 vccd1 sky130_fd_sc_hd__tapvpwrvgnd_1
XTAP_TAPCELL_ROW_56_533 vssd1 vccd1 sky130_fd_sc_hd__tapvpwrvgnd_1
XFILLER_37_99 vssd1 vssd1 vccd1 vccd1 sky130_fd_sc_hd__fill_1
Xclkbuf_leaf_21_clk clknet_2_3__leaf_clk vssd1 vssd1 vccd1 vccd1 clknet_leaf_21_clk
+ sky130_fd_sc_hd__clkbuf_8
XFILLER_1_361 vccd1 vssd1 vccd1 vssd1 sky130_ef_sc_hd__decap_40_12
Xclkbuf_leaf_12_clk clknet_2_1__leaf_clk vssd1 vssd1 vccd1 vccd1 clknet_leaf_12_clk
+ sky130_fd_sc_hd__clkbuf_8
XANTENNA__1275__B1 CALC_INST.gencon_inst.operand2\[11\] vssd1 vssd1 vccd1 vccd1 sky130_fd_sc_hd__diode_2
X_2634_ clknet_leaf_11_clk _0193_ net97 vssd1 vssd1 vccd1 vccd1 CALC_INST.gencon_inst.add_calc.main.in2\[2\]
+ sky130_fd_sc_hd__dfrtp_1
X_2565_ clknet_leaf_12_clk _0124_ vssd1 vssd1 vccd1 vccd1 CALC_INST.gencon_inst.ALU_in1\[2\]
+ sky130_fd_sc_hd__dfxtp_1
X_1516_ net452 net75 net67 CALC_INST.gencon_inst.mult_calc.out\[0\] _0661_ vssd1 vssd1
+ vccd1 vccd1 _0095_ sky130_fd_sc_hd__a221o_1
X_2703_ clknet_leaf_24_clk net425 net105 vssd1 vssd1 vccd1 vccd1 CALC_INST.gencon_inst.mult_calc.main.GENERATE_ADDER\[4\].thingy.in2
+ sky130_fd_sc_hd__dfrtp_1
XFILLER_59_118 vssd1 vssd1 vccd1 vccd1 sky130_fd_sc_hd__fill_1
X_1378_ CALC_INST.gencon_inst.operand1\[12\] CALC_INST.gencon_inst.operand1\[13\]
+ _0548_ CALC_INST.gencon_inst.operand1\[14\] vssd1 vssd1 vccd1 vccd1 _0559_ sky130_fd_sc_hd__a31o_1
XANTENNA__1502__A1 net71 vssd1 vssd1 vccd1 vccd1 sky130_fd_sc_hd__diode_2
X_2496_ clknet_leaf_22_clk _0055_ net114 vssd1 vssd1 vccd1 vccd1 CALC_INST.gencon_inst.operand1\[8\]
+ sky130_fd_sc_hd__dfrtp_1
X_1447_ CALC_INST.input_ctrl_inst.col_index\[17\] _0608_ vssd1 vssd1 vccd1 vccd1 _0610_
+ sky130_fd_sc_hd__and2_1
XTAP_TAPCELL_ROW_53_514 vssd1 vccd1 sky130_fd_sc_hd__tapvpwrvgnd_1
XFILLER_23_210 vccd1 vssd1 vccd1 vssd1 sky130_ef_sc_hd__decap_40_12
XANTENNA__1569__A1 net71 vssd1 vssd1 vccd1 vccd1 sky130_fd_sc_hd__diode_2
XFILLER_23_35 vssd1 vssd1 vccd1 vccd1 sky130_fd_sc_hd__fill_1
XFILLER_48_43 vccd1 vssd1 vccd1 vssd1 sky130_ef_sc_hd__decap_40_12
XFILLER_58_195 vssd1 vssd1 vccd1 vccd1 sky130_fd_sc_hd__fill_1
XFILLER_48_98 vssd1 vssd1 vccd1 vccd1 sky130_fd_sc_hd__fill_1
XFILLER_46_335 vssd1 vssd1 vccd1 vccd1 sky130_fd_sc_hd__fill_2
XFILLER_64_97 vccd1 vssd1 vccd1 vssd1 sky130_ef_sc_hd__decap_40_12
XFILLER_61_349 vssd1 vssd1 vccd1 vccd1 sky130_fd_sc_hd__fill_2
Xfanout91 net93 vssd1 vssd1 vccd1 vccd1 net91 sky130_fd_sc_hd__clkbuf_4
XTAP_TAPCELL_ROW_16_249 vssd1 vccd1 sky130_fd_sc_hd__tapvpwrvgnd_1
X_1301_ _0486_ net69 _0494_ vssd1 vssd1 vccd1 vccd1 _0496_ sky130_fd_sc_hd__a21o_1
X_1232_ _0439_ vssd1 vssd1 vccd1 vccd1 _0440_ sky130_fd_sc_hd__inv_2
XFILLER_36_5 vssd1 vssd1 vccd1 vccd1 sky130_fd_sc_hd__fill_2
Xclkbuf_leaf_1_clk clknet_2_0__leaf_clk vssd1 vssd1 vccd1 vccd1 clknet_leaf_1_clk
+ sky130_fd_sc_hd__clkbuf_8
X_2350_ net38 _1188_ _1189_ net40 CALC_INST.input_ctrl_inst.debounce_cnt\[7\] vssd1
+ vssd1 vccd1 vccd1 _0024_ sky130_fd_sc_hd__a32o_1
X_2281_ CALC_INST.gencon_inst.mult_calc.INn2\[5\] CALC_INST.gencon_inst.mult_calc.INn2\[4\]
+ CALC_INST.gencon_inst.mult_calc.INn2\[7\] CALC_INST.gencon_inst.mult_calc.INn2\[6\]
+ vssd1 vssd1 vccd1 vccd1 _1139_ sky130_fd_sc_hd__or4_1
X_1996_ _0902_ _0903_ vssd1 vssd1 vccd1 vccd1 _0945_ sky130_fd_sc_hd__nand2b_1
XFILLER_20_257 vssd1 vssd1 vccd1 vccd1 sky130_fd_sc_hd__fill_1
X_2617_ clknet_leaf_11_clk _0176_ net97 vssd1 vssd1 vccd1 vccd1 CALC_INST.gencon_inst.add_calc.main.a0.in1
+ sky130_fd_sc_hd__dfrtp_1
XANTENNA_fanout116_A net121 vssd1 vssd1 vccd1 vccd1 sky130_fd_sc_hd__diode_2
X_2548_ clknet_leaf_21_clk _0107_ net118 vssd1 vssd1 vccd1 vccd1 net17 sky130_fd_sc_hd__dfrtp_1
X_2479_ clknet_leaf_23_clk _0038_ net114 vssd1 vssd1 vccd1 vccd1 CALC_INST.gencon_inst.operand2\[6\]
+ sky130_fd_sc_hd__dfrtp_4
XFILLER_34_89 vssd1 vssd1 vccd1 vccd1 sky130_fd_sc_hd__fill_2
XTAP_TAPCELL_ROW_21_285 vssd1 vccd1 sky130_fd_sc_hd__tapvpwrvgnd_1
Xclkload0 clknet_leaf_0_clk vssd1 vssd1 vccd1 vccd1 clkload0/Y sky130_fd_sc_hd__inv_8
XFILLER_59_53 vssd1 vssd1 vccd1 vccd1 sky130_fd_sc_hd__fill_2
XFILLER_59_20 vssd1 vssd1 vccd1 vccd1 sky130_fd_sc_hd__fill_1
XFILLER_61_113 vssd1 vssd1 vccd1 vccd1 sky130_fd_sc_hd__fill_2
XTAP_TAPCELL_ROW_29_341 vssd1 vccd1 sky130_fd_sc_hd__tapvpwrvgnd_1
XFILLER_19_357 vssd1 vssd1 vccd1 vccd1 sky130_fd_sc_hd__fill_4
X_1850_ net418 net363 net139 vssd1 vssd1 vccd1 vccd1 _0238_ sky130_fd_sc_hd__mux2_1
X_1781_ _0803_ _0804_ vssd1 vssd1 vccd1 vccd1 _0806_ sky130_fd_sc_hd__nand2_1
X_2333_ CALC_INST.input_ctrl_inst.debounce_cnt\[3\] CALC_INST.input_ctrl_inst.debounce_cnt\[2\]
+ CALC_INST.input_ctrl_inst.debounce_cnt\[0\] CALC_INST.input_ctrl_inst.debounce_cnt\[1\]
+ vssd1 vssd1 vccd1 vccd1 _1177_ sky130_fd_sc_hd__and4_1
X_2402_ CALC_INST.input_ctrl_inst.col_index\[11\] CALC_INST.input_ctrl_inst.col_index\[10\]
+ CALC_INST.input_ctrl_inst.col_index\[12\] CALC_INST.input_ctrl_inst.col_index\[15\]
+ vssd1 vssd1 vccd1 vccd1 _0382_ sky130_fd_sc_hd__and4_1
X_2195_ CALC_INST.input_ctrl_inst.scan_timer\[0\] vssd1 vssd1 vccd1 vccd1 _1055_ sky130_fd_sc_hd__inv_2
XFILLER_37_132 vssd1 vssd1 vccd1 vccd1 sky130_fd_sc_hd__fill_1
XFILLER_37_121 vssd1 vssd1 vccd1 vccd1 sky130_fd_sc_hd__fill_2
XFILLER_37_110 vssd1 vssd1 vccd1 vccd1 sky130_fd_sc_hd__fill_2
X_2264_ _1093_ _1121_ vssd1 vssd1 vccd1 vccd1 _1122_ sky130_fd_sc_hd__or2_1
XTAP_TAPCELL_ROW_35_388 vssd1 vccd1 sky130_fd_sc_hd__tapvpwrvgnd_1
XFILLER_33_393 vssd1 vssd1 vccd1 vccd1 sky130_fd_sc_hd__fill_1
XFILLER_33_382 vssd1 vssd1 vccd1 vccd1 sky130_fd_sc_hd__fill_4
X_1979_ _0862_ _0929_ vssd1 vssd1 vccd1 vccd1 _0930_ sky130_fd_sc_hd__nor2_1
Xhold56 CALC_INST.gencon_inst.ALU_in2\[15\] vssd1 vssd1 vccd1 vccd1 net255 sky130_fd_sc_hd__dlygate4sd3_1
Xhold34 CALC_INST.gencon_inst.keypad_input\[3\] vssd1 vssd1 vccd1 vccd1 net233 sky130_fd_sc_hd__dlygate4sd3_1
Xhold45 CALC_INST.gencon_inst.mult_calc.INn1\[12\] vssd1 vssd1 vccd1 vccd1 net244
+ sky130_fd_sc_hd__dlygate4sd3_1
Xhold12 CALC_INST.gencon_inst.mult_calc.INn1\[8\] vssd1 vssd1 vccd1 vccd1 net211 sky130_fd_sc_hd__dlygate4sd3_1
Xhold23 CALC_INST.gencon_inst.mult_calc.main.GENERATE_ADDER\[2\].thingy.in1 vssd1
+ vssd1 vccd1 vccd1 net222 sky130_fd_sc_hd__dlygate4sd3_1
Xhold78 CALC_INST.gencon_inst.add_calc.start vssd1 vssd1 vccd1 vccd1 net277 sky130_fd_sc_hd__dlygate4sd3_1
Xhold67 _0158_ vssd1 vssd1 vccd1 vccd1 net266 sky130_fd_sc_hd__dlygate4sd3_1
XFILLER_45_44 vssd1 vssd1 vccd1 vccd1 sky130_fd_sc_hd__fill_1
XFILLER_43_113 vssd1 vssd1 vccd1 vccd1 sky130_fd_sc_hd__fill_1
XTAP_TAPCELL_ROW_26_322 vssd1 vccd1 sky130_fd_sc_hd__tapvpwrvgnd_1
Xhold89 CALC_INST.gencon_inst.mult_calc.countSave\[8\] vssd1 vssd1 vccd1 vccd1 net288
+ sky130_fd_sc_hd__dlygate4sd3_1
XANTENNA__2470__Q CALC_INST.gencon_inst.add_calc.state\[1\] vssd1 vssd1 vccd1 vccd1
+ sky130_fd_sc_hd__diode_2
XFILLER_61_98 vccd1 vssd1 vccd1 vssd1 sky130_ef_sc_hd__decap_40_12
XFILLER_61_54 vssd1 vssd1 vccd1 vccd1 sky130_fd_sc_hd__fill_2
XFILLER_61_43 vssd1 vssd1 vccd1 vccd1 sky130_fd_sc_hd__fill_2
XANTENNA__1632__A0 CALC_INST.gencon_inst.operand2\[11\] vssd1 vssd1 vccd1 vccd1 sky130_fd_sc_hd__diode_2
XANTENNA__1297__B _0490_ vssd1 vssd1 vccd1 vccd1 sky130_fd_sc_hd__diode_2
XANTENNA__2188__A1 CALC_INST.gencon_inst.mult_calc.start vssd1 vssd1 vccd1 vccd1 sky130_fd_sc_hd__diode_2
XANTENNA__1517__S net74 vssd1 vssd1 vccd1 vccd1 sky130_fd_sc_hd__diode_2
XFILLER_19_110 vssd1 vssd1 vccd1 vccd1 sky130_fd_sc_hd__fill_2
XANTENNA__1320__C1 net45 vssd1 vssd1 vccd1 vccd1 sky130_fd_sc_hd__diode_2
XFILLER_34_168 vssd1 vssd1 vccd1 vccd1 sky130_fd_sc_hd__fill_2
X_1902_ CALC_INST.gencon_inst.mult_calc.INn2\[15\] CALC_INST.gencon_inst.mult_calc.INn1\[15\]
+ vssd1 vssd1 vccd1 vccd1 _0855_ sky130_fd_sc_hd__xor2_1
XANTENNA_clkbuf_0_clk_A clk vssd1 vssd1 vccd1 vccd1 sky130_fd_sc_hd__diode_2
X_1833_ _0846_ _0847_ _0848_ vssd1 vssd1 vccd1 vccd1 _0850_ sky130_fd_sc_hd__o21ai_1
X_1764_ _0782_ _0786_ _0783_ vssd1 vssd1 vccd1 vccd1 _0791_ sky130_fd_sc_hd__o21a_1
X_1695_ net431 _0747_ net153 vssd1 vssd1 vccd1 vccd1 _0189_ sky130_fd_sc_hd__mux2_1
X_2316_ CALC_INST.input_ctrl_inst.RowSync\[2\] CALC_INST.input_ctrl_inst.col_index\[3\]
+ CALC_INST.input_ctrl_inst.RowSync\[3\] vssd1 vssd1 vccd1 vccd1 _1164_ sky130_fd_sc_hd__o21ai_1
X_2178_ _1043_ vssd1 vssd1 vccd1 vccd1 _1044_ sky130_fd_sc_hd__inv_2
X_2247_ _1089_ _1104_ vssd1 vssd1 vccd1 vccd1 _1105_ sky130_fd_sc_hd__or2_1
XANTENNA__2103__A1 net133 vssd1 vssd1 vccd1 vccd1 sky130_fd_sc_hd__diode_2
XTAP_TAPCELL_ROW_23_303 vssd1 vccd1 sky130_fd_sc_hd__tapvpwrvgnd_1
XANTENNA_fanout96_A net100 vssd1 vssd1 vccd1 vccd1 sky130_fd_sc_hd__diode_2
XANTENNA_wire51_X net51 vssd1 vssd1 vccd1 vccd1 sky130_fd_sc_hd__diode_2
Xoutput13 net13 vssd1 vssd1 vccd1 vccd1 gpio_out[16] sky130_fd_sc_hd__buf_2
Xoutput24 net24 vssd1 vssd1 vccd1 vccd1 gpio_out[27] sky130_fd_sc_hd__buf_2
Xteam_06_158 vssd1 vssd1 vccd1 vccd1 team_06_158/HI gpio_oeb[6] sky130_fd_sc_hd__conb_1
XFILLER_56_21 vssd1 vssd1 vccd1 vccd1 sky130_fd_sc_hd__fill_4
Xteam_06_169 vssd1 vssd1 vccd1 vccd1 team_06_169/HI gpio_oeb[17] sky130_fd_sc_hd__conb_1
XFILLER_0_223 vssd1 vssd1 vccd1 vccd1 sky130_fd_sc_hd__fill_1
XFILLER_56_282 vssd1 vssd1 vccd1 vccd1 sky130_fd_sc_hd__fill_2
XANTENNA_clkbuf_leaf_2_clk_A clknet_2_0__leaf_clk vssd1 vssd1 vccd1 vccd1 sky130_fd_sc_hd__diode_2
XPHY_EDGE_ROW_19_Right_19 vssd1 vssd1 vccd1 vccd1 sky130_fd_sc_hd__decap_3
XFILLER_16_124 vccd1 vssd1 vccd1 vssd1 sky130_ef_sc_hd__decap_40_12
XFILLER_12_363 vssd1 vssd1 vccd1 vccd1 sky130_fd_sc_hd__fill_1
XPHY_EDGE_ROW_28_Right_28 vssd1 vssd1 vccd1 vccd1 sky130_fd_sc_hd__decap_3
X_1480_ CALC_INST.input_ctrl_inst.col_index\[27\] _0630_ _0632_ _0582_ vssd1 vssd1
+ vccd1 vccd1 _0633_ sky130_fd_sc_hd__o211a_1
X_2032_ net32 _0972_ _0974_ vssd1 vssd1 vccd1 vccd1 _0975_ sky130_fd_sc_hd__a21oi_1
XFILLER_54_219 vssd1 vssd1 vccd1 vccd1 sky130_fd_sc_hd__fill_4
XANTENNA__1710__S net62 vssd1 vssd1 vccd1 vccd1 sky130_fd_sc_hd__diode_2
XFILLER_47_260 vssd1 vssd1 vccd1 vccd1 sky130_fd_sc_hd__fill_1
XPHY_EDGE_ROW_37_Right_37 vssd1 vssd1 vccd1 vccd1 sky130_fd_sc_hd__decap_3
XANTENNA__2097__B1 net34 vssd1 vssd1 vccd1 vccd1 sky130_fd_sc_hd__diode_2
X_2101_ net133 net240 net122 CALC_INST.gencon_inst.mult_calc.count.GENERATE_ADDER\[3\].thingy.in1
+ vssd1 vssd1 vccd1 vccd1 _0340_ sky130_fd_sc_hd__a22o_1
X_2865_ clknet_leaf_10_clk net205 vssd1 vssd1 vccd1 vccd1 CALC_INST.input_ctrl_inst.scan_timer\[19\]
+ sky130_fd_sc_hd__dfxtp_1
X_1678_ CALC_INST.gencon_inst.ALU_in2\[5\] CALC_INST.gencon_inst.ALU_in1\[5\] net62
+ vssd1 vssd1 vccd1 vccd1 _0739_ sky130_fd_sc_hd__mux2_1
XPHY_EDGE_ROW_46_Right_46 vssd1 vssd1 vccd1 vccd1 sky130_fd_sc_hd__decap_3
Xhold301 CALC_INST.gencon_inst.operator_input\[1\] vssd1 vssd1 vccd1 vccd1 net500
+ sky130_fd_sc_hd__dlygate4sd3_1
XFILLER_7_92 vccd1 vssd1 vccd1 vssd1 sky130_ef_sc_hd__decap_40_12
X_2796_ clknet_leaf_29_clk net308 net101 vssd1 vssd1 vccd1 vccd1 CALC_INST.gencon_inst.mult_calc.count.GENERATE_ADDER\[5\].thingy.in1
+ sky130_fd_sc_hd__dfrtp_1
X_1816_ net439 net131 _0835_ net142 vssd1 vssd1 vccd1 vccd1 _0222_ sky130_fd_sc_hd__a22o_1
X_1747_ CALC_INST.gencon_inst.mult_calc.main.a0.in2 CALC_INST.gencon_inst.mult_calc.main.a0.in1
+ vssd1 vssd1 vccd1 vccd1 _0777_ sky130_fd_sc_hd__or2_1
XPHY_EDGE_ROW_55_Right_55 vssd1 vssd1 vccd1 vccd1 sky130_fd_sc_hd__decap_3
XFILLER_53_241 vssd1 vssd1 vccd1 vccd1 sky130_fd_sc_hd__fill_1
XFILLER_26_24 vssd1 vssd1 vccd1 vccd1 sky130_fd_sc_hd__fill_4
XPHY_EDGE_ROW_64_Right_64 vssd1 vssd1 vccd1 vccd1 sky130_fd_sc_hd__decap_3
XTAP_TAPCELL_ROW_51_497 vssd1 vccd1 sky130_fd_sc_hd__tapvpwrvgnd_1
XFILLER_42_89 vssd1 vssd1 vccd1 vccd1 sky130_fd_sc_hd__fill_2
XPHY_EDGE_ROW_39_Left_104 vssd1 vssd1 vccd1 vccd1 sky130_fd_sc_hd__decap_3
XANTENNA_fanout99_X net99 vssd1 vssd1 vccd1 vccd1 sky130_fd_sc_hd__diode_2
XTAP_TAPCELL_ROW_59_553 vssd1 vccd1 sky130_fd_sc_hd__tapvpwrvgnd_1
XPHY_EDGE_ROW_48_Left_113 vssd1 vssd1 vccd1 vccd1 sky130_fd_sc_hd__decap_3
XANTENNA__1523__C1 net71 vssd1 vssd1 vccd1 vccd1 sky130_fd_sc_hd__diode_2
XFILLER_29_293 vssd1 vssd1 vccd1 vccd1 sky130_fd_sc_hd__fill_2
XTAP_TAPCELL_ROW_8_197 vssd1 vccd1 sky130_fd_sc_hd__tapvpwrvgnd_1
XANTENNA__2079__B1 net130 vssd1 vssd1 vccd1 vccd1 sky130_fd_sc_hd__diode_2
XTAP_TAPCELL_ROW_42_431 vssd1 vccd1 sky130_fd_sc_hd__tapvpwrvgnd_1
XPHY_EDGE_ROW_57_Left_122 vssd1 vssd1 vccd1 vccd1 sky130_fd_sc_hd__decap_3
X_2581_ clknet_leaf_13_clk _0140_ vssd1 vssd1 vccd1 vccd1 CALC_INST.gencon_inst.ALU_in2\[2\]
+ sky130_fd_sc_hd__dfxtp_1
X_2650_ clknet_leaf_5_clk _0209_ net99 vssd1 vssd1 vccd1 vccd1 CALC_INST.gencon_inst.gencon_state\[3\]
+ sky130_fd_sc_hd__dfrtp_4
X_1601_ net95 _0656_ vssd1 vssd1 vccd1 vccd1 _0722_ sky130_fd_sc_hd__nand2_1
X_1532_ CALC_INST.gencon_inst.operand2\[5\] CALC_INST.gencon_inst.operand1\[5\] net74
+ vssd1 vssd1 vccd1 vccd1 _0674_ sky130_fd_sc_hd__mux2_1
X_1394_ CALC_INST.input_ctrl_inst.scan_timer\[3\] CALC_INST.input_ctrl_inst.scan_timer\[2\]
+ CALC_INST.input_ctrl_inst.scan_timer\[5\] CALC_INST.input_ctrl_inst.scan_timer\[4\]
+ vssd1 vssd1 vccd1 vccd1 _0574_ sky130_fd_sc_hd__or4b_1
XANTENNA__1514__C1 net71 vssd1 vssd1 vccd1 vccd1 sky130_fd_sc_hd__diode_2
X_1463_ CALC_INST.input_ctrl_inst.col_index\[22\] _0619_ _0584_ vssd1 vssd1 vccd1
+ vccd1 _0621_ sky130_fd_sc_hd__a21oi_1
X_2015_ _0918_ _0960_ vssd1 vssd1 vccd1 vccd1 _0961_ sky130_fd_sc_hd__xnor2_1
X_2848_ clknet_leaf_7_clk _0363_ vssd1 vssd1 vccd1 vccd1 CALC_INST.input_ctrl_inst.scan_timer\[2\]
+ sky130_fd_sc_hd__dfxtp_1
Xhold142 CALC_INST.gencon_inst.add_calc.main.in2\[7\] vssd1 vssd1 vccd1 vccd1 net341
+ sky130_fd_sc_hd__dlygate4sd3_1
Xhold175 CALC_INST.input_ctrl_inst.scan_timer\[9\] vssd1 vssd1 vccd1 vccd1 net374
+ sky130_fd_sc_hd__dlygate4sd3_1
Xhold197 CALC_INST.gencon_inst.add_calc.sameSignVal vssd1 vssd1 vccd1 vccd1 net396
+ sky130_fd_sc_hd__dlygate4sd3_1
Xhold186 CALC_INST.gencon_inst.add_calc.main.GENERATE_ADDER\[14\].thingy.in1 vssd1
+ vssd1 vccd1 vccd1 net385 sky130_fd_sc_hd__dlygate4sd3_1
X_2779_ clknet_leaf_23_clk _0329_ vssd1 vssd1 vccd1 vccd1 CALC_INST.gencon_inst.mult_calc.INn2\[8\]
+ sky130_fd_sc_hd__dfxtp_1
Xhold164 CALC_INST.gencon_inst.mult_calc.INn2\[11\] vssd1 vssd1 vccd1 vccd1 net363
+ sky130_fd_sc_hd__dlygate4sd3_1
Xhold120 CALC_INST.input_ctrl_inst.input_control_state\[0\] vssd1 vssd1 vccd1 vccd1
+ net319 sky130_fd_sc_hd__dlygate4sd3_1
Xhold131 CALC_INST.gencon_inst.mult_calc.main.GENERATE_ADDER\[12\].thingy.in2 vssd1
+ vssd1 vccd1 vccd1 net330 sky130_fd_sc_hd__dlygate4sd3_1
Xhold153 CALC_INST.gencon_inst.mult_calc.main.GENERATE_ADDER\[5\].thingy.in2 vssd1
+ vssd1 vccd1 vccd1 net352 sky130_fd_sc_hd__dlygate4sd3_1
XFILLER_58_333 vssd1 vssd1 vccd1 vccd1 sky130_fd_sc_hd__fill_1
XTAP_TAPCELL_ROW_56_534 vssd1 vccd1 sky130_fd_sc_hd__tapvpwrvgnd_1
XANTENNA_fanout59_A net62 vssd1 vssd1 vccd1 vccd1 sky130_fd_sc_hd__diode_2
XTAP_TAPCELL_ROW_5_178 vssd1 vccd1 sky130_fd_sc_hd__tapvpwrvgnd_1
XFILLER_53_66 vssd1 vssd1 vccd1 vccd1 sky130_fd_sc_hd__fill_2
XANTENNA__1339__A2 net47 vssd1 vssd1 vccd1 vccd1 sky130_fd_sc_hd__diode_2
XFILLER_5_145 vssd1 vssd1 vccd1 vccd1 sky130_fd_sc_hd__fill_2
XFILLER_1_373 vccd1 vssd1 vccd1 vssd1 sky130_ef_sc_hd__decap_40_12
XANTENNA__1578__A2 _0560_ vssd1 vssd1 vccd1 vccd1 sky130_fd_sc_hd__diode_2
XFILLER_20_406 vssd1 vssd1 vccd1 vccd1 sky130_fd_sc_hd__fill_1
X_2702_ clknet_leaf_30_clk net384 net104 vssd1 vssd1 vccd1 vccd1 CALC_INST.gencon_inst.mult_calc.main.GENERATE_ADDER\[3\].thingy.in2
+ sky130_fd_sc_hd__dfrtp_1
X_2633_ clknet_leaf_11_clk _0192_ net96 vssd1 vssd1 vccd1 vccd1 CALC_INST.gencon_inst.add_calc.main.in2\[1\]
+ sky130_fd_sc_hd__dfrtp_1
X_2564_ clknet_leaf_11_clk _0123_ vssd1 vssd1 vccd1 vccd1 CALC_INST.gencon_inst.ALU_in1\[1\]
+ sky130_fd_sc_hd__dfxtp_1
X_2495_ clknet_leaf_22_clk _0054_ net114 vssd1 vssd1 vccd1 vccd1 CALC_INST.gencon_inst.operand1\[7\]
+ sky130_fd_sc_hd__dfrtp_1
X_1515_ net149 _0414_ vssd1 vssd1 vccd1 vccd1 _0662_ sky130_fd_sc_hd__and2_1
XFILLER_55_358 vssd1 vssd1 vccd1 vccd1 sky130_fd_sc_hd__fill_4
X_1377_ CALC_INST.gencon_inst.operand1\[13\] net48 _0557_ _0558_ vssd1 vssd1 vccd1
+ vccd1 _0060_ sky130_fd_sc_hd__o22a_1
XFILLER_4_71 vssd1 vssd1 vccd1 vccd1 sky130_fd_sc_hd__fill_1
X_1446_ CALC_INST.input_ctrl_inst.col_index\[17\] _0608_ vssd1 vssd1 vccd1 vccd1 _0609_
+ sky130_fd_sc_hd__nor2_1
XTAP_TAPCELL_ROW_61_570 vssd1 vccd1 sky130_fd_sc_hd__tapvpwrvgnd_1
XFILLER_23_222 vssd1 vssd1 vccd1 vccd1 sky130_fd_sc_hd__fill_2
XFILLER_48_55 vssd1 vssd1 vccd1 vccd1 sky130_fd_sc_hd__fill_4
XFILLER_64_76 vssd1 vssd1 vccd1 vccd1 sky130_fd_sc_hd__fill_8
XFILLER_64_65 vssd1 vssd1 vccd1 vccd1 sky130_fd_sc_hd__fill_8
XFILLER_64_43 vssd1 vssd1 vccd1 vccd1 sky130_fd_sc_hd__fill_2
XFILLER_46_358 vssd1 vssd1 vccd1 vccd1 sky130_fd_sc_hd__fill_1
XFILLER_0_29 vssd1 vssd1 vccd1 vccd1 sky130_fd_sc_hd__fill_8
Xfanout70 _0492_ vssd1 vssd1 vccd1 vccd1 net70 sky130_fd_sc_hd__clkbuf_2
Xfanout92 net93 vssd1 vssd1 vccd1 vccd1 net92 sky130_fd_sc_hd__clkbuf_4
Xfanout81 net82 vssd1 vssd1 vccd1 vccd1 net81 sky130_fd_sc_hd__clkbuf_4
XPHY_EDGE_ROW_24_Left_89 vssd1 vssd1 vccd1 vccd1 sky130_fd_sc_hd__decap_3
XFILLER_13_91 vssd1 vssd1 vccd1 vccd1 sky130_fd_sc_hd__fill_4
XFILLER_64_111 vssd1 vssd1 vccd1 vccd1 sky130_fd_sc_hd__fill_1
X_1300_ _0486_ net69 _0494_ vssd1 vssd1 vccd1 vccd1 _0495_ sky130_fd_sc_hd__a21oi_1
X_1231_ _0430_ _0432_ _0436_ _0438_ vssd1 vssd1 vccd1 vccd1 _0439_ sky130_fd_sc_hd__o211a_1
X_2280_ CALC_INST.gencon_inst.mult_calc.compCount.in2\[14\] _1097_ _1136_ _1137_ vssd1
+ vssd1 vccd1 vccd1 _1138_ sky130_fd_sc_hd__a22oi_2
XFILLER_64_177 vssd1 vssd1 vccd1 vccd1 sky130_fd_sc_hd__fill_1
XFILLER_45_391 vssd1 vssd1 vccd1 vccd1 sky130_fd_sc_hd__fill_1
X_1995_ _0939_ _0942_ vssd1 vssd1 vccd1 vccd1 _0944_ sky130_fd_sc_hd__or2_1
X_2616_ clknet_leaf_10_clk _0175_ net98 vssd1 vssd1 vccd1 vccd1 CALC_INST.gencon_inst.ALU_finish
+ sky130_fd_sc_hd__dfrtp_1
XFILLER_9_281 vssd1 vssd1 vccd1 vccd1 sky130_fd_sc_hd__fill_2
X_2547_ clknet_leaf_21_clk _0106_ net117 vssd1 vssd1 vccd1 vccd1 net16 sky130_fd_sc_hd__dfrtp_1
X_2478_ clknet_leaf_23_clk _0037_ net113 vssd1 vssd1 vccd1 vccd1 CALC_INST.gencon_inst.operand2\[5\]
+ sky130_fd_sc_hd__dfrtp_2
X_1429_ net413 _0599_ vssd1 vssd1 vccd1 vccd1 _0071_ sky130_fd_sc_hd__xor2_1
XFILLER_34_24 vssd1 vssd1 vccd1 vccd1 sky130_fd_sc_hd__fill_1
XFILLER_11_203 vssd1 vssd1 vccd1 vccd1 sky130_fd_sc_hd__fill_4
XFILLER_11_214 vssd1 vssd1 vccd1 vccd1 sky130_fd_sc_hd__fill_8
XFILLER_11_236 vssd1 vssd1 vccd1 vccd1 sky130_fd_sc_hd__fill_4
Xclkload1 clknet_leaf_1_clk vssd1 vssd1 vccd1 vccd1 clkload1/Y sky130_fd_sc_hd__inv_6
XFILLER_50_45 vssd1 vssd1 vccd1 vccd1 sky130_fd_sc_hd__fill_1
XTAP_TAPCELL_ROW_21_286 vssd1 vccd1 sky130_fd_sc_hd__tapvpwrvgnd_1
XFILLER_19_347 vssd1 vssd1 vccd1 vccd1 sky130_fd_sc_hd__fill_1
XFILLER_61_125 vssd1 vssd1 vccd1 vccd1 sky130_fd_sc_hd__fill_1
XTAP_TAPCELL_ROW_29_342 vssd1 vccd1 sky130_fd_sc_hd__tapvpwrvgnd_1
X_1780_ _0803_ _0804_ vssd1 vssd1 vccd1 vccd1 _0805_ sky130_fd_sc_hd__or2_1
X_2332_ net38 _1175_ _1176_ net40 net490 vssd1 vssd1 vccd1 vccd1 _0019_ sky130_fd_sc_hd__a32o_1
X_2401_ CALC_INST.input_ctrl_inst.col_index\[4\] _1227_ _1228_ vssd1 vssd1 vccd1 vccd1
+ _1229_ sky130_fd_sc_hd__a21oi_1
X_2194_ CALC_INST.gencon_inst.gencon_state\[3\] vssd1 vssd1 vccd1 vccd1 _1054_ sky130_fd_sc_hd__inv_2
XFILLER_37_199 vssd1 vssd1 vccd1 vccd1 sky130_fd_sc_hd__fill_1
XFILLER_25_339 vssd1 vssd1 vccd1 vccd1 sky130_fd_sc_hd__fill_1
X_2263_ CALC_INST.gencon_inst.mult_calc.count.GENERATE_ADDER\[9\].thingy.in1 _1092_
+ vssd1 vssd1 vccd1 vccd1 _1121_ sky130_fd_sc_hd__nor2_1
X_1978_ _0866_ _0870_ _0926_ _0867_ _0863_ vssd1 vssd1 vccd1 vccd1 _0929_ sky130_fd_sc_hd__o311a_1
Xhold68 CALC_INST.gencon_inst.ALU_in2\[4\] vssd1 vssd1 vccd1 vccd1 net267 sky130_fd_sc_hd__dlygate4sd3_1
Xhold57 CALC_INST.gencon_inst.ALU_in2\[14\] vssd1 vssd1 vccd1 vccd1 net256 sky130_fd_sc_hd__dlygate4sd3_1
Xhold79 CALC_INST.gencon_inst.mult_calc.INn1\[10\] vssd1 vssd1 vccd1 vccd1 net278
+ sky130_fd_sc_hd__dlygate4sd3_1
Xhold24 CALC_INST.gencon_inst.mult_calc.main.GENERATE_ADDER\[1\].thingy.in1 vssd1
+ vssd1 vccd1 vccd1 net223 sky130_fd_sc_hd__dlygate4sd3_1
Xhold13 CALC_INST.gencon_inst.mult_calc.INn1\[0\] vssd1 vssd1 vccd1 vccd1 net212 sky130_fd_sc_hd__dlygate4sd3_1
Xhold46 CALC_INST.gencon_inst.mult_calc.main.GENERATE_ADDER\[5\].thingy.in1 vssd1
+ vssd1 vccd1 vccd1 net245 sky130_fd_sc_hd__dlygate4sd3_1
Xhold35 CALC_INST.gencon_inst.mult_calc.INn1\[11\] vssd1 vssd1 vccd1 vccd1 net234
+ sky130_fd_sc_hd__dlygate4sd3_1
XTAP_TAPCELL_ROW_26_323 vssd1 vccd1 sky130_fd_sc_hd__tapvpwrvgnd_1
XFILLER_16_306 vssd1 vssd1 vccd1 vccd1 sky130_fd_sc_hd__fill_2
XANTENNA__2188__A2 net155 vssd1 vssd1 vccd1 vccd1 sky130_fd_sc_hd__diode_2
XFILLER_10_92 vssd1 vssd1 vccd1 vccd1 sky130_fd_sc_hd__fill_2
XFILLER_62_401 vssd1 vssd1 vccd1 vccd1 sky130_fd_sc_hd__fill_2
XFILLER_20_9 vssd1 vssd1 vccd1 vccd1 sky130_fd_sc_hd__fill_1
XFILLER_19_90 vccd1 vssd1 vccd1 vssd1 sky130_ef_sc_hd__decap_40_12
XFILLER_19_155 vssd1 vssd1 vccd1 vccd1 sky130_fd_sc_hd__fill_4
X_1901_ CALC_INST.gencon_inst.mult_calc.out\[15\] net272 net143 vssd1 vssd1 vccd1
+ vccd1 _0288_ sky130_fd_sc_hd__mux2_1
X_1832_ _0846_ _0847_ _0848_ vssd1 vssd1 vccd1 vccd1 _0849_ sky130_fd_sc_hd__or3_1
XANTENNA__1708__S net62 vssd1 vssd1 vccd1 vccd1 sky130_fd_sc_hd__diode_2
X_1694_ CALC_INST.gencon_inst.ALU_in2\[13\] CALC_INST.gencon_inst.ALU_in1\[13\] net61
+ vssd1 vssd1 vccd1 vccd1 _0747_ sky130_fd_sc_hd__mux2_1
X_1763_ _0788_ _0789_ vssd1 vssd1 vccd1 vccd1 _0790_ sky130_fd_sc_hd__nand2b_1
XFILLER_57_217 vssd1 vssd1 vccd1 vccd1 sky130_fd_sc_hd__fill_4
XFILLER_57_206 vssd1 vssd1 vccd1 vccd1 sky130_fd_sc_hd__fill_2
X_2315_ CALC_INST.input_ctrl_inst.RowSync\[0\] CALC_INST.input_ctrl_inst.col_index\[3\]
+ CALC_INST.input_ctrl_inst.RowSync\[1\] vssd1 vssd1 vccd1 vccd1 _1163_ sky130_fd_sc_hd__or3b_1
XPHY_EDGE_ROW_27_Left_92 vssd1 vssd1 vccd1 vccd1 sky130_fd_sc_hd__decap_3
X_2246_ CALC_INST.gencon_inst.mult_calc.count.GENERATE_ADDER\[3\].thingy.in1 _1087_
+ vssd1 vssd1 vccd1 vccd1 _1104_ sky130_fd_sc_hd__nor2_1
X_2177_ CALC_INST.input_ctrl_inst.scan_timer\[15\] _1041_ vssd1 vssd1 vccd1 vccd1
+ _1043_ sky130_fd_sc_hd__and2_1
XTAP_TAPCELL_ROW_23_304 vssd1 vccd1 sky130_fd_sc_hd__tapvpwrvgnd_1
XPHY_EDGE_ROW_11_Left_76 vssd1 vssd1 vccd1 vccd1 sky130_fd_sc_hd__decap_3
XFILLER_15_15 vssd1 vssd1 vccd1 vccd1 sky130_fd_sc_hd__fill_8
XFILLER_40_139 vssd1 vssd1 vccd1 vccd1 sky130_fd_sc_hd__fill_1
XFILLER_33_191 vssd1 vssd1 vccd1 vccd1 sky130_fd_sc_hd__fill_8
Xteam_06_159 vssd1 vssd1 vccd1 vccd1 team_06_159/HI gpio_oeb[7] sky130_fd_sc_hd__conb_1
Xoutput25 net25 vssd1 vssd1 vccd1 vccd1 gpio_out[28] sky130_fd_sc_hd__buf_2
Xoutput14 net14 vssd1 vssd1 vccd1 vccd1 gpio_out[17] sky130_fd_sc_hd__buf_2
XFILLER_56_261 vssd1 vssd1 vccd1 vccd1 sky130_fd_sc_hd__fill_4
XFILLER_0_279 vssd1 vssd1 vccd1 vccd1 sky130_fd_sc_hd__fill_1
XANTENNA_fanout44_X net44 vssd1 vssd1 vccd1 vccd1 sky130_fd_sc_hd__diode_2
XFILLER_16_136 vssd1 vssd1 vccd1 vccd1 sky130_fd_sc_hd__fill_4
XFILLER_16_169 vssd1 vssd1 vccd1 vccd1 sky130_fd_sc_hd__fill_2
XFILLER_21_91 vccd1 vssd1 vccd1 vssd1 sky130_ef_sc_hd__decap_40_12
XFILLER_8_313 vssd1 vssd1 vccd1 vccd1 sky130_fd_sc_hd__fill_1
XANTENNA__1541__B1 net67 vssd1 vssd1 vccd1 vccd1 sky130_fd_sc_hd__diode_2
X_2100_ net133 net259 net122 net320 vssd1 vssd1 vccd1 vccd1 _0339_ sky130_fd_sc_hd__a22o_1
X_2031_ _0922_ _0973_ vssd1 vssd1 vccd1 vccd1 _0974_ sky130_fd_sc_hd__xnor2_1
XFILLER_47_283 vssd1 vssd1 vccd1 vccd1 sky130_fd_sc_hd__fill_1
XANTENNA__1499__A net71 vssd1 vssd1 vccd1 vccd1 sky130_fd_sc_hd__diode_2
X_2864_ clknet_leaf_10_clk net488 vssd1 vssd1 vccd1 vccd1 CALC_INST.input_ctrl_inst.scan_timer\[18\]
+ sky130_fd_sc_hd__dfxtp_1
X_2795_ clknet_leaf_29_clk _0341_ net101 vssd1 vssd1 vccd1 vccd1 CALC_INST.gencon_inst.mult_calc.count.GENERATE_ADDER\[4\].thingy.in1
+ sky130_fd_sc_hd__dfrtp_1
X_1815_ _0832_ _0834_ vssd1 vssd1 vccd1 vccd1 _0835_ sky130_fd_sc_hd__xnor2_1
X_1677_ net376 _0738_ net151 vssd1 vssd1 vccd1 vccd1 _0180_ sky130_fd_sc_hd__mux2_1
Xhold302 CALC_INST.gencon_inst.operator_input\[2\] vssd1 vssd1 vccd1 vccd1 net501
+ sky130_fd_sc_hd__dlygate4sd3_1
X_1746_ CALC_INST.gencon_inst.mult_calc.main.a0.in2 CALC_INST.gencon_inst.mult_calc.main.a0.in1
+ vssd1 vssd1 vccd1 vccd1 _0776_ sky130_fd_sc_hd__nand2_1
XFILLER_38_261 vssd1 vssd1 vccd1 vccd1 sky130_fd_sc_hd__fill_8
XFILLER_38_250 vssd1 vssd1 vccd1 vccd1 sky130_fd_sc_hd__fill_2
XANTENNA__1901__S net143 vssd1 vssd1 vccd1 vccd1 sky130_fd_sc_hd__diode_2
X_2229_ CALC_INST.gencon_inst.mult_calc.count.GENERATE_ADDER\[1\].thingy.in1 CALC_INST.gencon_inst.mult_calc.count.GENERATE_ADDER\[1\].thingy.cIn
+ CALC_INST.gencon_inst.mult_calc.count.GENERATE_ADDER\[2\].thingy.in1 vssd1 vssd1
+ vccd1 vccd1 _1087_ sky130_fd_sc_hd__and3_1
XFILLER_13_128 vssd1 vssd1 vccd1 vccd1 sky130_fd_sc_hd__fill_1
XTAP_TAPCELL_ROW_51_498 vssd1 vccd1 sky130_fd_sc_hd__tapvpwrvgnd_1
XTAP_TAPCELL_ROW_8_198 vssd1 vccd1 sky130_fd_sc_hd__tapvpwrvgnd_1
XTAP_TAPCELL_ROW_59_554 vssd1 vccd1 sky130_fd_sc_hd__tapvpwrvgnd_1
XTAP_TAPCELL_ROW_42_432 vssd1 vccd1 sky130_fd_sc_hd__tapvpwrvgnd_1
XFILLER_8_154 vssd1 vssd1 vccd1 vccd1 sky130_fd_sc_hd__fill_2
X_2580_ clknet_leaf_11_clk _0139_ vssd1 vssd1 vccd1 vccd1 CALC_INST.gencon_inst.ALU_in2\[1\]
+ sky130_fd_sc_hd__dfxtp_1
X_1600_ net299 _0719_ _0720_ vssd1 vssd1 vccd1 vccd1 _0120_ sky130_fd_sc_hd__a21bo_1
X_1531_ net485 _0659_ _0673_ _0656_ _0672_ vssd1 vssd1 vccd1 vccd1 _0099_ sky130_fd_sc_hd__a221o_1
X_1462_ net465 net52 _0620_ vssd1 vssd1 vccd1 vccd1 _0083_ sky130_fd_sc_hd__a21bo_1
X_1393_ _0563_ _0571_ _0572_ vssd1 vssd1 vccd1 vccd1 _0573_ sky130_fd_sc_hd__or3b_1
X_2014_ _0890_ _0891_ vssd1 vssd1 vccd1 vccd1 _0960_ sky130_fd_sc_hd__nand2b_1
XFILLER_50_223 vssd1 vssd1 vccd1 vccd1 sky130_fd_sc_hd__fill_1
X_2847_ clknet_leaf_7_clk _0362_ vssd1 vssd1 vccd1 vccd1 CALC_INST.input_ctrl_inst.scan_timer\[1\]
+ sky130_fd_sc_hd__dfxtp_1
XANTENNA_clkbuf_2_1__f_clk_A clknet_0_clk vssd1 vssd1 vccd1 vccd1 sky130_fd_sc_hd__diode_2
X_2778_ clknet_leaf_23_clk net441 vssd1 vssd1 vccd1 vccd1 CALC_INST.gencon_inst.mult_calc.INn2\[7\]
+ sky130_fd_sc_hd__dfxtp_1
Xhold110 CALC_INST.gencon_inst.mult_calc.countSave\[9\] vssd1 vssd1 vccd1 vccd1 net309
+ sky130_fd_sc_hd__dlygate4sd3_1
XFILLER_12_16 vssd1 vssd1 vccd1 vccd1 sky130_fd_sc_hd__fill_2
XFILLER_12_27 vssd1 vssd1 vccd1 vccd1 sky130_fd_sc_hd__fill_1
XANTENNA_fanout139_A CALC_INST.gencon_inst.mult_calc.state\[3\] vssd1 vssd1 vccd1
+ vccd1 sky130_fd_sc_hd__diode_2
Xhold176 CALC_INST.input_ctrl_inst.scan_timer\[13\] vssd1 vssd1 vccd1 vccd1 net375
+ sky130_fd_sc_hd__dlygate4sd3_1
Xhold165 CALC_INST.gencon_inst.add_calc.main.in2\[4\] vssd1 vssd1 vccd1 vccd1 net364
+ sky130_fd_sc_hd__dlygate4sd3_1
Xhold154 CALC_INST.gencon_inst.ALU_finish vssd1 vssd1 vccd1 vccd1 net353 sky130_fd_sc_hd__dlygate4sd3_1
Xhold198 _0210_ vssd1 vssd1 vccd1 vccd1 net397 sky130_fd_sc_hd__dlygate4sd3_1
X_1729_ _0420_ _0494_ vssd1 vssd1 vccd1 vccd1 _0765_ sky130_fd_sc_hd__nor2_1
Xhold187 CALC_INST.gencon_inst.mult_calc.INn2\[3\] vssd1 vssd1 vccd1 vccd1 net386
+ sky130_fd_sc_hd__dlygate4sd3_1
Xhold132 _0270_ vssd1 vssd1 vccd1 vccd1 net331 sky130_fd_sc_hd__dlygate4sd3_1
Xhold143 CALC_INST.gencon_inst.mult_calc.main.GENERATE_ADDER\[13\].thingy.in2 vssd1
+ vssd1 vccd1 vccd1 net342 sky130_fd_sc_hd__dlygate4sd3_1
XANTENNA_clkbuf_leaf_1_clk_A clknet_2_0__leaf_clk vssd1 vssd1 vccd1 vccd1 sky130_fd_sc_hd__diode_2
Xhold121 CALC_INST.gencon_inst.mult_calc.count.GENERATE_ADDER\[2\].thingy.in1 vssd1
+ vssd1 vccd1 vccd1 net320 sky130_fd_sc_hd__dlygate4sd3_1
XTAP_TAPCELL_ROW_56_535 vssd1 vccd1 sky130_fd_sc_hd__tapvpwrvgnd_1
XFILLER_37_57 vssd1 vssd1 vccd1 vccd1 sky130_fd_sc_hd__fill_4
XFILLER_37_35 vssd1 vssd1 vccd1 vccd1 sky130_fd_sc_hd__fill_1
XFILLER_26_253 vssd1 vssd1 vccd1 vccd1 sky130_fd_sc_hd__fill_4
XTAP_TAPCELL_ROW_64_590 vssd1 vccd1 sky130_fd_sc_hd__tapvpwrvgnd_1
XFILLER_41_267 vssd1 vssd1 vccd1 vccd1 sky130_fd_sc_hd__fill_1
XFILLER_5_113 vssd1 vssd1 vccd1 vccd1 sky130_fd_sc_hd__fill_2
XFILLER_64_326 vssd1 vssd1 vccd1 vccd1 sky130_fd_sc_hd__fill_8
XFILLER_1_385 vssd1 vssd1 vccd1 vccd1 sky130_fd_sc_hd__fill_4
XFILLER_27_90 vssd1 vssd1 vccd1 vccd1 sky130_fd_sc_hd__fill_2
X_2632_ clknet_leaf_11_clk _0191_ net97 vssd1 vssd1 vccd1 vccd1 CALC_INST.gencon_inst.add_calc.main.in2\[0\]
+ sky130_fd_sc_hd__dfrtp_1
X_2701_ clknet_leaf_31_clk net433 net89 vssd1 vssd1 vccd1 vccd1 CALC_INST.gencon_inst.mult_calc.main.GENERATE_ADDER\[2\].thingy.in2
+ sky130_fd_sc_hd__dfrtp_1
X_2563_ clknet_leaf_13_clk _0122_ vssd1 vssd1 vccd1 vccd1 CALC_INST.gencon_inst.ALU_in1\[0\]
+ sky130_fd_sc_hd__dfxtp_1
X_1514_ net30 _0660_ _0658_ net71 vssd1 vssd1 vccd1 vccd1 _0661_ sky130_fd_sc_hd__o211a_1
X_2494_ clknet_leaf_15_clk _0053_ net114 vssd1 vssd1 vccd1 vccd1 CALC_INST.gencon_inst.operand1\[6\]
+ sky130_fd_sc_hd__dfrtp_2
XFILLER_4_94 vssd1 vssd1 vccd1 vccd1 sky130_fd_sc_hd__fill_2
X_1445_ _0385_ _0596_ CALC_INST.input_ctrl_inst.col_index\[16\] vssd1 vssd1 vccd1
+ vccd1 _0608_ sky130_fd_sc_hd__and3b_1
X_1376_ CALC_INST.gencon_inst.ALU_out\[13\] net78 net70 CALC_INST.gencon_inst.mult_calc.out\[13\]
+ net46 vssd1 vssd1 vccd1 vccd1 _0558_ sky130_fd_sc_hd__a221o_1
XFILLER_23_289 vssd1 vssd1 vccd1 vccd1 sky130_fd_sc_hd__fill_1
XFILLER_23_278 vssd1 vssd1 vccd1 vccd1 sky130_fd_sc_hd__fill_2
XFILLER_2_127 vccd1 vssd1 vccd1 vssd1 sky130_ef_sc_hd__decap_40_12
XFILLER_48_67 vssd1 vssd1 vccd1 vccd1 sky130_fd_sc_hd__fill_8
XANTENNA_fanout71_A _0415_ vssd1 vssd1 vccd1 vccd1 sky130_fd_sc_hd__diode_2
XFILLER_64_55 vssd1 vssd1 vccd1 vccd1 sky130_fd_sc_hd__fill_1
XFILLER_61_318 vssd1 vssd1 vccd1 vccd1 sky130_fd_sc_hd__fill_4
XFILLER_54_381 vssd1 vssd1 vccd1 vccd1 sky130_fd_sc_hd__fill_1
Xfanout60 net62 vssd1 vssd1 vccd1 vccd1 net60 sky130_fd_sc_hd__clkbuf_4
Xfanout71 _0415_ vssd1 vssd1 vccd1 vccd1 net71 sky130_fd_sc_hd__clkbuf_4
Xfanout93 net100 vssd1 vssd1 vccd1 vccd1 net93 sky130_fd_sc_hd__buf_2
Xfanout82 net93 vssd1 vssd1 vccd1 vccd1 net82 sky130_fd_sc_hd__clkbuf_4
XFILLER_43_8 vssd1 vssd1 vccd1 vccd1 sky130_fd_sc_hd__fill_8
XFILLER_37_337 vssd1 vssd1 vccd1 vccd1 sky130_fd_sc_hd__fill_4
X_1230_ CALC_INST.gencon_inst.operand2\[2\] CALC_INST.gencon_inst.latched_keypad_input\[2\]
+ vssd1 vssd1 vccd1 vccd1 _0438_ sky130_fd_sc_hd__or2_1
XFILLER_60_340 vssd1 vssd1 vccd1 vccd1 sky130_fd_sc_hd__fill_1
X_1994_ net456 _0943_ net154 vssd1 vssd1 vccd1 vccd1 _0292_ sky130_fd_sc_hd__mux2_1
XANTENNA__2115__B net155 vssd1 vssd1 vccd1 vccd1 sky130_fd_sc_hd__diode_2
Xclkload30 clknet_leaf_21_clk vssd1 vssd1 vccd1 vccd1 clkload30/Y sky130_fd_sc_hd__inv_6
X_2615_ clknet_leaf_3_clk _0174_ vssd1 vssd1 vccd1 vccd1 CALC_INST.gencon_inst.mult_calc.INn1\[15\]
+ sky130_fd_sc_hd__dfxtp_1
X_2546_ clknet_leaf_21_clk _0105_ net117 vssd1 vssd1 vccd1 vccd1 net15 sky130_fd_sc_hd__dfrtp_1
X_2477_ clknet_leaf_23_clk _0036_ net113 vssd1 vssd1 vccd1 vccd1 CALC_INST.gencon_inst.operand2\[4\]
+ sky130_fd_sc_hd__dfrtp_2
X_1428_ _0598_ _0599_ vssd1 vssd1 vccd1 vccd1 _0070_ sky130_fd_sc_hd__nor2_1
XFILLER_18_26 vssd1 vssd1 vccd1 vccd1 sky130_fd_sc_hd__fill_2
X_1359_ CALC_INST.gencon_inst.operand1\[9\] net47 _0543_ _0544_ vssd1 vssd1 vccd1
+ vccd1 _0056_ sky130_fd_sc_hd__o22a_1
Xclkload2 clknet_leaf_2_clk vssd1 vssd1 vccd1 vccd1 clkload2/Y sky130_fd_sc_hd__bufinv_16
XTAP_TAPCELL_ROW_21_287 vssd1 vccd1 sky130_fd_sc_hd__tapvpwrvgnd_1
XFILLER_59_55 vssd1 vssd1 vccd1 vccd1 sky130_fd_sc_hd__fill_1
XFILLER_50_68 vssd1 vssd1 vccd1 vccd1 sky130_fd_sc_hd__fill_8
XFILLER_46_167 vssd1 vssd1 vccd1 vccd1 sky130_fd_sc_hd__fill_1
XANTENNA_fanout74_X net74 vssd1 vssd1 vccd1 vccd1 sky130_fd_sc_hd__diode_2
XANTENNA__2484__Q CALC_INST.gencon_inst.operand2\[11\] vssd1 vssd1 vccd1 vccd1 sky130_fd_sc_hd__diode_2
XTAP_TAPCELL_ROW_29_343 vssd1 vccd1 sky130_fd_sc_hd__tapvpwrvgnd_1
XFILLER_19_337 vssd1 vssd1 vccd1 vccd1 sky130_fd_sc_hd__fill_8
XFILLER_61_159 vssd1 vssd1 vccd1 vccd1 sky130_fd_sc_hd__fill_2
XFILLER_61_115 vssd1 vssd1 vccd1 vccd1 sky130_fd_sc_hd__fill_1
XANTENNA__2216__A CALC_INST.input_ctrl_inst.key_pressed vssd1 vssd1 vccd1 vccd1 sky130_fd_sc_hd__diode_2
XFILLER_6_241 vssd1 vssd1 vccd1 vccd1 sky130_fd_sc_hd__fill_1
XTAP_TAPCELL_ROW_12_221 vssd1 vccd1 sky130_fd_sc_hd__tapvpwrvgnd_1
X_2400_ CALC_INST.input_ctrl_inst.col_index\[1\] CALC_INST.input_ctrl_inst.col_index\[0\]
+ CALC_INST.input_ctrl_inst.col_index\[2\] CALC_INST.input_ctrl_inst.col_index\[3\]
+ vssd1 vssd1 vccd1 vccd1 _1228_ sky130_fd_sc_hd__o31a_1
XANTENNA__1402__A2 net53 vssd1 vssd1 vccd1 vccd1 sky130_fd_sc_hd__diode_2
X_2331_ CALC_INST.input_ctrl_inst.debounce_cnt\[0\] CALC_INST.input_ctrl_inst.debounce_cnt\[1\]
+ CALC_INST.input_ctrl_inst.debounce_cnt\[2\] vssd1 vssd1 vccd1 vccd1 _1176_ sky130_fd_sc_hd__a21o_1
X_2262_ CALC_INST.gencon_inst.mult_calc.compCount.in2\[7\] _1115_ _1116_ _1114_ _1119_
+ vssd1 vssd1 vccd1 vccd1 _1120_ sky130_fd_sc_hd__o221a_1
X_2193_ net134 vssd1 vssd1 vccd1 vccd1 _1053_ sky130_fd_sc_hd__inv_2
X_1977_ _0866_ _0870_ _0926_ _0867_ vssd1 vssd1 vccd1 vccd1 _0928_ sky130_fd_sc_hd__o31a_1
XANTENNA_fanout121_A CALC_INST.gencon_inst.add_calc.nRST vssd1 vssd1 vccd1 vccd1 sky130_fd_sc_hd__diode_2
X_2529_ clknet_leaf_0_clk _0088_ net81 vssd1 vssd1 vccd1 vccd1 CALC_INST.input_ctrl_inst.col_index\[26\]
+ sky130_fd_sc_hd__dfrtp_1
XFILLER_20_27 vssd1 vssd1 vccd1 vccd1 sky130_fd_sc_hd__fill_1
Xhold58 CALC_INST.gencon_inst.ALU_in2\[7\] vssd1 vssd1 vccd1 vccd1 net257 sky130_fd_sc_hd__dlygate4sd3_1
Xhold69 CALC_INST.gencon_inst.ALU_in1\[14\] vssd1 vssd1 vccd1 vccd1 net268 sky130_fd_sc_hd__dlygate4sd3_1
Xhold25 CALC_INST.gencon_inst.prev_operator_input\[0\] vssd1 vssd1 vccd1 vccd1 net224
+ sky130_fd_sc_hd__dlygate4sd3_1
Xhold47 CALC_INST.gencon_inst.keypad_input\[1\] vssd1 vssd1 vccd1 vccd1 net246 sky130_fd_sc_hd__dlygate4sd3_1
Xhold14 CALC_INST.gencon_inst.mult_calc.INn1\[5\] vssd1 vssd1 vccd1 vccd1 net213 sky130_fd_sc_hd__dlygate4sd3_1
Xhold36 _0253_ vssd1 vssd1 vccd1 vccd1 net235 sky130_fd_sc_hd__dlygate4sd3_1
XTAP_TAPCELL_ROW_26_324 vssd1 vccd1 sky130_fd_sc_hd__tapvpwrvgnd_1
XFILLER_61_45 vssd1 vssd1 vccd1 vccd1 sky130_fd_sc_hd__fill_1
XFILLER_3_277 vssd1 vssd1 vccd1 vccd1 sky130_fd_sc_hd__fill_2
XFILLER_42_181 vssd1 vssd1 vccd1 vccd1 sky130_fd_sc_hd__fill_8
XFILLER_30_365 vssd1 vssd1 vccd1 vccd1 sky130_fd_sc_hd__fill_1
X_1831_ _0841_ _0843_ _0842_ vssd1 vssd1 vccd1 vccd1 _0848_ sky130_fd_sc_hd__a21boi_1
X_1900_ CALC_INST.gencon_inst.mult_calc.out\[14\] net408 net144 vssd1 vssd1 vccd1
+ vccd1 _0287_ sky130_fd_sc_hd__mux2_1
XFILLER_15_351 vssd1 vssd1 vccd1 vccd1 sky130_fd_sc_hd__fill_1
X_1693_ net426 _0746_ net153 vssd1 vssd1 vccd1 vccd1 _0188_ sky130_fd_sc_hd__mux2_1
X_1762_ CALC_INST.gencon_inst.mult_calc.main.GENERATE_ADDER\[3\].thingy.in2 CALC_INST.gencon_inst.mult_calc.main.GENERATE_ADDER\[3\].thingy.in1
+ vssd1 vssd1 vccd1 vccd1 _0789_ sky130_fd_sc_hd__nand2_1
X_2176_ _1022_ _1040_ _1042_ vssd1 vssd1 vccd1 vccd1 _0375_ sky130_fd_sc_hd__and3_1
X_2314_ _1159_ _1160_ CALC_INST.input_ctrl_inst.RowSync\[1\] vssd1 vssd1 vccd1 vccd1
+ _1162_ sky130_fd_sc_hd__a21o_1
X_2245_ CALC_INST.gencon_inst.mult_calc.compCount.in2\[2\] _1099_ vssd1 vssd1 vccd1
+ vccd1 _1103_ sky130_fd_sc_hd__or2_1
XTAP_TAPCELL_ROW_31_360 vssd1 vccd1 sky130_fd_sc_hd__tapvpwrvgnd_1
Xoutput15 net15 vssd1 vssd1 vccd1 vccd1 gpio_out[18] sky130_fd_sc_hd__buf_2
XPHY_EDGE_ROW_1_Right_1 vssd1 vssd1 vccd1 vccd1 sky130_fd_sc_hd__decap_3
XFILLER_0_225 vccd1 vssd1 vccd1 vssd1 sky130_ef_sc_hd__decap_40_12
Xoutput26 net26 vssd1 vssd1 vccd1 vccd1 gpio_out[4] sky130_fd_sc_hd__buf_2
XFILLER_56_284 vssd1 vssd1 vccd1 vccd1 sky130_fd_sc_hd__fill_1
XFILLER_56_45 vssd1 vssd1 vccd1 vccd1 sky130_fd_sc_hd__fill_4
XANTENNA__1550__B2 _0656_ vssd1 vssd1 vccd1 vccd1 sky130_fd_sc_hd__diode_2
XFILLER_16_115 vssd1 vssd1 vccd1 vccd1 sky130_fd_sc_hd__fill_2
X_2030_ _0878_ _0879_ vssd1 vssd1 vccd1 vccd1 _0973_ sky130_fd_sc_hd__and2b_1
XANTENNA__1544__S net74 vssd1 vssd1 vccd1 vccd1 sky130_fd_sc_hd__diode_2
XFILLER_62_210 vssd1 vssd1 vccd1 vccd1 sky130_fd_sc_hd__fill_4
XFILLER_50_405 vssd1 vssd1 vccd1 vccd1 sky130_fd_sc_hd__fill_2
XTAP_TAPCELL_ROW_45_452 vssd1 vccd1 sky130_fd_sc_hd__tapvpwrvgnd_1
XANTENNA__2097__A2 net42 vssd1 vssd1 vccd1 vccd1 sky130_fd_sc_hd__diode_2
XFILLER_22_118 vssd1 vssd1 vccd1 vccd1 sky130_fd_sc_hd__fill_2
X_2863_ clknet_leaf_9_clk _0378_ vssd1 vssd1 vccd1 vccd1 CALC_INST.input_ctrl_inst.scan_timer\[17\]
+ sky130_fd_sc_hd__dfxtp_1
X_2794_ clknet_leaf_29_clk net241 net101 vssd1 vssd1 vccd1 vccd1 CALC_INST.gencon_inst.mult_calc.count.GENERATE_ADDER\[3\].thingy.in1
+ sky130_fd_sc_hd__dfrtp_1
X_1745_ net139 net141 vssd1 vssd1 vccd1 vccd1 _0775_ sky130_fd_sc_hd__nor2_1
X_1814_ CALC_INST.gencon_inst.mult_calc.main.GENERATE_ADDER\[9\].thingy.in2 CALC_INST.gencon_inst.mult_calc.main.GENERATE_ADDER\[9\].thingy.in1
+ _0833_ vssd1 vssd1 vccd1 vccd1 _0834_ sky130_fd_sc_hd__o21bai_2
X_1676_ CALC_INST.gencon_inst.ALU_in2\[4\] CALC_INST.gencon_inst.ALU_in1\[4\] net59
+ vssd1 vssd1 vccd1 vccd1 _0738_ sky130_fd_sc_hd__mux2_1
XFILLER_7_391 vssd1 vssd1 vccd1 vccd1 sky130_fd_sc_hd__fill_1
Xhold303 CALC_INST.input_ctrl_inst.debounce_cnt\[10\] vssd1 vssd1 vccd1 vccd1 net502
+ sky130_fd_sc_hd__dlygate4sd3_1
X_2159_ CALC_INST.input_ctrl_inst.scan_timer\[7\] CALC_INST.input_ctrl_inst.scan_timer\[8\]
+ _1029_ vssd1 vssd1 vccd1 vccd1 _1032_ sky130_fd_sc_hd__and3_1
XANTENNA__2088__A2 _0728_ vssd1 vssd1 vccd1 vccd1 sky130_fd_sc_hd__diode_2
X_2228_ _1068_ _1086_ _1084_ _1071_ vssd1 vssd1 vccd1 vccd1 CALC_INST.input_ctrl_inst.next_state\[0\]
+ sky130_fd_sc_hd__a211o_1
XANTENNA__2065__A2_N net127 vssd1 vssd1 vccd1 vccd1 sky130_fd_sc_hd__diode_2
XFILLER_41_405 vssd1 vssd1 vccd1 vccd1 sky130_fd_sc_hd__fill_2
Xclkbuf_leaf_33_clk clknet_2_0__leaf_clk vssd1 vssd1 vccd1 vccd1 clknet_leaf_33_clk
+ sky130_fd_sc_hd__clkbuf_8
XTAP_TAPCELL_ROW_51_499 vssd1 vccd1 sky130_fd_sc_hd__tapvpwrvgnd_1
XFILLER_21_195 vssd1 vssd1 vccd1 vccd1 sky130_fd_sc_hd__fill_4
XTAP_TAPCELL_ROW_59_555 vssd1 vccd1 sky130_fd_sc_hd__tapvpwrvgnd_1
XTAP_TAPCELL_ROW_8_199 vssd1 vccd1 sky130_fd_sc_hd__tapvpwrvgnd_1
XTAP_TAPCELL_ROW_42_433 vssd1 vccd1 sky130_fd_sc_hd__tapvpwrvgnd_1
Xclkbuf_leaf_24_clk clknet_2_2__leaf_clk vssd1 vssd1 vccd1 vccd1 clknet_leaf_24_clk
+ sky130_fd_sc_hd__clkbuf_8
XFILLER_8_100 vccd1 vssd1 vccd1 vssd1 sky130_ef_sc_hd__decap_40_12
XFILLER_16_81 vssd1 vssd1 vccd1 vccd1 sky130_fd_sc_hd__fill_2
XFILLER_59_6 vccd1 vssd1 vccd1 vssd1 sky130_ef_sc_hd__decap_40_12
X_1392_ CALC_INST.input_ctrl_inst.scan_timer\[7\] CALC_INST.input_ctrl_inst.scan_timer\[6\]
+ CALC_INST.input_ctrl_inst.scan_timer\[9\] CALC_INST.input_ctrl_inst.scan_timer\[8\]
+ vssd1 vssd1 vccd1 vccd1 _0572_ sky130_fd_sc_hd__and4b_1
X_1530_ CALC_INST.gencon_inst.operand2\[4\] CALC_INST.gencon_inst.operand1\[4\] net73
+ vssd1 vssd1 vccd1 vccd1 _0673_ sky130_fd_sc_hd__mux2_1
X_1461_ _0618_ _0619_ _0582_ vssd1 vssd1 vccd1 vccd1 _0620_ sky130_fd_sc_hd__or3b_1
X_2013_ net33 _0958_ vssd1 vssd1 vccd1 vccd1 _0959_ sky130_fd_sc_hd__nand2_1
Xclkbuf_leaf_15_clk clknet_2_3__leaf_clk vssd1 vssd1 vccd1 vccd1 clknet_leaf_15_clk
+ sky130_fd_sc_hd__clkbuf_8
XANTENNA__1303__A _0490_ vssd1 vssd1 vccd1 vccd1 sky130_fd_sc_hd__diode_2
XFILLER_35_287 vssd1 vssd1 vccd1 vccd1 sky130_fd_sc_hd__fill_1
Xhold144 CALC_INST.gencon_inst.add_calc.main.in2\[1\] vssd1 vssd1 vccd1 vccd1 net343
+ sky130_fd_sc_hd__dlygate4sd3_1
X_2846_ clknet_leaf_7_clk _0361_ vssd1 vssd1 vccd1 vccd1 CALC_INST.input_ctrl_inst.scan_timer\[0\]
+ sky130_fd_sc_hd__dfxtp_1
Xhold100 CALC_INST.gencon_inst.latched_operator_input\[2\] vssd1 vssd1 vccd1 vccd1
+ net299 sky130_fd_sc_hd__dlygate4sd3_1
X_1728_ _0648_ _0653_ CALC_INST.equal_input net73 vssd1 vssd1 vccd1 vccd1 _0764_ sky130_fd_sc_hd__o2bb2a_1
X_2777_ clknet_leaf_23_clk _0327_ vssd1 vssd1 vccd1 vccd1 CALC_INST.gencon_inst.mult_calc.INn2\[6\]
+ sky130_fd_sc_hd__dfxtp_1
Xhold133 CALC_INST.gencon_inst.mult_calc.adderSave\[13\] vssd1 vssd1 vccd1 vccd1 net332
+ sky130_fd_sc_hd__dlygate4sd3_1
Xhold122 CALC_INST.gencon_inst.mult_calc.adderSave\[7\] vssd1 vssd1 vccd1 vccd1 net321
+ sky130_fd_sc_hd__dlygate4sd3_1
XFILLER_2_309 vccd1 vssd1 vccd1 vssd1 sky130_ef_sc_hd__decap_40_12
Xhold111 _0346_ vssd1 vssd1 vccd1 vccd1 net310 sky130_fd_sc_hd__dlygate4sd3_1
XANTENNA__1753__A1 net141 vssd1 vssd1 vccd1 vccd1 sky130_fd_sc_hd__diode_2
Xhold155 CALC_INST.gencon_inst.add_calc.main.in2\[11\] vssd1 vssd1 vccd1 vccd1 net354
+ sky130_fd_sc_hd__dlygate4sd3_1
Xhold177 CALC_INST.gencon_inst.add_calc.main.GENERATE_ADDER\[4\].thingy.in1 vssd1
+ vssd1 vccd1 vccd1 net376 sky130_fd_sc_hd__dlygate4sd3_1
XANTENNA_input6_A nrst vssd1 vssd1 vccd1 vccd1 sky130_fd_sc_hd__diode_2
X_1659_ net244 _0695_ net44 vssd1 vssd1 vccd1 vccd1 _0171_ sky130_fd_sc_hd__mux2_1
Xhold199 CALC_INST.gencon_inst.mult_calc.INn2\[13\] vssd1 vssd1 vccd1 vccd1 net398
+ sky130_fd_sc_hd__dlygate4sd3_1
Xhold188 _0324_ vssd1 vssd1 vccd1 vccd1 net387 sky130_fd_sc_hd__dlygate4sd3_1
Xhold166 CALC_INST.gencon_inst.mult_calc.main.GENERATE_ADDER\[14\].thingy.in2 vssd1
+ vssd1 vccd1 vccd1 net365 sky130_fd_sc_hd__dlygate4sd3_1
XTAP_TAPCELL_ROW_64_591 vssd1 vccd1 sky130_fd_sc_hd__tapvpwrvgnd_1
XFILLER_41_279 vssd1 vssd1 vccd1 vccd1 sky130_fd_sc_hd__fill_1
XFILLER_5_169 vssd1 vssd1 vccd1 vccd1 sky130_fd_sc_hd__fill_4
XFILLER_49_335 vssd1 vssd1 vccd1 vccd1 sky130_fd_sc_hd__fill_1
X_2631_ clknet_leaf_19_clk _0190_ net119 vssd1 vssd1 vccd1 vccd1 CALC_INST.gencon_inst.add_calc.main.GENERATE_ADDER\[14\].thingy.in1
+ sky130_fd_sc_hd__dfrtp_1
X_2562_ clknet_leaf_7_clk net218 vssd1 vssd1 vccd1 vccd1 CALC_INST.gencon_inst.prev_read_input
+ sky130_fd_sc_hd__dfxtp_1
X_2700_ clknet_leaf_32_clk _0259_ net92 vssd1 vssd1 vccd1 vccd1 CALC_INST.gencon_inst.mult_calc.main.GENERATE_ADDER\[1\].thingy.in2
+ sky130_fd_sc_hd__dfrtp_1
X_1513_ _0415_ _0655_ vssd1 vssd1 vccd1 vccd1 _0660_ sky130_fd_sc_hd__nand2_4
X_1375_ CALC_INST.gencon_inst.operand1\[13\] _0552_ _0556_ vssd1 vssd1 vccd1 vccd1
+ _0557_ sky130_fd_sc_hd__o21a_1
X_2493_ clknet_leaf_15_clk _0052_ net113 vssd1 vssd1 vccd1 vccd1 CALC_INST.gencon_inst.operand1\[5\]
+ sky130_fd_sc_hd__dfrtp_2
Xclkbuf_leaf_4_clk clknet_2_0__leaf_clk vssd1 vssd1 vccd1 vccd1 clknet_leaf_4_clk
+ sky130_fd_sc_hd__clkbuf_8
X_1444_ net359 _0607_ vssd1 vssd1 vccd1 vccd1 _0078_ sky130_fd_sc_hd__xnor2_1
XFILLER_63_393 vccd1 vssd1 vccd1 vssd1 sky130_ef_sc_hd__decap_40_12
XANTENNA_fanout151_A CALC_INST.gencon_inst.add_calc.state\[2\] vssd1 vssd1 vccd1 vccd1
+ sky130_fd_sc_hd__diode_2
XFILLER_23_49 vssd1 vssd1 vccd1 vccd1 sky130_fd_sc_hd__fill_4
XFILLER_2_139 vssd1 vssd1 vccd1 vccd1 sky130_fd_sc_hd__fill_1
X_2829_ clknet_leaf_34_clk _0023_ net87 vssd1 vssd1 vccd1 vccd1 CALC_INST.input_ctrl_inst.debounce_cnt\[6\]
+ sky130_fd_sc_hd__dfrtp_1
XFILLER_64_12 vccd1 vssd1 vccd1 vssd1 sky130_ef_sc_hd__decap_40_12
XFILLER_58_110 vssd1 vssd1 vccd1 vccd1 sky130_fd_sc_hd__fill_1
XANTENNA_fanout64_A _0724_ vssd1 vssd1 vccd1 vccd1 sky130_fd_sc_hd__diode_2
XTAP_TAPCELL_ROW_1_150 vssd1 vccd1 sky130_fd_sc_hd__tapvpwrvgnd_1
Xfanout61 net62 vssd1 vssd1 vccd1 vccd1 net61 sky130_fd_sc_hd__clkbuf_2
Xfanout94 net96 vssd1 vssd1 vccd1 vccd1 net94 sky130_fd_sc_hd__clkbuf_4
Xfanout50 _0425_ vssd1 vssd1 vccd1 vccd1 net50 sky130_fd_sc_hd__dlymetal6s2s_1
Xfanout83 net86 vssd1 vssd1 vccd1 vccd1 net83 sky130_fd_sc_hd__clkbuf_4
XFILLER_29_7 vccd1 vssd1 vccd1 vssd1 sky130_ef_sc_hd__decap_40_12
XFILLER_64_113 vccd1 vssd1 vccd1 vssd1 sky130_ef_sc_hd__decap_40_12
XFILLER_60_363 vssd1 vssd1 vccd1 vccd1 sky130_fd_sc_hd__fill_1
X_1993_ _0940_ _0942_ vssd1 vssd1 vccd1 vccd1 _0943_ sky130_fd_sc_hd__xnor2_1
XANTENNA_clkbuf_leaf_0_clk_A clknet_2_0__leaf_clk vssd1 vssd1 vccd1 vccd1 sky130_fd_sc_hd__diode_2
XFILLER_9_261 vssd1 vssd1 vccd1 vccd1 sky130_fd_sc_hd__fill_2
XFILLER_20_205 vssd1 vssd1 vccd1 vccd1 sky130_fd_sc_hd__fill_2
Xclkload31 clknet_leaf_22_clk vssd1 vssd1 vccd1 vccd1 clkload31/Y sky130_fd_sc_hd__inv_6
X_2545_ clknet_leaf_21_clk _0104_ net117 vssd1 vssd1 vccd1 vccd1 net14 sky130_fd_sc_hd__dfrtp_1
X_2614_ clknet_leaf_24_clk _0173_ vssd1 vssd1 vccd1 vccd1 CALC_INST.gencon_inst.mult_calc.INn1\[14\]
+ sky130_fd_sc_hd__dfxtp_1
Xclkload20 clknet_leaf_28_clk vssd1 vssd1 vccd1 vccd1 clkload20/Y sky130_fd_sc_hd__inv_6
X_1358_ CALC_INST.gencon_inst.ALU_out\[9\] net77 net70 CALC_INST.gencon_inst.mult_calc.out\[9\]
+ net45 vssd1 vssd1 vccd1 vccd1 _0544_ sky130_fd_sc_hd__a221o_1
X_2476_ clknet_leaf_4_clk _0035_ net113 vssd1 vssd1 vccd1 vccd1 CALC_INST.gencon_inst.operand2\[3\]
+ sky130_fd_sc_hd__dfrtp_2
XFILLER_28_327 vssd1 vssd1 vccd1 vccd1 sky130_fd_sc_hd__fill_4
X_1427_ CALC_INST.input_ctrl_inst.col_index\[8\] net51 _0596_ vssd1 vssd1 vccd1 vccd1
+ _0599_ sky130_fd_sc_hd__and3_1
XANTENNA_fanout154_X net154 vssd1 vssd1 vccd1 vccd1 sky130_fd_sc_hd__diode_2
X_1289_ CALC_INST.gencon_inst.mult_calc.out\[14\] net50 _0484_ net55 vssd1 vssd1 vccd1
+ vccd1 _0485_ sky130_fd_sc_hd__a22o_1
Xclkload3 clknet_leaf_3_clk vssd1 vssd1 vccd1 vccd1 clkload3/X sky130_fd_sc_hd__clkbuf_4
XTAP_TAPCELL_ROW_21_288 vssd1 vccd1 sky130_fd_sc_hd__tapvpwrvgnd_1
XANTENNA_fanout67_X net67 vssd1 vssd1 vccd1 vccd1 sky130_fd_sc_hd__diode_2
XTAP_TAPCELL_ROW_29_344 vssd1 vccd1 sky130_fd_sc_hd__tapvpwrvgnd_1
XANTENNA__1883__B1 net125 vssd1 vssd1 vccd1 vccd1 sky130_fd_sc_hd__diode_2
XANTENNA__2765__Q CALC_INST.gencon_inst.mult_calc.state\[3\] vssd1 vssd1 vccd1 vccd1
+ sky130_fd_sc_hd__diode_2
XFILLER_42_363 vssd1 vssd1 vccd1 vccd1 sky130_fd_sc_hd__fill_1
XANTENNA_clkbuf_2_3__f_clk_X clknet_2_3__leaf_clk vssd1 vssd1 vccd1 vccd1 sky130_fd_sc_hd__diode_2
XTAP_TAPCELL_ROW_12_222 vssd1 vccd1 sky130_fd_sc_hd__tapvpwrvgnd_1
XFILLER_37_113 vssd1 vssd1 vccd1 vccd1 sky130_fd_sc_hd__fill_2
XFILLER_37_102 vssd1 vssd1 vccd1 vccd1 sky130_fd_sc_hd__fill_8
X_2330_ CALC_INST.input_ctrl_inst.debounce_cnt\[2\] CALC_INST.input_ctrl_inst.debounce_cnt\[0\]
+ CALC_INST.input_ctrl_inst.debounce_cnt\[1\] vssd1 vssd1 vccd1 vccd1 _1175_ sky130_fd_sc_hd__nand3_1
X_2261_ CALC_INST.gencon_inst.mult_calc.compCount.in2\[8\] _1118_ vssd1 vssd1 vccd1
+ vccd1 _1119_ sky130_fd_sc_hd__or2_1
X_2192_ net141 vssd1 vssd1 vccd1 vccd1 _1052_ sky130_fd_sc_hd__inv_2
XFILLER_33_330 vssd1 vssd1 vccd1 vccd1 sky130_fd_sc_hd__fill_1
XFILLER_60_193 vssd1 vssd1 vccd1 vccd1 sky130_fd_sc_hd__fill_2
X_1976_ _0870_ _0926_ vssd1 vssd1 vccd1 vccd1 _0927_ sky130_fd_sc_hd__nor2_1
XANTENNA_fanout114_A net121 vssd1 vssd1 vccd1 vccd1 sky130_fd_sc_hd__diode_2
X_2528_ clknet_leaf_0_clk _0087_ net81 vssd1 vssd1 vccd1 vccd1 CALC_INST.input_ctrl_inst.col_index\[25\]
+ sky130_fd_sc_hd__dfrtp_1
Xhold37 CALC_INST.input_ctrl_inst.scan_timer\[17\] vssd1 vssd1 vccd1 vccd1 net236
+ sky130_fd_sc_hd__dlygate4sd3_1
Xhold59 CALC_INST.gencon_inst.ALU_in1\[3\] vssd1 vssd1 vccd1 vccd1 net258 sky130_fd_sc_hd__dlygate4sd3_1
XFILLER_43_105 vssd1 vssd1 vccd1 vccd1 sky130_fd_sc_hd__fill_4
Xhold15 CALC_INST.gencon_inst.prev_operator_input\[2\] vssd1 vssd1 vccd1 vccd1 net214
+ sky130_fd_sc_hd__dlygate4sd3_1
X_2459_ CALC_INST.gencon_inst.operand2\[0\] net36 _0429_ vssd1 vssd1 vccd1 vccd1 _0032_
+ sky130_fd_sc_hd__o21a_1
Xhold26 CALC_INST.gencon_inst.mult_calc.main.GENERATE_ADDER\[13\].thingy.in1 vssd1
+ vssd1 vccd1 vccd1 net225 sky130_fd_sc_hd__dlygate4sd3_1
Xhold48 CALC_INST.gencon_inst.mult_calc.countSave\[0\] vssd1 vssd1 vccd1 vccd1 net247
+ sky130_fd_sc_hd__dlygate4sd3_1
XFILLER_61_57 vssd1 vssd1 vccd1 vccd1 sky130_fd_sc_hd__fill_1
XTAP_TAPCELL_ROW_34_380 vssd1 vccd1 sky130_fd_sc_hd__tapvpwrvgnd_1
XTAP_TAPCELL_ROW_26_325 vssd1 vccd1 sky130_fd_sc_hd__tapvpwrvgnd_1
XFILLER_3_223 vssd1 vssd1 vccd1 vccd1 sky130_fd_sc_hd__fill_1
XFILLER_59_271 vssd1 vssd1 vccd1 vccd1 sky130_fd_sc_hd__fill_4
XFILLER_19_113 vssd1 vssd1 vccd1 vccd1 sky130_fd_sc_hd__fill_4
XFILLER_62_403 vssd1 vssd1 vccd1 vccd1 sky130_fd_sc_hd__fill_1
XANTENNA__2033__B1 net126 vssd1 vssd1 vccd1 vccd1 sky130_fd_sc_hd__diode_2
XFILLER_42_193 vssd1 vssd1 vccd1 vccd1 sky130_fd_sc_hd__fill_2
XFILLER_42_171 vssd1 vssd1 vccd1 vccd1 sky130_fd_sc_hd__fill_8
X_1830_ CALC_INST.gencon_inst.mult_calc.main.GENERATE_ADDER\[13\].thingy.in2 CALC_INST.gencon_inst.mult_calc.main.GENERATE_ADDER\[13\].thingy.in1
+ vssd1 vssd1 vccd1 vccd1 _0847_ sky130_fd_sc_hd__and2_1
X_1761_ CALC_INST.gencon_inst.mult_calc.main.GENERATE_ADDER\[3\].thingy.in2 CALC_INST.gencon_inst.mult_calc.main.GENERATE_ADDER\[3\].thingy.in1
+ vssd1 vssd1 vccd1 vccd1 _0788_ sky130_fd_sc_hd__nor2_1
X_1692_ CALC_INST.gencon_inst.ALU_in2\[12\] CALC_INST.gencon_inst.ALU_in1\[12\] net61
+ vssd1 vssd1 vccd1 vccd1 _0746_ sky130_fd_sc_hd__mux2_1
X_2313_ _1159_ _1160_ vssd1 vssd1 vccd1 vccd1 _1161_ sky130_fd_sc_hd__nand2_1
XFILLER_57_208 vssd1 vssd1 vccd1 vccd1 sky130_fd_sc_hd__fill_1
X_2175_ _1041_ vssd1 vssd1 vccd1 vccd1 _1042_ sky130_fd_sc_hd__inv_2
X_2244_ CALC_INST.gencon_inst.mult_calc.compCount.in2\[2\] _1099_ _1101_ CALC_INST.gencon_inst.mult_calc.compCount.in2\[1\]
+ _1100_ vssd1 vssd1 vccd1 vccd1 _1102_ sky130_fd_sc_hd__a221o_1
X_1959_ net145 CALC_INST.gencon_inst.add_calc.main.a0.in1 CALC_INST.gencon_inst.add_calc.main.in2\[0\]
+ vssd1 vssd1 vccd1 vccd1 _0910_ sky130_fd_sc_hd__mux2_1
XFILLER_48_208 vssd1 vssd1 vccd1 vccd1 sky130_fd_sc_hd__fill_2
Xoutput16 net16 vssd1 vssd1 vccd1 vccd1 gpio_out[19] sky130_fd_sc_hd__buf_2
XANTENNA__1550__A2 _0659_ vssd1 vssd1 vccd1 vccd1 sky130_fd_sc_hd__diode_2
Xoutput27 net27 vssd1 vssd1 vccd1 vccd1 gpio_out[5] sky130_fd_sc_hd__buf_2
XFILLER_0_237 vccd1 vssd1 vccd1 vssd1 sky130_ef_sc_hd__decap_40_12
XFILLER_56_79 vssd1 vssd1 vccd1 vccd1 sky130_fd_sc_hd__fill_1
XFILLER_24_193 vssd1 vssd1 vccd1 vccd1 sky130_fd_sc_hd__fill_2
XFILLER_8_359 vssd1 vssd1 vccd1 vccd1 sky130_fd_sc_hd__fill_2
XANTENNA__1560__S net74 vssd1 vssd1 vccd1 vccd1 sky130_fd_sc_hd__diode_2
XTAP_TAPCELL_ROW_45_453 vssd1 vccd1 sky130_fd_sc_hd__tapvpwrvgnd_1
Xclkbuf_0_clk clk vssd1 vssd1 vccd1 vccd1 clknet_0_clk sky130_fd_sc_hd__clkbuf_16
Xmax_cap80 _0386_ vssd1 vssd1 vccd1 vccd1 net80 sky130_fd_sc_hd__clkbuf_1
X_2862_ clknet_leaf_9_clk _0377_ vssd1 vssd1 vccd1 vccd1 CALC_INST.input_ctrl_inst.scan_timer\[16\]
+ sky130_fd_sc_hd__dfxtp_1
Xhold304 CALC_INST.input_ctrl_inst.scan_timer\[10\] vssd1 vssd1 vccd1 vccd1 net503
+ sky130_fd_sc_hd__dlygate4sd3_1
X_1744_ net150 net145 _0774_ vssd1 vssd1 vccd1 vccd1 _0211_ sky130_fd_sc_hd__o21a_1
XFILLER_30_141 vssd1 vssd1 vccd1 vccd1 sky130_fd_sc_hd__fill_1
X_1813_ _0814_ _0819_ _0822_ _0826_ _0820_ vssd1 vssd1 vccd1 vccd1 _0833_ sky130_fd_sc_hd__o311a_1
X_2793_ clknet_leaf_33_clk _0339_ net88 vssd1 vssd1 vccd1 vccd1 CALC_INST.gencon_inst.mult_calc.count.GENERATE_ADDER\[2\].thingy.in1
+ sky130_fd_sc_hd__dfrtp_1
X_1675_ net367 _0737_ net151 vssd1 vssd1 vccd1 vccd1 _0179_ sky130_fd_sc_hd__mux2_1
XPHY_EDGE_ROW_15_Right_15 vssd1 vssd1 vccd1 vccd1 sky130_fd_sc_hd__decap_3
X_2158_ CALC_INST.input_ctrl_inst.scan_timer\[7\] _1029_ CALC_INST.input_ctrl_inst.scan_timer\[8\]
+ vssd1 vssd1 vccd1 vccd1 _1031_ sky130_fd_sc_hd__a21o_1
XFILLER_53_222 vssd1 vssd1 vccd1 vccd1 sky130_fd_sc_hd__fill_2
XFILLER_53_211 vssd1 vssd1 vccd1 vccd1 sky130_fd_sc_hd__fill_2
X_2089_ net440 _0728_ net35 CALC_INST.gencon_inst.operand2\[7\] vssd1 vssd1 vccd1
+ vccd1 _0328_ sky130_fd_sc_hd__a22o_1
X_2227_ _1085_ vssd1 vssd1 vccd1 vccd1 _1086_ sky130_fd_sc_hd__inv_2
XPHY_EDGE_ROW_24_Right_24 vssd1 vssd1 vccd1 vccd1 sky130_fd_sc_hd__decap_3
XPHY_EDGE_ROW_33_Right_33 vssd1 vssd1 vccd1 vccd1 sky130_fd_sc_hd__decap_3
XTAP_TAPCELL_ROW_59_556 vssd1 vccd1 sky130_fd_sc_hd__tapvpwrvgnd_1
XANTENNA__1523__A2 _0660_ vssd1 vssd1 vccd1 vccd1 sky130_fd_sc_hd__diode_2
XPHY_EDGE_ROW_42_Right_42 vssd1 vssd1 vccd1 vccd1 sky130_fd_sc_hd__decap_3
XTAP_TAPCELL_ROW_42_434 vssd1 vccd1 sky130_fd_sc_hd__tapvpwrvgnd_1
XPHY_EDGE_ROW_51_Right_51 vssd1 vssd1 vccd1 vccd1 sky130_fd_sc_hd__decap_3
XFILLER_8_112 vssd1 vssd1 vccd1 vccd1 sky130_fd_sc_hd__fill_1
XFILLER_8_167 vssd1 vssd1 vccd1 vccd1 sky130_fd_sc_hd__fill_1
X_1391_ CALC_INST.input_ctrl_inst.scan_timer\[11\] CALC_INST.input_ctrl_inst.scan_timer\[10\]
+ CALC_INST.input_ctrl_inst.scan_timer\[13\] CALC_INST.input_ctrl_inst.scan_timer\[12\]
+ vssd1 vssd1 vccd1 vccd1 _0571_ sky130_fd_sc_hd__or4_1
XANTENNA__1514__A2 _0660_ vssd1 vssd1 vccd1 vccd1 sky130_fd_sc_hd__diode_2
X_1460_ CALC_INST.input_ctrl_inst.col_index\[21\] CALC_INST.input_ctrl_inst.col_index\[20\]
+ _0615_ vssd1 vssd1 vccd1 vccd1 _0619_ sky130_fd_sc_hd__and3_1
XPHY_EDGE_ROW_60_Right_60 vssd1 vssd1 vccd1 vccd1 sky130_fd_sc_hd__decap_3
X_2012_ _0949_ _0951_ _0956_ vssd1 vssd1 vccd1 vccd1 _0958_ sky130_fd_sc_hd__or3_1
XPHY_EDGE_ROW_35_Left_100 vssd1 vssd1 vccd1 vccd1 sky130_fd_sc_hd__decap_3
X_2845_ clknet_leaf_6_clk _0030_ net94 vssd1 vssd1 vccd1 vccd1 CALC_INST.input_ctrl_inst.decoded_key\[3\]
+ sky130_fd_sc_hd__dfstp_1
XFILLER_12_18 vssd1 vssd1 vccd1 vccd1 sky130_fd_sc_hd__fill_1
Xhold101 CALC_INST.gencon_inst.ALU_in1\[4\] vssd1 vssd1 vccd1 vccd1 net300 sky130_fd_sc_hd__dlygate4sd3_1
X_1727_ net336 _0763_ net152 vssd1 vssd1 vccd1 vccd1 _0205_ sky130_fd_sc_hd__mux2_1
X_2776_ clknet_leaf_23_clk _0326_ vssd1 vssd1 vccd1 vccd1 CALC_INST.gencon_inst.mult_calc.INn2\[5\]
+ sky130_fd_sc_hd__dfxtp_1
X_1658_ net234 _0692_ net44 vssd1 vssd1 vccd1 vccd1 _0170_ sky130_fd_sc_hd__mux2_1
Xhold167 _0272_ vssd1 vssd1 vccd1 vccd1 net366 sky130_fd_sc_hd__dlygate4sd3_1
Xhold134 CALC_INST.gencon_inst.mult_calc.main.GENERATE_ADDER\[7\].thingy.in2 vssd1
+ vssd1 vccd1 vccd1 net333 sky130_fd_sc_hd__dlygate4sd3_1
Xhold112 CALC_INST.gencon_inst.mult_calc.countSave\[13\] vssd1 vssd1 vccd1 vccd1 net311
+ sky130_fd_sc_hd__dlygate4sd3_1
Xhold156 CALC_INST.gencon_inst.mult_calc.compCount.in2\[8\] vssd1 vssd1 vccd1 vccd1
+ net355 sky130_fd_sc_hd__dlygate4sd3_1
Xhold123 CALC_INST.gencon_inst.mult_calc.count.GENERATE_ADDER\[14\].thingy.in1 vssd1
+ vssd1 vccd1 vccd1 net322 sky130_fd_sc_hd__dlygate4sd3_1
Xhold145 CALC_INST.gencon_inst.mult_calc.adderSave\[0\] vssd1 vssd1 vccd1 vccd1 net344
+ sky130_fd_sc_hd__dlygate4sd3_1
Xhold189 CALC_INST.gencon_inst.add_calc.main.in2\[10\] vssd1 vssd1 vccd1 vccd1 net388
+ sky130_fd_sc_hd__dlygate4sd3_1
Xhold178 CALC_INST.input_ctrl_inst.scan_timer\[10\] vssd1 vssd1 vccd1 vccd1 net377
+ sky130_fd_sc_hd__dlygate4sd3_1
X_1589_ CALC_INST.gencon_inst.key_read _0419_ _0712_ _0717_ vssd1 vssd1 vccd1 vccd1
+ _0718_ sky130_fd_sc_hd__a31o_1
XTAP_TAPCELL_ROW_64_592 vssd1 vccd1 sky130_fd_sc_hd__tapvpwrvgnd_1
XFILLER_53_47 vssd1 vssd1 vccd1 vccd1 sky130_fd_sc_hd__fill_2
XANTENNA__2466__A0 CALC_INST.gencon_inst.operand2\[1\] vssd1 vssd1 vccd1 vccd1 sky130_fd_sc_hd__diode_2
XFILLER_26_266 vssd1 vssd1 vccd1 vccd1 sky130_fd_sc_hd__fill_4
XFILLER_26_233 vssd1 vssd1 vccd1 vccd1 sky130_fd_sc_hd__fill_4
XFILLER_64_317 vssd1 vssd1 vccd1 vccd1 sky130_fd_sc_hd__fill_1
XTAP_TAPCELL_ROW_4_170 vssd1 vccd1 sky130_fd_sc_hd__tapvpwrvgnd_1
XFILLER_17_200 vssd1 vssd1 vccd1 vccd1 sky130_fd_sc_hd__fill_1
X_2630_ clknet_leaf_19_clk _0189_ net119 vssd1 vssd1 vccd1 vccd1 CALC_INST.gencon_inst.add_calc.main.GENERATE_ADDER\[13\].thingy.in1
+ sky130_fd_sc_hd__dfrtp_1
X_2561_ clknet_leaf_7_clk _0120_ net95 vssd1 vssd1 vccd1 vccd1 CALC_INST.gencon_inst.latched_operator_input\[2\]
+ sky130_fd_sc_hd__dfrtp_1
X_2492_ clknet_leaf_14_clk _0051_ net113 vssd1 vssd1 vccd1 vccd1 CALC_INST.gencon_inst.operand1\[4\]
+ sky130_fd_sc_hd__dfrtp_1
X_1512_ _0414_ _0656_ vssd1 vssd1 vccd1 vccd1 _0659_ sky130_fd_sc_hd__nor2_4
X_1374_ CALC_INST.gencon_inst.operand1\[13\] _0552_ _0491_ vssd1 vssd1 vccd1 vccd1
+ _0556_ sky130_fd_sc_hd__a21oi_1
XFILLER_4_96 vssd1 vssd1 vccd1 vccd1 sky130_fd_sc_hd__fill_1
X_1443_ _0606_ _0607_ vssd1 vssd1 vccd1 vccd1 _0077_ sky130_fd_sc_hd__and2_1
X_2828_ clknet_leaf_34_clk _0022_ net87 vssd1 vssd1 vccd1 vccd1 CALC_INST.input_ctrl_inst.debounce_cnt\[5\]
+ sky130_fd_sc_hd__dfrtp_1
X_2759_ clknet_leaf_27_clk _0318_ net112 vssd1 vssd1 vccd1 vccd1 CALC_INST.gencon_inst.mult_calc.countSave\[12\]
+ sky130_fd_sc_hd__dfrtp_1
XFILLER_64_24 vssd1 vssd1 vccd1 vccd1 sky130_fd_sc_hd__fill_4
XFILLER_58_199 vssd1 vssd1 vccd1 vccd1 sky130_fd_sc_hd__fill_4
XFILLER_58_100 vssd1 vssd1 vccd1 vccd1 sky130_fd_sc_hd__fill_2
Xfanout62 _0733_ vssd1 vssd1 vccd1 vccd1 net62 sky130_fd_sc_hd__buf_2
Xfanout73 net74 vssd1 vssd1 vccd1 vccd1 net73 sky130_fd_sc_hd__clkbuf_4
Xfanout40 net41 vssd1 vssd1 vccd1 vccd1 net40 sky130_fd_sc_hd__buf_2
Xfanout95 net96 vssd1 vssd1 vccd1 vccd1 net95 sky130_fd_sc_hd__buf_2
Xfanout84 net86 vssd1 vssd1 vccd1 vccd1 net84 sky130_fd_sc_hd__clkbuf_2
XFILLER_6_402 vssd1 vssd1 vccd1 vccd1 sky130_fd_sc_hd__fill_2
XFILLER_64_169 vssd1 vssd1 vccd1 vccd1 sky130_fd_sc_hd__fill_2
XFILLER_64_125 vccd1 vssd1 vccd1 vssd1 sky130_ef_sc_hd__decap_40_12
X_1992_ _0912_ _0941_ vssd1 vssd1 vccd1 vccd1 _0942_ sky130_fd_sc_hd__xnor2_1
Xclkload10 clknet_leaf_7_clk vssd1 vssd1 vccd1 vccd1 clkload10/Y sky130_fd_sc_hd__clkinv_2
XTAP_TAPCELL_ROW_15_242 vssd1 vccd1 sky130_fd_sc_hd__tapvpwrvgnd_1
X_2475_ clknet_leaf_14_clk _0034_ net99 vssd1 vssd1 vccd1 vccd1 CALC_INST.gencon_inst.operand2\[2\]
+ sky130_fd_sc_hd__dfrtp_1
X_2544_ clknet_leaf_21_clk _0103_ net117 vssd1 vssd1 vccd1 vccd1 net13 sky130_fd_sc_hd__dfrtp_1
X_2613_ clknet_leaf_25_clk _0172_ vssd1 vssd1 vccd1 vccd1 CALC_INST.gencon_inst.mult_calc.INn1\[13\]
+ sky130_fd_sc_hd__dfxtp_1
Xclkload21 clknet_leaf_29_clk vssd1 vssd1 vccd1 vccd1 clkload21/Y sky130_fd_sc_hd__clkinv_4
X_1357_ _0541_ _0542_ vssd1 vssd1 vccd1 vccd1 _0543_ sky130_fd_sc_hd__nor2_1
X_1288_ _0482_ _0483_ vssd1 vssd1 vccd1 vccd1 _0484_ sky130_fd_sc_hd__nor2_1
X_1426_ net51 _0596_ net478 vssd1 vssd1 vccd1 vccd1 _0598_ sky130_fd_sc_hd__a21oi_1
XFILLER_18_17 vssd1 vssd1 vccd1 vccd1 sky130_fd_sc_hd__fill_1
Xclkload4 clknet_leaf_4_clk vssd1 vssd1 vccd1 vccd1 clkload4/Y sky130_fd_sc_hd__clkinv_1
XTAP_TAPCELL_ROW_21_289 vssd1 vccd1 sky130_fd_sc_hd__tapvpwrvgnd_1
XFILLER_3_405 vssd1 vssd1 vccd1 vccd1 sky130_fd_sc_hd__fill_2
XFILLER_59_57 vssd1 vssd1 vccd1 vccd1 sky130_fd_sc_hd__fill_4
XANTENNA__1653__S net44 vssd1 vssd1 vccd1 vccd1 sky130_fd_sc_hd__diode_2
XTAP_TAPCELL_ROW_29_345 vssd1 vccd1 sky130_fd_sc_hd__tapvpwrvgnd_1
XFILLER_42_353 vssd1 vssd1 vccd1 vccd1 sky130_fd_sc_hd__fill_2
XFILLER_24_82 vssd1 vssd1 vccd1 vccd1 sky130_fd_sc_hd__fill_2
XTAP_TAPCELL_ROW_12_223 vssd1 vccd1 sky130_fd_sc_hd__tapvpwrvgnd_1
XANTENNA__1563__S net74 vssd1 vssd1 vccd1 vccd1 sky130_fd_sc_hd__diode_2
X_2191_ CALC_INST.input_ctrl_inst.RowSync\[2\] vssd1 vssd1 vccd1 vccd1 _1051_ sky130_fd_sc_hd__inv_2
X_2260_ _1092_ _1117_ vssd1 vssd1 vccd1 vccd1 _1118_ sky130_fd_sc_hd__or2_1
XFILLER_37_169 vssd1 vssd1 vccd1 vccd1 sky130_fd_sc_hd__fill_1
X_1975_ _0874_ _0878_ _0923_ _0875_ _0871_ vssd1 vssd1 vccd1 vccd1 _0926_ sky130_fd_sc_hd__o311a_1
XFILLER_20_29 vssd1 vssd1 vccd1 vccd1 sky130_fd_sc_hd__fill_2
Xhold38 _1046_ vssd1 vssd1 vccd1 vccd1 net237 sky130_fd_sc_hd__dlygate4sd3_1
Xhold16 _0157_ vssd1 vssd1 vccd1 vccd1 net215 sky130_fd_sc_hd__dlygate4sd3_1
Xhold27 CALC_INST.gencon_inst.prev_operator_input\[1\] vssd1 vssd1 vccd1 vccd1 net226
+ sky130_fd_sc_hd__dlygate4sd3_1
X_2458_ CALC_INST.gencon_inst.mult_calc.out\[0\] net49 _0426_ _0428_ vssd1 vssd1 vccd1
+ vccd1 _0429_ sky130_fd_sc_hd__a22o_1
XANTENNA__2866__Q CALC_INST.gencon_inst.mult_calc.start vssd1 vssd1 vccd1 vccd1 sky130_fd_sc_hd__diode_2
X_2527_ clknet_leaf_0_clk _0086_ net82 vssd1 vssd1 vccd1 vccd1 CALC_INST.input_ctrl_inst.col_index\[24\]
+ sky130_fd_sc_hd__dfrtp_1
X_1409_ _1061_ _0413_ vssd1 vssd1 vccd1 vccd1 _0586_ sky130_fd_sc_hd__nor2_1
Xhold49 CALC_INST.gencon_inst.ALU_in1\[0\] vssd1 vssd1 vccd1 vccd1 net248 sky130_fd_sc_hd__dlygate4sd3_1
XFILLER_28_136 vssd1 vssd1 vccd1 vccd1 sky130_fd_sc_hd__fill_2
X_2389_ _1086_ _1167_ _1050_ vssd1 vssd1 vccd1 vccd1 _1219_ sky130_fd_sc_hd__a21o_1
XFILLER_16_309 vssd1 vssd1 vccd1 vccd1 sky130_fd_sc_hd__fill_4
XFILLER_51_183 vssd1 vssd1 vccd1 vccd1 sky130_fd_sc_hd__fill_2
XTAP_TAPCELL_ROW_34_381 vssd1 vccd1 sky130_fd_sc_hd__tapvpwrvgnd_1
XFILLER_3_279 vssd1 vssd1 vccd1 vccd1 sky130_fd_sc_hd__fill_1
X_1691_ net371 _0745_ net153 vssd1 vssd1 vccd1 vccd1 _0187_ sky130_fd_sc_hd__mux2_1
XFILLER_51_80 vssd1 vssd1 vccd1 vccd1 sky130_fd_sc_hd__fill_2
XFILLER_30_356 vssd1 vssd1 vccd1 vccd1 sky130_fd_sc_hd__fill_4
X_1760_ net473 net129 _0787_ net141 vssd1 vssd1 vccd1 vccd1 _0214_ sky130_fd_sc_hd__a22o_1
X_2312_ CALC_INST.input_ctrl_inst.col_index\[3\] CALC_INST.input_ctrl_inst.col_index\[2\]
+ vssd1 vssd1 vccd1 vccd1 _1160_ sky130_fd_sc_hd__nand2_1
X_2174_ CALC_INST.input_ctrl_inst.scan_timer\[13\] CALC_INST.input_ctrl_inst.scan_timer\[14\]
+ _1038_ vssd1 vssd1 vccd1 vccd1 _1041_ sky130_fd_sc_hd__and3_1
XTAP_TAPCELL_ROW_48_473 vssd1 vccd1 sky130_fd_sc_hd__tapvpwrvgnd_1
X_2243_ CALC_INST.gencon_inst.mult_calc.count.GENERATE_ADDER\[1\].thingy.in1 CALC_INST.gencon_inst.mult_calc.count.GENERATE_ADDER\[1\].thingy.cIn
+ vssd1 vssd1 vccd1 vccd1 _1101_ sky130_fd_sc_hd__xnor2_1
XFILLER_40_109 vssd1 vssd1 vccd1 vccd1 sky130_fd_sc_hd__fill_1
XFILLER_21_367 vssd1 vssd1 vccd1 vccd1 sky130_fd_sc_hd__fill_2
X_1958_ CALC_INST.gencon_inst.add_calc.main.GENERATE_ADDER\[1\].thingy.in1 _0908_
+ vssd1 vssd1 vccd1 vccd1 _0909_ sky130_fd_sc_hd__nor2_1
Xoutput17 net17 vssd1 vssd1 vccd1 vccd1 gpio_out[20] sky130_fd_sc_hd__buf_2
X_1889_ CALC_INST.gencon_inst.mult_calc.out\[3\] net447 net143 vssd1 vssd1 vccd1 vccd1
+ _0276_ sky130_fd_sc_hd__mux2_1
Xoutput28 net28 vssd1 vssd1 vccd1 vccd1 gpio_out[6] sky130_fd_sc_hd__buf_2
XFILLER_56_25 vssd1 vssd1 vccd1 vccd1 sky130_fd_sc_hd__fill_2
XFILLER_29_401 vssd1 vssd1 vccd1 vccd1 sky130_fd_sc_hd__fill_4
XFILLER_0_249 vssd1 vssd1 vccd1 vccd1 sky130_fd_sc_hd__fill_2
XFILLER_16_117 vssd1 vssd1 vccd1 vccd1 sky130_fd_sc_hd__fill_1
XFILLER_12_334 vssd1 vssd1 vccd1 vccd1 sky130_fd_sc_hd__fill_2
XFILLER_47_242 vssd1 vssd1 vccd1 vccd1 sky130_fd_sc_hd__fill_2
X_2861_ clknet_leaf_9_clk _0376_ vssd1 vssd1 vccd1 vccd1 CALC_INST.input_ctrl_inst.scan_timer\[15\]
+ sky130_fd_sc_hd__dfxtp_1
XTAP_TAPCELL_ROW_45_454 vssd1 vccd1 sky130_fd_sc_hd__tapvpwrvgnd_1
XFILLER_15_194 vssd1 vssd1 vccd1 vccd1 sky130_fd_sc_hd__fill_4
XANTENNA__2006__B2 net126 vssd1 vssd1 vccd1 vccd1 sky130_fd_sc_hd__diode_2
X_1674_ CALC_INST.gencon_inst.ALU_in2\[3\] CALC_INST.gencon_inst.ALU_in1\[3\] net59
+ vssd1 vssd1 vccd1 vccd1 _0737_ sky130_fd_sc_hd__mux2_1
X_1743_ CALC_INST.gencon_inst.ALU_in1\[15\] net396 _0774_ vssd1 vssd1 vccd1 vccd1
+ _0210_ sky130_fd_sc_hd__mux2_1
Xhold305 CALC_INST.input_ctrl_inst.read_input_flag vssd1 vssd1 vccd1 vccd1 net504
+ sky130_fd_sc_hd__dlygate4sd3_1
X_2792_ clknet_leaf_33_clk net282 net88 vssd1 vssd1 vccd1 vccd1 CALC_INST.gencon_inst.mult_calc.count.GENERATE_ADDER\[1\].thingy.in1
+ sky130_fd_sc_hd__dfrtp_2
XFILLER_7_30 vccd1 vssd1 vccd1 vssd1 sky130_ef_sc_hd__decap_40_12
XFILLER_7_393 vssd1 vssd1 vccd1 vccd1 sky130_fd_sc_hd__fill_8
X_1812_ _0830_ _0831_ vssd1 vssd1 vccd1 vccd1 _0832_ sky130_fd_sc_hd__and2b_1
XANTENNA__1604__X _0724_ vssd1 vssd1 vccd1 vccd1 sky130_fd_sc_hd__diode_2
XANTENNA__1517__A0 CALC_INST.gencon_inst.operand2\[1\] vssd1 vssd1 vccd1 vccd1 sky130_fd_sc_hd__diode_2
X_2226_ CALC_INST.input_ctrl_inst.input_control_state\[0\] CALC_INST.input_ctrl_inst.input_control_state\[3\]
+ CALC_INST.input_ctrl_inst.input_control_state\[2\] CALC_INST.input_ctrl_inst.input_control_state\[1\]
+ vssd1 vssd1 vccd1 vccd1 _1085_ sky130_fd_sc_hd__or4b_2
X_2157_ net460 _1029_ vssd1 vssd1 vccd1 vccd1 _0368_ sky130_fd_sc_hd__xor2_1
XFILLER_38_242 vssd1 vssd1 vccd1 vccd1 sky130_fd_sc_hd__fill_8
X_2088_ net406 _0728_ net35 CALC_INST.gencon_inst.operand2\[6\] vssd1 vssd1 vccd1
+ vccd1 _0327_ sky130_fd_sc_hd__a22o_1
XFILLER_42_27 vssd1 vssd1 vccd1 vccd1 sky130_fd_sc_hd__fill_1
XANTENNA__1661__S _0727_ vssd1 vssd1 vccd1 vccd1 sky130_fd_sc_hd__diode_2
XTAP_TAPCELL_ROW_42_435 vssd1 vccd1 sky130_fd_sc_hd__tapvpwrvgnd_1
XANTENNA_fanout42_X net42 vssd1 vssd1 vccd1 vccd1 sky130_fd_sc_hd__diode_2
XFILLER_16_83 vssd1 vssd1 vccd1 vccd1 sky130_fd_sc_hd__fill_1
XTAP_TAPCELL_ROW_50_490 vssd1 vccd1 sky130_fd_sc_hd__tapvpwrvgnd_1
XFILLER_4_330 vssd1 vssd1 vccd1 vccd1 sky130_fd_sc_hd__fill_1
XFILLER_12_197 vssd1 vssd1 vccd1 vccd1 sky130_fd_sc_hd__fill_4
XTAP_TAPCELL_ROW_7_190 vssd1 vccd1 sky130_fd_sc_hd__tapvpwrvgnd_1
X_1390_ net53 vssd1 vssd1 vccd1 vccd1 _0570_ sky130_fd_sc_hd__inv_2
X_2011_ net479 _0957_ net154 vssd1 vssd1 vccd1 vccd1 _0295_ sky130_fd_sc_hd__mux2_1
X_2844_ clknet_leaf_6_clk _0029_ net94 vssd1 vssd1 vccd1 vccd1 CALC_INST.input_ctrl_inst.decoded_key\[2\]
+ sky130_fd_sc_hd__dfstp_2
Xhold168 CALC_INST.gencon_inst.add_calc.main.GENERATE_ADDER\[3\].thingy.in1 vssd1
+ vssd1 vccd1 vccd1 net367 sky130_fd_sc_hd__dlygate4sd3_1
Xhold135 CALC_INST.gencon_inst.add_calc.state\[0\] vssd1 vssd1 vccd1 vccd1 net334
+ sky130_fd_sc_hd__dlygate4sd3_1
Xhold113 CALC_INST.input_ctrl_inst.scan_timer\[11\] vssd1 vssd1 vccd1 vccd1 net312
+ sky130_fd_sc_hd__dlygate4sd3_1
Xhold102 CALC_INST.gencon_inst.ALU_in2\[12\] vssd1 vssd1 vccd1 vccd1 net301 sky130_fd_sc_hd__dlygate4sd3_1
X_1726_ CALC_INST.gencon_inst.ALU_in1\[14\] CALC_INST.gencon_inst.ALU_in2\[14\] net60
+ vssd1 vssd1 vccd1 vccd1 _0763_ sky130_fd_sc_hd__mux2_1
X_1588_ CALC_INST.gencon_inst.operator_input\[2\] CALC_INST.gencon_inst.operator_input\[1\]
+ CALC_INST.gencon_inst.operator_input\[0\] _0656_ _0716_ vssd1 vssd1 vccd1 vccd1
+ _0717_ sky130_fd_sc_hd__o311a_1
X_1657_ net278 _0690_ net44 vssd1 vssd1 vccd1 vccd1 _0169_ sky130_fd_sc_hd__mux2_1
X_2775_ clknet_leaf_23_clk _0325_ vssd1 vssd1 vccd1 vccd1 CALC_INST.gencon_inst.mult_calc.INn2\[4\]
+ sky130_fd_sc_hd__dfxtp_1
Xhold146 CALC_INST.gencon_inst.mult_calc.INn2\[1\] vssd1 vssd1 vccd1 vccd1 net345
+ sky130_fd_sc_hd__dlygate4sd3_1
Xhold179 CALC_INST.input_ctrl_inst.debounce_cnt\[16\] vssd1 vssd1 vccd1 vccd1 net378
+ sky130_fd_sc_hd__dlygate4sd3_1
Xhold124 CALC_INST.gencon_inst.mult_calc.count.GENERATE_ADDER\[6\].thingy.in1 vssd1
+ vssd1 vccd1 vccd1 net323 sky130_fd_sc_hd__dlygate4sd3_1
Xhold157 _0235_ vssd1 vssd1 vccd1 vccd1 net356 sky130_fd_sc_hd__dlygate4sd3_1
X_2209_ CALC_INST.input_ctrl_inst.input_control_state\[1\] CALC_INST.input_ctrl_inst.input_control_state\[3\]
+ CALC_INST.input_ctrl_inst.input_control_state\[2\] CALC_INST.input_ctrl_inst.input_control_state\[0\]
+ vssd1 vssd1 vccd1 vccd1 _1069_ sky130_fd_sc_hd__and4bb_1
XTAP_TAPCELL_ROW_64_593 vssd1 vccd1 sky130_fd_sc_hd__tapvpwrvgnd_1
XFILLER_41_259 vssd1 vssd1 vccd1 vccd1 sky130_fd_sc_hd__fill_8
XANTENNA__1656__S net44 vssd1 vssd1 vccd1 vccd1 sky130_fd_sc_hd__diode_2
XFILLER_1_333 vssd1 vssd1 vccd1 vccd1 sky130_fd_sc_hd__fill_2
Xclkbuf_2_0__f_clk clknet_0_clk vssd1 vssd1 vccd1 vccd1 clknet_2_0__leaf_clk sky130_fd_sc_hd__clkbuf_16
XTAP_TAPCELL_ROW_4_171 vssd1 vccd1 sky130_fd_sc_hd__tapvpwrvgnd_1
XFILLER_17_245 vssd1 vssd1 vccd1 vccd1 sky130_fd_sc_hd__fill_4
X_1511_ _0655_ _0657_ vssd1 vssd1 vccd1 vccd1 _0658_ sky130_fd_sc_hd__or2_1
X_2560_ clknet_leaf_7_clk _0119_ net95 vssd1 vssd1 vccd1 vccd1 CALC_INST.gencon_inst.latched_operator_input\[1\]
+ sky130_fd_sc_hd__dfrtp_1
X_2491_ clknet_leaf_14_clk _0050_ net113 vssd1 vssd1 vccd1 vccd1 CALC_INST.gencon_inst.operand1\[3\]
+ sky130_fd_sc_hd__dfrtp_1
X_1442_ _0385_ _0597_ vssd1 vssd1 vccd1 vccd1 _0607_ sky130_fd_sc_hd__or2_1
X_1373_ CALC_INST.gencon_inst.operand1\[12\] net48 _0554_ _0555_ vssd1 vssd1 vccd1
+ vccd1 _0059_ sky130_fd_sc_hd__o22a_1
XTAP_TAPCELL_ROW_53_508 vssd1 vccd1 sky130_fd_sc_hd__tapvpwrvgnd_1
X_2758_ clknet_leaf_27_clk _0317_ net107 vssd1 vssd1 vccd1 vccd1 CALC_INST.gencon_inst.mult_calc.countSave\[11\]
+ sky130_fd_sc_hd__dfrtp_1
X_2827_ clknet_leaf_34_clk _0021_ net87 vssd1 vssd1 vccd1 vccd1 CALC_INST.input_ctrl_inst.debounce_cnt\[4\]
+ sky130_fd_sc_hd__dfrtp_1
XANTENNA_fanout137_A CALC_INST.gencon_inst.mult_calc.state\[3\] vssd1 vssd1 vccd1
+ vccd1 sky130_fd_sc_hd__diode_2
X_1709_ net417 _0754_ net151 vssd1 vssd1 vccd1 vccd1 _0196_ sky130_fd_sc_hd__mux2_1
X_2689_ clknet_leaf_23_clk _0248_ net105 vssd1 vssd1 vccd1 vccd1 CALC_INST.gencon_inst.mult_calc.main.GENERATE_ADDER\[6\].thingy.in1
+ sky130_fd_sc_hd__dfrtp_1
XPHY_EDGE_ROW_18_Left_83 vssd1 vssd1 vccd1 vccd1 sky130_fd_sc_hd__decap_3
XFILLER_46_307 vssd1 vssd1 vccd1 vccd1 sky130_fd_sc_hd__fill_1
XPHY_EDGE_ROW_54_Left_119 vssd1 vssd1 vccd1 vccd1 sky130_fd_sc_hd__decap_3
Xfanout63 _0724_ vssd1 vssd1 vccd1 vccd1 net63 sky130_fd_sc_hd__clkbuf_4
Xfanout96 net100 vssd1 vssd1 vccd1 vccd1 net96 sky130_fd_sc_hd__clkbuf_2
Xfanout74 _0646_ vssd1 vssd1 vccd1 vccd1 net74 sky130_fd_sc_hd__clkbuf_4
Xfanout85 net86 vssd1 vssd1 vccd1 vccd1 net85 sky130_fd_sc_hd__clkbuf_4
Xfanout41 _1169_ vssd1 vssd1 vccd1 vccd1 net41 sky130_fd_sc_hd__clkbuf_2
Xfanout52 net53 vssd1 vssd1 vccd1 vccd1 net52 sky130_fd_sc_hd__buf_2
XPHY_EDGE_ROW_63_Left_128 vssd1 vssd1 vccd1 vccd1 sky130_fd_sc_hd__decap_3
XFILLER_38_70 vccd1 vssd1 vccd1 vssd1 sky130_ef_sc_hd__decap_40_12
XFILLER_64_137 vssd1 vssd1 vccd1 vccd1 sky130_fd_sc_hd__fill_2
XFILLER_60_365 vssd1 vssd1 vccd1 vccd1 sky130_fd_sc_hd__fill_1
XFILLER_45_351 vssd1 vssd1 vccd1 vccd1 sky130_fd_sc_hd__fill_1
XTAP_TAPCELL_ROW_15_243 vssd1 vccd1 sky130_fd_sc_hd__tapvpwrvgnd_1
X_1991_ _0906_ _0907_ vssd1 vssd1 vccd1 vccd1 _0941_ sky130_fd_sc_hd__nand2b_1
Xclkload11 clknet_leaf_8_clk vssd1 vssd1 vccd1 vccd1 clkload11/Y sky130_fd_sc_hd__inv_6
X_2612_ clknet_leaf_25_clk _0171_ vssd1 vssd1 vccd1 vccd1 CALC_INST.gencon_inst.mult_calc.INn1\[12\]
+ sky130_fd_sc_hd__dfxtp_1
XFILLER_9_263 vssd1 vssd1 vccd1 vccd1 sky130_fd_sc_hd__fill_1
Xclkload22 clknet_leaf_30_clk vssd1 vssd1 vccd1 vccd1 clkload22/Y sky130_fd_sc_hd__inv_8
X_2543_ clknet_leaf_21_clk _0102_ net117 vssd1 vssd1 vccd1 vccd1 net12 sky130_fd_sc_hd__dfrtp_1
X_2474_ clknet_leaf_4_clk _0033_ net92 vssd1 vssd1 vccd1 vccd1 CALC_INST.gencon_inst.operand2\[1\]
+ sky130_fd_sc_hd__dfrtp_2
X_1425_ net410 _0592_ _0597_ vssd1 vssd1 vccd1 vccd1 _0069_ sky130_fd_sc_hd__o21a_1
XFILLER_55_159 vssd1 vssd1 vccd1 vccd1 sky130_fd_sc_hd__fill_1
X_1356_ CALC_INST.gencon_inst.operand1\[9\] _0537_ _0490_ vssd1 vssd1 vccd1 vccd1
+ _0542_ sky130_fd_sc_hd__o21ai_1
X_1287_ CALC_INST.gencon_inst.operand2\[13\] _0476_ CALC_INST.gencon_inst.operand2\[14\]
+ vssd1 vssd1 vccd1 vccd1 _0483_ sky130_fd_sc_hd__a21oi_1
Xclkload5 clknet_leaf_33_clk vssd1 vssd1 vccd1 vccd1 clkload5/Y sky130_fd_sc_hd__clkinv_4
XFILLER_11_207 vssd1 vssd1 vccd1 vccd1 sky130_fd_sc_hd__fill_2
XFILLER_59_69 vccd1 vssd1 vccd1 vssd1 sky130_ef_sc_hd__decap_40_12
XANTENNA__1332__B2 net45 vssd1 vssd1 vccd1 vccd1 sky130_fd_sc_hd__diode_2
XPHY_EDGE_ROW_3_Left_68 vssd1 vssd1 vccd1 vccd1 sky130_fd_sc_hd__decap_3
XFILLER_42_343 vssd1 vssd1 vccd1 vccd1 sky130_fd_sc_hd__fill_2
XTAP_TAPCELL_ROW_29_346 vssd1 vccd1 sky130_fd_sc_hd__tapvpwrvgnd_1
XFILLER_27_373 vssd1 vssd1 vccd1 vccd1 sky130_fd_sc_hd__fill_2
XFILLER_24_50 vssd1 vssd1 vccd1 vccd1 sky130_fd_sc_hd__fill_1
XFILLER_6_233 vssd1 vssd1 vccd1 vccd1 sky130_fd_sc_hd__fill_1
XTAP_TAPCELL_ROW_12_224 vssd1 vccd1 sky130_fd_sc_hd__tapvpwrvgnd_1
XANTENNA__1844__S net137 vssd1 vssd1 vccd1 vccd1 sky130_fd_sc_hd__diode_2
XFILLER_37_115 vssd1 vssd1 vccd1 vccd1 sky130_fd_sc_hd__fill_1
X_2190_ CALC_INST.input_ctrl_inst.debounce_cnt\[17\] vssd1 vssd1 vccd1 vccd1 _1050_
+ sky130_fd_sc_hd__inv_2
X_1974_ _0874_ _0878_ _0923_ _0875_ vssd1 vssd1 vccd1 vccd1 _0925_ sky130_fd_sc_hd__o31a_1
XFILLER_60_195 vssd1 vssd1 vccd1 vccd1 sky130_fd_sc_hd__fill_1
XFILLER_56_402 vssd1 vssd1 vccd1 vccd1 sky130_fd_sc_hd__fill_4
Xhold28 _0156_ vssd1 vssd1 vccd1 vccd1 net227 sky130_fd_sc_hd__dlygate4sd3_1
XANTENNA__1562__B2 _0656_ vssd1 vssd1 vccd1 vccd1 sky130_fd_sc_hd__diode_2
X_2457_ net54 _0427_ _0422_ vssd1 vssd1 vccd1 vccd1 _0428_ sky130_fd_sc_hd__a21o_1
Xhold17 CALC_INST.gencon_inst.mult_calc.INn1\[3\] vssd1 vssd1 vccd1 vccd1 net216 sky130_fd_sc_hd__dlygate4sd3_1
Xhold39 CALC_INST.gencon_inst.mult_calc.main.GENERATE_ADDER\[14\].thingy.in1 vssd1
+ vssd1 vccd1 vccd1 net238 sky130_fd_sc_hd__dlygate4sd3_1
X_2388_ _1216_ _1217_ vssd1 vssd1 vccd1 vccd1 _1218_ sky130_fd_sc_hd__or2_1
X_2526_ clknet_leaf_0_clk _0085_ net81 vssd1 vssd1 vccd1 vccd1 CALC_INST.input_ctrl_inst.col_index\[23\]
+ sky130_fd_sc_hd__dfrtp_1
X_1408_ _1061_ _0413_ net53 _0583_ vssd1 vssd1 vccd1 vccd1 _0064_ sky130_fd_sc_hd__o31a_1
X_1339_ CALC_INST.gencon_inst.operand1\[5\] net47 _0525_ _0527_ vssd1 vssd1 vccd1
+ vccd1 _0052_ sky130_fd_sc_hd__o22a_1
XFILLER_51_151 vssd1 vssd1 vccd1 vccd1 sky130_fd_sc_hd__fill_1
XFILLER_3_225 vssd1 vssd1 vccd1 vccd1 sky130_fd_sc_hd__fill_4
XFILLER_19_126 vssd1 vssd1 vccd1 vccd1 sky130_fd_sc_hd__fill_4
XFILLER_19_159 vssd1 vssd1 vccd1 vccd1 sky130_fd_sc_hd__fill_1
XFILLER_42_195 vssd1 vssd1 vccd1 vccd1 sky130_fd_sc_hd__fill_1
XANTENNA__1839__S net137 vssd1 vssd1 vccd1 vccd1 sky130_fd_sc_hd__diode_2
X_1690_ CALC_INST.gencon_inst.ALU_in2\[11\] CALC_INST.gencon_inst.ALU_in1\[11\] net60
+ vssd1 vssd1 vccd1 vccd1 _0745_ sky130_fd_sc_hd__mux2_1
X_2311_ CALC_INST.input_ctrl_inst.col_index\[3\] CALC_INST.input_ctrl_inst.col_index\[2\]
+ vssd1 vssd1 vccd1 vccd1 _1159_ sky130_fd_sc_hd__or2_1
X_2242_ CALC_INST.gencon_inst.mult_calc.count.GENERATE_ADDER\[1\].thingy.in1 CALC_INST.gencon_inst.mult_calc.compCount.in2\[1\]
+ CALC_INST.gencon_inst.mult_calc.compCount.in2\[0\] CALC_INST.gencon_inst.mult_calc.count.GENERATE_ADDER\[1\].thingy.cIn
+ vssd1 vssd1 vccd1 vccd1 _1100_ sky130_fd_sc_hd__o211a_1
X_2173_ CALC_INST.input_ctrl_inst.scan_timer\[13\] CALC_INST.input_ctrl_inst.scan_timer\[12\]
+ _1036_ CALC_INST.input_ctrl_inst.scan_timer\[14\] vssd1 vssd1 vccd1 vccd1 _1040_
+ sky130_fd_sc_hd__a31o_1
XTAP_TAPCELL_ROW_48_474 vssd1 vccd1 sky130_fd_sc_hd__tapvpwrvgnd_1
X_1957_ CALC_INST.gencon_inst.add_calc.main.in2\[1\] net145 vssd1 vssd1 vccd1 vccd1
+ _0908_ sky130_fd_sc_hd__xor2_1
XFILLER_21_324 vssd1 vssd1 vccd1 vccd1 sky130_fd_sc_hd__fill_4
Xoutput18 net18 vssd1 vssd1 vccd1 vccd1 gpio_out[21] sky130_fd_sc_hd__buf_2
X_1888_ CALC_INST.gencon_inst.mult_calc.out\[2\] net473 net143 vssd1 vssd1 vccd1 vccd1
+ _0275_ sky130_fd_sc_hd__mux2_1
Xoutput29 net29 vssd1 vssd1 vccd1 vccd1 gpio_out[7] sky130_fd_sc_hd__buf_2
X_2509_ clknet_leaf_3_clk _0068_ net85 vssd1 vssd1 vccd1 vccd1 CALC_INST.input_ctrl_inst.col_index\[6\]
+ sky130_fd_sc_hd__dfrtp_1
XFILLER_56_265 vssd1 vssd1 vccd1 vccd1 sky130_fd_sc_hd__fill_1
XANTENNA__1513__A _0415_ vssd1 vssd1 vccd1 vccd1 sky130_fd_sc_hd__diode_2
XFILLER_56_298 vssd1 vssd1 vccd1 vccd1 sky130_fd_sc_hd__fill_1
XANTENNA__1659__S net44 vssd1 vssd1 vccd1 vccd1 sky130_fd_sc_hd__diode_2
XFILLER_24_195 vssd1 vssd1 vccd1 vccd1 sky130_fd_sc_hd__fill_1
XANTENNA__1774__B2 net141 vssd1 vssd1 vccd1 vccd1 sky130_fd_sc_hd__diode_2
XFILLER_8_317 vssd1 vssd1 vccd1 vccd1 sky130_fd_sc_hd__fill_4
XPHY_EDGE_ROW_6_Left_71 vssd1 vssd1 vccd1 vccd1 sky130_fd_sc_hd__decap_3
Xclkbuf_leaf_27_clk clknet_2_2__leaf_clk vssd1 vssd1 vccd1 vccd1 clknet_leaf_27_clk
+ sky130_fd_sc_hd__clkbuf_8
X_2860_ clknet_leaf_9_clk _0375_ vssd1 vssd1 vccd1 vccd1 CALC_INST.input_ctrl_inst.scan_timer\[14\]
+ sky130_fd_sc_hd__dfxtp_1
XTAP_TAPCELL_ROW_45_455 vssd1 vccd1 sky130_fd_sc_hd__tapvpwrvgnd_1
XFILLER_30_187 vssd1 vssd1 vccd1 vccd1 sky130_fd_sc_hd__fill_1
X_2791_ clknet_leaf_29_clk _0337_ net88 vssd1 vssd1 vccd1 vccd1 CALC_INST.gencon_inst.mult_calc.count.GENERATE_ADDER\[1\].thingy.cIn
+ sky130_fd_sc_hd__dfrtp_2
XFILLER_15_140 vssd1 vssd1 vccd1 vccd1 sky130_fd_sc_hd__fill_1
XFILLER_15_162 vssd1 vssd1 vccd1 vccd1 sky130_fd_sc_hd__fill_1
XFILLER_15_173 vssd1 vssd1 vccd1 vccd1 sky130_fd_sc_hd__fill_1
X_1811_ CALC_INST.gencon_inst.mult_calc.main.GENERATE_ADDER\[10\].thingy.in2 CALC_INST.gencon_inst.mult_calc.main.GENERATE_ADDER\[10\].thingy.in1
+ vssd1 vssd1 vccd1 vccd1 _0831_ sky130_fd_sc_hd__nand2_1
X_1673_ net401 _0736_ net150 vssd1 vssd1 vccd1 vccd1 _0178_ sky130_fd_sc_hd__mux2_1
X_1742_ _0732_ net150 vssd1 vssd1 vccd1 vccd1 _0774_ sky130_fd_sc_hd__nand2b_1
XFILLER_7_42 vssd1 vssd1 vccd1 vccd1 sky130_fd_sc_hd__fill_2
XFILLER_11_390 vssd1 vssd1 vccd1 vccd1 sky130_fd_sc_hd__fill_2
X_2225_ _1075_ _1079_ _1081_ _1083_ vssd1 vssd1 vccd1 vccd1 _1084_ sky130_fd_sc_hd__or4b_1
Xclkbuf_leaf_18_clk clknet_2_3__leaf_clk vssd1 vssd1 vccd1 vccd1 clknet_leaf_18_clk
+ sky130_fd_sc_hd__clkbuf_8
XFILLER_53_235 vssd1 vssd1 vccd1 vccd1 sky130_fd_sc_hd__fill_2
XFILLER_53_202 vssd1 vssd1 vccd1 vccd1 sky130_fd_sc_hd__fill_1
X_2156_ _1022_ _1028_ _1030_ vssd1 vssd1 vccd1 vccd1 _0367_ sky130_fd_sc_hd__and3_1
X_2087_ net443 _0728_ net35 CALC_INST.gencon_inst.operand2\[5\] vssd1 vssd1 vccd1
+ vccd1 _0326_ sky130_fd_sc_hd__a22o_1
XPHY_EDGE_ROW_5_Right_5 vssd1 vssd1 vccd1 vccd1 sky130_fd_sc_hd__decap_3
XFILLER_21_143 vssd1 vssd1 vccd1 vccd1 sky130_fd_sc_hd__fill_2
XFILLER_21_132 vssd1 vssd1 vccd1 vccd1 sky130_fd_sc_hd__fill_2
XANTENNA_fanout122_X net122 vssd1 vssd1 vccd1 vccd1 sky130_fd_sc_hd__diode_2
XFILLER_44_224 vssd1 vssd1 vccd1 vccd1 sky130_fd_sc_hd__fill_2
XTAP_TAPCELL_ROW_42_436 vssd1 vccd1 sky130_fd_sc_hd__tapvpwrvgnd_1
XPHY_EDGE_ROW_32_Left_97 vssd1 vssd1 vccd1 vccd1 sky130_fd_sc_hd__decap_3
XFILLER_12_187 vssd1 vssd1 vccd1 vccd1 sky130_fd_sc_hd__fill_1
XTAP_TAPCELL_ROW_50_491 vssd1 vccd1 sky130_fd_sc_hd__tapvpwrvgnd_1
XFILLER_32_83 vssd1 vssd1 vccd1 vccd1 sky130_fd_sc_hd__fill_1
XFILLER_32_50 vccd1 vssd1 vccd1 vssd1 sky130_ef_sc_hd__decap_40_12
XFILLER_4_320 vssd1 vssd1 vccd1 vccd1 sky130_fd_sc_hd__fill_2
X_2010_ _0954_ _0956_ vssd1 vssd1 vccd1 vccd1 _0957_ sky130_fd_sc_hd__xnor2_1
XTAP_TAPCELL_ROW_7_191 vssd1 vccd1 sky130_fd_sc_hd__tapvpwrvgnd_1
X_2912_ CALC_INST.complete vssd1 vssd1 vccd1 vccd1 net25 sky130_fd_sc_hd__buf_1
X_1725_ net340 _0762_ net153 vssd1 vssd1 vccd1 vccd1 _0204_ sky130_fd_sc_hd__mux2_1
X_2843_ clknet_leaf_6_clk _0028_ net94 vssd1 vssd1 vccd1 vccd1 CALC_INST.input_ctrl_inst.decoded_key\[1\]
+ sky130_fd_sc_hd__dfstp_1
X_2774_ clknet_leaf_31_clk net387 vssd1 vssd1 vccd1 vccd1 CALC_INST.gencon_inst.mult_calc.INn2\[3\]
+ sky130_fd_sc_hd__dfxtp_1
Xhold125 CALC_INST.gencon_inst.ALU_in2\[11\] vssd1 vssd1 vccd1 vccd1 net324 sky130_fd_sc_hd__dlygate4sd3_1
Xhold136 CALC_INST.gencon_inst.ALU_in1\[10\] vssd1 vssd1 vccd1 vccd1 net335 sky130_fd_sc_hd__dlygate4sd3_1
Xhold169 CALC_INST.gencon_inst.latched_operator_input\[0\] vssd1 vssd1 vccd1 vccd1
+ net368 sky130_fd_sc_hd__dlygate4sd3_1
Xclkbuf_leaf_7_clk clknet_2_1__leaf_clk vssd1 vssd1 vccd1 vccd1 clknet_leaf_7_clk
+ sky130_fd_sc_hd__clkbuf_8
X_1587_ CALC_INST.gencon_inst.prev_operator_input\[1\] CALC_INST.gencon_inst.prev_operator_input\[0\]
+ CALC_INST.gencon_inst.prev_operator_input\[2\] vssd1 vssd1 vccd1 vccd1 _0716_ sky130_fd_sc_hd__nor3_1
Xhold158 CALC_INST.complete vssd1 vssd1 vccd1 vccd1 net357 sky130_fd_sc_hd__dlygate4sd3_1
Xhold147 _0322_ vssd1 vssd1 vccd1 vccd1 net346 sky130_fd_sc_hd__dlygate4sd3_1
X_1656_ net243 _0686_ net44 vssd1 vssd1 vccd1 vccd1 _0168_ sky130_fd_sc_hd__mux2_1
Xhold103 CALC_INST.gencon_inst.mult_calc.countSave\[12\] vssd1 vssd1 vccd1 vccd1 net302
+ sky130_fd_sc_hd__dlygate4sd3_1
Xhold114 CALC_INST.gencon_inst.mult_calc.count.GENERATE_ADDER\[13\].thingy.in1 vssd1
+ vssd1 vccd1 vccd1 net313 sky130_fd_sc_hd__dlygate4sd3_1
X_2139_ _1055_ CALC_INST.input_ctrl_inst.key_pressed _1080_ _1146_ vssd1 vssd1 vccd1
+ vccd1 _1020_ sky130_fd_sc_hd__nor4_1
XFILLER_26_246 vssd1 vssd1 vccd1 vccd1 sky130_fd_sc_hd__fill_4
X_2208_ CALC_INST.input_ctrl_inst.debounce_cnt\[14\] _1067_ _1064_ vssd1 vssd1 vccd1
+ vccd1 _1068_ sky130_fd_sc_hd__o21a_1
XTAP_TAPCELL_ROW_64_594 vssd1 vccd1 sky130_fd_sc_hd__tapvpwrvgnd_1
XANTENNA__1509__Y _0656_ vssd1 vssd1 vccd1 vccd1 sky130_fd_sc_hd__diode_2
XFILLER_5_106 vssd1 vssd1 vccd1 vccd1 sky130_fd_sc_hd__fill_1
XFILLER_1_389 vssd1 vssd1 vccd1 vccd1 sky130_fd_sc_hd__fill_2
XFILLER_17_279 vssd1 vssd1 vccd1 vccd1 sky130_fd_sc_hd__fill_1
XANTENNA__2090__B1 net34 vssd1 vssd1 vccd1 vccd1 sky130_fd_sc_hd__diode_2
XFILLER_57_6 vccd1 vssd1 vccd1 vssd1 sky130_ef_sc_hd__decap_40_12
X_1510_ CALC_INST.gencon_inst.operand2\[0\] CALC_INST.gencon_inst.operand1\[0\] net73
+ vssd1 vssd1 vccd1 vccd1 _0657_ sky130_fd_sc_hd__mux2_1
X_2490_ clknet_leaf_13_clk _0049_ net99 vssd1 vssd1 vccd1 vccd1 CALC_INST.gencon_inst.operand1\[2\]
+ sky130_fd_sc_hd__dfrtp_1
X_1441_ CALC_INST.input_ctrl_inst.col_index\[13\] CALC_INST.input_ctrl_inst.col_index\[14\]
+ _0603_ CALC_INST.input_ctrl_inst.col_index\[15\] vssd1 vssd1 vccd1 vccd1 _0606_
+ sky130_fd_sc_hd__a31o_1
XFILLER_48_360 vssd1 vssd1 vccd1 vccd1 sky130_fd_sc_hd__fill_4
X_1372_ CALC_INST.gencon_inst.ALU_out\[12\] net77 net70 CALC_INST.gencon_inst.mult_calc.out\[12\]
+ net46 vssd1 vssd1 vccd1 vccd1 _0555_ sky130_fd_sc_hd__a221o_1
XANTENNA__1353__C1 net45 vssd1 vssd1 vccd1 vccd1 sky130_fd_sc_hd__diode_2
XTAP_TAPCELL_ROW_61_564 vssd1 vccd1 sky130_fd_sc_hd__tapvpwrvgnd_1
XTAP_TAPCELL_ROW_53_509 vssd1 vccd1 sky130_fd_sc_hd__tapvpwrvgnd_1
XTAP_TAPCELL_ROW_18_263 vssd1 vccd1 sky130_fd_sc_hd__tapvpwrvgnd_1
X_1708_ CALC_INST.gencon_inst.ALU_in1\[5\] CALC_INST.gencon_inst.ALU_in2\[5\] net62
+ vssd1 vssd1 vccd1 vccd1 _0754_ sky130_fd_sc_hd__mux2_1
XFILLER_31_293 vssd1 vssd1 vccd1 vccd1 sky130_fd_sc_hd__fill_2
X_2688_ clknet_leaf_31_clk _0247_ net105 vssd1 vssd1 vccd1 vccd1 CALC_INST.gencon_inst.mult_calc.main.GENERATE_ADDER\[5\].thingy.in1
+ sky130_fd_sc_hd__dfrtp_1
X_2826_ clknet_leaf_34_clk _0020_ net87 vssd1 vssd1 vccd1 vccd1 CALC_INST.input_ctrl_inst.debounce_cnt\[3\]
+ sky130_fd_sc_hd__dfrtp_1
X_2757_ clknet_leaf_27_clk _0316_ net107 vssd1 vssd1 vccd1 vccd1 CALC_INST.gencon_inst.mult_calc.countSave\[10\]
+ sky130_fd_sc_hd__dfrtp_1
X_1639_ net226 _0722_ _0723_ CALC_INST.gencon_inst.operator_input\[1\] vssd1 vssd1
+ vccd1 vccd1 _0156_ sky130_fd_sc_hd__a22o_1
XANTENNA_input4_A gpio_in[2] vssd1 vssd1 vccd1 vccd1 sky130_fd_sc_hd__diode_2
XFILLER_64_48 vssd1 vssd1 vccd1 vccd1 sky130_fd_sc_hd__fill_4
XFILLER_64_37 vssd1 vssd1 vccd1 vccd1 sky130_fd_sc_hd__fill_2
XFILLER_54_363 vssd1 vssd1 vccd1 vccd1 sky130_fd_sc_hd__fill_1
XFILLER_54_341 vssd1 vssd1 vccd1 vccd1 sky130_fd_sc_hd__fill_1
Xfanout97 net98 vssd1 vssd1 vccd1 vccd1 net97 sky130_fd_sc_hd__clkbuf_4
Xfanout64 _0724_ vssd1 vssd1 vccd1 vccd1 net64 sky130_fd_sc_hd__clkbuf_2
Xfanout53 _0569_ vssd1 vssd1 vccd1 vccd1 net53 sky130_fd_sc_hd__clkbuf_2
Xfanout75 _0488_ vssd1 vssd1 vccd1 vccd1 net75 sky130_fd_sc_hd__buf_2
Xfanout42 _0728_ vssd1 vssd1 vccd1 vccd1 net42 sky130_fd_sc_hd__buf_2
Xfanout86 net93 vssd1 vssd1 vccd1 vccd1 net86 sky130_fd_sc_hd__dlymetal6s2s_1
XANTENNA__2072__B1 net130 vssd1 vssd1 vccd1 vccd1 sky130_fd_sc_hd__diode_2
XFILLER_13_30 vssd1 vssd1 vccd1 vccd1 sky130_fd_sc_hd__fill_2
XFILLER_13_41 vssd1 vssd1 vccd1 vccd1 sky130_fd_sc_hd__fill_8
XFILLER_64_149 vssd1 vssd1 vccd1 vccd1 sky130_fd_sc_hd__fill_2
XFILLER_38_82 vssd1 vssd1 vccd1 vccd1 sky130_fd_sc_hd__fill_2
XFILLER_37_308 vccd1 vssd1 vccd1 vssd1 sky130_ef_sc_hd__decap_40_12
XFILLER_1_175 vccd1 vssd1 vccd1 vssd1 sky130_ef_sc_hd__decap_40_12
XFILLER_60_322 vssd1 vssd1 vccd1 vccd1 sky130_fd_sc_hd__fill_2
X_1990_ net33 _0939_ vssd1 vssd1 vccd1 vccd1 _0940_ sky130_fd_sc_hd__nand2_1
XANTENNA__2063__B1 net126 vssd1 vssd1 vccd1 vccd1 sky130_fd_sc_hd__diode_2
XTAP_TAPCELL_ROW_15_244 vssd1 vccd1 sky130_fd_sc_hd__tapvpwrvgnd_1
Xclkload12 clknet_leaf_9_clk vssd1 vssd1 vccd1 vccd1 clkload12/Y sky130_fd_sc_hd__clkinv_4
XFILLER_55_3 vssd1 vssd1 vccd1 vccd1 sky130_fd_sc_hd__fill_1
X_2542_ clknet_leaf_14_clk _0101_ net113 vssd1 vssd1 vccd1 vccd1 net11 sky130_fd_sc_hd__dfrtp_1
X_2611_ clknet_leaf_25_clk _0170_ vssd1 vssd1 vccd1 vccd1 CALC_INST.gencon_inst.mult_calc.INn1\[11\]
+ sky130_fd_sc_hd__dfxtp_1
Xclkload23 clknet_leaf_31_clk vssd1 vssd1 vccd1 vccd1 clkload23/Y sky130_fd_sc_hd__inv_6
X_1355_ CALC_INST.gencon_inst.operand1\[7\] CALC_INST.gencon_inst.operand1\[8\] CALC_INST.gencon_inst.operand1\[9\]
+ _0529_ vssd1 vssd1 vccd1 vccd1 _0541_ sky130_fd_sc_hd__and4_1
X_2473_ clknet_leaf_4_clk _0032_ net92 vssd1 vssd1 vccd1 vccd1 CALC_INST.gencon_inst.operand2\[0\]
+ sky130_fd_sc_hd__dfrtp_2
X_1424_ net51 _0596_ vssd1 vssd1 vccd1 vccd1 _0597_ sky130_fd_sc_hd__nand2_1
XANTENNA__1341__A _0491_ vssd1 vssd1 vccd1 vccd1 sky130_fd_sc_hd__diode_2
XFILLER_36_363 vssd1 vssd1 vccd1 vccd1 sky130_fd_sc_hd__fill_1
X_1286_ CALC_INST.gencon_inst.operand2\[14\] CALC_INST.gencon_inst.operand2\[13\]
+ _0476_ vssd1 vssd1 vccd1 vccd1 _0482_ sky130_fd_sc_hd__and3_1
Xclkload6 clknet_leaf_34_clk vssd1 vssd1 vccd1 vccd1 clkload6/X sky130_fd_sc_hd__clkbuf_4
XANTENNA__1565__C1 _0415_ vssd1 vssd1 vccd1 vccd1 sky130_fd_sc_hd__diode_2
X_2809_ clknet_leaf_2_clk net5 net84 vssd1 vssd1 vccd1 vccd1 CALC_INST.input_ctrl_inst.RowMid\[3\]
+ sky130_fd_sc_hd__dfstp_1
XFILLER_46_105 vssd1 vssd1 vccd1 vccd1 sky130_fd_sc_hd__fill_4
XFILLER_42_355 vssd1 vssd1 vccd1 vccd1 sky130_fd_sc_hd__fill_1
XFILLER_42_311 vssd1 vssd1 vccd1 vccd1 sky130_fd_sc_hd__fill_4
XFILLER_40_72 vssd1 vssd1 vccd1 vccd1 sky130_fd_sc_hd__fill_4
XFILLER_24_62 vssd1 vssd1 vccd1 vccd1 sky130_fd_sc_hd__fill_1
XFILLER_10_230 vssd1 vssd1 vccd1 vccd1 sky130_fd_sc_hd__fill_1
XTAP_TAPCELL_ROW_12_225 vssd1 vccd1 sky130_fd_sc_hd__tapvpwrvgnd_1
XTAP_TAPCELL_ROW_20_280 vssd1 vccd1 sky130_fd_sc_hd__tapvpwrvgnd_1
XFILLER_40_94 vssd1 vssd1 vccd1 vccd1 sky130_fd_sc_hd__fill_1
XFILLER_18_363 vssd1 vssd1 vccd1 vccd1 sky130_fd_sc_hd__fill_1
X_1973_ _0878_ _0923_ vssd1 vssd1 vccd1 vccd1 _0924_ sky130_fd_sc_hd__nor2_1
XFILLER_60_185 vssd1 vssd1 vccd1 vccd1 sky130_fd_sc_hd__fill_8
X_2525_ clknet_leaf_0_clk _0084_ net81 vssd1 vssd1 vccd1 vccd1 CALC_INST.input_ctrl_inst.col_index\[22\]
+ sky130_fd_sc_hd__dfrtp_1
X_1338_ CALC_INST.gencon_inst.operand1\[5\] _0521_ vssd1 vssd1 vccd1 vccd1 _0528_
+ sky130_fd_sc_hd__and2_1
Xhold18 CALC_INST.gencon_inst.prev_read_input vssd1 vssd1 vccd1 vccd1 net217 sky130_fd_sc_hd__dlygate4sd3_1
XANTENNA__1562__A2 _0659_ vssd1 vssd1 vccd1 vccd1 sky130_fd_sc_hd__diode_2
X_2456_ CALC_INST.gencon_inst.operand2\[0\] CALC_INST.gencon_inst.latched_keypad_input\[0\]
+ vssd1 vssd1 vccd1 vccd1 _0427_ sky130_fd_sc_hd__nand2_1
X_2387_ _1050_ _1214_ vssd1 vssd1 vccd1 vccd1 _1217_ sky130_fd_sc_hd__nor2_1
Xhold29 CALC_INST.gencon_inst.mult_calc.main.a0.in1 vssd1 vssd1 vccd1 vccd1 net228
+ sky130_fd_sc_hd__dlygate4sd3_1
X_1407_ _0584_ vssd1 vssd1 vccd1 vccd1 _0585_ sky130_fd_sc_hd__inv_2
X_1269_ CALC_INST.gencon_inst.operand2\[9\] _0469_ net37 vssd1 vssd1 vccd1 vccd1 _0041_
+ sky130_fd_sc_hd__mux2_1
XFILLER_3_215 vssd1 vssd1 vccd1 vccd1 sky130_fd_sc_hd__fill_8
XFILLER_59_263 vssd1 vssd1 vccd1 vccd1 sky130_fd_sc_hd__fill_2
XANTENNA__1680__S net62 vssd1 vssd1 vccd1 vccd1 sky130_fd_sc_hd__diode_2
XFILLER_27_171 vssd1 vssd1 vccd1 vccd1 sky130_fd_sc_hd__fill_1
XFILLER_19_62 vssd1 vssd1 vccd1 vccd1 sky130_fd_sc_hd__fill_2
XANTENNA__1855__S net137 vssd1 vssd1 vccd1 vccd1 sky130_fd_sc_hd__diode_2
X_2172_ net375 _1038_ vssd1 vssd1 vccd1 vccd1 _0374_ sky130_fd_sc_hd__xor2_1
X_2310_ CALC_INST.input_ctrl_inst.decoded_key\[2\] _1078_ _1148_ _1158_ vssd1 vssd1
+ vccd1 vccd1 _0029_ sky130_fd_sc_hd__a211o_1
XFILLER_32_5 vccd1 vssd1 vccd1 vssd1 sky130_ef_sc_hd__decap_40_12
X_2241_ _1088_ _1098_ vssd1 vssd1 vccd1 vccd1 _1099_ sky130_fd_sc_hd__nand2_1
XFILLER_18_3 vssd1 vssd1 vccd1 vccd1 sky130_fd_sc_hd__fill_4
XFILLER_53_406 vssd1 vssd1 vccd1 vccd1 sky130_fd_sc_hd__fill_1
XTAP_TAPCELL_ROW_48_475 vssd1 vccd1 sky130_fd_sc_hd__tapvpwrvgnd_1
X_1956_ CALC_INST.gencon_inst.add_calc.main.GENERATE_ADDER\[2\].thingy.in1 _0904_
+ _0905_ vssd1 vssd1 vccd1 vccd1 _0907_ sky130_fd_sc_hd__nand3_1
X_1887_ CALC_INST.gencon_inst.mult_calc.out\[1\] net338 net143 vssd1 vssd1 vccd1 vccd1
+ _0274_ sky130_fd_sc_hd__mux2_1
Xoutput19 net19 vssd1 vssd1 vccd1 vccd1 gpio_out[22] sky130_fd_sc_hd__buf_2
XANTENNA_fanout112_A CALC_INST.gencon_inst.add_calc.nRST vssd1 vssd1 vccd1 vccd1 sky130_fd_sc_hd__diode_2
X_2508_ clknet_leaf_1_clk _0067_ net85 vssd1 vssd1 vccd1 vccd1 CALC_INST.input_ctrl_inst.col_index\[5\]
+ sky130_fd_sc_hd__dfrtp_1
XFILLER_56_38 vssd1 vssd1 vccd1 vccd1 sky130_fd_sc_hd__fill_4
XFILLER_56_27 vssd1 vssd1 vccd1 vccd1 sky130_fd_sc_hd__fill_1
XANTENNA__1513__B _0655_ vssd1 vssd1 vccd1 vccd1 sky130_fd_sc_hd__diode_2
X_2439_ net127 _1138_ vssd1 vssd1 vccd1 vccd1 _0004_ sky130_fd_sc_hd__nor2_1
XFILLER_24_174 vssd1 vssd1 vccd1 vccd1 sky130_fd_sc_hd__fill_1
XFILLER_24_152 vssd1 vssd1 vccd1 vccd1 sky130_fd_sc_hd__fill_2
XFILLER_12_336 vssd1 vssd1 vccd1 vccd1 sky130_fd_sc_hd__fill_1
XANTENNA__1774__A2 net132 vssd1 vssd1 vccd1 vccd1 sky130_fd_sc_hd__diode_2
XFILLER_47_277 vssd1 vssd1 vccd1 vccd1 sky130_fd_sc_hd__fill_2
XTAP_TAPCELL_ROW_45_456 vssd1 vccd1 sky130_fd_sc_hd__tapvpwrvgnd_1
Xmax_cap72 _1226_ vssd1 vssd1 vccd1 vccd1 net72 sky130_fd_sc_hd__buf_1
XFILLER_62_81 vssd1 vssd1 vccd1 vccd1 sky130_fd_sc_hd__fill_2
X_1741_ _0769_ _0711_ vssd1 vssd1 vccd1 vccd1 _0209_ sky130_fd_sc_hd__and2b_1
XFILLER_30_100 vccd1 vssd1 vccd1 vssd1 sky130_ef_sc_hd__decap_40_12
X_2790_ clknet_leaf_34_clk net270 net87 vssd1 vssd1 vccd1 vccd1 net23 sky130_fd_sc_hd__dfrtp_1
X_1810_ CALC_INST.gencon_inst.mult_calc.main.GENERATE_ADDER\[10\].thingy.in2 CALC_INST.gencon_inst.mult_calc.main.GENERATE_ADDER\[10\].thingy.in1
+ vssd1 vssd1 vccd1 vccd1 _0830_ sky130_fd_sc_hd__nor2_1
X_1672_ CALC_INST.gencon_inst.ALU_in2\[2\] CALC_INST.gencon_inst.ALU_in1\[2\] net59
+ vssd1 vssd1 vccd1 vccd1 _0736_ sky130_fd_sc_hd__mux2_1
X_2155_ _1029_ vssd1 vssd1 vccd1 vccd1 _1030_ sky130_fd_sc_hd__inv_2
XFILLER_38_277 vssd1 vssd1 vccd1 vccd1 sky130_fd_sc_hd__fill_2
X_2224_ CALC_INST.input_ctrl_inst.input_control_state\[0\] CALC_INST.input_ctrl_inst.input_control_state\[1\]
+ CALC_INST.input_ctrl_inst.input_control_state\[3\] CALC_INST.input_ctrl_inst.input_control_state\[2\]
+ vssd1 vssd1 vccd1 vccd1 _1083_ sky130_fd_sc_hd__or4_1
X_2086_ net437 net42 net34 CALC_INST.gencon_inst.operand2\[4\] vssd1 vssd1 vccd1 vccd1
+ _0325_ sky130_fd_sc_hd__a22o_1
X_1939_ _0888_ _0889_ CALC_INST.gencon_inst.add_calc.main.GENERATE_ADDER\[6\].thingy.in1
+ vssd1 vssd1 vccd1 vccd1 _0890_ sky130_fd_sc_hd__a21oi_1
XFILLER_21_199 vssd1 vssd1 vccd1 vccd1 sky130_fd_sc_hd__fill_1
XFILLER_44_269 vssd1 vssd1 vccd1 vccd1 sky130_fd_sc_hd__fill_2
XFILLER_17_406 vssd1 vssd1 vccd1 vccd1 sky130_fd_sc_hd__fill_1
XTAP_TAPCELL_ROW_50_492 vssd1 vccd1 sky130_fd_sc_hd__tapvpwrvgnd_1
XTAP_TAPCELL_ROW_42_437 vssd1 vccd1 sky130_fd_sc_hd__tapvpwrvgnd_1
XFILLER_32_62 vssd1 vssd1 vccd1 vccd1 sky130_fd_sc_hd__fill_1
XPHY_EDGE_ROW_11_Right_11 vssd1 vssd1 vccd1 vccd1 sky130_fd_sc_hd__decap_3
XFILLER_12_122 vssd1 vssd1 vccd1 vccd1 sky130_fd_sc_hd__fill_4
XFILLER_12_133 vssd1 vssd1 vccd1 vccd1 sky130_fd_sc_hd__fill_2
XFILLER_12_166 vssd1 vssd1 vccd1 vccd1 sky130_fd_sc_hd__fill_1
XFILLER_16_85 vssd1 vssd1 vccd1 vccd1 sky130_fd_sc_hd__fill_4
XPHY_EDGE_ROW_20_Right_20 vssd1 vssd1 vccd1 vccd1 sky130_fd_sc_hd__decap_3
XTAP_TAPCELL_ROW_7_192 vssd1 vccd1 sky130_fd_sc_hd__tapvpwrvgnd_1
X_2911_ CALC_INST.input_ctrl_inst.key_pressed vssd1 vssd1 vccd1 vccd1 net24 sky130_fd_sc_hd__clkbuf_1
X_1724_ CALC_INST.gencon_inst.ALU_in1\[13\] CALC_INST.gencon_inst.ALU_in2\[13\] net61
+ vssd1 vssd1 vccd1 vccd1 _0762_ sky130_fd_sc_hd__mux2_1
Xhold126 CALC_INST.gencon_inst.ALU_in1\[12\] vssd1 vssd1 vccd1 vccd1 net325 sky130_fd_sc_hd__dlygate4sd3_1
X_2773_ clknet_leaf_4_clk _0323_ vssd1 vssd1 vccd1 vccd1 CALC_INST.gencon_inst.mult_calc.INn2\[2\]
+ sky130_fd_sc_hd__dfxtp_1
X_2842_ clknet_leaf_2_clk _0027_ net83 vssd1 vssd1 vccd1 vccd1 CALC_INST.input_ctrl_inst.decoded_key\[0\]
+ sky130_fd_sc_hd__dfrtp_1
Xhold104 CALC_INST.gencon_inst.mult_calc.countSave\[10\] vssd1 vssd1 vccd1 vccd1 net303
+ sky130_fd_sc_hd__dlygate4sd3_1
Xhold115 CALC_INST.gencon_inst.mult_calc.countSave\[14\] vssd1 vssd1 vccd1 vccd1 net314
+ sky130_fd_sc_hd__dlygate4sd3_1
Xhold148 CALC_INST.gencon_inst.add_calc.main.in2\[3\] vssd1 vssd1 vccd1 vccd1 net347
+ sky130_fd_sc_hd__dlygate4sd3_1
XFILLER_58_339 vssd1 vssd1 vccd1 vccd1 sky130_fd_sc_hd__fill_1
Xhold159 CALC_INST.gencon_inst.add_calc.main.in2\[12\] vssd1 vssd1 vccd1 vccd1 net358
+ sky130_fd_sc_hd__dlygate4sd3_1
Xhold137 CALC_INST.gencon_inst.add_calc.main.in2\[14\] vssd1 vssd1 vccd1 vccd1 net336
+ sky130_fd_sc_hd__dlygate4sd3_1
X_1586_ net149 net148 _1054_ CALC_INST.gencon_inst.gencon_state\[2\] vssd1 vssd1 vccd1
+ vccd1 _0715_ sky130_fd_sc_hd__and4b_2
X_1655_ net211 _0683_ net44 vssd1 vssd1 vccd1 vccd1 _0167_ sky130_fd_sc_hd__mux2_1
XTAP_TAPCELL_ROW_56_529 vssd1 vccd1 sky130_fd_sc_hd__tapvpwrvgnd_1
X_2138_ net155 _1149_ _1004_ net409 _1019_ vssd1 vssd1 vccd1 vccd1 _0360_ sky130_fd_sc_hd__o221a_1
XFILLER_37_18 vssd1 vssd1 vccd1 vccd1 sky130_fd_sc_hd__fill_4
X_2069_ net127 _1107_ net129 net284 vssd1 vssd1 vccd1 vccd1 _0310_ sky130_fd_sc_hd__a2bb2o_1
X_2207_ _1065_ _1066_ CALC_INST.input_ctrl_inst.debounce_cnt\[13\] vssd1 vssd1 vccd1
+ vccd1 _1067_ sky130_fd_sc_hd__o21a_1
XTAP_TAPCELL_ROW_64_595 vssd1 vccd1 sky130_fd_sc_hd__tapvpwrvgnd_1
XFILLER_53_28 vssd1 vssd1 vccd1 vccd1 sky130_fd_sc_hd__fill_1
XANTENNA__1426__A1 net51 vssd1 vssd1 vccd1 vccd1 sky130_fd_sc_hd__diode_2
XANTENNA_fanout92_A net93 vssd1 vssd1 vccd1 vccd1 sky130_fd_sc_hd__diode_2
XFILLER_64_309 vssd1 vssd1 vccd1 vccd1 sky130_fd_sc_hd__fill_8
XFILLER_57_361 vssd1 vssd1 vccd1 vccd1 sky130_fd_sc_hd__fill_1
XFILLER_1_335 vssd1 vssd1 vccd1 vccd1 sky130_fd_sc_hd__fill_1
XFILLER_40_261 vssd1 vssd1 vccd1 vccd1 sky130_fd_sc_hd__fill_1
X_1371_ _0552_ _0553_ vssd1 vssd1 vccd1 vccd1 _0554_ sky130_fd_sc_hd__nor2_1
X_1440_ net349 _0605_ vssd1 vssd1 vccd1 vccd1 _0076_ sky130_fd_sc_hd__xnor2_1
XTAP_TAPCELL_ROW_61_565 vssd1 vccd1 sky130_fd_sc_hd__tapvpwrvgnd_1
X_2825_ clknet_leaf_33_clk _0019_ net88 vssd1 vssd1 vccd1 vccd1 CALC_INST.input_ctrl_inst.debounce_cnt\[2\]
+ sky130_fd_sc_hd__dfrtp_1
XTAP_TAPCELL_ROW_18_264 vssd1 vccd1 sky130_fd_sc_hd__tapvpwrvgnd_1
X_1707_ net364 _0753_ net151 vssd1 vssd1 vccd1 vccd1 _0195_ sky130_fd_sc_hd__mux2_1
X_1638_ net224 _0722_ _0723_ CALC_INST.gencon_inst.operator_input\[0\] vssd1 vssd1
+ vccd1 vccd1 _0155_ sky130_fd_sc_hd__a22o_1
X_2687_ clknet_leaf_23_clk _0246_ net105 vssd1 vssd1 vccd1 vccd1 CALC_INST.gencon_inst.mult_calc.main.GENERATE_ADDER\[4\].thingy.in1
+ sky130_fd_sc_hd__dfrtp_1
X_2756_ clknet_leaf_28_clk _0315_ net102 vssd1 vssd1 vccd1 vccd1 CALC_INST.gencon_inst.mult_calc.countSave\[9\]
+ sky130_fd_sc_hd__dfrtp_1
XFILLER_46_309 vssd1 vssd1 vccd1 vccd1 sky130_fd_sc_hd__fill_1
XANTENNA__2136__A2 net155 vssd1 vssd1 vccd1 vccd1 sky130_fd_sc_hd__diode_2
X_1569_ net71 _0700_ _0701_ _0659_ vssd1 vssd1 vccd1 vccd1 _0702_ sky130_fd_sc_hd__a211o_1
XFILLER_54_353 vssd1 vssd1 vccd1 vccd1 sky130_fd_sc_hd__fill_2
XFILLER_54_331 vssd1 vssd1 vccd1 vccd1 sky130_fd_sc_hd__fill_8
Xfanout32 _0933_ vssd1 vssd1 vccd1 vccd1 net32 sky130_fd_sc_hd__buf_2
Xfanout98 net99 vssd1 vssd1 vccd1 vccd1 net98 sky130_fd_sc_hd__clkbuf_4
Xfanout65 _0724_ vssd1 vssd1 vccd1 vccd1 net65 sky130_fd_sc_hd__clkbuf_4
Xfanout76 _0488_ vssd1 vssd1 vccd1 vccd1 net76 sky130_fd_sc_hd__dlymetal6s2s_1
Xfanout54 _0424_ vssd1 vssd1 vccd1 vccd1 net54 sky130_fd_sc_hd__buf_2
Xfanout43 net44 vssd1 vssd1 vccd1 vccd1 net43 sky130_fd_sc_hd__clkbuf_4
Xfanout87 net90 vssd1 vssd1 vccd1 vccd1 net87 sky130_fd_sc_hd__clkbuf_4
XFILLER_1_121 vssd1 vssd1 vccd1 vccd1 sky130_fd_sc_hd__fill_4
XFILLER_64_139 vssd1 vssd1 vccd1 vccd1 sky130_fd_sc_hd__fill_1
XFILLER_49_147 vssd1 vssd1 vccd1 vccd1 sky130_fd_sc_hd__fill_1
XFILLER_1_187 vccd1 vssd1 vccd1 vssd1 sky130_ef_sc_hd__decap_40_12
XFILLER_54_93 vssd1 vssd1 vccd1 vccd1 sky130_fd_sc_hd__fill_1
XTAP_TAPCELL_ROW_15_245 vssd1 vccd1 sky130_fd_sc_hd__tapvpwrvgnd_1
Xclkload13 clknet_leaf_10_clk vssd1 vssd1 vccd1 vccd1 clkload13/Y sky130_fd_sc_hd__clkinv_2
X_2472_ clknet_leaf_10_clk _0005_ net96 vssd1 vssd1 vccd1 vccd1 CALC_INST.gencon_inst.add_calc.next_finish
+ sky130_fd_sc_hd__dfrtp_1
X_2541_ clknet_leaf_20_clk _0100_ net117 vssd1 vssd1 vccd1 vccd1 net10 sky130_fd_sc_hd__dfrtp_1
Xclkload24 clknet_leaf_14_clk vssd1 vssd1 vccd1 vccd1 clkload24/Y sky130_fd_sc_hd__inv_12
X_2610_ clknet_leaf_25_clk _0169_ vssd1 vssd1 vccd1 vccd1 CALC_INST.gencon_inst.mult_calc.INn1\[10\]
+ sky130_fd_sc_hd__dfxtp_1
X_1354_ CALC_INST.gencon_inst.operand1\[8\] net47 _0539_ _0540_ vssd1 vssd1 vccd1
+ vccd1 _0055_ sky130_fd_sc_hd__o22a_1
X_1285_ CALC_INST.gencon_inst.operand2\[13\] _0481_ net37 vssd1 vssd1 vccd1 vccd1
+ _0045_ sky130_fd_sc_hd__mux2_1
X_1423_ _0593_ _0586_ _0388_ CALC_INST.input_ctrl_inst.col_index\[3\] vssd1 vssd1
+ vccd1 vccd1 _0596_ sky130_fd_sc_hd__and4b_1
XANTENNA__1877__A1 net133 vssd1 vssd1 vccd1 vccd1 sky130_fd_sc_hd__diode_2
XFILLER_51_301 vssd1 vssd1 vccd1 vccd1 sky130_fd_sc_hd__fill_2
X_2808_ clknet_leaf_6_clk net4 net94 vssd1 vssd1 vccd1 vccd1 CALC_INST.input_ctrl_inst.RowMid\[2\]
+ sky130_fd_sc_hd__dfstp_1
Xclkload7 clknet_leaf_35_clk vssd1 vssd1 vccd1 vccd1 clkload7/Y sky130_fd_sc_hd__inv_8
XFILLER_59_49 vssd1 vssd1 vccd1 vccd1 sky130_fd_sc_hd__fill_4
X_2739_ clknet_leaf_17_clk _0298_ net116 vssd1 vssd1 vccd1 vccd1 CALC_INST.gencon_inst.ALU_out\[8\]
+ sky130_fd_sc_hd__dfrtp_1
XFILLER_46_139 vssd1 vssd1 vccd1 vccd1 sky130_fd_sc_hd__fill_1
XANTENNA__1678__S net62 vssd1 vssd1 vccd1 vccd1 sky130_fd_sc_hd__diode_2
XFILLER_27_375 vssd1 vssd1 vccd1 vccd1 sky130_fd_sc_hd__fill_1
XTAP_TAPCELL_ROW_12_226 vssd1 vccd1 sky130_fd_sc_hd__tapvpwrvgnd_1
XANTENNA__1556__A0 CALC_INST.gencon_inst.operand2\[11\] vssd1 vssd1 vccd1 vccd1 sky130_fd_sc_hd__diode_2
XTAP_TAPCELL_ROW_20_281 vssd1 vccd1 sky130_fd_sc_hd__tapvpwrvgnd_1
XFILLER_45_183 vssd1 vssd1 vccd1 vccd1 sky130_fd_sc_hd__fill_1
X_1972_ _0882_ _0886_ _0920_ _0883_ _0879_ vssd1 vssd1 vccd1 vccd1 _0923_ sky130_fd_sc_hd__o311a_1
XFILLER_60_197 vssd1 vssd1 vccd1 vccd1 sky130_fd_sc_hd__fill_8
XPHY_EDGE_ROW_49_Right_49 vssd1 vssd1 vccd1 vccd1 sky130_fd_sc_hd__decap_3
XANTENNA__1336__B _0491_ vssd1 vssd1 vccd1 vccd1 sky130_fd_sc_hd__diode_2
X_2455_ CALC_INST.gencon_inst.operand2\[0\] CALC_INST.gencon_inst.latched_keypad_input\[0\]
+ vssd1 vssd1 vccd1 vccd1 _0426_ sky130_fd_sc_hd__or2_1
X_2524_ clknet_leaf_35_clk _0083_ net81 vssd1 vssd1 vccd1 vccd1 CALC_INST.input_ctrl_inst.col_index\[21\]
+ sky130_fd_sc_hd__dfrtp_1
XPHY_EDGE_ROW_58_Right_58 vssd1 vssd1 vccd1 vccd1 sky130_fd_sc_hd__decap_3
Xhold19 _0121_ vssd1 vssd1 vccd1 vccd1 net218 sky130_fd_sc_hd__dlygate4sd3_1
X_1337_ net45 _0522_ _0526_ _0521_ CALC_INST.gencon_inst.operand1\[5\] vssd1 vssd1
+ vccd1 vccd1 _0527_ sky130_fd_sc_hd__o32a_1
X_1268_ net54 _0467_ _0468_ net49 CALC_INST.gencon_inst.mult_calc.out\[9\] vssd1 vssd1
+ vccd1 vccd1 _0469_ sky130_fd_sc_hd__a32o_1
X_2386_ _1050_ _1214_ vssd1 vssd1 vccd1 vccd1 _1216_ sky130_fd_sc_hd__and2_1
X_1406_ net51 _0581_ vssd1 vssd1 vccd1 vccd1 _0584_ sky130_fd_sc_hd__nand2_2
XFILLER_43_109 vssd1 vssd1 vccd1 vccd1 sky130_fd_sc_hd__fill_2
XFILLER_36_150 vssd1 vssd1 vccd1 vccd1 sky130_fd_sc_hd__fill_1
XFILLER_24_301 vssd1 vssd1 vccd1 vccd1 sky130_fd_sc_hd__fill_4
XANTENNA__2911__A CALC_INST.input_ctrl_inst.key_pressed vssd1 vssd1 vccd1 vccd1 sky130_fd_sc_hd__diode_2
XFILLER_47_404 vssd1 vssd1 vccd1 vccd1 sky130_fd_sc_hd__fill_2
XFILLER_34_109 vssd1 vssd1 vccd1 vccd1 sky130_fd_sc_hd__fill_2
XFILLER_19_117 vssd1 vssd1 vccd1 vccd1 sky130_fd_sc_hd__fill_1
XFILLER_51_72 vssd1 vssd1 vccd1 vccd1 sky130_fd_sc_hd__fill_8
XFILLER_42_197 vssd1 vssd1 vccd1 vccd1 sky130_fd_sc_hd__fill_2
XANTENNA__2552__RESET_B net99 vssd1 vssd1 vccd1 vccd1 sky130_fd_sc_hd__diode_2
XANTENNA__1529__B1 net67 vssd1 vssd1 vccd1 vccd1 sky130_fd_sc_hd__diode_2
X_2171_ _1038_ _1039_ vssd1 vssd1 vccd1 vccd1 _0373_ sky130_fd_sc_hd__nor2_1
X_2240_ CALC_INST.gencon_inst.mult_calc.count.GENERATE_ADDER\[1\].thingy.in1 CALC_INST.gencon_inst.mult_calc.count.GENERATE_ADDER\[1\].thingy.cIn
+ CALC_INST.gencon_inst.mult_calc.count.GENERATE_ADDER\[2\].thingy.in1 vssd1 vssd1
+ vccd1 vccd1 _1098_ sky130_fd_sc_hd__a21o_1
XTAP_TAPCELL_ROW_48_476 vssd1 vccd1 sky130_fd_sc_hd__tapvpwrvgnd_1
XFILLER_21_337 vssd1 vssd1 vccd1 vccd1 sky130_fd_sc_hd__fill_2
X_1955_ _0904_ _0905_ CALC_INST.gencon_inst.add_calc.main.GENERATE_ADDER\[2\].thingy.in1
+ vssd1 vssd1 vccd1 vccd1 _0906_ sky130_fd_sc_hd__a21oi_1
XTAP_TAPCELL_ROW_31_354 vssd1 vccd1 sky130_fd_sc_hd__tapvpwrvgnd_1
XFILLER_21_359 vssd1 vssd1 vccd1 vccd1 sky130_fd_sc_hd__fill_8
X_1886_ CALC_INST.gencon_inst.mult_calc.out\[0\] net344 net143 vssd1 vssd1 vccd1 vccd1
+ _0273_ sky130_fd_sc_hd__mux2_1
XANTENNA_fanout105_A net112 vssd1 vssd1 vccd1 vccd1 sky130_fd_sc_hd__diode_2
X_2438_ net495 net454 vssd1 vssd1 vccd1 vccd1 _0003_ sky130_fd_sc_hd__and2_1
X_2507_ clknet_leaf_1_clk _0066_ net83 vssd1 vssd1 vccd1 vccd1 CALC_INST.input_ctrl_inst.col_index\[4\]
+ sky130_fd_sc_hd__dfrtp_2
XFILLER_56_223 vccd1 vssd1 vccd1 vssd1 sky130_ef_sc_hd__decap_40_12
XTAP_TAPCELL_ROW_39_410 vssd1 vccd1 sky130_fd_sc_hd__tapvpwrvgnd_1
X_2369_ CALC_INST.input_ctrl_inst.debounce_cnt\[13\] _1201_ vssd1 vssd1 vccd1 vccd1
+ _1203_ sky130_fd_sc_hd__nand2_1
XFILLER_24_131 vssd1 vssd1 vccd1 vccd1 sky130_fd_sc_hd__fill_1
XFILLER_46_83 vssd1 vssd1 vccd1 vccd1 sky130_fd_sc_hd__fill_1
XTAP_TAPCELL_ROW_45_457 vssd1 vccd1 sky130_fd_sc_hd__tapvpwrvgnd_1
XFILLER_30_112 vccd1 vssd1 vccd1 vssd1 sky130_ef_sc_hd__decap_40_12
X_1671_ CALC_INST.gencon_inst.add_calc.main.GENERATE_ADDER\[1\].thingy.in1 _0735_
+ net150 vssd1 vssd1 vccd1 vccd1 _0177_ sky130_fd_sc_hd__mux2_1
X_1740_ _0766_ _0773_ _0420_ vssd1 vssd1 vccd1 vccd1 _0208_ sky130_fd_sc_hd__a21o_1
XFILLER_7_44 vssd1 vssd1 vccd1 vccd1 sky130_fd_sc_hd__fill_1
XFILLER_7_66 vssd1 vssd1 vccd1 vccd1 sky130_fd_sc_hd__fill_1
XFILLER_11_370 vssd1 vssd1 vccd1 vccd1 sky130_fd_sc_hd__fill_2
XFILLER_11_381 vssd1 vssd1 vccd1 vccd1 sky130_fd_sc_hd__fill_2
X_2154_ CALC_INST.input_ctrl_inst.scan_timer\[5\] CALC_INST.input_ctrl_inst.scan_timer\[4\]
+ CALC_INST.input_ctrl_inst.scan_timer\[6\] _1025_ vssd1 vssd1 vccd1 vccd1 _1029_
+ sky130_fd_sc_hd__and4_2
X_2223_ CALC_INST.input_ctrl_inst.key_pressed _1080_ vssd1 vssd1 vccd1 vccd1 _1082_
+ sky130_fd_sc_hd__or2_1
X_2085_ net386 net43 _1002_ CALC_INST.gencon_inst.operand2\[3\] vssd1 vssd1 vccd1
+ vccd1 _0324_ sky130_fd_sc_hd__o22a_1
XFILLER_61_281 vccd1 vssd1 vccd1 vssd1 sky130_ef_sc_hd__decap_40_12
XFILLER_21_134 vssd1 vssd1 vccd1 vccd1 sky130_fd_sc_hd__fill_1
X_1938_ net146 CALC_INST.gencon_inst.add_calc.main.in2\[6\] vssd1 vssd1 vccd1 vccd1
+ _0889_ sky130_fd_sc_hd__nand2_1
XANTENNA__2461__A CALC_INST.gencon_inst.operand2\[1\] vssd1 vssd1 vccd1 vccd1 sky130_fd_sc_hd__diode_2
X_1869_ net127 net123 vssd1 vssd1 vccd1 vccd1 _0854_ sky130_fd_sc_hd__nand2_1
XFILLER_29_212 vssd1 vssd1 vccd1 vccd1 sky130_fd_sc_hd__fill_4
XFILLER_52_270 vssd1 vssd1 vccd1 vccd1 sky130_fd_sc_hd__fill_1
XFILLER_29_289 vssd1 vssd1 vccd1 vccd1 sky130_fd_sc_hd__fill_4
XFILLER_29_278 vssd1 vssd1 vccd1 vccd1 sky130_fd_sc_hd__fill_2
XTAP_TAPCELL_ROW_50_493 vssd1 vccd1 sky130_fd_sc_hd__tapvpwrvgnd_1
XFILLER_32_85 vssd1 vssd1 vccd1 vccd1 sky130_fd_sc_hd__fill_2
XFILLER_4_388 vccd1 vssd1 vccd1 vssd1 sky130_ef_sc_hd__decap_40_12
XFILLER_43_281 vssd1 vssd1 vccd1 vccd1 sky130_fd_sc_hd__fill_4
XFILLER_35_248 vssd1 vssd1 vccd1 vccd1 sky130_fd_sc_hd__fill_2
X_2841_ clknet_leaf_3_clk _0017_ net91 vssd1 vssd1 vccd1 vccd1 CALC_INST.input_ctrl_inst.debounce_cnt\[18\]
+ sky130_fd_sc_hd__dfrtp_1
Xhold105 CALC_INST.gencon_inst.ALU_out\[15\] vssd1 vssd1 vccd1 vccd1 net304 sky130_fd_sc_hd__dlygate4sd3_1
X_1723_ net358 _0761_ net153 vssd1 vssd1 vccd1 vccd1 _0203_ sky130_fd_sc_hd__mux2_1
Xhold149 CALC_INST.input_ctrl_inst.read_input_flag vssd1 vssd1 vccd1 vccd1 net348
+ sky130_fd_sc_hd__dlygate4sd3_1
X_1654_ net220 _0680_ net44 vssd1 vssd1 vccd1 vccd1 _0166_ sky130_fd_sc_hd__mux2_1
X_2772_ clknet_leaf_4_clk net346 vssd1 vssd1 vccd1 vccd1 CALC_INST.gencon_inst.mult_calc.INn2\[1\]
+ sky130_fd_sc_hd__dfxtp_1
Xhold116 CALC_INST.gencon_inst.mult_calc.countSave\[6\] vssd1 vssd1 vccd1 vccd1 net315
+ sky130_fd_sc_hd__dlygate4sd3_1
Xhold127 CALC_INST.input_ctrl_inst.debounce_cnt\[3\] vssd1 vssd1 vccd1 vccd1 net326
+ sky130_fd_sc_hd__dlygate4sd3_1
Xhold138 CALC_INST.gencon_inst.mult_calc.adderSave\[5\] vssd1 vssd1 vccd1 vccd1 net337
+ sky130_fd_sc_hd__dlygate4sd3_1
X_1585_ net217 _0713_ vssd1 vssd1 vccd1 vccd1 _0714_ sky130_fd_sc_hd__nor2_1
X_2206_ CALC_INST.input_ctrl_inst.debounce_cnt\[9\] CALC_INST.input_ctrl_inst.debounce_cnt\[11\]
+ CALC_INST.input_ctrl_inst.debounce_cnt\[10\] CALC_INST.input_ctrl_inst.debounce_cnt\[12\]
+ vssd1 vssd1 vccd1 vccd1 _1066_ sky130_fd_sc_hd__or4_1
XTAP_TAPCELL_ROW_64_585 vssd1 vccd1 sky130_fd_sc_hd__tapvpwrvgnd_1
X_2137_ _1151_ _1009_ _1004_ vssd1 vssd1 vccd1 vccd1 _1019_ sky130_fd_sc_hd__o21ai_1
X_2068_ net127 _1105_ net129 net240 vssd1 vssd1 vccd1 vccd1 _0309_ sky130_fd_sc_hd__a2bb2o_1
XTAP_TAPCELL_ROW_64_596 vssd1 vccd1 sky130_fd_sc_hd__tapvpwrvgnd_1
XFILLER_57_384 vssd1 vssd1 vccd1 vccd1 sky130_fd_sc_hd__fill_8
XFILLER_27_52 vssd1 vssd1 vccd1 vccd1 sky130_fd_sc_hd__fill_1
XFILLER_40_251 vssd1 vssd1 vccd1 vccd1 sky130_fd_sc_hd__fill_1
XANTENNA__2090__A2 net42 vssd1 vssd1 vccd1 vccd1 sky130_fd_sc_hd__diode_2
XFILLER_27_96 vssd1 vssd1 vccd1 vccd1 sky130_fd_sc_hd__fill_1
XFILLER_9_403 vssd1 vssd1 vccd1 vccd1 sky130_fd_sc_hd__fill_1
XFILLER_43_84 vssd1 vssd1 vccd1 vccd1 sky130_fd_sc_hd__fill_1
XFILLER_4_141 vssd1 vssd1 vccd1 vccd1 sky130_fd_sc_hd__fill_1
X_1370_ CALC_INST.gencon_inst.operand1\[12\] _0548_ _0490_ vssd1 vssd1 vccd1 vccd1
+ _0553_ sky130_fd_sc_hd__o21ai_1
XFILLER_4_56 vssd1 vssd1 vccd1 vccd1 sky130_fd_sc_hd__fill_2
XFILLER_0_391 vssd1 vssd1 vccd1 vccd1 sky130_fd_sc_hd__fill_1
XFILLER_63_376 vccd1 vssd1 vccd1 vssd1 sky130_ef_sc_hd__decap_40_12
XFILLER_63_343 vssd1 vssd1 vccd1 vccd1 sky130_fd_sc_hd__fill_1
XTAP_TAPCELL_ROW_18_265 vssd1 vccd1 sky130_fd_sc_hd__tapvpwrvgnd_1
XTAP_TAPCELL_ROW_61_566 vssd1 vccd1 sky130_fd_sc_hd__tapvpwrvgnd_1
X_2824_ clknet_leaf_33_clk _0018_ net88 vssd1 vssd1 vccd1 vccd1 CALC_INST.input_ctrl_inst.debounce_cnt\[1\]
+ sky130_fd_sc_hd__dfrtp_2
X_1637_ net277 _1146_ net63 vssd1 vssd1 vccd1 vccd1 _0154_ sky130_fd_sc_hd__a21bo_1
X_1706_ CALC_INST.gencon_inst.ALU_in1\[4\] CALC_INST.gencon_inst.ALU_in2\[4\] net59
+ vssd1 vssd1 vccd1 vccd1 _0753_ sky130_fd_sc_hd__mux2_1
X_2686_ clknet_leaf_31_clk _0245_ net105 vssd1 vssd1 vccd1 vccd1 CALC_INST.gencon_inst.mult_calc.main.GENERATE_ADDER\[3\].thingy.in1
+ sky130_fd_sc_hd__dfrtp_1
X_2755_ clknet_leaf_28_clk _0314_ net102 vssd1 vssd1 vccd1 vccd1 CALC_INST.gencon_inst.mult_calc.countSave\[8\]
+ sky130_fd_sc_hd__dfrtp_1
XFILLER_48_29 vssd1 vssd1 vccd1 vccd1 sky130_fd_sc_hd__fill_1
X_1499_ net71 net73 vssd1 vssd1 vccd1 vccd1 _0647_ sky130_fd_sc_hd__nand2_1
X_1568_ CALC_INST.gencon_inst.ALU_out\[14\] net77 net68 CALC_INST.gencon_inst.mult_calc.out\[14\]
+ vssd1 vssd1 vccd1 vccd1 _0701_ sky130_fd_sc_hd__a22o_1
XFILLER_64_39 vssd1 vssd1 vccd1 vccd1 sky130_fd_sc_hd__fill_1
Xfanout33 _0933_ vssd1 vssd1 vccd1 vccd1 net33 sky130_fd_sc_hd__buf_2
XFILLER_54_365 vssd1 vssd1 vccd1 vccd1 sky130_fd_sc_hd__fill_1
Xfanout55 _0424_ vssd1 vssd1 vccd1 vccd1 net55 sky130_fd_sc_hd__clkbuf_2
Xfanout44 _0727_ vssd1 vssd1 vccd1 vccd1 net44 sky130_fd_sc_hd__clkbuf_4
XTAP_TAPCELL_ROW_1_144 vssd1 vccd1 sky130_fd_sc_hd__tapvpwrvgnd_1
Xfanout66 _0724_ vssd1 vssd1 vccd1 vccd1 net66 sky130_fd_sc_hd__buf_2
Xfanout99 net100 vssd1 vssd1 vccd1 vccd1 net99 sky130_fd_sc_hd__clkbuf_4
Xfanout77 net78 vssd1 vssd1 vccd1 vccd1 net77 sky130_fd_sc_hd__buf_2
XTAP_TAPCELL_ROW_9_200 vssd1 vccd1 sky130_fd_sc_hd__tapvpwrvgnd_1
Xfanout88 net90 vssd1 vssd1 vccd1 vccd1 net88 sky130_fd_sc_hd__clkbuf_4
XFILLER_1_199 vccd1 vssd1 vccd1 vssd1 sky130_ef_sc_hd__decap_40_12
XFILLER_8_3 vssd1 vssd1 vccd1 vccd1 sky130_fd_sc_hd__fill_8
XFILLER_38_51 vssd1 vssd1 vccd1 vccd1 sky130_fd_sc_hd__fill_1
XFILLER_60_324 vssd1 vssd1 vccd1 vccd1 sky130_fd_sc_hd__fill_1
XFILLER_54_83 vssd1 vssd1 vccd1 vccd1 sky130_fd_sc_hd__fill_1
XPHY_EDGE_ROW_41_Left_106 vssd1 vssd1 vccd1 vccd1 sky130_fd_sc_hd__decap_3
XFILLER_9_222 vssd1 vssd1 vccd1 vccd1 sky130_fd_sc_hd__fill_2
XFILLER_13_262 vssd1 vssd1 vccd1 vccd1 sky130_fd_sc_hd__fill_1
XFILLER_13_284 vssd1 vssd1 vccd1 vccd1 sky130_fd_sc_hd__fill_1
XTAP_TAPCELL_ROW_15_246 vssd1 vccd1 sky130_fd_sc_hd__tapvpwrvgnd_1
XFILLER_62_6 vccd1 vssd1 vccd1 vssd1 sky130_ef_sc_hd__decap_40_12
Xclkload25 clknet_leaf_16_clk vssd1 vssd1 vccd1 vccd1 clkload25/Y sky130_fd_sc_hd__clkinv_8
Xclkload14 clknet_leaf_11_clk vssd1 vssd1 vccd1 vccd1 clkload14/Y sky130_fd_sc_hd__clkinv_2
X_2471_ clknet_leaf_10_clk _0001_ net96 vssd1 vssd1 vccd1 vccd1 CALC_INST.gencon_inst.add_calc.state\[2\]
+ sky130_fd_sc_hd__dfrtp_2
XANTENNA__1574__B2 net71 vssd1 vssd1 vccd1 vccd1 sky130_fd_sc_hd__diode_2
X_2540_ clknet_leaf_14_clk _0099_ net113 vssd1 vssd1 vccd1 vccd1 net9 sky130_fd_sc_hd__dfrtp_1
X_1422_ _0387_ _0588_ _0594_ vssd1 vssd1 vccd1 vccd1 _0595_ sky130_fd_sc_hd__and3_1
XPHY_EDGE_ROW_50_Left_115 vssd1 vssd1 vccd1 vccd1 sky130_fd_sc_hd__decap_3
XFILLER_48_170 vssd1 vssd1 vccd1 vccd1 sky130_fd_sc_hd__fill_1
X_1353_ CALC_INST.gencon_inst.ALU_out\[8\] net78 net69 CALC_INST.gencon_inst.mult_calc.out\[8\]
+ net45 vssd1 vssd1 vccd1 vccd1 _0540_ sky130_fd_sc_hd__a221o_1
X_1284_ net55 _0479_ _0480_ net50 CALC_INST.gencon_inst.mult_calc.out\[13\] vssd1
+ vssd1 vccd1 vccd1 _0481_ sky130_fd_sc_hd__a32o_1
XFILLER_51_313 vssd1 vssd1 vccd1 vccd1 sky130_fd_sc_hd__fill_2
XFILLER_36_365 vssd1 vssd1 vccd1 vccd1 sky130_fd_sc_hd__fill_1
XFILLER_36_354 vssd1 vssd1 vccd1 vccd1 sky130_fd_sc_hd__fill_2
X_2738_ clknet_leaf_16_clk _0297_ net116 vssd1 vssd1 vccd1 vccd1 CALC_INST.gencon_inst.ALU_out\[7\]
+ sky130_fd_sc_hd__dfrtp_1
XFILLER_50_19 vssd1 vssd1 vccd1 vccd1 sky130_fd_sc_hd__fill_1
Xclkload8 clknet_leaf_5_clk vssd1 vssd1 vccd1 vccd1 clkload8/Y sky130_fd_sc_hd__clkinv_2
X_2807_ clknet_leaf_2_clk net3 net84 vssd1 vssd1 vccd1 vccd1 CALC_INST.input_ctrl_inst.RowMid\[1\]
+ sky130_fd_sc_hd__dfstp_1
XFILLER_59_402 vssd1 vssd1 vccd1 vccd1 sky130_fd_sc_hd__fill_4
X_2669_ clknet_leaf_33_clk _0228_ net89 vssd1 vssd1 vccd1 vccd1 CALC_INST.gencon_inst.mult_calc.compCount.in2\[1\]
+ sky130_fd_sc_hd__dfrtp_1
XTAP_TAPCELL_ROW_12_227 vssd1 vccd1 sky130_fd_sc_hd__tapvpwrvgnd_1
XTAP_TAPCELL_ROW_20_282 vssd1 vccd1 sky130_fd_sc_hd__tapvpwrvgnd_1
XFILLER_33_368 vssd1 vssd1 vccd1 vccd1 sky130_fd_sc_hd__fill_1
X_1971_ _0882_ _0886_ _0920_ _0883_ vssd1 vssd1 vccd1 vccd1 _0922_ sky130_fd_sc_hd__o31a_1
X_2454_ _0414_ net54 vssd1 vssd1 vccd1 vccd1 _0425_ sky130_fd_sc_hd__nor2_1
X_2385_ net39 _1214_ _1215_ net41 net378 vssd1 vssd1 vccd1 vccd1 _0015_ sky130_fd_sc_hd__a32o_1
X_2523_ clknet_leaf_35_clk _0082_ net93 vssd1 vssd1 vccd1 vccd1 CALC_INST.input_ctrl_inst.col_index\[20\]
+ sky130_fd_sc_hd__dfrtp_2
X_1405_ _0412_ _0570_ _0581_ CALC_INST.input_ctrl_inst.col_index\[2\] vssd1 vssd1
+ vccd1 vccd1 _0583_ sky130_fd_sc_hd__a31o_1
Xinput1 en vssd1 vssd1 vccd1 vccd1 net1 sky130_fd_sc_hd__clkbuf_1
X_1336_ CALC_INST.gencon_inst.operand1\[5\] _0491_ vssd1 vssd1 vccd1 vccd1 _0526_
+ sky130_fd_sc_hd__nor2_1
X_1267_ CALC_INST.gencon_inst.operand2\[9\] _0464_ vssd1 vssd1 vccd1 vccd1 _0468_
+ sky130_fd_sc_hd__or2_1
XTAP_TAPCELL_ROW_26_319 vssd1 vccd1 sky130_fd_sc_hd__tapvpwrvgnd_1
XFILLER_61_18 vssd1 vssd1 vccd1 vccd1 sky130_fd_sc_hd__fill_2
XFILLER_36_195 vssd1 vssd1 vccd1 vccd1 sky130_fd_sc_hd__fill_1
XFILLER_59_298 vssd1 vssd1 vccd1 vccd1 sky130_fd_sc_hd__fill_2
XFILLER_59_210 vccd1 vssd1 vccd1 vssd1 sky130_ef_sc_hd__decap_40_12
XFILLER_19_64 vssd1 vssd1 vccd1 vccd1 sky130_fd_sc_hd__fill_1
XFILLER_42_132 vssd1 vssd1 vccd1 vccd1 sky130_fd_sc_hd__fill_8
XFILLER_15_335 vssd1 vssd1 vccd1 vccd1 sky130_fd_sc_hd__fill_1
X_2170_ net449 _1036_ vssd1 vssd1 vccd1 vccd1 _1039_ sky130_fd_sc_hd__nor2_1
XTAP_TAPCELL_ROW_48_477 vssd1 vccd1 sky130_fd_sc_hd__tapvpwrvgnd_1
X_1954_ net145 CALC_INST.gencon_inst.add_calc.main.in2\[2\] vssd1 vssd1 vccd1 vccd1
+ _0905_ sky130_fd_sc_hd__nand2_1
XFILLER_18_195 vssd1 vssd1 vccd1 vccd1 sky130_fd_sc_hd__fill_1
XTAP_TAPCELL_ROW_31_355 vssd1 vccd1 sky130_fd_sc_hd__tapvpwrvgnd_1
X_1885_ net136 CALC_INST.gencon_inst.mult_calc.adderSave\[14\] net125 net365 vssd1
+ vssd1 vccd1 vccd1 _0272_ sky130_fd_sc_hd__a22o_1
XFILLER_29_405 vssd1 vssd1 vccd1 vccd1 sky130_fd_sc_hd__fill_2
XFILLER_0_209 vccd1 vssd1 vccd1 vssd1 sky130_ef_sc_hd__decap_40_12
X_2368_ _1201_ _1202_ net467 net41 vssd1 vssd1 vccd1 vccd1 _0011_ sky130_fd_sc_hd__a2bb2o_1
X_2437_ _0411_ _0413_ vssd1 vssd1 vccd1 vccd1 net29 sky130_fd_sc_hd__or2_1
X_2506_ clknet_leaf_1_clk _0065_ net83 vssd1 vssd1 vccd1 vccd1 CALC_INST.input_ctrl_inst.col_index\[3\]
+ sky130_fd_sc_hd__dfrtp_2
XFILLER_56_235 vssd1 vssd1 vccd1 vccd1 sky130_fd_sc_hd__fill_1
X_1319_ _0511_ _0490_ _0510_ vssd1 vssd1 vccd1 vccd1 _0512_ sky130_fd_sc_hd__and3b_1
XTAP_TAPCELL_ROW_39_411 vssd1 vccd1 sky130_fd_sc_hd__tapvpwrvgnd_1
X_2299_ CALC_INST.input_ctrl_inst.decoded_key\[3\] CALC_INST.input_ctrl_inst.decoded_key\[2\]
+ vssd1 vssd1 vccd1 vccd1 _1151_ sky130_fd_sc_hd__nand2_1
XFILLER_20_360 vssd1 vssd1 vccd1 vccd1 sky130_fd_sc_hd__fill_4
XFILLER_8_309 vssd1 vssd1 vccd1 vccd1 sky130_fd_sc_hd__fill_4
XFILLER_47_279 vssd1 vssd1 vccd1 vccd1 sky130_fd_sc_hd__fill_1
XANTENNA__1273__A CALC_INST.gencon_inst.operand2\[11\] vssd1 vssd1 vccd1 vccd1 sky130_fd_sc_hd__diode_2
XTAP_TAPCELL_ROW_45_458 vssd1 vccd1 sky130_fd_sc_hd__tapvpwrvgnd_1
XFILLER_30_124 vssd1 vssd1 vccd1 vccd1 sky130_fd_sc_hd__fill_4
XFILLER_15_154 vssd1 vssd1 vccd1 vccd1 sky130_fd_sc_hd__fill_4
XFILLER_15_198 vssd1 vssd1 vccd1 vccd1 sky130_fd_sc_hd__fill_2
XFILLER_62_83 vssd1 vssd1 vccd1 vccd1 sky130_fd_sc_hd__fill_1
X_1670_ CALC_INST.gencon_inst.ALU_in2\[1\] CALC_INST.gencon_inst.ALU_in1\[1\] net59
+ vssd1 vssd1 vccd1 vccd1 _0735_ sky130_fd_sc_hd__mux2_1
XFILLER_7_23 vssd1 vssd1 vccd1 vccd1 sky130_fd_sc_hd__fill_2
XFILLER_11_393 vssd1 vssd1 vccd1 vccd1 sky130_fd_sc_hd__fill_2
X_2222_ CALC_INST.input_ctrl_inst.key_pressed _1080_ vssd1 vssd1 vccd1 vccd1 _1081_
+ sky130_fd_sc_hd__nor2_1
X_2153_ CALC_INST.input_ctrl_inst.scan_timer\[5\] CALC_INST.input_ctrl_inst.scan_timer\[4\]
+ _1025_ CALC_INST.input_ctrl_inst.scan_timer\[6\] vssd1 vssd1 vccd1 vccd1 _1028_
+ sky130_fd_sc_hd__a31o_1
XFILLER_46_290 vssd1 vssd1 vccd1 vccd1 sky130_fd_sc_hd__fill_1
X_2084_ net395 net42 net34 CALC_INST.gencon_inst.operand2\[2\] vssd1 vssd1 vccd1 vccd1
+ _0323_ sky130_fd_sc_hd__a22o_1
XFILLER_61_293 vssd1 vssd1 vccd1 vccd1 sky130_fd_sc_hd__fill_8
X_1937_ net146 CALC_INST.gencon_inst.add_calc.main.in2\[6\] vssd1 vssd1 vccd1 vccd1
+ _0888_ sky130_fd_sc_hd__or2_1
XANTENNA__1645__X _0728_ vssd1 vssd1 vccd1 vccd1 sky130_fd_sc_hd__diode_2
X_1868_ net238 net219 net140 vssd1 vssd1 vccd1 vccd1 _0256_ sky130_fd_sc_hd__mux2_1
X_1799_ _0819_ _0820_ vssd1 vssd1 vccd1 vccd1 _0821_ sky130_fd_sc_hd__and2b_1
XFILLER_44_249 vssd1 vssd1 vccd1 vccd1 sky130_fd_sc_hd__fill_2
XFILLER_44_216 vssd1 vssd1 vccd1 vccd1 sky130_fd_sc_hd__fill_8
XFILLER_12_102 vssd1 vssd1 vccd1 vccd1 sky130_fd_sc_hd__fill_4
XFILLER_12_135 vssd1 vssd1 vccd1 vccd1 sky130_fd_sc_hd__fill_1
XFILLER_16_65 vccd1 vssd1 vccd1 vssd1 sky130_ef_sc_hd__decap_40_12
XFILLER_8_117 vssd1 vssd1 vccd1 vccd1 sky130_fd_sc_hd__fill_2
XFILLER_8_139 vssd1 vssd1 vccd1 vccd1 sky130_fd_sc_hd__fill_1
XANTENNA_clkbuf_leaf_19_clk_A clknet_2_3__leaf_clk vssd1 vssd1 vccd1 vccd1 sky130_fd_sc_hd__diode_2
XANTENNA__1450__B _0578_ vssd1 vssd1 vccd1 vccd1 sky130_fd_sc_hd__diode_2
XANTENNA__2093__B1 net34 vssd1 vssd1 vccd1 vccd1 sky130_fd_sc_hd__diode_2
X_2771_ clknet_leaf_4_clk net436 vssd1 vssd1 vccd1 vccd1 CALC_INST.gencon_inst.mult_calc.INn2\[0\]
+ sky130_fd_sc_hd__dfxtp_1
X_2840_ clknet_leaf_3_clk _0016_ net85 vssd1 vssd1 vccd1 vccd1 CALC_INST.input_ctrl_inst.debounce_cnt\[17\]
+ sky130_fd_sc_hd__dfrtp_1
Xhold128 CALC_INST.gencon_inst.add_calc.main.in2\[2\] vssd1 vssd1 vccd1 vccd1 net327
+ sky130_fd_sc_hd__dlygate4sd3_1
X_1722_ CALC_INST.gencon_inst.ALU_in1\[12\] CALC_INST.gencon_inst.ALU_in2\[12\] net61
+ vssd1 vssd1 vccd1 vccd1 _0761_ sky130_fd_sc_hd__mux2_1
Xhold117 CALC_INST.gencon_inst.ALU_in2\[2\] vssd1 vssd1 vccd1 vccd1 net316 sky130_fd_sc_hd__dlygate4sd3_1
X_1584_ CALC_INST.gencon_inst.read_input _0656_ vssd1 vssd1 vccd1 vccd1 _0713_ sky130_fd_sc_hd__nand2_2
X_1653_ net221 _0729_ net44 vssd1 vssd1 vccd1 vccd1 _0165_ sky130_fd_sc_hd__mux2_1
Xhold139 CALC_INST.gencon_inst.mult_calc.adderSave\[1\] vssd1 vssd1 vccd1 vccd1 net338
+ sky130_fd_sc_hd__dlygate4sd3_1
Xhold106 CALC_INST.gencon_inst.mult_calc.count.GENERATE_ADDER\[12\].thingy.in1 vssd1
+ vssd1 vccd1 vccd1 net305 sky130_fd_sc_hd__dlygate4sd3_1
XPHY_EDGE_ROW_9_Right_9 vssd1 vssd1 vccd1 vccd1 sky130_fd_sc_hd__decap_3
X_2205_ CALC_INST.input_ctrl_inst.debounce_cnt\[5\] CALC_INST.input_ctrl_inst.debounce_cnt\[7\]
+ CALC_INST.input_ctrl_inst.debounce_cnt\[6\] CALC_INST.input_ctrl_inst.debounce_cnt\[8\]
+ vssd1 vssd1 vccd1 vccd1 _1065_ sky130_fd_sc_hd__o31a_1
XTAP_TAPCELL_ROW_64_597 vssd1 vccd1 sky130_fd_sc_hd__tapvpwrvgnd_1
XTAP_TAPCELL_ROW_64_586 vssd1 vccd1 sky130_fd_sc_hd__tapvpwrvgnd_1
X_2136_ net501 net155 _1016_ _1018_ vssd1 vssd1 vccd1 vccd1 _0359_ sky130_fd_sc_hd__a22o_1
XANTENNA__2084__B1 net34 vssd1 vssd1 vccd1 vccd1 sky130_fd_sc_hd__diode_2
X_2067_ net141 _1088_ _1098_ net129 net259 vssd1 vssd1 vccd1 vccd1 _0308_ sky130_fd_sc_hd__a32o_1
XFILLER_1_337 vccd1 vssd1 vccd1 vssd1 sky130_ef_sc_hd__decap_40_12
XANTENNA__2075__B1 net130 vssd1 vssd1 vccd1 vccd1 sky130_fd_sc_hd__diode_2
XFILLER_0_370 vccd1 vssd1 vccd1 vssd1 sky130_ef_sc_hd__decap_40_12
XFILLER_63_388 vssd1 vssd1 vccd1 vccd1 sky130_fd_sc_hd__fill_4
XANTENNA__1408__A3 net53 vssd1 vssd1 vccd1 vccd1 sky130_fd_sc_hd__diode_2
XTAP_TAPCELL_ROW_18_266 vssd1 vccd1 sky130_fd_sc_hd__tapvpwrvgnd_1
X_1705_ net347 _0752_ net151 vssd1 vssd1 vccd1 vccd1 _0194_ sky130_fd_sc_hd__mux2_1
XTAP_TAPCELL_ROW_61_567 vssd1 vccd1 sky130_fd_sc_hd__tapvpwrvgnd_1
X_2823_ clknet_leaf_33_clk _0008_ net88 vssd1 vssd1 vccd1 vccd1 CALC_INST.input_ctrl_inst.debounce_cnt\[0\]
+ sky130_fd_sc_hd__dfrtp_2
X_2754_ clknet_leaf_28_clk _0313_ net102 vssd1 vssd1 vccd1 vccd1 CALC_INST.gencon_inst.mult_calc.countSave\[7\]
+ sky130_fd_sc_hd__dfrtp_1
X_1636_ CALC_INST.gencon_inst.operand2\[15\] net255 net63 vssd1 vssd1 vccd1 vccd1
+ _0153_ sky130_fd_sc_hd__mux2_1
X_1567_ CALC_INST.gencon_inst.operand2\[14\] CALC_INST.gencon_inst.operand1\[14\]
+ _0646_ vssd1 vssd1 vccd1 vccd1 _0700_ sky130_fd_sc_hd__mux2_1
X_2685_ clknet_leaf_31_clk _0244_ net92 vssd1 vssd1 vccd1 vccd1 CALC_INST.gencon_inst.mult_calc.main.GENERATE_ADDER\[2\].thingy.in1
+ sky130_fd_sc_hd__dfrtp_1
XFILLER_64_29 vssd1 vssd1 vccd1 vccd1 sky130_fd_sc_hd__fill_8
X_1498_ CALC_INST.gencon_inst.gencon_state\[3\] CALC_INST.gencon_inst.gencon_state\[2\]
+ _0644_ vssd1 vssd1 vccd1 vccd1 _0646_ sky130_fd_sc_hd__or3_2
X_2119_ CALC_INST.input_ctrl_inst.decoded_key\[0\] CALC_INST.input_ctrl_inst.decoded_key\[2\]
+ _1006_ _1007_ _1004_ vssd1 vssd1 vccd1 vccd1 _1008_ sky130_fd_sc_hd__o221ai_1
XTAP_TAPCELL_ROW_1_145 vssd1 vccd1 sky130_fd_sc_hd__tapvpwrvgnd_1
XTAP_TAPCELL_ROW_52_501 vssd1 vccd1 sky130_fd_sc_hd__tapvpwrvgnd_1
Xfanout67 _0662_ vssd1 vssd1 vccd1 vccd1 net67 sky130_fd_sc_hd__buf_2
Xfanout45 _0496_ vssd1 vssd1 vccd1 vccd1 net45 sky130_fd_sc_hd__buf_2
Xfanout78 _0488_ vssd1 vssd1 vccd1 vccd1 net78 sky130_fd_sc_hd__clkbuf_2
Xfanout34 _1001_ vssd1 vssd1 vccd1 vccd1 net34 sky130_fd_sc_hd__clkbuf_4
XFILLER_10_403 vssd1 vssd1 vccd1 vccd1 sky130_fd_sc_hd__fill_1
Xfanout89 net90 vssd1 vssd1 vccd1 vccd1 net89 sky130_fd_sc_hd__clkbuf_2
XTAP_TAPCELL_ROW_9_201 vssd1 vccd1 sky130_fd_sc_hd__tapvpwrvgnd_1
XFILLER_60_314 vssd1 vssd1 vccd1 vccd1 sky130_fd_sc_hd__fill_8
XFILLER_38_85 vssd1 vssd1 vccd1 vccd1 sky130_fd_sc_hd__fill_2
Xclkload15 clknet_leaf_12_clk vssd1 vssd1 vccd1 vccd1 clkload15/Y sky130_fd_sc_hd__clkinvlp_4
Xclkload26 clknet_leaf_17_clk vssd1 vssd1 vccd1 vccd1 clkload26/Y sky130_fd_sc_hd__inv_6
XTAP_TAPCELL_ROW_15_247 vssd1 vccd1 sky130_fd_sc_hd__tapvpwrvgnd_1
X_2470_ clknet_leaf_11_clk net150 net97 vssd1 vssd1 vccd1 vccd1 CALC_INST.gencon_inst.add_calc.state\[1\]
+ sky130_fd_sc_hd__dfrtp_4
XFILLER_48_5 vssd1 vssd1 vccd1 vccd1 sky130_fd_sc_hd__fill_4
XANTENNA__1890__S net143 vssd1 vssd1 vccd1 vccd1 sky130_fd_sc_hd__diode_2
X_1421_ _1227_ net79 _0593_ vssd1 vssd1 vccd1 vccd1 _0594_ sky130_fd_sc_hd__o21ba_1
XFILLER_48_193 vssd1 vssd1 vccd1 vccd1 sky130_fd_sc_hd__fill_2
X_1352_ CALC_INST.gencon_inst.operand1\[8\] _0533_ _0538_ vssd1 vssd1 vccd1 vccd1
+ _0539_ sky130_fd_sc_hd__o21a_1
X_1283_ CALC_INST.gencon_inst.operand2\[13\] _0476_ vssd1 vssd1 vccd1 vccd1 _0480_
+ sky130_fd_sc_hd__or2_1
XANTENNA__2039__B1 net126 vssd1 vssd1 vccd1 vccd1 sky130_fd_sc_hd__diode_2
XFILLER_51_303 vssd1 vssd1 vccd1 vccd1 sky130_fd_sc_hd__fill_1
X_2737_ clknet_leaf_16_clk _0296_ net115 vssd1 vssd1 vccd1 vccd1 CALC_INST.gencon_inst.ALU_out\[6\]
+ sky130_fd_sc_hd__dfrtp_1
XANTENNA__1565__A2 _0660_ vssd1 vssd1 vccd1 vccd1 sky130_fd_sc_hd__diode_2
Xclkload9 clknet_leaf_6_clk vssd1 vssd1 vccd1 vccd1 clkload9/Y sky130_fd_sc_hd__clkinv_2
X_2806_ clknet_leaf_2_clk net2 net84 vssd1 vssd1 vccd1 vccd1 CALC_INST.input_ctrl_inst.RowMid\[0\]
+ sky130_fd_sc_hd__dfstp_1
X_2668_ clknet_leaf_32_clk net298 net89 vssd1 vssd1 vccd1 vccd1 CALC_INST.gencon_inst.mult_calc.compCount.in2\[0\]
+ sky130_fd_sc_hd__dfrtp_1
XFILLER_59_18 vssd1 vssd1 vccd1 vccd1 sky130_fd_sc_hd__fill_2
X_2599_ clknet_leaf_11_clk net266 vssd1 vssd1 vccd1 vccd1 CALC_INST.gencon_inst.addOrSub
+ sky130_fd_sc_hd__dfxtp_1
X_1619_ CALC_INST.gencon_inst.operand1\[14\] net268 net65 vssd1 vssd1 vccd1 vccd1
+ _0136_ sky130_fd_sc_hd__mux2_1
XANTENNA_input2_A gpio_in[0] vssd1 vssd1 vccd1 vccd1 sky130_fd_sc_hd__diode_2
XFILLER_54_141 vssd1 vssd1 vccd1 vccd1 sky130_fd_sc_hd__fill_2
XFILLER_27_333 vssd1 vssd1 vccd1 vccd1 sky130_fd_sc_hd__fill_1
XFILLER_6_204 vssd1 vssd1 vccd1 vccd1 sky130_fd_sc_hd__fill_1
XFILLER_10_255 vssd1 vssd1 vccd1 vccd1 sky130_fd_sc_hd__fill_4
XTAP_TAPCELL_ROW_20_283 vssd1 vccd1 sky130_fd_sc_hd__tapvpwrvgnd_1
XFILLER_49_51 vssd1 vssd1 vccd1 vccd1 sky130_fd_sc_hd__fill_4
X_1970_ _0886_ _0920_ vssd1 vssd1 vccd1 vccd1 _0921_ sky130_fd_sc_hd__nor2_1
XPHY_EDGE_ROW_23_Left_88 vssd1 vssd1 vccd1 vccd1 sky130_fd_sc_hd__decap_3
XFILLER_53_3 vccd1 vssd1 vccd1 vssd1 sky130_ef_sc_hd__decap_40_12
XFILLER_41_391 vssd1 vssd1 vccd1 vccd1 sky130_fd_sc_hd__fill_1
X_2522_ clknet_leaf_34_clk _0081_ net82 vssd1 vssd1 vccd1 vccd1 CALC_INST.input_ctrl_inst.col_index\[19\]
+ sky130_fd_sc_hd__dfrtp_1
X_1335_ CALC_INST.gencon_inst.ALU_out\[5\] net76 net69 CALC_INST.gencon_inst.mult_calc.out\[5\]
+ vssd1 vssd1 vccd1 vccd1 _0525_ sky130_fd_sc_hd__a22o_1
X_2453_ _0416_ _0423_ vssd1 vssd1 vccd1 vccd1 _0424_ sky130_fd_sc_hd__nor2_1
X_2384_ CALC_INST.input_ctrl_inst.debounce_cnt\[16\] _1212_ vssd1 vssd1 vccd1 vccd1
+ _1215_ sky130_fd_sc_hd__or2_1
X_1404_ _0570_ _0581_ vssd1 vssd1 vccd1 vccd1 _0582_ sky130_fd_sc_hd__and2_1
XFILLER_56_406 vssd1 vssd1 vccd1 vccd1 sky130_fd_sc_hd__fill_1
XFILLER_51_111 vssd1 vssd1 vccd1 vccd1 sky130_fd_sc_hd__fill_1
XFILLER_36_163 vssd1 vssd1 vccd1 vccd1 sky130_fd_sc_hd__fill_2
XFILLER_36_141 vssd1 vssd1 vccd1 vccd1 sky130_fd_sc_hd__fill_2
X_1266_ CALC_INST.gencon_inst.operand2\[9\] _0464_ vssd1 vssd1 vccd1 vccd1 _0467_
+ sky130_fd_sc_hd__nand2_1
Xinput2 gpio_in[0] vssd1 vssd1 vccd1 vccd1 net2 sky130_fd_sc_hd__clkbuf_1
XTAP_TAPCELL_ROW_34_375 vssd1 vccd1 sky130_fd_sc_hd__tapvpwrvgnd_1
XFILLER_59_222 vssd1 vssd1 vccd1 vccd1 sky130_fd_sc_hd__fill_2
XANTENNA_fanout60_A net62 vssd1 vssd1 vccd1 vccd1 sky130_fd_sc_hd__diode_2
XFILLER_47_406 vssd1 vssd1 vccd1 vccd1 sky130_fd_sc_hd__fill_1
XFILLER_19_54 vssd1 vssd1 vccd1 vccd1 sky130_fd_sc_hd__fill_2
XFILLER_42_166 vssd1 vssd1 vccd1 vccd1 sky130_fd_sc_hd__fill_2
XFILLER_42_144 vssd1 vssd1 vccd1 vccd1 sky130_fd_sc_hd__fill_1
XFILLER_35_64 vssd1 vssd1 vccd1 vccd1 sky130_fd_sc_hd__fill_1
XFILLER_15_314 vssd1 vssd1 vccd1 vccd1 sky130_fd_sc_hd__fill_1
XFILLER_2_273 vccd1 vssd1 vccd1 vssd1 sky130_ef_sc_hd__decap_40_12
XFILLER_2_251 vssd1 vssd1 vccd1 vccd1 sky130_fd_sc_hd__fill_1
XTAP_TAPCELL_ROW_48_478 vssd1 vccd1 sky130_fd_sc_hd__tapvpwrvgnd_1
XFILLER_18_141 vssd1 vssd1 vccd1 vccd1 sky130_fd_sc_hd__fill_4
X_1953_ net145 CALC_INST.gencon_inst.add_calc.main.in2\[2\] vssd1 vssd1 vccd1 vccd1
+ _0904_ sky130_fd_sc_hd__or2_1
XTAP_TAPCELL_ROW_31_356 vssd1 vccd1 sky130_fd_sc_hd__tapvpwrvgnd_1
X_1884_ net136 net332 net125 net342 vssd1 vssd1 vccd1 vccd1 _0271_ sky130_fd_sc_hd__a22o_1
XFILLER_21_328 vssd1 vssd1 vccd1 vccd1 sky130_fd_sc_hd__fill_1
XANTENNA__2649__RESET_B net99 vssd1 vssd1 vccd1 vccd1 sky130_fd_sc_hd__diode_2
X_2505_ clknet_leaf_1_clk _0064_ net83 vssd1 vssd1 vccd1 vccd1 CALC_INST.input_ctrl_inst.col_index\[2\]
+ sky130_fd_sc_hd__dfrtp_2
X_1318_ _0501_ _0503_ _0507_ _0509_ vssd1 vssd1 vccd1 vccd1 _0511_ sky130_fd_sc_hd__o211a_1
XTAP_TAPCELL_ROW_39_412 vssd1 vccd1 sky130_fd_sc_hd__tapvpwrvgnd_1
XANTENNA__1644__A net155 vssd1 vssd1 vccd1 vccd1 sky130_fd_sc_hd__diode_2
X_2298_ CALC_INST.input_ctrl_inst.decoded_key\[1\] CALC_INST.input_ctrl_inst.decoded_key\[0\]
+ vssd1 vssd1 vccd1 vccd1 _1150_ sky130_fd_sc_hd__nand2_1
X_2367_ CALC_INST.input_ctrl_inst.debounce_cnt\[12\] _1198_ net39 vssd1 vssd1 vccd1
+ vccd1 _1202_ sky130_fd_sc_hd__o21ai_1
X_2436_ CALC_INST.input_ctrl_inst.col_index\[0\] _0411_ CALC_INST.input_ctrl_inst.col_index\[1\]
+ vssd1 vssd1 vccd1 vccd1 net28 sky130_fd_sc_hd__or3b_1
X_1249_ CALC_INST.gencon_inst.operand2\[5\] _0450_ vssd1 vssd1 vccd1 vccd1 _0454_
+ sky130_fd_sc_hd__nor2_1
XFILLER_24_144 vssd1 vssd1 vccd1 vccd1 sky130_fd_sc_hd__fill_8
XFILLER_12_306 vssd1 vssd1 vccd1 vccd1 sky130_fd_sc_hd__fill_2
XFILLER_21_55 vssd1 vssd1 vccd1 vccd1 sky130_fd_sc_hd__fill_1
XFILLER_47_225 vssd1 vssd1 vccd1 vccd1 sky130_fd_sc_hd__fill_1
XFILLER_46_74 vssd1 vssd1 vccd1 vccd1 sky130_fd_sc_hd__fill_1
XFILLER_62_73 vssd1 vssd1 vccd1 vccd1 sky130_fd_sc_hd__fill_8
XFILLER_30_169 vssd1 vssd1 vccd1 vccd1 sky130_fd_sc_hd__fill_2
XFILLER_30_136 vssd1 vssd1 vccd1 vccd1 sky130_fd_sc_hd__fill_4
XFILLER_11_372 vssd1 vssd1 vccd1 vccd1 sky130_fd_sc_hd__fill_1
X_2152_ net380 _1027_ vssd1 vssd1 vccd1 vccd1 _0366_ sky130_fd_sc_hd__xnor2_1
X_2221_ CALC_INST.input_ctrl_inst.input_control_state\[1\] CALC_INST.input_ctrl_inst.input_control_state\[3\]
+ CALC_INST.input_ctrl_inst.input_control_state\[2\] CALC_INST.input_ctrl_inst.input_control_state\[0\]
+ vssd1 vssd1 vccd1 vccd1 _1080_ sky130_fd_sc_hd__or4b_2
XFILLER_16_3 vccd1 vssd1 vccd1 vssd1 sky130_ef_sc_hd__decap_40_12
XFILLER_53_239 vssd1 vssd1 vccd1 vccd1 sky130_fd_sc_hd__fill_2
X_2083_ net345 net44 _1002_ CALC_INST.gencon_inst.operand2\[1\] vssd1 vssd1 vccd1
+ vccd1 _0322_ sky130_fd_sc_hd__o22a_1
XFILLER_21_103 vssd1 vssd1 vccd1 vccd1 sky130_fd_sc_hd__fill_2
X_1936_ CALC_INST.gencon_inst.add_calc.main.GENERATE_ADDER\[7\].thingy.in1 _0884_
+ _0885_ vssd1 vssd1 vccd1 vccd1 _0887_ sky130_fd_sc_hd__nand3_1
X_1867_ net225 net206 net140 vssd1 vssd1 vccd1 vccd1 _0255_ sky130_fd_sc_hd__mux2_1
XPHY_EDGE_ROW_26_Left_91 vssd1 vssd1 vccd1 vccd1 sky130_fd_sc_hd__decap_3
XANTENNA__1374__B1 _0491_ vssd1 vssd1 vccd1 vccd1 sky130_fd_sc_hd__diode_2
X_1798_ CALC_INST.gencon_inst.mult_calc.main.GENERATE_ADDER\[8\].thingy.in2 CALC_INST.gencon_inst.mult_calc.main.GENERATE_ADDER\[8\].thingy.in1
+ vssd1 vssd1 vccd1 vccd1 _0820_ sky130_fd_sc_hd__nand2_1
XPHY_EDGE_ROW_10_Left_75 vssd1 vssd1 vccd1 vccd1 sky130_fd_sc_hd__decap_3
X_2419_ CALC_INST.input_ctrl_inst.col_index\[23\] _1228_ _0396_ _0398_ vssd1 vssd1
+ vccd1 vccd1 _0399_ sky130_fd_sc_hd__or4b_1
XFILLER_16_77 vssd1 vssd1 vccd1 vccd1 sky130_fd_sc_hd__fill_4
XFILLER_4_346 vssd1 vssd1 vccd1 vccd1 sky130_fd_sc_hd__fill_2
XANTENNA__2093__B2 CALC_INST.gencon_inst.operand2\[11\] vssd1 vssd1 vccd1 vccd1 sky130_fd_sc_hd__diode_2
X_1721_ net354 _0760_ net153 vssd1 vssd1 vccd1 vccd1 _0202_ sky130_fd_sc_hd__mux2_1
X_2770_ clknet_leaf_2_clk net201 net83 vssd1 vssd1 vccd1 vccd1 CALC_INST.input_ctrl_inst.RowSync\[3\]
+ sky130_fd_sc_hd__dfstp_1
Xhold118 CALC_INST.gencon_inst.add_calc.next_finish vssd1 vssd1 vccd1 vccd1 net317
+ sky130_fd_sc_hd__dlygate4sd3_1
Xhold107 CALC_INST.gencon_inst.ALU_in1\[1\] vssd1 vssd1 vccd1 vccd1 net306 sky130_fd_sc_hd__dlygate4sd3_1
XANTENNA__1356__B1 _0490_ vssd1 vssd1 vccd1 vccd1 sky130_fd_sc_hd__diode_2
X_1583_ CALC_INST.gencon_inst.gencon_state\[3\] _0644_ _0654_ _0493_ vssd1 vssd1 vccd1
+ vccd1 _0712_ sky130_fd_sc_hd__o211a_1
X_1652_ CALC_INST.gencon_inst.operand2\[6\] CALC_INST.gencon_inst.operand1\[6\] _0646_
+ vssd1 vssd1 vccd1 vccd1 _0729_ sky130_fd_sc_hd__mux2_1
Xhold129 CALC_INST.input_ctrl_inst.input_control_state\[1\] vssd1 vssd1 vccd1 vccd1
+ net328 sky130_fd_sc_hd__dlygate4sd3_1
X_2135_ net500 net155 _1018_ _1057_ vssd1 vssd1 vccd1 vccd1 _0358_ sky130_fd_sc_hd__a22o_1
X_2204_ CALC_INST.input_ctrl_inst.debounce_cnt\[15\] CALC_INST.input_ctrl_inst.debounce_cnt\[17\]
+ CALC_INST.input_ctrl_inst.debounce_cnt\[16\] CALC_INST.input_ctrl_inst.debounce_cnt\[18\]
+ vssd1 vssd1 vccd1 vccd1 _1064_ sky130_fd_sc_hd__and4_1
XTAP_TAPCELL_ROW_64_598 vssd1 vccd1 sky130_fd_sc_hd__tapvpwrvgnd_1
XTAP_TAPCELL_ROW_64_587 vssd1 vccd1 sky130_fd_sc_hd__tapvpwrvgnd_1
XFILLER_34_294 vssd1 vssd1 vccd1 vccd1 sky130_fd_sc_hd__fill_1
XFILLER_34_283 vssd1 vssd1 vccd1 vccd1 sky130_fd_sc_hd__fill_1
XFILLER_34_250 vssd1 vssd1 vccd1 vccd1 sky130_fd_sc_hd__fill_2
X_2066_ net127 _1101_ net129 net281 vssd1 vssd1 vccd1 vccd1 _0307_ sky130_fd_sc_hd__a2bb2o_1
X_1919_ _0868_ _0869_ CALC_INST.gencon_inst.add_calc.main.GENERATE_ADDER\[11\].thingy.in1
+ vssd1 vssd1 vccd1 vccd1 _0870_ sky130_fd_sc_hd__a21oi_1
XFILLER_57_320 vssd1 vssd1 vccd1 vccd1 sky130_fd_sc_hd__fill_2
XFILLER_1_349 vccd1 vssd1 vccd1 vssd1 sky130_ef_sc_hd__decap_40_12
XFILLER_1_305 vccd1 vssd1 vccd1 vssd1 sky130_ef_sc_hd__decap_40_12
XTAP_TAPCELL_ROW_4_165 vssd1 vccd1 sky130_fd_sc_hd__tapvpwrvgnd_1
XFILLER_43_53 vssd1 vssd1 vccd1 vccd1 sky130_fd_sc_hd__fill_2
XANTENNA__2302__A2 CALC_INST.input_ctrl_inst.key_pressed vssd1 vssd1 vccd1 vccd1 sky130_fd_sc_hd__diode_2
XFILLER_0_393 vssd1 vssd1 vccd1 vccd1 sky130_fd_sc_hd__fill_8
XFILLER_0_382 vssd1 vssd1 vccd1 vccd1 sky130_fd_sc_hd__fill_4
XFILLER_63_323 vssd1 vssd1 vccd1 vccd1 sky130_fd_sc_hd__fill_4
XTAP_TAPCELL_ROW_61_568 vssd1 vccd1 sky130_fd_sc_hd__tapvpwrvgnd_1
XANTENNA__1888__S net143 vssd1 vssd1 vccd1 vccd1 sky130_fd_sc_hd__diode_2
XTAP_TAPCELL_ROW_18_267 vssd1 vccd1 sky130_fd_sc_hd__tapvpwrvgnd_1
X_1704_ CALC_INST.gencon_inst.ALU_in1\[3\] CALC_INST.gencon_inst.ALU_in2\[3\] net59
+ vssd1 vssd1 vccd1 vccd1 _0752_ sky130_fd_sc_hd__mux2_1
X_2822_ clknet_leaf_5_clk _0360_ vssd1 vssd1 vccd1 vccd1 CALC_INST.equal_input sky130_fd_sc_hd__dfxtp_1
X_2684_ clknet_leaf_4_clk _0243_ net92 vssd1 vssd1 vccd1 vccd1 CALC_INST.gencon_inst.mult_calc.main.GENERATE_ADDER\[1\].thingy.in1
+ sky130_fd_sc_hd__dfrtp_1
X_2753_ clknet_leaf_29_clk _0312_ net102 vssd1 vssd1 vccd1 vccd1 CALC_INST.gencon_inst.mult_calc.countSave\[6\]
+ sky130_fd_sc_hd__dfrtp_1
X_1635_ CALC_INST.gencon_inst.operand2\[14\] net256 net65 vssd1 vssd1 vccd1 vccd1
+ _0152_ sky130_fd_sc_hd__mux2_1
X_1566_ net468 net78 net68 CALC_INST.gencon_inst.mult_calc.out\[13\] _0699_ vssd1
+ vssd1 vccd1 vccd1 _0108_ sky130_fd_sc_hd__a221o_1
X_1497_ net149 net148 _0489_ vssd1 vssd1 vccd1 vccd1 _0645_ sky130_fd_sc_hd__and3_1
X_2049_ _0977_ _0979_ _0984_ vssd1 vssd1 vccd1 vccd1 _0989_ sky130_fd_sc_hd__or3_1
XFILLER_54_323 vssd1 vssd1 vccd1 vccd1 sky130_fd_sc_hd__fill_1
X_2118_ CALC_INST.input_ctrl_inst.decoded_key\[0\] _1057_ vssd1 vssd1 vccd1 vccd1
+ _1007_ sky130_fd_sc_hd__nand2_1
XTAP_TAPCELL_ROW_1_146 vssd1 vccd1 sky130_fd_sc_hd__tapvpwrvgnd_1
XANTENNA_clkbuf_leaf_18_clk_A clknet_2_3__leaf_clk vssd1 vssd1 vccd1 vccd1 sky130_fd_sc_hd__diode_2
XTAP_TAPCELL_ROW_52_502 vssd1 vccd1 sky130_fd_sc_hd__tapvpwrvgnd_1
Xfanout46 _0496_ vssd1 vssd1 vccd1 vccd1 net46 sky130_fd_sc_hd__clkbuf_2
Xfanout68 _0662_ vssd1 vssd1 vccd1 vccd1 net68 sky130_fd_sc_hd__dlymetal6s2s_1
Xfanout35 _1001_ vssd1 vssd1 vccd1 vccd1 net35 sky130_fd_sc_hd__dlymetal6s2s_1
XTAP_TAPCELL_ROW_9_202 vssd1 vccd1 sky130_fd_sc_hd__tapvpwrvgnd_1
XFILLER_13_67 vccd1 vssd1 vccd1 vssd1 sky130_ef_sc_hd__decap_40_12
XANTENNA_fanout90_A net93 vssd1 vssd1 vccd1 vccd1 sky130_fd_sc_hd__diode_2
XFILLER_64_109 vssd1 vssd1 vccd1 vccd1 sky130_fd_sc_hd__fill_2
XFILLER_60_359 vssd1 vssd1 vccd1 vccd1 sky130_fd_sc_hd__fill_4
XTAP_TAPCELL_ROW_15_248 vssd1 vccd1 sky130_fd_sc_hd__tapvpwrvgnd_1
Xclkload27 clknet_leaf_18_clk vssd1 vssd1 vccd1 vccd1 clkload27/Y sky130_fd_sc_hd__inv_12
XANTENNA__1296__X _0491_ vssd1 vssd1 vccd1 vccd1 sky130_fd_sc_hd__diode_2
XANTENNA__1271__A2 net49 vssd1 vssd1 vccd1 vccd1 sky130_fd_sc_hd__diode_2
Xclkload16 clknet_leaf_24_clk vssd1 vssd1 vccd1 vccd1 clkload16/X sky130_fd_sc_hd__clkbuf_8
X_1351_ _0491_ _0537_ vssd1 vssd1 vccd1 vccd1 _0538_ sky130_fd_sc_hd__nor2_1
X_1420_ CALC_INST.input_ctrl_inst.col_index\[4\] _1228_ _1229_ vssd1 vssd1 vccd1 vccd1
+ _0593_ sky130_fd_sc_hd__a21oi_1
XFILLER_36_356 vssd1 vssd1 vccd1 vccd1 sky130_fd_sc_hd__fill_1
XFILLER_36_334 vccd1 vssd1 vccd1 vssd1 sky130_ef_sc_hd__decap_40_12
X_1282_ CALC_INST.gencon_inst.operand2\[13\] _0476_ vssd1 vssd1 vccd1 vccd1 _0479_
+ sky130_fd_sc_hd__nand2_1
XANTENNA__2287__A1 net141 vssd1 vssd1 vccd1 vccd1 sky130_fd_sc_hd__diode_2
XFILLER_51_315 vssd1 vssd1 vccd1 vccd1 sky130_fd_sc_hd__fill_1
X_2805_ clknet_leaf_27_clk _0351_ net108 vssd1 vssd1 vccd1 vccd1 CALC_INST.gencon_inst.mult_calc.count.GENERATE_ADDER\[14\].thingy.in1
+ sky130_fd_sc_hd__dfrtp_1
X_2736_ clknet_leaf_15_clk _0295_ net115 vssd1 vssd1 vccd1 vccd1 CALC_INST.gencon_inst.ALU_out\[5\]
+ sky130_fd_sc_hd__dfrtp_1
X_1618_ CALC_INST.gencon_inst.operand1\[13\] net249 net66 vssd1 vssd1 vccd1 vccd1
+ _0135_ sky130_fd_sc_hd__mux2_1
X_2667_ clknet_leaf_24_clk _0226_ net109 vssd1 vssd1 vccd1 vccd1 CALC_INST.gencon_inst.mult_calc.adderSave\[14\]
+ sky130_fd_sc_hd__dfrtp_1
XFILLER_46_109 vssd1 vssd1 vccd1 vccd1 sky130_fd_sc_hd__fill_2
X_2598_ clknet_leaf_7_clk net215 vssd1 vssd1 vccd1 vccd1 CALC_INST.gencon_inst.prev_operator_input\[2\]
+ sky130_fd_sc_hd__dfxtp_1
X_1549_ CALC_INST.gencon_inst.ALU_out\[9\] net77 net67 CALC_INST.gencon_inst.mult_calc.out\[9\]
+ vssd1 vssd1 vccd1 vccd1 _0687_ sky130_fd_sc_hd__a22o_1
XFILLER_42_315 vssd1 vssd1 vccd1 vccd1 sky130_fd_sc_hd__fill_1
XANTENNA__2450__A1 net71 vssd1 vssd1 vccd1 vccd1 sky130_fd_sc_hd__diode_2
Xhold290 CALC_INST.gencon_inst.add_calc.main.in2\[0\] vssd1 vssd1 vccd1 vccd1 net489
+ sky130_fd_sc_hd__dlygate4sd3_1
XFILLER_49_30 vssd1 vssd1 vccd1 vccd1 sky130_fd_sc_hd__fill_4
XFILLER_40_76 vssd1 vssd1 vccd1 vccd1 sky130_fd_sc_hd__fill_2
XANTENNA_fanout93_X net93 vssd1 vssd1 vccd1 vccd1 sky130_fd_sc_hd__diode_2
XFILLER_60_156 vssd1 vssd1 vccd1 vccd1 sky130_fd_sc_hd__fill_1
XFILLER_45_186 vssd1 vssd1 vccd1 vccd1 sky130_fd_sc_hd__fill_1
XANTENNA__2062__S CALC_INST.gencon_inst.add_calc.state\[1\] vssd1 vssd1 vccd1 vccd1
+ sky130_fd_sc_hd__diode_2
X_2521_ clknet_leaf_35_clk _0080_ net82 vssd1 vssd1 vccd1 vccd1 CALC_INST.input_ctrl_inst.col_index\[18\]
+ sky130_fd_sc_hd__dfrtp_1
XFILLER_46_3 vssd1 vssd1 vccd1 vccd1 sky130_fd_sc_hd__fill_2
X_1334_ CALC_INST.gencon_inst.operand1\[4\] net47 _0523_ _0524_ vssd1 vssd1 vccd1
+ vccd1 _0051_ sky130_fd_sc_hd__o22a_1
X_2452_ net148 net149 vssd1 vssd1 vccd1 vccd1 _0423_ sky130_fd_sc_hd__nand2b_1
X_1265_ CALC_INST.gencon_inst.operand2\[8\] _0466_ net36 vssd1 vssd1 vccd1 vccd1 _0040_
+ sky130_fd_sc_hd__mux2_1
X_2383_ CALC_INST.input_ctrl_inst.debounce_cnt\[16\] _1212_ vssd1 vssd1 vccd1 vccd1
+ _1214_ sky130_fd_sc_hd__nand2_1
X_1403_ _1061_ _0391_ _0410_ _0412_ vssd1 vssd1 vccd1 vccd1 _0581_ sky130_fd_sc_hd__nand4_2
XPHY_EDGE_ROW_18_Right_18 vssd1 vssd1 vccd1 vccd1 sky130_fd_sc_hd__decap_3
XFILLER_36_153 vssd1 vssd1 vccd1 vccd1 sky130_fd_sc_hd__fill_4
XPHY_EDGE_ROW_27_Right_27 vssd1 vssd1 vccd1 vccd1 sky130_fd_sc_hd__decap_3
Xinput3 gpio_in[1] vssd1 vssd1 vccd1 vccd1 net3 sky130_fd_sc_hd__clkbuf_1
XTAP_TAPCELL_ROW_34_376 vssd1 vccd1 sky130_fd_sc_hd__tapvpwrvgnd_1
XANTENNA_fanout140_A CALC_INST.gencon_inst.mult_calc.state\[3\] vssd1 vssd1 vccd1
+ vccd1 sky130_fd_sc_hd__diode_2
XPHY_EDGE_ROW_36_Right_36 vssd1 vssd1 vccd1 vccd1 sky130_fd_sc_hd__decap_3
XFILLER_10_79 vssd1 vssd1 vccd1 vccd1 sky130_fd_sc_hd__fill_2
X_2719_ clknet_leaf_30_clk _0278_ net105 vssd1 vssd1 vccd1 vccd1 CALC_INST.gencon_inst.mult_calc.out\[5\]
+ sky130_fd_sc_hd__dfrtp_1
XPHY_EDGE_ROW_45_Right_45 vssd1 vssd1 vccd1 vccd1 sky130_fd_sc_hd__decap_3
XFILLER_42_189 vssd1 vssd1 vccd1 vccd1 sky130_fd_sc_hd__fill_2
XFILLER_15_337 vssd1 vssd1 vccd1 vccd1 sky130_fd_sc_hd__fill_2
XPHY_EDGE_ROW_54_Right_54 vssd1 vssd1 vccd1 vccd1 sky130_fd_sc_hd__decap_3
XFILLER_51_42 vssd1 vssd1 vccd1 vccd1 sky130_fd_sc_hd__fill_2
XFILLER_2_285 vssd1 vssd1 vccd1 vccd1 sky130_fd_sc_hd__fill_2
XPHY_EDGE_ROW_63_Right_63 vssd1 vssd1 vccd1 vccd1 sky130_fd_sc_hd__decap_3
XANTENNA__2057__S CALC_INST.gencon_inst.add_calc.state\[1\] vssd1 vssd1 vccd1 vccd1
+ sky130_fd_sc_hd__diode_2
XTAP_TAPCELL_ROW_48_479 vssd1 vccd1 sky130_fd_sc_hd__tapvpwrvgnd_1
XPHY_EDGE_ROW_38_Left_103 vssd1 vssd1 vccd1 vccd1 sky130_fd_sc_hd__decap_3
XFILLER_33_145 vssd1 vssd1 vccd1 vccd1 sky130_fd_sc_hd__fill_1
XFILLER_18_7 vssd1 vssd1 vccd1 vccd1 sky130_fd_sc_hd__fill_2
XFILLER_18_197 vssd1 vssd1 vccd1 vccd1 sky130_fd_sc_hd__fill_1
X_1952_ CALC_INST.gencon_inst.add_calc.main.GENERATE_ADDER\[3\].thingy.in1 _0900_
+ _0901_ vssd1 vssd1 vccd1 vccd1 _0903_ sky130_fd_sc_hd__nand3_1
XFILLER_33_167 vssd1 vssd1 vccd1 vccd1 sky130_fd_sc_hd__fill_1
XTAP_TAPCELL_ROW_31_357 vssd1 vccd1 sky130_fd_sc_hd__tapvpwrvgnd_1
X_1883_ net136 CALC_INST.gencon_inst.mult_calc.adderSave\[12\] net125 net330 vssd1
+ vssd1 vccd1 vccd1 _0270_ sky130_fd_sc_hd__a22o_1
XPHY_EDGE_ROW_47_Left_112 vssd1 vssd1 vccd1 vccd1 sky130_fd_sc_hd__decap_3
X_2435_ CALC_INST.input_ctrl_inst.col_index\[1\] _1060_ _0411_ vssd1 vssd1 vccd1 vccd1
+ net27 sky130_fd_sc_hd__or3_1
X_2504_ clknet_leaf_1_clk _0063_ net83 vssd1 vssd1 vccd1 vccd1 CALC_INST.input_ctrl_inst.col_index\[1\]
+ sky130_fd_sc_hd__dfrtp_2
XTAP_TAPCELL_ROW_39_413 vssd1 vccd1 sky130_fd_sc_hd__tapvpwrvgnd_1
X_1317_ _0507_ _0509_ _0501_ _0503_ vssd1 vssd1 vccd1 vccd1 _0510_ sky130_fd_sc_hd__a211o_1
X_1248_ CALC_INST.gencon_inst.operand2\[4\] net36 _0453_ vssd1 vssd1 vccd1 vccd1 _0036_
+ sky130_fd_sc_hd__o21a_1
X_2297_ _1068_ _1069_ vssd1 vssd1 vccd1 vccd1 _1149_ sky130_fd_sc_hd__nand2_1
X_2366_ CALC_INST.input_ctrl_inst.debounce_cnt\[12\] _1198_ vssd1 vssd1 vccd1 vccd1
+ _1201_ sky130_fd_sc_hd__and2_1
XFILLER_64_281 vccd1 vssd1 vccd1 vssd1 sky130_ef_sc_hd__decap_40_12
XPHY_EDGE_ROW_56_Left_121 vssd1 vssd1 vccd1 vccd1 sky130_fd_sc_hd__decap_3
XANTENNA__2102__B1 net122 vssd1 vssd1 vccd1 vccd1 sky130_fd_sc_hd__diode_2
XANTENNA_fanout143_X net143 vssd1 vssd1 vccd1 vccd1 sky130_fd_sc_hd__diode_2
XFILLER_46_64 vssd1 vssd1 vccd1 vccd1 sky130_fd_sc_hd__fill_2
XFILLER_15_123 vssd1 vssd1 vccd1 vccd1 sky130_fd_sc_hd__fill_4
XFILLER_62_85 vccd1 vssd1 vccd1 vssd1 sky130_ef_sc_hd__decap_40_12
XFILLER_62_52 vssd1 vssd1 vccd1 vccd1 sky130_fd_sc_hd__fill_2
XFILLER_7_377 vccd1 vssd1 vccd1 vssd1 sky130_ef_sc_hd__decap_40_12
X_2151_ CALC_INST.input_ctrl_inst.scan_timer\[4\] _1025_ _1027_ _1022_ vssd1 vssd1
+ vccd1 vccd1 _0365_ sky130_fd_sc_hd__o211a_1
X_2220_ CALC_INST.gencon_inst.key_read _1078_ vssd1 vssd1 vccd1 vccd1 _1079_ sky130_fd_sc_hd__nor2_1
X_2082_ net435 net42 net34 CALC_INST.gencon_inst.operand2\[0\] vssd1 vssd1 vccd1 vccd1
+ _0321_ sky130_fd_sc_hd__a22o_1
X_1935_ _0884_ _0885_ CALC_INST.gencon_inst.add_calc.main.GENERATE_ADDER\[7\].thingy.in1
+ vssd1 vssd1 vccd1 vccd1 _0886_ sky130_fd_sc_hd__a21oi_1
X_1866_ net262 net244 net140 vssd1 vssd1 vccd1 vccd1 _0254_ sky130_fd_sc_hd__mux2_1
X_1797_ CALC_INST.gencon_inst.mult_calc.main.GENERATE_ADDER\[8\].thingy.in2 CALC_INST.gencon_inst.mult_calc.main.GENERATE_ADDER\[8\].thingy.in1
+ vssd1 vssd1 vccd1 vccd1 _0819_ sky130_fd_sc_hd__nor2_1
X_2418_ CALC_INST.input_ctrl_inst.col_index\[21\] CALC_INST.input_ctrl_inst.col_index\[20\]
+ CALC_INST.input_ctrl_inst.col_index\[22\] _0397_ vssd1 vssd1 vccd1 vccd1 _0398_
+ sky130_fd_sc_hd__nor4_1
X_2349_ CALC_INST.input_ctrl_inst.debounce_cnt\[7\] _1186_ vssd1 vssd1 vccd1 vccd1
+ _1189_ sky130_fd_sc_hd__nand2_1
XANTENNA__1390__A net53 vssd1 vssd1 vccd1 vccd1 sky130_fd_sc_hd__diode_2
XPHY_EDGE_ROW_0_Right_0 vssd1 vssd1 vccd1 vccd1 sky130_fd_sc_hd__decap_3
XFILLER_12_126 vssd1 vssd1 vccd1 vccd1 sky130_fd_sc_hd__fill_1
XFILLER_43_295 vssd1 vssd1 vccd1 vccd1 sky130_fd_sc_hd__fill_2
XFILLER_43_273 vssd1 vssd1 vccd1 vccd1 sky130_fd_sc_hd__fill_4
XANTENNA__2093__A2 net42 vssd1 vssd1 vccd1 vccd1 sky130_fd_sc_hd__diode_2
X_1720_ CALC_INST.gencon_inst.ALU_in1\[11\] CALC_INST.gencon_inst.ALU_in2\[11\] net61
+ vssd1 vssd1 vccd1 vccd1 _0760_ sky130_fd_sc_hd__mux2_1
XTAP_TAPCELL_ROW_41_430 vssd1 vccd1 sky130_fd_sc_hd__tapvpwrvgnd_1
X_1651_ net213 _0674_ net43 vssd1 vssd1 vccd1 vccd1 _0164_ sky130_fd_sc_hd__mux2_1
Xhold108 CALC_INST.gencon_inst.mult_calc.countSave\[5\] vssd1 vssd1 vccd1 vccd1 net307
+ sky130_fd_sc_hd__dlygate4sd3_1
Xhold119 CALC_INST.gencon_inst.ALU_in1\[11\] vssd1 vssd1 vccd1 vccd1 net318 sky130_fd_sc_hd__dlygate4sd3_1
X_1582_ _0416_ _0644_ vssd1 vssd1 vccd1 vccd1 _0711_ sky130_fd_sc_hd__nor2_1
XFILLER_3_391 vssd1 vssd1 vccd1 vccd1 sky130_fd_sc_hd__fill_1
X_2203_ CALC_INST.gencon_inst.mult_calc.out\[15\] vssd1 vssd1 vccd1 vccd1 _1063_ sky130_fd_sc_hd__inv_2
X_2134_ CALC_INST.gencon_inst.operator_input\[0\] net155 _1018_ CALC_INST.input_ctrl_inst.decoded_key\[2\]
+ vssd1 vssd1 vccd1 vccd1 _0357_ sky130_fd_sc_hd__a22o_1
X_2065_ CALC_INST.gencon_inst.mult_calc.count.GENERATE_ADDER\[1\].thingy.cIn net127
+ net247 net129 vssd1 vssd1 vccd1 vccd1 _0306_ sky130_fd_sc_hd__a2bb2o_1
XTAP_TAPCELL_ROW_64_588 vssd1 vccd1 sky130_fd_sc_hd__tapvpwrvgnd_1
XFILLER_34_262 vssd1 vssd1 vccd1 vccd1 sky130_fd_sc_hd__fill_1
XANTENNA__2084__A2 net42 vssd1 vssd1 vccd1 vccd1 sky130_fd_sc_hd__diode_2
X_1918_ net147 CALC_INST.gencon_inst.add_calc.main.in2\[11\] vssd1 vssd1 vccd1 vccd1
+ _0869_ sky130_fd_sc_hd__nand2_1
X_1849_ net360 net351 net139 vssd1 vssd1 vccd1 vccd1 _0237_ sky130_fd_sc_hd__mux2_1
XTAP_TAPCELL_ROW_4_166 vssd1 vccd1 sky130_fd_sc_hd__tapvpwrvgnd_1
XFILLER_1_317 vccd1 vssd1 vccd1 vssd1 sky130_ef_sc_hd__decap_40_12
XTAP_TAPCELL_ROW_55_522 vssd1 vccd1 sky130_fd_sc_hd__tapvpwrvgnd_1
XFILLER_27_66 vssd1 vssd1 vccd1 vccd1 sky130_fd_sc_hd__fill_1
XFILLER_25_240 vssd1 vssd1 vccd1 vccd1 sky130_fd_sc_hd__fill_2
XFILLER_13_402 vssd1 vssd1 vccd1 vccd1 sky130_fd_sc_hd__fill_4
XANTENNA__1994__S net154 vssd1 vssd1 vccd1 vccd1 sky130_fd_sc_hd__diode_2
Xclkbuf_leaf_20_clk clknet_2_3__leaf_clk vssd1 vssd1 vccd1 vccd1 clknet_leaf_20_clk
+ sky130_fd_sc_hd__clkbuf_8
XFILLER_40_232 vssd1 vssd1 vccd1 vccd1 sky130_fd_sc_hd__fill_1
XFILLER_4_15 vssd1 vssd1 vccd1 vccd1 sky130_fd_sc_hd__fill_2
XTAP_TAPCELL_ROW_61_569 vssd1 vccd1 sky130_fd_sc_hd__tapvpwrvgnd_1
X_2821_ clknet_leaf_1_clk net190 net85 vssd1 vssd1 vccd1 vccd1 CALC_INST.input_ctrl_inst.input_control_state\[3\]
+ sky130_fd_sc_hd__dfrtp_1
XFILLER_16_251 vssd1 vssd1 vccd1 vccd1 sky130_fd_sc_hd__fill_1
XFILLER_16_273 vssd1 vssd1 vccd1 vccd1 sky130_fd_sc_hd__fill_1
XTAP_TAPCELL_ROW_18_268 vssd1 vccd1 sky130_fd_sc_hd__tapvpwrvgnd_1
X_1703_ net327 _0751_ net150 vssd1 vssd1 vccd1 vccd1 _0193_ sky130_fd_sc_hd__mux2_1
Xclkbuf_leaf_11_clk clknet_2_1__leaf_clk vssd1 vssd1 vccd1 vccd1 clknet_leaf_11_clk
+ sky130_fd_sc_hd__clkbuf_8
X_1634_ CALC_INST.gencon_inst.operand2\[13\] net253 net66 vssd1 vssd1 vccd1 vccd1
+ _0151_ sky130_fd_sc_hd__mux2_1
XANTENNA__1577__A1 net45 vssd1 vssd1 vccd1 vccd1 sky130_fd_sc_hd__diode_2
X_2683_ clknet_leaf_3_clk _0242_ net91 vssd1 vssd1 vccd1 vccd1 CALC_INST.gencon_inst.mult_calc.main.a0.in1
+ sky130_fd_sc_hd__dfrtp_1
X_2752_ clknet_leaf_29_clk _0311_ net101 vssd1 vssd1 vccd1 vccd1 CALC_INST.gencon_inst.mult_calc.countSave\[5\]
+ sky130_fd_sc_hd__dfrtp_1
XFILLER_58_129 vssd1 vssd1 vccd1 vccd1 sky130_fd_sc_hd__fill_1
X_1565_ net18 _0660_ _0698_ _0415_ vssd1 vssd1 vccd1 vccd1 _0699_ sky130_fd_sc_hd__o211a_1
X_1496_ net149 net148 vssd1 vssd1 vccd1 vccd1 _0644_ sky130_fd_sc_hd__nand2_1
X_2048_ _0927_ _0987_ vssd1 vssd1 vccd1 vccd1 _0988_ sky130_fd_sc_hd__xnor2_2
XTAP_TAPCELL_ROW_52_503 vssd1 vccd1 sky130_fd_sc_hd__tapvpwrvgnd_1
X_2117_ CALC_INST.input_ctrl_inst.decoded_key\[1\] CALC_INST.input_ctrl_inst.decoded_key\[2\]
+ vssd1 vssd1 vccd1 vccd1 _1006_ sky130_fd_sc_hd__nand2b_1
XTAP_TAPCELL_ROW_1_147 vssd1 vccd1 sky130_fd_sc_hd__tapvpwrvgnd_1
Xfanout47 _0495_ vssd1 vssd1 vccd1 vccd1 net47 sky130_fd_sc_hd__clkbuf_4
Xfanout69 _0492_ vssd1 vssd1 vccd1 vccd1 net69 sky130_fd_sc_hd__buf_2
Xfanout36 _0421_ vssd1 vssd1 vccd1 vccd1 net36 sky130_fd_sc_hd__clkbuf_4
XFILLER_13_79 vccd1 vssd1 vccd1 vssd1 sky130_ef_sc_hd__decap_40_12
XFILLER_1_125 vssd1 vssd1 vccd1 vccd1 sky130_fd_sc_hd__fill_2
XFILLER_1_147 vssd1 vssd1 vccd1 vccd1 sky130_fd_sc_hd__fill_1
XTAP_TAPCELL_ROW_9_203 vssd1 vccd1 sky130_fd_sc_hd__tapvpwrvgnd_1
XFILLER_38_87 vssd1 vssd1 vccd1 vccd1 sky130_fd_sc_hd__fill_1
XFILLER_60_305 vssd1 vssd1 vccd1 vccd1 sky130_fd_sc_hd__fill_2
XFILLER_53_390 vssd1 vssd1 vccd1 vccd1 sky130_fd_sc_hd__fill_2
Xclkload28 clknet_leaf_19_clk vssd1 vssd1 vccd1 vccd1 clkload28/Y sky130_fd_sc_hd__inv_6
Xclkload17 clknet_leaf_25_clk vssd1 vssd1 vccd1 vccd1 clkload17/Y sky130_fd_sc_hd__inv_6
X_1350_ CALC_INST.gencon_inst.operand1\[7\] CALC_INST.gencon_inst.operand1\[8\] _0529_
+ vssd1 vssd1 vccd1 vccd1 _0537_ sky130_fd_sc_hd__and3_1
X_1281_ CALC_INST.gencon_inst.operand2\[12\] _0478_ net37 vssd1 vssd1 vccd1 vccd1
+ _0044_ sky130_fd_sc_hd__mux2_1
XFILLER_48_195 vssd1 vssd1 vccd1 vccd1 sky130_fd_sc_hd__fill_1
XFILLER_36_346 vssd1 vssd1 vccd1 vccd1 sky130_fd_sc_hd__fill_8
Xclkbuf_leaf_0_clk clknet_2_0__leaf_clk vssd1 vssd1 vccd1 vccd1 clknet_leaf_0_clk
+ sky130_fd_sc_hd__clkbuf_8
X_2804_ clknet_leaf_27_clk _0350_ net108 vssd1 vssd1 vccd1 vccd1 CALC_INST.gencon_inst.mult_calc.count.GENERATE_ADDER\[13\].thingy.in1
+ sky130_fd_sc_hd__dfrtp_1
X_2735_ clknet_leaf_16_clk _0294_ net115 vssd1 vssd1 vccd1 vccd1 CALC_INST.gencon_inst.ALU_out\[4\]
+ sky130_fd_sc_hd__dfrtp_1
X_1617_ CALC_INST.gencon_inst.operand1\[12\] net325 net66 vssd1 vssd1 vccd1 vccd1
+ _0134_ sky130_fd_sc_hd__mux2_1
X_2597_ clknet_leaf_7_clk net227 vssd1 vssd1 vccd1 vccd1 CALC_INST.gencon_inst.prev_operator_input\[1\]
+ sky130_fd_sc_hd__dfxtp_1
XANTENNA__1366__C _0490_ vssd1 vssd1 vccd1 vccd1 sky130_fd_sc_hd__diode_2
X_2666_ clknet_leaf_25_clk _0225_ net111 vssd1 vssd1 vccd1 vccd1 CALC_INST.gencon_inst.mult_calc.adderSave\[13\]
+ sky130_fd_sc_hd__dfrtp_1
X_1548_ CALC_INST.gencon_inst.operand2\[9\] CALC_INST.gencon_inst.operand1\[9\] net74
+ vssd1 vssd1 vccd1 vccd1 _0686_ sky130_fd_sc_hd__mux2_1
X_1479_ _0401_ _0406_ _0595_ vssd1 vssd1 vccd1 vccd1 _0632_ sky130_fd_sc_hd__nand3_1
XFILLER_54_165 vssd1 vssd1 vccd1 vccd1 sky130_fd_sc_hd__fill_2
XFILLER_42_305 vssd1 vssd1 vccd1 vccd1 sky130_fd_sc_hd__fill_2
XTAP_TAPCELL_ROW_37_396 vssd1 vccd1 sky130_fd_sc_hd__tapvpwrvgnd_1
XFILLER_27_346 vssd1 vssd1 vccd1 vccd1 sky130_fd_sc_hd__fill_2
XFILLER_24_23 vssd1 vssd1 vccd1 vccd1 sky130_fd_sc_hd__fill_2
XFILLER_40_11 vssd1 vssd1 vccd1 vccd1 sky130_fd_sc_hd__fill_1
Xhold280 CALC_INST.gencon_inst.ALU_out\[5\] vssd1 vssd1 vccd1 vccd1 net479 sky130_fd_sc_hd__dlygate4sd3_1
Xhold291 CALC_INST.input_ctrl_inst.debounce_cnt\[2\] vssd1 vssd1 vccd1 vccd1 net490
+ sky130_fd_sc_hd__dlygate4sd3_1
XFILLER_6_3 vssd1 vssd1 vccd1 vccd1 sky130_fd_sc_hd__fill_8
XFILLER_60_168 vccd1 vssd1 vccd1 vssd1 sky130_ef_sc_hd__decap_40_12
XFILLER_45_198 vssd1 vssd1 vccd1 vccd1 sky130_fd_sc_hd__fill_4
XFILLER_60_6 vccd1 vssd1 vccd1 vssd1 sky130_ef_sc_hd__decap_40_12
X_2451_ net71 _0417_ _0420_ vssd1 vssd1 vccd1 vccd1 _0422_ sky130_fd_sc_hd__a21o_1
X_2520_ clknet_leaf_34_clk _0079_ net82 vssd1 vssd1 vccd1 vccd1 CALC_INST.input_ctrl_inst.col_index\[17\]
+ sky130_fd_sc_hd__dfrtp_1
X_1402_ _0413_ net53 _0580_ CALC_INST.input_ctrl_inst.col_index\[1\] vssd1 vssd1 vccd1
+ vccd1 _0063_ sky130_fd_sc_hd__o22a_1
XANTENNA_clkbuf_leaf_17_clk_A clknet_2_3__leaf_clk vssd1 vssd1 vccd1 vccd1 sky130_fd_sc_hd__diode_2
X_1333_ CALC_INST.gencon_inst.ALU_out\[4\] net75 net69 CALC_INST.gencon_inst.mult_calc.out\[4\]
+ vssd1 vssd1 vccd1 vccd1 _0524_ sky130_fd_sc_hd__a22o_1
XFILLER_39_3 vssd1 vssd1 vccd1 vccd1 sky130_fd_sc_hd__fill_2
Xinput4 gpio_in[2] vssd1 vssd1 vccd1 vccd1 net4 sky130_fd_sc_hd__clkbuf_1
X_1264_ _0464_ _0465_ CALC_INST.gencon_inst.mult_calc.out\[8\] net49 vssd1 vssd1 vccd1
+ vccd1 _0466_ sky130_fd_sc_hd__a2bb2o_1
X_2382_ _1212_ _1213_ net469 net41 vssd1 vssd1 vccd1 vccd1 _0014_ sky130_fd_sc_hd__a2bb2o_1
XFILLER_51_179 vssd1 vssd1 vccd1 vccd1 sky130_fd_sc_hd__fill_4
Xclkbuf_2_1__f_clk clknet_0_clk vssd1 vssd1 vccd1 vccd1 clknet_2_1__leaf_clk sky130_fd_sc_hd__clkbuf_16
XFILLER_36_143 vssd1 vssd1 vccd1 vccd1 sky130_fd_sc_hd__fill_1
XFILLER_24_305 vssd1 vssd1 vccd1 vccd1 sky130_fd_sc_hd__fill_1
XTAP_TAPCELL_ROW_34_377 vssd1 vccd1 sky130_fd_sc_hd__tapvpwrvgnd_1
X_2718_ clknet_leaf_31_clk _0277_ net105 vssd1 vssd1 vccd1 vccd1 CALC_INST.gencon_inst.mult_calc.out\[4\]
+ sky130_fd_sc_hd__dfrtp_1
X_2649_ clknet_leaf_5_clk _0208_ net99 vssd1 vssd1 vccd1 vccd1 CALC_INST.gencon_inst.gencon_state\[2\]
+ sky130_fd_sc_hd__dfrtp_4
XFILLER_10_58 vssd1 vssd1 vccd1 vccd1 sky130_fd_sc_hd__fill_1
XFILLER_42_102 vssd1 vssd1 vccd1 vccd1 sky130_fd_sc_hd__fill_2
XFILLER_15_349 vssd1 vssd1 vccd1 vccd1 sky130_fd_sc_hd__fill_2
XANTENNA__1870__A0 net143 vssd1 vssd1 vccd1 vccd1 sky130_fd_sc_hd__diode_2
X_1951_ _0900_ _0901_ CALC_INST.gencon_inst.add_calc.main.GENERATE_ADDER\[3\].thingy.in1
+ vssd1 vssd1 vccd1 vccd1 _0902_ sky130_fd_sc_hd__a21oi_1
XANTENNA__1622__A0 CALC_INST.gencon_inst.operand2\[1\] vssd1 vssd1 vccd1 vccd1 sky130_fd_sc_hd__diode_2
XTAP_TAPCELL_ROW_31_358 vssd1 vccd1 sky130_fd_sc_hd__tapvpwrvgnd_1
X_1882_ net136 CALC_INST.gencon_inst.mult_calc.adderSave\[11\] net125 net381 vssd1
+ vssd1 vccd1 vccd1 _0269_ sky130_fd_sc_hd__a22o_1
X_2503_ clknet_leaf_1_clk _0062_ net83 vssd1 vssd1 vccd1 vccd1 CALC_INST.input_ctrl_inst.col_index\[0\]
+ sky130_fd_sc_hd__dfrtp_4
X_2365_ net38 _1199_ _1200_ net41 net400 vssd1 vssd1 vccd1 vccd1 _0010_ sky130_fd_sc_hd__a32o_1
X_2434_ CALC_INST.input_ctrl_inst.col_index\[1\] CALC_INST.input_ctrl_inst.col_index\[0\]
+ vssd1 vssd1 vccd1 vccd1 _0413_ sky130_fd_sc_hd__nand2_1
XTAP_TAPCELL_ROW_39_414 vssd1 vccd1 sky130_fd_sc_hd__tapvpwrvgnd_1
X_1316_ CALC_INST.gencon_inst.operand1\[2\] CALC_INST.gencon_inst.latched_keypad_input\[2\]
+ vssd1 vssd1 vccd1 vccd1 _0509_ sky130_fd_sc_hd__or2_1
X_1247_ CALC_INST.gencon_inst.mult_calc.out\[4\] net49 _0451_ _0452_ vssd1 vssd1 vccd1
+ vccd1 _0453_ sky130_fd_sc_hd__a22o_1
X_2296_ _1068_ _1069_ vssd1 vssd1 vccd1 vccd1 _1148_ sky130_fd_sc_hd__and2_1
XANTENNA__2102__A1 net133 vssd1 vssd1 vccd1 vccd1 sky130_fd_sc_hd__diode_2
XFILLER_64_293 vssd1 vssd1 vccd1 vccd1 sky130_fd_sc_hd__fill_4
XFILLER_21_79 vccd1 vssd1 vccd1 vssd1 sky130_ef_sc_hd__decap_40_12
XANTENNA_fanout49_X net49 vssd1 vssd1 vccd1 vccd1 sky130_fd_sc_hd__diode_2
XFILLER_15_113 vssd1 vssd1 vccd1 vccd1 sky130_fd_sc_hd__fill_2
XFILLER_15_135 vssd1 vssd1 vccd1 vccd1 sky130_fd_sc_hd__fill_1
XFILLER_62_97 vccd1 vssd1 vccd1 vssd1 sky130_ef_sc_hd__decap_40_12
XFILLER_7_389 vssd1 vssd1 vccd1 vccd1 sky130_fd_sc_hd__fill_2
XANTENNA__1745__B net141 vssd1 vssd1 vccd1 vccd1 sky130_fd_sc_hd__diode_2
X_2150_ CALC_INST.input_ctrl_inst.scan_timer\[4\] _1025_ vssd1 vssd1 vccd1 vccd1 _1027_
+ sky130_fd_sc_hd__nand2_1
X_2081_ net34 vssd1 vssd1 vccd1 vccd1 _1002_ sky130_fd_sc_hd__inv_2
XFILLER_61_241 vssd1 vssd1 vccd1 vccd1 sky130_fd_sc_hd__fill_1
X_1934_ net146 CALC_INST.gencon_inst.add_calc.main.in2\[7\] vssd1 vssd1 vccd1 vccd1
+ _0885_ sky130_fd_sc_hd__nand2_1
XTAP_TAPCELL_ROW_44_450 vssd1 vccd1 sky130_fd_sc_hd__tapvpwrvgnd_1
XFILLER_21_105 vssd1 vssd1 vccd1 vccd1 sky130_fd_sc_hd__fill_1
X_1796_ net141 _0817_ _0818_ net321 net132 vssd1 vssd1 vccd1 vccd1 _0219_ sky130_fd_sc_hd__a32o_1
X_1865_ CALC_INST.gencon_inst.mult_calc.main.GENERATE_ADDER\[11\].thingy.in1 net234
+ net140 vssd1 vssd1 vccd1 vccd1 _0253_ sky130_fd_sc_hd__mux2_1
X_2348_ CALC_INST.input_ctrl_inst.debounce_cnt\[7\] _1186_ vssd1 vssd1 vccd1 vccd1
+ _1188_ sky130_fd_sc_hd__or2_1
X_2417_ CALC_INST.input_ctrl_inst.col_index\[17\] CALC_INST.input_ctrl_inst.col_index\[16\]
+ CALC_INST.input_ctrl_inst.col_index\[19\] CALC_INST.input_ctrl_inst.col_index\[18\]
+ vssd1 vssd1 vccd1 vccd1 _0397_ sky130_fd_sc_hd__or4_1
X_2279_ CALC_INST.gencon_inst.mult_calc.compCount.in2\[14\] _1097_ _1134_ CALC_INST.gencon_inst.mult_calc.compCount.in2\[13\]
+ vssd1 vssd1 vccd1 vccd1 _1137_ sky130_fd_sc_hd__o22a_1
XFILLER_4_348 vssd1 vssd1 vccd1 vccd1 sky130_fd_sc_hd__fill_1
XTAP_TAPCELL_ROW_7_186 vssd1 vccd1 sky130_fd_sc_hd__tapvpwrvgnd_1
XANTENNA__2078__B1 net130 vssd1 vssd1 vccd1 vccd1 sky130_fd_sc_hd__diode_2
XFILLER_43_285 vssd1 vssd1 vccd1 vccd1 sky130_fd_sc_hd__fill_2
X_1581_ net45 _0709_ _0710_ _0707_ net459 vssd1 vssd1 vccd1 vccd1 _0112_ sky130_fd_sc_hd__o32a_1
X_1650_ net207 _0673_ net43 vssd1 vssd1 vccd1 vccd1 _0163_ sky130_fd_sc_hd__mux2_1
Xhold109 _0342_ vssd1 vssd1 vccd1 vccd1 net308 sky130_fd_sc_hd__dlygate4sd3_1
X_2202_ CALC_INST.input_ctrl_inst.col_index\[23\] vssd1 vssd1 vccd1 vccd1 _1062_ sky130_fd_sc_hd__inv_2
X_2064_ net154 net304 net33 _1000_ vssd1 vssd1 vccd1 vccd1 _0305_ sky130_fd_sc_hd__o22a_1
X_2133_ net155 _1148_ _1150_ vssd1 vssd1 vccd1 vccd1 _1018_ sky130_fd_sc_hd__nor3_1
XTAP_TAPCELL_ROW_64_589 vssd1 vccd1 sky130_fd_sc_hd__tapvpwrvgnd_1
X_1917_ net147 CALC_INST.gencon_inst.add_calc.main.in2\[11\] vssd1 vssd1 vccd1 vccd1
+ _0868_ sky130_fd_sc_hd__or2_1
XFILLER_1_329 vssd1 vssd1 vccd1 vccd1 sky130_fd_sc_hd__fill_4
X_1848_ net419 CALC_INST.gencon_inst.mult_calc.INn2\[9\] net139 vssd1 vssd1 vccd1
+ vccd1 _0236_ sky130_fd_sc_hd__mux2_1
X_1779_ _0794_ _0798_ _0795_ vssd1 vssd1 vccd1 vccd1 _0804_ sky130_fd_sc_hd__o21a_1
XFILLER_57_333 vssd1 vssd1 vccd1 vccd1 sky130_fd_sc_hd__fill_2
XFILLER_57_322 vssd1 vssd1 vccd1 vccd1 sky130_fd_sc_hd__fill_1
XTAP_TAPCELL_ROW_4_167 vssd1 vccd1 sky130_fd_sc_hd__tapvpwrvgnd_1
XTAP_TAPCELL_ROW_55_523 vssd1 vccd1 sky130_fd_sc_hd__tapvpwrvgnd_1
XFILLER_43_55 vssd1 vssd1 vccd1 vccd1 sky130_fd_sc_hd__fill_1
XFILLER_43_99 vssd1 vssd1 vccd1 vccd1 sky130_fd_sc_hd__fill_2
XFILLER_40_288 vssd1 vssd1 vccd1 vccd1 sky130_fd_sc_hd__fill_1
XFILLER_4_101 vssd1 vssd1 vccd1 vccd1 sky130_fd_sc_hd__fill_4
XFILLER_4_178 vssd1 vssd1 vccd1 vccd1 sky130_fd_sc_hd__fill_1
X_2820_ clknet_leaf_2_clk CALC_INST.input_ctrl_inst.next_state\[2\] net85 vssd1 vssd1
+ vccd1 vccd1 CALC_INST.input_ctrl_inst.input_control_state\[2\] sky130_fd_sc_hd__dfrtp_4
X_2751_ clknet_leaf_29_clk _0310_ net101 vssd1 vssd1 vccd1 vccd1 CALC_INST.gencon_inst.mult_calc.countSave\[4\]
+ sky130_fd_sc_hd__dfrtp_1
XTAP_TAPCELL_ROW_18_269 vssd1 vccd1 sky130_fd_sc_hd__tapvpwrvgnd_1
X_1702_ CALC_INST.gencon_inst.ALU_in1\[2\] CALC_INST.gencon_inst.ALU_in2\[2\] net59
+ vssd1 vssd1 vccd1 vccd1 _0751_ sky130_fd_sc_hd__mux2_1
X_1633_ CALC_INST.gencon_inst.operand2\[12\] net301 net66 vssd1 vssd1 vccd1 vccd1
+ _0150_ sky130_fd_sc_hd__mux2_1
X_1564_ _0655_ _0697_ vssd1 vssd1 vccd1 vccd1 _0698_ sky130_fd_sc_hd__or2_1
XANTENNA__1329__A2 net47 vssd1 vssd1 vccd1 vccd1 sky130_fd_sc_hd__diode_2
X_2682_ clknet_leaf_26_clk _0241_ net107 vssd1 vssd1 vccd1 vccd1 CALC_INST.gencon_inst.mult_calc.compCount.in2\[14\]
+ sky130_fd_sc_hd__dfrtp_1
XFILLER_39_355 vssd1 vssd1 vccd1 vccd1 sky130_fd_sc_hd__fill_2
XFILLER_39_333 vssd1 vssd1 vccd1 vccd1 sky130_fd_sc_hd__fill_1
X_1495_ _0643_ _0642_ net461 vssd1 vssd1 vccd1 vccd1 _0093_ sky130_fd_sc_hd__mux2_1
X_2047_ _0866_ _0867_ vssd1 vssd1 vccd1 vccd1 _0987_ sky130_fd_sc_hd__nand2b_1
XTAP_TAPCELL_ROW_52_504 vssd1 vccd1 sky130_fd_sc_hd__tapvpwrvgnd_1
Xfanout37 _0421_ vssd1 vssd1 vccd1 vccd1 net37 sky130_fd_sc_hd__clkbuf_2
X_2116_ _1077_ net94 vssd1 vssd1 vccd1 vccd1 _1005_ sky130_fd_sc_hd__nand2_1
XTAP_TAPCELL_ROW_1_148 vssd1 vccd1 sky130_fd_sc_hd__tapvpwrvgnd_1
Xfanout59 net62 vssd1 vssd1 vccd1 vccd1 net59 sky130_fd_sc_hd__clkbuf_4
Xfanout48 _0495_ vssd1 vssd1 vccd1 vccd1 net48 sky130_fd_sc_hd__dlymetal6s2s_1
XFILLER_22_244 vssd1 vssd1 vccd1 vccd1 sky130_fd_sc_hd__fill_8
XTAP_TAPCELL_ROW_9_204 vssd1 vccd1 sky130_fd_sc_hd__tapvpwrvgnd_1
XFILLER_45_314 vccd1 vssd1 vccd1 vssd1 sky130_ef_sc_hd__decap_40_12
Xclkload29 clknet_leaf_20_clk vssd1 vssd1 vccd1 vccd1 clkload29/Y sky130_fd_sc_hd__inv_8
XANTENNA__1559__A2 _0660_ vssd1 vssd1 vccd1 vccd1 sky130_fd_sc_hd__diode_2
Xclkload18 clknet_leaf_26_clk vssd1 vssd1 vccd1 vccd1 clkload18/Y sky130_fd_sc_hd__clkinv_2
X_1280_ _0476_ _0477_ CALC_INST.gencon_inst.mult_calc.out\[12\] net50 vssd1 vssd1
+ vccd1 vccd1 _0478_ sky130_fd_sc_hd__a2bb2o_1
XFILLER_0_181 vccd1 vssd1 vccd1 vssd1 sky130_ef_sc_hd__decap_40_12
XFILLER_63_177 vssd1 vssd1 vccd1 vccd1 sky130_fd_sc_hd__fill_2
XFILLER_63_111 vssd1 vssd1 vccd1 vccd1 sky130_fd_sc_hd__fill_1
X_2734_ clknet_leaf_12_clk _0293_ net98 vssd1 vssd1 vccd1 vccd1 CALC_INST.gencon_inst.ALU_out\[3\]
+ sky130_fd_sc_hd__dfrtp_1
X_2803_ clknet_leaf_27_clk _0349_ net112 vssd1 vssd1 vccd1 vccd1 CALC_INST.gencon_inst.mult_calc.count.GENERATE_ADDER\[12\].thingy.in1
+ sky130_fd_sc_hd__dfrtp_1
XFILLER_59_406 vssd1 vssd1 vccd1 vccd1 sky130_fd_sc_hd__fill_1
XANTENNA__1663__B net154 vssd1 vssd1 vccd1 vccd1 sky130_fd_sc_hd__diode_2
X_1616_ CALC_INST.gencon_inst.operand1\[11\] net318 net66 vssd1 vssd1 vccd1 vccd1
+ _0133_ sky130_fd_sc_hd__mux2_1
X_2596_ clknet_leaf_7_clk _0155_ vssd1 vssd1 vccd1 vccd1 CALC_INST.gencon_inst.prev_operator_input\[0\]
+ sky130_fd_sc_hd__dfxtp_1
X_1547_ _0684_ _0685_ vssd1 vssd1 vccd1 vccd1 _0103_ sky130_fd_sc_hd__or2_1
X_2665_ clknet_leaf_26_clk _0224_ net110 vssd1 vssd1 vccd1 vccd1 CALC_INST.gencon_inst.mult_calc.adderSave\[12\]
+ sky130_fd_sc_hd__dfrtp_1
XFILLER_27_369 vssd1 vssd1 vccd1 vccd1 sky130_fd_sc_hd__fill_4
X_1478_ _0584_ _0631_ net494 net52 vssd1 vssd1 vccd1 vccd1 _0088_ sky130_fd_sc_hd__a2bb2o_1
XTAP_TAPCELL_ROW_37_397 vssd1 vccd1 sky130_fd_sc_hd__tapvpwrvgnd_1
XANTENNA__1789__A2 net130 vssd1 vssd1 vccd1 vccd1 sky130_fd_sc_hd__diode_2
XFILLER_40_78 vssd1 vssd1 vccd1 vccd1 sky130_fd_sc_hd__fill_1
XFILLER_40_56 vssd1 vssd1 vccd1 vccd1 sky130_fd_sc_hd__fill_2
XFILLER_40_45 vssd1 vssd1 vccd1 vccd1 sky130_fd_sc_hd__fill_1
XFILLER_6_207 vssd1 vssd1 vccd1 vccd1 sky130_fd_sc_hd__fill_1
XANTENNA__1410__A1 net51 vssd1 vssd1 vccd1 vccd1 sky130_fd_sc_hd__diode_2
Xhold281 CALC_INST.gencon_inst.ALU_in1\[15\] vssd1 vssd1 vccd1 vccd1 net480 sky130_fd_sc_hd__dlygate4sd3_1
Xhold270 CALC_INST.input_ctrl_inst.debounce_cnt\[15\] vssd1 vssd1 vccd1 vccd1 net469
+ sky130_fd_sc_hd__dlygate4sd3_1
Xhold292 CALC_INST.input_ctrl_inst.debounce_cnt\[5\] vssd1 vssd1 vccd1 vccd1 net491
+ sky130_fd_sc_hd__dlygate4sd3_1
XFILLER_41_372 vssd1 vssd1 vccd1 vccd1 sky130_fd_sc_hd__fill_1
XTAP_TAPCELL_ROW_11_220 vssd1 vccd1 sky130_fd_sc_hd__tapvpwrvgnd_1
X_2450_ net71 _0417_ _0420_ vssd1 vssd1 vccd1 vccd1 _0421_ sky130_fd_sc_hd__a21oi_1
X_2381_ CALC_INST.input_ctrl_inst.debounce_cnt\[15\] _1206_ net39 vssd1 vssd1 vccd1
+ vccd1 _1213_ sky130_fd_sc_hd__o21ai_1
X_1401_ _0579_ _0580_ vssd1 vssd1 vccd1 vccd1 _0062_ sky130_fd_sc_hd__nor2_1
X_1332_ CALC_INST.gencon_inst.operand1\[4\] _0514_ _0517_ _0522_ net45 vssd1 vssd1
+ vccd1 vccd1 _0523_ sky130_fd_sc_hd__o32a_1
X_1263_ CALC_INST.gencon_inst.operand2\[8\] _0461_ net54 vssd1 vssd1 vccd1 vccd1 _0465_
+ sky130_fd_sc_hd__o21ai_1
Xinput5 gpio_in[3] vssd1 vssd1 vccd1 vccd1 net5 sky130_fd_sc_hd__clkbuf_1
XFILLER_51_169 vssd1 vssd1 vccd1 vccd1 sky130_fd_sc_hd__fill_1
XFILLER_51_147 vssd1 vssd1 vccd1 vccd1 sky130_fd_sc_hd__fill_4
XANTENNA__1498__X _0646_ vssd1 vssd1 vccd1 vccd1 sky130_fd_sc_hd__diode_2
XTAP_TAPCELL_ROW_34_378 vssd1 vccd1 sky130_fd_sc_hd__tapvpwrvgnd_1
XFILLER_17_391 vssd1 vssd1 vccd1 vccd1 sky130_fd_sc_hd__fill_1
X_2717_ clknet_leaf_31_clk _0276_ net92 vssd1 vssd1 vccd1 vccd1 CALC_INST.gencon_inst.mult_calc.out\[3\]
+ sky130_fd_sc_hd__dfrtp_1
XFILLER_59_247 vssd1 vssd1 vccd1 vccd1 sky130_fd_sc_hd__fill_2
XFILLER_59_225 vssd1 vssd1 vccd1 vccd1 sky130_fd_sc_hd__fill_2
X_2579_ clknet_leaf_13_clk _0138_ vssd1 vssd1 vccd1 vccd1 CALC_INST.gencon_inst.ALU_in2\[0\]
+ sky130_fd_sc_hd__dfxtp_1
X_2648_ clknet_leaf_5_clk _0207_ net94 vssd1 vssd1 vccd1 vccd1 CALC_INST.gencon_inst.gencon_state\[1\]
+ sky130_fd_sc_hd__dfrtp_1
XTAP_TAPCELL_ROW_25_312 vssd1 vccd1 sky130_fd_sc_hd__tapvpwrvgnd_1
XFILLER_15_339 vssd1 vssd1 vccd1 vccd1 sky130_fd_sc_hd__fill_1
XFILLER_51_44 vssd1 vssd1 vccd1 vccd1 sky130_fd_sc_hd__fill_1
XFILLER_58_280 vssd1 vssd1 vccd1 vccd1 sky130_fd_sc_hd__fill_1
XFILLER_2_287 vssd1 vssd1 vccd1 vccd1 sky130_fd_sc_hd__fill_1
XFILLER_18_9 vssd1 vssd1 vccd1 vccd1 sky130_fd_sc_hd__fill_1
XFILLER_18_111 vssd1 vssd1 vccd1 vccd1 sky130_fd_sc_hd__fill_1
XFILLER_61_401 vssd1 vssd1 vccd1 vccd1 sky130_fd_sc_hd__fill_2
X_1950_ net145 CALC_INST.gencon_inst.add_calc.main.in2\[3\] vssd1 vssd1 vccd1 vccd1
+ _0901_ sky130_fd_sc_hd__nand2_1
XFILLER_33_169 vssd1 vssd1 vccd1 vccd1 sky130_fd_sc_hd__fill_1
X_2502_ clknet_leaf_22_clk _0061_ net118 vssd1 vssd1 vccd1 vccd1 CALC_INST.gencon_inst.operand1\[14\]
+ sky130_fd_sc_hd__dfrtp_1
XTAP_TAPCELL_ROW_31_359 vssd1 vccd1 sky130_fd_sc_hd__tapvpwrvgnd_1
X_1881_ net135 CALC_INST.gencon_inst.mult_calc.adderSave\[10\] net124 net389 vssd1
+ vssd1 vccd1 vccd1 _0268_ sky130_fd_sc_hd__a22o_1
X_1315_ _0507_ vssd1 vssd1 vccd1 vccd1 _0508_ sky130_fd_sc_hd__inv_2
X_2364_ CALC_INST.input_ctrl_inst.debounce_cnt\[10\] _1194_ CALC_INST.input_ctrl_inst.debounce_cnt\[11\]
+ vssd1 vssd1 vccd1 vccd1 _1200_ sky130_fd_sc_hd__a21o_1
X_2433_ CALC_INST.input_ctrl_inst.col_index\[1\] CALC_INST.input_ctrl_inst.col_index\[0\]
+ vssd1 vssd1 vccd1 vccd1 _0412_ sky130_fd_sc_hd__and2_1
X_2295_ net277 net317 net154 vssd1 vssd1 vccd1 vccd1 _0005_ sky130_fd_sc_hd__a21o_1
XTAP_TAPCELL_ROW_47_470 vssd1 vccd1 sky130_fd_sc_hd__tapvpwrvgnd_1
XANTENNA__1310__B1 _0491_ vssd1 vssd1 vccd1 vccd1 sky130_fd_sc_hd__diode_2
XTAP_TAPCELL_ROW_39_415 vssd1 vccd1 sky130_fd_sc_hd__tapvpwrvgnd_1
X_1246_ CALC_INST.gencon_inst.operand2\[4\] _0443_ _0447_ vssd1 vssd1 vccd1 vccd1
+ _0452_ sky130_fd_sc_hd__or3_1
XFILLER_2_93 vssd1 vssd1 vccd1 vccd1 sky130_fd_sc_hd__fill_4
XFILLER_20_331 vssd1 vssd1 vccd1 vccd1 sky130_fd_sc_hd__fill_8
XFILLER_62_54 vssd1 vssd1 vccd1 vccd1 sky130_fd_sc_hd__fill_1
Xmax_cap56 net57 vssd1 vssd1 vccd1 vccd1 net56 sky130_fd_sc_hd__clkbuf_1
XFILLER_30_128 vssd1 vssd1 vccd1 vccd1 sky130_fd_sc_hd__fill_1
XANTENNA_clkbuf_2_0__f_clk_A clknet_0_clk vssd1 vssd1 vccd1 vccd1 sky130_fd_sc_hd__diode_2
XFILLER_15_158 vssd1 vssd1 vccd1 vccd1 sky130_fd_sc_hd__fill_2
XANTENNA_clkbuf_leaf_16_clk_A clknet_2_3__leaf_clk vssd1 vssd1 vccd1 vccd1 sky130_fd_sc_hd__diode_2
XANTENNA__2471__Q CALC_INST.gencon_inst.add_calc.state\[2\] vssd1 vssd1 vccd1 vccd1
+ sky130_fd_sc_hd__diode_2
XFILLER_11_331 vssd1 vssd1 vccd1 vccd1 sky130_fd_sc_hd__fill_4
XFILLER_46_250 vssd1 vssd1 vccd1 vccd1 sky130_fd_sc_hd__fill_2
X_2080_ _0715_ net43 vssd1 vssd1 vccd1 vccd1 _1001_ sky130_fd_sc_hd__and2_1
XFILLER_61_275 vssd1 vssd1 vccd1 vccd1 sky130_fd_sc_hd__fill_4
X_1933_ net146 CALC_INST.gencon_inst.add_calc.main.in2\[7\] vssd1 vssd1 vccd1 vccd1
+ _0884_ sky130_fd_sc_hd__or2_1
XTAP_TAPCELL_ROW_44_451 vssd1 vccd1 sky130_fd_sc_hd__tapvpwrvgnd_1
X_1795_ _0813_ _0815_ _0816_ vssd1 vssd1 vccd1 vccd1 _0818_ sky130_fd_sc_hd__a21o_1
XFILLER_6_390 vccd1 vssd1 vccd1 vssd1 sky130_ef_sc_hd__decap_40_12
X_1864_ net280 net278 net140 vssd1 vssd1 vccd1 vccd1 _0252_ sky130_fd_sc_hd__mux2_1
X_2347_ net38 _1185_ _1187_ net40 net405 vssd1 vssd1 vccd1 vccd1 _0023_ sky130_fd_sc_hd__a32o_1
X_2278_ _1132_ _1133_ _1135_ vssd1 vssd1 vccd1 vccd1 _1136_ sky130_fd_sc_hd__a21o_1
X_2416_ _1225_ _1227_ vssd1 vssd1 vccd1 vccd1 _0396_ sky130_fd_sc_hd__nor2_1
XFILLER_12_106 vssd1 vssd1 vccd1 vccd1 sky130_fd_sc_hd__fill_1
XTAP_TAPCELL_ROW_50_487 vssd1 vccd1 sky130_fd_sc_hd__tapvpwrvgnd_1
XFILLER_4_316 vssd1 vssd1 vccd1 vccd1 sky130_fd_sc_hd__fill_4
XTAP_TAPCELL_ROW_58_543 vssd1 vccd1 sky130_fd_sc_hd__tapvpwrvgnd_1
XTAP_TAPCELL_ROW_7_187 vssd1 vccd1 sky130_fd_sc_hd__tapvpwrvgnd_1
XFILLER_43_297 vssd1 vssd1 vccd1 vccd1 sky130_fd_sc_hd__fill_1
XFILLER_31_404 vssd1 vssd1 vccd1 vccd1 sky130_fd_sc_hd__fill_2
X_1580_ _0703_ _0706_ vssd1 vssd1 vccd1 vccd1 _0710_ sky130_fd_sc_hd__or2_1
XFILLER_7_143 vssd1 vssd1 vccd1 vccd1 sky130_fd_sc_hd__fill_2
XFILLER_7_165 vssd1 vssd1 vccd1 vccd1 sky130_fd_sc_hd__fill_1
X_2132_ net233 _1004_ _1017_ _1003_ vssd1 vssd1 vccd1 vccd1 _0356_ sky130_fd_sc_hd__o211a_1
XFILLER_3_393 vccd1 vssd1 vccd1 vssd1 sky130_ef_sc_hd__decap_40_12
XFILLER_14_3 vccd1 vssd1 vccd1 vssd1 sky130_ef_sc_hd__decap_40_12
X_2201_ CALC_INST.input_ctrl_inst.col_index\[2\] vssd1 vssd1 vccd1 vccd1 _1061_ sky130_fd_sc_hd__inv_2
X_2063_ _1059_ CALC_INST.gencon_inst.add_calc.sameSignVal net126 vssd1 vssd1 vccd1
+ vccd1 _1000_ sky130_fd_sc_hd__a21o_1
XFILLER_34_220 vssd1 vssd1 vccd1 vccd1 sky130_fd_sc_hd__fill_2
XPHY_EDGE_ROW_14_Left_79 vssd1 vssd1 vccd1 vccd1 sky130_fd_sc_hd__decap_3
X_1916_ CALC_INST.gencon_inst.add_calc.main.GENERATE_ADDER\[12\].thingy.in1 _0864_
+ _0865_ vssd1 vssd1 vccd1 vccd1 _0867_ sky130_fd_sc_hd__nand3_1
X_1847_ net355 CALC_INST.gencon_inst.mult_calc.INn2\[8\] net139 vssd1 vssd1 vccd1
+ vccd1 _0235_ sky130_fd_sc_hd__mux2_1
X_1778_ _0800_ _0802_ vssd1 vssd1 vccd1 vccd1 _0803_ sky130_fd_sc_hd__nand2_1
XFILLER_57_378 vssd1 vssd1 vccd1 vccd1 sky130_fd_sc_hd__fill_2
XTAP_TAPCELL_ROW_55_524 vssd1 vccd1 sky130_fd_sc_hd__tapvpwrvgnd_1
XFILLER_27_57 vssd1 vssd1 vccd1 vccd1 sky130_fd_sc_hd__fill_1
XTAP_TAPCELL_ROW_4_168 vssd1 vccd1 sky130_fd_sc_hd__tapvpwrvgnd_1
XFILLER_4_124 vssd1 vssd1 vccd1 vccd1 sky130_fd_sc_hd__fill_2
XFILLER_48_334 vssd1 vssd1 vccd1 vccd1 sky130_fd_sc_hd__fill_1
XFILLER_4_17 vssd1 vssd1 vccd1 vccd1 sky130_fd_sc_hd__fill_1
XFILLER_0_363 vssd1 vssd1 vccd1 vccd1 sky130_fd_sc_hd__fill_1
X_1701_ net343 _0750_ net150 vssd1 vssd1 vccd1 vccd1 _0192_ sky130_fd_sc_hd__mux2_1
XFILLER_31_289 vssd1 vssd1 vccd1 vccd1 sky130_fd_sc_hd__fill_4
X_2750_ clknet_leaf_33_clk _0309_ net101 vssd1 vssd1 vccd1 vccd1 CALC_INST.gencon_inst.mult_calc.countSave\[3\]
+ sky130_fd_sc_hd__dfrtp_1
X_2681_ clknet_leaf_26_clk _0240_ net107 vssd1 vssd1 vccd1 vccd1 CALC_INST.gencon_inst.mult_calc.compCount.in2\[13\]
+ sky130_fd_sc_hd__dfrtp_1
X_1632_ CALC_INST.gencon_inst.operand2\[11\] net324 net66 vssd1 vssd1 vccd1 vccd1
+ _0149_ sky130_fd_sc_hd__mux2_1
X_1563_ CALC_INST.gencon_inst.operand2\[13\] CALC_INST.gencon_inst.operand1\[13\]
+ net74 vssd1 vssd1 vccd1 vccd1 _0697_ sky130_fd_sc_hd__mux2_1
X_1494_ CALC_INST.input_ctrl_inst.col_index\[30\] _0585_ _0638_ vssd1 vssd1 vccd1
+ vccd1 _0643_ sky130_fd_sc_hd__and3_1
XFILLER_39_378 vssd1 vssd1 vccd1 vccd1 sky130_fd_sc_hd__fill_1
X_2115_ _1078_ net155 vssd1 vssd1 vccd1 vccd1 _1004_ sky130_fd_sc_hd__nor2_2
XTAP_TAPCELL_ROW_1_149 vssd1 vccd1 sky130_fd_sc_hd__tapvpwrvgnd_1
X_2046_ _0986_ _0985_ CALC_INST.gencon_inst.ALU_out\[11\] _1056_ vssd1 vssd1 vccd1
+ vccd1 _0301_ sky130_fd_sc_hd__a2bb2o_1
XTAP_TAPCELL_ROW_52_505 vssd1 vccd1 sky130_fd_sc_hd__tapvpwrvgnd_1
Xfanout49 _0425_ vssd1 vssd1 vccd1 vccd1 net49 sky130_fd_sc_hd__buf_2
Xfanout38 net39 vssd1 vssd1 vccd1 vccd1 net38 sky130_fd_sc_hd__buf_2
XTAP_TAPCELL_ROW_60_560 vssd1 vccd1 sky130_fd_sc_hd__tapvpwrvgnd_1
XTAP_TAPCELL_ROW_9_205 vssd1 vccd1 sky130_fd_sc_hd__tapvpwrvgnd_1
XFILLER_60_329 vssd1 vssd1 vccd1 vccd1 sky130_fd_sc_hd__fill_4
XFILLER_60_307 vssd1 vssd1 vccd1 vccd1 sky130_fd_sc_hd__fill_1
XFILLER_54_22 vssd1 vssd1 vccd1 vccd1 sky130_fd_sc_hd__fill_1
XFILLER_45_326 vssd1 vssd1 vccd1 vccd1 sky130_fd_sc_hd__fill_2
XFILLER_9_249 vssd1 vssd1 vccd1 vccd1 sky130_fd_sc_hd__fill_1
XFILLER_48_9 vssd1 vssd1 vccd1 vccd1 sky130_fd_sc_hd__fill_2
Xclkload19 clknet_leaf_27_clk vssd1 vssd1 vccd1 vccd1 clkload19/Y sky130_fd_sc_hd__inv_8
XFILLER_36_304 vssd1 vssd1 vccd1 vccd1 sky130_fd_sc_hd__fill_4
XFILLER_0_193 vssd1 vssd1 vccd1 vccd1 sky130_fd_sc_hd__fill_2
XFILLER_48_197 vssd1 vssd1 vccd1 vccd1 sky130_fd_sc_hd__fill_1
XANTENNA__1247__A2 net49 vssd1 vssd1 vccd1 vccd1 sky130_fd_sc_hd__diode_2
X_2733_ clknet_leaf_12_clk _0292_ net98 vssd1 vssd1 vccd1 vccd1 CALC_INST.gencon_inst.ALU_out\[2\]
+ sky130_fd_sc_hd__dfrtp_1
X_2802_ clknet_leaf_27_clk _0348_ net107 vssd1 vssd1 vccd1 vccd1 CALC_INST.gencon_inst.mult_calc.count.GENERATE_ADDER\[11\].thingy.in1
+ sky130_fd_sc_hd__dfrtp_1
XFILLER_8_271 vssd1 vssd1 vccd1 vccd1 sky130_fd_sc_hd__fill_1
XTAP_TAPCELL_ROW_14_240 vssd1 vccd1 sky130_fd_sc_hd__tapvpwrvgnd_1
X_2664_ clknet_leaf_26_clk _0223_ net110 vssd1 vssd1 vccd1 vccd1 CALC_INST.gencon_inst.mult_calc.adderSave\[11\]
+ sky130_fd_sc_hd__dfrtp_1
X_2595_ clknet_leaf_10_clk _0154_ vssd1 vssd1 vccd1 vccd1 CALC_INST.gencon_inst.add_calc.start
+ sky130_fd_sc_hd__dfxtp_1
X_1615_ CALC_INST.gencon_inst.operand1\[10\] net335 net66 vssd1 vssd1 vccd1 vccd1
+ _0132_ sky130_fd_sc_hd__mux2_1
X_1546_ net13 _0659_ _0683_ _0656_ vssd1 vssd1 vccd1 vccd1 _0685_ sky130_fd_sc_hd__a22o_1
XFILLER_5_71 vssd1 vssd1 vccd1 vccd1 sky130_fd_sc_hd__fill_1
X_1477_ _0629_ _0630_ vssd1 vssd1 vccd1 vccd1 _0631_ sky130_fd_sc_hd__or2_1
XFILLER_54_167 vssd1 vssd1 vccd1 vccd1 sky130_fd_sc_hd__fill_1
XFILLER_42_307 vssd1 vssd1 vccd1 vccd1 sky130_fd_sc_hd__fill_1
XFILLER_39_164 vssd1 vssd1 vccd1 vccd1 sky130_fd_sc_hd__fill_4
XFILLER_27_348 vssd1 vssd1 vccd1 vccd1 sky130_fd_sc_hd__fill_1
X_2029_ _0968_ _0969_ vssd1 vssd1 vccd1 vccd1 _0972_ sky130_fd_sc_hd__or2_1
XTAP_TAPCELL_ROW_37_398 vssd1 vccd1 sky130_fd_sc_hd__tapvpwrvgnd_1
XFILLER_24_58 vssd1 vssd1 vccd1 vccd1 sky130_fd_sc_hd__fill_4
XPHY_EDGE_ROW_17_Left_82 vssd1 vssd1 vccd1 vccd1 sky130_fd_sc_hd__decap_3
Xhold260 CALC_INST.gencon_inst.operand1\[15\] vssd1 vssd1 vccd1 vccd1 net459 sky130_fd_sc_hd__dlygate4sd3_1
XFILLER_2_403 vssd1 vssd1 vccd1 vccd1 sky130_fd_sc_hd__fill_1
Xhold271 CALC_INST.input_ctrl_inst.debounce_cnt\[13\] vssd1 vssd1 vccd1 vccd1 net470
+ sky130_fd_sc_hd__dlygate4sd3_1
Xhold293 CALC_INST.gencon_inst.ALU_out\[6\] vssd1 vssd1 vccd1 vccd1 net492 sky130_fd_sc_hd__dlygate4sd3_1
XFILLER_49_55 vssd1 vssd1 vccd1 vccd1 sky130_fd_sc_hd__fill_1
Xhold282 CALC_INST.input_ctrl_inst.col_index\[12\] vssd1 vssd1 vccd1 vccd1 net481
+ sky130_fd_sc_hd__dlygate4sd3_1
XFILLER_60_148 vssd1 vssd1 vccd1 vccd1 sky130_fd_sc_hd__fill_8
XANTENNA__2474__Q CALC_INST.gencon_inst.operand2\[1\] vssd1 vssd1 vccd1 vccd1 sky130_fd_sc_hd__diode_2
XFILLER_18_337 vssd1 vssd1 vccd1 vccd1 sky130_fd_sc_hd__fill_2
X_1331_ _0491_ _0521_ vssd1 vssd1 vccd1 vccd1 _0522_ sky130_fd_sc_hd__nor2_1
XFILLER_39_5 vssd1 vssd1 vccd1 vccd1 sky130_fd_sc_hd__fill_1
X_2380_ CALC_INST.input_ctrl_inst.debounce_cnt\[15\] _1206_ vssd1 vssd1 vccd1 vccd1
+ _1212_ sky130_fd_sc_hd__and2_1
X_1400_ _1060_ net53 vssd1 vssd1 vccd1 vccd1 _0580_ sky130_fd_sc_hd__nor2_1
Xinput6 nrst vssd1 vssd1 vccd1 vccd1 net6 sky130_fd_sc_hd__clkbuf_1
X_1262_ CALC_INST.gencon_inst.operand2\[8\] CALC_INST.gencon_inst.operand2\[7\] CALC_INST.gencon_inst.operand2\[6\]
+ _0455_ vssd1 vssd1 vccd1 vccd1 _0464_ sky130_fd_sc_hd__and4_1
XTAP_TAPCELL_ROW_34_379 vssd1 vccd1 sky130_fd_sc_hd__tapvpwrvgnd_1
XANTENNA_fanout119_A net121 vssd1 vssd1 vccd1 vccd1 sky130_fd_sc_hd__diode_2
X_2647_ clknet_leaf_5_clk _0206_ net99 vssd1 vssd1 vccd1 vccd1 CALC_INST.gencon_inst.gencon_state\[0\]
+ sky130_fd_sc_hd__dfrtp_1
X_2716_ clknet_leaf_4_clk _0275_ net92 vssd1 vssd1 vccd1 vccd1 CALC_INST.gencon_inst.mult_calc.out\[2\]
+ sky130_fd_sc_hd__dfrtp_1
X_2578_ clknet_leaf_8_clk _0137_ vssd1 vssd1 vccd1 vccd1 CALC_INST.gencon_inst.ALU_in1\[15\]
+ sky130_fd_sc_hd__dfxtp_1
X_1529_ CALC_INST.gencon_inst.ALU_out\[4\] net75 net67 CALC_INST.gencon_inst.mult_calc.out\[4\]
+ vssd1 vssd1 vccd1 vccd1 _0672_ sky130_fd_sc_hd__a22o_1
XANTENNA__2105__B1 net122 vssd1 vssd1 vccd1 vccd1 sky130_fd_sc_hd__diode_2
XTAP_TAPCELL_ROW_25_313 vssd1 vccd1 sky130_fd_sc_hd__tapvpwrvgnd_1
XPHY_EDGE_ROW_2_Left_67 vssd1 vssd1 vccd1 vccd1 sky130_fd_sc_hd__decap_3
XPHY_EDGE_ROW_14_Right_14 vssd1 vssd1 vccd1 vccd1 sky130_fd_sc_hd__decap_3
XANTENNA__1584__B _0656_ vssd1 vssd1 vccd1 vccd1 sky130_fd_sc_hd__diode_2
XPHY_EDGE_ROW_23_Right_23 vssd1 vssd1 vccd1 vccd1 sky130_fd_sc_hd__decap_3
XFILLER_58_292 vccd1 vssd1 vccd1 vssd1 sky130_ef_sc_hd__decap_40_12
XFILLER_18_156 vssd1 vssd1 vccd1 vccd1 sky130_fd_sc_hd__fill_2
XPHY_EDGE_ROW_32_Right_32 vssd1 vssd1 vccd1 vccd1 sky130_fd_sc_hd__decap_3
X_1880_ net136 net379 net124 CALC_INST.gencon_inst.mult_calc.main.GENERATE_ADDER\[9\].thingy.in2
+ vssd1 vssd1 vccd1 vccd1 _0267_ sky130_fd_sc_hd__a22o_1
X_2501_ clknet_leaf_20_clk _0060_ net118 vssd1 vssd1 vccd1 vccd1 CALC_INST.gencon_inst.operand1\[13\]
+ sky130_fd_sc_hd__dfrtp_2
XPHY_EDGE_ROW_41_Right_41 vssd1 vssd1 vccd1 vccd1 sky130_fd_sc_hd__decap_3
XTAP_TAPCELL_ROW_39_416 vssd1 vccd1 sky130_fd_sc_hd__tapvpwrvgnd_1
X_1314_ CALC_INST.gencon_inst.operand1\[2\] CALC_INST.gencon_inst.latched_keypad_input\[2\]
+ vssd1 vssd1 vccd1 vccd1 _0507_ sky130_fd_sc_hd__nand2_1
X_2294_ CALC_INST.gencon_inst.key_read _1077_ _1074_ _1071_ vssd1 vssd1 vccd1 vccd1
+ CALC_INST.input_ctrl_inst.next_state\[2\] sky130_fd_sc_hd__a211o_1
X_2432_ _0402_ _0405_ _1061_ _0391_ _0401_ vssd1 vssd1 vccd1 vccd1 _0411_ sky130_fd_sc_hd__o2111ai_2
X_2363_ _1198_ vssd1 vssd1 vccd1 vccd1 _1199_ sky130_fd_sc_hd__inv_2
XFILLER_64_240 vssd1 vssd1 vccd1 vccd1 sky130_fd_sc_hd__fill_8
XPHY_EDGE_ROW_50_Right_50 vssd1 vssd1 vccd1 vccd1 sky130_fd_sc_hd__decap_3
XTAP_TAPCELL_ROW_47_471 vssd1 vccd1 sky130_fd_sc_hd__tapvpwrvgnd_1
X_1245_ _0416_ _0423_ _0450_ net36 vssd1 vssd1 vccd1 vccd1 _0451_ sky130_fd_sc_hd__o31ai_1
XFILLER_21_37 vssd1 vssd1 vccd1 vccd1 sky130_fd_sc_hd__fill_4
XFILLER_62_33 vssd1 vssd1 vccd1 vccd1 sky130_fd_sc_hd__fill_2
Xmax_cap57 net58 vssd1 vssd1 vccd1 vccd1 net57 sky130_fd_sc_hd__clkbuf_1
XFILLER_11_310 vssd1 vssd1 vccd1 vccd1 sky130_fd_sc_hd__fill_1
XFILLER_15_104 vssd1 vssd1 vccd1 vccd1 sky130_fd_sc_hd__fill_2
Xmax_cap79 net80 vssd1 vssd1 vccd1 vccd1 net79 sky130_fd_sc_hd__clkbuf_1
XFILLER_7_314 vssd1 vssd1 vccd1 vccd1 sky130_fd_sc_hd__fill_2
XFILLER_11_70 vssd1 vssd1 vccd1 vccd1 sky130_fd_sc_hd__fill_1
XFILLER_61_221 vssd1 vssd1 vccd1 vccd1 sky130_fd_sc_hd__fill_2
XFILLER_46_262 vssd1 vssd1 vccd1 vccd1 sky130_fd_sc_hd__fill_4
XANTENNA__2096__A2 _0728_ vssd1 vssd1 vccd1 vccd1 sky130_fd_sc_hd__diode_2
X_1932_ CALC_INST.gencon_inst.add_calc.main.GENERATE_ADDER\[8\].thingy.in1 _0880_
+ _0881_ vssd1 vssd1 vccd1 vccd1 _0883_ sky130_fd_sc_hd__nand3_1
X_1863_ CALC_INST.gencon_inst.mult_calc.main.GENERATE_ADDER\[9\].thingy.in1 net243
+ net139 vssd1 vssd1 vccd1 vccd1 _0251_ sky130_fd_sc_hd__mux2_1
X_2415_ _1225_ net72 _0391_ _0394_ vssd1 vssd1 vccd1 vccd1 _0395_ sky130_fd_sc_hd__a211o_1
X_1794_ _0813_ _0815_ _0816_ vssd1 vssd1 vccd1 vccd1 _0817_ sky130_fd_sc_hd__nand3_1
XANTENNA__1531__B2 _0656_ vssd1 vssd1 vccd1 vccd1 sky130_fd_sc_hd__diode_2
XANTENNA__2087__A2 _0728_ vssd1 vssd1 vccd1 vccd1 sky130_fd_sc_hd__diode_2
X_2346_ _1186_ vssd1 vssd1 vccd1 vccd1 _1187_ sky130_fd_sc_hd__inv_2
X_2277_ CALC_INST.gencon_inst.mult_calc.compCount.in2\[12\] _1131_ _1134_ CALC_INST.gencon_inst.mult_calc.compCount.in2\[13\]
+ vssd1 vssd1 vccd1 vccd1 _1135_ sky130_fd_sc_hd__a22o_1
XFILLER_52_287 vssd1 vssd1 vccd1 vccd1 sky130_fd_sc_hd__fill_1
XFILLER_52_210 vssd1 vssd1 vccd1 vccd1 sky130_fd_sc_hd__fill_2
XANTENNA__1399__B net51 vssd1 vssd1 vccd1 vccd1 sky130_fd_sc_hd__diode_2
XFILLER_16_15 vssd1 vssd1 vccd1 vccd1 sky130_fd_sc_hd__fill_1
Xclkbuf_leaf_32_clk clknet_2_0__leaf_clk vssd1 vssd1 vccd1 vccd1 clknet_leaf_32_clk
+ sky130_fd_sc_hd__clkbuf_8
XANTENNA_fanout141_X net141 vssd1 vssd1 vccd1 vccd1 sky130_fd_sc_hd__diode_2
XTAP_TAPCELL_ROW_50_488 vssd1 vccd1 sky130_fd_sc_hd__tapvpwrvgnd_1
XFILLER_32_25 vssd1 vssd1 vccd1 vccd1 sky130_fd_sc_hd__fill_2
XFILLER_4_306 vssd1 vssd1 vccd1 vccd1 sky130_fd_sc_hd__fill_2
XANTENNA_fanout99_A net100 vssd1 vssd1 vccd1 vccd1 sky130_fd_sc_hd__diode_2
XTAP_TAPCELL_ROW_7_188 vssd1 vccd1 sky130_fd_sc_hd__tapvpwrvgnd_1
XTAP_TAPCELL_ROW_58_544 vssd1 vccd1 sky130_fd_sc_hd__tapvpwrvgnd_1
Xclkbuf_leaf_23_clk clknet_2_2__leaf_clk vssd1 vssd1 vccd1 vccd1 clknet_leaf_23_clk
+ sky130_fd_sc_hd__clkbuf_8
XPHY_EDGE_ROW_5_Left_70 vssd1 vssd1 vccd1 vccd1 sky130_fd_sc_hd__decap_3
X_2062_ net482 _0999_ CALC_INST.gencon_inst.add_calc.state\[1\] vssd1 vssd1 vccd1
+ vccd1 _0304_ sky130_fd_sc_hd__mux2_1
X_2131_ _1150_ _1009_ _1016_ _1005_ vssd1 vssd1 vccd1 vccd1 _1017_ sky130_fd_sc_hd__a31o_1
X_2200_ CALC_INST.input_ctrl_inst.col_index\[0\] vssd1 vssd1 vccd1 vccd1 _1060_ sky130_fd_sc_hd__inv_2
XANTENNA__1277__A0 CALC_INST.gencon_inst.operand2\[11\] vssd1 vssd1 vccd1 vccd1 sky130_fd_sc_hd__diode_2
X_1915_ _0864_ _0865_ CALC_INST.gencon_inst.add_calc.main.GENERATE_ADDER\[12\].thingy.in1
+ vssd1 vssd1 vccd1 vccd1 _0866_ sky130_fd_sc_hd__a21oi_1
Xclkbuf_leaf_14_clk clknet_2_3__leaf_clk vssd1 vssd1 vccd1 vccd1 clknet_leaf_14_clk
+ sky130_fd_sc_hd__clkbuf_8
XFILLER_8_82 vssd1 vssd1 vccd1 vccd1 sky130_fd_sc_hd__fill_2
X_1846_ net402 CALC_INST.gencon_inst.mult_calc.INn2\[7\] net137 vssd1 vssd1 vccd1
+ vccd1 _0234_ sky130_fd_sc_hd__mux2_1
X_1777_ CALC_INST.gencon_inst.mult_calc.main.GENERATE_ADDER\[5\].thingy.in2 CALC_INST.gencon_inst.mult_calc.main.GENERATE_ADDER\[5\].thingy.in1
+ vssd1 vssd1 vccd1 vccd1 _0802_ sky130_fd_sc_hd__nand2_1
XANTENNA_clkbuf_leaf_15_clk_A clknet_2_3__leaf_clk vssd1 vssd1 vccd1 vccd1 sky130_fd_sc_hd__diode_2
XPHY_EDGE_ROW_4_Right_4 vssd1 vssd1 vccd1 vccd1 sky130_fd_sc_hd__decap_3
XFILLER_57_335 vssd1 vssd1 vccd1 vccd1 sky130_fd_sc_hd__fill_1
XTAP_TAPCELL_ROW_55_525 vssd1 vccd1 sky130_fd_sc_hd__tapvpwrvgnd_1
XANTENNA__1268__B1 net49 vssd1 vssd1 vccd1 vccd1 sky130_fd_sc_hd__diode_2
XTAP_TAPCELL_ROW_4_169 vssd1 vccd1 sky130_fd_sc_hd__tapvpwrvgnd_1
X_2329_ net38 _1173_ _1174_ net40 net486 vssd1 vssd1 vccd1 vccd1 _0018_ sky130_fd_sc_hd__a32o_1
XTAP_TAPCELL_ROW_63_580 vssd1 vccd1 sky130_fd_sc_hd__tapvpwrvgnd_1
XPHY_EDGE_ROW_31_Left_96 vssd1 vssd1 vccd1 vccd1 sky130_fd_sc_hd__decap_3
XFILLER_0_386 vssd1 vssd1 vccd1 vccd1 sky130_fd_sc_hd__fill_2
X_1700_ CALC_INST.gencon_inst.ALU_in1\[1\] CALC_INST.gencon_inst.ALU_in2\[1\] net59
+ vssd1 vssd1 vccd1 vccd1 _0750_ sky130_fd_sc_hd__mux2_1
X_1631_ CALC_INST.gencon_inst.operand2\[10\] net329 net66 vssd1 vssd1 vccd1 vccd1
+ _0148_ sky130_fd_sc_hd__mux2_1
XFILLER_33_90 vssd1 vssd1 vccd1 vccd1 sky130_fd_sc_hd__fill_1
XFILLER_31_279 vssd1 vssd1 vccd1 vccd1 sky130_fd_sc_hd__fill_1
X_2680_ clknet_leaf_27_clk net362 net107 vssd1 vssd1 vccd1 vccd1 CALC_INST.gencon_inst.mult_calc.compCount.in2\[12\]
+ sky130_fd_sc_hd__dfrtp_1
X_1562_ net295 _0659_ _0695_ _0656_ _0696_ vssd1 vssd1 vccd1 vccd1 _0107_ sky130_fd_sc_hd__a221o_1
Xclkbuf_leaf_3_clk clknet_2_0__leaf_clk vssd1 vssd1 vccd1 vccd1 clknet_leaf_3_clk
+ sky130_fd_sc_hd__clkbuf_8
X_1493_ _0639_ _0641_ _0642_ net496 vssd1 vssd1 vccd1 vccd1 _0092_ sky130_fd_sc_hd__a2bb2o_1
X_2045_ net32 _0982_ _0984_ _1056_ vssd1 vssd1 vccd1 vccd1 _0986_ sky130_fd_sc_hd__a31o_1
X_2114_ _1075_ _1148_ net86 vssd1 vssd1 vccd1 vccd1 _1003_ sky130_fd_sc_hd__o21ai_1
XANTENNA_clkbuf_2_2__f_clk_X clknet_2_2__leaf_clk vssd1 vssd1 vccd1 vccd1 sky130_fd_sc_hd__diode_2
XTAP_TAPCELL_ROW_60_561 vssd1 vccd1 sky130_fd_sc_hd__tapvpwrvgnd_1
XTAP_TAPCELL_ROW_52_506 vssd1 vccd1 sky130_fd_sc_hd__tapvpwrvgnd_1
Xfanout39 _1172_ vssd1 vssd1 vccd1 vccd1 net39 sky130_fd_sc_hd__clkbuf_2
XFILLER_22_235 vssd1 vssd1 vccd1 vccd1 sky130_fd_sc_hd__fill_1
XTAP_TAPCELL_ROW_17_260 vssd1 vccd1 sky130_fd_sc_hd__tapvpwrvgnd_1
X_1829_ CALC_INST.gencon_inst.mult_calc.main.GENERATE_ADDER\[13\].thingy.in2 CALC_INST.gencon_inst.mult_calc.main.GENERATE_ADDER\[13\].thingy.in1
+ vssd1 vssd1 vccd1 vccd1 _0846_ sky130_fd_sc_hd__nor2_1
XTAP_TAPCELL_ROW_9_206 vssd1 vccd1 sky130_fd_sc_hd__tapvpwrvgnd_1
XFILLER_5_401 vssd1 vssd1 vccd1 vccd1 sky130_fd_sc_hd__fill_2
XFILLER_13_279 vssd1 vssd1 vccd1 vccd1 sky130_fd_sc_hd__fill_1
XFILLER_48_165 vssd1 vssd1 vccd1 vccd1 sky130_fd_sc_hd__fill_1
XFILLER_0_161 vssd1 vssd1 vccd1 vccd1 sky130_fd_sc_hd__fill_4
XFILLER_63_179 vssd1 vssd1 vccd1 vccd1 sky130_fd_sc_hd__fill_1
X_2801_ clknet_leaf_27_clk _0347_ net107 vssd1 vssd1 vccd1 vccd1 CALC_INST.gencon_inst.mult_calc.count.GENERATE_ADDER\[10\].thingy.in1
+ sky130_fd_sc_hd__dfrtp_1
XTAP_TAPCELL_ROW_14_241 vssd1 vccd1 sky130_fd_sc_hd__tapvpwrvgnd_1
X_2732_ clknet_leaf_12_clk _0291_ net98 vssd1 vssd1 vccd1 vccd1 CALC_INST.gencon_inst.ALU_out\[1\]
+ sky130_fd_sc_hd__dfrtp_1
X_2594_ clknet_leaf_8_clk _0153_ vssd1 vssd1 vccd1 vccd1 CALC_INST.gencon_inst.ALU_in2\[15\]
+ sky130_fd_sc_hd__dfxtp_1
X_1614_ CALC_INST.gencon_inst.operand1\[9\] net283 net65 vssd1 vssd1 vccd1 vccd1 _0131_
+ sky130_fd_sc_hd__mux2_1
XFILLER_8_261 vssd1 vssd1 vccd1 vccd1 sky130_fd_sc_hd__fill_4
X_2663_ clknet_leaf_26_clk _0222_ net108 vssd1 vssd1 vccd1 vccd1 CALC_INST.gencon_inst.mult_calc.adderSave\[10\]
+ sky130_fd_sc_hd__dfrtp_1
X_1545_ CALC_INST.gencon_inst.ALU_out\[8\] net78 net67 CALC_INST.gencon_inst.mult_calc.out\[8\]
+ vssd1 vssd1 vccd1 vccd1 _0684_ sky130_fd_sc_hd__a22o_1
X_1476_ CALC_INST.input_ctrl_inst.col_index\[25\] CALC_INST.input_ctrl_inst.col_index\[26\]
+ _0626_ vssd1 vssd1 vccd1 vccd1 _0630_ sky130_fd_sc_hd__and3_1
X_2028_ net493 _0971_ CALC_INST.gencon_inst.add_calc.state\[1\] vssd1 vssd1 vccd1
+ vccd1 _0298_ sky130_fd_sc_hd__mux2_1
XTAP_TAPCELL_ROW_37_399 vssd1 vccd1 sky130_fd_sc_hd__tapvpwrvgnd_1
Xhold250 CALC_INST.input_ctrl_inst.scan_timer\[12\] vssd1 vssd1 vccd1 vccd1 net449
+ sky130_fd_sc_hd__dlygate4sd3_1
Xhold294 CALC_INST.gencon_inst.ALU_out\[8\] vssd1 vssd1 vccd1 vccd1 net493 sky130_fd_sc_hd__dlygate4sd3_1
Xhold261 CALC_INST.input_ctrl_inst.scan_timer\[7\] vssd1 vssd1 vccd1 vccd1 net460
+ sky130_fd_sc_hd__dlygate4sd3_1
Xhold283 CALC_INST.gencon_inst.ALU_out\[14\] vssd1 vssd1 vccd1 vccd1 net482 sky130_fd_sc_hd__dlygate4sd3_1
Xhold272 CALC_INST.gencon_inst.ALU_out\[3\] vssd1 vssd1 vccd1 vccd1 net471 sky130_fd_sc_hd__dlygate4sd3_1
XFILLER_49_34 vssd1 vssd1 vccd1 vccd1 sky130_fd_sc_hd__fill_2
XTAP_TAPCELL_ROW_20_277 vssd1 vccd1 sky130_fd_sc_hd__tapvpwrvgnd_1
XFILLER_45_113 vssd1 vssd1 vccd1 vccd1 sky130_fd_sc_hd__fill_4
XANTENNA__1882__B1 net125 vssd1 vssd1 vccd1 vccd1 sky130_fd_sc_hd__diode_2
XFILLER_60_138 vssd1 vssd1 vccd1 vccd1 sky130_fd_sc_hd__fill_2
XFILLER_45_179 vssd1 vssd1 vccd1 vccd1 sky130_fd_sc_hd__fill_4
XFILLER_41_352 vccd1 vssd1 vccd1 vssd1 sky130_ef_sc_hd__decap_40_12
XTAP_TAPCELL_ROW_28_333 vssd1 vccd1 sky130_fd_sc_hd__tapvpwrvgnd_1
XANTENNA__2222__A CALC_INST.input_ctrl_inst.key_pressed vssd1 vssd1 vccd1 vccd1 sky130_fd_sc_hd__diode_2
X_1330_ _0514_ _0517_ CALC_INST.gencon_inst.operand1\[4\] vssd1 vssd1 vccd1 vccd1
+ _0521_ sky130_fd_sc_hd__o21a_1
X_1261_ CALC_INST.gencon_inst.operand2\[7\] net36 _0462_ _0463_ vssd1 vssd1 vccd1
+ vccd1 _0039_ sky130_fd_sc_hd__o22a_1
XFILLER_30_91 vssd1 vssd1 vccd1 vccd1 sky130_fd_sc_hd__fill_1
XFILLER_36_146 vssd1 vssd1 vccd1 vccd1 sky130_fd_sc_hd__fill_4
XFILLER_36_102 vssd1 vssd1 vccd1 vccd1 sky130_fd_sc_hd__fill_4
XFILLER_32_363 vssd1 vssd1 vccd1 vccd1 sky130_fd_sc_hd__fill_1
X_2646_ clknet_leaf_17_clk _0205_ net119 vssd1 vssd1 vccd1 vccd1 CALC_INST.gencon_inst.add_calc.main.in2\[14\]
+ sky130_fd_sc_hd__dfrtp_1
X_2577_ clknet_leaf_22_clk _0136_ vssd1 vssd1 vccd1 vccd1 CALC_INST.gencon_inst.ALU_in1\[14\]
+ sky130_fd_sc_hd__dfxtp_1
X_2715_ clknet_leaf_4_clk _0274_ net92 vssd1 vssd1 vccd1 vccd1 CALC_INST.gencon_inst.mult_calc.out\[1\]
+ sky130_fd_sc_hd__dfrtp_1
XFILLER_59_249 vssd1 vssd1 vccd1 vccd1 sky130_fd_sc_hd__fill_1
X_1528_ net471 net75 net67 CALC_INST.gencon_inst.mult_calc.out\[3\] _0671_ vssd1 vssd1
+ vccd1 vccd1 _0098_ sky130_fd_sc_hd__a221o_1
XANTENNA__2105__A1 net133 vssd1 vssd1 vccd1 vccd1 sky130_fd_sc_hd__diode_2
X_1459_ CALC_INST.input_ctrl_inst.col_index\[20\] _0615_ CALC_INST.input_ctrl_inst.col_index\[21\]
+ vssd1 vssd1 vccd1 vccd1 _0618_ sky130_fd_sc_hd__a21oi_1
XFILLER_27_157 vssd1 vssd1 vccd1 vccd1 sky130_fd_sc_hd__fill_2
XTAP_TAPCELL_ROW_25_314 vssd1 vccd1 sky130_fd_sc_hd__tapvpwrvgnd_1
XFILLER_4_3 vccd1 vssd1 vccd1 vssd1 sky130_ef_sc_hd__decap_40_12
XFILLER_2_212 vssd1 vssd1 vccd1 vccd1 sky130_fd_sc_hd__fill_1
XFILLER_61_403 vssd1 vssd1 vccd1 vccd1 sky130_fd_sc_hd__fill_1
XFILLER_14_363 vssd1 vssd1 vccd1 vccd1 sky130_fd_sc_hd__fill_1
X_2500_ clknet_leaf_20_clk _0059_ net118 vssd1 vssd1 vccd1 vccd1 CALC_INST.gencon_inst.operand1\[12\]
+ sky130_fd_sc_hd__dfrtp_1
X_2431_ _1226_ _0410_ vssd1 vssd1 vccd1 vccd1 net26 sky130_fd_sc_hd__nand2_1
X_1313_ CALC_INST.gencon_inst.operand1\[1\] net47 _0505_ _0506_ vssd1 vssd1 vccd1
+ vccd1 _0048_ sky130_fd_sc_hd__o22a_1
XFILLER_37_3 vssd1 vssd1 vccd1 vccd1 sky130_fd_sc_hd__fill_8
X_1244_ _0443_ _0447_ CALC_INST.gencon_inst.operand2\[4\] vssd1 vssd1 vccd1 vccd1
+ _0450_ sky130_fd_sc_hd__o21a_1
X_2293_ _1079_ _1086_ _1147_ vssd1 vssd1 vccd1 vccd1 CALC_INST.input_ctrl_inst.next_state\[1\]
+ sky130_fd_sc_hd__or3_1
XANTENNA__2099__B1 net122 vssd1 vssd1 vccd1 vccd1 sky130_fd_sc_hd__diode_2
X_2362_ CALC_INST.input_ctrl_inst.debounce_cnt\[11\] CALC_INST.input_ctrl_inst.debounce_cnt\[10\]
+ _1194_ vssd1 vssd1 vccd1 vccd1 _1198_ sky130_fd_sc_hd__and3_1
XTAP_TAPCELL_ROW_47_472 vssd1 vccd1 sky130_fd_sc_hd__tapvpwrvgnd_1
XTAP_TAPCELL_ROW_30_350 vssd1 vccd1 sky130_fd_sc_hd__tapvpwrvgnd_1
XANTENNA_fanout131_A net132 vssd1 vssd1 vccd1 vccd1 sky130_fd_sc_hd__diode_2
XANTENNA__1905__S net154 vssd1 vssd1 vccd1 vccd1 sky130_fd_sc_hd__diode_2
X_2629_ clknet_leaf_19_clk _0188_ net120 vssd1 vssd1 vccd1 vccd1 CALC_INST.gencon_inst.add_calc.main.GENERATE_ADDER\[12\].thingy.in1
+ sky130_fd_sc_hd__dfrtp_1
XANTENNA_fanout44_A _0727_ vssd1 vssd1 vccd1 vccd1 sky130_fd_sc_hd__diode_2
XFILLER_15_127 vssd1 vssd1 vccd1 vccd1 sky130_fd_sc_hd__fill_2
XFILLER_46_241 vssd1 vssd1 vccd1 vccd1 sky130_fd_sc_hd__fill_1
XANTENNA__2005__B1 net126 vssd1 vssd1 vccd1 vccd1 sky130_fd_sc_hd__diode_2
X_1931_ _0880_ _0881_ CALC_INST.gencon_inst.add_calc.main.GENERATE_ADDER\[8\].thingy.in1
+ vssd1 vssd1 vccd1 vccd1 _0882_ sky130_fd_sc_hd__a21oi_1
XANTENNA__1359__A2 net47 vssd1 vssd1 vccd1 vccd1 sky130_fd_sc_hd__diode_2
X_1862_ net229 net211 net139 vssd1 vssd1 vccd1 vccd1 _0250_ sky130_fd_sc_hd__mux2_1
X_1793_ _0807_ _0811_ _0808_ vssd1 vssd1 vccd1 vccd1 _0816_ sky130_fd_sc_hd__o21ai_1
X_2414_ CALC_INST.input_ctrl_inst.col_index\[17\] CALC_INST.input_ctrl_inst.col_index\[16\]
+ _0392_ _0393_ vssd1 vssd1 vccd1 vccd1 _0394_ sky130_fd_sc_hd__nand4_1
XANTENNA__1531__A2 _0659_ vssd1 vssd1 vccd1 vccd1 sky130_fd_sc_hd__diode_2
XFILLER_37_285 vssd1 vssd1 vccd1 vccd1 sky130_fd_sc_hd__fill_2
X_2345_ CALC_INST.input_ctrl_inst.debounce_cnt\[4\] CALC_INST.input_ctrl_inst.debounce_cnt\[5\]
+ CALC_INST.input_ctrl_inst.debounce_cnt\[6\] _1177_ vssd1 vssd1 vccd1 vccd1 _1186_
+ sky130_fd_sc_hd__and4_1
X_2276_ CALC_INST.gencon_inst.mult_calc.count.GENERATE_ADDER\[13\].thingy.in1 _1095_
+ vssd1 vssd1 vccd1 vccd1 _1134_ sky130_fd_sc_hd__xnor2_1
XFILLER_20_141 vssd1 vssd1 vccd1 vccd1 sky130_fd_sc_hd__fill_4
XTAP_TAPCELL_ROW_50_489 vssd1 vccd1 sky130_fd_sc_hd__tapvpwrvgnd_1
XTAP_TAPCELL_ROW_7_189 vssd1 vccd1 sky130_fd_sc_hd__tapvpwrvgnd_1
XTAP_TAPCELL_ROW_58_545 vssd1 vccd1 sky130_fd_sc_hd__tapvpwrvgnd_1
XANTENNA_fanout47_X net47 vssd1 vssd1 vccd1 vccd1 sky130_fd_sc_hd__diode_2
XFILLER_43_277 vssd1 vssd1 vccd1 vccd1 sky130_fd_sc_hd__fill_2
XFILLER_43_200 vssd1 vssd1 vccd1 vccd1 sky130_fd_sc_hd__fill_4
XFILLER_31_406 vssd1 vssd1 vccd1 vccd1 sky130_fd_sc_hd__fill_1
XPHY_EDGE_ROW_44_Left_109 vssd1 vssd1 vccd1 vccd1 sky130_fd_sc_hd__decap_3
XFILLER_22_70 vssd1 vssd1 vccd1 vccd1 sky130_fd_sc_hd__fill_2
XFILLER_22_81 vssd1 vssd1 vccd1 vccd1 sky130_fd_sc_hd__fill_2
X_2061_ _0996_ _0998_ vssd1 vssd1 vccd1 vccd1 _0999_ sky130_fd_sc_hd__xnor2_1
XPHY_EDGE_ROW_53_Left_118 vssd1 vssd1 vccd1 vccd1 sky130_fd_sc_hd__decap_3
X_2130_ _1057_ CALC_INST.input_ctrl_inst.decoded_key\[2\] vssd1 vssd1 vccd1 vccd1
+ _1016_ sky130_fd_sc_hd__nor2_1
X_1914_ net147 CALC_INST.gencon_inst.add_calc.main.in2\[12\] vssd1 vssd1 vccd1 vccd1
+ _0865_ sky130_fd_sc_hd__nand2_1
XFILLER_34_222 vssd1 vssd1 vccd1 vccd1 sky130_fd_sc_hd__fill_1
XPHY_EDGE_ROW_62_Left_127 vssd1 vssd1 vccd1 vccd1 sky130_fd_sc_hd__decap_3
X_1845_ net430 net406 net138 vssd1 vssd1 vccd1 vccd1 _0233_ sky130_fd_sc_hd__mux2_1
X_1776_ _0800_ vssd1 vssd1 vccd1 vccd1 _0801_ sky130_fd_sc_hd__inv_2
XFILLER_57_325 vssd1 vssd1 vccd1 vccd1 sky130_fd_sc_hd__fill_8
X_2328_ CALC_INST.input_ctrl_inst.debounce_cnt\[0\] CALC_INST.input_ctrl_inst.debounce_cnt\[1\]
+ vssd1 vssd1 vccd1 vccd1 _1174_ sky130_fd_sc_hd__nand2_1
XFILLER_57_347 vccd1 vssd1 vccd1 vssd1 sky130_ef_sc_hd__decap_40_12
XTAP_TAPCELL_ROW_55_526 vssd1 vccd1 sky130_fd_sc_hd__tapvpwrvgnd_1
XANTENNA__2465__B1 net49 vssd1 vssd1 vccd1 vccd1 sky130_fd_sc_hd__diode_2
X_2259_ CALC_INST.gencon_inst.mult_calc.count.GENERATE_ADDER\[7\].thingy.in1 _1091_
+ CALC_INST.gencon_inst.mult_calc.count.GENERATE_ADDER\[8\].thingy.in1 vssd1 vssd1
+ vccd1 vccd1 _1117_ sky130_fd_sc_hd__a21oi_1
XFILLER_13_406 vssd1 vssd1 vccd1 vccd1 sky130_fd_sc_hd__fill_1
XTAP_TAPCELL_ROW_63_581 vssd1 vccd1 sky130_fd_sc_hd__tapvpwrvgnd_1
XFILLER_40_247 vssd1 vssd1 vccd1 vccd1 sky130_fd_sc_hd__fill_4
XFILLER_0_321 vccd1 vssd1 vccd1 vssd1 sky130_ef_sc_hd__decap_40_12
XFILLER_48_303 vssd1 vssd1 vccd1 vccd1 sky130_fd_sc_hd__fill_4
XFILLER_0_365 vssd1 vssd1 vccd1 vccd1 sky130_fd_sc_hd__fill_2
XFILLER_31_225 vssd1 vssd1 vccd1 vccd1 sky130_fd_sc_hd__fill_4
X_1630_ CALC_INST.gencon_inst.operand2\[9\] net276 net65 vssd1 vssd1 vccd1 vccd1 _0147_
+ sky130_fd_sc_hd__mux2_1
X_1561_ CALC_INST.gencon_inst.ALU_out\[12\] net77 net68 CALC_INST.gencon_inst.mult_calc.out\[12\]
+ vssd1 vssd1 vccd1 vccd1 _0696_ sky130_fd_sc_hd__a22o_1
XFILLER_39_303 vssd1 vssd1 vccd1 vccd1 sky130_fd_sc_hd__fill_1
X_1492_ net51 _0641_ vssd1 vssd1 vccd1 vccd1 _0642_ sky130_fd_sc_hd__nand2_1
X_2044_ net32 _0982_ _0984_ vssd1 vssd1 vccd1 vccd1 _0985_ sky130_fd_sc_hd__a21oi_1
XFILLER_54_339 vssd1 vssd1 vccd1 vccd1 sky130_fd_sc_hd__fill_2
XTAP_TAPCELL_ROW_52_507 vssd1 vccd1 sky130_fd_sc_hd__tapvpwrvgnd_1
X_2113_ CALC_INST.gencon_inst.read_input _1078_ _1152_ _1058_ vssd1 vssd1 vccd1 vccd1
+ _0352_ sky130_fd_sc_hd__a22o_1
XTAP_TAPCELL_ROW_60_562 vssd1 vccd1 sky130_fd_sc_hd__tapvpwrvgnd_1
XTAP_TAPCELL_ROW_17_261 vssd1 vccd1 sky130_fd_sc_hd__tapvpwrvgnd_1
X_1828_ net142 _0844_ _0845_ net339 net131 vssd1 vssd1 vccd1 vccd1 _0224_ sky130_fd_sc_hd__a32o_1
X_1759_ _0784_ _0786_ vssd1 vssd1 vccd1 vccd1 _0787_ sky130_fd_sc_hd__xnor2_1
XTAP_TAPCELL_ROW_0_140 vssd1 vccd1 sky130_fd_sc_hd__tapvpwrvgnd_1
XFILLER_63_169 vssd1 vssd1 vccd1 vccd1 sky130_fd_sc_hd__fill_8
XFILLER_29_391 vssd1 vssd1 vccd1 vccd1 sky130_fd_sc_hd__fill_1
XFILLER_0_195 vssd1 vssd1 vccd1 vccd1 sky130_fd_sc_hd__fill_1
X_2731_ clknet_leaf_11_clk _0290_ net97 vssd1 vssd1 vccd1 vccd1 CALC_INST.gencon_inst.ALU_out\[0\]
+ sky130_fd_sc_hd__dfrtp_1
XANTENNA_clkbuf_leaf_14_clk_A clknet_2_3__leaf_clk vssd1 vssd1 vccd1 vccd1 sky130_fd_sc_hd__diode_2
X_2800_ clknet_leaf_28_clk net310 net107 vssd1 vssd1 vccd1 vccd1 CALC_INST.gencon_inst.mult_calc.count.GENERATE_ADDER\[9\].thingy.in1
+ sky130_fd_sc_hd__dfrtp_1
X_2593_ clknet_leaf_20_clk _0152_ vssd1 vssd1 vccd1 vccd1 CALC_INST.gencon_inst.ALU_in2\[14\]
+ sky130_fd_sc_hd__dfxtp_1
X_1613_ CALC_INST.gencon_inst.operand1\[8\] net285 net65 vssd1 vssd1 vccd1 vccd1 _0130_
+ sky130_fd_sc_hd__mux2_1
X_1544_ CALC_INST.gencon_inst.operand2\[8\] CALC_INST.gencon_inst.operand1\[8\] net74
+ vssd1 vssd1 vccd1 vccd1 _0683_ sky130_fd_sc_hd__mux2_1
XANTENNA_clkbuf_leaf_29_clk_A clknet_2_2__leaf_clk vssd1 vssd1 vccd1 vccd1 sky130_fd_sc_hd__diode_2
XFILLER_8_251 vssd1 vssd1 vccd1 vccd1 sky130_fd_sc_hd__fill_1
X_2662_ clknet_leaf_30_clk _0221_ net109 vssd1 vssd1 vccd1 vccd1 CALC_INST.gencon_inst.mult_calc.adderSave\[9\]
+ sky130_fd_sc_hd__dfrtp_1
XFILLER_39_177 vssd1 vssd1 vccd1 vccd1 sky130_fd_sc_hd__fill_1
XFILLER_39_111 vssd1 vssd1 vccd1 vccd1 sky130_fd_sc_hd__fill_1
X_1475_ CALC_INST.input_ctrl_inst.col_index\[25\] _0626_ CALC_INST.input_ctrl_inst.col_index\[26\]
+ vssd1 vssd1 vccd1 vccd1 _0629_ sky130_fd_sc_hd__a21oi_1
X_2027_ _0968_ _0970_ vssd1 vssd1 vccd1 vccd1 _0971_ sky130_fd_sc_hd__xnor2_1
XTAP_TAPCELL_ROW_20_278 vssd1 vccd1 sky130_fd_sc_hd__tapvpwrvgnd_1
XFILLER_49_57 vssd1 vssd1 vccd1 vccd1 sky130_fd_sc_hd__fill_1
Xhold284 net11 vssd1 vssd1 vccd1 vccd1 net483 sky130_fd_sc_hd__dlygate4sd3_1
Xhold262 CALC_INST.input_ctrl_inst.col_index\[31\] vssd1 vssd1 vccd1 vccd1 net461
+ sky130_fd_sc_hd__dlygate4sd3_1
Xhold295 CALC_INST.input_ctrl_inst.col_index\[26\] vssd1 vssd1 vccd1 vccd1 net494
+ sky130_fd_sc_hd__dlygate4sd3_1
Xhold273 CALC_INST.gencon_inst.mult_calc.compCount.in2\[14\] vssd1 vssd1 vccd1 vccd1
+ net472 sky130_fd_sc_hd__dlygate4sd3_1
Xhold240 CALC_INST.gencon_inst.mult_calc.adderSave\[10\] vssd1 vssd1 vccd1 vccd1 net439
+ sky130_fd_sc_hd__dlygate4sd3_1
Xhold251 CALC_INST.gencon_inst.mult_calc.compCount.in2\[13\] vssd1 vssd1 vccd1 vccd1
+ net450 sky130_fd_sc_hd__dlygate4sd3_1
XANTENNA_fanout74_A _0646_ vssd1 vssd1 vccd1 vccd1 sky130_fd_sc_hd__diode_2
XTAP_TAPCELL_ROW_28_334 vssd1 vccd1 sky130_fd_sc_hd__tapvpwrvgnd_1
XFILLER_41_364 vssd1 vssd1 vccd1 vccd1 sky130_fd_sc_hd__fill_8
XANTENNA__1553__S net74 vssd1 vssd1 vccd1 vccd1 sky130_fd_sc_hd__diode_2
X_1260_ CALC_INST.gencon_inst.mult_calc.out\[7\] net49 _0422_ vssd1 vssd1 vccd1 vccd1
+ _0463_ sky130_fd_sc_hd__a21o_1
XFILLER_24_309 vssd1 vssd1 vccd1 vccd1 sky130_fd_sc_hd__fill_1
XFILLER_32_386 vssd1 vssd1 vccd1 vccd1 sky130_fd_sc_hd__fill_1
X_2714_ clknet_leaf_32_clk _0273_ net91 vssd1 vssd1 vccd1 vccd1 CALC_INST.gencon_inst.mult_calc.out\[0\]
+ sky130_fd_sc_hd__dfrtp_1
X_2645_ clknet_leaf_19_clk _0204_ net119 vssd1 vssd1 vccd1 vccd1 CALC_INST.gencon_inst.add_calc.main.in2\[13\]
+ sky130_fd_sc_hd__dfrtp_1
X_2576_ clknet_leaf_20_clk _0135_ vssd1 vssd1 vccd1 vccd1 CALC_INST.gencon_inst.ALU_in1\[13\]
+ sky130_fd_sc_hd__dfxtp_1
X_1527_ net8 _0660_ _0670_ net71 vssd1 vssd1 vccd1 vccd1 _0671_ sky130_fd_sc_hd__o211a_1
X_1389_ _1082_ _0566_ _0567_ _0568_ vssd1 vssd1 vccd1 vccd1 _0569_ sky130_fd_sc_hd__or4_1
X_1458_ CALC_INST.input_ctrl_inst.col_index\[20\] net52 _0582_ _0617_ vssd1 vssd1
+ vccd1 vccd1 _0082_ sky130_fd_sc_hd__a22o_1
XTAP_TAPCELL_ROW_33_370 vssd1 vccd1 sky130_fd_sc_hd__tapvpwrvgnd_1
XTAP_TAPCELL_ROW_25_315 vssd1 vccd1 sky130_fd_sc_hd__tapvpwrvgnd_1
XFILLER_58_250 vssd1 vssd1 vccd1 vccd1 sky130_fd_sc_hd__fill_2
XFILLER_2_235 vccd1 vssd1 vccd1 vssd1 sky130_ef_sc_hd__decap_40_12
XANTENNA__1304__B1 net45 vssd1 vssd1 vccd1 vccd1 sky130_fd_sc_hd__diode_2
XFILLER_14_331 vssd1 vssd1 vccd1 vccd1 sky130_fd_sc_hd__fill_2
XANTENNA__1548__S net74 vssd1 vssd1 vccd1 vccd1 sky130_fd_sc_hd__diode_2
X_2361_ net39 _1196_ _1197_ net40 net502 vssd1 vssd1 vccd1 vccd1 _0009_ sky130_fd_sc_hd__a32o_1
X_2430_ _0401_ _0409_ vssd1 vssd1 vccd1 vccd1 _0410_ sky130_fd_sc_hd__and2_1
XFILLER_64_231 vssd1 vssd1 vccd1 vccd1 sky130_fd_sc_hd__fill_1
XFILLER_49_283 vssd1 vssd1 vccd1 vccd1 sky130_fd_sc_hd__fill_2
X_1312_ CALC_INST.gencon_inst.ALU_out\[1\] net75 net69 CALC_INST.gencon_inst.mult_calc.out\[1\]
+ net45 vssd1 vssd1 vccd1 vccd1 _0506_ sky130_fd_sc_hd__a221o_1
X_1243_ CALC_INST.gencon_inst.operand2\[3\] _0449_ net36 vssd1 vssd1 vccd1 vccd1 _0035_
+ sky130_fd_sc_hd__mux2_1
X_2292_ _1072_ _1080_ vssd1 vssd1 vccd1 vccd1 _1147_ sky130_fd_sc_hd__nor2_1
XANTENNA__2099__A1 net133 vssd1 vssd1 vccd1 vccd1 sky130_fd_sc_hd__diode_2
XFILLER_64_297 vssd1 vssd1 vccd1 vccd1 sky130_fd_sc_hd__fill_2
XFILLER_64_253 vssd1 vssd1 vccd1 vccd1 sky130_fd_sc_hd__fill_4
XTAP_TAPCELL_ROW_30_351 vssd1 vccd1 sky130_fd_sc_hd__tapvpwrvgnd_1
XANTENNA_fanout124_A net125 vssd1 vssd1 vccd1 vccd1 sky130_fd_sc_hd__diode_2
X_2628_ clknet_leaf_18_clk _0187_ net120 vssd1 vssd1 vccd1 vccd1 CALC_INST.gencon_inst.add_calc.main.GENERATE_ADDER\[11\].thingy.in1
+ sky130_fd_sc_hd__dfrtp_1
X_2559_ clknet_leaf_5_clk _0118_ net95 vssd1 vssd1 vccd1 vccd1 CALC_INST.gencon_inst.latched_operator_input\[0\]
+ sky130_fd_sc_hd__dfrtp_1
XANTENNA__1534__B1 _0674_ vssd1 vssd1 vccd1 vccd1 sky130_fd_sc_hd__diode_2
XFILLER_55_275 vssd1 vssd1 vccd1 vccd1 sky130_fd_sc_hd__fill_4
XFILLER_62_35 vssd1 vssd1 vccd1 vccd1 sky130_fd_sc_hd__fill_1
XFILLER_38_209 vssd1 vssd1 vccd1 vccd1 sky130_fd_sc_hd__fill_4
XFILLER_61_223 vssd1 vssd1 vccd1 vccd1 sky130_fd_sc_hd__fill_1
X_1930_ net146 CALC_INST.gencon_inst.add_calc.main.in2\[8\] vssd1 vssd1 vccd1 vccd1
+ _0881_ sky130_fd_sc_hd__nand2_1
XFILLER_46_286 vssd1 vssd1 vccd1 vccd1 sky130_fd_sc_hd__fill_4
X_1861_ net242 net220 net139 vssd1 vssd1 vccd1 vccd1 _0249_ sky130_fd_sc_hd__mux2_1
X_1792_ CALC_INST.gencon_inst.mult_calc.main.GENERATE_ADDER\[7\].thingy.in2 CALC_INST.gencon_inst.mult_calc.main.GENERATE_ADDER\[7\].thingy.in1
+ vssd1 vssd1 vccd1 vccd1 _0815_ sky130_fd_sc_hd__nand2_1
XANTENNA__1516__B1 net67 vssd1 vssd1 vccd1 vccd1 sky130_fd_sc_hd__diode_2
X_2344_ CALC_INST.input_ctrl_inst.debounce_cnt\[6\] _1183_ vssd1 vssd1 vccd1 vccd1
+ _1185_ sky130_fd_sc_hd__or2_1
X_2413_ CALC_INST.input_ctrl_inst.col_index\[21\] CALC_INST.input_ctrl_inst.col_index\[23\]
+ CALC_INST.input_ctrl_inst.col_index\[22\] vssd1 vssd1 vccd1 vccd1 _0393_ sky130_fd_sc_hd__and3_1
X_2275_ CALC_INST.gencon_inst.mult_calc.compCount.in2\[11\] _1128_ _1129_ _1126_ vssd1
+ vssd1 vccd1 vccd1 _1133_ sky130_fd_sc_hd__o22a_1
XFILLER_16_39 vssd1 vssd1 vccd1 vccd1 sky130_fd_sc_hd__fill_4
XFILLER_32_27 vssd1 vssd1 vccd1 vccd1 sky130_fd_sc_hd__fill_1
XFILLER_20_131 vssd1 vssd1 vccd1 vccd1 sky130_fd_sc_hd__fill_8
XANTENNA__2320__B CALC_INST.input_ctrl_inst.key_pressed vssd1 vssd1 vccd1 vccd1 sky130_fd_sc_hd__diode_2
XANTENNA_fanout127_X net127 vssd1 vssd1 vccd1 vccd1 sky130_fd_sc_hd__diode_2
XTAP_TAPCELL_ROW_58_546 vssd1 vccd1 sky130_fd_sc_hd__tapvpwrvgnd_1
XFILLER_43_289 vssd1 vssd1 vccd1 vccd1 sky130_fd_sc_hd__fill_1
XTAP_TAPCELL_ROW_41_424 vssd1 vccd1 sky130_fd_sc_hd__tapvpwrvgnd_1
XFILLER_22_60 vssd1 vssd1 vccd1 vccd1 sky130_fd_sc_hd__fill_2
XFILLER_7_124 vssd1 vssd1 vccd1 vccd1 sky130_fd_sc_hd__fill_1
XFILLER_3_385 vssd1 vssd1 vccd1 vccd1 sky130_fd_sc_hd__fill_4
X_2060_ _0930_ _0997_ vssd1 vssd1 vccd1 vccd1 _0998_ sky130_fd_sc_hd__xnor2_1
XFILLER_34_212 vssd1 vssd1 vccd1 vccd1 sky130_fd_sc_hd__fill_8
XFILLER_21_7 vssd1 vssd1 vccd1 vccd1 sky130_fd_sc_hd__fill_2
X_1913_ net147 CALC_INST.gencon_inst.add_calc.main.in2\[12\] vssd1 vssd1 vccd1 vccd1
+ _0864_ sky130_fd_sc_hd__or2_1
X_1844_ net453 net443 net137 vssd1 vssd1 vccd1 vccd1 _0232_ sky130_fd_sc_hd__mux2_1
X_1775_ CALC_INST.gencon_inst.mult_calc.main.GENERATE_ADDER\[5\].thingy.in2 CALC_INST.gencon_inst.mult_calc.main.GENERATE_ADDER\[5\].thingy.in1
+ vssd1 vssd1 vccd1 vccd1 _0800_ sky130_fd_sc_hd__or2_1
XFILLER_57_359 vssd1 vssd1 vccd1 vccd1 sky130_fd_sc_hd__fill_2
XFILLER_57_337 vssd1 vssd1 vccd1 vccd1 sky130_fd_sc_hd__fill_2
X_2327_ CALC_INST.input_ctrl_inst.debounce_cnt\[0\] CALC_INST.input_ctrl_inst.debounce_cnt\[1\]
+ vssd1 vssd1 vccd1 vccd1 _1173_ sky130_fd_sc_hd__or2_1
X_2258_ CALC_INST.gencon_inst.mult_calc.compCount.in2\[6\] _1113_ _1115_ CALC_INST.gencon_inst.mult_calc.compCount.in2\[7\]
+ vssd1 vssd1 vccd1 vccd1 _1116_ sky130_fd_sc_hd__a22o_1
XTAP_TAPCELL_ROW_63_582 vssd1 vccd1 sky130_fd_sc_hd__tapvpwrvgnd_1
XTAP_TAPCELL_ROW_55_527 vssd1 vccd1 sky130_fd_sc_hd__tapvpwrvgnd_1
X_2189_ CALC_INST.input_ctrl_inst.debounce_cnt\[14\] vssd1 vssd1 vccd1 vccd1 _1049_
+ sky130_fd_sc_hd__inv_2
XFILLER_4_105 vssd1 vssd1 vccd1 vccd1 sky130_fd_sc_hd__fill_1
XFILLER_0_333 vssd1 vssd1 vccd1 vccd1 sky130_fd_sc_hd__fill_2
XTAP_TAPCELL_ROW_3_160 vssd1 vccd1 sky130_fd_sc_hd__tapvpwrvgnd_1
XFILLER_17_60 vssd1 vssd1 vccd1 vccd1 sky130_fd_sc_hd__fill_2
XFILLER_17_82 vssd1 vssd1 vccd1 vccd1 sky130_fd_sc_hd__fill_4
X_1560_ CALC_INST.gencon_inst.operand2\[12\] CALC_INST.gencon_inst.operand1\[12\]
+ net74 vssd1 vssd1 vccd1 vccd1 _0695_ sky130_fd_sc_hd__mux2_1
XANTENNA__1556__S net74 vssd1 vssd1 vccd1 vccd1 sky130_fd_sc_hd__diode_2
XFILLER_39_326 vssd1 vssd1 vccd1 vccd1 sky130_fd_sc_hd__fill_1
X_1491_ CALC_INST.input_ctrl_inst.col_index\[29\] CALC_INST.input_ctrl_inst.col_index\[30\]
+ _0635_ _0584_ vssd1 vssd1 vccd1 vccd1 _0641_ sky130_fd_sc_hd__a31o_1
XFILLER_12_3 vssd1 vssd1 vccd1 vccd1 sky130_fd_sc_hd__fill_4
X_2112_ net135 net314 net124 net322 vssd1 vssd1 vccd1 vccd1 _0351_ sky130_fd_sc_hd__a22o_1
X_2043_ _0925_ _0983_ vssd1 vssd1 vccd1 vccd1 _0984_ sky130_fd_sc_hd__xnor2_1
XTAP_TAPCELL_ROW_17_262 vssd1 vccd1 sky130_fd_sc_hd__tapvpwrvgnd_1
XTAP_TAPCELL_ROW_60_563 vssd1 vccd1 sky130_fd_sc_hd__tapvpwrvgnd_1
X_1827_ _0841_ _0842_ _0843_ vssd1 vssd1 vccd1 vccd1 _0845_ sky130_fd_sc_hd__a21o_1
X_1689_ net373 _0744_ net152 vssd1 vssd1 vccd1 vccd1 _0186_ sky130_fd_sc_hd__mux2_1
X_1758_ _0779_ _0785_ vssd1 vssd1 vccd1 vccd1 _0786_ sky130_fd_sc_hd__or2_1
XFILLER_38_26 vssd1 vssd1 vccd1 vccd1 sky130_fd_sc_hd__fill_2
XTAP_TAPCELL_ROW_0_141 vssd1 vccd1 sky130_fd_sc_hd__tapvpwrvgnd_1
XTAP_TAPCELL_ROW_0_130 vssd1 vccd1 sky130_fd_sc_hd__tapvpwrvgnd_1
XTAP_TAPCELL_ROW_23_298 vssd1 vccd1 sky130_fd_sc_hd__tapvpwrvgnd_1
XFILLER_5_403 vssd1 vssd1 vccd1 vccd1 sky130_fd_sc_hd__fill_1
XFILLER_0_141 vssd1 vssd1 vccd1 vccd1 sky130_fd_sc_hd__fill_8
X_2730_ clknet_leaf_3_clk _0289_ net91 vssd1 vssd1 vccd1 vccd1 CALC_INST.gencon_inst.mult_calc.diffSign
+ sky130_fd_sc_hd__dfrtp_1
X_2661_ clknet_leaf_24_clk _0220_ net109 vssd1 vssd1 vccd1 vccd1 CALC_INST.gencon_inst.mult_calc.adderSave\[8\]
+ sky130_fd_sc_hd__dfrtp_1
X_2592_ clknet_leaf_20_clk _0151_ vssd1 vssd1 vccd1 vccd1 CALC_INST.gencon_inst.ALU_in2\[13\]
+ sky130_fd_sc_hd__dfxtp_1
X_1612_ CALC_INST.gencon_inst.operand1\[7\] net273 net65 vssd1 vssd1 vccd1 vccd1 _0129_
+ sky130_fd_sc_hd__mux2_1
X_1543_ net271 _0660_ _0682_ vssd1 vssd1 vccd1 vccd1 _0102_ sky130_fd_sc_hd__o21a_1
XFILLER_5_63 vssd1 vssd1 vccd1 vccd1 sky130_fd_sc_hd__fill_8
X_1474_ CALC_INST.input_ctrl_inst.col_index\[25\] net52 _0582_ _0628_ vssd1 vssd1
+ vccd1 vccd1 _0087_ sky130_fd_sc_hd__a22o_1
XFILLER_54_126 vssd1 vssd1 vccd1 vccd1 sky130_fd_sc_hd__fill_2
XFILLER_27_307 vssd1 vssd1 vccd1 vccd1 sky130_fd_sc_hd__fill_2
X_2026_ net32 _0969_ vssd1 vssd1 vccd1 vccd1 _0970_ sky130_fd_sc_hd__nand2_1
XANTENNA_fanout154_A CALC_INST.gencon_inst.add_calc.state\[1\] vssd1 vssd1 vccd1 vccd1
+ sky130_fd_sc_hd__diode_2
XANTENNA__1985__A net154 vssd1 vssd1 vccd1 vccd1 sky130_fd_sc_hd__diode_2
X_2859_ clknet_leaf_10_clk _0374_ vssd1 vssd1 vccd1 vccd1 CALC_INST.input_ctrl_inst.scan_timer\[13\]
+ sky130_fd_sc_hd__dfxtp_1
XTAP_TAPCELL_ROW_20_279 vssd1 vccd1 sky130_fd_sc_hd__tapvpwrvgnd_1
XFILLER_49_36 vssd1 vssd1 vccd1 vccd1 sky130_fd_sc_hd__fill_1
XFILLER_49_25 vssd1 vssd1 vccd1 vccd1 sky130_fd_sc_hd__fill_2
Xhold241 CALC_INST.gencon_inst.mult_calc.INn2\[7\] vssd1 vssd1 vccd1 vccd1 net440
+ sky130_fd_sc_hd__dlygate4sd3_1
Xhold230 _0333_ vssd1 vssd1 vccd1 vccd1 net429 sky130_fd_sc_hd__dlygate4sd3_1
Xhold285 CALC_INST.input_ctrl_inst.debounce_cnt\[18\] vssd1 vssd1 vccd1 vccd1 net484
+ sky130_fd_sc_hd__dlygate4sd3_1
Xhold263 CALC_INST.input_ctrl_inst.col_index\[17\] vssd1 vssd1 vccd1 vccd1 net462
+ sky130_fd_sc_hd__dlygate4sd3_1
Xhold274 CALC_INST.gencon_inst.mult_calc.adderSave\[2\] vssd1 vssd1 vccd1 vccd1 net473
+ sky130_fd_sc_hd__dlygate4sd3_1
Xhold252 CALC_INST.gencon_inst.mult_calc.main.a0.in2 vssd1 vssd1 vccd1 vccd1 net451
+ sky130_fd_sc_hd__dlygate4sd3_1
Xhold296 CALC_INST.gencon_inst.mult_calc.start vssd1 vssd1 vccd1 vccd1 net495 sky130_fd_sc_hd__dlygate4sd3_1
XANTENNA_fanout67_A _0662_ vssd1 vssd1 vccd1 vccd1 sky130_fd_sc_hd__diode_2
XFILLER_45_104 vssd1 vssd1 vccd1 vccd1 sky130_fd_sc_hd__fill_8
XTAP_TAPCELL_ROW_28_335 vssd1 vccd1 sky130_fd_sc_hd__tapvpwrvgnd_1
XANTENNA_clkbuf_2_3__f_clk_A clknet_0_clk vssd1 vssd1 vccd1 vccd1 sky130_fd_sc_hd__diode_2
XTAP_TAPCELL_ROW_36_390 vssd1 vccd1 sky130_fd_sc_hd__tapvpwrvgnd_1
XFILLER_14_83 vssd1 vssd1 vccd1 vccd1 sky130_fd_sc_hd__fill_1
XFILLER_30_82 vssd1 vssd1 vccd1 vccd1 sky130_fd_sc_hd__fill_2
XFILLER_51_129 vssd1 vssd1 vccd1 vccd1 sky130_fd_sc_hd__fill_2
XFILLER_36_159 vssd1 vssd1 vccd1 vccd1 sky130_fd_sc_hd__fill_1
X_2644_ clknet_leaf_19_clk _0203_ net120 vssd1 vssd1 vccd1 vccd1 CALC_INST.gencon_inst.add_calc.main.in2\[12\]
+ sky130_fd_sc_hd__dfrtp_1
X_2713_ clknet_leaf_26_clk net366 net109 vssd1 vssd1 vccd1 vccd1 CALC_INST.gencon_inst.mult_calc.main.GENERATE_ADDER\[14\].thingy.in2
+ sky130_fd_sc_hd__dfrtp_1
X_2575_ clknet_leaf_20_clk _0134_ vssd1 vssd1 vccd1 vccd1 CALC_INST.gencon_inst.ALU_in1\[12\]
+ sky130_fd_sc_hd__dfxtp_1
X_1526_ _0655_ _0669_ vssd1 vssd1 vccd1 vccd1 _0670_ sky130_fd_sc_hd__or2_1
X_1457_ CALC_INST.input_ctrl_inst.col_index\[20\] _0615_ vssd1 vssd1 vccd1 vccd1 _0617_
+ sky130_fd_sc_hd__xor2_1
X_1388_ CALC_INST.input_ctrl_inst.scan_timer\[11\] _0563_ CALC_INST.input_ctrl_inst.scan_timer\[8\]
+ vssd1 vssd1 vccd1 vccd1 _0568_ sky130_fd_sc_hd__or3b_1
XFILLER_35_38 vssd1 vssd1 vccd1 vccd1 sky130_fd_sc_hd__fill_1
X_2009_ _0916_ _0955_ vssd1 vssd1 vccd1 vccd1 _0956_ sky130_fd_sc_hd__xnor2_1
XFILLER_42_129 vssd1 vssd1 vccd1 vccd1 sky130_fd_sc_hd__fill_1
XTAP_TAPCELL_ROW_33_371 vssd1 vccd1 sky130_fd_sc_hd__tapvpwrvgnd_1
XTAP_TAPCELL_ROW_25_316 vssd1 vccd1 sky130_fd_sc_hd__tapvpwrvgnd_1
XFILLER_23_376 vssd1 vssd1 vccd1 vccd1 sky130_fd_sc_hd__fill_1
XANTENNA__1654__S net44 vssd1 vssd1 vccd1 vccd1 sky130_fd_sc_hd__diode_2
XFILLER_58_284 vssd1 vssd1 vccd1 vccd1 sky130_fd_sc_hd__fill_1
XANTENNA_clkbuf_leaf_13_clk_A clknet_2_1__leaf_clk vssd1 vssd1 vccd1 vccd1 sky130_fd_sc_hd__diode_2
XANTENNA_clkbuf_leaf_28_clk_A clknet_2_2__leaf_clk vssd1 vssd1 vccd1 vccd1 sky130_fd_sc_hd__diode_2
XFILLER_41_162 vssd1 vssd1 vccd1 vccd1 sky130_fd_sc_hd__fill_1
XFILLER_41_70 vssd1 vssd1 vccd1 vccd1 sky130_fd_sc_hd__fill_1
X_2291_ net155 vssd1 vssd1 vccd1 vccd1 CALC_INST.gencon_inst.add_calc.nRST sky130_fd_sc_hd__inv_2
XFILLER_44_6 vssd1 vssd1 vccd1 vccd1 sky130_fd_sc_hd__fill_1
X_1311_ _0503_ _0504_ vssd1 vssd1 vccd1 vccd1 _0505_ sky130_fd_sc_hd__nor2_1
X_2360_ CALC_INST.input_ctrl_inst.debounce_cnt\[10\] _1194_ vssd1 vssd1 vccd1 vccd1
+ _1197_ sky130_fd_sc_hd__or2_1
X_1242_ net54 _0446_ _0448_ net49 CALC_INST.gencon_inst.mult_calc.out\[3\] vssd1 vssd1
+ vccd1 vccd1 _0449_ sky130_fd_sc_hd__a32o_1
XFILLER_2_97 vssd1 vssd1 vccd1 vccd1 sky130_fd_sc_hd__fill_2
XPHY_EDGE_ROW_10_Right_10 vssd1 vssd1 vccd1 vccd1 sky130_fd_sc_hd__decap_3
X_2627_ clknet_leaf_18_clk _0186_ net120 vssd1 vssd1 vccd1 vccd1 CALC_INST.gencon_inst.add_calc.main.GENERATE_ADDER\[10\].thingy.in1
+ sky130_fd_sc_hd__dfrtp_1
XTAP_TAPCELL_ROW_30_352 vssd1 vccd1 sky130_fd_sc_hd__tapvpwrvgnd_1
XANTENNA__1782__A1 net141 vssd1 vssd1 vccd1 vccd1 sky130_fd_sc_hd__diode_2
XANTENNA__1782__B2 net132 vssd1 vssd1 vccd1 vccd1 sky130_fd_sc_hd__diode_2
X_2489_ clknet_leaf_13_clk _0048_ net99 vssd1 vssd1 vccd1 vccd1 CALC_INST.gencon_inst.operand1\[1\]
+ sky130_fd_sc_hd__dfrtp_1
XANTENNA__1534__B2 _0656_ vssd1 vssd1 vccd1 vccd1 sky130_fd_sc_hd__diode_2
X_1509_ net73 _0654_ vssd1 vssd1 vccd1 vccd1 _0656_ sky130_fd_sc_hd__nand2_4
X_2558_ clknet_leaf_5_clk _0117_ net95 vssd1 vssd1 vccd1 vccd1 CALC_INST.gencon_inst.latched_keypad_input\[3\]
+ sky130_fd_sc_hd__dfrtp_2
XFILLER_28_402 vssd1 vssd1 vccd1 vccd1 sky130_fd_sc_hd__fill_4
XFILLER_55_254 vssd1 vssd1 vccd1 vccd1 sky130_fd_sc_hd__fill_1
Xclkbuf_leaf_35_clk clknet_2_0__leaf_clk vssd1 vssd1 vccd1 vccd1 clknet_leaf_35_clk
+ sky130_fd_sc_hd__clkbuf_8
XFILLER_11_335 vssd1 vssd1 vccd1 vccd1 sky130_fd_sc_hd__fill_1
XFILLER_11_62 vssd1 vssd1 vccd1 vccd1 sky130_fd_sc_hd__fill_1
XFILLER_46_276 vssd1 vssd1 vccd1 vccd1 sky130_fd_sc_hd__fill_2
XFILLER_61_279 vssd1 vssd1 vccd1 vccd1 sky130_fd_sc_hd__fill_1
XFILLER_36_81 vssd1 vssd1 vccd1 vccd1 sky130_fd_sc_hd__fill_2
X_1860_ net239 net221 net138 vssd1 vssd1 vccd1 vccd1 _0248_ sky130_fd_sc_hd__mux2_1
Xclkbuf_leaf_26_clk clknet_2_2__leaf_clk vssd1 vssd1 vccd1 vccd1 clknet_leaf_26_clk
+ sky130_fd_sc_hd__clkbuf_8
X_1791_ _0813_ vssd1 vssd1 vccd1 vccd1 _0814_ sky130_fd_sc_hd__inv_2
X_2343_ net38 _1182_ _1184_ net40 net491 vssd1 vssd1 vccd1 vccd1 _0022_ sky130_fd_sc_hd__a32o_1
X_2412_ CALC_INST.input_ctrl_inst.col_index\[19\] CALC_INST.input_ctrl_inst.col_index\[18\]
+ CALC_INST.input_ctrl_inst.col_index\[20\] vssd1 vssd1 vccd1 vccd1 _0392_ sky130_fd_sc_hd__and3_1
X_2274_ CALC_INST.gencon_inst.mult_calc.compCount.in2\[12\] _1131_ vssd1 vssd1 vccd1
+ vccd1 _1132_ sky130_fd_sc_hd__or2_1
Xclkbuf_leaf_17_clk clknet_2_3__leaf_clk vssd1 vssd1 vccd1 vccd1 clknet_leaf_17_clk
+ sky130_fd_sc_hd__clkbuf_8
XFILLER_37_287 vssd1 vssd1 vccd1 vccd1 sky130_fd_sc_hd__fill_1
XFILLER_37_221 vssd1 vssd1 vccd1 vccd1 sky130_fd_sc_hd__fill_2
X_1989_ _0856_ _0935_ vssd1 vssd1 vccd1 vccd1 _0939_ sky130_fd_sc_hd__nand2b_1
XFILLER_32_17 vssd1 vssd1 vccd1 vccd1 sky130_fd_sc_hd__fill_8
XFILLER_20_110 vssd1 vssd1 vccd1 vccd1 sky130_fd_sc_hd__fill_4
XFILLER_20_165 vssd1 vssd1 vccd1 vccd1 sky130_fd_sc_hd__fill_1
XTAP_TAPCELL_ROW_58_547 vssd1 vccd1 sky130_fd_sc_hd__tapvpwrvgnd_1
XFILLER_43_279 vssd1 vssd1 vccd1 vccd1 sky130_fd_sc_hd__fill_1
XTAP_TAPCELL_ROW_41_425 vssd1 vccd1 sky130_fd_sc_hd__tapvpwrvgnd_1
XFILLER_22_83 vssd1 vssd1 vccd1 vccd1 sky130_fd_sc_hd__fill_1
XFILLER_22_72 vssd1 vssd1 vccd1 vccd1 sky130_fd_sc_hd__fill_1
XANTENNA__1842__S net137 vssd1 vssd1 vccd1 vccd1 sky130_fd_sc_hd__diode_2
XTAP_TAPCELL_ROW_6_180 vssd1 vccd1 sky130_fd_sc_hd__tapvpwrvgnd_1
XFILLER_19_210 vssd1 vssd1 vccd1 vccd1 sky130_fd_sc_hd__fill_2
XFILLER_19_221 vssd1 vssd1 vccd1 vccd1 sky130_fd_sc_hd__fill_2
X_1912_ CALC_INST.gencon_inst.add_calc.main.GENERATE_ADDER\[13\].thingy.in1 _0860_
+ _0861_ vssd1 vssd1 vccd1 vccd1 _0863_ sky130_fd_sc_hd__nand3_1
XFILLER_8_41 vssd1 vssd1 vccd1 vccd1 sky130_fd_sc_hd__fill_4
XFILLER_8_85 vssd1 vssd1 vccd1 vccd1 sky130_fd_sc_hd__fill_8
X_1843_ net391 CALC_INST.gencon_inst.mult_calc.INn2\[4\] net137 vssd1 vssd1 vccd1
+ vccd1 _0231_ sky130_fd_sc_hd__mux2_1
Xclkbuf_leaf_6_clk clknet_2_1__leaf_clk vssd1 vssd1 vccd1 vccd1 clknet_leaf_6_clk
+ sky130_fd_sc_hd__clkbuf_8
X_1774_ net434 net132 _0799_ net141 vssd1 vssd1 vccd1 vccd1 _0216_ sky130_fd_sc_hd__a22o_1
X_2257_ CALC_INST.gencon_inst.mult_calc.count.GENERATE_ADDER\[7\].thingy.in1 _1091_
+ vssd1 vssd1 vccd1 vccd1 _1115_ sky130_fd_sc_hd__xnor2_1
X_2326_ net38 net40 CALC_INST.input_ctrl_inst.debounce_cnt\[0\] vssd1 vssd1 vccd1
+ vccd1 _0008_ sky130_fd_sc_hd__mux2_1
XTAP_TAPCELL_ROW_63_583 vssd1 vccd1 sky130_fd_sc_hd__tapvpwrvgnd_1
XTAP_TAPCELL_ROW_55_528 vssd1 vccd1 sky130_fd_sc_hd__tapvpwrvgnd_1
XFILLER_43_16 vssd1 vssd1 vccd1 vccd1 sky130_fd_sc_hd__fill_1
XFILLER_40_205 vssd1 vssd1 vccd1 vccd1 sky130_fd_sc_hd__fill_2
X_2188_ CALC_INST.gencon_inst.mult_calc.start net155 net43 vssd1 vssd1 vccd1 vccd1
+ _0381_ sky130_fd_sc_hd__a21o_1
XFILLER_25_279 vssd1 vssd1 vccd1 vccd1 sky130_fd_sc_hd__fill_1
XANTENNA__1515__X _0662_ vssd1 vssd1 vccd1 vccd1 sky130_fd_sc_hd__diode_2
XTAP_TAPCELL_ROW_3_161 vssd1 vccd1 sky130_fd_sc_hd__tapvpwrvgnd_1
XPHY_EDGE_ROW_9_Left_74 vssd1 vssd1 vccd1 vccd1 sky130_fd_sc_hd__decap_3
XFILLER_31_216 vssd1 vssd1 vccd1 vccd1 sky130_fd_sc_hd__fill_8
X_1490_ CALC_INST.input_ctrl_inst.col_index\[29\] net52 _0585_ _0640_ vssd1 vssd1
+ vccd1 vccd1 _0091_ sky130_fd_sc_hd__a22o_1
X_2042_ _0870_ _0871_ vssd1 vssd1 vccd1 vccd1 _0983_ sky130_fd_sc_hd__and2b_1
Xhold1 CALC_INST.input_ctrl_inst.RowMid\[2\] vssd1 vssd1 vccd1 vccd1 net200 sky130_fd_sc_hd__dlygate4sd3_1
X_2111_ net135 net311 net124 net313 vssd1 vssd1 vccd1 vccd1 _0350_ sky130_fd_sc_hd__a22o_1
XPHY_EDGE_ROW_8_Right_8 vssd1 vssd1 vccd1 vccd1 sky130_fd_sc_hd__decap_3
X_1826_ _0841_ _0842_ _0843_ vssd1 vssd1 vccd1 vccd1 _0844_ sky130_fd_sc_hd__nand3_1
X_1688_ CALC_INST.gencon_inst.ALU_in2\[10\] CALC_INST.gencon_inst.ALU_in1\[10\] net60
+ vssd1 vssd1 vccd1 vccd1 _0744_ sky130_fd_sc_hd__mux2_1
XANTENNA__2489__RESET_B net99 vssd1 vssd1 vccd1 vccd1 sky130_fd_sc_hd__diode_2
XPHY_EDGE_ROW_39_Right_39 vssd1 vssd1 vccd1 vccd1 sky130_fd_sc_hd__decap_3
X_1757_ CALC_INST.gencon_inst.mult_calc.main.a0.in2 CALC_INST.gencon_inst.mult_calc.main.a0.in1
+ CALC_INST.gencon_inst.mult_calc.main.GENERATE_ADDER\[1\].thingy.in2 CALC_INST.gencon_inst.mult_calc.main.GENERATE_ADDER\[1\].thingy.in1
+ vssd1 vssd1 vccd1 vccd1 _0785_ sky130_fd_sc_hd__a22oi_1
XFILLER_57_135 vssd1 vssd1 vccd1 vccd1 sky130_fd_sc_hd__fill_1
XANTENNA__1511__A _0655_ vssd1 vssd1 vccd1 vccd1 sky130_fd_sc_hd__diode_2
XFILLER_38_393 vssd1 vssd1 vccd1 vccd1 sky130_fd_sc_hd__fill_2
XFILLER_38_49 vssd1 vssd1 vccd1 vccd1 sky130_fd_sc_hd__fill_2
X_2309_ _1155_ _1157_ _1156_ _1077_ vssd1 vssd1 vccd1 vccd1 _1158_ sky130_fd_sc_hd__o211a_1
XTAP_TAPCELL_ROW_0_142 vssd1 vccd1 sky130_fd_sc_hd__tapvpwrvgnd_1
XTAP_TAPCELL_ROW_0_131 vssd1 vccd1 sky130_fd_sc_hd__tapvpwrvgnd_1
XPHY_EDGE_ROW_48_Right_48 vssd1 vssd1 vccd1 vccd1 sky130_fd_sc_hd__decap_3
XANTENNA__1657__S net44 vssd1 vssd1 vccd1 vccd1 sky130_fd_sc_hd__diode_2
XPHY_EDGE_ROW_57_Right_57 vssd1 vssd1 vccd1 vccd1 sky130_fd_sc_hd__decap_3
XTAP_TAPCELL_ROW_23_299 vssd1 vccd1 sky130_fd_sc_hd__tapvpwrvgnd_1
XANTENNA__1885__B1 net125 vssd1 vssd1 vccd1 vccd1 sky130_fd_sc_hd__diode_2
XANTENNA__2069__A1_N net127 vssd1 vssd1 vccd1 vccd1 sky130_fd_sc_hd__diode_2
XFILLER_0_197 vccd1 vssd1 vccd1 vssd1 sky130_ef_sc_hd__decap_40_12
XFILLER_63_138 vssd1 vssd1 vccd1 vccd1 sky130_fd_sc_hd__fill_1
XFILLER_63_105 vssd1 vssd1 vccd1 vccd1 sky130_fd_sc_hd__fill_4
X_1611_ CALC_INST.gencon_inst.operand1\[6\] net264 net65 vssd1 vssd1 vccd1 vccd1 _0128_
+ sky130_fd_sc_hd__mux2_1
XFILLER_44_81 vssd1 vssd1 vccd1 vccd1 sky130_fd_sc_hd__fill_2
XANTENNA__1567__S _0646_ vssd1 vssd1 vccd1 vccd1 sky130_fd_sc_hd__diode_2
X_2660_ clknet_leaf_30_clk _0219_ net106 vssd1 vssd1 vccd1 vccd1 CALC_INST.gencon_inst.mult_calc.adderSave\[7\]
+ sky130_fd_sc_hd__dfrtp_1
X_2591_ clknet_leaf_19_clk _0150_ vssd1 vssd1 vccd1 vccd1 CALC_INST.gencon_inst.ALU_in2\[12\]
+ sky130_fd_sc_hd__dfxtp_1
X_1542_ _0415_ _0680_ _0681_ _0659_ vssd1 vssd1 vccd1 vccd1 _0682_ sky130_fd_sc_hd__a211o_1
X_1473_ CALC_INST.input_ctrl_inst.col_index\[25\] _0626_ vssd1 vssd1 vccd1 vccd1 _0628_
+ sky130_fd_sc_hd__xor2_1
X_2025_ _0958_ _0961_ _0964_ vssd1 vssd1 vccd1 vccd1 _0969_ sky130_fd_sc_hd__or3_1
XPHY_EDGE_ROW_59_Left_124 vssd1 vssd1 vccd1 vccd1 sky130_fd_sc_hd__decap_3
XANTENNA__1331__A _0491_ vssd1 vssd1 vccd1 vccd1 sky130_fd_sc_hd__diode_2
XFILLER_24_29 vssd1 vssd1 vccd1 vccd1 sky130_fd_sc_hd__fill_1
X_2858_ clknet_leaf_9_clk _0373_ vssd1 vssd1 vccd1 vccd1 CALC_INST.input_ctrl_inst.scan_timer\[12\]
+ sky130_fd_sc_hd__dfxtp_1
Xhold253 CALC_INST.gencon_inst.ALU_out\[0\] vssd1 vssd1 vccd1 vccd1 net452 sky130_fd_sc_hd__dlygate4sd3_1
Xhold242 _0328_ vssd1 vssd1 vccd1 vccd1 net441 sky130_fd_sc_hd__dlygate4sd3_1
X_2789_ clknet_leaf_2_clk net328 net84 vssd1 vssd1 vccd1 vccd1 net22 sky130_fd_sc_hd__dfrtp_1
Xhold231 CALC_INST.gencon_inst.mult_calc.compCount.in2\[6\] vssd1 vssd1 vccd1 vccd1
+ net430 sky130_fd_sc_hd__dlygate4sd3_1
Xhold220 CALC_INST.gencon_inst.mult_calc.compCount.in2\[9\] vssd1 vssd1 vccd1 vccd1
+ net419 sky130_fd_sc_hd__dlygate4sd3_1
X_1809_ net142 _0828_ _0829_ net379 net131 vssd1 vssd1 vccd1 vccd1 _0221_ sky130_fd_sc_hd__a32o_1
Xhold264 CALC_INST.gencon_inst.ALU_out\[12\] vssd1 vssd1 vccd1 vccd1 net463 sky130_fd_sc_hd__dlygate4sd3_1
Xhold286 net9 vssd1 vssd1 vccd1 vccd1 net485 sky130_fd_sc_hd__dlygate4sd3_1
Xhold297 CALC_INST.input_ctrl_inst.col_index\[30\] vssd1 vssd1 vccd1 vccd1 net496
+ sky130_fd_sc_hd__dlygate4sd3_1
Xhold275 CALC_INST.input_ctrl_inst.col_index\[24\] vssd1 vssd1 vccd1 vccd1 net474
+ sky130_fd_sc_hd__dlygate4sd3_1
XANTENNA__1512__Y _0659_ vssd1 vssd1 vccd1 vccd1 sky130_fd_sc_hd__diode_2
XTAP_TAPCELL_ROW_28_336 vssd1 vccd1 sky130_fd_sc_hd__tapvpwrvgnd_1
XFILLER_26_330 vssd1 vssd1 vccd1 vccd1 sky130_fd_sc_hd__fill_1
XTAP_TAPCELL_ROW_36_391 vssd1 vccd1 sky130_fd_sc_hd__tapvpwrvgnd_1
XTAP_TAPCELL_ROW_11_214 vssd1 vccd1 sky130_fd_sc_hd__tapvpwrvgnd_1
XANTENNA__2011__S net154 vssd1 vssd1 vccd1 vccd1 sky130_fd_sc_hd__diode_2
XANTENNA__1570__A2 _0660_ vssd1 vssd1 vccd1 vccd1 sky130_fd_sc_hd__diode_2
XFILLER_30_61 vssd1 vssd1 vccd1 vccd1 sky130_fd_sc_hd__fill_1
X_2643_ clknet_leaf_18_clk _0202_ net120 vssd1 vssd1 vccd1 vccd1 CALC_INST.gencon_inst.add_calc.main.in2\[11\]
+ sky130_fd_sc_hd__dfrtp_1
X_2574_ clknet_leaf_19_clk _0133_ vssd1 vssd1 vccd1 vccd1 CALC_INST.gencon_inst.ALU_in1\[11\]
+ sky130_fd_sc_hd__dfxtp_1
X_2712_ clknet_leaf_25_clk _0271_ net110 vssd1 vssd1 vccd1 vccd1 CALC_INST.gencon_inst.mult_calc.main.GENERATE_ADDER\[13\].thingy.in2
+ sky130_fd_sc_hd__dfrtp_1
X_1387_ CALC_INST.input_ctrl_inst.scan_timer\[1\] CALC_INST.input_ctrl_inst.scan_timer\[0\]
+ CALC_INST.input_ctrl_inst.scan_timer\[3\] _0565_ vssd1 vssd1 vccd1 vccd1 _0567_
+ sky130_fd_sc_hd__or4_1
X_1525_ CALC_INST.gencon_inst.operand2\[3\] CALC_INST.gencon_inst.operand1\[3\] net73
+ vssd1 vssd1 vccd1 vccd1 _0669_ sky130_fd_sc_hd__mux2_1
X_1456_ net457 net52 _0616_ vssd1 vssd1 vccd1 vccd1 _0081_ sky130_fd_sc_hd__a21bo_1
X_2008_ _0894_ _0895_ vssd1 vssd1 vccd1 vccd1 _0955_ sky130_fd_sc_hd__and2b_1
XANTENNA__1313__A2 net47 vssd1 vssd1 vccd1 vccd1 sky130_fd_sc_hd__diode_2
XFILLER_35_171 vssd1 vssd1 vccd1 vccd1 sky130_fd_sc_hd__fill_1
XTAP_TAPCELL_ROW_25_317 vssd1 vccd1 sky130_fd_sc_hd__tapvpwrvgnd_1
XFILLER_50_152 vssd1 vssd1 vccd1 vccd1 sky130_fd_sc_hd__fill_1
XANTENNA__2444__X _0415_ vssd1 vssd1 vccd1 vccd1 sky130_fd_sc_hd__diode_2
XTAP_TAPCELL_ROW_33_372 vssd1 vccd1 sky130_fd_sc_hd__tapvpwrvgnd_1
XFILLER_14_333 vssd1 vssd1 vccd1 vccd1 sky130_fd_sc_hd__fill_1
X_2290_ net6 net1 vssd1 vssd1 vccd1 vccd1 _1146_ sky130_fd_sc_hd__nand2_2
X_1310_ _0497_ _0502_ _0491_ vssd1 vssd1 vccd1 vccd1 _0504_ sky130_fd_sc_hd__a21o_1
XANTENNA__1543__A2 _0660_ vssd1 vssd1 vccd1 vccd1 sky130_fd_sc_hd__diode_2
X_1241_ _0447_ vssd1 vssd1 vccd1 vccd1 _0448_ sky130_fd_sc_hd__inv_2
XPHY_EDGE_ROW_22_Left_87 vssd1 vssd1 vccd1 vccd1 sky130_fd_sc_hd__decap_3
XFILLER_1_281 vccd1 vssd1 vccd1 vssd1 sky130_ef_sc_hd__decap_40_12
XFILLER_64_299 vssd1 vssd1 vccd1 vccd1 sky130_fd_sc_hd__fill_1
XFILLER_52_406 vssd1 vssd1 vccd1 vccd1 sky130_fd_sc_hd__fill_1
XFILLER_49_285 vssd1 vssd1 vccd1 vccd1 sky130_fd_sc_hd__fill_1
XTAP_TAPCELL_ROW_30_353 vssd1 vccd1 sky130_fd_sc_hd__tapvpwrvgnd_1
X_2626_ clknet_leaf_17_clk _0185_ net119 vssd1 vssd1 vccd1 vccd1 CALC_INST.gencon_inst.add_calc.main.GENERATE_ADDER\[9\].thingy.in1
+ sky130_fd_sc_hd__dfrtp_1
XANTENNA__1519__C1 net71 vssd1 vssd1 vccd1 vccd1 sky130_fd_sc_hd__diode_2
XANTENNA__1534__A2 _0659_ vssd1 vssd1 vccd1 vccd1 sky130_fd_sc_hd__diode_2
X_2557_ clknet_leaf_5_clk _0116_ net95 vssd1 vssd1 vccd1 vccd1 CALC_INST.gencon_inst.latched_keypad_input\[2\]
+ sky130_fd_sc_hd__dfrtp_1
X_2488_ clknet_leaf_13_clk _0047_ net97 vssd1 vssd1 vccd1 vccd1 CALC_INST.gencon_inst.operand1\[0\]
+ sky130_fd_sc_hd__dfrtp_1
XFILLER_46_49 vssd1 vssd1 vccd1 vccd1 sky130_fd_sc_hd__fill_2
X_1508_ _0645_ _0653_ vssd1 vssd1 vccd1 vccd1 _0655_ sky130_fd_sc_hd__nor2_2
X_1439_ _0604_ _0605_ vssd1 vssd1 vccd1 vccd1 _0075_ sky130_fd_sc_hd__and2b_1
XFILLER_62_26 vssd1 vssd1 vccd1 vccd1 sky130_fd_sc_hd__fill_2
XFILLER_43_406 vssd1 vssd1 vccd1 vccd1 sky130_fd_sc_hd__fill_1
XFILLER_2_3 vssd1 vssd1 vccd1 vccd1 sky130_fd_sc_hd__fill_8
XFILLER_46_266 vssd1 vssd1 vccd1 vccd1 sky130_fd_sc_hd__fill_1
XFILLER_46_244 vssd1 vssd1 vccd1 vccd1 sky130_fd_sc_hd__fill_2
XTAP_TAPCELL_ROW_44_445 vssd1 vccd1 sky130_fd_sc_hd__tapvpwrvgnd_1
X_1790_ CALC_INST.gencon_inst.mult_calc.main.GENERATE_ADDER\[7\].thingy.in2 CALC_INST.gencon_inst.mult_calc.main.GENERATE_ADDER\[7\].thingy.in1
+ vssd1 vssd1 vccd1 vccd1 _0813_ sky130_fd_sc_hd__or2_1
XFILLER_6_362 vssd1 vssd1 vccd1 vccd1 sky130_fd_sc_hd__fill_2
X_2411_ _0390_ vssd1 vssd1 vccd1 vccd1 _0391_ sky130_fd_sc_hd__inv_2
X_2342_ _1183_ vssd1 vssd1 vccd1 vccd1 _1184_ sky130_fd_sc_hd__inv_2
X_2273_ _1095_ _1130_ vssd1 vssd1 vccd1 vccd1 _1131_ sky130_fd_sc_hd__or2_1
X_1988_ net126 _0937_ _0938_ _0936_ vssd1 vssd1 vccd1 vccd1 _0291_ sky130_fd_sc_hd__o31a_1
XANTENNA_clkbuf_leaf_12_clk_A clknet_2_1__leaf_clk vssd1 vssd1 vccd1 vccd1 sky130_fd_sc_hd__diode_2
XFILLER_57_26 vssd1 vssd1 vccd1 vccd1 sky130_fd_sc_hd__fill_1
X_2609_ clknet_leaf_24_clk _0168_ vssd1 vssd1 vccd1 vccd1 CALC_INST.gencon_inst.mult_calc.INn1\[9\]
+ sky130_fd_sc_hd__dfxtp_1
XANTENNA_clkbuf_leaf_27_clk_A clknet_2_2__leaf_clk vssd1 vssd1 vccd1 vccd1 sky130_fd_sc_hd__diode_2
XTAP_TAPCELL_ROW_58_548 vssd1 vccd1 sky130_fd_sc_hd__tapvpwrvgnd_1
XFILLER_57_48 vssd1 vssd1 vccd1 vccd1 sky130_fd_sc_hd__fill_1
XFILLER_43_225 vssd1 vssd1 vccd1 vccd1 sky130_fd_sc_hd__fill_4
XFILLER_28_277 vssd1 vssd1 vccd1 vccd1 sky130_fd_sc_hd__fill_4
Xclkbuf_2_2__f_clk clknet_0_clk vssd1 vssd1 vccd1 vccd1 clknet_2_2__leaf_clk sky130_fd_sc_hd__clkbuf_16
XFILLER_16_406 vssd1 vssd1 vccd1 vccd1 sky130_fd_sc_hd__fill_1
XTAP_TAPCELL_ROW_41_426 vssd1 vccd1 sky130_fd_sc_hd__tapvpwrvgnd_1
XANTENNA_fanout42_A _0728_ vssd1 vssd1 vccd1 vccd1 sky130_fd_sc_hd__diode_2
XFILLER_7_104 vssd1 vssd1 vccd1 vccd1 sky130_fd_sc_hd__fill_2
XFILLER_22_62 vssd1 vssd1 vccd1 vccd1 sky130_fd_sc_hd__fill_1
XFILLER_22_40 vccd1 vssd1 vccd1 vssd1 sky130_ef_sc_hd__decap_40_12
XTAP_TAPCELL_ROW_6_181 vssd1 vccd1 sky130_fd_sc_hd__tapvpwrvgnd_1
XANTENNA__1424__A net51 vssd1 vssd1 vccd1 vccd1 sky130_fd_sc_hd__diode_2
X_1911_ _0860_ _0861_ CALC_INST.gencon_inst.add_calc.main.GENERATE_ADDER\[13\].thingy.in1
+ vssd1 vssd1 vccd1 vccd1 _0862_ sky130_fd_sc_hd__a21oi_1
X_1773_ _0796_ _0798_ vssd1 vssd1 vccd1 vccd1 _0799_ sky130_fd_sc_hd__xnor2_1
X_1842_ net414 net386 net137 vssd1 vssd1 vccd1 vccd1 _0230_ sky130_fd_sc_hd__mux2_1
X_2187_ net204 _1047_ vssd1 vssd1 vccd1 vccd1 _0380_ sky130_fd_sc_hd__xnor2_1
XANTENNA__1370__B1 _0490_ vssd1 vssd1 vccd1 vccd1 sky130_fd_sc_hd__diode_2
XPHY_EDGE_ROW_40_Left_105 vssd1 vssd1 vccd1 vccd1 sky130_fd_sc_hd__decap_3
X_2325_ _1071_ _1072_ _1171_ vssd1 vssd1 vccd1 vccd1 _1172_ sky130_fd_sc_hd__a21o_1
XPHY_EDGE_ROW_25_Left_90 vssd1 vssd1 vccd1 vccd1 sky130_fd_sc_hd__decap_3
X_2256_ CALC_INST.gencon_inst.mult_calc.compCount.in2\[5\] _1109_ _1113_ CALC_INST.gencon_inst.mult_calc.compCount.in2\[6\]
+ _1111_ vssd1 vssd1 vccd1 vccd1 _1114_ sky130_fd_sc_hd__o221a_1
XTAP_TAPCELL_ROW_63_584 vssd1 vccd1 sky130_fd_sc_hd__tapvpwrvgnd_1
XFILLER_25_236 vssd1 vssd1 vccd1 vccd1 sky130_fd_sc_hd__fill_4
XANTENNA_fanout132_X net132 vssd1 vssd1 vccd1 vccd1 sky130_fd_sc_hd__diode_2
XFILLER_0_357 vssd1 vssd1 vccd1 vccd1 sky130_fd_sc_hd__fill_2
XFILLER_0_335 vssd1 vssd1 vccd1 vccd1 sky130_fd_sc_hd__fill_1
XFILLER_56_350 vssd1 vssd1 vccd1 vccd1 sky130_fd_sc_hd__fill_4
XANTENNA_fanout45_X net45 vssd1 vssd1 vccd1 vccd1 sky130_fd_sc_hd__diode_2
XTAP_TAPCELL_ROW_3_162 vssd1 vccd1 sky130_fd_sc_hd__tapvpwrvgnd_1
XFILLER_17_62 vssd1 vssd1 vccd1 vccd1 sky130_fd_sc_hd__fill_1
XFILLER_33_50 vssd1 vssd1 vccd1 vccd1 sky130_fd_sc_hd__fill_2
XFILLER_33_61 vssd1 vssd1 vccd1 vccd1 sky130_fd_sc_hd__fill_2
XFILLER_24_280 vssd1 vssd1 vccd1 vccd1 sky130_fd_sc_hd__fill_1
X_2041_ _0977_ _0979_ vssd1 vssd1 vccd1 vccd1 _0982_ sky130_fd_sc_hd__or2_1
Xhold2 CALC_INST.input_ctrl_inst.RowMid\[3\] vssd1 vssd1 vccd1 vccd1 net201 sky130_fd_sc_hd__dlygate4sd3_1
X_2110_ net135 net302 net124 net305 vssd1 vssd1 vccd1 vccd1 _0349_ sky130_fd_sc_hd__a22o_1
XFILLER_62_342 vssd1 vssd1 vccd1 vccd1 sky130_fd_sc_hd__fill_4
XANTENNA__1601__B _0656_ vssd1 vssd1 vccd1 vccd1 sky130_fd_sc_hd__diode_2
XFILLER_22_217 vssd1 vssd1 vccd1 vccd1 sky130_fd_sc_hd__fill_1
XFILLER_30_250 vssd1 vssd1 vccd1 vccd1 sky130_fd_sc_hd__fill_2
X_1825_ _0836_ _0839_ _0837_ vssd1 vssd1 vccd1 vccd1 _0843_ sky130_fd_sc_hd__o21ai_1
X_1756_ _0782_ _0783_ vssd1 vssd1 vccd1 vccd1 _0784_ sky130_fd_sc_hd__and2b_1
X_1687_ net466 _0743_ net152 vssd1 vssd1 vccd1 vccd1 _0185_ sky130_fd_sc_hd__mux2_1
XANTENNA__2135__A2 net155 vssd1 vssd1 vccd1 vccd1 sky130_fd_sc_hd__diode_2
X_2308_ CALC_INST.input_ctrl_inst.RowSync\[2\] CALC_INST.input_ctrl_inst.RowSync\[0\]
+ CALC_INST.input_ctrl_inst.col_index\[2\] vssd1 vssd1 vccd1 vccd1 _1157_ sky130_fd_sc_hd__a21o_1
XTAP_TAPCELL_ROW_0_143 vssd1 vccd1 sky130_fd_sc_hd__tapvpwrvgnd_1
XTAP_TAPCELL_ROW_0_132 vssd1 vccd1 sky130_fd_sc_hd__tapvpwrvgnd_1
X_2239_ CALC_INST.gencon_inst.mult_calc.count.GENERATE_ADDER\[14\].thingy.in1 _1096_
+ vssd1 vssd1 vccd1 vccd1 _1097_ sky130_fd_sc_hd__xor2_1
XFILLER_21_250 vssd1 vssd1 vccd1 vccd1 sky130_fd_sc_hd__fill_1
XFILLER_0_154 vssd1 vssd1 vccd1 vccd1 sky130_fd_sc_hd__fill_2
XFILLER_0_165 vssd1 vssd1 vccd1 vccd1 sky130_fd_sc_hd__fill_2
XFILLER_44_386 vssd1 vssd1 vccd1 vccd1 sky130_fd_sc_hd__fill_1
XFILLER_44_353 vssd1 vssd1 vccd1 vccd1 sky130_fd_sc_hd__fill_1
XFILLER_44_93 vssd1 vssd1 vccd1 vccd1 sky130_fd_sc_hd__fill_4
XFILLER_44_60 vssd1 vssd1 vccd1 vccd1 sky130_fd_sc_hd__fill_1
X_2590_ clknet_leaf_19_clk _0149_ vssd1 vssd1 vccd1 vccd1 CALC_INST.gencon_inst.ALU_in2\[11\]
+ sky130_fd_sc_hd__dfxtp_1
X_1610_ CALC_INST.gencon_inst.operand1\[5\] net279 net64 vssd1 vssd1 vccd1 vccd1 _0127_
+ sky130_fd_sc_hd__mux2_1
XFILLER_12_294 vssd1 vssd1 vccd1 vccd1 sky130_fd_sc_hd__fill_2
X_1541_ CALC_INST.gencon_inst.ALU_out\[7\] net78 net67 CALC_INST.gencon_inst.mult_calc.out\[7\]
+ vssd1 vssd1 vccd1 vccd1 _0681_ sky130_fd_sc_hd__a22o_1
XFILLER_5_98 vssd1 vssd1 vccd1 vccd1 sky130_fd_sc_hd__fill_8
X_1472_ _0584_ _0627_ _0624_ vssd1 vssd1 vccd1 vccd1 _0086_ sky130_fd_sc_hd__o21ai_1
X_2024_ _0921_ _0967_ vssd1 vssd1 vccd1 vccd1 _0968_ sky130_fd_sc_hd__xnor2_1
XFILLER_54_139 vssd1 vssd1 vccd1 vccd1 sky130_fd_sc_hd__fill_1
XANTENNA__2551__RESET_B net100 vssd1 vssd1 vccd1 vccd1 sky130_fd_sc_hd__diode_2
XFILLER_39_169 vssd1 vssd1 vccd1 vccd1 sky130_fd_sc_hd__fill_8
XFILLER_35_331 vssd1 vssd1 vccd1 vccd1 sky130_fd_sc_hd__fill_4
XFILLER_35_320 vssd1 vssd1 vccd1 vccd1 sky130_fd_sc_hd__fill_2
X_2857_ clknet_leaf_8_clk _0372_ vssd1 vssd1 vccd1 vccd1 CALC_INST.input_ctrl_inst.scan_timer\[11\]
+ sky130_fd_sc_hd__dfxtp_1
XFILLER_10_209 vssd1 vssd1 vccd1 vccd1 sky130_fd_sc_hd__fill_1
Xhold265 CALC_INST.gencon_inst.add_calc.main.a0.in1 vssd1 vssd1 vccd1 vccd1 net464
+ sky130_fd_sc_hd__dlygate4sd3_1
Xhold232 CALC_INST.gencon_inst.add_calc.main.GENERATE_ADDER\[13\].thingy.in1 vssd1
+ vssd1 vccd1 vccd1 net431 sky130_fd_sc_hd__dlygate4sd3_1
XFILLER_49_27 vssd1 vssd1 vccd1 vccd1 sky130_fd_sc_hd__fill_1
Xhold210 CALC_INST.equal_input vssd1 vssd1 vccd1 vccd1 net409 sky130_fd_sc_hd__dlygate4sd3_1
XFILLER_40_29 vssd1 vssd1 vccd1 vccd1 sky130_fd_sc_hd__fill_1
X_1739_ _0418_ _0645_ _0770_ vssd1 vssd1 vccd1 vccd1 _0773_ sky130_fd_sc_hd__or3_1
X_2788_ clknet_leaf_2_clk net319 net83 vssd1 vssd1 vccd1 vccd1 net21 sky130_fd_sc_hd__dfrtp_1
X_1808_ _0825_ _0826_ _0827_ vssd1 vssd1 vccd1 vccd1 _0829_ sky130_fd_sc_hd__a21o_1
Xhold287 CALC_INST.input_ctrl_inst.debounce_cnt\[1\] vssd1 vssd1 vccd1 vccd1 net486
+ sky130_fd_sc_hd__dlygate4sd3_1
Xhold276 CALC_INST.input_ctrl_inst.debounce_cnt\[8\] vssd1 vssd1 vccd1 vccd1 net475
+ sky130_fd_sc_hd__dlygate4sd3_1
Xhold221 _0236_ vssd1 vssd1 vccd1 vccd1 net420 sky130_fd_sc_hd__dlygate4sd3_1
Xhold254 CALC_INST.gencon_inst.mult_calc.compCount.in2\[5\] vssd1 vssd1 vccd1 vccd1
+ net453 sky130_fd_sc_hd__dlygate4sd3_1
Xhold243 CALC_INST.gencon_inst.mult_calc.adderSave\[6\] vssd1 vssd1 vccd1 vccd1 net442
+ sky130_fd_sc_hd__dlygate4sd3_1
XANTENNA__1522__A _0655_ vssd1 vssd1 vccd1 vccd1 sky130_fd_sc_hd__diode_2
XFILLER_45_117 vssd1 vssd1 vccd1 vccd1 sky130_fd_sc_hd__fill_2
Xhold298 CALC_INST.input_ctrl_inst.col_index\[3\] vssd1 vssd1 vccd1 vccd1 net497 sky130_fd_sc_hd__dlygate4sd3_1
XFILLER_18_309 vssd1 vssd1 vccd1 vccd1 sky130_fd_sc_hd__fill_1
XTAP_TAPCELL_ROW_36_392 vssd1 vccd1 sky130_fd_sc_hd__tapvpwrvgnd_1
XTAP_TAPCELL_ROW_28_337 vssd1 vccd1 sky130_fd_sc_hd__tapvpwrvgnd_1
XTAP_TAPCELL_ROW_11_215 vssd1 vccd1 sky130_fd_sc_hd__tapvpwrvgnd_1
XFILLER_14_41 vssd1 vssd1 vccd1 vccd1 sky130_fd_sc_hd__fill_4
XFILLER_51_109 vssd1 vssd1 vccd1 vccd1 sky130_fd_sc_hd__fill_2
X_2711_ clknet_leaf_25_clk net331 net110 vssd1 vssd1 vccd1 vccd1 CALC_INST.gencon_inst.mult_calc.main.GENERATE_ADDER\[12\].thingy.in2
+ sky130_fd_sc_hd__dfrtp_1
X_2642_ clknet_leaf_17_clk _0201_ net119 vssd1 vssd1 vccd1 vccd1 CALC_INST.gencon_inst.add_calc.main.in2\[10\]
+ sky130_fd_sc_hd__dfrtp_1
X_2573_ clknet_leaf_19_clk _0132_ vssd1 vssd1 vccd1 vccd1 CALC_INST.gencon_inst.ALU_in1\[10\]
+ sky130_fd_sc_hd__dfxtp_1
X_1524_ net456 net75 net67 CALC_INST.gencon_inst.mult_calc.out\[2\] _0668_ vssd1 vssd1
+ vccd1 vccd1 _0097_ sky130_fd_sc_hd__a221o_1
XFILLER_55_404 vssd1 vssd1 vccd1 vccd1 sky130_fd_sc_hd__fill_2
X_1386_ CALC_INST.input_ctrl_inst.scan_timer\[2\] CALC_INST.input_ctrl_inst.scan_timer\[10\]
+ _0564_ CALC_INST.input_ctrl_inst.scan_timer\[9\] vssd1 vssd1 vccd1 vccd1 _0566_
+ sky130_fd_sc_hd__or4b_1
X_1455_ _0584_ _0614_ _0615_ vssd1 vssd1 vccd1 vccd1 _0616_ sky130_fd_sc_hd__or3_1
X_2007_ _0949_ _0951_ net33 vssd1 vssd1 vccd1 vccd1 _0954_ sky130_fd_sc_hd__o21ai_1
XFILLER_50_120 vssd1 vssd1 vccd1 vccd1 sky130_fd_sc_hd__fill_1
XFILLER_35_194 vssd1 vssd1 vccd1 vccd1 sky130_fd_sc_hd__fill_2
XTAP_TAPCELL_ROW_25_318 vssd1 vccd1 sky130_fd_sc_hd__tapvpwrvgnd_1
XFILLER_51_17 vssd1 vssd1 vccd1 vccd1 sky130_fd_sc_hd__fill_1
XTAP_TAPCELL_ROW_33_373 vssd1 vccd1 sky130_fd_sc_hd__tapvpwrvgnd_1
XANTENNA__2068__A1_N net127 vssd1 vssd1 vccd1 vccd1 sky130_fd_sc_hd__diode_2
XANTENNA__1537__B1 net67 vssd1 vssd1 vccd1 vccd1 sky130_fd_sc_hd__diode_2
XFILLER_2_249 vssd1 vssd1 vccd1 vccd1 sky130_fd_sc_hd__fill_2
XFILLER_58_253 vssd1 vssd1 vccd1 vccd1 sky130_fd_sc_hd__fill_1
XFILLER_58_242 vssd1 vssd1 vccd1 vccd1 sky130_fd_sc_hd__fill_8
XFILLER_41_175 vssd1 vssd1 vccd1 vccd1 sky130_fd_sc_hd__fill_1
XANTENNA__2022__S net154 vssd1 vssd1 vccd1 vccd1 sky130_fd_sc_hd__diode_2
XFILLER_51_9 vssd1 vssd1 vccd1 vccd1 sky130_fd_sc_hd__fill_8
XANTENNA__1528__B1 net67 vssd1 vssd1 vccd1 vccd1 sky130_fd_sc_hd__diode_2
X_1240_ _0437_ _0439_ _0444_ _0445_ vssd1 vssd1 vccd1 vccd1 _0447_ sky130_fd_sc_hd__o211a_1
XFILLER_2_11 vssd1 vssd1 vccd1 vccd1 sky130_fd_sc_hd__fill_1
XFILLER_1_293 vccd1 vssd1 vccd1 vssd1 sky130_ef_sc_hd__decap_40_12
XFILLER_64_267 vccd1 vssd1 vccd1 vssd1 sky130_ef_sc_hd__decap_40_12
XFILLER_24_109 vssd1 vssd1 vccd1 vccd1 sky130_fd_sc_hd__fill_1
XFILLER_32_186 vssd1 vssd1 vccd1 vccd1 sky130_fd_sc_hd__fill_1
XFILLER_9_393 vssd1 vssd1 vccd1 vccd1 sky130_fd_sc_hd__fill_4
X_2625_ clknet_leaf_17_clk _0184_ net115 vssd1 vssd1 vccd1 vccd1 CALC_INST.gencon_inst.add_calc.main.GENERATE_ADDER\[8\].thingy.in1
+ sky130_fd_sc_hd__dfrtp_1
X_1507_ CALC_INST.gencon_inst.gencon_state\[3\] _0487_ vssd1 vssd1 vccd1 vccd1 _0654_
+ sky130_fd_sc_hd__or2_4
X_2487_ clknet_leaf_22_clk _0046_ net118 vssd1 vssd1 vccd1 vccd1 CALC_INST.gencon_inst.operand2\[14\]
+ sky130_fd_sc_hd__dfrtp_1
X_2556_ clknet_leaf_5_clk _0115_ net94 vssd1 vssd1 vccd1 vccd1 CALC_INST.gencon_inst.latched_keypad_input\[1\]
+ sky130_fd_sc_hd__dfrtp_2
XFILLER_55_223 vssd1 vssd1 vccd1 vccd1 sky130_fd_sc_hd__fill_1
X_1369_ CALC_INST.gencon_inst.operand1\[12\] _0548_ vssd1 vssd1 vccd1 vccd1 _0552_
+ sky130_fd_sc_hd__and2_1
X_1438_ CALC_INST.input_ctrl_inst.col_index\[13\] _0603_ vssd1 vssd1 vccd1 vccd1 _0605_
+ sky130_fd_sc_hd__nand2_1
XFILLER_23_120 vssd1 vssd1 vccd1 vccd1 sky130_fd_sc_hd__fill_2
XFILLER_11_53 vssd1 vssd1 vccd1 vccd1 sky130_fd_sc_hd__fill_2
XTAP_TAPCELL_ROW_44_446 vssd1 vccd1 sky130_fd_sc_hd__tapvpwrvgnd_1
XFILLER_36_83 vssd1 vssd1 vccd1 vccd1 sky130_fd_sc_hd__fill_1
XANTENNA__2017__S net154 vssd1 vssd1 vccd1 vccd1 sky130_fd_sc_hd__diode_2
XFILLER_52_82 vssd1 vssd1 vccd1 vccd1 sky130_fd_sc_hd__fill_2
XANTENNA__1856__S net137 vssd1 vssd1 vccd1 vccd1 sky130_fd_sc_hd__diode_2
XFILLER_14_197 vssd1 vssd1 vccd1 vccd1 sky130_fd_sc_hd__fill_2
X_2341_ CALC_INST.input_ctrl_inst.debounce_cnt\[4\] CALC_INST.input_ctrl_inst.debounce_cnt\[5\]
+ _1177_ vssd1 vssd1 vccd1 vccd1 _1183_ sky130_fd_sc_hd__and3_1
XFILLER_6_341 vssd1 vssd1 vccd1 vccd1 sky130_fd_sc_hd__fill_1
X_2410_ net72 _1228_ vssd1 vssd1 vccd1 vccd1 _0390_ sky130_fd_sc_hd__or2_1
XFILLER_37_223 vssd1 vssd1 vccd1 vccd1 sky130_fd_sc_hd__fill_1
X_2272_ CALC_INST.gencon_inst.mult_calc.count.GENERATE_ADDER\[12\].thingy.in1 _1094_
+ vssd1 vssd1 vccd1 vccd1 _1130_ sky130_fd_sc_hd__nor2_1
XFILLER_52_248 vssd1 vssd1 vccd1 vccd1 sky130_fd_sc_hd__fill_2
X_1987_ _0856_ net33 _0935_ vssd1 vssd1 vccd1 vccd1 _0938_ sky130_fd_sc_hd__and3_1
XANTENNA_fanout122_A net125 vssd1 vssd1 vccd1 vccd1 sky130_fd_sc_hd__diode_2
XFILLER_20_145 vssd1 vssd1 vccd1 vccd1 sky130_fd_sc_hd__fill_2
X_2539_ clknet_leaf_13_clk _0098_ net113 vssd1 vssd1 vccd1 vccd1 net8 sky130_fd_sc_hd__dfrtp_1
X_2608_ clknet_leaf_23_clk _0167_ vssd1 vssd1 vccd1 vccd1 CALC_INST.gencon_inst.mult_calc.INn1\[8\]
+ sky130_fd_sc_hd__dfxtp_1
XTAP_TAPCELL_ROW_58_549 vssd1 vccd1 sky130_fd_sc_hd__tapvpwrvgnd_1
XFILLER_43_204 vssd1 vssd1 vccd1 vccd1 sky130_fd_sc_hd__fill_2
XTAP_TAPCELL_ROW_41_427 vssd1 vccd1 sky130_fd_sc_hd__tapvpwrvgnd_1
XFILLER_22_52 vssd1 vssd1 vccd1 vccd1 sky130_fd_sc_hd__fill_8
XFILLER_11_134 vssd1 vssd1 vccd1 vccd1 sky130_fd_sc_hd__fill_4
XFILLER_22_85 vssd1 vssd1 vccd1 vccd1 sky130_fd_sc_hd__fill_4
XFILLER_3_311 vssd1 vssd1 vccd1 vccd1 sky130_fd_sc_hd__fill_2
XFILLER_47_82 vssd1 vssd1 vccd1 vccd1 sky130_fd_sc_hd__fill_2
XTAP_TAPCELL_ROW_6_182 vssd1 vccd1 sky130_fd_sc_hd__tapvpwrvgnd_1
XFILLER_19_201 vssd1 vssd1 vccd1 vccd1 sky130_fd_sc_hd__fill_4
XFILLER_19_212 vssd1 vssd1 vccd1 vccd1 sky130_fd_sc_hd__fill_1
XFILLER_19_223 vssd1 vssd1 vccd1 vccd1 sky130_fd_sc_hd__fill_1
XFILLER_63_81 vccd1 vssd1 vccd1 vssd1 sky130_ef_sc_hd__decap_40_12
X_1910_ net147 CALC_INST.gencon_inst.add_calc.main.in2\[13\] vssd1 vssd1 vccd1 vccd1
+ _0861_ sky130_fd_sc_hd__nand2_1
XFILLER_6_160 vssd1 vssd1 vccd1 vccd1 sky130_fd_sc_hd__fill_8
X_1841_ net369 CALC_INST.gencon_inst.mult_calc.INn2\[2\] net138 vssd1 vssd1 vccd1
+ vccd1 _0229_ sky130_fd_sc_hd__mux2_1
X_1772_ _0788_ _0797_ vssd1 vssd1 vccd1 vccd1 _0798_ sky130_fd_sc_hd__or2_1
X_2324_ _1085_ _1170_ vssd1 vssd1 vccd1 vccd1 _1171_ sky130_fd_sc_hd__nor2_1
X_2186_ _1047_ _1048_ vssd1 vssd1 vccd1 vccd1 _0379_ sky130_fd_sc_hd__and2_1
X_2255_ _1091_ _1112_ vssd1 vssd1 vccd1 vccd1 _1113_ sky130_fd_sc_hd__nand2b_1
XANTENNA_fanout125_X net125 vssd1 vssd1 vccd1 vccd1 sky130_fd_sc_hd__diode_2
XFILLER_48_307 vssd1 vssd1 vccd1 vccd1 sky130_fd_sc_hd__fill_1
XFILLER_56_384 vssd1 vssd1 vccd1 vccd1 sky130_fd_sc_hd__fill_1
XTAP_TAPCELL_ROW_3_163 vssd1 vccd1 sky130_fd_sc_hd__tapvpwrvgnd_1
XFILLER_16_204 vssd1 vssd1 vccd1 vccd1 sky130_fd_sc_hd__fill_1
XFILLER_3_185 vssd1 vssd1 vccd1 vccd1 sky130_fd_sc_hd__fill_1
XFILLER_3_130 vssd1 vssd1 vccd1 vccd1 sky130_fd_sc_hd__fill_4
X_2040_ _0981_ _0980_ CALC_INST.gencon_inst.ALU_out\[10\] net126 vssd1 vssd1 vccd1
+ vccd1 _0300_ sky130_fd_sc_hd__a2bb2o_1
XANTENNA_clkbuf_leaf_11_clk_A clknet_2_1__leaf_clk vssd1 vssd1 vccd1 vccd1 sky130_fd_sc_hd__diode_2
XFILLER_39_329 vssd1 vssd1 vccd1 vccd1 sky130_fd_sc_hd__fill_4
Xhold3 CALC_INST.input_ctrl_inst.RowMid\[0\] vssd1 vssd1 vccd1 vccd1 net202 sky130_fd_sc_hd__dlygate4sd3_1
XFILLER_62_365 vccd1 vssd1 vccd1 vssd1 sky130_ef_sc_hd__decap_40_12
XANTENNA_clkbuf_leaf_26_clk_A clknet_2_2__leaf_clk vssd1 vssd1 vccd1 vccd1 sky130_fd_sc_hd__diode_2
X_1686_ CALC_INST.gencon_inst.ALU_in2\[9\] CALC_INST.gencon_inst.ALU_in1\[9\] net60
+ vssd1 vssd1 vccd1 vccd1 _0743_ sky130_fd_sc_hd__mux2_1
X_1755_ CALC_INST.gencon_inst.mult_calc.main.GENERATE_ADDER\[2\].thingy.in2 CALC_INST.gencon_inst.mult_calc.main.GENERATE_ADDER\[2\].thingy.in1
+ vssd1 vssd1 vccd1 vccd1 _0783_ sky130_fd_sc_hd__nand2_1
X_1824_ CALC_INST.gencon_inst.mult_calc.main.GENERATE_ADDER\[12\].thingy.in2 CALC_INST.gencon_inst.mult_calc.main.GENERATE_ADDER\[12\].thingy.in1
+ vssd1 vssd1 vccd1 vccd1 _0842_ sky130_fd_sc_hd__nand2_1
XFILLER_38_29 vssd1 vssd1 vccd1 vccd1 sky130_fd_sc_hd__fill_4
X_2307_ CALC_INST.input_ctrl_inst.col_index\[2\] _1155_ vssd1 vssd1 vccd1 vccd1 _1156_
+ sky130_fd_sc_hd__nand2_1
X_2238_ CALC_INST.gencon_inst.mult_calc.count.GENERATE_ADDER\[13\].thingy.in1 _1095_
+ vssd1 vssd1 vccd1 vccd1 _1096_ sky130_fd_sc_hd__nand2_1
X_2169_ CALC_INST.input_ctrl_inst.scan_timer\[12\] _1036_ vssd1 vssd1 vccd1 vccd1
+ _1038_ sky130_fd_sc_hd__and2_1
XTAP_TAPCELL_ROW_51_500 vssd1 vccd1 sky130_fd_sc_hd__tapvpwrvgnd_1
XTAP_TAPCELL_ROW_0_133 vssd1 vccd1 sky130_fd_sc_hd__tapvpwrvgnd_1
XFILLER_0_111 vssd1 vssd1 vccd1 vccd1 sky130_fd_sc_hd__fill_1
XFILLER_48_137 vssd1 vssd1 vccd1 vccd1 sky130_fd_sc_hd__fill_1
XFILLER_48_115 vssd1 vssd1 vccd1 vccd1 sky130_fd_sc_hd__fill_4
XFILLER_44_83 vssd1 vssd1 vccd1 vccd1 sky130_fd_sc_hd__fill_1
XTAP_TAPCELL_ROW_14_235 vssd1 vccd1 sky130_fd_sc_hd__tapvpwrvgnd_1
XFILLER_60_93 vssd1 vssd1 vccd1 vccd1 sky130_fd_sc_hd__fill_1
XFILLER_60_71 vccd1 vssd1 vccd1 vssd1 sky130_ef_sc_hd__decap_40_12
XANTENNA__1573__B2 _0655_ vssd1 vssd1 vccd1 vccd1 sky130_fd_sc_hd__diode_2
X_1540_ CALC_INST.gencon_inst.operand2\[7\] CALC_INST.gencon_inst.operand1\[7\] net74
+ vssd1 vssd1 vccd1 vccd1 _0680_ sky130_fd_sc_hd__mux2_1
XFILLER_5_55 vssd1 vssd1 vccd1 vccd1 sky130_fd_sc_hd__fill_1
XFILLER_5_44 vssd1 vssd1 vccd1 vccd1 sky130_fd_sc_hd__fill_4
XFILLER_5_77 vssd1 vssd1 vccd1 vccd1 sky130_fd_sc_hd__fill_2
X_1471_ _0625_ _0626_ vssd1 vssd1 vccd1 vccd1 _0627_ sky130_fd_sc_hd__or2_1
X_2023_ _0882_ _0883_ vssd1 vssd1 vccd1 vccd1 _0967_ sky130_fd_sc_hd__nand2b_1
X_2856_ clknet_leaf_10_clk _0371_ vssd1 vssd1 vccd1 vccd1 CALC_INST.input_ctrl_inst.scan_timer\[10\]
+ sky130_fd_sc_hd__dfxtp_1
XFILLER_50_346 vssd1 vssd1 vccd1 vccd1 sky130_fd_sc_hd__fill_2
X_1807_ _0825_ _0826_ _0827_ vssd1 vssd1 vccd1 vccd1 _0828_ sky130_fd_sc_hd__nand3_1
Xhold288 CALC_INST.input_ctrl_inst.scan_timer\[18\] vssd1 vssd1 vccd1 vccd1 net487
+ sky130_fd_sc_hd__dlygate4sd3_1
X_1669_ net464 _0734_ net150 vssd1 vssd1 vccd1 vccd1 _0176_ sky130_fd_sc_hd__mux2_1
Xhold200 CALC_INST.gencon_inst.add_calc.main.in2\[8\] vssd1 vssd1 vccd1 vccd1 net399
+ sky130_fd_sc_hd__dlygate4sd3_1
X_1738_ net148 _0772_ _0766_ vssd1 vssd1 vccd1 vccd1 _0207_ sky130_fd_sc_hd__mux2_1
X_2787_ clknet_leaf_6_clk _0031_ net94 vssd1 vssd1 vccd1 vccd1 CALC_INST.input_ctrl_inst.read_input_flag
+ sky130_fd_sc_hd__dfrtp_1
Xhold244 CALC_INST.gencon_inst.mult_calc.INn2\[5\] vssd1 vssd1 vccd1 vccd1 net443
+ sky130_fd_sc_hd__dlygate4sd3_1
Xhold222 CALC_INST.gencon_inst.mult_calc.adderSave\[8\] vssd1 vssd1 vccd1 vccd1 net421
+ sky130_fd_sc_hd__dlygate4sd3_1
Xhold277 CALC_INST.input_ctrl_inst.col_index\[5\] vssd1 vssd1 vccd1 vccd1 net476 sky130_fd_sc_hd__dlygate4sd3_1
Xhold266 CALC_INST.input_ctrl_inst.col_index\[21\] vssd1 vssd1 vccd1 vccd1 net465
+ sky130_fd_sc_hd__dlygate4sd3_1
Xhold255 CALC_INST.gencon_inst.mult_calc.state\[0\] vssd1 vssd1 vccd1 vccd1 net454
+ sky130_fd_sc_hd__dlygate4sd3_1
Xhold233 CALC_INST.gencon_inst.mult_calc.main.GENERATE_ADDER\[2\].thingy.in2 vssd1
+ vssd1 vccd1 vccd1 net432 sky130_fd_sc_hd__dlygate4sd3_1
Xhold211 CALC_INST.input_ctrl_inst.col_index\[7\] vssd1 vssd1 vccd1 vccd1 net410 sky130_fd_sc_hd__dlygate4sd3_1
Xhold299 CALC_INST.input_ctrl_inst.col_index\[6\] vssd1 vssd1 vccd1 vccd1 net498 sky130_fd_sc_hd__dlygate4sd3_1
XTAP_TAPCELL_ROW_28_338 vssd1 vccd1 sky130_fd_sc_hd__tapvpwrvgnd_1
XFILLER_53_184 vssd1 vssd1 vccd1 vccd1 sky130_fd_sc_hd__fill_1
XTAP_TAPCELL_ROW_36_393 vssd1 vccd1 sky130_fd_sc_hd__tapvpwrvgnd_1
XFILLER_26_365 vssd1 vssd1 vccd1 vccd1 sky130_fd_sc_hd__fill_4
XTAP_TAPCELL_ROW_11_216 vssd1 vccd1 sky130_fd_sc_hd__tapvpwrvgnd_1
XFILLER_49_402 vssd1 vssd1 vccd1 vccd1 sky130_fd_sc_hd__fill_4
XFILLER_30_85 vssd1 vssd1 vccd1 vccd1 sky130_fd_sc_hd__fill_4
XFILLER_55_82 vssd1 vssd1 vccd1 vccd1 sky130_fd_sc_hd__fill_1
X_2710_ clknet_leaf_26_clk net382 net110 vssd1 vssd1 vccd1 vccd1 CALC_INST.gencon_inst.mult_calc.main.GENERATE_ADDER\[11\].thingy.in2
+ sky130_fd_sc_hd__dfrtp_1
X_2641_ clknet_leaf_16_clk _0200_ net116 vssd1 vssd1 vccd1 vccd1 CALC_INST.gencon_inst.add_calc.main.in2\[9\]
+ sky130_fd_sc_hd__dfrtp_1
XFILLER_58_3 vccd1 vssd1 vccd1 vssd1 sky130_ef_sc_hd__decap_40_12
X_1523_ net7 _0660_ _0667_ net71 vssd1 vssd1 vccd1 vccd1 _0668_ sky130_fd_sc_hd__o211a_1
X_2572_ clknet_leaf_22_clk _0131_ vssd1 vssd1 vccd1 vccd1 CALC_INST.gencon_inst.ALU_in1\[9\]
+ sky130_fd_sc_hd__dfxtp_1
XANTENNA__1546__B2 _0656_ vssd1 vssd1 vccd1 vccd1 sky130_fd_sc_hd__diode_2
X_1454_ CALC_INST.input_ctrl_inst.col_index\[19\] CALC_INST.input_ctrl_inst.col_index\[18\]
+ _0610_ vssd1 vssd1 vccd1 vccd1 _0615_ sky130_fd_sc_hd__and3_1
X_1385_ CALC_INST.input_ctrl_inst.scan_timer\[5\] CALC_INST.input_ctrl_inst.scan_timer\[7\]
+ CALC_INST.input_ctrl_inst.scan_timer\[6\] CALC_INST.input_ctrl_inst.scan_timer\[4\]
+ vssd1 vssd1 vccd1 vccd1 _0565_ sky130_fd_sc_hd__or4bb_1
X_2006_ _0953_ _0952_ CALC_INST.gencon_inst.ALU_out\[4\] net126 vssd1 vssd1 vccd1
+ vccd1 _0294_ sky130_fd_sc_hd__a2bb2o_1
XANTENNA_fanout152_A CALC_INST.gencon_inst.add_calc.state\[2\] vssd1 vssd1 vccd1 vccd1
+ sky130_fd_sc_hd__diode_2
XFILLER_23_335 vssd1 vssd1 vccd1 vccd1 sky130_fd_sc_hd__fill_1
XFILLER_23_302 vssd1 vssd1 vccd1 vccd1 sky130_fd_sc_hd__fill_4
XANTENNA__1234__B1 net49 vssd1 vssd1 vccd1 vccd1 sky130_fd_sc_hd__diode_2
XTAP_TAPCELL_ROW_33_374 vssd1 vccd1 sky130_fd_sc_hd__tapvpwrvgnd_1
X_2839_ clknet_leaf_3_clk _0015_ net91 vssd1 vssd1 vccd1 vccd1 CALC_INST.input_ctrl_inst.debounce_cnt\[16\]
+ sky130_fd_sc_hd__dfrtp_1
XANTENNA_fanout65_A _0724_ vssd1 vssd1 vccd1 vccd1 sky130_fd_sc_hd__diode_2
XFILLER_41_51 vssd1 vssd1 vccd1 vccd1 sky130_fd_sc_hd__fill_4
XANTENNA__1427__B net51 vssd1 vssd1 vccd1 vccd1 sky130_fd_sc_hd__diode_2
XFILLER_49_221 vssd1 vssd1 vccd1 vccd1 sky130_fd_sc_hd__fill_2
XFILLER_2_45 vssd1 vssd1 vccd1 vccd1 sky130_fd_sc_hd__fill_1
XFILLER_1_261 vccd1 vssd1 vccd1 vssd1 sky130_ef_sc_hd__decap_40_12
XFILLER_64_279 vssd1 vssd1 vccd1 vccd1 sky130_fd_sc_hd__fill_1
XFILLER_64_257 vssd1 vssd1 vccd1 vccd1 sky130_fd_sc_hd__fill_2
XTAP_TAPCELL_ROW_47_466 vssd1 vccd1 sky130_fd_sc_hd__tapvpwrvgnd_1
Xclkbuf_leaf_29_clk clknet_2_2__leaf_clk vssd1 vssd1 vccd1 vccd1 clknet_leaf_29_clk
+ sky130_fd_sc_hd__clkbuf_8
X_2624_ clknet_leaf_15_clk _0183_ net115 vssd1 vssd1 vccd1 vccd1 CALC_INST.gencon_inst.add_calc.main.GENERATE_ADDER\[7\].thingy.in1
+ sky130_fd_sc_hd__dfrtp_1
X_1506_ CALC_INST.gencon_inst.gencon_state\[3\] _0487_ vssd1 vssd1 vccd1 vccd1 _0653_
+ sky130_fd_sc_hd__nor2_1
X_2486_ clknet_leaf_25_clk _0045_ net110 vssd1 vssd1 vccd1 vccd1 CALC_INST.gencon_inst.operand2\[13\]
+ sky130_fd_sc_hd__dfrtp_2
X_2555_ clknet_leaf_3_clk _0114_ net85 vssd1 vssd1 vccd1 vccd1 CALC_INST.gencon_inst.latched_keypad_input\[0\]
+ sky130_fd_sc_hd__dfrtp_1
X_1437_ CALC_INST.input_ctrl_inst.col_index\[13\] _0603_ vssd1 vssd1 vccd1 vccd1 _0604_
+ sky130_fd_sc_hd__nor2_1
XFILLER_55_279 vssd1 vssd1 vccd1 vccd1 sky130_fd_sc_hd__fill_1
X_1299_ CALC_INST.gencon_inst.mult_calc.finish _0493_ vssd1 vssd1 vccd1 vccd1 _0494_
+ sky130_fd_sc_hd__nor2_1
X_1368_ CALC_INST.gencon_inst.operand1\[11\] net48 _0550_ _0551_ vssd1 vssd1 vccd1
+ vccd1 _0058_ sky130_fd_sc_hd__o22a_1
XANTENNA_fanout155_X net155 vssd1 vssd1 vccd1 vccd1 sky130_fd_sc_hd__diode_2
XFILLER_23_198 vccd1 vssd1 vccd1 vssd1 sky130_ef_sc_hd__decap_40_12
XFILLER_23_165 vssd1 vssd1 vccd1 vccd1 sky130_fd_sc_hd__fill_1
XFILLER_19_405 vssd1 vssd1 vccd1 vccd1 sky130_fd_sc_hd__fill_2
XTAP_TAPCELL_ROW_44_447 vssd1 vccd1 sky130_fd_sc_hd__tapvpwrvgnd_1
X_2340_ CALC_INST.input_ctrl_inst.debounce_cnt\[4\] _1177_ CALC_INST.input_ctrl_inst.debounce_cnt\[5\]
+ vssd1 vssd1 vccd1 vccd1 _1182_ sky130_fd_sc_hd__a21o_1
X_2271_ CALC_INST.gencon_inst.mult_calc.compCount.in2\[10\] _1124_ _1128_ CALC_INST.gencon_inst.mult_calc.compCount.in2\[11\]
+ vssd1 vssd1 vccd1 vccd1 _1129_ sky130_fd_sc_hd__a22o_1
XFILLER_37_213 vssd1 vssd1 vccd1 vccd1 sky130_fd_sc_hd__fill_8
XFILLER_60_293 vssd1 vssd1 vccd1 vccd1 sky130_fd_sc_hd__fill_4
XFILLER_60_282 vssd1 vssd1 vccd1 vccd1 sky130_fd_sc_hd__fill_2
XANTENNA__1988__A1 net126 vssd1 vssd1 vccd1 vccd1 sky130_fd_sc_hd__diode_2
X_1986_ _0856_ net33 _0935_ vssd1 vssd1 vccd1 vccd1 _0937_ sky130_fd_sc_hd__a21oi_1
XFILLER_20_157 vssd1 vssd1 vccd1 vccd1 sky130_fd_sc_hd__fill_8
Xclkbuf_leaf_9_clk clknet_2_1__leaf_clk vssd1 vssd1 vccd1 vccd1 clknet_leaf_9_clk
+ sky130_fd_sc_hd__clkbuf_8
XANTENNA_fanout115_A net121 vssd1 vssd1 vccd1 vccd1 sky130_fd_sc_hd__diode_2
X_2607_ clknet_leaf_23_clk _0166_ vssd1 vssd1 vccd1 vccd1 CALC_INST.gencon_inst.mult_calc.INn1\[7\]
+ sky130_fd_sc_hd__dfxtp_1
X_2469_ clknet_leaf_10_clk _0000_ net96 vssd1 vssd1 vccd1 vccd1 CALC_INST.gencon_inst.add_calc.state\[0\]
+ sky130_fd_sc_hd__dfstp_1
X_2538_ clknet_leaf_13_clk _0097_ net100 vssd1 vssd1 vccd1 vccd1 net7 sky130_fd_sc_hd__dfrtp_1
XFILLER_43_216 vssd1 vssd1 vccd1 vccd1 sky130_fd_sc_hd__fill_8
XTAP_TAPCELL_ROW_41_428 vssd1 vccd1 sky130_fd_sc_hd__tapvpwrvgnd_1
XFILLER_22_31 vssd1 vssd1 vccd1 vccd1 sky130_fd_sc_hd__fill_4
XFILLER_11_113 vssd1 vssd1 vccd1 vccd1 sky130_fd_sc_hd__fill_1
XFILLER_3_389 vssd1 vssd1 vccd1 vccd1 sky130_fd_sc_hd__fill_2
XFILLER_3_301 vssd1 vssd1 vccd1 vccd1 sky130_fd_sc_hd__fill_2
XTAP_TAPCELL_ROW_6_183 vssd1 vccd1 sky130_fd_sc_hd__tapvpwrvgnd_1
XFILLER_63_93 vccd1 vssd1 vccd1 vssd1 sky130_ef_sc_hd__decap_40_12
XANTENNA__2028__S CALC_INST.gencon_inst.add_calc.state\[1\] vssd1 vssd1 vccd1 vccd1
+ sky130_fd_sc_hd__diode_2
XANTENNA__2092__B1 net34 vssd1 vssd1 vccd1 vccd1 sky130_fd_sc_hd__diode_2
XFILLER_8_11 vssd1 vssd1 vccd1 vccd1 sky130_fd_sc_hd__fill_2
X_1840_ net423 net345 net137 vssd1 vssd1 vccd1 vccd1 _0228_ sky130_fd_sc_hd__mux2_1
XFILLER_8_66 vccd1 vssd1 vccd1 vssd1 sky130_ef_sc_hd__decap_40_12
X_1771_ _0779_ _0782_ _0785_ _0789_ _0783_ vssd1 vssd1 vccd1 vccd1 _0797_ sky130_fd_sc_hd__o311a_1
X_2323_ _1068_ _1072_ vssd1 vssd1 vccd1 vccd1 _1170_ sky130_fd_sc_hd__or2_1
X_2254_ CALC_INST.gencon_inst.mult_calc.count.GENERATE_ADDER\[5\].thingy.in1 CALC_INST.gencon_inst.mult_calc.count.GENERATE_ADDER\[4\].thingy.in1
+ _1089_ CALC_INST.gencon_inst.mult_calc.count.GENERATE_ADDER\[6\].thingy.in1 vssd1
+ vssd1 vccd1 vccd1 _1112_ sky130_fd_sc_hd__a31o_1
X_2185_ CALC_INST.input_ctrl_inst.scan_timer\[18\] _1045_ vssd1 vssd1 vccd1 vccd1
+ _1048_ sky130_fd_sc_hd__or2_1
X_1969_ _0890_ _0894_ _0917_ _0891_ _0887_ vssd1 vssd1 vccd1 vccd1 _0920_ sky130_fd_sc_hd__o311a_1
XANTENNA__2138__A1 net155 vssd1 vssd1 vccd1 vccd1 sky130_fd_sc_hd__diode_2
XFILLER_0_337 vccd1 vssd1 vccd1 vssd1 sky130_ef_sc_hd__decap_40_12
XTAP_TAPCELL_ROW_3_164 vssd1 vccd1 sky130_fd_sc_hd__tapvpwrvgnd_1
XFILLER_0_359 vssd1 vssd1 vccd1 vccd1 sky130_fd_sc_hd__fill_1
XTAP_TAPCELL_ROW_54_520 vssd1 vccd1 sky130_fd_sc_hd__tapvpwrvgnd_1
XFILLER_33_52 vssd1 vssd1 vccd1 vccd1 sky130_fd_sc_hd__fill_1
XFILLER_8_404 vssd1 vssd1 vccd1 vccd1 sky130_fd_sc_hd__fill_2
XANTENNA__2074__B1 net130 vssd1 vssd1 vccd1 vccd1 sky130_fd_sc_hd__diode_2
XFILLER_16_227 vssd1 vssd1 vccd1 vccd1 sky130_fd_sc_hd__fill_2
XFILLER_16_249 vssd1 vssd1 vccd1 vccd1 sky130_fd_sc_hd__fill_2
XFILLER_17_86 vssd1 vssd1 vccd1 vccd1 sky130_fd_sc_hd__fill_2
XFILLER_33_63 vssd1 vssd1 vccd1 vccd1 sky130_fd_sc_hd__fill_1
XFILLER_58_71 vccd1 vssd1 vccd1 vssd1 sky130_ef_sc_hd__decap_40_12
Xhold4 CALC_INST.input_ctrl_inst.RowMid\[1\] vssd1 vssd1 vccd1 vccd1 net203 sky130_fd_sc_hd__dlygate4sd3_1
XFILLER_12_7 vssd1 vssd1 vccd1 vccd1 sky130_fd_sc_hd__fill_2
XFILLER_62_377 vccd1 vssd1 vccd1 vssd1 sky130_ef_sc_hd__decap_40_12
XFILLER_30_285 vssd1 vssd1 vccd1 vccd1 sky130_fd_sc_hd__fill_1
X_1823_ CALC_INST.gencon_inst.mult_calc.main.GENERATE_ADDER\[12\].thingy.in2 CALC_INST.gencon_inst.mult_calc.main.GENERATE_ADDER\[12\].thingy.in1
+ vssd1 vssd1 vccd1 vccd1 _0841_ sky130_fd_sc_hd__or2_1
XFILLER_15_293 vssd1 vssd1 vccd1 vccd1 sky130_fd_sc_hd__fill_1
X_1685_ net407 _0742_ net152 vssd1 vssd1 vccd1 vccd1 _0184_ sky130_fd_sc_hd__mux2_1
XANTENNA__1328__C1 net45 vssd1 vssd1 vccd1 vccd1 sky130_fd_sc_hd__diode_2
X_1754_ CALC_INST.gencon_inst.mult_calc.main.GENERATE_ADDER\[2\].thingy.in2 CALC_INST.gencon_inst.mult_calc.main.GENERATE_ADDER\[2\].thingy.in1
+ vssd1 vssd1 vccd1 vccd1 _0782_ sky130_fd_sc_hd__nor2_1
X_2306_ _1051_ CALC_INST.input_ctrl_inst.RowSync\[1\] CALC_INST.input_ctrl_inst.RowSync\[3\]
+ vssd1 vssd1 vccd1 vccd1 _1155_ sky130_fd_sc_hd__o21ai_1
X_2237_ CALC_INST.gencon_inst.mult_calc.count.GENERATE_ADDER\[12\].thingy.in1 _1094_
+ vssd1 vssd1 vccd1 vccd1 _1095_ sky130_fd_sc_hd__and2_1
X_2168_ _1036_ _1037_ vssd1 vssd1 vccd1 vccd1 _0372_ sky130_fd_sc_hd__nor2_1
X_2099_ net133 net281 net122 CALC_INST.gencon_inst.mult_calc.count.GENERATE_ADDER\[1\].thingy.in1
+ vssd1 vssd1 vccd1 vccd1 _0338_ sky130_fd_sc_hd__a22o_1
XTAP_TAPCELL_ROW_0_134 vssd1 vccd1 sky130_fd_sc_hd__tapvpwrvgnd_1
XANTENNA__2192__A net141 vssd1 vssd1 vccd1 vccd1 sky130_fd_sc_hd__diode_2
XPHY_EDGE_ROW_17_Right_17 vssd1 vssd1 vccd1 vccd1 sky130_fd_sc_hd__decap_3
XANTENNA__1334__A2 net47 vssd1 vssd1 vccd1 vccd1 sky130_fd_sc_hd__diode_2
XPHY_EDGE_ROW_26_Right_26 vssd1 vssd1 vccd1 vccd1 sky130_fd_sc_hd__decap_3
XFILLER_0_156 vssd1 vssd1 vccd1 vccd1 sky130_fd_sc_hd__fill_1
XFILLER_0_167 vssd1 vssd1 vccd1 vccd1 sky130_fd_sc_hd__fill_1
XANTENNA__2295__B1 net154 vssd1 vssd1 vccd1 vccd1 sky130_fd_sc_hd__diode_2
XPHY_EDGE_ROW_35_Right_35 vssd1 vssd1 vccd1 vccd1 sky130_fd_sc_hd__decap_3
XFILLER_12_296 vssd1 vssd1 vccd1 vccd1 sky130_fd_sc_hd__fill_1
XTAP_TAPCELL_ROW_14_236 vssd1 vccd1 sky130_fd_sc_hd__tapvpwrvgnd_1
XFILLER_60_83 vssd1 vssd1 vccd1 vccd1 sky130_fd_sc_hd__fill_1
XANTENNA__1573__A2 _0660_ vssd1 vssd1 vccd1 vccd1 sky130_fd_sc_hd__diode_2
XANTENNA__1558__C1 _0659_ vssd1 vssd1 vccd1 vccd1 sky130_fd_sc_hd__diode_2
XTAP_TAPCELL_ROW_22_291 vssd1 vccd1 sky130_fd_sc_hd__tapvpwrvgnd_1
XFILLER_8_267 vssd1 vssd1 vccd1 vccd1 sky130_fd_sc_hd__fill_4
X_1470_ CALC_INST.input_ctrl_inst.col_index\[24\] _0401_ _0595_ vssd1 vssd1 vccd1
+ vccd1 _0626_ sky130_fd_sc_hd__and3_1
XPHY_EDGE_ROW_44_Right_44 vssd1 vssd1 vccd1 vccd1 sky130_fd_sc_hd__decap_3
X_2022_ CALC_INST.gencon_inst.ALU_out\[7\] _0966_ net154 vssd1 vssd1 vccd1 vccd1 _0297_
+ sky130_fd_sc_hd__mux2_1
XFILLER_62_174 vssd1 vssd1 vccd1 vccd1 sky130_fd_sc_hd__fill_2
XFILLER_62_141 vssd1 vssd1 vccd1 vccd1 sky130_fd_sc_hd__fill_4
XFILLER_62_130 vssd1 vssd1 vccd1 vccd1 sky130_fd_sc_hd__fill_2
XPHY_EDGE_ROW_53_Right_53 vssd1 vssd1 vccd1 vccd1 sky130_fd_sc_hd__decap_3
X_2855_ clknet_leaf_9_clk _0370_ vssd1 vssd1 vccd1 vccd1 CALC_INST.input_ctrl_inst.scan_timer\[9\]
+ sky130_fd_sc_hd__dfxtp_1
X_2786_ clknet_leaf_4_clk net275 vssd1 vssd1 vccd1 vccd1 CALC_INST.gencon_inst.mult_calc.INn2\[15\]
+ sky130_fd_sc_hd__dfxtp_1
Xhold201 CALC_INST.input_ctrl_inst.debounce_cnt\[11\] vssd1 vssd1 vccd1 vccd1 net400
+ sky130_fd_sc_hd__dlygate4sd3_1
X_1806_ _0819_ _0823_ _0820_ vssd1 vssd1 vccd1 vccd1 _0827_ sky130_fd_sc_hd__o21ai_1
Xhold267 CALC_INST.gencon_inst.add_calc.main.GENERATE_ADDER\[9\].thingy.in1 vssd1
+ vssd1 vccd1 vccd1 net466 sky130_fd_sc_hd__dlygate4sd3_1
Xhold289 _0379_ vssd1 vssd1 vccd1 vccd1 net488 sky130_fd_sc_hd__dlygate4sd3_1
XPHY_EDGE_ROW_62_Right_62 vssd1 vssd1 vccd1 vccd1 sky130_fd_sc_hd__decap_3
Xhold245 CALC_INST.input_ctrl_inst.scan_timer\[15\] vssd1 vssd1 vccd1 vccd1 net444
+ sky130_fd_sc_hd__dlygate4sd3_1
Xhold212 CALC_INST.gencon_inst.add_calc.main.GENERATE_ADDER\[6\].thingy.in1 vssd1
+ vssd1 vccd1 vccd1 net411 sky130_fd_sc_hd__dlygate4sd3_1
Xhold256 CALC_INST.gencon_inst.ALU_out\[1\] vssd1 vssd1 vccd1 vccd1 net455 sky130_fd_sc_hd__dlygate4sd3_1
X_1668_ CALC_INST.gencon_inst.ALU_in2\[0\] CALC_INST.gencon_inst.ALU_in1\[0\] net59
+ vssd1 vssd1 vccd1 vccd1 _0734_ sky130_fd_sc_hd__mux2_1
X_1599_ net269 _0720_ _0719_ vssd1 vssd1 vccd1 vccd1 _0119_ sky130_fd_sc_hd__a21bo_1
X_1737_ CALC_INST.equal_input _0645_ _0770_ _0771_ vssd1 vssd1 vccd1 vccd1 _0772_
+ sky130_fd_sc_hd__a211o_1
XPHY_EDGE_ROW_37_Left_102 vssd1 vssd1 vccd1 vccd1 sky130_fd_sc_hd__decap_3
Xhold223 CALC_INST.gencon_inst.mult_calc.adderSave\[11\] vssd1 vssd1 vccd1 vccd1 net422
+ sky130_fd_sc_hd__dlygate4sd3_1
Xhold278 CALC_INST.input_ctrl_inst.col_index\[10\] vssd1 vssd1 vccd1 vccd1 net477
+ sky130_fd_sc_hd__dlygate4sd3_1
Xhold234 _0260_ vssd1 vssd1 vccd1 vccd1 net433 sky130_fd_sc_hd__dlygate4sd3_1
XTAP_TAPCELL_ROW_28_339 vssd1 vccd1 sky130_fd_sc_hd__tapvpwrvgnd_1
XPHY_EDGE_ROW_46_Left_111 vssd1 vssd1 vccd1 vccd1 sky130_fd_sc_hd__decap_3
XTAP_TAPCELL_ROW_36_394 vssd1 vccd1 sky130_fd_sc_hd__tapvpwrvgnd_1
XTAP_TAPCELL_ROW_11_217 vssd1 vccd1 sky130_fd_sc_hd__tapvpwrvgnd_1
XANTENNA_clkbuf_leaf_10_clk_A clknet_2_1__leaf_clk vssd1 vssd1 vccd1 vccd1 sky130_fd_sc_hd__diode_2
XPHY_EDGE_ROW_55_Left_120 vssd1 vssd1 vccd1 vccd1 sky130_fd_sc_hd__decap_3
XFILLER_5_204 vccd1 vssd1 vccd1 vssd1 sky130_ef_sc_hd__decap_40_12
XANTENNA_clkbuf_leaf_25_clk_A clknet_2_2__leaf_clk vssd1 vssd1 vccd1 vccd1 sky130_fd_sc_hd__diode_2
XFILLER_32_303 vssd1 vssd1 vccd1 vccd1 sky130_fd_sc_hd__fill_4
X_2640_ clknet_leaf_17_clk _0199_ net116 vssd1 vssd1 vccd1 vccd1 CALC_INST.gencon_inst.add_calc.main.in2\[8\]
+ sky130_fd_sc_hd__dfrtp_1
X_2571_ clknet_leaf_15_clk _0130_ vssd1 vssd1 vccd1 vccd1 CALC_INST.gencon_inst.ALU_in1\[8\]
+ sky130_fd_sc_hd__dfxtp_1
X_1522_ _0655_ _0666_ vssd1 vssd1 vccd1 vccd1 _0667_ sky130_fd_sc_hd__or2_1
XANTENNA__1546__A2 _0659_ vssd1 vssd1 vccd1 vccd1 sky130_fd_sc_hd__diode_2
X_1453_ CALC_INST.input_ctrl_inst.col_index\[18\] _0610_ CALC_INST.input_ctrl_inst.col_index\[19\]
+ vssd1 vssd1 vccd1 vccd1 _0614_ sky130_fd_sc_hd__a21oi_1
X_2005_ net33 _0949_ _0951_ net126 vssd1 vssd1 vccd1 vccd1 _0953_ sky130_fd_sc_hd__a31o_1
XFILLER_55_406 vssd1 vssd1 vccd1 vccd1 sky130_fd_sc_hd__fill_1
X_1384_ CALC_INST.input_ctrl_inst.scan_timer\[13\] CALC_INST.input_ctrl_inst.scan_timer\[12\]
+ CALC_INST.input_ctrl_inst.scan_timer\[15\] CALC_INST.input_ctrl_inst.scan_timer\[14\]
+ vssd1 vssd1 vccd1 vccd1 _0564_ sky130_fd_sc_hd__or4bb_1
XFILLER_50_177 vssd1 vssd1 vccd1 vccd1 sky130_fd_sc_hd__fill_2
XANTENNA_fanout100_X net100 vssd1 vssd1 vccd1 vccd1 sky130_fd_sc_hd__diode_2
X_2769_ clknet_leaf_2_clk net200 net84 vssd1 vssd1 vccd1 vccd1 CALC_INST.input_ctrl_inst.RowSync\[2\]
+ sky130_fd_sc_hd__dfstp_1
X_2838_ clknet_leaf_3_clk _0014_ net91 vssd1 vssd1 vccd1 vccd1 CALC_INST.input_ctrl_inst.debounce_cnt\[15\]
+ sky130_fd_sc_hd__dfrtp_1
XFILLER_58_266 vccd1 vssd1 vccd1 vssd1 sky130_ef_sc_hd__decap_40_12
XFILLER_41_111 vssd1 vssd1 vccd1 vccd1 sky130_fd_sc_hd__fill_1
XFILLER_41_100 vssd1 vssd1 vccd1 vccd1 sky130_fd_sc_hd__fill_1
XFILLER_64_225 vssd1 vssd1 vccd1 vccd1 sky130_fd_sc_hd__fill_4
XFILLER_49_211 vssd1 vssd1 vccd1 vccd1 sky130_fd_sc_hd__fill_1
XFILLER_1_273 vssd1 vssd1 vccd1 vccd1 sky130_fd_sc_hd__fill_4
XTAP_TAPCELL_ROW_47_467 vssd1 vccd1 sky130_fd_sc_hd__tapvpwrvgnd_1
XFILLER_20_339 vssd1 vssd1 vccd1 vccd1 sky130_fd_sc_hd__fill_1
X_2623_ clknet_leaf_15_clk _0182_ net115 vssd1 vssd1 vccd1 vccd1 CALC_INST.gencon_inst.add_calc.main.GENERATE_ADDER\[6\].thingy.in1
+ sky130_fd_sc_hd__dfrtp_1
XANTENNA__1519__A2 _0660_ vssd1 vssd1 vccd1 vccd1 sky130_fd_sc_hd__diode_2
X_2554_ clknet_leaf_5_clk _0113_ net95 vssd1 vssd1 vccd1 vccd1 CALC_INST.gencon_inst.key_read
+ sky130_fd_sc_hd__dfrtp_1
XANTENNA__1767__A2 net132 vssd1 vssd1 vccd1 vccd1 sky130_fd_sc_hd__diode_2
X_1367_ CALC_INST.gencon_inst.ALU_out\[11\] net77 net70 CALC_INST.gencon_inst.mult_calc.out\[11\]
+ net46 vssd1 vssd1 vccd1 vccd1 _0551_ sky130_fd_sc_hd__a221o_1
X_1505_ CALC_INST.gencon_inst.operand2\[15\] _0650_ _0652_ vssd1 vssd1 vccd1 vccd1
+ _0094_ sky130_fd_sc_hd__o21a_1
X_2485_ clknet_leaf_21_clk _0044_ net117 vssd1 vssd1 vccd1 vccd1 CALC_INST.gencon_inst.operand2\[12\]
+ sky130_fd_sc_hd__dfrtp_2
XFILLER_28_406 vssd1 vssd1 vccd1 vccd1 sky130_fd_sc_hd__fill_1
X_1436_ _0602_ _0603_ vssd1 vssd1 vccd1 vccd1 _0074_ sky130_fd_sc_hd__nor2_1
XFILLER_62_18 vssd1 vssd1 vccd1 vccd1 sky130_fd_sc_hd__fill_8
X_1298_ CALC_INST.gencon_inst.gencon_state\[3\] _0486_ vssd1 vssd1 vccd1 vccd1 _0493_
+ sky130_fd_sc_hd__or2_1
XFILLER_23_111 vssd1 vssd1 vccd1 vccd1 sky130_fd_sc_hd__fill_1
XFILLER_62_29 vssd1 vssd1 vccd1 vccd1 sky130_fd_sc_hd__fill_4
XFILLER_11_55 vssd1 vssd1 vccd1 vccd1 sky130_fd_sc_hd__fill_1
XTAP_TAPCELL_ROW_44_448 vssd1 vccd1 sky130_fd_sc_hd__tapvpwrvgnd_1
XFILLER_36_63 vssd1 vssd1 vccd1 vccd1 sky130_fd_sc_hd__fill_2
XFILLER_10_361 vssd1 vssd1 vccd1 vccd1 sky130_fd_sc_hd__fill_2
XFILLER_14_199 vssd1 vssd1 vccd1 vccd1 sky130_fd_sc_hd__fill_1
X_2270_ _1094_ _1127_ vssd1 vssd1 vccd1 vccd1 _1128_ sky130_fd_sc_hd__or2_1
XFILLER_52_206 vssd1 vssd1 vccd1 vccd1 sky130_fd_sc_hd__fill_4
XFILLER_37_225 vssd1 vssd1 vccd1 vccd1 sky130_fd_sc_hd__fill_2
X_1985_ net154 CALC_INST.gencon_inst.ALU_out\[1\] vssd1 vssd1 vccd1 vccd1 _0936_ sky130_fd_sc_hd__or2_1
XANTENNA__2291__Y CALC_INST.gencon_inst.add_calc.nRST vssd1 vssd1 vccd1 vccd1 sky130_fd_sc_hd__diode_2
X_2537_ clknet_leaf_13_clk _0096_ net98 vssd1 vssd1 vccd1 vccd1 net31 sky130_fd_sc_hd__dfrtp_1
X_2606_ clknet_leaf_23_clk _0165_ vssd1 vssd1 vccd1 vccd1 CALC_INST.gencon_inst.mult_calc.INn1\[6\]
+ sky130_fd_sc_hd__dfxtp_1
XANTENNA_fanout108_A net112 vssd1 vssd1 vccd1 vccd1 sky130_fd_sc_hd__diode_2
XFILLER_57_18 vssd1 vssd1 vccd1 vccd1 sky130_fd_sc_hd__fill_8
X_2468_ _0436_ vssd1 vssd1 vccd1 vccd1 _0437_ sky130_fd_sc_hd__inv_2
X_2399_ CALC_INST.input_ctrl_inst.col_index\[1\] CALC_INST.input_ctrl_inst.col_index\[0\]
+ _1159_ vssd1 vssd1 vccd1 vccd1 _1227_ sky130_fd_sc_hd__or3_1
X_1419_ _0591_ _0592_ vssd1 vssd1 vccd1 vccd1 _0068_ sky130_fd_sc_hd__nor2_1
XFILLER_43_206 vssd1 vssd1 vccd1 vccd1 sky130_fd_sc_hd__fill_1
XTAP_TAPCELL_ROW_41_429 vssd1 vccd1 sky130_fd_sc_hd__tapvpwrvgnd_1
Xwire51 _0577_ vssd1 vssd1 vccd1 vccd1 net51 sky130_fd_sc_hd__buf_2
XFILLER_11_169 vssd1 vssd1 vccd1 vccd1 sky130_fd_sc_hd__fill_2
XFILLER_3_313 vssd1 vssd1 vccd1 vccd1 sky130_fd_sc_hd__fill_1
XTAP_TAPCELL_ROW_57_540 vssd1 vccd1 sky130_fd_sc_hd__tapvpwrvgnd_1
XTAP_TAPCELL_ROW_6_184 vssd1 vccd1 sky130_fd_sc_hd__tapvpwrvgnd_1
XFILLER_19_236 vssd1 vssd1 vccd1 vccd1 sky130_fd_sc_hd__fill_1
XFILLER_30_401 vssd1 vssd1 vccd1 vccd1 sky130_fd_sc_hd__fill_4
X_1770_ _0794_ _0795_ vssd1 vssd1 vccd1 vccd1 _0796_ sky130_fd_sc_hd__and2b_1
XFILLER_8_45 vssd1 vssd1 vccd1 vccd1 sky130_fd_sc_hd__fill_1
XFILLER_8_78 vssd1 vssd1 vccd1 vccd1 sky130_fd_sc_hd__fill_1
X_2184_ net487 _1045_ vssd1 vssd1 vccd1 vccd1 _1047_ sky130_fd_sc_hd__nand2_1
XFILLER_33_3 vccd1 vssd1 vccd1 vssd1 sky130_ef_sc_hd__decap_40_12
X_2322_ _1071_ CALC_INST.input_ctrl_inst.key_pressed _1168_ vssd1 vssd1 vccd1 vccd1
+ _1169_ sky130_fd_sc_hd__a21o_1
X_2253_ _1106_ _1108_ _1109_ CALC_INST.gencon_inst.mult_calc.compCount.in2\[5\] _1110_
+ vssd1 vssd1 vccd1 vccd1 _1111_ sky130_fd_sc_hd__a221o_1
XFILLER_33_250 vssd1 vssd1 vccd1 vccd1 sky130_fd_sc_hd__fill_2
XANTENNA__2083__B2 CALC_INST.gencon_inst.operand2\[1\] vssd1 vssd1 vccd1 vccd1 sky130_fd_sc_hd__diode_2
X_1968_ _0890_ _0894_ _0917_ _0891_ vssd1 vssd1 vccd1 vccd1 _0919_ sky130_fd_sc_hd__o31a_1
X_1899_ CALC_INST.gencon_inst.mult_calc.out\[13\] net332 net144 vssd1 vssd1 vccd1
+ vccd1 _0286_ sky130_fd_sc_hd__mux2_1
XANTENNA__1346__B1 _0490_ vssd1 vssd1 vccd1 vccd1 sky130_fd_sc_hd__diode_2
XFILLER_0_349 vssd1 vssd1 vccd1 vccd1 sky130_fd_sc_hd__fill_8
XFILLER_0_305 vssd1 vssd1 vccd1 vccd1 sky130_fd_sc_hd__fill_2
XFILLER_56_320 vccd1 vssd1 vccd1 vssd1 sky130_ef_sc_hd__decap_40_12
XTAP_TAPCELL_ROW_54_521 vssd1 vccd1 sky130_fd_sc_hd__tapvpwrvgnd_1
XFILLER_48_309 vssd1 vssd1 vccd1 vccd1 sky130_fd_sc_hd__fill_8
XFILLER_33_42 vssd1 vssd1 vccd1 vccd1 sky130_fd_sc_hd__fill_8
XANTENNA__2066__A1_N net127 vssd1 vssd1 vccd1 vccd1 sky130_fd_sc_hd__diode_2
Xhold5 CALC_INST.input_ctrl_inst.scan_timer\[19\] vssd1 vssd1 vccd1 vccd1 net204 sky130_fd_sc_hd__dlygate4sd3_1
XFILLER_58_83 vssd1 vssd1 vccd1 vccd1 sky130_fd_sc_hd__fill_1
XFILLER_62_389 vccd1 vssd1 vccd1 vssd1 sky130_ef_sc_hd__decap_40_12
XFILLER_62_301 vssd1 vssd1 vccd1 vccd1 sky130_fd_sc_hd__fill_2
XTAP_TAPCELL_ROW_17_256 vssd1 vccd1 sky130_fd_sc_hd__tapvpwrvgnd_1
XTAP_TAPCELL_ROW_60_557 vssd1 vccd1 sky130_fd_sc_hd__tapvpwrvgnd_1
XPHY_EDGE_ROW_29_Left_94 vssd1 vssd1 vccd1 vccd1 sky130_fd_sc_hd__decap_3
X_1753_ net141 _0780_ _0781_ net338 net129 vssd1 vssd1 vccd1 vccd1 _0213_ sky130_fd_sc_hd__a32o_1
X_1822_ net422 net131 _0840_ net142 vssd1 vssd1 vccd1 vccd1 _0223_ sky130_fd_sc_hd__a22o_1
X_1684_ CALC_INST.gencon_inst.ALU_in2\[8\] CALC_INST.gencon_inst.ALU_in1\[8\] net60
+ vssd1 vssd1 vccd1 vccd1 _0742_ sky130_fd_sc_hd__mux2_1
X_2167_ net503 _1034_ net312 vssd1 vssd1 vccd1 vccd1 _1037_ sky130_fd_sc_hd__a21oi_1
XFILLER_53_323 vccd1 vssd1 vccd1 vssd1 sky130_ef_sc_hd__decap_40_12
XFILLER_53_301 vssd1 vssd1 vccd1 vccd1 sky130_fd_sc_hd__fill_4
XFILLER_38_342 vssd1 vssd1 vccd1 vccd1 sky130_fd_sc_hd__fill_1
X_2305_ CALC_INST.input_ctrl_inst.decoded_key\[1\] _1078_ _1148_ _1154_ vssd1 vssd1
+ vccd1 vccd1 _0028_ sky130_fd_sc_hd__a211o_1
XTAP_TAPCELL_ROW_0_135 vssd1 vccd1 sky130_fd_sc_hd__tapvpwrvgnd_1
X_2236_ CALC_INST.gencon_inst.mult_calc.count.GENERATE_ADDER\[11\].thingy.in1 CALC_INST.gencon_inst.mult_calc.count.GENERATE_ADDER\[10\].thingy.in1
+ _1093_ vssd1 vssd1 vccd1 vccd1 _1094_ sky130_fd_sc_hd__and3_1
XPHY_EDGE_ROW_13_Left_78 vssd1 vssd1 vccd1 vccd1 sky130_fd_sc_hd__decap_3
XFILLER_21_242 vssd1 vssd1 vccd1 vccd1 sky130_fd_sc_hd__fill_8
XFILLER_21_231 vssd1 vssd1 vccd1 vccd1 sky130_fd_sc_hd__fill_2
X_2098_ net133 net247 net122 CALC_INST.gencon_inst.mult_calc.count.GENERATE_ADDER\[1\].thingy.cIn
+ vssd1 vssd1 vccd1 vccd1 _0337_ sky130_fd_sc_hd__a22o_1
XANTENNA_fanout130_X net130 vssd1 vssd1 vccd1 vccd1 sky130_fd_sc_hd__diode_2
XFILLER_0_113 vssd1 vssd1 vccd1 vccd1 sky130_fd_sc_hd__fill_4
XFILLER_63_109 vssd1 vssd1 vccd1 vccd1 sky130_fd_sc_hd__fill_2
XFILLER_44_52 vssd1 vssd1 vccd1 vccd1 sky130_fd_sc_hd__fill_8
XFILLER_60_62 vssd1 vssd1 vccd1 vccd1 sky130_fd_sc_hd__fill_1
XTAP_TAPCELL_ROW_22_292 vssd1 vccd1 sky130_fd_sc_hd__tapvpwrvgnd_1
XFILLER_12_231 vssd1 vssd1 vccd1 vccd1 sky130_fd_sc_hd__fill_1
XTAP_TAPCELL_ROW_14_237 vssd1 vccd1 sky130_fd_sc_hd__tapvpwrvgnd_1
XFILLER_5_57 vssd1 vssd1 vccd1 vccd1 sky130_fd_sc_hd__fill_1
XFILLER_5_79 vssd1 vssd1 vccd1 vccd1 sky130_fd_sc_hd__fill_1
X_2021_ _0964_ _0965_ vssd1 vssd1 vccd1 vccd1 _0966_ sky130_fd_sc_hd__xnor2_1
XANTENNA__2286__A1 CALC_INST.gencon_inst.mult_calc.start vssd1 vssd1 vccd1 vccd1 sky130_fd_sc_hd__diode_2
Xhold202 CALC_INST.gencon_inst.add_calc.main.GENERATE_ADDER\[2\].thingy.in1 vssd1
+ vssd1 vccd1 vccd1 net401 sky130_fd_sc_hd__dlygate4sd3_1
X_2854_ clknet_leaf_9_clk _0369_ vssd1 vssd1 vccd1 vccd1 CALC_INST.input_ctrl_inst.scan_timer\[8\]
+ sky130_fd_sc_hd__dfxtp_1
X_1736_ CALC_INST.gencon_inst.gencon_state\[3\] _0423_ _0721_ vssd1 vssd1 vccd1 vccd1
+ _0771_ sky130_fd_sc_hd__o21ai_1
XANTENNA__1549__B1 net67 vssd1 vssd1 vccd1 vccd1 sky130_fd_sc_hd__diode_2
X_2785_ clknet_leaf_24_clk _0335_ vssd1 vssd1 vccd1 vccd1 CALC_INST.gencon_inst.mult_calc.INn2\[14\]
+ sky130_fd_sc_hd__dfxtp_1
Xhold235 CALC_INST.gencon_inst.mult_calc.adderSave\[4\] vssd1 vssd1 vccd1 vccd1 net434
+ sky130_fd_sc_hd__dlygate4sd3_1
Xhold213 CALC_INST.input_ctrl_inst.col_index\[11\] vssd1 vssd1 vccd1 vccd1 net412
+ sky130_fd_sc_hd__dlygate4sd3_1
Xhold224 CALC_INST.gencon_inst.mult_calc.compCount.in2\[1\] vssd1 vssd1 vccd1 vccd1
+ net423 sky130_fd_sc_hd__dlygate4sd3_1
X_1805_ CALC_INST.gencon_inst.mult_calc.main.GENERATE_ADDER\[9\].thingy.in2 CALC_INST.gencon_inst.mult_calc.main.GENERATE_ADDER\[9\].thingy.in1
+ vssd1 vssd1 vccd1 vccd1 _0826_ sky130_fd_sc_hd__nand2_1
Xhold257 CALC_INST.gencon_inst.ALU_out\[2\] vssd1 vssd1 vccd1 vccd1 net456 sky130_fd_sc_hd__dlygate4sd3_1
X_1667_ CALC_INST.gencon_inst.ALU_in1\[15\] _0732_ vssd1 vssd1 vccd1 vccd1 _0733_
+ sky130_fd_sc_hd__nand2_1
Xhold246 CALC_INST.input_ctrl_inst.scan_timer\[2\] vssd1 vssd1 vccd1 vccd1 net445
+ sky130_fd_sc_hd__dlygate4sd3_1
X_1598_ CALC_INST.gencon_inst.operator_input\[0\] net368 _0721_ vssd1 vssd1 vccd1
+ vccd1 _0118_ sky130_fd_sc_hd__mux2_1
Xhold279 CALC_INST.input_ctrl_inst.col_index\[8\] vssd1 vssd1 vccd1 vccd1 net478 sky130_fd_sc_hd__dlygate4sd3_1
Xhold268 CALC_INST.input_ctrl_inst.debounce_cnt\[12\] vssd1 vssd1 vccd1 vccd1 net467
+ sky130_fd_sc_hd__dlygate4sd3_1
X_2219_ CALC_INST.input_ctrl_inst.input_control_state\[0\] CALC_INST.input_ctrl_inst.input_control_state\[1\]
+ _1076_ vssd1 vssd1 vccd1 vccd1 _1078_ sky130_fd_sc_hd__nand3_4
XTAP_TAPCELL_ROW_36_395 vssd1 vccd1 sky130_fd_sc_hd__tapvpwrvgnd_1
XANTENNA__1252__A2 net49 vssd1 vssd1 vccd1 vccd1 sky130_fd_sc_hd__diode_2
XTAP_TAPCELL_ROW_11_218 vssd1 vccd1 sky130_fd_sc_hd__tapvpwrvgnd_1
XFILLER_14_77 vssd1 vssd1 vccd1 vccd1 sky130_fd_sc_hd__fill_1
XFILLER_5_216 vssd1 vssd1 vccd1 vccd1 sky130_fd_sc_hd__fill_2
XFILLER_39_74 vssd1 vssd1 vccd1 vccd1 sky130_fd_sc_hd__fill_4
XFILLER_39_30 vssd1 vssd1 vccd1 vccd1 sky130_fd_sc_hd__fill_1
XFILLER_44_197 vssd1 vssd1 vccd1 vccd1 sky130_fd_sc_hd__fill_1
XFILLER_32_359 vssd1 vssd1 vccd1 vccd1 sky130_fd_sc_hd__fill_4
XANTENNA__2052__S CALC_INST.gencon_inst.add_calc.state\[1\] vssd1 vssd1 vccd1 vccd1
+ sky130_fd_sc_hd__diode_2
X_2570_ clknet_leaf_15_clk _0129_ vssd1 vssd1 vccd1 vccd1 CALC_INST.gencon_inst.ALU_in1\[7\]
+ sky130_fd_sc_hd__dfxtp_1
X_1383_ CALC_INST.input_ctrl_inst.scan_timer\[17\] CALC_INST.input_ctrl_inst.scan_timer\[16\]
+ CALC_INST.input_ctrl_inst.scan_timer\[19\] CALC_INST.input_ctrl_inst.scan_timer\[18\]
+ vssd1 vssd1 vccd1 vccd1 _0563_ sky130_fd_sc_hd__or4_1
X_1521_ CALC_INST.gencon_inst.operand2\[2\] CALC_INST.gencon_inst.operand1\[2\] net73
+ vssd1 vssd1 vccd1 vccd1 _0666_ sky130_fd_sc_hd__mux2_1
X_1452_ _0584_ _0613_ _0612_ vssd1 vssd1 vccd1 vccd1 _0080_ sky130_fd_sc_hd__o21ai_1
XANTENNA__1891__S net143 vssd1 vssd1 vccd1 vccd1 sky130_fd_sc_hd__diode_2
X_2004_ net33 _0949_ _0951_ vssd1 vssd1 vccd1 vccd1 _0952_ sky130_fd_sc_hd__a21oi_1
XANTENNA_fanout138_A CALC_INST.gencon_inst.mult_calc.state\[3\] vssd1 vssd1 vccd1
+ vccd1 sky130_fd_sc_hd__diode_2
X_1719_ net388 _0759_ net153 vssd1 vssd1 vccd1 vccd1 _0201_ sky130_fd_sc_hd__mux2_1
X_2768_ clknet_leaf_2_clk net203 net83 vssd1 vssd1 vccd1 vccd1 CALC_INST.input_ctrl_inst.RowSync\[1\]
+ sky130_fd_sc_hd__dfstp_1
X_2699_ clknet_leaf_32_clk _0258_ net92 vssd1 vssd1 vccd1 vccd1 CALC_INST.gencon_inst.mult_calc.main.a0.in2
+ sky130_fd_sc_hd__dfrtp_1
X_2837_ clknet_leaf_3_clk _0013_ net85 vssd1 vssd1 vccd1 vccd1 CALC_INST.input_ctrl_inst.debounce_cnt\[14\]
+ sky130_fd_sc_hd__dfrtp_1
XFILLER_58_278 vssd1 vssd1 vccd1 vccd1 sky130_fd_sc_hd__fill_2
XPHY_EDGE_ROW_16_Left_81 vssd1 vssd1 vccd1 vccd1 sky130_fd_sc_hd__decap_3
XFILLER_18_109 vssd1 vssd1 vccd1 vccd1 sky130_fd_sc_hd__fill_2
XTAP_TAPCELL_ROW_24_310 vssd1 vccd1 sky130_fd_sc_hd__tapvpwrvgnd_1
XFILLER_49_223 vssd1 vssd1 vccd1 vccd1 sky130_fd_sc_hd__fill_1
XFILLER_49_234 vssd1 vssd1 vccd1 vccd1 sky130_fd_sc_hd__fill_1
XTAP_TAPCELL_ROW_47_468 vssd1 vccd1 sky130_fd_sc_hd__tapvpwrvgnd_1
XFILLER_9_330 vssd1 vssd1 vccd1 vccd1 sky130_fd_sc_hd__fill_4
XANTENNA__1886__S net143 vssd1 vssd1 vccd1 vccd1 sky130_fd_sc_hd__diode_2
X_2622_ clknet_leaf_16_clk _0181_ net115 vssd1 vssd1 vccd1 vccd1 CALC_INST.gencon_inst.add_calc.main.GENERATE_ADDER\[5\].thingy.in1
+ sky130_fd_sc_hd__dfrtp_1
X_2553_ clknet_leaf_13_clk _0112_ net99 vssd1 vssd1 vccd1 vccd1 CALC_INST.gencon_inst.operand1\[15\]
+ sky130_fd_sc_hd__dfrtp_1
X_1504_ CALC_INST.gencon_inst.mult_calc.out\[15\] _0418_ net54 _0651_ _0422_ vssd1
+ vssd1 vccd1 vccd1 _0652_ sky130_fd_sc_hd__a221o_1
X_1366_ _0548_ _0549_ _0490_ vssd1 vssd1 vccd1 vccd1 _0550_ sky130_fd_sc_hd__and3b_1
X_2484_ clknet_leaf_22_clk _0043_ net118 vssd1 vssd1 vccd1 vccd1 CALC_INST.gencon_inst.operand2\[11\]
+ sky130_fd_sc_hd__dfrtp_2
X_1435_ CALC_INST.input_ctrl_inst.col_index\[11\] CALC_INST.input_ctrl_inst.col_index\[12\]
+ _0601_ vssd1 vssd1 vccd1 vccd1 _0603_ sky130_fd_sc_hd__and3_1
XFILLER_63_281 vssd1 vssd1 vccd1 vccd1 sky130_fd_sc_hd__fill_2
X_1297_ net78 _0490_ vssd1 vssd1 vccd1 vccd1 _0492_ sky130_fd_sc_hd__nor2_1
XFILLER_23_134 vssd1 vssd1 vccd1 vccd1 sky130_fd_sc_hd__fill_2
XANTENNA__2101__B1 net122 vssd1 vssd1 vccd1 vccd1 sky130_fd_sc_hd__diode_2
XANTENNA_clkbuf_leaf_24_clk_A clknet_2_2__leaf_clk vssd1 vssd1 vccd1 vccd1 sky130_fd_sc_hd__diode_2
XFILLER_61_207 vssd1 vssd1 vccd1 vccd1 sky130_fd_sc_hd__fill_2
XFILLER_52_41 vssd1 vssd1 vccd1 vccd1 sky130_fd_sc_hd__fill_8
XTAP_TAPCELL_ROW_44_449 vssd1 vccd1 sky130_fd_sc_hd__tapvpwrvgnd_1
XPHY_EDGE_ROW_1_Left_66 vssd1 vssd1 vccd1 vccd1 sky130_fd_sc_hd__decap_3
XFILLER_60_240 vssd1 vssd1 vccd1 vccd1 sky130_fd_sc_hd__fill_2
XFILLER_52_229 vssd1 vssd1 vccd1 vccd1 sky130_fd_sc_hd__fill_1
XFILLER_37_237 vccd1 vssd1 vccd1 vssd1 sky130_ef_sc_hd__decap_40_12
XFILLER_60_284 vssd1 vssd1 vccd1 vccd1 sky130_fd_sc_hd__fill_1
X_1984_ _0910_ _0934_ vssd1 vssd1 vccd1 vccd1 _0935_ sky130_fd_sc_hd__xnor2_1
X_2536_ clknet_leaf_13_clk _0095_ net98 vssd1 vssd1 vccd1 vccd1 net30 sky130_fd_sc_hd__dfrtp_1
X_2467_ CALC_INST.gencon_inst.operand2\[2\] CALC_INST.gencon_inst.latched_keypad_input\[2\]
+ vssd1 vssd1 vccd1 vccd1 _0436_ sky130_fd_sc_hd__nand2_1
XANTENNA__1645__A net155 vssd1 vssd1 vccd1 vccd1 sky130_fd_sc_hd__diode_2
X_2605_ clknet_leaf_23_clk _0164_ vssd1 vssd1 vccd1 vccd1 CALC_INST.gencon_inst.mult_calc.INn1\[5\]
+ sky130_fd_sc_hd__dfxtp_1
X_1349_ CALC_INST.gencon_inst.operand1\[7\] net47 _0535_ _0536_ vssd1 vssd1 vccd1
+ vccd1 _0054_ sky130_fd_sc_hd__o22a_1
XFILLER_28_248 vssd1 vssd1 vccd1 vccd1 sky130_fd_sc_hd__fill_4
X_2398_ CALC_INST.input_ctrl_inst.col_index\[1\] CALC_INST.input_ctrl_inst.col_index\[0\]
+ _1159_ vssd1 vssd1 vccd1 vccd1 _1226_ sky130_fd_sc_hd__nor3_1
X_1418_ CALC_INST.input_ctrl_inst.col_index\[5\] CALC_INST.input_ctrl_inst.col_index\[6\]
+ _0590_ vssd1 vssd1 vccd1 vccd1 _0592_ sky130_fd_sc_hd__and3_1
XANTENNA__1379__X _0560_ vssd1 vssd1 vccd1 vccd1 sky130_fd_sc_hd__diode_2
Xfanout150 CALC_INST.gencon_inst.add_calc.state\[2\] vssd1 vssd1 vccd1 vccd1 net150
+ sky130_fd_sc_hd__buf_2
XTAP_TAPCELL_ROW_6_185 vssd1 vccd1 sky130_fd_sc_hd__tapvpwrvgnd_1
XFILLER_63_40 vssd1 vssd1 vccd1 vccd1 sky130_fd_sc_hd__fill_1
XTAP_TAPCELL_ROW_57_541 vssd1 vccd1 sky130_fd_sc_hd__tapvpwrvgnd_1
XFILLER_42_240 vssd1 vssd1 vccd1 vccd1 sky130_fd_sc_hd__fill_1
XANTENNA__2092__A2 net42 vssd1 vssd1 vccd1 vccd1 sky130_fd_sc_hd__diode_2
X_2321_ _1086_ _1167_ _1069_ vssd1 vssd1 vccd1 vccd1 _1168_ sky130_fd_sc_hd__a21oi_1
X_2183_ _1045_ net237 vssd1 vssd1 vccd1 vccd1 _0378_ sky130_fd_sc_hd__nor2_1
XFILLER_2_391 vccd1 vssd1 vccd1 vssd1 sky130_ef_sc_hd__decap_40_12
X_2252_ CALC_INST.gencon_inst.mult_calc.compCount.in2\[4\] _1107_ vssd1 vssd1 vccd1
+ vccd1 _1110_ sky130_fd_sc_hd__and2_1
XANTENNA__2083__A2 net44 vssd1 vssd1 vccd1 vccd1 sky130_fd_sc_hd__diode_2
X_1967_ _0894_ _0917_ vssd1 vssd1 vccd1 vccd1 _0918_ sky130_fd_sc_hd__nor2_1
XANTENNA_fanout120_A net121 vssd1 vssd1 vccd1 vccd1 sky130_fd_sc_hd__diode_2
X_1898_ CALC_INST.gencon_inst.mult_calc.out\[12\] net339 net144 vssd1 vssd1 vccd1
+ vccd1 _0285_ sky130_fd_sc_hd__mux2_1
X_2519_ clknet_leaf_0_clk _0078_ net82 vssd1 vssd1 vccd1 vccd1 CALC_INST.input_ctrl_inst.col_index\[16\]
+ sky130_fd_sc_hd__dfrtp_1
XFILLER_56_354 vssd1 vssd1 vccd1 vccd1 sky130_fd_sc_hd__fill_2
XFILLER_56_332 vssd1 vssd1 vccd1 vccd1 sky130_fd_sc_hd__fill_2
XFILLER_8_406 vssd1 vssd1 vccd1 vccd1 sky130_fd_sc_hd__fill_1
XFILLER_12_402 vssd1 vssd1 vccd1 vccd1 sky130_fd_sc_hd__fill_4
XANTENNA__1337__A1 net45 vssd1 vssd1 vccd1 vccd1 sky130_fd_sc_hd__diode_2
XFILLER_3_177 vssd1 vssd1 vccd1 vccd1 sky130_fd_sc_hd__fill_8
Xhold6 _0380_ vssd1 vssd1 vccd1 vccd1 net205 sky130_fd_sc_hd__dlygate4sd3_1
XFILLER_62_346 vssd1 vssd1 vccd1 vccd1 sky130_fd_sc_hd__fill_1
XFILLER_30_210 vssd1 vssd1 vccd1 vccd1 sky130_fd_sc_hd__fill_2
XTAP_TAPCELL_ROW_17_257 vssd1 vccd1 sky130_fd_sc_hd__tapvpwrvgnd_1
XTAP_TAPCELL_ROW_60_558 vssd1 vccd1 sky130_fd_sc_hd__tapvpwrvgnd_1
Xclkbuf_leaf_10_clk clknet_2_1__leaf_clk vssd1 vssd1 vccd1 vccd1 clknet_leaf_10_clk
+ sky130_fd_sc_hd__clkbuf_8
X_1683_ net448 _0741_ net152 vssd1 vssd1 vccd1 vccd1 _0183_ sky130_fd_sc_hd__mux2_1
X_1752_ _0778_ _0779_ _0776_ vssd1 vssd1 vccd1 vccd1 _0781_ sky130_fd_sc_hd__o21ai_1
X_1821_ _0838_ _0839_ vssd1 vssd1 vccd1 vccd1 _0840_ sky130_fd_sc_hd__xor2_1
X_2304_ CALC_INST.input_ctrl_inst.col_index\[1\] _1072_ _1077_ vssd1 vssd1 vccd1 vccd1
+ _1154_ sky130_fd_sc_hd__o21a_1
XFILLER_53_335 vssd1 vssd1 vccd1 vccd1 sky130_fd_sc_hd__fill_1
X_2166_ CALC_INST.input_ctrl_inst.scan_timer\[11\] CALC_INST.input_ctrl_inst.scan_timer\[10\]
+ _1034_ vssd1 vssd1 vccd1 vccd1 _1036_ sky130_fd_sc_hd__and3_1
X_2097_ net274 net42 net34 CALC_INST.gencon_inst.operand2\[15\] vssd1 vssd1 vccd1
+ vccd1 _0336_ sky130_fd_sc_hd__a22o_1
XTAP_TAPCELL_ROW_0_136 vssd1 vccd1 sky130_fd_sc_hd__tapvpwrvgnd_1
X_2235_ CALC_INST.gencon_inst.mult_calc.count.GENERATE_ADDER\[9\].thingy.in1 _1092_
+ vssd1 vssd1 vccd1 vccd1 _1093_ sky130_fd_sc_hd__and2_1
XANTENNA__1803__A2 net130 vssd1 vssd1 vccd1 vccd1 sky130_fd_sc_hd__diode_2
XPHY_EDGE_ROW_3_Right_3 vssd1 vssd1 vccd1 vccd1 sky130_fd_sc_hd__decap_3
XFILLER_0_169 vccd1 vssd1 vccd1 vssd1 sky130_ef_sc_hd__decap_40_12
XFILLER_56_195 vssd1 vssd1 vccd1 vccd1 sky130_fd_sc_hd__fill_1
XFILLER_44_31 vssd1 vssd1 vccd1 vccd1 sky130_fd_sc_hd__fill_1
XFILLER_29_387 vssd1 vssd1 vccd1 vccd1 sky130_fd_sc_hd__fill_4
XFILLER_12_221 vssd1 vssd1 vccd1 vccd1 sky130_fd_sc_hd__fill_8
XFILLER_60_85 vssd1 vssd1 vccd1 vccd1 sky130_fd_sc_hd__fill_8
XFILLER_44_97 vssd1 vssd1 vccd1 vccd1 sky130_fd_sc_hd__fill_2
XANTENNA__1558__A1 _0415_ vssd1 vssd1 vccd1 vccd1 sky130_fd_sc_hd__diode_2
XPHY_EDGE_ROW_30_Left_95 vssd1 vssd1 vccd1 vccd1 sky130_fd_sc_hd__decap_3
XTAP_TAPCELL_ROW_22_293 vssd1 vccd1 sky130_fd_sc_hd__tapvpwrvgnd_1
XTAP_TAPCELL_ROW_14_238 vssd1 vccd1 sky130_fd_sc_hd__tapvpwrvgnd_1
X_2020_ _0958_ _0961_ net32 vssd1 vssd1 vccd1 vccd1 _0965_ sky130_fd_sc_hd__o21ai_1
XFILLER_35_335 vssd1 vssd1 vccd1 vccd1 sky130_fd_sc_hd__fill_1
XANTENNA__1889__S net143 vssd1 vssd1 vccd1 vccd1 sky130_fd_sc_hd__diode_2
X_2853_ clknet_leaf_9_clk _0368_ vssd1 vssd1 vccd1 vccd1 CALC_INST.input_ctrl_inst.scan_timer\[7\]
+ sky130_fd_sc_hd__dfxtp_1
XFILLER_35_368 vssd1 vssd1 vccd1 vccd1 sky130_fd_sc_hd__fill_4
Xhold269 CALC_INST.gencon_inst.ALU_out\[13\] vssd1 vssd1 vccd1 vccd1 net468 sky130_fd_sc_hd__dlygate4sd3_1
X_1666_ CALC_INST.gencon_inst.addOrSub _0731_ vssd1 vssd1 vccd1 vccd1 _0732_ sky130_fd_sc_hd__xnor2_1
X_1735_ _0711_ _0769_ _0715_ vssd1 vssd1 vccd1 vccd1 _0770_ sky130_fd_sc_hd__a21o_1
X_2784_ clknet_leaf_24_clk _0334_ vssd1 vssd1 vccd1 vccd1 CALC_INST.gencon_inst.mult_calc.INn2\[13\]
+ sky130_fd_sc_hd__dfxtp_1
Xhold236 CALC_INST.gencon_inst.mult_calc.INn2\[0\] vssd1 vssd1 vccd1 vccd1 net435
+ sky130_fd_sc_hd__dlygate4sd3_1
Xhold225 CALC_INST.gencon_inst.mult_calc.main.GENERATE_ADDER\[4\].thingy.in2 vssd1
+ vssd1 vccd1 vccd1 net424 sky130_fd_sc_hd__dlygate4sd3_1
Xhold247 CALC_INST.gencon_inst.mult_calc.main.GENERATE_ADDER\[1\].thingy.in2 vssd1
+ vssd1 vccd1 vccd1 net446 sky130_fd_sc_hd__dlygate4sd3_1
X_1804_ CALC_INST.gencon_inst.mult_calc.main.GENERATE_ADDER\[9\].thingy.in2 CALC_INST.gencon_inst.mult_calc.main.GENERATE_ADDER\[9\].thingy.in1
+ vssd1 vssd1 vccd1 vccd1 _0825_ sky130_fd_sc_hd__or2_1
Xhold258 CALC_INST.input_ctrl_inst.col_index\[19\] vssd1 vssd1 vccd1 vccd1 net457
+ sky130_fd_sc_hd__dlygate4sd3_1
Xhold214 CALC_INST.input_ctrl_inst.col_index\[9\] vssd1 vssd1 vccd1 vccd1 net413 sky130_fd_sc_hd__dlygate4sd3_1
Xhold203 CALC_INST.gencon_inst.mult_calc.compCount.in2\[7\] vssd1 vssd1 vccd1 vccd1
+ net402 sky130_fd_sc_hd__dlygate4sd3_1
XFILLER_58_405 vssd1 vssd1 vccd1 vccd1 sky130_fd_sc_hd__fill_2
X_1597_ _0648_ _0654_ vssd1 vssd1 vccd1 vccd1 _0721_ sky130_fd_sc_hd__or2_1
X_2149_ _1025_ _1026_ vssd1 vssd1 vccd1 vccd1 _0364_ sky130_fd_sc_hd__and2b_1
XFILLER_41_327 vssd1 vssd1 vccd1 vccd1 sky130_fd_sc_hd__fill_2
XFILLER_38_184 vccd1 vssd1 vccd1 vssd1 sky130_ef_sc_hd__decap_40_12
XFILLER_26_313 vssd1 vssd1 vccd1 vccd1 sky130_fd_sc_hd__fill_1
X_2218_ CALC_INST.input_ctrl_inst.input_control_state\[0\] CALC_INST.input_ctrl_inst.input_control_state\[1\]
+ _1076_ vssd1 vssd1 vccd1 vccd1 _1077_ sky130_fd_sc_hd__and3_2
XTAP_TAPCELL_ROW_11_219 vssd1 vccd1 sky130_fd_sc_hd__tapvpwrvgnd_1
XFILLER_1_401 vssd1 vssd1 vccd1 vccd1 sky130_fd_sc_hd__fill_2
XFILLER_44_121 vssd1 vssd1 vccd1 vccd1 sky130_fd_sc_hd__fill_2
XTAP_TAPCELL_ROW_27_330 vssd1 vccd1 sky130_fd_sc_hd__tapvpwrvgnd_1
X_1520_ net455 net75 net67 CALC_INST.gencon_inst.mult_calc.out\[1\] _0665_ vssd1 vssd1
+ vccd1 vccd1 _0096_ sky130_fd_sc_hd__a221o_1
XFILLER_4_250 vssd1 vssd1 vccd1 vccd1 sky130_fd_sc_hd__fill_2
X_1382_ CALC_INST.gencon_inst.operand1\[14\] net48 _0561_ _0562_ vssd1 vssd1 vccd1
+ vccd1 _0061_ sky130_fd_sc_hd__o22a_1
X_1451_ CALC_INST.input_ctrl_inst.col_index\[18\] _0610_ vssd1 vssd1 vccd1 vccd1 _0613_
+ sky130_fd_sc_hd__xnor2_1
X_2003_ _0915_ _0950_ vssd1 vssd1 vccd1 vccd1 _0951_ sky130_fd_sc_hd__xnor2_1
XFILLER_50_179 vssd1 vssd1 vccd1 vccd1 sky130_fd_sc_hd__fill_1
X_2836_ clknet_leaf_3_clk _0012_ net91 vssd1 vssd1 vccd1 vccd1 CALC_INST.input_ctrl_inst.debounce_cnt\[13\]
+ sky130_fd_sc_hd__dfrtp_1
X_1718_ CALC_INST.gencon_inst.ALU_in1\[10\] CALC_INST.gencon_inst.ALU_in2\[10\] net61
+ vssd1 vssd1 vccd1 vccd1 _0759_ sky130_fd_sc_hd__mux2_1
X_1649_ net216 _0669_ net43 vssd1 vssd1 vccd1 vccd1 _0162_ sky130_fd_sc_hd__mux2_1
X_2767_ clknet_leaf_2_clk net202 net83 vssd1 vssd1 vccd1 vccd1 CALC_INST.input_ctrl_inst.RowSync\[0\]
+ sky130_fd_sc_hd__dfstp_1
X_2698_ clknet_leaf_32_clk _0257_ net91 vssd1 vssd1 vccd1 vccd1 CALC_INST.gencon_inst.mult_calc.finish
+ sky130_fd_sc_hd__dfrtp_1
XANTENNA_input5_A gpio_in[3] vssd1 vssd1 vccd1 vccd1 sky130_fd_sc_hd__diode_2
XFILLER_25_55 vssd1 vssd1 vccd1 vccd1 sky130_fd_sc_hd__fill_1
XFILLER_25_11 vssd1 vssd1 vccd1 vccd1 sky130_fd_sc_hd__fill_4
XTAP_TAPCELL_ROW_24_311 vssd1 vccd1 sky130_fd_sc_hd__tapvpwrvgnd_1
XFILLER_22_360 vssd1 vssd1 vccd1 vccd1 sky130_fd_sc_hd__fill_2
XFILLER_49_279 vssd1 vssd1 vccd1 vccd1 sky130_fd_sc_hd__fill_1
XTAP_TAPCELL_ROW_47_469 vssd1 vccd1 sky130_fd_sc_hd__tapvpwrvgnd_1
XTAP_TAPCELL_ROW_30_347 vssd1 vccd1 sky130_fd_sc_hd__tapvpwrvgnd_1
X_2621_ clknet_leaf_12_clk _0180_ net115 vssd1 vssd1 vccd1 vccd1 CALC_INST.gencon_inst.add_calc.main.GENERATE_ADDER\[4\].thingy.in1
+ sky130_fd_sc_hd__dfrtp_1
X_2483_ clknet_leaf_21_clk _0042_ net117 vssd1 vssd1 vccd1 vccd1 CALC_INST.gencon_inst.operand2\[10\]
+ sky130_fd_sc_hd__dfrtp_2
X_2552_ clknet_leaf_4_clk _0111_ net99 vssd1 vssd1 vccd1 vccd1 CALC_INST.complete
+ sky130_fd_sc_hd__dfrtp_1
X_1503_ CALC_INST.gencon_inst.operand2\[15\] _0482_ vssd1 vssd1 vccd1 vccd1 _0651_
+ sky130_fd_sc_hd__xor2_1
X_1365_ CALC_INST.gencon_inst.operand1\[10\] _0541_ CALC_INST.gencon_inst.operand1\[11\]
+ vssd1 vssd1 vccd1 vccd1 _0549_ sky130_fd_sc_hd__a21o_1
X_1296_ net149 CALC_INST.gencon_inst.gencon_state\[3\] CALC_INST.gencon_inst.gencon_state\[2\]
+ net148 vssd1 vssd1 vccd1 vccd1 _0491_ sky130_fd_sc_hd__or4b_4
XTAP_TAPCELL_ROW_38_403 vssd1 vccd1 sky130_fd_sc_hd__tapvpwrvgnd_1
X_1434_ CALC_INST.input_ctrl_inst.col_index\[11\] _0601_ net481 vssd1 vssd1 vccd1
+ vccd1 _0602_ sky130_fd_sc_hd__a21oi_1
XANTENNA_fanout150_A CALC_INST.gencon_inst.add_calc.state\[2\] vssd1 vssd1 vccd1 vccd1
+ sky130_fd_sc_hd__diode_2
XANTENNA__2101__A1 net133 vssd1 vssd1 vccd1 vccd1 sky130_fd_sc_hd__diode_2
X_2819_ clknet_leaf_3_clk CALC_INST.input_ctrl_inst.next_state\[1\] net85 vssd1 vssd1
+ vccd1 vccd1 CALC_INST.input_ctrl_inst.input_control_state\[1\] sky130_fd_sc_hd__dfrtp_4
XANTENNA_fanout63_A _0724_ vssd1 vssd1 vccd1 vccd1 sky130_fd_sc_hd__diode_2
XFILLER_10_363 vssd1 vssd1 vccd1 vccd1 sky130_fd_sc_hd__fill_1
XFILLER_37_227 vssd1 vssd1 vccd1 vccd1 sky130_fd_sc_hd__fill_1
XFILLER_60_274 vssd1 vssd1 vccd1 vccd1 sky130_fd_sc_hd__fill_8
XFILLER_37_249 vssd1 vssd1 vccd1 vccd1 sky130_fd_sc_hd__fill_1
X_1983_ CALC_INST.gencon_inst.add_calc.main.GENERATE_ADDER\[1\].thingy.in1 _0908_
+ vssd1 vssd1 vccd1 vccd1 _0934_ sky130_fd_sc_hd__xor2_1
X_2604_ clknet_leaf_31_clk _0163_ vssd1 vssd1 vccd1 vccd1 CALC_INST.gencon_inst.mult_calc.INn1\[4\]
+ sky130_fd_sc_hd__dfxtp_1
XANTENNA__1358__C1 net45 vssd1 vssd1 vccd1 vccd1 sky130_fd_sc_hd__diode_2
X_2535_ clknet_leaf_4_clk _0094_ net99 vssd1 vssd1 vccd1 vccd1 CALC_INST.gencon_inst.operand2\[15\]
+ sky130_fd_sc_hd__dfrtp_2
X_2466_ CALC_INST.gencon_inst.operand2\[1\] _0435_ net36 vssd1 vssd1 vccd1 vccd1 _0033_
+ sky130_fd_sc_hd__mux2_1
X_1417_ CALC_INST.input_ctrl_inst.col_index\[5\] _0590_ net498 vssd1 vssd1 vccd1 vccd1
+ _0591_ sky130_fd_sc_hd__a21oi_1
XANTENNA__1380__B _0490_ vssd1 vssd1 vccd1 vccd1 sky130_fd_sc_hd__diode_2
X_1348_ CALC_INST.gencon_inst.ALU_out\[7\] net78 net69 CALC_INST.gencon_inst.mult_calc.out\[7\]
+ net46 vssd1 vssd1 vccd1 vccd1 _0536_ sky130_fd_sc_hd__a221o_1
X_1279_ CALC_INST.gencon_inst.operand2\[12\] _0472_ net55 vssd1 vssd1 vccd1 vccd1
+ _0477_ sky130_fd_sc_hd__o21ai_1
XANTENNA__2086__B1 net34 vssd1 vssd1 vccd1 vccd1 sky130_fd_sc_hd__diode_2
X_2397_ _1223_ _1224_ vssd1 vssd1 vccd1 vccd1 _1225_ sky130_fd_sc_hd__nor2_1
XFILLER_11_138 vssd1 vssd1 vccd1 vccd1 sky130_fd_sc_hd__fill_2
Xfanout151 CALC_INST.gencon_inst.add_calc.state\[2\] vssd1 vssd1 vccd1 vccd1 net151
+ sky130_fd_sc_hd__buf_2
XFILLER_59_363 vssd1 vssd1 vccd1 vccd1 sky130_fd_sc_hd__fill_1
Xfanout140 CALC_INST.gencon_inst.mult_calc.state\[3\] vssd1 vssd1 vccd1 vccd1 net140
+ sky130_fd_sc_hd__clkbuf_4
XTAP_TAPCELL_ROW_57_542 vssd1 vccd1 sky130_fd_sc_hd__tapvpwrvgnd_1
XANTENNA__2077__B1 net130 vssd1 vssd1 vccd1 vccd1 sky130_fd_sc_hd__diode_2
XTAP_TAPCELL_ROW_40_420 vssd1 vccd1 sky130_fd_sc_hd__tapvpwrvgnd_1
X_2320_ _1068_ CALC_INST.input_ctrl_inst.key_pressed vssd1 vssd1 vccd1 vccd1 _1167_
+ sky130_fd_sc_hd__or2_1
X_2251_ CALC_INST.gencon_inst.mult_calc.count.GENERATE_ADDER\[5\].thingy.in1 _1090_
+ vssd1 vssd1 vccd1 vccd1 _1109_ sky130_fd_sc_hd__xor2_1
X_2182_ CALC_INST.input_ctrl_inst.scan_timer\[16\] _1043_ net236 vssd1 vssd1 vccd1
+ vccd1 _1046_ sky130_fd_sc_hd__a21oi_1
XANTENNA_clkbuf_leaf_23_clk_A clknet_2_2__leaf_clk vssd1 vssd1 vccd1 vccd1 sky130_fd_sc_hd__diode_2
XTAP_TAPCELL_ROW_63_578 vssd1 vccd1 sky130_fd_sc_hd__tapvpwrvgnd_1
X_1966_ _0898_ _0902_ _0914_ _0899_ _0895_ vssd1 vssd1 vccd1 vccd1 _0917_ sky130_fd_sc_hd__o311a_1
XFILLER_33_252 vssd1 vssd1 vccd1 vccd1 sky130_fd_sc_hd__fill_1
XANTENNA__2523__RESET_B net93 vssd1 vssd1 vccd1 vccd1 sky130_fd_sc_hd__diode_2
XANTENNA_fanout113_A net121 vssd1 vssd1 vccd1 vccd1 sky130_fd_sc_hd__diode_2
X_1897_ CALC_INST.gencon_inst.mult_calc.out\[11\] net422 net144 vssd1 vssd1 vccd1
+ vccd1 _0284_ sky130_fd_sc_hd__mux2_1
X_2449_ CALC_INST.gencon_inst.mult_calc.finish _0419_ vssd1 vssd1 vccd1 vccd1 _0420_
+ sky130_fd_sc_hd__nor2_1
XFILLER_0_307 vssd1 vssd1 vccd1 vccd1 sky130_fd_sc_hd__fill_1
X_2518_ clknet_leaf_1_clk _0077_ net82 vssd1 vssd1 vccd1 vccd1 CALC_INST.input_ctrl_inst.col_index\[15\]
+ sky130_fd_sc_hd__dfrtp_1
XFILLER_33_88 vssd1 vssd1 vccd1 vccd1 sky130_fd_sc_hd__fill_2
XFILLER_3_167 vssd1 vssd1 vccd1 vccd1 sky130_fd_sc_hd__fill_1
XFILLER_59_182 vssd1 vssd1 vccd1 vccd1 sky130_fd_sc_hd__fill_2
XFILLER_58_85 vssd1 vssd1 vccd1 vccd1 sky130_fd_sc_hd__fill_2
Xhold7 CALC_INST.gencon_inst.mult_calc.INn1\[13\] vssd1 vssd1 vccd1 vccd1 net206 sky130_fd_sc_hd__dlygate4sd3_1
XTAP_TAPCELL_ROW_60_559 vssd1 vccd1 sky130_fd_sc_hd__tapvpwrvgnd_1
XFILLER_30_255 vssd1 vssd1 vccd1 vccd1 sky130_fd_sc_hd__fill_1
X_1820_ _0830_ _0834_ _0831_ vssd1 vssd1 vccd1 vccd1 _0839_ sky130_fd_sc_hd__o21a_1
XTAP_TAPCELL_ROW_17_258 vssd1 vccd1 sky130_fd_sc_hd__tapvpwrvgnd_1
X_1682_ CALC_INST.gencon_inst.ALU_in2\[7\] CALC_INST.gencon_inst.ALU_in1\[7\] net60
+ vssd1 vssd1 vccd1 vccd1 _0741_ sky130_fd_sc_hd__mux2_1
X_1751_ _0776_ _0778_ _0779_ vssd1 vssd1 vccd1 vccd1 _0780_ sky130_fd_sc_hd__or3_1
X_2303_ CALC_INST.input_ctrl_inst.decoded_key\[0\] _1077_ _1149_ _1153_ vssd1 vssd1
+ vccd1 vccd1 _0027_ sky130_fd_sc_hd__o211a_1
X_2234_ CALC_INST.gencon_inst.mult_calc.count.GENERATE_ADDER\[8\].thingy.in1 CALC_INST.gencon_inst.mult_calc.count.GENERATE_ADDER\[7\].thingy.in1
+ _1091_ vssd1 vssd1 vccd1 vccd1 _1092_ sky130_fd_sc_hd__and3_1
X_2165_ net377 _1034_ vssd1 vssd1 vccd1 vccd1 _0371_ sky130_fd_sc_hd__xor2_1
X_2096_ net404 _0728_ net35 CALC_INST.gencon_inst.operand2\[14\] vssd1 vssd1 vccd1
+ vccd1 _0335_ sky130_fd_sc_hd__a22o_1
XFILLER_0_81 vssd1 vssd1 vccd1 vccd1 sky130_fd_sc_hd__fill_2
XTAP_TAPCELL_ROW_0_137 vssd1 vccd1 sky130_fd_sc_hd__tapvpwrvgnd_1
X_1949_ net145 CALC_INST.gencon_inst.add_calc.main.in2\[3\] vssd1 vssd1 vccd1 vccd1
+ _0900_ sky130_fd_sc_hd__or2_1
XANTENNA__1264__B2 net49 vssd1 vssd1 vccd1 vccd1 sky130_fd_sc_hd__diode_2
XFILLER_21_211 vssd1 vssd1 vccd1 vccd1 sky130_fd_sc_hd__fill_4
XFILLER_56_174 vccd1 vssd1 vccd1 vssd1 sky130_ef_sc_hd__decap_40_12
XFILLER_56_141 vssd1 vssd1 vccd1 vccd1 sky130_fd_sc_hd__fill_1
XFILLER_48_119 vssd1 vssd1 vccd1 vccd1 sky130_fd_sc_hd__fill_1
XTAP_TAPCELL_ROW_14_239 vssd1 vccd1 sky130_fd_sc_hd__tapvpwrvgnd_1
XFILLER_60_42 vssd1 vssd1 vccd1 vccd1 sky130_fd_sc_hd__fill_1
XTAP_TAPCELL_ROW_22_294 vssd1 vccd1 sky130_fd_sc_hd__tapvpwrvgnd_1
XFILLER_5_26 vssd1 vssd1 vccd1 vccd1 sky130_fd_sc_hd__fill_2
XFILLER_5_48 vssd1 vssd1 vccd1 vccd1 sky130_fd_sc_hd__fill_1
XFILLER_50_306 vssd1 vssd1 vccd1 vccd1 sky130_fd_sc_hd__fill_2
XFILLER_47_141 vssd1 vssd1 vccd1 vccd1 sky130_fd_sc_hd__fill_1
XPHY_EDGE_ROW_13_Right_13 vssd1 vssd1 vccd1 vccd1 sky130_fd_sc_hd__decap_3
X_2852_ clknet_leaf_8_clk _0367_ vssd1 vssd1 vccd1 vccd1 CALC_INST.input_ctrl_inst.scan_timer\[6\]
+ sky130_fd_sc_hd__dfxtp_1
X_2783_ clknet_leaf_24_clk net429 vssd1 vssd1 vccd1 vccd1 CALC_INST.gencon_inst.mult_calc.INn2\[12\]
+ sky130_fd_sc_hd__dfxtp_1
XPHY_EDGE_ROW_22_Right_22 vssd1 vssd1 vccd1 vccd1 sky130_fd_sc_hd__decap_3
X_1803_ net421 net130 _0824_ net142 vssd1 vssd1 vccd1 vccd1 _0220_ sky130_fd_sc_hd__a22o_1
X_1665_ CALC_INST.gencon_inst.ALU_in2\[15\] CALC_INST.gencon_inst.ALU_in1\[15\] vssd1
+ vssd1 vccd1 vccd1 _0731_ sky130_fd_sc_hd__xnor2_1
X_1596_ CALC_INST.gencon_inst.operator_input\[2\] _0653_ vssd1 vssd1 vccd1 vccd1 _0720_
+ sky130_fd_sc_hd__nand2_1
X_1734_ CALC_INST.gencon_inst.mult_calc.finish CALC_INST.gencon_inst.ALU_finish vssd1
+ vssd1 vccd1 vccd1 _0769_ sky130_fd_sc_hd__nor2_1
Xhold259 CALC_INST.gencon_inst.mult_calc.INn2\[8\] vssd1 vssd1 vccd1 vccd1 net458
+ sky130_fd_sc_hd__dlygate4sd3_1
Xhold237 _0321_ vssd1 vssd1 vccd1 vccd1 net436 sky130_fd_sc_hd__dlygate4sd3_1
Xhold226 _0262_ vssd1 vssd1 vccd1 vccd1 net425 sky130_fd_sc_hd__dlygate4sd3_1
Xhold215 CALC_INST.gencon_inst.mult_calc.compCount.in2\[3\] vssd1 vssd1 vccd1 vccd1
+ net414 sky130_fd_sc_hd__dlygate4sd3_1
Xhold204 _0234_ vssd1 vssd1 vccd1 vccd1 net403 sky130_fd_sc_hd__dlygate4sd3_1
Xhold248 CALC_INST.gencon_inst.mult_calc.adderSave\[3\] vssd1 vssd1 vccd1 vccd1 net447
+ sky130_fd_sc_hd__dlygate4sd3_1
XPHY_EDGE_ROW_31_Right_31 vssd1 vssd1 vccd1 vccd1 sky130_fd_sc_hd__decap_3
XFILLER_26_303 vssd1 vssd1 vccd1 vccd1 sky130_fd_sc_hd__fill_2
X_2217_ CALC_INST.input_ctrl_inst.input_control_state\[3\] CALC_INST.input_ctrl_inst.input_control_state\[2\]
+ vssd1 vssd1 vccd1 vccd1 _1076_ sky130_fd_sc_hd__nor2_1
XFILLER_53_111 vssd1 vssd1 vccd1 vccd1 sky130_fd_sc_hd__fill_1
X_2148_ CALC_INST.input_ctrl_inst.scan_timer\[1\] CALC_INST.input_ctrl_inst.scan_timer\[2\]
+ net57 CALC_INST.input_ctrl_inst.scan_timer\[3\] vssd1 vssd1 vccd1 vccd1 _1026_ sky130_fd_sc_hd__a31o_1
X_2079_ net128 _1097_ net130 net314 vssd1 vssd1 vccd1 vccd1 _0320_ sky130_fd_sc_hd__a2bb2o_1
XPHY_EDGE_ROW_40_Right_40 vssd1 vssd1 vccd1 vccd1 sky130_fd_sc_hd__decap_3
XFILLER_30_45 vssd1 vssd1 vccd1 vccd1 sky130_fd_sc_hd__fill_1
XFILLER_5_218 vssd1 vssd1 vccd1 vccd1 sky130_fd_sc_hd__fill_1
XFILLER_49_406 vssd1 vssd1 vccd1 vccd1 sky130_fd_sc_hd__fill_1
XANTENNA_fanout93_A net100 vssd1 vssd1 vccd1 vccd1 sky130_fd_sc_hd__diode_2
XFILLER_30_89 vssd1 vssd1 vccd1 vccd1 sky130_fd_sc_hd__fill_2
XFILLER_30_78 vssd1 vssd1 vccd1 vccd1 sky130_fd_sc_hd__fill_4
XFILLER_55_64 vssd1 vssd1 vccd1 vccd1 sky130_fd_sc_hd__fill_2
XFILLER_55_53 vssd1 vssd1 vccd1 vccd1 sky130_fd_sc_hd__fill_2
XFILLER_55_20 vssd1 vssd1 vccd1 vccd1 sky130_fd_sc_hd__fill_1
XTAP_TAPCELL_ROW_27_331 vssd1 vccd1 sky130_fd_sc_hd__tapvpwrvgnd_1
XFILLER_40_361 vssd1 vssd1 vccd1 vccd1 sky130_fd_sc_hd__fill_2
X_1450_ CALC_INST.input_ctrl_inst.col_index\[18\] _0578_ vssd1 vssd1 vccd1 vccd1 _0612_
+ sky130_fd_sc_hd__nand2_1
X_1381_ CALC_INST.gencon_inst.ALU_out\[14\] net77 net70 CALC_INST.gencon_inst.mult_calc.out\[14\]
+ net46 vssd1 vssd1 vccd1 vccd1 _0562_ sky130_fd_sc_hd__a221o_1
XFILLER_4_295 vssd1 vssd1 vccd1 vccd1 sky130_fd_sc_hd__fill_1
X_2002_ _0898_ _0899_ vssd1 vssd1 vccd1 vccd1 _0950_ sky130_fd_sc_hd__nand2b_1
XFILLER_35_166 vssd1 vssd1 vccd1 vccd1 sky130_fd_sc_hd__fill_2
XFILLER_35_133 vssd1 vssd1 vccd1 vccd1 sky130_fd_sc_hd__fill_1
XFILLER_35_111 vssd1 vssd1 vccd1 vccd1 sky130_fd_sc_hd__fill_1
XFILLER_23_306 vssd1 vssd1 vccd1 vccd1 sky130_fd_sc_hd__fill_2
XANTENNA_clkbuf_0_clk_X clknet_0_clk vssd1 vssd1 vccd1 vccd1 sky130_fd_sc_hd__diode_2
XFILLER_31_350 vssd1 vssd1 vccd1 vccd1 sky130_fd_sc_hd__fill_2
X_2835_ clknet_leaf_32_clk _0011_ net90 vssd1 vssd1 vccd1 vccd1 CALC_INST.input_ctrl_inst.debounce_cnt\[12\]
+ sky130_fd_sc_hd__dfrtp_1
X_2766_ clknet_leaf_30_clk _0004_ net108 vssd1 vssd1 vccd1 vccd1 CALC_INST.gencon_inst.mult_calc.state\[4\]
+ sky130_fd_sc_hd__dfrtp_1
X_1717_ net350 _0758_ net152 vssd1 vssd1 vccd1 vccd1 _0200_ sky130_fd_sc_hd__mux2_1
X_1579_ CALC_INST.gencon_inst.operand1\[15\] _0560_ _0708_ vssd1 vssd1 vccd1 vccd1
+ _0709_ sky130_fd_sc_hd__o21a_1
X_2697_ clknet_leaf_24_clk _0256_ net109 vssd1 vssd1 vccd1 vccd1 CALC_INST.gencon_inst.mult_calc.main.GENERATE_ADDER\[14\].thingy.in1
+ sky130_fd_sc_hd__dfrtp_1
X_1648_ net209 _0666_ net43 vssd1 vssd1 vccd1 vccd1 _0161_ sky130_fd_sc_hd__mux2_1
XFILLER_6_80 vssd1 vssd1 vccd1 vccd1 sky130_fd_sc_hd__fill_4
XANTENNA__1398__X _0578_ vssd1 vssd1 vccd1 vccd1 sky130_fd_sc_hd__diode_2
XFILLER_41_66 vssd1 vssd1 vccd1 vccd1 sky130_fd_sc_hd__fill_1
XFILLER_41_55 vssd1 vssd1 vccd1 vccd1 sky130_fd_sc_hd__fill_1
XFILLER_49_203 vssd1 vssd1 vccd1 vccd1 sky130_fd_sc_hd__fill_8
XFILLER_64_217 vssd1 vssd1 vccd1 vccd1 sky130_fd_sc_hd__fill_2
XFILLER_32_114 vssd1 vssd1 vccd1 vccd1 sky130_fd_sc_hd__fill_2
X_2620_ clknet_leaf_12_clk _0179_ net98 vssd1 vssd1 vccd1 vccd1 CALC_INST.gencon_inst.add_calc.main.GENERATE_ADDER\[3\].thingy.in1
+ sky130_fd_sc_hd__dfrtp_1
XTAP_TAPCELL_ROW_30_348 vssd1 vccd1 sky130_fd_sc_hd__tapvpwrvgnd_1
XFILLER_9_321 vssd1 vssd1 vccd1 vccd1 sky130_fd_sc_hd__fill_2
XANTENNA__1468__B _0578_ vssd1 vssd1 vccd1 vccd1 sky130_fd_sc_hd__diode_2
XFILLER_13_361 vssd1 vssd1 vccd1 vccd1 sky130_fd_sc_hd__fill_2
XFILLER_13_383 vssd1 vssd1 vccd1 vccd1 sky130_fd_sc_hd__fill_1
X_2551_ clknet_leaf_13_clk _0110_ net100 vssd1 vssd1 vccd1 vccd1 net20 sky130_fd_sc_hd__dfrtp_1
X_1502_ net71 _0417_ net73 _0649_ _0420_ vssd1 vssd1 vccd1 vccd1 _0650_ sky130_fd_sc_hd__a311oi_1
X_2482_ clknet_leaf_22_clk _0041_ net114 vssd1 vssd1 vccd1 vccd1 CALC_INST.gencon_inst.operand2\[9\]
+ sky130_fd_sc_hd__dfrtp_2
X_1433_ net412 _0601_ vssd1 vssd1 vccd1 vccd1 _0073_ sky130_fd_sc_hd__xor2_1
X_1364_ CALC_INST.gencon_inst.operand1\[10\] CALC_INST.gencon_inst.operand1\[11\]
+ _0541_ vssd1 vssd1 vccd1 vccd1 _0548_ sky130_fd_sc_hd__and3_1
X_1295_ net149 net148 _0489_ vssd1 vssd1 vccd1 vccd1 _0490_ sky130_fd_sc_hd__and3b_2
XTAP_TAPCELL_ROW_38_404 vssd1 vccd1 sky130_fd_sc_hd__tapvpwrvgnd_1
XFILLER_23_169 vssd1 vssd1 vccd1 vccd1 sky130_fd_sc_hd__fill_1
XFILLER_23_136 vssd1 vssd1 vccd1 vccd1 sky130_fd_sc_hd__fill_1
X_2818_ clknet_leaf_2_clk CALC_INST.input_ctrl_inst.next_state\[0\] net86 vssd1 vssd1
+ vccd1 vccd1 CALC_INST.input_ctrl_inst.input_control_state\[0\] sky130_fd_sc_hd__dfrtp_4
X_2749_ clknet_leaf_33_clk _0308_ net88 vssd1 vssd1 vccd1 vccd1 CALC_INST.gencon_inst.mult_calc.countSave\[2\]
+ sky130_fd_sc_hd__dfrtp_1
XFILLER_61_209 vssd1 vssd1 vccd1 vccd1 sky130_fd_sc_hd__fill_1
XFILLER_54_272 vssd1 vssd1 vccd1 vccd1 sky130_fd_sc_hd__fill_8
XFILLER_60_297 vssd1 vssd1 vccd1 vccd1 sky130_fd_sc_hd__fill_1
XFILLER_60_253 vssd1 vssd1 vccd1 vccd1 sky130_fd_sc_hd__fill_1
X_1982_ _0859_ _0862_ _0929_ _0932_ vssd1 vssd1 vccd1 vccd1 _0933_ sky130_fd_sc_hd__o31a_1
XTAP_TAPCELL_ROW_43_440 vssd1 vccd1 sky130_fd_sc_hd__tapvpwrvgnd_1
XFILLER_20_139 vssd1 vssd1 vccd1 vccd1 sky130_fd_sc_hd__fill_1
X_2603_ clknet_leaf_31_clk _0162_ vssd1 vssd1 vccd1 vccd1 CALC_INST.gencon_inst.mult_calc.INn1\[3\]
+ sky130_fd_sc_hd__dfxtp_1
X_2534_ clknet_leaf_35_clk _0093_ net81 vssd1 vssd1 vccd1 vccd1 CALC_INST.input_ctrl_inst.col_index\[31\]
+ sky130_fd_sc_hd__dfrtp_1
X_1347_ _0533_ _0534_ vssd1 vssd1 vccd1 vccd1 _0535_ sky130_fd_sc_hd__nor2_1
X_2465_ net54 _0433_ _0434_ net49 CALC_INST.gencon_inst.mult_calc.out\[1\] vssd1 vssd1
+ vccd1 vccd1 _0435_ sky130_fd_sc_hd__a32o_1
XANTENNA__2322__A2 CALC_INST.input_ctrl_inst.key_pressed vssd1 vssd1 vccd1 vccd1 sky130_fd_sc_hd__diode_2
X_1416_ net476 _0590_ vssd1 vssd1 vccd1 vccd1 _0067_ sky130_fd_sc_hd__xor2_1
XFILLER_5_390 vssd1 vssd1 vccd1 vccd1 sky130_fd_sc_hd__fill_2
X_2396_ CALC_INST.input_ctrl_inst.col_index\[9\] CALC_INST.input_ctrl_inst.col_index\[8\]
+ CALC_INST.input_ctrl_inst.col_index\[11\] CALC_INST.input_ctrl_inst.col_index\[10\]
+ vssd1 vssd1 vccd1 vccd1 _1224_ sky130_fd_sc_hd__or4_1
X_1278_ CALC_INST.gencon_inst.operand2\[12\] _0472_ vssd1 vssd1 vccd1 vccd1 _0476_
+ sky130_fd_sc_hd__and2_1
XFILLER_22_35 vssd1 vssd1 vccd1 vccd1 sky130_fd_sc_hd__fill_2
XFILLER_0_6 vssd1 vssd1 vccd1 vccd1 sky130_fd_sc_hd__fill_8
Xfanout152 CALC_INST.gencon_inst.add_calc.state\[2\] vssd1 vssd1 vccd1 vccd1 net152
+ sky130_fd_sc_hd__clkbuf_4
Xfanout130 net132 vssd1 vssd1 vccd1 vccd1 net130 sky130_fd_sc_hd__buf_2
Xfanout141 CALC_INST.gencon_inst.mult_calc.state\[2\] vssd1 vssd1 vccd1 vccd1 net141
+ sky130_fd_sc_hd__clkbuf_4
XFILLER_63_31 vssd1 vssd1 vccd1 vccd1 sky130_fd_sc_hd__fill_1
XANTENNA__1588__B1 _0656_ vssd1 vssd1 vccd1 vccd1 sky130_fd_sc_hd__diode_2
XTAP_TAPCELL_ROW_40_421 vssd1 vccd1 sky130_fd_sc_hd__tapvpwrvgnd_1
XFILLER_40_7 vssd1 vssd1 vccd1 vccd1 sky130_fd_sc_hd__fill_4
X_2250_ CALC_INST.gencon_inst.mult_calc.compCount.in2\[3\] _1105_ _1107_ CALC_INST.gencon_inst.mult_calc.compCount.in2\[4\]
+ vssd1 vssd1 vccd1 vccd1 _1108_ sky130_fd_sc_hd__o22a_1
X_2181_ CALC_INST.input_ctrl_inst.scan_timer\[17\] CALC_INST.input_ctrl_inst.scan_timer\[16\]
+ _1043_ vssd1 vssd1 vccd1 vccd1 _1045_ sky130_fd_sc_hd__and3_1
XTAP_TAPCELL_ROW_63_579 vssd1 vccd1 sky130_fd_sc_hd__tapvpwrvgnd_1
X_1965_ _0898_ _0902_ _0914_ _0899_ vssd1 vssd1 vccd1 vccd1 _0916_ sky130_fd_sc_hd__o31a_1
XANTENNA_fanout106_A net112 vssd1 vssd1 vccd1 vccd1 sky130_fd_sc_hd__diode_2
X_1896_ CALC_INST.gencon_inst.mult_calc.out\[10\] net439 net144 vssd1 vssd1 vccd1
+ vccd1 _0283_ sky130_fd_sc_hd__mux2_1
X_2517_ clknet_leaf_3_clk _0076_ net85 vssd1 vssd1 vccd1 vccd1 CALC_INST.input_ctrl_inst.col_index\[14\]
+ sky130_fd_sc_hd__dfrtp_1
XFILLER_56_356 vssd1 vssd1 vccd1 vccd1 sky130_fd_sc_hd__fill_1
XFILLER_56_334 vssd1 vssd1 vccd1 vccd1 sky130_fd_sc_hd__fill_1
X_2448_ CALC_INST.gencon_inst.gencon_state\[0\] _0417_ vssd1 vssd1 vccd1 vccd1 _0419_
+ sky130_fd_sc_hd__or2_1
X_2379_ _1070_ _1210_ _1211_ vssd1 vssd1 vccd1 vccd1 _0013_ sky130_fd_sc_hd__a21oi_1
XFILLER_24_253 vssd1 vssd1 vccd1 vccd1 sky130_fd_sc_hd__fill_2
XFILLER_59_150 vssd1 vssd1 vccd1 vccd1 sky130_fd_sc_hd__fill_4
XFILLER_47_301 vssd1 vssd1 vccd1 vccd1 sky130_fd_sc_hd__fill_2
Xhold8 CALC_INST.gencon_inst.mult_calc.INn1\[4\] vssd1 vssd1 vccd1 vccd1 net207 sky130_fd_sc_hd__dlygate4sd3_1
XFILLER_30_267 vssd1 vssd1 vccd1 vccd1 sky130_fd_sc_hd__fill_1
XFILLER_30_212 vssd1 vssd1 vccd1 vccd1 sky130_fd_sc_hd__fill_1
X_1750_ CALC_INST.gencon_inst.mult_calc.main.GENERATE_ADDER\[1\].thingy.in2 CALC_INST.gencon_inst.mult_calc.main.GENERATE_ADDER\[1\].thingy.in1
+ vssd1 vssd1 vccd1 vccd1 _0779_ sky130_fd_sc_hd__nor2_1
XFILLER_15_231 vssd1 vssd1 vccd1 vccd1 sky130_fd_sc_hd__fill_1
XTAP_TAPCELL_ROW_17_259 vssd1 vccd1 sky130_fd_sc_hd__tapvpwrvgnd_1
X_1681_ net411 _0740_ net152 vssd1 vssd1 vccd1 vccd1 _0182_ sky130_fd_sc_hd__mux2_1
X_2164_ net374 _1032_ _1035_ _1022_ vssd1 vssd1 vccd1 vccd1 _0370_ sky130_fd_sc_hd__o211a_1
XFILLER_38_301 vssd1 vssd1 vccd1 vccd1 sky130_fd_sc_hd__fill_1
X_2302_ CALC_INST.input_ctrl_inst.col_index\[0\] CALC_INST.input_ctrl_inst.key_pressed
+ _1078_ vssd1 vssd1 vccd1 vccd1 _1153_ sky130_fd_sc_hd__a21o_1
XANTENNA__1492__A net51 vssd1 vssd1 vccd1 vccd1 sky130_fd_sc_hd__diode_2
X_2233_ CALC_INST.gencon_inst.mult_calc.count.GENERATE_ADDER\[6\].thingy.in1 CALC_INST.gencon_inst.mult_calc.count.GENERATE_ADDER\[5\].thingy.in1
+ CALC_INST.gencon_inst.mult_calc.count.GENERATE_ADDER\[4\].thingy.in1 _1089_ vssd1
+ vssd1 vccd1 vccd1 _1091_ sky130_fd_sc_hd__and4_1
XFILLER_53_337 vssd1 vssd1 vccd1 vccd1 sky130_fd_sc_hd__fill_4
XFILLER_38_389 vssd1 vssd1 vccd1 vccd1 sky130_fd_sc_hd__fill_2
XFILLER_38_367 vssd1 vssd1 vccd1 vccd1 sky130_fd_sc_hd__fill_2
X_2095_ net398 net42 net35 CALC_INST.gencon_inst.operand2\[13\] vssd1 vssd1 vccd1
+ vccd1 _0334_ sky130_fd_sc_hd__a22o_1
XTAP_TAPCELL_ROW_0_138 vssd1 vccd1 sky130_fd_sc_hd__tapvpwrvgnd_1
X_1948_ CALC_INST.gencon_inst.add_calc.main.GENERATE_ADDER\[4\].thingy.in1 _0896_
+ _0897_ vssd1 vssd1 vccd1 vccd1 _0899_ sky130_fd_sc_hd__nand3_1
X_1879_ net135 net421 net124 net427 vssd1 vssd1 vccd1 vccd1 _0266_ sky130_fd_sc_hd__a22o_1
XFILLER_9_91 vssd1 vssd1 vccd1 vccd1 sky130_fd_sc_hd__fill_1
XFILLER_0_149 vssd1 vssd1 vccd1 vccd1 sky130_fd_sc_hd__fill_1
XFILLER_56_186 vssd1 vssd1 vccd1 vccd1 sky130_fd_sc_hd__fill_1
XFILLER_56_153 vssd1 vssd1 vccd1 vccd1 sky130_fd_sc_hd__fill_1
XFILLER_44_326 vssd1 vssd1 vccd1 vccd1 sky130_fd_sc_hd__fill_2
XFILLER_28_56 vssd1 vssd1 vccd1 vccd1 sky130_fd_sc_hd__fill_1
XFILLER_44_44 vssd1 vssd1 vccd1 vccd1 sky130_fd_sc_hd__fill_4
XANTENNA_clkbuf_leaf_22_clk_A clknet_2_3__leaf_clk vssd1 vssd1 vccd1 vccd1 sky130_fd_sc_hd__diode_2
XTAP_TAPCELL_ROW_22_295 vssd1 vccd1 sky130_fd_sc_hd__tapvpwrvgnd_1
XFILLER_4_400 vssd1 vssd1 vccd1 vccd1 sky130_fd_sc_hd__fill_4
Xclkbuf_2_3__f_clk clknet_0_clk vssd1 vssd1 vccd1 vccd1 clknet_2_3__leaf_clk sky130_fd_sc_hd__clkbuf_16
XFILLER_35_337 vssd1 vssd1 vccd1 vccd1 sky130_fd_sc_hd__fill_1
X_2851_ clknet_leaf_8_clk _0366_ vssd1 vssd1 vccd1 vccd1 CALC_INST.input_ctrl_inst.scan_timer\[5\]
+ sky130_fd_sc_hd__dfxtp_1
X_1733_ _0766_ _0768_ vssd1 vssd1 vccd1 vccd1 _0206_ sky130_fd_sc_hd__xnor2_1
X_2782_ clknet_leaf_24_clk _0332_ vssd1 vssd1 vccd1 vccd1 CALC_INST.gencon_inst.mult_calc.INn2\[11\]
+ sky130_fd_sc_hd__dfxtp_1
X_1802_ _0821_ _0823_ vssd1 vssd1 vccd1 vccd1 _0824_ sky130_fd_sc_hd__xnor2_1
Xhold227 CALC_INST.gencon_inst.add_calc.main.GENERATE_ADDER\[12\].thingy.in1 vssd1
+ vssd1 vccd1 vccd1 net426 sky130_fd_sc_hd__dlygate4sd3_1
X_1664_ net317 net353 _0730_ vssd1 vssd1 vccd1 vccd1 _0175_ sky130_fd_sc_hd__mux2_1
Xhold249 CALC_INST.gencon_inst.add_calc.main.GENERATE_ADDER\[7\].thingy.in1 vssd1
+ vssd1 vccd1 vccd1 net448 sky130_fd_sc_hd__dlygate4sd3_1
X_1595_ CALC_INST.gencon_inst.operator_input\[1\] _0653_ vssd1 vssd1 vccd1 vccd1 _0719_
+ sky130_fd_sc_hd__nand2_1
Xhold238 CALC_INST.gencon_inst.mult_calc.INn2\[4\] vssd1 vssd1 vccd1 vccd1 net437
+ sky130_fd_sc_hd__dlygate4sd3_1
Xhold205 CALC_INST.gencon_inst.mult_calc.INn2\[14\] vssd1 vssd1 vccd1 vccd1 net404
+ sky130_fd_sc_hd__dlygate4sd3_1
Xhold216 CALC_INST.gencon_inst.mult_calc.main.GENERATE_ADDER\[6\].thingy.in2 vssd1
+ vssd1 vccd1 vccd1 net415 sky130_fd_sc_hd__dlygate4sd3_1
X_2147_ CALC_INST.input_ctrl_inst.scan_timer\[1\] CALC_INST.input_ctrl_inst.scan_timer\[3\]
+ CALC_INST.input_ctrl_inst.scan_timer\[2\] net58 vssd1 vssd1 vccd1 vccd1 _1025_ sky130_fd_sc_hd__and4_1
XFILLER_38_197 vccd1 vssd1 vccd1 vssd1 sky130_ef_sc_hd__decap_40_12
X_2216_ CALC_INST.input_ctrl_inst.key_pressed _1073_ vssd1 vssd1 vccd1 vccd1 _1075_
+ sky130_fd_sc_hd__nor2_1
X_2078_ net128 _1134_ net130 net311 vssd1 vssd1 vccd1 vccd1 _0319_ sky130_fd_sc_hd__a2bb2o_1
XANTENNA_fanout86_A net93 vssd1 vssd1 vccd1 vccd1 sky130_fd_sc_hd__diode_2
XFILLER_1_403 vssd1 vssd1 vccd1 vccd1 sky130_fd_sc_hd__fill_1
XFILLER_32_307 vssd1 vssd1 vccd1 vccd1 sky130_fd_sc_hd__fill_1
XFILLER_29_131 vssd1 vssd1 vccd1 vccd1 sky130_fd_sc_hd__fill_1
XTAP_TAPCELL_ROW_27_332 vssd1 vccd1 sky130_fd_sc_hd__tapvpwrvgnd_1
XFILLER_17_315 vssd1 vssd1 vccd1 vccd1 sky130_fd_sc_hd__fill_1
XFILLER_17_337 vccd1 vssd1 vccd1 vssd1 sky130_ef_sc_hd__decap_40_12
XTAP_TAPCELL_ROW_10_210 vssd1 vccd1 sky130_fd_sc_hd__tapvpwrvgnd_1
X_1380_ _0560_ _0490_ _0559_ vssd1 vssd1 vccd1 vccd1 _0561_ sky130_fd_sc_hd__and3b_1
X_2001_ _0939_ _0942_ _0946_ vssd1 vssd1 vccd1 vccd1 _0949_ sky130_fd_sc_hd__or3_1
XANTENNA__1467__A2 _0578_ vssd1 vssd1 vccd1 vccd1 sky130_fd_sc_hd__diode_2
XTAP_TAPCELL_ROW_33_368 vssd1 vccd1 sky130_fd_sc_hd__tapvpwrvgnd_1
X_1716_ CALC_INST.gencon_inst.ALU_in1\[9\] CALC_INST.gencon_inst.ALU_in2\[9\] net60
+ vssd1 vssd1 vccd1 vccd1 _0758_ sky130_fd_sc_hd__mux2_1
XFILLER_31_373 vssd1 vssd1 vccd1 vccd1 sky130_fd_sc_hd__fill_2
X_2696_ clknet_leaf_25_clk _0255_ net110 vssd1 vssd1 vccd1 vccd1 CALC_INST.gencon_inst.mult_calc.main.GENERATE_ADDER\[13\].thingy.in1
+ sky130_fd_sc_hd__dfrtp_1
XFILLER_6_70 vssd1 vssd1 vccd1 vccd1 sky130_fd_sc_hd__fill_4
X_2834_ clknet_leaf_32_clk _0010_ net87 vssd1 vssd1 vccd1 vccd1 CALC_INST.input_ctrl_inst.debounce_cnt\[11\]
+ sky130_fd_sc_hd__dfrtp_1
X_2765_ clknet_leaf_32_clk _0003_ net89 vssd1 vssd1 vccd1 vccd1 CALC_INST.gencon_inst.mult_calc.state\[3\]
+ sky130_fd_sc_hd__dfrtp_1
X_1578_ CALC_INST.gencon_inst.operand1\[15\] _0560_ _0491_ vssd1 vssd1 vccd1 vccd1
+ _0708_ sky130_fd_sc_hd__a21oi_1
X_1647_ net210 _0663_ net43 vssd1 vssd1 vccd1 vccd1 _0160_ sky130_fd_sc_hd__mux2_1
XFILLER_26_189 vssd1 vssd1 vccd1 vccd1 sky130_fd_sc_hd__fill_1
XFILLER_26_101 vssd1 vssd1 vccd1 vccd1 sky130_fd_sc_hd__fill_1
XANTENNA__2104__B1 net122 vssd1 vssd1 vccd1 vccd1 sky130_fd_sc_hd__diode_2
XFILLER_25_57 vssd1 vssd1 vccd1 vccd1 sky130_fd_sc_hd__fill_2
XFILLER_1_211 vssd1 vssd1 vccd1 vccd1 sky130_fd_sc_hd__fill_1
XFILLER_1_222 vssd1 vssd1 vccd1 vccd1 sky130_fd_sc_hd__fill_2
XFILLER_9_3 vssd1 vssd1 vccd1 vccd1 sky130_fd_sc_hd__fill_8
XFILLER_64_229 vssd1 vssd1 vccd1 vccd1 sky130_fd_sc_hd__fill_2
XFILLER_57_281 vccd1 vssd1 vccd1 vssd1 sky130_ef_sc_hd__decap_40_12
XFILLER_1_277 vssd1 vssd1 vccd1 vccd1 sky130_fd_sc_hd__fill_2
XFILLER_32_137 vssd1 vssd1 vccd1 vccd1 sky130_fd_sc_hd__fill_1
X_2550_ clknet_leaf_21_clk _0109_ net117 vssd1 vssd1 vccd1 vccd1 net19 sky130_fd_sc_hd__dfrtp_1
XTAP_TAPCELL_ROW_30_349 vssd1 vccd1 sky130_fd_sc_hd__tapvpwrvgnd_1
XFILLER_9_355 vssd1 vssd1 vccd1 vccd1 sky130_fd_sc_hd__fill_2
XFILLER_9_399 vssd1 vssd1 vccd1 vccd1 sky130_fd_sc_hd__fill_2
X_1363_ CALC_INST.gencon_inst.operand1\[10\] net47 _0546_ _0547_ vssd1 vssd1 vccd1
+ vccd1 _0057_ sky130_fd_sc_hd__o22a_1
X_1501_ CALC_INST.gencon_inst.operator_input\[0\] CALC_INST.gencon_inst.key_read _0648_
+ net73 vssd1 vssd1 vccd1 vccd1 _0649_ sky130_fd_sc_hd__a31oi_1
X_2481_ clknet_leaf_23_clk _0040_ net114 vssd1 vssd1 vccd1 vccd1 CALC_INST.gencon_inst.operand2\[8\]
+ sky130_fd_sc_hd__dfrtp_1
X_1432_ _0600_ _0601_ vssd1 vssd1 vccd1 vccd1 _0072_ sky130_fd_sc_hd__nor2_1
XTAP_TAPCELL_ROW_46_460 vssd1 vccd1 sky130_fd_sc_hd__tapvpwrvgnd_1
XPHY_EDGE_ROW_43_Left_108 vssd1 vssd1 vccd1 vccd1 sky130_fd_sc_hd__decap_3
X_1294_ CALC_INST.gencon_inst.gencon_state\[3\] CALC_INST.gencon_inst.gencon_state\[2\]
+ vssd1 vssd1 vccd1 vccd1 _0489_ sky130_fd_sc_hd__nor2_1
XTAP_TAPCELL_ROW_38_405 vssd1 vccd1 sky130_fd_sc_hd__tapvpwrvgnd_1
XFILLER_31_192 vssd1 vssd1 vccd1 vccd1 sky130_fd_sc_hd__fill_2
XPHY_EDGE_ROW_52_Left_117 vssd1 vssd1 vccd1 vccd1 sky130_fd_sc_hd__decap_3
X_2817_ clknet_leaf_6_clk _0359_ vssd1 vssd1 vccd1 vccd1 CALC_INST.gencon_inst.operator_input\[2\]
+ sky130_fd_sc_hd__dfxtp_1
X_2748_ clknet_leaf_33_clk _0307_ net88 vssd1 vssd1 vccd1 vccd1 CALC_INST.gencon_inst.mult_calc.countSave\[1\]
+ sky130_fd_sc_hd__dfrtp_1
X_2679_ clknet_leaf_28_clk _0238_ net107 vssd1 vssd1 vccd1 vccd1 CALC_INST.gencon_inst.mult_calc.compCount.in2\[11\]
+ sky130_fd_sc_hd__dfrtp_1
XPHY_EDGE_ROW_61_Left_126 vssd1 vssd1 vccd1 vccd1 sky130_fd_sc_hd__decap_3
XFILLER_54_262 vssd1 vssd1 vccd1 vccd1 sky130_fd_sc_hd__fill_1
XANTENNA__2442__B1_N CALC_INST.gencon_inst.mult_calc.start vssd1 vssd1 vccd1 vccd1
+ sky130_fd_sc_hd__diode_2
XANTENNA__2095__A2 net42 vssd1 vssd1 vccd1 vccd1 sky130_fd_sc_hd__diode_2
X_1981_ _1059_ _0931_ vssd1 vssd1 vccd1 vccd1 _0932_ sky130_fd_sc_hd__nor2_1
XTAP_TAPCELL_ROW_43_441 vssd1 vccd1 sky130_fd_sc_hd__tapvpwrvgnd_1
X_2602_ clknet_leaf_31_clk _0161_ vssd1 vssd1 vccd1 vccd1 CALC_INST.gencon_inst.mult_calc.INn1\[2\]
+ sky130_fd_sc_hd__dfxtp_1
X_2533_ clknet_leaf_35_clk _0092_ net81 vssd1 vssd1 vccd1 vccd1 CALC_INST.input_ctrl_inst.col_index\[30\]
+ sky130_fd_sc_hd__dfrtp_1
X_1346_ CALC_INST.gencon_inst.operand1\[7\] _0529_ _0490_ vssd1 vssd1 vccd1 vccd1
+ _0534_ sky130_fd_sc_hd__o21ai_1
X_2464_ _0430_ _0431_ _0427_ vssd1 vssd1 vccd1 vccd1 _0434_ sky130_fd_sc_hd__o21ai_1
X_1415_ _0589_ _0590_ vssd1 vssd1 vccd1 vccd1 _0066_ sky130_fd_sc_hd__nor2_1
X_2395_ CALC_INST.input_ctrl_inst.col_index\[13\] CALC_INST.input_ctrl_inst.col_index\[12\]
+ CALC_INST.input_ctrl_inst.col_index\[15\] CALC_INST.input_ctrl_inst.col_index\[14\]
+ vssd1 vssd1 vccd1 vccd1 _1223_ sky130_fd_sc_hd__or4_1
XANTENNA__2086__A2 net42 vssd1 vssd1 vccd1 vccd1 sky130_fd_sc_hd__diode_2
X_1277_ CALC_INST.gencon_inst.operand2\[11\] _0475_ net37 vssd1 vssd1 vccd1 vccd1
+ _0043_ sky130_fd_sc_hd__mux2_1
Xclkbuf_leaf_31_clk clknet_2_2__leaf_clk vssd1 vssd1 vccd1 vccd1 clknet_leaf_31_clk
+ sky130_fd_sc_hd__clkbuf_8
Xfanout120 net121 vssd1 vssd1 vccd1 vccd1 net120 sky130_fd_sc_hd__buf_2
XANTENNA_clkbuf_2_1__f_clk_X clknet_2_1__leaf_clk vssd1 vssd1 vccd1 vccd1 sky130_fd_sc_hd__diode_2
Xfanout131 net132 vssd1 vssd1 vccd1 vccd1 net131 sky130_fd_sc_hd__clkbuf_2
Xfanout153 CALC_INST.gencon_inst.add_calc.state\[2\] vssd1 vssd1 vccd1 vccd1 net153
+ sky130_fd_sc_hd__buf_2
XFILLER_47_99 vssd1 vssd1 vccd1 vccd1 sky130_fd_sc_hd__fill_4
XFILLER_47_22 vssd1 vssd1 vccd1 vccd1 sky130_fd_sc_hd__fill_2
Xfanout142 CALC_INST.gencon_inst.mult_calc.state\[2\] vssd1 vssd1 vccd1 vccd1 net142
+ sky130_fd_sc_hd__buf_2
XFILLER_63_54 vssd1 vssd1 vccd1 vccd1 sky130_fd_sc_hd__fill_2
XFILLER_63_21 vssd1 vssd1 vccd1 vccd1 sky130_fd_sc_hd__fill_8
Xclkbuf_leaf_22_clk clknet_2_3__leaf_clk vssd1 vssd1 vccd1 vccd1 clknet_leaf_22_clk
+ sky130_fd_sc_hd__clkbuf_8
XTAP_TAPCELL_ROW_40_422 vssd1 vccd1 sky130_fd_sc_hd__tapvpwrvgnd_1
XFILLER_30_405 vssd1 vssd1 vccd1 vccd1 sky130_fd_sc_hd__fill_2
XFILLER_8_27 vssd1 vssd1 vccd1 vccd1 sky130_fd_sc_hd__fill_1
X_2180_ net296 _1043_ vssd1 vssd1 vccd1 vccd1 _0377_ sky130_fd_sc_hd__xor2_1
XFILLER_2_361 vssd1 vssd1 vccd1 vccd1 sky130_fd_sc_hd__fill_2
XANTENNA__1760__B2 net141 vssd1 vssd1 vccd1 vccd1 sky130_fd_sc_hd__diode_2
XFILLER_18_251 vssd1 vssd1 vccd1 vccd1 sky130_fd_sc_hd__fill_1
X_1964_ _0902_ _0914_ vssd1 vssd1 vccd1 vccd1 _0915_ sky130_fd_sc_hd__nor2_1
Xclkbuf_leaf_13_clk clknet_2_1__leaf_clk vssd1 vssd1 vccd1 vccd1 clknet_leaf_13_clk
+ sky130_fd_sc_hd__clkbuf_8
XFILLER_33_276 vssd1 vssd1 vccd1 vccd1 sky130_fd_sc_hd__fill_4
X_1895_ CALC_INST.gencon_inst.mult_calc.out\[9\] net379 net144 vssd1 vssd1 vccd1 vccd1
+ _0282_ sky130_fd_sc_hd__mux2_1
X_2447_ net149 _0417_ vssd1 vssd1 vccd1 vccd1 _0418_ sky130_fd_sc_hd__nor2_1
XFILLER_0_309 vccd1 vssd1 vccd1 vssd1 sky130_ef_sc_hd__decap_40_12
X_2516_ clknet_leaf_32_clk _0075_ net82 vssd1 vssd1 vccd1 vccd1 CALC_INST.input_ctrl_inst.col_index\[13\]
+ sky130_fd_sc_hd__dfrtp_1
X_1329_ CALC_INST.gencon_inst.operand1\[3\] net47 _0519_ _0520_ vssd1 vssd1 vccd1
+ vccd1 _0050_ sky130_fd_sc_hd__o22a_1
X_2378_ _1072_ _1205_ _1208_ _1167_ _1069_ vssd1 vssd1 vccd1 vccd1 _1211_ sky130_fd_sc_hd__o221a_1
XTAP_TAPCELL_ROW_3_158 vssd1 vccd1 sky130_fd_sc_hd__tapvpwrvgnd_1
XFILLER_33_57 vssd1 vssd1 vccd1 vccd1 sky130_fd_sc_hd__fill_4
XFILLER_24_276 vssd1 vssd1 vccd1 vccd1 sky130_fd_sc_hd__fill_4
XFILLER_59_173 vssd1 vssd1 vccd1 vccd1 sky130_fd_sc_hd__fill_2
XFILLER_59_140 vssd1 vssd1 vccd1 vccd1 sky130_fd_sc_hd__fill_8
XANTENNA_fanout71_X net71 vssd1 vssd1 vccd1 vccd1 sky130_fd_sc_hd__diode_2
Xhold9 CALC_INST.gencon_inst.mult_calc.main.GENERATE_ADDER\[4\].thingy.in1 vssd1 vssd1
+ vccd1 vccd1 net208 sky130_fd_sc_hd__dlygate4sd3_1
XFILLER_59_184 vssd1 vssd1 vccd1 vccd1 sky130_fd_sc_hd__fill_1
XFILLER_15_221 vssd1 vssd1 vccd1 vccd1 sky130_fd_sc_hd__fill_2
XFILLER_30_246 vssd1 vssd1 vccd1 vccd1 sky130_fd_sc_hd__fill_4
XFILLER_15_265 vssd1 vssd1 vccd1 vccd1 sky130_fd_sc_hd__fill_2
X_1680_ CALC_INST.gencon_inst.ALU_in2\[6\] CALC_INST.gencon_inst.ALU_in1\[6\] net62
+ vssd1 vssd1 vccd1 vccd1 _0740_ sky130_fd_sc_hd__mux2_1
X_2301_ net348 _1152_ _1149_ vssd1 vssd1 vccd1 vccd1 _0031_ sky130_fd_sc_hd__o21a_1
XFILLER_53_305 vssd1 vssd1 vccd1 vccd1 sky130_fd_sc_hd__fill_2
X_2163_ _1034_ vssd1 vssd1 vccd1 vccd1 _1035_ sky130_fd_sc_hd__inv_2
Xclkbuf_leaf_2_clk clknet_2_0__leaf_clk vssd1 vssd1 vccd1 vccd1 clknet_leaf_2_clk
+ sky130_fd_sc_hd__clkbuf_8
X_2232_ CALC_INST.gencon_inst.mult_calc.count.GENERATE_ADDER\[4\].thingy.in1 _1089_
+ vssd1 vssd1 vccd1 vccd1 _1090_ sky130_fd_sc_hd__nand2_1
XFILLER_61_371 vssd1 vssd1 vccd1 vccd1 sky130_fd_sc_hd__fill_1
X_2094_ net428 net42 net34 CALC_INST.gencon_inst.operand2\[12\] vssd1 vssd1 vccd1
+ vccd1 _0333_ sky130_fd_sc_hd__a22o_1
XFILLER_0_83 vssd1 vssd1 vccd1 vccd1 sky130_fd_sc_hd__fill_1
XTAP_TAPCELL_ROW_0_139 vssd1 vccd1 sky130_fd_sc_hd__tapvpwrvgnd_1
X_1947_ _0896_ _0897_ CALC_INST.gencon_inst.add_calc.main.GENERATE_ADDER\[4\].thingy.in1
+ vssd1 vssd1 vccd1 vccd1 _0898_ sky130_fd_sc_hd__a21oi_1
X_1878_ net133 net321 net122 net333 vssd1 vssd1 vccd1 vccd1 _0265_ sky130_fd_sc_hd__a22o_1
XFILLER_0_117 vssd1 vssd1 vccd1 vccd1 sky130_fd_sc_hd__fill_2
XFILLER_44_12 vssd1 vssd1 vccd1 vccd1 sky130_fd_sc_hd__fill_8
XFILLER_28_24 vssd1 vssd1 vccd1 vccd1 sky130_fd_sc_hd__fill_4
XTAP_TAPCELL_ROW_22_296 vssd1 vccd1 sky130_fd_sc_hd__tapvpwrvgnd_1
XFILLER_5_28 vssd1 vssd1 vccd1 vccd1 sky130_fd_sc_hd__fill_1
XANTENNA__1532__S net74 vssd1 vssd1 vccd1 vccd1 sky130_fd_sc_hd__diode_2
XPHY_EDGE_ROW_8_Left_73 vssd1 vssd1 vccd1 vccd1 sky130_fd_sc_hd__decap_3
XFILLER_62_135 vssd1 vssd1 vccd1 vccd1 sky130_fd_sc_hd__fill_4
X_2850_ clknet_leaf_8_clk _0365_ vssd1 vssd1 vccd1 vccd1 CALC_INST.input_ctrl_inst.scan_timer\[4\]
+ sky130_fd_sc_hd__dfxtp_1
X_1663_ net150 net154 vssd1 vssd1 vccd1 vccd1 _0730_ sky130_fd_sc_hd__or2_1
X_1732_ _0654_ _0767_ vssd1 vssd1 vccd1 vccd1 _0768_ sky130_fd_sc_hd__nand2_1
X_2781_ clknet_leaf_24_clk _0331_ vssd1 vssd1 vccd1 vccd1 CALC_INST.gencon_inst.mult_calc.INn2\[10\]
+ sky130_fd_sc_hd__dfxtp_1
X_1801_ _0814_ _0822_ vssd1 vssd1 vccd1 vccd1 _0823_ sky130_fd_sc_hd__or2_1
Xhold206 CALC_INST.input_ctrl_inst.debounce_cnt\[6\] vssd1 vssd1 vccd1 vccd1 net405
+ sky130_fd_sc_hd__dlygate4sd3_1
XTAP_TAPCELL_ROW_13_230 vssd1 vccd1 sky130_fd_sc_hd__tapvpwrvgnd_1
Xhold217 _0264_ vssd1 vssd1 vccd1 vccd1 net416 sky130_fd_sc_hd__dlygate4sd3_1
X_1594_ net233 CALC_INST.gencon_inst.latched_keypad_input\[3\] _0713_ vssd1 vssd1
+ vccd1 vccd1 _0117_ sky130_fd_sc_hd__mux2_1
Xhold239 CALC_INST.gencon_inst.mult_calc.INn2\[9\] vssd1 vssd1 vccd1 vccd1 net438
+ sky130_fd_sc_hd__dlygate4sd3_1
Xhold228 CALC_INST.gencon_inst.mult_calc.main.GENERATE_ADDER\[8\].thingy.in2 vssd1
+ vssd1 vccd1 vccd1 net427 sky130_fd_sc_hd__dlygate4sd3_1
XPHY_EDGE_ROW_7_Right_7 vssd1 vssd1 vccd1 vccd1 sky130_fd_sc_hd__decap_3
X_2146_ net445 _1023_ vssd1 vssd1 vccd1 vccd1 _0363_ sky130_fd_sc_hd__xnor2_1
X_2215_ _1073_ vssd1 vssd1 vccd1 vccd1 _1074_ sky130_fd_sc_hd__inv_2
XFILLER_26_305 vssd1 vssd1 vccd1 vccd1 sky130_fd_sc_hd__fill_1
X_2077_ net128 _1131_ net130 net302 vssd1 vssd1 vccd1 vccd1 _0318_ sky130_fd_sc_hd__a2bb2o_1
XFILLER_41_319 vssd1 vssd1 vccd1 vccd1 sky130_fd_sc_hd__fill_8
XFILLER_14_15 vssd1 vssd1 vccd1 vccd1 sky130_fd_sc_hd__fill_2
XFILLER_14_48 vssd1 vssd1 vccd1 vccd1 sky130_fd_sc_hd__fill_2
XANTENNA_fanout121_X net121 vssd1 vssd1 vccd1 vccd1 sky130_fd_sc_hd__diode_2
XFILLER_30_69 vssd1 vssd1 vccd1 vccd1 sky130_fd_sc_hd__fill_1
XFILLER_39_78 vssd1 vssd1 vccd1 vccd1 sky130_fd_sc_hd__fill_2
XFILLER_55_55 vssd1 vssd1 vccd1 vccd1 sky130_fd_sc_hd__fill_1
XFILLER_44_135 vssd1 vssd1 vccd1 vccd1 sky130_fd_sc_hd__fill_1
XANTENNA_fanout34_X net34 vssd1 vssd1 vccd1 vccd1 sky130_fd_sc_hd__diode_2
XPHY_EDGE_ROW_34_Left_99 vssd1 vssd1 vccd1 vccd1 sky130_fd_sc_hd__decap_3
XFILLER_25_360 vssd1 vssd1 vccd1 vccd1 sky130_fd_sc_hd__fill_1
XFILLER_40_385 vssd1 vssd1 vccd1 vccd1 sky130_fd_sc_hd__fill_2
XFILLER_40_363 vssd1 vssd1 vccd1 vccd1 sky130_fd_sc_hd__fill_1
XTAP_TAPCELL_ROW_10_211 vssd1 vccd1 sky130_fd_sc_hd__tapvpwrvgnd_1
XFILLER_4_253 vssd1 vssd1 vccd1 vccd1 sky130_fd_sc_hd__fill_4
XFILLER_4_242 vssd1 vssd1 vccd1 vccd1 sky130_fd_sc_hd__fill_8
XFILLER_4_231 vssd1 vssd1 vccd1 vccd1 sky130_fd_sc_hd__fill_2
X_2000_ _0948_ _0947_ net471 net126 vssd1 vssd1 vccd1 vccd1 _0293_ sky130_fd_sc_hd__a2bb2o_1
XANTENNA__1872__B1 net122 vssd1 vssd1 vccd1 vccd1 sky130_fd_sc_hd__diode_2
XTAP_TAPCELL_ROW_33_369 vssd1 vccd1 sky130_fd_sc_hd__tapvpwrvgnd_1
XFILLER_23_308 vssd1 vssd1 vccd1 vccd1 sky130_fd_sc_hd__fill_1
X_2833_ clknet_leaf_32_clk _0009_ net88 vssd1 vssd1 vccd1 vccd1 CALC_INST.input_ctrl_inst.debounce_cnt\[10\]
+ sky130_fd_sc_hd__dfrtp_1
X_1715_ net399 _0757_ net152 vssd1 vssd1 vccd1 vccd1 _0199_ sky130_fd_sc_hd__mux2_1
X_2695_ clknet_leaf_25_clk _0254_ net110 vssd1 vssd1 vccd1 vccd1 CALC_INST.gencon_inst.mult_calc.main.GENERATE_ADDER\[12\].thingy.in1
+ sky130_fd_sc_hd__dfrtp_1
X_1646_ net212 _0657_ net43 vssd1 vssd1 vccd1 vccd1 _0159_ sky130_fd_sc_hd__mux2_1
XFILLER_6_93 vssd1 vssd1 vccd1 vccd1 sky130_fd_sc_hd__fill_4
X_2764_ clknet_leaf_30_clk _0007_ net103 vssd1 vssd1 vccd1 vccd1 CALC_INST.gencon_inst.mult_calc.state\[2\]
+ sky130_fd_sc_hd__dfrtp_1
X_1577_ net45 _0654_ _0706_ vssd1 vssd1 vccd1 vccd1 _0707_ sky130_fd_sc_hd__a21oi_1
XANTENNA_clkbuf_leaf_21_clk_A clknet_2_3__leaf_clk vssd1 vssd1 vccd1 vccd1 sky130_fd_sc_hd__diode_2
XANTENNA__2104__A1 net133 vssd1 vssd1 vccd1 vccd1 sky130_fd_sc_hd__diode_2
XTAP_TAPCELL_ROW_49_480 vssd1 vccd1 sky130_fd_sc_hd__tapvpwrvgnd_1
XANTENNA__1312__C1 net45 vssd1 vssd1 vccd1 vccd1 sky130_fd_sc_hd__diode_2
X_2129_ net230 _1004_ _1015_ _1003_ vssd1 vssd1 vccd1 vccd1 _0355_ sky130_fd_sc_hd__o211a_1
XFILLER_25_36 vssd1 vssd1 vccd1 vccd1 sky130_fd_sc_hd__fill_2
XFILLER_41_24 vssd1 vssd1 vccd1 vccd1 sky130_fd_sc_hd__fill_2
XFILLER_64_219 vssd1 vssd1 vccd1 vccd1 sky130_fd_sc_hd__fill_1
XFILLER_57_293 vssd1 vssd1 vccd1 vccd1 sky130_fd_sc_hd__fill_4
XFILLER_17_113 vssd1 vssd1 vccd1 vccd1 sky130_fd_sc_hd__fill_2
XFILLER_17_124 vssd1 vssd1 vccd1 vccd1 sky130_fd_sc_hd__fill_2
XFILLER_9_334 vssd1 vssd1 vccd1 vccd1 sky130_fd_sc_hd__fill_2
XFILLER_15_91 vssd1 vssd1 vccd1 vccd1 sky130_fd_sc_hd__fill_2
X_1500_ CALC_INST.gencon_inst.operator_input\[2\] CALC_INST.gencon_inst.operator_input\[1\]
+ vssd1 vssd1 vccd1 vccd1 _0648_ sky130_fd_sc_hd__nor2_1
X_2480_ clknet_leaf_23_clk _0039_ net113 vssd1 vssd1 vccd1 vccd1 CALC_INST.gencon_inst.operand2\[7\]
+ sky130_fd_sc_hd__dfrtp_2
XANTENNA__2213__Y CALC_INST.input_ctrl_inst.key_pressed vssd1 vssd1 vccd1 vccd1 sky130_fd_sc_hd__diode_2
XFILLER_9_345 vssd1 vssd1 vccd1 vccd1 sky130_fd_sc_hd__fill_2
XANTENNA__1542__C1 _0659_ vssd1 vssd1 vccd1 vccd1 sky130_fd_sc_hd__diode_2
X_1293_ _1054_ _0487_ vssd1 vssd1 vccd1 vccd1 _0488_ sky130_fd_sc_hd__nor2_1
X_1362_ CALC_INST.gencon_inst.ALU_out\[10\] net77 net70 CALC_INST.gencon_inst.mult_calc.out\[10\]
+ net46 vssd1 vssd1 vccd1 vccd1 _0547_ sky130_fd_sc_hd__a221o_1
Xteam_06_191 vssd1 vssd1 vccd1 vccd1 gpio_oeb[0] team_06_191/LO sky130_fd_sc_hd__conb_1
Xteam_06_180 vssd1 vssd1 vccd1 vccd1 team_06_180/HI gpio_oeb[28] sky130_fd_sc_hd__conb_1
X_1431_ CALC_INST.input_ctrl_inst.col_index\[9\] CALC_INST.input_ctrl_inst.col_index\[10\]
+ _0599_ vssd1 vssd1 vccd1 vccd1 _0601_ sky130_fd_sc_hd__and3_1
XTAP_TAPCELL_ROW_46_461 vssd1 vccd1 sky130_fd_sc_hd__tapvpwrvgnd_1
XTAP_TAPCELL_ROW_38_406 vssd1 vccd1 sky130_fd_sc_hd__tapvpwrvgnd_1
XFILLER_23_127 vssd1 vssd1 vccd1 vccd1 sky130_fd_sc_hd__fill_2
XANTENNA__2098__B1 net122 vssd1 vssd1 vccd1 vccd1 sky130_fd_sc_hd__diode_2
X_2816_ clknet_leaf_6_clk _0358_ vssd1 vssd1 vccd1 vccd1 CALC_INST.gencon_inst.operator_input\[1\]
+ sky130_fd_sc_hd__dfxtp_1
XANTENNA_fanout129_A net132 vssd1 vssd1 vccd1 vccd1 sky130_fd_sc_hd__diode_2
X_1629_ CALC_INST.gencon_inst.operand2\[8\] net263 net65 vssd1 vssd1 vccd1 vccd1 _0146_
+ sky130_fd_sc_hd__mux2_1
X_2747_ clknet_leaf_33_clk _0306_ net88 vssd1 vssd1 vccd1 vccd1 CALC_INST.gencon_inst.mult_calc.countSave\[0\]
+ sky130_fd_sc_hd__dfrtp_1
XFILLER_11_49 vssd1 vssd1 vccd1 vccd1 sky130_fd_sc_hd__fill_4
X_2678_ clknet_leaf_28_clk _0237_ net107 vssd1 vssd1 vccd1 vccd1 CALC_INST.gencon_inst.mult_calc.compCount.in2\[10\]
+ sky130_fd_sc_hd__dfrtp_1
XANTENNA_input3_A gpio_in[1] vssd1 vssd1 vccd1 vccd1 sky130_fd_sc_hd__diode_2
XFILLER_52_78 vssd1 vssd1 vccd1 vccd1 sky130_fd_sc_hd__fill_4
XFILLER_45_263 vssd1 vssd1 vccd1 vccd1 sky130_fd_sc_hd__fill_1
XANTENNA__2650__RESET_B net99 vssd1 vssd1 vccd1 vccd1 sky130_fd_sc_hd__diode_2
XANTENNA__1540__S net74 vssd1 vssd1 vccd1 vccd1 sky130_fd_sc_hd__diode_2
X_1980_ CALC_INST.gencon_inst.add_calc.main.GENERATE_ADDER\[14\].thingy.in1 _0857_
+ _0858_ vssd1 vssd1 vccd1 vccd1 _0931_ sky130_fd_sc_hd__and3_1
XTAP_TAPCELL_ROW_43_442 vssd1 vccd1 sky130_fd_sc_hd__tapvpwrvgnd_1
XFILLER_9_142 vssd1 vssd1 vccd1 vccd1 sky130_fd_sc_hd__fill_2
XFILLER_20_119 vccd1 vssd1 vccd1 vssd1 sky130_ef_sc_hd__decap_40_12
X_2463_ _0432_ vssd1 vssd1 vccd1 vccd1 _0433_ sky130_fd_sc_hd__inv_2
X_2601_ clknet_leaf_4_clk _0160_ vssd1 vssd1 vccd1 vccd1 CALC_INST.gencon_inst.mult_calc.INn1\[1\]
+ sky130_fd_sc_hd__dfxtp_1
XPHY_EDGE_ROW_21_Left_86 vssd1 vssd1 vccd1 vccd1 sky130_fd_sc_hd__decap_3
X_2532_ clknet_leaf_35_clk _0091_ net81 vssd1 vssd1 vccd1 vccd1 CALC_INST.input_ctrl_inst.col_index\[29\]
+ sky130_fd_sc_hd__dfrtp_1
X_1345_ CALC_INST.gencon_inst.operand1\[7\] _0529_ vssd1 vssd1 vccd1 vccd1 _0533_
+ sky130_fd_sc_hd__and2_1
X_1276_ net55 _0473_ _0474_ net50 CALC_INST.gencon_inst.mult_calc.out\[11\] vssd1
+ vssd1 vccd1 vccd1 _0475_ sky130_fd_sc_hd__a32o_1
X_2394_ _1071_ _1168_ _1171_ _1222_ vssd1 vssd1 vccd1 vccd1 _0017_ sky130_fd_sc_hd__o31a_1
X_1414_ CALC_INST.input_ctrl_inst.col_index\[4\] _0570_ _0588_ vssd1 vssd1 vccd1 vccd1
+ _0590_ sky130_fd_sc_hd__and3_1
XANTENNA__1349__A2 net47 vssd1 vssd1 vccd1 vccd1 sky130_fd_sc_hd__diode_2
XFILLER_59_355 vssd1 vssd1 vccd1 vccd1 sky130_fd_sc_hd__fill_8
Xfanout154 CALC_INST.gencon_inst.add_calc.state\[1\] vssd1 vssd1 vccd1 vccd1 net154
+ sky130_fd_sc_hd__clkbuf_4
Xfanout121 CALC_INST.gencon_inst.add_calc.nRST vssd1 vssd1 vccd1 vccd1 net121 sky130_fd_sc_hd__buf_2
Xfanout110 net111 vssd1 vssd1 vccd1 vccd1 net110 sky130_fd_sc_hd__clkbuf_4
Xfanout132 _0775_ vssd1 vssd1 vccd1 vccd1 net132 sky130_fd_sc_hd__buf_2
Xfanout143 CALC_INST.gencon_inst.mult_calc.next_finish vssd1 vssd1 vccd1 vccd1 net143
+ sky130_fd_sc_hd__clkbuf_4
XANTENNA_fanout61_A net62 vssd1 vssd1 vccd1 vccd1 sky130_fd_sc_hd__diode_2
XTAP_TAPCELL_ROW_40_423 vssd1 vccd1 sky130_fd_sc_hd__tapvpwrvgnd_1
XFILLER_10_141 vssd1 vssd1 vccd1 vccd1 sky130_fd_sc_hd__fill_2
X_1963_ _0906_ _0909_ _0911_ _0907_ _0903_ vssd1 vssd1 vccd1 vccd1 _0914_ sky130_fd_sc_hd__o311a_1
XANTENNA__1579__A2 _0560_ vssd1 vssd1 vccd1 vccd1 sky130_fd_sc_hd__diode_2
X_1894_ CALC_INST.gencon_inst.mult_calc.out\[8\] net421 net144 vssd1 vssd1 vccd1 vccd1
+ _0281_ sky130_fd_sc_hd__mux2_1
X_2446_ CALC_INST.gencon_inst.gencon_state\[1\] _0416_ vssd1 vssd1 vccd1 vccd1 _0417_
+ sky130_fd_sc_hd__or2_1
X_2515_ clknet_leaf_34_clk _0074_ net90 vssd1 vssd1 vccd1 vccd1 CALC_INST.input_ctrl_inst.col_index\[12\]
+ sky130_fd_sc_hd__dfrtp_1
XTAP_TAPCELL_ROW_54_515 vssd1 vccd1 sky130_fd_sc_hd__tapvpwrvgnd_1
X_1328_ CALC_INST.gencon_inst.ALU_out\[3\] net76 net69 CALC_INST.gencon_inst.mult_calc.out\[3\]
+ net45 vssd1 vssd1 vccd1 vccd1 _0520_ sky130_fd_sc_hd__a221o_1
X_1259_ _0461_ net54 _0460_ vssd1 vssd1 vccd1 vccd1 _0462_ sky130_fd_sc_hd__and3b_1
X_2377_ _1049_ _1209_ _1086_ vssd1 vssd1 vccd1 vccd1 _1210_ sky130_fd_sc_hd__mux2_1
XTAP_TAPCELL_ROW_3_159 vssd1 vccd1 sky130_fd_sc_hd__tapvpwrvgnd_1
XFILLER_64_391 vssd1 vssd1 vccd1 vccd1 sky130_fd_sc_hd__fill_1
XFILLER_24_255 vssd1 vssd1 vccd1 vccd1 sky130_fd_sc_hd__fill_1
XFILLER_12_406 vssd1 vssd1 vccd1 vccd1 sky130_fd_sc_hd__fill_1
XFILLER_15_200 vssd1 vssd1 vccd1 vccd1 sky130_fd_sc_hd__fill_1
X_2300_ CALC_INST.input_ctrl_inst.decoded_key\[0\] _1151_ _1150_ _1077_ vssd1 vssd1
+ vccd1 vccd1 _1152_ sky130_fd_sc_hd__o211a_1
X_2231_ CALC_INST.gencon_inst.mult_calc.count.GENERATE_ADDER\[3\].thingy.in1 _1087_
+ vssd1 vssd1 vccd1 vccd1 _1089_ sky130_fd_sc_hd__and2_1
X_2162_ CALC_INST.input_ctrl_inst.scan_timer\[7\] CALC_INST.input_ctrl_inst.scan_timer\[9\]
+ CALC_INST.input_ctrl_inst.scan_timer\[8\] _1029_ vssd1 vssd1 vccd1 vccd1 _1034_
+ sky130_fd_sc_hd__and4_1
X_2093_ net363 net42 net34 CALC_INST.gencon_inst.operand2\[11\] vssd1 vssd1 vccd1
+ vccd1 _0332_ sky130_fd_sc_hd__a22o_1
XFILLER_21_269 vssd1 vssd1 vccd1 vccd1 sky130_fd_sc_hd__fill_1
XFILLER_9_71 vccd1 vssd1 vccd1 vssd1 sky130_ef_sc_hd__decap_40_12
XTAP_TAPCELL_ROW_16_250 vssd1 vccd1 sky130_fd_sc_hd__tapvpwrvgnd_1
X_1946_ net145 CALC_INST.gencon_inst.add_calc.main.in2\[4\] vssd1 vssd1 vccd1 vccd1
+ _0897_ sky130_fd_sc_hd__nand2_1
XANTENNA_fanout111_A net112 vssd1 vssd1 vccd1 vccd1 sky130_fd_sc_hd__diode_2
X_1877_ net133 CALC_INST.gencon_inst.mult_calc.adderSave\[6\] net123 net415 vssd1
+ vssd1 vccd1 vccd1 _0264_ sky130_fd_sc_hd__a22o_1
XANTENNA__1903__S net137 vssd1 vssd1 vccd1 vccd1 sky130_fd_sc_hd__diode_2
X_2429_ _0405_ _0408_ _0402_ vssd1 vssd1 vccd1 vccd1 _0409_ sky130_fd_sc_hd__mux2_1
XFILLER_44_339 vssd1 vssd1 vccd1 vccd1 sky130_fd_sc_hd__fill_1
XFILLER_44_317 vssd1 vssd1 vccd1 vccd1 sky130_fd_sc_hd__fill_1
XTAP_TAPCELL_ROW_22_297 vssd1 vccd1 sky130_fd_sc_hd__tapvpwrvgnd_1
XANTENNA__1651__A1 _0674_ vssd1 vssd1 vccd1 vccd1 sky130_fd_sc_hd__diode_2
XTAP_TAPCELL_ROW_13_231 vssd1 vccd1 sky130_fd_sc_hd__tapvpwrvgnd_1
X_1800_ _0801_ _0807_ _0810_ _0815_ _0808_ vssd1 vssd1 vccd1 vccd1 _0822_ sky130_fd_sc_hd__o311a_1
Xhold218 CALC_INST.gencon_inst.add_calc.main.in2\[5\] vssd1 vssd1 vccd1 vccd1 net417
+ sky130_fd_sc_hd__dlygate4sd3_1
X_1731_ net149 net148 CALC_INST.gencon_inst.ALU_finish _0416_ vssd1 vssd1 vccd1 vccd1
+ _0767_ sky130_fd_sc_hd__a31o_1
Xhold207 CALC_INST.gencon_inst.mult_calc.INn2\[6\] vssd1 vssd1 vccd1 vccd1 net406
+ sky130_fd_sc_hd__dlygate4sd3_1
Xhold229 CALC_INST.gencon_inst.mult_calc.INn2\[12\] vssd1 vssd1 vccd1 vccd1 net428
+ sky130_fd_sc_hd__dlygate4sd3_1
X_1662_ net250 _0704_ net43 vssd1 vssd1 vccd1 vccd1 _0174_ sky130_fd_sc_hd__mux2_1
X_2780_ clknet_leaf_23_clk _0330_ vssd1 vssd1 vccd1 vccd1 CALC_INST.gencon_inst.mult_calc.INn2\[9\]
+ sky130_fd_sc_hd__dfxtp_1
X_1593_ net230 CALC_INST.gencon_inst.latched_keypad_input\[2\] _0713_ vssd1 vssd1
+ vccd1 vccd1 _0116_ sky130_fd_sc_hd__mux2_1
X_2214_ CALC_INST.input_ctrl_inst.input_control_state\[0\] CALC_INST.input_ctrl_inst.input_control_state\[1\]
+ CALC_INST.input_ctrl_inst.input_control_state\[3\] CALC_INST.input_ctrl_inst.input_control_state\[2\]
+ vssd1 vssd1 vccd1 vccd1 _1073_ sky130_fd_sc_hd__or4b_1
X_2145_ _1023_ _1024_ vssd1 vssd1 vccd1 vccd1 _0362_ sky130_fd_sc_hd__and2_1
XFILLER_38_166 vccd1 vssd1 vccd1 vssd1 sky130_ef_sc_hd__decap_40_12
X_2076_ net128 _1128_ net130 net292 vssd1 vssd1 vccd1 vccd1 _0317_ sky130_fd_sc_hd__a2bb2o_1
X_1929_ net146 CALC_INST.gencon_inst.add_calc.main.in2\[8\] vssd1 vssd1 vccd1 vccd1
+ _0880_ sky130_fd_sc_hd__or2_1
XTAP_TAPCELL_ROW_36_389 vssd1 vccd1 sky130_fd_sc_hd__tapvpwrvgnd_1
XFILLER_39_57 vssd1 vssd1 vccd1 vccd1 sky130_fd_sc_hd__fill_1
XFILLER_55_78 vssd1 vssd1 vccd1 vccd1 sky130_fd_sc_hd__fill_4
XFILLER_44_125 vssd1 vssd1 vccd1 vccd1 sky130_fd_sc_hd__fill_1
XANTENNA__1869__A net127 vssd1 vssd1 vccd1 vccd1 sky130_fd_sc_hd__diode_2
XTAP_TAPCELL_ROW_10_212 vssd1 vccd1 sky130_fd_sc_hd__tapvpwrvgnd_1
XFILLER_4_276 vssd1 vssd1 vccd1 vccd1 sky130_fd_sc_hd__fill_2
XFILLER_35_169 vssd1 vssd1 vccd1 vccd1 sky130_fd_sc_hd__fill_2
XFILLER_35_158 vssd1 vssd1 vccd1 vccd1 sky130_fd_sc_hd__fill_8
Xhold90 CALC_INST.gencon_inst.mult_calc.countSave\[7\] vssd1 vssd1 vccd1 vccd1 net289
+ sky130_fd_sc_hd__dlygate4sd3_1
XFILLER_43_180 vssd1 vssd1 vccd1 vccd1 sky130_fd_sc_hd__fill_1
X_2832_ clknet_leaf_34_clk _0026_ net87 vssd1 vssd1 vccd1 vccd1 CALC_INST.input_ctrl_inst.debounce_cnt\[9\]
+ sky130_fd_sc_hd__dfrtp_1
X_2763_ clknet_leaf_28_clk _0006_ net103 vssd1 vssd1 vccd1 vccd1 CALC_INST.gencon_inst.mult_calc.next_finish
+ sky130_fd_sc_hd__dfrtp_1
X_1714_ CALC_INST.gencon_inst.ALU_in1\[8\] CALC_INST.gencon_inst.ALU_in2\[8\] net60
+ vssd1 vssd1 vccd1 vccd1 _0757_ sky130_fd_sc_hd__mux2_1
X_1576_ CALC_INST.gencon_inst.operator_input\[0\] CALC_INST.gencon_inst.key_read _0648_
+ _0654_ vssd1 vssd1 vccd1 vccd1 _0706_ sky130_fd_sc_hd__a31oi_1
X_1645_ net155 _0726_ vssd1 vssd1 vccd1 vccd1 _0728_ sky130_fd_sc_hd__or2_2
X_2694_ clknet_leaf_26_clk net235 net110 vssd1 vssd1 vccd1 vccd1 CALC_INST.gencon_inst.mult_calc.main.GENERATE_ADDER\[11\].thingy.in1
+ sky130_fd_sc_hd__dfrtp_1
X_2059_ _0859_ _0931_ vssd1 vssd1 vccd1 vccd1 _0997_ sky130_fd_sc_hd__nor2_1
XTAP_TAPCELL_ROW_49_481 vssd1 vccd1 sky130_fd_sc_hd__tapvpwrvgnd_1
X_2128_ _1011_ _1014_ _1004_ vssd1 vssd1 vccd1 vccd1 _1015_ sky130_fd_sc_hd__o21ai_1
XFILLER_34_191 vssd1 vssd1 vccd1 vccd1 sky130_fd_sc_hd__fill_4
XANTENNA__2040__B2 net126 vssd1 vssd1 vccd1 vccd1 sky130_fd_sc_hd__diode_2
XANTENNA_fanout91_A net93 vssd1 vssd1 vccd1 vccd1 sky130_fd_sc_hd__diode_2
XFILLER_1_279 vssd1 vssd1 vccd1 vccd1 sky130_fd_sc_hd__fill_1
XFILLER_17_147 vssd1 vssd1 vccd1 vccd1 sky130_fd_sc_hd__fill_1
XFILLER_49_6 vssd1 vssd1 vccd1 vccd1 sky130_fd_sc_hd__fill_1
XANTENNA__2223__A CALC_INST.input_ctrl_inst.key_pressed vssd1 vssd1 vccd1 vccd1 sky130_fd_sc_hd__diode_2
X_1430_ CALC_INST.input_ctrl_inst.col_index\[9\] _0599_ net477 vssd1 vssd1 vccd1 vccd1
+ _0600_ sky130_fd_sc_hd__a21oi_1
Xteam_06_170 vssd1 vssd1 vccd1 vccd1 team_06_170/HI gpio_oeb[18] sky130_fd_sc_hd__conb_1
Xteam_06_181 vssd1 vssd1 vccd1 vccd1 team_06_181/HI gpio_out[0] sky130_fd_sc_hd__conb_1
X_1361_ CALC_INST.gencon_inst.operand1\[10\] _0541_ _0545_ vssd1 vssd1 vccd1 vccd1
+ _0546_ sky130_fd_sc_hd__o21a_1
X_1292_ net149 net148 CALC_INST.gencon_inst.gencon_state\[2\] vssd1 vssd1 vccd1 vccd1
+ _0487_ sky130_fd_sc_hd__or3_1
XTAP_TAPCELL_ROW_38_407 vssd1 vccd1 sky130_fd_sc_hd__tapvpwrvgnd_1
XANTENNA__2098__A1 net133 vssd1 vssd1 vccd1 vccd1 sky130_fd_sc_hd__diode_2
Xteam_06_192 vssd1 vssd1 vccd1 vccd1 gpio_oeb[1] team_06_192/LO sky130_fd_sc_hd__conb_1
XFILLER_51_404 vssd1 vssd1 vccd1 vccd1 sky130_fd_sc_hd__fill_2
XTAP_TAPCELL_ROW_46_462 vssd1 vccd1 sky130_fd_sc_hd__tapvpwrvgnd_1
X_2746_ clknet_leaf_11_clk _0305_ net97 vssd1 vssd1 vccd1 vccd1 CALC_INST.gencon_inst.ALU_out\[15\]
+ sky130_fd_sc_hd__dfrtp_1
X_2815_ clknet_leaf_6_clk _0357_ vssd1 vssd1 vccd1 vccd1 CALC_INST.gencon_inst.operator_input\[0\]
+ sky130_fd_sc_hd__dfxtp_1
XANTENNA__2133__A net155 vssd1 vssd1 vccd1 vccd1 sky130_fd_sc_hd__diode_2
XFILLER_31_194 vssd1 vssd1 vccd1 vccd1 sky130_fd_sc_hd__fill_1
X_1628_ CALC_INST.gencon_inst.operand2\[7\] net257 net65 vssd1 vssd1 vccd1 vccd1 _0145_
+ sky130_fd_sc_hd__mux2_1
XANTENNA__1533__B1 net67 vssd1 vssd1 vccd1 vccd1 sky130_fd_sc_hd__diode_2
X_1559_ net261 _0660_ _0694_ vssd1 vssd1 vccd1 vccd1 _0106_ sky130_fd_sc_hd__o21a_1
X_2677_ clknet_leaf_28_clk net420 net102 vssd1 vssd1 vccd1 vccd1 CALC_INST.gencon_inst.mult_calc.compCount.in2\[9\]
+ sky130_fd_sc_hd__dfrtp_1
XFILLER_14_139 vssd1 vssd1 vccd1 vccd1 sky130_fd_sc_hd__fill_1
XANTENNA__1524__B1 net67 vssd1 vssd1 vccd1 vccd1 sky130_fd_sc_hd__diode_2
XTAP_TAPCELL_ROW_43_443 vssd1 vccd1 sky130_fd_sc_hd__tapvpwrvgnd_1
XANTENNA_clkbuf_leaf_20_clk_A clknet_2_3__leaf_clk vssd1 vssd1 vccd1 vccd1 sky130_fd_sc_hd__diode_2
X_2600_ clknet_leaf_3_clk _0159_ vssd1 vssd1 vccd1 vccd1 CALC_INST.gencon_inst.mult_calc.INn1\[0\]
+ sky130_fd_sc_hd__dfxtp_1
XFILLER_9_121 vccd1 vssd1 vccd1 vssd1 sky130_ef_sc_hd__decap_40_12
X_2462_ _0427_ _0430_ _0431_ vssd1 vssd1 vccd1 vccd1 _0432_ sky130_fd_sc_hd__nor3_1
X_2393_ net39 _1217_ net484 vssd1 vssd1 vccd1 vccd1 _1222_ sky130_fd_sc_hd__a21o_1
XANTENNA_clkbuf_leaf_35_clk_A clknet_2_0__leaf_clk vssd1 vssd1 vccd1 vccd1 sky130_fd_sc_hd__diode_2
X_2531_ clknet_leaf_35_clk _0090_ net81 vssd1 vssd1 vccd1 vccd1 CALC_INST.input_ctrl_inst.col_index\[28\]
+ sky130_fd_sc_hd__dfrtp_1
XFILLER_5_393 vssd1 vssd1 vccd1 vccd1 sky130_fd_sc_hd__fill_8
X_1413_ _0570_ _0588_ CALC_INST.input_ctrl_inst.col_index\[4\] vssd1 vssd1 vccd1 vccd1
+ _0589_ sky130_fd_sc_hd__a21oi_1
X_1344_ CALC_INST.gencon_inst.operand1\[6\] net48 _0531_ _0532_ vssd1 vssd1 vccd1
+ vccd1 _0053_ sky130_fd_sc_hd__o22a_1
XFILLER_36_253 vssd1 vssd1 vccd1 vccd1 sky130_fd_sc_hd__fill_1
X_1275_ CALC_INST.gencon_inst.operand2\[10\] CALC_INST.gencon_inst.operand2\[9\] _0464_
+ CALC_INST.gencon_inst.operand2\[11\] vssd1 vssd1 vccd1 vccd1 _0474_ sky130_fd_sc_hd__a31o_1
XFILLER_51_201 vssd1 vssd1 vccd1 vccd1 sky130_fd_sc_hd__fill_4
XFILLER_36_275 vccd1 vssd1 vccd1 vssd1 sky130_ef_sc_hd__decap_40_12
XFILLER_36_264 vssd1 vssd1 vccd1 vccd1 sky130_fd_sc_hd__fill_2
X_2729_ clknet_leaf_4_clk _0288_ net91 vssd1 vssd1 vccd1 vccd1 CALC_INST.gencon_inst.mult_calc.out\[15\]
+ sky130_fd_sc_hd__dfrtp_1
XFILLER_22_27 vssd1 vssd1 vccd1 vccd1 sky130_fd_sc_hd__fill_1
Xfanout100 CALC_INST.gencon_inst.add_calc.nRST vssd1 vssd1 vccd1 vccd1 net100 sky130_fd_sc_hd__clkbuf_2
XFILLER_47_13 vssd1 vssd1 vccd1 vccd1 sky130_fd_sc_hd__fill_1
Xfanout155 _1146_ vssd1 vssd1 vccd1 vccd1 net155 sky130_fd_sc_hd__clkbuf_4
Xfanout111 net112 vssd1 vssd1 vccd1 vccd1 net111 sky130_fd_sc_hd__clkbuf_2
Xfanout133 CALC_INST.gencon_inst.mult_calc.state\[4\] vssd1 vssd1 vccd1 vccd1 net133
+ sky130_fd_sc_hd__clkbuf_4
XTAP_TAPCELL_ROW_6_179 vssd1 vccd1 sky130_fd_sc_hd__tapvpwrvgnd_1
Xfanout122 net125 vssd1 vssd1 vccd1 vccd1 net122 sky130_fd_sc_hd__clkbuf_4
Xfanout144 CALC_INST.gencon_inst.mult_calc.next_finish vssd1 vssd1 vccd1 vccd1 net144
+ sky130_fd_sc_hd__clkbuf_4
XPHY_EDGE_ROW_29_Right_29 vssd1 vssd1 vccd1 vccd1 sky130_fd_sc_hd__decap_3
XPHY_EDGE_ROW_38_Right_38 vssd1 vssd1 vccd1 vccd1 sky130_fd_sc_hd__decap_3
XFILLER_8_29 vccd1 vssd1 vccd1 vssd1 sky130_ef_sc_hd__decap_40_12
XFILLER_2_363 vssd1 vssd1 vccd1 vccd1 sky130_fd_sc_hd__fill_1
XPHY_EDGE_ROW_47_Right_47 vssd1 vssd1 vccd1 vccd1 sky130_fd_sc_hd__decap_3
X_1962_ _0906_ _0909_ _0911_ _0907_ vssd1 vssd1 vccd1 vccd1 _0913_ sky130_fd_sc_hd__o31a_1
XPHY_EDGE_ROW_56_Right_56 vssd1 vssd1 vccd1 vccd1 sky130_fd_sc_hd__decap_3
XFILLER_33_223 vssd1 vssd1 vccd1 vccd1 sky130_fd_sc_hd__fill_1
X_1893_ CALC_INST.gencon_inst.mult_calc.out\[7\] net321 net144 vssd1 vssd1 vccd1 vccd1
+ _0280_ sky130_fd_sc_hd__mux2_1
X_2445_ _1054_ CALC_INST.gencon_inst.gencon_state\[2\] vssd1 vssd1 vccd1 vccd1 _0416_
+ sky130_fd_sc_hd__nand2_2
X_2376_ CALC_INST.input_ctrl_inst.key_pressed _1205_ _1208_ _1170_ vssd1 vssd1 vccd1
+ vccd1 _1209_ sky130_fd_sc_hd__o22a_1
X_2514_ clknet_leaf_34_clk _0073_ net87 vssd1 vssd1 vccd1 vccd1 CALC_INST.input_ctrl_inst.col_index\[11\]
+ sky130_fd_sc_hd__dfrtp_1
XTAP_TAPCELL_ROW_54_516 vssd1 vccd1 sky130_fd_sc_hd__tapvpwrvgnd_1
X_1327_ _0517_ _0518_ _0490_ vssd1 vssd1 vccd1 vccd1 _0519_ sky130_fd_sc_hd__and3b_1
X_1258_ CALC_INST.gencon_inst.operand2\[7\] CALC_INST.gencon_inst.operand2\[6\] _0455_
+ vssd1 vssd1 vccd1 vccd1 _0461_ sky130_fd_sc_hd__and3_1
XFILLER_24_234 vssd1 vssd1 vccd1 vccd1 sky130_fd_sc_hd__fill_4
XFILLER_17_49 vssd1 vssd1 vccd1 vccd1 sky130_fd_sc_hd__fill_2
XTAP_TAPCELL_ROW_19_270 vssd1 vccd1 sky130_fd_sc_hd__tapvpwrvgnd_1
XTAP_TAPCELL_ROW_62_571 vssd1 vccd1 sky130_fd_sc_hd__tapvpwrvgnd_1
XPHY_EDGE_ROW_49_Left_114 vssd1 vssd1 vccd1 vccd1 sky130_fd_sc_hd__decap_3
XFILLER_33_15 vssd1 vssd1 vccd1 vccd1 sky130_fd_sc_hd__fill_4
XFILLER_3_105 vssd1 vssd1 vccd1 vccd1 sky130_fd_sc_hd__fill_1
XFILLER_59_175 vssd1 vssd1 vccd1 vccd1 sky130_fd_sc_hd__fill_1
XPHY_EDGE_ROW_58_Left_123 vssd1 vssd1 vccd1 vccd1 sky130_fd_sc_hd__decap_3
XFILLER_47_337 vssd1 vssd1 vccd1 vccd1 sky130_fd_sc_hd__fill_2
XFILLER_15_223 vssd1 vssd1 vccd1 vccd1 sky130_fd_sc_hd__fill_1
XFILLER_15_289 vssd1 vssd1 vccd1 vccd1 sky130_fd_sc_hd__fill_2
XFILLER_23_81 vssd1 vssd1 vccd1 vccd1 sky130_fd_sc_hd__fill_2
XFILLER_38_304 vssd1 vssd1 vccd1 vccd1 sky130_fd_sc_hd__fill_2
XFILLER_2_171 vssd1 vssd1 vccd1 vccd1 sky130_fd_sc_hd__fill_4
XFILLER_2_160 vssd1 vssd1 vccd1 vccd1 sky130_fd_sc_hd__fill_2
X_2230_ CALC_INST.gencon_inst.mult_calc.count.GENERATE_ADDER\[1\].thingy.in1 CALC_INST.gencon_inst.mult_calc.count.GENERATE_ADDER\[1\].thingy.cIn
+ CALC_INST.gencon_inst.mult_calc.count.GENERATE_ADDER\[2\].thingy.in1 vssd1 vssd1
+ vccd1 vccd1 _1088_ sky130_fd_sc_hd__nand3_1
X_2161_ _1022_ _1031_ _1033_ vssd1 vssd1 vccd1 vccd1 _0369_ sky130_fd_sc_hd__and3_1
XFILLER_38_326 vssd1 vssd1 vccd1 vccd1 sky130_fd_sc_hd__fill_1
X_2092_ net351 net42 net34 CALC_INST.gencon_inst.operand2\[10\] vssd1 vssd1 vccd1
+ vccd1 _0331_ sky130_fd_sc_hd__a22o_1
XANTENNA_clkbuf_2_2__f_clk_A clknet_0_clk vssd1 vssd1 vccd1 vccd1 sky130_fd_sc_hd__diode_2
XFILLER_0_85 vccd1 vssd1 vccd1 vssd1 sky130_ef_sc_hd__decap_40_12
XFILLER_61_351 vssd1 vssd1 vccd1 vccd1 sky130_fd_sc_hd__fill_1
X_1945_ net145 CALC_INST.gencon_inst.add_calc.main.in2\[4\] vssd1 vssd1 vccd1 vccd1
+ _0896_ sky130_fd_sc_hd__or2_1
XFILLER_21_215 vssd1 vssd1 vccd1 vccd1 sky130_fd_sc_hd__fill_2
XFILLER_9_83 vssd1 vssd1 vccd1 vccd1 sky130_fd_sc_hd__fill_8
XTAP_TAPCELL_ROW_16_251 vssd1 vccd1 sky130_fd_sc_hd__tapvpwrvgnd_1
X_1876_ net134 net337 net123 net352 vssd1 vssd1 vccd1 vccd1 _0263_ sky130_fd_sc_hd__a22o_1
XANTENNA_fanout104_A net112 vssd1 vssd1 vccd1 vccd1 sky130_fd_sc_hd__diode_2
XFILLER_0_119 vssd1 vssd1 vccd1 vccd1 sky130_fd_sc_hd__fill_1
X_2428_ CALC_INST.input_ctrl_inst.col_index\[29\] CALC_INST.input_ctrl_inst.col_index\[31\]
+ _0407_ vssd1 vssd1 vccd1 vccd1 _0408_ sky130_fd_sc_hd__and3_1
X_2359_ CALC_INST.input_ctrl_inst.debounce_cnt\[10\] _1194_ vssd1 vssd1 vccd1 vccd1
+ _1196_ sky130_fd_sc_hd__nand2_1
XFILLER_44_25 vssd1 vssd1 vccd1 vccd1 sky130_fd_sc_hd__fill_2
XFILLER_34_91 vssd1 vssd1 vccd1 vccd1 sky130_fd_sc_hd__fill_1
XTAP_TAPCELL_ROW_13_232 vssd1 vccd1 sky130_fd_sc_hd__tapvpwrvgnd_1
Xhold208 CALC_INST.gencon_inst.add_calc.main.GENERATE_ADDER\[8\].thingy.in1 vssd1
+ vssd1 vccd1 vccd1 net407 sky130_fd_sc_hd__dlygate4sd3_1
X_1730_ CALC_INST.gencon_inst.read_input _0764_ _0765_ vssd1 vssd1 vccd1 vccd1 _0766_
+ sky130_fd_sc_hd__o21a_1
X_1592_ net246 CALC_INST.gencon_inst.latched_keypad_input\[1\] _0713_ vssd1 vssd1
+ vccd1 vccd1 _0115_ sky130_fd_sc_hd__mux2_1
X_1661_ net219 _0700_ _0727_ vssd1 vssd1 vccd1 vccd1 _0173_ sky130_fd_sc_hd__mux2_1
Xhold219 CALC_INST.gencon_inst.mult_calc.compCount.in2\[11\] vssd1 vssd1 vccd1 vccd1
+ net418 sky130_fd_sc_hd__dlygate4sd3_1
X_2144_ CALC_INST.input_ctrl_inst.scan_timer\[1\] net56 vssd1 vssd1 vccd1 vccd1 _1024_
+ sky130_fd_sc_hd__or2_1
X_2213_ _1072_ vssd1 vssd1 vccd1 vccd1 CALC_INST.input_ctrl_inst.key_pressed sky130_fd_sc_hd__inv_2
X_2075_ net128 _1124_ net130 net303 vssd1 vssd1 vccd1 vccd1 _0316_ sky130_fd_sc_hd__a2bb2o_1
XFILLER_14_17 vssd1 vssd1 vccd1 vccd1 sky130_fd_sc_hd__fill_1
X_1928_ CALC_INST.gencon_inst.add_calc.main.GENERATE_ADDER\[9\].thingy.in1 _0876_
+ _0877_ vssd1 vssd1 vccd1 vccd1 _0879_ sky130_fd_sc_hd__nand3_1
X_1859_ net245 net213 net138 vssd1 vssd1 vccd1 vccd1 _0247_ sky130_fd_sc_hd__mux2_1
XFILLER_30_49 vccd1 vssd1 vccd1 vssd1 sky130_ef_sc_hd__decap_40_12
XFILLER_55_57 vssd1 vssd1 vccd1 vccd1 sky130_fd_sc_hd__fill_1
XFILLER_29_178 vssd1 vssd1 vccd1 vccd1 sky130_fd_sc_hd__fill_2
XFILLER_4_233 vssd1 vssd1 vccd1 vccd1 sky130_fd_sc_hd__fill_1
XTAP_TAPCELL_ROW_10_213 vssd1 vccd1 sky130_fd_sc_hd__tapvpwrvgnd_1
XFILLER_50_118 vssd1 vssd1 vccd1 vccd1 sky130_fd_sc_hd__fill_2
Xhold80 CALC_INST.gencon_inst.ALU_in1\[5\] vssd1 vssd1 vccd1 vccd1 net279 sky130_fd_sc_hd__dlygate4sd3_1
Xhold91 _0344_ vssd1 vssd1 vccd1 vccd1 net290 sky130_fd_sc_hd__dlygate4sd3_1
X_1713_ net341 _0756_ net152 vssd1 vssd1 vccd1 vccd1 _0198_ sky130_fd_sc_hd__mux2_1
X_2831_ clknet_leaf_34_clk _0025_ net87 vssd1 vssd1 vccd1 vccd1 CALC_INST.input_ctrl_inst.debounce_cnt\[8\]
+ sky130_fd_sc_hd__dfrtp_1
X_2762_ clknet_leaf_32_clk _0002_ net89 vssd1 vssd1 vccd1 vccd1 CALC_INST.gencon_inst.mult_calc.state\[0\]
+ sky130_fd_sc_hd__dfstp_1
X_1575_ _1054_ net357 _0487_ _0414_ vssd1 vssd1 vccd1 vccd1 _0111_ sky130_fd_sc_hd__a31o_1
X_1644_ net155 _0726_ vssd1 vssd1 vccd1 vccd1 _0727_ sky130_fd_sc_hd__nor2_1
X_2693_ clknet_leaf_26_clk _0252_ net108 vssd1 vssd1 vccd1 vccd1 CALC_INST.gencon_inst.mult_calc.main.GENERATE_ADDER\[10\].thingy.in1
+ sky130_fd_sc_hd__dfrtp_1
XTAP_TAPCELL_ROW_49_482 vssd1 vccd1 sky130_fd_sc_hd__tapvpwrvgnd_1
X_2127_ CALC_INST.input_ctrl_inst.decoded_key\[2\] _1150_ CALC_INST.input_ctrl_inst.decoded_key\[3\]
+ vssd1 vssd1 vccd1 vccd1 _1014_ sky130_fd_sc_hd__a21oi_1
X_2058_ _0988_ _0989_ _0994_ net32 vssd1 vssd1 vccd1 vccd1 _0996_ sky130_fd_sc_hd__o31a_1
XFILLER_41_129 vssd1 vssd1 vccd1 vccd1 sky130_fd_sc_hd__fill_1
XTAP_TAPCELL_ROW_24_305 vssd1 vccd1 sky130_fd_sc_hd__tapvpwrvgnd_1
XFILLER_1_214 vssd1 vssd1 vccd1 vccd1 sky130_fd_sc_hd__fill_8
XFILLER_1_225 vccd1 vssd1 vccd1 vssd1 sky130_ef_sc_hd__decap_40_12
XFILLER_57_251 vssd1 vssd1 vccd1 vccd1 sky130_fd_sc_hd__fill_2
XFILLER_45_402 vssd1 vssd1 vccd1 vccd1 sky130_fd_sc_hd__fill_1
XFILLER_17_115 vssd1 vssd1 vccd1 vccd1 sky130_fd_sc_hd__fill_1
XFILLER_17_126 vssd1 vssd1 vccd1 vccd1 sky130_fd_sc_hd__fill_1
XFILLER_40_195 vssd1 vssd1 vccd1 vccd1 sky130_fd_sc_hd__fill_1
XFILLER_9_347 vssd1 vssd1 vccd1 vccd1 sky130_fd_sc_hd__fill_1
XFILLER_15_93 vssd1 vssd1 vccd1 vccd1 sky130_fd_sc_hd__fill_1
XFILLER_63_9 vccd1 vssd1 vccd1 vssd1 sky130_ef_sc_hd__decap_40_12
X_1360_ CALC_INST.gencon_inst.operand1\[10\] _0541_ _0491_ vssd1 vssd1 vccd1 vccd1
+ _0545_ sky130_fd_sc_hd__a21oi_1
Xteam_06_182 vssd1 vssd1 vccd1 vccd1 team_06_182/HI gpio_out[1] sky130_fd_sc_hd__conb_1
Xteam_06_193 vssd1 vssd1 vccd1 vccd1 gpio_oeb[2] team_06_193/LO sky130_fd_sc_hd__conb_1
Xteam_06_171 vssd1 vssd1 vccd1 vccd1 team_06_171/HI gpio_oeb[19] sky130_fd_sc_hd__conb_1
XANTENNA__1542__A1 _0415_ vssd1 vssd1 vccd1 vccd1 sky130_fd_sc_hd__diode_2
X_1291_ CALC_INST.gencon_inst.gencon_state\[2\] _0423_ vssd1 vssd1 vccd1 vccd1 _0486_
+ sky130_fd_sc_hd__or2_1
XTAP_TAPCELL_ROW_38_408 vssd1 vccd1 sky130_fd_sc_hd__tapvpwrvgnd_1
Xteam_06_160 vssd1 vssd1 vccd1 vccd1 team_06_160/HI gpio_oeb[8] sky130_fd_sc_hd__conb_1
XANTENNA_clkbuf_leaf_9_clk_A clknet_2_1__leaf_clk vssd1 vssd1 vccd1 vccd1 sky130_fd_sc_hd__diode_2
XTAP_TAPCELL_ROW_46_463 vssd1 vccd1 sky130_fd_sc_hd__tapvpwrvgnd_1
X_2745_ clknet_leaf_17_clk _0304_ net119 vssd1 vssd1 vccd1 vccd1 CALC_INST.gencon_inst.ALU_out\[14\]
+ sky130_fd_sc_hd__dfrtp_1
X_2814_ clknet_leaf_6_clk _0356_ vssd1 vssd1 vccd1 vccd1 CALC_INST.gencon_inst.keypad_input\[3\]
+ sky130_fd_sc_hd__dfxtp_1
X_2676_ clknet_leaf_28_clk net356 net103 vssd1 vssd1 vccd1 vccd1 CALC_INST.gencon_inst.mult_calc.compCount.in2\[8\]
+ sky130_fd_sc_hd__dfrtp_1
X_1627_ CALC_INST.gencon_inst.operand2\[6\] net287 net65 vssd1 vssd1 vccd1 vccd1 _0144_
+ sky130_fd_sc_hd__mux2_1
X_1558_ _0415_ _0692_ _0693_ _0659_ vssd1 vssd1 vccd1 vccd1 _0694_ sky130_fd_sc_hd__a211o_1
X_1489_ _0637_ _0638_ vssd1 vssd1 vccd1 vccd1 _0640_ sky130_fd_sc_hd__nor2_1
XFILLER_36_59 vssd1 vssd1 vccd1 vccd1 sky130_fd_sc_hd__fill_4
XANTENNA__2089__A2 _0728_ vssd1 vssd1 vccd1 vccd1 sky130_fd_sc_hd__diode_2
Xclkbuf_leaf_34_clk clknet_2_0__leaf_clk vssd1 vssd1 vccd1 vccd1 clknet_leaf_34_clk
+ sky130_fd_sc_hd__clkbuf_8
XFILLER_6_339 vssd1 vssd1 vccd1 vccd1 sky130_fd_sc_hd__fill_2
XFILLER_60_268 vssd1 vssd1 vccd1 vccd1 sky130_fd_sc_hd__fill_1
XFILLER_60_224 vccd1 vssd1 vccd1 vssd1 sky130_ef_sc_hd__decap_40_12
XFILLER_45_243 vssd1 vssd1 vccd1 vccd1 sky130_fd_sc_hd__fill_1
XTAP_TAPCELL_ROW_43_444 vssd1 vccd1 sky130_fd_sc_hd__tapvpwrvgnd_1
Xclkbuf_leaf_25_clk clknet_2_2__leaf_clk vssd1 vssd1 vccd1 vccd1 clknet_leaf_25_clk
+ sky130_fd_sc_hd__clkbuf_8
XFILLER_61_6 vccd1 vssd1 vccd1 vssd1 sky130_ef_sc_hd__decap_40_12
X_2530_ clknet_leaf_0_clk _0089_ net81 vssd1 vssd1 vccd1 vccd1 CALC_INST.input_ctrl_inst.col_index\[27\]
+ sky130_fd_sc_hd__dfrtp_1
XFILLER_9_144 vssd1 vssd1 vccd1 vccd1 sky130_fd_sc_hd__fill_1
XFILLER_13_184 vssd1 vssd1 vccd1 vccd1 sky130_fd_sc_hd__fill_1
X_1343_ CALC_INST.gencon_inst.ALU_out\[6\] net76 net70 CALC_INST.gencon_inst.mult_calc.out\[6\]
+ net46 vssd1 vssd1 vccd1 vccd1 _0532_ sky130_fd_sc_hd__a221o_1
X_2461_ CALC_INST.gencon_inst.operand2\[1\] CALC_INST.gencon_inst.latched_keypad_input\[1\]
+ vssd1 vssd1 vccd1 vccd1 _0431_ sky130_fd_sc_hd__nor2_1
X_2392_ _1070_ _1220_ _1221_ vssd1 vssd1 vccd1 vccd1 _0016_ sky130_fd_sc_hd__a21oi_1
X_1412_ _0570_ _0588_ _0587_ vssd1 vssd1 vccd1 vccd1 _0065_ sky130_fd_sc_hd__a21oi_1
Xwire58 _1020_ vssd1 vssd1 vccd1 vccd1 net58 sky130_fd_sc_hd__clkbuf_1
XFILLER_36_287 vccd1 vssd1 vccd1 vssd1 sky130_ef_sc_hd__decap_40_12
X_1274_ _0472_ vssd1 vssd1 vccd1 vccd1 _0473_ sky130_fd_sc_hd__inv_2
Xclkbuf_leaf_16_clk clknet_2_3__leaf_clk vssd1 vssd1 vccd1 vccd1 clknet_leaf_16_clk
+ sky130_fd_sc_hd__clkbuf_8
XFILLER_51_279 vssd1 vssd1 vccd1 vccd1 sky130_fd_sc_hd__fill_1
X_2728_ clknet_leaf_24_clk _0287_ net109 vssd1 vssd1 vccd1 vccd1 CALC_INST.gencon_inst.mult_calc.out\[14\]
+ sky130_fd_sc_hd__dfrtp_1
X_2659_ clknet_leaf_30_clk _0218_ net102 vssd1 vssd1 vccd1 vccd1 CALC_INST.gencon_inst.mult_calc.adderSave\[6\]
+ sky130_fd_sc_hd__dfrtp_1
XTAP_TAPCELL_ROW_57_536 vssd1 vccd1 sky130_fd_sc_hd__tapvpwrvgnd_1
Xfanout145 CALC_INST.gencon_inst.add_calc.diffSign vssd1 vssd1 vccd1 vccd1 net145
+ sky130_fd_sc_hd__buf_2
XFILLER_47_69 vssd1 vssd1 vccd1 vccd1 sky130_fd_sc_hd__fill_1
Xfanout112 CALC_INST.gencon_inst.add_calc.nRST vssd1 vssd1 vccd1 vccd1 net112 sky130_fd_sc_hd__buf_2
Xfanout123 net125 vssd1 vssd1 vccd1 vccd1 net123 sky130_fd_sc_hd__buf_2
Xfanout134 CALC_INST.gencon_inst.mult_calc.state\[4\] vssd1 vssd1 vccd1 vccd1 net134
+ sky130_fd_sc_hd__buf_2
Xfanout101 net104 vssd1 vssd1 vccd1 vccd1 net101 sky130_fd_sc_hd__clkbuf_4
XFILLER_42_224 vssd1 vssd1 vccd1 vccd1 sky130_fd_sc_hd__fill_1
XFILLER_27_287 vssd1 vssd1 vccd1 vccd1 sky130_fd_sc_hd__fill_1
XFILLER_6_136 vssd1 vssd1 vccd1 vccd1 sky130_fd_sc_hd__fill_4
XFILLER_10_121 vccd1 vssd1 vccd1 vssd1 sky130_ef_sc_hd__decap_40_12
XFILLER_10_143 vssd1 vssd1 vccd1 vccd1 sky130_fd_sc_hd__fill_1
X_1961_ _0909_ _0911_ vssd1 vssd1 vccd1 vccd1 _0912_ sky130_fd_sc_hd__nor2_1
X_1892_ CALC_INST.gencon_inst.mult_calc.out\[6\] net442 net143 vssd1 vssd1 vccd1 vccd1
+ _0279_ sky130_fd_sc_hd__mux2_1
XFILLER_5_180 vssd1 vssd1 vccd1 vccd1 sky130_fd_sc_hd__fill_2
X_2513_ clknet_leaf_34_clk _0072_ net90 vssd1 vssd1 vccd1 vccd1 CALC_INST.input_ctrl_inst.col_index\[10\]
+ sky130_fd_sc_hd__dfrtp_1
X_1326_ _0515_ _0516_ _0508_ _0511_ vssd1 vssd1 vccd1 vccd1 _0518_ sky130_fd_sc_hd__a211o_1
Xclkbuf_leaf_5_clk clknet_2_1__leaf_clk vssd1 vssd1 vccd1 vccd1 clknet_leaf_5_clk
+ sky130_fd_sc_hd__clkbuf_8
X_2444_ CALC_INST.gencon_inst.gencon_state\[1\] _1054_ CALC_INST.gencon_inst.gencon_state\[2\]
+ vssd1 vssd1 vccd1 vccd1 _0415_ sky130_fd_sc_hd__or3_4
X_2375_ _1206_ _1207_ vssd1 vssd1 vccd1 vccd1 _1208_ sky130_fd_sc_hd__or2_1
XFILLER_64_393 vssd1 vssd1 vccd1 vccd1 sky130_fd_sc_hd__fill_4
XTAP_TAPCELL_ROW_54_517 vssd1 vccd1 sky130_fd_sc_hd__tapvpwrvgnd_1
X_1257_ CALC_INST.gencon_inst.operand2\[6\] _0455_ CALC_INST.gencon_inst.operand2\[7\]
+ vssd1 vssd1 vccd1 vccd1 _0460_ sky130_fd_sc_hd__a21o_1
XTAP_TAPCELL_ROW_19_271 vssd1 vccd1 sky130_fd_sc_hd__tapvpwrvgnd_1
XTAP_TAPCELL_ROW_62_572 vssd1 vccd1 sky130_fd_sc_hd__tapvpwrvgnd_1
XANTENNA_fanout137_X net137 vssd1 vssd1 vccd1 vccd1 sky130_fd_sc_hd__diode_2
XFILLER_3_139 vssd1 vssd1 vccd1 vccd1 sky130_fd_sc_hd__fill_2
XANTENNA_hold296_A CALC_INST.gencon_inst.mult_calc.start vssd1 vssd1 vccd1 vccd1 sky130_fd_sc_hd__diode_2
XFILLER_59_198 vccd1 vssd1 vccd1 vssd1 sky130_ef_sc_hd__decap_40_12
XFILLER_59_154 vssd1 vssd1 vccd1 vccd1 sky130_fd_sc_hd__fill_2
XFILLER_59_132 vssd1 vssd1 vccd1 vccd1 sky130_fd_sc_hd__fill_1
XFILLER_47_349 vssd1 vssd1 vccd1 vccd1 sky130_fd_sc_hd__fill_2
XANTENNA__1652__S _0646_ vssd1 vssd1 vccd1 vccd1 sky130_fd_sc_hd__diode_2
XFILLER_55_393 vssd1 vssd1 vccd1 vccd1 sky130_fd_sc_hd__fill_2
XANTENNA__1400__B net53 vssd1 vssd1 vccd1 vccd1 sky130_fd_sc_hd__diode_2
XANTENNA_clkbuf_leaf_34_clk_A clknet_2_0__leaf_clk vssd1 vssd1 vccd1 vccd1 sky130_fd_sc_hd__diode_2
XFILLER_15_279 vssd1 vssd1 vccd1 vccd1 sky130_fd_sc_hd__fill_1
XFILLER_7_401 vssd1 vssd1 vccd1 vccd1 sky130_fd_sc_hd__fill_2
X_2160_ _1032_ vssd1 vssd1 vccd1 vccd1 _1033_ sky130_fd_sc_hd__inv_2
XFILLER_38_338 vssd1 vssd1 vccd1 vccd1 sky130_fd_sc_hd__fill_4
X_2091_ net438 net42 net34 CALC_INST.gencon_inst.operand2\[9\] vssd1 vssd1 vccd1 vccd1
+ _0330_ sky130_fd_sc_hd__a22o_1
XFILLER_0_20 vssd1 vssd1 vccd1 vccd1 sky130_fd_sc_hd__fill_2
XFILLER_0_42 vccd1 vssd1 vccd1 vssd1 sky130_ef_sc_hd__decap_40_12
XFILLER_0_97 vccd1 vssd1 vccd1 vssd1 sky130_ef_sc_hd__decap_40_12
X_1944_ CALC_INST.gencon_inst.add_calc.main.GENERATE_ADDER\[5\].thingy.in1 _0892_
+ _0893_ vssd1 vssd1 vccd1 vccd1 _0895_ sky130_fd_sc_hd__nand3_1
X_1875_ net134 CALC_INST.gencon_inst.mult_calc.adderSave\[4\] net123 net424 vssd1
+ vssd1 vccd1 vccd1 _0262_ sky130_fd_sc_hd__a22o_1
XTAP_TAPCELL_ROW_16_252 vssd1 vccd1 sky130_fd_sc_hd__tapvpwrvgnd_1
XANTENNA__2141__B net53 vssd1 vssd1 vccd1 vccd1 sky130_fd_sc_hd__diode_2
XFILLER_0_109 vssd1 vssd1 vccd1 vccd1 sky130_fd_sc_hd__fill_2
X_2427_ CALC_INST.input_ctrl_inst.col_index\[28\] CALC_INST.input_ctrl_inst.col_index\[30\]
+ _0406_ vssd1 vssd1 vccd1 vccd1 _0407_ sky130_fd_sc_hd__and3_1
X_1309_ _0497_ _0502_ vssd1 vssd1 vccd1 vccd1 _0503_ sky130_fd_sc_hd__nor2_1
X_2358_ net38 _1193_ _1195_ net40 net393 vssd1 vssd1 vccd1 vccd1 _0026_ sky130_fd_sc_hd__a32o_1
X_2289_ _1053_ _1143_ net123 vssd1 vssd1 vccd1 vccd1 _0007_ sky130_fd_sc_hd__a21oi_1
XFILLER_52_363 vssd1 vssd1 vccd1 vccd1 sky130_fd_sc_hd__fill_1
XFILLER_44_48 vssd1 vssd1 vccd1 vccd1 sky130_fd_sc_hd__fill_2
XANTENNA__1884__B1 net125 vssd1 vssd1 vccd1 vccd1 sky130_fd_sc_hd__diode_2
XFILLER_18_93 vssd1 vssd1 vccd1 vccd1 sky130_fd_sc_hd__fill_1
XFILLER_34_81 vssd1 vssd1 vccd1 vccd1 sky130_fd_sc_hd__fill_2
XTAP_TAPCELL_ROW_13_233 vssd1 vccd1 sky130_fd_sc_hd__tapvpwrvgnd_1
X_1591_ net232 CALC_INST.gencon_inst.latched_keypad_input\[0\] _0713_ vssd1 vssd1
+ vccd1 vccd1 _0114_ sky130_fd_sc_hd__mux2_1
X_1660_ net206 _0697_ net44 vssd1 vssd1 vccd1 vccd1 _0172_ sky130_fd_sc_hd__mux2_1
Xhold209 CALC_INST.gencon_inst.mult_calc.adderSave\[14\] vssd1 vssd1 vccd1 vccd1 net408
+ sky130_fd_sc_hd__dlygate4sd3_1
X_2143_ CALC_INST.input_ctrl_inst.scan_timer\[1\] net56 vssd1 vssd1 vccd1 vccd1 _1023_
+ sky130_fd_sc_hd__nand2_1
X_2212_ CALC_INST.input_ctrl_inst.RowSync\[2\] CALC_INST.input_ctrl_inst.RowSync\[0\]
+ CALC_INST.input_ctrl_inst.RowSync\[1\] CALC_INST.input_ctrl_inst.RowSync\[3\] vssd1
+ vssd1 vccd1 vccd1 _1072_ sky130_fd_sc_hd__and4_2
XFILLER_61_193 vssd1 vssd1 vccd1 vccd1 sky130_fd_sc_hd__fill_2
X_2074_ net128 _1122_ net130 net309 vssd1 vssd1 vccd1 vccd1 _0315_ sky130_fd_sc_hd__a2bb2o_1
X_1927_ _0876_ _0877_ CALC_INST.gencon_inst.add_calc.main.GENERATE_ADDER\[9\].thingy.in1
+ vssd1 vssd1 vccd1 vccd1 _0878_ sky130_fd_sc_hd__a21oi_2
X_1858_ net208 net207 net138 vssd1 vssd1 vccd1 vccd1 _0246_ sky130_fd_sc_hd__mux2_1
X_1789_ net442 net130 _0812_ net142 vssd1 vssd1 vccd1 vccd1 _0218_ sky130_fd_sc_hd__a22o_1
XFILLER_29_113 vssd1 vssd1 vccd1 vccd1 sky130_fd_sc_hd__fill_2
XFILLER_4_278 vssd1 vssd1 vccd1 vccd1 sky130_fd_sc_hd__fill_1
XFILLER_20_83 vssd1 vssd1 vccd1 vccd1 sky130_fd_sc_hd__fill_1
Xhold92 CALC_INST.gencon_inst.ALU_in2\[1\] vssd1 vssd1 vccd1 vccd1 net291 sky130_fd_sc_hd__dlygate4sd3_1
Xhold70 CALC_INST.gencon_inst.latched_operator_input\[1\] vssd1 vssd1 vccd1 vccd1
+ net269 sky130_fd_sc_hd__dlygate4sd3_1
XANTENNA__1321__A2 net47 vssd1 vssd1 vccd1 vccd1 sky130_fd_sc_hd__diode_2
XANTENNA__1406__A net51 vssd1 vssd1 vccd1 vccd1 sky130_fd_sc_hd__diode_2
XANTENNA__1840__S net137 vssd1 vssd1 vccd1 vccd1 sky130_fd_sc_hd__diode_2
Xhold81 CALC_INST.gencon_inst.mult_calc.main.GENERATE_ADDER\[10\].thingy.in1 vssd1
+ vssd1 vccd1 vccd1 net280 sky130_fd_sc_hd__dlygate4sd3_1
X_2830_ clknet_leaf_34_clk _0024_ net87 vssd1 vssd1 vccd1 vccd1 CALC_INST.input_ctrl_inst.debounce_cnt\[7\]
+ sky130_fd_sc_hd__dfrtp_1
XFILLER_16_363 vssd1 vssd1 vccd1 vccd1 sky130_fd_sc_hd__fill_1
XANTENNA_1 _1059_ vssd1 vssd1 vccd1 vccd1 sky130_fd_sc_hd__diode_2
X_1712_ CALC_INST.gencon_inst.ALU_in1\[7\] CALC_INST.gencon_inst.ALU_in2\[7\] net60
+ vssd1 vssd1 vccd1 vccd1 _0756_ sky130_fd_sc_hd__mux2_1
X_1643_ _0713_ _0725_ _0715_ vssd1 vssd1 vccd1 vccd1 _0726_ sky130_fd_sc_hd__mux2_1
X_2692_ clknet_leaf_26_clk _0251_ net109 vssd1 vssd1 vccd1 vccd1 CALC_INST.gencon_inst.mult_calc.main.GENERATE_ADDER\[9\].thingy.in1
+ sky130_fd_sc_hd__dfrtp_1
X_2761_ clknet_leaf_26_clk _0320_ net108 vssd1 vssd1 vccd1 vccd1 CALC_INST.gencon_inst.mult_calc.countSave\[14\]
+ sky130_fd_sc_hd__dfrtp_1
X_1574_ _0647_ _0703_ _0705_ net71 vssd1 vssd1 vccd1 vccd1 _0110_ sky130_fd_sc_hd__a22o_1
X_2057_ net468 _0995_ CALC_INST.gencon_inst.add_calc.state\[1\] vssd1 vssd1 vccd1
+ vccd1 _0303_ sky130_fd_sc_hd__mux2_1
XTAP_TAPCELL_ROW_49_483 vssd1 vccd1 sky130_fd_sc_hd__tapvpwrvgnd_1
X_2126_ _1003_ _1013_ vssd1 vssd1 vccd1 vccd1 _0354_ sky130_fd_sc_hd__and2_1
XTAP_TAPCELL_ROW_32_361 vssd1 vccd1 sky130_fd_sc_hd__tapvpwrvgnd_1
XTAP_TAPCELL_ROW_24_306 vssd1 vccd1 sky130_fd_sc_hd__tapvpwrvgnd_1
XANTENNA__1660__S net44 vssd1 vssd1 vccd1 vccd1 sky130_fd_sc_hd__diode_2
XFILLER_1_237 vccd1 vssd1 vccd1 vssd1 sky130_ef_sc_hd__decap_40_12
XFILLER_57_274 vssd1 vssd1 vccd1 vccd1 sky130_fd_sc_hd__fill_4
XFILLER_15_50 vssd1 vssd1 vccd1 vccd1 sky130_fd_sc_hd__fill_2
XFILLER_40_130 vssd1 vssd1 vccd1 vccd1 sky130_fd_sc_hd__fill_1
XFILLER_9_337 vssd1 vssd1 vccd1 vccd1 sky130_fd_sc_hd__fill_8
Xteam_06_183 vssd1 vssd1 vccd1 vccd1 team_06_183/HI gpio_out[2] sky130_fd_sc_hd__conb_1
Xteam_06_172 vssd1 vssd1 vccd1 vccd1 team_06_172/HI gpio_oeb[20] sky130_fd_sc_hd__conb_1
XFILLER_56_9 vccd1 vssd1 vccd1 vssd1 sky130_ef_sc_hd__decap_40_12
Xteam_06_161 vssd1 vssd1 vccd1 vccd1 team_06_161/HI gpio_oeb[9] sky130_fd_sc_hd__conb_1
XANTENNA__1527__C1 net71 vssd1 vssd1 vccd1 vccd1 sky130_fd_sc_hd__diode_2
XFILLER_63_222 vssd1 vssd1 vccd1 vccd1 sky130_fd_sc_hd__fill_2
Xteam_06_194 vssd1 vssd1 vccd1 vccd1 gpio_oeb[3] team_06_194/LO sky130_fd_sc_hd__conb_1
XTAP_TAPCELL_ROW_38_409 vssd1 vccd1 sky130_fd_sc_hd__tapvpwrvgnd_1
X_1290_ CALC_INST.gencon_inst.operand2\[14\] _0485_ net37 vssd1 vssd1 vccd1 vccd1
+ _0046_ sky130_fd_sc_hd__mux2_1
XFILLER_0_281 vccd1 vssd1 vccd1 vssd1 sky130_ef_sc_hd__decap_40_12
XFILLER_51_406 vssd1 vssd1 vccd1 vccd1 sky130_fd_sc_hd__fill_1
XTAP_TAPCELL_ROW_46_464 vssd1 vccd1 sky130_fd_sc_hd__tapvpwrvgnd_1
X_2813_ clknet_leaf_6_clk _0355_ vssd1 vssd1 vccd1 vccd1 CALC_INST.gencon_inst.keypad_input\[2\]
+ sky130_fd_sc_hd__dfxtp_1
X_2744_ clknet_leaf_17_clk _0303_ net120 vssd1 vssd1 vccd1 vccd1 CALC_INST.gencon_inst.ALU_out\[13\]
+ sky130_fd_sc_hd__dfrtp_1
X_1626_ CALC_INST.gencon_inst.operand2\[5\] net260 net64 vssd1 vssd1 vccd1 vccd1 _0143_
+ sky130_fd_sc_hd__mux2_1
X_2675_ clknet_leaf_29_clk net403 net103 vssd1 vssd1 vccd1 vccd1 CALC_INST.gencon_inst.mult_calc.compCount.in2\[7\]
+ sky130_fd_sc_hd__dfrtp_1
X_1557_ CALC_INST.gencon_inst.ALU_out\[11\] net77 net68 CALC_INST.gencon_inst.mult_calc.out\[11\]
+ vssd1 vssd1 vccd1 vccd1 _0693_ sky130_fd_sc_hd__a22o_1
XANTENNA__2535__RESET_B net99 vssd1 vssd1 vccd1 vccd1 sky130_fd_sc_hd__diode_2
X_1488_ CALC_INST.input_ctrl_inst.col_index\[29\] _0635_ vssd1 vssd1 vccd1 vccd1 _0639_
+ sky130_fd_sc_hd__nand2_1
X_2109_ net135 net292 net124 net293 vssd1 vssd1 vccd1 vccd1 _0348_ sky130_fd_sc_hd__a22o_1
XFILLER_22_141 vssd1 vssd1 vccd1 vccd1 sky130_fd_sc_hd__fill_2
XANTENNA__1655__S net44 vssd1 vssd1 vccd1 vccd1 sky130_fd_sc_hd__diode_2
XFILLER_45_233 vssd1 vssd1 vccd1 vccd1 sky130_fd_sc_hd__fill_2
XFILLER_45_211 vssd1 vssd1 vccd1 vccd1 sky130_fd_sc_hd__fill_1
XFILLER_60_236 vssd1 vssd1 vccd1 vccd1 sky130_fd_sc_hd__fill_4
XFILLER_54_6 vssd1 vssd1 vccd1 vccd1 sky130_fd_sc_hd__fill_1
X_2460_ CALC_INST.gencon_inst.operand2\[1\] CALC_INST.gencon_inst.latched_keypad_input\[1\]
+ vssd1 vssd1 vccd1 vccd1 _0430_ sky130_fd_sc_hd__and2_1
X_1342_ CALC_INST.gencon_inst.operand1\[6\] _0528_ _0530_ vssd1 vssd1 vccd1 vccd1
+ _0531_ sky130_fd_sc_hd__o21a_1
X_1273_ CALC_INST.gencon_inst.operand2\[11\] CALC_INST.gencon_inst.operand2\[10\]
+ CALC_INST.gencon_inst.operand2\[9\] _0464_ vssd1 vssd1 vccd1 vccd1 _0472_ sky130_fd_sc_hd__and4_1
X_2391_ _1050_ _1170_ _1218_ _1167_ _1069_ vssd1 vssd1 vccd1 vccd1 _1221_ sky130_fd_sc_hd__o221a_1
X_1411_ _1160_ _0413_ vssd1 vssd1 vccd1 vccd1 _0588_ sky130_fd_sc_hd__nor2_1
XFILLER_51_225 vssd1 vssd1 vccd1 vccd1 sky130_fd_sc_hd__fill_4
XFILLER_36_299 vssd1 vssd1 vccd1 vccd1 sky130_fd_sc_hd__fill_1
XFILLER_22_18 vssd1 vssd1 vccd1 vccd1 sky130_fd_sc_hd__fill_1
X_1609_ CALC_INST.gencon_inst.operand1\[4\] net300 net64 vssd1 vssd1 vccd1 vccd1 _0126_
+ sky130_fd_sc_hd__mux2_1
X_2589_ clknet_leaf_19_clk _0148_ vssd1 vssd1 vccd1 vccd1 CALC_INST.gencon_inst.ALU_in2\[10\]
+ sky130_fd_sc_hd__dfxtp_1
Xfanout113 net121 vssd1 vssd1 vccd1 vccd1 net113 sky130_fd_sc_hd__clkbuf_4
X_2727_ clknet_leaf_25_clk _0286_ net111 vssd1 vssd1 vccd1 vccd1 CALC_INST.gencon_inst.mult_calc.out\[13\]
+ sky130_fd_sc_hd__dfrtp_1
X_2658_ clknet_leaf_30_clk _0217_ net105 vssd1 vssd1 vccd1 vccd1 CALC_INST.gencon_inst.mult_calc.adderSave\[5\]
+ sky130_fd_sc_hd__dfrtp_1
Xfanout102 net104 vssd1 vssd1 vccd1 vccd1 net102 sky130_fd_sc_hd__clkbuf_4
XFILLER_59_314 vssd1 vssd1 vccd1 vccd1 sky130_fd_sc_hd__fill_2
Xfanout146 net147 vssd1 vssd1 vccd1 vccd1 net146 sky130_fd_sc_hd__buf_2
XTAP_TAPCELL_ROW_57_537 vssd1 vccd1 sky130_fd_sc_hd__tapvpwrvgnd_1
XANTENNA_input1_A en vssd1 vssd1 vccd1 vccd1 sky130_fd_sc_hd__diode_2
Xfanout124 net125 vssd1 vssd1 vccd1 vccd1 net124 sky130_fd_sc_hd__clkbuf_4
Xfanout135 CALC_INST.gencon_inst.mult_calc.state\[4\] vssd1 vssd1 vccd1 vccd1 net135
+ sky130_fd_sc_hd__clkbuf_4
XFILLER_50_280 vssd1 vssd1 vccd1 vccd1 sky130_fd_sc_hd__fill_1
XFILLER_10_133 vssd1 vssd1 vccd1 vccd1 sky130_fd_sc_hd__fill_4
XANTENNA_clkbuf_leaf_8_clk_A clknet_2_1__leaf_clk vssd1 vssd1 vccd1 vccd1 sky130_fd_sc_hd__diode_2
XFILLER_2_321 vssd1 vssd1 vccd1 vccd1 sky130_fd_sc_hd__fill_2
X_1960_ CALC_INST.gencon_inst.add_calc.main.GENERATE_ADDER\[1\].thingy.in1 _0908_
+ _0910_ vssd1 vssd1 vccd1 vccd1 _0911_ sky130_fd_sc_hd__a21oi_1
XFILLER_33_269 vssd1 vssd1 vccd1 vccd1 sky130_fd_sc_hd__fill_2
X_1891_ CALC_INST.gencon_inst.mult_calc.out\[5\] net337 net143 vssd1 vssd1 vccd1 vccd1
+ _0278_ sky130_fd_sc_hd__mux2_1
X_2443_ net148 _1054_ CALC_INST.gencon_inst.gencon_state\[2\] vssd1 vssd1 vccd1 vccd1
+ _0414_ sky130_fd_sc_hd__nor3_2
X_2512_ clknet_leaf_34_clk _0071_ net82 vssd1 vssd1 vccd1 vccd1 CALC_INST.input_ctrl_inst.col_index\[9\]
+ sky130_fd_sc_hd__dfrtp_1
XANTENNA__2139__B CALC_INST.input_ctrl_inst.key_pressed vssd1 vssd1 vccd1 vccd1 sky130_fd_sc_hd__diode_2
X_1325_ _0508_ _0511_ _0515_ _0516_ vssd1 vssd1 vccd1 vccd1 _0517_ sky130_fd_sc_hd__o211a_1
X_1256_ CALC_INST.gencon_inst.operand2\[6\] net36 _0459_ vssd1 vssd1 vccd1 vccd1 _0038_
+ sky130_fd_sc_hd__o21a_1
XFILLER_17_29 vssd1 vssd1 vccd1 vccd1 sky130_fd_sc_hd__fill_1
X_2374_ _1049_ _1203_ vssd1 vssd1 vccd1 vccd1 _1207_ sky130_fd_sc_hd__and2_1
XTAP_TAPCELL_ROW_62_573 vssd1 vccd1 sky130_fd_sc_hd__tapvpwrvgnd_1
XTAP_TAPCELL_ROW_54_518 vssd1 vccd1 sky130_fd_sc_hd__tapvpwrvgnd_1
XTAP_TAPCELL_ROW_19_272 vssd1 vccd1 sky130_fd_sc_hd__tapvpwrvgnd_1
XFILLER_3_118 vssd1 vssd1 vccd1 vccd1 sky130_fd_sc_hd__fill_1
XFILLER_47_339 vssd1 vssd1 vccd1 vccd1 sky130_fd_sc_hd__fill_1
XANTENNA__1360__B1 _0491_ vssd1 vssd1 vccd1 vccd1 sky130_fd_sc_hd__diode_2
XTAP_TAPCELL_ROW_2_151 vssd1 vccd1 sky130_fd_sc_hd__tapvpwrvgnd_1
XFILLER_15_225 vssd1 vssd1 vccd1 vccd1 sky130_fd_sc_hd__fill_4
XFILLER_23_83 vssd1 vssd1 vccd1 vccd1 sky130_fd_sc_hd__fill_1
XANTENNA__1843__S net137 vssd1 vssd1 vccd1 vccd1 sky130_fd_sc_hd__diode_2
X_2090_ net458 net42 net34 CALC_INST.gencon_inst.operand2\[8\] vssd1 vssd1 vccd1 vccd1
+ _0329_ sky130_fd_sc_hd__a22o_1
XFILLER_2_162 vssd1 vssd1 vccd1 vccd1 sky130_fd_sc_hd__fill_1
XFILLER_46_361 vssd1 vssd1 vccd1 vccd1 sky130_fd_sc_hd__fill_1
XFILLER_0_54 vssd1 vssd1 vccd1 vccd1 sky130_fd_sc_hd__fill_2
XTAP_TAPCELL_ROW_16_253 vssd1 vccd1 sky130_fd_sc_hd__tapvpwrvgnd_1
X_1943_ _0892_ _0893_ CALC_INST.gencon_inst.add_calc.main.GENERATE_ADDER\[5\].thingy.in1
+ vssd1 vssd1 vccd1 vccd1 _0894_ sky130_fd_sc_hd__a21oi_1
X_1874_ net134 CALC_INST.gencon_inst.mult_calc.adderSave\[3\] net123 net383 vssd1
+ vssd1 vccd1 vccd1 _0261_ sky130_fd_sc_hd__a22o_1
XANTENNA__2134__A2 net155 vssd1 vssd1 vccd1 vccd1 sky130_fd_sc_hd__diode_2
X_2426_ CALC_INST.input_ctrl_inst.col_index\[25\] CALC_INST.input_ctrl_inst.col_index\[24\]
+ CALC_INST.input_ctrl_inst.col_index\[27\] CALC_INST.input_ctrl_inst.col_index\[26\]
+ vssd1 vssd1 vccd1 vccd1 _0406_ sky130_fd_sc_hd__and4_1
X_1308_ CALC_INST.gencon_inst.operand1\[1\] CALC_INST.gencon_inst.latched_keypad_input\[1\]
+ vssd1 vssd1 vccd1 vccd1 _0502_ sky130_fd_sc_hd__xnor2_1
X_1239_ _0444_ _0445_ _0437_ _0439_ vssd1 vssd1 vccd1 vccd1 _0446_ sky130_fd_sc_hd__a211o_1
X_2357_ _1194_ vssd1 vssd1 vccd1 vccd1 _1195_ sky130_fd_sc_hd__inv_2
X_2288_ net139 net135 vssd1 vssd1 vccd1 vccd1 _1145_ sky130_fd_sc_hd__nor2_1
XFILLER_60_37 vssd1 vssd1 vccd1 vccd1 sky130_fd_sc_hd__fill_1
XFILLER_60_26 vssd1 vssd1 vccd1 vccd1 sky130_fd_sc_hd__fill_2
XFILLER_44_27 vssd1 vssd1 vccd1 vccd1 sky130_fd_sc_hd__fill_1
XFILLER_60_48 vssd1 vssd1 vccd1 vccd1 sky130_fd_sc_hd__fill_1
XANTENNA_fanout62_X net62 vssd1 vssd1 vccd1 vccd1 sky130_fd_sc_hd__diode_2
XFILLER_62_139 vssd1 vssd1 vccd1 vccd1 sky130_fd_sc_hd__fill_1
XFILLER_55_191 vssd1 vssd1 vccd1 vccd1 sky130_fd_sc_hd__fill_4
XFILLER_43_342 vssd1 vssd1 vccd1 vccd1 sky130_fd_sc_hd__fill_1
XTAP_TAPCELL_ROW_13_234 vssd1 vccd1 sky130_fd_sc_hd__tapvpwrvgnd_1
X_1590_ _0714_ _0715_ _0718_ vssd1 vssd1 vccd1 vccd1 _0113_ sky130_fd_sc_hd__or3_1
X_2142_ net58 _1021_ _1022_ vssd1 vssd1 vccd1 vccd1 _0361_ sky130_fd_sc_hd__and3b_1
XFILLER_38_114 vssd1 vssd1 vccd1 vccd1 sky130_fd_sc_hd__fill_2
X_2211_ _1068_ _1070_ vssd1 vssd1 vccd1 vccd1 _1071_ sky130_fd_sc_hd__nor2_1
XFILLER_19_383 vssd1 vssd1 vccd1 vccd1 sky130_fd_sc_hd__fill_1
XFILLER_19_361 vssd1 vssd1 vccd1 vccd1 sky130_fd_sc_hd__fill_2
X_2073_ net128 _1118_ net130 net288 vssd1 vssd1 vccd1 vccd1 _0314_ sky130_fd_sc_hd__a2bb2o_1
XFILLER_15_3 vccd1 vssd1 vccd1 vssd1 sky130_ef_sc_hd__decap_40_12
XFILLER_61_150 vssd1 vssd1 vccd1 vccd1 sky130_fd_sc_hd__fill_1
XFILLER_46_191 vssd1 vssd1 vccd1 vccd1 sky130_fd_sc_hd__fill_1
XPHY_EDGE_ROW_28_Left_93 vssd1 vssd1 vccd1 vccd1 sky130_fd_sc_hd__decap_3
X_1926_ net146 CALC_INST.gencon_inst.add_calc.main.in2\[9\] vssd1 vssd1 vccd1 vccd1
+ _0877_ sky130_fd_sc_hd__nand2_1
X_1857_ net231 net216 net138 vssd1 vssd1 vccd1 vccd1 _0245_ sky130_fd_sc_hd__mux2_1
X_1788_ _0809_ _0811_ vssd1 vssd1 vccd1 vccd1 _0812_ sky130_fd_sc_hd__xnor2_1
XPHY_EDGE_ROW_12_Left_77 vssd1 vssd1 vccd1 vccd1 sky130_fd_sc_hd__decap_3
XANTENNA_clkbuf_leaf_33_clk_A clknet_2_0__leaf_clk vssd1 vssd1 vccd1 vccd1 sky130_fd_sc_hd__diode_2
X_2409_ _0388_ vssd1 vssd1 vccd1 vccd1 _0389_ sky130_fd_sc_hd__inv_2
XTAP_TAPCELL_ROW_27_326 vssd1 vccd1 sky130_fd_sc_hd__tapvpwrvgnd_1
XANTENNA__1658__S net44 vssd1 vssd1 vccd1 vccd1 sky130_fd_sc_hd__diode_2
XFILLER_4_257 vssd1 vssd1 vccd1 vccd1 sky130_fd_sc_hd__fill_1
Xhold93 CALC_INST.gencon_inst.mult_calc.countSave\[11\] vssd1 vssd1 vccd1 vccd1 net292
+ sky130_fd_sc_hd__dlygate4sd3_1
Xhold82 CALC_INST.gencon_inst.mult_calc.countSave\[1\] vssd1 vssd1 vccd1 vccd1 net281
+ sky130_fd_sc_hd__dlygate4sd3_1
Xhold60 CALC_INST.gencon_inst.mult_calc.countSave\[2\] vssd1 vssd1 vccd1 vccd1 net259
+ sky130_fd_sc_hd__dlygate4sd3_1
Xhold71 CALC_INST.input_ctrl_inst.input_control_state\[2\] vssd1 vssd1 vccd1 vccd1
+ net270 sky130_fd_sc_hd__dlygate4sd3_1
XFILLER_16_342 vssd1 vssd1 vccd1 vccd1 sky130_fd_sc_hd__fill_1
XANTENNA__2034__B2 net126 vssd1 vssd1 vccd1 vccd1 sky130_fd_sc_hd__diode_2
X_1711_ net394 _0755_ net151 vssd1 vssd1 vccd1 vccd1 _0197_ sky130_fd_sc_hd__mux2_1
X_1642_ CALC_INST.gencon_inst.latched_operator_input\[1\] CALC_INST.gencon_inst.latched_operator_input\[0\]
+ CALC_INST.gencon_inst.latched_operator_input\[2\] vssd1 vssd1 vccd1 vccd1 _0725_
+ sky130_fd_sc_hd__or3b_1
X_2691_ clknet_leaf_24_clk _0250_ net105 vssd1 vssd1 vccd1 vccd1 CALC_INST.gencon_inst.mult_calc.main.GENERATE_ADDER\[8\].thingy.in1
+ sky130_fd_sc_hd__dfrtp_1
X_2760_ clknet_leaf_27_clk _0319_ net108 vssd1 vssd1 vccd1 vccd1 CALC_INST.gencon_inst.mult_calc.countSave\[13\]
+ sky130_fd_sc_hd__dfrtp_1
X_1573_ net20 _0660_ _0704_ _0655_ vssd1 vssd1 vccd1 vccd1 _0705_ sky130_fd_sc_hd__o22a_1
XANTENNA__1545__B1 net67 vssd1 vssd1 vccd1 vccd1 sky130_fd_sc_hd__diode_2
X_2056_ _0992_ _0994_ vssd1 vssd1 vccd1 vccd1 _0995_ sky130_fd_sc_hd__xnor2_1
XTAP_TAPCELL_ROW_49_484 vssd1 vccd1 sky130_fd_sc_hd__tapvpwrvgnd_1
XFILLER_41_109 vssd1 vssd1 vccd1 vccd1 sky130_fd_sc_hd__fill_2
X_2125_ CALC_INST.gencon_inst.keypad_input\[1\] _1005_ _1010_ _1012_ vssd1 vssd1 vccd1
+ vccd1 _1013_ sky130_fd_sc_hd__a22o_1
XTAP_TAPCELL_ROW_24_307 vssd1 vccd1 sky130_fd_sc_hd__tapvpwrvgnd_1
X_1909_ net147 CALC_INST.gencon_inst.add_calc.main.in2\[13\] vssd1 vssd1 vccd1 vccd1
+ _0860_ sky130_fd_sc_hd__or2_1
XTAP_TAPCELL_ROW_32_362 vssd1 vccd1 sky130_fd_sc_hd__tapvpwrvgnd_1
XANTENNA_fanout112_X net112 vssd1 vssd1 vccd1 vccd1 sky130_fd_sc_hd__diode_2
XFILLER_1_249 vccd1 vssd1 vccd1 vssd1 sky130_ef_sc_hd__decap_40_12
XANTENNA__1513__Y _0660_ vssd1 vssd1 vccd1 vccd1 sky130_fd_sc_hd__diode_2
XFILLER_57_297 vssd1 vssd1 vccd1 vccd1 sky130_fd_sc_hd__fill_2
XFILLER_13_334 vssd1 vssd1 vccd1 vccd1 sky130_fd_sc_hd__fill_2
XFILLER_31_83 vssd1 vssd1 vccd1 vccd1 sky130_fd_sc_hd__fill_8
Xteam_06_173 vssd1 vssd1 vccd1 vccd1 team_06_173/HI gpio_oeb[21] sky130_fd_sc_hd__conb_1
Xteam_06_162 vssd1 vssd1 vccd1 vccd1 team_06_162/HI gpio_oeb[10] sky130_fd_sc_hd__conb_1
Xteam_06_184 vssd1 vssd1 vccd1 vccd1 team_06_184/HI gpio_out[3] sky130_fd_sc_hd__conb_1
Xteam_06_195 vssd1 vssd1 vccd1 vccd1 gpio_oeb[29] team_06_195/LO sky130_fd_sc_hd__conb_1
XTAP_TAPCELL_ROW_46_465 vssd1 vccd1 sky130_fd_sc_hd__tapvpwrvgnd_1
XFILLER_0_293 vccd1 vssd1 vccd1 vssd1 sky130_ef_sc_hd__decap_40_12
X_2743_ clknet_leaf_19_clk _0302_ net119 vssd1 vssd1 vccd1 vccd1 CALC_INST.gencon_inst.ALU_out\[12\]
+ sky130_fd_sc_hd__dfrtp_1
X_2812_ clknet_leaf_6_clk _0354_ vssd1 vssd1 vccd1 vccd1 CALC_INST.gencon_inst.keypad_input\[1\]
+ sky130_fd_sc_hd__dfxtp_1
X_1625_ CALC_INST.gencon_inst.operand2\[4\] net267 net63 vssd1 vssd1 vccd1 vccd1 _0142_
+ sky130_fd_sc_hd__mux2_1
X_1556_ CALC_INST.gencon_inst.operand2\[11\] CALC_INST.gencon_inst.operand1\[11\]
+ net74 vssd1 vssd1 vccd1 vccd1 _0692_ sky130_fd_sc_hd__mux2_1
X_2674_ clknet_leaf_29_clk _0233_ net103 vssd1 vssd1 vccd1 vccd1 CALC_INST.gencon_inst.mult_calc.compCount.in2\[6\]
+ sky130_fd_sc_hd__dfrtp_1
XANTENNA__1766__B1 net127 vssd1 vssd1 vccd1 vccd1 sky130_fd_sc_hd__diode_2
X_1487_ CALC_INST.input_ctrl_inst.col_index\[29\] _0635_ vssd1 vssd1 vccd1 vccd1 _0638_
+ sky130_fd_sc_hd__and2_1
X_2039_ net32 _0977_ _0979_ net126 vssd1 vssd1 vccd1 vccd1 _0981_ sky130_fd_sc_hd__a31o_1
X_2108_ net135 net303 net124 CALC_INST.gencon_inst.mult_calc.count.GENERATE_ADDER\[10\].thingy.in1
+ vssd1 vssd1 vccd1 vccd1 _0347_ sky130_fd_sc_hd__a22o_1
XANTENNA__1508__Y _0655_ vssd1 vssd1 vccd1 vccd1 sky130_fd_sc_hd__diode_2
XPHY_EDGE_ROW_15_Left_80 vssd1 vssd1 vccd1 vccd1 sky130_fd_sc_hd__decap_3
XANTENNA__1846__S net137 vssd1 vssd1 vccd1 vccd1 sky130_fd_sc_hd__diode_2
X_1410_ net51 _0586_ net497 vssd1 vssd1 vccd1 vccd1 _0587_ sky130_fd_sc_hd__a21oi_1
X_1341_ _0491_ _0529_ vssd1 vssd1 vccd1 vccd1 _0530_ sky130_fd_sc_hd__nor2_1
X_1272_ CALC_INST.gencon_inst.operand2\[10\] _0471_ net37 vssd1 vssd1 vccd1 vccd1
+ _0042_ sky130_fd_sc_hd__mux2_1
X_2390_ _1085_ _1170_ _1218_ _1219_ vssd1 vssd1 vccd1 vccd1 _1220_ sky130_fd_sc_hd__o31a_1
XFILLER_3_65 vssd1 vssd1 vccd1 vccd1 sky130_fd_sc_hd__fill_2
X_2726_ clknet_leaf_26_clk _0285_ net110 vssd1 vssd1 vccd1 vccd1 CALC_INST.gencon_inst.mult_calc.out\[12\]
+ sky130_fd_sc_hd__dfrtp_1
Xfanout147 CALC_INST.gencon_inst.add_calc.diffSign vssd1 vssd1 vccd1 vccd1 net147
+ sky130_fd_sc_hd__buf_2
X_1608_ CALC_INST.gencon_inst.operand1\[3\] net258 net63 vssd1 vssd1 vccd1 vccd1 _0125_
+ sky130_fd_sc_hd__mux2_1
X_1539_ CALC_INST.gencon_inst.operand1\[6\] _0654_ _0660_ net483 _0679_ vssd1 vssd1
+ vccd1 vccd1 _0101_ sky130_fd_sc_hd__o221a_1
X_2588_ clknet_leaf_15_clk _0147_ vssd1 vssd1 vccd1 vccd1 CALC_INST.gencon_inst.ALU_in2\[9\]
+ sky130_fd_sc_hd__dfxtp_1
Xfanout114 net121 vssd1 vssd1 vccd1 vccd1 net114 sky130_fd_sc_hd__clkbuf_2
X_2657_ clknet_leaf_31_clk _0216_ net105 vssd1 vssd1 vccd1 vccd1 CALC_INST.gencon_inst.mult_calc.adderSave\[4\]
+ sky130_fd_sc_hd__dfrtp_1
Xfanout103 net104 vssd1 vssd1 vccd1 vccd1 net103 sky130_fd_sc_hd__clkbuf_2
Xfanout125 _1145_ vssd1 vssd1 vccd1 vccd1 net125 sky130_fd_sc_hd__clkbuf_2
Xfanout136 CALC_INST.gencon_inst.mult_calc.state\[4\] vssd1 vssd1 vccd1 vccd1 net136
+ sky130_fd_sc_hd__dlymetal6s2s_1
XTAP_TAPCELL_ROW_57_538 vssd1 vccd1 sky130_fd_sc_hd__tapvpwrvgnd_1
XFILLER_27_223 vssd1 vssd1 vccd1 vccd1 sky130_fd_sc_hd__fill_1
XFILLER_12_41 vccd1 vssd1 vccd1 vssd1 sky130_ef_sc_hd__decap_40_12
XFILLER_12_63 vssd1 vssd1 vccd1 vccd1 sky130_fd_sc_hd__fill_4
XFILLER_12_85 vssd1 vssd1 vccd1 vccd1 sky130_fd_sc_hd__fill_2
XPHY_EDGE_ROW_0_Left_65 vssd1 vssd1 vccd1 vccd1 sky130_fd_sc_hd__decap_3
Xhold190 CALC_INST.gencon_inst.mult_calc.main.GENERATE_ADDER\[10\].thingy.in2 vssd1
+ vssd1 vccd1 vccd1 net389 sky130_fd_sc_hd__dlygate4sd3_1
XFILLER_37_93 vssd1 vssd1 vccd1 vccd1 sky130_fd_sc_hd__fill_4
XPHY_EDGE_ROW_16_Right_16 vssd1 vssd1 vccd1 vccd1 sky130_fd_sc_hd__decap_3
XPHY_EDGE_ROW_25_Right_25 vssd1 vssd1 vccd1 vccd1 sky130_fd_sc_hd__decap_3
X_1890_ CALC_INST.gencon_inst.mult_calc.out\[4\] net434 net143 vssd1 vssd1 vccd1 vccd1
+ _0277_ sky130_fd_sc_hd__mux2_1
XFILLER_45_3 vssd1 vssd1 vccd1 vccd1 sky130_fd_sc_hd__fill_1
XFILLER_5_182 vssd1 vssd1 vccd1 vccd1 sky130_fd_sc_hd__fill_1
X_2511_ clknet_leaf_34_clk _0070_ net82 vssd1 vssd1 vccd1 vccd1 CALC_INST.input_ctrl_inst.col_index\[8\]
+ sky130_fd_sc_hd__dfrtp_1
X_2442_ net143 net454 CALC_INST.gencon_inst.mult_calc.start vssd1 vssd1 vccd1 vccd1
+ _0002_ sky130_fd_sc_hd__o21ba_1
X_2373_ CALC_INST.input_ctrl_inst.debounce_cnt\[13\] CALC_INST.input_ctrl_inst.debounce_cnt\[14\]
+ _1201_ vssd1 vssd1 vccd1 vccd1 _1206_ sky130_fd_sc_hd__and3_1
XFILLER_64_362 vssd1 vssd1 vccd1 vccd1 sky130_fd_sc_hd__fill_2
X_1324_ CALC_INST.gencon_inst.operand1\[3\] CALC_INST.gencon_inst.latched_keypad_input\[3\]
+ vssd1 vssd1 vccd1 vccd1 _0516_ sky130_fd_sc_hd__or2_1
X_1255_ CALC_INST.gencon_inst.mult_calc.out\[6\] net50 _0458_ net55 _0422_ vssd1 vssd1
+ vccd1 vccd1 _0459_ sky130_fd_sc_hd__a221o_1
XPHY_EDGE_ROW_34_Right_34 vssd1 vssd1 vccd1 vccd1 sky130_fd_sc_hd__decap_3
XTAP_TAPCELL_ROW_62_574 vssd1 vccd1 sky130_fd_sc_hd__tapvpwrvgnd_1
XTAP_TAPCELL_ROW_54_519 vssd1 vccd1 sky130_fd_sc_hd__tapvpwrvgnd_1
XFILLER_33_29 vssd1 vssd1 vccd1 vccd1 sky130_fd_sc_hd__fill_1
XFILLER_24_248 vssd1 vssd1 vccd1 vccd1 sky130_fd_sc_hd__fill_4
XTAP_TAPCELL_ROW_19_273 vssd1 vccd1 sky130_fd_sc_hd__tapvpwrvgnd_1
XPHY_EDGE_ROW_43_Right_43 vssd1 vssd1 vccd1 vccd1 sky130_fd_sc_hd__decap_3
X_2709_ clknet_leaf_26_clk net390 net108 vssd1 vssd1 vccd1 vccd1 CALC_INST.gencon_inst.mult_calc.main.GENERATE_ADDER\[10\].thingy.in2
+ sky130_fd_sc_hd__dfrtp_1
XFILLER_59_167 vssd1 vssd1 vccd1 vccd1 sky130_fd_sc_hd__fill_1
XFILLER_58_15 vssd1 vssd1 vccd1 vccd1 sky130_fd_sc_hd__fill_4
XPHY_EDGE_ROW_52_Right_52 vssd1 vssd1 vccd1 vccd1 sky130_fd_sc_hd__decap_3
XANTENNA__1380__A_N _0560_ vssd1 vssd1 vccd1 vccd1 sky130_fd_sc_hd__diode_2
XFILLER_55_362 vssd1 vssd1 vccd1 vccd1 sky130_fd_sc_hd__fill_2
XFILLER_55_351 vssd1 vssd1 vccd1 vccd1 sky130_fd_sc_hd__fill_1
XTAP_TAPCELL_ROW_2_152 vssd1 vccd1 sky130_fd_sc_hd__tapvpwrvgnd_1
XANTENNA_fanout52_A net53 vssd1 vssd1 vccd1 vccd1 sky130_fd_sc_hd__diode_2
XPHY_EDGE_ROW_61_Right_61 vssd1 vssd1 vccd1 vccd1 sky130_fd_sc_hd__decap_3
XPHY_EDGE_ROW_36_Left_101 vssd1 vssd1 vccd1 vccd1 sky130_fd_sc_hd__decap_3
XANTENNA__2081__A net34 vssd1 vssd1 vccd1 vccd1 sky130_fd_sc_hd__diode_2
XFILLER_23_281 vssd1 vssd1 vccd1 vccd1 sky130_fd_sc_hd__fill_8
XFILLER_7_403 vssd1 vssd1 vccd1 vccd1 sky130_fd_sc_hd__fill_1
XFILLER_2_141 vssd1 vssd1 vccd1 vccd1 sky130_fd_sc_hd__fill_2
XPHY_EDGE_ROW_45_Left_110 vssd1 vssd1 vccd1 vccd1 sky130_fd_sc_hd__decap_3
XFILLER_0_22 vssd1 vssd1 vccd1 vccd1 sky130_fd_sc_hd__fill_1
XFILLER_17_7 vssd1 vssd1 vccd1 vccd1 sky130_fd_sc_hd__fill_1
X_1942_ CALC_INST.gencon_inst.add_calc.diffSign CALC_INST.gencon_inst.add_calc.main.in2\[5\]
+ vssd1 vssd1 vccd1 vccd1 _0893_ sky130_fd_sc_hd__nand2_1
XTAP_TAPCELL_ROW_16_254 vssd1 vccd1 sky130_fd_sc_hd__tapvpwrvgnd_1
XANTENNA__1319__B _0490_ vssd1 vssd1 vccd1 vccd1 sky130_fd_sc_hd__diode_2
X_1873_ net134 CALC_INST.gencon_inst.mult_calc.adderSave\[2\] net123 net432 vssd1
+ vssd1 vccd1 vccd1 _0260_ sky130_fd_sc_hd__a22o_1
X_2356_ CALC_INST.input_ctrl_inst.debounce_cnt\[7\] CALC_INST.input_ctrl_inst.debounce_cnt\[9\]
+ CALC_INST.input_ctrl_inst.debounce_cnt\[8\] _1186_ vssd1 vssd1 vccd1 vccd1 _1194_
+ sky130_fd_sc_hd__and4_1
X_2425_ _0403_ _0404_ vssd1 vssd1 vccd1 vccd1 _0405_ sky130_fd_sc_hd__nor2_1
X_1307_ CALC_INST.gencon_inst.operand1\[1\] CALC_INST.gencon_inst.latched_keypad_input\[1\]
+ vssd1 vssd1 vccd1 vccd1 _0501_ sky130_fd_sc_hd__and2_1
XFILLER_37_351 vssd1 vssd1 vccd1 vccd1 sky130_fd_sc_hd__fill_2
X_1238_ CALC_INST.gencon_inst.operand2\[3\] CALC_INST.gencon_inst.latched_keypad_input\[3\]
+ vssd1 vssd1 vccd1 vccd1 _0445_ sky130_fd_sc_hd__or2_1
X_2287_ net141 _1138_ _1144_ vssd1 vssd1 vccd1 vccd1 _0006_ sky130_fd_sc_hd__a21o_1
XANTENNA_clkbuf_leaf_7_clk_A clknet_2_1__leaf_clk vssd1 vssd1 vccd1 vccd1 sky130_fd_sc_hd__diode_2
XFILLER_12_229 vssd1 vssd1 vccd1 vccd1 sky130_fd_sc_hd__fill_2
XANTENNA__1581__A1 net45 vssd1 vssd1 vccd1 vccd1 sky130_fd_sc_hd__diode_2
XANTENNA__1532__X _0674_ vssd1 vssd1 vccd1 vccd1 sky130_fd_sc_hd__diode_2
XFILLER_34_83 vssd1 vssd1 vccd1 vccd1 sky130_fd_sc_hd__fill_1
XANTENNA__1854__S net137 vssd1 vssd1 vccd1 vccd1 sky130_fd_sc_hd__diode_2
XTAP_TAPCELL_ROW_21_290 vssd1 vccd1 sky130_fd_sc_hd__tapvpwrvgnd_1
XFILLER_7_233 vssd1 vssd1 vccd1 vccd1 sky130_fd_sc_hd__fill_1
XFILLER_7_266 vssd1 vssd1 vccd1 vccd1 sky130_fd_sc_hd__fill_1
XFILLER_7_277 vssd1 vssd1 vccd1 vccd1 sky130_fd_sc_hd__fill_2
XFILLER_11_240 vssd1 vssd1 vccd1 vccd1 sky130_fd_sc_hd__fill_2
X_2210_ CALC_INST.input_ctrl_inst.input_control_state\[1\] CALC_INST.input_ctrl_inst.input_control_state\[3\]
+ CALC_INST.input_ctrl_inst.input_control_state\[2\] CALC_INST.input_ctrl_inst.input_control_state\[0\]
+ vssd1 vssd1 vccd1 vccd1 _1070_ sky130_fd_sc_hd__or4bb_1
X_2141_ _1146_ net53 vssd1 vssd1 vccd1 vccd1 _1022_ sky130_fd_sc_hd__or2_2
XFILLER_38_137 vssd1 vssd1 vccd1 vccd1 sky130_fd_sc_hd__fill_2
XFILLER_34_321 vssd1 vssd1 vccd1 vccd1 sky130_fd_sc_hd__fill_2
X_2072_ net127 _1115_ net130 net289 vssd1 vssd1 vccd1 vccd1 _0313_ sky130_fd_sc_hd__a2bb2o_1
X_1925_ net146 CALC_INST.gencon_inst.add_calc.main.in2\[9\] vssd1 vssd1 vccd1 vccd1
+ _0876_ sky130_fd_sc_hd__or2_1
XFILLER_34_365 vssd1 vssd1 vccd1 vccd1 sky130_fd_sc_hd__fill_2
X_1856_ net222 net209 net137 vssd1 vssd1 vccd1 vccd1 _0244_ sky130_fd_sc_hd__mux2_1
X_1787_ _0801_ _0810_ vssd1 vssd1 vccd1 vccd1 _0811_ sky130_fd_sc_hd__or2_1
XFILLER_57_402 vssd1 vssd1 vccd1 vccd1 sky130_fd_sc_hd__fill_4
XPHY_EDGE_ROW_2_Right_2 vssd1 vssd1 vccd1 vccd1 sky130_fd_sc_hd__decap_3
X_2339_ net38 _1180_ _1181_ net40 CALC_INST.input_ctrl_inst.debounce_cnt\[4\] vssd1
+ vssd1 vccd1 vccd1 _0021_ sky130_fd_sc_hd__a32o_1
X_2408_ _1227_ net80 _0387_ vssd1 vssd1 vccd1 vccd1 _0388_ sky130_fd_sc_hd__o21a_1
XANTENNA__1512__B _0656_ vssd1 vssd1 vccd1 vccd1 sky130_fd_sc_hd__diode_2
XTAP_TAPCELL_ROW_35_382 vssd1 vccd1 sky130_fd_sc_hd__tapvpwrvgnd_1
XTAP_TAPCELL_ROW_27_327 vssd1 vccd1 sky130_fd_sc_hd__tapvpwrvgnd_1
XFILLER_40_357 vssd1 vssd1 vccd1 vccd1 sky130_fd_sc_hd__fill_4
XFILLER_4_203 vccd1 vssd1 vccd1 vssd1 sky130_ef_sc_hd__decap_40_12
XANTENNA__1554__B2 _0656_ vssd1 vssd1 vccd1 vccd1 sky130_fd_sc_hd__diode_2
XFILLER_20_85 vssd1 vssd1 vccd1 vccd1 sky130_fd_sc_hd__fill_4
XFILLER_63_405 vssd1 vssd1 vccd1 vccd1 sky130_fd_sc_hd__fill_2
Xhold61 CALC_INST.gencon_inst.ALU_in2\[5\] vssd1 vssd1 vccd1 vccd1 net260 sky130_fd_sc_hd__dlygate4sd3_1
Xhold50 CALC_INST.gencon_inst.ALU_in1\[13\] vssd1 vssd1 vccd1 vccd1 net249 sky130_fd_sc_hd__dlygate4sd3_1
Xhold72 net12 vssd1 vssd1 vccd1 vccd1 net271 sky130_fd_sc_hd__dlygate4sd3_1
XFILLER_29_83 vssd1 vssd1 vccd1 vccd1 sky130_fd_sc_hd__fill_2
Xhold94 CALC_INST.gencon_inst.mult_calc.count.GENERATE_ADDER\[11\].thingy.in1 vssd1
+ vssd1 vccd1 vccd1 net293 sky130_fd_sc_hd__dlygate4sd3_1
Xhold83 _0338_ vssd1 vssd1 vccd1 vccd1 net282 sky130_fd_sc_hd__dlygate4sd3_1
XFILLER_45_60 vssd1 vssd1 vccd1 vccd1 sky130_fd_sc_hd__fill_1
XFILLER_31_335 vssd1 vssd1 vccd1 vccd1 sky130_fd_sc_hd__fill_1
XFILLER_16_398 vssd1 vssd1 vccd1 vccd1 sky130_fd_sc_hd__fill_8
X_1710_ CALC_INST.gencon_inst.ALU_in1\[6\] CALC_INST.gencon_inst.ALU_in2\[6\] net62
+ vssd1 vssd1 vccd1 vccd1 _0755_ sky130_fd_sc_hd__mux2_1
X_1641_ CALC_INST.gencon_inst.latched_operator_input\[0\] net265 net63 vssd1 vssd1
+ vccd1 vccd1 _0158_ sky130_fd_sc_hd__mux2_1
X_1572_ CALC_INST.gencon_inst.operand2\[15\] CALC_INST.gencon_inst.operand1\[15\]
+ net73 vssd1 vssd1 vccd1 vccd1 _0704_ sky130_fd_sc_hd__mux2_1
XANTENNA__1242__B1 net49 vssd1 vssd1 vccd1 vccd1 sky130_fd_sc_hd__diode_2
X_2690_ clknet_leaf_23_clk _0249_ net106 vssd1 vssd1 vccd1 vccd1 CALC_INST.gencon_inst.mult_calc.main.GENERATE_ADDER\[7\].thingy.in1
+ sky130_fd_sc_hd__dfrtp_1
X_2124_ _1005_ _1011_ vssd1 vssd1 vccd1 vccd1 _1012_ sky130_fd_sc_hd__nor2_1
X_2055_ _0928_ _0993_ vssd1 vssd1 vccd1 vccd1 _0994_ sky130_fd_sc_hd__xnor2_1
XTAP_TAPCELL_ROW_49_485 vssd1 vccd1 sky130_fd_sc_hd__tapvpwrvgnd_1
XTAP_TAPCELL_ROW_24_308 vssd1 vccd1 sky130_fd_sc_hd__tapvpwrvgnd_1
X_1908_ _0857_ _0858_ CALC_INST.gencon_inst.add_calc.main.GENERATE_ADDER\[14\].thingy.in1
+ vssd1 vssd1 vccd1 vccd1 _0859_ sky130_fd_sc_hd__a21oi_1
XFILLER_34_195 vssd1 vssd1 vccd1 vccd1 sky130_fd_sc_hd__fill_1
XTAP_TAPCELL_ROW_32_363 vssd1 vccd1 sky130_fd_sc_hd__tapvpwrvgnd_1
XFILLER_22_346 vssd1 vssd1 vccd1 vccd1 sky130_fd_sc_hd__fill_2
X_1839_ net297 CALC_INST.gencon_inst.mult_calc.INn2\[0\] net137 vssd1 vssd1 vccd1
+ vccd1 _0227_ sky130_fd_sc_hd__mux2_1
XFILLER_57_265 vssd1 vssd1 vccd1 vccd1 sky130_fd_sc_hd__fill_1
XFILLER_57_221 vssd1 vssd1 vccd1 vccd1 sky130_fd_sc_hd__fill_2
XFILLER_9_317 vssd1 vssd1 vccd1 vccd1 sky130_fd_sc_hd__fill_4
XFILLER_13_357 vssd1 vssd1 vccd1 vccd1 sky130_fd_sc_hd__fill_4
Xteam_06_196 vssd1 vssd1 vccd1 vccd1 gpio_oeb[30] team_06_196/LO sky130_fd_sc_hd__conb_1
Xteam_06_163 vssd1 vssd1 vccd1 vccd1 team_06_163/HI gpio_oeb[11] sky130_fd_sc_hd__conb_1
Xteam_06_185 vssd1 vssd1 vccd1 vccd1 team_06_185/HI gpio_out[29] sky130_fd_sc_hd__conb_1
Xteam_06_174 vssd1 vssd1 vccd1 vccd1 team_06_174/HI gpio_oeb[22] sky130_fd_sc_hd__conb_1
Xclkbuf_leaf_28_clk clknet_2_2__leaf_clk vssd1 vssd1 vccd1 vccd1 clknet_leaf_28_clk
+ sky130_fd_sc_hd__clkbuf_8
X_2742_ clknet_leaf_18_clk _0301_ net120 vssd1 vssd1 vccd1 vccd1 CALC_INST.gencon_inst.ALU_out\[11\]
+ sky130_fd_sc_hd__dfrtp_1
X_2811_ clknet_leaf_5_clk _0353_ vssd1 vssd1 vccd1 vccd1 CALC_INST.gencon_inst.keypad_input\[0\]
+ sky130_fd_sc_hd__dfxtp_1
XFILLER_31_143 vssd1 vssd1 vccd1 vccd1 sky130_fd_sc_hd__fill_2
XANTENNA__2803__RESET_B net112 vssd1 vssd1 vccd1 vccd1 sky130_fd_sc_hd__diode_2
XFILLER_8_361 vssd1 vssd1 vccd1 vccd1 sky130_fd_sc_hd__fill_1
XANTENNA_clkbuf_leaf_32_clk_A clknet_2_0__leaf_clk vssd1 vssd1 vccd1 vccd1 sky130_fd_sc_hd__diode_2
X_1624_ CALC_INST.gencon_inst.operand2\[3\] net252 net64 vssd1 vssd1 vccd1 vccd1 _0141_
+ sky130_fd_sc_hd__mux2_1
X_1555_ _0689_ _0691_ vssd1 vssd1 vccd1 vccd1 _0105_ sky130_fd_sc_hd__or2_1
X_2673_ clknet_leaf_29_clk _0232_ net104 vssd1 vssd1 vccd1 vccd1 CALC_INST.gencon_inst.mult_calc.compCount.in2\[5\]
+ sky130_fd_sc_hd__dfrtp_1
Xclkbuf_leaf_19_clk clknet_2_3__leaf_clk vssd1 vssd1 vccd1 vccd1 clknet_leaf_19_clk
+ sky130_fd_sc_hd__clkbuf_8
XTAP_TAPCELL_ROW_37_400 vssd1 vccd1 sky130_fd_sc_hd__tapvpwrvgnd_1
XFILLER_36_29 vssd1 vssd1 vccd1 vccd1 sky130_fd_sc_hd__fill_2
X_1486_ CALC_INST.input_ctrl_inst.col_index\[29\] _0635_ vssd1 vssd1 vccd1 vccd1 _0637_
+ sky130_fd_sc_hd__nor2_1
X_2107_ net135 net309 net124 CALC_INST.gencon_inst.mult_calc.count.GENERATE_ADDER\[9\].thingy.in1
+ vssd1 vssd1 vccd1 vccd1 _0346_ sky130_fd_sc_hd__a22o_1
XANTENNA__2439__A net127 vssd1 vssd1 vccd1 vccd1 sky130_fd_sc_hd__diode_2
X_2038_ net32 _0977_ _0979_ vssd1 vssd1 vccd1 vccd1 _0980_ sky130_fd_sc_hd__a21oi_1
XFILLER_22_154 vssd1 vssd1 vccd1 vccd1 sky130_fd_sc_hd__fill_2
XANTENNA__1518__A _0655_ vssd1 vssd1 vccd1 vccd1 sky130_fd_sc_hd__diode_2
XANTENNA_fanout82_A net93 vssd1 vssd1 vccd1 vccd1 sky130_fd_sc_hd__diode_2
XFILLER_45_235 vssd1 vssd1 vccd1 vccd1 sky130_fd_sc_hd__fill_1
XFILLER_45_202 vssd1 vssd1 vccd1 vccd1 sky130_fd_sc_hd__fill_2
XFILLER_26_73 vssd1 vssd1 vccd1 vccd1 sky130_fd_sc_hd__fill_4
XFILLER_26_40 vssd1 vssd1 vccd1 vccd1 sky130_fd_sc_hd__fill_1
XFILLER_42_83 vssd1 vssd1 vccd1 vccd1 sky130_fd_sc_hd__fill_1
XFILLER_9_158 vssd1 vssd1 vccd1 vccd1 sky130_fd_sc_hd__fill_4
XANTENNA__1748__A1 net141 vssd1 vssd1 vccd1 vccd1 sky130_fd_sc_hd__diode_2
X_1340_ _0514_ _0517_ CALC_INST.gencon_inst.operand1\[4\] CALC_INST.gencon_inst.operand1\[5\]
+ CALC_INST.gencon_inst.operand1\[6\] vssd1 vssd1 vccd1 vccd1 _0529_ sky130_fd_sc_hd__o2111a_1
XFILLER_5_342 vssd1 vssd1 vccd1 vccd1 sky130_fd_sc_hd__fill_4
X_1271_ CALC_INST.gencon_inst.mult_calc.out\[10\] net49 _0470_ net55 vssd1 vssd1 vccd1
+ vccd1 _0471_ sky130_fd_sc_hd__a22o_1
XFILLER_51_238 vssd1 vssd1 vccd1 vccd1 sky130_fd_sc_hd__fill_1
XFILLER_51_205 vssd1 vssd1 vccd1 vccd1 sky130_fd_sc_hd__fill_2
Xclkbuf_leaf_8_clk clknet_2_1__leaf_clk vssd1 vssd1 vccd1 vccd1 clknet_leaf_8_clk
+ sky130_fd_sc_hd__clkbuf_8
X_2656_ clknet_leaf_32_clk _0215_ net101 vssd1 vssd1 vccd1 vccd1 CALC_INST.gencon_inst.mult_calc.adderSave\[3\]
+ sky130_fd_sc_hd__dfrtp_1
X_2725_ clknet_leaf_26_clk _0284_ net109 vssd1 vssd1 vccd1 vccd1 CALC_INST.gencon_inst.mult_calc.out\[11\]
+ sky130_fd_sc_hd__dfrtp_1
Xfanout126 _1056_ vssd1 vssd1 vccd1 vccd1 net126 sky130_fd_sc_hd__buf_2
Xfanout115 net121 vssd1 vssd1 vccd1 vccd1 net115 sky130_fd_sc_hd__clkbuf_4
X_1607_ CALC_INST.gencon_inst.operand1\[2\] net251 net64 vssd1 vssd1 vccd1 vccd1 _0124_
+ sky130_fd_sc_hd__mux2_1
X_2587_ clknet_leaf_15_clk _0146_ vssd1 vssd1 vccd1 vccd1 CALC_INST.gencon_inst.ALU_in2\[8\]
+ sky130_fd_sc_hd__dfxtp_1
X_1538_ _0677_ _0678_ vssd1 vssd1 vccd1 vccd1 _0679_ sky130_fd_sc_hd__or2_1
Xfanout148 CALC_INST.gencon_inst.gencon_state\[1\] vssd1 vssd1 vccd1 vccd1 net148
+ sky130_fd_sc_hd__clkbuf_2
X_1469_ _0401_ _0596_ CALC_INST.input_ctrl_inst.col_index\[24\] vssd1 vssd1 vccd1
+ vccd1 _0625_ sky130_fd_sc_hd__a21oi_1
Xfanout137 CALC_INST.gencon_inst.mult_calc.state\[3\] vssd1 vssd1 vccd1 vccd1 net137
+ sky130_fd_sc_hd__clkbuf_4
Xfanout104 net112 vssd1 vssd1 vccd1 vccd1 net104 sky130_fd_sc_hd__clkbuf_2
XFILLER_63_49 vssd1 vssd1 vccd1 vccd1 sky130_fd_sc_hd__fill_2
XTAP_TAPCELL_ROW_57_539 vssd1 vccd1 sky130_fd_sc_hd__tapvpwrvgnd_1
XFILLER_27_257 vssd1 vssd1 vccd1 vccd1 sky130_fd_sc_hd__fill_2
XTAP_TAPCELL_ROW_40_417 vssd1 vccd1 sky130_fd_sc_hd__tapvpwrvgnd_1
XFILLER_6_117 vssd1 vssd1 vccd1 vccd1 sky130_fd_sc_hd__fill_2
XFILLER_2_345 vccd1 vssd1 vccd1 vssd1 sky130_ef_sc_hd__decap_40_12
XFILLER_12_53 vssd1 vssd1 vccd1 vccd1 sky130_fd_sc_hd__fill_2
Xhold180 CALC_INST.gencon_inst.mult_calc.adderSave\[9\] vssd1 vssd1 vccd1 vccd1 net379
+ sky130_fd_sc_hd__dlygate4sd3_1
XFILLER_58_382 vssd1 vssd1 vccd1 vccd1 sky130_fd_sc_hd__fill_2
XFILLER_58_360 vssd1 vssd1 vccd1 vccd1 sky130_fd_sc_hd__fill_4
XANTENNA__2458__A2 net49 vssd1 vssd1 vccd1 vccd1 sky130_fd_sc_hd__diode_2
XFILLER_2_367 vccd1 vssd1 vccd1 vssd1 sky130_ef_sc_hd__decap_40_12
XTAP_TAPCELL_ROW_5_172 vssd1 vccd1 sky130_fd_sc_hd__tapvpwrvgnd_1
Xhold191 _0268_ vssd1 vssd1 vccd1 vccd1 net390 sky130_fd_sc_hd__dlygate4sd3_1
XFILLER_37_61 vssd1 vssd1 vccd1 vccd1 sky130_fd_sc_hd__fill_2
XANTENNA__2091__B1 net34 vssd1 vssd1 vccd1 vccd1 sky130_fd_sc_hd__diode_2
X_2510_ clknet_leaf_1_clk _0069_ net85 vssd1 vssd1 vccd1 vccd1 CALC_INST.input_ctrl_inst.col_index\[7\]
+ sky130_fd_sc_hd__dfrtp_1
X_2441_ net277 net334 vssd1 vssd1 vccd1 vccd1 _0001_ sky130_fd_sc_hd__and2_1
X_1323_ CALC_INST.gencon_inst.operand1\[3\] CALC_INST.gencon_inst.latched_keypad_input\[3\]
+ vssd1 vssd1 vccd1 vccd1 _0515_ sky130_fd_sc_hd__nand2_1
X_2372_ _1049_ _1064_ vssd1 vssd1 vccd1 vccd1 _1205_ sky130_fd_sc_hd__or2_1
X_1254_ CALC_INST.gencon_inst.operand2\[6\] _0455_ vssd1 vssd1 vccd1 vccd1 _0458_
+ sky130_fd_sc_hd__xor2_1
XTAP_TAPCELL_ROW_19_274 vssd1 vccd1 sky130_fd_sc_hd__tapvpwrvgnd_1
XTAP_TAPCELL_ROW_62_575 vssd1 vccd1 sky130_fd_sc_hd__tapvpwrvgnd_1
XFILLER_33_19 vssd1 vssd1 vccd1 vccd1 sky130_fd_sc_hd__fill_2
XANTENNA__2082__B1 net34 vssd1 vssd1 vccd1 vccd1 sky130_fd_sc_hd__diode_2
XFILLER_24_238 vssd1 vssd1 vccd1 vccd1 sky130_fd_sc_hd__fill_2
X_2639_ clknet_leaf_15_clk _0198_ net116 vssd1 vssd1 vccd1 vccd1 CALC_INST.gencon_inst.add_calc.main.in2\[7\]
+ sky130_fd_sc_hd__dfrtp_1
X_2708_ clknet_leaf_26_clk _0267_ net109 vssd1 vssd1 vccd1 vccd1 CALC_INST.gencon_inst.mult_calc.main.GENERATE_ADDER\[9\].thingy.in2
+ sky130_fd_sc_hd__dfrtp_1
XFILLER_55_330 vssd1 vssd1 vccd1 vccd1 sky130_fd_sc_hd__fill_2
XTAP_TAPCELL_ROW_2_153 vssd1 vccd1 sky130_fd_sc_hd__tapvpwrvgnd_1
XANTENNA__2376__A1 CALC_INST.input_ctrl_inst.key_pressed vssd1 vssd1 vccd1 vccd1 sky130_fd_sc_hd__diode_2
XANTENNA__2073__B1 net130 vssd1 vssd1 vccd1 vccd1 sky130_fd_sc_hd__diode_2
XFILLER_2_175 vssd1 vssd1 vccd1 vccd1 sky130_fd_sc_hd__fill_1
XANTENNA__2647__RESET_B net99 vssd1 vssd1 vccd1 vccd1 sky130_fd_sc_hd__diode_2
X_1941_ net145 CALC_INST.gencon_inst.add_calc.main.in2\[5\] vssd1 vssd1 vccd1 vccd1
+ _0892_ sky130_fd_sc_hd__or2_1
XFILLER_61_322 vssd1 vssd1 vccd1 vccd1 sky130_fd_sc_hd__fill_2
X_1872_ net134 net338 net122 net446 vssd1 vssd1 vccd1 vccd1 _0259_ sky130_fd_sc_hd__a22o_1
XTAP_TAPCELL_ROW_16_255 vssd1 vccd1 sky130_fd_sc_hd__tapvpwrvgnd_1
X_1306_ CALC_INST.gencon_inst.operand1\[0\] net47 _0499_ _0500_ vssd1 vssd1 vccd1
+ vccd1 _0047_ sky130_fd_sc_hd__o22a_1
XANTENNA__1878__B1 net122 vssd1 vssd1 vccd1 vccd1 sky130_fd_sc_hd__diode_2
X_2355_ CALC_INST.input_ctrl_inst.debounce_cnt\[9\] _1191_ vssd1 vssd1 vccd1 vccd1
+ _1193_ sky130_fd_sc_hd__or2_1
X_2424_ CALC_INST.input_ctrl_inst.col_index\[25\] CALC_INST.input_ctrl_inst.col_index\[24\]
+ CALC_INST.input_ctrl_inst.col_index\[27\] CALC_INST.input_ctrl_inst.col_index\[26\]
+ vssd1 vssd1 vccd1 vccd1 _0404_ sky130_fd_sc_hd__or4_1
X_2286_ CALC_INST.gencon_inst.mult_calc.start net144 _1143_ net139 vssd1 vssd1 vccd1
+ vccd1 _1144_ sky130_fd_sc_hd__a22o_1
XFILLER_64_182 vssd1 vssd1 vccd1 vccd1 sky130_fd_sc_hd__fill_2
XFILLER_64_160 vssd1 vssd1 vccd1 vccd1 sky130_fd_sc_hd__fill_8
XFILLER_44_29 vssd1 vssd1 vccd1 vccd1 sky130_fd_sc_hd__fill_2
XANTENNA__1351__A _0491_ vssd1 vssd1 vccd1 vccd1 sky130_fd_sc_hd__diode_2
XFILLER_37_341 vssd1 vssd1 vccd1 vccd1 sky130_fd_sc_hd__fill_2
X_1237_ CALC_INST.gencon_inst.operand2\[3\] CALC_INST.gencon_inst.latched_keypad_input\[3\]
+ vssd1 vssd1 vccd1 vccd1 _0444_ sky130_fd_sc_hd__nand2_1
XANTENNA__1526__A _0655_ vssd1 vssd1 vccd1 vccd1 sky130_fd_sc_hd__diode_2
XFILLER_28_363 vssd1 vssd1 vccd1 vccd1 sky130_fd_sc_hd__fill_1
XFILLER_50_94 vssd1 vssd1 vccd1 vccd1 sky130_fd_sc_hd__fill_4
XFILLER_7_223 vssd1 vssd1 vccd1 vccd1 sky130_fd_sc_hd__fill_1
XFILLER_59_81 vccd1 vssd1 vccd1 vssd1 sky130_ef_sc_hd__decap_40_12
X_2140_ _1081_ net94 CALC_INST.input_ctrl_inst.scan_timer\[0\] vssd1 vssd1 vccd1 vccd1
+ _1021_ sky130_fd_sc_hd__a21o_1
XFILLER_38_116 vssd1 vssd1 vccd1 vccd1 sky130_fd_sc_hd__fill_1
XFILLER_34_344 vssd1 vssd1 vccd1 vccd1 sky130_fd_sc_hd__fill_2
XFILLER_34_311 vssd1 vssd1 vccd1 vccd1 sky130_fd_sc_hd__fill_1
XFILLER_19_363 vssd1 vssd1 vccd1 vccd1 sky130_fd_sc_hd__fill_1
X_2071_ net127 _1113_ net129 net315 vssd1 vssd1 vccd1 vccd1 _0312_ sky130_fd_sc_hd__a2bb2o_1
X_1924_ CALC_INST.gencon_inst.add_calc.main.GENERATE_ADDER\[10\].thingy.in1 _0872_
+ _0873_ vssd1 vssd1 vccd1 vccd1 _0875_ sky130_fd_sc_hd__nand3_1
X_1855_ net223 net210 net137 vssd1 vssd1 vccd1 vccd1 _0243_ sky130_fd_sc_hd__mux2_1
X_1786_ _0788_ _0794_ _0797_ _0802_ _0795_ vssd1 vssd1 vccd1 vccd1 _0810_ sky130_fd_sc_hd__o311a_1
X_2338_ CALC_INST.input_ctrl_inst.debounce_cnt\[4\] _1177_ vssd1 vssd1 vccd1 vccd1
+ _1181_ sky130_fd_sc_hd__nand2_1
X_2269_ CALC_INST.gencon_inst.mult_calc.count.GENERATE_ADDER\[10\].thingy.in1 _1093_
+ CALC_INST.gencon_inst.mult_calc.count.GENERATE_ADDER\[11\].thingy.in1 vssd1 vssd1
+ vccd1 vccd1 _1127_ sky130_fd_sc_hd__a21oi_1
X_2407_ CALC_INST.input_ctrl_inst.col_index\[5\] CALC_INST.input_ctrl_inst.col_index\[4\]
+ CALC_INST.input_ctrl_inst.col_index\[7\] CALC_INST.input_ctrl_inst.col_index\[6\]
+ _0386_ vssd1 vssd1 vccd1 vccd1 _0387_ sky130_fd_sc_hd__a41o_1
XPHY_EDGE_ROW_64_Left_129 vssd1 vssd1 vccd1 vccd1 sky130_fd_sc_hd__decap_3
XTAP_TAPCELL_ROW_35_383 vssd1 vccd1 sky130_fd_sc_hd__tapvpwrvgnd_1
XTAP_TAPCELL_ROW_27_328 vssd1 vccd1 sky130_fd_sc_hd__tapvpwrvgnd_1
XFILLER_4_215 vssd1 vssd1 vccd1 vccd1 sky130_fd_sc_hd__fill_4
XFILLER_20_31 vssd1 vssd1 vccd1 vccd1 sky130_fd_sc_hd__fill_1
XANTENNA__1306__A2 net47 vssd1 vssd1 vccd1 vccd1 sky130_fd_sc_hd__diode_2
XANTENNA__1554__A2 _0659_ vssd1 vssd1 vccd1 vccd1 sky130_fd_sc_hd__diode_2
Xhold40 CALC_INST.gencon_inst.mult_calc.main.GENERATE_ADDER\[6\].thingy.in1 vssd1
+ vssd1 vccd1 vccd1 net239 sky130_fd_sc_hd__dlygate4sd3_1
Xhold84 CALC_INST.gencon_inst.ALU_in1\[9\] vssd1 vssd1 vccd1 vccd1 net283 sky130_fd_sc_hd__dlygate4sd3_1
Xhold62 net16 vssd1 vssd1 vccd1 vccd1 net261 sky130_fd_sc_hd__dlygate4sd3_1
Xhold51 CALC_INST.gencon_inst.mult_calc.INn1\[15\] vssd1 vssd1 vccd1 vccd1 net250
+ sky130_fd_sc_hd__dlygate4sd3_1
Xhold73 CALC_INST.gencon_inst.mult_calc.diffSign vssd1 vssd1 vccd1 vccd1 net272 sky130_fd_sc_hd__dlygate4sd3_1
Xhold95 CALC_INST.gencon_inst.mult_calc.count.GENERATE_ADDER\[8\].thingy.in1 vssd1
+ vssd1 vccd1 vccd1 net294 sky130_fd_sc_hd__dlygate4sd3_1
XFILLER_31_303 vssd1 vssd1 vccd1 vccd1 sky130_fd_sc_hd__fill_2
X_1571_ _1063_ _0486_ net75 CALC_INST.gencon_inst.ALU_out\[15\] vssd1 vssd1 vccd1
+ vccd1 _0703_ sky130_fd_sc_hd__a2bb2o_1
X_1640_ net214 _0722_ _0723_ CALC_INST.gencon_inst.operator_input\[2\] vssd1 vssd1
+ vccd1 vccd1 _0157_ sky130_fd_sc_hd__a22o_1
XFILLER_6_11 vssd1 vssd1 vccd1 vccd1 sky130_fd_sc_hd__fill_2
XANTENNA_clkbuf_leaf_6_clk_A clknet_2_1__leaf_clk vssd1 vssd1 vccd1 vccd1 sky130_fd_sc_hd__diode_2
X_2123_ CALC_INST.input_ctrl_inst.decoded_key\[2\] _1009_ CALC_INST.input_ctrl_inst.decoded_key\[3\]
+ vssd1 vssd1 vccd1 vccd1 _1011_ sky130_fd_sc_hd__o21a_1
XFILLER_26_119 vssd1 vssd1 vccd1 vccd1 sky130_fd_sc_hd__fill_1
X_2054_ _0862_ _0863_ vssd1 vssd1 vccd1 vccd1 _0993_ sky130_fd_sc_hd__and2b_1
XTAP_TAPCELL_ROW_49_486 vssd1 vccd1 sky130_fd_sc_hd__tapvpwrvgnd_1
XTAP_TAPCELL_ROW_24_309 vssd1 vccd1 sky130_fd_sc_hd__tapvpwrvgnd_1
X_1907_ net147 CALC_INST.gencon_inst.add_calc.main.in2\[14\] vssd1 vssd1 vccd1 vccd1
+ _0858_ sky130_fd_sc_hd__nand2_1
XANTENNA__2460__A CALC_INST.gencon_inst.operand2\[1\] vssd1 vssd1 vccd1 vccd1 sky130_fd_sc_hd__diode_2
XTAP_TAPCELL_ROW_32_364 vssd1 vccd1 sky130_fd_sc_hd__tapvpwrvgnd_1
X_1838_ net408 net131 _0853_ net142 vssd1 vssd1 vccd1 vccd1 _0226_ sky130_fd_sc_hd__a22o_1
X_1769_ CALC_INST.gencon_inst.mult_calc.main.GENERATE_ADDER\[4\].thingy.in2 CALC_INST.gencon_inst.mult_calc.main.GENERATE_ADDER\[4\].thingy.in1
+ vssd1 vssd1 vccd1 vccd1 _0795_ sky130_fd_sc_hd__nand2_1
XFILLER_57_299 vssd1 vssd1 vccd1 vccd1 sky130_fd_sc_hd__fill_1
XFILLER_17_108 vssd1 vssd1 vccd1 vccd1 sky130_fd_sc_hd__fill_4
XFILLER_40_155 vssd1 vssd1 vccd1 vccd1 sky130_fd_sc_hd__fill_1
XFILLER_25_196 vssd1 vssd1 vccd1 vccd1 sky130_fd_sc_hd__fill_1
XFILLER_25_152 vssd1 vssd1 vccd1 vccd1 sky130_fd_sc_hd__fill_4
XFILLER_15_75 vccd1 vssd1 vccd1 vssd1 sky130_ef_sc_hd__decap_40_12
Xoutput30 net30 vssd1 vssd1 vccd1 vccd1 gpio_out[8] sky130_fd_sc_hd__buf_2
XANTENNA__1527__A2 _0660_ vssd1 vssd1 vccd1 vccd1 sky130_fd_sc_hd__diode_2
Xteam_06_175 vssd1 vssd1 vccd1 vccd1 team_06_175/HI gpio_oeb[23] sky130_fd_sc_hd__conb_1
XFILLER_48_200 vssd1 vssd1 vccd1 vccd1 sky130_fd_sc_hd__fill_8
Xteam_06_197 vssd1 vssd1 vccd1 vccd1 gpio_oeb[31] team_06_197/LO sky130_fd_sc_hd__conb_1
Xteam_06_164 vssd1 vssd1 vccd1 vccd1 team_06_164/HI gpio_oeb[12] sky130_fd_sc_hd__conb_1
XFILLER_0_251 vssd1 vssd1 vccd1 vccd1 sky130_fd_sc_hd__fill_1
Xteam_06_186 vssd1 vssd1 vccd1 vccd1 team_06_186/HI gpio_out[30] sky130_fd_sc_hd__conb_1
XFILLER_63_214 vssd1 vssd1 vccd1 vccd1 sky130_fd_sc_hd__fill_8
XFILLER_31_111 vssd1 vssd1 vccd1 vccd1 sky130_fd_sc_hd__fill_1
XFILLER_16_152 vssd1 vssd1 vccd1 vccd1 sky130_fd_sc_hd__fill_4
X_2741_ clknet_leaf_17_clk _0300_ net119 vssd1 vssd1 vccd1 vccd1 CALC_INST.gencon_inst.ALU_out\[10\]
+ sky130_fd_sc_hd__dfrtp_1
X_2810_ clknet_leaf_7_clk _0352_ net94 vssd1 vssd1 vccd1 vccd1 CALC_INST.gencon_inst.read_input
+ sky130_fd_sc_hd__dfrtp_2
XFILLER_31_166 vssd1 vssd1 vccd1 vccd1 sky130_fd_sc_hd__fill_2
XFILLER_8_373 vssd1 vssd1 vccd1 vccd1 sky130_fd_sc_hd__fill_1
XFILLER_8_384 vccd1 vssd1 vccd1 vssd1 sky130_ef_sc_hd__decap_40_12
XFILLER_12_380 vssd1 vssd1 vccd1 vccd1 sky130_fd_sc_hd__fill_2
X_2672_ clknet_leaf_29_clk net392 net101 vssd1 vssd1 vccd1 vccd1 CALC_INST.gencon_inst.mult_calc.compCount.in2\[4\]
+ sky130_fd_sc_hd__dfrtp_1
X_1623_ CALC_INST.gencon_inst.operand2\[2\] net316 net64 vssd1 vssd1 vccd1 vccd1 _0140_
+ sky130_fd_sc_hd__mux2_1
XANTENNA__1327__C _0490_ vssd1 vssd1 vccd1 vccd1 sky130_fd_sc_hd__diode_2
X_1554_ net15 _0659_ _0690_ _0656_ vssd1 vssd1 vccd1 vccd1 _0691_ sky130_fd_sc_hd__a22o_1
X_1485_ net499 net52 _0585_ _0636_ vssd1 vssd1 vccd1 vccd1 _0090_ sky130_fd_sc_hd__a22o_1
.ends
